// File: TMRDFFSNRNQX1.spi.pex
// Created: Tue Apr 29 10:46:26 2025
// Program "Calibre xRC"
// Version "v2023.2_27.15"
// Nominal Temperature: 30C
// Circuit Temperature: 30C
//
simulator lang=spectre
subckt PM_TMRDFFSNRNQX1\%GND ( 1 167 171 174 179 189 197 207 215 225 233 243 \
 251 261 269 279 287 297 305 315 323 333 341 351 359 369 377 387 395 405 413 \
 423 431 441 449 459 467 477 485 495 503 511 517 523 531 542 547 551 564 566 \
 568 570 572 574 576 578 580 582 584 586 588 590 592 594 596 598 600 603 605 \
 612 619 620 621 622 623 624 625 626 627 628 629 630 631 632 633 634 635 636 \
 637 638 639 640 )
c1096 ( 640 0 ) capacitor c=0.0584751f //x=97.555 //y=0.55
c1097 ( 639 0 ) capacitor c=0.0215013f //x=94.72 //y=1.045
c1098 ( 638 0 ) capacitor c=0.0215013f //x=91.39 //y=1.045
c1099 ( 637 0 ) capacitor c=0.0207058f //x=88.06 //y=1.045
c1100 ( 636 0 ) capacitor c=0.0225954f //x=83.145 //y=1.055
c1101 ( 635 0 ) capacitor c=0.0225954f //x=78.335 //y=1.055
c1102 ( 634 0 ) capacitor c=0.0225954f //x=73.525 //y=1.055
c1103 ( 633 0 ) capacitor c=0.0225954f //x=68.715 //y=1.055
c1104 ( 632 0 ) capacitor c=0.0225954f //x=63.905 //y=1.055
c1105 ( 631 0 ) capacitor c=0.0225954f //x=59.095 //y=1.055
c1106 ( 630 0 ) capacitor c=0.0225954f //x=54.285 //y=1.055
c1107 ( 629 0 ) capacitor c=0.0225954f //x=49.475 //y=1.055
c1108 ( 628 0 ) capacitor c=0.0225954f //x=44.665 //y=1.055
c1109 ( 627 0 ) capacitor c=0.0225954f //x=39.855 //y=1.055
c1110 ( 626 0 ) capacitor c=0.0225954f //x=35.045 //y=1.055
c1111 ( 625 0 ) capacitor c=0.0225954f //x=30.235 //y=1.055
c1112 ( 624 0 ) capacitor c=0.0225954f //x=25.425 //y=1.055
c1113 ( 623 0 ) capacitor c=0.0225954f //x=20.615 //y=1.055
c1114 ( 622 0 ) capacitor c=0.0225954f //x=15.805 //y=1.055
c1115 ( 621 0 ) capacitor c=0.0225954f //x=10.995 //y=1.055
c1116 ( 620 0 ) capacitor c=0.0225954f //x=6.185 //y=1.055
c1117 ( 619 0 ) capacitor c=0.022675f //x=1.375 //y=1.055
c1118 ( 612 0 ) capacitor c=0.253772f //x=98.66 //y=0.175
c1119 ( 605 0 ) capacitor c=0.102069f //x=97.06 //y=0.175
c1120 ( 604 0 ) capacitor c=0.00446416f //x=94.91 //y=0.175
c1121 ( 603 0 ) capacitor c=0.101321f //x=93.73 //y=0.175
c1122 ( 602 0 ) capacitor c=0.00446416f //x=91.51 //y=0.18
c1123 ( 600 0 ) capacitor c=0.116223f //x=90.4 //y=0.175
c1124 ( 599 0 ) capacitor c=0.00446416f //x=88.25 //y=0.175
c1125 ( 598 0 ) capacitor c=0.107439f //x=87.07 //y=0.175
c1126 ( 597 0 ) capacitor c=0.00446464f //x=83.335 //y=0.175
c1127 ( 596 0 ) capacitor c=0.107081f //x=82.26 //y=0.175
c1128 ( 595 0 ) capacitor c=0.00446464f //x=78.525 //y=0.175
c1129 ( 594 0 ) capacitor c=0.107029f //x=77.45 //y=0.175
c1130 ( 593 0 ) capacitor c=0.00446464f //x=73.715 //y=0.175
c1131 ( 592 0 ) capacitor c=0.107178f //x=72.64 //y=0.175
c1132 ( 591 0 ) capacitor c=0.00446464f //x=68.905 //y=0.175
c1133 ( 590 0 ) capacitor c=0.107419f //x=67.83 //y=0.175
c1134 ( 589 0 ) capacitor c=0.00446464f //x=64.095 //y=0.175
c1135 ( 588 0 ) capacitor c=0.107156f //x=63.02 //y=0.175
c1136 ( 587 0 ) capacitor c=0.00446464f //x=59.285 //y=0.175
c1137 ( 586 0 ) capacitor c=0.107149f //x=58.21 //y=0.175
c1138 ( 585 0 ) capacitor c=0.00446464f //x=54.475 //y=0.175
c1139 ( 584 0 ) capacitor c=0.107156f //x=53.4 //y=0.175
c1140 ( 583 0 ) capacitor c=0.00446464f //x=49.665 //y=0.175
c1141 ( 582 0 ) capacitor c=0.107029f //x=48.59 //y=0.175
c1142 ( 581 0 ) capacitor c=0.00446464f //x=44.855 //y=0.175
c1143 ( 580 0 ) capacitor c=0.107178f //x=43.78 //y=0.175
c1144 ( 579 0 ) capacitor c=0.00446464f //x=40.045 //y=0.175
c1145 ( 578 0 ) capacitor c=0.107419f //x=38.97 //y=0.175
c1146 ( 577 0 ) capacitor c=0.00446464f //x=35.235 //y=0.175
c1147 ( 576 0 ) capacitor c=0.107156f //x=34.16 //y=0.175
c1148 ( 575 0 ) capacitor c=0.00446464f //x=30.425 //y=0.175
c1149 ( 574 0 ) capacitor c=0.107149f //x=29.35 //y=0.175
c1150 ( 573 0 ) capacitor c=0.00446464f //x=25.615 //y=0.175
c1151 ( 572 0 ) capacitor c=0.107156f //x=24.54 //y=0.175
c1152 ( 571 0 ) capacitor c=0.00446464f //x=20.805 //y=0.175
c1153 ( 570 0 ) capacitor c=0.107029f //x=19.73 //y=0.175
c1154 ( 569 0 ) capacitor c=0.00446464f //x=15.995 //y=0.175
c1155 ( 568 0 ) capacitor c=0.107178f //x=14.92 //y=0.175
c1156 ( 567 0 ) capacitor c=0.00446464f //x=11.185 //y=0.175
c1157 ( 566 0 ) capacitor c=0.107419f //x=10.11 //y=0.175
c1158 ( 565 0 ) capacitor c=0.00446464f //x=6.375 //y=0.175
c1159 ( 564 0 ) capacitor c=0.107156f //x=5.3 //y=0.175
c1160 ( 563 0 ) capacitor c=0.00446464f //x=1.565 //y=0.175
c1161 ( 554 0 ) capacitor c=0.00583665f //x=98.66 //y=0.63
c1162 ( 551 0 ) capacitor c=0.00542565f //x=98.575 //y=0.715
c1163 ( 550 0 ) capacitor c=0.00479856f //x=98.175 //y=0.63
c1164 ( 547 0 ) capacitor c=0.00707849f //x=98.09 //y=0.715
c1165 ( 542 0 ) capacitor c=0.00588377f //x=97.69 //y=0.63
c1166 ( 539 0 ) capacitor c=0.0191899f //x=97.605 //y=0.175
c1167 ( 531 0 ) capacitor c=0.0758845f //x=96.89 //y=0.175
c1168 ( 523 0 ) capacitor c=0.0393378f //x=94.825 //y=0.175
c1169 ( 517 0 ) capacitor c=0.0725462f //x=93.56 //y=0.175
c1170 ( 511 0 ) capacitor c=0.0391794f //x=91.495 //y=0.175
c1171 ( 503 0 ) capacitor c=0.0726307f //x=90.23 //y=0.175
c1172 ( 495 0 ) capacitor c=0.039444f //x=88.165 //y=0.175
c1173 ( 485 0 ) capacitor c=0.135065f //x=86.9 //y=0.175
c1174 ( 477 0 ) capacitor c=0.0342713f //x=83.25 //y=0.175
c1175 ( 467 0 ) capacitor c=0.135263f //x=82.09 //y=0.175
c1176 ( 459 0 ) capacitor c=0.0342713f //x=78.44 //y=0.175
c1177 ( 449 0 ) capacitor c=0.135264f //x=77.28 //y=0.175
c1178 ( 441 0 ) capacitor c=0.0342713f //x=73.63 //y=0.175
c1179 ( 431 0 ) capacitor c=0.135066f //x=72.47 //y=0.175
c1180 ( 423 0 ) capacitor c=0.0342713f //x=68.82 //y=0.175
c1181 ( 413 0 ) capacitor c=0.135066f //x=67.66 //y=0.175
c1182 ( 405 0 ) capacitor c=0.0342713f //x=64.01 //y=0.175
c1183 ( 395 0 ) capacitor c=0.135066f //x=62.85 //y=0.175
c1184 ( 387 0 ) capacitor c=0.0342713f //x=59.2 //y=0.175
c1185 ( 377 0 ) capacitor c=0.135066f //x=58.04 //y=0.175
c1186 ( 369 0 ) capacitor c=0.0342713f //x=54.39 //y=0.175
c1187 ( 359 0 ) capacitor c=0.135066f //x=53.23 //y=0.175
c1188 ( 351 0 ) capacitor c=0.0342713f //x=49.58 //y=0.175
c1189 ( 341 0 ) capacitor c=0.135264f //x=48.42 //y=0.175
c1190 ( 333 0 ) capacitor c=0.0342713f //x=44.77 //y=0.175
c1191 ( 323 0 ) capacitor c=0.135066f //x=43.61 //y=0.175
c1192 ( 315 0 ) capacitor c=0.0342713f //x=39.96 //y=0.175
c1193 ( 305 0 ) capacitor c=0.135066f //x=38.8 //y=0.175
c1194 ( 297 0 ) capacitor c=0.0342713f //x=35.15 //y=0.175
c1195 ( 287 0 ) capacitor c=0.135066f //x=33.99 //y=0.175
c1196 ( 279 0 ) capacitor c=0.0342713f //x=30.34 //y=0.175
c1197 ( 269 0 ) capacitor c=0.135066f //x=29.18 //y=0.175
c1198 ( 261 0 ) capacitor c=0.0342713f //x=25.53 //y=0.175
c1199 ( 251 0 ) capacitor c=0.135066f //x=24.37 //y=0.175
c1200 ( 243 0 ) capacitor c=0.0342713f //x=20.72 //y=0.175
c1201 ( 233 0 ) capacitor c=0.135264f //x=19.56 //y=0.175
c1202 ( 225 0 ) capacitor c=0.0342713f //x=15.91 //y=0.175
c1203 ( 215 0 ) capacitor c=0.135066f //x=14.75 //y=0.175
c1204 ( 207 0 ) capacitor c=0.0342713f //x=11.1 //y=0.175
c1205 ( 197 0 ) capacitor c=0.135066f //x=9.94 //y=0.175
c1206 ( 189 0 ) capacitor c=0.0342713f //x=6.29 //y=0.175
c1207 ( 179 0 ) capacitor c=0.13511f //x=5.13 //y=0.175
c1208 ( 174 0 ) capacitor c=0.196729f //x=1.23 //y=0.18
c1209 ( 171 0 ) capacitor c=0.0370791f //x=1.48 //y=0.175
c1210 ( 167 0 ) capacitor c=2.97829f //x=98.54 //y=0.18
r1211 (  611 612 ) resistor r=4.18529 //w=0.367 //l=0.12 //layer=li \
 //thickness=0.1 //x=98.54 //y=0.175 //x2=98.66 //y2=0.175
r1212 (  609 611 ) resistor r=12.7302 //w=0.367 //l=0.365 //layer=li \
 //thickness=0.1 //x=98.175 //y=0.175 //x2=98.54 //y2=0.175
r1213 (  608 609 ) resistor r=13.079 //w=0.367 //l=0.375 //layer=li \
 //thickness=0.1 //x=97.8 //y=0.175 //x2=98.175 //y2=0.175
r1214 (  606 608 ) resistor r=3.83651 //w=0.367 //l=0.11 //layer=li \
 //thickness=0.1 //x=97.69 //y=0.175 //x2=97.8 //y2=0.175
r1215 (  555 640 ) resistor r=5.4201 //w=0.17 //l=0.085 //layer=li \
 //thickness=0.1 //x=98.66 //y=0.8 //x2=98.66 //y2=0.715
r1216 (  555 640 ) resistor r=41.4118 //w=0.187 //l=0.605 //layer=li \
 //thickness=0.1 //x=98.66 //y=0.8 //x2=98.66 //y2=1.405
r1217 (  554 640 ) resistor r=5.4201 //w=0.17 //l=0.085 //layer=li \
 //thickness=0.1 //x=98.66 //y=0.63 //x2=98.66 //y2=0.715
r1218 (  553 612 ) resistor r=5.21862 //w=0.35 //l=0.175 //layer=li \
 //thickness=0.1 //x=98.66 //y=0.35 //x2=98.66 //y2=0.175
r1219 (  553 554 ) resistor r=19.1658 //w=0.187 //l=0.28 //layer=li \
 //thickness=0.1 //x=98.66 //y=0.35 //x2=98.66 //y2=0.63
r1220 (  552 640 ) resistor r=5.4201 //w=0.17 //l=0.085 //layer=li \
 //thickness=0.1 //x=98.26 //y=0.715 //x2=98.175 //y2=0.715
r1221 (  551 640 ) resistor r=1.40859 //w=0.34 //l=0.085 //layer=li \
 //thickness=0.1 //x=98.575 //y=0.715 //x2=98.66 //y2=0.715
r1222 (  551 552 ) resistor r=21.5615 //w=0.187 //l=0.315 //layer=li \
 //thickness=0.1 //x=98.575 //y=0.715 //x2=98.26 //y2=0.715
r1223 (  550 640 ) resistor r=1.40859 //w=0.34 //l=0.085 //layer=li \
 //thickness=0.1 //x=98.175 //y=0.63 //x2=98.175 //y2=0.715
r1224 (  549 609 ) resistor r=5.21862 //w=0.35 //l=0.175 //layer=li \
 //thickness=0.1 //x=98.175 //y=0.35 //x2=98.175 //y2=0.175
r1225 (  549 550 ) resistor r=19.1658 //w=0.187 //l=0.28 //layer=li \
 //thickness=0.1 //x=98.175 //y=0.35 //x2=98.175 //y2=0.63
r1226 (  548 640 ) resistor r=1.40859 //w=0.34 //l=0.085 //layer=li \
 //thickness=0.1 //x=97.775 //y=0.715 //x2=97.69 //y2=0.715
r1227 (  547 640 ) resistor r=5.4201 //w=0.17 //l=0.085 //layer=li \
 //thickness=0.1 //x=98.09 //y=0.715 //x2=98.175 //y2=0.715
r1228 (  547 548 ) resistor r=21.5615 //w=0.187 //l=0.315 //layer=li \
 //thickness=0.1 //x=98.09 //y=0.715 //x2=97.775 //y2=0.715
r1229 (  543 640 ) resistor r=5.4201 //w=0.17 //l=0.085 //layer=li \
 //thickness=0.1 //x=97.69 //y=0.8 //x2=97.69 //y2=0.715
r1230 (  543 640 ) resistor r=41.4118 //w=0.187 //l=0.605 //layer=li \
 //thickness=0.1 //x=97.69 //y=0.8 //x2=97.69 //y2=1.405
r1231 (  542 640 ) resistor r=5.4201 //w=0.17 //l=0.085 //layer=li \
 //thickness=0.1 //x=97.69 //y=0.63 //x2=97.69 //y2=0.715
r1232 (  541 606 ) resistor r=5.21862 //w=0.35 //l=0.175 //layer=li \
 //thickness=0.1 //x=97.69 //y=0.35 //x2=97.69 //y2=0.175
r1233 (  541 542 ) resistor r=19.1658 //w=0.187 //l=0.28 //layer=li \
 //thickness=0.1 //x=97.69 //y=0.35 //x2=97.69 //y2=0.63
r1234 (  540 605 ) resistor r=5.29055 //w=0.35 //l=0.17 //layer=li \
 //thickness=0.1 //x=97.23 //y=0.175 //x2=97.06 //y2=0.175
r1235 (  539 606 ) resistor r=2.96458 //w=0.367 //l=0.085 //layer=li \
 //thickness=0.1 //x=97.605 //y=0.175 //x2=97.69 //y2=0.175
r1236 (  539 540 ) resistor r=13.079 //w=0.367 //l=0.375 //layer=li \
 //thickness=0.1 //x=97.605 //y=0.175 //x2=97.23 //y2=0.175
r1237 (  534 536 ) resistor r=38.7139 //w=0.367 //l=1.11 //layer=li \
 //thickness=0.1 //x=95.21 //y=0.175 //x2=96.32 //y2=0.175
r1238 (  532 604 ) resistor r=2.87058 //w=0.35 //l=0.085 //layer=li \
 //thickness=0.1 //x=94.995 //y=0.175 //x2=94.91 //y2=0.175
r1239 (  532 534 ) resistor r=7.49864 //w=0.367 //l=0.215 //layer=li \
 //thickness=0.1 //x=94.995 //y=0.175 //x2=95.21 //y2=0.175
r1240 (  531 605 ) resistor r=5.29055 //w=0.35 //l=0.17 //layer=li \
 //thickness=0.1 //x=96.89 //y=0.175 //x2=97.06 //y2=0.175
r1241 (  531 536 ) resistor r=19.8801 //w=0.367 //l=0.57 //layer=li \
 //thickness=0.1 //x=96.89 //y=0.175 //x2=96.32 //y2=0.175
r1242 (  527 604 ) resistor r=4.23183 //w=0.7 //l=0.175 //layer=li \
 //thickness=0.1 //x=94.91 //y=0.35 //x2=94.91 //y2=0.175
r1243 (  527 639 ) resistor r=53.7326 //w=0.187 //l=0.785 //layer=li \
 //thickness=0.1 //x=94.91 //y=0.35 //x2=94.91 //y2=1.135
r1244 (  524 603 ) resistor r=5.29055 //w=0.35 //l=0.17 //layer=li \
 //thickness=0.1 //x=93.9 //y=0.175 //x2=93.73 //y2=0.175
r1245 (  524 526 ) resistor r=6.97548 //w=0.367 //l=0.2 //layer=li \
 //thickness=0.1 //x=93.9 //y=0.175 //x2=94.1 //y2=0.175
r1246 (  523 604 ) resistor r=2.87058 //w=0.35 //l=0.085 //layer=li \
 //thickness=0.1 //x=94.825 //y=0.175 //x2=94.91 //y2=0.175
r1247 (  523 526 ) resistor r=25.2861 //w=0.367 //l=0.725 //layer=li \
 //thickness=0.1 //x=94.825 //y=0.175 //x2=94.1 //y2=0.175
r1248 (  518 602 ) resistor r=2.87058 //w=0.35 //l=0.085 //layer=li \
 //thickness=0.1 //x=91.665 //y=0.175 //x2=91.58 //y2=0.175
r1249 (  518 520 ) resistor r=33.3079 //w=0.367 //l=0.955 //layer=li \
 //thickness=0.1 //x=91.665 //y=0.175 //x2=92.62 //y2=0.175
r1250 (  517 603 ) resistor r=5.29055 //w=0.35 //l=0.17 //layer=li \
 //thickness=0.1 //x=93.56 //y=0.175 //x2=93.73 //y2=0.175
r1251 (  517 520 ) resistor r=32.7847 //w=0.367 //l=0.94 //layer=li \
 //thickness=0.1 //x=93.56 //y=0.175 //x2=92.62 //y2=0.175
r1252 (  513 602 ) resistor r=4.23183 //w=0.7 //l=0.175 //layer=li \
 //thickness=0.1 //x=91.58 //y=0.35 //x2=91.58 //y2=0.175
r1253 (  513 638 ) resistor r=53.7326 //w=0.187 //l=0.785 //layer=li \
 //thickness=0.1 //x=91.58 //y=0.35 //x2=91.58 //y2=1.135
r1254 (  512 600 ) resistor r=5.29055 //w=0.35 //l=0.17 //layer=li \
 //thickness=0.1 //x=90.57 //y=0.175 //x2=90.4 //y2=0.175
r1255 (  511 602 ) resistor r=2.87058 //w=0.35 //l=0.085 //layer=li \
 //thickness=0.1 //x=91.495 //y=0.175 //x2=91.58 //y2=0.175
r1256 (  511 512 ) resistor r=32.2616 //w=0.367 //l=0.925 //layer=li \
 //thickness=0.1 //x=91.495 //y=0.175 //x2=90.57 //y2=0.175
r1257 (  506 508 ) resistor r=38.7139 //w=0.367 //l=1.11 //layer=li \
 //thickness=0.1 //x=88.92 //y=0.175 //x2=90.03 //y2=0.175
r1258 (  504 599 ) resistor r=2.87058 //w=0.35 //l=0.085 //layer=li \
 //thickness=0.1 //x=88.335 //y=0.175 //x2=88.25 //y2=0.175
r1259 (  504 506 ) resistor r=20.4033 //w=0.367 //l=0.585 //layer=li \
 //thickness=0.1 //x=88.335 //y=0.175 //x2=88.92 //y2=0.175
r1260 (  503 600 ) resistor r=5.29055 //w=0.35 //l=0.17 //layer=li \
 //thickness=0.1 //x=90.23 //y=0.175 //x2=90.4 //y2=0.175
r1261 (  503 508 ) resistor r=6.97548 //w=0.367 //l=0.2 //layer=li \
 //thickness=0.1 //x=90.23 //y=0.175 //x2=90.03 //y2=0.175
r1262 (  499 599 ) resistor r=4.23183 //w=0.7 //l=0.175 //layer=li \
 //thickness=0.1 //x=88.25 //y=0.35 //x2=88.25 //y2=0.175
r1263 (  499 637 ) resistor r=53.7326 //w=0.187 //l=0.785 //layer=li \
 //thickness=0.1 //x=88.25 //y=0.35 //x2=88.25 //y2=1.135
r1264 (  496 598 ) resistor r=5.29055 //w=0.35 //l=0.17 //layer=li \
 //thickness=0.1 //x=87.24 //y=0.175 //x2=87.07 //y2=0.175
r1265 (  496 498 ) resistor r=19.8801 //w=0.367 //l=0.57 //layer=li \
 //thickness=0.1 //x=87.24 //y=0.175 //x2=87.81 //y2=0.175
r1266 (  495 599 ) resistor r=2.87058 //w=0.35 //l=0.085 //layer=li \
 //thickness=0.1 //x=88.165 //y=0.175 //x2=88.25 //y2=0.175
r1267 (  495 498 ) resistor r=12.3815 //w=0.367 //l=0.355 //layer=li \
 //thickness=0.1 //x=88.165 //y=0.175 //x2=87.81 //y2=0.175
r1268 (  490 492 ) resistor r=38.7139 //w=0.367 //l=1.11 //layer=li \
 //thickness=0.1 //x=85.22 //y=0.175 //x2=86.33 //y2=0.175
r1269 (  488 490 ) resistor r=38.7139 //w=0.367 //l=1.11 //layer=li \
 //thickness=0.1 //x=84.11 //y=0.175 //x2=85.22 //y2=0.175
r1270 (  486 597 ) resistor r=2.87058 //w=0.35 //l=0.085 //layer=li \
 //thickness=0.1 //x=83.42 //y=0.175 //x2=83.335 //y2=0.175
r1271 (  486 488 ) resistor r=24.0654 //w=0.367 //l=0.69 //layer=li \
 //thickness=0.1 //x=83.42 //y=0.175 //x2=84.11 //y2=0.175
r1272 (  485 598 ) resistor r=5.29055 //w=0.35 //l=0.17 //layer=li \
 //thickness=0.1 //x=86.9 //y=0.175 //x2=87.07 //y2=0.175
r1273 (  485 492 ) resistor r=19.8801 //w=0.367 //l=0.57 //layer=li \
 //thickness=0.1 //x=86.9 //y=0.175 //x2=86.33 //y2=0.175
r1274 (  481 597 ) resistor r=4.23183 //w=0.7 //l=0.175 //layer=li \
 //thickness=0.1 //x=83.335 //y=0.35 //x2=83.335 //y2=0.175
r1275 (  481 636 ) resistor r=54.4171 //w=0.187 //l=0.795 //layer=li \
 //thickness=0.1 //x=83.335 //y=0.35 //x2=83.335 //y2=1.145
r1276 (  478 596 ) resistor r=5.29055 //w=0.35 //l=0.17 //layer=li \
 //thickness=0.1 //x=82.43 //y=0.175 //x2=82.26 //y2=0.175
r1277 (  478 480 ) resistor r=19.8801 //w=0.367 //l=0.57 //layer=li \
 //thickness=0.1 //x=82.43 //y=0.175 //x2=83 //y2=0.175
r1278 (  477 597 ) resistor r=2.87058 //w=0.35 //l=0.085 //layer=li \
 //thickness=0.1 //x=83.25 //y=0.175 //x2=83.335 //y2=0.175
r1279 (  477 480 ) resistor r=8.71935 //w=0.367 //l=0.25 //layer=li \
 //thickness=0.1 //x=83.25 //y=0.175 //x2=83 //y2=0.175
r1280 (  472 474 ) resistor r=38.7139 //w=0.367 //l=1.11 //layer=li \
 //thickness=0.1 //x=80.41 //y=0.175 //x2=81.52 //y2=0.175
r1281 (  470 472 ) resistor r=38.7139 //w=0.367 //l=1.11 //layer=li \
 //thickness=0.1 //x=79.3 //y=0.175 //x2=80.41 //y2=0.175
r1282 (  468 595 ) resistor r=2.87058 //w=0.35 //l=0.085 //layer=li \
 //thickness=0.1 //x=78.61 //y=0.175 //x2=78.525 //y2=0.175
r1283 (  468 470 ) resistor r=24.0654 //w=0.367 //l=0.69 //layer=li \
 //thickness=0.1 //x=78.61 //y=0.175 //x2=79.3 //y2=0.175
r1284 (  467 596 ) resistor r=5.29055 //w=0.35 //l=0.17 //layer=li \
 //thickness=0.1 //x=82.09 //y=0.175 //x2=82.26 //y2=0.175
r1285 (  467 474 ) resistor r=19.8801 //w=0.367 //l=0.57 //layer=li \
 //thickness=0.1 //x=82.09 //y=0.175 //x2=81.52 //y2=0.175
r1286 (  463 595 ) resistor r=4.23183 //w=0.7 //l=0.175 //layer=li \
 //thickness=0.1 //x=78.525 //y=0.35 //x2=78.525 //y2=0.175
r1287 (  463 635 ) resistor r=54.4171 //w=0.187 //l=0.795 //layer=li \
 //thickness=0.1 //x=78.525 //y=0.35 //x2=78.525 //y2=1.145
r1288 (  460 594 ) resistor r=5.29055 //w=0.35 //l=0.17 //layer=li \
 //thickness=0.1 //x=77.62 //y=0.175 //x2=77.45 //y2=0.175
r1289 (  460 462 ) resistor r=19.8801 //w=0.367 //l=0.57 //layer=li \
 //thickness=0.1 //x=77.62 //y=0.175 //x2=78.19 //y2=0.175
r1290 (  459 595 ) resistor r=2.87058 //w=0.35 //l=0.085 //layer=li \
 //thickness=0.1 //x=78.44 //y=0.175 //x2=78.525 //y2=0.175
r1291 (  459 462 ) resistor r=8.71935 //w=0.367 //l=0.25 //layer=li \
 //thickness=0.1 //x=78.44 //y=0.175 //x2=78.19 //y2=0.175
r1292 (  454 456 ) resistor r=38.7139 //w=0.367 //l=1.11 //layer=li \
 //thickness=0.1 //x=75.6 //y=0.175 //x2=76.71 //y2=0.175
r1293 (  452 454 ) resistor r=38.7139 //w=0.367 //l=1.11 //layer=li \
 //thickness=0.1 //x=74.49 //y=0.175 //x2=75.6 //y2=0.175
r1294 (  450 593 ) resistor r=2.87058 //w=0.35 //l=0.085 //layer=li \
 //thickness=0.1 //x=73.8 //y=0.175 //x2=73.715 //y2=0.175
r1295 (  450 452 ) resistor r=24.0654 //w=0.367 //l=0.69 //layer=li \
 //thickness=0.1 //x=73.8 //y=0.175 //x2=74.49 //y2=0.175
r1296 (  449 594 ) resistor r=5.29055 //w=0.35 //l=0.17 //layer=li \
 //thickness=0.1 //x=77.28 //y=0.175 //x2=77.45 //y2=0.175
r1297 (  449 456 ) resistor r=19.8801 //w=0.367 //l=0.57 //layer=li \
 //thickness=0.1 //x=77.28 //y=0.175 //x2=76.71 //y2=0.175
r1298 (  445 593 ) resistor r=4.23183 //w=0.7 //l=0.175 //layer=li \
 //thickness=0.1 //x=73.715 //y=0.35 //x2=73.715 //y2=0.175
r1299 (  445 634 ) resistor r=54.4171 //w=0.187 //l=0.795 //layer=li \
 //thickness=0.1 //x=73.715 //y=0.35 //x2=73.715 //y2=1.145
r1300 (  442 592 ) resistor r=5.29055 //w=0.35 //l=0.17 //layer=li \
 //thickness=0.1 //x=72.81 //y=0.175 //x2=72.64 //y2=0.175
r1301 (  442 444 ) resistor r=19.8801 //w=0.367 //l=0.57 //layer=li \
 //thickness=0.1 //x=72.81 //y=0.175 //x2=73.38 //y2=0.175
r1302 (  441 593 ) resistor r=2.87058 //w=0.35 //l=0.085 //layer=li \
 //thickness=0.1 //x=73.63 //y=0.175 //x2=73.715 //y2=0.175
r1303 (  441 444 ) resistor r=8.71935 //w=0.367 //l=0.25 //layer=li \
 //thickness=0.1 //x=73.63 //y=0.175 //x2=73.38 //y2=0.175
r1304 (  436 438 ) resistor r=38.7139 //w=0.367 //l=1.11 //layer=li \
 //thickness=0.1 //x=70.79 //y=0.175 //x2=71.9 //y2=0.175
r1305 (  434 436 ) resistor r=38.7139 //w=0.367 //l=1.11 //layer=li \
 //thickness=0.1 //x=69.68 //y=0.175 //x2=70.79 //y2=0.175
r1306 (  432 591 ) resistor r=2.87058 //w=0.35 //l=0.085 //layer=li \
 //thickness=0.1 //x=68.99 //y=0.175 //x2=68.905 //y2=0.175
r1307 (  432 434 ) resistor r=24.0654 //w=0.367 //l=0.69 //layer=li \
 //thickness=0.1 //x=68.99 //y=0.175 //x2=69.68 //y2=0.175
r1308 (  431 592 ) resistor r=5.29055 //w=0.35 //l=0.17 //layer=li \
 //thickness=0.1 //x=72.47 //y=0.175 //x2=72.64 //y2=0.175
r1309 (  431 438 ) resistor r=19.8801 //w=0.367 //l=0.57 //layer=li \
 //thickness=0.1 //x=72.47 //y=0.175 //x2=71.9 //y2=0.175
r1310 (  427 591 ) resistor r=4.23183 //w=0.7 //l=0.175 //layer=li \
 //thickness=0.1 //x=68.905 //y=0.35 //x2=68.905 //y2=0.175
r1311 (  427 633 ) resistor r=54.4171 //w=0.187 //l=0.795 //layer=li \
 //thickness=0.1 //x=68.905 //y=0.35 //x2=68.905 //y2=1.145
r1312 (  424 590 ) resistor r=5.29055 //w=0.35 //l=0.17 //layer=li \
 //thickness=0.1 //x=68 //y=0.175 //x2=67.83 //y2=0.175
r1313 (  424 426 ) resistor r=19.8801 //w=0.367 //l=0.57 //layer=li \
 //thickness=0.1 //x=68 //y=0.175 //x2=68.57 //y2=0.175
r1314 (  423 591 ) resistor r=2.87058 //w=0.35 //l=0.085 //layer=li \
 //thickness=0.1 //x=68.82 //y=0.175 //x2=68.905 //y2=0.175
r1315 (  423 426 ) resistor r=8.71935 //w=0.367 //l=0.25 //layer=li \
 //thickness=0.1 //x=68.82 //y=0.175 //x2=68.57 //y2=0.175
r1316 (  418 420 ) resistor r=38.7139 //w=0.367 //l=1.11 //layer=li \
 //thickness=0.1 //x=65.98 //y=0.175 //x2=67.09 //y2=0.175
r1317 (  416 418 ) resistor r=38.7139 //w=0.367 //l=1.11 //layer=li \
 //thickness=0.1 //x=64.87 //y=0.175 //x2=65.98 //y2=0.175
r1318 (  414 589 ) resistor r=2.87058 //w=0.35 //l=0.085 //layer=li \
 //thickness=0.1 //x=64.18 //y=0.175 //x2=64.095 //y2=0.175
r1319 (  414 416 ) resistor r=24.0654 //w=0.367 //l=0.69 //layer=li \
 //thickness=0.1 //x=64.18 //y=0.175 //x2=64.87 //y2=0.175
r1320 (  413 590 ) resistor r=5.29055 //w=0.35 //l=0.17 //layer=li \
 //thickness=0.1 //x=67.66 //y=0.175 //x2=67.83 //y2=0.175
r1321 (  413 420 ) resistor r=19.8801 //w=0.367 //l=0.57 //layer=li \
 //thickness=0.1 //x=67.66 //y=0.175 //x2=67.09 //y2=0.175
r1322 (  409 589 ) resistor r=4.23183 //w=0.7 //l=0.175 //layer=li \
 //thickness=0.1 //x=64.095 //y=0.35 //x2=64.095 //y2=0.175
r1323 (  409 632 ) resistor r=54.4171 //w=0.187 //l=0.795 //layer=li \
 //thickness=0.1 //x=64.095 //y=0.35 //x2=64.095 //y2=1.145
r1324 (  406 588 ) resistor r=5.29055 //w=0.35 //l=0.17 //layer=li \
 //thickness=0.1 //x=63.19 //y=0.175 //x2=63.02 //y2=0.175
r1325 (  406 408 ) resistor r=19.8801 //w=0.367 //l=0.57 //layer=li \
 //thickness=0.1 //x=63.19 //y=0.175 //x2=63.76 //y2=0.175
r1326 (  405 589 ) resistor r=2.87058 //w=0.35 //l=0.085 //layer=li \
 //thickness=0.1 //x=64.01 //y=0.175 //x2=64.095 //y2=0.175
r1327 (  405 408 ) resistor r=8.71935 //w=0.367 //l=0.25 //layer=li \
 //thickness=0.1 //x=64.01 //y=0.175 //x2=63.76 //y2=0.175
r1328 (  400 402 ) resistor r=38.7139 //w=0.367 //l=1.11 //layer=li \
 //thickness=0.1 //x=61.17 //y=0.175 //x2=62.28 //y2=0.175
r1329 (  398 400 ) resistor r=38.7139 //w=0.367 //l=1.11 //layer=li \
 //thickness=0.1 //x=60.06 //y=0.175 //x2=61.17 //y2=0.175
r1330 (  396 587 ) resistor r=2.87058 //w=0.35 //l=0.085 //layer=li \
 //thickness=0.1 //x=59.37 //y=0.175 //x2=59.285 //y2=0.175
r1331 (  396 398 ) resistor r=24.0654 //w=0.367 //l=0.69 //layer=li \
 //thickness=0.1 //x=59.37 //y=0.175 //x2=60.06 //y2=0.175
r1332 (  395 588 ) resistor r=5.29055 //w=0.35 //l=0.17 //layer=li \
 //thickness=0.1 //x=62.85 //y=0.175 //x2=63.02 //y2=0.175
r1333 (  395 402 ) resistor r=19.8801 //w=0.367 //l=0.57 //layer=li \
 //thickness=0.1 //x=62.85 //y=0.175 //x2=62.28 //y2=0.175
r1334 (  391 587 ) resistor r=4.23183 //w=0.7 //l=0.175 //layer=li \
 //thickness=0.1 //x=59.285 //y=0.35 //x2=59.285 //y2=0.175
r1335 (  391 631 ) resistor r=54.4171 //w=0.187 //l=0.795 //layer=li \
 //thickness=0.1 //x=59.285 //y=0.35 //x2=59.285 //y2=1.145
r1336 (  388 586 ) resistor r=5.29055 //w=0.35 //l=0.17 //layer=li \
 //thickness=0.1 //x=58.38 //y=0.175 //x2=58.21 //y2=0.175
r1337 (  388 390 ) resistor r=19.8801 //w=0.367 //l=0.57 //layer=li \
 //thickness=0.1 //x=58.38 //y=0.175 //x2=58.95 //y2=0.175
r1338 (  387 587 ) resistor r=2.87058 //w=0.35 //l=0.085 //layer=li \
 //thickness=0.1 //x=59.2 //y=0.175 //x2=59.285 //y2=0.175
r1339 (  387 390 ) resistor r=8.71935 //w=0.367 //l=0.25 //layer=li \
 //thickness=0.1 //x=59.2 //y=0.175 //x2=58.95 //y2=0.175
r1340 (  382 384 ) resistor r=38.7139 //w=0.367 //l=1.11 //layer=li \
 //thickness=0.1 //x=56.36 //y=0.175 //x2=57.47 //y2=0.175
r1341 (  380 382 ) resistor r=38.7139 //w=0.367 //l=1.11 //layer=li \
 //thickness=0.1 //x=55.25 //y=0.175 //x2=56.36 //y2=0.175
r1342 (  378 585 ) resistor r=2.87058 //w=0.35 //l=0.085 //layer=li \
 //thickness=0.1 //x=54.56 //y=0.175 //x2=54.475 //y2=0.175
r1343 (  378 380 ) resistor r=24.0654 //w=0.367 //l=0.69 //layer=li \
 //thickness=0.1 //x=54.56 //y=0.175 //x2=55.25 //y2=0.175
r1344 (  377 586 ) resistor r=5.29055 //w=0.35 //l=0.17 //layer=li \
 //thickness=0.1 //x=58.04 //y=0.175 //x2=58.21 //y2=0.175
r1345 (  377 384 ) resistor r=19.8801 //w=0.367 //l=0.57 //layer=li \
 //thickness=0.1 //x=58.04 //y=0.175 //x2=57.47 //y2=0.175
r1346 (  373 585 ) resistor r=4.23183 //w=0.7 //l=0.175 //layer=li \
 //thickness=0.1 //x=54.475 //y=0.35 //x2=54.475 //y2=0.175
r1347 (  373 630 ) resistor r=54.4171 //w=0.187 //l=0.795 //layer=li \
 //thickness=0.1 //x=54.475 //y=0.35 //x2=54.475 //y2=1.145
r1348 (  370 584 ) resistor r=5.29055 //w=0.35 //l=0.17 //layer=li \
 //thickness=0.1 //x=53.57 //y=0.175 //x2=53.4 //y2=0.175
r1349 (  370 372 ) resistor r=19.8801 //w=0.367 //l=0.57 //layer=li \
 //thickness=0.1 //x=53.57 //y=0.175 //x2=54.14 //y2=0.175
r1350 (  369 585 ) resistor r=2.87058 //w=0.35 //l=0.085 //layer=li \
 //thickness=0.1 //x=54.39 //y=0.175 //x2=54.475 //y2=0.175
r1351 (  369 372 ) resistor r=8.71935 //w=0.367 //l=0.25 //layer=li \
 //thickness=0.1 //x=54.39 //y=0.175 //x2=54.14 //y2=0.175
r1352 (  364 366 ) resistor r=38.7139 //w=0.367 //l=1.11 //layer=li \
 //thickness=0.1 //x=51.55 //y=0.175 //x2=52.66 //y2=0.175
r1353 (  362 364 ) resistor r=38.7139 //w=0.367 //l=1.11 //layer=li \
 //thickness=0.1 //x=50.44 //y=0.175 //x2=51.55 //y2=0.175
r1354 (  360 583 ) resistor r=2.87058 //w=0.35 //l=0.085 //layer=li \
 //thickness=0.1 //x=49.75 //y=0.175 //x2=49.665 //y2=0.175
r1355 (  360 362 ) resistor r=24.0654 //w=0.367 //l=0.69 //layer=li \
 //thickness=0.1 //x=49.75 //y=0.175 //x2=50.44 //y2=0.175
r1356 (  359 584 ) resistor r=5.29055 //w=0.35 //l=0.17 //layer=li \
 //thickness=0.1 //x=53.23 //y=0.175 //x2=53.4 //y2=0.175
r1357 (  359 366 ) resistor r=19.8801 //w=0.367 //l=0.57 //layer=li \
 //thickness=0.1 //x=53.23 //y=0.175 //x2=52.66 //y2=0.175
r1358 (  355 583 ) resistor r=4.23183 //w=0.7 //l=0.175 //layer=li \
 //thickness=0.1 //x=49.665 //y=0.35 //x2=49.665 //y2=0.175
r1359 (  355 629 ) resistor r=54.4171 //w=0.187 //l=0.795 //layer=li \
 //thickness=0.1 //x=49.665 //y=0.35 //x2=49.665 //y2=1.145
r1360 (  352 582 ) resistor r=5.29055 //w=0.35 //l=0.17 //layer=li \
 //thickness=0.1 //x=48.76 //y=0.175 //x2=48.59 //y2=0.175
r1361 (  352 354 ) resistor r=19.8801 //w=0.367 //l=0.57 //layer=li \
 //thickness=0.1 //x=48.76 //y=0.175 //x2=49.33 //y2=0.175
r1362 (  351 583 ) resistor r=2.87058 //w=0.35 //l=0.085 //layer=li \
 //thickness=0.1 //x=49.58 //y=0.175 //x2=49.665 //y2=0.175
r1363 (  351 354 ) resistor r=8.71935 //w=0.367 //l=0.25 //layer=li \
 //thickness=0.1 //x=49.58 //y=0.175 //x2=49.33 //y2=0.175
r1364 (  346 348 ) resistor r=38.7139 //w=0.367 //l=1.11 //layer=li \
 //thickness=0.1 //x=46.74 //y=0.175 //x2=47.85 //y2=0.175
r1365 (  344 346 ) resistor r=38.7139 //w=0.367 //l=1.11 //layer=li \
 //thickness=0.1 //x=45.63 //y=0.175 //x2=46.74 //y2=0.175
r1366 (  342 581 ) resistor r=2.87058 //w=0.35 //l=0.085 //layer=li \
 //thickness=0.1 //x=44.94 //y=0.175 //x2=44.855 //y2=0.175
r1367 (  342 344 ) resistor r=24.0654 //w=0.367 //l=0.69 //layer=li \
 //thickness=0.1 //x=44.94 //y=0.175 //x2=45.63 //y2=0.175
r1368 (  341 582 ) resistor r=5.29055 //w=0.35 //l=0.17 //layer=li \
 //thickness=0.1 //x=48.42 //y=0.175 //x2=48.59 //y2=0.175
r1369 (  341 348 ) resistor r=19.8801 //w=0.367 //l=0.57 //layer=li \
 //thickness=0.1 //x=48.42 //y=0.175 //x2=47.85 //y2=0.175
r1370 (  337 581 ) resistor r=4.23183 //w=0.7 //l=0.175 //layer=li \
 //thickness=0.1 //x=44.855 //y=0.35 //x2=44.855 //y2=0.175
r1371 (  337 628 ) resistor r=54.4171 //w=0.187 //l=0.795 //layer=li \
 //thickness=0.1 //x=44.855 //y=0.35 //x2=44.855 //y2=1.145
r1372 (  334 580 ) resistor r=5.29055 //w=0.35 //l=0.17 //layer=li \
 //thickness=0.1 //x=43.95 //y=0.175 //x2=43.78 //y2=0.175
r1373 (  334 336 ) resistor r=19.8801 //w=0.367 //l=0.57 //layer=li \
 //thickness=0.1 //x=43.95 //y=0.175 //x2=44.52 //y2=0.175
r1374 (  333 581 ) resistor r=2.87058 //w=0.35 //l=0.085 //layer=li \
 //thickness=0.1 //x=44.77 //y=0.175 //x2=44.855 //y2=0.175
r1375 (  333 336 ) resistor r=8.71935 //w=0.367 //l=0.25 //layer=li \
 //thickness=0.1 //x=44.77 //y=0.175 //x2=44.52 //y2=0.175
r1376 (  328 330 ) resistor r=38.7139 //w=0.367 //l=1.11 //layer=li \
 //thickness=0.1 //x=41.93 //y=0.175 //x2=43.04 //y2=0.175
r1377 (  326 328 ) resistor r=38.7139 //w=0.367 //l=1.11 //layer=li \
 //thickness=0.1 //x=40.82 //y=0.175 //x2=41.93 //y2=0.175
r1378 (  324 579 ) resistor r=2.87058 //w=0.35 //l=0.085 //layer=li \
 //thickness=0.1 //x=40.13 //y=0.175 //x2=40.045 //y2=0.175
r1379 (  324 326 ) resistor r=24.0654 //w=0.367 //l=0.69 //layer=li \
 //thickness=0.1 //x=40.13 //y=0.175 //x2=40.82 //y2=0.175
r1380 (  323 580 ) resistor r=5.29055 //w=0.35 //l=0.17 //layer=li \
 //thickness=0.1 //x=43.61 //y=0.175 //x2=43.78 //y2=0.175
r1381 (  323 330 ) resistor r=19.8801 //w=0.367 //l=0.57 //layer=li \
 //thickness=0.1 //x=43.61 //y=0.175 //x2=43.04 //y2=0.175
r1382 (  319 579 ) resistor r=4.23183 //w=0.7 //l=0.175 //layer=li \
 //thickness=0.1 //x=40.045 //y=0.35 //x2=40.045 //y2=0.175
r1383 (  319 627 ) resistor r=54.4171 //w=0.187 //l=0.795 //layer=li \
 //thickness=0.1 //x=40.045 //y=0.35 //x2=40.045 //y2=1.145
r1384 (  316 578 ) resistor r=5.29055 //w=0.35 //l=0.17 //layer=li \
 //thickness=0.1 //x=39.14 //y=0.175 //x2=38.97 //y2=0.175
r1385 (  316 318 ) resistor r=19.8801 //w=0.367 //l=0.57 //layer=li \
 //thickness=0.1 //x=39.14 //y=0.175 //x2=39.71 //y2=0.175
r1386 (  315 579 ) resistor r=2.87058 //w=0.35 //l=0.085 //layer=li \
 //thickness=0.1 //x=39.96 //y=0.175 //x2=40.045 //y2=0.175
r1387 (  315 318 ) resistor r=8.71935 //w=0.367 //l=0.25 //layer=li \
 //thickness=0.1 //x=39.96 //y=0.175 //x2=39.71 //y2=0.175
r1388 (  310 312 ) resistor r=38.7139 //w=0.367 //l=1.11 //layer=li \
 //thickness=0.1 //x=37.12 //y=0.175 //x2=38.23 //y2=0.175
r1389 (  308 310 ) resistor r=38.7139 //w=0.367 //l=1.11 //layer=li \
 //thickness=0.1 //x=36.01 //y=0.175 //x2=37.12 //y2=0.175
r1390 (  306 577 ) resistor r=2.87058 //w=0.35 //l=0.085 //layer=li \
 //thickness=0.1 //x=35.32 //y=0.175 //x2=35.235 //y2=0.175
r1391 (  306 308 ) resistor r=24.0654 //w=0.367 //l=0.69 //layer=li \
 //thickness=0.1 //x=35.32 //y=0.175 //x2=36.01 //y2=0.175
r1392 (  305 578 ) resistor r=5.29055 //w=0.35 //l=0.17 //layer=li \
 //thickness=0.1 //x=38.8 //y=0.175 //x2=38.97 //y2=0.175
r1393 (  305 312 ) resistor r=19.8801 //w=0.367 //l=0.57 //layer=li \
 //thickness=0.1 //x=38.8 //y=0.175 //x2=38.23 //y2=0.175
r1394 (  301 577 ) resistor r=4.23183 //w=0.7 //l=0.175 //layer=li \
 //thickness=0.1 //x=35.235 //y=0.35 //x2=35.235 //y2=0.175
r1395 (  301 626 ) resistor r=54.4171 //w=0.187 //l=0.795 //layer=li \
 //thickness=0.1 //x=35.235 //y=0.35 //x2=35.235 //y2=1.145
r1396 (  298 576 ) resistor r=5.29055 //w=0.35 //l=0.17 //layer=li \
 //thickness=0.1 //x=34.33 //y=0.175 //x2=34.16 //y2=0.175
r1397 (  298 300 ) resistor r=19.8801 //w=0.367 //l=0.57 //layer=li \
 //thickness=0.1 //x=34.33 //y=0.175 //x2=34.9 //y2=0.175
r1398 (  297 577 ) resistor r=2.87058 //w=0.35 //l=0.085 //layer=li \
 //thickness=0.1 //x=35.15 //y=0.175 //x2=35.235 //y2=0.175
r1399 (  297 300 ) resistor r=8.71935 //w=0.367 //l=0.25 //layer=li \
 //thickness=0.1 //x=35.15 //y=0.175 //x2=34.9 //y2=0.175
r1400 (  292 294 ) resistor r=38.7139 //w=0.367 //l=1.11 //layer=li \
 //thickness=0.1 //x=32.31 //y=0.175 //x2=33.42 //y2=0.175
r1401 (  290 292 ) resistor r=38.7139 //w=0.367 //l=1.11 //layer=li \
 //thickness=0.1 //x=31.2 //y=0.175 //x2=32.31 //y2=0.175
r1402 (  288 575 ) resistor r=2.87058 //w=0.35 //l=0.085 //layer=li \
 //thickness=0.1 //x=30.51 //y=0.175 //x2=30.425 //y2=0.175
r1403 (  288 290 ) resistor r=24.0654 //w=0.367 //l=0.69 //layer=li \
 //thickness=0.1 //x=30.51 //y=0.175 //x2=31.2 //y2=0.175
r1404 (  287 576 ) resistor r=5.29055 //w=0.35 //l=0.17 //layer=li \
 //thickness=0.1 //x=33.99 //y=0.175 //x2=34.16 //y2=0.175
r1405 (  287 294 ) resistor r=19.8801 //w=0.367 //l=0.57 //layer=li \
 //thickness=0.1 //x=33.99 //y=0.175 //x2=33.42 //y2=0.175
r1406 (  283 575 ) resistor r=4.23183 //w=0.7 //l=0.175 //layer=li \
 //thickness=0.1 //x=30.425 //y=0.35 //x2=30.425 //y2=0.175
r1407 (  283 625 ) resistor r=54.4171 //w=0.187 //l=0.795 //layer=li \
 //thickness=0.1 //x=30.425 //y=0.35 //x2=30.425 //y2=1.145
r1408 (  280 574 ) resistor r=5.29055 //w=0.35 //l=0.17 //layer=li \
 //thickness=0.1 //x=29.52 //y=0.175 //x2=29.35 //y2=0.175
r1409 (  280 282 ) resistor r=19.8801 //w=0.367 //l=0.57 //layer=li \
 //thickness=0.1 //x=29.52 //y=0.175 //x2=30.09 //y2=0.175
r1410 (  279 575 ) resistor r=2.87058 //w=0.35 //l=0.085 //layer=li \
 //thickness=0.1 //x=30.34 //y=0.175 //x2=30.425 //y2=0.175
r1411 (  279 282 ) resistor r=8.71935 //w=0.367 //l=0.25 //layer=li \
 //thickness=0.1 //x=30.34 //y=0.175 //x2=30.09 //y2=0.175
r1412 (  274 276 ) resistor r=38.7139 //w=0.367 //l=1.11 //layer=li \
 //thickness=0.1 //x=27.5 //y=0.175 //x2=28.61 //y2=0.175
r1413 (  272 274 ) resistor r=38.7139 //w=0.367 //l=1.11 //layer=li \
 //thickness=0.1 //x=26.39 //y=0.175 //x2=27.5 //y2=0.175
r1414 (  270 573 ) resistor r=2.87058 //w=0.35 //l=0.085 //layer=li \
 //thickness=0.1 //x=25.7 //y=0.175 //x2=25.615 //y2=0.175
r1415 (  270 272 ) resistor r=24.0654 //w=0.367 //l=0.69 //layer=li \
 //thickness=0.1 //x=25.7 //y=0.175 //x2=26.39 //y2=0.175
r1416 (  269 574 ) resistor r=5.29055 //w=0.35 //l=0.17 //layer=li \
 //thickness=0.1 //x=29.18 //y=0.175 //x2=29.35 //y2=0.175
r1417 (  269 276 ) resistor r=19.8801 //w=0.367 //l=0.57 //layer=li \
 //thickness=0.1 //x=29.18 //y=0.175 //x2=28.61 //y2=0.175
r1418 (  265 573 ) resistor r=4.23183 //w=0.7 //l=0.175 //layer=li \
 //thickness=0.1 //x=25.615 //y=0.35 //x2=25.615 //y2=0.175
r1419 (  265 624 ) resistor r=54.4171 //w=0.187 //l=0.795 //layer=li \
 //thickness=0.1 //x=25.615 //y=0.35 //x2=25.615 //y2=1.145
r1420 (  262 572 ) resistor r=5.29055 //w=0.35 //l=0.17 //layer=li \
 //thickness=0.1 //x=24.71 //y=0.175 //x2=24.54 //y2=0.175
r1421 (  262 264 ) resistor r=19.8801 //w=0.367 //l=0.57 //layer=li \
 //thickness=0.1 //x=24.71 //y=0.175 //x2=25.28 //y2=0.175
r1422 (  261 573 ) resistor r=2.87058 //w=0.35 //l=0.085 //layer=li \
 //thickness=0.1 //x=25.53 //y=0.175 //x2=25.615 //y2=0.175
r1423 (  261 264 ) resistor r=8.71935 //w=0.367 //l=0.25 //layer=li \
 //thickness=0.1 //x=25.53 //y=0.175 //x2=25.28 //y2=0.175
r1424 (  256 258 ) resistor r=38.7139 //w=0.367 //l=1.11 //layer=li \
 //thickness=0.1 //x=22.69 //y=0.175 //x2=23.8 //y2=0.175
r1425 (  254 256 ) resistor r=38.7139 //w=0.367 //l=1.11 //layer=li \
 //thickness=0.1 //x=21.58 //y=0.175 //x2=22.69 //y2=0.175
r1426 (  252 571 ) resistor r=2.87058 //w=0.35 //l=0.085 //layer=li \
 //thickness=0.1 //x=20.89 //y=0.175 //x2=20.805 //y2=0.175
r1427 (  252 254 ) resistor r=24.0654 //w=0.367 //l=0.69 //layer=li \
 //thickness=0.1 //x=20.89 //y=0.175 //x2=21.58 //y2=0.175
r1428 (  251 572 ) resistor r=5.29055 //w=0.35 //l=0.17 //layer=li \
 //thickness=0.1 //x=24.37 //y=0.175 //x2=24.54 //y2=0.175
r1429 (  251 258 ) resistor r=19.8801 //w=0.367 //l=0.57 //layer=li \
 //thickness=0.1 //x=24.37 //y=0.175 //x2=23.8 //y2=0.175
r1430 (  247 571 ) resistor r=4.23183 //w=0.7 //l=0.175 //layer=li \
 //thickness=0.1 //x=20.805 //y=0.35 //x2=20.805 //y2=0.175
r1431 (  247 623 ) resistor r=54.4171 //w=0.187 //l=0.795 //layer=li \
 //thickness=0.1 //x=20.805 //y=0.35 //x2=20.805 //y2=1.145
r1432 (  244 570 ) resistor r=5.29055 //w=0.35 //l=0.17 //layer=li \
 //thickness=0.1 //x=19.9 //y=0.175 //x2=19.73 //y2=0.175
r1433 (  244 246 ) resistor r=19.8801 //w=0.367 //l=0.57 //layer=li \
 //thickness=0.1 //x=19.9 //y=0.175 //x2=20.47 //y2=0.175
r1434 (  243 571 ) resistor r=2.87058 //w=0.35 //l=0.085 //layer=li \
 //thickness=0.1 //x=20.72 //y=0.175 //x2=20.805 //y2=0.175
r1435 (  243 246 ) resistor r=8.71935 //w=0.367 //l=0.25 //layer=li \
 //thickness=0.1 //x=20.72 //y=0.175 //x2=20.47 //y2=0.175
r1436 (  238 240 ) resistor r=38.7139 //w=0.367 //l=1.11 //layer=li \
 //thickness=0.1 //x=17.88 //y=0.175 //x2=18.99 //y2=0.175
r1437 (  236 238 ) resistor r=38.7139 //w=0.367 //l=1.11 //layer=li \
 //thickness=0.1 //x=16.77 //y=0.175 //x2=17.88 //y2=0.175
r1438 (  234 569 ) resistor r=2.87058 //w=0.35 //l=0.085 //layer=li \
 //thickness=0.1 //x=16.08 //y=0.175 //x2=15.995 //y2=0.175
r1439 (  234 236 ) resistor r=24.0654 //w=0.367 //l=0.69 //layer=li \
 //thickness=0.1 //x=16.08 //y=0.175 //x2=16.77 //y2=0.175
r1440 (  233 570 ) resistor r=5.29055 //w=0.35 //l=0.17 //layer=li \
 //thickness=0.1 //x=19.56 //y=0.175 //x2=19.73 //y2=0.175
r1441 (  233 240 ) resistor r=19.8801 //w=0.367 //l=0.57 //layer=li \
 //thickness=0.1 //x=19.56 //y=0.175 //x2=18.99 //y2=0.175
r1442 (  229 569 ) resistor r=4.23183 //w=0.7 //l=0.175 //layer=li \
 //thickness=0.1 //x=15.995 //y=0.35 //x2=15.995 //y2=0.175
r1443 (  229 622 ) resistor r=54.4171 //w=0.187 //l=0.795 //layer=li \
 //thickness=0.1 //x=15.995 //y=0.35 //x2=15.995 //y2=1.145
r1444 (  226 568 ) resistor r=5.29055 //w=0.35 //l=0.17 //layer=li \
 //thickness=0.1 //x=15.09 //y=0.175 //x2=14.92 //y2=0.175
r1445 (  226 228 ) resistor r=19.8801 //w=0.367 //l=0.57 //layer=li \
 //thickness=0.1 //x=15.09 //y=0.175 //x2=15.66 //y2=0.175
r1446 (  225 569 ) resistor r=2.87058 //w=0.35 //l=0.085 //layer=li \
 //thickness=0.1 //x=15.91 //y=0.175 //x2=15.995 //y2=0.175
r1447 (  225 228 ) resistor r=8.71935 //w=0.367 //l=0.25 //layer=li \
 //thickness=0.1 //x=15.91 //y=0.175 //x2=15.66 //y2=0.175
r1448 (  220 222 ) resistor r=38.7139 //w=0.367 //l=1.11 //layer=li \
 //thickness=0.1 //x=13.07 //y=0.175 //x2=14.18 //y2=0.175
r1449 (  218 220 ) resistor r=38.7139 //w=0.367 //l=1.11 //layer=li \
 //thickness=0.1 //x=11.96 //y=0.175 //x2=13.07 //y2=0.175
r1450 (  216 567 ) resistor r=2.87058 //w=0.35 //l=0.085 //layer=li \
 //thickness=0.1 //x=11.27 //y=0.175 //x2=11.185 //y2=0.175
r1451 (  216 218 ) resistor r=24.0654 //w=0.367 //l=0.69 //layer=li \
 //thickness=0.1 //x=11.27 //y=0.175 //x2=11.96 //y2=0.175
r1452 (  215 568 ) resistor r=5.29055 //w=0.35 //l=0.17 //layer=li \
 //thickness=0.1 //x=14.75 //y=0.175 //x2=14.92 //y2=0.175
r1453 (  215 222 ) resistor r=19.8801 //w=0.367 //l=0.57 //layer=li \
 //thickness=0.1 //x=14.75 //y=0.175 //x2=14.18 //y2=0.175
r1454 (  211 567 ) resistor r=4.23183 //w=0.7 //l=0.175 //layer=li \
 //thickness=0.1 //x=11.185 //y=0.35 //x2=11.185 //y2=0.175
r1455 (  211 621 ) resistor r=54.4171 //w=0.187 //l=0.795 //layer=li \
 //thickness=0.1 //x=11.185 //y=0.35 //x2=11.185 //y2=1.145
r1456 (  208 566 ) resistor r=5.29055 //w=0.35 //l=0.17 //layer=li \
 //thickness=0.1 //x=10.28 //y=0.175 //x2=10.11 //y2=0.175
r1457 (  208 210 ) resistor r=19.8801 //w=0.367 //l=0.57 //layer=li \
 //thickness=0.1 //x=10.28 //y=0.175 //x2=10.85 //y2=0.175
r1458 (  207 567 ) resistor r=2.87058 //w=0.35 //l=0.085 //layer=li \
 //thickness=0.1 //x=11.1 //y=0.175 //x2=11.185 //y2=0.175
r1459 (  207 210 ) resistor r=8.71935 //w=0.367 //l=0.25 //layer=li \
 //thickness=0.1 //x=11.1 //y=0.175 //x2=10.85 //y2=0.175
r1460 (  202 204 ) resistor r=38.7139 //w=0.367 //l=1.11 //layer=li \
 //thickness=0.1 //x=8.26 //y=0.175 //x2=9.37 //y2=0.175
r1461 (  200 202 ) resistor r=38.7139 //w=0.367 //l=1.11 //layer=li \
 //thickness=0.1 //x=7.15 //y=0.175 //x2=8.26 //y2=0.175
r1462 (  198 565 ) resistor r=2.87058 //w=0.35 //l=0.085 //layer=li \
 //thickness=0.1 //x=6.46 //y=0.175 //x2=6.375 //y2=0.175
r1463 (  198 200 ) resistor r=24.0654 //w=0.367 //l=0.69 //layer=li \
 //thickness=0.1 //x=6.46 //y=0.175 //x2=7.15 //y2=0.175
r1464 (  197 566 ) resistor r=5.29055 //w=0.35 //l=0.17 //layer=li \
 //thickness=0.1 //x=9.94 //y=0.175 //x2=10.11 //y2=0.175
r1465 (  197 204 ) resistor r=19.8801 //w=0.367 //l=0.57 //layer=li \
 //thickness=0.1 //x=9.94 //y=0.175 //x2=9.37 //y2=0.175
r1466 (  193 565 ) resistor r=4.23183 //w=0.7 //l=0.175 //layer=li \
 //thickness=0.1 //x=6.375 //y=0.35 //x2=6.375 //y2=0.175
r1467 (  193 620 ) resistor r=54.4171 //w=0.187 //l=0.795 //layer=li \
 //thickness=0.1 //x=6.375 //y=0.35 //x2=6.375 //y2=1.145
r1468 (  190 564 ) resistor r=5.29055 //w=0.35 //l=0.17 //layer=li \
 //thickness=0.1 //x=5.47 //y=0.175 //x2=5.3 //y2=0.175
r1469 (  190 192 ) resistor r=19.8801 //w=0.367 //l=0.57 //layer=li \
 //thickness=0.1 //x=5.47 //y=0.175 //x2=6.04 //y2=0.175
r1470 (  189 565 ) resistor r=2.87058 //w=0.35 //l=0.085 //layer=li \
 //thickness=0.1 //x=6.29 //y=0.175 //x2=6.375 //y2=0.175
r1471 (  189 192 ) resistor r=8.71935 //w=0.367 //l=0.25 //layer=li \
 //thickness=0.1 //x=6.29 //y=0.175 //x2=6.04 //y2=0.175
r1472 (  184 186 ) resistor r=38.7139 //w=0.367 //l=1.11 //layer=li \
 //thickness=0.1 //x=3.45 //y=0.175 //x2=4.56 //y2=0.175
r1473 (  182 184 ) resistor r=38.7139 //w=0.367 //l=1.11 //layer=li \
 //thickness=0.1 //x=2.34 //y=0.175 //x2=3.45 //y2=0.175
r1474 (  180 563 ) resistor r=2.87058 //w=0.35 //l=0.085 //layer=li \
 //thickness=0.1 //x=1.65 //y=0.175 //x2=1.565 //y2=0.175
r1475 (  180 182 ) resistor r=24.0654 //w=0.367 //l=0.69 //layer=li \
 //thickness=0.1 //x=1.65 //y=0.175 //x2=2.34 //y2=0.175
r1476 (  179 564 ) resistor r=5.29055 //w=0.35 //l=0.17 //layer=li \
 //thickness=0.1 //x=5.13 //y=0.175 //x2=5.3 //y2=0.175
r1477 (  179 186 ) resistor r=19.8801 //w=0.367 //l=0.57 //layer=li \
 //thickness=0.1 //x=5.13 //y=0.175 //x2=4.56 //y2=0.175
r1478 (  175 563 ) resistor r=4.23183 //w=0.7 //l=0.175 //layer=li \
 //thickness=0.1 //x=1.565 //y=0.35 //x2=1.565 //y2=0.175
r1479 (  175 619 ) resistor r=54.4171 //w=0.187 //l=0.795 //layer=li \
 //thickness=0.1 //x=1.565 //y=0.35 //x2=1.565 //y2=1.145
r1480 (  171 563 ) resistor r=2.87058 //w=0.35 //l=0.085 //layer=li \
 //thickness=0.1 //x=1.48 //y=0.175 //x2=1.565 //y2=0.175
r1481 (  171 174 ) resistor r=8.71935 //w=0.367 //l=0.25 //layer=li \
 //thickness=0.1 //x=1.48 //y=0.175 //x2=1.23 //y2=0.175
r1482 (  167 611 ) resistor r=4.65 //w=0.17 //l=0.34 //layer=mcon //count=2 \
 //x=98.54 //y=0.18 //x2=98.54 //y2=0.18
r1483 (  165 608 ) resistor r=3.1 //w=0.17 //l=0.51 //layer=mcon //count=3 \
 //x=97.8 //y=0.18 //x2=97.8 //y2=0.18
r1484 (  165 167 ) resistor r=0.297428 //w=0.311 //l=0.74 //layer=m1 \
 //thickness=0.36 //x=97.8 //y=0.175 //x2=98.54 //y2=0.175
r1485 (  163 536 ) resistor r=3.1 //w=0.17 //l=0.51 //layer=mcon //count=3 \
 //x=96.32 //y=0.18 //x2=96.32 //y2=0.18
r1486 (  163 165 ) resistor r=0.594855 //w=0.311 //l=1.48 //layer=m1 \
 //thickness=0.36 //x=96.32 //y=0.175 //x2=97.8 //y2=0.175
r1487 (  161 534 ) resistor r=3.1 //w=0.17 //l=0.51 //layer=mcon //count=3 \
 //x=95.21 //y=0.18 //x2=95.21 //y2=0.18
r1488 (  161 163 ) resistor r=0.446141 //w=0.311 //l=1.11 //layer=m1 \
 //thickness=0.36 //x=95.21 //y=0.175 //x2=96.32 //y2=0.175
r1489 (  159 526 ) resistor r=3.1 //w=0.17 //l=0.51 //layer=mcon //count=3 \
 //x=94.1 //y=0.18 //x2=94.1 //y2=0.18
r1490 (  159 161 ) resistor r=0.446141 //w=0.311 //l=1.11 //layer=m1 \
 //thickness=0.36 //x=94.1 //y=0.175 //x2=95.21 //y2=0.175
r1491 (  157 520 ) resistor r=3.1 //w=0.17 //l=0.51 //layer=mcon //count=3 \
 //x=92.62 //y=0.18 //x2=92.62 //y2=0.18
r1492 (  157 159 ) resistor r=0.594855 //w=0.311 //l=1.48 //layer=m1 \
 //thickness=0.36 //x=92.62 //y=0.175 //x2=94.1 //y2=0.175
r1493 (  155 602 ) resistor r=3.1 //w=0.17 //l=0.51 //layer=mcon //count=3 \
 //x=91.51 //y=0.18 //x2=91.51 //y2=0.18
r1494 (  155 157 ) resistor r=0.446141 //w=0.311 //l=1.11 //layer=m1 \
 //thickness=0.36 //x=91.51 //y=0.175 //x2=92.62 //y2=0.175
r1495 (  153 508 ) resistor r=3.1 //w=0.17 //l=0.51 //layer=mcon //count=3 \
 //x=90.03 //y=0.18 //x2=90.03 //y2=0.18
r1496 (  153 155 ) resistor r=0.594855 //w=0.311 //l=1.48 //layer=m1 \
 //thickness=0.36 //x=90.03 //y=0.175 //x2=91.51 //y2=0.175
r1497 (  151 506 ) resistor r=3.1 //w=0.17 //l=0.51 //layer=mcon //count=3 \
 //x=88.92 //y=0.18 //x2=88.92 //y2=0.18
r1498 (  151 153 ) resistor r=0.446141 //w=0.311 //l=1.11 //layer=m1 \
 //thickness=0.36 //x=88.92 //y=0.175 //x2=90.03 //y2=0.175
r1499 (  149 498 ) resistor r=3.1 //w=0.17 //l=0.51 //layer=mcon //count=3 \
 //x=87.81 //y=0.18 //x2=87.81 //y2=0.18
r1500 (  149 151 ) resistor r=0.446141 //w=0.311 //l=1.11 //layer=m1 \
 //thickness=0.36 //x=87.81 //y=0.175 //x2=88.92 //y2=0.175
r1501 (  147 492 ) resistor r=3.1 //w=0.17 //l=0.51 //layer=mcon //count=3 \
 //x=86.33 //y=0.18 //x2=86.33 //y2=0.18
r1502 (  147 149 ) resistor r=0.594855 //w=0.311 //l=1.48 //layer=m1 \
 //thickness=0.36 //x=86.33 //y=0.175 //x2=87.81 //y2=0.175
r1503 (  145 490 ) resistor r=3.1 //w=0.17 //l=0.51 //layer=mcon //count=3 \
 //x=85.22 //y=0.18 //x2=85.22 //y2=0.18
r1504 (  145 147 ) resistor r=0.446141 //w=0.311 //l=1.11 //layer=m1 \
 //thickness=0.36 //x=85.22 //y=0.175 //x2=86.33 //y2=0.175
r1505 (  143 488 ) resistor r=3.1 //w=0.17 //l=0.51 //layer=mcon //count=3 \
 //x=84.11 //y=0.18 //x2=84.11 //y2=0.18
r1506 (  143 145 ) resistor r=0.446141 //w=0.311 //l=1.11 //layer=m1 \
 //thickness=0.36 //x=84.11 //y=0.175 //x2=85.22 //y2=0.175
r1507 (  141 480 ) resistor r=3.1 //w=0.17 //l=0.51 //layer=mcon //count=3 \
 //x=83 //y=0.18 //x2=83 //y2=0.18
r1508 (  141 143 ) resistor r=0.446141 //w=0.311 //l=1.11 //layer=m1 \
 //thickness=0.36 //x=83 //y=0.175 //x2=84.11 //y2=0.175
r1509 (  139 474 ) resistor r=3.1 //w=0.17 //l=0.51 //layer=mcon //count=3 \
 //x=81.52 //y=0.18 //x2=81.52 //y2=0.18
r1510 (  139 141 ) resistor r=0.594855 //w=0.311 //l=1.48 //layer=m1 \
 //thickness=0.36 //x=81.52 //y=0.175 //x2=83 //y2=0.175
r1511 (  137 472 ) resistor r=3.1 //w=0.17 //l=0.51 //layer=mcon //count=3 \
 //x=80.41 //y=0.18 //x2=80.41 //y2=0.18
r1512 (  137 139 ) resistor r=0.446141 //w=0.311 //l=1.11 //layer=m1 \
 //thickness=0.36 //x=80.41 //y=0.175 //x2=81.52 //y2=0.175
r1513 (  135 470 ) resistor r=3.1 //w=0.17 //l=0.51 //layer=mcon //count=3 \
 //x=79.3 //y=0.18 //x2=79.3 //y2=0.18
r1514 (  135 137 ) resistor r=0.446141 //w=0.311 //l=1.11 //layer=m1 \
 //thickness=0.36 //x=79.3 //y=0.175 //x2=80.41 //y2=0.175
r1515 (  133 462 ) resistor r=3.1 //w=0.17 //l=0.51 //layer=mcon //count=3 \
 //x=78.19 //y=0.18 //x2=78.19 //y2=0.18
r1516 (  133 135 ) resistor r=0.446141 //w=0.311 //l=1.11 //layer=m1 \
 //thickness=0.36 //x=78.19 //y=0.175 //x2=79.3 //y2=0.175
r1517 (  131 456 ) resistor r=3.1 //w=0.17 //l=0.51 //layer=mcon //count=3 \
 //x=76.71 //y=0.18 //x2=76.71 //y2=0.18
r1518 (  131 133 ) resistor r=0.594855 //w=0.311 //l=1.48 //layer=m1 \
 //thickness=0.36 //x=76.71 //y=0.175 //x2=78.19 //y2=0.175
r1519 (  129 454 ) resistor r=3.1 //w=0.17 //l=0.51 //layer=mcon //count=3 \
 //x=75.6 //y=0.18 //x2=75.6 //y2=0.18
r1520 (  129 131 ) resistor r=0.446141 //w=0.311 //l=1.11 //layer=m1 \
 //thickness=0.36 //x=75.6 //y=0.175 //x2=76.71 //y2=0.175
r1521 (  127 452 ) resistor r=3.1 //w=0.17 //l=0.51 //layer=mcon //count=3 \
 //x=74.49 //y=0.18 //x2=74.49 //y2=0.18
r1522 (  127 129 ) resistor r=0.446141 //w=0.311 //l=1.11 //layer=m1 \
 //thickness=0.36 //x=74.49 //y=0.175 //x2=75.6 //y2=0.175
r1523 (  125 444 ) resistor r=3.1 //w=0.17 //l=0.51 //layer=mcon //count=3 \
 //x=73.38 //y=0.18 //x2=73.38 //y2=0.18
r1524 (  125 127 ) resistor r=0.446141 //w=0.311 //l=1.11 //layer=m1 \
 //thickness=0.36 //x=73.38 //y=0.175 //x2=74.49 //y2=0.175
r1525 (  123 438 ) resistor r=3.1 //w=0.17 //l=0.51 //layer=mcon //count=3 \
 //x=71.9 //y=0.18 //x2=71.9 //y2=0.18
r1526 (  123 125 ) resistor r=0.594855 //w=0.311 //l=1.48 //layer=m1 \
 //thickness=0.36 //x=71.9 //y=0.175 //x2=73.38 //y2=0.175
r1527 (  121 436 ) resistor r=3.1 //w=0.17 //l=0.51 //layer=mcon //count=3 \
 //x=70.79 //y=0.18 //x2=70.79 //y2=0.18
r1528 (  121 123 ) resistor r=0.446141 //w=0.311 //l=1.11 //layer=m1 \
 //thickness=0.36 //x=70.79 //y=0.175 //x2=71.9 //y2=0.175
r1529 (  119 434 ) resistor r=3.1 //w=0.17 //l=0.51 //layer=mcon //count=3 \
 //x=69.68 //y=0.18 //x2=69.68 //y2=0.18
r1530 (  119 121 ) resistor r=0.446141 //w=0.311 //l=1.11 //layer=m1 \
 //thickness=0.36 //x=69.68 //y=0.175 //x2=70.79 //y2=0.175
r1531 (  117 426 ) resistor r=3.1 //w=0.17 //l=0.51 //layer=mcon //count=3 \
 //x=68.57 //y=0.18 //x2=68.57 //y2=0.18
r1532 (  117 119 ) resistor r=0.446141 //w=0.311 //l=1.11 //layer=m1 \
 //thickness=0.36 //x=68.57 //y=0.175 //x2=69.68 //y2=0.175
r1533 (  115 420 ) resistor r=3.1 //w=0.17 //l=0.51 //layer=mcon //count=3 \
 //x=67.09 //y=0.18 //x2=67.09 //y2=0.18
r1534 (  115 117 ) resistor r=0.594855 //w=0.311 //l=1.48 //layer=m1 \
 //thickness=0.36 //x=67.09 //y=0.175 //x2=68.57 //y2=0.175
r1535 (  113 418 ) resistor r=3.1 //w=0.17 //l=0.51 //layer=mcon //count=3 \
 //x=65.98 //y=0.18 //x2=65.98 //y2=0.18
r1536 (  113 115 ) resistor r=0.446141 //w=0.311 //l=1.11 //layer=m1 \
 //thickness=0.36 //x=65.98 //y=0.175 //x2=67.09 //y2=0.175
r1537 (  111 416 ) resistor r=3.1 //w=0.17 //l=0.51 //layer=mcon //count=3 \
 //x=64.87 //y=0.18 //x2=64.87 //y2=0.18
r1538 (  111 113 ) resistor r=0.446141 //w=0.311 //l=1.11 //layer=m1 \
 //thickness=0.36 //x=64.87 //y=0.175 //x2=65.98 //y2=0.175
r1539 (  109 408 ) resistor r=3.1 //w=0.17 //l=0.51 //layer=mcon //count=3 \
 //x=63.76 //y=0.18 //x2=63.76 //y2=0.18
r1540 (  109 111 ) resistor r=0.446141 //w=0.311 //l=1.11 //layer=m1 \
 //thickness=0.36 //x=63.76 //y=0.175 //x2=64.87 //y2=0.175
r1541 (  107 402 ) resistor r=3.1 //w=0.17 //l=0.51 //layer=mcon //count=3 \
 //x=62.28 //y=0.18 //x2=62.28 //y2=0.18
r1542 (  107 109 ) resistor r=0.594855 //w=0.311 //l=1.48 //layer=m1 \
 //thickness=0.36 //x=62.28 //y=0.175 //x2=63.76 //y2=0.175
r1543 (  105 400 ) resistor r=3.1 //w=0.17 //l=0.51 //layer=mcon //count=3 \
 //x=61.17 //y=0.18 //x2=61.17 //y2=0.18
r1544 (  105 107 ) resistor r=0.446141 //w=0.311 //l=1.11 //layer=m1 \
 //thickness=0.36 //x=61.17 //y=0.175 //x2=62.28 //y2=0.175
r1545 (  103 398 ) resistor r=3.1 //w=0.17 //l=0.51 //layer=mcon //count=3 \
 //x=60.06 //y=0.18 //x2=60.06 //y2=0.18
r1546 (  103 105 ) resistor r=0.446141 //w=0.311 //l=1.11 //layer=m1 \
 //thickness=0.36 //x=60.06 //y=0.175 //x2=61.17 //y2=0.175
r1547 (  101 390 ) resistor r=3.1 //w=0.17 //l=0.51 //layer=mcon //count=3 \
 //x=58.95 //y=0.18 //x2=58.95 //y2=0.18
r1548 (  101 103 ) resistor r=0.446141 //w=0.311 //l=1.11 //layer=m1 \
 //thickness=0.36 //x=58.95 //y=0.175 //x2=60.06 //y2=0.175
r1549 (  99 384 ) resistor r=3.1 //w=0.17 //l=0.51 //layer=mcon //count=3 \
 //x=57.47 //y=0.18 //x2=57.47 //y2=0.18
r1550 (  99 101 ) resistor r=0.594855 //w=0.311 //l=1.48 //layer=m1 \
 //thickness=0.36 //x=57.47 //y=0.175 //x2=58.95 //y2=0.175
r1551 (  97 382 ) resistor r=3.1 //w=0.17 //l=0.51 //layer=mcon //count=3 \
 //x=56.36 //y=0.18 //x2=56.36 //y2=0.18
r1552 (  97 99 ) resistor r=0.446141 //w=0.311 //l=1.11 //layer=m1 \
 //thickness=0.36 //x=56.36 //y=0.175 //x2=57.47 //y2=0.175
r1553 (  95 380 ) resistor r=3.1 //w=0.17 //l=0.51 //layer=mcon //count=3 \
 //x=55.25 //y=0.18 //x2=55.25 //y2=0.18
r1554 (  95 97 ) resistor r=0.446141 //w=0.311 //l=1.11 //layer=m1 \
 //thickness=0.36 //x=55.25 //y=0.175 //x2=56.36 //y2=0.175
r1555 (  93 372 ) resistor r=3.1 //w=0.17 //l=0.51 //layer=mcon //count=3 \
 //x=54.14 //y=0.18 //x2=54.14 //y2=0.18
r1556 (  93 95 ) resistor r=0.446141 //w=0.311 //l=1.11 //layer=m1 \
 //thickness=0.36 //x=54.14 //y=0.175 //x2=55.25 //y2=0.175
r1557 (  91 366 ) resistor r=3.1 //w=0.17 //l=0.51 //layer=mcon //count=3 \
 //x=52.66 //y=0.18 //x2=52.66 //y2=0.18
r1558 (  91 93 ) resistor r=0.594855 //w=0.311 //l=1.48 //layer=m1 \
 //thickness=0.36 //x=52.66 //y=0.175 //x2=54.14 //y2=0.175
r1559 (  89 364 ) resistor r=3.1 //w=0.17 //l=0.51 //layer=mcon //count=3 \
 //x=51.55 //y=0.18 //x2=51.55 //y2=0.18
r1560 (  89 91 ) resistor r=0.446141 //w=0.311 //l=1.11 //layer=m1 \
 //thickness=0.36 //x=51.55 //y=0.175 //x2=52.66 //y2=0.175
r1561 (  87 362 ) resistor r=3.1 //w=0.17 //l=0.51 //layer=mcon //count=3 \
 //x=50.44 //y=0.18 //x2=50.44 //y2=0.18
r1562 (  87 89 ) resistor r=0.446141 //w=0.311 //l=1.11 //layer=m1 \
 //thickness=0.36 //x=50.44 //y=0.175 //x2=51.55 //y2=0.175
r1563 (  84 354 ) resistor r=3.1 //w=0.17 //l=0.51 //layer=mcon //count=3 \
 //x=49.33 //y=0.18 //x2=49.33 //y2=0.18
r1564 (  82 348 ) resistor r=3.1 //w=0.17 //l=0.51 //layer=mcon //count=3 \
 //x=47.85 //y=0.18 //x2=47.85 //y2=0.18
r1565 (  82 84 ) resistor r=0.594855 //w=0.311 //l=1.48 //layer=m1 \
 //thickness=0.36 //x=47.85 //y=0.175 //x2=49.33 //y2=0.175
r1566 (  80 346 ) resistor r=3.1 //w=0.17 //l=0.51 //layer=mcon //count=3 \
 //x=46.74 //y=0.18 //x2=46.74 //y2=0.18
r1567 (  80 82 ) resistor r=0.446141 //w=0.311 //l=1.11 //layer=m1 \
 //thickness=0.36 //x=46.74 //y=0.175 //x2=47.85 //y2=0.175
r1568 (  78 344 ) resistor r=3.1 //w=0.17 //l=0.51 //layer=mcon //count=3 \
 //x=45.63 //y=0.18 //x2=45.63 //y2=0.18
r1569 (  78 80 ) resistor r=0.446141 //w=0.311 //l=1.11 //layer=m1 \
 //thickness=0.36 //x=45.63 //y=0.175 //x2=46.74 //y2=0.175
r1570 (  76 336 ) resistor r=3.1 //w=0.17 //l=0.51 //layer=mcon //count=3 \
 //x=44.52 //y=0.18 //x2=44.52 //y2=0.18
r1571 (  76 78 ) resistor r=0.446141 //w=0.311 //l=1.11 //layer=m1 \
 //thickness=0.36 //x=44.52 //y=0.175 //x2=45.63 //y2=0.175
r1572 (  74 330 ) resistor r=3.1 //w=0.17 //l=0.51 //layer=mcon //count=3 \
 //x=43.04 //y=0.18 //x2=43.04 //y2=0.18
r1573 (  74 76 ) resistor r=0.594855 //w=0.311 //l=1.48 //layer=m1 \
 //thickness=0.36 //x=43.04 //y=0.175 //x2=44.52 //y2=0.175
r1574 (  72 328 ) resistor r=3.1 //w=0.17 //l=0.51 //layer=mcon //count=3 \
 //x=41.93 //y=0.18 //x2=41.93 //y2=0.18
r1575 (  72 74 ) resistor r=0.446141 //w=0.311 //l=1.11 //layer=m1 \
 //thickness=0.36 //x=41.93 //y=0.175 //x2=43.04 //y2=0.175
r1576 (  70 326 ) resistor r=3.1 //w=0.17 //l=0.51 //layer=mcon //count=3 \
 //x=40.82 //y=0.18 //x2=40.82 //y2=0.18
r1577 (  70 72 ) resistor r=0.446141 //w=0.311 //l=1.11 //layer=m1 \
 //thickness=0.36 //x=40.82 //y=0.175 //x2=41.93 //y2=0.175
r1578 (  68 318 ) resistor r=3.1 //w=0.17 //l=0.51 //layer=mcon //count=3 \
 //x=39.71 //y=0.18 //x2=39.71 //y2=0.18
r1579 (  68 70 ) resistor r=0.446141 //w=0.311 //l=1.11 //layer=m1 \
 //thickness=0.36 //x=39.71 //y=0.175 //x2=40.82 //y2=0.175
r1580 (  66 312 ) resistor r=3.1 //w=0.17 //l=0.51 //layer=mcon //count=3 \
 //x=38.23 //y=0.18 //x2=38.23 //y2=0.18
r1581 (  66 68 ) resistor r=0.594855 //w=0.311 //l=1.48 //layer=m1 \
 //thickness=0.36 //x=38.23 //y=0.175 //x2=39.71 //y2=0.175
r1582 (  64 310 ) resistor r=3.1 //w=0.17 //l=0.51 //layer=mcon //count=3 \
 //x=37.12 //y=0.18 //x2=37.12 //y2=0.18
r1583 (  64 66 ) resistor r=0.446141 //w=0.311 //l=1.11 //layer=m1 \
 //thickness=0.36 //x=37.12 //y=0.175 //x2=38.23 //y2=0.175
r1584 (  62 308 ) resistor r=3.1 //w=0.17 //l=0.51 //layer=mcon //count=3 \
 //x=36.01 //y=0.18 //x2=36.01 //y2=0.18
r1585 (  62 64 ) resistor r=0.446141 //w=0.311 //l=1.11 //layer=m1 \
 //thickness=0.36 //x=36.01 //y=0.175 //x2=37.12 //y2=0.175
r1586 (  60 300 ) resistor r=3.1 //w=0.17 //l=0.51 //layer=mcon //count=3 \
 //x=34.9 //y=0.18 //x2=34.9 //y2=0.18
r1587 (  60 62 ) resistor r=0.446141 //w=0.311 //l=1.11 //layer=m1 \
 //thickness=0.36 //x=34.9 //y=0.175 //x2=36.01 //y2=0.175
r1588 (  58 294 ) resistor r=3.1 //w=0.17 //l=0.51 //layer=mcon //count=3 \
 //x=33.42 //y=0.18 //x2=33.42 //y2=0.18
r1589 (  58 60 ) resistor r=0.594855 //w=0.311 //l=1.48 //layer=m1 \
 //thickness=0.36 //x=33.42 //y=0.175 //x2=34.9 //y2=0.175
r1590 (  56 292 ) resistor r=3.1 //w=0.17 //l=0.51 //layer=mcon //count=3 \
 //x=32.31 //y=0.18 //x2=32.31 //y2=0.18
r1591 (  56 58 ) resistor r=0.446141 //w=0.311 //l=1.11 //layer=m1 \
 //thickness=0.36 //x=32.31 //y=0.175 //x2=33.42 //y2=0.175
r1592 (  54 290 ) resistor r=3.1 //w=0.17 //l=0.51 //layer=mcon //count=3 \
 //x=31.2 //y=0.18 //x2=31.2 //y2=0.18
r1593 (  54 56 ) resistor r=0.446141 //w=0.311 //l=1.11 //layer=m1 \
 //thickness=0.36 //x=31.2 //y=0.175 //x2=32.31 //y2=0.175
r1594 (  52 282 ) resistor r=3.1 //w=0.17 //l=0.51 //layer=mcon //count=3 \
 //x=30.09 //y=0.18 //x2=30.09 //y2=0.18
r1595 (  52 54 ) resistor r=0.446141 //w=0.311 //l=1.11 //layer=m1 \
 //thickness=0.36 //x=30.09 //y=0.175 //x2=31.2 //y2=0.175
r1596 (  50 276 ) resistor r=3.1 //w=0.17 //l=0.51 //layer=mcon //count=3 \
 //x=28.61 //y=0.18 //x2=28.61 //y2=0.18
r1597 (  50 52 ) resistor r=0.594855 //w=0.311 //l=1.48 //layer=m1 \
 //thickness=0.36 //x=28.61 //y=0.175 //x2=30.09 //y2=0.175
r1598 (  48 274 ) resistor r=3.1 //w=0.17 //l=0.51 //layer=mcon //count=3 \
 //x=27.5 //y=0.18 //x2=27.5 //y2=0.18
r1599 (  48 50 ) resistor r=0.446141 //w=0.311 //l=1.11 //layer=m1 \
 //thickness=0.36 //x=27.5 //y=0.175 //x2=28.61 //y2=0.175
r1600 (  46 272 ) resistor r=3.1 //w=0.17 //l=0.51 //layer=mcon //count=3 \
 //x=26.39 //y=0.18 //x2=26.39 //y2=0.18
r1601 (  46 48 ) resistor r=0.446141 //w=0.311 //l=1.11 //layer=m1 \
 //thickness=0.36 //x=26.39 //y=0.175 //x2=27.5 //y2=0.175
r1602 (  44 264 ) resistor r=3.1 //w=0.17 //l=0.51 //layer=mcon //count=3 \
 //x=25.28 //y=0.18 //x2=25.28 //y2=0.18
r1603 (  44 46 ) resistor r=0.446141 //w=0.311 //l=1.11 //layer=m1 \
 //thickness=0.36 //x=25.28 //y=0.175 //x2=26.39 //y2=0.175
r1604 (  42 258 ) resistor r=3.1 //w=0.17 //l=0.51 //layer=mcon //count=3 \
 //x=23.8 //y=0.18 //x2=23.8 //y2=0.18
r1605 (  42 44 ) resistor r=0.594855 //w=0.311 //l=1.48 //layer=m1 \
 //thickness=0.36 //x=23.8 //y=0.175 //x2=25.28 //y2=0.175
r1606 (  40 256 ) resistor r=3.1 //w=0.17 //l=0.51 //layer=mcon //count=3 \
 //x=22.69 //y=0.18 //x2=22.69 //y2=0.18
r1607 (  40 42 ) resistor r=0.446141 //w=0.311 //l=1.11 //layer=m1 \
 //thickness=0.36 //x=22.69 //y=0.175 //x2=23.8 //y2=0.175
r1608 (  38 254 ) resistor r=3.1 //w=0.17 //l=0.51 //layer=mcon //count=3 \
 //x=21.58 //y=0.18 //x2=21.58 //y2=0.18
r1609 (  38 40 ) resistor r=0.446141 //w=0.311 //l=1.11 //layer=m1 \
 //thickness=0.36 //x=21.58 //y=0.175 //x2=22.69 //y2=0.175
r1610 (  36 246 ) resistor r=3.1 //w=0.17 //l=0.51 //layer=mcon //count=3 \
 //x=20.47 //y=0.18 //x2=20.47 //y2=0.18
r1611 (  36 38 ) resistor r=0.446141 //w=0.311 //l=1.11 //layer=m1 \
 //thickness=0.36 //x=20.47 //y=0.175 //x2=21.58 //y2=0.175
r1612 (  34 240 ) resistor r=3.1 //w=0.17 //l=0.51 //layer=mcon //count=3 \
 //x=18.99 //y=0.18 //x2=18.99 //y2=0.18
r1613 (  34 36 ) resistor r=0.594855 //w=0.311 //l=1.48 //layer=m1 \
 //thickness=0.36 //x=18.99 //y=0.175 //x2=20.47 //y2=0.175
r1614 (  32 238 ) resistor r=3.1 //w=0.17 //l=0.51 //layer=mcon //count=3 \
 //x=17.88 //y=0.18 //x2=17.88 //y2=0.18
r1615 (  32 34 ) resistor r=0.446141 //w=0.311 //l=1.11 //layer=m1 \
 //thickness=0.36 //x=17.88 //y=0.175 //x2=18.99 //y2=0.175
r1616 (  30 236 ) resistor r=3.1 //w=0.17 //l=0.51 //layer=mcon //count=3 \
 //x=16.77 //y=0.18 //x2=16.77 //y2=0.18
r1617 (  30 32 ) resistor r=0.446141 //w=0.311 //l=1.11 //layer=m1 \
 //thickness=0.36 //x=16.77 //y=0.175 //x2=17.88 //y2=0.175
r1618 (  28 228 ) resistor r=3.1 //w=0.17 //l=0.51 //layer=mcon //count=3 \
 //x=15.66 //y=0.18 //x2=15.66 //y2=0.18
r1619 (  28 30 ) resistor r=0.446141 //w=0.311 //l=1.11 //layer=m1 \
 //thickness=0.36 //x=15.66 //y=0.175 //x2=16.77 //y2=0.175
r1620 (  26 222 ) resistor r=3.1 //w=0.17 //l=0.51 //layer=mcon //count=3 \
 //x=14.18 //y=0.18 //x2=14.18 //y2=0.18
r1621 (  26 28 ) resistor r=0.594855 //w=0.311 //l=1.48 //layer=m1 \
 //thickness=0.36 //x=14.18 //y=0.175 //x2=15.66 //y2=0.175
r1622 (  24 220 ) resistor r=3.1 //w=0.17 //l=0.51 //layer=mcon //count=3 \
 //x=13.07 //y=0.18 //x2=13.07 //y2=0.18
r1623 (  24 26 ) resistor r=0.446141 //w=0.311 //l=1.11 //layer=m1 \
 //thickness=0.36 //x=13.07 //y=0.175 //x2=14.18 //y2=0.175
r1624 (  22 218 ) resistor r=3.1 //w=0.17 //l=0.51 //layer=mcon //count=3 \
 //x=11.96 //y=0.18 //x2=11.96 //y2=0.18
r1625 (  22 24 ) resistor r=0.446141 //w=0.311 //l=1.11 //layer=m1 \
 //thickness=0.36 //x=11.96 //y=0.175 //x2=13.07 //y2=0.175
r1626 (  20 210 ) resistor r=3.1 //w=0.17 //l=0.51 //layer=mcon //count=3 \
 //x=10.85 //y=0.18 //x2=10.85 //y2=0.18
r1627 (  20 22 ) resistor r=0.446141 //w=0.311 //l=1.11 //layer=m1 \
 //thickness=0.36 //x=10.85 //y=0.175 //x2=11.96 //y2=0.175
r1628 (  18 204 ) resistor r=3.1 //w=0.17 //l=0.51 //layer=mcon //count=3 \
 //x=9.37 //y=0.18 //x2=9.37 //y2=0.18
r1629 (  18 20 ) resistor r=0.594855 //w=0.311 //l=1.48 //layer=m1 \
 //thickness=0.36 //x=9.37 //y=0.175 //x2=10.85 //y2=0.175
r1630 (  16 202 ) resistor r=3.1 //w=0.17 //l=0.51 //layer=mcon //count=3 \
 //x=8.26 //y=0.18 //x2=8.26 //y2=0.18
r1631 (  16 18 ) resistor r=0.446141 //w=0.311 //l=1.11 //layer=m1 \
 //thickness=0.36 //x=8.26 //y=0.175 //x2=9.37 //y2=0.175
r1632 (  14 200 ) resistor r=3.1 //w=0.17 //l=0.51 //layer=mcon //count=3 \
 //x=7.15 //y=0.18 //x2=7.15 //y2=0.18
r1633 (  14 16 ) resistor r=0.446141 //w=0.311 //l=1.11 //layer=m1 \
 //thickness=0.36 //x=7.15 //y=0.175 //x2=8.26 //y2=0.175
r1634 (  12 192 ) resistor r=3.1 //w=0.17 //l=0.51 //layer=mcon //count=3 \
 //x=6.04 //y=0.18 //x2=6.04 //y2=0.18
r1635 (  12 14 ) resistor r=0.446141 //w=0.311 //l=1.11 //layer=m1 \
 //thickness=0.36 //x=6.04 //y=0.175 //x2=7.15 //y2=0.175
r1636 (  10 186 ) resistor r=3.1 //w=0.17 //l=0.51 //layer=mcon //count=3 \
 //x=4.56 //y=0.18 //x2=4.56 //y2=0.18
r1637 (  10 12 ) resistor r=0.594855 //w=0.311 //l=1.48 //layer=m1 \
 //thickness=0.36 //x=4.56 //y=0.175 //x2=6.04 //y2=0.175
r1638 (  8 184 ) resistor r=3.1 //w=0.17 //l=0.51 //layer=mcon //count=3 \
 //x=3.45 //y=0.18 //x2=3.45 //y2=0.18
r1639 (  8 10 ) resistor r=0.446141 //w=0.311 //l=1.11 //layer=m1 \
 //thickness=0.36 //x=3.45 //y=0.175 //x2=4.56 //y2=0.175
r1640 (  6 182 ) resistor r=3.1 //w=0.17 //l=0.51 //layer=mcon //count=3 \
 //x=2.34 //y=0.18 //x2=2.34 //y2=0.18
r1641 (  6 8 ) resistor r=0.446141 //w=0.311 //l=1.11 //layer=m1 \
 //thickness=0.36 //x=2.34 //y=0.175 //x2=3.45 //y2=0.175
r1642 (  3 174 ) resistor r=3.1 //w=0.17 //l=0.51 //layer=mcon //count=3 \
 //x=1.23 //y=0.18 //x2=1.23 //y2=0.18
r1643 (  3 6 ) resistor r=0.446141 //w=0.311 //l=1.11 //layer=m1 \
 //thickness=0.36 //x=1.23 //y=0.175 //x2=2.34 //y2=0.175
r1644 (  1 87 ) resistor r=0.223071 //w=0.311 //l=0.555 //layer=m1 \
 //thickness=0.36 //x=49.885 //y=0.175 //x2=50.44 //y2=0.175
r1645 (  1 84 ) resistor r=0.223071 //w=0.311 //l=0.555 //layer=m1 \
 //thickness=0.36 //x=49.885 //y=0.175 //x2=49.33 //y2=0.175
ends PM_TMRDFFSNRNQX1\%GND

subckt PM_TMRDFFSNRNQX1\%VDD ( 1 167 171 174 181 191 199 209 215 225 235 243 \
 253 259 269 279 287 297 303 313 323 331 341 347 357 367 375 385 391 401 411 \
 419 429 435 445 455 463 473 479 489 499 507 517 523 533 543 551 561 567 577 \
 587 595 605 611 621 631 639 649 655 665 675 683 693 699 709 719 727 737 743 \
 753 763 771 781 787 797 807 815 825 831 841 851 859 869 875 885 895 903 913 \
 919 929 939 947 957 963 971 979 989 995 1003 1013 1021 1037 1042 1047 1052 \
 1057 1062 1067 1072 1077 1082 1087 1092 1097 1102 1107 1112 1117 1122 1127 \
 1128 1129 1133 1134 1135 1136 1137 1138 1139 1140 1141 1142 1143 1144 1145 \
 1146 1147 1148 1149 1150 1151 1152 1153 1154 1155 1156 1157 1158 1159 1160 \
 1161 1162 1163 1164 1165 1166 1167 1168 1169 1170 1171 1172 1173 1174 1175 \
 1176 1177 1178 1179 1180 1181 1182 1183 1184 1185 1186 1187 1188 1189 1190 \
 1191 1192 1193 1194 1195 1196 1197 1198 1199 1200 1201 1202 1203 1204 1205 \
 1206 1207 1208 1209 1210 )
c1196 ( 1210 0 ) capacitor c=0.0433931f //x=98.47 //y=5.2
c1197 ( 1209 0 ) capacitor c=0.0420334f //x=97.6 //y=5.2
c1198 ( 1208 0 ) capacitor c=0.0476809f //x=89.475 //y=5.205
c1199 ( 1207 0 ) capacitor c=0.0241715f //x=88.595 //y=5.205
c1200 ( 1206 0 ) capacitor c=0.0467094f //x=87.725 //y=5.205
c1201 ( 1205 0 ) capacitor c=0.045218f //x=85.845 //y=5.2
c1202 ( 1204 0 ) capacitor c=0.0241521f //x=84.965 //y=5.2
c1203 ( 1203 0 ) capacitor c=0.0241521f //x=84.085 //y=5.2
c1204 ( 1202 0 ) capacitor c=0.053132f //x=83.215 //y=5.2
c1205 ( 1201 0 ) capacitor c=0.045218f //x=81.035 //y=5.2
c1206 ( 1200 0 ) capacitor c=0.0241521f //x=80.155 //y=5.2
c1207 ( 1199 0 ) capacitor c=0.0241521f //x=79.275 //y=5.2
c1208 ( 1198 0 ) capacitor c=0.053132f //x=78.405 //y=5.2
c1209 ( 1197 0 ) capacitor c=0.045218f //x=76.225 //y=5.2
c1210 ( 1196 0 ) capacitor c=0.0240372f //x=75.345 //y=5.2
c1211 ( 1195 0 ) capacitor c=0.0240372f //x=74.465 //y=5.2
c1212 ( 1194 0 ) capacitor c=0.0530795f //x=73.595 //y=5.2
c1213 ( 1193 0 ) capacitor c=0.0451031f //x=71.415 //y=5.2
c1214 ( 1192 0 ) capacitor c=0.0240372f //x=70.535 //y=5.2
c1215 ( 1191 0 ) capacitor c=0.0240372f //x=69.655 //y=5.2
c1216 ( 1190 0 ) capacitor c=0.0530795f //x=68.785 //y=5.2
c1217 ( 1189 0 ) capacitor c=0.0451031f //x=66.605 //y=5.2
c1218 ( 1188 0 ) capacitor c=0.0240372f //x=65.725 //y=5.2
c1219 ( 1187 0 ) capacitor c=0.0240372f //x=64.845 //y=5.2
c1220 ( 1186 0 ) capacitor c=0.0530795f //x=63.975 //y=5.2
c1221 ( 1185 0 ) capacitor c=0.0451031f //x=61.795 //y=5.2
c1222 ( 1184 0 ) capacitor c=0.0240372f //x=60.915 //y=5.2
c1223 ( 1183 0 ) capacitor c=0.0240372f //x=60.035 //y=5.2
c1224 ( 1182 0 ) capacitor c=0.0530795f //x=59.165 //y=5.2
c1225 ( 1181 0 ) capacitor c=0.0451031f //x=56.985 //y=5.2
c1226 ( 1180 0 ) capacitor c=0.0240372f //x=56.105 //y=5.2
c1227 ( 1179 0 ) capacitor c=0.0240372f //x=55.225 //y=5.2
c1228 ( 1178 0 ) capacitor c=0.0530795f //x=54.355 //y=5.2
c1229 ( 1177 0 ) capacitor c=0.0451031f //x=52.175 //y=5.2
c1230 ( 1176 0 ) capacitor c=0.0240372f //x=51.295 //y=5.2
c1231 ( 1175 0 ) capacitor c=0.0240372f //x=50.415 //y=5.2
c1232 ( 1174 0 ) capacitor c=0.0530795f //x=49.545 //y=5.2
c1233 ( 1173 0 ) capacitor c=0.0451031f //x=47.365 //y=5.2
c1234 ( 1172 0 ) capacitor c=0.0240372f //x=46.485 //y=5.2
c1235 ( 1171 0 ) capacitor c=0.0240372f //x=45.605 //y=5.2
c1236 ( 1170 0 ) capacitor c=0.0530795f //x=44.735 //y=5.2
c1237 ( 1169 0 ) capacitor c=0.0451031f //x=42.555 //y=5.2
c1238 ( 1168 0 ) capacitor c=0.0240372f //x=41.675 //y=5.2
c1239 ( 1167 0 ) capacitor c=0.0240372f //x=40.795 //y=5.2
c1240 ( 1166 0 ) capacitor c=0.0530795f //x=39.925 //y=5.2
c1241 ( 1165 0 ) capacitor c=0.0451031f //x=37.745 //y=5.2
c1242 ( 1164 0 ) capacitor c=0.0240372f //x=36.865 //y=5.2
c1243 ( 1163 0 ) capacitor c=0.0240372f //x=35.985 //y=5.2
c1244 ( 1162 0 ) capacitor c=0.0530795f //x=35.115 //y=5.2
c1245 ( 1161 0 ) capacitor c=0.0451031f //x=32.935 //y=5.2
c1246 ( 1160 0 ) capacitor c=0.0240372f //x=32.055 //y=5.2
c1247 ( 1159 0 ) capacitor c=0.0240372f //x=31.175 //y=5.2
c1248 ( 1158 0 ) capacitor c=0.0530795f //x=30.305 //y=5.2
c1249 ( 1157 0 ) capacitor c=0.045218f //x=28.125 //y=5.2
c1250 ( 1156 0 ) capacitor c=0.0241521f //x=27.245 //y=5.2
c1251 ( 1155 0 ) capacitor c=0.0241521f //x=26.365 //y=5.2
c1252 ( 1154 0 ) capacitor c=0.053132f //x=25.495 //y=5.2
c1253 ( 1153 0 ) capacitor c=0.045218f //x=23.315 //y=5.2
c1254 ( 1152 0 ) capacitor c=0.0241521f //x=22.435 //y=5.2
c1255 ( 1151 0 ) capacitor c=0.0241521f //x=21.555 //y=5.2
c1256 ( 1150 0 ) capacitor c=0.053132f //x=20.685 //y=5.2
c1257 ( 1149 0 ) capacitor c=0.045218f //x=18.505 //y=5.2
c1258 ( 1148 0 ) capacitor c=0.0241521f //x=17.625 //y=5.2
c1259 ( 1147 0 ) capacitor c=0.0241521f //x=16.745 //y=5.2
c1260 ( 1146 0 ) capacitor c=0.053132f //x=15.875 //y=5.2
c1261 ( 1145 0 ) capacitor c=0.045218f //x=13.695 //y=5.2
c1262 ( 1144 0 ) capacitor c=0.0241521f //x=12.815 //y=5.2
c1263 ( 1143 0 ) capacitor c=0.0241521f //x=11.935 //y=5.2
c1264 ( 1142 0 ) capacitor c=0.053132f //x=11.065 //y=5.2
c1265 ( 1141 0 ) capacitor c=0.045218f //x=8.885 //y=5.2
c1266 ( 1140 0 ) capacitor c=0.0241521f //x=8.005 //y=5.2
c1267 ( 1139 0 ) capacitor c=0.0242401f //x=7.125 //y=5.2
c1268 ( 1138 0 ) capacitor c=0.0531794f //x=6.255 //y=5.2
c1269 ( 1137 0 ) capacitor c=0.045306f //x=4.075 //y=5.2
c1270 ( 1136 0 ) capacitor c=0.0242401f //x=3.195 //y=5.2
c1271 ( 1135 0 ) capacitor c=0.0242401f //x=2.315 //y=5.2
c1272 ( 1134 0 ) capacitor c=0.0531407f //x=1.445 //y=5.2
c1273 ( 1133 0 ) capacitor c=0.252867f //x=98.54 //y=7.58
c1274 ( 1131 0 ) capacitor c=0.00597439f //x=97.8 //y=7.58
c1275 ( 1129 0 ) capacitor c=0.107782f //x=97.06 //y=7.585
c1276 ( 1128 0 ) capacitor c=0.113453f //x=93.73 //y=7.585
c1277 ( 1127 0 ) capacitor c=0.121512f //x=90.4 //y=7.585
c1278 ( 1126 0 ) capacitor c=0.00597439f //x=89.62 //y=7.585
c1279 ( 1125 0 ) capacitor c=0.00597439f //x=88.74 //y=7.585
c1280 ( 1124 0 ) capacitor c=0.00597439f //x=87.81 //y=7.58
c1281 ( 1122 0 ) capacitor c=0.133098f //x=87.07 //y=7.585
c1282 ( 1121 0 ) capacitor c=0.00597439f //x=85.99 //y=7.585
c1283 ( 1120 0 ) capacitor c=0.00597439f //x=85.11 //y=7.585
c1284 ( 1119 0 ) capacitor c=0.00597439f //x=84.23 //y=7.585
c1285 ( 1118 0 ) capacitor c=0.00597439f //x=83.35 //y=7.585
c1286 ( 1117 0 ) capacitor c=0.15536f //x=82.26 //y=7.585
c1287 ( 1116 0 ) capacitor c=0.00597439f //x=81.18 //y=7.585
c1288 ( 1115 0 ) capacitor c=0.00597439f //x=80.3 //y=7.585
c1289 ( 1114 0 ) capacitor c=0.00597439f //x=79.42 //y=7.585
c1290 ( 1113 0 ) capacitor c=0.00597439f //x=78.54 //y=7.585
c1291 ( 1112 0 ) capacitor c=0.15481f //x=77.45 //y=7.585
c1292 ( 1111 0 ) capacitor c=0.00597439f //x=76.37 //y=7.585
c1293 ( 1110 0 ) capacitor c=0.00597439f //x=75.49 //y=7.585
c1294 ( 1109 0 ) capacitor c=0.00597439f //x=74.61 //y=7.585
c1295 ( 1108 0 ) capacitor c=0.00597439f //x=73.73 //y=7.585
c1296 ( 1107 0 ) capacitor c=0.153845f //x=72.64 //y=7.585
c1297 ( 1106 0 ) capacitor c=0.00597439f //x=71.56 //y=7.585
c1298 ( 1105 0 ) capacitor c=0.00597439f //x=70.68 //y=7.585
c1299 ( 1104 0 ) capacitor c=0.00597439f //x=69.8 //y=7.585
c1300 ( 1103 0 ) capacitor c=0.00597439f //x=68.92 //y=7.585
c1301 ( 1102 0 ) capacitor c=0.153927f //x=67.83 //y=7.585
c1302 ( 1101 0 ) capacitor c=0.00597439f //x=66.75 //y=7.585
c1303 ( 1100 0 ) capacitor c=0.00597439f //x=65.87 //y=7.585
c1304 ( 1099 0 ) capacitor c=0.00597439f //x=64.99 //y=7.585
c1305 ( 1098 0 ) capacitor c=0.00597439f //x=64.11 //y=7.585
c1306 ( 1097 0 ) capacitor c=0.158415f //x=63.02 //y=7.585
c1307 ( 1096 0 ) capacitor c=0.00597439f //x=61.94 //y=7.585
c1308 ( 1095 0 ) capacitor c=0.00597439f //x=61.06 //y=7.585
c1309 ( 1094 0 ) capacitor c=0.00597439f //x=60.18 //y=7.585
c1310 ( 1093 0 ) capacitor c=0.00597439f //x=59.3 //y=7.585
c1311 ( 1092 0 ) capacitor c=0.153864f //x=58.21 //y=7.585
c1312 ( 1091 0 ) capacitor c=0.00597439f //x=57.13 //y=7.585
c1313 ( 1090 0 ) capacitor c=0.00597439f //x=56.25 //y=7.585
c1314 ( 1089 0 ) capacitor c=0.00597439f //x=55.37 //y=7.585
c1315 ( 1088 0 ) capacitor c=0.00597439f //x=54.49 //y=7.585
c1316 ( 1087 0 ) capacitor c=0.153973f //x=53.4 //y=7.585
c1317 ( 1086 0 ) capacitor c=0.00597439f //x=52.32 //y=7.585
c1318 ( 1085 0 ) capacitor c=0.00597439f //x=51.44 //y=7.585
c1319 ( 1084 0 ) capacitor c=0.00597439f //x=50.56 //y=7.585
c1320 ( 1083 0 ) capacitor c=0.00597439f //x=49.68 //y=7.585
c1321 ( 1082 0 ) capacitor c=0.153927f //x=48.59 //y=7.585
c1322 ( 1081 0 ) capacitor c=0.00597439f //x=47.51 //y=7.585
c1323 ( 1080 0 ) capacitor c=0.00597439f //x=46.63 //y=7.585
c1324 ( 1079 0 ) capacitor c=0.00597439f //x=45.75 //y=7.585
c1325 ( 1078 0 ) capacitor c=0.00597439f //x=44.87 //y=7.585
c1326 ( 1077 0 ) capacitor c=0.153903f //x=43.78 //y=7.585
c1327 ( 1076 0 ) capacitor c=0.00597439f //x=42.7 //y=7.585
c1328 ( 1075 0 ) capacitor c=0.00597439f //x=41.82 //y=7.585
c1329 ( 1074 0 ) capacitor c=0.00597439f //x=40.94 //y=7.585
c1330 ( 1073 0 ) capacitor c=0.00597439f //x=40.06 //y=7.585
c1331 ( 1072 0 ) capacitor c=0.153927f //x=38.97 //y=7.585
c1332 ( 1071 0 ) capacitor c=0.00597439f //x=37.89 //y=7.585
c1333 ( 1070 0 ) capacitor c=0.00597439f //x=37.01 //y=7.585
c1334 ( 1069 0 ) capacitor c=0.00597439f //x=36.13 //y=7.585
c1335 ( 1068 0 ) capacitor c=0.00597439f //x=35.25 //y=7.585
c1336 ( 1067 0 ) capacitor c=0.15408f //x=34.16 //y=7.585
c1337 ( 1066 0 ) capacitor c=0.00597439f //x=33.08 //y=7.585
c1338 ( 1065 0 ) capacitor c=0.00597439f //x=32.2 //y=7.585
c1339 ( 1064 0 ) capacitor c=0.00597439f //x=31.32 //y=7.585
c1340 ( 1063 0 ) capacitor c=0.00597439f //x=30.44 //y=7.585
c1341 ( 1062 0 ) capacitor c=0.15396f //x=29.35 //y=7.585
c1342 ( 1061 0 ) capacitor c=0.00597439f //x=28.27 //y=7.585
c1343 ( 1060 0 ) capacitor c=0.00597439f //x=27.39 //y=7.585
c1344 ( 1059 0 ) capacitor c=0.00597439f //x=26.51 //y=7.585
c1345 ( 1058 0 ) capacitor c=0.00597439f //x=25.63 //y=7.585
c1346 ( 1057 0 ) capacitor c=0.15536f //x=24.54 //y=7.585
c1347 ( 1056 0 ) capacitor c=0.00597439f //x=23.46 //y=7.585
c1348 ( 1055 0 ) capacitor c=0.00597439f //x=22.58 //y=7.585
c1349 ( 1054 0 ) capacitor c=0.00597439f //x=21.7 //y=7.585
c1350 ( 1053 0 ) capacitor c=0.00597439f //x=20.82 //y=7.585
c1351 ( 1052 0 ) capacitor c=0.155314f //x=19.73 //y=7.585
c1352 ( 1051 0 ) capacitor c=0.00597439f //x=18.65 //y=7.585
c1353 ( 1050 0 ) capacitor c=0.00597439f //x=17.77 //y=7.585
c1354 ( 1049 0 ) capacitor c=0.00597439f //x=16.89 //y=7.585
c1355 ( 1048 0 ) capacitor c=0.00597439f //x=16.01 //y=7.585
c1356 ( 1047 0 ) capacitor c=0.15529f //x=14.92 //y=7.585
c1357 ( 1046 0 ) capacitor c=0.00597439f //x=13.84 //y=7.585
c1358 ( 1045 0 ) capacitor c=0.00597439f //x=12.96 //y=7.585
c1359 ( 1044 0 ) capacitor c=0.00597439f //x=12.08 //y=7.585
c1360 ( 1043 0 ) capacitor c=0.00597439f //x=11.2 //y=7.585
c1361 ( 1042 0 ) capacitor c=0.155314f //x=10.11 //y=7.585
c1362 ( 1041 0 ) capacitor c=0.00597439f //x=9.03 //y=7.585
c1363 ( 1040 0 ) capacitor c=0.00597439f //x=8.15 //y=7.585
c1364 ( 1039 0 ) capacitor c=0.00597439f //x=7.27 //y=7.585
c1365 ( 1038 0 ) capacitor c=0.00597439f //x=6.39 //y=7.585
c1366 ( 1037 0 ) capacitor c=0.157412f //x=5.3 //y=7.585
c1367 ( 1036 0 ) capacitor c=0.00597439f //x=4.22 //y=7.585
c1368 ( 1035 0 ) capacitor c=0.00597439f //x=3.34 //y=7.585
c1369 ( 1034 0 ) capacitor c=0.00597439f //x=2.46 //y=7.585
c1370 ( 1033 0 ) capacitor c=0.00597439f //x=1.58 //y=7.585
c1371 ( 1021 0 ) capacitor c=0.0291772f //x=98.53 //y=7.585
c1372 ( 1013 0 ) capacitor c=0.0187886f //x=97.65 //y=7.585
c1373 ( 1003 0 ) capacitor c=0.122205f //x=96.89 //y=7.585
c1374 ( 995 0 ) capacitor c=0.122102f //x=93.56 //y=7.585
c1375 ( 989 0 ) capacitor c=0.0238235f //x=90.23 //y=7.585
c1376 ( 979 0 ) capacitor c=0.0288071f //x=89.535 //y=7.585
c1377 ( 971 0 ) capacitor c=0.0287754f //x=88.655 //y=7.585
c1378 ( 963 0 ) capacitor c=0.024303f //x=87.775 //y=7.585
c1379 ( 957 0 ) capacitor c=0.0397734f //x=86.9 //y=7.585
c1380 ( 947 0 ) capacitor c=0.0291138f //x=85.905 //y=7.585
c1381 ( 939 0 ) capacitor c=0.0290172f //x=85.025 //y=7.585
c1382 ( 929 0 ) capacitor c=0.0287649f //x=84.145 //y=7.585
c1383 ( 919 0 ) capacitor c=0.0386886f //x=83.265 //y=7.585
c1384 ( 913 0 ) capacitor c=0.0397734f //x=82.09 //y=7.585
c1385 ( 903 0 ) capacitor c=0.0291138f //x=81.095 //y=7.585
c1386 ( 895 0 ) capacitor c=0.0290172f //x=80.215 //y=7.585
c1387 ( 885 0 ) capacitor c=0.0287649f //x=79.335 //y=7.585
c1388 ( 875 0 ) capacitor c=0.0386886f //x=78.455 //y=7.585
c1389 ( 869 0 ) capacitor c=0.0397734f //x=77.28 //y=7.585
c1390 ( 859 0 ) capacitor c=0.0291116f //x=76.285 //y=7.585
c1391 ( 851 0 ) capacitor c=0.0289898f //x=75.405 //y=7.585
c1392 ( 841 0 ) capacitor c=0.0287487f //x=74.525 //y=7.585
c1393 ( 831 0 ) capacitor c=0.0386886f //x=73.645 //y=7.585
c1394 ( 825 0 ) capacitor c=0.0397093f //x=72.47 //y=7.585
c1395 ( 815 0 ) capacitor c=0.0290822f //x=71.475 //y=7.585
c1396 ( 807 0 ) capacitor c=0.0289898f //x=70.595 //y=7.585
c1397 ( 797 0 ) capacitor c=0.0287487f //x=69.715 //y=7.585
c1398 ( 787 0 ) capacitor c=0.0386886f //x=68.835 //y=7.585
c1399 ( 781 0 ) capacitor c=0.0397093f //x=67.66 //y=7.585
c1400 ( 771 0 ) capacitor c=0.0290822f //x=66.665 //y=7.585
c1401 ( 763 0 ) capacitor c=0.0289898f //x=65.785 //y=7.585
c1402 ( 753 0 ) capacitor c=0.0287487f //x=64.905 //y=7.585
c1403 ( 743 0 ) capacitor c=0.0386886f //x=64.025 //y=7.585
c1404 ( 737 0 ) capacitor c=0.0397093f //x=62.85 //y=7.585
c1405 ( 727 0 ) capacitor c=0.0290822f //x=61.855 //y=7.585
c1406 ( 719 0 ) capacitor c=0.0289898f //x=60.975 //y=7.585
c1407 ( 709 0 ) capacitor c=0.0287487f //x=60.095 //y=7.585
c1408 ( 699 0 ) capacitor c=0.0386886f //x=59.215 //y=7.585
c1409 ( 693 0 ) capacitor c=0.0397093f //x=58.04 //y=7.585
c1410 ( 683 0 ) capacitor c=0.0290822f //x=57.045 //y=7.585
c1411 ( 675 0 ) capacitor c=0.0289898f //x=56.165 //y=7.585
c1412 ( 665 0 ) capacitor c=0.0287487f //x=55.285 //y=7.585
c1413 ( 655 0 ) capacitor c=0.0386886f //x=54.405 //y=7.585
c1414 ( 649 0 ) capacitor c=0.0397093f //x=53.23 //y=7.585
c1415 ( 639 0 ) capacitor c=0.0290822f //x=52.235 //y=7.585
c1416 ( 631 0 ) capacitor c=0.0289898f //x=51.355 //y=7.585
c1417 ( 621 0 ) capacitor c=0.0287487f //x=50.475 //y=7.585
c1418 ( 611 0 ) capacitor c=0.0386886f //x=49.595 //y=7.585
c1419 ( 605 0 ) capacitor c=0.0397093f //x=48.42 //y=7.585
c1420 ( 595 0 ) capacitor c=0.0290822f //x=47.425 //y=7.585
c1421 ( 587 0 ) capacitor c=0.0289898f //x=46.545 //y=7.585
c1422 ( 577 0 ) capacitor c=0.0287487f //x=45.665 //y=7.585
c1423 ( 567 0 ) capacitor c=0.0386886f //x=44.785 //y=7.585
c1424 ( 561 0 ) capacitor c=0.0397093f //x=43.61 //y=7.585
c1425 ( 551 0 ) capacitor c=0.0290822f //x=42.615 //y=7.585
c1426 ( 543 0 ) capacitor c=0.0289898f //x=41.735 //y=7.585
c1427 ( 533 0 ) capacitor c=0.0287487f //x=40.855 //y=7.585
c1428 ( 523 0 ) capacitor c=0.0386886f //x=39.975 //y=7.585
c1429 ( 517 0 ) capacitor c=0.0397093f //x=38.8 //y=7.585
c1430 ( 507 0 ) capacitor c=0.0290822f //x=37.805 //y=7.585
c1431 ( 499 0 ) capacitor c=0.0289898f //x=36.925 //y=7.585
c1432 ( 489 0 ) capacitor c=0.0287487f //x=36.045 //y=7.585
c1433 ( 479 0 ) capacitor c=0.0386886f //x=35.165 //y=7.585
c1434 ( 473 0 ) capacitor c=0.0397093f //x=33.99 //y=7.585
c1435 ( 463 0 ) capacitor c=0.0290822f //x=32.995 //y=7.585
c1436 ( 455 0 ) capacitor c=0.0289898f //x=32.115 //y=7.585
c1437 ( 445 0 ) capacitor c=0.0287487f //x=31.235 //y=7.585
c1438 ( 435 0 ) capacitor c=0.0386886f //x=30.355 //y=7.585
c1439 ( 429 0 ) capacitor c=0.0397187f //x=29.18 //y=7.585
c1440 ( 419 0 ) capacitor c=0.0291138f //x=28.185 //y=7.585
c1441 ( 411 0 ) capacitor c=0.0290172f //x=27.305 //y=7.585
c1442 ( 401 0 ) capacitor c=0.0287649f //x=26.425 //y=7.585
c1443 ( 391 0 ) capacitor c=0.0386886f //x=25.545 //y=7.585
c1444 ( 385 0 ) capacitor c=0.0397734f //x=24.37 //y=7.585
c1445 ( 375 0 ) capacitor c=0.0291138f //x=23.375 //y=7.585
c1446 ( 367 0 ) capacitor c=0.0290172f //x=22.495 //y=7.585
c1447 ( 357 0 ) capacitor c=0.0287649f //x=21.615 //y=7.585
c1448 ( 347 0 ) capacitor c=0.0386886f //x=20.735 //y=7.585
c1449 ( 341 0 ) capacitor c=0.0397734f //x=19.56 //y=7.585
c1450 ( 331 0 ) capacitor c=0.0291138f //x=18.565 //y=7.585
c1451 ( 323 0 ) capacitor c=0.0290163f //x=17.685 //y=7.585
c1452 ( 313 0 ) capacitor c=0.0287649f //x=16.805 //y=7.585
c1453 ( 303 0 ) capacitor c=0.0386886f //x=15.925 //y=7.585
c1454 ( 297 0 ) capacitor c=0.0397734f //x=14.75 //y=7.585
c1455 ( 287 0 ) capacitor c=0.0291138f //x=13.755 //y=7.585
c1456 ( 279 0 ) capacitor c=0.0290172f //x=12.875 //y=7.585
c1457 ( 269 0 ) capacitor c=0.0287649f //x=11.995 //y=7.585
c1458 ( 259 0 ) capacitor c=0.0386886f //x=11.115 //y=7.585
c1459 ( 253 0 ) capacitor c=0.0397734f //x=9.94 //y=7.585
c1460 ( 243 0 ) capacitor c=0.0291138f //x=8.945 //y=7.585
c1461 ( 235 0 ) capacitor c=0.0290163f //x=8.065 //y=7.585
c1462 ( 225 0 ) capacitor c=0.0287792f //x=7.185 //y=7.585
c1463 ( 215 0 ) capacitor c=0.0386886f //x=6.305 //y=7.585
c1464 ( 209 0 ) capacitor c=0.0398302f //x=5.13 //y=7.585
c1465 ( 199 0 ) capacitor c=0.0291418f //x=4.135 //y=7.585
c1466 ( 191 0 ) capacitor c=0.0290414f //x=3.255 //y=7.585
c1467 ( 181 0 ) capacitor c=0.0287792f //x=2.375 //y=7.585
c1468 ( 174 0 ) capacitor c=0.253398f //x=1.23 //y=7.58
c1469 ( 171 0 ) capacitor c=0.0445047f //x=1.495 //y=7.585
c1470 ( 167 0 ) capacitor c=3.29683f //x=98.54 //y=7.58
r1471 (  1023 1133 ) resistor r=4.23183 //w=0.7 //l=0.175 //layer=li \
 //thickness=0.1 //x=98.615 //y=7.41 //x2=98.615 //y2=7.585
r1472 (  1023 1210 ) resistor r=56.4706 //w=0.187 //l=0.825 //layer=li \
 //thickness=0.1 //x=98.615 //y=7.41 //x2=98.615 //y2=6.585
r1473 (  1022 1131 ) resistor r=2.87058 //w=0.35 //l=0.085 //layer=li \
 //thickness=0.1 //x=97.82 //y=7.585 //x2=97.735 //y2=7.585
r1474 (  1021 1133 ) resistor r=2.87058 //w=0.35 //l=0.085 //layer=li \
 //thickness=0.1 //x=98.53 //y=7.585 //x2=98.615 //y2=7.585
r1475 (  1021 1022 ) resistor r=24.7629 //w=0.367 //l=0.71 //layer=li \
 //thickness=0.1 //x=98.53 //y=7.585 //x2=97.82 //y2=7.585
r1476 (  1015 1131 ) resistor r=4.23183 //w=0.7 //l=0.175 //layer=li \
 //thickness=0.1 //x=97.735 //y=7.41 //x2=97.735 //y2=7.585
r1477 (  1015 1209 ) resistor r=56.4706 //w=0.187 //l=0.825 //layer=li \
 //thickness=0.1 //x=97.735 //y=7.41 //x2=97.735 //y2=6.585
r1478 (  1014 1129 ) resistor r=5.29055 //w=0.35 //l=0.17 //layer=li \
 //thickness=0.1 //x=97.23 //y=7.585 //x2=97.06 //y2=7.585
r1479 (  1013 1131 ) resistor r=2.87058 //w=0.35 //l=0.085 //layer=li \
 //thickness=0.1 //x=97.65 //y=7.585 //x2=97.735 //y2=7.585
r1480 (  1013 1014 ) resistor r=14.6485 //w=0.367 //l=0.42 //layer=li \
 //thickness=0.1 //x=97.65 //y=7.585 //x2=97.23 //y2=7.585
r1481 (  1008 1010 ) resistor r=38.7139 //w=0.367 //l=1.11 //layer=li \
 //thickness=0.1 //x=95.21 //y=7.585 //x2=96.32 //y2=7.585
r1482 (  1006 1008 ) resistor r=38.7139 //w=0.367 //l=1.11 //layer=li \
 //thickness=0.1 //x=94.1 //y=7.585 //x2=95.21 //y2=7.585
r1483 (  1004 1128 ) resistor r=5.29055 //w=0.35 //l=0.17 //layer=li \
 //thickness=0.1 //x=93.9 //y=7.585 //x2=93.73 //y2=7.585
r1484 (  1004 1006 ) resistor r=6.97548 //w=0.367 //l=0.2 //layer=li \
 //thickness=0.1 //x=93.9 //y=7.585 //x2=94.1 //y2=7.585
r1485 (  1003 1129 ) resistor r=5.29055 //w=0.35 //l=0.17 //layer=li \
 //thickness=0.1 //x=96.89 //y=7.585 //x2=97.06 //y2=7.585
r1486 (  1003 1010 ) resistor r=19.8801 //w=0.367 //l=0.57 //layer=li \
 //thickness=0.1 //x=96.89 //y=7.585 //x2=96.32 //y2=7.585
r1487 (  998 1000 ) resistor r=38.7139 //w=0.367 //l=1.11 //layer=li \
 //thickness=0.1 //x=91.51 //y=7.585 //x2=92.62 //y2=7.585
r1488 (  996 1127 ) resistor r=5.29055 //w=0.35 //l=0.17 //layer=li \
 //thickness=0.1 //x=90.57 //y=7.585 //x2=90.4 //y2=7.585
r1489 (  996 998 ) resistor r=32.7847 //w=0.367 //l=0.94 //layer=li \
 //thickness=0.1 //x=90.57 //y=7.585 //x2=91.51 //y2=7.585
r1490 (  995 1128 ) resistor r=5.29055 //w=0.35 //l=0.17 //layer=li \
 //thickness=0.1 //x=93.56 //y=7.585 //x2=93.73 //y2=7.585
r1491 (  995 1000 ) resistor r=32.7847 //w=0.367 //l=0.94 //layer=li \
 //thickness=0.1 //x=93.56 //y=7.585 //x2=92.62 //y2=7.585
r1492 (  990 1126 ) resistor r=2.87058 //w=0.35 //l=0.085 //layer=li \
 //thickness=0.1 //x=89.705 //y=7.585 //x2=89.62 //y2=7.585
r1493 (  990 992 ) resistor r=11.3351 //w=0.367 //l=0.325 //layer=li \
 //thickness=0.1 //x=89.705 //y=7.585 //x2=90.03 //y2=7.585
r1494 (  989 1127 ) resistor r=5.29055 //w=0.35 //l=0.17 //layer=li \
 //thickness=0.1 //x=90.23 //y=7.585 //x2=90.4 //y2=7.585
r1495 (  989 992 ) resistor r=6.97548 //w=0.367 //l=0.2 //layer=li \
 //thickness=0.1 //x=90.23 //y=7.585 //x2=90.03 //y2=7.585
r1496 (  983 1126 ) resistor r=4.23183 //w=0.7 //l=0.175 //layer=li \
 //thickness=0.1 //x=89.62 //y=7.41 //x2=89.62 //y2=7.585
r1497 (  983 1208 ) resistor r=56.8128 //w=0.187 //l=0.83 //layer=li \
 //thickness=0.1 //x=89.62 //y=7.41 //x2=89.62 //y2=6.58
r1498 (  980 1125 ) resistor r=2.87058 //w=0.35 //l=0.085 //layer=li \
 //thickness=0.1 //x=88.825 //y=7.585 //x2=88.74 //y2=7.585
r1499 (  980 982 ) resistor r=3.31335 //w=0.367 //l=0.095 //layer=li \
 //thickness=0.1 //x=88.825 //y=7.585 //x2=88.92 //y2=7.585
r1500 (  979 1126 ) resistor r=2.87058 //w=0.35 //l=0.085 //layer=li \
 //thickness=0.1 //x=89.535 //y=7.585 //x2=89.62 //y2=7.585
r1501 (  979 982 ) resistor r=21.4496 //w=0.367 //l=0.615 //layer=li \
 //thickness=0.1 //x=89.535 //y=7.585 //x2=88.92 //y2=7.585
r1502 (  973 1125 ) resistor r=4.23183 //w=0.7 //l=0.175 //layer=li \
 //thickness=0.1 //x=88.74 //y=7.41 //x2=88.74 //y2=7.585
r1503 (  973 1207 ) resistor r=33.5401 //w=0.187 //l=0.49 //layer=li \
 //thickness=0.1 //x=88.74 //y=7.41 //x2=88.74 //y2=6.92
r1504 (  972 1124 ) resistor r=2.87058 //w=0.35 //l=0.085 //layer=li \
 //thickness=0.1 //x=87.945 //y=7.585 //x2=87.86 //y2=7.585
r1505 (  971 1125 ) resistor r=2.87058 //w=0.35 //l=0.085 //layer=li \
 //thickness=0.1 //x=88.655 //y=7.585 //x2=88.74 //y2=7.585
r1506 (  971 972 ) resistor r=24.7629 //w=0.367 //l=0.71 //layer=li \
 //thickness=0.1 //x=88.655 //y=7.585 //x2=87.945 //y2=7.585
r1507 (  965 1124 ) resistor r=4.23183 //w=0.7 //l=0.175 //layer=li \
 //thickness=0.1 //x=87.86 //y=7.41 //x2=87.86 //y2=7.585
r1508 (  965 1206 ) resistor r=56.8128 //w=0.187 //l=0.83 //layer=li \
 //thickness=0.1 //x=87.86 //y=7.41 //x2=87.86 //y2=6.58
r1509 (  964 1122 ) resistor r=5.29055 //w=0.35 //l=0.17 //layer=li \
 //thickness=0.1 //x=87.24 //y=7.585 //x2=87.07 //y2=7.585
r1510 (  963 1124 ) resistor r=2.87058 //w=0.35 //l=0.085 //layer=li \
 //thickness=0.1 //x=87.775 //y=7.585 //x2=87.86 //y2=7.585
r1511 (  963 964 ) resistor r=18.6594 //w=0.367 //l=0.535 //layer=li \
 //thickness=0.1 //x=87.775 //y=7.585 //x2=87.24 //y2=7.585
r1512 (  958 1121 ) resistor r=2.87058 //w=0.35 //l=0.085 //layer=li \
 //thickness=0.1 //x=86.075 //y=7.585 //x2=85.99 //y2=7.585
r1513 (  958 960 ) resistor r=8.89373 //w=0.367 //l=0.255 //layer=li \
 //thickness=0.1 //x=86.075 //y=7.585 //x2=86.33 //y2=7.585
r1514 (  957 1122 ) resistor r=5.29055 //w=0.35 //l=0.17 //layer=li \
 //thickness=0.1 //x=86.9 //y=7.585 //x2=87.07 //y2=7.585
r1515 (  957 960 ) resistor r=19.8801 //w=0.367 //l=0.57 //layer=li \
 //thickness=0.1 //x=86.9 //y=7.585 //x2=86.33 //y2=7.585
r1516 (  951 1121 ) resistor r=4.23183 //w=0.7 //l=0.175 //layer=li \
 //thickness=0.1 //x=85.99 //y=7.41 //x2=85.99 //y2=7.585
r1517 (  951 1205 ) resistor r=33.1979 //w=0.187 //l=0.485 //layer=li \
 //thickness=0.1 //x=85.99 //y=7.41 //x2=85.99 //y2=6.925
r1518 (  948 1120 ) resistor r=2.87058 //w=0.35 //l=0.085 //layer=li \
 //thickness=0.1 //x=85.195 //y=7.585 //x2=85.11 //y2=7.585
r1519 (  948 950 ) resistor r=0.871935 //w=0.367 //l=0.025 //layer=li \
 //thickness=0.1 //x=85.195 //y=7.585 //x2=85.22 //y2=7.585
r1520 (  947 1121 ) resistor r=2.87058 //w=0.35 //l=0.085 //layer=li \
 //thickness=0.1 //x=85.905 //y=7.585 //x2=85.99 //y2=7.585
r1521 (  947 950 ) resistor r=23.891 //w=0.367 //l=0.685 //layer=li \
 //thickness=0.1 //x=85.905 //y=7.585 //x2=85.22 //y2=7.585
r1522 (  941 1120 ) resistor r=4.23183 //w=0.7 //l=0.175 //layer=li \
 //thickness=0.1 //x=85.11 //y=7.41 //x2=85.11 //y2=7.585
r1523 (  941 1204 ) resistor r=33.1979 //w=0.187 //l=0.485 //layer=li \
 //thickness=0.1 //x=85.11 //y=7.41 //x2=85.11 //y2=6.925
r1524 (  940 1119 ) resistor r=2.87058 //w=0.35 //l=0.085 //layer=li \
 //thickness=0.1 //x=84.315 //y=7.585 //x2=84.23 //y2=7.585
r1525 (  939 1120 ) resistor r=2.87058 //w=0.35 //l=0.085 //layer=li \
 //thickness=0.1 //x=85.025 //y=7.585 //x2=85.11 //y2=7.585
r1526 (  939 940 ) resistor r=24.7629 //w=0.367 //l=0.71 //layer=li \
 //thickness=0.1 //x=85.025 //y=7.585 //x2=84.315 //y2=7.585
r1527 (  933 1119 ) resistor r=4.23183 //w=0.7 //l=0.175 //layer=li \
 //thickness=0.1 //x=84.23 //y=7.41 //x2=84.23 //y2=7.585
r1528 (  933 1203 ) resistor r=33.1979 //w=0.187 //l=0.485 //layer=li \
 //thickness=0.1 //x=84.23 //y=7.41 //x2=84.23 //y2=6.925
r1529 (  930 1118 ) resistor r=2.87058 //w=0.35 //l=0.085 //layer=li \
 //thickness=0.1 //x=83.435 //y=7.585 //x2=83.35 //y2=7.585
r1530 (  930 932 ) resistor r=23.5422 //w=0.367 //l=0.675 //layer=li \
 //thickness=0.1 //x=83.435 //y=7.585 //x2=84.11 //y2=7.585
r1531 (  929 1119 ) resistor r=2.87058 //w=0.35 //l=0.085 //layer=li \
 //thickness=0.1 //x=84.145 //y=7.585 //x2=84.23 //y2=7.585
r1532 (  929 932 ) resistor r=1.22071 //w=0.367 //l=0.035 //layer=li \
 //thickness=0.1 //x=84.145 //y=7.585 //x2=84.11 //y2=7.585
r1533 (  923 1118 ) resistor r=4.23183 //w=0.7 //l=0.175 //layer=li \
 //thickness=0.1 //x=83.35 //y=7.41 //x2=83.35 //y2=7.585
r1534 (  923 1202 ) resistor r=56.4706 //w=0.187 //l=0.825 //layer=li \
 //thickness=0.1 //x=83.35 //y=7.41 //x2=83.35 //y2=6.585
r1535 (  920 1117 ) resistor r=5.29055 //w=0.35 //l=0.17 //layer=li \
 //thickness=0.1 //x=82.43 //y=7.585 //x2=82.26 //y2=7.585
r1536 (  920 922 ) resistor r=19.8801 //w=0.367 //l=0.57 //layer=li \
 //thickness=0.1 //x=82.43 //y=7.585 //x2=83 //y2=7.585
r1537 (  919 1118 ) resistor r=2.87058 //w=0.35 //l=0.085 //layer=li \
 //thickness=0.1 //x=83.265 //y=7.585 //x2=83.35 //y2=7.585
r1538 (  919 922 ) resistor r=9.24251 //w=0.367 //l=0.265 //layer=li \
 //thickness=0.1 //x=83.265 //y=7.585 //x2=83 //y2=7.585
r1539 (  914 1116 ) resistor r=2.87058 //w=0.35 //l=0.085 //layer=li \
 //thickness=0.1 //x=81.265 //y=7.585 //x2=81.18 //y2=7.585
r1540 (  914 916 ) resistor r=8.89373 //w=0.367 //l=0.255 //layer=li \
 //thickness=0.1 //x=81.265 //y=7.585 //x2=81.52 //y2=7.585
r1541 (  913 1117 ) resistor r=5.29055 //w=0.35 //l=0.17 //layer=li \
 //thickness=0.1 //x=82.09 //y=7.585 //x2=82.26 //y2=7.585
r1542 (  913 916 ) resistor r=19.8801 //w=0.367 //l=0.57 //layer=li \
 //thickness=0.1 //x=82.09 //y=7.585 //x2=81.52 //y2=7.585
r1543 (  907 1116 ) resistor r=4.23183 //w=0.7 //l=0.175 //layer=li \
 //thickness=0.1 //x=81.18 //y=7.41 //x2=81.18 //y2=7.585
r1544 (  907 1201 ) resistor r=33.1979 //w=0.187 //l=0.485 //layer=li \
 //thickness=0.1 //x=81.18 //y=7.41 //x2=81.18 //y2=6.925
r1545 (  904 1115 ) resistor r=2.87058 //w=0.35 //l=0.085 //layer=li \
 //thickness=0.1 //x=80.385 //y=7.585 //x2=80.3 //y2=7.585
r1546 (  904 906 ) resistor r=0.871935 //w=0.367 //l=0.025 //layer=li \
 //thickness=0.1 //x=80.385 //y=7.585 //x2=80.41 //y2=7.585
r1547 (  903 1116 ) resistor r=2.87058 //w=0.35 //l=0.085 //layer=li \
 //thickness=0.1 //x=81.095 //y=7.585 //x2=81.18 //y2=7.585
r1548 (  903 906 ) resistor r=23.891 //w=0.367 //l=0.685 //layer=li \
 //thickness=0.1 //x=81.095 //y=7.585 //x2=80.41 //y2=7.585
r1549 (  897 1115 ) resistor r=4.23183 //w=0.7 //l=0.175 //layer=li \
 //thickness=0.1 //x=80.3 //y=7.41 //x2=80.3 //y2=7.585
r1550 (  897 1200 ) resistor r=33.1979 //w=0.187 //l=0.485 //layer=li \
 //thickness=0.1 //x=80.3 //y=7.41 //x2=80.3 //y2=6.925
r1551 (  896 1114 ) resistor r=2.87058 //w=0.35 //l=0.085 //layer=li \
 //thickness=0.1 //x=79.505 //y=7.585 //x2=79.42 //y2=7.585
r1552 (  895 1115 ) resistor r=2.87058 //w=0.35 //l=0.085 //layer=li \
 //thickness=0.1 //x=80.215 //y=7.585 //x2=80.3 //y2=7.585
r1553 (  895 896 ) resistor r=24.7629 //w=0.367 //l=0.71 //layer=li \
 //thickness=0.1 //x=80.215 //y=7.585 //x2=79.505 //y2=7.585
r1554 (  889 1114 ) resistor r=4.23183 //w=0.7 //l=0.175 //layer=li \
 //thickness=0.1 //x=79.42 //y=7.41 //x2=79.42 //y2=7.585
r1555 (  889 1199 ) resistor r=33.1979 //w=0.187 //l=0.485 //layer=li \
 //thickness=0.1 //x=79.42 //y=7.41 //x2=79.42 //y2=6.925
r1556 (  886 1113 ) resistor r=2.87058 //w=0.35 //l=0.085 //layer=li \
 //thickness=0.1 //x=78.625 //y=7.585 //x2=78.54 //y2=7.585
r1557 (  886 888 ) resistor r=23.5422 //w=0.367 //l=0.675 //layer=li \
 //thickness=0.1 //x=78.625 //y=7.585 //x2=79.3 //y2=7.585
r1558 (  885 1114 ) resistor r=2.87058 //w=0.35 //l=0.085 //layer=li \
 //thickness=0.1 //x=79.335 //y=7.585 //x2=79.42 //y2=7.585
r1559 (  885 888 ) resistor r=1.22071 //w=0.367 //l=0.035 //layer=li \
 //thickness=0.1 //x=79.335 //y=7.585 //x2=79.3 //y2=7.585
r1560 (  879 1113 ) resistor r=4.23183 //w=0.7 //l=0.175 //layer=li \
 //thickness=0.1 //x=78.54 //y=7.41 //x2=78.54 //y2=7.585
r1561 (  879 1198 ) resistor r=56.4706 //w=0.187 //l=0.825 //layer=li \
 //thickness=0.1 //x=78.54 //y=7.41 //x2=78.54 //y2=6.585
r1562 (  876 1112 ) resistor r=5.29055 //w=0.35 //l=0.17 //layer=li \
 //thickness=0.1 //x=77.62 //y=7.585 //x2=77.45 //y2=7.585
r1563 (  876 878 ) resistor r=19.8801 //w=0.367 //l=0.57 //layer=li \
 //thickness=0.1 //x=77.62 //y=7.585 //x2=78.19 //y2=7.585
r1564 (  875 1113 ) resistor r=2.87058 //w=0.35 //l=0.085 //layer=li \
 //thickness=0.1 //x=78.455 //y=7.585 //x2=78.54 //y2=7.585
r1565 (  875 878 ) resistor r=9.24251 //w=0.367 //l=0.265 //layer=li \
 //thickness=0.1 //x=78.455 //y=7.585 //x2=78.19 //y2=7.585
r1566 (  870 1111 ) resistor r=2.87058 //w=0.35 //l=0.085 //layer=li \
 //thickness=0.1 //x=76.455 //y=7.585 //x2=76.37 //y2=7.585
r1567 (  870 872 ) resistor r=8.89373 //w=0.367 //l=0.255 //layer=li \
 //thickness=0.1 //x=76.455 //y=7.585 //x2=76.71 //y2=7.585
r1568 (  869 1112 ) resistor r=5.29055 //w=0.35 //l=0.17 //layer=li \
 //thickness=0.1 //x=77.28 //y=7.585 //x2=77.45 //y2=7.585
r1569 (  869 872 ) resistor r=19.8801 //w=0.367 //l=0.57 //layer=li \
 //thickness=0.1 //x=77.28 //y=7.585 //x2=76.71 //y2=7.585
r1570 (  863 1111 ) resistor r=4.23183 //w=0.7 //l=0.175 //layer=li \
 //thickness=0.1 //x=76.37 //y=7.41 //x2=76.37 //y2=7.585
r1571 (  863 1197 ) resistor r=33.1979 //w=0.187 //l=0.485 //layer=li \
 //thickness=0.1 //x=76.37 //y=7.41 //x2=76.37 //y2=6.925
r1572 (  860 1110 ) resistor r=2.87058 //w=0.35 //l=0.085 //layer=li \
 //thickness=0.1 //x=75.575 //y=7.585 //x2=75.49 //y2=7.585
r1573 (  860 862 ) resistor r=0.871935 //w=0.367 //l=0.025 //layer=li \
 //thickness=0.1 //x=75.575 //y=7.585 //x2=75.6 //y2=7.585
r1574 (  859 1111 ) resistor r=2.87058 //w=0.35 //l=0.085 //layer=li \
 //thickness=0.1 //x=76.285 //y=7.585 //x2=76.37 //y2=7.585
r1575 (  859 862 ) resistor r=23.891 //w=0.367 //l=0.685 //layer=li \
 //thickness=0.1 //x=76.285 //y=7.585 //x2=75.6 //y2=7.585
r1576 (  853 1110 ) resistor r=4.23183 //w=0.7 //l=0.175 //layer=li \
 //thickness=0.1 //x=75.49 //y=7.41 //x2=75.49 //y2=7.585
r1577 (  853 1196 ) resistor r=33.1979 //w=0.187 //l=0.485 //layer=li \
 //thickness=0.1 //x=75.49 //y=7.41 //x2=75.49 //y2=6.925
r1578 (  852 1109 ) resistor r=2.87058 //w=0.35 //l=0.085 //layer=li \
 //thickness=0.1 //x=74.695 //y=7.585 //x2=74.61 //y2=7.585
r1579 (  851 1110 ) resistor r=2.87058 //w=0.35 //l=0.085 //layer=li \
 //thickness=0.1 //x=75.405 //y=7.585 //x2=75.49 //y2=7.585
r1580 (  851 852 ) resistor r=24.7629 //w=0.367 //l=0.71 //layer=li \
 //thickness=0.1 //x=75.405 //y=7.585 //x2=74.695 //y2=7.585
r1581 (  845 1109 ) resistor r=4.23183 //w=0.7 //l=0.175 //layer=li \
 //thickness=0.1 //x=74.61 //y=7.41 //x2=74.61 //y2=7.585
r1582 (  845 1195 ) resistor r=33.1979 //w=0.187 //l=0.485 //layer=li \
 //thickness=0.1 //x=74.61 //y=7.41 //x2=74.61 //y2=6.925
r1583 (  842 1108 ) resistor r=2.87058 //w=0.35 //l=0.085 //layer=li \
 //thickness=0.1 //x=73.815 //y=7.585 //x2=73.73 //y2=7.585
r1584 (  842 844 ) resistor r=23.5422 //w=0.367 //l=0.675 //layer=li \
 //thickness=0.1 //x=73.815 //y=7.585 //x2=74.49 //y2=7.585
r1585 (  841 1109 ) resistor r=2.87058 //w=0.35 //l=0.085 //layer=li \
 //thickness=0.1 //x=74.525 //y=7.585 //x2=74.61 //y2=7.585
r1586 (  841 844 ) resistor r=1.22071 //w=0.367 //l=0.035 //layer=li \
 //thickness=0.1 //x=74.525 //y=7.585 //x2=74.49 //y2=7.585
r1587 (  835 1108 ) resistor r=4.23183 //w=0.7 //l=0.175 //layer=li \
 //thickness=0.1 //x=73.73 //y=7.41 //x2=73.73 //y2=7.585
r1588 (  835 1194 ) resistor r=56.4706 //w=0.187 //l=0.825 //layer=li \
 //thickness=0.1 //x=73.73 //y=7.41 //x2=73.73 //y2=6.585
r1589 (  832 1107 ) resistor r=5.29055 //w=0.35 //l=0.17 //layer=li \
 //thickness=0.1 //x=72.81 //y=7.585 //x2=72.64 //y2=7.585
r1590 (  832 834 ) resistor r=19.8801 //w=0.367 //l=0.57 //layer=li \
 //thickness=0.1 //x=72.81 //y=7.585 //x2=73.38 //y2=7.585
r1591 (  831 1108 ) resistor r=2.87058 //w=0.35 //l=0.085 //layer=li \
 //thickness=0.1 //x=73.645 //y=7.585 //x2=73.73 //y2=7.585
r1592 (  831 834 ) resistor r=9.24251 //w=0.367 //l=0.265 //layer=li \
 //thickness=0.1 //x=73.645 //y=7.585 //x2=73.38 //y2=7.585
r1593 (  826 1106 ) resistor r=2.87058 //w=0.35 //l=0.085 //layer=li \
 //thickness=0.1 //x=71.645 //y=7.585 //x2=71.56 //y2=7.585
r1594 (  826 828 ) resistor r=8.89373 //w=0.367 //l=0.255 //layer=li \
 //thickness=0.1 //x=71.645 //y=7.585 //x2=71.9 //y2=7.585
r1595 (  825 1107 ) resistor r=5.29055 //w=0.35 //l=0.17 //layer=li \
 //thickness=0.1 //x=72.47 //y=7.585 //x2=72.64 //y2=7.585
r1596 (  825 828 ) resistor r=19.8801 //w=0.367 //l=0.57 //layer=li \
 //thickness=0.1 //x=72.47 //y=7.585 //x2=71.9 //y2=7.585
r1597 (  819 1106 ) resistor r=4.23183 //w=0.7 //l=0.175 //layer=li \
 //thickness=0.1 //x=71.56 //y=7.41 //x2=71.56 //y2=7.585
r1598 (  819 1193 ) resistor r=33.1979 //w=0.187 //l=0.485 //layer=li \
 //thickness=0.1 //x=71.56 //y=7.41 //x2=71.56 //y2=6.925
r1599 (  816 1105 ) resistor r=2.87058 //w=0.35 //l=0.085 //layer=li \
 //thickness=0.1 //x=70.765 //y=7.585 //x2=70.68 //y2=7.585
r1600 (  816 818 ) resistor r=0.871935 //w=0.367 //l=0.025 //layer=li \
 //thickness=0.1 //x=70.765 //y=7.585 //x2=70.79 //y2=7.585
r1601 (  815 1106 ) resistor r=2.87058 //w=0.35 //l=0.085 //layer=li \
 //thickness=0.1 //x=71.475 //y=7.585 //x2=71.56 //y2=7.585
r1602 (  815 818 ) resistor r=23.891 //w=0.367 //l=0.685 //layer=li \
 //thickness=0.1 //x=71.475 //y=7.585 //x2=70.79 //y2=7.585
r1603 (  809 1105 ) resistor r=4.23183 //w=0.7 //l=0.175 //layer=li \
 //thickness=0.1 //x=70.68 //y=7.41 //x2=70.68 //y2=7.585
r1604 (  809 1192 ) resistor r=33.1979 //w=0.187 //l=0.485 //layer=li \
 //thickness=0.1 //x=70.68 //y=7.41 //x2=70.68 //y2=6.925
r1605 (  808 1104 ) resistor r=2.87058 //w=0.35 //l=0.085 //layer=li \
 //thickness=0.1 //x=69.885 //y=7.585 //x2=69.8 //y2=7.585
r1606 (  807 1105 ) resistor r=2.87058 //w=0.35 //l=0.085 //layer=li \
 //thickness=0.1 //x=70.595 //y=7.585 //x2=70.68 //y2=7.585
r1607 (  807 808 ) resistor r=24.7629 //w=0.367 //l=0.71 //layer=li \
 //thickness=0.1 //x=70.595 //y=7.585 //x2=69.885 //y2=7.585
r1608 (  801 1104 ) resistor r=4.23183 //w=0.7 //l=0.175 //layer=li \
 //thickness=0.1 //x=69.8 //y=7.41 //x2=69.8 //y2=7.585
r1609 (  801 1191 ) resistor r=33.1979 //w=0.187 //l=0.485 //layer=li \
 //thickness=0.1 //x=69.8 //y=7.41 //x2=69.8 //y2=6.925
r1610 (  798 1103 ) resistor r=2.87058 //w=0.35 //l=0.085 //layer=li \
 //thickness=0.1 //x=69.005 //y=7.585 //x2=68.92 //y2=7.585
r1611 (  798 800 ) resistor r=23.5422 //w=0.367 //l=0.675 //layer=li \
 //thickness=0.1 //x=69.005 //y=7.585 //x2=69.68 //y2=7.585
r1612 (  797 1104 ) resistor r=2.87058 //w=0.35 //l=0.085 //layer=li \
 //thickness=0.1 //x=69.715 //y=7.585 //x2=69.8 //y2=7.585
r1613 (  797 800 ) resistor r=1.22071 //w=0.367 //l=0.035 //layer=li \
 //thickness=0.1 //x=69.715 //y=7.585 //x2=69.68 //y2=7.585
r1614 (  791 1103 ) resistor r=4.23183 //w=0.7 //l=0.175 //layer=li \
 //thickness=0.1 //x=68.92 //y=7.41 //x2=68.92 //y2=7.585
r1615 (  791 1190 ) resistor r=56.4706 //w=0.187 //l=0.825 //layer=li \
 //thickness=0.1 //x=68.92 //y=7.41 //x2=68.92 //y2=6.585
r1616 (  788 1102 ) resistor r=5.29055 //w=0.35 //l=0.17 //layer=li \
 //thickness=0.1 //x=68 //y=7.585 //x2=67.83 //y2=7.585
r1617 (  788 790 ) resistor r=19.8801 //w=0.367 //l=0.57 //layer=li \
 //thickness=0.1 //x=68 //y=7.585 //x2=68.57 //y2=7.585
r1618 (  787 1103 ) resistor r=2.87058 //w=0.35 //l=0.085 //layer=li \
 //thickness=0.1 //x=68.835 //y=7.585 //x2=68.92 //y2=7.585
r1619 (  787 790 ) resistor r=9.24251 //w=0.367 //l=0.265 //layer=li \
 //thickness=0.1 //x=68.835 //y=7.585 //x2=68.57 //y2=7.585
r1620 (  782 1101 ) resistor r=2.87058 //w=0.35 //l=0.085 //layer=li \
 //thickness=0.1 //x=66.835 //y=7.585 //x2=66.75 //y2=7.585
r1621 (  782 784 ) resistor r=8.89373 //w=0.367 //l=0.255 //layer=li \
 //thickness=0.1 //x=66.835 //y=7.585 //x2=67.09 //y2=7.585
r1622 (  781 1102 ) resistor r=5.29055 //w=0.35 //l=0.17 //layer=li \
 //thickness=0.1 //x=67.66 //y=7.585 //x2=67.83 //y2=7.585
r1623 (  781 784 ) resistor r=19.8801 //w=0.367 //l=0.57 //layer=li \
 //thickness=0.1 //x=67.66 //y=7.585 //x2=67.09 //y2=7.585
r1624 (  775 1101 ) resistor r=4.23183 //w=0.7 //l=0.175 //layer=li \
 //thickness=0.1 //x=66.75 //y=7.41 //x2=66.75 //y2=7.585
r1625 (  775 1189 ) resistor r=33.1979 //w=0.187 //l=0.485 //layer=li \
 //thickness=0.1 //x=66.75 //y=7.41 //x2=66.75 //y2=6.925
r1626 (  772 1100 ) resistor r=2.87058 //w=0.35 //l=0.085 //layer=li \
 //thickness=0.1 //x=65.955 //y=7.585 //x2=65.87 //y2=7.585
r1627 (  772 774 ) resistor r=0.871935 //w=0.367 //l=0.025 //layer=li \
 //thickness=0.1 //x=65.955 //y=7.585 //x2=65.98 //y2=7.585
r1628 (  771 1101 ) resistor r=2.87058 //w=0.35 //l=0.085 //layer=li \
 //thickness=0.1 //x=66.665 //y=7.585 //x2=66.75 //y2=7.585
r1629 (  771 774 ) resistor r=23.891 //w=0.367 //l=0.685 //layer=li \
 //thickness=0.1 //x=66.665 //y=7.585 //x2=65.98 //y2=7.585
r1630 (  765 1100 ) resistor r=4.23183 //w=0.7 //l=0.175 //layer=li \
 //thickness=0.1 //x=65.87 //y=7.41 //x2=65.87 //y2=7.585
r1631 (  765 1188 ) resistor r=33.1979 //w=0.187 //l=0.485 //layer=li \
 //thickness=0.1 //x=65.87 //y=7.41 //x2=65.87 //y2=6.925
r1632 (  764 1099 ) resistor r=2.87058 //w=0.35 //l=0.085 //layer=li \
 //thickness=0.1 //x=65.075 //y=7.585 //x2=64.99 //y2=7.585
r1633 (  763 1100 ) resistor r=2.87058 //w=0.35 //l=0.085 //layer=li \
 //thickness=0.1 //x=65.785 //y=7.585 //x2=65.87 //y2=7.585
r1634 (  763 764 ) resistor r=24.7629 //w=0.367 //l=0.71 //layer=li \
 //thickness=0.1 //x=65.785 //y=7.585 //x2=65.075 //y2=7.585
r1635 (  757 1099 ) resistor r=4.23183 //w=0.7 //l=0.175 //layer=li \
 //thickness=0.1 //x=64.99 //y=7.41 //x2=64.99 //y2=7.585
r1636 (  757 1187 ) resistor r=33.1979 //w=0.187 //l=0.485 //layer=li \
 //thickness=0.1 //x=64.99 //y=7.41 //x2=64.99 //y2=6.925
r1637 (  754 1098 ) resistor r=2.87058 //w=0.35 //l=0.085 //layer=li \
 //thickness=0.1 //x=64.195 //y=7.585 //x2=64.11 //y2=7.585
r1638 (  754 756 ) resistor r=23.5422 //w=0.367 //l=0.675 //layer=li \
 //thickness=0.1 //x=64.195 //y=7.585 //x2=64.87 //y2=7.585
r1639 (  753 1099 ) resistor r=2.87058 //w=0.35 //l=0.085 //layer=li \
 //thickness=0.1 //x=64.905 //y=7.585 //x2=64.99 //y2=7.585
r1640 (  753 756 ) resistor r=1.22071 //w=0.367 //l=0.035 //layer=li \
 //thickness=0.1 //x=64.905 //y=7.585 //x2=64.87 //y2=7.585
r1641 (  747 1098 ) resistor r=4.23183 //w=0.7 //l=0.175 //layer=li \
 //thickness=0.1 //x=64.11 //y=7.41 //x2=64.11 //y2=7.585
r1642 (  747 1186 ) resistor r=56.4706 //w=0.187 //l=0.825 //layer=li \
 //thickness=0.1 //x=64.11 //y=7.41 //x2=64.11 //y2=6.585
r1643 (  744 1097 ) resistor r=5.29055 //w=0.35 //l=0.17 //layer=li \
 //thickness=0.1 //x=63.19 //y=7.585 //x2=63.02 //y2=7.585
r1644 (  744 746 ) resistor r=19.8801 //w=0.367 //l=0.57 //layer=li \
 //thickness=0.1 //x=63.19 //y=7.585 //x2=63.76 //y2=7.585
r1645 (  743 1098 ) resistor r=2.87058 //w=0.35 //l=0.085 //layer=li \
 //thickness=0.1 //x=64.025 //y=7.585 //x2=64.11 //y2=7.585
r1646 (  743 746 ) resistor r=9.24251 //w=0.367 //l=0.265 //layer=li \
 //thickness=0.1 //x=64.025 //y=7.585 //x2=63.76 //y2=7.585
r1647 (  738 1096 ) resistor r=2.87058 //w=0.35 //l=0.085 //layer=li \
 //thickness=0.1 //x=62.025 //y=7.585 //x2=61.94 //y2=7.585
r1648 (  738 740 ) resistor r=8.89373 //w=0.367 //l=0.255 //layer=li \
 //thickness=0.1 //x=62.025 //y=7.585 //x2=62.28 //y2=7.585
r1649 (  737 1097 ) resistor r=5.29055 //w=0.35 //l=0.17 //layer=li \
 //thickness=0.1 //x=62.85 //y=7.585 //x2=63.02 //y2=7.585
r1650 (  737 740 ) resistor r=19.8801 //w=0.367 //l=0.57 //layer=li \
 //thickness=0.1 //x=62.85 //y=7.585 //x2=62.28 //y2=7.585
r1651 (  731 1096 ) resistor r=4.23183 //w=0.7 //l=0.175 //layer=li \
 //thickness=0.1 //x=61.94 //y=7.41 //x2=61.94 //y2=7.585
r1652 (  731 1185 ) resistor r=33.1979 //w=0.187 //l=0.485 //layer=li \
 //thickness=0.1 //x=61.94 //y=7.41 //x2=61.94 //y2=6.925
r1653 (  728 1095 ) resistor r=2.87058 //w=0.35 //l=0.085 //layer=li \
 //thickness=0.1 //x=61.145 //y=7.585 //x2=61.06 //y2=7.585
r1654 (  728 730 ) resistor r=0.871935 //w=0.367 //l=0.025 //layer=li \
 //thickness=0.1 //x=61.145 //y=7.585 //x2=61.17 //y2=7.585
r1655 (  727 1096 ) resistor r=2.87058 //w=0.35 //l=0.085 //layer=li \
 //thickness=0.1 //x=61.855 //y=7.585 //x2=61.94 //y2=7.585
r1656 (  727 730 ) resistor r=23.891 //w=0.367 //l=0.685 //layer=li \
 //thickness=0.1 //x=61.855 //y=7.585 //x2=61.17 //y2=7.585
r1657 (  721 1095 ) resistor r=4.23183 //w=0.7 //l=0.175 //layer=li \
 //thickness=0.1 //x=61.06 //y=7.41 //x2=61.06 //y2=7.585
r1658 (  721 1184 ) resistor r=33.1979 //w=0.187 //l=0.485 //layer=li \
 //thickness=0.1 //x=61.06 //y=7.41 //x2=61.06 //y2=6.925
r1659 (  720 1094 ) resistor r=2.87058 //w=0.35 //l=0.085 //layer=li \
 //thickness=0.1 //x=60.265 //y=7.585 //x2=60.18 //y2=7.585
r1660 (  719 1095 ) resistor r=2.87058 //w=0.35 //l=0.085 //layer=li \
 //thickness=0.1 //x=60.975 //y=7.585 //x2=61.06 //y2=7.585
r1661 (  719 720 ) resistor r=24.7629 //w=0.367 //l=0.71 //layer=li \
 //thickness=0.1 //x=60.975 //y=7.585 //x2=60.265 //y2=7.585
r1662 (  713 1094 ) resistor r=4.23183 //w=0.7 //l=0.175 //layer=li \
 //thickness=0.1 //x=60.18 //y=7.41 //x2=60.18 //y2=7.585
r1663 (  713 1183 ) resistor r=33.1979 //w=0.187 //l=0.485 //layer=li \
 //thickness=0.1 //x=60.18 //y=7.41 //x2=60.18 //y2=6.925
r1664 (  710 1093 ) resistor r=2.87058 //w=0.35 //l=0.085 //layer=li \
 //thickness=0.1 //x=59.385 //y=7.585 //x2=59.3 //y2=7.585
r1665 (  710 712 ) resistor r=23.5422 //w=0.367 //l=0.675 //layer=li \
 //thickness=0.1 //x=59.385 //y=7.585 //x2=60.06 //y2=7.585
r1666 (  709 1094 ) resistor r=2.87058 //w=0.35 //l=0.085 //layer=li \
 //thickness=0.1 //x=60.095 //y=7.585 //x2=60.18 //y2=7.585
r1667 (  709 712 ) resistor r=1.22071 //w=0.367 //l=0.035 //layer=li \
 //thickness=0.1 //x=60.095 //y=7.585 //x2=60.06 //y2=7.585
r1668 (  703 1093 ) resistor r=4.23183 //w=0.7 //l=0.175 //layer=li \
 //thickness=0.1 //x=59.3 //y=7.41 //x2=59.3 //y2=7.585
r1669 (  703 1182 ) resistor r=56.4706 //w=0.187 //l=0.825 //layer=li \
 //thickness=0.1 //x=59.3 //y=7.41 //x2=59.3 //y2=6.585
r1670 (  700 1092 ) resistor r=5.29055 //w=0.35 //l=0.17 //layer=li \
 //thickness=0.1 //x=58.38 //y=7.585 //x2=58.21 //y2=7.585
r1671 (  700 702 ) resistor r=19.8801 //w=0.367 //l=0.57 //layer=li \
 //thickness=0.1 //x=58.38 //y=7.585 //x2=58.95 //y2=7.585
r1672 (  699 1093 ) resistor r=2.87058 //w=0.35 //l=0.085 //layer=li \
 //thickness=0.1 //x=59.215 //y=7.585 //x2=59.3 //y2=7.585
r1673 (  699 702 ) resistor r=9.24251 //w=0.367 //l=0.265 //layer=li \
 //thickness=0.1 //x=59.215 //y=7.585 //x2=58.95 //y2=7.585
r1674 (  694 1091 ) resistor r=2.87058 //w=0.35 //l=0.085 //layer=li \
 //thickness=0.1 //x=57.215 //y=7.585 //x2=57.13 //y2=7.585
r1675 (  694 696 ) resistor r=8.89373 //w=0.367 //l=0.255 //layer=li \
 //thickness=0.1 //x=57.215 //y=7.585 //x2=57.47 //y2=7.585
r1676 (  693 1092 ) resistor r=5.29055 //w=0.35 //l=0.17 //layer=li \
 //thickness=0.1 //x=58.04 //y=7.585 //x2=58.21 //y2=7.585
r1677 (  693 696 ) resistor r=19.8801 //w=0.367 //l=0.57 //layer=li \
 //thickness=0.1 //x=58.04 //y=7.585 //x2=57.47 //y2=7.585
r1678 (  687 1091 ) resistor r=4.23183 //w=0.7 //l=0.175 //layer=li \
 //thickness=0.1 //x=57.13 //y=7.41 //x2=57.13 //y2=7.585
r1679 (  687 1181 ) resistor r=33.1979 //w=0.187 //l=0.485 //layer=li \
 //thickness=0.1 //x=57.13 //y=7.41 //x2=57.13 //y2=6.925
r1680 (  684 1090 ) resistor r=2.87058 //w=0.35 //l=0.085 //layer=li \
 //thickness=0.1 //x=56.335 //y=7.585 //x2=56.25 //y2=7.585
r1681 (  684 686 ) resistor r=0.871935 //w=0.367 //l=0.025 //layer=li \
 //thickness=0.1 //x=56.335 //y=7.585 //x2=56.36 //y2=7.585
r1682 (  683 1091 ) resistor r=2.87058 //w=0.35 //l=0.085 //layer=li \
 //thickness=0.1 //x=57.045 //y=7.585 //x2=57.13 //y2=7.585
r1683 (  683 686 ) resistor r=23.891 //w=0.367 //l=0.685 //layer=li \
 //thickness=0.1 //x=57.045 //y=7.585 //x2=56.36 //y2=7.585
r1684 (  677 1090 ) resistor r=4.23183 //w=0.7 //l=0.175 //layer=li \
 //thickness=0.1 //x=56.25 //y=7.41 //x2=56.25 //y2=7.585
r1685 (  677 1180 ) resistor r=33.1979 //w=0.187 //l=0.485 //layer=li \
 //thickness=0.1 //x=56.25 //y=7.41 //x2=56.25 //y2=6.925
r1686 (  676 1089 ) resistor r=2.87058 //w=0.35 //l=0.085 //layer=li \
 //thickness=0.1 //x=55.455 //y=7.585 //x2=55.37 //y2=7.585
r1687 (  675 1090 ) resistor r=2.87058 //w=0.35 //l=0.085 //layer=li \
 //thickness=0.1 //x=56.165 //y=7.585 //x2=56.25 //y2=7.585
r1688 (  675 676 ) resistor r=24.7629 //w=0.367 //l=0.71 //layer=li \
 //thickness=0.1 //x=56.165 //y=7.585 //x2=55.455 //y2=7.585
r1689 (  669 1089 ) resistor r=4.23183 //w=0.7 //l=0.175 //layer=li \
 //thickness=0.1 //x=55.37 //y=7.41 //x2=55.37 //y2=7.585
r1690 (  669 1179 ) resistor r=33.1979 //w=0.187 //l=0.485 //layer=li \
 //thickness=0.1 //x=55.37 //y=7.41 //x2=55.37 //y2=6.925
r1691 (  666 1088 ) resistor r=2.87058 //w=0.35 //l=0.085 //layer=li \
 //thickness=0.1 //x=54.575 //y=7.585 //x2=54.49 //y2=7.585
r1692 (  666 668 ) resistor r=23.5422 //w=0.367 //l=0.675 //layer=li \
 //thickness=0.1 //x=54.575 //y=7.585 //x2=55.25 //y2=7.585
r1693 (  665 1089 ) resistor r=2.87058 //w=0.35 //l=0.085 //layer=li \
 //thickness=0.1 //x=55.285 //y=7.585 //x2=55.37 //y2=7.585
r1694 (  665 668 ) resistor r=1.22071 //w=0.367 //l=0.035 //layer=li \
 //thickness=0.1 //x=55.285 //y=7.585 //x2=55.25 //y2=7.585
r1695 (  659 1088 ) resistor r=4.23183 //w=0.7 //l=0.175 //layer=li \
 //thickness=0.1 //x=54.49 //y=7.41 //x2=54.49 //y2=7.585
r1696 (  659 1178 ) resistor r=56.4706 //w=0.187 //l=0.825 //layer=li \
 //thickness=0.1 //x=54.49 //y=7.41 //x2=54.49 //y2=6.585
r1697 (  656 1087 ) resistor r=5.29055 //w=0.35 //l=0.17 //layer=li \
 //thickness=0.1 //x=53.57 //y=7.585 //x2=53.4 //y2=7.585
r1698 (  656 658 ) resistor r=19.8801 //w=0.367 //l=0.57 //layer=li \
 //thickness=0.1 //x=53.57 //y=7.585 //x2=54.14 //y2=7.585
r1699 (  655 1088 ) resistor r=2.87058 //w=0.35 //l=0.085 //layer=li \
 //thickness=0.1 //x=54.405 //y=7.585 //x2=54.49 //y2=7.585
r1700 (  655 658 ) resistor r=9.24251 //w=0.367 //l=0.265 //layer=li \
 //thickness=0.1 //x=54.405 //y=7.585 //x2=54.14 //y2=7.585
r1701 (  650 1086 ) resistor r=2.87058 //w=0.35 //l=0.085 //layer=li \
 //thickness=0.1 //x=52.405 //y=7.585 //x2=52.32 //y2=7.585
r1702 (  650 652 ) resistor r=8.89373 //w=0.367 //l=0.255 //layer=li \
 //thickness=0.1 //x=52.405 //y=7.585 //x2=52.66 //y2=7.585
r1703 (  649 1087 ) resistor r=5.29055 //w=0.35 //l=0.17 //layer=li \
 //thickness=0.1 //x=53.23 //y=7.585 //x2=53.4 //y2=7.585
r1704 (  649 652 ) resistor r=19.8801 //w=0.367 //l=0.57 //layer=li \
 //thickness=0.1 //x=53.23 //y=7.585 //x2=52.66 //y2=7.585
r1705 (  643 1086 ) resistor r=4.23183 //w=0.7 //l=0.175 //layer=li \
 //thickness=0.1 //x=52.32 //y=7.41 //x2=52.32 //y2=7.585
r1706 (  643 1177 ) resistor r=33.1979 //w=0.187 //l=0.485 //layer=li \
 //thickness=0.1 //x=52.32 //y=7.41 //x2=52.32 //y2=6.925
r1707 (  640 1085 ) resistor r=2.87058 //w=0.35 //l=0.085 //layer=li \
 //thickness=0.1 //x=51.525 //y=7.585 //x2=51.44 //y2=7.585
r1708 (  640 642 ) resistor r=0.871935 //w=0.367 //l=0.025 //layer=li \
 //thickness=0.1 //x=51.525 //y=7.585 //x2=51.55 //y2=7.585
r1709 (  639 1086 ) resistor r=2.87058 //w=0.35 //l=0.085 //layer=li \
 //thickness=0.1 //x=52.235 //y=7.585 //x2=52.32 //y2=7.585
r1710 (  639 642 ) resistor r=23.891 //w=0.367 //l=0.685 //layer=li \
 //thickness=0.1 //x=52.235 //y=7.585 //x2=51.55 //y2=7.585
r1711 (  633 1085 ) resistor r=4.23183 //w=0.7 //l=0.175 //layer=li \
 //thickness=0.1 //x=51.44 //y=7.41 //x2=51.44 //y2=7.585
r1712 (  633 1176 ) resistor r=33.1979 //w=0.187 //l=0.485 //layer=li \
 //thickness=0.1 //x=51.44 //y=7.41 //x2=51.44 //y2=6.925
r1713 (  632 1084 ) resistor r=2.87058 //w=0.35 //l=0.085 //layer=li \
 //thickness=0.1 //x=50.645 //y=7.585 //x2=50.56 //y2=7.585
r1714 (  631 1085 ) resistor r=2.87058 //w=0.35 //l=0.085 //layer=li \
 //thickness=0.1 //x=51.355 //y=7.585 //x2=51.44 //y2=7.585
r1715 (  631 632 ) resistor r=24.7629 //w=0.367 //l=0.71 //layer=li \
 //thickness=0.1 //x=51.355 //y=7.585 //x2=50.645 //y2=7.585
r1716 (  625 1084 ) resistor r=4.23183 //w=0.7 //l=0.175 //layer=li \
 //thickness=0.1 //x=50.56 //y=7.41 //x2=50.56 //y2=7.585
r1717 (  625 1175 ) resistor r=33.1979 //w=0.187 //l=0.485 //layer=li \
 //thickness=0.1 //x=50.56 //y=7.41 //x2=50.56 //y2=6.925
r1718 (  622 1083 ) resistor r=2.87058 //w=0.35 //l=0.085 //layer=li \
 //thickness=0.1 //x=49.765 //y=7.585 //x2=49.68 //y2=7.585
r1719 (  622 624 ) resistor r=23.5422 //w=0.367 //l=0.675 //layer=li \
 //thickness=0.1 //x=49.765 //y=7.585 //x2=50.44 //y2=7.585
r1720 (  621 1084 ) resistor r=2.87058 //w=0.35 //l=0.085 //layer=li \
 //thickness=0.1 //x=50.475 //y=7.585 //x2=50.56 //y2=7.585
r1721 (  621 624 ) resistor r=1.22071 //w=0.367 //l=0.035 //layer=li \
 //thickness=0.1 //x=50.475 //y=7.585 //x2=50.44 //y2=7.585
r1722 (  615 1083 ) resistor r=4.23183 //w=0.7 //l=0.175 //layer=li \
 //thickness=0.1 //x=49.68 //y=7.41 //x2=49.68 //y2=7.585
r1723 (  615 1174 ) resistor r=56.4706 //w=0.187 //l=0.825 //layer=li \
 //thickness=0.1 //x=49.68 //y=7.41 //x2=49.68 //y2=6.585
r1724 (  612 1082 ) resistor r=5.29055 //w=0.35 //l=0.17 //layer=li \
 //thickness=0.1 //x=48.76 //y=7.585 //x2=48.59 //y2=7.585
r1725 (  612 614 ) resistor r=19.8801 //w=0.367 //l=0.57 //layer=li \
 //thickness=0.1 //x=48.76 //y=7.585 //x2=49.33 //y2=7.585
r1726 (  611 1083 ) resistor r=2.87058 //w=0.35 //l=0.085 //layer=li \
 //thickness=0.1 //x=49.595 //y=7.585 //x2=49.68 //y2=7.585
r1727 (  611 614 ) resistor r=9.24251 //w=0.367 //l=0.265 //layer=li \
 //thickness=0.1 //x=49.595 //y=7.585 //x2=49.33 //y2=7.585
r1728 (  606 1081 ) resistor r=2.87058 //w=0.35 //l=0.085 //layer=li \
 //thickness=0.1 //x=47.595 //y=7.585 //x2=47.51 //y2=7.585
r1729 (  606 608 ) resistor r=8.89373 //w=0.367 //l=0.255 //layer=li \
 //thickness=0.1 //x=47.595 //y=7.585 //x2=47.85 //y2=7.585
r1730 (  605 1082 ) resistor r=5.29055 //w=0.35 //l=0.17 //layer=li \
 //thickness=0.1 //x=48.42 //y=7.585 //x2=48.59 //y2=7.585
r1731 (  605 608 ) resistor r=19.8801 //w=0.367 //l=0.57 //layer=li \
 //thickness=0.1 //x=48.42 //y=7.585 //x2=47.85 //y2=7.585
r1732 (  599 1081 ) resistor r=4.23183 //w=0.7 //l=0.175 //layer=li \
 //thickness=0.1 //x=47.51 //y=7.41 //x2=47.51 //y2=7.585
r1733 (  599 1173 ) resistor r=33.1979 //w=0.187 //l=0.485 //layer=li \
 //thickness=0.1 //x=47.51 //y=7.41 //x2=47.51 //y2=6.925
r1734 (  596 1080 ) resistor r=2.87058 //w=0.35 //l=0.085 //layer=li \
 //thickness=0.1 //x=46.715 //y=7.585 //x2=46.63 //y2=7.585
r1735 (  596 598 ) resistor r=0.871935 //w=0.367 //l=0.025 //layer=li \
 //thickness=0.1 //x=46.715 //y=7.585 //x2=46.74 //y2=7.585
r1736 (  595 1081 ) resistor r=2.87058 //w=0.35 //l=0.085 //layer=li \
 //thickness=0.1 //x=47.425 //y=7.585 //x2=47.51 //y2=7.585
r1737 (  595 598 ) resistor r=23.891 //w=0.367 //l=0.685 //layer=li \
 //thickness=0.1 //x=47.425 //y=7.585 //x2=46.74 //y2=7.585
r1738 (  589 1080 ) resistor r=4.23183 //w=0.7 //l=0.175 //layer=li \
 //thickness=0.1 //x=46.63 //y=7.41 //x2=46.63 //y2=7.585
r1739 (  589 1172 ) resistor r=33.1979 //w=0.187 //l=0.485 //layer=li \
 //thickness=0.1 //x=46.63 //y=7.41 //x2=46.63 //y2=6.925
r1740 (  588 1079 ) resistor r=2.87058 //w=0.35 //l=0.085 //layer=li \
 //thickness=0.1 //x=45.835 //y=7.585 //x2=45.75 //y2=7.585
r1741 (  587 1080 ) resistor r=2.87058 //w=0.35 //l=0.085 //layer=li \
 //thickness=0.1 //x=46.545 //y=7.585 //x2=46.63 //y2=7.585
r1742 (  587 588 ) resistor r=24.7629 //w=0.367 //l=0.71 //layer=li \
 //thickness=0.1 //x=46.545 //y=7.585 //x2=45.835 //y2=7.585
r1743 (  581 1079 ) resistor r=4.23183 //w=0.7 //l=0.175 //layer=li \
 //thickness=0.1 //x=45.75 //y=7.41 //x2=45.75 //y2=7.585
r1744 (  581 1171 ) resistor r=33.1979 //w=0.187 //l=0.485 //layer=li \
 //thickness=0.1 //x=45.75 //y=7.41 //x2=45.75 //y2=6.925
r1745 (  578 1078 ) resistor r=2.87058 //w=0.35 //l=0.085 //layer=li \
 //thickness=0.1 //x=44.955 //y=7.585 //x2=44.87 //y2=7.585
r1746 (  578 580 ) resistor r=23.5422 //w=0.367 //l=0.675 //layer=li \
 //thickness=0.1 //x=44.955 //y=7.585 //x2=45.63 //y2=7.585
r1747 (  577 1079 ) resistor r=2.87058 //w=0.35 //l=0.085 //layer=li \
 //thickness=0.1 //x=45.665 //y=7.585 //x2=45.75 //y2=7.585
r1748 (  577 580 ) resistor r=1.22071 //w=0.367 //l=0.035 //layer=li \
 //thickness=0.1 //x=45.665 //y=7.585 //x2=45.63 //y2=7.585
r1749 (  571 1078 ) resistor r=4.23183 //w=0.7 //l=0.175 //layer=li \
 //thickness=0.1 //x=44.87 //y=7.41 //x2=44.87 //y2=7.585
r1750 (  571 1170 ) resistor r=56.4706 //w=0.187 //l=0.825 //layer=li \
 //thickness=0.1 //x=44.87 //y=7.41 //x2=44.87 //y2=6.585
r1751 (  568 1077 ) resistor r=5.29055 //w=0.35 //l=0.17 //layer=li \
 //thickness=0.1 //x=43.95 //y=7.585 //x2=43.78 //y2=7.585
r1752 (  568 570 ) resistor r=19.8801 //w=0.367 //l=0.57 //layer=li \
 //thickness=0.1 //x=43.95 //y=7.585 //x2=44.52 //y2=7.585
r1753 (  567 1078 ) resistor r=2.87058 //w=0.35 //l=0.085 //layer=li \
 //thickness=0.1 //x=44.785 //y=7.585 //x2=44.87 //y2=7.585
r1754 (  567 570 ) resistor r=9.24251 //w=0.367 //l=0.265 //layer=li \
 //thickness=0.1 //x=44.785 //y=7.585 //x2=44.52 //y2=7.585
r1755 (  562 1076 ) resistor r=2.87058 //w=0.35 //l=0.085 //layer=li \
 //thickness=0.1 //x=42.785 //y=7.585 //x2=42.7 //y2=7.585
r1756 (  562 564 ) resistor r=8.89373 //w=0.367 //l=0.255 //layer=li \
 //thickness=0.1 //x=42.785 //y=7.585 //x2=43.04 //y2=7.585
r1757 (  561 1077 ) resistor r=5.29055 //w=0.35 //l=0.17 //layer=li \
 //thickness=0.1 //x=43.61 //y=7.585 //x2=43.78 //y2=7.585
r1758 (  561 564 ) resistor r=19.8801 //w=0.367 //l=0.57 //layer=li \
 //thickness=0.1 //x=43.61 //y=7.585 //x2=43.04 //y2=7.585
r1759 (  555 1076 ) resistor r=4.23183 //w=0.7 //l=0.175 //layer=li \
 //thickness=0.1 //x=42.7 //y=7.41 //x2=42.7 //y2=7.585
r1760 (  555 1169 ) resistor r=33.1979 //w=0.187 //l=0.485 //layer=li \
 //thickness=0.1 //x=42.7 //y=7.41 //x2=42.7 //y2=6.925
r1761 (  552 1075 ) resistor r=2.87058 //w=0.35 //l=0.085 //layer=li \
 //thickness=0.1 //x=41.905 //y=7.585 //x2=41.82 //y2=7.585
r1762 (  552 554 ) resistor r=0.871935 //w=0.367 //l=0.025 //layer=li \
 //thickness=0.1 //x=41.905 //y=7.585 //x2=41.93 //y2=7.585
r1763 (  551 1076 ) resistor r=2.87058 //w=0.35 //l=0.085 //layer=li \
 //thickness=0.1 //x=42.615 //y=7.585 //x2=42.7 //y2=7.585
r1764 (  551 554 ) resistor r=23.891 //w=0.367 //l=0.685 //layer=li \
 //thickness=0.1 //x=42.615 //y=7.585 //x2=41.93 //y2=7.585
r1765 (  545 1075 ) resistor r=4.23183 //w=0.7 //l=0.175 //layer=li \
 //thickness=0.1 //x=41.82 //y=7.41 //x2=41.82 //y2=7.585
r1766 (  545 1168 ) resistor r=33.1979 //w=0.187 //l=0.485 //layer=li \
 //thickness=0.1 //x=41.82 //y=7.41 //x2=41.82 //y2=6.925
r1767 (  544 1074 ) resistor r=2.87058 //w=0.35 //l=0.085 //layer=li \
 //thickness=0.1 //x=41.025 //y=7.585 //x2=40.94 //y2=7.585
r1768 (  543 1075 ) resistor r=2.87058 //w=0.35 //l=0.085 //layer=li \
 //thickness=0.1 //x=41.735 //y=7.585 //x2=41.82 //y2=7.585
r1769 (  543 544 ) resistor r=24.7629 //w=0.367 //l=0.71 //layer=li \
 //thickness=0.1 //x=41.735 //y=7.585 //x2=41.025 //y2=7.585
r1770 (  537 1074 ) resistor r=4.23183 //w=0.7 //l=0.175 //layer=li \
 //thickness=0.1 //x=40.94 //y=7.41 //x2=40.94 //y2=7.585
r1771 (  537 1167 ) resistor r=33.1979 //w=0.187 //l=0.485 //layer=li \
 //thickness=0.1 //x=40.94 //y=7.41 //x2=40.94 //y2=6.925
r1772 (  534 1073 ) resistor r=2.87058 //w=0.35 //l=0.085 //layer=li \
 //thickness=0.1 //x=40.145 //y=7.585 //x2=40.06 //y2=7.585
r1773 (  534 536 ) resistor r=23.5422 //w=0.367 //l=0.675 //layer=li \
 //thickness=0.1 //x=40.145 //y=7.585 //x2=40.82 //y2=7.585
r1774 (  533 1074 ) resistor r=2.87058 //w=0.35 //l=0.085 //layer=li \
 //thickness=0.1 //x=40.855 //y=7.585 //x2=40.94 //y2=7.585
r1775 (  533 536 ) resistor r=1.22071 //w=0.367 //l=0.035 //layer=li \
 //thickness=0.1 //x=40.855 //y=7.585 //x2=40.82 //y2=7.585
r1776 (  527 1073 ) resistor r=4.23183 //w=0.7 //l=0.175 //layer=li \
 //thickness=0.1 //x=40.06 //y=7.41 //x2=40.06 //y2=7.585
r1777 (  527 1166 ) resistor r=56.4706 //w=0.187 //l=0.825 //layer=li \
 //thickness=0.1 //x=40.06 //y=7.41 //x2=40.06 //y2=6.585
r1778 (  524 1072 ) resistor r=5.29055 //w=0.35 //l=0.17 //layer=li \
 //thickness=0.1 //x=39.14 //y=7.585 //x2=38.97 //y2=7.585
r1779 (  524 526 ) resistor r=19.8801 //w=0.367 //l=0.57 //layer=li \
 //thickness=0.1 //x=39.14 //y=7.585 //x2=39.71 //y2=7.585
r1780 (  523 1073 ) resistor r=2.87058 //w=0.35 //l=0.085 //layer=li \
 //thickness=0.1 //x=39.975 //y=7.585 //x2=40.06 //y2=7.585
r1781 (  523 526 ) resistor r=9.24251 //w=0.367 //l=0.265 //layer=li \
 //thickness=0.1 //x=39.975 //y=7.585 //x2=39.71 //y2=7.585
r1782 (  518 1071 ) resistor r=2.87058 //w=0.35 //l=0.085 //layer=li \
 //thickness=0.1 //x=37.975 //y=7.585 //x2=37.89 //y2=7.585
r1783 (  518 520 ) resistor r=8.89373 //w=0.367 //l=0.255 //layer=li \
 //thickness=0.1 //x=37.975 //y=7.585 //x2=38.23 //y2=7.585
r1784 (  517 1072 ) resistor r=5.29055 //w=0.35 //l=0.17 //layer=li \
 //thickness=0.1 //x=38.8 //y=7.585 //x2=38.97 //y2=7.585
r1785 (  517 520 ) resistor r=19.8801 //w=0.367 //l=0.57 //layer=li \
 //thickness=0.1 //x=38.8 //y=7.585 //x2=38.23 //y2=7.585
r1786 (  511 1071 ) resistor r=4.23183 //w=0.7 //l=0.175 //layer=li \
 //thickness=0.1 //x=37.89 //y=7.41 //x2=37.89 //y2=7.585
r1787 (  511 1165 ) resistor r=33.1979 //w=0.187 //l=0.485 //layer=li \
 //thickness=0.1 //x=37.89 //y=7.41 //x2=37.89 //y2=6.925
r1788 (  508 1070 ) resistor r=2.87058 //w=0.35 //l=0.085 //layer=li \
 //thickness=0.1 //x=37.095 //y=7.585 //x2=37.01 //y2=7.585
r1789 (  508 510 ) resistor r=0.871935 //w=0.367 //l=0.025 //layer=li \
 //thickness=0.1 //x=37.095 //y=7.585 //x2=37.12 //y2=7.585
r1790 (  507 1071 ) resistor r=2.87058 //w=0.35 //l=0.085 //layer=li \
 //thickness=0.1 //x=37.805 //y=7.585 //x2=37.89 //y2=7.585
r1791 (  507 510 ) resistor r=23.891 //w=0.367 //l=0.685 //layer=li \
 //thickness=0.1 //x=37.805 //y=7.585 //x2=37.12 //y2=7.585
r1792 (  501 1070 ) resistor r=4.23183 //w=0.7 //l=0.175 //layer=li \
 //thickness=0.1 //x=37.01 //y=7.41 //x2=37.01 //y2=7.585
r1793 (  501 1164 ) resistor r=33.1979 //w=0.187 //l=0.485 //layer=li \
 //thickness=0.1 //x=37.01 //y=7.41 //x2=37.01 //y2=6.925
r1794 (  500 1069 ) resistor r=2.87058 //w=0.35 //l=0.085 //layer=li \
 //thickness=0.1 //x=36.215 //y=7.585 //x2=36.13 //y2=7.585
r1795 (  499 1070 ) resistor r=2.87058 //w=0.35 //l=0.085 //layer=li \
 //thickness=0.1 //x=36.925 //y=7.585 //x2=37.01 //y2=7.585
r1796 (  499 500 ) resistor r=24.7629 //w=0.367 //l=0.71 //layer=li \
 //thickness=0.1 //x=36.925 //y=7.585 //x2=36.215 //y2=7.585
r1797 (  493 1069 ) resistor r=4.23183 //w=0.7 //l=0.175 //layer=li \
 //thickness=0.1 //x=36.13 //y=7.41 //x2=36.13 //y2=7.585
r1798 (  493 1163 ) resistor r=33.1979 //w=0.187 //l=0.485 //layer=li \
 //thickness=0.1 //x=36.13 //y=7.41 //x2=36.13 //y2=6.925
r1799 (  490 1068 ) resistor r=2.87058 //w=0.35 //l=0.085 //layer=li \
 //thickness=0.1 //x=35.335 //y=7.585 //x2=35.25 //y2=7.585
r1800 (  490 492 ) resistor r=23.5422 //w=0.367 //l=0.675 //layer=li \
 //thickness=0.1 //x=35.335 //y=7.585 //x2=36.01 //y2=7.585
r1801 (  489 1069 ) resistor r=2.87058 //w=0.35 //l=0.085 //layer=li \
 //thickness=0.1 //x=36.045 //y=7.585 //x2=36.13 //y2=7.585
r1802 (  489 492 ) resistor r=1.22071 //w=0.367 //l=0.035 //layer=li \
 //thickness=0.1 //x=36.045 //y=7.585 //x2=36.01 //y2=7.585
r1803 (  483 1068 ) resistor r=4.23183 //w=0.7 //l=0.175 //layer=li \
 //thickness=0.1 //x=35.25 //y=7.41 //x2=35.25 //y2=7.585
r1804 (  483 1162 ) resistor r=56.4706 //w=0.187 //l=0.825 //layer=li \
 //thickness=0.1 //x=35.25 //y=7.41 //x2=35.25 //y2=6.585
r1805 (  480 1067 ) resistor r=5.29055 //w=0.35 //l=0.17 //layer=li \
 //thickness=0.1 //x=34.33 //y=7.585 //x2=34.16 //y2=7.585
r1806 (  480 482 ) resistor r=19.8801 //w=0.367 //l=0.57 //layer=li \
 //thickness=0.1 //x=34.33 //y=7.585 //x2=34.9 //y2=7.585
r1807 (  479 1068 ) resistor r=2.87058 //w=0.35 //l=0.085 //layer=li \
 //thickness=0.1 //x=35.165 //y=7.585 //x2=35.25 //y2=7.585
r1808 (  479 482 ) resistor r=9.24251 //w=0.367 //l=0.265 //layer=li \
 //thickness=0.1 //x=35.165 //y=7.585 //x2=34.9 //y2=7.585
r1809 (  474 1066 ) resistor r=2.87058 //w=0.35 //l=0.085 //layer=li \
 //thickness=0.1 //x=33.165 //y=7.585 //x2=33.08 //y2=7.585
r1810 (  474 476 ) resistor r=8.89373 //w=0.367 //l=0.255 //layer=li \
 //thickness=0.1 //x=33.165 //y=7.585 //x2=33.42 //y2=7.585
r1811 (  473 1067 ) resistor r=5.29055 //w=0.35 //l=0.17 //layer=li \
 //thickness=0.1 //x=33.99 //y=7.585 //x2=34.16 //y2=7.585
r1812 (  473 476 ) resistor r=19.8801 //w=0.367 //l=0.57 //layer=li \
 //thickness=0.1 //x=33.99 //y=7.585 //x2=33.42 //y2=7.585
r1813 (  467 1066 ) resistor r=4.23183 //w=0.7 //l=0.175 //layer=li \
 //thickness=0.1 //x=33.08 //y=7.41 //x2=33.08 //y2=7.585
r1814 (  467 1161 ) resistor r=33.1979 //w=0.187 //l=0.485 //layer=li \
 //thickness=0.1 //x=33.08 //y=7.41 //x2=33.08 //y2=6.925
r1815 (  464 1065 ) resistor r=2.87058 //w=0.35 //l=0.085 //layer=li \
 //thickness=0.1 //x=32.285 //y=7.585 //x2=32.2 //y2=7.585
r1816 (  464 466 ) resistor r=0.871935 //w=0.367 //l=0.025 //layer=li \
 //thickness=0.1 //x=32.285 //y=7.585 //x2=32.31 //y2=7.585
r1817 (  463 1066 ) resistor r=2.87058 //w=0.35 //l=0.085 //layer=li \
 //thickness=0.1 //x=32.995 //y=7.585 //x2=33.08 //y2=7.585
r1818 (  463 466 ) resistor r=23.891 //w=0.367 //l=0.685 //layer=li \
 //thickness=0.1 //x=32.995 //y=7.585 //x2=32.31 //y2=7.585
r1819 (  457 1065 ) resistor r=4.23183 //w=0.7 //l=0.175 //layer=li \
 //thickness=0.1 //x=32.2 //y=7.41 //x2=32.2 //y2=7.585
r1820 (  457 1160 ) resistor r=33.1979 //w=0.187 //l=0.485 //layer=li \
 //thickness=0.1 //x=32.2 //y=7.41 //x2=32.2 //y2=6.925
r1821 (  456 1064 ) resistor r=2.87058 //w=0.35 //l=0.085 //layer=li \
 //thickness=0.1 //x=31.405 //y=7.585 //x2=31.32 //y2=7.585
r1822 (  455 1065 ) resistor r=2.87058 //w=0.35 //l=0.085 //layer=li \
 //thickness=0.1 //x=32.115 //y=7.585 //x2=32.2 //y2=7.585
r1823 (  455 456 ) resistor r=24.7629 //w=0.367 //l=0.71 //layer=li \
 //thickness=0.1 //x=32.115 //y=7.585 //x2=31.405 //y2=7.585
r1824 (  449 1064 ) resistor r=4.23183 //w=0.7 //l=0.175 //layer=li \
 //thickness=0.1 //x=31.32 //y=7.41 //x2=31.32 //y2=7.585
r1825 (  449 1159 ) resistor r=33.1979 //w=0.187 //l=0.485 //layer=li \
 //thickness=0.1 //x=31.32 //y=7.41 //x2=31.32 //y2=6.925
r1826 (  446 1063 ) resistor r=2.87058 //w=0.35 //l=0.085 //layer=li \
 //thickness=0.1 //x=30.525 //y=7.585 //x2=30.44 //y2=7.585
r1827 (  446 448 ) resistor r=23.5422 //w=0.367 //l=0.675 //layer=li \
 //thickness=0.1 //x=30.525 //y=7.585 //x2=31.2 //y2=7.585
r1828 (  445 1064 ) resistor r=2.87058 //w=0.35 //l=0.085 //layer=li \
 //thickness=0.1 //x=31.235 //y=7.585 //x2=31.32 //y2=7.585
r1829 (  445 448 ) resistor r=1.22071 //w=0.367 //l=0.035 //layer=li \
 //thickness=0.1 //x=31.235 //y=7.585 //x2=31.2 //y2=7.585
r1830 (  439 1063 ) resistor r=4.23183 //w=0.7 //l=0.175 //layer=li \
 //thickness=0.1 //x=30.44 //y=7.41 //x2=30.44 //y2=7.585
r1831 (  439 1158 ) resistor r=56.4706 //w=0.187 //l=0.825 //layer=li \
 //thickness=0.1 //x=30.44 //y=7.41 //x2=30.44 //y2=6.585
r1832 (  436 1062 ) resistor r=5.29055 //w=0.35 //l=0.17 //layer=li \
 //thickness=0.1 //x=29.52 //y=7.585 //x2=29.35 //y2=7.585
r1833 (  436 438 ) resistor r=19.8801 //w=0.367 //l=0.57 //layer=li \
 //thickness=0.1 //x=29.52 //y=7.585 //x2=30.09 //y2=7.585
r1834 (  435 1063 ) resistor r=2.87058 //w=0.35 //l=0.085 //layer=li \
 //thickness=0.1 //x=30.355 //y=7.585 //x2=30.44 //y2=7.585
r1835 (  435 438 ) resistor r=9.24251 //w=0.367 //l=0.265 //layer=li \
 //thickness=0.1 //x=30.355 //y=7.585 //x2=30.09 //y2=7.585
r1836 (  430 1061 ) resistor r=2.87058 //w=0.35 //l=0.085 //layer=li \
 //thickness=0.1 //x=28.355 //y=7.585 //x2=28.27 //y2=7.585
r1837 (  430 432 ) resistor r=8.89373 //w=0.367 //l=0.255 //layer=li \
 //thickness=0.1 //x=28.355 //y=7.585 //x2=28.61 //y2=7.585
r1838 (  429 1062 ) resistor r=5.29055 //w=0.35 //l=0.17 //layer=li \
 //thickness=0.1 //x=29.18 //y=7.585 //x2=29.35 //y2=7.585
r1839 (  429 432 ) resistor r=19.8801 //w=0.367 //l=0.57 //layer=li \
 //thickness=0.1 //x=29.18 //y=7.585 //x2=28.61 //y2=7.585
r1840 (  423 1061 ) resistor r=4.23183 //w=0.7 //l=0.175 //layer=li \
 //thickness=0.1 //x=28.27 //y=7.41 //x2=28.27 //y2=7.585
r1841 (  423 1157 ) resistor r=33.1979 //w=0.187 //l=0.485 //layer=li \
 //thickness=0.1 //x=28.27 //y=7.41 //x2=28.27 //y2=6.925
r1842 (  420 1060 ) resistor r=2.87058 //w=0.35 //l=0.085 //layer=li \
 //thickness=0.1 //x=27.475 //y=7.585 //x2=27.39 //y2=7.585
r1843 (  420 422 ) resistor r=0.871935 //w=0.367 //l=0.025 //layer=li \
 //thickness=0.1 //x=27.475 //y=7.585 //x2=27.5 //y2=7.585
r1844 (  419 1061 ) resistor r=2.87058 //w=0.35 //l=0.085 //layer=li \
 //thickness=0.1 //x=28.185 //y=7.585 //x2=28.27 //y2=7.585
r1845 (  419 422 ) resistor r=23.891 //w=0.367 //l=0.685 //layer=li \
 //thickness=0.1 //x=28.185 //y=7.585 //x2=27.5 //y2=7.585
r1846 (  413 1060 ) resistor r=4.23183 //w=0.7 //l=0.175 //layer=li \
 //thickness=0.1 //x=27.39 //y=7.41 //x2=27.39 //y2=7.585
r1847 (  413 1156 ) resistor r=33.1979 //w=0.187 //l=0.485 //layer=li \
 //thickness=0.1 //x=27.39 //y=7.41 //x2=27.39 //y2=6.925
r1848 (  412 1059 ) resistor r=2.87058 //w=0.35 //l=0.085 //layer=li \
 //thickness=0.1 //x=26.595 //y=7.585 //x2=26.51 //y2=7.585
r1849 (  411 1060 ) resistor r=2.87058 //w=0.35 //l=0.085 //layer=li \
 //thickness=0.1 //x=27.305 //y=7.585 //x2=27.39 //y2=7.585
r1850 (  411 412 ) resistor r=24.7629 //w=0.367 //l=0.71 //layer=li \
 //thickness=0.1 //x=27.305 //y=7.585 //x2=26.595 //y2=7.585
r1851 (  405 1059 ) resistor r=4.23183 //w=0.7 //l=0.175 //layer=li \
 //thickness=0.1 //x=26.51 //y=7.41 //x2=26.51 //y2=7.585
r1852 (  405 1155 ) resistor r=33.1979 //w=0.187 //l=0.485 //layer=li \
 //thickness=0.1 //x=26.51 //y=7.41 //x2=26.51 //y2=6.925
r1853 (  402 1058 ) resistor r=2.87058 //w=0.35 //l=0.085 //layer=li \
 //thickness=0.1 //x=25.715 //y=7.585 //x2=25.63 //y2=7.585
r1854 (  402 404 ) resistor r=23.5422 //w=0.367 //l=0.675 //layer=li \
 //thickness=0.1 //x=25.715 //y=7.585 //x2=26.39 //y2=7.585
r1855 (  401 1059 ) resistor r=2.87058 //w=0.35 //l=0.085 //layer=li \
 //thickness=0.1 //x=26.425 //y=7.585 //x2=26.51 //y2=7.585
r1856 (  401 404 ) resistor r=1.22071 //w=0.367 //l=0.035 //layer=li \
 //thickness=0.1 //x=26.425 //y=7.585 //x2=26.39 //y2=7.585
r1857 (  395 1058 ) resistor r=4.23183 //w=0.7 //l=0.175 //layer=li \
 //thickness=0.1 //x=25.63 //y=7.41 //x2=25.63 //y2=7.585
r1858 (  395 1154 ) resistor r=56.4706 //w=0.187 //l=0.825 //layer=li \
 //thickness=0.1 //x=25.63 //y=7.41 //x2=25.63 //y2=6.585
r1859 (  392 1057 ) resistor r=5.29055 //w=0.35 //l=0.17 //layer=li \
 //thickness=0.1 //x=24.71 //y=7.585 //x2=24.54 //y2=7.585
r1860 (  392 394 ) resistor r=19.8801 //w=0.367 //l=0.57 //layer=li \
 //thickness=0.1 //x=24.71 //y=7.585 //x2=25.28 //y2=7.585
r1861 (  391 1058 ) resistor r=2.87058 //w=0.35 //l=0.085 //layer=li \
 //thickness=0.1 //x=25.545 //y=7.585 //x2=25.63 //y2=7.585
r1862 (  391 394 ) resistor r=9.24251 //w=0.367 //l=0.265 //layer=li \
 //thickness=0.1 //x=25.545 //y=7.585 //x2=25.28 //y2=7.585
r1863 (  386 1056 ) resistor r=2.87058 //w=0.35 //l=0.085 //layer=li \
 //thickness=0.1 //x=23.545 //y=7.585 //x2=23.46 //y2=7.585
r1864 (  386 388 ) resistor r=8.89373 //w=0.367 //l=0.255 //layer=li \
 //thickness=0.1 //x=23.545 //y=7.585 //x2=23.8 //y2=7.585
r1865 (  385 1057 ) resistor r=5.29055 //w=0.35 //l=0.17 //layer=li \
 //thickness=0.1 //x=24.37 //y=7.585 //x2=24.54 //y2=7.585
r1866 (  385 388 ) resistor r=19.8801 //w=0.367 //l=0.57 //layer=li \
 //thickness=0.1 //x=24.37 //y=7.585 //x2=23.8 //y2=7.585
r1867 (  379 1056 ) resistor r=4.23183 //w=0.7 //l=0.175 //layer=li \
 //thickness=0.1 //x=23.46 //y=7.41 //x2=23.46 //y2=7.585
r1868 (  379 1153 ) resistor r=33.1979 //w=0.187 //l=0.485 //layer=li \
 //thickness=0.1 //x=23.46 //y=7.41 //x2=23.46 //y2=6.925
r1869 (  376 1055 ) resistor r=2.87058 //w=0.35 //l=0.085 //layer=li \
 //thickness=0.1 //x=22.665 //y=7.585 //x2=22.58 //y2=7.585
r1870 (  376 378 ) resistor r=0.871935 //w=0.367 //l=0.025 //layer=li \
 //thickness=0.1 //x=22.665 //y=7.585 //x2=22.69 //y2=7.585
r1871 (  375 1056 ) resistor r=2.87058 //w=0.35 //l=0.085 //layer=li \
 //thickness=0.1 //x=23.375 //y=7.585 //x2=23.46 //y2=7.585
r1872 (  375 378 ) resistor r=23.891 //w=0.367 //l=0.685 //layer=li \
 //thickness=0.1 //x=23.375 //y=7.585 //x2=22.69 //y2=7.585
r1873 (  369 1055 ) resistor r=4.23183 //w=0.7 //l=0.175 //layer=li \
 //thickness=0.1 //x=22.58 //y=7.41 //x2=22.58 //y2=7.585
r1874 (  369 1152 ) resistor r=33.1979 //w=0.187 //l=0.485 //layer=li \
 //thickness=0.1 //x=22.58 //y=7.41 //x2=22.58 //y2=6.925
r1875 (  368 1054 ) resistor r=2.87058 //w=0.35 //l=0.085 //layer=li \
 //thickness=0.1 //x=21.785 //y=7.585 //x2=21.7 //y2=7.585
r1876 (  367 1055 ) resistor r=2.87058 //w=0.35 //l=0.085 //layer=li \
 //thickness=0.1 //x=22.495 //y=7.585 //x2=22.58 //y2=7.585
r1877 (  367 368 ) resistor r=24.7629 //w=0.367 //l=0.71 //layer=li \
 //thickness=0.1 //x=22.495 //y=7.585 //x2=21.785 //y2=7.585
r1878 (  361 1054 ) resistor r=4.23183 //w=0.7 //l=0.175 //layer=li \
 //thickness=0.1 //x=21.7 //y=7.41 //x2=21.7 //y2=7.585
r1879 (  361 1151 ) resistor r=33.1979 //w=0.187 //l=0.485 //layer=li \
 //thickness=0.1 //x=21.7 //y=7.41 //x2=21.7 //y2=6.925
r1880 (  358 1053 ) resistor r=2.87058 //w=0.35 //l=0.085 //layer=li \
 //thickness=0.1 //x=20.905 //y=7.585 //x2=20.82 //y2=7.585
r1881 (  358 360 ) resistor r=23.5422 //w=0.367 //l=0.675 //layer=li \
 //thickness=0.1 //x=20.905 //y=7.585 //x2=21.58 //y2=7.585
r1882 (  357 1054 ) resistor r=2.87058 //w=0.35 //l=0.085 //layer=li \
 //thickness=0.1 //x=21.615 //y=7.585 //x2=21.7 //y2=7.585
r1883 (  357 360 ) resistor r=1.22071 //w=0.367 //l=0.035 //layer=li \
 //thickness=0.1 //x=21.615 //y=7.585 //x2=21.58 //y2=7.585
r1884 (  351 1053 ) resistor r=4.23183 //w=0.7 //l=0.175 //layer=li \
 //thickness=0.1 //x=20.82 //y=7.41 //x2=20.82 //y2=7.585
r1885 (  351 1150 ) resistor r=56.4706 //w=0.187 //l=0.825 //layer=li \
 //thickness=0.1 //x=20.82 //y=7.41 //x2=20.82 //y2=6.585
r1886 (  348 1052 ) resistor r=5.29055 //w=0.35 //l=0.17 //layer=li \
 //thickness=0.1 //x=19.9 //y=7.585 //x2=19.73 //y2=7.585
r1887 (  348 350 ) resistor r=19.8801 //w=0.367 //l=0.57 //layer=li \
 //thickness=0.1 //x=19.9 //y=7.585 //x2=20.47 //y2=7.585
r1888 (  347 1053 ) resistor r=2.87058 //w=0.35 //l=0.085 //layer=li \
 //thickness=0.1 //x=20.735 //y=7.585 //x2=20.82 //y2=7.585
r1889 (  347 350 ) resistor r=9.24251 //w=0.367 //l=0.265 //layer=li \
 //thickness=0.1 //x=20.735 //y=7.585 //x2=20.47 //y2=7.585
r1890 (  342 1051 ) resistor r=2.87058 //w=0.35 //l=0.085 //layer=li \
 //thickness=0.1 //x=18.735 //y=7.585 //x2=18.65 //y2=7.585
r1891 (  342 344 ) resistor r=8.89373 //w=0.367 //l=0.255 //layer=li \
 //thickness=0.1 //x=18.735 //y=7.585 //x2=18.99 //y2=7.585
r1892 (  341 1052 ) resistor r=5.29055 //w=0.35 //l=0.17 //layer=li \
 //thickness=0.1 //x=19.56 //y=7.585 //x2=19.73 //y2=7.585
r1893 (  341 344 ) resistor r=19.8801 //w=0.367 //l=0.57 //layer=li \
 //thickness=0.1 //x=19.56 //y=7.585 //x2=18.99 //y2=7.585
r1894 (  335 1051 ) resistor r=4.23183 //w=0.7 //l=0.175 //layer=li \
 //thickness=0.1 //x=18.65 //y=7.41 //x2=18.65 //y2=7.585
r1895 (  335 1149 ) resistor r=33.1979 //w=0.187 //l=0.485 //layer=li \
 //thickness=0.1 //x=18.65 //y=7.41 //x2=18.65 //y2=6.925
r1896 (  332 1050 ) resistor r=2.87058 //w=0.35 //l=0.085 //layer=li \
 //thickness=0.1 //x=17.855 //y=7.585 //x2=17.77 //y2=7.585
r1897 (  332 334 ) resistor r=0.871935 //w=0.367 //l=0.025 //layer=li \
 //thickness=0.1 //x=17.855 //y=7.585 //x2=17.88 //y2=7.585
r1898 (  331 1051 ) resistor r=2.87058 //w=0.35 //l=0.085 //layer=li \
 //thickness=0.1 //x=18.565 //y=7.585 //x2=18.65 //y2=7.585
r1899 (  331 334 ) resistor r=23.891 //w=0.367 //l=0.685 //layer=li \
 //thickness=0.1 //x=18.565 //y=7.585 //x2=17.88 //y2=7.585
r1900 (  325 1050 ) resistor r=4.23183 //w=0.7 //l=0.175 //layer=li \
 //thickness=0.1 //x=17.77 //y=7.41 //x2=17.77 //y2=7.585
r1901 (  325 1148 ) resistor r=33.1979 //w=0.187 //l=0.485 //layer=li \
 //thickness=0.1 //x=17.77 //y=7.41 //x2=17.77 //y2=6.925
r1902 (  324 1049 ) resistor r=2.87058 //w=0.35 //l=0.085 //layer=li \
 //thickness=0.1 //x=16.975 //y=7.585 //x2=16.89 //y2=7.585
r1903 (  323 1050 ) resistor r=2.87058 //w=0.35 //l=0.085 //layer=li \
 //thickness=0.1 //x=17.685 //y=7.585 //x2=17.77 //y2=7.585
r1904 (  323 324 ) resistor r=24.7629 //w=0.367 //l=0.71 //layer=li \
 //thickness=0.1 //x=17.685 //y=7.585 //x2=16.975 //y2=7.585
r1905 (  317 1049 ) resistor r=4.23183 //w=0.7 //l=0.175 //layer=li \
 //thickness=0.1 //x=16.89 //y=7.41 //x2=16.89 //y2=7.585
r1906 (  317 1147 ) resistor r=33.1979 //w=0.187 //l=0.485 //layer=li \
 //thickness=0.1 //x=16.89 //y=7.41 //x2=16.89 //y2=6.925
r1907 (  314 1048 ) resistor r=2.87058 //w=0.35 //l=0.085 //layer=li \
 //thickness=0.1 //x=16.095 //y=7.585 //x2=16.01 //y2=7.585
r1908 (  314 316 ) resistor r=23.5422 //w=0.367 //l=0.675 //layer=li \
 //thickness=0.1 //x=16.095 //y=7.585 //x2=16.77 //y2=7.585
r1909 (  313 1049 ) resistor r=2.87058 //w=0.35 //l=0.085 //layer=li \
 //thickness=0.1 //x=16.805 //y=7.585 //x2=16.89 //y2=7.585
r1910 (  313 316 ) resistor r=1.22071 //w=0.367 //l=0.035 //layer=li \
 //thickness=0.1 //x=16.805 //y=7.585 //x2=16.77 //y2=7.585
r1911 (  307 1048 ) resistor r=4.23183 //w=0.7 //l=0.175 //layer=li \
 //thickness=0.1 //x=16.01 //y=7.41 //x2=16.01 //y2=7.585
r1912 (  307 1146 ) resistor r=56.4706 //w=0.187 //l=0.825 //layer=li \
 //thickness=0.1 //x=16.01 //y=7.41 //x2=16.01 //y2=6.585
r1913 (  304 1047 ) resistor r=5.29055 //w=0.35 //l=0.17 //layer=li \
 //thickness=0.1 //x=15.09 //y=7.585 //x2=14.92 //y2=7.585
r1914 (  304 306 ) resistor r=19.8801 //w=0.367 //l=0.57 //layer=li \
 //thickness=0.1 //x=15.09 //y=7.585 //x2=15.66 //y2=7.585
r1915 (  303 1048 ) resistor r=2.87058 //w=0.35 //l=0.085 //layer=li \
 //thickness=0.1 //x=15.925 //y=7.585 //x2=16.01 //y2=7.585
r1916 (  303 306 ) resistor r=9.24251 //w=0.367 //l=0.265 //layer=li \
 //thickness=0.1 //x=15.925 //y=7.585 //x2=15.66 //y2=7.585
r1917 (  298 1046 ) resistor r=2.87058 //w=0.35 //l=0.085 //layer=li \
 //thickness=0.1 //x=13.925 //y=7.585 //x2=13.84 //y2=7.585
r1918 (  298 300 ) resistor r=8.89373 //w=0.367 //l=0.255 //layer=li \
 //thickness=0.1 //x=13.925 //y=7.585 //x2=14.18 //y2=7.585
r1919 (  297 1047 ) resistor r=5.29055 //w=0.35 //l=0.17 //layer=li \
 //thickness=0.1 //x=14.75 //y=7.585 //x2=14.92 //y2=7.585
r1920 (  297 300 ) resistor r=19.8801 //w=0.367 //l=0.57 //layer=li \
 //thickness=0.1 //x=14.75 //y=7.585 //x2=14.18 //y2=7.585
r1921 (  291 1046 ) resistor r=4.23183 //w=0.7 //l=0.175 //layer=li \
 //thickness=0.1 //x=13.84 //y=7.41 //x2=13.84 //y2=7.585
r1922 (  291 1145 ) resistor r=33.1979 //w=0.187 //l=0.485 //layer=li \
 //thickness=0.1 //x=13.84 //y=7.41 //x2=13.84 //y2=6.925
r1923 (  288 1045 ) resistor r=2.87058 //w=0.35 //l=0.085 //layer=li \
 //thickness=0.1 //x=13.045 //y=7.585 //x2=12.96 //y2=7.585
r1924 (  288 290 ) resistor r=0.871935 //w=0.367 //l=0.025 //layer=li \
 //thickness=0.1 //x=13.045 //y=7.585 //x2=13.07 //y2=7.585
r1925 (  287 1046 ) resistor r=2.87058 //w=0.35 //l=0.085 //layer=li \
 //thickness=0.1 //x=13.755 //y=7.585 //x2=13.84 //y2=7.585
r1926 (  287 290 ) resistor r=23.891 //w=0.367 //l=0.685 //layer=li \
 //thickness=0.1 //x=13.755 //y=7.585 //x2=13.07 //y2=7.585
r1927 (  281 1045 ) resistor r=4.23183 //w=0.7 //l=0.175 //layer=li \
 //thickness=0.1 //x=12.96 //y=7.41 //x2=12.96 //y2=7.585
r1928 (  281 1144 ) resistor r=33.1979 //w=0.187 //l=0.485 //layer=li \
 //thickness=0.1 //x=12.96 //y=7.41 //x2=12.96 //y2=6.925
r1929 (  280 1044 ) resistor r=2.87058 //w=0.35 //l=0.085 //layer=li \
 //thickness=0.1 //x=12.165 //y=7.585 //x2=12.08 //y2=7.585
r1930 (  279 1045 ) resistor r=2.87058 //w=0.35 //l=0.085 //layer=li \
 //thickness=0.1 //x=12.875 //y=7.585 //x2=12.96 //y2=7.585
r1931 (  279 280 ) resistor r=24.7629 //w=0.367 //l=0.71 //layer=li \
 //thickness=0.1 //x=12.875 //y=7.585 //x2=12.165 //y2=7.585
r1932 (  273 1044 ) resistor r=4.23183 //w=0.7 //l=0.175 //layer=li \
 //thickness=0.1 //x=12.08 //y=7.41 //x2=12.08 //y2=7.585
r1933 (  273 1143 ) resistor r=33.1979 //w=0.187 //l=0.485 //layer=li \
 //thickness=0.1 //x=12.08 //y=7.41 //x2=12.08 //y2=6.925
r1934 (  270 1043 ) resistor r=2.87058 //w=0.35 //l=0.085 //layer=li \
 //thickness=0.1 //x=11.285 //y=7.585 //x2=11.2 //y2=7.585
r1935 (  270 272 ) resistor r=23.5422 //w=0.367 //l=0.675 //layer=li \
 //thickness=0.1 //x=11.285 //y=7.585 //x2=11.96 //y2=7.585
r1936 (  269 1044 ) resistor r=2.87058 //w=0.35 //l=0.085 //layer=li \
 //thickness=0.1 //x=11.995 //y=7.585 //x2=12.08 //y2=7.585
r1937 (  269 272 ) resistor r=1.22071 //w=0.367 //l=0.035 //layer=li \
 //thickness=0.1 //x=11.995 //y=7.585 //x2=11.96 //y2=7.585
r1938 (  263 1043 ) resistor r=4.23183 //w=0.7 //l=0.175 //layer=li \
 //thickness=0.1 //x=11.2 //y=7.41 //x2=11.2 //y2=7.585
r1939 (  263 1142 ) resistor r=56.4706 //w=0.187 //l=0.825 //layer=li \
 //thickness=0.1 //x=11.2 //y=7.41 //x2=11.2 //y2=6.585
r1940 (  260 1042 ) resistor r=5.29055 //w=0.35 //l=0.17 //layer=li \
 //thickness=0.1 //x=10.28 //y=7.585 //x2=10.11 //y2=7.585
r1941 (  260 262 ) resistor r=19.8801 //w=0.367 //l=0.57 //layer=li \
 //thickness=0.1 //x=10.28 //y=7.585 //x2=10.85 //y2=7.585
r1942 (  259 1043 ) resistor r=2.87058 //w=0.35 //l=0.085 //layer=li \
 //thickness=0.1 //x=11.115 //y=7.585 //x2=11.2 //y2=7.585
r1943 (  259 262 ) resistor r=9.24251 //w=0.367 //l=0.265 //layer=li \
 //thickness=0.1 //x=11.115 //y=7.585 //x2=10.85 //y2=7.585
r1944 (  254 1041 ) resistor r=2.87058 //w=0.35 //l=0.085 //layer=li \
 //thickness=0.1 //x=9.115 //y=7.585 //x2=9.03 //y2=7.585
r1945 (  254 256 ) resistor r=8.89373 //w=0.367 //l=0.255 //layer=li \
 //thickness=0.1 //x=9.115 //y=7.585 //x2=9.37 //y2=7.585
r1946 (  253 1042 ) resistor r=5.29055 //w=0.35 //l=0.17 //layer=li \
 //thickness=0.1 //x=9.94 //y=7.585 //x2=10.11 //y2=7.585
r1947 (  253 256 ) resistor r=19.8801 //w=0.367 //l=0.57 //layer=li \
 //thickness=0.1 //x=9.94 //y=7.585 //x2=9.37 //y2=7.585
r1948 (  247 1041 ) resistor r=4.23183 //w=0.7 //l=0.175 //layer=li \
 //thickness=0.1 //x=9.03 //y=7.41 //x2=9.03 //y2=7.585
r1949 (  247 1141 ) resistor r=33.1979 //w=0.187 //l=0.485 //layer=li \
 //thickness=0.1 //x=9.03 //y=7.41 //x2=9.03 //y2=6.925
r1950 (  244 1040 ) resistor r=2.87058 //w=0.35 //l=0.085 //layer=li \
 //thickness=0.1 //x=8.235 //y=7.585 //x2=8.15 //y2=7.585
r1951 (  244 246 ) resistor r=0.871935 //w=0.367 //l=0.025 //layer=li \
 //thickness=0.1 //x=8.235 //y=7.585 //x2=8.26 //y2=7.585
r1952 (  243 1041 ) resistor r=2.87058 //w=0.35 //l=0.085 //layer=li \
 //thickness=0.1 //x=8.945 //y=7.585 //x2=9.03 //y2=7.585
r1953 (  243 246 ) resistor r=23.891 //w=0.367 //l=0.685 //layer=li \
 //thickness=0.1 //x=8.945 //y=7.585 //x2=8.26 //y2=7.585
r1954 (  237 1040 ) resistor r=4.23183 //w=0.7 //l=0.175 //layer=li \
 //thickness=0.1 //x=8.15 //y=7.41 //x2=8.15 //y2=7.585
r1955 (  237 1140 ) resistor r=33.1979 //w=0.187 //l=0.485 //layer=li \
 //thickness=0.1 //x=8.15 //y=7.41 //x2=8.15 //y2=6.925
r1956 (  236 1039 ) resistor r=2.87058 //w=0.35 //l=0.085 //layer=li \
 //thickness=0.1 //x=7.355 //y=7.585 //x2=7.27 //y2=7.585
r1957 (  235 1040 ) resistor r=2.87058 //w=0.35 //l=0.085 //layer=li \
 //thickness=0.1 //x=8.065 //y=7.585 //x2=8.15 //y2=7.585
r1958 (  235 236 ) resistor r=24.7629 //w=0.367 //l=0.71 //layer=li \
 //thickness=0.1 //x=8.065 //y=7.585 //x2=7.355 //y2=7.585
r1959 (  229 1039 ) resistor r=4.23183 //w=0.7 //l=0.175 //layer=li \
 //thickness=0.1 //x=7.27 //y=7.41 //x2=7.27 //y2=7.585
r1960 (  229 1139 ) resistor r=33.1979 //w=0.187 //l=0.485 //layer=li \
 //thickness=0.1 //x=7.27 //y=7.41 //x2=7.27 //y2=6.925
r1961 (  226 1038 ) resistor r=2.87058 //w=0.35 //l=0.085 //layer=li \
 //thickness=0.1 //x=6.475 //y=7.585 //x2=6.39 //y2=7.585
r1962 (  226 228 ) resistor r=23.5422 //w=0.367 //l=0.675 //layer=li \
 //thickness=0.1 //x=6.475 //y=7.585 //x2=7.15 //y2=7.585
r1963 (  225 1039 ) resistor r=2.87058 //w=0.35 //l=0.085 //layer=li \
 //thickness=0.1 //x=7.185 //y=7.585 //x2=7.27 //y2=7.585
r1964 (  225 228 ) resistor r=1.22071 //w=0.367 //l=0.035 //layer=li \
 //thickness=0.1 //x=7.185 //y=7.585 //x2=7.15 //y2=7.585
r1965 (  219 1038 ) resistor r=4.23183 //w=0.7 //l=0.175 //layer=li \
 //thickness=0.1 //x=6.39 //y=7.41 //x2=6.39 //y2=7.585
r1966 (  219 1138 ) resistor r=56.4706 //w=0.187 //l=0.825 //layer=li \
 //thickness=0.1 //x=6.39 //y=7.41 //x2=6.39 //y2=6.585
r1967 (  216 1037 ) resistor r=5.29055 //w=0.35 //l=0.17 //layer=li \
 //thickness=0.1 //x=5.47 //y=7.585 //x2=5.3 //y2=7.585
r1968 (  216 218 ) resistor r=19.8801 //w=0.367 //l=0.57 //layer=li \
 //thickness=0.1 //x=5.47 //y=7.585 //x2=6.04 //y2=7.585
r1969 (  215 1038 ) resistor r=2.87058 //w=0.35 //l=0.085 //layer=li \
 //thickness=0.1 //x=6.305 //y=7.585 //x2=6.39 //y2=7.585
r1970 (  215 218 ) resistor r=9.24251 //w=0.367 //l=0.265 //layer=li \
 //thickness=0.1 //x=6.305 //y=7.585 //x2=6.04 //y2=7.585
r1971 (  210 1036 ) resistor r=2.87058 //w=0.35 //l=0.085 //layer=li \
 //thickness=0.1 //x=4.305 //y=7.585 //x2=4.22 //y2=7.585
r1972 (  210 212 ) resistor r=8.89373 //w=0.367 //l=0.255 //layer=li \
 //thickness=0.1 //x=4.305 //y=7.585 //x2=4.56 //y2=7.585
r1973 (  209 1037 ) resistor r=5.29055 //w=0.35 //l=0.17 //layer=li \
 //thickness=0.1 //x=5.13 //y=7.585 //x2=5.3 //y2=7.585
r1974 (  209 212 ) resistor r=19.8801 //w=0.367 //l=0.57 //layer=li \
 //thickness=0.1 //x=5.13 //y=7.585 //x2=4.56 //y2=7.585
r1975 (  203 1036 ) resistor r=4.23183 //w=0.7 //l=0.175 //layer=li \
 //thickness=0.1 //x=4.22 //y=7.41 //x2=4.22 //y2=7.585
r1976 (  203 1137 ) resistor r=33.1979 //w=0.187 //l=0.485 //layer=li \
 //thickness=0.1 //x=4.22 //y=7.41 //x2=4.22 //y2=6.925
r1977 (  200 1035 ) resistor r=2.87058 //w=0.35 //l=0.085 //layer=li \
 //thickness=0.1 //x=3.425 //y=7.585 //x2=3.34 //y2=7.585
r1978 (  200 202 ) resistor r=0.871935 //w=0.367 //l=0.025 //layer=li \
 //thickness=0.1 //x=3.425 //y=7.585 //x2=3.45 //y2=7.585
r1979 (  199 1036 ) resistor r=2.87058 //w=0.35 //l=0.085 //layer=li \
 //thickness=0.1 //x=4.135 //y=7.585 //x2=4.22 //y2=7.585
r1980 (  199 202 ) resistor r=23.891 //w=0.367 //l=0.685 //layer=li \
 //thickness=0.1 //x=4.135 //y=7.585 //x2=3.45 //y2=7.585
r1981 (  193 1035 ) resistor r=4.23183 //w=0.7 //l=0.175 //layer=li \
 //thickness=0.1 //x=3.34 //y=7.41 //x2=3.34 //y2=7.585
r1982 (  193 1136 ) resistor r=33.1979 //w=0.187 //l=0.485 //layer=li \
 //thickness=0.1 //x=3.34 //y=7.41 //x2=3.34 //y2=6.925
r1983 (  192 1034 ) resistor r=2.87058 //w=0.35 //l=0.085 //layer=li \
 //thickness=0.1 //x=2.545 //y=7.585 //x2=2.46 //y2=7.585
r1984 (  191 1035 ) resistor r=2.87058 //w=0.35 //l=0.085 //layer=li \
 //thickness=0.1 //x=3.255 //y=7.585 //x2=3.34 //y2=7.585
r1985 (  191 192 ) resistor r=24.7629 //w=0.367 //l=0.71 //layer=li \
 //thickness=0.1 //x=3.255 //y=7.585 //x2=2.545 //y2=7.585
r1986 (  185 1034 ) resistor r=4.23183 //w=0.7 //l=0.175 //layer=li \
 //thickness=0.1 //x=2.46 //y=7.41 //x2=2.46 //y2=7.585
r1987 (  185 1135 ) resistor r=33.1979 //w=0.187 //l=0.485 //layer=li \
 //thickness=0.1 //x=2.46 //y=7.41 //x2=2.46 //y2=6.925
r1988 (  182 1033 ) resistor r=2.87058 //w=0.35 //l=0.085 //layer=li \
 //thickness=0.1 //x=1.665 //y=7.585 //x2=1.58 //y2=7.585
r1989 (  182 184 ) resistor r=23.5422 //w=0.367 //l=0.675 //layer=li \
 //thickness=0.1 //x=1.665 //y=7.585 //x2=2.34 //y2=7.585
r1990 (  181 1034 ) resistor r=2.87058 //w=0.35 //l=0.085 //layer=li \
 //thickness=0.1 //x=2.375 //y=7.585 //x2=2.46 //y2=7.585
r1991 (  181 184 ) resistor r=1.22071 //w=0.367 //l=0.035 //layer=li \
 //thickness=0.1 //x=2.375 //y=7.585 //x2=2.34 //y2=7.585
r1992 (  175 1033 ) resistor r=4.23183 //w=0.7 //l=0.175 //layer=li \
 //thickness=0.1 //x=1.58 //y=7.41 //x2=1.58 //y2=7.585
r1993 (  175 1134 ) resistor r=56.4706 //w=0.187 //l=0.825 //layer=li \
 //thickness=0.1 //x=1.58 //y=7.41 //x2=1.58 //y2=6.585
r1994 (  171 1033 ) resistor r=2.87058 //w=0.35 //l=0.085 //layer=li \
 //thickness=0.1 //x=1.495 //y=7.585 //x2=1.58 //y2=7.585
r1995 (  171 174 ) resistor r=9.24251 //w=0.367 //l=0.265 //layer=li \
 //thickness=0.1 //x=1.495 //y=7.585 //x2=1.23 //y2=7.585
r1996 (  167 1133 ) resistor r=4.65 //w=0.17 //l=0.34 //layer=mcon //count=2 \
 //x=98.54 //y=7.58 //x2=98.54 //y2=7.58
r1997 (  165 1131 ) resistor r=3.1 //w=0.17 //l=0.51 //layer=mcon //count=3 \
 //x=97.8 //y=7.58 //x2=97.8 //y2=7.58
r1998 (  165 167 ) resistor r=0.297428 //w=0.311 //l=0.74 //layer=m1 \
 //thickness=0.36 //x=97.8 //y=7.585 //x2=98.54 //y2=7.585
r1999 (  163 1010 ) resistor r=3.1 //w=0.17 //l=0.51 //layer=mcon //count=3 \
 //x=96.32 //y=7.58 //x2=96.32 //y2=7.58
r2000 (  163 165 ) resistor r=0.594855 //w=0.311 //l=1.48 //layer=m1 \
 //thickness=0.36 //x=96.32 //y=7.585 //x2=97.8 //y2=7.585
r2001 (  161 1008 ) resistor r=3.1 //w=0.17 //l=0.51 //layer=mcon //count=3 \
 //x=95.21 //y=7.58 //x2=95.21 //y2=7.58
r2002 (  161 163 ) resistor r=0.446141 //w=0.311 //l=1.11 //layer=m1 \
 //thickness=0.36 //x=95.21 //y=7.585 //x2=96.32 //y2=7.585
r2003 (  159 1006 ) resistor r=3.1 //w=0.17 //l=0.51 //layer=mcon //count=3 \
 //x=94.1 //y=7.58 //x2=94.1 //y2=7.58
r2004 (  159 161 ) resistor r=0.446141 //w=0.311 //l=1.11 //layer=m1 \
 //thickness=0.36 //x=94.1 //y=7.585 //x2=95.21 //y2=7.585
r2005 (  157 1000 ) resistor r=3.1 //w=0.17 //l=0.51 //layer=mcon //count=3 \
 //x=92.62 //y=7.58 //x2=92.62 //y2=7.58
r2006 (  157 159 ) resistor r=0.594855 //w=0.311 //l=1.48 //layer=m1 \
 //thickness=0.36 //x=92.62 //y=7.585 //x2=94.1 //y2=7.585
r2007 (  155 998 ) resistor r=3.1 //w=0.17 //l=0.51 //layer=mcon //count=3 \
 //x=91.51 //y=7.58 //x2=91.51 //y2=7.58
r2008 (  155 157 ) resistor r=0.446141 //w=0.311 //l=1.11 //layer=m1 \
 //thickness=0.36 //x=91.51 //y=7.585 //x2=92.62 //y2=7.585
r2009 (  153 992 ) resistor r=3.1 //w=0.17 //l=0.51 //layer=mcon //count=3 \
 //x=90.03 //y=7.58 //x2=90.03 //y2=7.58
r2010 (  153 155 ) resistor r=0.594855 //w=0.311 //l=1.48 //layer=m1 \
 //thickness=0.36 //x=90.03 //y=7.585 //x2=91.51 //y2=7.585
r2011 (  151 982 ) resistor r=3.1 //w=0.17 //l=0.51 //layer=mcon //count=3 \
 //x=88.92 //y=7.58 //x2=88.92 //y2=7.58
r2012 (  151 153 ) resistor r=0.446141 //w=0.311 //l=1.11 //layer=m1 \
 //thickness=0.36 //x=88.92 //y=7.585 //x2=90.03 //y2=7.585
r2013 (  149 1124 ) resistor r=3.1 //w=0.17 //l=0.51 //layer=mcon //count=3 \
 //x=87.81 //y=7.58 //x2=87.81 //y2=7.58
r2014 (  149 151 ) resistor r=0.446141 //w=0.311 //l=1.11 //layer=m1 \
 //thickness=0.36 //x=87.81 //y=7.585 //x2=88.92 //y2=7.585
r2015 (  147 960 ) resistor r=3.1 //w=0.17 //l=0.51 //layer=mcon //count=3 \
 //x=86.33 //y=7.58 //x2=86.33 //y2=7.58
r2016 (  147 149 ) resistor r=0.594855 //w=0.311 //l=1.48 //layer=m1 \
 //thickness=0.36 //x=86.33 //y=7.585 //x2=87.81 //y2=7.585
r2017 (  145 950 ) resistor r=3.1 //w=0.17 //l=0.51 //layer=mcon //count=3 \
 //x=85.22 //y=7.58 //x2=85.22 //y2=7.58
r2018 (  145 147 ) resistor r=0.446141 //w=0.311 //l=1.11 //layer=m1 \
 //thickness=0.36 //x=85.22 //y=7.585 //x2=86.33 //y2=7.585
r2019 (  143 932 ) resistor r=3.1 //w=0.17 //l=0.51 //layer=mcon //count=3 \
 //x=84.11 //y=7.58 //x2=84.11 //y2=7.58
r2020 (  143 145 ) resistor r=0.446141 //w=0.311 //l=1.11 //layer=m1 \
 //thickness=0.36 //x=84.11 //y=7.585 //x2=85.22 //y2=7.585
r2021 (  141 922 ) resistor r=3.1 //w=0.17 //l=0.51 //layer=mcon //count=3 \
 //x=83 //y=7.58 //x2=83 //y2=7.58
r2022 (  141 143 ) resistor r=0.446141 //w=0.311 //l=1.11 //layer=m1 \
 //thickness=0.36 //x=83 //y=7.585 //x2=84.11 //y2=7.585
r2023 (  139 916 ) resistor r=3.1 //w=0.17 //l=0.51 //layer=mcon //count=3 \
 //x=81.52 //y=7.58 //x2=81.52 //y2=7.58
r2024 (  139 141 ) resistor r=0.594855 //w=0.311 //l=1.48 //layer=m1 \
 //thickness=0.36 //x=81.52 //y=7.585 //x2=83 //y2=7.585
r2025 (  137 906 ) resistor r=3.1 //w=0.17 //l=0.51 //layer=mcon //count=3 \
 //x=80.41 //y=7.58 //x2=80.41 //y2=7.58
r2026 (  137 139 ) resistor r=0.446141 //w=0.311 //l=1.11 //layer=m1 \
 //thickness=0.36 //x=80.41 //y=7.585 //x2=81.52 //y2=7.585
r2027 (  135 888 ) resistor r=3.1 //w=0.17 //l=0.51 //layer=mcon //count=3 \
 //x=79.3 //y=7.58 //x2=79.3 //y2=7.58
r2028 (  135 137 ) resistor r=0.446141 //w=0.311 //l=1.11 //layer=m1 \
 //thickness=0.36 //x=79.3 //y=7.585 //x2=80.41 //y2=7.585
r2029 (  133 878 ) resistor r=3.1 //w=0.17 //l=0.51 //layer=mcon //count=3 \
 //x=78.19 //y=7.58 //x2=78.19 //y2=7.58
r2030 (  133 135 ) resistor r=0.446141 //w=0.311 //l=1.11 //layer=m1 \
 //thickness=0.36 //x=78.19 //y=7.585 //x2=79.3 //y2=7.585
r2031 (  131 872 ) resistor r=3.1 //w=0.17 //l=0.51 //layer=mcon //count=3 \
 //x=76.71 //y=7.58 //x2=76.71 //y2=7.58
r2032 (  131 133 ) resistor r=0.594855 //w=0.311 //l=1.48 //layer=m1 \
 //thickness=0.36 //x=76.71 //y=7.585 //x2=78.19 //y2=7.585
r2033 (  129 862 ) resistor r=3.1 //w=0.17 //l=0.51 //layer=mcon //count=3 \
 //x=75.6 //y=7.58 //x2=75.6 //y2=7.58
r2034 (  129 131 ) resistor r=0.446141 //w=0.311 //l=1.11 //layer=m1 \
 //thickness=0.36 //x=75.6 //y=7.585 //x2=76.71 //y2=7.585
r2035 (  127 844 ) resistor r=3.1 //w=0.17 //l=0.51 //layer=mcon //count=3 \
 //x=74.49 //y=7.58 //x2=74.49 //y2=7.58
r2036 (  127 129 ) resistor r=0.446141 //w=0.311 //l=1.11 //layer=m1 \
 //thickness=0.36 //x=74.49 //y=7.585 //x2=75.6 //y2=7.585
r2037 (  125 834 ) resistor r=3.1 //w=0.17 //l=0.51 //layer=mcon //count=3 \
 //x=73.38 //y=7.58 //x2=73.38 //y2=7.58
r2038 (  125 127 ) resistor r=0.446141 //w=0.311 //l=1.11 //layer=m1 \
 //thickness=0.36 //x=73.38 //y=7.585 //x2=74.49 //y2=7.585
r2039 (  123 828 ) resistor r=3.1 //w=0.17 //l=0.51 //layer=mcon //count=3 \
 //x=71.9 //y=7.58 //x2=71.9 //y2=7.58
r2040 (  123 125 ) resistor r=0.594855 //w=0.311 //l=1.48 //layer=m1 \
 //thickness=0.36 //x=71.9 //y=7.585 //x2=73.38 //y2=7.585
r2041 (  121 818 ) resistor r=3.1 //w=0.17 //l=0.51 //layer=mcon //count=3 \
 //x=70.79 //y=7.58 //x2=70.79 //y2=7.58
r2042 (  121 123 ) resistor r=0.446141 //w=0.311 //l=1.11 //layer=m1 \
 //thickness=0.36 //x=70.79 //y=7.585 //x2=71.9 //y2=7.585
r2043 (  119 800 ) resistor r=3.1 //w=0.17 //l=0.51 //layer=mcon //count=3 \
 //x=69.68 //y=7.58 //x2=69.68 //y2=7.58
r2044 (  119 121 ) resistor r=0.446141 //w=0.311 //l=1.11 //layer=m1 \
 //thickness=0.36 //x=69.68 //y=7.585 //x2=70.79 //y2=7.585
r2045 (  117 790 ) resistor r=3.1 //w=0.17 //l=0.51 //layer=mcon //count=3 \
 //x=68.57 //y=7.58 //x2=68.57 //y2=7.58
r2046 (  117 119 ) resistor r=0.446141 //w=0.311 //l=1.11 //layer=m1 \
 //thickness=0.36 //x=68.57 //y=7.585 //x2=69.68 //y2=7.585
r2047 (  115 784 ) resistor r=3.1 //w=0.17 //l=0.51 //layer=mcon //count=3 \
 //x=67.09 //y=7.58 //x2=67.09 //y2=7.58
r2048 (  115 117 ) resistor r=0.594855 //w=0.311 //l=1.48 //layer=m1 \
 //thickness=0.36 //x=67.09 //y=7.585 //x2=68.57 //y2=7.585
r2049 (  113 774 ) resistor r=3.1 //w=0.17 //l=0.51 //layer=mcon //count=3 \
 //x=65.98 //y=7.58 //x2=65.98 //y2=7.58
r2050 (  113 115 ) resistor r=0.446141 //w=0.311 //l=1.11 //layer=m1 \
 //thickness=0.36 //x=65.98 //y=7.585 //x2=67.09 //y2=7.585
r2051 (  111 756 ) resistor r=3.1 //w=0.17 //l=0.51 //layer=mcon //count=3 \
 //x=64.87 //y=7.58 //x2=64.87 //y2=7.58
r2052 (  111 113 ) resistor r=0.446141 //w=0.311 //l=1.11 //layer=m1 \
 //thickness=0.36 //x=64.87 //y=7.585 //x2=65.98 //y2=7.585
r2053 (  109 746 ) resistor r=3.1 //w=0.17 //l=0.51 //layer=mcon //count=3 \
 //x=63.76 //y=7.58 //x2=63.76 //y2=7.58
r2054 (  109 111 ) resistor r=0.446141 //w=0.311 //l=1.11 //layer=m1 \
 //thickness=0.36 //x=63.76 //y=7.585 //x2=64.87 //y2=7.585
r2055 (  107 740 ) resistor r=3.1 //w=0.17 //l=0.51 //layer=mcon //count=3 \
 //x=62.28 //y=7.58 //x2=62.28 //y2=7.58
r2056 (  107 109 ) resistor r=0.594855 //w=0.311 //l=1.48 //layer=m1 \
 //thickness=0.36 //x=62.28 //y=7.585 //x2=63.76 //y2=7.585
r2057 (  105 730 ) resistor r=3.1 //w=0.17 //l=0.51 //layer=mcon //count=3 \
 //x=61.17 //y=7.58 //x2=61.17 //y2=7.58
r2058 (  105 107 ) resistor r=0.446141 //w=0.311 //l=1.11 //layer=m1 \
 //thickness=0.36 //x=61.17 //y=7.585 //x2=62.28 //y2=7.585
r2059 (  103 712 ) resistor r=3.1 //w=0.17 //l=0.51 //layer=mcon //count=3 \
 //x=60.06 //y=7.58 //x2=60.06 //y2=7.58
r2060 (  103 105 ) resistor r=0.446141 //w=0.311 //l=1.11 //layer=m1 \
 //thickness=0.36 //x=60.06 //y=7.585 //x2=61.17 //y2=7.585
r2061 (  101 702 ) resistor r=3.1 //w=0.17 //l=0.51 //layer=mcon //count=3 \
 //x=58.95 //y=7.58 //x2=58.95 //y2=7.58
r2062 (  101 103 ) resistor r=0.446141 //w=0.311 //l=1.11 //layer=m1 \
 //thickness=0.36 //x=58.95 //y=7.585 //x2=60.06 //y2=7.585
r2063 (  99 696 ) resistor r=3.1 //w=0.17 //l=0.51 //layer=mcon //count=3 \
 //x=57.47 //y=7.58 //x2=57.47 //y2=7.58
r2064 (  99 101 ) resistor r=0.594855 //w=0.311 //l=1.48 //layer=m1 \
 //thickness=0.36 //x=57.47 //y=7.585 //x2=58.95 //y2=7.585
r2065 (  97 686 ) resistor r=3.1 //w=0.17 //l=0.51 //layer=mcon //count=3 \
 //x=56.36 //y=7.58 //x2=56.36 //y2=7.58
r2066 (  97 99 ) resistor r=0.446141 //w=0.311 //l=1.11 //layer=m1 \
 //thickness=0.36 //x=56.36 //y=7.585 //x2=57.47 //y2=7.585
r2067 (  95 668 ) resistor r=3.1 //w=0.17 //l=0.51 //layer=mcon //count=3 \
 //x=55.25 //y=7.58 //x2=55.25 //y2=7.58
r2068 (  95 97 ) resistor r=0.446141 //w=0.311 //l=1.11 //layer=m1 \
 //thickness=0.36 //x=55.25 //y=7.585 //x2=56.36 //y2=7.585
r2069 (  93 658 ) resistor r=3.1 //w=0.17 //l=0.51 //layer=mcon //count=3 \
 //x=54.14 //y=7.58 //x2=54.14 //y2=7.58
r2070 (  93 95 ) resistor r=0.446141 //w=0.311 //l=1.11 //layer=m1 \
 //thickness=0.36 //x=54.14 //y=7.585 //x2=55.25 //y2=7.585
r2071 (  91 652 ) resistor r=3.1 //w=0.17 //l=0.51 //layer=mcon //count=3 \
 //x=52.66 //y=7.58 //x2=52.66 //y2=7.58
r2072 (  91 93 ) resistor r=0.594855 //w=0.311 //l=1.48 //layer=m1 \
 //thickness=0.36 //x=52.66 //y=7.585 //x2=54.14 //y2=7.585
r2073 (  89 642 ) resistor r=3.1 //w=0.17 //l=0.51 //layer=mcon //count=3 \
 //x=51.55 //y=7.58 //x2=51.55 //y2=7.58
r2074 (  89 91 ) resistor r=0.446141 //w=0.311 //l=1.11 //layer=m1 \
 //thickness=0.36 //x=51.55 //y=7.585 //x2=52.66 //y2=7.585
r2075 (  87 624 ) resistor r=3.1 //w=0.17 //l=0.51 //layer=mcon //count=3 \
 //x=50.44 //y=7.58 //x2=50.44 //y2=7.58
r2076 (  87 89 ) resistor r=0.446141 //w=0.311 //l=1.11 //layer=m1 \
 //thickness=0.36 //x=50.44 //y=7.585 //x2=51.55 //y2=7.585
r2077 (  84 614 ) resistor r=3.1 //w=0.17 //l=0.51 //layer=mcon //count=3 \
 //x=49.33 //y=7.58 //x2=49.33 //y2=7.58
r2078 (  82 608 ) resistor r=3.1 //w=0.17 //l=0.51 //layer=mcon //count=3 \
 //x=47.85 //y=7.58 //x2=47.85 //y2=7.58
r2079 (  82 84 ) resistor r=0.594855 //w=0.311 //l=1.48 //layer=m1 \
 //thickness=0.36 //x=47.85 //y=7.585 //x2=49.33 //y2=7.585
r2080 (  80 598 ) resistor r=3.1 //w=0.17 //l=0.51 //layer=mcon //count=3 \
 //x=46.74 //y=7.58 //x2=46.74 //y2=7.58
r2081 (  80 82 ) resistor r=0.446141 //w=0.311 //l=1.11 //layer=m1 \
 //thickness=0.36 //x=46.74 //y=7.585 //x2=47.85 //y2=7.585
r2082 (  78 580 ) resistor r=3.1 //w=0.17 //l=0.51 //layer=mcon //count=3 \
 //x=45.63 //y=7.58 //x2=45.63 //y2=7.58
r2083 (  78 80 ) resistor r=0.446141 //w=0.311 //l=1.11 //layer=m1 \
 //thickness=0.36 //x=45.63 //y=7.585 //x2=46.74 //y2=7.585
r2084 (  76 570 ) resistor r=3.1 //w=0.17 //l=0.51 //layer=mcon //count=3 \
 //x=44.52 //y=7.58 //x2=44.52 //y2=7.58
r2085 (  76 78 ) resistor r=0.446141 //w=0.311 //l=1.11 //layer=m1 \
 //thickness=0.36 //x=44.52 //y=7.585 //x2=45.63 //y2=7.585
r2086 (  74 564 ) resistor r=3.1 //w=0.17 //l=0.51 //layer=mcon //count=3 \
 //x=43.04 //y=7.58 //x2=43.04 //y2=7.58
r2087 (  74 76 ) resistor r=0.594855 //w=0.311 //l=1.48 //layer=m1 \
 //thickness=0.36 //x=43.04 //y=7.585 //x2=44.52 //y2=7.585
r2088 (  72 554 ) resistor r=3.1 //w=0.17 //l=0.51 //layer=mcon //count=3 \
 //x=41.93 //y=7.58 //x2=41.93 //y2=7.58
r2089 (  72 74 ) resistor r=0.446141 //w=0.311 //l=1.11 //layer=m1 \
 //thickness=0.36 //x=41.93 //y=7.585 //x2=43.04 //y2=7.585
r2090 (  70 536 ) resistor r=3.1 //w=0.17 //l=0.51 //layer=mcon //count=3 \
 //x=40.82 //y=7.58 //x2=40.82 //y2=7.58
r2091 (  70 72 ) resistor r=0.446141 //w=0.311 //l=1.11 //layer=m1 \
 //thickness=0.36 //x=40.82 //y=7.585 //x2=41.93 //y2=7.585
r2092 (  68 526 ) resistor r=3.1 //w=0.17 //l=0.51 //layer=mcon //count=3 \
 //x=39.71 //y=7.58 //x2=39.71 //y2=7.58
r2093 (  68 70 ) resistor r=0.446141 //w=0.311 //l=1.11 //layer=m1 \
 //thickness=0.36 //x=39.71 //y=7.585 //x2=40.82 //y2=7.585
r2094 (  66 520 ) resistor r=3.1 //w=0.17 //l=0.51 //layer=mcon //count=3 \
 //x=38.23 //y=7.58 //x2=38.23 //y2=7.58
r2095 (  66 68 ) resistor r=0.594855 //w=0.311 //l=1.48 //layer=m1 \
 //thickness=0.36 //x=38.23 //y=7.585 //x2=39.71 //y2=7.585
r2096 (  64 510 ) resistor r=3.1 //w=0.17 //l=0.51 //layer=mcon //count=3 \
 //x=37.12 //y=7.58 //x2=37.12 //y2=7.58
r2097 (  64 66 ) resistor r=0.446141 //w=0.311 //l=1.11 //layer=m1 \
 //thickness=0.36 //x=37.12 //y=7.585 //x2=38.23 //y2=7.585
r2098 (  62 492 ) resistor r=3.1 //w=0.17 //l=0.51 //layer=mcon //count=3 \
 //x=36.01 //y=7.58 //x2=36.01 //y2=7.58
r2099 (  62 64 ) resistor r=0.446141 //w=0.311 //l=1.11 //layer=m1 \
 //thickness=0.36 //x=36.01 //y=7.585 //x2=37.12 //y2=7.585
r2100 (  60 482 ) resistor r=3.1 //w=0.17 //l=0.51 //layer=mcon //count=3 \
 //x=34.9 //y=7.58 //x2=34.9 //y2=7.58
r2101 (  60 62 ) resistor r=0.446141 //w=0.311 //l=1.11 //layer=m1 \
 //thickness=0.36 //x=34.9 //y=7.585 //x2=36.01 //y2=7.585
r2102 (  58 476 ) resistor r=3.1 //w=0.17 //l=0.51 //layer=mcon //count=3 \
 //x=33.42 //y=7.58 //x2=33.42 //y2=7.58
r2103 (  58 60 ) resistor r=0.594855 //w=0.311 //l=1.48 //layer=m1 \
 //thickness=0.36 //x=33.42 //y=7.585 //x2=34.9 //y2=7.585
r2104 (  56 466 ) resistor r=3.1 //w=0.17 //l=0.51 //layer=mcon //count=3 \
 //x=32.31 //y=7.58 //x2=32.31 //y2=7.58
r2105 (  56 58 ) resistor r=0.446141 //w=0.311 //l=1.11 //layer=m1 \
 //thickness=0.36 //x=32.31 //y=7.585 //x2=33.42 //y2=7.585
r2106 (  54 448 ) resistor r=3.1 //w=0.17 //l=0.51 //layer=mcon //count=3 \
 //x=31.2 //y=7.58 //x2=31.2 //y2=7.58
r2107 (  54 56 ) resistor r=0.446141 //w=0.311 //l=1.11 //layer=m1 \
 //thickness=0.36 //x=31.2 //y=7.585 //x2=32.31 //y2=7.585
r2108 (  52 438 ) resistor r=3.1 //w=0.17 //l=0.51 //layer=mcon //count=3 \
 //x=30.09 //y=7.58 //x2=30.09 //y2=7.58
r2109 (  52 54 ) resistor r=0.446141 //w=0.311 //l=1.11 //layer=m1 \
 //thickness=0.36 //x=30.09 //y=7.585 //x2=31.2 //y2=7.585
r2110 (  50 432 ) resistor r=3.1 //w=0.17 //l=0.51 //layer=mcon //count=3 \
 //x=28.61 //y=7.58 //x2=28.61 //y2=7.58
r2111 (  50 52 ) resistor r=0.594855 //w=0.311 //l=1.48 //layer=m1 \
 //thickness=0.36 //x=28.61 //y=7.585 //x2=30.09 //y2=7.585
r2112 (  48 422 ) resistor r=3.1 //w=0.17 //l=0.51 //layer=mcon //count=3 \
 //x=27.5 //y=7.58 //x2=27.5 //y2=7.58
r2113 (  48 50 ) resistor r=0.446141 //w=0.311 //l=1.11 //layer=m1 \
 //thickness=0.36 //x=27.5 //y=7.585 //x2=28.61 //y2=7.585
r2114 (  46 404 ) resistor r=3.1 //w=0.17 //l=0.51 //layer=mcon //count=3 \
 //x=26.39 //y=7.58 //x2=26.39 //y2=7.58
r2115 (  46 48 ) resistor r=0.446141 //w=0.311 //l=1.11 //layer=m1 \
 //thickness=0.36 //x=26.39 //y=7.585 //x2=27.5 //y2=7.585
r2116 (  44 394 ) resistor r=3.1 //w=0.17 //l=0.51 //layer=mcon //count=3 \
 //x=25.28 //y=7.58 //x2=25.28 //y2=7.58
r2117 (  44 46 ) resistor r=0.446141 //w=0.311 //l=1.11 //layer=m1 \
 //thickness=0.36 //x=25.28 //y=7.585 //x2=26.39 //y2=7.585
r2118 (  42 388 ) resistor r=3.1 //w=0.17 //l=0.51 //layer=mcon //count=3 \
 //x=23.8 //y=7.58 //x2=23.8 //y2=7.58
r2119 (  42 44 ) resistor r=0.594855 //w=0.311 //l=1.48 //layer=m1 \
 //thickness=0.36 //x=23.8 //y=7.585 //x2=25.28 //y2=7.585
r2120 (  40 378 ) resistor r=3.1 //w=0.17 //l=0.51 //layer=mcon //count=3 \
 //x=22.69 //y=7.58 //x2=22.69 //y2=7.58
r2121 (  40 42 ) resistor r=0.446141 //w=0.311 //l=1.11 //layer=m1 \
 //thickness=0.36 //x=22.69 //y=7.585 //x2=23.8 //y2=7.585
r2122 (  38 360 ) resistor r=3.1 //w=0.17 //l=0.51 //layer=mcon //count=3 \
 //x=21.58 //y=7.58 //x2=21.58 //y2=7.58
r2123 (  38 40 ) resistor r=0.446141 //w=0.311 //l=1.11 //layer=m1 \
 //thickness=0.36 //x=21.58 //y=7.585 //x2=22.69 //y2=7.585
r2124 (  36 350 ) resistor r=3.1 //w=0.17 //l=0.51 //layer=mcon //count=3 \
 //x=20.47 //y=7.58 //x2=20.47 //y2=7.58
r2125 (  36 38 ) resistor r=0.446141 //w=0.311 //l=1.11 //layer=m1 \
 //thickness=0.36 //x=20.47 //y=7.585 //x2=21.58 //y2=7.585
r2126 (  34 344 ) resistor r=3.1 //w=0.17 //l=0.51 //layer=mcon //count=3 \
 //x=18.99 //y=7.58 //x2=18.99 //y2=7.58
r2127 (  34 36 ) resistor r=0.594855 //w=0.311 //l=1.48 //layer=m1 \
 //thickness=0.36 //x=18.99 //y=7.585 //x2=20.47 //y2=7.585
r2128 (  32 334 ) resistor r=3.1 //w=0.17 //l=0.51 //layer=mcon //count=3 \
 //x=17.88 //y=7.58 //x2=17.88 //y2=7.58
r2129 (  32 34 ) resistor r=0.446141 //w=0.311 //l=1.11 //layer=m1 \
 //thickness=0.36 //x=17.88 //y=7.585 //x2=18.99 //y2=7.585
r2130 (  30 316 ) resistor r=3.1 //w=0.17 //l=0.51 //layer=mcon //count=3 \
 //x=16.77 //y=7.58 //x2=16.77 //y2=7.58
r2131 (  30 32 ) resistor r=0.446141 //w=0.311 //l=1.11 //layer=m1 \
 //thickness=0.36 //x=16.77 //y=7.585 //x2=17.88 //y2=7.585
r2132 (  28 306 ) resistor r=3.1 //w=0.17 //l=0.51 //layer=mcon //count=3 \
 //x=15.66 //y=7.58 //x2=15.66 //y2=7.58
r2133 (  28 30 ) resistor r=0.446141 //w=0.311 //l=1.11 //layer=m1 \
 //thickness=0.36 //x=15.66 //y=7.585 //x2=16.77 //y2=7.585
r2134 (  26 300 ) resistor r=3.1 //w=0.17 //l=0.51 //layer=mcon //count=3 \
 //x=14.18 //y=7.58 //x2=14.18 //y2=7.58
r2135 (  26 28 ) resistor r=0.594855 //w=0.311 //l=1.48 //layer=m1 \
 //thickness=0.36 //x=14.18 //y=7.585 //x2=15.66 //y2=7.585
r2136 (  24 290 ) resistor r=3.1 //w=0.17 //l=0.51 //layer=mcon //count=3 \
 //x=13.07 //y=7.58 //x2=13.07 //y2=7.58
r2137 (  24 26 ) resistor r=0.446141 //w=0.311 //l=1.11 //layer=m1 \
 //thickness=0.36 //x=13.07 //y=7.585 //x2=14.18 //y2=7.585
r2138 (  22 272 ) resistor r=3.1 //w=0.17 //l=0.51 //layer=mcon //count=3 \
 //x=11.96 //y=7.58 //x2=11.96 //y2=7.58
r2139 (  22 24 ) resistor r=0.446141 //w=0.311 //l=1.11 //layer=m1 \
 //thickness=0.36 //x=11.96 //y=7.585 //x2=13.07 //y2=7.585
r2140 (  20 262 ) resistor r=3.1 //w=0.17 //l=0.51 //layer=mcon //count=3 \
 //x=10.85 //y=7.58 //x2=10.85 //y2=7.58
r2141 (  20 22 ) resistor r=0.446141 //w=0.311 //l=1.11 //layer=m1 \
 //thickness=0.36 //x=10.85 //y=7.585 //x2=11.96 //y2=7.585
r2142 (  18 256 ) resistor r=3.1 //w=0.17 //l=0.51 //layer=mcon //count=3 \
 //x=9.37 //y=7.58 //x2=9.37 //y2=7.58
r2143 (  18 20 ) resistor r=0.594855 //w=0.311 //l=1.48 //layer=m1 \
 //thickness=0.36 //x=9.37 //y=7.585 //x2=10.85 //y2=7.585
r2144 (  16 246 ) resistor r=3.1 //w=0.17 //l=0.51 //layer=mcon //count=3 \
 //x=8.26 //y=7.58 //x2=8.26 //y2=7.58
r2145 (  16 18 ) resistor r=0.446141 //w=0.311 //l=1.11 //layer=m1 \
 //thickness=0.36 //x=8.26 //y=7.585 //x2=9.37 //y2=7.585
r2146 (  14 228 ) resistor r=3.1 //w=0.17 //l=0.51 //layer=mcon //count=3 \
 //x=7.15 //y=7.58 //x2=7.15 //y2=7.58
r2147 (  14 16 ) resistor r=0.446141 //w=0.311 //l=1.11 //layer=m1 \
 //thickness=0.36 //x=7.15 //y=7.585 //x2=8.26 //y2=7.585
r2148 (  12 218 ) resistor r=3.1 //w=0.17 //l=0.51 //layer=mcon //count=3 \
 //x=6.04 //y=7.58 //x2=6.04 //y2=7.58
r2149 (  12 14 ) resistor r=0.446141 //w=0.311 //l=1.11 //layer=m1 \
 //thickness=0.36 //x=6.04 //y=7.585 //x2=7.15 //y2=7.585
r2150 (  10 212 ) resistor r=3.1 //w=0.17 //l=0.51 //layer=mcon //count=3 \
 //x=4.56 //y=7.58 //x2=4.56 //y2=7.58
r2151 (  10 12 ) resistor r=0.594855 //w=0.311 //l=1.48 //layer=m1 \
 //thickness=0.36 //x=4.56 //y=7.585 //x2=6.04 //y2=7.585
r2152 (  8 202 ) resistor r=3.1 //w=0.17 //l=0.51 //layer=mcon //count=3 \
 //x=3.45 //y=7.58 //x2=3.45 //y2=7.58
r2153 (  8 10 ) resistor r=0.446141 //w=0.311 //l=1.11 //layer=m1 \
 //thickness=0.36 //x=3.45 //y=7.585 //x2=4.56 //y2=7.585
r2154 (  6 184 ) resistor r=3.1 //w=0.17 //l=0.51 //layer=mcon //count=3 \
 //x=2.34 //y=7.58 //x2=2.34 //y2=7.58
r2155 (  6 8 ) resistor r=0.446141 //w=0.311 //l=1.11 //layer=m1 \
 //thickness=0.36 //x=2.34 //y=7.585 //x2=3.45 //y2=7.585
r2156 (  3 174 ) resistor r=3.1 //w=0.17 //l=0.51 //layer=mcon //count=3 \
 //x=1.23 //y=7.58 //x2=1.23 //y2=7.58
r2157 (  3 6 ) resistor r=0.446141 //w=0.311 //l=1.11 //layer=m1 \
 //thickness=0.36 //x=1.23 //y=7.585 //x2=2.34 //y2=7.585
r2158 (  1 87 ) resistor r=0.223071 //w=0.311 //l=0.555 //layer=m1 \
 //thickness=0.36 //x=49.885 //y=7.585 //x2=50.44 //y2=7.585
r2159 (  1 84 ) resistor r=0.223071 //w=0.311 //l=0.555 //layer=m1 \
 //thickness=0.36 //x=49.885 //y=7.585 //x2=49.33 //y2=7.585
ends PM_TMRDFFSNRNQX1\%VDD

subckt PM_TMRDFFSNRNQX1\%noxref_3 ( 1 2 3 4 17 18 25 33 39 40 44 46 54 61 62 \
 63 64 65 66 67 68 69 70 71 72 73 75 81 82 83 84 88 89 90 91 92 94 100 101 102 \
 103 123 125 126 127 )
c240 ( 127 0 ) capacitor c=0.023087f //x=3.635 //y=5.2
c241 ( 126 0 ) capacitor c=0.023519f //x=2.755 //y=5.2
c242 ( 125 0 ) capacitor c=0.0224735f //x=1.875 //y=5.2
c243 ( 123 0 ) capacitor c=0.00853354f //x=3.885 //y=1.095
c244 ( 103 0 ) capacitor c=0.0556143f //x=11.495 //y=4.97
c245 ( 102 0 ) capacitor c=0.0293157f //x=11.785 //y=4.97
c246 ( 101 0 ) capacitor c=0.0347816f //x=11.45 //y=1.4
c247 ( 100 0 ) capacitor c=0.0187487f //x=11.45 //y=1.055
c248 ( 94 0 ) capacitor c=0.0137055f //x=11.295 //y=1.555
c249 ( 92 0 ) capacitor c=0.0149861f //x=11.295 //y=0.9
c250 ( 91 0 ) capacitor c=0.096037f //x=10.92 //y=2.095
c251 ( 90 0 ) capacitor c=0.0228993f //x=10.92 //y=1.71
c252 ( 89 0 ) capacitor c=0.0234352f //x=10.92 //y=1.4
c253 ( 88 0 ) capacitor c=0.0198724f //x=10.92 //y=1.055
c254 ( 84 0 ) capacitor c=0.055995f //x=6.685 //y=4.97
c255 ( 83 0 ) capacitor c=0.0298189f //x=6.975 //y=4.97
c256 ( 82 0 ) capacitor c=0.0347816f //x=6.64 //y=1.4
c257 ( 81 0 ) capacitor c=0.0187487f //x=6.64 //y=1.055
c258 ( 75 0 ) capacitor c=0.0137055f //x=6.485 //y=1.555
c259 ( 73 0 ) capacitor c=0.0149861f //x=6.485 //y=0.9
c260 ( 72 0 ) capacitor c=0.096037f //x=6.11 //y=2.095
c261 ( 71 0 ) capacitor c=0.0228993f //x=6.11 //y=1.71
c262 ( 70 0 ) capacitor c=0.0234352f //x=6.11 //y=1.4
c263 ( 69 0 ) capacitor c=0.0198724f //x=6.11 //y=1.055
c264 ( 68 0 ) capacitor c=0.110114f //x=11.86 //y=6.2
c265 ( 67 0 ) capacitor c=0.158956f //x=11.42 //y=6.2
c266 ( 66 0 ) capacitor c=0.110114f //x=7.05 //y=6.2
c267 ( 65 0 ) capacitor c=0.158956f //x=6.61 //y=6.2
c268 ( 62 0 ) capacitor c=0.00116729f //x=3.78 //y=5.335
c269 ( 61 0 ) capacitor c=0.00226015f //x=2.9 //y=5.335
c270 ( 54 0 ) capacitor c=0.0970684f //x=11.22 //y=2.26
c271 ( 46 0 ) capacitor c=0.102314f //x=6.41 //y=2.26
c272 ( 44 0 ) capacitor c=0.111586f //x=4.56 //y=2.77
c273 ( 40 0 ) capacitor c=0.00398962f //x=4.16 //y=1.845
c274 ( 39 0 ) capacitor c=0.0137288f //x=4.475 //y=1.845
c275 ( 33 0 ) capacitor c=0.0291119f //x=4.475 //y=5.335
c276 ( 25 0 ) capacitor c=0.0184197f //x=3.695 //y=5.335
c277 ( 18 0 ) capacitor c=0.00351598f //x=2.105 //y=5.335
c278 ( 17 0 ) capacitor c=0.0155255f //x=2.815 //y=5.335
c279 ( 4 0 ) capacitor c=0.00440131f //x=6.525 //y=2.77
c280 ( 3 0 ) capacitor c=0.0870935f //x=11.105 //y=2.77
c281 ( 2 0 ) capacitor c=0.0124623f //x=4.675 //y=2.77
c282 ( 1 0 ) capacitor c=0.0300768f //x=6.295 //y=2.77
r283 (  102 104 ) resistor r=26.9307 //w=0.15 //l=0.106066 //layer=ply \
 //thickness=0.18 //x=11.785 //y=4.97 //x2=11.86 //y2=5.045
r284 (  102 103 ) resistor r=148.702 //w=0.094 //l=0.29 //layer=ply \
 //thickness=0.18 //x=11.785 //y=4.97 //x2=11.495 //y2=4.97
r285 (  101 122 ) resistor r=45.1352 //w=0.168 //l=0.173853 //layer=ply \
 //thickness=0.18 //x=11.45 //y=1.4 //x2=11.41 //y2=1.555
r286 (  100 121 ) resistor r=45.1352 //w=0.168 //l=0.173853 //layer=ply \
 //thickness=0.18 //x=11.45 //y=1.055 //x2=11.41 //y2=0.9
r287 (  100 101 ) resistor r=176.904 //w=0.094 //l=0.345 //layer=ply \
 //thickness=0.18 //x=11.45 //y=1.055 //x2=11.45 //y2=1.4
r288 (  97 103 ) resistor r=22.7971 //w=0.269 //l=0.106066 //layer=ply \
 //thickness=0.18 //x=11.42 //y=5.045 //x2=11.495 //y2=4.97
r289 (  97 120 ) resistor r=35.8364 //w=0.269 //l=0.270185 //layer=ply \
 //thickness=0.18 //x=11.42 //y=5.045 //x2=11.22 //y2=4.88
r290 (  95 116 ) resistor r=10.701 //w=0.21 //l=0.115 //layer=ply \
 //thickness=0.18 //x=11.075 //y=1.555 //x2=10.96 //y2=1.555
r291 (  94 122 ) resistor r=5.52526 //w=0.168 //l=0.115 //layer=ply \
 //thickness=0.18 //x=11.295 //y=1.555 //x2=11.41 //y2=1.555
r292 (  93 115 ) resistor r=5.52526 //w=0.168 //l=0.115 //layer=ply \
 //thickness=0.18 //x=11.075 //y=0.9 //x2=10.96 //y2=0.9
r293 (  92 121 ) resistor r=5.52526 //w=0.168 //l=0.115 //layer=ply \
 //thickness=0.18 //x=11.295 //y=0.9 //x2=11.41 //y2=0.9
r294 (  92 93 ) resistor r=112.809 //w=0.094 //l=0.22 //layer=ply \
 //thickness=0.18 //x=11.295 //y=0.9 //x2=11.075 //y2=0.9
r295 (  91 118 ) resistor r=58.7805 //w=0.246 //l=0.373497 //layer=ply \
 //thickness=0.18 //x=10.92 //y=2.095 //x2=11.22 //y2=2.26
r296 (  90 116 ) resistor r=39.5823 //w=0.21 //l=0.173853 //layer=ply \
 //thickness=0.18 //x=10.92 //y=1.71 //x2=10.96 //y2=1.555
r297 (  90 91 ) resistor r=197.415 //w=0.094 //l=0.385 //layer=ply \
 //thickness=0.18 //x=10.92 //y=1.71 //x2=10.92 //y2=2.095
r298 (  89 116 ) resistor r=39.5823 //w=0.21 //l=0.173853 //layer=ply \
 //thickness=0.18 //x=10.92 //y=1.4 //x2=10.96 //y2=1.555
r299 (  88 115 ) resistor r=45.1352 //w=0.168 //l=0.173853 //layer=ply \
 //thickness=0.18 //x=10.92 //y=1.055 //x2=10.96 //y2=0.9
r300 (  88 89 ) resistor r=176.904 //w=0.094 //l=0.345 //layer=ply \
 //thickness=0.18 //x=10.92 //y=1.055 //x2=10.92 //y2=1.4
r301 (  83 85 ) resistor r=26.9307 //w=0.15 //l=0.106066 //layer=ply \
 //thickness=0.18 //x=6.975 //y=4.97 //x2=7.05 //y2=5.045
r302 (  83 84 ) resistor r=148.702 //w=0.094 //l=0.29 //layer=ply \
 //thickness=0.18 //x=6.975 //y=4.97 //x2=6.685 //y2=4.97
r303 (  82 114 ) resistor r=45.1352 //w=0.168 //l=0.173853 //layer=ply \
 //thickness=0.18 //x=6.64 //y=1.4 //x2=6.6 //y2=1.555
r304 (  81 113 ) resistor r=45.1352 //w=0.168 //l=0.173853 //layer=ply \
 //thickness=0.18 //x=6.64 //y=1.055 //x2=6.6 //y2=0.9
r305 (  81 82 ) resistor r=176.904 //w=0.094 //l=0.345 //layer=ply \
 //thickness=0.18 //x=6.64 //y=1.055 //x2=6.64 //y2=1.4
r306 (  78 84 ) resistor r=22.7971 //w=0.269 //l=0.106066 //layer=ply \
 //thickness=0.18 //x=6.61 //y=5.045 //x2=6.685 //y2=4.97
r307 (  78 112 ) resistor r=35.8364 //w=0.269 //l=0.270185 //layer=ply \
 //thickness=0.18 //x=6.61 //y=5.045 //x2=6.41 //y2=4.88
r308 (  76 108 ) resistor r=10.701 //w=0.21 //l=0.115 //layer=ply \
 //thickness=0.18 //x=6.265 //y=1.555 //x2=6.15 //y2=1.555
r309 (  75 114 ) resistor r=5.52526 //w=0.168 //l=0.115 //layer=ply \
 //thickness=0.18 //x=6.485 //y=1.555 //x2=6.6 //y2=1.555
r310 (  74 107 ) resistor r=5.52526 //w=0.168 //l=0.115 //layer=ply \
 //thickness=0.18 //x=6.265 //y=0.9 //x2=6.15 //y2=0.9
r311 (  73 113 ) resistor r=5.52526 //w=0.168 //l=0.115 //layer=ply \
 //thickness=0.18 //x=6.485 //y=0.9 //x2=6.6 //y2=0.9
r312 (  73 74 ) resistor r=112.809 //w=0.094 //l=0.22 //layer=ply \
 //thickness=0.18 //x=6.485 //y=0.9 //x2=6.265 //y2=0.9
r313 (  72 110 ) resistor r=58.7805 //w=0.246 //l=0.373497 //layer=ply \
 //thickness=0.18 //x=6.11 //y=2.095 //x2=6.41 //y2=2.26
r314 (  71 108 ) resistor r=39.5823 //w=0.21 //l=0.173853 //layer=ply \
 //thickness=0.18 //x=6.11 //y=1.71 //x2=6.15 //y2=1.555
r315 (  71 72 ) resistor r=197.415 //w=0.094 //l=0.385 //layer=ply \
 //thickness=0.18 //x=6.11 //y=1.71 //x2=6.11 //y2=2.095
r316 (  70 108 ) resistor r=39.5823 //w=0.21 //l=0.173853 //layer=ply \
 //thickness=0.18 //x=6.11 //y=1.4 //x2=6.15 //y2=1.555
r317 (  69 107 ) resistor r=45.1352 //w=0.168 //l=0.173853 //layer=ply \
 //thickness=0.18 //x=6.11 //y=1.055 //x2=6.15 //y2=0.9
r318 (  69 70 ) resistor r=176.904 //w=0.094 //l=0.345 //layer=ply \
 //thickness=0.18 //x=6.11 //y=1.055 //x2=6.11 //y2=1.4
r319 (  68 104 ) resistor r=592.245 //w=0.094 //l=1.155 //layer=ply \
 //thickness=0.18 //x=11.86 //y=6.2 //x2=11.86 //y2=5.045
r320 (  67 97 ) resistor r=592.245 //w=0.094 //l=1.155 //layer=ply \
 //thickness=0.18 //x=11.42 //y=6.2 //x2=11.42 //y2=5.045
r321 (  66 85 ) resistor r=592.245 //w=0.094 //l=1.155 //layer=ply \
 //thickness=0.18 //x=7.05 //y=6.2 //x2=7.05 //y2=5.045
r322 (  65 78 ) resistor r=592.245 //w=0.094 //l=1.155 //layer=ply \
 //thickness=0.18 //x=6.61 //y=6.2 //x2=6.61 //y2=5.045
r323 (  64 94 ) resistor r=56.4043 //w=0.094 //l=0.11 //layer=ply \
 //thickness=0.18 //x=11.185 //y=1.555 //x2=11.295 //y2=1.555
r324 (  64 95 ) resistor r=56.4043 //w=0.094 //l=0.11 //layer=ply \
 //thickness=0.18 //x=11.185 //y=1.555 //x2=11.075 //y2=1.555
r325 (  63 75 ) resistor r=56.4043 //w=0.094 //l=0.11 //layer=ply \
 //thickness=0.18 //x=6.375 //y=1.555 //x2=6.485 //y2=1.555
r326 (  63 76 ) resistor r=56.4043 //w=0.094 //l=0.11 //layer=ply \
 //thickness=0.18 //x=6.375 //y=1.555 //x2=6.265 //y2=1.555
r327 (  59 120 ) resistor r=152 //w=0.17 //l=0.17 //layer=licon //count=1 \
 //x=11.22 //y=4.88 //x2=11.22 //y2=4.88
r328 (  57 59 ) resistor r=144.428 //w=0.187 //l=2.11 //layer=li \
 //thickness=0.1 //x=11.22 //y=2.77 //x2=11.22 //y2=4.88
r329 (  54 118 ) resistor r=152 //w=0.17 //l=0.17 //layer=licon //count=1 \
 //x=11.22 //y=2.26 //x2=11.22 //y2=2.26
r330 (  54 57 ) resistor r=34.9091 //w=0.187 //l=0.51 //layer=li \
 //thickness=0.1 //x=11.22 //y=2.26 //x2=11.22 //y2=2.77
r331 (  51 112 ) resistor r=152 //w=0.17 //l=0.17 //layer=licon //count=1 \
 //x=6.41 //y=4.88 //x2=6.41 //y2=4.88
r332 (  49 51 ) resistor r=144.428 //w=0.187 //l=2.11 //layer=li \
 //thickness=0.1 //x=6.41 //y=2.77 //x2=6.41 //y2=4.88
r333 (  46 110 ) resistor r=152 //w=0.17 //l=0.17 //layer=licon //count=1 \
 //x=6.41 //y=2.26 //x2=6.41 //y2=2.26
r334 (  46 49 ) resistor r=34.9091 //w=0.187 //l=0.51 //layer=li \
 //thickness=0.1 //x=6.41 //y=2.26 //x2=6.41 //y2=2.77
r335 (  42 44 ) resistor r=169.754 //w=0.187 //l=2.48 //layer=li \
 //thickness=0.1 //x=4.56 //y=5.25 //x2=4.56 //y2=2.77
r336 (  41 44 ) resistor r=57.4973 //w=0.187 //l=0.84 //layer=li \
 //thickness=0.1 //x=4.56 //y=1.93 //x2=4.56 //y2=2.77
r337 (  39 41 ) resistor r=7.15173 //w=0.17 //l=0.120208 //layer=li \
 //thickness=0.1 //x=4.475 //y=1.845 //x2=4.56 //y2=1.93
r338 (  39 40 ) resistor r=21.5615 //w=0.187 //l=0.315 //layer=li \
 //thickness=0.1 //x=4.475 //y=1.845 //x2=4.16 //y2=1.845
r339 (  35 40 ) resistor r=7.15173 //w=0.17 //l=0.120208 //layer=li \
 //thickness=0.1 //x=4.075 //y=1.76 //x2=4.16 //y2=1.845
r340 (  35 123 ) resistor r=39.016 //w=0.187 //l=0.57 //layer=li \
 //thickness=0.1 //x=4.075 //y=1.76 //x2=4.075 //y2=1.19
r341 (  34 62 ) resistor r=5.4201 //w=0.17 //l=0.085 //layer=li \
 //thickness=0.1 //x=3.865 //y=5.335 //x2=3.78 //y2=5.335
r342 (  33 42 ) resistor r=7.15173 //w=0.17 //l=0.120208 //layer=li \
 //thickness=0.1 //x=4.475 //y=5.335 //x2=4.56 //y2=5.25
r343 (  33 34 ) resistor r=41.754 //w=0.187 //l=0.61 //layer=li \
 //thickness=0.1 //x=4.475 //y=5.335 //x2=3.865 //y2=5.335
r344 (  27 62 ) resistor r=1.40859 //w=0.34 //l=0.085 //layer=li \
 //thickness=0.1 //x=3.78 //y=5.42 //x2=3.78 //y2=5.335
r345 (  27 127 ) resistor r=33.1979 //w=0.187 //l=0.485 //layer=li \
 //thickness=0.1 //x=3.78 //y=5.42 //x2=3.78 //y2=5.905
r346 (  26 61 ) resistor r=5.4201 //w=0.17 //l=0.085 //layer=li \
 //thickness=0.1 //x=2.985 //y=5.335 //x2=2.9 //y2=5.335
r347 (  25 62 ) resistor r=5.4201 //w=0.17 //l=0.085 //layer=li \
 //thickness=0.1 //x=3.695 //y=5.335 //x2=3.78 //y2=5.335
r348 (  25 26 ) resistor r=48.5989 //w=0.187 //l=0.71 //layer=li \
 //thickness=0.1 //x=3.695 //y=5.335 //x2=2.985 //y2=5.335
r349 (  19 61 ) resistor r=1.40859 //w=0.34 //l=0.085 //layer=li \
 //thickness=0.1 //x=2.9 //y=5.42 //x2=2.9 //y2=5.335
r350 (  19 126 ) resistor r=33.1979 //w=0.187 //l=0.485 //layer=li \
 //thickness=0.1 //x=2.9 //y=5.42 //x2=2.9 //y2=5.905
r351 (  17 61 ) resistor r=5.4201 //w=0.17 //l=0.085 //layer=li \
 //thickness=0.1 //x=2.815 //y=5.335 //x2=2.9 //y2=5.335
r352 (  17 18 ) resistor r=48.5989 //w=0.187 //l=0.71 //layer=li \
 //thickness=0.1 //x=2.815 //y=5.335 //x2=2.105 //y2=5.335
r353 (  11 18 ) resistor r=7.15173 //w=0.17 //l=0.120208 //layer=li \
 //thickness=0.1 //x=2.02 //y=5.42 //x2=2.105 //y2=5.335
r354 (  11 125 ) resistor r=33.1979 //w=0.187 //l=0.485 //layer=li \
 //thickness=0.1 //x=2.02 //y=5.42 //x2=2.02 //y2=5.905
r355 (  10 57 ) resistor r=9.3 //w=0.17 //l=0.17 //layer=mcon //count=1 \
 //x=11.22 //y=2.77 //x2=11.22 //y2=2.77
r356 (  8 49 ) resistor r=9.3 //w=0.17 //l=0.17 //layer=mcon //count=1 \
 //x=6.41 //y=2.77 //x2=6.41 //y2=2.77
r357 (  6 44 ) resistor r=9.3 //w=0.17 //l=0.17 //layer=mcon //count=1 \
 //x=4.56 //y=2.77 //x2=4.56 //y2=2.77
r358 (  4 8 ) resistor r=0.0880901 //w=0.191 //l=0.115 //layer=m1 \
 //thickness=0.36 //x=6.525 //y=2.77 //x2=6.41 //y2=2.77
r359 (  3 10 ) resistor r=0.0717383 //w=0.224 //l=0.115 //layer=m1 \
 //thickness=0.36 //x=11.105 //y=2.77 //x2=11.22 //y2=2.77
r360 (  3 4 ) resistor r=4.37023 //w=0.131 //l=4.58 //layer=m1 \
 //thickness=0.36 //x=11.105 //y=2.77 //x2=6.525 //y2=2.77
r361 (  2 6 ) resistor r=0.0717383 //w=0.224 //l=0.115 //layer=m1 \
 //thickness=0.36 //x=4.675 //y=2.77 //x2=4.56 //y2=2.77
r362 (  1 8 ) resistor r=0.0880901 //w=0.191 //l=0.115 //layer=m1 \
 //thickness=0.36 //x=6.295 //y=2.77 //x2=6.41 //y2=2.77
r363 (  1 2 ) resistor r=1.5458 //w=0.131 //l=1.62 //layer=m1 //thickness=0.36 \
 //x=6.295 //y=2.77 //x2=4.675 //y2=2.77
ends PM_TMRDFFSNRNQX1\%noxref_3

subckt PM_TMRDFFSNRNQX1\%noxref_4 ( 1 2 13 14 21 29 35 36 40 42 49 50 51 52 53 \
 54 55 56 57 58 60 66 67 68 69 81 83 84 85 )
c165 ( 85 0 ) capacitor c=0.023087f //x=13.255 //y=5.2
c166 ( 84 0 ) capacitor c=0.023519f //x=12.375 //y=5.2
c167 ( 83 0 ) capacitor c=0.0224735f //x=11.495 //y=5.2
c168 ( 81 0 ) capacitor c=0.00853354f //x=13.505 //y=1.095
c169 ( 69 0 ) capacitor c=0.0557698f //x=16.305 //y=4.97
c170 ( 68 0 ) capacitor c=0.0293157f //x=16.595 //y=4.97
c171 ( 67 0 ) capacitor c=0.0347816f //x=16.26 //y=1.4
c172 ( 66 0 ) capacitor c=0.0187487f //x=16.26 //y=1.055
c173 ( 60 0 ) capacitor c=0.0137055f //x=16.105 //y=1.555
c174 ( 58 0 ) capacitor c=0.0149861f //x=16.105 //y=0.9
c175 ( 57 0 ) capacitor c=0.096037f //x=15.73 //y=2.095
c176 ( 56 0 ) capacitor c=0.0228993f //x=15.73 //y=1.71
c177 ( 55 0 ) capacitor c=0.0234352f //x=15.73 //y=1.4
c178 ( 54 0 ) capacitor c=0.0198724f //x=15.73 //y=1.055
c179 ( 53 0 ) capacitor c=0.110114f //x=16.67 //y=6.2
c180 ( 52 0 ) capacitor c=0.158956f //x=16.23 //y=6.2
c181 ( 50 0 ) capacitor c=0.00106608f //x=13.4 //y=5.335
c182 ( 49 0 ) capacitor c=0.00207319f //x=12.52 //y=5.335
c183 ( 42 0 ) capacitor c=0.0939064f //x=16.03 //y=2.26
c184 ( 40 0 ) capacitor c=0.10406f //x=14.18 //y=2.77
c185 ( 36 0 ) capacitor c=0.00398962f //x=13.78 //y=1.845
c186 ( 35 0 ) capacitor c=0.0137288f //x=14.095 //y=1.845
c187 ( 29 0 ) capacitor c=0.0283082f //x=14.095 //y=5.335
c188 ( 21 0 ) capacitor c=0.0176454f //x=13.315 //y=5.335
c189 ( 14 0 ) capacitor c=0.00332903f //x=11.725 //y=5.335
c190 ( 13 0 ) capacitor c=0.0148427f //x=12.435 //y=5.335
c191 ( 2 0 ) capacitor c=0.00808366f //x=14.295 //y=2.77
c192 ( 1 0 ) capacitor c=0.0352679f //x=15.915 //y=2.77
r193 (  68 70 ) resistor r=26.9307 //w=0.15 //l=0.106066 //layer=ply \
 //thickness=0.18 //x=16.595 //y=4.97 //x2=16.67 //y2=5.045
r194 (  68 69 ) resistor r=148.702 //w=0.094 //l=0.29 //layer=ply \
 //thickness=0.18 //x=16.595 //y=4.97 //x2=16.305 //y2=4.97
r195 (  67 80 ) resistor r=45.1352 //w=0.168 //l=0.173853 //layer=ply \
 //thickness=0.18 //x=16.26 //y=1.4 //x2=16.22 //y2=1.555
r196 (  66 79 ) resistor r=45.1352 //w=0.168 //l=0.173853 //layer=ply \
 //thickness=0.18 //x=16.26 //y=1.055 //x2=16.22 //y2=0.9
r197 (  66 67 ) resistor r=176.904 //w=0.094 //l=0.345 //layer=ply \
 //thickness=0.18 //x=16.26 //y=1.055 //x2=16.26 //y2=1.4
r198 (  63 69 ) resistor r=22.7971 //w=0.269 //l=0.106066 //layer=ply \
 //thickness=0.18 //x=16.23 //y=5.045 //x2=16.305 //y2=4.97
r199 (  63 78 ) resistor r=35.8364 //w=0.269 //l=0.270185 //layer=ply \
 //thickness=0.18 //x=16.23 //y=5.045 //x2=16.03 //y2=4.88
r200 (  61 74 ) resistor r=10.701 //w=0.21 //l=0.115 //layer=ply \
 //thickness=0.18 //x=15.885 //y=1.555 //x2=15.77 //y2=1.555
r201 (  60 80 ) resistor r=5.52526 //w=0.168 //l=0.115 //layer=ply \
 //thickness=0.18 //x=16.105 //y=1.555 //x2=16.22 //y2=1.555
r202 (  59 73 ) resistor r=5.52526 //w=0.168 //l=0.115 //layer=ply \
 //thickness=0.18 //x=15.885 //y=0.9 //x2=15.77 //y2=0.9
r203 (  58 79 ) resistor r=5.52526 //w=0.168 //l=0.115 //layer=ply \
 //thickness=0.18 //x=16.105 //y=0.9 //x2=16.22 //y2=0.9
r204 (  58 59 ) resistor r=112.809 //w=0.094 //l=0.22 //layer=ply \
 //thickness=0.18 //x=16.105 //y=0.9 //x2=15.885 //y2=0.9
r205 (  57 76 ) resistor r=58.7805 //w=0.246 //l=0.373497 //layer=ply \
 //thickness=0.18 //x=15.73 //y=2.095 //x2=16.03 //y2=2.26
r206 (  56 74 ) resistor r=39.5823 //w=0.21 //l=0.173853 //layer=ply \
 //thickness=0.18 //x=15.73 //y=1.71 //x2=15.77 //y2=1.555
r207 (  56 57 ) resistor r=197.415 //w=0.094 //l=0.385 //layer=ply \
 //thickness=0.18 //x=15.73 //y=1.71 //x2=15.73 //y2=2.095
r208 (  55 74 ) resistor r=39.5823 //w=0.21 //l=0.173853 //layer=ply \
 //thickness=0.18 //x=15.73 //y=1.4 //x2=15.77 //y2=1.555
r209 (  54 73 ) resistor r=45.1352 //w=0.168 //l=0.173853 //layer=ply \
 //thickness=0.18 //x=15.73 //y=1.055 //x2=15.77 //y2=0.9
r210 (  54 55 ) resistor r=176.904 //w=0.094 //l=0.345 //layer=ply \
 //thickness=0.18 //x=15.73 //y=1.055 //x2=15.73 //y2=1.4
r211 (  53 70 ) resistor r=592.245 //w=0.094 //l=1.155 //layer=ply \
 //thickness=0.18 //x=16.67 //y=6.2 //x2=16.67 //y2=5.045
r212 (  52 63 ) resistor r=592.245 //w=0.094 //l=1.155 //layer=ply \
 //thickness=0.18 //x=16.23 //y=6.2 //x2=16.23 //y2=5.045
r213 (  51 60 ) resistor r=56.4043 //w=0.094 //l=0.11 //layer=ply \
 //thickness=0.18 //x=15.995 //y=1.555 //x2=16.105 //y2=1.555
r214 (  51 61 ) resistor r=56.4043 //w=0.094 //l=0.11 //layer=ply \
 //thickness=0.18 //x=15.995 //y=1.555 //x2=15.885 //y2=1.555
r215 (  47 78 ) resistor r=152 //w=0.17 //l=0.17 //layer=licon //count=1 \
 //x=16.03 //y=4.88 //x2=16.03 //y2=4.88
r216 (  45 47 ) resistor r=144.428 //w=0.187 //l=2.11 //layer=li \
 //thickness=0.1 //x=16.03 //y=2.77 //x2=16.03 //y2=4.88
r217 (  42 76 ) resistor r=152 //w=0.17 //l=0.17 //layer=licon //count=1 \
 //x=16.03 //y=2.26 //x2=16.03 //y2=2.26
r218 (  42 45 ) resistor r=34.9091 //w=0.187 //l=0.51 //layer=li \
 //thickness=0.1 //x=16.03 //y=2.26 //x2=16.03 //y2=2.77
r219 (  38 40 ) resistor r=169.754 //w=0.187 //l=2.48 //layer=li \
 //thickness=0.1 //x=14.18 //y=5.25 //x2=14.18 //y2=2.77
r220 (  37 40 ) resistor r=57.4973 //w=0.187 //l=0.84 //layer=li \
 //thickness=0.1 //x=14.18 //y=1.93 //x2=14.18 //y2=2.77
r221 (  35 37 ) resistor r=7.15173 //w=0.17 //l=0.120208 //layer=li \
 //thickness=0.1 //x=14.095 //y=1.845 //x2=14.18 //y2=1.93
r222 (  35 36 ) resistor r=21.5615 //w=0.187 //l=0.315 //layer=li \
 //thickness=0.1 //x=14.095 //y=1.845 //x2=13.78 //y2=1.845
r223 (  31 36 ) resistor r=7.15173 //w=0.17 //l=0.120208 //layer=li \
 //thickness=0.1 //x=13.695 //y=1.76 //x2=13.78 //y2=1.845
r224 (  31 81 ) resistor r=39.016 //w=0.187 //l=0.57 //layer=li \
 //thickness=0.1 //x=13.695 //y=1.76 //x2=13.695 //y2=1.19
r225 (  30 50 ) resistor r=5.4201 //w=0.17 //l=0.085 //layer=li \
 //thickness=0.1 //x=13.485 //y=5.335 //x2=13.4 //y2=5.335
r226 (  29 38 ) resistor r=7.15173 //w=0.17 //l=0.120208 //layer=li \
 //thickness=0.1 //x=14.095 //y=5.335 //x2=14.18 //y2=5.25
r227 (  29 30 ) resistor r=41.754 //w=0.187 //l=0.61 //layer=li \
 //thickness=0.1 //x=14.095 //y=5.335 //x2=13.485 //y2=5.335
r228 (  23 50 ) resistor r=1.40859 //w=0.34 //l=0.085 //layer=li \
 //thickness=0.1 //x=13.4 //y=5.42 //x2=13.4 //y2=5.335
r229 (  23 85 ) resistor r=33.1979 //w=0.187 //l=0.485 //layer=li \
 //thickness=0.1 //x=13.4 //y=5.42 //x2=13.4 //y2=5.905
r230 (  22 49 ) resistor r=5.4201 //w=0.17 //l=0.085 //layer=li \
 //thickness=0.1 //x=12.605 //y=5.335 //x2=12.52 //y2=5.335
r231 (  21 50 ) resistor r=5.4201 //w=0.17 //l=0.085 //layer=li \
 //thickness=0.1 //x=13.315 //y=5.335 //x2=13.4 //y2=5.335
r232 (  21 22 ) resistor r=48.5989 //w=0.187 //l=0.71 //layer=li \
 //thickness=0.1 //x=13.315 //y=5.335 //x2=12.605 //y2=5.335
r233 (  15 49 ) resistor r=1.40859 //w=0.34 //l=0.085 //layer=li \
 //thickness=0.1 //x=12.52 //y=5.42 //x2=12.52 //y2=5.335
r234 (  15 84 ) resistor r=33.1979 //w=0.187 //l=0.485 //layer=li \
 //thickness=0.1 //x=12.52 //y=5.42 //x2=12.52 //y2=5.905
r235 (  13 49 ) resistor r=5.4201 //w=0.17 //l=0.085 //layer=li \
 //thickness=0.1 //x=12.435 //y=5.335 //x2=12.52 //y2=5.335
r236 (  13 14 ) resistor r=48.5989 //w=0.187 //l=0.71 //layer=li \
 //thickness=0.1 //x=12.435 //y=5.335 //x2=11.725 //y2=5.335
r237 (  7 14 ) resistor r=7.15173 //w=0.17 //l=0.120208 //layer=li \
 //thickness=0.1 //x=11.64 //y=5.42 //x2=11.725 //y2=5.335
r238 (  7 83 ) resistor r=33.1979 //w=0.187 //l=0.485 //layer=li \
 //thickness=0.1 //x=11.64 //y=5.42 //x2=11.64 //y2=5.905
r239 (  6 45 ) resistor r=9.3 //w=0.17 //l=0.17 //layer=mcon //count=1 \
 //x=16.03 //y=2.77 //x2=16.03 //y2=2.77
r240 (  4 40 ) resistor r=9.3 //w=0.17 //l=0.17 //layer=mcon //count=1 \
 //x=14.18 //y=2.77 //x2=14.18 //y2=2.77
r241 (  2 4 ) resistor r=0.0717383 //w=0.224 //l=0.115 //layer=m1 \
 //thickness=0.36 //x=14.295 //y=2.77 //x2=14.18 //y2=2.77
r242 (  1 6 ) resistor r=0.0717383 //w=0.224 //l=0.115 //layer=m1 \
 //thickness=0.36 //x=15.915 //y=2.77 //x2=16.03 //y2=2.77
r243 (  1 2 ) resistor r=1.5458 //w=0.131 //l=1.62 //layer=m1 //thickness=0.36 \
 //x=15.915 //y=2.77 //x2=14.295 //y2=2.77
ends PM_TMRDFFSNRNQX1\%noxref_4

subckt PM_TMRDFFSNRNQX1\%noxref_5 ( 1 2 3 4 12 25 26 33 41 47 48 52 54 61 62 \
 63 64 65 66 67 68 72 73 74 79 81 84 85 86 87 88 89 90 92 98 99 100 101 106 \
 107 112 123 125 126 127 )
c267 ( 127 0 ) capacitor c=0.023087f //x=8.445 //y=5.2
c268 ( 126 0 ) capacitor c=0.023519f //x=7.565 //y=5.2
c269 ( 125 0 ) capacitor c=0.0224735f //x=6.685 //y=5.2
c270 ( 123 0 ) capacitor c=0.00853354f //x=8.695 //y=1.095
c271 ( 112 0 ) capacitor c=0.059212f //x=3.82 //y=4.88
c272 ( 107 0 ) capacitor c=0.0273931f //x=3.82 //y=2.095
c273 ( 106 0 ) capacitor c=0.045877f //x=3.82 //y=2.26
c274 ( 101 0 ) capacitor c=0.0556143f //x=21.115 //y=4.97
c275 ( 100 0 ) capacitor c=0.0293157f //x=21.405 //y=4.97
c276 ( 99 0 ) capacitor c=0.0347816f //x=21.07 //y=1.4
c277 ( 98 0 ) capacitor c=0.0187487f //x=21.07 //y=1.055
c278 ( 92 0 ) capacitor c=0.0137055f //x=20.915 //y=1.555
c279 ( 90 0 ) capacitor c=0.0149861f //x=20.915 //y=0.9
c280 ( 89 0 ) capacitor c=0.096037f //x=20.54 //y=2.095
c281 ( 88 0 ) capacitor c=0.0228993f //x=20.54 //y=1.71
c282 ( 87 0 ) capacitor c=0.0234352f //x=20.54 //y=1.4
c283 ( 86 0 ) capacitor c=0.0198724f //x=20.54 //y=1.055
c284 ( 85 0 ) capacitor c=0.0432517f //x=4.34 //y=1.44
c285 ( 84 0 ) capacitor c=0.0200379f //x=4.34 //y=1.095
c286 ( 81 0 ) capacitor c=0.0148873f //x=4.185 //y=1.595
c287 ( 79 0 ) capacitor c=0.0157803f //x=4.185 //y=0.94
c288 ( 74 0 ) capacitor c=0.0218028f //x=3.81 //y=1.75
c289 ( 73 0 ) capacitor c=0.0207459f //x=3.81 //y=1.44
c290 ( 72 0 ) capacitor c=0.0194308f //x=3.81 //y=1.095
c291 ( 68 0 ) capacitor c=0.110114f //x=21.48 //y=6.2
c292 ( 67 0 ) capacitor c=0.158956f //x=21.04 //y=6.2
c293 ( 66 0 ) capacitor c=0.158794f //x=4 //y=6.2
c294 ( 65 0 ) capacitor c=0.110114f //x=3.56 //y=6.2
c295 ( 62 0 ) capacitor c=0.00106608f //x=8.59 //y=5.335
c296 ( 61 0 ) capacitor c=0.00207162f //x=7.71 //y=5.335
c297 ( 54 0 ) capacitor c=0.0965808f //x=20.84 //y=2.26
c298 ( 52 0 ) capacitor c=0.10653f //x=9.37 //y=3.51
c299 ( 48 0 ) capacitor c=0.00398962f //x=8.97 //y=1.845
c300 ( 47 0 ) capacitor c=0.0137288f //x=9.285 //y=1.845
c301 ( 41 0 ) capacitor c=0.0283082f //x=9.285 //y=5.335
c302 ( 33 0 ) capacitor c=0.0176454f //x=8.505 //y=5.335
c303 ( 26 0 ) capacitor c=0.00351598f //x=6.915 //y=5.335
c304 ( 25 0 ) capacitor c=0.0154196f //x=7.625 //y=5.335
c305 ( 12 0 ) capacitor c=0.0883624f //x=3.82 //y=2.26
c306 ( 4 0 ) capacitor c=0.00578611f //x=9.485 //y=3.51
c307 ( 3 0 ) capacitor c=0.184375f //x=20.725 //y=3.51
c308 ( 2 0 ) capacitor c=0.0148738f //x=3.935 //y=3.51
c309 ( 1 0 ) capacitor c=0.107193f //x=9.255 //y=3.51
r310 (  106 107 ) resistor r=52.7279 //w=0.214 //l=0.165 //layer=ply \
 //thickness=0.18 //x=3.82 //y=2.26 //x2=3.82 //y2=2.095
r311 (  100 102 ) resistor r=26.9307 //w=0.15 //l=0.106066 //layer=ply \
 //thickness=0.18 //x=21.405 //y=4.97 //x2=21.48 //y2=5.045
r312 (  100 101 ) resistor r=148.702 //w=0.094 //l=0.29 //layer=ply \
 //thickness=0.18 //x=21.405 //y=4.97 //x2=21.115 //y2=4.97
r313 (  99 122 ) resistor r=45.1352 //w=0.168 //l=0.173853 //layer=ply \
 //thickness=0.18 //x=21.07 //y=1.4 //x2=21.03 //y2=1.555
r314 (  98 121 ) resistor r=45.1352 //w=0.168 //l=0.173853 //layer=ply \
 //thickness=0.18 //x=21.07 //y=1.055 //x2=21.03 //y2=0.9
r315 (  98 99 ) resistor r=176.904 //w=0.094 //l=0.345 //layer=ply \
 //thickness=0.18 //x=21.07 //y=1.055 //x2=21.07 //y2=1.4
r316 (  95 101 ) resistor r=22.7971 //w=0.269 //l=0.106066 //layer=ply \
 //thickness=0.18 //x=21.04 //y=5.045 //x2=21.115 //y2=4.97
r317 (  95 120 ) resistor r=35.8364 //w=0.269 //l=0.270185 //layer=ply \
 //thickness=0.18 //x=21.04 //y=5.045 //x2=20.84 //y2=4.88
r318 (  93 116 ) resistor r=10.701 //w=0.21 //l=0.115 //layer=ply \
 //thickness=0.18 //x=20.695 //y=1.555 //x2=20.58 //y2=1.555
r319 (  92 122 ) resistor r=5.52526 //w=0.168 //l=0.115 //layer=ply \
 //thickness=0.18 //x=20.915 //y=1.555 //x2=21.03 //y2=1.555
r320 (  91 115 ) resistor r=5.52526 //w=0.168 //l=0.115 //layer=ply \
 //thickness=0.18 //x=20.695 //y=0.9 //x2=20.58 //y2=0.9
r321 (  90 121 ) resistor r=5.52526 //w=0.168 //l=0.115 //layer=ply \
 //thickness=0.18 //x=20.915 //y=0.9 //x2=21.03 //y2=0.9
r322 (  90 91 ) resistor r=112.809 //w=0.094 //l=0.22 //layer=ply \
 //thickness=0.18 //x=20.915 //y=0.9 //x2=20.695 //y2=0.9
r323 (  89 118 ) resistor r=58.7805 //w=0.246 //l=0.373497 //layer=ply \
 //thickness=0.18 //x=20.54 //y=2.095 //x2=20.84 //y2=2.26
r324 (  88 116 ) resistor r=39.5823 //w=0.21 //l=0.173853 //layer=ply \
 //thickness=0.18 //x=20.54 //y=1.71 //x2=20.58 //y2=1.555
r325 (  88 89 ) resistor r=197.415 //w=0.094 //l=0.385 //layer=ply \
 //thickness=0.18 //x=20.54 //y=1.71 //x2=20.54 //y2=2.095
r326 (  87 116 ) resistor r=39.5823 //w=0.21 //l=0.173853 //layer=ply \
 //thickness=0.18 //x=20.54 //y=1.4 //x2=20.58 //y2=1.555
r327 (  86 115 ) resistor r=45.1352 //w=0.168 //l=0.173853 //layer=ply \
 //thickness=0.18 //x=20.54 //y=1.055 //x2=20.58 //y2=0.9
r328 (  86 87 ) resistor r=176.904 //w=0.094 //l=0.345 //layer=ply \
 //thickness=0.18 //x=20.54 //y=1.055 //x2=20.54 //y2=1.4
r329 (  85 114 ) resistor r=45.1352 //w=0.168 //l=0.173853 //layer=ply \
 //thickness=0.18 //x=4.34 //y=1.44 //x2=4.3 //y2=1.595
r330 (  84 113 ) resistor r=45.1352 //w=0.168 //l=0.173853 //layer=ply \
 //thickness=0.18 //x=4.34 //y=1.095 //x2=4.3 //y2=0.94
r331 (  84 85 ) resistor r=176.904 //w=0.094 //l=0.345 //layer=ply \
 //thickness=0.18 //x=4.34 //y=1.095 //x2=4.34 //y2=1.44
r332 (  82 110 ) resistor r=10.701 //w=0.21 //l=0.115 //layer=ply \
 //thickness=0.18 //x=3.965 //y=1.595 //x2=3.85 //y2=1.595
r333 (  81 114 ) resistor r=5.52526 //w=0.168 //l=0.115 //layer=ply \
 //thickness=0.18 //x=4.185 //y=1.595 //x2=4.3 //y2=1.595
r334 (  80 109 ) resistor r=5.52526 //w=0.168 //l=0.115 //layer=ply \
 //thickness=0.18 //x=3.965 //y=0.94 //x2=3.85 //y2=0.94
r335 (  79 113 ) resistor r=5.52526 //w=0.168 //l=0.115 //layer=ply \
 //thickness=0.18 //x=4.185 //y=0.94 //x2=4.3 //y2=0.94
r336 (  79 80 ) resistor r=112.809 //w=0.094 //l=0.22 //layer=ply \
 //thickness=0.18 //x=4.185 //y=0.94 //x2=3.965 //y2=0.94
r337 (  76 112 ) resistor r=37.236 //w=0.233 //l=0.249199 //layer=ply \
 //thickness=0.18 //x=4 //y=5.045 //x2=3.82 //y2=4.88
r338 (  74 110 ) resistor r=39.5823 //w=0.21 //l=0.173853 //layer=ply \
 //thickness=0.18 //x=3.81 //y=1.75 //x2=3.85 //y2=1.595
r339 (  74 107 ) resistor r=176.904 //w=0.094 //l=0.345 //layer=ply \
 //thickness=0.18 //x=3.81 //y=1.75 //x2=3.81 //y2=2.095
r340 (  73 110 ) resistor r=39.5823 //w=0.21 //l=0.173853 //layer=ply \
 //thickness=0.18 //x=3.81 //y=1.44 //x2=3.85 //y2=1.595
r341 (  72 109 ) resistor r=45.1352 //w=0.168 //l=0.173853 //layer=ply \
 //thickness=0.18 //x=3.81 //y=1.095 //x2=3.85 //y2=0.94
r342 (  72 73 ) resistor r=176.904 //w=0.094 //l=0.345 //layer=ply \
 //thickness=0.18 //x=3.81 //y=1.095 //x2=3.81 //y2=1.44
r343 (  69 112 ) resistor r=53.7854 //w=0.233 //l=0.332415 //layer=ply \
 //thickness=0.18 //x=3.56 //y=5.045 //x2=3.82 //y2=4.88
r344 (  68 102 ) resistor r=592.245 //w=0.094 //l=1.155 //layer=ply \
 //thickness=0.18 //x=21.48 //y=6.2 //x2=21.48 //y2=5.045
r345 (  67 95 ) resistor r=592.245 //w=0.094 //l=1.155 //layer=ply \
 //thickness=0.18 //x=21.04 //y=6.2 //x2=21.04 //y2=5.045
r346 (  66 76 ) resistor r=592.245 //w=0.094 //l=1.155 //layer=ply \
 //thickness=0.18 //x=4 //y=6.2 //x2=4 //y2=5.045
r347 (  65 69 ) resistor r=592.245 //w=0.094 //l=1.155 //layer=ply \
 //thickness=0.18 //x=3.56 //y=6.2 //x2=3.56 //y2=5.045
r348 (  64 92 ) resistor r=56.4043 //w=0.094 //l=0.11 //layer=ply \
 //thickness=0.18 //x=20.805 //y=1.555 //x2=20.915 //y2=1.555
r349 (  64 93 ) resistor r=56.4043 //w=0.094 //l=0.11 //layer=ply \
 //thickness=0.18 //x=20.805 //y=1.555 //x2=20.695 //y2=1.555
r350 (  63 81 ) resistor r=56.4043 //w=0.094 //l=0.11 //layer=ply \
 //thickness=0.18 //x=4.075 //y=1.595 //x2=4.185 //y2=1.595
r351 (  63 82 ) resistor r=56.4043 //w=0.094 //l=0.11 //layer=ply \
 //thickness=0.18 //x=4.075 //y=1.595 //x2=3.965 //y2=1.595
r352 (  59 120 ) resistor r=152 //w=0.17 //l=0.17 //layer=licon //count=1 \
 //x=20.84 //y=4.88 //x2=20.84 //y2=4.88
r353 (  57 59 ) resistor r=93.7754 //w=0.187 //l=1.37 //layer=li \
 //thickness=0.1 //x=20.84 //y=3.51 //x2=20.84 //y2=4.88
r354 (  54 118 ) resistor r=152 //w=0.17 //l=0.17 //layer=licon //count=1 \
 //x=20.84 //y=2.26 //x2=20.84 //y2=2.26
r355 (  54 57 ) resistor r=85.5615 //w=0.187 //l=1.25 //layer=li \
 //thickness=0.1 //x=20.84 //y=2.26 //x2=20.84 //y2=3.51
r356 (  50 52 ) resistor r=119.102 //w=0.187 //l=1.74 //layer=li \
 //thickness=0.1 //x=9.37 //y=5.25 //x2=9.37 //y2=3.51
r357 (  49 52 ) resistor r=108.15 //w=0.187 //l=1.58 //layer=li \
 //thickness=0.1 //x=9.37 //y=1.93 //x2=9.37 //y2=3.51
r358 (  47 49 ) resistor r=7.15173 //w=0.17 //l=0.120208 //layer=li \
 //thickness=0.1 //x=9.285 //y=1.845 //x2=9.37 //y2=1.93
r359 (  47 48 ) resistor r=21.5615 //w=0.187 //l=0.315 //layer=li \
 //thickness=0.1 //x=9.285 //y=1.845 //x2=8.97 //y2=1.845
r360 (  43 48 ) resistor r=7.15173 //w=0.17 //l=0.120208 //layer=li \
 //thickness=0.1 //x=8.885 //y=1.76 //x2=8.97 //y2=1.845
r361 (  43 123 ) resistor r=39.016 //w=0.187 //l=0.57 //layer=li \
 //thickness=0.1 //x=8.885 //y=1.76 //x2=8.885 //y2=1.19
r362 (  42 62 ) resistor r=5.4201 //w=0.17 //l=0.085 //layer=li \
 //thickness=0.1 //x=8.675 //y=5.335 //x2=8.59 //y2=5.335
r363 (  41 50 ) resistor r=7.15173 //w=0.17 //l=0.120208 //layer=li \
 //thickness=0.1 //x=9.285 //y=5.335 //x2=9.37 //y2=5.25
r364 (  41 42 ) resistor r=41.754 //w=0.187 //l=0.61 //layer=li \
 //thickness=0.1 //x=9.285 //y=5.335 //x2=8.675 //y2=5.335
r365 (  35 62 ) resistor r=1.40859 //w=0.34 //l=0.085 //layer=li \
 //thickness=0.1 //x=8.59 //y=5.42 //x2=8.59 //y2=5.335
r366 (  35 127 ) resistor r=33.1979 //w=0.187 //l=0.485 //layer=li \
 //thickness=0.1 //x=8.59 //y=5.42 //x2=8.59 //y2=5.905
r367 (  34 61 ) resistor r=5.4201 //w=0.17 //l=0.085 //layer=li \
 //thickness=0.1 //x=7.795 //y=5.335 //x2=7.71 //y2=5.335
r368 (  33 62 ) resistor r=5.4201 //w=0.17 //l=0.085 //layer=li \
 //thickness=0.1 //x=8.505 //y=5.335 //x2=8.59 //y2=5.335
r369 (  33 34 ) resistor r=48.5989 //w=0.187 //l=0.71 //layer=li \
 //thickness=0.1 //x=8.505 //y=5.335 //x2=7.795 //y2=5.335
r370 (  27 61 ) resistor r=1.40859 //w=0.34 //l=0.085 //layer=li \
 //thickness=0.1 //x=7.71 //y=5.42 //x2=7.71 //y2=5.335
r371 (  27 126 ) resistor r=33.1979 //w=0.187 //l=0.485 //layer=li \
 //thickness=0.1 //x=7.71 //y=5.42 //x2=7.71 //y2=5.905
r372 (  25 61 ) resistor r=5.4201 //w=0.17 //l=0.085 //layer=li \
 //thickness=0.1 //x=7.625 //y=5.335 //x2=7.71 //y2=5.335
r373 (  25 26 ) resistor r=48.5989 //w=0.187 //l=0.71 //layer=li \
 //thickness=0.1 //x=7.625 //y=5.335 //x2=6.915 //y2=5.335
r374 (  19 26 ) resistor r=7.15173 //w=0.17 //l=0.120208 //layer=li \
 //thickness=0.1 //x=6.83 //y=5.42 //x2=6.915 //y2=5.335
r375 (  19 125 ) resistor r=33.1979 //w=0.187 //l=0.485 //layer=li \
 //thickness=0.1 //x=6.83 //y=5.42 //x2=6.83 //y2=5.905
r376 (  17 112 ) resistor r=152 //w=0.17 //l=0.17 //layer=licon //count=1 \
 //x=3.82 //y=4.88 //x2=3.82 //y2=4.88
r377 (  15 17 ) resistor r=93.7754 //w=0.187 //l=1.37 //layer=li \
 //thickness=0.1 //x=3.82 //y=3.51 //x2=3.82 //y2=4.88
r378 (  12 106 ) resistor r=152 //w=0.17 //l=0.17 //layer=licon //count=1 \
 //x=3.82 //y=2.26 //x2=3.82 //y2=2.26
r379 (  12 15 ) resistor r=85.5615 //w=0.187 //l=1.25 //layer=li \
 //thickness=0.1 //x=3.82 //y=2.26 //x2=3.82 //y2=3.51
r380 (  10 57 ) resistor r=9.3 //w=0.17 //l=0.17 //layer=mcon //count=1 \
 //x=20.84 //y=3.51 //x2=20.84 //y2=3.51
r381 (  8 52 ) resistor r=9.3 //w=0.17 //l=0.17 //layer=mcon //count=1 \
 //x=9.37 //y=3.51 //x2=9.37 //y2=3.51
r382 (  6 15 ) resistor r=9.3 //w=0.17 //l=0.17 //layer=mcon //count=1 \
 //x=3.82 //y=3.51 //x2=3.82 //y2=3.51
r383 (  4 8 ) resistor r=0.0880901 //w=0.191 //l=0.115 //layer=m1 \
 //thickness=0.36 //x=9.485 //y=3.51 //x2=9.37 //y2=3.51
r384 (  3 10 ) resistor r=0.0717383 //w=0.224 //l=0.115 //layer=m1 \
 //thickness=0.36 //x=20.725 //y=3.51 //x2=20.84 //y2=3.51
r385 (  3 4 ) resistor r=10.7252 //w=0.131 //l=11.24 //layer=m1 \
 //thickness=0.36 //x=20.725 //y=3.51 //x2=9.485 //y2=3.51
r386 (  2 6 ) resistor r=0.0717383 //w=0.224 //l=0.115 //layer=m1 \
 //thickness=0.36 //x=3.935 //y=3.51 //x2=3.82 //y2=3.51
r387 (  1 8 ) resistor r=0.0880901 //w=0.191 //l=0.115 //layer=m1 \
 //thickness=0.36 //x=9.255 //y=3.51 //x2=9.37 //y2=3.51
r388 (  1 2 ) resistor r=5.07634 //w=0.131 //l=5.32 //layer=m1 \
 //thickness=0.36 //x=9.255 //y=3.51 //x2=3.935 //y2=3.51
ends PM_TMRDFFSNRNQX1\%noxref_5

subckt PM_TMRDFFSNRNQX1\%noxref_6 ( 1 2 13 14 21 29 35 36 40 42 49 50 51 52 53 \
 54 55 56 57 58 60 66 67 68 69 81 83 84 85 )
c164 ( 85 0 ) capacitor c=0.023087f //x=22.875 //y=5.2
c165 ( 84 0 ) capacitor c=0.023519f //x=21.995 //y=5.2
c166 ( 83 0 ) capacitor c=0.0224735f //x=21.115 //y=5.2
c167 ( 81 0 ) capacitor c=0.00853354f //x=23.125 //y=1.095
c168 ( 69 0 ) capacitor c=0.0556143f //x=25.925 //y=4.97
c169 ( 68 0 ) capacitor c=0.0293157f //x=26.215 //y=4.97
c170 ( 67 0 ) capacitor c=0.0347816f //x=25.88 //y=1.4
c171 ( 66 0 ) capacitor c=0.0187487f //x=25.88 //y=1.055
c172 ( 60 0 ) capacitor c=0.0137055f //x=25.725 //y=1.555
c173 ( 58 0 ) capacitor c=0.0149861f //x=25.725 //y=0.9
c174 ( 57 0 ) capacitor c=0.096037f //x=25.35 //y=2.095
c175 ( 56 0 ) capacitor c=0.0228993f //x=25.35 //y=1.71
c176 ( 55 0 ) capacitor c=0.0234352f //x=25.35 //y=1.4
c177 ( 54 0 ) capacitor c=0.0198724f //x=25.35 //y=1.055
c178 ( 53 0 ) capacitor c=0.110114f //x=26.29 //y=6.2
c179 ( 52 0 ) capacitor c=0.158956f //x=25.85 //y=6.2
c180 ( 50 0 ) capacitor c=0.00106608f //x=23.02 //y=5.335
c181 ( 49 0 ) capacitor c=0.00207319f //x=22.14 //y=5.335
c182 ( 42 0 ) capacitor c=0.0937944f //x=25.65 //y=2.26
c183 ( 40 0 ) capacitor c=0.103719f //x=23.8 //y=2.77
c184 ( 36 0 ) capacitor c=0.00398962f //x=23.4 //y=1.845
c185 ( 35 0 ) capacitor c=0.0137288f //x=23.715 //y=1.845
c186 ( 29 0 ) capacitor c=0.0283082f //x=23.715 //y=5.335
c187 ( 21 0 ) capacitor c=0.0176454f //x=22.935 //y=5.335
c188 ( 14 0 ) capacitor c=0.00332903f //x=21.345 //y=5.335
c189 ( 13 0 ) capacitor c=0.0148427f //x=22.055 //y=5.335
c190 ( 2 0 ) capacitor c=0.0116088f //x=23.915 //y=2.77
c191 ( 1 0 ) capacitor c=0.0352679f //x=25.535 //y=2.77
r192 (  68 70 ) resistor r=26.9307 //w=0.15 //l=0.106066 //layer=ply \
 //thickness=0.18 //x=26.215 //y=4.97 //x2=26.29 //y2=5.045
r193 (  68 69 ) resistor r=148.702 //w=0.094 //l=0.29 //layer=ply \
 //thickness=0.18 //x=26.215 //y=4.97 //x2=25.925 //y2=4.97
r194 (  67 80 ) resistor r=45.1352 //w=0.168 //l=0.173853 //layer=ply \
 //thickness=0.18 //x=25.88 //y=1.4 //x2=25.84 //y2=1.555
r195 (  66 79 ) resistor r=45.1352 //w=0.168 //l=0.173853 //layer=ply \
 //thickness=0.18 //x=25.88 //y=1.055 //x2=25.84 //y2=0.9
r196 (  66 67 ) resistor r=176.904 //w=0.094 //l=0.345 //layer=ply \
 //thickness=0.18 //x=25.88 //y=1.055 //x2=25.88 //y2=1.4
r197 (  63 69 ) resistor r=22.7971 //w=0.269 //l=0.106066 //layer=ply \
 //thickness=0.18 //x=25.85 //y=5.045 //x2=25.925 //y2=4.97
r198 (  63 78 ) resistor r=35.8364 //w=0.269 //l=0.270185 //layer=ply \
 //thickness=0.18 //x=25.85 //y=5.045 //x2=25.65 //y2=4.88
r199 (  61 74 ) resistor r=10.701 //w=0.21 //l=0.115 //layer=ply \
 //thickness=0.18 //x=25.505 //y=1.555 //x2=25.39 //y2=1.555
r200 (  60 80 ) resistor r=5.52526 //w=0.168 //l=0.115 //layer=ply \
 //thickness=0.18 //x=25.725 //y=1.555 //x2=25.84 //y2=1.555
r201 (  59 73 ) resistor r=5.52526 //w=0.168 //l=0.115 //layer=ply \
 //thickness=0.18 //x=25.505 //y=0.9 //x2=25.39 //y2=0.9
r202 (  58 79 ) resistor r=5.52526 //w=0.168 //l=0.115 //layer=ply \
 //thickness=0.18 //x=25.725 //y=0.9 //x2=25.84 //y2=0.9
r203 (  58 59 ) resistor r=112.809 //w=0.094 //l=0.22 //layer=ply \
 //thickness=0.18 //x=25.725 //y=0.9 //x2=25.505 //y2=0.9
r204 (  57 76 ) resistor r=58.7805 //w=0.246 //l=0.373497 //layer=ply \
 //thickness=0.18 //x=25.35 //y=2.095 //x2=25.65 //y2=2.26
r205 (  56 74 ) resistor r=39.5823 //w=0.21 //l=0.173853 //layer=ply \
 //thickness=0.18 //x=25.35 //y=1.71 //x2=25.39 //y2=1.555
r206 (  56 57 ) resistor r=197.415 //w=0.094 //l=0.385 //layer=ply \
 //thickness=0.18 //x=25.35 //y=1.71 //x2=25.35 //y2=2.095
r207 (  55 74 ) resistor r=39.5823 //w=0.21 //l=0.173853 //layer=ply \
 //thickness=0.18 //x=25.35 //y=1.4 //x2=25.39 //y2=1.555
r208 (  54 73 ) resistor r=45.1352 //w=0.168 //l=0.173853 //layer=ply \
 //thickness=0.18 //x=25.35 //y=1.055 //x2=25.39 //y2=0.9
r209 (  54 55 ) resistor r=176.904 //w=0.094 //l=0.345 //layer=ply \
 //thickness=0.18 //x=25.35 //y=1.055 //x2=25.35 //y2=1.4
r210 (  53 70 ) resistor r=592.245 //w=0.094 //l=1.155 //layer=ply \
 //thickness=0.18 //x=26.29 //y=6.2 //x2=26.29 //y2=5.045
r211 (  52 63 ) resistor r=592.245 //w=0.094 //l=1.155 //layer=ply \
 //thickness=0.18 //x=25.85 //y=6.2 //x2=25.85 //y2=5.045
r212 (  51 60 ) resistor r=56.4043 //w=0.094 //l=0.11 //layer=ply \
 //thickness=0.18 //x=25.615 //y=1.555 //x2=25.725 //y2=1.555
r213 (  51 61 ) resistor r=56.4043 //w=0.094 //l=0.11 //layer=ply \
 //thickness=0.18 //x=25.615 //y=1.555 //x2=25.505 //y2=1.555
r214 (  47 78 ) resistor r=152 //w=0.17 //l=0.17 //layer=licon //count=1 \
 //x=25.65 //y=4.88 //x2=25.65 //y2=4.88
r215 (  45 47 ) resistor r=144.428 //w=0.187 //l=2.11 //layer=li \
 //thickness=0.1 //x=25.65 //y=2.77 //x2=25.65 //y2=4.88
r216 (  42 76 ) resistor r=152 //w=0.17 //l=0.17 //layer=licon //count=1 \
 //x=25.65 //y=2.26 //x2=25.65 //y2=2.26
r217 (  42 45 ) resistor r=34.9091 //w=0.187 //l=0.51 //layer=li \
 //thickness=0.1 //x=25.65 //y=2.26 //x2=25.65 //y2=2.77
r218 (  38 40 ) resistor r=169.754 //w=0.187 //l=2.48 //layer=li \
 //thickness=0.1 //x=23.8 //y=5.25 //x2=23.8 //y2=2.77
r219 (  37 40 ) resistor r=57.4973 //w=0.187 //l=0.84 //layer=li \
 //thickness=0.1 //x=23.8 //y=1.93 //x2=23.8 //y2=2.77
r220 (  35 37 ) resistor r=7.15173 //w=0.17 //l=0.120208 //layer=li \
 //thickness=0.1 //x=23.715 //y=1.845 //x2=23.8 //y2=1.93
r221 (  35 36 ) resistor r=21.5615 //w=0.187 //l=0.315 //layer=li \
 //thickness=0.1 //x=23.715 //y=1.845 //x2=23.4 //y2=1.845
r222 (  31 36 ) resistor r=7.15173 //w=0.17 //l=0.120208 //layer=li \
 //thickness=0.1 //x=23.315 //y=1.76 //x2=23.4 //y2=1.845
r223 (  31 81 ) resistor r=39.016 //w=0.187 //l=0.57 //layer=li \
 //thickness=0.1 //x=23.315 //y=1.76 //x2=23.315 //y2=1.19
r224 (  30 50 ) resistor r=5.4201 //w=0.17 //l=0.085 //layer=li \
 //thickness=0.1 //x=23.105 //y=5.335 //x2=23.02 //y2=5.335
r225 (  29 38 ) resistor r=7.15173 //w=0.17 //l=0.120208 //layer=li \
 //thickness=0.1 //x=23.715 //y=5.335 //x2=23.8 //y2=5.25
r226 (  29 30 ) resistor r=41.754 //w=0.187 //l=0.61 //layer=li \
 //thickness=0.1 //x=23.715 //y=5.335 //x2=23.105 //y2=5.335
r227 (  23 50 ) resistor r=1.40859 //w=0.34 //l=0.085 //layer=li \
 //thickness=0.1 //x=23.02 //y=5.42 //x2=23.02 //y2=5.335
r228 (  23 85 ) resistor r=33.1979 //w=0.187 //l=0.485 //layer=li \
 //thickness=0.1 //x=23.02 //y=5.42 //x2=23.02 //y2=5.905
r229 (  22 49 ) resistor r=5.4201 //w=0.17 //l=0.085 //layer=li \
 //thickness=0.1 //x=22.225 //y=5.335 //x2=22.14 //y2=5.335
r230 (  21 50 ) resistor r=5.4201 //w=0.17 //l=0.085 //layer=li \
 //thickness=0.1 //x=22.935 //y=5.335 //x2=23.02 //y2=5.335
r231 (  21 22 ) resistor r=48.5989 //w=0.187 //l=0.71 //layer=li \
 //thickness=0.1 //x=22.935 //y=5.335 //x2=22.225 //y2=5.335
r232 (  15 49 ) resistor r=1.40859 //w=0.34 //l=0.085 //layer=li \
 //thickness=0.1 //x=22.14 //y=5.42 //x2=22.14 //y2=5.335
r233 (  15 84 ) resistor r=33.1979 //w=0.187 //l=0.485 //layer=li \
 //thickness=0.1 //x=22.14 //y=5.42 //x2=22.14 //y2=5.905
r234 (  13 49 ) resistor r=5.4201 //w=0.17 //l=0.085 //layer=li \
 //thickness=0.1 //x=22.055 //y=5.335 //x2=22.14 //y2=5.335
r235 (  13 14 ) resistor r=48.5989 //w=0.187 //l=0.71 //layer=li \
 //thickness=0.1 //x=22.055 //y=5.335 //x2=21.345 //y2=5.335
r236 (  7 14 ) resistor r=7.15173 //w=0.17 //l=0.120208 //layer=li \
 //thickness=0.1 //x=21.26 //y=5.42 //x2=21.345 //y2=5.335
r237 (  7 83 ) resistor r=33.1979 //w=0.187 //l=0.485 //layer=li \
 //thickness=0.1 //x=21.26 //y=5.42 //x2=21.26 //y2=5.905
r238 (  6 45 ) resistor r=9.3 //w=0.17 //l=0.17 //layer=mcon //count=1 \
 //x=25.65 //y=2.77 //x2=25.65 //y2=2.77
r239 (  4 40 ) resistor r=9.3 //w=0.17 //l=0.17 //layer=mcon //count=1 \
 //x=23.8 //y=2.77 //x2=23.8 //y2=2.77
r240 (  2 4 ) resistor r=0.0717383 //w=0.224 //l=0.115 //layer=m1 \
 //thickness=0.36 //x=23.915 //y=2.77 //x2=23.8 //y2=2.77
r241 (  1 6 ) resistor r=0.0717383 //w=0.224 //l=0.115 //layer=m1 \
 //thickness=0.36 //x=25.535 //y=2.77 //x2=25.65 //y2=2.77
r242 (  1 2 ) resistor r=1.5458 //w=0.131 //l=1.62 //layer=m1 //thickness=0.36 \
 //x=25.535 //y=2.77 //x2=23.915 //y2=2.77
ends PM_TMRDFFSNRNQX1\%noxref_6

subckt PM_TMRDFFSNRNQX1\%noxref_7 ( 1 2 3 4 5 6 16 24 37 38 45 53 59 60 64 66 \
 73 74 75 76 77 78 79 80 81 82 83 87 88 89 94 96 99 100 104 105 106 111 113 \
 116 117 121 122 123 128 130 133 134 136 137 142 146 147 152 156 157 162 165 \
 167 168 169 )
c338 ( 169 0 ) capacitor c=0.023087f //x=18.065 //y=5.2
c339 ( 168 0 ) capacitor c=0.023519f //x=17.185 //y=5.2
c340 ( 167 0 ) capacitor c=0.0224735f //x=16.305 //y=5.2
c341 ( 165 0 ) capacitor c=0.00853354f //x=18.315 //y=1.095
c342 ( 162 0 ) capacitor c=0.0587755f //x=27.87 //y=4.88
c343 ( 157 0 ) capacitor c=0.0273931f //x=27.87 //y=2.095
c344 ( 156 0 ) capacitor c=0.0456313f //x=27.87 //y=2.26
c345 ( 152 0 ) capacitor c=0.0587755f //x=13.44 //y=4.88
c346 ( 147 0 ) capacitor c=0.0273931f //x=13.44 //y=2.095
c347 ( 146 0 ) capacitor c=0.0456313f //x=13.44 //y=2.26
c348 ( 142 0 ) capacitor c=0.058931f //x=8.63 //y=4.88
c349 ( 137 0 ) capacitor c=0.0273931f //x=8.63 //y=2.095
c350 ( 136 0 ) capacitor c=0.0456313f //x=8.63 //y=2.26
c351 ( 134 0 ) capacitor c=0.0432517f //x=28.39 //y=1.44
c352 ( 133 0 ) capacitor c=0.0200379f //x=28.39 //y=1.095
c353 ( 130 0 ) capacitor c=0.0148873f //x=28.235 //y=1.595
c354 ( 128 0 ) capacitor c=0.0157803f //x=28.235 //y=0.94
c355 ( 123 0 ) capacitor c=0.0218028f //x=27.86 //y=1.75
c356 ( 122 0 ) capacitor c=0.0207459f //x=27.86 //y=1.44
c357 ( 121 0 ) capacitor c=0.0194308f //x=27.86 //y=1.095
c358 ( 117 0 ) capacitor c=0.0432517f //x=13.96 //y=1.44
c359 ( 116 0 ) capacitor c=0.0200379f //x=13.96 //y=1.095
c360 ( 113 0 ) capacitor c=0.0148873f //x=13.805 //y=1.595
c361 ( 111 0 ) capacitor c=0.0157803f //x=13.805 //y=0.94
c362 ( 106 0 ) capacitor c=0.0218028f //x=13.43 //y=1.75
c363 ( 105 0 ) capacitor c=0.0207459f //x=13.43 //y=1.44
c364 ( 104 0 ) capacitor c=0.0194308f //x=13.43 //y=1.095
c365 ( 100 0 ) capacitor c=0.0432517f //x=9.15 //y=1.44
c366 ( 99 0 ) capacitor c=0.0200379f //x=9.15 //y=1.095
c367 ( 96 0 ) capacitor c=0.0148873f //x=8.995 //y=1.595
c368 ( 94 0 ) capacitor c=0.0157803f //x=8.995 //y=0.94
c369 ( 89 0 ) capacitor c=0.0218028f //x=8.62 //y=1.75
c370 ( 88 0 ) capacitor c=0.0207459f //x=8.62 //y=1.44
c371 ( 87 0 ) capacitor c=0.0194308f //x=8.62 //y=1.095
c372 ( 83 0 ) capacitor c=0.158794f //x=28.05 //y=6.2
c373 ( 82 0 ) capacitor c=0.110114f //x=27.61 //y=6.2
c374 ( 81 0 ) capacitor c=0.158794f //x=13.62 //y=6.2
c375 ( 80 0 ) capacitor c=0.110114f //x=13.18 //y=6.2
c376 ( 79 0 ) capacitor c=0.158794f //x=8.81 //y=6.2
c377 ( 78 0 ) capacitor c=0.110114f //x=8.37 //y=6.2
c378 ( 74 0 ) capacitor c=0.00106608f //x=18.21 //y=5.335
c379 ( 73 0 ) capacitor c=0.00207162f //x=17.33 //y=5.335
c380 ( 66 0 ) capacitor c=0.0816644f //x=27.87 //y=2.26
c381 ( 64 0 ) capacitor c=0.105458f //x=18.99 //y=3.88
c382 ( 60 0 ) capacitor c=0.00398962f //x=18.59 //y=1.845
c383 ( 59 0 ) capacitor c=0.0137288f //x=18.905 //y=1.845
c384 ( 53 0 ) capacitor c=0.0283082f //x=18.905 //y=5.335
c385 ( 45 0 ) capacitor c=0.0176454f //x=18.125 //y=5.335
c386 ( 38 0 ) capacitor c=0.00332903f //x=16.535 //y=5.335
c387 ( 37 0 ) capacitor c=0.014837f //x=17.245 //y=5.335
c388 ( 24 0 ) capacitor c=0.0810736f //x=13.44 //y=2.26
c389 ( 16 0 ) capacitor c=0.0819749f //x=8.63 //y=2.26
c390 ( 6 0 ) capacitor c=0.0055354f //x=19.105 //y=3.88
c391 ( 5 0 ) capacitor c=0.146292f //x=27.755 //y=3.88
c392 ( 4 0 ) capacitor c=0.00556898f //x=13.555 //y=3.88
c393 ( 3 0 ) capacitor c=0.0758356f //x=18.875 //y=3.88
c394 ( 2 0 ) capacitor c=0.0138772f //x=8.745 //y=3.88
c395 ( 1 0 ) capacitor c=0.067053f //x=13.325 //y=3.88
r396 (  156 157 ) resistor r=52.7279 //w=0.214 //l=0.165 //layer=ply \
 //thickness=0.18 //x=27.87 //y=2.26 //x2=27.87 //y2=2.095
r397 (  146 147 ) resistor r=52.7279 //w=0.214 //l=0.165 //layer=ply \
 //thickness=0.18 //x=13.44 //y=2.26 //x2=13.44 //y2=2.095
r398 (  136 137 ) resistor r=52.7279 //w=0.214 //l=0.165 //layer=ply \
 //thickness=0.18 //x=8.63 //y=2.26 //x2=8.63 //y2=2.095
r399 (  134 164 ) resistor r=45.1352 //w=0.168 //l=0.173853 //layer=ply \
 //thickness=0.18 //x=28.39 //y=1.44 //x2=28.35 //y2=1.595
r400 (  133 163 ) resistor r=45.1352 //w=0.168 //l=0.173853 //layer=ply \
 //thickness=0.18 //x=28.39 //y=1.095 //x2=28.35 //y2=0.94
r401 (  133 134 ) resistor r=176.904 //w=0.094 //l=0.345 //layer=ply \
 //thickness=0.18 //x=28.39 //y=1.095 //x2=28.39 //y2=1.44
r402 (  131 160 ) resistor r=10.701 //w=0.21 //l=0.115 //layer=ply \
 //thickness=0.18 //x=28.015 //y=1.595 //x2=27.9 //y2=1.595
r403 (  130 164 ) resistor r=5.52526 //w=0.168 //l=0.115 //layer=ply \
 //thickness=0.18 //x=28.235 //y=1.595 //x2=28.35 //y2=1.595
r404 (  129 159 ) resistor r=5.52526 //w=0.168 //l=0.115 //layer=ply \
 //thickness=0.18 //x=28.015 //y=0.94 //x2=27.9 //y2=0.94
r405 (  128 163 ) resistor r=5.52526 //w=0.168 //l=0.115 //layer=ply \
 //thickness=0.18 //x=28.235 //y=0.94 //x2=28.35 //y2=0.94
r406 (  128 129 ) resistor r=112.809 //w=0.094 //l=0.22 //layer=ply \
 //thickness=0.18 //x=28.235 //y=0.94 //x2=28.015 //y2=0.94
r407 (  125 162 ) resistor r=37.236 //w=0.233 //l=0.249199 //layer=ply \
 //thickness=0.18 //x=28.05 //y=5.045 //x2=27.87 //y2=4.88
r408 (  123 160 ) resistor r=39.5823 //w=0.21 //l=0.173853 //layer=ply \
 //thickness=0.18 //x=27.86 //y=1.75 //x2=27.9 //y2=1.595
r409 (  123 157 ) resistor r=176.904 //w=0.094 //l=0.345 //layer=ply \
 //thickness=0.18 //x=27.86 //y=1.75 //x2=27.86 //y2=2.095
r410 (  122 160 ) resistor r=39.5823 //w=0.21 //l=0.173853 //layer=ply \
 //thickness=0.18 //x=27.86 //y=1.44 //x2=27.9 //y2=1.595
r411 (  121 159 ) resistor r=45.1352 //w=0.168 //l=0.173853 //layer=ply \
 //thickness=0.18 //x=27.86 //y=1.095 //x2=27.9 //y2=0.94
r412 (  121 122 ) resistor r=176.904 //w=0.094 //l=0.345 //layer=ply \
 //thickness=0.18 //x=27.86 //y=1.095 //x2=27.86 //y2=1.44
r413 (  118 162 ) resistor r=53.7854 //w=0.233 //l=0.332415 //layer=ply \
 //thickness=0.18 //x=27.61 //y=5.045 //x2=27.87 //y2=4.88
r414 (  117 154 ) resistor r=45.1352 //w=0.168 //l=0.173853 //layer=ply \
 //thickness=0.18 //x=13.96 //y=1.44 //x2=13.92 //y2=1.595
r415 (  116 153 ) resistor r=45.1352 //w=0.168 //l=0.173853 //layer=ply \
 //thickness=0.18 //x=13.96 //y=1.095 //x2=13.92 //y2=0.94
r416 (  116 117 ) resistor r=176.904 //w=0.094 //l=0.345 //layer=ply \
 //thickness=0.18 //x=13.96 //y=1.095 //x2=13.96 //y2=1.44
r417 (  114 150 ) resistor r=10.701 //w=0.21 //l=0.115 //layer=ply \
 //thickness=0.18 //x=13.585 //y=1.595 //x2=13.47 //y2=1.595
r418 (  113 154 ) resistor r=5.52526 //w=0.168 //l=0.115 //layer=ply \
 //thickness=0.18 //x=13.805 //y=1.595 //x2=13.92 //y2=1.595
r419 (  112 149 ) resistor r=5.52526 //w=0.168 //l=0.115 //layer=ply \
 //thickness=0.18 //x=13.585 //y=0.94 //x2=13.47 //y2=0.94
r420 (  111 153 ) resistor r=5.52526 //w=0.168 //l=0.115 //layer=ply \
 //thickness=0.18 //x=13.805 //y=0.94 //x2=13.92 //y2=0.94
r421 (  111 112 ) resistor r=112.809 //w=0.094 //l=0.22 //layer=ply \
 //thickness=0.18 //x=13.805 //y=0.94 //x2=13.585 //y2=0.94
r422 (  108 152 ) resistor r=37.236 //w=0.233 //l=0.249199 //layer=ply \
 //thickness=0.18 //x=13.62 //y=5.045 //x2=13.44 //y2=4.88
r423 (  106 150 ) resistor r=39.5823 //w=0.21 //l=0.173853 //layer=ply \
 //thickness=0.18 //x=13.43 //y=1.75 //x2=13.47 //y2=1.595
r424 (  106 147 ) resistor r=176.904 //w=0.094 //l=0.345 //layer=ply \
 //thickness=0.18 //x=13.43 //y=1.75 //x2=13.43 //y2=2.095
r425 (  105 150 ) resistor r=39.5823 //w=0.21 //l=0.173853 //layer=ply \
 //thickness=0.18 //x=13.43 //y=1.44 //x2=13.47 //y2=1.595
r426 (  104 149 ) resistor r=45.1352 //w=0.168 //l=0.173853 //layer=ply \
 //thickness=0.18 //x=13.43 //y=1.095 //x2=13.47 //y2=0.94
r427 (  104 105 ) resistor r=176.904 //w=0.094 //l=0.345 //layer=ply \
 //thickness=0.18 //x=13.43 //y=1.095 //x2=13.43 //y2=1.44
r428 (  101 152 ) resistor r=53.7854 //w=0.233 //l=0.332415 //layer=ply \
 //thickness=0.18 //x=13.18 //y=5.045 //x2=13.44 //y2=4.88
r429 (  100 144 ) resistor r=45.1352 //w=0.168 //l=0.173853 //layer=ply \
 //thickness=0.18 //x=9.15 //y=1.44 //x2=9.11 //y2=1.595
r430 (  99 143 ) resistor r=45.1352 //w=0.168 //l=0.173853 //layer=ply \
 //thickness=0.18 //x=9.15 //y=1.095 //x2=9.11 //y2=0.94
r431 (  99 100 ) resistor r=176.904 //w=0.094 //l=0.345 //layer=ply \
 //thickness=0.18 //x=9.15 //y=1.095 //x2=9.15 //y2=1.44
r432 (  97 140 ) resistor r=10.701 //w=0.21 //l=0.115 //layer=ply \
 //thickness=0.18 //x=8.775 //y=1.595 //x2=8.66 //y2=1.595
r433 (  96 144 ) resistor r=5.52526 //w=0.168 //l=0.115 //layer=ply \
 //thickness=0.18 //x=8.995 //y=1.595 //x2=9.11 //y2=1.595
r434 (  95 139 ) resistor r=5.52526 //w=0.168 //l=0.115 //layer=ply \
 //thickness=0.18 //x=8.775 //y=0.94 //x2=8.66 //y2=0.94
r435 (  94 143 ) resistor r=5.52526 //w=0.168 //l=0.115 //layer=ply \
 //thickness=0.18 //x=8.995 //y=0.94 //x2=9.11 //y2=0.94
r436 (  94 95 ) resistor r=112.809 //w=0.094 //l=0.22 //layer=ply \
 //thickness=0.18 //x=8.995 //y=0.94 //x2=8.775 //y2=0.94
r437 (  91 142 ) resistor r=37.236 //w=0.233 //l=0.249199 //layer=ply \
 //thickness=0.18 //x=8.81 //y=5.045 //x2=8.63 //y2=4.88
r438 (  89 140 ) resistor r=39.5823 //w=0.21 //l=0.173853 //layer=ply \
 //thickness=0.18 //x=8.62 //y=1.75 //x2=8.66 //y2=1.595
r439 (  89 137 ) resistor r=176.904 //w=0.094 //l=0.345 //layer=ply \
 //thickness=0.18 //x=8.62 //y=1.75 //x2=8.62 //y2=2.095
r440 (  88 140 ) resistor r=39.5823 //w=0.21 //l=0.173853 //layer=ply \
 //thickness=0.18 //x=8.62 //y=1.44 //x2=8.66 //y2=1.595
r441 (  87 139 ) resistor r=45.1352 //w=0.168 //l=0.173853 //layer=ply \
 //thickness=0.18 //x=8.62 //y=1.095 //x2=8.66 //y2=0.94
r442 (  87 88 ) resistor r=176.904 //w=0.094 //l=0.345 //layer=ply \
 //thickness=0.18 //x=8.62 //y=1.095 //x2=8.62 //y2=1.44
r443 (  84 142 ) resistor r=53.7854 //w=0.233 //l=0.332415 //layer=ply \
 //thickness=0.18 //x=8.37 //y=5.045 //x2=8.63 //y2=4.88
r444 (  83 125 ) resistor r=592.245 //w=0.094 //l=1.155 //layer=ply \
 //thickness=0.18 //x=28.05 //y=6.2 //x2=28.05 //y2=5.045
r445 (  82 118 ) resistor r=592.245 //w=0.094 //l=1.155 //layer=ply \
 //thickness=0.18 //x=27.61 //y=6.2 //x2=27.61 //y2=5.045
r446 (  81 108 ) resistor r=592.245 //w=0.094 //l=1.155 //layer=ply \
 //thickness=0.18 //x=13.62 //y=6.2 //x2=13.62 //y2=5.045
r447 (  80 101 ) resistor r=592.245 //w=0.094 //l=1.155 //layer=ply \
 //thickness=0.18 //x=13.18 //y=6.2 //x2=13.18 //y2=5.045
r448 (  79 91 ) resistor r=592.245 //w=0.094 //l=1.155 //layer=ply \
 //thickness=0.18 //x=8.81 //y=6.2 //x2=8.81 //y2=5.045
r449 (  78 84 ) resistor r=592.245 //w=0.094 //l=1.155 //layer=ply \
 //thickness=0.18 //x=8.37 //y=6.2 //x2=8.37 //y2=5.045
r450 (  77 130 ) resistor r=56.4043 //w=0.094 //l=0.11 //layer=ply \
 //thickness=0.18 //x=28.125 //y=1.595 //x2=28.235 //y2=1.595
r451 (  77 131 ) resistor r=56.4043 //w=0.094 //l=0.11 //layer=ply \
 //thickness=0.18 //x=28.125 //y=1.595 //x2=28.015 //y2=1.595
r452 (  76 113 ) resistor r=56.4043 //w=0.094 //l=0.11 //layer=ply \
 //thickness=0.18 //x=13.695 //y=1.595 //x2=13.805 //y2=1.595
r453 (  76 114 ) resistor r=56.4043 //w=0.094 //l=0.11 //layer=ply \
 //thickness=0.18 //x=13.695 //y=1.595 //x2=13.585 //y2=1.595
r454 (  75 96 ) resistor r=56.4043 //w=0.094 //l=0.11 //layer=ply \
 //thickness=0.18 //x=8.885 //y=1.595 //x2=8.995 //y2=1.595
r455 (  75 97 ) resistor r=56.4043 //w=0.094 //l=0.11 //layer=ply \
 //thickness=0.18 //x=8.885 //y=1.595 //x2=8.775 //y2=1.595
r456 (  71 162 ) resistor r=152 //w=0.17 //l=0.17 //layer=licon //count=1 \
 //x=27.87 //y=4.88 //x2=27.87 //y2=4.88
r457 (  69 71 ) resistor r=68.4492 //w=0.187 //l=1 //layer=li //thickness=0.1 \
 //x=27.87 //y=3.88 //x2=27.87 //y2=4.88
r458 (  66 156 ) resistor r=152 //w=0.17 //l=0.17 //layer=licon //count=1 \
 //x=27.87 //y=2.26 //x2=27.87 //y2=2.26
r459 (  66 69 ) resistor r=110.888 //w=0.187 //l=1.62 //layer=li \
 //thickness=0.1 //x=27.87 //y=2.26 //x2=27.87 //y2=3.88
r460 (  62 64 ) resistor r=93.7754 //w=0.187 //l=1.37 //layer=li \
 //thickness=0.1 //x=18.99 //y=5.25 //x2=18.99 //y2=3.88
r461 (  61 64 ) resistor r=133.476 //w=0.187 //l=1.95 //layer=li \
 //thickness=0.1 //x=18.99 //y=1.93 //x2=18.99 //y2=3.88
r462 (  59 61 ) resistor r=7.15173 //w=0.17 //l=0.120208 //layer=li \
 //thickness=0.1 //x=18.905 //y=1.845 //x2=18.99 //y2=1.93
r463 (  59 60 ) resistor r=21.5615 //w=0.187 //l=0.315 //layer=li \
 //thickness=0.1 //x=18.905 //y=1.845 //x2=18.59 //y2=1.845
r464 (  55 60 ) resistor r=7.15173 //w=0.17 //l=0.120208 //layer=li \
 //thickness=0.1 //x=18.505 //y=1.76 //x2=18.59 //y2=1.845
r465 (  55 165 ) resistor r=39.016 //w=0.187 //l=0.57 //layer=li \
 //thickness=0.1 //x=18.505 //y=1.76 //x2=18.505 //y2=1.19
r466 (  54 74 ) resistor r=5.4201 //w=0.17 //l=0.085 //layer=li \
 //thickness=0.1 //x=18.295 //y=5.335 //x2=18.21 //y2=5.335
r467 (  53 62 ) resistor r=7.15173 //w=0.17 //l=0.120208 //layer=li \
 //thickness=0.1 //x=18.905 //y=5.335 //x2=18.99 //y2=5.25
r468 (  53 54 ) resistor r=41.754 //w=0.187 //l=0.61 //layer=li \
 //thickness=0.1 //x=18.905 //y=5.335 //x2=18.295 //y2=5.335
r469 (  47 74 ) resistor r=1.40859 //w=0.34 //l=0.085 //layer=li \
 //thickness=0.1 //x=18.21 //y=5.42 //x2=18.21 //y2=5.335
r470 (  47 169 ) resistor r=33.1979 //w=0.187 //l=0.485 //layer=li \
 //thickness=0.1 //x=18.21 //y=5.42 //x2=18.21 //y2=5.905
r471 (  46 73 ) resistor r=5.4201 //w=0.17 //l=0.085 //layer=li \
 //thickness=0.1 //x=17.415 //y=5.335 //x2=17.33 //y2=5.335
r472 (  45 74 ) resistor r=5.4201 //w=0.17 //l=0.085 //layer=li \
 //thickness=0.1 //x=18.125 //y=5.335 //x2=18.21 //y2=5.335
r473 (  45 46 ) resistor r=48.5989 //w=0.187 //l=0.71 //layer=li \
 //thickness=0.1 //x=18.125 //y=5.335 //x2=17.415 //y2=5.335
r474 (  39 73 ) resistor r=1.40859 //w=0.34 //l=0.085 //layer=li \
 //thickness=0.1 //x=17.33 //y=5.42 //x2=17.33 //y2=5.335
r475 (  39 168 ) resistor r=33.1979 //w=0.187 //l=0.485 //layer=li \
 //thickness=0.1 //x=17.33 //y=5.42 //x2=17.33 //y2=5.905
r476 (  37 73 ) resistor r=5.4201 //w=0.17 //l=0.085 //layer=li \
 //thickness=0.1 //x=17.245 //y=5.335 //x2=17.33 //y2=5.335
r477 (  37 38 ) resistor r=48.5989 //w=0.187 //l=0.71 //layer=li \
 //thickness=0.1 //x=17.245 //y=5.335 //x2=16.535 //y2=5.335
r478 (  31 38 ) resistor r=7.15173 //w=0.17 //l=0.120208 //layer=li \
 //thickness=0.1 //x=16.45 //y=5.42 //x2=16.535 //y2=5.335
r479 (  31 167 ) resistor r=33.1979 //w=0.187 //l=0.485 //layer=li \
 //thickness=0.1 //x=16.45 //y=5.42 //x2=16.45 //y2=5.905
r480 (  29 152 ) resistor r=152 //w=0.17 //l=0.17 //layer=licon //count=1 \
 //x=13.44 //y=4.88 //x2=13.44 //y2=4.88
r481 (  27 29 ) resistor r=68.4492 //w=0.187 //l=1 //layer=li //thickness=0.1 \
 //x=13.44 //y=3.88 //x2=13.44 //y2=4.88
r482 (  24 146 ) resistor r=152 //w=0.17 //l=0.17 //layer=licon //count=1 \
 //x=13.44 //y=2.26 //x2=13.44 //y2=2.26
r483 (  24 27 ) resistor r=110.888 //w=0.187 //l=1.62 //layer=li \
 //thickness=0.1 //x=13.44 //y=2.26 //x2=13.44 //y2=3.88
r484 (  21 142 ) resistor r=152 //w=0.17 //l=0.17 //layer=licon //count=1 \
 //x=8.63 //y=4.88 //x2=8.63 //y2=4.88
r485 (  19 21 ) resistor r=68.4492 //w=0.187 //l=1 //layer=li //thickness=0.1 \
 //x=8.63 //y=3.88 //x2=8.63 //y2=4.88
r486 (  16 136 ) resistor r=152 //w=0.17 //l=0.17 //layer=licon //count=1 \
 //x=8.63 //y=2.26 //x2=8.63 //y2=2.26
r487 (  16 19 ) resistor r=110.888 //w=0.187 //l=1.62 //layer=li \
 //thickness=0.1 //x=8.63 //y=2.26 //x2=8.63 //y2=3.88
r488 (  14 69 ) resistor r=9.3 //w=0.17 //l=0.17 //layer=mcon //count=1 \
 //x=27.87 //y=3.88 //x2=27.87 //y2=3.88
r489 (  12 64 ) resistor r=9.3 //w=0.17 //l=0.17 //layer=mcon //count=1 \
 //x=18.99 //y=3.88 //x2=18.99 //y2=3.88
r490 (  10 27 ) resistor r=9.3 //w=0.17 //l=0.17 //layer=mcon //count=1 \
 //x=13.44 //y=3.88 //x2=13.44 //y2=3.88
r491 (  8 19 ) resistor r=9.3 //w=0.17 //l=0.17 //layer=mcon //count=1 \
 //x=8.63 //y=3.88 //x2=8.63 //y2=3.88
r492 (  6 12 ) resistor r=0.0880901 //w=0.191 //l=0.115 //layer=m1 \
 //thickness=0.36 //x=19.105 //y=3.88 //x2=18.99 //y2=3.88
r493 (  5 14 ) resistor r=0.0717383 //w=0.224 //l=0.115 //layer=m1 \
 //thickness=0.36 //x=27.755 //y=3.88 //x2=27.87 //y2=3.88
r494 (  5 6 ) resistor r=8.25382 //w=0.131 //l=8.65 //layer=m1 \
 //thickness=0.36 //x=27.755 //y=3.88 //x2=19.105 //y2=3.88
r495 (  4 10 ) resistor r=0.0880901 //w=0.191 //l=0.115 //layer=m1 \
 //thickness=0.36 //x=13.555 //y=3.88 //x2=13.44 //y2=3.88
r496 (  3 12 ) resistor r=0.0880901 //w=0.191 //l=0.115 //layer=m1 \
 //thickness=0.36 //x=18.875 //y=3.88 //x2=18.99 //y2=3.88
r497 (  3 4 ) resistor r=5.07634 //w=0.131 //l=5.32 //layer=m1 \
 //thickness=0.36 //x=18.875 //y=3.88 //x2=13.555 //y2=3.88
r498 (  2 8 ) resistor r=0.0717383 //w=0.224 //l=0.115 //layer=m1 \
 //thickness=0.36 //x=8.745 //y=3.88 //x2=8.63 //y2=3.88
r499 (  1 10 ) resistor r=0.0880901 //w=0.191 //l=0.115 //layer=m1 \
 //thickness=0.36 //x=13.325 //y=3.88 //x2=13.44 //y2=3.88
r500 (  1 2 ) resistor r=4.37023 //w=0.131 //l=4.58 //layer=m1 \
 //thickness=0.36 //x=13.325 //y=3.88 //x2=8.745 //y2=3.88
ends PM_TMRDFFSNRNQX1\%noxref_7

subckt PM_TMRDFFSNRNQX1\%noxref_8 ( 1 2 3 4 6 7 8 9 10 22 35 36 43 51 57 58 62 \
 66 74 81 82 83 84 85 86 87 88 89 90 91 95 96 97 102 104 107 108 109 110 111 \
 112 116 118 121 122 123 124 128 129 130 131 135 137 143 144 146 147 152 156 \
 169 172 174 175 176 )
c629 ( 176 0 ) capacitor c=0.023087f //x=27.685 //y=5.2
c630 ( 175 0 ) capacitor c=0.023519f //x=26.805 //y=5.2
c631 ( 174 0 ) capacitor c=0.0224735f //x=25.925 //y=5.2
c632 ( 172 0 ) capacitor c=0.00853354f //x=27.935 //y=1.095
c633 ( 169 0 ) capacitor c=0.0655948f //x=91.51 //y=4.885
c634 ( 156 0 ) capacitor c=0.054113f //x=87.81 //y=2.26
c635 ( 152 0 ) capacitor c=0.0587755f //x=23.06 //y=4.88
c636 ( 147 0 ) capacitor c=0.0273931f //x=23.06 //y=2.095
c637 ( 146 0 ) capacitor c=0.0456313f //x=23.06 //y=2.26
c638 ( 144 0 ) capacitor c=0.0342409f //x=91.845 //y=1.39
c639 ( 143 0 ) capacitor c=0.0187384f //x=91.845 //y=1.045
c640 ( 137 0 ) capacitor c=0.0141797f //x=91.69 //y=1.545
c641 ( 135 0 ) capacitor c=0.0149844f //x=91.69 //y=0.89
c642 ( 131 0 ) capacitor c=0.0954119f //x=91.315 //y=2.095
c643 ( 130 0 ) capacitor c=0.022465f //x=91.315 //y=1.7
c644 ( 129 0 ) capacitor c=0.0234376f //x=91.315 //y=1.39
c645 ( 128 0 ) capacitor c=0.0199343f //x=91.315 //y=1.045
c646 ( 124 0 ) capacitor c=0.0318948f //x=88.515 //y=1.39
c647 ( 123 0 ) capacitor c=0.0187384f //x=88.515 //y=1.045
c648 ( 122 0 ) capacitor c=0.0605713f //x=88.155 //y=4.975
c649 ( 121 0 ) capacitor c=0.0292043f //x=88.445 //y=4.975
c650 ( 118 0 ) capacitor c=0.0157913f //x=88.36 //y=1.545
c651 ( 116 0 ) capacitor c=0.0149844f //x=88.36 //y=0.89
c652 ( 112 0 ) capacitor c=0.0302441f //x=87.985 //y=2.095
c653 ( 111 0 ) capacitor c=0.0237559f //x=87.985 //y=1.7
c654 ( 110 0 ) capacitor c=0.0234352f //x=87.985 //y=1.39
c655 ( 109 0 ) capacitor c=0.0199931f //x=87.985 //y=1.045
c656 ( 108 0 ) capacitor c=0.0432517f //x=23.58 //y=1.44
c657 ( 107 0 ) capacitor c=0.0200379f //x=23.58 //y=1.095
c658 ( 104 0 ) capacitor c=0.0148873f //x=23.425 //y=1.595
c659 ( 102 0 ) capacitor c=0.0157803f //x=23.425 //y=0.94
c660 ( 97 0 ) capacitor c=0.0218028f //x=23.05 //y=1.75
c661 ( 96 0 ) capacitor c=0.0207459f //x=23.05 //y=1.44
c662 ( 95 0 ) capacitor c=0.0194308f //x=23.05 //y=1.095
c663 ( 91 0 ) capacitor c=0.110336f //x=91.84 //y=6.205
c664 ( 90 0 ) capacitor c=0.154049f //x=91.4 //y=6.205
c665 ( 89 0 ) capacitor c=0.110003f //x=88.52 //y=6.205
c666 ( 88 0 ) capacitor c=0.15424f //x=88.08 //y=6.205
c667 ( 87 0 ) capacitor c=0.158794f //x=23.24 //y=6.2
c668 ( 86 0 ) capacitor c=0.110114f //x=22.8 //y=6.2
c669 ( 82 0 ) capacitor c=0.00106608f //x=27.83 //y=5.335
c670 ( 81 0 ) capacitor c=0.00207319f //x=26.95 //y=5.335
c671 ( 74 0 ) capacitor c=0.119551f //x=91.51 //y=2.26
c672 ( 66 0 ) capacitor c=0.0994818f //x=87.81 //y=2.26
c673 ( 62 0 ) capacitor c=0.106944f //x=28.61 //y=3.51
c674 ( 58 0 ) capacitor c=0.00398962f //x=28.21 //y=1.845
c675 ( 57 0 ) capacitor c=0.0137288f //x=28.525 //y=1.845
c676 ( 51 0 ) capacitor c=0.0282124f //x=28.525 //y=5.335
c677 ( 43 0 ) capacitor c=0.0176454f //x=27.745 //y=5.335
c678 ( 36 0 ) capacitor c=0.00332903f //x=26.155 //y=5.335
c679 ( 35 0 ) capacitor c=0.0148427f //x=26.865 //y=5.335
c680 ( 22 0 ) capacitor c=0.0820026f //x=23.06 //y=2.26
c681 ( 10 0 ) capacitor c=0.00638553f //x=87.925 //y=4.62
c682 ( 9 0 ) capacitor c=0.0799095f //x=91.395 //y=4.62
c683 ( 8 0 ) capacitor c=0.00309768f //x=75.685 //y=4.62
c684 ( 7 0 ) capacitor c=0.267484f //x=87.695 //y=4.62
c685 ( 6 0 ) capacitor c=0.00718365f //x=75.6 //y=4.905
c686 ( 4 0 ) capacitor c=0.0158574f //x=28.725 //y=4.99
c687 ( 3 0 ) capacitor c=0.852749f //x=75.515 //y=4.99
c688 ( 2 0 ) capacitor c=0.00906635f //x=23.175 //y=3.51
c689 ( 1 0 ) capacitor c=0.0889942f //x=28.495 //y=3.51
r690 (  167 169 ) resistor r=22.7554 //w=0.233 //l=0.11 //layer=ply \
 //thickness=0.18 //x=91.4 //y=4.885 //x2=91.51 //y2=4.885
r691 (  146 147 ) resistor r=52.7279 //w=0.214 //l=0.165 //layer=ply \
 //thickness=0.18 //x=23.06 //y=2.26 //x2=23.06 //y2=2.095
r692 (  144 171 ) resistor r=45.1352 //w=0.168 //l=0.173853 //layer=ply \
 //thickness=0.18 //x=91.845 //y=1.39 //x2=91.805 //y2=1.545
r693 (  143 170 ) resistor r=45.1352 //w=0.168 //l=0.173853 //layer=ply \
 //thickness=0.18 //x=91.845 //y=1.045 //x2=91.805 //y2=0.89
r694 (  143 144 ) resistor r=176.904 //w=0.094 //l=0.345 //layer=ply \
 //thickness=0.18 //x=91.845 //y=1.045 //x2=91.845 //y2=1.39
r695 (  140 169 ) resistor r=68.2661 //w=0.233 //l=0.404166 //layer=ply \
 //thickness=0.18 //x=91.84 //y=5.05 //x2=91.51 //y2=4.885
r696 (  138 166 ) resistor r=10.701 //w=0.21 //l=0.115 //layer=ply \
 //thickness=0.18 //x=91.47 //y=1.545 //x2=91.355 //y2=1.545
r697 (  137 171 ) resistor r=5.52526 //w=0.168 //l=0.115 //layer=ply \
 //thickness=0.18 //x=91.69 //y=1.545 //x2=91.805 //y2=1.545
r698 (  136 165 ) resistor r=5.52526 //w=0.168 //l=0.115 //layer=ply \
 //thickness=0.18 //x=91.47 //y=0.89 //x2=91.355 //y2=0.89
r699 (  135 170 ) resistor r=5.52526 //w=0.168 //l=0.115 //layer=ply \
 //thickness=0.18 //x=91.69 //y=0.89 //x2=91.805 //y2=0.89
r700 (  135 136 ) resistor r=112.809 //w=0.094 //l=0.22 //layer=ply \
 //thickness=0.18 //x=91.69 //y=0.89 //x2=91.47 //y2=0.89
r701 (  132 167 ) resistor r=13.0941 //w=0.233 //l=0.165 //layer=ply \
 //thickness=0.18 //x=91.4 //y=5.05 //x2=91.4 //y2=4.885
r702 (  131 164 ) resistor r=34.8111 //w=0.27 //l=0.264953 //layer=ply \
 //thickness=0.18 //x=91.315 //y=2.095 //x2=91.51 //y2=2.26
r703 (  130 166 ) resistor r=39.5823 //w=0.21 //l=0.173853 //layer=ply \
 //thickness=0.18 //x=91.315 //y=1.7 //x2=91.355 //y2=1.545
r704 (  130 131 ) resistor r=202.543 //w=0.094 //l=0.395 //layer=ply \
 //thickness=0.18 //x=91.315 //y=1.7 //x2=91.315 //y2=2.095
r705 (  129 166 ) resistor r=39.5823 //w=0.21 //l=0.173853 //layer=ply \
 //thickness=0.18 //x=91.315 //y=1.39 //x2=91.355 //y2=1.545
r706 (  128 165 ) resistor r=45.1352 //w=0.168 //l=0.173853 //layer=ply \
 //thickness=0.18 //x=91.315 //y=1.045 //x2=91.355 //y2=0.89
r707 (  128 129 ) resistor r=176.904 //w=0.094 //l=0.345 //layer=ply \
 //thickness=0.18 //x=91.315 //y=1.045 //x2=91.315 //y2=1.39
r708 (  124 162 ) resistor r=45.1352 //w=0.168 //l=0.173853 //layer=ply \
 //thickness=0.18 //x=88.515 //y=1.39 //x2=88.475 //y2=1.545
r709 (  123 161 ) resistor r=45.1352 //w=0.168 //l=0.173853 //layer=ply \
 //thickness=0.18 //x=88.515 //y=1.045 //x2=88.475 //y2=0.89
r710 (  123 124 ) resistor r=176.904 //w=0.094 //l=0.345 //layer=ply \
 //thickness=0.18 //x=88.515 //y=1.045 //x2=88.515 //y2=1.39
r711 (  121 125 ) resistor r=26.9307 //w=0.15 //l=0.106066 //layer=ply \
 //thickness=0.18 //x=88.445 //y=4.975 //x2=88.52 //y2=5.05
r712 (  121 122 ) resistor r=148.702 //w=0.094 //l=0.29 //layer=ply \
 //thickness=0.18 //x=88.445 //y=4.975 //x2=88.155 //y2=4.975
r713 (  119 160 ) resistor r=10.701 //w=0.21 //l=0.115 //layer=ply \
 //thickness=0.18 //x=88.14 //y=1.545 //x2=88.025 //y2=1.545
r714 (  118 162 ) resistor r=5.52526 //w=0.168 //l=0.115 //layer=ply \
 //thickness=0.18 //x=88.36 //y=1.545 //x2=88.475 //y2=1.545
r715 (  117 159 ) resistor r=5.52526 //w=0.168 //l=0.115 //layer=ply \
 //thickness=0.18 //x=88.14 //y=0.89 //x2=88.025 //y2=0.89
r716 (  116 161 ) resistor r=5.52526 //w=0.168 //l=0.115 //layer=ply \
 //thickness=0.18 //x=88.36 //y=0.89 //x2=88.475 //y2=0.89
r717 (  116 117 ) resistor r=112.809 //w=0.094 //l=0.22 //layer=ply \
 //thickness=0.18 //x=88.36 //y=0.89 //x2=88.14 //y2=0.89
r718 (  113 122 ) resistor r=22.1787 //w=0.252 //l=0.106066 //layer=ply \
 //thickness=0.18 //x=88.08 //y=5.05 //x2=88.155 //y2=4.975
r719 (  113 158 ) resistor r=51.6429 //w=0.252 //l=0.34271 //layer=ply \
 //thickness=0.18 //x=88.08 //y=5.05 //x2=87.81 //y2=4.885
r720 (  112 156 ) resistor r=30.4513 //w=0.277 //l=0.243926 //layer=ply \
 //thickness=0.18 //x=87.985 //y=2.095 //x2=87.81 //y2=2.26
r721 (  111 160 ) resistor r=39.5823 //w=0.21 //l=0.173853 //layer=ply \
 //thickness=0.18 //x=87.985 //y=1.7 //x2=88.025 //y2=1.545
r722 (  111 112 ) resistor r=202.543 //w=0.094 //l=0.395 //layer=ply \
 //thickness=0.18 //x=87.985 //y=1.7 //x2=87.985 //y2=2.095
r723 (  110 160 ) resistor r=39.5823 //w=0.21 //l=0.173853 //layer=ply \
 //thickness=0.18 //x=87.985 //y=1.39 //x2=88.025 //y2=1.545
r724 (  109 159 ) resistor r=45.1352 //w=0.168 //l=0.173853 //layer=ply \
 //thickness=0.18 //x=87.985 //y=1.045 //x2=88.025 //y2=0.89
r725 (  109 110 ) resistor r=176.904 //w=0.094 //l=0.345 //layer=ply \
 //thickness=0.18 //x=87.985 //y=1.045 //x2=87.985 //y2=1.39
r726 (  108 154 ) resistor r=45.1352 //w=0.168 //l=0.173853 //layer=ply \
 //thickness=0.18 //x=23.58 //y=1.44 //x2=23.54 //y2=1.595
r727 (  107 153 ) resistor r=45.1352 //w=0.168 //l=0.173853 //layer=ply \
 //thickness=0.18 //x=23.58 //y=1.095 //x2=23.54 //y2=0.94
r728 (  107 108 ) resistor r=176.904 //w=0.094 //l=0.345 //layer=ply \
 //thickness=0.18 //x=23.58 //y=1.095 //x2=23.58 //y2=1.44
r729 (  105 150 ) resistor r=10.701 //w=0.21 //l=0.115 //layer=ply \
 //thickness=0.18 //x=23.205 //y=1.595 //x2=23.09 //y2=1.595
r730 (  104 154 ) resistor r=5.52526 //w=0.168 //l=0.115 //layer=ply \
 //thickness=0.18 //x=23.425 //y=1.595 //x2=23.54 //y2=1.595
r731 (  103 149 ) resistor r=5.52526 //w=0.168 //l=0.115 //layer=ply \
 //thickness=0.18 //x=23.205 //y=0.94 //x2=23.09 //y2=0.94
r732 (  102 153 ) resistor r=5.52526 //w=0.168 //l=0.115 //layer=ply \
 //thickness=0.18 //x=23.425 //y=0.94 //x2=23.54 //y2=0.94
r733 (  102 103 ) resistor r=112.809 //w=0.094 //l=0.22 //layer=ply \
 //thickness=0.18 //x=23.425 //y=0.94 //x2=23.205 //y2=0.94
r734 (  99 152 ) resistor r=37.236 //w=0.233 //l=0.249199 //layer=ply \
 //thickness=0.18 //x=23.24 //y=5.045 //x2=23.06 //y2=4.88
r735 (  97 150 ) resistor r=39.5823 //w=0.21 //l=0.173853 //layer=ply \
 //thickness=0.18 //x=23.05 //y=1.75 //x2=23.09 //y2=1.595
r736 (  97 147 ) resistor r=176.904 //w=0.094 //l=0.345 //layer=ply \
 //thickness=0.18 //x=23.05 //y=1.75 //x2=23.05 //y2=2.095
r737 (  96 150 ) resistor r=39.5823 //w=0.21 //l=0.173853 //layer=ply \
 //thickness=0.18 //x=23.05 //y=1.44 //x2=23.09 //y2=1.595
r738 (  95 149 ) resistor r=45.1352 //w=0.168 //l=0.173853 //layer=ply \
 //thickness=0.18 //x=23.05 //y=1.095 //x2=23.09 //y2=0.94
r739 (  95 96 ) resistor r=176.904 //w=0.094 //l=0.345 //layer=ply \
 //thickness=0.18 //x=23.05 //y=1.095 //x2=23.05 //y2=1.44
r740 (  92 152 ) resistor r=53.7854 //w=0.233 //l=0.332415 //layer=ply \
 //thickness=0.18 //x=22.8 //y=5.045 //x2=23.06 //y2=4.88
r741 (  91 140 ) resistor r=592.245 //w=0.094 //l=1.155 //layer=ply \
 //thickness=0.18 //x=91.84 //y=6.205 //x2=91.84 //y2=5.05
r742 (  90 132 ) resistor r=592.245 //w=0.094 //l=1.155 //layer=ply \
 //thickness=0.18 //x=91.4 //y=6.205 //x2=91.4 //y2=5.05
r743 (  89 125 ) resistor r=592.245 //w=0.094 //l=1.155 //layer=ply \
 //thickness=0.18 //x=88.52 //y=6.205 //x2=88.52 //y2=5.05
r744 (  88 113 ) resistor r=592.245 //w=0.094 //l=1.155 //layer=ply \
 //thickness=0.18 //x=88.08 //y=6.205 //x2=88.08 //y2=5.05
r745 (  87 99 ) resistor r=592.245 //w=0.094 //l=1.155 //layer=ply \
 //thickness=0.18 //x=23.24 //y=6.2 //x2=23.24 //y2=5.045
r746 (  86 92 ) resistor r=592.245 //w=0.094 //l=1.155 //layer=ply \
 //thickness=0.18 //x=22.8 //y=6.2 //x2=22.8 //y2=5.045
r747 (  85 137 ) resistor r=56.4043 //w=0.094 //l=0.11 //layer=ply \
 //thickness=0.18 //x=91.58 //y=1.545 //x2=91.69 //y2=1.545
r748 (  85 138 ) resistor r=56.4043 //w=0.094 //l=0.11 //layer=ply \
 //thickness=0.18 //x=91.58 //y=1.545 //x2=91.47 //y2=1.545
r749 (  84 118 ) resistor r=56.4043 //w=0.094 //l=0.11 //layer=ply \
 //thickness=0.18 //x=88.25 //y=1.545 //x2=88.36 //y2=1.545
r750 (  84 119 ) resistor r=56.4043 //w=0.094 //l=0.11 //layer=ply \
 //thickness=0.18 //x=88.25 //y=1.545 //x2=88.14 //y2=1.545
r751 (  83 104 ) resistor r=56.4043 //w=0.094 //l=0.11 //layer=ply \
 //thickness=0.18 //x=23.315 //y=1.595 //x2=23.425 //y2=1.595
r752 (  83 105 ) resistor r=56.4043 //w=0.094 //l=0.11 //layer=ply \
 //thickness=0.18 //x=23.315 //y=1.595 //x2=23.205 //y2=1.595
r753 (  79 169 ) resistor r=152 //w=0.17 //l=0.17 //layer=licon //count=1 \
 //x=91.51 //y=4.885 //x2=91.51 //y2=4.885
r754 (  77 79 ) resistor r=18.139 //w=0.187 //l=0.265 //layer=li \
 //thickness=0.1 //x=91.51 //y=4.62 //x2=91.51 //y2=4.885
r755 (  74 164 ) resistor r=152 //w=0.17 //l=0.17 //layer=licon //count=1 \
 //x=91.51 //y=2.26 //x2=91.51 //y2=2.26
r756 (  74 77 ) resistor r=161.54 //w=0.187 //l=2.36 //layer=li \
 //thickness=0.1 //x=91.51 //y=2.26 //x2=91.51 //y2=4.62
r757 (  71 158 ) resistor r=152 //w=0.17 //l=0.17 //layer=licon //count=1 \
 //x=87.81 //y=4.885 //x2=87.81 //y2=4.885
r758 (  69 71 ) resistor r=18.139 //w=0.187 //l=0.265 //layer=li \
 //thickness=0.1 //x=87.81 //y=4.62 //x2=87.81 //y2=4.885
r759 (  66 156 ) resistor r=152 //w=0.17 //l=0.17 //layer=licon //count=1 \
 //x=87.81 //y=2.26 //x2=87.81 //y2=2.26
r760 (  66 69 ) resistor r=161.54 //w=0.187 //l=2.36 //layer=li \
 //thickness=0.1 //x=87.81 //y=2.26 //x2=87.81 //y2=4.62
r761 (  62 64 ) resistor r=101.305 //w=0.187 //l=1.48 //layer=li \
 //thickness=0.1 //x=28.61 //y=3.51 //x2=28.61 //y2=4.99
r762 (  60 64 ) resistor r=17.7968 //w=0.187 //l=0.26 //layer=li \
 //thickness=0.1 //x=28.61 //y=5.25 //x2=28.61 //y2=4.99
r763 (  59 62 ) resistor r=108.15 //w=0.187 //l=1.58 //layer=li \
 //thickness=0.1 //x=28.61 //y=1.93 //x2=28.61 //y2=3.51
r764 (  57 59 ) resistor r=7.15173 //w=0.17 //l=0.120208 //layer=li \
 //thickness=0.1 //x=28.525 //y=1.845 //x2=28.61 //y2=1.93
r765 (  57 58 ) resistor r=21.5615 //w=0.187 //l=0.315 //layer=li \
 //thickness=0.1 //x=28.525 //y=1.845 //x2=28.21 //y2=1.845
r766 (  53 58 ) resistor r=7.15173 //w=0.17 //l=0.120208 //layer=li \
 //thickness=0.1 //x=28.125 //y=1.76 //x2=28.21 //y2=1.845
r767 (  53 172 ) resistor r=39.016 //w=0.187 //l=0.57 //layer=li \
 //thickness=0.1 //x=28.125 //y=1.76 //x2=28.125 //y2=1.19
r768 (  52 82 ) resistor r=5.4201 //w=0.17 //l=0.085 //layer=li \
 //thickness=0.1 //x=27.915 //y=5.335 //x2=27.83 //y2=5.335
r769 (  51 60 ) resistor r=7.15173 //w=0.17 //l=0.120208 //layer=li \
 //thickness=0.1 //x=28.525 //y=5.335 //x2=28.61 //y2=5.25
r770 (  51 52 ) resistor r=41.754 //w=0.187 //l=0.61 //layer=li \
 //thickness=0.1 //x=28.525 //y=5.335 //x2=27.915 //y2=5.335
r771 (  45 82 ) resistor r=1.40859 //w=0.34 //l=0.085 //layer=li \
 //thickness=0.1 //x=27.83 //y=5.42 //x2=27.83 //y2=5.335
r772 (  45 176 ) resistor r=33.1979 //w=0.187 //l=0.485 //layer=li \
 //thickness=0.1 //x=27.83 //y=5.42 //x2=27.83 //y2=5.905
r773 (  44 81 ) resistor r=5.4201 //w=0.17 //l=0.085 //layer=li \
 //thickness=0.1 //x=27.035 //y=5.335 //x2=26.95 //y2=5.335
r774 (  43 82 ) resistor r=5.4201 //w=0.17 //l=0.085 //layer=li \
 //thickness=0.1 //x=27.745 //y=5.335 //x2=27.83 //y2=5.335
r775 (  43 44 ) resistor r=48.5989 //w=0.187 //l=0.71 //layer=li \
 //thickness=0.1 //x=27.745 //y=5.335 //x2=27.035 //y2=5.335
r776 (  37 81 ) resistor r=1.40859 //w=0.34 //l=0.085 //layer=li \
 //thickness=0.1 //x=26.95 //y=5.42 //x2=26.95 //y2=5.335
r777 (  37 175 ) resistor r=33.1979 //w=0.187 //l=0.485 //layer=li \
 //thickness=0.1 //x=26.95 //y=5.42 //x2=26.95 //y2=5.905
r778 (  35 81 ) resistor r=5.4201 //w=0.17 //l=0.085 //layer=li \
 //thickness=0.1 //x=26.865 //y=5.335 //x2=26.95 //y2=5.335
r779 (  35 36 ) resistor r=48.5989 //w=0.187 //l=0.71 //layer=li \
 //thickness=0.1 //x=26.865 //y=5.335 //x2=26.155 //y2=5.335
r780 (  29 36 ) resistor r=7.15173 //w=0.17 //l=0.120208 //layer=li \
 //thickness=0.1 //x=26.07 //y=5.42 //x2=26.155 //y2=5.335
r781 (  29 174 ) resistor r=33.1979 //w=0.187 //l=0.485 //layer=li \
 //thickness=0.1 //x=26.07 //y=5.42 //x2=26.07 //y2=5.905
r782 (  27 152 ) resistor r=152 //w=0.17 //l=0.17 //layer=licon //count=1 \
 //x=23.06 //y=4.88 //x2=23.06 //y2=4.88
r783 (  25 27 ) resistor r=93.7754 //w=0.187 //l=1.37 //layer=li \
 //thickness=0.1 //x=23.06 //y=3.51 //x2=23.06 //y2=4.88
r784 (  22 146 ) resistor r=152 //w=0.17 //l=0.17 //layer=licon //count=1 \
 //x=23.06 //y=2.26 //x2=23.06 //y2=2.26
r785 (  22 25 ) resistor r=85.5615 //w=0.187 //l=1.25 //layer=li \
 //thickness=0.1 //x=23.06 //y=2.26 //x2=23.06 //y2=3.51
r786 (  20 77 ) resistor r=9.3 //w=0.17 //l=0.17 //layer=mcon //count=1 \
 //x=91.51 //y=4.62 //x2=91.51 //y2=4.62
r787 (  18 69 ) resistor r=9.3 //w=0.17 //l=0.17 //layer=mcon //count=1 \
 //x=87.81 //y=4.62 //x2=87.81 //y2=4.62
r788 (  16 62 ) resistor r=9.3 //w=0.17 //l=0.17 //layer=mcon //count=1 \
 //x=28.61 //y=3.51 //x2=28.61 //y2=3.51
r789 (  14 64 ) resistor r=9.3 //w=0.17 //l=0.17 //layer=mcon //count=1 \
 //x=28.61 //y=4.99 //x2=28.61 //y2=4.99
r790 (  12 25 ) resistor r=9.3 //w=0.17 //l=0.17 //layer=mcon //count=1 \
 //x=23.06 //y=3.51 //x2=23.06 //y2=3.51
r791 (  10 18 ) resistor r=0.0880901 //w=0.191 //l=0.115 //layer=m1 \
 //thickness=0.36 //x=87.925 //y=4.62 //x2=87.81 //y2=4.62
r792 (  9 20 ) resistor r=0.0717383 //w=0.224 //l=0.115 //layer=m1 \
 //thickness=0.36 //x=91.395 //y=4.62 //x2=91.51 //y2=4.62
r793 (  9 10 ) resistor r=3.31107 //w=0.131 //l=3.47 //layer=m1 \
 //thickness=0.36 //x=91.395 //y=4.62 //x2=87.925 //y2=4.62
r794 (  7 18 ) resistor r=0.0880901 //w=0.191 //l=0.115 //layer=m1 \
 //thickness=0.36 //x=87.695 //y=4.62 //x2=87.81 //y2=4.62
r795 (  7 8 ) resistor r=11.4599 //w=0.131 //l=12.01 //layer=m1 \
 //thickness=0.36 //x=87.695 //y=4.62 //x2=75.685 //y2=4.62
r796 (  5 8 ) resistor r=0.0718295 //w=0.17 //l=0.120208 //layer=m1 \
 //thickness=0.36 //x=75.6 //y=4.705 //x2=75.685 //y2=4.62
r797 (  5 6 ) resistor r=0.19084 //w=0.131 //l=0.2 //layer=m1 //thickness=0.36 \
 //x=75.6 //y=4.705 //x2=75.6 //y2=4.905
r798 (  4 14 ) resistor r=0.0717383 //w=0.224 //l=0.115 //layer=m1 \
 //thickness=0.36 //x=28.725 //y=4.99 //x2=28.61 //y2=4.99
r799 (  3 6 ) resistor r=0.0698411 //w=0.17 //l=0.120208 //layer=m1 \
 //thickness=0.36 //x=75.515 //y=4.99 //x2=75.6 //y2=4.905
r800 (  3 4 ) resistor r=44.6469 //w=0.131 //l=46.79 //layer=m1 \
 //thickness=0.36 //x=75.515 //y=4.99 //x2=28.725 //y2=4.99
r801 (  2 12 ) resistor r=0.0717383 //w=0.224 //l=0.115 //layer=m1 \
 //thickness=0.36 //x=23.175 //y=3.51 //x2=23.06 //y2=3.51
r802 (  1 16 ) resistor r=0.0717383 //w=0.224 //l=0.115 //layer=m1 \
 //thickness=0.36 //x=28.495 //y=3.51 //x2=28.61 //y2=3.51
r803 (  1 2 ) resistor r=5.07634 //w=0.131 //l=5.32 //layer=m1 \
 //thickness=0.36 //x=28.495 //y=3.51 //x2=23.175 //y2=3.51
ends PM_TMRDFFSNRNQX1\%noxref_8

subckt PM_TMRDFFSNRNQX1\%noxref_9 ( 1 2 3 4 17 18 25 33 39 40 44 46 54 61 62 \
 63 64 65 66 67 68 69 70 71 72 73 75 81 82 83 84 88 89 90 91 92 94 100 101 102 \
 103 123 125 126 127 )
c253 ( 127 0 ) capacitor c=0.023087f //x=32.495 //y=5.2
c254 ( 126 0 ) capacitor c=0.023519f //x=31.615 //y=5.2
c255 ( 125 0 ) capacitor c=0.0224735f //x=30.735 //y=5.2
c256 ( 123 0 ) capacitor c=0.00853354f //x=32.745 //y=1.095
c257 ( 103 0 ) capacitor c=0.0547611f //x=40.355 //y=4.97
c258 ( 102 0 ) capacitor c=0.0294456f //x=40.645 //y=4.97
c259 ( 101 0 ) capacitor c=0.0347816f //x=40.31 //y=1.4
c260 ( 100 0 ) capacitor c=0.0187487f //x=40.31 //y=1.055
c261 ( 94 0 ) capacitor c=0.0137055f //x=40.155 //y=1.555
c262 ( 92 0 ) capacitor c=0.0149861f //x=40.155 //y=0.9
c263 ( 91 0 ) capacitor c=0.096037f //x=39.78 //y=2.095
c264 ( 90 0 ) capacitor c=0.0228993f //x=39.78 //y=1.71
c265 ( 89 0 ) capacitor c=0.0234352f //x=39.78 //y=1.4
c266 ( 88 0 ) capacitor c=0.0198724f //x=39.78 //y=1.055
c267 ( 84 0 ) capacitor c=0.0549166f //x=35.545 //y=4.97
c268 ( 83 0 ) capacitor c=0.0294456f //x=35.835 //y=4.97
c269 ( 82 0 ) capacitor c=0.0347816f //x=35.5 //y=1.4
c270 ( 81 0 ) capacitor c=0.0187487f //x=35.5 //y=1.055
c271 ( 75 0 ) capacitor c=0.0137055f //x=35.345 //y=1.555
c272 ( 73 0 ) capacitor c=0.0149861f //x=35.345 //y=0.9
c273 ( 72 0 ) capacitor c=0.096037f //x=34.97 //y=2.095
c274 ( 71 0 ) capacitor c=0.0228993f //x=34.97 //y=1.71
c275 ( 70 0 ) capacitor c=0.0234352f //x=34.97 //y=1.4
c276 ( 69 0 ) capacitor c=0.0198724f //x=34.97 //y=1.055
c277 ( 68 0 ) capacitor c=0.109949f //x=40.72 //y=6.2
c278 ( 67 0 ) capacitor c=0.158483f //x=40.28 //y=6.2
c279 ( 66 0 ) capacitor c=0.109949f //x=35.91 //y=6.2
c280 ( 65 0 ) capacitor c=0.158483f //x=35.47 //y=6.2
c281 ( 62 0 ) capacitor c=9.74268e-19 //x=32.64 //y=5.335
c282 ( 61 0 ) capacitor c=0.00191414f //x=31.76 //y=5.335
c283 ( 54 0 ) capacitor c=0.0914984f //x=40.08 //y=2.26
c284 ( 46 0 ) capacitor c=0.0942434f //x=35.27 //y=2.26
c285 ( 44 0 ) capacitor c=0.106133f //x=33.42 //y=2.77
c286 ( 40 0 ) capacitor c=0.00398962f //x=33.02 //y=1.845
c287 ( 39 0 ) capacitor c=0.0137288f //x=33.335 //y=1.845
c288 ( 33 0 ) capacitor c=0.0276208f //x=33.335 //y=5.335
c289 ( 25 0 ) capacitor c=0.0169868f //x=32.555 //y=5.335
c290 ( 18 0 ) capacitor c=0.00316998f //x=30.965 //y=5.335
c291 ( 17 0 ) capacitor c=0.014258f //x=31.675 //y=5.335
c292 ( 4 0 ) capacitor c=0.00401138f //x=35.385 //y=2.77
c293 ( 3 0 ) capacitor c=0.0706637f //x=39.965 //y=2.77
c294 ( 2 0 ) capacitor c=0.0120752f //x=33.535 //y=2.77
c295 ( 1 0 ) capacitor c=0.0233554f //x=35.155 //y=2.77
r296 (  102 104 ) resistor r=26.9307 //w=0.15 //l=0.106066 //layer=ply \
 //thickness=0.18 //x=40.645 //y=4.97 //x2=40.72 //y2=5.045
r297 (  102 103 ) resistor r=148.702 //w=0.094 //l=0.29 //layer=ply \
 //thickness=0.18 //x=40.645 //y=4.97 //x2=40.355 //y2=4.97
r298 (  101 122 ) resistor r=45.1352 //w=0.168 //l=0.173853 //layer=ply \
 //thickness=0.18 //x=40.31 //y=1.4 //x2=40.27 //y2=1.555
r299 (  100 121 ) resistor r=45.1352 //w=0.168 //l=0.173853 //layer=ply \
 //thickness=0.18 //x=40.31 //y=1.055 //x2=40.27 //y2=0.9
r300 (  100 101 ) resistor r=176.904 //w=0.094 //l=0.345 //layer=ply \
 //thickness=0.18 //x=40.31 //y=1.055 //x2=40.31 //y2=1.4
r301 (  97 103 ) resistor r=22.7971 //w=0.269 //l=0.106066 //layer=ply \
 //thickness=0.18 //x=40.28 //y=5.045 //x2=40.355 //y2=4.97
r302 (  97 120 ) resistor r=35.8364 //w=0.269 //l=0.270185 //layer=ply \
 //thickness=0.18 //x=40.28 //y=5.045 //x2=40.08 //y2=4.88
r303 (  95 116 ) resistor r=10.701 //w=0.21 //l=0.115 //layer=ply \
 //thickness=0.18 //x=39.935 //y=1.555 //x2=39.82 //y2=1.555
r304 (  94 122 ) resistor r=5.52526 //w=0.168 //l=0.115 //layer=ply \
 //thickness=0.18 //x=40.155 //y=1.555 //x2=40.27 //y2=1.555
r305 (  93 115 ) resistor r=5.52526 //w=0.168 //l=0.115 //layer=ply \
 //thickness=0.18 //x=39.935 //y=0.9 //x2=39.82 //y2=0.9
r306 (  92 121 ) resistor r=5.52526 //w=0.168 //l=0.115 //layer=ply \
 //thickness=0.18 //x=40.155 //y=0.9 //x2=40.27 //y2=0.9
r307 (  92 93 ) resistor r=112.809 //w=0.094 //l=0.22 //layer=ply \
 //thickness=0.18 //x=40.155 //y=0.9 //x2=39.935 //y2=0.9
r308 (  91 118 ) resistor r=58.7805 //w=0.246 //l=0.373497 //layer=ply \
 //thickness=0.18 //x=39.78 //y=2.095 //x2=40.08 //y2=2.26
r309 (  90 116 ) resistor r=39.5823 //w=0.21 //l=0.173853 //layer=ply \
 //thickness=0.18 //x=39.78 //y=1.71 //x2=39.82 //y2=1.555
r310 (  90 91 ) resistor r=197.415 //w=0.094 //l=0.385 //layer=ply \
 //thickness=0.18 //x=39.78 //y=1.71 //x2=39.78 //y2=2.095
r311 (  89 116 ) resistor r=39.5823 //w=0.21 //l=0.173853 //layer=ply \
 //thickness=0.18 //x=39.78 //y=1.4 //x2=39.82 //y2=1.555
r312 (  88 115 ) resistor r=45.1352 //w=0.168 //l=0.173853 //layer=ply \
 //thickness=0.18 //x=39.78 //y=1.055 //x2=39.82 //y2=0.9
r313 (  88 89 ) resistor r=176.904 //w=0.094 //l=0.345 //layer=ply \
 //thickness=0.18 //x=39.78 //y=1.055 //x2=39.78 //y2=1.4
r314 (  83 85 ) resistor r=26.9307 //w=0.15 //l=0.106066 //layer=ply \
 //thickness=0.18 //x=35.835 //y=4.97 //x2=35.91 //y2=5.045
r315 (  83 84 ) resistor r=148.702 //w=0.094 //l=0.29 //layer=ply \
 //thickness=0.18 //x=35.835 //y=4.97 //x2=35.545 //y2=4.97
r316 (  82 114 ) resistor r=45.1352 //w=0.168 //l=0.173853 //layer=ply \
 //thickness=0.18 //x=35.5 //y=1.4 //x2=35.46 //y2=1.555
r317 (  81 113 ) resistor r=45.1352 //w=0.168 //l=0.173853 //layer=ply \
 //thickness=0.18 //x=35.5 //y=1.055 //x2=35.46 //y2=0.9
r318 (  81 82 ) resistor r=176.904 //w=0.094 //l=0.345 //layer=ply \
 //thickness=0.18 //x=35.5 //y=1.055 //x2=35.5 //y2=1.4
r319 (  78 84 ) resistor r=22.7971 //w=0.269 //l=0.106066 //layer=ply \
 //thickness=0.18 //x=35.47 //y=5.045 //x2=35.545 //y2=4.97
r320 (  78 112 ) resistor r=35.8364 //w=0.269 //l=0.270185 //layer=ply \
 //thickness=0.18 //x=35.47 //y=5.045 //x2=35.27 //y2=4.88
r321 (  76 108 ) resistor r=10.701 //w=0.21 //l=0.115 //layer=ply \
 //thickness=0.18 //x=35.125 //y=1.555 //x2=35.01 //y2=1.555
r322 (  75 114 ) resistor r=5.52526 //w=0.168 //l=0.115 //layer=ply \
 //thickness=0.18 //x=35.345 //y=1.555 //x2=35.46 //y2=1.555
r323 (  74 107 ) resistor r=5.52526 //w=0.168 //l=0.115 //layer=ply \
 //thickness=0.18 //x=35.125 //y=0.9 //x2=35.01 //y2=0.9
r324 (  73 113 ) resistor r=5.52526 //w=0.168 //l=0.115 //layer=ply \
 //thickness=0.18 //x=35.345 //y=0.9 //x2=35.46 //y2=0.9
r325 (  73 74 ) resistor r=112.809 //w=0.094 //l=0.22 //layer=ply \
 //thickness=0.18 //x=35.345 //y=0.9 //x2=35.125 //y2=0.9
r326 (  72 110 ) resistor r=58.7805 //w=0.246 //l=0.373497 //layer=ply \
 //thickness=0.18 //x=34.97 //y=2.095 //x2=35.27 //y2=2.26
r327 (  71 108 ) resistor r=39.5823 //w=0.21 //l=0.173853 //layer=ply \
 //thickness=0.18 //x=34.97 //y=1.71 //x2=35.01 //y2=1.555
r328 (  71 72 ) resistor r=197.415 //w=0.094 //l=0.385 //layer=ply \
 //thickness=0.18 //x=34.97 //y=1.71 //x2=34.97 //y2=2.095
r329 (  70 108 ) resistor r=39.5823 //w=0.21 //l=0.173853 //layer=ply \
 //thickness=0.18 //x=34.97 //y=1.4 //x2=35.01 //y2=1.555
r330 (  69 107 ) resistor r=45.1352 //w=0.168 //l=0.173853 //layer=ply \
 //thickness=0.18 //x=34.97 //y=1.055 //x2=35.01 //y2=0.9
r331 (  69 70 ) resistor r=176.904 //w=0.094 //l=0.345 //layer=ply \
 //thickness=0.18 //x=34.97 //y=1.055 //x2=34.97 //y2=1.4
r332 (  68 104 ) resistor r=592.245 //w=0.094 //l=1.155 //layer=ply \
 //thickness=0.18 //x=40.72 //y=6.2 //x2=40.72 //y2=5.045
r333 (  67 97 ) resistor r=592.245 //w=0.094 //l=1.155 //layer=ply \
 //thickness=0.18 //x=40.28 //y=6.2 //x2=40.28 //y2=5.045
r334 (  66 85 ) resistor r=592.245 //w=0.094 //l=1.155 //layer=ply \
 //thickness=0.18 //x=35.91 //y=6.2 //x2=35.91 //y2=5.045
r335 (  65 78 ) resistor r=592.245 //w=0.094 //l=1.155 //layer=ply \
 //thickness=0.18 //x=35.47 //y=6.2 //x2=35.47 //y2=5.045
r336 (  64 94 ) resistor r=56.4043 //w=0.094 //l=0.11 //layer=ply \
 //thickness=0.18 //x=40.045 //y=1.555 //x2=40.155 //y2=1.555
r337 (  64 95 ) resistor r=56.4043 //w=0.094 //l=0.11 //layer=ply \
 //thickness=0.18 //x=40.045 //y=1.555 //x2=39.935 //y2=1.555
r338 (  63 75 ) resistor r=56.4043 //w=0.094 //l=0.11 //layer=ply \
 //thickness=0.18 //x=35.235 //y=1.555 //x2=35.345 //y2=1.555
r339 (  63 76 ) resistor r=56.4043 //w=0.094 //l=0.11 //layer=ply \
 //thickness=0.18 //x=35.235 //y=1.555 //x2=35.125 //y2=1.555
r340 (  59 120 ) resistor r=152 //w=0.17 //l=0.17 //layer=licon //count=1 \
 //x=40.08 //y=4.88 //x2=40.08 //y2=4.88
r341 (  57 59 ) resistor r=144.428 //w=0.187 //l=2.11 //layer=li \
 //thickness=0.1 //x=40.08 //y=2.77 //x2=40.08 //y2=4.88
r342 (  54 118 ) resistor r=152 //w=0.17 //l=0.17 //layer=licon //count=1 \
 //x=40.08 //y=2.26 //x2=40.08 //y2=2.26
r343 (  54 57 ) resistor r=34.9091 //w=0.187 //l=0.51 //layer=li \
 //thickness=0.1 //x=40.08 //y=2.26 //x2=40.08 //y2=2.77
r344 (  51 112 ) resistor r=152 //w=0.17 //l=0.17 //layer=licon //count=1 \
 //x=35.27 //y=4.88 //x2=35.27 //y2=4.88
r345 (  49 51 ) resistor r=144.428 //w=0.187 //l=2.11 //layer=li \
 //thickness=0.1 //x=35.27 //y=2.77 //x2=35.27 //y2=4.88
r346 (  46 110 ) resistor r=152 //w=0.17 //l=0.17 //layer=licon //count=1 \
 //x=35.27 //y=2.26 //x2=35.27 //y2=2.26
r347 (  46 49 ) resistor r=34.9091 //w=0.187 //l=0.51 //layer=li \
 //thickness=0.1 //x=35.27 //y=2.26 //x2=35.27 //y2=2.77
r348 (  42 44 ) resistor r=169.754 //w=0.187 //l=2.48 //layer=li \
 //thickness=0.1 //x=33.42 //y=5.25 //x2=33.42 //y2=2.77
r349 (  41 44 ) resistor r=57.4973 //w=0.187 //l=0.84 //layer=li \
 //thickness=0.1 //x=33.42 //y=1.93 //x2=33.42 //y2=2.77
r350 (  39 41 ) resistor r=7.15173 //w=0.17 //l=0.120208 //layer=li \
 //thickness=0.1 //x=33.335 //y=1.845 //x2=33.42 //y2=1.93
r351 (  39 40 ) resistor r=21.5615 //w=0.187 //l=0.315 //layer=li \
 //thickness=0.1 //x=33.335 //y=1.845 //x2=33.02 //y2=1.845
r352 (  35 40 ) resistor r=7.15173 //w=0.17 //l=0.120208 //layer=li \
 //thickness=0.1 //x=32.935 //y=1.76 //x2=33.02 //y2=1.845
r353 (  35 123 ) resistor r=39.016 //w=0.187 //l=0.57 //layer=li \
 //thickness=0.1 //x=32.935 //y=1.76 //x2=32.935 //y2=1.19
r354 (  34 62 ) resistor r=5.4201 //w=0.17 //l=0.085 //layer=li \
 //thickness=0.1 //x=32.725 //y=5.335 //x2=32.64 //y2=5.335
r355 (  33 42 ) resistor r=7.15173 //w=0.17 //l=0.120208 //layer=li \
 //thickness=0.1 //x=33.335 //y=5.335 //x2=33.42 //y2=5.25
r356 (  33 34 ) resistor r=41.754 //w=0.187 //l=0.61 //layer=li \
 //thickness=0.1 //x=33.335 //y=5.335 //x2=32.725 //y2=5.335
r357 (  27 62 ) resistor r=1.40859 //w=0.34 //l=0.085 //layer=li \
 //thickness=0.1 //x=32.64 //y=5.42 //x2=32.64 //y2=5.335
r358 (  27 127 ) resistor r=33.1979 //w=0.187 //l=0.485 //layer=li \
 //thickness=0.1 //x=32.64 //y=5.42 //x2=32.64 //y2=5.905
r359 (  26 61 ) resistor r=5.4201 //w=0.17 //l=0.085 //layer=li \
 //thickness=0.1 //x=31.845 //y=5.335 //x2=31.76 //y2=5.335
r360 (  25 62 ) resistor r=5.4201 //w=0.17 //l=0.085 //layer=li \
 //thickness=0.1 //x=32.555 //y=5.335 //x2=32.64 //y2=5.335
r361 (  25 26 ) resistor r=48.5989 //w=0.187 //l=0.71 //layer=li \
 //thickness=0.1 //x=32.555 //y=5.335 //x2=31.845 //y2=5.335
r362 (  19 61 ) resistor r=1.40859 //w=0.34 //l=0.085 //layer=li \
 //thickness=0.1 //x=31.76 //y=5.42 //x2=31.76 //y2=5.335
r363 (  19 126 ) resistor r=33.1979 //w=0.187 //l=0.485 //layer=li \
 //thickness=0.1 //x=31.76 //y=5.42 //x2=31.76 //y2=5.905
r364 (  17 61 ) resistor r=5.4201 //w=0.17 //l=0.085 //layer=li \
 //thickness=0.1 //x=31.675 //y=5.335 //x2=31.76 //y2=5.335
r365 (  17 18 ) resistor r=48.5989 //w=0.187 //l=0.71 //layer=li \
 //thickness=0.1 //x=31.675 //y=5.335 //x2=30.965 //y2=5.335
r366 (  11 18 ) resistor r=7.15173 //w=0.17 //l=0.120208 //layer=li \
 //thickness=0.1 //x=30.88 //y=5.42 //x2=30.965 //y2=5.335
r367 (  11 125 ) resistor r=33.1979 //w=0.187 //l=0.485 //layer=li \
 //thickness=0.1 //x=30.88 //y=5.42 //x2=30.88 //y2=5.905
r368 (  10 57 ) resistor r=9.3 //w=0.17 //l=0.17 //layer=mcon //count=1 \
 //x=40.08 //y=2.77 //x2=40.08 //y2=2.77
r369 (  8 49 ) resistor r=9.3 //w=0.17 //l=0.17 //layer=mcon //count=1 \
 //x=35.27 //y=2.77 //x2=35.27 //y2=2.77
r370 (  6 44 ) resistor r=9.3 //w=0.17 //l=0.17 //layer=mcon //count=1 \
 //x=33.42 //y=2.77 //x2=33.42 //y2=2.77
r371 (  4 8 ) resistor r=0.0880901 //w=0.191 //l=0.115 //layer=m1 \
 //thickness=0.36 //x=35.385 //y=2.77 //x2=35.27 //y2=2.77
r372 (  3 10 ) resistor r=0.0717383 //w=0.224 //l=0.115 //layer=m1 \
 //thickness=0.36 //x=39.965 //y=2.77 //x2=40.08 //y2=2.77
r373 (  3 4 ) resistor r=4.37023 //w=0.131 //l=4.58 //layer=m1 \
 //thickness=0.36 //x=39.965 //y=2.77 //x2=35.385 //y2=2.77
r374 (  2 6 ) resistor r=0.0717383 //w=0.224 //l=0.115 //layer=m1 \
 //thickness=0.36 //x=33.535 //y=2.77 //x2=33.42 //y2=2.77
r375 (  1 8 ) resistor r=0.0880901 //w=0.191 //l=0.115 //layer=m1 \
 //thickness=0.36 //x=35.155 //y=2.77 //x2=35.27 //y2=2.77
r376 (  1 2 ) resistor r=1.5458 //w=0.131 //l=1.62 //layer=m1 //thickness=0.36 \
 //x=35.155 //y=2.77 //x2=33.535 //y2=2.77
ends PM_TMRDFFSNRNQX1\%noxref_9

subckt PM_TMRDFFSNRNQX1\%noxref_10 ( 1 2 13 14 21 29 35 36 40 42 49 50 51 52 \
 53 54 55 56 57 58 60 66 67 68 69 81 83 84 85 )
c169 ( 85 0 ) capacitor c=0.023087f //x=42.115 //y=5.2
c170 ( 84 0 ) capacitor c=0.023519f //x=41.235 //y=5.2
c171 ( 83 0 ) capacitor c=0.0224735f //x=40.355 //y=5.2
c172 ( 81 0 ) capacitor c=0.00853354f //x=42.365 //y=1.095
c173 ( 69 0 ) capacitor c=0.0549166f //x=45.165 //y=4.97
c174 ( 68 0 ) capacitor c=0.0294456f //x=45.455 //y=4.97
c175 ( 67 0 ) capacitor c=0.0347816f //x=45.12 //y=1.4
c176 ( 66 0 ) capacitor c=0.0187487f //x=45.12 //y=1.055
c177 ( 60 0 ) capacitor c=0.0137055f //x=44.965 //y=1.555
c178 ( 58 0 ) capacitor c=0.0149861f //x=44.965 //y=0.9
c179 ( 57 0 ) capacitor c=0.096037f //x=44.59 //y=2.095
c180 ( 56 0 ) capacitor c=0.0228993f //x=44.59 //y=1.71
c181 ( 55 0 ) capacitor c=0.0234352f //x=44.59 //y=1.4
c182 ( 54 0 ) capacitor c=0.0198724f //x=44.59 //y=1.055
c183 ( 53 0 ) capacitor c=0.109949f //x=45.53 //y=6.2
c184 ( 52 0 ) capacitor c=0.158483f //x=45.09 //y=6.2
c185 ( 50 0 ) capacitor c=9.74268e-19 //x=42.26 //y=5.335
c186 ( 49 0 ) capacitor c=0.00191414f //x=41.38 //y=5.335
c187 ( 42 0 ) capacitor c=0.0911502f //x=44.89 //y=2.26
c188 ( 40 0 ) capacitor c=0.103494f //x=43.04 //y=2.77
c189 ( 36 0 ) capacitor c=0.00398962f //x=42.64 //y=1.845
c190 ( 35 0 ) capacitor c=0.0137288f //x=42.955 //y=1.845
c191 ( 29 0 ) capacitor c=0.0276208f //x=42.955 //y=5.335
c192 ( 21 0 ) capacitor c=0.0169868f //x=42.175 //y=5.335
c193 ( 14 0 ) capacitor c=0.00316998f //x=40.585 //y=5.335
c194 ( 13 0 ) capacitor c=0.014258f //x=41.295 //y=5.335
c195 ( 2 0 ) capacitor c=0.00808366f //x=43.155 //y=2.77
c196 ( 1 0 ) capacitor c=0.0351856f //x=44.775 //y=2.77
r197 (  68 70 ) resistor r=26.9307 //w=0.15 //l=0.106066 //layer=ply \
 //thickness=0.18 //x=45.455 //y=4.97 //x2=45.53 //y2=5.045
r198 (  68 69 ) resistor r=148.702 //w=0.094 //l=0.29 //layer=ply \
 //thickness=0.18 //x=45.455 //y=4.97 //x2=45.165 //y2=4.97
r199 (  67 80 ) resistor r=45.1352 //w=0.168 //l=0.173853 //layer=ply \
 //thickness=0.18 //x=45.12 //y=1.4 //x2=45.08 //y2=1.555
r200 (  66 79 ) resistor r=45.1352 //w=0.168 //l=0.173853 //layer=ply \
 //thickness=0.18 //x=45.12 //y=1.055 //x2=45.08 //y2=0.9
r201 (  66 67 ) resistor r=176.904 //w=0.094 //l=0.345 //layer=ply \
 //thickness=0.18 //x=45.12 //y=1.055 //x2=45.12 //y2=1.4
r202 (  63 69 ) resistor r=22.7971 //w=0.269 //l=0.106066 //layer=ply \
 //thickness=0.18 //x=45.09 //y=5.045 //x2=45.165 //y2=4.97
r203 (  63 78 ) resistor r=35.8364 //w=0.269 //l=0.270185 //layer=ply \
 //thickness=0.18 //x=45.09 //y=5.045 //x2=44.89 //y2=4.88
r204 (  61 74 ) resistor r=10.701 //w=0.21 //l=0.115 //layer=ply \
 //thickness=0.18 //x=44.745 //y=1.555 //x2=44.63 //y2=1.555
r205 (  60 80 ) resistor r=5.52526 //w=0.168 //l=0.115 //layer=ply \
 //thickness=0.18 //x=44.965 //y=1.555 //x2=45.08 //y2=1.555
r206 (  59 73 ) resistor r=5.52526 //w=0.168 //l=0.115 //layer=ply \
 //thickness=0.18 //x=44.745 //y=0.9 //x2=44.63 //y2=0.9
r207 (  58 79 ) resistor r=5.52526 //w=0.168 //l=0.115 //layer=ply \
 //thickness=0.18 //x=44.965 //y=0.9 //x2=45.08 //y2=0.9
r208 (  58 59 ) resistor r=112.809 //w=0.094 //l=0.22 //layer=ply \
 //thickness=0.18 //x=44.965 //y=0.9 //x2=44.745 //y2=0.9
r209 (  57 76 ) resistor r=58.7805 //w=0.246 //l=0.373497 //layer=ply \
 //thickness=0.18 //x=44.59 //y=2.095 //x2=44.89 //y2=2.26
r210 (  56 74 ) resistor r=39.5823 //w=0.21 //l=0.173853 //layer=ply \
 //thickness=0.18 //x=44.59 //y=1.71 //x2=44.63 //y2=1.555
r211 (  56 57 ) resistor r=197.415 //w=0.094 //l=0.385 //layer=ply \
 //thickness=0.18 //x=44.59 //y=1.71 //x2=44.59 //y2=2.095
r212 (  55 74 ) resistor r=39.5823 //w=0.21 //l=0.173853 //layer=ply \
 //thickness=0.18 //x=44.59 //y=1.4 //x2=44.63 //y2=1.555
r213 (  54 73 ) resistor r=45.1352 //w=0.168 //l=0.173853 //layer=ply \
 //thickness=0.18 //x=44.59 //y=1.055 //x2=44.63 //y2=0.9
r214 (  54 55 ) resistor r=176.904 //w=0.094 //l=0.345 //layer=ply \
 //thickness=0.18 //x=44.59 //y=1.055 //x2=44.59 //y2=1.4
r215 (  53 70 ) resistor r=592.245 //w=0.094 //l=1.155 //layer=ply \
 //thickness=0.18 //x=45.53 //y=6.2 //x2=45.53 //y2=5.045
r216 (  52 63 ) resistor r=592.245 //w=0.094 //l=1.155 //layer=ply \
 //thickness=0.18 //x=45.09 //y=6.2 //x2=45.09 //y2=5.045
r217 (  51 60 ) resistor r=56.4043 //w=0.094 //l=0.11 //layer=ply \
 //thickness=0.18 //x=44.855 //y=1.555 //x2=44.965 //y2=1.555
r218 (  51 61 ) resistor r=56.4043 //w=0.094 //l=0.11 //layer=ply \
 //thickness=0.18 //x=44.855 //y=1.555 //x2=44.745 //y2=1.555
r219 (  47 78 ) resistor r=152 //w=0.17 //l=0.17 //layer=licon //count=1 \
 //x=44.89 //y=4.88 //x2=44.89 //y2=4.88
r220 (  45 47 ) resistor r=144.428 //w=0.187 //l=2.11 //layer=li \
 //thickness=0.1 //x=44.89 //y=2.77 //x2=44.89 //y2=4.88
r221 (  42 76 ) resistor r=152 //w=0.17 //l=0.17 //layer=licon //count=1 \
 //x=44.89 //y=2.26 //x2=44.89 //y2=2.26
r222 (  42 45 ) resistor r=34.9091 //w=0.187 //l=0.51 //layer=li \
 //thickness=0.1 //x=44.89 //y=2.26 //x2=44.89 //y2=2.77
r223 (  38 40 ) resistor r=169.754 //w=0.187 //l=2.48 //layer=li \
 //thickness=0.1 //x=43.04 //y=5.25 //x2=43.04 //y2=2.77
r224 (  37 40 ) resistor r=57.4973 //w=0.187 //l=0.84 //layer=li \
 //thickness=0.1 //x=43.04 //y=1.93 //x2=43.04 //y2=2.77
r225 (  35 37 ) resistor r=7.15173 //w=0.17 //l=0.120208 //layer=li \
 //thickness=0.1 //x=42.955 //y=1.845 //x2=43.04 //y2=1.93
r226 (  35 36 ) resistor r=21.5615 //w=0.187 //l=0.315 //layer=li \
 //thickness=0.1 //x=42.955 //y=1.845 //x2=42.64 //y2=1.845
r227 (  31 36 ) resistor r=7.15173 //w=0.17 //l=0.120208 //layer=li \
 //thickness=0.1 //x=42.555 //y=1.76 //x2=42.64 //y2=1.845
r228 (  31 81 ) resistor r=39.016 //w=0.187 //l=0.57 //layer=li \
 //thickness=0.1 //x=42.555 //y=1.76 //x2=42.555 //y2=1.19
r229 (  30 50 ) resistor r=5.4201 //w=0.17 //l=0.085 //layer=li \
 //thickness=0.1 //x=42.345 //y=5.335 //x2=42.26 //y2=5.335
r230 (  29 38 ) resistor r=7.15173 //w=0.17 //l=0.120208 //layer=li \
 //thickness=0.1 //x=42.955 //y=5.335 //x2=43.04 //y2=5.25
r231 (  29 30 ) resistor r=41.754 //w=0.187 //l=0.61 //layer=li \
 //thickness=0.1 //x=42.955 //y=5.335 //x2=42.345 //y2=5.335
r232 (  23 50 ) resistor r=1.40859 //w=0.34 //l=0.085 //layer=li \
 //thickness=0.1 //x=42.26 //y=5.42 //x2=42.26 //y2=5.335
r233 (  23 85 ) resistor r=33.1979 //w=0.187 //l=0.485 //layer=li \
 //thickness=0.1 //x=42.26 //y=5.42 //x2=42.26 //y2=5.905
r234 (  22 49 ) resistor r=5.4201 //w=0.17 //l=0.085 //layer=li \
 //thickness=0.1 //x=41.465 //y=5.335 //x2=41.38 //y2=5.335
r235 (  21 50 ) resistor r=5.4201 //w=0.17 //l=0.085 //layer=li \
 //thickness=0.1 //x=42.175 //y=5.335 //x2=42.26 //y2=5.335
r236 (  21 22 ) resistor r=48.5989 //w=0.187 //l=0.71 //layer=li \
 //thickness=0.1 //x=42.175 //y=5.335 //x2=41.465 //y2=5.335
r237 (  15 49 ) resistor r=1.40859 //w=0.34 //l=0.085 //layer=li \
 //thickness=0.1 //x=41.38 //y=5.42 //x2=41.38 //y2=5.335
r238 (  15 84 ) resistor r=33.1979 //w=0.187 //l=0.485 //layer=li \
 //thickness=0.1 //x=41.38 //y=5.42 //x2=41.38 //y2=5.905
r239 (  13 49 ) resistor r=5.4201 //w=0.17 //l=0.085 //layer=li \
 //thickness=0.1 //x=41.295 //y=5.335 //x2=41.38 //y2=5.335
r240 (  13 14 ) resistor r=48.5989 //w=0.187 //l=0.71 //layer=li \
 //thickness=0.1 //x=41.295 //y=5.335 //x2=40.585 //y2=5.335
r241 (  7 14 ) resistor r=7.15173 //w=0.17 //l=0.120208 //layer=li \
 //thickness=0.1 //x=40.5 //y=5.42 //x2=40.585 //y2=5.335
r242 (  7 83 ) resistor r=33.1979 //w=0.187 //l=0.485 //layer=li \
 //thickness=0.1 //x=40.5 //y=5.42 //x2=40.5 //y2=5.905
r243 (  6 45 ) resistor r=9.3 //w=0.17 //l=0.17 //layer=mcon //count=1 \
 //x=44.89 //y=2.77 //x2=44.89 //y2=2.77
r244 (  4 40 ) resistor r=9.3 //w=0.17 //l=0.17 //layer=mcon //count=1 \
 //x=43.04 //y=2.77 //x2=43.04 //y2=2.77
r245 (  2 4 ) resistor r=0.0717383 //w=0.224 //l=0.115 //layer=m1 \
 //thickness=0.36 //x=43.155 //y=2.77 //x2=43.04 //y2=2.77
r246 (  1 6 ) resistor r=0.0717383 //w=0.224 //l=0.115 //layer=m1 \
 //thickness=0.36 //x=44.775 //y=2.77 //x2=44.89 //y2=2.77
r247 (  1 2 ) resistor r=1.5458 //w=0.131 //l=1.62 //layer=m1 //thickness=0.36 \
 //x=44.775 //y=2.77 //x2=43.155 //y2=2.77
ends PM_TMRDFFSNRNQX1\%noxref_10

subckt PM_TMRDFFSNRNQX1\%noxref_11 ( 1 2 3 4 12 25 26 33 41 47 48 52 54 61 62 \
 63 64 65 66 67 68 72 73 74 79 81 84 85 86 87 88 89 90 92 98 99 100 101 106 \
 107 112 123 125 126 127 )
c281 ( 127 0 ) capacitor c=0.023087f //x=37.305 //y=5.2
c282 ( 126 0 ) capacitor c=0.023519f //x=36.425 //y=5.2
c283 ( 125 0 ) capacitor c=0.0224735f //x=35.545 //y=5.2
c284 ( 123 0 ) capacitor c=0.00853354f //x=37.555 //y=1.095
c285 ( 112 0 ) capacitor c=0.0588394f //x=32.68 //y=4.88
c286 ( 107 0 ) capacitor c=0.0273931f //x=32.68 //y=2.095
c287 ( 106 0 ) capacitor c=0.0456313f //x=32.68 //y=2.26
c288 ( 101 0 ) capacitor c=0.0547611f //x=49.975 //y=4.97
c289 ( 100 0 ) capacitor c=0.0294456f //x=50.265 //y=4.97
c290 ( 99 0 ) capacitor c=0.0347816f //x=49.93 //y=1.4
c291 ( 98 0 ) capacitor c=0.0187487f //x=49.93 //y=1.055
c292 ( 92 0 ) capacitor c=0.0137055f //x=49.775 //y=1.555
c293 ( 90 0 ) capacitor c=0.0149861f //x=49.775 //y=0.9
c294 ( 89 0 ) capacitor c=0.096037f //x=49.4 //y=2.095
c295 ( 88 0 ) capacitor c=0.0228993f //x=49.4 //y=1.71
c296 ( 87 0 ) capacitor c=0.0234352f //x=49.4 //y=1.4
c297 ( 86 0 ) capacitor c=0.0198724f //x=49.4 //y=1.055
c298 ( 85 0 ) capacitor c=0.0432517f //x=33.2 //y=1.44
c299 ( 84 0 ) capacitor c=0.0200379f //x=33.2 //y=1.095
c300 ( 81 0 ) capacitor c=0.0148873f //x=33.045 //y=1.595
c301 ( 79 0 ) capacitor c=0.0157803f //x=33.045 //y=0.94
c302 ( 74 0 ) capacitor c=0.0218028f //x=32.67 //y=1.75
c303 ( 73 0 ) capacitor c=0.0207459f //x=32.67 //y=1.44
c304 ( 72 0 ) capacitor c=0.0194308f //x=32.67 //y=1.095
c305 ( 68 0 ) capacitor c=0.109949f //x=50.34 //y=6.2
c306 ( 67 0 ) capacitor c=0.158483f //x=49.9 //y=6.2
c307 ( 66 0 ) capacitor c=0.158754f //x=32.86 //y=6.2
c308 ( 65 0 ) capacitor c=0.109949f //x=32.42 //y=6.2
c309 ( 62 0 ) capacitor c=9.74268e-19 //x=37.45 //y=5.335
c310 ( 61 0 ) capacitor c=0.00191414f //x=36.57 //y=5.335
c311 ( 54 0 ) capacitor c=0.0938247f //x=49.7 //y=2.26
c312 ( 52 0 ) capacitor c=0.103032f //x=38.23 //y=3.51
c313 ( 48 0 ) capacitor c=0.00398962f //x=37.83 //y=1.845
c314 ( 47 0 ) capacitor c=0.0137288f //x=38.145 //y=1.845
c315 ( 41 0 ) capacitor c=0.0276208f //x=38.145 //y=5.335
c316 ( 33 0 ) capacitor c=0.0169868f //x=37.365 //y=5.335
c317 ( 26 0 ) capacitor c=0.00316998f //x=35.775 //y=5.335
c318 ( 25 0 ) capacitor c=0.014258f //x=36.485 //y=5.335
c319 ( 12 0 ) capacitor c=0.0816952f //x=32.68 //y=2.26
c320 ( 4 0 ) capacitor c=0.00551333f //x=38.345 //y=3.51
c321 ( 3 0 ) capacitor c=0.173188f //x=49.585 //y=3.51
c322 ( 2 0 ) capacitor c=0.0108616f //x=32.795 //y=3.51
c323 ( 1 0 ) capacitor c=0.0905825f //x=38.115 //y=3.51
r324 (  106 107 ) resistor r=52.7279 //w=0.214 //l=0.165 //layer=ply \
 //thickness=0.18 //x=32.68 //y=2.26 //x2=32.68 //y2=2.095
r325 (  100 102 ) resistor r=26.9307 //w=0.15 //l=0.106066 //layer=ply \
 //thickness=0.18 //x=50.265 //y=4.97 //x2=50.34 //y2=5.045
r326 (  100 101 ) resistor r=148.702 //w=0.094 //l=0.29 //layer=ply \
 //thickness=0.18 //x=50.265 //y=4.97 //x2=49.975 //y2=4.97
r327 (  99 122 ) resistor r=45.1352 //w=0.168 //l=0.173853 //layer=ply \
 //thickness=0.18 //x=49.93 //y=1.4 //x2=49.89 //y2=1.555
r328 (  98 121 ) resistor r=45.1352 //w=0.168 //l=0.173853 //layer=ply \
 //thickness=0.18 //x=49.93 //y=1.055 //x2=49.89 //y2=0.9
r329 (  98 99 ) resistor r=176.904 //w=0.094 //l=0.345 //layer=ply \
 //thickness=0.18 //x=49.93 //y=1.055 //x2=49.93 //y2=1.4
r330 (  95 101 ) resistor r=22.7971 //w=0.269 //l=0.106066 //layer=ply \
 //thickness=0.18 //x=49.9 //y=5.045 //x2=49.975 //y2=4.97
r331 (  95 120 ) resistor r=35.8364 //w=0.269 //l=0.270185 //layer=ply \
 //thickness=0.18 //x=49.9 //y=5.045 //x2=49.7 //y2=4.88
r332 (  93 116 ) resistor r=10.701 //w=0.21 //l=0.115 //layer=ply \
 //thickness=0.18 //x=49.555 //y=1.555 //x2=49.44 //y2=1.555
r333 (  92 122 ) resistor r=5.52526 //w=0.168 //l=0.115 //layer=ply \
 //thickness=0.18 //x=49.775 //y=1.555 //x2=49.89 //y2=1.555
r334 (  91 115 ) resistor r=5.52526 //w=0.168 //l=0.115 //layer=ply \
 //thickness=0.18 //x=49.555 //y=0.9 //x2=49.44 //y2=0.9
r335 (  90 121 ) resistor r=5.52526 //w=0.168 //l=0.115 //layer=ply \
 //thickness=0.18 //x=49.775 //y=0.9 //x2=49.89 //y2=0.9
r336 (  90 91 ) resistor r=112.809 //w=0.094 //l=0.22 //layer=ply \
 //thickness=0.18 //x=49.775 //y=0.9 //x2=49.555 //y2=0.9
r337 (  89 118 ) resistor r=58.7805 //w=0.246 //l=0.373497 //layer=ply \
 //thickness=0.18 //x=49.4 //y=2.095 //x2=49.7 //y2=2.26
r338 (  88 116 ) resistor r=39.5823 //w=0.21 //l=0.173853 //layer=ply \
 //thickness=0.18 //x=49.4 //y=1.71 //x2=49.44 //y2=1.555
r339 (  88 89 ) resistor r=197.415 //w=0.094 //l=0.385 //layer=ply \
 //thickness=0.18 //x=49.4 //y=1.71 //x2=49.4 //y2=2.095
r340 (  87 116 ) resistor r=39.5823 //w=0.21 //l=0.173853 //layer=ply \
 //thickness=0.18 //x=49.4 //y=1.4 //x2=49.44 //y2=1.555
r341 (  86 115 ) resistor r=45.1352 //w=0.168 //l=0.173853 //layer=ply \
 //thickness=0.18 //x=49.4 //y=1.055 //x2=49.44 //y2=0.9
r342 (  86 87 ) resistor r=176.904 //w=0.094 //l=0.345 //layer=ply \
 //thickness=0.18 //x=49.4 //y=1.055 //x2=49.4 //y2=1.4
r343 (  85 114 ) resistor r=45.1352 //w=0.168 //l=0.173853 //layer=ply \
 //thickness=0.18 //x=33.2 //y=1.44 //x2=33.16 //y2=1.595
r344 (  84 113 ) resistor r=45.1352 //w=0.168 //l=0.173853 //layer=ply \
 //thickness=0.18 //x=33.2 //y=1.095 //x2=33.16 //y2=0.94
r345 (  84 85 ) resistor r=176.904 //w=0.094 //l=0.345 //layer=ply \
 //thickness=0.18 //x=33.2 //y=1.095 //x2=33.2 //y2=1.44
r346 (  82 110 ) resistor r=10.701 //w=0.21 //l=0.115 //layer=ply \
 //thickness=0.18 //x=32.825 //y=1.595 //x2=32.71 //y2=1.595
r347 (  81 114 ) resistor r=5.52526 //w=0.168 //l=0.115 //layer=ply \
 //thickness=0.18 //x=33.045 //y=1.595 //x2=33.16 //y2=1.595
r348 (  80 109 ) resistor r=5.52526 //w=0.168 //l=0.115 //layer=ply \
 //thickness=0.18 //x=32.825 //y=0.94 //x2=32.71 //y2=0.94
r349 (  79 113 ) resistor r=5.52526 //w=0.168 //l=0.115 //layer=ply \
 //thickness=0.18 //x=33.045 //y=0.94 //x2=33.16 //y2=0.94
r350 (  79 80 ) resistor r=112.809 //w=0.094 //l=0.22 //layer=ply \
 //thickness=0.18 //x=33.045 //y=0.94 //x2=32.825 //y2=0.94
r351 (  76 112 ) resistor r=37.236 //w=0.233 //l=0.249199 //layer=ply \
 //thickness=0.18 //x=32.86 //y=5.045 //x2=32.68 //y2=4.88
r352 (  74 110 ) resistor r=39.5823 //w=0.21 //l=0.173853 //layer=ply \
 //thickness=0.18 //x=32.67 //y=1.75 //x2=32.71 //y2=1.595
r353 (  74 107 ) resistor r=176.904 //w=0.094 //l=0.345 //layer=ply \
 //thickness=0.18 //x=32.67 //y=1.75 //x2=32.67 //y2=2.095
r354 (  73 110 ) resistor r=39.5823 //w=0.21 //l=0.173853 //layer=ply \
 //thickness=0.18 //x=32.67 //y=1.44 //x2=32.71 //y2=1.595
r355 (  72 109 ) resistor r=45.1352 //w=0.168 //l=0.173853 //layer=ply \
 //thickness=0.18 //x=32.67 //y=1.095 //x2=32.71 //y2=0.94
r356 (  72 73 ) resistor r=176.904 //w=0.094 //l=0.345 //layer=ply \
 //thickness=0.18 //x=32.67 //y=1.095 //x2=32.67 //y2=1.44
r357 (  69 112 ) resistor r=53.7854 //w=0.233 //l=0.332415 //layer=ply \
 //thickness=0.18 //x=32.42 //y=5.045 //x2=32.68 //y2=4.88
r358 (  68 102 ) resistor r=592.245 //w=0.094 //l=1.155 //layer=ply \
 //thickness=0.18 //x=50.34 //y=6.2 //x2=50.34 //y2=5.045
r359 (  67 95 ) resistor r=592.245 //w=0.094 //l=1.155 //layer=ply \
 //thickness=0.18 //x=49.9 //y=6.2 //x2=49.9 //y2=5.045
r360 (  66 76 ) resistor r=592.245 //w=0.094 //l=1.155 //layer=ply \
 //thickness=0.18 //x=32.86 //y=6.2 //x2=32.86 //y2=5.045
r361 (  65 69 ) resistor r=592.245 //w=0.094 //l=1.155 //layer=ply \
 //thickness=0.18 //x=32.42 //y=6.2 //x2=32.42 //y2=5.045
r362 (  64 92 ) resistor r=56.4043 //w=0.094 //l=0.11 //layer=ply \
 //thickness=0.18 //x=49.665 //y=1.555 //x2=49.775 //y2=1.555
r363 (  64 93 ) resistor r=56.4043 //w=0.094 //l=0.11 //layer=ply \
 //thickness=0.18 //x=49.665 //y=1.555 //x2=49.555 //y2=1.555
r364 (  63 81 ) resistor r=56.4043 //w=0.094 //l=0.11 //layer=ply \
 //thickness=0.18 //x=32.935 //y=1.595 //x2=33.045 //y2=1.595
r365 (  63 82 ) resistor r=56.4043 //w=0.094 //l=0.11 //layer=ply \
 //thickness=0.18 //x=32.935 //y=1.595 //x2=32.825 //y2=1.595
r366 (  59 120 ) resistor r=152 //w=0.17 //l=0.17 //layer=licon //count=1 \
 //x=49.7 //y=4.88 //x2=49.7 //y2=4.88
r367 (  57 59 ) resistor r=93.7754 //w=0.187 //l=1.37 //layer=li \
 //thickness=0.1 //x=49.7 //y=3.51 //x2=49.7 //y2=4.88
r368 (  54 118 ) resistor r=152 //w=0.17 //l=0.17 //layer=licon //count=1 \
 //x=49.7 //y=2.26 //x2=49.7 //y2=2.26
r369 (  54 57 ) resistor r=85.5615 //w=0.187 //l=1.25 //layer=li \
 //thickness=0.1 //x=49.7 //y=2.26 //x2=49.7 //y2=3.51
r370 (  50 52 ) resistor r=119.102 //w=0.187 //l=1.74 //layer=li \
 //thickness=0.1 //x=38.23 //y=5.25 //x2=38.23 //y2=3.51
r371 (  49 52 ) resistor r=108.15 //w=0.187 //l=1.58 //layer=li \
 //thickness=0.1 //x=38.23 //y=1.93 //x2=38.23 //y2=3.51
r372 (  47 49 ) resistor r=7.15173 //w=0.17 //l=0.120208 //layer=li \
 //thickness=0.1 //x=38.145 //y=1.845 //x2=38.23 //y2=1.93
r373 (  47 48 ) resistor r=21.5615 //w=0.187 //l=0.315 //layer=li \
 //thickness=0.1 //x=38.145 //y=1.845 //x2=37.83 //y2=1.845
r374 (  43 48 ) resistor r=7.15173 //w=0.17 //l=0.120208 //layer=li \
 //thickness=0.1 //x=37.745 //y=1.76 //x2=37.83 //y2=1.845
r375 (  43 123 ) resistor r=39.016 //w=0.187 //l=0.57 //layer=li \
 //thickness=0.1 //x=37.745 //y=1.76 //x2=37.745 //y2=1.19
r376 (  42 62 ) resistor r=5.4201 //w=0.17 //l=0.085 //layer=li \
 //thickness=0.1 //x=37.535 //y=5.335 //x2=37.45 //y2=5.335
r377 (  41 50 ) resistor r=7.15173 //w=0.17 //l=0.120208 //layer=li \
 //thickness=0.1 //x=38.145 //y=5.335 //x2=38.23 //y2=5.25
r378 (  41 42 ) resistor r=41.754 //w=0.187 //l=0.61 //layer=li \
 //thickness=0.1 //x=38.145 //y=5.335 //x2=37.535 //y2=5.335
r379 (  35 62 ) resistor r=1.40859 //w=0.34 //l=0.085 //layer=li \
 //thickness=0.1 //x=37.45 //y=5.42 //x2=37.45 //y2=5.335
r380 (  35 127 ) resistor r=33.1979 //w=0.187 //l=0.485 //layer=li \
 //thickness=0.1 //x=37.45 //y=5.42 //x2=37.45 //y2=5.905
r381 (  34 61 ) resistor r=5.4201 //w=0.17 //l=0.085 //layer=li \
 //thickness=0.1 //x=36.655 //y=5.335 //x2=36.57 //y2=5.335
r382 (  33 62 ) resistor r=5.4201 //w=0.17 //l=0.085 //layer=li \
 //thickness=0.1 //x=37.365 //y=5.335 //x2=37.45 //y2=5.335
r383 (  33 34 ) resistor r=48.5989 //w=0.187 //l=0.71 //layer=li \
 //thickness=0.1 //x=37.365 //y=5.335 //x2=36.655 //y2=5.335
r384 (  27 61 ) resistor r=1.40859 //w=0.34 //l=0.085 //layer=li \
 //thickness=0.1 //x=36.57 //y=5.42 //x2=36.57 //y2=5.335
r385 (  27 126 ) resistor r=33.1979 //w=0.187 //l=0.485 //layer=li \
 //thickness=0.1 //x=36.57 //y=5.42 //x2=36.57 //y2=5.905
r386 (  25 61 ) resistor r=5.4201 //w=0.17 //l=0.085 //layer=li \
 //thickness=0.1 //x=36.485 //y=5.335 //x2=36.57 //y2=5.335
r387 (  25 26 ) resistor r=48.5989 //w=0.187 //l=0.71 //layer=li \
 //thickness=0.1 //x=36.485 //y=5.335 //x2=35.775 //y2=5.335
r388 (  19 26 ) resistor r=7.15173 //w=0.17 //l=0.120208 //layer=li \
 //thickness=0.1 //x=35.69 //y=5.42 //x2=35.775 //y2=5.335
r389 (  19 125 ) resistor r=33.1979 //w=0.187 //l=0.485 //layer=li \
 //thickness=0.1 //x=35.69 //y=5.42 //x2=35.69 //y2=5.905
r390 (  17 112 ) resistor r=152 //w=0.17 //l=0.17 //layer=licon //count=1 \
 //x=32.68 //y=4.88 //x2=32.68 //y2=4.88
r391 (  15 17 ) resistor r=93.7754 //w=0.187 //l=1.37 //layer=li \
 //thickness=0.1 //x=32.68 //y=3.51 //x2=32.68 //y2=4.88
r392 (  12 106 ) resistor r=152 //w=0.17 //l=0.17 //layer=licon //count=1 \
 //x=32.68 //y=2.26 //x2=32.68 //y2=2.26
r393 (  12 15 ) resistor r=85.5615 //w=0.187 //l=1.25 //layer=li \
 //thickness=0.1 //x=32.68 //y=2.26 //x2=32.68 //y2=3.51
r394 (  10 57 ) resistor r=9.3 //w=0.17 //l=0.17 //layer=mcon //count=1 \
 //x=49.7 //y=3.51 //x2=49.7 //y2=3.51
r395 (  8 52 ) resistor r=9.3 //w=0.17 //l=0.17 //layer=mcon //count=1 \
 //x=38.23 //y=3.51 //x2=38.23 //y2=3.51
r396 (  6 15 ) resistor r=9.3 //w=0.17 //l=0.17 //layer=mcon //count=1 \
 //x=32.68 //y=3.51 //x2=32.68 //y2=3.51
r397 (  4 8 ) resistor r=0.0880901 //w=0.191 //l=0.115 //layer=m1 \
 //thickness=0.36 //x=38.345 //y=3.51 //x2=38.23 //y2=3.51
r398 (  3 10 ) resistor r=0.0717383 //w=0.224 //l=0.115 //layer=m1 \
 //thickness=0.36 //x=49.585 //y=3.51 //x2=49.7 //y2=3.51
r399 (  3 4 ) resistor r=10.7252 //w=0.131 //l=11.24 //layer=m1 \
 //thickness=0.36 //x=49.585 //y=3.51 //x2=38.345 //y2=3.51
r400 (  2 6 ) resistor r=0.0717383 //w=0.224 //l=0.115 //layer=m1 \
 //thickness=0.36 //x=32.795 //y=3.51 //x2=32.68 //y2=3.51
r401 (  1 8 ) resistor r=0.0880901 //w=0.191 //l=0.115 //layer=m1 \
 //thickness=0.36 //x=38.115 //y=3.51 //x2=38.23 //y2=3.51
r402 (  1 2 ) resistor r=5.07634 //w=0.131 //l=5.32 //layer=m1 \
 //thickness=0.36 //x=38.115 //y=3.51 //x2=32.795 //y2=3.51
ends PM_TMRDFFSNRNQX1\%noxref_11

subckt PM_TMRDFFSNRNQX1\%noxref_12 ( 1 2 13 14 21 29 35 36 40 42 49 50 51 52 \
 53 54 55 56 57 58 60 66 67 68 69 81 83 84 85 )
c168 ( 85 0 ) capacitor c=0.023087f //x=51.735 //y=5.2
c169 ( 84 0 ) capacitor c=0.023519f //x=50.855 //y=5.2
c170 ( 83 0 ) capacitor c=0.0224735f //x=49.975 //y=5.2
c171 ( 81 0 ) capacitor c=0.00853354f //x=51.985 //y=1.095
c172 ( 69 0 ) capacitor c=0.0547611f //x=54.785 //y=4.97
c173 ( 68 0 ) capacitor c=0.0294456f //x=55.075 //y=4.97
c174 ( 67 0 ) capacitor c=0.0347816f //x=54.74 //y=1.4
c175 ( 66 0 ) capacitor c=0.0187487f //x=54.74 //y=1.055
c176 ( 60 0 ) capacitor c=0.0137055f //x=54.585 //y=1.555
c177 ( 58 0 ) capacitor c=0.0149861f //x=54.585 //y=0.9
c178 ( 57 0 ) capacitor c=0.096037f //x=54.21 //y=2.095
c179 ( 56 0 ) capacitor c=0.0228993f //x=54.21 //y=1.71
c180 ( 55 0 ) capacitor c=0.0234352f //x=54.21 //y=1.4
c181 ( 54 0 ) capacitor c=0.0198724f //x=54.21 //y=1.055
c182 ( 53 0 ) capacitor c=0.109949f //x=55.15 //y=6.2
c183 ( 52 0 ) capacitor c=0.158483f //x=54.71 //y=6.2
c184 ( 50 0 ) capacitor c=9.74268e-19 //x=51.88 //y=5.335
c185 ( 49 0 ) capacitor c=0.00191414f //x=51 //y=5.335
c186 ( 42 0 ) capacitor c=0.0910382f //x=54.51 //y=2.26
c187 ( 40 0 ) capacitor c=0.103154f //x=52.66 //y=2.77
c188 ( 36 0 ) capacitor c=0.00398962f //x=52.26 //y=1.845
c189 ( 35 0 ) capacitor c=0.0137288f //x=52.575 //y=1.845
c190 ( 29 0 ) capacitor c=0.0276208f //x=52.575 //y=5.335
c191 ( 21 0 ) capacitor c=0.0169868f //x=51.795 //y=5.335
c192 ( 14 0 ) capacitor c=0.00316998f //x=50.205 //y=5.335
c193 ( 13 0 ) capacitor c=0.014258f //x=50.915 //y=5.335
c194 ( 2 0 ) capacitor c=0.0116088f //x=52.775 //y=2.77
c195 ( 1 0 ) capacitor c=0.0351856f //x=54.395 //y=2.77
r196 (  68 70 ) resistor r=26.9307 //w=0.15 //l=0.106066 //layer=ply \
 //thickness=0.18 //x=55.075 //y=4.97 //x2=55.15 //y2=5.045
r197 (  68 69 ) resistor r=148.702 //w=0.094 //l=0.29 //layer=ply \
 //thickness=0.18 //x=55.075 //y=4.97 //x2=54.785 //y2=4.97
r198 (  67 80 ) resistor r=45.1352 //w=0.168 //l=0.173853 //layer=ply \
 //thickness=0.18 //x=54.74 //y=1.4 //x2=54.7 //y2=1.555
r199 (  66 79 ) resistor r=45.1352 //w=0.168 //l=0.173853 //layer=ply \
 //thickness=0.18 //x=54.74 //y=1.055 //x2=54.7 //y2=0.9
r200 (  66 67 ) resistor r=176.904 //w=0.094 //l=0.345 //layer=ply \
 //thickness=0.18 //x=54.74 //y=1.055 //x2=54.74 //y2=1.4
r201 (  63 69 ) resistor r=22.7971 //w=0.269 //l=0.106066 //layer=ply \
 //thickness=0.18 //x=54.71 //y=5.045 //x2=54.785 //y2=4.97
r202 (  63 78 ) resistor r=35.8364 //w=0.269 //l=0.270185 //layer=ply \
 //thickness=0.18 //x=54.71 //y=5.045 //x2=54.51 //y2=4.88
r203 (  61 74 ) resistor r=10.701 //w=0.21 //l=0.115 //layer=ply \
 //thickness=0.18 //x=54.365 //y=1.555 //x2=54.25 //y2=1.555
r204 (  60 80 ) resistor r=5.52526 //w=0.168 //l=0.115 //layer=ply \
 //thickness=0.18 //x=54.585 //y=1.555 //x2=54.7 //y2=1.555
r205 (  59 73 ) resistor r=5.52526 //w=0.168 //l=0.115 //layer=ply \
 //thickness=0.18 //x=54.365 //y=0.9 //x2=54.25 //y2=0.9
r206 (  58 79 ) resistor r=5.52526 //w=0.168 //l=0.115 //layer=ply \
 //thickness=0.18 //x=54.585 //y=0.9 //x2=54.7 //y2=0.9
r207 (  58 59 ) resistor r=112.809 //w=0.094 //l=0.22 //layer=ply \
 //thickness=0.18 //x=54.585 //y=0.9 //x2=54.365 //y2=0.9
r208 (  57 76 ) resistor r=58.7805 //w=0.246 //l=0.373497 //layer=ply \
 //thickness=0.18 //x=54.21 //y=2.095 //x2=54.51 //y2=2.26
r209 (  56 74 ) resistor r=39.5823 //w=0.21 //l=0.173853 //layer=ply \
 //thickness=0.18 //x=54.21 //y=1.71 //x2=54.25 //y2=1.555
r210 (  56 57 ) resistor r=197.415 //w=0.094 //l=0.385 //layer=ply \
 //thickness=0.18 //x=54.21 //y=1.71 //x2=54.21 //y2=2.095
r211 (  55 74 ) resistor r=39.5823 //w=0.21 //l=0.173853 //layer=ply \
 //thickness=0.18 //x=54.21 //y=1.4 //x2=54.25 //y2=1.555
r212 (  54 73 ) resistor r=45.1352 //w=0.168 //l=0.173853 //layer=ply \
 //thickness=0.18 //x=54.21 //y=1.055 //x2=54.25 //y2=0.9
r213 (  54 55 ) resistor r=176.904 //w=0.094 //l=0.345 //layer=ply \
 //thickness=0.18 //x=54.21 //y=1.055 //x2=54.21 //y2=1.4
r214 (  53 70 ) resistor r=592.245 //w=0.094 //l=1.155 //layer=ply \
 //thickness=0.18 //x=55.15 //y=6.2 //x2=55.15 //y2=5.045
r215 (  52 63 ) resistor r=592.245 //w=0.094 //l=1.155 //layer=ply \
 //thickness=0.18 //x=54.71 //y=6.2 //x2=54.71 //y2=5.045
r216 (  51 60 ) resistor r=56.4043 //w=0.094 //l=0.11 //layer=ply \
 //thickness=0.18 //x=54.475 //y=1.555 //x2=54.585 //y2=1.555
r217 (  51 61 ) resistor r=56.4043 //w=0.094 //l=0.11 //layer=ply \
 //thickness=0.18 //x=54.475 //y=1.555 //x2=54.365 //y2=1.555
r218 (  47 78 ) resistor r=152 //w=0.17 //l=0.17 //layer=licon //count=1 \
 //x=54.51 //y=4.88 //x2=54.51 //y2=4.88
r219 (  45 47 ) resistor r=144.428 //w=0.187 //l=2.11 //layer=li \
 //thickness=0.1 //x=54.51 //y=2.77 //x2=54.51 //y2=4.88
r220 (  42 76 ) resistor r=152 //w=0.17 //l=0.17 //layer=licon //count=1 \
 //x=54.51 //y=2.26 //x2=54.51 //y2=2.26
r221 (  42 45 ) resistor r=34.9091 //w=0.187 //l=0.51 //layer=li \
 //thickness=0.1 //x=54.51 //y=2.26 //x2=54.51 //y2=2.77
r222 (  38 40 ) resistor r=169.754 //w=0.187 //l=2.48 //layer=li \
 //thickness=0.1 //x=52.66 //y=5.25 //x2=52.66 //y2=2.77
r223 (  37 40 ) resistor r=57.4973 //w=0.187 //l=0.84 //layer=li \
 //thickness=0.1 //x=52.66 //y=1.93 //x2=52.66 //y2=2.77
r224 (  35 37 ) resistor r=7.15173 //w=0.17 //l=0.120208 //layer=li \
 //thickness=0.1 //x=52.575 //y=1.845 //x2=52.66 //y2=1.93
r225 (  35 36 ) resistor r=21.5615 //w=0.187 //l=0.315 //layer=li \
 //thickness=0.1 //x=52.575 //y=1.845 //x2=52.26 //y2=1.845
r226 (  31 36 ) resistor r=7.15173 //w=0.17 //l=0.120208 //layer=li \
 //thickness=0.1 //x=52.175 //y=1.76 //x2=52.26 //y2=1.845
r227 (  31 81 ) resistor r=39.016 //w=0.187 //l=0.57 //layer=li \
 //thickness=0.1 //x=52.175 //y=1.76 //x2=52.175 //y2=1.19
r228 (  30 50 ) resistor r=5.4201 //w=0.17 //l=0.085 //layer=li \
 //thickness=0.1 //x=51.965 //y=5.335 //x2=51.88 //y2=5.335
r229 (  29 38 ) resistor r=7.15173 //w=0.17 //l=0.120208 //layer=li \
 //thickness=0.1 //x=52.575 //y=5.335 //x2=52.66 //y2=5.25
r230 (  29 30 ) resistor r=41.754 //w=0.187 //l=0.61 //layer=li \
 //thickness=0.1 //x=52.575 //y=5.335 //x2=51.965 //y2=5.335
r231 (  23 50 ) resistor r=1.40859 //w=0.34 //l=0.085 //layer=li \
 //thickness=0.1 //x=51.88 //y=5.42 //x2=51.88 //y2=5.335
r232 (  23 85 ) resistor r=33.1979 //w=0.187 //l=0.485 //layer=li \
 //thickness=0.1 //x=51.88 //y=5.42 //x2=51.88 //y2=5.905
r233 (  22 49 ) resistor r=5.4201 //w=0.17 //l=0.085 //layer=li \
 //thickness=0.1 //x=51.085 //y=5.335 //x2=51 //y2=5.335
r234 (  21 50 ) resistor r=5.4201 //w=0.17 //l=0.085 //layer=li \
 //thickness=0.1 //x=51.795 //y=5.335 //x2=51.88 //y2=5.335
r235 (  21 22 ) resistor r=48.5989 //w=0.187 //l=0.71 //layer=li \
 //thickness=0.1 //x=51.795 //y=5.335 //x2=51.085 //y2=5.335
r236 (  15 49 ) resistor r=1.40859 //w=0.34 //l=0.085 //layer=li \
 //thickness=0.1 //x=51 //y=5.42 //x2=51 //y2=5.335
r237 (  15 84 ) resistor r=33.1979 //w=0.187 //l=0.485 //layer=li \
 //thickness=0.1 //x=51 //y=5.42 //x2=51 //y2=5.905
r238 (  13 49 ) resistor r=5.4201 //w=0.17 //l=0.085 //layer=li \
 //thickness=0.1 //x=50.915 //y=5.335 //x2=51 //y2=5.335
r239 (  13 14 ) resistor r=48.5989 //w=0.187 //l=0.71 //layer=li \
 //thickness=0.1 //x=50.915 //y=5.335 //x2=50.205 //y2=5.335
r240 (  7 14 ) resistor r=7.15173 //w=0.17 //l=0.120208 //layer=li \
 //thickness=0.1 //x=50.12 //y=5.42 //x2=50.205 //y2=5.335
r241 (  7 83 ) resistor r=33.1979 //w=0.187 //l=0.485 //layer=li \
 //thickness=0.1 //x=50.12 //y=5.42 //x2=50.12 //y2=5.905
r242 (  6 45 ) resistor r=9.3 //w=0.17 //l=0.17 //layer=mcon //count=1 \
 //x=54.51 //y=2.77 //x2=54.51 //y2=2.77
r243 (  4 40 ) resistor r=9.3 //w=0.17 //l=0.17 //layer=mcon //count=1 \
 //x=52.66 //y=2.77 //x2=52.66 //y2=2.77
r244 (  2 4 ) resistor r=0.0717383 //w=0.224 //l=0.115 //layer=m1 \
 //thickness=0.36 //x=52.775 //y=2.77 //x2=52.66 //y2=2.77
r245 (  1 6 ) resistor r=0.0717383 //w=0.224 //l=0.115 //layer=m1 \
 //thickness=0.36 //x=54.395 //y=2.77 //x2=54.51 //y2=2.77
r246 (  1 2 ) resistor r=1.5458 //w=0.131 //l=1.62 //layer=m1 //thickness=0.36 \
 //x=54.395 //y=2.77 //x2=52.775 //y2=2.77
ends PM_TMRDFFSNRNQX1\%noxref_12

subckt PM_TMRDFFSNRNQX1\%noxref_13 ( 1 2 3 4 5 6 16 24 37 38 45 53 59 60 64 66 \
 73 74 75 76 77 78 79 80 81 82 83 87 88 89 94 96 99 100 104 105 106 111 113 \
 116 117 121 122 123 128 130 133 134 136 137 142 146 147 152 156 157 162 165 \
 167 168 169 )
c347 ( 169 0 ) capacitor c=0.023087f //x=46.925 //y=5.2
c348 ( 168 0 ) capacitor c=0.023519f //x=46.045 //y=5.2
c349 ( 167 0 ) capacitor c=0.0224735f //x=45.165 //y=5.2
c350 ( 165 0 ) capacitor c=0.00853354f //x=47.175 //y=1.095
c351 ( 162 0 ) capacitor c=0.0588394f //x=56.73 //y=4.88
c352 ( 157 0 ) capacitor c=0.0273931f //x=56.73 //y=2.095
c353 ( 156 0 ) capacitor c=0.0456313f //x=56.73 //y=2.26
c354 ( 152 0 ) capacitor c=0.0588394f //x=42.3 //y=4.88
c355 ( 147 0 ) capacitor c=0.0273931f //x=42.3 //y=2.095
c356 ( 146 0 ) capacitor c=0.0456313f //x=42.3 //y=2.26
c357 ( 142 0 ) capacitor c=0.0589949f //x=37.49 //y=4.88
c358 ( 137 0 ) capacitor c=0.0273931f //x=37.49 //y=2.095
c359 ( 136 0 ) capacitor c=0.0456313f //x=37.49 //y=2.26
c360 ( 134 0 ) capacitor c=0.0432517f //x=57.25 //y=1.44
c361 ( 133 0 ) capacitor c=0.0200379f //x=57.25 //y=1.095
c362 ( 130 0 ) capacitor c=0.0148873f //x=57.095 //y=1.595
c363 ( 128 0 ) capacitor c=0.0157803f //x=57.095 //y=0.94
c364 ( 123 0 ) capacitor c=0.0218028f //x=56.72 //y=1.75
c365 ( 122 0 ) capacitor c=0.0207459f //x=56.72 //y=1.44
c366 ( 121 0 ) capacitor c=0.0194308f //x=56.72 //y=1.095
c367 ( 117 0 ) capacitor c=0.0432517f //x=42.82 //y=1.44
c368 ( 116 0 ) capacitor c=0.0200379f //x=42.82 //y=1.095
c369 ( 113 0 ) capacitor c=0.0148873f //x=42.665 //y=1.595
c370 ( 111 0 ) capacitor c=0.0157803f //x=42.665 //y=0.94
c371 ( 106 0 ) capacitor c=0.0218028f //x=42.29 //y=1.75
c372 ( 105 0 ) capacitor c=0.0207459f //x=42.29 //y=1.44
c373 ( 104 0 ) capacitor c=0.0194308f //x=42.29 //y=1.095
c374 ( 100 0 ) capacitor c=0.0432517f //x=38.01 //y=1.44
c375 ( 99 0 ) capacitor c=0.0200379f //x=38.01 //y=1.095
c376 ( 96 0 ) capacitor c=0.0148873f //x=37.855 //y=1.595
c377 ( 94 0 ) capacitor c=0.0157803f //x=37.855 //y=0.94
c378 ( 89 0 ) capacitor c=0.0218028f //x=37.48 //y=1.75
c379 ( 88 0 ) capacitor c=0.0207459f //x=37.48 //y=1.44
c380 ( 87 0 ) capacitor c=0.0194308f //x=37.48 //y=1.095
c381 ( 83 0 ) capacitor c=0.158754f //x=56.91 //y=6.2
c382 ( 82 0 ) capacitor c=0.109949f //x=56.47 //y=6.2
c383 ( 81 0 ) capacitor c=0.158754f //x=42.48 //y=6.2
c384 ( 80 0 ) capacitor c=0.109949f //x=42.04 //y=6.2
c385 ( 79 0 ) capacitor c=0.158754f //x=37.67 //y=6.2
c386 ( 78 0 ) capacitor c=0.109949f //x=37.23 //y=6.2
c387 ( 74 0 ) capacitor c=9.74268e-19 //x=47.07 //y=5.335
c388 ( 73 0 ) capacitor c=0.00191414f //x=46.19 //y=5.335
c389 ( 66 0 ) capacitor c=0.0797834f //x=56.73 //y=2.26
c390 ( 64 0 ) capacitor c=0.104892f //x=47.85 //y=3.88
c391 ( 60 0 ) capacitor c=0.00398962f //x=47.45 //y=1.845
c392 ( 59 0 ) capacitor c=0.0137288f //x=47.765 //y=1.845
c393 ( 53 0 ) capacitor c=0.0276208f //x=47.765 //y=5.335
c394 ( 45 0 ) capacitor c=0.0169868f //x=46.985 //y=5.335
c395 ( 38 0 ) capacitor c=0.00316998f //x=45.395 //y=5.335
c396 ( 37 0 ) capacitor c=0.014258f //x=46.105 //y=5.335
c397 ( 24 0 ) capacitor c=0.0790362f //x=42.3 //y=2.26
c398 ( 16 0 ) capacitor c=0.0776243f //x=37.49 //y=2.26
c399 ( 6 0 ) capacitor c=0.0055354f //x=47.965 //y=3.88
c400 ( 5 0 ) capacitor c=0.137252f //x=56.615 //y=3.88
c401 ( 4 0 ) capacitor c=0.00533183f //x=42.415 //y=3.88
c402 ( 3 0 ) capacitor c=0.0751185f //x=47.735 //y=3.88
c403 ( 2 0 ) capacitor c=0.01364f //x=37.605 //y=3.88
c404 ( 1 0 ) capacitor c=0.0665749f //x=42.185 //y=3.88
r405 (  156 157 ) resistor r=52.7279 //w=0.214 //l=0.165 //layer=ply \
 //thickness=0.18 //x=56.73 //y=2.26 //x2=56.73 //y2=2.095
r406 (  146 147 ) resistor r=52.7279 //w=0.214 //l=0.165 //layer=ply \
 //thickness=0.18 //x=42.3 //y=2.26 //x2=42.3 //y2=2.095
r407 (  136 137 ) resistor r=52.7279 //w=0.214 //l=0.165 //layer=ply \
 //thickness=0.18 //x=37.49 //y=2.26 //x2=37.49 //y2=2.095
r408 (  134 164 ) resistor r=45.1352 //w=0.168 //l=0.173853 //layer=ply \
 //thickness=0.18 //x=57.25 //y=1.44 //x2=57.21 //y2=1.595
r409 (  133 163 ) resistor r=45.1352 //w=0.168 //l=0.173853 //layer=ply \
 //thickness=0.18 //x=57.25 //y=1.095 //x2=57.21 //y2=0.94
r410 (  133 134 ) resistor r=176.904 //w=0.094 //l=0.345 //layer=ply \
 //thickness=0.18 //x=57.25 //y=1.095 //x2=57.25 //y2=1.44
r411 (  131 160 ) resistor r=10.701 //w=0.21 //l=0.115 //layer=ply \
 //thickness=0.18 //x=56.875 //y=1.595 //x2=56.76 //y2=1.595
r412 (  130 164 ) resistor r=5.52526 //w=0.168 //l=0.115 //layer=ply \
 //thickness=0.18 //x=57.095 //y=1.595 //x2=57.21 //y2=1.595
r413 (  129 159 ) resistor r=5.52526 //w=0.168 //l=0.115 //layer=ply \
 //thickness=0.18 //x=56.875 //y=0.94 //x2=56.76 //y2=0.94
r414 (  128 163 ) resistor r=5.52526 //w=0.168 //l=0.115 //layer=ply \
 //thickness=0.18 //x=57.095 //y=0.94 //x2=57.21 //y2=0.94
r415 (  128 129 ) resistor r=112.809 //w=0.094 //l=0.22 //layer=ply \
 //thickness=0.18 //x=57.095 //y=0.94 //x2=56.875 //y2=0.94
r416 (  125 162 ) resistor r=37.236 //w=0.233 //l=0.249199 //layer=ply \
 //thickness=0.18 //x=56.91 //y=5.045 //x2=56.73 //y2=4.88
r417 (  123 160 ) resistor r=39.5823 //w=0.21 //l=0.173853 //layer=ply \
 //thickness=0.18 //x=56.72 //y=1.75 //x2=56.76 //y2=1.595
r418 (  123 157 ) resistor r=176.904 //w=0.094 //l=0.345 //layer=ply \
 //thickness=0.18 //x=56.72 //y=1.75 //x2=56.72 //y2=2.095
r419 (  122 160 ) resistor r=39.5823 //w=0.21 //l=0.173853 //layer=ply \
 //thickness=0.18 //x=56.72 //y=1.44 //x2=56.76 //y2=1.595
r420 (  121 159 ) resistor r=45.1352 //w=0.168 //l=0.173853 //layer=ply \
 //thickness=0.18 //x=56.72 //y=1.095 //x2=56.76 //y2=0.94
r421 (  121 122 ) resistor r=176.904 //w=0.094 //l=0.345 //layer=ply \
 //thickness=0.18 //x=56.72 //y=1.095 //x2=56.72 //y2=1.44
r422 (  118 162 ) resistor r=53.7854 //w=0.233 //l=0.332415 //layer=ply \
 //thickness=0.18 //x=56.47 //y=5.045 //x2=56.73 //y2=4.88
r423 (  117 154 ) resistor r=45.1352 //w=0.168 //l=0.173853 //layer=ply \
 //thickness=0.18 //x=42.82 //y=1.44 //x2=42.78 //y2=1.595
r424 (  116 153 ) resistor r=45.1352 //w=0.168 //l=0.173853 //layer=ply \
 //thickness=0.18 //x=42.82 //y=1.095 //x2=42.78 //y2=0.94
r425 (  116 117 ) resistor r=176.904 //w=0.094 //l=0.345 //layer=ply \
 //thickness=0.18 //x=42.82 //y=1.095 //x2=42.82 //y2=1.44
r426 (  114 150 ) resistor r=10.701 //w=0.21 //l=0.115 //layer=ply \
 //thickness=0.18 //x=42.445 //y=1.595 //x2=42.33 //y2=1.595
r427 (  113 154 ) resistor r=5.52526 //w=0.168 //l=0.115 //layer=ply \
 //thickness=0.18 //x=42.665 //y=1.595 //x2=42.78 //y2=1.595
r428 (  112 149 ) resistor r=5.52526 //w=0.168 //l=0.115 //layer=ply \
 //thickness=0.18 //x=42.445 //y=0.94 //x2=42.33 //y2=0.94
r429 (  111 153 ) resistor r=5.52526 //w=0.168 //l=0.115 //layer=ply \
 //thickness=0.18 //x=42.665 //y=0.94 //x2=42.78 //y2=0.94
r430 (  111 112 ) resistor r=112.809 //w=0.094 //l=0.22 //layer=ply \
 //thickness=0.18 //x=42.665 //y=0.94 //x2=42.445 //y2=0.94
r431 (  108 152 ) resistor r=37.236 //w=0.233 //l=0.249199 //layer=ply \
 //thickness=0.18 //x=42.48 //y=5.045 //x2=42.3 //y2=4.88
r432 (  106 150 ) resistor r=39.5823 //w=0.21 //l=0.173853 //layer=ply \
 //thickness=0.18 //x=42.29 //y=1.75 //x2=42.33 //y2=1.595
r433 (  106 147 ) resistor r=176.904 //w=0.094 //l=0.345 //layer=ply \
 //thickness=0.18 //x=42.29 //y=1.75 //x2=42.29 //y2=2.095
r434 (  105 150 ) resistor r=39.5823 //w=0.21 //l=0.173853 //layer=ply \
 //thickness=0.18 //x=42.29 //y=1.44 //x2=42.33 //y2=1.595
r435 (  104 149 ) resistor r=45.1352 //w=0.168 //l=0.173853 //layer=ply \
 //thickness=0.18 //x=42.29 //y=1.095 //x2=42.33 //y2=0.94
r436 (  104 105 ) resistor r=176.904 //w=0.094 //l=0.345 //layer=ply \
 //thickness=0.18 //x=42.29 //y=1.095 //x2=42.29 //y2=1.44
r437 (  101 152 ) resistor r=53.7854 //w=0.233 //l=0.332415 //layer=ply \
 //thickness=0.18 //x=42.04 //y=5.045 //x2=42.3 //y2=4.88
r438 (  100 144 ) resistor r=45.1352 //w=0.168 //l=0.173853 //layer=ply \
 //thickness=0.18 //x=38.01 //y=1.44 //x2=37.97 //y2=1.595
r439 (  99 143 ) resistor r=45.1352 //w=0.168 //l=0.173853 //layer=ply \
 //thickness=0.18 //x=38.01 //y=1.095 //x2=37.97 //y2=0.94
r440 (  99 100 ) resistor r=176.904 //w=0.094 //l=0.345 //layer=ply \
 //thickness=0.18 //x=38.01 //y=1.095 //x2=38.01 //y2=1.44
r441 (  97 140 ) resistor r=10.701 //w=0.21 //l=0.115 //layer=ply \
 //thickness=0.18 //x=37.635 //y=1.595 //x2=37.52 //y2=1.595
r442 (  96 144 ) resistor r=5.52526 //w=0.168 //l=0.115 //layer=ply \
 //thickness=0.18 //x=37.855 //y=1.595 //x2=37.97 //y2=1.595
r443 (  95 139 ) resistor r=5.52526 //w=0.168 //l=0.115 //layer=ply \
 //thickness=0.18 //x=37.635 //y=0.94 //x2=37.52 //y2=0.94
r444 (  94 143 ) resistor r=5.52526 //w=0.168 //l=0.115 //layer=ply \
 //thickness=0.18 //x=37.855 //y=0.94 //x2=37.97 //y2=0.94
r445 (  94 95 ) resistor r=112.809 //w=0.094 //l=0.22 //layer=ply \
 //thickness=0.18 //x=37.855 //y=0.94 //x2=37.635 //y2=0.94
r446 (  91 142 ) resistor r=37.236 //w=0.233 //l=0.249199 //layer=ply \
 //thickness=0.18 //x=37.67 //y=5.045 //x2=37.49 //y2=4.88
r447 (  89 140 ) resistor r=39.5823 //w=0.21 //l=0.173853 //layer=ply \
 //thickness=0.18 //x=37.48 //y=1.75 //x2=37.52 //y2=1.595
r448 (  89 137 ) resistor r=176.904 //w=0.094 //l=0.345 //layer=ply \
 //thickness=0.18 //x=37.48 //y=1.75 //x2=37.48 //y2=2.095
r449 (  88 140 ) resistor r=39.5823 //w=0.21 //l=0.173853 //layer=ply \
 //thickness=0.18 //x=37.48 //y=1.44 //x2=37.52 //y2=1.595
r450 (  87 139 ) resistor r=45.1352 //w=0.168 //l=0.173853 //layer=ply \
 //thickness=0.18 //x=37.48 //y=1.095 //x2=37.52 //y2=0.94
r451 (  87 88 ) resistor r=176.904 //w=0.094 //l=0.345 //layer=ply \
 //thickness=0.18 //x=37.48 //y=1.095 //x2=37.48 //y2=1.44
r452 (  84 142 ) resistor r=53.7854 //w=0.233 //l=0.332415 //layer=ply \
 //thickness=0.18 //x=37.23 //y=5.045 //x2=37.49 //y2=4.88
r453 (  83 125 ) resistor r=592.245 //w=0.094 //l=1.155 //layer=ply \
 //thickness=0.18 //x=56.91 //y=6.2 //x2=56.91 //y2=5.045
r454 (  82 118 ) resistor r=592.245 //w=0.094 //l=1.155 //layer=ply \
 //thickness=0.18 //x=56.47 //y=6.2 //x2=56.47 //y2=5.045
r455 (  81 108 ) resistor r=592.245 //w=0.094 //l=1.155 //layer=ply \
 //thickness=0.18 //x=42.48 //y=6.2 //x2=42.48 //y2=5.045
r456 (  80 101 ) resistor r=592.245 //w=0.094 //l=1.155 //layer=ply \
 //thickness=0.18 //x=42.04 //y=6.2 //x2=42.04 //y2=5.045
r457 (  79 91 ) resistor r=592.245 //w=0.094 //l=1.155 //layer=ply \
 //thickness=0.18 //x=37.67 //y=6.2 //x2=37.67 //y2=5.045
r458 (  78 84 ) resistor r=592.245 //w=0.094 //l=1.155 //layer=ply \
 //thickness=0.18 //x=37.23 //y=6.2 //x2=37.23 //y2=5.045
r459 (  77 130 ) resistor r=56.4043 //w=0.094 //l=0.11 //layer=ply \
 //thickness=0.18 //x=56.985 //y=1.595 //x2=57.095 //y2=1.595
r460 (  77 131 ) resistor r=56.4043 //w=0.094 //l=0.11 //layer=ply \
 //thickness=0.18 //x=56.985 //y=1.595 //x2=56.875 //y2=1.595
r461 (  76 113 ) resistor r=56.4043 //w=0.094 //l=0.11 //layer=ply \
 //thickness=0.18 //x=42.555 //y=1.595 //x2=42.665 //y2=1.595
r462 (  76 114 ) resistor r=56.4043 //w=0.094 //l=0.11 //layer=ply \
 //thickness=0.18 //x=42.555 //y=1.595 //x2=42.445 //y2=1.595
r463 (  75 96 ) resistor r=56.4043 //w=0.094 //l=0.11 //layer=ply \
 //thickness=0.18 //x=37.745 //y=1.595 //x2=37.855 //y2=1.595
r464 (  75 97 ) resistor r=56.4043 //w=0.094 //l=0.11 //layer=ply \
 //thickness=0.18 //x=37.745 //y=1.595 //x2=37.635 //y2=1.595
r465 (  71 162 ) resistor r=152 //w=0.17 //l=0.17 //layer=licon //count=1 \
 //x=56.73 //y=4.88 //x2=56.73 //y2=4.88
r466 (  69 71 ) resistor r=68.4492 //w=0.187 //l=1 //layer=li //thickness=0.1 \
 //x=56.73 //y=3.88 //x2=56.73 //y2=4.88
r467 (  66 156 ) resistor r=152 //w=0.17 //l=0.17 //layer=licon //count=1 \
 //x=56.73 //y=2.26 //x2=56.73 //y2=2.26
r468 (  66 69 ) resistor r=110.888 //w=0.187 //l=1.62 //layer=li \
 //thickness=0.1 //x=56.73 //y=2.26 //x2=56.73 //y2=3.88
r469 (  62 64 ) resistor r=93.7754 //w=0.187 //l=1.37 //layer=li \
 //thickness=0.1 //x=47.85 //y=5.25 //x2=47.85 //y2=3.88
r470 (  61 64 ) resistor r=133.476 //w=0.187 //l=1.95 //layer=li \
 //thickness=0.1 //x=47.85 //y=1.93 //x2=47.85 //y2=3.88
r471 (  59 61 ) resistor r=7.15173 //w=0.17 //l=0.120208 //layer=li \
 //thickness=0.1 //x=47.765 //y=1.845 //x2=47.85 //y2=1.93
r472 (  59 60 ) resistor r=21.5615 //w=0.187 //l=0.315 //layer=li \
 //thickness=0.1 //x=47.765 //y=1.845 //x2=47.45 //y2=1.845
r473 (  55 60 ) resistor r=7.15173 //w=0.17 //l=0.120208 //layer=li \
 //thickness=0.1 //x=47.365 //y=1.76 //x2=47.45 //y2=1.845
r474 (  55 165 ) resistor r=39.016 //w=0.187 //l=0.57 //layer=li \
 //thickness=0.1 //x=47.365 //y=1.76 //x2=47.365 //y2=1.19
r475 (  54 74 ) resistor r=5.4201 //w=0.17 //l=0.085 //layer=li \
 //thickness=0.1 //x=47.155 //y=5.335 //x2=47.07 //y2=5.335
r476 (  53 62 ) resistor r=7.15173 //w=0.17 //l=0.120208 //layer=li \
 //thickness=0.1 //x=47.765 //y=5.335 //x2=47.85 //y2=5.25
r477 (  53 54 ) resistor r=41.754 //w=0.187 //l=0.61 //layer=li \
 //thickness=0.1 //x=47.765 //y=5.335 //x2=47.155 //y2=5.335
r478 (  47 74 ) resistor r=1.40859 //w=0.34 //l=0.085 //layer=li \
 //thickness=0.1 //x=47.07 //y=5.42 //x2=47.07 //y2=5.335
r479 (  47 169 ) resistor r=33.1979 //w=0.187 //l=0.485 //layer=li \
 //thickness=0.1 //x=47.07 //y=5.42 //x2=47.07 //y2=5.905
r480 (  46 73 ) resistor r=5.4201 //w=0.17 //l=0.085 //layer=li \
 //thickness=0.1 //x=46.275 //y=5.335 //x2=46.19 //y2=5.335
r481 (  45 74 ) resistor r=5.4201 //w=0.17 //l=0.085 //layer=li \
 //thickness=0.1 //x=46.985 //y=5.335 //x2=47.07 //y2=5.335
r482 (  45 46 ) resistor r=48.5989 //w=0.187 //l=0.71 //layer=li \
 //thickness=0.1 //x=46.985 //y=5.335 //x2=46.275 //y2=5.335
r483 (  39 73 ) resistor r=1.40859 //w=0.34 //l=0.085 //layer=li \
 //thickness=0.1 //x=46.19 //y=5.42 //x2=46.19 //y2=5.335
r484 (  39 168 ) resistor r=33.1979 //w=0.187 //l=0.485 //layer=li \
 //thickness=0.1 //x=46.19 //y=5.42 //x2=46.19 //y2=5.905
r485 (  37 73 ) resistor r=5.4201 //w=0.17 //l=0.085 //layer=li \
 //thickness=0.1 //x=46.105 //y=5.335 //x2=46.19 //y2=5.335
r486 (  37 38 ) resistor r=48.5989 //w=0.187 //l=0.71 //layer=li \
 //thickness=0.1 //x=46.105 //y=5.335 //x2=45.395 //y2=5.335
r487 (  31 38 ) resistor r=7.15173 //w=0.17 //l=0.120208 //layer=li \
 //thickness=0.1 //x=45.31 //y=5.42 //x2=45.395 //y2=5.335
r488 (  31 167 ) resistor r=33.1979 //w=0.187 //l=0.485 //layer=li \
 //thickness=0.1 //x=45.31 //y=5.42 //x2=45.31 //y2=5.905
r489 (  29 152 ) resistor r=152 //w=0.17 //l=0.17 //layer=licon //count=1 \
 //x=42.3 //y=4.88 //x2=42.3 //y2=4.88
r490 (  27 29 ) resistor r=68.4492 //w=0.187 //l=1 //layer=li //thickness=0.1 \
 //x=42.3 //y=3.88 //x2=42.3 //y2=4.88
r491 (  24 146 ) resistor r=152 //w=0.17 //l=0.17 //layer=licon //count=1 \
 //x=42.3 //y=2.26 //x2=42.3 //y2=2.26
r492 (  24 27 ) resistor r=110.888 //w=0.187 //l=1.62 //layer=li \
 //thickness=0.1 //x=42.3 //y=2.26 //x2=42.3 //y2=3.88
r493 (  21 142 ) resistor r=152 //w=0.17 //l=0.17 //layer=licon //count=1 \
 //x=37.49 //y=4.88 //x2=37.49 //y2=4.88
r494 (  19 21 ) resistor r=68.4492 //w=0.187 //l=1 //layer=li //thickness=0.1 \
 //x=37.49 //y=3.88 //x2=37.49 //y2=4.88
r495 (  16 136 ) resistor r=152 //w=0.17 //l=0.17 //layer=licon //count=1 \
 //x=37.49 //y=2.26 //x2=37.49 //y2=2.26
r496 (  16 19 ) resistor r=110.888 //w=0.187 //l=1.62 //layer=li \
 //thickness=0.1 //x=37.49 //y=2.26 //x2=37.49 //y2=3.88
r497 (  14 69 ) resistor r=9.3 //w=0.17 //l=0.17 //layer=mcon //count=1 \
 //x=56.73 //y=3.88 //x2=56.73 //y2=3.88
r498 (  12 64 ) resistor r=9.3 //w=0.17 //l=0.17 //layer=mcon //count=1 \
 //x=47.85 //y=3.88 //x2=47.85 //y2=3.88
r499 (  10 27 ) resistor r=9.3 //w=0.17 //l=0.17 //layer=mcon //count=1 \
 //x=42.3 //y=3.88 //x2=42.3 //y2=3.88
r500 (  8 19 ) resistor r=9.3 //w=0.17 //l=0.17 //layer=mcon //count=1 \
 //x=37.49 //y=3.88 //x2=37.49 //y2=3.88
r501 (  6 12 ) resistor r=0.0880901 //w=0.191 //l=0.115 //layer=m1 \
 //thickness=0.36 //x=47.965 //y=3.88 //x2=47.85 //y2=3.88
r502 (  5 14 ) resistor r=0.0717383 //w=0.224 //l=0.115 //layer=m1 \
 //thickness=0.36 //x=56.615 //y=3.88 //x2=56.73 //y2=3.88
r503 (  5 6 ) resistor r=8.25382 //w=0.131 //l=8.65 //layer=m1 \
 //thickness=0.36 //x=56.615 //y=3.88 //x2=47.965 //y2=3.88
r504 (  4 10 ) resistor r=0.0880901 //w=0.191 //l=0.115 //layer=m1 \
 //thickness=0.36 //x=42.415 //y=3.88 //x2=42.3 //y2=3.88
r505 (  3 12 ) resistor r=0.0880901 //w=0.191 //l=0.115 //layer=m1 \
 //thickness=0.36 //x=47.735 //y=3.88 //x2=47.85 //y2=3.88
r506 (  3 4 ) resistor r=5.07634 //w=0.131 //l=5.32 //layer=m1 \
 //thickness=0.36 //x=47.735 //y=3.88 //x2=42.415 //y2=3.88
r507 (  2 8 ) resistor r=0.0717383 //w=0.224 //l=0.115 //layer=m1 \
 //thickness=0.36 //x=37.605 //y=3.88 //x2=37.49 //y2=3.88
r508 (  1 10 ) resistor r=0.0880901 //w=0.191 //l=0.115 //layer=m1 \
 //thickness=0.36 //x=42.185 //y=3.88 //x2=42.3 //y2=3.88
r509 (  1 2 ) resistor r=4.37023 //w=0.131 //l=4.58 //layer=m1 \
 //thickness=0.36 //x=42.185 //y=3.88 //x2=37.605 //y2=3.88
ends PM_TMRDFFSNRNQX1\%noxref_13

subckt PM_TMRDFFSNRNQX1\%noxref_14 ( 1 2 3 4 6 7 8 9 10 22 35 36 43 51 57 58 \
 62 65 67 73 77 78 82 85 86 87 88 89 90 91 92 93 97 98 99 104 106 109 110 111 \
 112 113 118 120 122 128 129 130 131 132 137 139 141 147 148 150 151 156 160 \
 161 164 172 173 176 184 186 187 188 )
c450 ( 188 0 ) capacitor c=0.023087f //x=56.545 //y=5.2
c451 ( 187 0 ) capacitor c=0.023519f //x=55.665 //y=5.2
c452 ( 186 0 ) capacitor c=0.0224735f //x=54.785 //y=5.2
c453 ( 184 0 ) capacitor c=0.00853354f //x=56.795 //y=1.095
c454 ( 176 0 ) capacitor c=0.0352016f //x=95.6 //y=4.885
c455 ( 173 0 ) capacitor c=0.0279733f //x=95.58 //y=2.095
c456 ( 172 0 ) capacitor c=0.0467621f //x=95.58 //y=2.26
c457 ( 164 0 ) capacitor c=0.03845f //x=88.96 //y=4.885
c458 ( 161 0 ) capacitor c=0.0300885f //x=88.92 //y=2.095
c459 ( 160 0 ) capacitor c=0.0504818f //x=88.92 //y=2.26
c460 ( 156 0 ) capacitor c=0.0588394f //x=51.92 //y=4.88
c461 ( 151 0 ) capacitor c=0.0273931f //x=51.92 //y=2.095
c462 ( 150 0 ) capacitor c=0.0456313f //x=51.92 //y=2.26
c463 ( 148 0 ) capacitor c=0.0237734f //x=96.145 //y=1.435
c464 ( 147 0 ) capacitor c=0.0191782f //x=96.145 //y=1.085
c465 ( 141 0 ) capacitor c=0.0351663f //x=95.99 //y=1.585
c466 ( 139 0 ) capacitor c=0.0157803f //x=95.99 //y=0.93
c467 ( 137 0 ) capacitor c=0.0374703f //x=95.985 //y=4.975
c468 ( 132 0 ) capacitor c=0.0200628f //x=95.615 //y=1.74
c469 ( 131 0 ) capacitor c=0.0168575f //x=95.615 //y=1.435
c470 ( 130 0 ) capacitor c=0.0174993f //x=95.615 //y=1.085
c471 ( 129 0 ) capacitor c=0.0435065f //x=89.485 //y=1.43
c472 ( 128 0 ) capacitor c=0.019286f //x=89.485 //y=1.085
c473 ( 122 0 ) capacitor c=0.0164316f //x=89.33 //y=1.585
c474 ( 120 0 ) capacitor c=0.0157795f //x=89.33 //y=0.93
c475 ( 118 0 ) capacitor c=0.029531f //x=89.325 //y=4.975
c476 ( 113 0 ) capacitor c=0.0206178f //x=88.955 //y=1.74
c477 ( 112 0 ) capacitor c=0.016848f //x=88.955 //y=1.43
c478 ( 111 0 ) capacitor c=0.0174777f //x=88.955 //y=1.085
c479 ( 110 0 ) capacitor c=0.0432517f //x=52.44 //y=1.44
c480 ( 109 0 ) capacitor c=0.0200379f //x=52.44 //y=1.095
c481 ( 106 0 ) capacitor c=0.0148873f //x=52.285 //y=1.595
c482 ( 104 0 ) capacitor c=0.0157803f //x=52.285 //y=0.94
c483 ( 99 0 ) capacitor c=0.0218028f //x=51.91 //y=1.75
c484 ( 98 0 ) capacitor c=0.0207459f //x=51.91 //y=1.44
c485 ( 97 0 ) capacitor c=0.0194308f //x=51.91 //y=1.095
c486 ( 93 0 ) capacitor c=0.15325f //x=96.06 //y=6.205
c487 ( 92 0 ) capacitor c=0.110411f //x=95.62 //y=6.205
c488 ( 91 0 ) capacitor c=0.154236f //x=89.4 //y=6.205
c489 ( 90 0 ) capacitor c=0.110294f //x=88.96 //y=6.205
c490 ( 89 0 ) capacitor c=0.158754f //x=52.1 //y=6.2
c491 ( 88 0 ) capacitor c=0.109949f //x=51.66 //y=6.2
c492 ( 82 0 ) capacitor c=0.00501304f //x=95.6 //y=4.885
c493 ( 78 0 ) capacitor c=9.74268e-19 //x=56.69 //y=5.335
c494 ( 77 0 ) capacitor c=0.00191414f //x=55.81 //y=5.335
c495 ( 73 0 ) capacitor c=0.0903046f //x=95.58 //y=2.26
c496 ( 67 0 ) capacitor c=0.110253f //x=88.92 //y=2.26
c497 ( 65 0 ) capacitor c=0.00669947f //x=88.92 //y=4.72
c498 ( 62 0 ) capacitor c=0.104652f //x=57.47 //y=3.51
c499 ( 58 0 ) capacitor c=0.00398962f //x=57.07 //y=1.845
c500 ( 57 0 ) capacitor c=0.0137288f //x=57.385 //y=1.845
c501 ( 51 0 ) capacitor c=0.0276208f //x=57.385 //y=5.335
c502 ( 43 0 ) capacitor c=0.0169868f //x=56.605 //y=5.335
c503 ( 36 0 ) capacitor c=0.00316998f //x=55.015 //y=5.335
c504 ( 35 0 ) capacitor c=0.014258f //x=55.725 //y=5.335
c505 ( 22 0 ) capacitor c=0.0799652f //x=51.92 //y=2.26
c506 ( 10 0 ) capacitor c=0.00672327f //x=89.035 //y=4.25
c507 ( 9 0 ) capacitor c=0.213063f //x=95.465 //y=4.25
c508 ( 8 0 ) capacitor c=0.004561f //x=65.695 //y=4.25
c509 ( 7 0 ) capacitor c=0.347024f //x=88.805 //y=4.25
c510 ( 6 0 ) capacitor c=0.00784097f //x=65.61 //y=4.165
c511 ( 4 0 ) capacitor c=0.00594726f //x=57.585 //y=3.88
c512 ( 3 0 ) capacitor c=0.14546f //x=65.525 //y=3.88
c513 ( 2 0 ) capacitor c=0.00889972f //x=52.035 //y=3.51
c514 ( 1 0 ) capacitor c=0.0876378f //x=57.355 //y=3.51
r515 (  178 179 ) resistor r=32.4568 //w=0.214 //l=0.075 //layer=ply \
 //thickness=0.18 //x=95.6 //y=4.975 //x2=95.6 //y2=5.05
r516 (  176 178 ) resistor r=20.271 //w=0.214 //l=0.09 //layer=ply \
 //thickness=0.18 //x=95.6 //y=4.885 //x2=95.6 //y2=4.975
r517 (  172 173 ) resistor r=52.7279 //w=0.214 //l=0.165 //layer=ply \
 //thickness=0.18 //x=95.58 //y=2.26 //x2=95.58 //y2=2.095
r518 (  164 166 ) resistor r=20.271 //w=0.214 //l=0.09 //layer=ply \
 //thickness=0.18 //x=88.96 //y=4.885 //x2=88.96 //y2=4.975
r519 (  160 161 ) resistor r=52.7279 //w=0.214 //l=0.165 //layer=ply \
 //thickness=0.18 //x=88.92 //y=2.26 //x2=88.92 //y2=2.095
r520 (  150 151 ) resistor r=52.7279 //w=0.214 //l=0.165 //layer=ply \
 //thickness=0.18 //x=51.92 //y=2.26 //x2=51.92 //y2=2.095
r521 (  148 183 ) resistor r=4.95774 //w=0.164 //l=0.112 //layer=ply \
 //thickness=0.18 //x=96.145 //y=1.435 //x2=96.145 //y2=1.547
r522 (  147 182 ) resistor r=45.1352 //w=0.168 //l=0.173853 //layer=ply \
 //thickness=0.18 //x=96.145 //y=1.085 //x2=96.105 //y2=0.93
r523 (  147 148 ) resistor r=179.468 //w=0.094 //l=0.35 //layer=ply \
 //thickness=0.18 //x=96.145 //y=1.085 //x2=96.145 //y2=1.435
r524 (  142 181 ) resistor r=10.8103 //w=0.211 //l=0.115 //layer=ply \
 //thickness=0.18 //x=95.77 //y=1.585 //x2=95.655 //y2=1.585
r525 (  141 183 ) resistor r=45.9962 //w=0.164 //l=0.17296 //layer=ply \
 //thickness=0.18 //x=95.99 //y=1.585 //x2=96.145 //y2=1.547
r526 (  140 180 ) resistor r=5.52526 //w=0.168 //l=0.115 //layer=ply \
 //thickness=0.18 //x=95.77 //y=0.93 //x2=95.655 //y2=0.93
r527 (  139 182 ) resistor r=5.52526 //w=0.168 //l=0.115 //layer=ply \
 //thickness=0.18 //x=95.99 //y=0.93 //x2=96.105 //y2=0.93
r528 (  139 140 ) resistor r=112.809 //w=0.094 //l=0.22 //layer=ply \
 //thickness=0.18 //x=95.99 //y=0.93 //x2=95.77 //y2=0.93
r529 (  138 178 ) resistor r=16.5046 //w=0.27 //l=0.135 //layer=ply \
 //thickness=0.18 //x=95.735 //y=4.975 //x2=95.6 //y2=4.975
r530 (  137 144 ) resistor r=26.9307 //w=0.15 //l=0.106066 //layer=ply \
 //thickness=0.18 //x=95.985 //y=4.975 //x2=96.06 //y2=5.05
r531 (  137 138 ) resistor r=128.191 //w=0.094 //l=0.25 //layer=ply \
 //thickness=0.18 //x=95.985 //y=4.975 //x2=95.735 //y2=4.975
r532 (  132 181 ) resistor r=39.5036 //w=0.211 //l=0.173853 //layer=ply \
 //thickness=0.18 //x=95.615 //y=1.74 //x2=95.655 //y2=1.585
r533 (  132 173 ) resistor r=182.032 //w=0.094 //l=0.355 //layer=ply \
 //thickness=0.18 //x=95.615 //y=1.74 //x2=95.615 //y2=2.095
r534 (  131 181 ) resistor r=38.3614 //w=0.211 //l=0.168819 //layer=ply \
 //thickness=0.18 //x=95.615 //y=1.435 //x2=95.655 //y2=1.585
r535 (  130 180 ) resistor r=45.1352 //w=0.168 //l=0.173853 //layer=ply \
 //thickness=0.18 //x=95.615 //y=1.085 //x2=95.655 //y2=0.93
r536 (  130 131 ) resistor r=179.468 //w=0.094 //l=0.35 //layer=ply \
 //thickness=0.18 //x=95.615 //y=1.085 //x2=95.615 //y2=1.435
r537 (  129 170 ) resistor r=45.1352 //w=0.168 //l=0.173853 //layer=ply \
 //thickness=0.18 //x=89.485 //y=1.43 //x2=89.445 //y2=1.585
r538 (  128 169 ) resistor r=45.1352 //w=0.168 //l=0.173853 //layer=ply \
 //thickness=0.18 //x=89.485 //y=1.085 //x2=89.445 //y2=0.93
r539 (  128 129 ) resistor r=176.904 //w=0.094 //l=0.345 //layer=ply \
 //thickness=0.18 //x=89.485 //y=1.085 //x2=89.485 //y2=1.43
r540 (  123 168 ) resistor r=10.701 //w=0.21 //l=0.115 //layer=ply \
 //thickness=0.18 //x=89.11 //y=1.585 //x2=88.995 //y2=1.585
r541 (  122 170 ) resistor r=5.52526 //w=0.168 //l=0.115 //layer=ply \
 //thickness=0.18 //x=89.33 //y=1.585 //x2=89.445 //y2=1.585
r542 (  121 167 ) resistor r=5.52526 //w=0.168 //l=0.115 //layer=ply \
 //thickness=0.18 //x=89.11 //y=0.93 //x2=88.995 //y2=0.93
r543 (  120 169 ) resistor r=5.52526 //w=0.168 //l=0.115 //layer=ply \
 //thickness=0.18 //x=89.33 //y=0.93 //x2=89.445 //y2=0.93
r544 (  120 121 ) resistor r=112.809 //w=0.094 //l=0.22 //layer=ply \
 //thickness=0.18 //x=89.33 //y=0.93 //x2=89.11 //y2=0.93
r545 (  119 166 ) resistor r=16.5046 //w=0.27 //l=0.135 //layer=ply \
 //thickness=0.18 //x=89.095 //y=4.975 //x2=88.96 //y2=4.975
r546 (  118 125 ) resistor r=26.9307 //w=0.15 //l=0.106066 //layer=ply \
 //thickness=0.18 //x=89.325 //y=4.975 //x2=89.4 //y2=5.05
r547 (  118 119 ) resistor r=117.936 //w=0.094 //l=0.23 //layer=ply \
 //thickness=0.18 //x=89.325 //y=4.975 //x2=89.095 //y2=4.975
r548 (  115 166 ) resistor r=32.4568 //w=0.214 //l=0.075 //layer=ply \
 //thickness=0.18 //x=88.96 //y=5.05 //x2=88.96 //y2=4.975
r549 (  113 168 ) resistor r=39.5823 //w=0.21 //l=0.173853 //layer=ply \
 //thickness=0.18 //x=88.955 //y=1.74 //x2=88.995 //y2=1.585
r550 (  113 161 ) resistor r=182.032 //w=0.094 //l=0.355 //layer=ply \
 //thickness=0.18 //x=88.955 //y=1.74 //x2=88.955 //y2=2.095
r551 (  112 168 ) resistor r=39.5823 //w=0.21 //l=0.173853 //layer=ply \
 //thickness=0.18 //x=88.955 //y=1.43 //x2=88.995 //y2=1.585
r552 (  111 167 ) resistor r=45.1352 //w=0.168 //l=0.173853 //layer=ply \
 //thickness=0.18 //x=88.955 //y=1.085 //x2=88.995 //y2=0.93
r553 (  111 112 ) resistor r=176.904 //w=0.094 //l=0.345 //layer=ply \
 //thickness=0.18 //x=88.955 //y=1.085 //x2=88.955 //y2=1.43
r554 (  110 158 ) resistor r=45.1352 //w=0.168 //l=0.173853 //layer=ply \
 //thickness=0.18 //x=52.44 //y=1.44 //x2=52.4 //y2=1.595
r555 (  109 157 ) resistor r=45.1352 //w=0.168 //l=0.173853 //layer=ply \
 //thickness=0.18 //x=52.44 //y=1.095 //x2=52.4 //y2=0.94
r556 (  109 110 ) resistor r=176.904 //w=0.094 //l=0.345 //layer=ply \
 //thickness=0.18 //x=52.44 //y=1.095 //x2=52.44 //y2=1.44
r557 (  107 154 ) resistor r=10.701 //w=0.21 //l=0.115 //layer=ply \
 //thickness=0.18 //x=52.065 //y=1.595 //x2=51.95 //y2=1.595
r558 (  106 158 ) resistor r=5.52526 //w=0.168 //l=0.115 //layer=ply \
 //thickness=0.18 //x=52.285 //y=1.595 //x2=52.4 //y2=1.595
r559 (  105 153 ) resistor r=5.52526 //w=0.168 //l=0.115 //layer=ply \
 //thickness=0.18 //x=52.065 //y=0.94 //x2=51.95 //y2=0.94
r560 (  104 157 ) resistor r=5.52526 //w=0.168 //l=0.115 //layer=ply \
 //thickness=0.18 //x=52.285 //y=0.94 //x2=52.4 //y2=0.94
r561 (  104 105 ) resistor r=112.809 //w=0.094 //l=0.22 //layer=ply \
 //thickness=0.18 //x=52.285 //y=0.94 //x2=52.065 //y2=0.94
r562 (  101 156 ) resistor r=37.236 //w=0.233 //l=0.249199 //layer=ply \
 //thickness=0.18 //x=52.1 //y=5.045 //x2=51.92 //y2=4.88
r563 (  99 154 ) resistor r=39.5823 //w=0.21 //l=0.173853 //layer=ply \
 //thickness=0.18 //x=51.91 //y=1.75 //x2=51.95 //y2=1.595
r564 (  99 151 ) resistor r=176.904 //w=0.094 //l=0.345 //layer=ply \
 //thickness=0.18 //x=51.91 //y=1.75 //x2=51.91 //y2=2.095
r565 (  98 154 ) resistor r=39.5823 //w=0.21 //l=0.173853 //layer=ply \
 //thickness=0.18 //x=51.91 //y=1.44 //x2=51.95 //y2=1.595
r566 (  97 153 ) resistor r=45.1352 //w=0.168 //l=0.173853 //layer=ply \
 //thickness=0.18 //x=51.91 //y=1.095 //x2=51.95 //y2=0.94
r567 (  97 98 ) resistor r=176.904 //w=0.094 //l=0.345 //layer=ply \
 //thickness=0.18 //x=51.91 //y=1.095 //x2=51.91 //y2=1.44
r568 (  94 156 ) resistor r=53.7854 //w=0.233 //l=0.332415 //layer=ply \
 //thickness=0.18 //x=51.66 //y=5.045 //x2=51.92 //y2=4.88
r569 (  93 144 ) resistor r=592.245 //w=0.094 //l=1.155 //layer=ply \
 //thickness=0.18 //x=96.06 //y=6.205 //x2=96.06 //y2=5.05
r570 (  92 179 ) resistor r=592.245 //w=0.094 //l=1.155 //layer=ply \
 //thickness=0.18 //x=95.62 //y=6.205 //x2=95.62 //y2=5.05
r571 (  91 125 ) resistor r=592.245 //w=0.094 //l=1.155 //layer=ply \
 //thickness=0.18 //x=89.4 //y=6.205 //x2=89.4 //y2=5.05
r572 (  90 115 ) resistor r=592.245 //w=0.094 //l=1.155 //layer=ply \
 //thickness=0.18 //x=88.96 //y=6.205 //x2=88.96 //y2=5.05
r573 (  89 101 ) resistor r=592.245 //w=0.094 //l=1.155 //layer=ply \
 //thickness=0.18 //x=52.1 //y=6.2 //x2=52.1 //y2=5.045
r574 (  88 94 ) resistor r=592.245 //w=0.094 //l=1.155 //layer=ply \
 //thickness=0.18 //x=51.66 //y=6.2 //x2=51.66 //y2=5.045
r575 (  87 141 ) resistor r=56.4043 //w=0.094 //l=0.11 //layer=ply \
 //thickness=0.18 //x=95.88 //y=1.585 //x2=95.99 //y2=1.585
r576 (  87 142 ) resistor r=56.4043 //w=0.094 //l=0.11 //layer=ply \
 //thickness=0.18 //x=95.88 //y=1.585 //x2=95.77 //y2=1.585
r577 (  86 122 ) resistor r=56.4043 //w=0.094 //l=0.11 //layer=ply \
 //thickness=0.18 //x=89.22 //y=1.585 //x2=89.33 //y2=1.585
r578 (  86 123 ) resistor r=56.4043 //w=0.094 //l=0.11 //layer=ply \
 //thickness=0.18 //x=89.22 //y=1.585 //x2=89.11 //y2=1.585
r579 (  85 106 ) resistor r=56.4043 //w=0.094 //l=0.11 //layer=ply \
 //thickness=0.18 //x=52.175 //y=1.595 //x2=52.285 //y2=1.595
r580 (  85 107 ) resistor r=56.4043 //w=0.094 //l=0.11 //layer=ply \
 //thickness=0.18 //x=52.175 //y=1.595 //x2=52.065 //y2=1.595
r581 (  82 176 ) resistor r=152 //w=0.17 //l=0.17 //layer=licon //count=1 \
 //x=95.6 //y=4.885 //x2=95.6 //y2=4.885
r582 (  82 83 ) resistor r=10.3507 //w=0.207 //l=0.165 //layer=li \
 //thickness=0.1 //x=95.59 //y=4.885 //x2=95.59 //y2=4.72
r583 (  80 164 ) resistor r=152 //w=0.17 //l=0.17 //layer=licon //count=1 \
 //x=88.96 //y=4.885 //x2=88.96 //y2=4.885
r584 (  76 83 ) resistor r=32.1711 //w=0.187 //l=0.47 //layer=li \
 //thickness=0.1 //x=95.58 //y=4.25 //x2=95.58 //y2=4.72
r585 (  73 172 ) resistor r=152 //w=0.17 //l=0.17 //layer=licon //count=1 \
 //x=95.58 //y=2.26 //x2=95.58 //y2=2.26
r586 (  73 76 ) resistor r=136.214 //w=0.187 //l=1.99 //layer=li \
 //thickness=0.1 //x=95.58 //y=2.26 //x2=95.58 //y2=4.25
r587 (  67 160 ) resistor r=152 //w=0.17 //l=0.17 //layer=licon //count=1 \
 //x=88.92 //y=2.26 //x2=88.92 //y2=2.26
r588 (  67 70 ) resistor r=136.214 //w=0.187 //l=1.99 //layer=li \
 //thickness=0.1 //x=88.92 //y=2.26 //x2=88.92 //y2=4.25
r589 (  65 80 ) resistor r=11.2426 //w=0.191 //l=0.174714 //layer=li \
 //thickness=0.1 //x=88.92 //y=4.72 //x2=88.94 //y2=4.885
r590 (  65 70 ) resistor r=32.1711 //w=0.187 //l=0.47 //layer=li \
 //thickness=0.1 //x=88.92 //y=4.72 //x2=88.92 //y2=4.25
r591 (  62 64 ) resistor r=25.3262 //w=0.187 //l=0.37 //layer=li \
 //thickness=0.1 //x=57.47 //y=3.51 //x2=57.47 //y2=3.88
r592 (  60 64 ) resistor r=93.7754 //w=0.187 //l=1.37 //layer=li \
 //thickness=0.1 //x=57.47 //y=5.25 //x2=57.47 //y2=3.88
r593 (  59 62 ) resistor r=108.15 //w=0.187 //l=1.58 //layer=li \
 //thickness=0.1 //x=57.47 //y=1.93 //x2=57.47 //y2=3.51
r594 (  57 59 ) resistor r=7.15173 //w=0.17 //l=0.120208 //layer=li \
 //thickness=0.1 //x=57.385 //y=1.845 //x2=57.47 //y2=1.93
r595 (  57 58 ) resistor r=21.5615 //w=0.187 //l=0.315 //layer=li \
 //thickness=0.1 //x=57.385 //y=1.845 //x2=57.07 //y2=1.845
r596 (  53 58 ) resistor r=7.15173 //w=0.17 //l=0.120208 //layer=li \
 //thickness=0.1 //x=56.985 //y=1.76 //x2=57.07 //y2=1.845
r597 (  53 184 ) resistor r=39.016 //w=0.187 //l=0.57 //layer=li \
 //thickness=0.1 //x=56.985 //y=1.76 //x2=56.985 //y2=1.19
r598 (  52 78 ) resistor r=5.4201 //w=0.17 //l=0.085 //layer=li \
 //thickness=0.1 //x=56.775 //y=5.335 //x2=56.69 //y2=5.335
r599 (  51 60 ) resistor r=7.15173 //w=0.17 //l=0.120208 //layer=li \
 //thickness=0.1 //x=57.385 //y=5.335 //x2=57.47 //y2=5.25
r600 (  51 52 ) resistor r=41.754 //w=0.187 //l=0.61 //layer=li \
 //thickness=0.1 //x=57.385 //y=5.335 //x2=56.775 //y2=5.335
r601 (  45 78 ) resistor r=1.40859 //w=0.34 //l=0.085 //layer=li \
 //thickness=0.1 //x=56.69 //y=5.42 //x2=56.69 //y2=5.335
r602 (  45 188 ) resistor r=33.1979 //w=0.187 //l=0.485 //layer=li \
 //thickness=0.1 //x=56.69 //y=5.42 //x2=56.69 //y2=5.905
r603 (  44 77 ) resistor r=5.4201 //w=0.17 //l=0.085 //layer=li \
 //thickness=0.1 //x=55.895 //y=5.335 //x2=55.81 //y2=5.335
r604 (  43 78 ) resistor r=5.4201 //w=0.17 //l=0.085 //layer=li \
 //thickness=0.1 //x=56.605 //y=5.335 //x2=56.69 //y2=5.335
r605 (  43 44 ) resistor r=48.5989 //w=0.187 //l=0.71 //layer=li \
 //thickness=0.1 //x=56.605 //y=5.335 //x2=55.895 //y2=5.335
r606 (  37 77 ) resistor r=1.40859 //w=0.34 //l=0.085 //layer=li \
 //thickness=0.1 //x=55.81 //y=5.42 //x2=55.81 //y2=5.335
r607 (  37 187 ) resistor r=33.1979 //w=0.187 //l=0.485 //layer=li \
 //thickness=0.1 //x=55.81 //y=5.42 //x2=55.81 //y2=5.905
r608 (  35 77 ) resistor r=5.4201 //w=0.17 //l=0.085 //layer=li \
 //thickness=0.1 //x=55.725 //y=5.335 //x2=55.81 //y2=5.335
r609 (  35 36 ) resistor r=48.5989 //w=0.187 //l=0.71 //layer=li \
 //thickness=0.1 //x=55.725 //y=5.335 //x2=55.015 //y2=5.335
r610 (  29 36 ) resistor r=7.15173 //w=0.17 //l=0.120208 //layer=li \
 //thickness=0.1 //x=54.93 //y=5.42 //x2=55.015 //y2=5.335
r611 (  29 186 ) resistor r=33.1979 //w=0.187 //l=0.485 //layer=li \
 //thickness=0.1 //x=54.93 //y=5.42 //x2=54.93 //y2=5.905
r612 (  27 156 ) resistor r=152 //w=0.17 //l=0.17 //layer=licon //count=1 \
 //x=51.92 //y=4.88 //x2=51.92 //y2=4.88
r613 (  25 27 ) resistor r=93.7754 //w=0.187 //l=1.37 //layer=li \
 //thickness=0.1 //x=51.92 //y=3.51 //x2=51.92 //y2=4.88
r614 (  22 150 ) resistor r=152 //w=0.17 //l=0.17 //layer=licon //count=1 \
 //x=51.92 //y=2.26 //x2=51.92 //y2=2.26
r615 (  22 25 ) resistor r=85.5615 //w=0.187 //l=1.25 //layer=li \
 //thickness=0.1 //x=51.92 //y=2.26 //x2=51.92 //y2=3.51
r616 (  20 76 ) resistor r=9.3 //w=0.17 //l=0.17 //layer=mcon //count=1 \
 //x=95.58 //y=4.25 //x2=95.58 //y2=4.25
r617 (  18 70 ) resistor r=9.3 //w=0.17 //l=0.17 //layer=mcon //count=1 \
 //x=88.92 //y=4.25 //x2=88.92 //y2=4.25
r618 (  16 62 ) resistor r=9.3 //w=0.17 //l=0.17 //layer=mcon //count=1 \
 //x=57.47 //y=3.51 //x2=57.47 //y2=3.51
r619 (  14 64 ) resistor r=9.3 //w=0.17 //l=0.17 //layer=mcon //count=1 \
 //x=57.47 //y=3.88 //x2=57.47 //y2=3.88
r620 (  12 25 ) resistor r=9.3 //w=0.17 //l=0.17 //layer=mcon //count=1 \
 //x=51.92 //y=3.51 //x2=51.92 //y2=3.51
r621 (  10 18 ) resistor r=0.0880901 //w=0.191 //l=0.115 //layer=m1 \
 //thickness=0.36 //x=89.035 //y=4.25 //x2=88.92 //y2=4.25
r622 (  9 20 ) resistor r=0.0717383 //w=0.224 //l=0.115 //layer=m1 \
 //thickness=0.36 //x=95.465 //y=4.25 //x2=95.58 //y2=4.25
r623 (  9 10 ) resistor r=6.1355 //w=0.131 //l=6.43 //layer=m1 \
 //thickness=0.36 //x=95.465 //y=4.25 //x2=89.035 //y2=4.25
r624 (  7 18 ) resistor r=0.0880901 //w=0.191 //l=0.115 //layer=m1 \
 //thickness=0.36 //x=88.805 //y=4.25 //x2=88.92 //y2=4.25
r625 (  7 8 ) resistor r=22.0515 //w=0.131 //l=23.11 //layer=m1 \
 //thickness=0.36 //x=88.805 //y=4.25 //x2=65.695 //y2=4.25
r626 (  6 8 ) resistor r=0.0698411 //w=0.17 //l=0.120208 //layer=m1 \
 //thickness=0.36 //x=65.61 //y=4.165 //x2=65.695 //y2=4.25
r627 (  5 6 ) resistor r=0.19084 //w=0.131 //l=0.2 //layer=m1 //thickness=0.36 \
 //x=65.61 //y=3.965 //x2=65.61 //y2=4.165
r628 (  4 14 ) resistor r=0.0717383 //w=0.224 //l=0.115 //layer=m1 \
 //thickness=0.36 //x=57.585 //y=3.88 //x2=57.47 //y2=3.88
r629 (  3 5 ) resistor r=0.0698411 //w=0.17 //l=0.120208 //layer=m1 \
 //thickness=0.36 //x=65.525 //y=3.88 //x2=65.61 //y2=3.965
r630 (  3 4 ) resistor r=7.57634 //w=0.131 //l=7.94 //layer=m1 \
 //thickness=0.36 //x=65.525 //y=3.88 //x2=57.585 //y2=3.88
r631 (  2 12 ) resistor r=0.0717383 //w=0.224 //l=0.115 //layer=m1 \
 //thickness=0.36 //x=52.035 //y=3.51 //x2=51.92 //y2=3.51
r632 (  1 16 ) resistor r=0.0717383 //w=0.224 //l=0.115 //layer=m1 \
 //thickness=0.36 //x=57.355 //y=3.51 //x2=57.47 //y2=3.51
r633 (  1 2 ) resistor r=5.07634 //w=0.131 //l=5.32 //layer=m1 \
 //thickness=0.36 //x=57.355 //y=3.51 //x2=52.035 //y2=3.51
ends PM_TMRDFFSNRNQX1\%noxref_14

subckt PM_TMRDFFSNRNQX1\%D ( 1 2 3 4 11 12 13 14 15 16 17 18 19 20 21 22 23 24 \
 26 40 51 60 61 62 63 64 65 66 67 68 69 70 71 72 73 75 81 82 83 84 88 89 90 91 \
 92 94 100 101 102 103 107 108 109 110 111 113 119 120 121 122 )
c341 ( 122 0 ) capacitor c=0.0547611f //x=59.595 //y=4.97
c342 ( 121 0 ) capacitor c=0.0294456f //x=59.885 //y=4.97
c343 ( 120 0 ) capacitor c=0.0347816f //x=59.55 //y=1.4
c344 ( 119 0 ) capacitor c=0.0187487f //x=59.55 //y=1.055
c345 ( 113 0 ) capacitor c=0.0137055f //x=59.395 //y=1.555
c346 ( 111 0 ) capacitor c=0.0149861f //x=59.395 //y=0.9
c347 ( 110 0 ) capacitor c=0.096037f //x=59.02 //y=2.095
c348 ( 109 0 ) capacitor c=0.0228993f //x=59.02 //y=1.71
c349 ( 108 0 ) capacitor c=0.0234352f //x=59.02 //y=1.4
c350 ( 107 0 ) capacitor c=0.0198724f //x=59.02 //y=1.055
c351 ( 103 0 ) capacitor c=0.0547611f //x=30.735 //y=4.97
c352 ( 102 0 ) capacitor c=0.0294456f //x=31.025 //y=4.97
c353 ( 101 0 ) capacitor c=0.0347816f //x=30.69 //y=1.4
c354 ( 100 0 ) capacitor c=0.0187487f //x=30.69 //y=1.055
c355 ( 94 0 ) capacitor c=0.0137055f //x=30.535 //y=1.555
c356 ( 92 0 ) capacitor c=0.0149861f //x=30.535 //y=0.9
c357 ( 91 0 ) capacitor c=0.096037f //x=30.16 //y=2.095
c358 ( 90 0 ) capacitor c=0.0228993f //x=30.16 //y=1.71
c359 ( 89 0 ) capacitor c=0.0234352f //x=30.16 //y=1.4
c360 ( 88 0 ) capacitor c=0.0198724f //x=30.16 //y=1.055
c361 ( 84 0 ) capacitor c=0.0558341f //x=1.875 //y=4.97
c362 ( 83 0 ) capacitor c=0.0298189f //x=2.165 //y=4.97
c363 ( 82 0 ) capacitor c=0.0347816f //x=1.83 //y=1.4
c364 ( 81 0 ) capacitor c=0.0187487f //x=1.83 //y=1.055
c365 ( 75 0 ) capacitor c=0.0137055f //x=1.675 //y=1.555
c366 ( 73 0 ) capacitor c=0.0149861f //x=1.675 //y=0.9
c367 ( 72 0 ) capacitor c=0.102158f //x=1.3 //y=2.095
c368 ( 71 0 ) capacitor c=0.0229444f //x=1.3 //y=1.71
c369 ( 70 0 ) capacitor c=0.0234352f //x=1.3 //y=1.4
c370 ( 69 0 ) capacitor c=0.0198724f //x=1.3 //y=1.055
c371 ( 68 0 ) capacitor c=0.109949f //x=59.96 //y=6.2
c372 ( 67 0 ) capacitor c=0.158483f //x=59.52 //y=6.2
c373 ( 66 0 ) capacitor c=0.109949f //x=31.1 //y=6.2
c374 ( 65 0 ) capacitor c=0.158483f //x=30.66 //y=6.2
c375 ( 64 0 ) capacitor c=0.110114f //x=2.24 //y=6.2
c376 ( 63 0 ) capacitor c=0.158956f //x=1.8 //y=6.2
c377 ( 51 0 ) capacitor c=0.0959046f //x=59.32 //y=2.26
c378 ( 40 0 ) capacitor c=0.0991769f //x=30.46 //y=2.26
c379 ( 26 0 ) capacitor c=0.124371f //x=1.6 //y=2.26
c380 ( 4 0 ) capacitor c=0.00590384f //x=30.575 //y=4.25
c381 ( 3 0 ) capacitor c=0.426259f //x=59.205 //y=4.25
c382 ( 2 0 ) capacitor c=0.0231516f //x=1.715 //y=4.25
c383 ( 1 0 ) capacitor c=0.512603f //x=30.345 //y=4.25
r384 (  121 123 ) resistor r=26.9307 //w=0.15 //l=0.106066 //layer=ply \
 //thickness=0.18 //x=59.885 //y=4.97 //x2=59.96 //y2=5.045
r385 (  121 122 ) resistor r=148.702 //w=0.094 //l=0.29 //layer=ply \
 //thickness=0.18 //x=59.885 //y=4.97 //x2=59.595 //y2=4.97
r386 (  120 149 ) resistor r=45.1352 //w=0.168 //l=0.173853 //layer=ply \
 //thickness=0.18 //x=59.55 //y=1.4 //x2=59.51 //y2=1.555
r387 (  119 148 ) resistor r=45.1352 //w=0.168 //l=0.173853 //layer=ply \
 //thickness=0.18 //x=59.55 //y=1.055 //x2=59.51 //y2=0.9
r388 (  119 120 ) resistor r=176.904 //w=0.094 //l=0.345 //layer=ply \
 //thickness=0.18 //x=59.55 //y=1.055 //x2=59.55 //y2=1.4
r389 (  116 122 ) resistor r=22.7971 //w=0.269 //l=0.106066 //layer=ply \
 //thickness=0.18 //x=59.52 //y=5.045 //x2=59.595 //y2=4.97
r390 (  116 147 ) resistor r=35.8364 //w=0.269 //l=0.270185 //layer=ply \
 //thickness=0.18 //x=59.52 //y=5.045 //x2=59.32 //y2=4.88
r391 (  114 143 ) resistor r=10.701 //w=0.21 //l=0.115 //layer=ply \
 //thickness=0.18 //x=59.175 //y=1.555 //x2=59.06 //y2=1.555
r392 (  113 149 ) resistor r=5.52526 //w=0.168 //l=0.115 //layer=ply \
 //thickness=0.18 //x=59.395 //y=1.555 //x2=59.51 //y2=1.555
r393 (  112 142 ) resistor r=5.52526 //w=0.168 //l=0.115 //layer=ply \
 //thickness=0.18 //x=59.175 //y=0.9 //x2=59.06 //y2=0.9
r394 (  111 148 ) resistor r=5.52526 //w=0.168 //l=0.115 //layer=ply \
 //thickness=0.18 //x=59.395 //y=0.9 //x2=59.51 //y2=0.9
r395 (  111 112 ) resistor r=112.809 //w=0.094 //l=0.22 //layer=ply \
 //thickness=0.18 //x=59.395 //y=0.9 //x2=59.175 //y2=0.9
r396 (  110 145 ) resistor r=58.7805 //w=0.246 //l=0.373497 //layer=ply \
 //thickness=0.18 //x=59.02 //y=2.095 //x2=59.32 //y2=2.26
r397 (  109 143 ) resistor r=39.5823 //w=0.21 //l=0.173853 //layer=ply \
 //thickness=0.18 //x=59.02 //y=1.71 //x2=59.06 //y2=1.555
r398 (  109 110 ) resistor r=197.415 //w=0.094 //l=0.385 //layer=ply \
 //thickness=0.18 //x=59.02 //y=1.71 //x2=59.02 //y2=2.095
r399 (  108 143 ) resistor r=39.5823 //w=0.21 //l=0.173853 //layer=ply \
 //thickness=0.18 //x=59.02 //y=1.4 //x2=59.06 //y2=1.555
r400 (  107 142 ) resistor r=45.1352 //w=0.168 //l=0.173853 //layer=ply \
 //thickness=0.18 //x=59.02 //y=1.055 //x2=59.06 //y2=0.9
r401 (  107 108 ) resistor r=176.904 //w=0.094 //l=0.345 //layer=ply \
 //thickness=0.18 //x=59.02 //y=1.055 //x2=59.02 //y2=1.4
r402 (  102 104 ) resistor r=26.9307 //w=0.15 //l=0.106066 //layer=ply \
 //thickness=0.18 //x=31.025 //y=4.97 //x2=31.1 //y2=5.045
r403 (  102 103 ) resistor r=148.702 //w=0.094 //l=0.29 //layer=ply \
 //thickness=0.18 //x=31.025 //y=4.97 //x2=30.735 //y2=4.97
r404 (  101 141 ) resistor r=45.1352 //w=0.168 //l=0.173853 //layer=ply \
 //thickness=0.18 //x=30.69 //y=1.4 //x2=30.65 //y2=1.555
r405 (  100 140 ) resistor r=45.1352 //w=0.168 //l=0.173853 //layer=ply \
 //thickness=0.18 //x=30.69 //y=1.055 //x2=30.65 //y2=0.9
r406 (  100 101 ) resistor r=176.904 //w=0.094 //l=0.345 //layer=ply \
 //thickness=0.18 //x=30.69 //y=1.055 //x2=30.69 //y2=1.4
r407 (  97 103 ) resistor r=22.7971 //w=0.269 //l=0.106066 //layer=ply \
 //thickness=0.18 //x=30.66 //y=5.045 //x2=30.735 //y2=4.97
r408 (  97 139 ) resistor r=35.8364 //w=0.269 //l=0.270185 //layer=ply \
 //thickness=0.18 //x=30.66 //y=5.045 //x2=30.46 //y2=4.88
r409 (  95 135 ) resistor r=10.701 //w=0.21 //l=0.115 //layer=ply \
 //thickness=0.18 //x=30.315 //y=1.555 //x2=30.2 //y2=1.555
r410 (  94 141 ) resistor r=5.52526 //w=0.168 //l=0.115 //layer=ply \
 //thickness=0.18 //x=30.535 //y=1.555 //x2=30.65 //y2=1.555
r411 (  93 134 ) resistor r=5.52526 //w=0.168 //l=0.115 //layer=ply \
 //thickness=0.18 //x=30.315 //y=0.9 //x2=30.2 //y2=0.9
r412 (  92 140 ) resistor r=5.52526 //w=0.168 //l=0.115 //layer=ply \
 //thickness=0.18 //x=30.535 //y=0.9 //x2=30.65 //y2=0.9
r413 (  92 93 ) resistor r=112.809 //w=0.094 //l=0.22 //layer=ply \
 //thickness=0.18 //x=30.535 //y=0.9 //x2=30.315 //y2=0.9
r414 (  91 137 ) resistor r=58.7805 //w=0.246 //l=0.373497 //layer=ply \
 //thickness=0.18 //x=30.16 //y=2.095 //x2=30.46 //y2=2.26
r415 (  90 135 ) resistor r=39.5823 //w=0.21 //l=0.173853 //layer=ply \
 //thickness=0.18 //x=30.16 //y=1.71 //x2=30.2 //y2=1.555
r416 (  90 91 ) resistor r=197.415 //w=0.094 //l=0.385 //layer=ply \
 //thickness=0.18 //x=30.16 //y=1.71 //x2=30.16 //y2=2.095
r417 (  89 135 ) resistor r=39.5823 //w=0.21 //l=0.173853 //layer=ply \
 //thickness=0.18 //x=30.16 //y=1.4 //x2=30.2 //y2=1.555
r418 (  88 134 ) resistor r=45.1352 //w=0.168 //l=0.173853 //layer=ply \
 //thickness=0.18 //x=30.16 //y=1.055 //x2=30.2 //y2=0.9
r419 (  88 89 ) resistor r=176.904 //w=0.094 //l=0.345 //layer=ply \
 //thickness=0.18 //x=30.16 //y=1.055 //x2=30.16 //y2=1.4
r420 (  83 85 ) resistor r=26.9307 //w=0.15 //l=0.106066 //layer=ply \
 //thickness=0.18 //x=2.165 //y=4.97 //x2=2.24 //y2=5.045
r421 (  83 84 ) resistor r=148.702 //w=0.094 //l=0.29 //layer=ply \
 //thickness=0.18 //x=2.165 //y=4.97 //x2=1.875 //y2=4.97
r422 (  82 133 ) resistor r=45.1352 //w=0.168 //l=0.173853 //layer=ply \
 //thickness=0.18 //x=1.83 //y=1.4 //x2=1.79 //y2=1.555
r423 (  81 132 ) resistor r=45.1352 //w=0.168 //l=0.173853 //layer=ply \
 //thickness=0.18 //x=1.83 //y=1.055 //x2=1.79 //y2=0.9
r424 (  81 82 ) resistor r=176.904 //w=0.094 //l=0.345 //layer=ply \
 //thickness=0.18 //x=1.83 //y=1.055 //x2=1.83 //y2=1.4
r425 (  78 84 ) resistor r=22.7971 //w=0.269 //l=0.106066 //layer=ply \
 //thickness=0.18 //x=1.8 //y=5.045 //x2=1.875 //y2=4.97
r426 (  78 131 ) resistor r=35.8364 //w=0.269 //l=0.270185 //layer=ply \
 //thickness=0.18 //x=1.8 //y=5.045 //x2=1.6 //y2=4.88
r427 (  76 127 ) resistor r=10.701 //w=0.21 //l=0.115 //layer=ply \
 //thickness=0.18 //x=1.455 //y=1.555 //x2=1.34 //y2=1.555
r428 (  75 133 ) resistor r=5.52526 //w=0.168 //l=0.115 //layer=ply \
 //thickness=0.18 //x=1.675 //y=1.555 //x2=1.79 //y2=1.555
r429 (  74 126 ) resistor r=5.52526 //w=0.168 //l=0.115 //layer=ply \
 //thickness=0.18 //x=1.455 //y=0.9 //x2=1.34 //y2=0.9
r430 (  73 132 ) resistor r=5.52526 //w=0.168 //l=0.115 //layer=ply \
 //thickness=0.18 //x=1.675 //y=0.9 //x2=1.79 //y2=0.9
r431 (  73 74 ) resistor r=112.809 //w=0.094 //l=0.22 //layer=ply \
 //thickness=0.18 //x=1.675 //y=0.9 //x2=1.455 //y2=0.9
r432 (  72 129 ) resistor r=58.7805 //w=0.246 //l=0.373497 //layer=ply \
 //thickness=0.18 //x=1.3 //y=2.095 //x2=1.6 //y2=2.26
r433 (  71 127 ) resistor r=39.5823 //w=0.21 //l=0.173853 //layer=ply \
 //thickness=0.18 //x=1.3 //y=1.71 //x2=1.34 //y2=1.555
r434 (  71 72 ) resistor r=197.415 //w=0.094 //l=0.385 //layer=ply \
 //thickness=0.18 //x=1.3 //y=1.71 //x2=1.3 //y2=2.095
r435 (  70 127 ) resistor r=39.5823 //w=0.21 //l=0.173853 //layer=ply \
 //thickness=0.18 //x=1.3 //y=1.4 //x2=1.34 //y2=1.555
r436 (  69 126 ) resistor r=45.1352 //w=0.168 //l=0.173853 //layer=ply \
 //thickness=0.18 //x=1.3 //y=1.055 //x2=1.34 //y2=0.9
r437 (  69 70 ) resistor r=176.904 //w=0.094 //l=0.345 //layer=ply \
 //thickness=0.18 //x=1.3 //y=1.055 //x2=1.3 //y2=1.4
r438 (  68 123 ) resistor r=592.245 //w=0.094 //l=1.155 //layer=ply \
 //thickness=0.18 //x=59.96 //y=6.2 //x2=59.96 //y2=5.045
r439 (  67 116 ) resistor r=592.245 //w=0.094 //l=1.155 //layer=ply \
 //thickness=0.18 //x=59.52 //y=6.2 //x2=59.52 //y2=5.045
r440 (  66 104 ) resistor r=592.245 //w=0.094 //l=1.155 //layer=ply \
 //thickness=0.18 //x=31.1 //y=6.2 //x2=31.1 //y2=5.045
r441 (  65 97 ) resistor r=592.245 //w=0.094 //l=1.155 //layer=ply \
 //thickness=0.18 //x=30.66 //y=6.2 //x2=30.66 //y2=5.045
r442 (  64 85 ) resistor r=592.245 //w=0.094 //l=1.155 //layer=ply \
 //thickness=0.18 //x=2.24 //y=6.2 //x2=2.24 //y2=5.045
r443 (  63 78 ) resistor r=592.245 //w=0.094 //l=1.155 //layer=ply \
 //thickness=0.18 //x=1.8 //y=6.2 //x2=1.8 //y2=5.045
r444 (  62 113 ) resistor r=56.4043 //w=0.094 //l=0.11 //layer=ply \
 //thickness=0.18 //x=59.285 //y=1.555 //x2=59.395 //y2=1.555
r445 (  62 114 ) resistor r=56.4043 //w=0.094 //l=0.11 //layer=ply \
 //thickness=0.18 //x=59.285 //y=1.555 //x2=59.175 //y2=1.555
r446 (  61 94 ) resistor r=56.4043 //w=0.094 //l=0.11 //layer=ply \
 //thickness=0.18 //x=30.425 //y=1.555 //x2=30.535 //y2=1.555
r447 (  61 95 ) resistor r=56.4043 //w=0.094 //l=0.11 //layer=ply \
 //thickness=0.18 //x=30.425 //y=1.555 //x2=30.315 //y2=1.555
r448 (  60 75 ) resistor r=56.4043 //w=0.094 //l=0.11 //layer=ply \
 //thickness=0.18 //x=1.565 //y=1.555 //x2=1.675 //y2=1.555
r449 (  60 76 ) resistor r=56.4043 //w=0.094 //l=0.11 //layer=ply \
 //thickness=0.18 //x=1.565 //y=1.555 //x2=1.455 //y2=1.555
r450 (  58 147 ) resistor r=152 //w=0.17 //l=0.17 //layer=licon //count=1 \
 //x=59.32 //y=4.88 //x2=59.32 //y2=4.88
r451 (  51 145 ) resistor r=152 //w=0.17 //l=0.17 //layer=licon //count=1 \
 //x=59.32 //y=2.26 //x2=59.32 //y2=2.26
r452 (  48 139 ) resistor r=152 //w=0.17 //l=0.17 //layer=licon //count=1 \
 //x=30.46 //y=4.88 //x2=30.46 //y2=4.88
r453 (  40 137 ) resistor r=152 //w=0.17 //l=0.17 //layer=licon //count=1 \
 //x=30.46 //y=2.26 //x2=30.46 //y2=2.26
r454 (  37 131 ) resistor r=152 //w=0.17 //l=0.17 //layer=licon //count=1 \
 //x=1.6 //y=4.88 //x2=1.6 //y2=4.88
r455 (  26 129 ) resistor r=152 //w=0.17 //l=0.17 //layer=licon //count=1 \
 //x=1.6 //y=2.26 //x2=1.6 //y2=2.26
r456 (  24 58 ) resistor r=43.123 //w=0.187 //l=0.63 //layer=li \
 //thickness=0.1 //x=59.32 //y=4.25 //x2=59.32 //y2=4.88
r457 (  23 24 ) resistor r=50.6524 //w=0.187 //l=0.74 //layer=li \
 //thickness=0.1 //x=59.32 //y=3.51 //x2=59.32 //y2=4.25
r458 (  22 23 ) resistor r=50.6524 //w=0.187 //l=0.74 //layer=li \
 //thickness=0.1 //x=59.32 //y=2.77 //x2=59.32 //y2=3.51
r459 (  22 51 ) resistor r=34.9091 //w=0.187 //l=0.51 //layer=li \
 //thickness=0.1 //x=59.32 //y=2.77 //x2=59.32 //y2=2.26
r460 (  21 48 ) resistor r=43.123 //w=0.187 //l=0.63 //layer=li \
 //thickness=0.1 //x=30.46 //y=4.25 //x2=30.46 //y2=4.88
r461 (  20 21 ) resistor r=25.3262 //w=0.187 //l=0.37 //layer=li \
 //thickness=0.1 //x=30.46 //y=3.88 //x2=30.46 //y2=4.25
r462 (  19 20 ) resistor r=25.3262 //w=0.187 //l=0.37 //layer=li \
 //thickness=0.1 //x=30.46 //y=3.51 //x2=30.46 //y2=3.88
r463 (  18 19 ) resistor r=50.6524 //w=0.187 //l=0.74 //layer=li \
 //thickness=0.1 //x=30.46 //y=2.77 //x2=30.46 //y2=3.51
r464 (  18 40 ) resistor r=34.9091 //w=0.187 //l=0.51 //layer=li \
 //thickness=0.1 //x=30.46 //y=2.77 //x2=30.46 //y2=2.26
r465 (  17 37 ) resistor r=17.7968 //w=0.187 //l=0.26 //layer=li \
 //thickness=0.1 //x=1.6 //y=4.62 //x2=1.6 //y2=4.88
r466 (  16 17 ) resistor r=25.3262 //w=0.187 //l=0.37 //layer=li \
 //thickness=0.1 //x=1.6 //y=4.25 //x2=1.6 //y2=4.62
r467 (  15 16 ) resistor r=25.3262 //w=0.187 //l=0.37 //layer=li \
 //thickness=0.1 //x=1.6 //y=3.88 //x2=1.6 //y2=4.25
r468 (  14 15 ) resistor r=25.3262 //w=0.187 //l=0.37 //layer=li \
 //thickness=0.1 //x=1.6 //y=3.51 //x2=1.6 //y2=3.88
r469 (  13 14 ) resistor r=25.3262 //w=0.187 //l=0.37 //layer=li \
 //thickness=0.1 //x=1.6 //y=3.14 //x2=1.6 //y2=3.51
r470 (  12 13 ) resistor r=25.3262 //w=0.187 //l=0.37 //layer=li \
 //thickness=0.1 //x=1.6 //y=2.77 //x2=1.6 //y2=3.14
r471 (  11 12 ) resistor r=25.3262 //w=0.187 //l=0.37 //layer=li \
 //thickness=0.1 //x=1.6 //y=2.4 //x2=1.6 //y2=2.77
r472 (  11 26 ) resistor r=9.58289 //w=0.187 //l=0.14 //layer=li \
 //thickness=0.1 //x=1.6 //y=2.4 //x2=1.6 //y2=2.26
r473 (  10 24 ) resistor r=9.3 //w=0.17 //l=0.17 //layer=mcon //count=1 \
 //x=59.32 //y=4.25 //x2=59.32 //y2=4.25
r474 (  8 21 ) resistor r=9.3 //w=0.17 //l=0.17 //layer=mcon //count=1 \
 //x=30.46 //y=4.25 //x2=30.46 //y2=4.25
r475 (  6 16 ) resistor r=9.3 //w=0.17 //l=0.17 //layer=mcon //count=1 //x=1.6 \
 //y=4.25 //x2=1.6 //y2=4.25
r476 (  4 8 ) resistor r=0.0880901 //w=0.191 //l=0.115 //layer=m1 \
 //thickness=0.36 //x=30.575 //y=4.25 //x2=30.46 //y2=4.25
r477 (  3 10 ) resistor r=0.0717383 //w=0.224 //l=0.115 //layer=m1 \
 //thickness=0.36 //x=59.205 //y=4.25 //x2=59.32 //y2=4.25
r478 (  3 4 ) resistor r=27.3187 //w=0.131 //l=28.63 //layer=m1 \
 //thickness=0.36 //x=59.205 //y=4.25 //x2=30.575 //y2=4.25
r479 (  2 6 ) resistor r=0.0738079 //w=0.207 //l=0.115 //layer=m1 \
 //thickness=0.36 //x=1.715 //y=4.25 //x2=1.6 //y2=4.25
r480 (  1 8 ) resistor r=0.0880901 //w=0.191 //l=0.115 //layer=m1 \
 //thickness=0.36 //x=30.345 //y=4.25 //x2=30.46 //y2=4.25
r481 (  1 2 ) resistor r=27.3187 //w=0.131 //l=28.63 //layer=m1 \
 //thickness=0.36 //x=30.345 //y=4.25 //x2=1.715 //y2=4.25
ends PM_TMRDFFSNRNQX1\%D

subckt PM_TMRDFFSNRNQX1\%noxref_16 ( 1 2 3 4 17 18 25 33 39 40 44 46 54 61 62 \
 63 64 65 66 67 68 69 70 71 72 73 75 81 82 83 84 88 89 90 91 92 94 100 101 102 \
 103 123 125 126 127 )
c253 ( 127 0 ) capacitor c=0.023087f //x=61.355 //y=5.2
c254 ( 126 0 ) capacitor c=0.023519f //x=60.475 //y=5.2
c255 ( 125 0 ) capacitor c=0.0224735f //x=59.595 //y=5.2
c256 ( 123 0 ) capacitor c=0.00853354f //x=61.605 //y=1.095
c257 ( 103 0 ) capacitor c=0.0547611f //x=69.215 //y=4.97
c258 ( 102 0 ) capacitor c=0.0294456f //x=69.505 //y=4.97
c259 ( 101 0 ) capacitor c=0.0347816f //x=69.17 //y=1.4
c260 ( 100 0 ) capacitor c=0.0187487f //x=69.17 //y=1.055
c261 ( 94 0 ) capacitor c=0.0137055f //x=69.015 //y=1.555
c262 ( 92 0 ) capacitor c=0.0149861f //x=69.015 //y=0.9
c263 ( 91 0 ) capacitor c=0.096037f //x=68.64 //y=2.095
c264 ( 90 0 ) capacitor c=0.0228993f //x=68.64 //y=1.71
c265 ( 89 0 ) capacitor c=0.0234352f //x=68.64 //y=1.4
c266 ( 88 0 ) capacitor c=0.0198724f //x=68.64 //y=1.055
c267 ( 84 0 ) capacitor c=0.0549166f //x=64.405 //y=4.97
c268 ( 83 0 ) capacitor c=0.0294456f //x=64.695 //y=4.97
c269 ( 82 0 ) capacitor c=0.0347816f //x=64.36 //y=1.4
c270 ( 81 0 ) capacitor c=0.0187487f //x=64.36 //y=1.055
c271 ( 75 0 ) capacitor c=0.0137055f //x=64.205 //y=1.555
c272 ( 73 0 ) capacitor c=0.0149861f //x=64.205 //y=0.9
c273 ( 72 0 ) capacitor c=0.096037f //x=63.83 //y=2.095
c274 ( 71 0 ) capacitor c=0.0228993f //x=63.83 //y=1.71
c275 ( 70 0 ) capacitor c=0.0234352f //x=63.83 //y=1.4
c276 ( 69 0 ) capacitor c=0.0198724f //x=63.83 //y=1.055
c277 ( 68 0 ) capacitor c=0.109949f //x=69.58 //y=6.2
c278 ( 67 0 ) capacitor c=0.158483f //x=69.14 //y=6.2
c279 ( 66 0 ) capacitor c=0.109949f //x=64.77 //y=6.2
c280 ( 65 0 ) capacitor c=0.158483f //x=64.33 //y=6.2
c281 ( 62 0 ) capacitor c=9.74268e-19 //x=61.5 //y=5.335
c282 ( 61 0 ) capacitor c=0.00191414f //x=60.62 //y=5.335
c283 ( 54 0 ) capacitor c=0.0913827f //x=68.94 //y=2.26
c284 ( 46 0 ) capacitor c=0.093372f //x=64.13 //y=2.26
c285 ( 44 0 ) capacitor c=0.105725f //x=62.28 //y=2.77
c286 ( 40 0 ) capacitor c=0.00398962f //x=61.88 //y=1.845
c287 ( 39 0 ) capacitor c=0.0137288f //x=62.195 //y=1.845
c288 ( 33 0 ) capacitor c=0.0276208f //x=62.195 //y=5.335
c289 ( 25 0 ) capacitor c=0.0169868f //x=61.415 //y=5.335
c290 ( 18 0 ) capacitor c=0.00316998f //x=59.825 //y=5.335
c291 ( 17 0 ) capacitor c=0.014258f //x=60.535 //y=5.335
c292 ( 4 0 ) capacitor c=0.00401138f //x=64.245 //y=2.77
c293 ( 3 0 ) capacitor c=0.0706637f //x=68.825 //y=2.77
c294 ( 2 0 ) capacitor c=0.0120752f //x=62.395 //y=2.77
c295 ( 1 0 ) capacitor c=0.0233554f //x=64.015 //y=2.77
r296 (  102 104 ) resistor r=26.9307 //w=0.15 //l=0.106066 //layer=ply \
 //thickness=0.18 //x=69.505 //y=4.97 //x2=69.58 //y2=5.045
r297 (  102 103 ) resistor r=148.702 //w=0.094 //l=0.29 //layer=ply \
 //thickness=0.18 //x=69.505 //y=4.97 //x2=69.215 //y2=4.97
r298 (  101 122 ) resistor r=45.1352 //w=0.168 //l=0.173853 //layer=ply \
 //thickness=0.18 //x=69.17 //y=1.4 //x2=69.13 //y2=1.555
r299 (  100 121 ) resistor r=45.1352 //w=0.168 //l=0.173853 //layer=ply \
 //thickness=0.18 //x=69.17 //y=1.055 //x2=69.13 //y2=0.9
r300 (  100 101 ) resistor r=176.904 //w=0.094 //l=0.345 //layer=ply \
 //thickness=0.18 //x=69.17 //y=1.055 //x2=69.17 //y2=1.4
r301 (  97 103 ) resistor r=22.7971 //w=0.269 //l=0.106066 //layer=ply \
 //thickness=0.18 //x=69.14 //y=5.045 //x2=69.215 //y2=4.97
r302 (  97 120 ) resistor r=35.8364 //w=0.269 //l=0.270185 //layer=ply \
 //thickness=0.18 //x=69.14 //y=5.045 //x2=68.94 //y2=4.88
r303 (  95 116 ) resistor r=10.701 //w=0.21 //l=0.115 //layer=ply \
 //thickness=0.18 //x=68.795 //y=1.555 //x2=68.68 //y2=1.555
r304 (  94 122 ) resistor r=5.52526 //w=0.168 //l=0.115 //layer=ply \
 //thickness=0.18 //x=69.015 //y=1.555 //x2=69.13 //y2=1.555
r305 (  93 115 ) resistor r=5.52526 //w=0.168 //l=0.115 //layer=ply \
 //thickness=0.18 //x=68.795 //y=0.9 //x2=68.68 //y2=0.9
r306 (  92 121 ) resistor r=5.52526 //w=0.168 //l=0.115 //layer=ply \
 //thickness=0.18 //x=69.015 //y=0.9 //x2=69.13 //y2=0.9
r307 (  92 93 ) resistor r=112.809 //w=0.094 //l=0.22 //layer=ply \
 //thickness=0.18 //x=69.015 //y=0.9 //x2=68.795 //y2=0.9
r308 (  91 118 ) resistor r=58.7805 //w=0.246 //l=0.373497 //layer=ply \
 //thickness=0.18 //x=68.64 //y=2.095 //x2=68.94 //y2=2.26
r309 (  90 116 ) resistor r=39.5823 //w=0.21 //l=0.173853 //layer=ply \
 //thickness=0.18 //x=68.64 //y=1.71 //x2=68.68 //y2=1.555
r310 (  90 91 ) resistor r=197.415 //w=0.094 //l=0.385 //layer=ply \
 //thickness=0.18 //x=68.64 //y=1.71 //x2=68.64 //y2=2.095
r311 (  89 116 ) resistor r=39.5823 //w=0.21 //l=0.173853 //layer=ply \
 //thickness=0.18 //x=68.64 //y=1.4 //x2=68.68 //y2=1.555
r312 (  88 115 ) resistor r=45.1352 //w=0.168 //l=0.173853 //layer=ply \
 //thickness=0.18 //x=68.64 //y=1.055 //x2=68.68 //y2=0.9
r313 (  88 89 ) resistor r=176.904 //w=0.094 //l=0.345 //layer=ply \
 //thickness=0.18 //x=68.64 //y=1.055 //x2=68.64 //y2=1.4
r314 (  83 85 ) resistor r=26.9307 //w=0.15 //l=0.106066 //layer=ply \
 //thickness=0.18 //x=64.695 //y=4.97 //x2=64.77 //y2=5.045
r315 (  83 84 ) resistor r=148.702 //w=0.094 //l=0.29 //layer=ply \
 //thickness=0.18 //x=64.695 //y=4.97 //x2=64.405 //y2=4.97
r316 (  82 114 ) resistor r=45.1352 //w=0.168 //l=0.173853 //layer=ply \
 //thickness=0.18 //x=64.36 //y=1.4 //x2=64.32 //y2=1.555
r317 (  81 113 ) resistor r=45.1352 //w=0.168 //l=0.173853 //layer=ply \
 //thickness=0.18 //x=64.36 //y=1.055 //x2=64.32 //y2=0.9
r318 (  81 82 ) resistor r=176.904 //w=0.094 //l=0.345 //layer=ply \
 //thickness=0.18 //x=64.36 //y=1.055 //x2=64.36 //y2=1.4
r319 (  78 84 ) resistor r=22.7971 //w=0.269 //l=0.106066 //layer=ply \
 //thickness=0.18 //x=64.33 //y=5.045 //x2=64.405 //y2=4.97
r320 (  78 112 ) resistor r=35.8364 //w=0.269 //l=0.270185 //layer=ply \
 //thickness=0.18 //x=64.33 //y=5.045 //x2=64.13 //y2=4.88
r321 (  76 108 ) resistor r=10.701 //w=0.21 //l=0.115 //layer=ply \
 //thickness=0.18 //x=63.985 //y=1.555 //x2=63.87 //y2=1.555
r322 (  75 114 ) resistor r=5.52526 //w=0.168 //l=0.115 //layer=ply \
 //thickness=0.18 //x=64.205 //y=1.555 //x2=64.32 //y2=1.555
r323 (  74 107 ) resistor r=5.52526 //w=0.168 //l=0.115 //layer=ply \
 //thickness=0.18 //x=63.985 //y=0.9 //x2=63.87 //y2=0.9
r324 (  73 113 ) resistor r=5.52526 //w=0.168 //l=0.115 //layer=ply \
 //thickness=0.18 //x=64.205 //y=0.9 //x2=64.32 //y2=0.9
r325 (  73 74 ) resistor r=112.809 //w=0.094 //l=0.22 //layer=ply \
 //thickness=0.18 //x=64.205 //y=0.9 //x2=63.985 //y2=0.9
r326 (  72 110 ) resistor r=58.7805 //w=0.246 //l=0.373497 //layer=ply \
 //thickness=0.18 //x=63.83 //y=2.095 //x2=64.13 //y2=2.26
r327 (  71 108 ) resistor r=39.5823 //w=0.21 //l=0.173853 //layer=ply \
 //thickness=0.18 //x=63.83 //y=1.71 //x2=63.87 //y2=1.555
r328 (  71 72 ) resistor r=197.415 //w=0.094 //l=0.385 //layer=ply \
 //thickness=0.18 //x=63.83 //y=1.71 //x2=63.83 //y2=2.095
r329 (  70 108 ) resistor r=39.5823 //w=0.21 //l=0.173853 //layer=ply \
 //thickness=0.18 //x=63.83 //y=1.4 //x2=63.87 //y2=1.555
r330 (  69 107 ) resistor r=45.1352 //w=0.168 //l=0.173853 //layer=ply \
 //thickness=0.18 //x=63.83 //y=1.055 //x2=63.87 //y2=0.9
r331 (  69 70 ) resistor r=176.904 //w=0.094 //l=0.345 //layer=ply \
 //thickness=0.18 //x=63.83 //y=1.055 //x2=63.83 //y2=1.4
r332 (  68 104 ) resistor r=592.245 //w=0.094 //l=1.155 //layer=ply \
 //thickness=0.18 //x=69.58 //y=6.2 //x2=69.58 //y2=5.045
r333 (  67 97 ) resistor r=592.245 //w=0.094 //l=1.155 //layer=ply \
 //thickness=0.18 //x=69.14 //y=6.2 //x2=69.14 //y2=5.045
r334 (  66 85 ) resistor r=592.245 //w=0.094 //l=1.155 //layer=ply \
 //thickness=0.18 //x=64.77 //y=6.2 //x2=64.77 //y2=5.045
r335 (  65 78 ) resistor r=592.245 //w=0.094 //l=1.155 //layer=ply \
 //thickness=0.18 //x=64.33 //y=6.2 //x2=64.33 //y2=5.045
r336 (  64 94 ) resistor r=56.4043 //w=0.094 //l=0.11 //layer=ply \
 //thickness=0.18 //x=68.905 //y=1.555 //x2=69.015 //y2=1.555
r337 (  64 95 ) resistor r=56.4043 //w=0.094 //l=0.11 //layer=ply \
 //thickness=0.18 //x=68.905 //y=1.555 //x2=68.795 //y2=1.555
r338 (  63 75 ) resistor r=56.4043 //w=0.094 //l=0.11 //layer=ply \
 //thickness=0.18 //x=64.095 //y=1.555 //x2=64.205 //y2=1.555
r339 (  63 76 ) resistor r=56.4043 //w=0.094 //l=0.11 //layer=ply \
 //thickness=0.18 //x=64.095 //y=1.555 //x2=63.985 //y2=1.555
r340 (  59 120 ) resistor r=152 //w=0.17 //l=0.17 //layer=licon //count=1 \
 //x=68.94 //y=4.88 //x2=68.94 //y2=4.88
r341 (  57 59 ) resistor r=144.428 //w=0.187 //l=2.11 //layer=li \
 //thickness=0.1 //x=68.94 //y=2.77 //x2=68.94 //y2=4.88
r342 (  54 118 ) resistor r=152 //w=0.17 //l=0.17 //layer=licon //count=1 \
 //x=68.94 //y=2.26 //x2=68.94 //y2=2.26
r343 (  54 57 ) resistor r=34.9091 //w=0.187 //l=0.51 //layer=li \
 //thickness=0.1 //x=68.94 //y=2.26 //x2=68.94 //y2=2.77
r344 (  51 112 ) resistor r=152 //w=0.17 //l=0.17 //layer=licon //count=1 \
 //x=64.13 //y=4.88 //x2=64.13 //y2=4.88
r345 (  49 51 ) resistor r=144.428 //w=0.187 //l=2.11 //layer=li \
 //thickness=0.1 //x=64.13 //y=2.77 //x2=64.13 //y2=4.88
r346 (  46 110 ) resistor r=152 //w=0.17 //l=0.17 //layer=licon //count=1 \
 //x=64.13 //y=2.26 //x2=64.13 //y2=2.26
r347 (  46 49 ) resistor r=34.9091 //w=0.187 //l=0.51 //layer=li \
 //thickness=0.1 //x=64.13 //y=2.26 //x2=64.13 //y2=2.77
r348 (  42 44 ) resistor r=169.754 //w=0.187 //l=2.48 //layer=li \
 //thickness=0.1 //x=62.28 //y=5.25 //x2=62.28 //y2=2.77
r349 (  41 44 ) resistor r=57.4973 //w=0.187 //l=0.84 //layer=li \
 //thickness=0.1 //x=62.28 //y=1.93 //x2=62.28 //y2=2.77
r350 (  39 41 ) resistor r=7.15173 //w=0.17 //l=0.120208 //layer=li \
 //thickness=0.1 //x=62.195 //y=1.845 //x2=62.28 //y2=1.93
r351 (  39 40 ) resistor r=21.5615 //w=0.187 //l=0.315 //layer=li \
 //thickness=0.1 //x=62.195 //y=1.845 //x2=61.88 //y2=1.845
r352 (  35 40 ) resistor r=7.15173 //w=0.17 //l=0.120208 //layer=li \
 //thickness=0.1 //x=61.795 //y=1.76 //x2=61.88 //y2=1.845
r353 (  35 123 ) resistor r=39.016 //w=0.187 //l=0.57 //layer=li \
 //thickness=0.1 //x=61.795 //y=1.76 //x2=61.795 //y2=1.19
r354 (  34 62 ) resistor r=5.4201 //w=0.17 //l=0.085 //layer=li \
 //thickness=0.1 //x=61.585 //y=5.335 //x2=61.5 //y2=5.335
r355 (  33 42 ) resistor r=7.15173 //w=0.17 //l=0.120208 //layer=li \
 //thickness=0.1 //x=62.195 //y=5.335 //x2=62.28 //y2=5.25
r356 (  33 34 ) resistor r=41.754 //w=0.187 //l=0.61 //layer=li \
 //thickness=0.1 //x=62.195 //y=5.335 //x2=61.585 //y2=5.335
r357 (  27 62 ) resistor r=1.40859 //w=0.34 //l=0.085 //layer=li \
 //thickness=0.1 //x=61.5 //y=5.42 //x2=61.5 //y2=5.335
r358 (  27 127 ) resistor r=33.1979 //w=0.187 //l=0.485 //layer=li \
 //thickness=0.1 //x=61.5 //y=5.42 //x2=61.5 //y2=5.905
r359 (  26 61 ) resistor r=5.4201 //w=0.17 //l=0.085 //layer=li \
 //thickness=0.1 //x=60.705 //y=5.335 //x2=60.62 //y2=5.335
r360 (  25 62 ) resistor r=5.4201 //w=0.17 //l=0.085 //layer=li \
 //thickness=0.1 //x=61.415 //y=5.335 //x2=61.5 //y2=5.335
r361 (  25 26 ) resistor r=48.5989 //w=0.187 //l=0.71 //layer=li \
 //thickness=0.1 //x=61.415 //y=5.335 //x2=60.705 //y2=5.335
r362 (  19 61 ) resistor r=1.40859 //w=0.34 //l=0.085 //layer=li \
 //thickness=0.1 //x=60.62 //y=5.42 //x2=60.62 //y2=5.335
r363 (  19 126 ) resistor r=33.1979 //w=0.187 //l=0.485 //layer=li \
 //thickness=0.1 //x=60.62 //y=5.42 //x2=60.62 //y2=5.905
r364 (  17 61 ) resistor r=5.4201 //w=0.17 //l=0.085 //layer=li \
 //thickness=0.1 //x=60.535 //y=5.335 //x2=60.62 //y2=5.335
r365 (  17 18 ) resistor r=48.5989 //w=0.187 //l=0.71 //layer=li \
 //thickness=0.1 //x=60.535 //y=5.335 //x2=59.825 //y2=5.335
r366 (  11 18 ) resistor r=7.15173 //w=0.17 //l=0.120208 //layer=li \
 //thickness=0.1 //x=59.74 //y=5.42 //x2=59.825 //y2=5.335
r367 (  11 125 ) resistor r=33.1979 //w=0.187 //l=0.485 //layer=li \
 //thickness=0.1 //x=59.74 //y=5.42 //x2=59.74 //y2=5.905
r368 (  10 57 ) resistor r=9.3 //w=0.17 //l=0.17 //layer=mcon //count=1 \
 //x=68.94 //y=2.77 //x2=68.94 //y2=2.77
r369 (  8 49 ) resistor r=9.3 //w=0.17 //l=0.17 //layer=mcon //count=1 \
 //x=64.13 //y=2.77 //x2=64.13 //y2=2.77
r370 (  6 44 ) resistor r=9.3 //w=0.17 //l=0.17 //layer=mcon //count=1 \
 //x=62.28 //y=2.77 //x2=62.28 //y2=2.77
r371 (  4 8 ) resistor r=0.0880901 //w=0.191 //l=0.115 //layer=m1 \
 //thickness=0.36 //x=64.245 //y=2.77 //x2=64.13 //y2=2.77
r372 (  3 10 ) resistor r=0.0717383 //w=0.224 //l=0.115 //layer=m1 \
 //thickness=0.36 //x=68.825 //y=2.77 //x2=68.94 //y2=2.77
r373 (  3 4 ) resistor r=4.37023 //w=0.131 //l=4.58 //layer=m1 \
 //thickness=0.36 //x=68.825 //y=2.77 //x2=64.245 //y2=2.77
r374 (  2 6 ) resistor r=0.0717383 //w=0.224 //l=0.115 //layer=m1 \
 //thickness=0.36 //x=62.395 //y=2.77 //x2=62.28 //y2=2.77
r375 (  1 8 ) resistor r=0.0880901 //w=0.191 //l=0.115 //layer=m1 \
 //thickness=0.36 //x=64.015 //y=2.77 //x2=64.13 //y2=2.77
r376 (  1 2 ) resistor r=1.5458 //w=0.131 //l=1.62 //layer=m1 //thickness=0.36 \
 //x=64.015 //y=2.77 //x2=62.395 //y2=2.77
ends PM_TMRDFFSNRNQX1\%noxref_16

subckt PM_TMRDFFSNRNQX1\%noxref_17 ( 1 2 13 14 21 29 35 36 40 42 49 50 51 52 \
 53 54 55 56 57 58 60 66 67 68 69 81 83 84 85 )
c168 ( 85 0 ) capacitor c=0.023087f //x=70.975 //y=5.2
c169 ( 84 0 ) capacitor c=0.023519f //x=70.095 //y=5.2
c170 ( 83 0 ) capacitor c=0.0224735f //x=69.215 //y=5.2
c171 ( 81 0 ) capacitor c=0.00853354f //x=71.225 //y=1.095
c172 ( 69 0 ) capacitor c=0.0547611f //x=74.025 //y=4.97
c173 ( 68 0 ) capacitor c=0.0294456f //x=74.315 //y=4.97
c174 ( 67 0 ) capacitor c=0.0347816f //x=73.98 //y=1.4
c175 ( 66 0 ) capacitor c=0.0187487f //x=73.98 //y=1.055
c176 ( 60 0 ) capacitor c=0.0137055f //x=73.825 //y=1.555
c177 ( 58 0 ) capacitor c=0.0149861f //x=73.825 //y=0.9
c178 ( 57 0 ) capacitor c=0.096037f //x=73.45 //y=2.095
c179 ( 56 0 ) capacitor c=0.0228993f //x=73.45 //y=1.71
c180 ( 55 0 ) capacitor c=0.0234352f //x=73.45 //y=1.4
c181 ( 54 0 ) capacitor c=0.0198724f //x=73.45 //y=1.055
c182 ( 53 0 ) capacitor c=0.109949f //x=74.39 //y=6.2
c183 ( 52 0 ) capacitor c=0.158483f //x=73.95 //y=6.2
c184 ( 50 0 ) capacitor c=9.74268e-19 //x=71.12 //y=5.335
c185 ( 49 0 ) capacitor c=0.00191414f //x=70.24 //y=5.335
c186 ( 42 0 ) capacitor c=0.0911502f //x=73.75 //y=2.26
c187 ( 40 0 ) capacitor c=0.103494f //x=71.9 //y=2.77
c188 ( 36 0 ) capacitor c=0.00398962f //x=71.5 //y=1.845
c189 ( 35 0 ) capacitor c=0.0137288f //x=71.815 //y=1.845
c190 ( 29 0 ) capacitor c=0.0276208f //x=71.815 //y=5.335
c191 ( 21 0 ) capacitor c=0.0169868f //x=71.035 //y=5.335
c192 ( 14 0 ) capacitor c=0.00316998f //x=69.445 //y=5.335
c193 ( 13 0 ) capacitor c=0.014258f //x=70.155 //y=5.335
c194 ( 2 0 ) capacitor c=0.00808366f //x=72.015 //y=2.77
c195 ( 1 0 ) capacitor c=0.0351856f //x=73.635 //y=2.77
r196 (  68 70 ) resistor r=26.9307 //w=0.15 //l=0.106066 //layer=ply \
 //thickness=0.18 //x=74.315 //y=4.97 //x2=74.39 //y2=5.045
r197 (  68 69 ) resistor r=148.702 //w=0.094 //l=0.29 //layer=ply \
 //thickness=0.18 //x=74.315 //y=4.97 //x2=74.025 //y2=4.97
r198 (  67 80 ) resistor r=45.1352 //w=0.168 //l=0.173853 //layer=ply \
 //thickness=0.18 //x=73.98 //y=1.4 //x2=73.94 //y2=1.555
r199 (  66 79 ) resistor r=45.1352 //w=0.168 //l=0.173853 //layer=ply \
 //thickness=0.18 //x=73.98 //y=1.055 //x2=73.94 //y2=0.9
r200 (  66 67 ) resistor r=176.904 //w=0.094 //l=0.345 //layer=ply \
 //thickness=0.18 //x=73.98 //y=1.055 //x2=73.98 //y2=1.4
r201 (  63 69 ) resistor r=22.7971 //w=0.269 //l=0.106066 //layer=ply \
 //thickness=0.18 //x=73.95 //y=5.045 //x2=74.025 //y2=4.97
r202 (  63 78 ) resistor r=35.8364 //w=0.269 //l=0.270185 //layer=ply \
 //thickness=0.18 //x=73.95 //y=5.045 //x2=73.75 //y2=4.88
r203 (  61 74 ) resistor r=10.701 //w=0.21 //l=0.115 //layer=ply \
 //thickness=0.18 //x=73.605 //y=1.555 //x2=73.49 //y2=1.555
r204 (  60 80 ) resistor r=5.52526 //w=0.168 //l=0.115 //layer=ply \
 //thickness=0.18 //x=73.825 //y=1.555 //x2=73.94 //y2=1.555
r205 (  59 73 ) resistor r=5.52526 //w=0.168 //l=0.115 //layer=ply \
 //thickness=0.18 //x=73.605 //y=0.9 //x2=73.49 //y2=0.9
r206 (  58 79 ) resistor r=5.52526 //w=0.168 //l=0.115 //layer=ply \
 //thickness=0.18 //x=73.825 //y=0.9 //x2=73.94 //y2=0.9
r207 (  58 59 ) resistor r=112.809 //w=0.094 //l=0.22 //layer=ply \
 //thickness=0.18 //x=73.825 //y=0.9 //x2=73.605 //y2=0.9
r208 (  57 76 ) resistor r=58.7805 //w=0.246 //l=0.373497 //layer=ply \
 //thickness=0.18 //x=73.45 //y=2.095 //x2=73.75 //y2=2.26
r209 (  56 74 ) resistor r=39.5823 //w=0.21 //l=0.173853 //layer=ply \
 //thickness=0.18 //x=73.45 //y=1.71 //x2=73.49 //y2=1.555
r210 (  56 57 ) resistor r=197.415 //w=0.094 //l=0.385 //layer=ply \
 //thickness=0.18 //x=73.45 //y=1.71 //x2=73.45 //y2=2.095
r211 (  55 74 ) resistor r=39.5823 //w=0.21 //l=0.173853 //layer=ply \
 //thickness=0.18 //x=73.45 //y=1.4 //x2=73.49 //y2=1.555
r212 (  54 73 ) resistor r=45.1352 //w=0.168 //l=0.173853 //layer=ply \
 //thickness=0.18 //x=73.45 //y=1.055 //x2=73.49 //y2=0.9
r213 (  54 55 ) resistor r=176.904 //w=0.094 //l=0.345 //layer=ply \
 //thickness=0.18 //x=73.45 //y=1.055 //x2=73.45 //y2=1.4
r214 (  53 70 ) resistor r=592.245 //w=0.094 //l=1.155 //layer=ply \
 //thickness=0.18 //x=74.39 //y=6.2 //x2=74.39 //y2=5.045
r215 (  52 63 ) resistor r=592.245 //w=0.094 //l=1.155 //layer=ply \
 //thickness=0.18 //x=73.95 //y=6.2 //x2=73.95 //y2=5.045
r216 (  51 60 ) resistor r=56.4043 //w=0.094 //l=0.11 //layer=ply \
 //thickness=0.18 //x=73.715 //y=1.555 //x2=73.825 //y2=1.555
r217 (  51 61 ) resistor r=56.4043 //w=0.094 //l=0.11 //layer=ply \
 //thickness=0.18 //x=73.715 //y=1.555 //x2=73.605 //y2=1.555
r218 (  47 78 ) resistor r=152 //w=0.17 //l=0.17 //layer=licon //count=1 \
 //x=73.75 //y=4.88 //x2=73.75 //y2=4.88
r219 (  45 47 ) resistor r=144.428 //w=0.187 //l=2.11 //layer=li \
 //thickness=0.1 //x=73.75 //y=2.77 //x2=73.75 //y2=4.88
r220 (  42 76 ) resistor r=152 //w=0.17 //l=0.17 //layer=licon //count=1 \
 //x=73.75 //y=2.26 //x2=73.75 //y2=2.26
r221 (  42 45 ) resistor r=34.9091 //w=0.187 //l=0.51 //layer=li \
 //thickness=0.1 //x=73.75 //y=2.26 //x2=73.75 //y2=2.77
r222 (  38 40 ) resistor r=169.754 //w=0.187 //l=2.48 //layer=li \
 //thickness=0.1 //x=71.9 //y=5.25 //x2=71.9 //y2=2.77
r223 (  37 40 ) resistor r=57.4973 //w=0.187 //l=0.84 //layer=li \
 //thickness=0.1 //x=71.9 //y=1.93 //x2=71.9 //y2=2.77
r224 (  35 37 ) resistor r=7.15173 //w=0.17 //l=0.120208 //layer=li \
 //thickness=0.1 //x=71.815 //y=1.845 //x2=71.9 //y2=1.93
r225 (  35 36 ) resistor r=21.5615 //w=0.187 //l=0.315 //layer=li \
 //thickness=0.1 //x=71.815 //y=1.845 //x2=71.5 //y2=1.845
r226 (  31 36 ) resistor r=7.15173 //w=0.17 //l=0.120208 //layer=li \
 //thickness=0.1 //x=71.415 //y=1.76 //x2=71.5 //y2=1.845
r227 (  31 81 ) resistor r=39.016 //w=0.187 //l=0.57 //layer=li \
 //thickness=0.1 //x=71.415 //y=1.76 //x2=71.415 //y2=1.19
r228 (  30 50 ) resistor r=5.4201 //w=0.17 //l=0.085 //layer=li \
 //thickness=0.1 //x=71.205 //y=5.335 //x2=71.12 //y2=5.335
r229 (  29 38 ) resistor r=7.15173 //w=0.17 //l=0.120208 //layer=li \
 //thickness=0.1 //x=71.815 //y=5.335 //x2=71.9 //y2=5.25
r230 (  29 30 ) resistor r=41.754 //w=0.187 //l=0.61 //layer=li \
 //thickness=0.1 //x=71.815 //y=5.335 //x2=71.205 //y2=5.335
r231 (  23 50 ) resistor r=1.40859 //w=0.34 //l=0.085 //layer=li \
 //thickness=0.1 //x=71.12 //y=5.42 //x2=71.12 //y2=5.335
r232 (  23 85 ) resistor r=33.1979 //w=0.187 //l=0.485 //layer=li \
 //thickness=0.1 //x=71.12 //y=5.42 //x2=71.12 //y2=5.905
r233 (  22 49 ) resistor r=5.4201 //w=0.17 //l=0.085 //layer=li \
 //thickness=0.1 //x=70.325 //y=5.335 //x2=70.24 //y2=5.335
r234 (  21 50 ) resistor r=5.4201 //w=0.17 //l=0.085 //layer=li \
 //thickness=0.1 //x=71.035 //y=5.335 //x2=71.12 //y2=5.335
r235 (  21 22 ) resistor r=48.5989 //w=0.187 //l=0.71 //layer=li \
 //thickness=0.1 //x=71.035 //y=5.335 //x2=70.325 //y2=5.335
r236 (  15 49 ) resistor r=1.40859 //w=0.34 //l=0.085 //layer=li \
 //thickness=0.1 //x=70.24 //y=5.42 //x2=70.24 //y2=5.335
r237 (  15 84 ) resistor r=33.1979 //w=0.187 //l=0.485 //layer=li \
 //thickness=0.1 //x=70.24 //y=5.42 //x2=70.24 //y2=5.905
r238 (  13 49 ) resistor r=5.4201 //w=0.17 //l=0.085 //layer=li \
 //thickness=0.1 //x=70.155 //y=5.335 //x2=70.24 //y2=5.335
r239 (  13 14 ) resistor r=48.5989 //w=0.187 //l=0.71 //layer=li \
 //thickness=0.1 //x=70.155 //y=5.335 //x2=69.445 //y2=5.335
r240 (  7 14 ) resistor r=7.15173 //w=0.17 //l=0.120208 //layer=li \
 //thickness=0.1 //x=69.36 //y=5.42 //x2=69.445 //y2=5.335
r241 (  7 83 ) resistor r=33.1979 //w=0.187 //l=0.485 //layer=li \
 //thickness=0.1 //x=69.36 //y=5.42 //x2=69.36 //y2=5.905
r242 (  6 45 ) resistor r=9.3 //w=0.17 //l=0.17 //layer=mcon //count=1 \
 //x=73.75 //y=2.77 //x2=73.75 //y2=2.77
r243 (  4 40 ) resistor r=9.3 //w=0.17 //l=0.17 //layer=mcon //count=1 \
 //x=71.9 //y=2.77 //x2=71.9 //y2=2.77
r244 (  2 4 ) resistor r=0.0717383 //w=0.224 //l=0.115 //layer=m1 \
 //thickness=0.36 //x=72.015 //y=2.77 //x2=71.9 //y2=2.77
r245 (  1 6 ) resistor r=0.0717383 //w=0.224 //l=0.115 //layer=m1 \
 //thickness=0.36 //x=73.635 //y=2.77 //x2=73.75 //y2=2.77
r246 (  1 2 ) resistor r=1.5458 //w=0.131 //l=1.62 //layer=m1 //thickness=0.36 \
 //x=73.635 //y=2.77 //x2=72.015 //y2=2.77
ends PM_TMRDFFSNRNQX1\%noxref_17

subckt PM_TMRDFFSNRNQX1\%CLK ( 1 2 3 4 5 6 7 8 9 10 23 24 25 26 27 28 29 30 31 \
 32 33 34 36 46 55 64 73 81 89 90 91 92 93 94 95 96 97 98 99 100 101 102 103 \
 104 105 106 107 108 109 111 117 118 119 120 121 126 127 128 130 136 137 138 \
 139 140 145 146 147 149 155 156 157 158 159 164 165 166 168 174 175 176 177 \
 178 183 184 185 187 193 194 195 196 197 202 203 204 206 212 213 214 215 216 \
 224 235 246 257 268 279 )
c715 ( 279 0 ) capacitor c=0.0333177f //x=74.86 //y=4.88
c716 ( 268 0 ) capacitor c=0.0333177f //x=65.24 //y=4.88
c717 ( 257 0 ) capacitor c=0.0333177f //x=46 //y=4.88
c718 ( 246 0 ) capacitor c=0.0333177f //x=36.38 //y=4.88
c719 ( 235 0 ) capacitor c=0.0334842f //x=17.14 //y=4.88
c720 ( 224 0 ) capacitor c=0.0334842f //x=7.52 //y=4.88
c721 ( 216 0 ) capacitor c=0.0252241f //x=75.195 //y=4.97
c722 ( 215 0 ) capacitor c=0.0825763f //x=74.95 //y=2.095
c723 ( 214 0 ) capacitor c=0.0170266f //x=74.95 //y=1.63
c724 ( 213 0 ) capacitor c=0.018609f //x=74.95 //y=1.4
c725 ( 212 0 ) capacitor c=0.0187309f //x=74.95 //y=1.09
c726 ( 206 0 ) capacitor c=0.014725f //x=74.795 //y=1.555
c727 ( 204 0 ) capacitor c=0.0146567f //x=74.795 //y=0.935
c728 ( 203 0 ) capacitor c=0.0335408f //x=74.425 //y=1.4
c729 ( 202 0 ) capacitor c=0.0173761f //x=74.425 //y=1.09
c730 ( 197 0 ) capacitor c=0.0246783f //x=65.575 //y=4.97
c731 ( 196 0 ) capacitor c=0.0825763f //x=65.33 //y=2.095
c732 ( 195 0 ) capacitor c=0.0170266f //x=65.33 //y=1.63
c733 ( 194 0 ) capacitor c=0.018609f //x=65.33 //y=1.4
c734 ( 193 0 ) capacitor c=0.0187309f //x=65.33 //y=1.09
c735 ( 187 0 ) capacitor c=0.014725f //x=65.175 //y=1.555
c736 ( 185 0 ) capacitor c=0.0146567f //x=65.175 //y=0.935
c737 ( 184 0 ) capacitor c=0.0335408f //x=64.805 //y=1.4
c738 ( 183 0 ) capacitor c=0.0173761f //x=64.805 //y=1.09
c739 ( 178 0 ) capacitor c=0.0246783f //x=46.335 //y=4.97
c740 ( 177 0 ) capacitor c=0.0825763f //x=46.09 //y=2.095
c741 ( 176 0 ) capacitor c=0.0170266f //x=46.09 //y=1.63
c742 ( 175 0 ) capacitor c=0.018609f //x=46.09 //y=1.4
c743 ( 174 0 ) capacitor c=0.0187309f //x=46.09 //y=1.09
c744 ( 168 0 ) capacitor c=0.014725f //x=45.935 //y=1.555
c745 ( 166 0 ) capacitor c=0.0146567f //x=45.935 //y=0.935
c746 ( 165 0 ) capacitor c=0.0335408f //x=45.565 //y=1.4
c747 ( 164 0 ) capacitor c=0.0173761f //x=45.565 //y=1.09
c748 ( 159 0 ) capacitor c=0.0246783f //x=36.715 //y=4.97
c749 ( 158 0 ) capacitor c=0.0825763f //x=36.47 //y=2.095
c750 ( 157 0 ) capacitor c=0.0170266f //x=36.47 //y=1.63
c751 ( 156 0 ) capacitor c=0.018609f //x=36.47 //y=1.4
c752 ( 155 0 ) capacitor c=0.0187309f //x=36.47 //y=1.09
c753 ( 149 0 ) capacitor c=0.014725f //x=36.315 //y=1.555
c754 ( 147 0 ) capacitor c=0.0146567f //x=36.315 //y=0.935
c755 ( 146 0 ) capacitor c=0.0335408f //x=35.945 //y=1.4
c756 ( 145 0 ) capacitor c=0.0173761f //x=35.945 //y=1.09
c757 ( 140 0 ) capacitor c=0.0245352f //x=17.475 //y=4.97
c758 ( 139 0 ) capacitor c=0.0825763f //x=17.23 //y=2.095
c759 ( 138 0 ) capacitor c=0.0170266f //x=17.23 //y=1.63
c760 ( 137 0 ) capacitor c=0.018609f //x=17.23 //y=1.4
c761 ( 136 0 ) capacitor c=0.0187309f //x=17.23 //y=1.09
c762 ( 130 0 ) capacitor c=0.014725f //x=17.075 //y=1.555
c763 ( 128 0 ) capacitor c=0.0146567f //x=17.075 //y=0.935
c764 ( 127 0 ) capacitor c=0.0335408f //x=16.705 //y=1.4
c765 ( 126 0 ) capacitor c=0.0173761f //x=16.705 //y=1.09
c766 ( 121 0 ) capacitor c=0.0245352f //x=7.855 //y=4.97
c767 ( 120 0 ) capacitor c=0.0825763f //x=7.61 //y=2.095
c768 ( 119 0 ) capacitor c=0.0170266f //x=7.61 //y=1.63
c769 ( 118 0 ) capacitor c=0.018609f //x=7.61 //y=1.4
c770 ( 117 0 ) capacitor c=0.0187309f //x=7.61 //y=1.09
c771 ( 111 0 ) capacitor c=0.014725f //x=7.455 //y=1.555
c772 ( 109 0 ) capacitor c=0.0146567f //x=7.455 //y=0.935
c773 ( 108 0 ) capacitor c=0.0335408f //x=7.085 //y=1.4
c774 ( 107 0 ) capacitor c=0.0173761f //x=7.085 //y=1.09
c775 ( 106 0 ) capacitor c=0.109949f //x=75.27 //y=6.2
c776 ( 105 0 ) capacitor c=0.109956f //x=74.83 //y=6.2
c777 ( 104 0 ) capacitor c=0.109949f //x=65.65 //y=6.2
c778 ( 103 0 ) capacitor c=0.109956f //x=65.21 //y=6.2
c779 ( 102 0 ) capacitor c=0.109949f //x=46.41 //y=6.2
c780 ( 101 0 ) capacitor c=0.109956f //x=45.97 //y=6.2
c781 ( 100 0 ) capacitor c=0.109949f //x=36.79 //y=6.2
c782 ( 99 0 ) capacitor c=0.109956f //x=36.35 //y=6.2
c783 ( 98 0 ) capacitor c=0.110114f //x=17.55 //y=6.2
c784 ( 97 0 ) capacitor c=0.11012f //x=17.11 //y=6.2
c785 ( 96 0 ) capacitor c=0.110114f //x=7.93 //y=6.2
c786 ( 95 0 ) capacitor c=0.11012f //x=7.49 //y=6.2
c787 ( 81 0 ) capacitor c=0.0880091f //x=74.86 //y=2.26
c788 ( 73 0 ) capacitor c=0.0867126f //x=65.24 //y=2.26
c789 ( 64 0 ) capacitor c=0.0882701f //x=46 //y=2.26
c790 ( 55 0 ) capacitor c=0.0881639f //x=36.38 //y=2.26
c791 ( 46 0 ) capacitor c=0.0899873f //x=17.14 //y=2.26
c792 ( 36 0 ) capacitor c=0.0925246f //x=7.52 //y=2.26
c793 ( 10 0 ) capacitor c=0.0052048f //x=65.355 //y=4.62
c794 ( 9 0 ) capacitor c=0.124137f //x=74.745 //y=4.62
c795 ( 8 0 ) capacitor c=0.00494979f //x=46.115 //y=4.62
c796 ( 7 0 ) capacitor c=0.255004f //x=65.125 //y=4.62
c797 ( 6 0 ) capacitor c=0.00494979f //x=36.495 //y=4.62
c798 ( 5 0 ) capacitor c=0.117333f //x=45.885 //y=4.62
c799 ( 4 0 ) capacitor c=0.00697397f //x=17.255 //y=4.62
c800 ( 3 0 ) capacitor c=0.345925f //x=36.265 //y=4.62
c801 ( 2 0 ) capacitor c=0.0154455f //x=7.635 //y=4.62
c802 ( 1 0 ) capacitor c=0.212324f //x=17.025 //y=4.62
r803 (  281 282 ) resistor r=32.4568 //w=0.214 //l=0.075 //layer=ply \
 //thickness=0.18 //x=74.86 //y=4.97 //x2=74.86 //y2=5.045
r804 (  279 281 ) resistor r=20.271 //w=0.214 //l=0.09 //layer=ply \
 //thickness=0.18 //x=74.86 //y=4.88 //x2=74.86 //y2=4.97
r805 (  270 271 ) resistor r=32.4568 //w=0.214 //l=0.075 //layer=ply \
 //thickness=0.18 //x=65.24 //y=4.97 //x2=65.24 //y2=5.045
r806 (  268 270 ) resistor r=20.271 //w=0.214 //l=0.09 //layer=ply \
 //thickness=0.18 //x=65.24 //y=4.88 //x2=65.24 //y2=4.97
r807 (  259 260 ) resistor r=32.4568 //w=0.214 //l=0.075 //layer=ply \
 //thickness=0.18 //x=46 //y=4.97 //x2=46 //y2=5.045
r808 (  257 259 ) resistor r=20.271 //w=0.214 //l=0.09 //layer=ply \
 //thickness=0.18 //x=46 //y=4.88 //x2=46 //y2=4.97
r809 (  248 249 ) resistor r=32.4568 //w=0.214 //l=0.075 //layer=ply \
 //thickness=0.18 //x=36.38 //y=4.97 //x2=36.38 //y2=5.045
r810 (  246 248 ) resistor r=20.271 //w=0.214 //l=0.09 //layer=ply \
 //thickness=0.18 //x=36.38 //y=4.88 //x2=36.38 //y2=4.97
r811 (  237 238 ) resistor r=32.4568 //w=0.214 //l=0.075 //layer=ply \
 //thickness=0.18 //x=17.14 //y=4.97 //x2=17.14 //y2=5.045
r812 (  235 237 ) resistor r=20.271 //w=0.214 //l=0.09 //layer=ply \
 //thickness=0.18 //x=17.14 //y=4.88 //x2=17.14 //y2=4.97
r813 (  226 227 ) resistor r=32.4568 //w=0.214 //l=0.075 //layer=ply \
 //thickness=0.18 //x=7.52 //y=4.97 //x2=7.52 //y2=5.045
r814 (  224 226 ) resistor r=20.271 //w=0.214 //l=0.09 //layer=ply \
 //thickness=0.18 //x=7.52 //y=4.88 //x2=7.52 //y2=4.97
r815 (  217 281 ) resistor r=16.5046 //w=0.27 //l=0.135 //layer=ply \
 //thickness=0.18 //x=74.995 //y=4.97 //x2=74.86 //y2=4.97
r816 (  216 218 ) resistor r=26.9307 //w=0.15 //l=0.106066 //layer=ply \
 //thickness=0.18 //x=75.195 //y=4.97 //x2=75.27 //y2=5.045
r817 (  216 217 ) resistor r=102.553 //w=0.094 //l=0.2 //layer=ply \
 //thickness=0.18 //x=75.195 //y=4.97 //x2=74.995 //y2=4.97
r818 (  215 286 ) resistor r=38.6777 //w=0.284 //l=0.198997 //layer=ply \
 //thickness=0.18 //x=74.95 //y=2.095 //x2=74.875 //y2=2.26
r819 (  214 284 ) resistor r=21.2976 //w=0.217 //l=0.0928709 //layer=ply \
 //thickness=0.18 //x=74.95 //y=1.63 //x2=74.91 //y2=1.555
r820 (  214 215 ) resistor r=238.436 //w=0.094 //l=0.465 //layer=ply \
 //thickness=0.18 //x=74.95 //y=1.63 //x2=74.95 //y2=2.095
r821 (  213 284 ) resistor r=39.0671 //w=0.217 //l=0.173853 //layer=ply \
 //thickness=0.18 //x=74.95 //y=1.4 //x2=74.91 //y2=1.555
r822 (  212 283 ) resistor r=45.1352 //w=0.168 //l=0.173853 //layer=ply \
 //thickness=0.18 //x=74.95 //y=1.09 //x2=74.91 //y2=0.935
r823 (  212 213 ) resistor r=158.957 //w=0.094 //l=0.31 //layer=ply \
 //thickness=0.18 //x=74.95 //y=1.09 //x2=74.95 //y2=1.4
r824 (  207 277 ) resistor r=5.52526 //w=0.168 //l=0.115 //layer=ply \
 //thickness=0.18 //x=74.58 //y=1.555 //x2=74.465 //y2=1.555
r825 (  206 284 ) resistor r=11.4558 //w=0.217 //l=0.115 //layer=ply \
 //thickness=0.18 //x=74.795 //y=1.555 //x2=74.91 //y2=1.555
r826 (  205 276 ) resistor r=5.52526 //w=0.168 //l=0.115 //layer=ply \
 //thickness=0.18 //x=74.58 //y=0.935 //x2=74.465 //y2=0.935
r827 (  204 283 ) resistor r=5.52526 //w=0.168 //l=0.115 //layer=ply \
 //thickness=0.18 //x=74.795 //y=0.935 //x2=74.91 //y2=0.935
r828 (  204 205 ) resistor r=110.245 //w=0.094 //l=0.215 //layer=ply \
 //thickness=0.18 //x=74.795 //y=0.935 //x2=74.58 //y2=0.935
r829 (  203 277 ) resistor r=45.1352 //w=0.168 //l=0.173853 //layer=ply \
 //thickness=0.18 //x=74.425 //y=1.4 //x2=74.465 //y2=1.555
r830 (  202 276 ) resistor r=45.1352 //w=0.168 //l=0.173853 //layer=ply \
 //thickness=0.18 //x=74.425 //y=1.09 //x2=74.465 //y2=0.935
r831 (  202 203 ) resistor r=158.957 //w=0.094 //l=0.31 //layer=ply \
 //thickness=0.18 //x=74.425 //y=1.09 //x2=74.425 //y2=1.4
r832 (  198 270 ) resistor r=16.5046 //w=0.27 //l=0.135 //layer=ply \
 //thickness=0.18 //x=65.375 //y=4.97 //x2=65.24 //y2=4.97
r833 (  197 199 ) resistor r=26.9307 //w=0.15 //l=0.106066 //layer=ply \
 //thickness=0.18 //x=65.575 //y=4.97 //x2=65.65 //y2=5.045
r834 (  197 198 ) resistor r=102.553 //w=0.094 //l=0.2 //layer=ply \
 //thickness=0.18 //x=65.575 //y=4.97 //x2=65.375 //y2=4.97
r835 (  196 275 ) resistor r=38.6777 //w=0.284 //l=0.198997 //layer=ply \
 //thickness=0.18 //x=65.33 //y=2.095 //x2=65.255 //y2=2.26
r836 (  195 273 ) resistor r=21.2976 //w=0.217 //l=0.0928709 //layer=ply \
 //thickness=0.18 //x=65.33 //y=1.63 //x2=65.29 //y2=1.555
r837 (  195 196 ) resistor r=238.436 //w=0.094 //l=0.465 //layer=ply \
 //thickness=0.18 //x=65.33 //y=1.63 //x2=65.33 //y2=2.095
r838 (  194 273 ) resistor r=39.0671 //w=0.217 //l=0.173853 //layer=ply \
 //thickness=0.18 //x=65.33 //y=1.4 //x2=65.29 //y2=1.555
r839 (  193 272 ) resistor r=45.1352 //w=0.168 //l=0.173853 //layer=ply \
 //thickness=0.18 //x=65.33 //y=1.09 //x2=65.29 //y2=0.935
r840 (  193 194 ) resistor r=158.957 //w=0.094 //l=0.31 //layer=ply \
 //thickness=0.18 //x=65.33 //y=1.09 //x2=65.33 //y2=1.4
r841 (  188 266 ) resistor r=5.52526 //w=0.168 //l=0.115 //layer=ply \
 //thickness=0.18 //x=64.96 //y=1.555 //x2=64.845 //y2=1.555
r842 (  187 273 ) resistor r=11.4558 //w=0.217 //l=0.115 //layer=ply \
 //thickness=0.18 //x=65.175 //y=1.555 //x2=65.29 //y2=1.555
r843 (  186 265 ) resistor r=5.52526 //w=0.168 //l=0.115 //layer=ply \
 //thickness=0.18 //x=64.96 //y=0.935 //x2=64.845 //y2=0.935
r844 (  185 272 ) resistor r=5.52526 //w=0.168 //l=0.115 //layer=ply \
 //thickness=0.18 //x=65.175 //y=0.935 //x2=65.29 //y2=0.935
r845 (  185 186 ) resistor r=110.245 //w=0.094 //l=0.215 //layer=ply \
 //thickness=0.18 //x=65.175 //y=0.935 //x2=64.96 //y2=0.935
r846 (  184 266 ) resistor r=45.1352 //w=0.168 //l=0.173853 //layer=ply \
 //thickness=0.18 //x=64.805 //y=1.4 //x2=64.845 //y2=1.555
r847 (  183 265 ) resistor r=45.1352 //w=0.168 //l=0.173853 //layer=ply \
 //thickness=0.18 //x=64.805 //y=1.09 //x2=64.845 //y2=0.935
r848 (  183 184 ) resistor r=158.957 //w=0.094 //l=0.31 //layer=ply \
 //thickness=0.18 //x=64.805 //y=1.09 //x2=64.805 //y2=1.4
r849 (  179 259 ) resistor r=16.5046 //w=0.27 //l=0.135 //layer=ply \
 //thickness=0.18 //x=46.135 //y=4.97 //x2=46 //y2=4.97
r850 (  178 180 ) resistor r=26.9307 //w=0.15 //l=0.106066 //layer=ply \
 //thickness=0.18 //x=46.335 //y=4.97 //x2=46.41 //y2=5.045
r851 (  178 179 ) resistor r=102.553 //w=0.094 //l=0.2 //layer=ply \
 //thickness=0.18 //x=46.335 //y=4.97 //x2=46.135 //y2=4.97
r852 (  177 264 ) resistor r=38.6777 //w=0.284 //l=0.198997 //layer=ply \
 //thickness=0.18 //x=46.09 //y=2.095 //x2=46.015 //y2=2.26
r853 (  176 262 ) resistor r=21.2976 //w=0.217 //l=0.0928709 //layer=ply \
 //thickness=0.18 //x=46.09 //y=1.63 //x2=46.05 //y2=1.555
r854 (  176 177 ) resistor r=238.436 //w=0.094 //l=0.465 //layer=ply \
 //thickness=0.18 //x=46.09 //y=1.63 //x2=46.09 //y2=2.095
r855 (  175 262 ) resistor r=39.0671 //w=0.217 //l=0.173853 //layer=ply \
 //thickness=0.18 //x=46.09 //y=1.4 //x2=46.05 //y2=1.555
r856 (  174 261 ) resistor r=45.1352 //w=0.168 //l=0.173853 //layer=ply \
 //thickness=0.18 //x=46.09 //y=1.09 //x2=46.05 //y2=0.935
r857 (  174 175 ) resistor r=158.957 //w=0.094 //l=0.31 //layer=ply \
 //thickness=0.18 //x=46.09 //y=1.09 //x2=46.09 //y2=1.4
r858 (  169 255 ) resistor r=5.52526 //w=0.168 //l=0.115 //layer=ply \
 //thickness=0.18 //x=45.72 //y=1.555 //x2=45.605 //y2=1.555
r859 (  168 262 ) resistor r=11.4558 //w=0.217 //l=0.115 //layer=ply \
 //thickness=0.18 //x=45.935 //y=1.555 //x2=46.05 //y2=1.555
r860 (  167 254 ) resistor r=5.52526 //w=0.168 //l=0.115 //layer=ply \
 //thickness=0.18 //x=45.72 //y=0.935 //x2=45.605 //y2=0.935
r861 (  166 261 ) resistor r=5.52526 //w=0.168 //l=0.115 //layer=ply \
 //thickness=0.18 //x=45.935 //y=0.935 //x2=46.05 //y2=0.935
r862 (  166 167 ) resistor r=110.245 //w=0.094 //l=0.215 //layer=ply \
 //thickness=0.18 //x=45.935 //y=0.935 //x2=45.72 //y2=0.935
r863 (  165 255 ) resistor r=45.1352 //w=0.168 //l=0.173853 //layer=ply \
 //thickness=0.18 //x=45.565 //y=1.4 //x2=45.605 //y2=1.555
r864 (  164 254 ) resistor r=45.1352 //w=0.168 //l=0.173853 //layer=ply \
 //thickness=0.18 //x=45.565 //y=1.09 //x2=45.605 //y2=0.935
r865 (  164 165 ) resistor r=158.957 //w=0.094 //l=0.31 //layer=ply \
 //thickness=0.18 //x=45.565 //y=1.09 //x2=45.565 //y2=1.4
r866 (  160 248 ) resistor r=16.5046 //w=0.27 //l=0.135 //layer=ply \
 //thickness=0.18 //x=36.515 //y=4.97 //x2=36.38 //y2=4.97
r867 (  159 161 ) resistor r=26.9307 //w=0.15 //l=0.106066 //layer=ply \
 //thickness=0.18 //x=36.715 //y=4.97 //x2=36.79 //y2=5.045
r868 (  159 160 ) resistor r=102.553 //w=0.094 //l=0.2 //layer=ply \
 //thickness=0.18 //x=36.715 //y=4.97 //x2=36.515 //y2=4.97
r869 (  158 253 ) resistor r=38.6777 //w=0.284 //l=0.198997 //layer=ply \
 //thickness=0.18 //x=36.47 //y=2.095 //x2=36.395 //y2=2.26
r870 (  157 251 ) resistor r=21.2976 //w=0.217 //l=0.0928709 //layer=ply \
 //thickness=0.18 //x=36.47 //y=1.63 //x2=36.43 //y2=1.555
r871 (  157 158 ) resistor r=238.436 //w=0.094 //l=0.465 //layer=ply \
 //thickness=0.18 //x=36.47 //y=1.63 //x2=36.47 //y2=2.095
r872 (  156 251 ) resistor r=39.0671 //w=0.217 //l=0.173853 //layer=ply \
 //thickness=0.18 //x=36.47 //y=1.4 //x2=36.43 //y2=1.555
r873 (  155 250 ) resistor r=45.1352 //w=0.168 //l=0.173853 //layer=ply \
 //thickness=0.18 //x=36.47 //y=1.09 //x2=36.43 //y2=0.935
r874 (  155 156 ) resistor r=158.957 //w=0.094 //l=0.31 //layer=ply \
 //thickness=0.18 //x=36.47 //y=1.09 //x2=36.47 //y2=1.4
r875 (  150 244 ) resistor r=5.52526 //w=0.168 //l=0.115 //layer=ply \
 //thickness=0.18 //x=36.1 //y=1.555 //x2=35.985 //y2=1.555
r876 (  149 251 ) resistor r=11.4558 //w=0.217 //l=0.115 //layer=ply \
 //thickness=0.18 //x=36.315 //y=1.555 //x2=36.43 //y2=1.555
r877 (  148 243 ) resistor r=5.52526 //w=0.168 //l=0.115 //layer=ply \
 //thickness=0.18 //x=36.1 //y=0.935 //x2=35.985 //y2=0.935
r878 (  147 250 ) resistor r=5.52526 //w=0.168 //l=0.115 //layer=ply \
 //thickness=0.18 //x=36.315 //y=0.935 //x2=36.43 //y2=0.935
r879 (  147 148 ) resistor r=110.245 //w=0.094 //l=0.215 //layer=ply \
 //thickness=0.18 //x=36.315 //y=0.935 //x2=36.1 //y2=0.935
r880 (  146 244 ) resistor r=45.1352 //w=0.168 //l=0.173853 //layer=ply \
 //thickness=0.18 //x=35.945 //y=1.4 //x2=35.985 //y2=1.555
r881 (  145 243 ) resistor r=45.1352 //w=0.168 //l=0.173853 //layer=ply \
 //thickness=0.18 //x=35.945 //y=1.09 //x2=35.985 //y2=0.935
r882 (  145 146 ) resistor r=158.957 //w=0.094 //l=0.31 //layer=ply \
 //thickness=0.18 //x=35.945 //y=1.09 //x2=35.945 //y2=1.4
r883 (  141 237 ) resistor r=16.5046 //w=0.27 //l=0.135 //layer=ply \
 //thickness=0.18 //x=17.275 //y=4.97 //x2=17.14 //y2=4.97
r884 (  140 142 ) resistor r=26.9307 //w=0.15 //l=0.106066 //layer=ply \
 //thickness=0.18 //x=17.475 //y=4.97 //x2=17.55 //y2=5.045
r885 (  140 141 ) resistor r=102.553 //w=0.094 //l=0.2 //layer=ply \
 //thickness=0.18 //x=17.475 //y=4.97 //x2=17.275 //y2=4.97
r886 (  139 242 ) resistor r=38.6777 //w=0.284 //l=0.198997 //layer=ply \
 //thickness=0.18 //x=17.23 //y=2.095 //x2=17.155 //y2=2.26
r887 (  138 240 ) resistor r=21.2976 //w=0.217 //l=0.0928709 //layer=ply \
 //thickness=0.18 //x=17.23 //y=1.63 //x2=17.19 //y2=1.555
r888 (  138 139 ) resistor r=238.436 //w=0.094 //l=0.465 //layer=ply \
 //thickness=0.18 //x=17.23 //y=1.63 //x2=17.23 //y2=2.095
r889 (  137 240 ) resistor r=39.0671 //w=0.217 //l=0.173853 //layer=ply \
 //thickness=0.18 //x=17.23 //y=1.4 //x2=17.19 //y2=1.555
r890 (  136 239 ) resistor r=45.1352 //w=0.168 //l=0.173853 //layer=ply \
 //thickness=0.18 //x=17.23 //y=1.09 //x2=17.19 //y2=0.935
r891 (  136 137 ) resistor r=158.957 //w=0.094 //l=0.31 //layer=ply \
 //thickness=0.18 //x=17.23 //y=1.09 //x2=17.23 //y2=1.4
r892 (  131 233 ) resistor r=5.52526 //w=0.168 //l=0.115 //layer=ply \
 //thickness=0.18 //x=16.86 //y=1.555 //x2=16.745 //y2=1.555
r893 (  130 240 ) resistor r=11.4558 //w=0.217 //l=0.115 //layer=ply \
 //thickness=0.18 //x=17.075 //y=1.555 //x2=17.19 //y2=1.555
r894 (  129 232 ) resistor r=5.52526 //w=0.168 //l=0.115 //layer=ply \
 //thickness=0.18 //x=16.86 //y=0.935 //x2=16.745 //y2=0.935
r895 (  128 239 ) resistor r=5.52526 //w=0.168 //l=0.115 //layer=ply \
 //thickness=0.18 //x=17.075 //y=0.935 //x2=17.19 //y2=0.935
r896 (  128 129 ) resistor r=110.245 //w=0.094 //l=0.215 //layer=ply \
 //thickness=0.18 //x=17.075 //y=0.935 //x2=16.86 //y2=0.935
r897 (  127 233 ) resistor r=45.1352 //w=0.168 //l=0.173853 //layer=ply \
 //thickness=0.18 //x=16.705 //y=1.4 //x2=16.745 //y2=1.555
r898 (  126 232 ) resistor r=45.1352 //w=0.168 //l=0.173853 //layer=ply \
 //thickness=0.18 //x=16.705 //y=1.09 //x2=16.745 //y2=0.935
r899 (  126 127 ) resistor r=158.957 //w=0.094 //l=0.31 //layer=ply \
 //thickness=0.18 //x=16.705 //y=1.09 //x2=16.705 //y2=1.4
r900 (  122 226 ) resistor r=16.5046 //w=0.27 //l=0.135 //layer=ply \
 //thickness=0.18 //x=7.655 //y=4.97 //x2=7.52 //y2=4.97
r901 (  121 123 ) resistor r=26.9307 //w=0.15 //l=0.106066 //layer=ply \
 //thickness=0.18 //x=7.855 //y=4.97 //x2=7.93 //y2=5.045
r902 (  121 122 ) resistor r=102.553 //w=0.094 //l=0.2 //layer=ply \
 //thickness=0.18 //x=7.855 //y=4.97 //x2=7.655 //y2=4.97
r903 (  120 231 ) resistor r=38.6777 //w=0.284 //l=0.198997 //layer=ply \
 //thickness=0.18 //x=7.61 //y=2.095 //x2=7.535 //y2=2.26
r904 (  119 229 ) resistor r=21.2976 //w=0.217 //l=0.0928709 //layer=ply \
 //thickness=0.18 //x=7.61 //y=1.63 //x2=7.57 //y2=1.555
r905 (  119 120 ) resistor r=238.436 //w=0.094 //l=0.465 //layer=ply \
 //thickness=0.18 //x=7.61 //y=1.63 //x2=7.61 //y2=2.095
r906 (  118 229 ) resistor r=39.0671 //w=0.217 //l=0.173853 //layer=ply \
 //thickness=0.18 //x=7.61 //y=1.4 //x2=7.57 //y2=1.555
r907 (  117 228 ) resistor r=45.1352 //w=0.168 //l=0.173853 //layer=ply \
 //thickness=0.18 //x=7.61 //y=1.09 //x2=7.57 //y2=0.935
r908 (  117 118 ) resistor r=158.957 //w=0.094 //l=0.31 //layer=ply \
 //thickness=0.18 //x=7.61 //y=1.09 //x2=7.61 //y2=1.4
r909 (  112 222 ) resistor r=5.52526 //w=0.168 //l=0.115 //layer=ply \
 //thickness=0.18 //x=7.24 //y=1.555 //x2=7.125 //y2=1.555
r910 (  111 229 ) resistor r=11.4558 //w=0.217 //l=0.115 //layer=ply \
 //thickness=0.18 //x=7.455 //y=1.555 //x2=7.57 //y2=1.555
r911 (  110 221 ) resistor r=5.52526 //w=0.168 //l=0.115 //layer=ply \
 //thickness=0.18 //x=7.24 //y=0.935 //x2=7.125 //y2=0.935
r912 (  109 228 ) resistor r=5.52526 //w=0.168 //l=0.115 //layer=ply \
 //thickness=0.18 //x=7.455 //y=0.935 //x2=7.57 //y2=0.935
r913 (  109 110 ) resistor r=110.245 //w=0.094 //l=0.215 //layer=ply \
 //thickness=0.18 //x=7.455 //y=0.935 //x2=7.24 //y2=0.935
r914 (  108 222 ) resistor r=45.1352 //w=0.168 //l=0.173853 //layer=ply \
 //thickness=0.18 //x=7.085 //y=1.4 //x2=7.125 //y2=1.555
r915 (  107 221 ) resistor r=45.1352 //w=0.168 //l=0.173853 //layer=ply \
 //thickness=0.18 //x=7.085 //y=1.09 //x2=7.125 //y2=0.935
r916 (  107 108 ) resistor r=158.957 //w=0.094 //l=0.31 //layer=ply \
 //thickness=0.18 //x=7.085 //y=1.09 //x2=7.085 //y2=1.4
r917 (  106 218 ) resistor r=592.245 //w=0.094 //l=1.155 //layer=ply \
 //thickness=0.18 //x=75.27 //y=6.2 //x2=75.27 //y2=5.045
r918 (  105 282 ) resistor r=592.245 //w=0.094 //l=1.155 //layer=ply \
 //thickness=0.18 //x=74.83 //y=6.2 //x2=74.83 //y2=5.045
r919 (  104 199 ) resistor r=592.245 //w=0.094 //l=1.155 //layer=ply \
 //thickness=0.18 //x=65.65 //y=6.2 //x2=65.65 //y2=5.045
r920 (  103 271 ) resistor r=592.245 //w=0.094 //l=1.155 //layer=ply \
 //thickness=0.18 //x=65.21 //y=6.2 //x2=65.21 //y2=5.045
r921 (  102 180 ) resistor r=592.245 //w=0.094 //l=1.155 //layer=ply \
 //thickness=0.18 //x=46.41 //y=6.2 //x2=46.41 //y2=5.045
r922 (  101 260 ) resistor r=592.245 //w=0.094 //l=1.155 //layer=ply \
 //thickness=0.18 //x=45.97 //y=6.2 //x2=45.97 //y2=5.045
r923 (  100 161 ) resistor r=592.245 //w=0.094 //l=1.155 //layer=ply \
 //thickness=0.18 //x=36.79 //y=6.2 //x2=36.79 //y2=5.045
r924 (  99 249 ) resistor r=592.245 //w=0.094 //l=1.155 //layer=ply \
 //thickness=0.18 //x=36.35 //y=6.2 //x2=36.35 //y2=5.045
r925 (  98 142 ) resistor r=592.245 //w=0.094 //l=1.155 //layer=ply \
 //thickness=0.18 //x=17.55 //y=6.2 //x2=17.55 //y2=5.045
r926 (  97 238 ) resistor r=592.245 //w=0.094 //l=1.155 //layer=ply \
 //thickness=0.18 //x=17.11 //y=6.2 //x2=17.11 //y2=5.045
r927 (  96 123 ) resistor r=592.245 //w=0.094 //l=1.155 //layer=ply \
 //thickness=0.18 //x=7.93 //y=6.2 //x2=7.93 //y2=5.045
r928 (  95 227 ) resistor r=592.245 //w=0.094 //l=1.155 //layer=ply \
 //thickness=0.18 //x=7.49 //y=6.2 //x2=7.49 //y2=5.045
r929 (  94 206 ) resistor r=55.3787 //w=0.094 //l=0.108 //layer=ply \
 //thickness=0.18 //x=74.687 //y=1.555 //x2=74.795 //y2=1.555
r930 (  94 207 ) resistor r=54.866 //w=0.094 //l=0.107 //layer=ply \
 //thickness=0.18 //x=74.687 //y=1.555 //x2=74.58 //y2=1.555
r931 (  93 187 ) resistor r=55.3787 //w=0.094 //l=0.108 //layer=ply \
 //thickness=0.18 //x=65.067 //y=1.555 //x2=65.175 //y2=1.555
r932 (  93 188 ) resistor r=54.866 //w=0.094 //l=0.107 //layer=ply \
 //thickness=0.18 //x=65.067 //y=1.555 //x2=64.96 //y2=1.555
r933 (  92 168 ) resistor r=55.3787 //w=0.094 //l=0.108 //layer=ply \
 //thickness=0.18 //x=45.827 //y=1.555 //x2=45.935 //y2=1.555
r934 (  92 169 ) resistor r=54.866 //w=0.094 //l=0.107 //layer=ply \
 //thickness=0.18 //x=45.827 //y=1.555 //x2=45.72 //y2=1.555
r935 (  91 149 ) resistor r=55.3787 //w=0.094 //l=0.108 //layer=ply \
 //thickness=0.18 //x=36.207 //y=1.555 //x2=36.315 //y2=1.555
r936 (  91 150 ) resistor r=54.866 //w=0.094 //l=0.107 //layer=ply \
 //thickness=0.18 //x=36.207 //y=1.555 //x2=36.1 //y2=1.555
r937 (  90 130 ) resistor r=55.3787 //w=0.094 //l=0.108 //layer=ply \
 //thickness=0.18 //x=16.967 //y=1.555 //x2=17.075 //y2=1.555
r938 (  90 131 ) resistor r=54.866 //w=0.094 //l=0.107 //layer=ply \
 //thickness=0.18 //x=16.967 //y=1.555 //x2=16.86 //y2=1.555
r939 (  89 111 ) resistor r=55.3787 //w=0.094 //l=0.108 //layer=ply \
 //thickness=0.18 //x=7.347 //y=1.555 //x2=7.455 //y2=1.555
r940 (  89 112 ) resistor r=54.866 //w=0.094 //l=0.107 //layer=ply \
 //thickness=0.18 //x=7.347 //y=1.555 //x2=7.24 //y2=1.555
r941 (  87 279 ) resistor r=152 //w=0.17 //l=0.17 //layer=licon //count=1 \
 //x=74.86 //y=4.88 //x2=74.86 //y2=4.88
r942 (  81 286 ) resistor r=152 //w=0.17 //l=0.17 //layer=licon //count=1 \
 //x=74.86 //y=2.26 //x2=74.86 //y2=2.26
r943 (  78 268 ) resistor r=152 //w=0.17 //l=0.17 //layer=licon //count=1 \
 //x=65.24 //y=4.88 //x2=65.24 //y2=4.88
r944 (  73 275 ) resistor r=152 //w=0.17 //l=0.17 //layer=licon //count=1 \
 //x=65.24 //y=2.26 //x2=65.24 //y2=2.26
r945 (  70 257 ) resistor r=152 //w=0.17 //l=0.17 //layer=licon //count=1 \
 //x=46 //y=4.88 //x2=46 //y2=4.88
r946 (  64 264 ) resistor r=152 //w=0.17 //l=0.17 //layer=licon //count=1 \
 //x=46 //y=2.26 //x2=46 //y2=2.26
r947 (  61 246 ) resistor r=152 //w=0.17 //l=0.17 //layer=licon //count=1 \
 //x=36.38 //y=4.88 //x2=36.38 //y2=4.88
r948 (  55 253 ) resistor r=152 //w=0.17 //l=0.17 //layer=licon //count=1 \
 //x=36.38 //y=2.26 //x2=36.38 //y2=2.26
r949 (  52 235 ) resistor r=152 //w=0.17 //l=0.17 //layer=licon //count=1 \
 //x=17.14 //y=4.88 //x2=17.14 //y2=4.88
r950 (  46 242 ) resistor r=152 //w=0.17 //l=0.17 //layer=licon //count=1 \
 //x=17.14 //y=2.26 //x2=17.14 //y2=2.26
r951 (  43 224 ) resistor r=152 //w=0.17 //l=0.17 //layer=licon //count=1 \
 //x=7.52 //y=4.88 //x2=7.52 //y2=4.88
r952 (  36 231 ) resistor r=152 //w=0.17 //l=0.17 //layer=licon //count=1 \
 //x=7.52 //y=2.26 //x2=7.52 //y2=2.26
r953 (  34 87 ) resistor r=17.7968 //w=0.187 //l=0.26 //layer=li \
 //thickness=0.1 //x=74.86 //y=4.62 //x2=74.86 //y2=4.88
r954 (  33 34 ) resistor r=126.631 //w=0.187 //l=1.85 //layer=li \
 //thickness=0.1 //x=74.86 //y=2.77 //x2=74.86 //y2=4.62
r955 (  33 81 ) resistor r=34.9091 //w=0.187 //l=0.51 //layer=li \
 //thickness=0.1 //x=74.86 //y=2.77 //x2=74.86 //y2=2.26
r956 (  32 78 ) resistor r=17.7968 //w=0.187 //l=0.26 //layer=li \
 //thickness=0.1 //x=65.24 //y=4.62 //x2=65.24 //y2=4.88
r957 (  32 73 ) resistor r=161.54 //w=0.187 //l=2.36 //layer=li \
 //thickness=0.1 //x=65.24 //y=4.62 //x2=65.24 //y2=2.26
r958 (  31 70 ) resistor r=17.7968 //w=0.187 //l=0.26 //layer=li \
 //thickness=0.1 //x=46 //y=4.62 //x2=46 //y2=4.88
r959 (  30 31 ) resistor r=126.631 //w=0.187 //l=1.85 //layer=li \
 //thickness=0.1 //x=46 //y=2.77 //x2=46 //y2=4.62
r960 (  30 64 ) resistor r=34.9091 //w=0.187 //l=0.51 //layer=li \
 //thickness=0.1 //x=46 //y=2.77 //x2=46 //y2=2.26
r961 (  29 61 ) resistor r=17.7968 //w=0.187 //l=0.26 //layer=li \
 //thickness=0.1 //x=36.38 //y=4.62 //x2=36.38 //y2=4.88
r962 (  28 29 ) resistor r=50.6524 //w=0.187 //l=0.74 //layer=li \
 //thickness=0.1 //x=36.38 //y=3.88 //x2=36.38 //y2=4.62
r963 (  28 55 ) resistor r=110.888 //w=0.187 //l=1.62 //layer=li \
 //thickness=0.1 //x=36.38 //y=3.88 //x2=36.38 //y2=2.26
r964 (  27 52 ) resistor r=17.7968 //w=0.187 //l=0.26 //layer=li \
 //thickness=0.1 //x=17.14 //y=4.62 //x2=17.14 //y2=4.88
r965 (  26 27 ) resistor r=126.631 //w=0.187 //l=1.85 //layer=li \
 //thickness=0.1 //x=17.14 //y=2.77 //x2=17.14 //y2=4.62
r966 (  26 46 ) resistor r=34.9091 //w=0.187 //l=0.51 //layer=li \
 //thickness=0.1 //x=17.14 //y=2.77 //x2=17.14 //y2=2.26
r967 (  25 43 ) resistor r=17.7968 //w=0.187 //l=0.26 //layer=li \
 //thickness=0.1 //x=7.52 //y=4.62 //x2=7.52 //y2=4.88
r968 (  24 25 ) resistor r=50.6524 //w=0.187 //l=0.74 //layer=li \
 //thickness=0.1 //x=7.52 //y=3.88 //x2=7.52 //y2=4.62
r969 (  23 24 ) resistor r=50.6524 //w=0.187 //l=0.74 //layer=li \
 //thickness=0.1 //x=7.52 //y=3.14 //x2=7.52 //y2=3.88
r970 (  23 36 ) resistor r=60.2353 //w=0.187 //l=0.88 //layer=li \
 //thickness=0.1 //x=7.52 //y=3.14 //x2=7.52 //y2=2.26
r971 (  22 34 ) resistor r=9.3 //w=0.17 //l=0.17 //layer=mcon //count=1 \
 //x=74.86 //y=4.62 //x2=74.86 //y2=4.62
r972 (  20 32 ) resistor r=9.3 //w=0.17 //l=0.17 //layer=mcon //count=1 \
 //x=65.24 //y=4.62 //x2=65.24 //y2=4.62
r973 (  18 31 ) resistor r=9.3 //w=0.17 //l=0.17 //layer=mcon //count=1 //x=46 \
 //y=4.62 //x2=46 //y2=4.62
r974 (  16 29 ) resistor r=9.3 //w=0.17 //l=0.17 //layer=mcon //count=1 \
 //x=36.38 //y=4.62 //x2=36.38 //y2=4.62
r975 (  14 27 ) resistor r=9.3 //w=0.17 //l=0.17 //layer=mcon //count=1 \
 //x=17.14 //y=4.62 //x2=17.14 //y2=4.62
r976 (  12 25 ) resistor r=9.3 //w=0.17 //l=0.17 //layer=mcon //count=1 \
 //x=7.52 //y=4.62 //x2=7.52 //y2=4.62
r977 (  10 20 ) resistor r=0.0880901 //w=0.191 //l=0.115 //layer=m1 \
 //thickness=0.36 //x=65.355 //y=4.62 //x2=65.24 //y2=4.62
r978 (  9 22 ) resistor r=0.0717383 //w=0.224 //l=0.115 //layer=m1 \
 //thickness=0.36 //x=74.745 //y=4.62 //x2=74.86 //y2=4.62
r979 (  9 10 ) resistor r=8.95992 //w=0.131 //l=9.39 //layer=m1 \
 //thickness=0.36 //x=74.745 //y=4.62 //x2=65.355 //y2=4.62
r980 (  8 18 ) resistor r=0.0880901 //w=0.191 //l=0.115 //layer=m1 \
 //thickness=0.36 //x=46.115 //y=4.62 //x2=46 //y2=4.62
r981 (  7 20 ) resistor r=0.0880901 //w=0.191 //l=0.115 //layer=m1 \
 //thickness=0.36 //x=65.125 //y=4.62 //x2=65.24 //y2=4.62
r982 (  7 8 ) resistor r=18.1393 //w=0.131 //l=19.01 //layer=m1 \
 //thickness=0.36 //x=65.125 //y=4.62 //x2=46.115 //y2=4.62
r983 (  6 16 ) resistor r=0.0880901 //w=0.191 //l=0.115 //layer=m1 \
 //thickness=0.36 //x=36.495 //y=4.62 //x2=36.38 //y2=4.62
r984 (  5 18 ) resistor r=0.0880901 //w=0.191 //l=0.115 //layer=m1 \
 //thickness=0.36 //x=45.885 //y=4.62 //x2=46 //y2=4.62
r985 (  5 6 ) resistor r=8.95992 //w=0.131 //l=9.39 //layer=m1 \
 //thickness=0.36 //x=45.885 //y=4.62 //x2=36.495 //y2=4.62
r986 (  4 14 ) resistor r=0.0880901 //w=0.191 //l=0.115 //layer=m1 \
 //thickness=0.36 //x=17.255 //y=4.62 //x2=17.14 //y2=4.62
r987 (  3 16 ) resistor r=0.0880901 //w=0.191 //l=0.115 //layer=m1 \
 //thickness=0.36 //x=36.265 //y=4.62 //x2=36.38 //y2=4.62
r988 (  3 4 ) resistor r=18.1393 //w=0.131 //l=19.01 //layer=m1 \
 //thickness=0.36 //x=36.265 //y=4.62 //x2=17.255 //y2=4.62
r989 (  2 12 ) resistor r=0.0717383 //w=0.224 //l=0.115 //layer=m1 \
 //thickness=0.36 //x=7.635 //y=4.62 //x2=7.52 //y2=4.62
r990 (  1 14 ) resistor r=0.0880901 //w=0.191 //l=0.115 //layer=m1 \
 //thickness=0.36 //x=17.025 //y=4.62 //x2=17.14 //y2=4.62
r991 (  1 2 ) resistor r=8.95992 //w=0.131 //l=9.39 //layer=m1 \
 //thickness=0.36 //x=17.025 //y=4.62 //x2=7.635 //y2=4.62
ends PM_TMRDFFSNRNQX1\%CLK

subckt PM_TMRDFFSNRNQX1\%noxref_19 ( 1 2 3 4 12 25 26 33 41 47 48 52 54 61 62 \
 63 64 65 66 67 68 72 73 74 79 81 84 85 86 87 88 89 90 92 98 99 100 101 106 \
 107 112 123 125 126 127 )
c274 ( 127 0 ) capacitor c=0.023087f //x=66.165 //y=5.2
c275 ( 126 0 ) capacitor c=0.023519f //x=65.285 //y=5.2
c276 ( 125 0 ) capacitor c=0.0224735f //x=64.405 //y=5.2
c277 ( 123 0 ) capacitor c=0.00853354f //x=66.415 //y=1.095
c278 ( 112 0 ) capacitor c=0.0588394f //x=61.54 //y=4.88
c279 ( 107 0 ) capacitor c=0.0273931f //x=61.54 //y=2.095
c280 ( 106 0 ) capacitor c=0.0456313f //x=61.54 //y=2.26
c281 ( 101 0 ) capacitor c=0.0556143f //x=78.835 //y=4.97
c282 ( 100 0 ) capacitor c=0.0293157f //x=79.125 //y=4.97
c283 ( 99 0 ) capacitor c=0.0347816f //x=78.79 //y=1.4
c284 ( 98 0 ) capacitor c=0.0187487f //x=78.79 //y=1.055
c285 ( 92 0 ) capacitor c=0.0137055f //x=78.635 //y=1.555
c286 ( 90 0 ) capacitor c=0.0149861f //x=78.635 //y=0.9
c287 ( 89 0 ) capacitor c=0.096037f //x=78.26 //y=2.095
c288 ( 88 0 ) capacitor c=0.0228993f //x=78.26 //y=1.71
c289 ( 87 0 ) capacitor c=0.0234352f //x=78.26 //y=1.4
c290 ( 86 0 ) capacitor c=0.0198724f //x=78.26 //y=1.055
c291 ( 85 0 ) capacitor c=0.0432517f //x=62.06 //y=1.44
c292 ( 84 0 ) capacitor c=0.0200379f //x=62.06 //y=1.095
c293 ( 81 0 ) capacitor c=0.0148873f //x=61.905 //y=1.595
c294 ( 79 0 ) capacitor c=0.0157803f //x=61.905 //y=0.94
c295 ( 74 0 ) capacitor c=0.0218028f //x=61.53 //y=1.75
c296 ( 73 0 ) capacitor c=0.0207459f //x=61.53 //y=1.44
c297 ( 72 0 ) capacitor c=0.0194308f //x=61.53 //y=1.095
c298 ( 68 0 ) capacitor c=0.110114f //x=79.2 //y=6.2
c299 ( 67 0 ) capacitor c=0.158956f //x=78.76 //y=6.2
c300 ( 66 0 ) capacitor c=0.158754f //x=61.72 //y=6.2
c301 ( 65 0 ) capacitor c=0.109949f //x=61.28 //y=6.2
c302 ( 62 0 ) capacitor c=9.74268e-19 //x=66.31 //y=5.335
c303 ( 61 0 ) capacitor c=0.00191414f //x=65.43 //y=5.335
c304 ( 54 0 ) capacitor c=0.0959558f //x=78.56 //y=2.26
c305 ( 52 0 ) capacitor c=0.1027f //x=67.09 //y=3.51
c306 ( 48 0 ) capacitor c=0.00398962f //x=66.69 //y=1.845
c307 ( 47 0 ) capacitor c=0.0137288f //x=67.005 //y=1.845
c308 ( 41 0 ) capacitor c=0.0276208f //x=67.005 //y=5.335
c309 ( 33 0 ) capacitor c=0.0169868f //x=66.225 //y=5.335
c310 ( 26 0 ) capacitor c=0.00316998f //x=64.635 //y=5.335
c311 ( 25 0 ) capacitor c=0.014258f //x=65.345 //y=5.335
c312 ( 12 0 ) capacitor c=0.0814556f //x=61.54 //y=2.26
c313 ( 4 0 ) capacitor c=0.00551333f //x=67.205 //y=3.51
c314 ( 3 0 ) capacitor c=0.17826f //x=78.445 //y=3.51
c315 ( 2 0 ) capacitor c=0.0105808f //x=61.655 //y=3.51
c316 ( 1 0 ) capacitor c=0.077341f //x=66.975 //y=3.51
r317 (  106 107 ) resistor r=52.7279 //w=0.214 //l=0.165 //layer=ply \
 //thickness=0.18 //x=61.54 //y=2.26 //x2=61.54 //y2=2.095
r318 (  100 102 ) resistor r=26.9307 //w=0.15 //l=0.106066 //layer=ply \
 //thickness=0.18 //x=79.125 //y=4.97 //x2=79.2 //y2=5.045
r319 (  100 101 ) resistor r=148.702 //w=0.094 //l=0.29 //layer=ply \
 //thickness=0.18 //x=79.125 //y=4.97 //x2=78.835 //y2=4.97
r320 (  99 122 ) resistor r=45.1352 //w=0.168 //l=0.173853 //layer=ply \
 //thickness=0.18 //x=78.79 //y=1.4 //x2=78.75 //y2=1.555
r321 (  98 121 ) resistor r=45.1352 //w=0.168 //l=0.173853 //layer=ply \
 //thickness=0.18 //x=78.79 //y=1.055 //x2=78.75 //y2=0.9
r322 (  98 99 ) resistor r=176.904 //w=0.094 //l=0.345 //layer=ply \
 //thickness=0.18 //x=78.79 //y=1.055 //x2=78.79 //y2=1.4
r323 (  95 101 ) resistor r=22.7971 //w=0.269 //l=0.106066 //layer=ply \
 //thickness=0.18 //x=78.76 //y=5.045 //x2=78.835 //y2=4.97
r324 (  95 120 ) resistor r=35.8364 //w=0.269 //l=0.270185 //layer=ply \
 //thickness=0.18 //x=78.76 //y=5.045 //x2=78.56 //y2=4.88
r325 (  93 116 ) resistor r=10.701 //w=0.21 //l=0.115 //layer=ply \
 //thickness=0.18 //x=78.415 //y=1.555 //x2=78.3 //y2=1.555
r326 (  92 122 ) resistor r=5.52526 //w=0.168 //l=0.115 //layer=ply \
 //thickness=0.18 //x=78.635 //y=1.555 //x2=78.75 //y2=1.555
r327 (  91 115 ) resistor r=5.52526 //w=0.168 //l=0.115 //layer=ply \
 //thickness=0.18 //x=78.415 //y=0.9 //x2=78.3 //y2=0.9
r328 (  90 121 ) resistor r=5.52526 //w=0.168 //l=0.115 //layer=ply \
 //thickness=0.18 //x=78.635 //y=0.9 //x2=78.75 //y2=0.9
r329 (  90 91 ) resistor r=112.809 //w=0.094 //l=0.22 //layer=ply \
 //thickness=0.18 //x=78.635 //y=0.9 //x2=78.415 //y2=0.9
r330 (  89 118 ) resistor r=58.7805 //w=0.246 //l=0.373497 //layer=ply \
 //thickness=0.18 //x=78.26 //y=2.095 //x2=78.56 //y2=2.26
r331 (  88 116 ) resistor r=39.5823 //w=0.21 //l=0.173853 //layer=ply \
 //thickness=0.18 //x=78.26 //y=1.71 //x2=78.3 //y2=1.555
r332 (  88 89 ) resistor r=197.415 //w=0.094 //l=0.385 //layer=ply \
 //thickness=0.18 //x=78.26 //y=1.71 //x2=78.26 //y2=2.095
r333 (  87 116 ) resistor r=39.5823 //w=0.21 //l=0.173853 //layer=ply \
 //thickness=0.18 //x=78.26 //y=1.4 //x2=78.3 //y2=1.555
r334 (  86 115 ) resistor r=45.1352 //w=0.168 //l=0.173853 //layer=ply \
 //thickness=0.18 //x=78.26 //y=1.055 //x2=78.3 //y2=0.9
r335 (  86 87 ) resistor r=176.904 //w=0.094 //l=0.345 //layer=ply \
 //thickness=0.18 //x=78.26 //y=1.055 //x2=78.26 //y2=1.4
r336 (  85 114 ) resistor r=45.1352 //w=0.168 //l=0.173853 //layer=ply \
 //thickness=0.18 //x=62.06 //y=1.44 //x2=62.02 //y2=1.595
r337 (  84 113 ) resistor r=45.1352 //w=0.168 //l=0.173853 //layer=ply \
 //thickness=0.18 //x=62.06 //y=1.095 //x2=62.02 //y2=0.94
r338 (  84 85 ) resistor r=176.904 //w=0.094 //l=0.345 //layer=ply \
 //thickness=0.18 //x=62.06 //y=1.095 //x2=62.06 //y2=1.44
r339 (  82 110 ) resistor r=10.701 //w=0.21 //l=0.115 //layer=ply \
 //thickness=0.18 //x=61.685 //y=1.595 //x2=61.57 //y2=1.595
r340 (  81 114 ) resistor r=5.52526 //w=0.168 //l=0.115 //layer=ply \
 //thickness=0.18 //x=61.905 //y=1.595 //x2=62.02 //y2=1.595
r341 (  80 109 ) resistor r=5.52526 //w=0.168 //l=0.115 //layer=ply \
 //thickness=0.18 //x=61.685 //y=0.94 //x2=61.57 //y2=0.94
r342 (  79 113 ) resistor r=5.52526 //w=0.168 //l=0.115 //layer=ply \
 //thickness=0.18 //x=61.905 //y=0.94 //x2=62.02 //y2=0.94
r343 (  79 80 ) resistor r=112.809 //w=0.094 //l=0.22 //layer=ply \
 //thickness=0.18 //x=61.905 //y=0.94 //x2=61.685 //y2=0.94
r344 (  76 112 ) resistor r=37.236 //w=0.233 //l=0.249199 //layer=ply \
 //thickness=0.18 //x=61.72 //y=5.045 //x2=61.54 //y2=4.88
r345 (  74 110 ) resistor r=39.5823 //w=0.21 //l=0.173853 //layer=ply \
 //thickness=0.18 //x=61.53 //y=1.75 //x2=61.57 //y2=1.595
r346 (  74 107 ) resistor r=176.904 //w=0.094 //l=0.345 //layer=ply \
 //thickness=0.18 //x=61.53 //y=1.75 //x2=61.53 //y2=2.095
r347 (  73 110 ) resistor r=39.5823 //w=0.21 //l=0.173853 //layer=ply \
 //thickness=0.18 //x=61.53 //y=1.44 //x2=61.57 //y2=1.595
r348 (  72 109 ) resistor r=45.1352 //w=0.168 //l=0.173853 //layer=ply \
 //thickness=0.18 //x=61.53 //y=1.095 //x2=61.57 //y2=0.94
r349 (  72 73 ) resistor r=176.904 //w=0.094 //l=0.345 //layer=ply \
 //thickness=0.18 //x=61.53 //y=1.095 //x2=61.53 //y2=1.44
r350 (  69 112 ) resistor r=53.7854 //w=0.233 //l=0.332415 //layer=ply \
 //thickness=0.18 //x=61.28 //y=5.045 //x2=61.54 //y2=4.88
r351 (  68 102 ) resistor r=592.245 //w=0.094 //l=1.155 //layer=ply \
 //thickness=0.18 //x=79.2 //y=6.2 //x2=79.2 //y2=5.045
r352 (  67 95 ) resistor r=592.245 //w=0.094 //l=1.155 //layer=ply \
 //thickness=0.18 //x=78.76 //y=6.2 //x2=78.76 //y2=5.045
r353 (  66 76 ) resistor r=592.245 //w=0.094 //l=1.155 //layer=ply \
 //thickness=0.18 //x=61.72 //y=6.2 //x2=61.72 //y2=5.045
r354 (  65 69 ) resistor r=592.245 //w=0.094 //l=1.155 //layer=ply \
 //thickness=0.18 //x=61.28 //y=6.2 //x2=61.28 //y2=5.045
r355 (  64 92 ) resistor r=56.4043 //w=0.094 //l=0.11 //layer=ply \
 //thickness=0.18 //x=78.525 //y=1.555 //x2=78.635 //y2=1.555
r356 (  64 93 ) resistor r=56.4043 //w=0.094 //l=0.11 //layer=ply \
 //thickness=0.18 //x=78.525 //y=1.555 //x2=78.415 //y2=1.555
r357 (  63 81 ) resistor r=56.4043 //w=0.094 //l=0.11 //layer=ply \
 //thickness=0.18 //x=61.795 //y=1.595 //x2=61.905 //y2=1.595
r358 (  63 82 ) resistor r=56.4043 //w=0.094 //l=0.11 //layer=ply \
 //thickness=0.18 //x=61.795 //y=1.595 //x2=61.685 //y2=1.595
r359 (  59 120 ) resistor r=152 //w=0.17 //l=0.17 //layer=licon //count=1 \
 //x=78.56 //y=4.88 //x2=78.56 //y2=4.88
r360 (  57 59 ) resistor r=93.7754 //w=0.187 //l=1.37 //layer=li \
 //thickness=0.1 //x=78.56 //y=3.51 //x2=78.56 //y2=4.88
r361 (  54 118 ) resistor r=152 //w=0.17 //l=0.17 //layer=licon //count=1 \
 //x=78.56 //y=2.26 //x2=78.56 //y2=2.26
r362 (  54 57 ) resistor r=85.5615 //w=0.187 //l=1.25 //layer=li \
 //thickness=0.1 //x=78.56 //y=2.26 //x2=78.56 //y2=3.51
r363 (  50 52 ) resistor r=119.102 //w=0.187 //l=1.74 //layer=li \
 //thickness=0.1 //x=67.09 //y=5.25 //x2=67.09 //y2=3.51
r364 (  49 52 ) resistor r=108.15 //w=0.187 //l=1.58 //layer=li \
 //thickness=0.1 //x=67.09 //y=1.93 //x2=67.09 //y2=3.51
r365 (  47 49 ) resistor r=7.15173 //w=0.17 //l=0.120208 //layer=li \
 //thickness=0.1 //x=67.005 //y=1.845 //x2=67.09 //y2=1.93
r366 (  47 48 ) resistor r=21.5615 //w=0.187 //l=0.315 //layer=li \
 //thickness=0.1 //x=67.005 //y=1.845 //x2=66.69 //y2=1.845
r367 (  43 48 ) resistor r=7.15173 //w=0.17 //l=0.120208 //layer=li \
 //thickness=0.1 //x=66.605 //y=1.76 //x2=66.69 //y2=1.845
r368 (  43 123 ) resistor r=39.016 //w=0.187 //l=0.57 //layer=li \
 //thickness=0.1 //x=66.605 //y=1.76 //x2=66.605 //y2=1.19
r369 (  42 62 ) resistor r=5.4201 //w=0.17 //l=0.085 //layer=li \
 //thickness=0.1 //x=66.395 //y=5.335 //x2=66.31 //y2=5.335
r370 (  41 50 ) resistor r=7.15173 //w=0.17 //l=0.120208 //layer=li \
 //thickness=0.1 //x=67.005 //y=5.335 //x2=67.09 //y2=5.25
r371 (  41 42 ) resistor r=41.754 //w=0.187 //l=0.61 //layer=li \
 //thickness=0.1 //x=67.005 //y=5.335 //x2=66.395 //y2=5.335
r372 (  35 62 ) resistor r=1.40859 //w=0.34 //l=0.085 //layer=li \
 //thickness=0.1 //x=66.31 //y=5.42 //x2=66.31 //y2=5.335
r373 (  35 127 ) resistor r=33.1979 //w=0.187 //l=0.485 //layer=li \
 //thickness=0.1 //x=66.31 //y=5.42 //x2=66.31 //y2=5.905
r374 (  34 61 ) resistor r=5.4201 //w=0.17 //l=0.085 //layer=li \
 //thickness=0.1 //x=65.515 //y=5.335 //x2=65.43 //y2=5.335
r375 (  33 62 ) resistor r=5.4201 //w=0.17 //l=0.085 //layer=li \
 //thickness=0.1 //x=66.225 //y=5.335 //x2=66.31 //y2=5.335
r376 (  33 34 ) resistor r=48.5989 //w=0.187 //l=0.71 //layer=li \
 //thickness=0.1 //x=66.225 //y=5.335 //x2=65.515 //y2=5.335
r377 (  27 61 ) resistor r=1.40859 //w=0.34 //l=0.085 //layer=li \
 //thickness=0.1 //x=65.43 //y=5.42 //x2=65.43 //y2=5.335
r378 (  27 126 ) resistor r=33.1979 //w=0.187 //l=0.485 //layer=li \
 //thickness=0.1 //x=65.43 //y=5.42 //x2=65.43 //y2=5.905
r379 (  25 61 ) resistor r=5.4201 //w=0.17 //l=0.085 //layer=li \
 //thickness=0.1 //x=65.345 //y=5.335 //x2=65.43 //y2=5.335
r380 (  25 26 ) resistor r=48.5989 //w=0.187 //l=0.71 //layer=li \
 //thickness=0.1 //x=65.345 //y=5.335 //x2=64.635 //y2=5.335
r381 (  19 26 ) resistor r=7.15173 //w=0.17 //l=0.120208 //layer=li \
 //thickness=0.1 //x=64.55 //y=5.42 //x2=64.635 //y2=5.335
r382 (  19 125 ) resistor r=33.1979 //w=0.187 //l=0.485 //layer=li \
 //thickness=0.1 //x=64.55 //y=5.42 //x2=64.55 //y2=5.905
r383 (  17 112 ) resistor r=152 //w=0.17 //l=0.17 //layer=licon //count=1 \
 //x=61.54 //y=4.88 //x2=61.54 //y2=4.88
r384 (  15 17 ) resistor r=93.7754 //w=0.187 //l=1.37 //layer=li \
 //thickness=0.1 //x=61.54 //y=3.51 //x2=61.54 //y2=4.88
r385 (  12 106 ) resistor r=152 //w=0.17 //l=0.17 //layer=licon //count=1 \
 //x=61.54 //y=2.26 //x2=61.54 //y2=2.26
r386 (  12 15 ) resistor r=85.5615 //w=0.187 //l=1.25 //layer=li \
 //thickness=0.1 //x=61.54 //y=2.26 //x2=61.54 //y2=3.51
r387 (  10 57 ) resistor r=9.3 //w=0.17 //l=0.17 //layer=mcon //count=1 \
 //x=78.56 //y=3.51 //x2=78.56 //y2=3.51
r388 (  8 52 ) resistor r=9.3 //w=0.17 //l=0.17 //layer=mcon //count=1 \
 //x=67.09 //y=3.51 //x2=67.09 //y2=3.51
r389 (  6 15 ) resistor r=9.3 //w=0.17 //l=0.17 //layer=mcon //count=1 \
 //x=61.54 //y=3.51 //x2=61.54 //y2=3.51
r390 (  4 8 ) resistor r=0.0880901 //w=0.191 //l=0.115 //layer=m1 \
 //thickness=0.36 //x=67.205 //y=3.51 //x2=67.09 //y2=3.51
r391 (  3 10 ) resistor r=0.0717383 //w=0.224 //l=0.115 //layer=m1 \
 //thickness=0.36 //x=78.445 //y=3.51 //x2=78.56 //y2=3.51
r392 (  3 4 ) resistor r=10.7252 //w=0.131 //l=11.24 //layer=m1 \
 //thickness=0.36 //x=78.445 //y=3.51 //x2=67.205 //y2=3.51
r393 (  2 6 ) resistor r=0.0717383 //w=0.224 //l=0.115 //layer=m1 \
 //thickness=0.36 //x=61.655 //y=3.51 //x2=61.54 //y2=3.51
r394 (  1 8 ) resistor r=0.0880901 //w=0.191 //l=0.115 //layer=m1 \
 //thickness=0.36 //x=66.975 //y=3.51 //x2=67.09 //y2=3.51
r395 (  1 2 ) resistor r=5.07634 //w=0.131 //l=5.32 //layer=m1 \
 //thickness=0.36 //x=66.975 //y=3.51 //x2=61.655 //y2=3.51
ends PM_TMRDFFSNRNQX1\%noxref_19

subckt PM_TMRDFFSNRNQX1\%RN ( 1 2 3 4 5 6 7 8 9 10 11 12 13 14 15 16 35 36 37 \
 38 39 40 41 42 43 44 45 46 47 48 49 50 51 52 53 54 55 56 57 58 59 60 61 62 63 \
 65 78 87 97 108 117 127 138 147 156 157 158 159 160 161 162 163 164 165 166 \
 167 168 169 170 171 172 173 174 175 176 177 178 179 180 181 182 183 184 185 \
 187 193 194 195 196 197 205 206 207 212 214 217 218 219 220 221 223 229 230 \
 231 232 233 238 239 240 242 248 249 250 251 252 260 261 262 267 269 272 273 \
 274 275 276 278 284 285 286 287 288 293 294 295 297 303 304 305 306 307 315 \
 316 317 322 324 327 328 329 330 331 333 339 340 341 342 343 351 360 361 366 \
 372 383 392 393 398 404 415 424 425 430 436 )
c1111 ( 436 0 ) capacitor c=0.0335551f //x=79.67 //y=4.88
c1112 ( 430 0 ) capacitor c=0.0584472f //x=75.97 //y=4.88
c1113 ( 425 0 ) capacitor c=0.0273931f //x=75.97 //y=2.095
c1114 ( 424 0 ) capacitor c=0.0455604f //x=75.97 //y=2.26
c1115 ( 415 0 ) capacitor c=0.0333886f //x=60.43 //y=4.88
c1116 ( 404 0 ) capacitor c=0.0333886f //x=50.81 //y=4.88
c1117 ( 398 0 ) capacitor c=0.0589949f //x=47.11 //y=4.88
c1118 ( 393 0 ) capacitor c=0.0273931f //x=47.11 //y=2.095
c1119 ( 392 0 ) capacitor c=0.0455604f //x=47.11 //y=2.26
c1120 ( 383 0 ) capacitor c=0.0333886f //x=31.57 //y=4.88
c1121 ( 372 0 ) capacitor c=0.0335551f //x=21.95 //y=4.88
c1122 ( 366 0 ) capacitor c=0.058931f //x=18.25 //y=4.88
c1123 ( 361 0 ) capacitor c=0.0273931f //x=18.25 //y=2.095
c1124 ( 360 0 ) capacitor c=0.0455604f //x=18.25 //y=2.26
c1125 ( 351 0 ) capacitor c=0.0336203f //x=2.71 //y=4.88
c1126 ( 343 0 ) capacitor c=0.0245352f //x=80.005 //y=4.97
c1127 ( 342 0 ) capacitor c=0.0827272f //x=79.76 //y=2.095
c1128 ( 341 0 ) capacitor c=0.0170266f //x=79.76 //y=1.63
c1129 ( 340 0 ) capacitor c=0.018609f //x=79.76 //y=1.4
c1130 ( 339 0 ) capacitor c=0.0187309f //x=79.76 //y=1.09
c1131 ( 333 0 ) capacitor c=0.014725f //x=79.605 //y=1.555
c1132 ( 331 0 ) capacitor c=0.0146567f //x=79.605 //y=0.935
c1133 ( 330 0 ) capacitor c=0.0335408f //x=79.235 //y=1.4
c1134 ( 329 0 ) capacitor c=0.0173761f //x=79.235 //y=1.09
c1135 ( 328 0 ) capacitor c=0.0432517f //x=76.49 //y=1.44
c1136 ( 327 0 ) capacitor c=0.0200379f //x=76.49 //y=1.095
c1137 ( 324 0 ) capacitor c=0.0148873f //x=76.335 //y=1.595
c1138 ( 322 0 ) capacitor c=0.0157803f //x=76.335 //y=0.94
c1139 ( 317 0 ) capacitor c=0.0218028f //x=75.96 //y=1.75
c1140 ( 316 0 ) capacitor c=0.0207459f //x=75.96 //y=1.44
c1141 ( 315 0 ) capacitor c=0.0194308f //x=75.96 //y=1.095
c1142 ( 307 0 ) capacitor c=0.0246783f //x=60.765 //y=4.97
c1143 ( 306 0 ) capacitor c=0.0825033f //x=60.52 //y=2.095
c1144 ( 305 0 ) capacitor c=0.0170266f //x=60.52 //y=1.63
c1145 ( 304 0 ) capacitor c=0.018609f //x=60.52 //y=1.4
c1146 ( 303 0 ) capacitor c=0.0187309f //x=60.52 //y=1.09
c1147 ( 297 0 ) capacitor c=0.014725f //x=60.365 //y=1.555
c1148 ( 295 0 ) capacitor c=0.0146567f //x=60.365 //y=0.935
c1149 ( 294 0 ) capacitor c=0.0335408f //x=59.995 //y=1.4
c1150 ( 293 0 ) capacitor c=0.0173761f //x=59.995 //y=1.09
c1151 ( 288 0 ) capacitor c=0.0246783f //x=51.145 //y=4.97
c1152 ( 287 0 ) capacitor c=0.0825033f //x=50.9 //y=2.095
c1153 ( 286 0 ) capacitor c=0.0170266f //x=50.9 //y=1.63
c1154 ( 285 0 ) capacitor c=0.018609f //x=50.9 //y=1.4
c1155 ( 284 0 ) capacitor c=0.0187309f //x=50.9 //y=1.09
c1156 ( 278 0 ) capacitor c=0.014725f //x=50.745 //y=1.555
c1157 ( 276 0 ) capacitor c=0.0146567f //x=50.745 //y=0.935
c1158 ( 275 0 ) capacitor c=0.0335408f //x=50.375 //y=1.4
c1159 ( 274 0 ) capacitor c=0.0173761f //x=50.375 //y=1.09
c1160 ( 273 0 ) capacitor c=0.0432517f //x=47.63 //y=1.44
c1161 ( 272 0 ) capacitor c=0.0200379f //x=47.63 //y=1.095
c1162 ( 269 0 ) capacitor c=0.0148873f //x=47.475 //y=1.595
c1163 ( 267 0 ) capacitor c=0.0157803f //x=47.475 //y=0.94
c1164 ( 262 0 ) capacitor c=0.0218028f //x=47.1 //y=1.75
c1165 ( 261 0 ) capacitor c=0.0207459f //x=47.1 //y=1.44
c1166 ( 260 0 ) capacitor c=0.0194308f //x=47.1 //y=1.095
c1167 ( 252 0 ) capacitor c=0.0246783f //x=31.905 //y=4.97
c1168 ( 251 0 ) capacitor c=0.0825033f //x=31.66 //y=2.095
c1169 ( 250 0 ) capacitor c=0.0170266f //x=31.66 //y=1.63
c1170 ( 249 0 ) capacitor c=0.018609f //x=31.66 //y=1.4
c1171 ( 248 0 ) capacitor c=0.0187309f //x=31.66 //y=1.09
c1172 ( 242 0 ) capacitor c=0.014725f //x=31.505 //y=1.555
c1173 ( 240 0 ) capacitor c=0.0146567f //x=31.505 //y=0.935
c1174 ( 239 0 ) capacitor c=0.0335408f //x=31.135 //y=1.4
c1175 ( 238 0 ) capacitor c=0.0173761f //x=31.135 //y=1.09
c1176 ( 233 0 ) capacitor c=0.0245352f //x=22.285 //y=4.97
c1177 ( 232 0 ) capacitor c=0.0825033f //x=22.04 //y=2.095
c1178 ( 231 0 ) capacitor c=0.0170266f //x=22.04 //y=1.63
c1179 ( 230 0 ) capacitor c=0.018609f //x=22.04 //y=1.4
c1180 ( 229 0 ) capacitor c=0.0187309f //x=22.04 //y=1.09
c1181 ( 223 0 ) capacitor c=0.014725f //x=21.885 //y=1.555
c1182 ( 221 0 ) capacitor c=0.0146567f //x=21.885 //y=0.935
c1183 ( 220 0 ) capacitor c=0.0335408f //x=21.515 //y=1.4
c1184 ( 219 0 ) capacitor c=0.0173761f //x=21.515 //y=1.09
c1185 ( 218 0 ) capacitor c=0.0432517f //x=18.77 //y=1.44
c1186 ( 217 0 ) capacitor c=0.0200379f //x=18.77 //y=1.095
c1187 ( 214 0 ) capacitor c=0.0148873f //x=18.615 //y=1.595
c1188 ( 212 0 ) capacitor c=0.0157803f //x=18.615 //y=0.94
c1189 ( 207 0 ) capacitor c=0.0218028f //x=18.24 //y=1.75
c1190 ( 206 0 ) capacitor c=0.0207459f //x=18.24 //y=1.44
c1191 ( 205 0 ) capacitor c=0.0194308f //x=18.24 //y=1.095
c1192 ( 197 0 ) capacitor c=0.024933f //x=3.045 //y=4.97
c1193 ( 196 0 ) capacitor c=0.0826756f //x=2.8 //y=2.095
c1194 ( 195 0 ) capacitor c=0.0170266f //x=2.8 //y=1.63
c1195 ( 194 0 ) capacitor c=0.018609f //x=2.8 //y=1.4
c1196 ( 193 0 ) capacitor c=0.0187309f //x=2.8 //y=1.09
c1197 ( 187 0 ) capacitor c=0.014725f //x=2.645 //y=1.555
c1198 ( 185 0 ) capacitor c=0.0146567f //x=2.645 //y=0.935
c1199 ( 184 0 ) capacitor c=0.0335408f //x=2.275 //y=1.4
c1200 ( 183 0 ) capacitor c=0.0173761f //x=2.275 //y=1.09
c1201 ( 182 0 ) capacitor c=0.110114f //x=80.08 //y=6.2
c1202 ( 181 0 ) capacitor c=0.11012f //x=79.64 //y=6.2
c1203 ( 180 0 ) capacitor c=0.158794f //x=76.15 //y=6.2
c1204 ( 179 0 ) capacitor c=0.11002f //x=75.71 //y=6.2
c1205 ( 178 0 ) capacitor c=0.109949f //x=60.84 //y=6.2
c1206 ( 177 0 ) capacitor c=0.109956f //x=60.4 //y=6.2
c1207 ( 176 0 ) capacitor c=0.109949f //x=51.22 //y=6.2
c1208 ( 175 0 ) capacitor c=0.109956f //x=50.78 //y=6.2
c1209 ( 174 0 ) capacitor c=0.158754f //x=47.29 //y=6.2
c1210 ( 173 0 ) capacitor c=0.109949f //x=46.85 //y=6.2
c1211 ( 172 0 ) capacitor c=0.109949f //x=31.98 //y=6.2
c1212 ( 171 0 ) capacitor c=0.109956f //x=31.54 //y=6.2
c1213 ( 170 0 ) capacitor c=0.110114f //x=22.36 //y=6.2
c1214 ( 169 0 ) capacitor c=0.11012f //x=21.92 //y=6.2
c1215 ( 168 0 ) capacitor c=0.158794f //x=18.43 //y=6.2
c1216 ( 167 0 ) capacitor c=0.110114f //x=17.99 //y=6.2
c1217 ( 166 0 ) capacitor c=0.110114f //x=3.12 //y=6.2
c1218 ( 165 0 ) capacitor c=0.11012f //x=2.68 //y=6.2
c1219 ( 147 0 ) capacitor c=0.0925003f //x=79.67 //y=2.26
c1220 ( 138 0 ) capacitor c=0.0818106f //x=75.97 //y=2.26
c1221 ( 127 0 ) capacitor c=0.092289f //x=60.43 //y=2.26
c1222 ( 117 0 ) capacitor c=0.0898147f //x=50.81 //y=2.26
c1223 ( 108 0 ) capacitor c=0.0797966f //x=47.11 //y=2.26
c1224 ( 97 0 ) capacitor c=0.0929489f //x=31.57 //y=2.26
c1225 ( 87 0 ) capacitor c=0.0915318f //x=21.95 //y=2.26
c1226 ( 78 0 ) capacitor c=0.081834f //x=18.25 //y=2.26
c1227 ( 65 0 ) capacitor c=0.100124f //x=2.71 //y=2.26
c1228 ( 16 0 ) capacitor c=0.00626811f //x=76.085 //y=2.4
c1229 ( 15 0 ) capacitor c=0.0882914f //x=79.555 //y=2.4
c1230 ( 14 0 ) capacitor c=0.00683472f //x=60.545 //y=2.4
c1231 ( 13 0 ) capacitor c=0.318477f //x=75.855 //y=2.4
c1232 ( 12 0 ) capacitor c=0.0059254f //x=50.925 //y=2.4
c1233 ( 11 0 ) capacitor c=0.207602f //x=60.315 //y=2.4
c1234 ( 10 0 ) capacitor c=0.00618146f //x=47.225 //y=2.4
c1235 ( 9 0 ) capacitor c=0.0804516f //x=50.695 //y=2.4
c1236 ( 8 0 ) capacitor c=0.00683472f //x=31.685 //y=2.4
c1237 ( 7 0 ) capacitor c=0.318477f //x=46.995 //y=2.4
c1238 ( 6 0 ) capacitor c=0.00601205f //x=22.065 //y=2.4
c1239 ( 5 0 ) capacitor c=0.208107f //x=31.455 //y=2.4
c1240 ( 4 0 ) capacitor c=0.00626811f //x=18.365 //y=2.4
c1241 ( 3 0 ) capacitor c=0.0805381f //x=21.835 //y=2.4
c1242 ( 2 0 ) capacitor c=0.0163048f //x=2.825 //y=2.4
c1243 ( 1 0 ) capacitor c=0.330466f //x=18.135 //y=2.4
r1244 (  438 439 ) resistor r=32.4568 //w=0.214 //l=0.075 //layer=ply \
 //thickness=0.18 //x=79.67 //y=4.97 //x2=79.67 //y2=5.045
r1245 (  436 438 ) resistor r=20.271 //w=0.214 //l=0.09 //layer=ply \
 //thickness=0.18 //x=79.67 //y=4.88 //x2=79.67 //y2=4.97
r1246 (  424 425 ) resistor r=52.7279 //w=0.214 //l=0.165 //layer=ply \
 //thickness=0.18 //x=75.97 //y=2.26 //x2=75.97 //y2=2.095
r1247 (  417 418 ) resistor r=32.4568 //w=0.214 //l=0.075 //layer=ply \
 //thickness=0.18 //x=60.43 //y=4.97 //x2=60.43 //y2=5.045
r1248 (  415 417 ) resistor r=20.271 //w=0.214 //l=0.09 //layer=ply \
 //thickness=0.18 //x=60.43 //y=4.88 //x2=60.43 //y2=4.97
r1249 (  406 407 ) resistor r=32.4568 //w=0.214 //l=0.075 //layer=ply \
 //thickness=0.18 //x=50.81 //y=4.97 //x2=50.81 //y2=5.045
r1250 (  404 406 ) resistor r=20.271 //w=0.214 //l=0.09 //layer=ply \
 //thickness=0.18 //x=50.81 //y=4.88 //x2=50.81 //y2=4.97
r1251 (  392 393 ) resistor r=52.7279 //w=0.214 //l=0.165 //layer=ply \
 //thickness=0.18 //x=47.11 //y=2.26 //x2=47.11 //y2=2.095
r1252 (  385 386 ) resistor r=32.4568 //w=0.214 //l=0.075 //layer=ply \
 //thickness=0.18 //x=31.57 //y=4.97 //x2=31.57 //y2=5.045
r1253 (  383 385 ) resistor r=20.271 //w=0.214 //l=0.09 //layer=ply \
 //thickness=0.18 //x=31.57 //y=4.88 //x2=31.57 //y2=4.97
r1254 (  374 375 ) resistor r=32.4568 //w=0.214 //l=0.075 //layer=ply \
 //thickness=0.18 //x=21.95 //y=4.97 //x2=21.95 //y2=5.045
r1255 (  372 374 ) resistor r=20.271 //w=0.214 //l=0.09 //layer=ply \
 //thickness=0.18 //x=21.95 //y=4.88 //x2=21.95 //y2=4.97
r1256 (  360 361 ) resistor r=52.7279 //w=0.214 //l=0.165 //layer=ply \
 //thickness=0.18 //x=18.25 //y=2.26 //x2=18.25 //y2=2.095
r1257 (  353 354 ) resistor r=32.4568 //w=0.214 //l=0.075 //layer=ply \
 //thickness=0.18 //x=2.71 //y=4.97 //x2=2.71 //y2=5.045
r1258 (  351 353 ) resistor r=20.271 //w=0.214 //l=0.09 //layer=ply \
 //thickness=0.18 //x=2.71 //y=4.88 //x2=2.71 //y2=4.97
r1259 (  344 438 ) resistor r=16.5046 //w=0.27 //l=0.135 //layer=ply \
 //thickness=0.18 //x=79.805 //y=4.97 //x2=79.67 //y2=4.97
r1260 (  343 345 ) resistor r=26.9307 //w=0.15 //l=0.106066 //layer=ply \
 //thickness=0.18 //x=80.005 //y=4.97 //x2=80.08 //y2=5.045
r1261 (  343 344 ) resistor r=102.553 //w=0.094 //l=0.2 //layer=ply \
 //thickness=0.18 //x=80.005 //y=4.97 //x2=79.805 //y2=4.97
r1262 (  342 443 ) resistor r=38.6777 //w=0.284 //l=0.198997 //layer=ply \
 //thickness=0.18 //x=79.76 //y=2.095 //x2=79.685 //y2=2.26
r1263 (  341 441 ) resistor r=21.2976 //w=0.217 //l=0.0928709 //layer=ply \
 //thickness=0.18 //x=79.76 //y=1.63 //x2=79.72 //y2=1.555
r1264 (  341 342 ) resistor r=238.436 //w=0.094 //l=0.465 //layer=ply \
 //thickness=0.18 //x=79.76 //y=1.63 //x2=79.76 //y2=2.095
r1265 (  340 441 ) resistor r=39.0671 //w=0.217 //l=0.173853 //layer=ply \
 //thickness=0.18 //x=79.76 //y=1.4 //x2=79.72 //y2=1.555
r1266 (  339 440 ) resistor r=45.1352 //w=0.168 //l=0.173853 //layer=ply \
 //thickness=0.18 //x=79.76 //y=1.09 //x2=79.72 //y2=0.935
r1267 (  339 340 ) resistor r=158.957 //w=0.094 //l=0.31 //layer=ply \
 //thickness=0.18 //x=79.76 //y=1.09 //x2=79.76 //y2=1.4
r1268 (  334 434 ) resistor r=5.52526 //w=0.168 //l=0.115 //layer=ply \
 //thickness=0.18 //x=79.39 //y=1.555 //x2=79.275 //y2=1.555
r1269 (  333 441 ) resistor r=11.4558 //w=0.217 //l=0.115 //layer=ply \
 //thickness=0.18 //x=79.605 //y=1.555 //x2=79.72 //y2=1.555
r1270 (  332 433 ) resistor r=5.52526 //w=0.168 //l=0.115 //layer=ply \
 //thickness=0.18 //x=79.39 //y=0.935 //x2=79.275 //y2=0.935
r1271 (  331 440 ) resistor r=5.52526 //w=0.168 //l=0.115 //layer=ply \
 //thickness=0.18 //x=79.605 //y=0.935 //x2=79.72 //y2=0.935
r1272 (  331 332 ) resistor r=110.245 //w=0.094 //l=0.215 //layer=ply \
 //thickness=0.18 //x=79.605 //y=0.935 //x2=79.39 //y2=0.935
r1273 (  330 434 ) resistor r=45.1352 //w=0.168 //l=0.173853 //layer=ply \
 //thickness=0.18 //x=79.235 //y=1.4 //x2=79.275 //y2=1.555
r1274 (  329 433 ) resistor r=45.1352 //w=0.168 //l=0.173853 //layer=ply \
 //thickness=0.18 //x=79.235 //y=1.09 //x2=79.275 //y2=0.935
r1275 (  329 330 ) resistor r=158.957 //w=0.094 //l=0.31 //layer=ply \
 //thickness=0.18 //x=79.235 //y=1.09 //x2=79.235 //y2=1.4
r1276 (  328 432 ) resistor r=45.1352 //w=0.168 //l=0.173853 //layer=ply \
 //thickness=0.18 //x=76.49 //y=1.44 //x2=76.45 //y2=1.595
r1277 (  327 431 ) resistor r=45.1352 //w=0.168 //l=0.173853 //layer=ply \
 //thickness=0.18 //x=76.49 //y=1.095 //x2=76.45 //y2=0.94
r1278 (  327 328 ) resistor r=176.904 //w=0.094 //l=0.345 //layer=ply \
 //thickness=0.18 //x=76.49 //y=1.095 //x2=76.49 //y2=1.44
r1279 (  325 428 ) resistor r=10.701 //w=0.21 //l=0.115 //layer=ply \
 //thickness=0.18 //x=76.115 //y=1.595 //x2=76 //y2=1.595
r1280 (  324 432 ) resistor r=5.52526 //w=0.168 //l=0.115 //layer=ply \
 //thickness=0.18 //x=76.335 //y=1.595 //x2=76.45 //y2=1.595
r1281 (  323 427 ) resistor r=5.52526 //w=0.168 //l=0.115 //layer=ply \
 //thickness=0.18 //x=76.115 //y=0.94 //x2=76 //y2=0.94
r1282 (  322 431 ) resistor r=5.52526 //w=0.168 //l=0.115 //layer=ply \
 //thickness=0.18 //x=76.335 //y=0.94 //x2=76.45 //y2=0.94
r1283 (  322 323 ) resistor r=112.809 //w=0.094 //l=0.22 //layer=ply \
 //thickness=0.18 //x=76.335 //y=0.94 //x2=76.115 //y2=0.94
r1284 (  319 430 ) resistor r=37.236 //w=0.233 //l=0.249199 //layer=ply \
 //thickness=0.18 //x=76.15 //y=5.045 //x2=75.97 //y2=4.88
r1285 (  317 428 ) resistor r=39.5823 //w=0.21 //l=0.173853 //layer=ply \
 //thickness=0.18 //x=75.96 //y=1.75 //x2=76 //y2=1.595
r1286 (  317 425 ) resistor r=176.904 //w=0.094 //l=0.345 //layer=ply \
 //thickness=0.18 //x=75.96 //y=1.75 //x2=75.96 //y2=2.095
r1287 (  316 428 ) resistor r=39.5823 //w=0.21 //l=0.173853 //layer=ply \
 //thickness=0.18 //x=75.96 //y=1.44 //x2=76 //y2=1.595
r1288 (  315 427 ) resistor r=45.1352 //w=0.168 //l=0.173853 //layer=ply \
 //thickness=0.18 //x=75.96 //y=1.095 //x2=76 //y2=0.94
r1289 (  315 316 ) resistor r=176.904 //w=0.094 //l=0.345 //layer=ply \
 //thickness=0.18 //x=75.96 //y=1.095 //x2=75.96 //y2=1.44
r1290 (  312 430 ) resistor r=53.7854 //w=0.233 //l=0.332415 //layer=ply \
 //thickness=0.18 //x=75.71 //y=5.045 //x2=75.97 //y2=4.88
r1291 (  308 417 ) resistor r=16.5046 //w=0.27 //l=0.135 //layer=ply \
 //thickness=0.18 //x=60.565 //y=4.97 //x2=60.43 //y2=4.97
r1292 (  307 309 ) resistor r=26.9307 //w=0.15 //l=0.106066 //layer=ply \
 //thickness=0.18 //x=60.765 //y=4.97 //x2=60.84 //y2=5.045
r1293 (  307 308 ) resistor r=102.553 //w=0.094 //l=0.2 //layer=ply \
 //thickness=0.18 //x=60.765 //y=4.97 //x2=60.565 //y2=4.97
r1294 (  306 422 ) resistor r=38.6777 //w=0.284 //l=0.198997 //layer=ply \
 //thickness=0.18 //x=60.52 //y=2.095 //x2=60.445 //y2=2.26
r1295 (  305 420 ) resistor r=21.2976 //w=0.217 //l=0.0928709 //layer=ply \
 //thickness=0.18 //x=60.52 //y=1.63 //x2=60.48 //y2=1.555
r1296 (  305 306 ) resistor r=238.436 //w=0.094 //l=0.465 //layer=ply \
 //thickness=0.18 //x=60.52 //y=1.63 //x2=60.52 //y2=2.095
r1297 (  304 420 ) resistor r=39.0671 //w=0.217 //l=0.173853 //layer=ply \
 //thickness=0.18 //x=60.52 //y=1.4 //x2=60.48 //y2=1.555
r1298 (  303 419 ) resistor r=45.1352 //w=0.168 //l=0.173853 //layer=ply \
 //thickness=0.18 //x=60.52 //y=1.09 //x2=60.48 //y2=0.935
r1299 (  303 304 ) resistor r=158.957 //w=0.094 //l=0.31 //layer=ply \
 //thickness=0.18 //x=60.52 //y=1.09 //x2=60.52 //y2=1.4
r1300 (  298 413 ) resistor r=5.52526 //w=0.168 //l=0.115 //layer=ply \
 //thickness=0.18 //x=60.15 //y=1.555 //x2=60.035 //y2=1.555
r1301 (  297 420 ) resistor r=11.4558 //w=0.217 //l=0.115 //layer=ply \
 //thickness=0.18 //x=60.365 //y=1.555 //x2=60.48 //y2=1.555
r1302 (  296 412 ) resistor r=5.52526 //w=0.168 //l=0.115 //layer=ply \
 //thickness=0.18 //x=60.15 //y=0.935 //x2=60.035 //y2=0.935
r1303 (  295 419 ) resistor r=5.52526 //w=0.168 //l=0.115 //layer=ply \
 //thickness=0.18 //x=60.365 //y=0.935 //x2=60.48 //y2=0.935
r1304 (  295 296 ) resistor r=110.245 //w=0.094 //l=0.215 //layer=ply \
 //thickness=0.18 //x=60.365 //y=0.935 //x2=60.15 //y2=0.935
r1305 (  294 413 ) resistor r=45.1352 //w=0.168 //l=0.173853 //layer=ply \
 //thickness=0.18 //x=59.995 //y=1.4 //x2=60.035 //y2=1.555
r1306 (  293 412 ) resistor r=45.1352 //w=0.168 //l=0.173853 //layer=ply \
 //thickness=0.18 //x=59.995 //y=1.09 //x2=60.035 //y2=0.935
r1307 (  293 294 ) resistor r=158.957 //w=0.094 //l=0.31 //layer=ply \
 //thickness=0.18 //x=59.995 //y=1.09 //x2=59.995 //y2=1.4
r1308 (  289 406 ) resistor r=16.5046 //w=0.27 //l=0.135 //layer=ply \
 //thickness=0.18 //x=50.945 //y=4.97 //x2=50.81 //y2=4.97
r1309 (  288 290 ) resistor r=26.9307 //w=0.15 //l=0.106066 //layer=ply \
 //thickness=0.18 //x=51.145 //y=4.97 //x2=51.22 //y2=5.045
r1310 (  288 289 ) resistor r=102.553 //w=0.094 //l=0.2 //layer=ply \
 //thickness=0.18 //x=51.145 //y=4.97 //x2=50.945 //y2=4.97
r1311 (  287 411 ) resistor r=38.6777 //w=0.284 //l=0.198997 //layer=ply \
 //thickness=0.18 //x=50.9 //y=2.095 //x2=50.825 //y2=2.26
r1312 (  286 409 ) resistor r=21.2976 //w=0.217 //l=0.0928709 //layer=ply \
 //thickness=0.18 //x=50.9 //y=1.63 //x2=50.86 //y2=1.555
r1313 (  286 287 ) resistor r=238.436 //w=0.094 //l=0.465 //layer=ply \
 //thickness=0.18 //x=50.9 //y=1.63 //x2=50.9 //y2=2.095
r1314 (  285 409 ) resistor r=39.0671 //w=0.217 //l=0.173853 //layer=ply \
 //thickness=0.18 //x=50.9 //y=1.4 //x2=50.86 //y2=1.555
r1315 (  284 408 ) resistor r=45.1352 //w=0.168 //l=0.173853 //layer=ply \
 //thickness=0.18 //x=50.9 //y=1.09 //x2=50.86 //y2=0.935
r1316 (  284 285 ) resistor r=158.957 //w=0.094 //l=0.31 //layer=ply \
 //thickness=0.18 //x=50.9 //y=1.09 //x2=50.9 //y2=1.4
r1317 (  279 402 ) resistor r=5.52526 //w=0.168 //l=0.115 //layer=ply \
 //thickness=0.18 //x=50.53 //y=1.555 //x2=50.415 //y2=1.555
r1318 (  278 409 ) resistor r=11.4558 //w=0.217 //l=0.115 //layer=ply \
 //thickness=0.18 //x=50.745 //y=1.555 //x2=50.86 //y2=1.555
r1319 (  277 401 ) resistor r=5.52526 //w=0.168 //l=0.115 //layer=ply \
 //thickness=0.18 //x=50.53 //y=0.935 //x2=50.415 //y2=0.935
r1320 (  276 408 ) resistor r=5.52526 //w=0.168 //l=0.115 //layer=ply \
 //thickness=0.18 //x=50.745 //y=0.935 //x2=50.86 //y2=0.935
r1321 (  276 277 ) resistor r=110.245 //w=0.094 //l=0.215 //layer=ply \
 //thickness=0.18 //x=50.745 //y=0.935 //x2=50.53 //y2=0.935
r1322 (  275 402 ) resistor r=45.1352 //w=0.168 //l=0.173853 //layer=ply \
 //thickness=0.18 //x=50.375 //y=1.4 //x2=50.415 //y2=1.555
r1323 (  274 401 ) resistor r=45.1352 //w=0.168 //l=0.173853 //layer=ply \
 //thickness=0.18 //x=50.375 //y=1.09 //x2=50.415 //y2=0.935
r1324 (  274 275 ) resistor r=158.957 //w=0.094 //l=0.31 //layer=ply \
 //thickness=0.18 //x=50.375 //y=1.09 //x2=50.375 //y2=1.4
r1325 (  273 400 ) resistor r=45.1352 //w=0.168 //l=0.173853 //layer=ply \
 //thickness=0.18 //x=47.63 //y=1.44 //x2=47.59 //y2=1.595
r1326 (  272 399 ) resistor r=45.1352 //w=0.168 //l=0.173853 //layer=ply \
 //thickness=0.18 //x=47.63 //y=1.095 //x2=47.59 //y2=0.94
r1327 (  272 273 ) resistor r=176.904 //w=0.094 //l=0.345 //layer=ply \
 //thickness=0.18 //x=47.63 //y=1.095 //x2=47.63 //y2=1.44
r1328 (  270 396 ) resistor r=10.701 //w=0.21 //l=0.115 //layer=ply \
 //thickness=0.18 //x=47.255 //y=1.595 //x2=47.14 //y2=1.595
r1329 (  269 400 ) resistor r=5.52526 //w=0.168 //l=0.115 //layer=ply \
 //thickness=0.18 //x=47.475 //y=1.595 //x2=47.59 //y2=1.595
r1330 (  268 395 ) resistor r=5.52526 //w=0.168 //l=0.115 //layer=ply \
 //thickness=0.18 //x=47.255 //y=0.94 //x2=47.14 //y2=0.94
r1331 (  267 399 ) resistor r=5.52526 //w=0.168 //l=0.115 //layer=ply \
 //thickness=0.18 //x=47.475 //y=0.94 //x2=47.59 //y2=0.94
r1332 (  267 268 ) resistor r=112.809 //w=0.094 //l=0.22 //layer=ply \
 //thickness=0.18 //x=47.475 //y=0.94 //x2=47.255 //y2=0.94
r1333 (  264 398 ) resistor r=37.236 //w=0.233 //l=0.249199 //layer=ply \
 //thickness=0.18 //x=47.29 //y=5.045 //x2=47.11 //y2=4.88
r1334 (  262 396 ) resistor r=39.5823 //w=0.21 //l=0.173853 //layer=ply \
 //thickness=0.18 //x=47.1 //y=1.75 //x2=47.14 //y2=1.595
r1335 (  262 393 ) resistor r=176.904 //w=0.094 //l=0.345 //layer=ply \
 //thickness=0.18 //x=47.1 //y=1.75 //x2=47.1 //y2=2.095
r1336 (  261 396 ) resistor r=39.5823 //w=0.21 //l=0.173853 //layer=ply \
 //thickness=0.18 //x=47.1 //y=1.44 //x2=47.14 //y2=1.595
r1337 (  260 395 ) resistor r=45.1352 //w=0.168 //l=0.173853 //layer=ply \
 //thickness=0.18 //x=47.1 //y=1.095 //x2=47.14 //y2=0.94
r1338 (  260 261 ) resistor r=176.904 //w=0.094 //l=0.345 //layer=ply \
 //thickness=0.18 //x=47.1 //y=1.095 //x2=47.1 //y2=1.44
r1339 (  257 398 ) resistor r=53.7854 //w=0.233 //l=0.332415 //layer=ply \
 //thickness=0.18 //x=46.85 //y=5.045 //x2=47.11 //y2=4.88
r1340 (  253 385 ) resistor r=16.5046 //w=0.27 //l=0.135 //layer=ply \
 //thickness=0.18 //x=31.705 //y=4.97 //x2=31.57 //y2=4.97
r1341 (  252 254 ) resistor r=26.9307 //w=0.15 //l=0.106066 //layer=ply \
 //thickness=0.18 //x=31.905 //y=4.97 //x2=31.98 //y2=5.045
r1342 (  252 253 ) resistor r=102.553 //w=0.094 //l=0.2 //layer=ply \
 //thickness=0.18 //x=31.905 //y=4.97 //x2=31.705 //y2=4.97
r1343 (  251 390 ) resistor r=38.6777 //w=0.284 //l=0.198997 //layer=ply \
 //thickness=0.18 //x=31.66 //y=2.095 //x2=31.585 //y2=2.26
r1344 (  250 388 ) resistor r=21.2976 //w=0.217 //l=0.0928709 //layer=ply \
 //thickness=0.18 //x=31.66 //y=1.63 //x2=31.62 //y2=1.555
r1345 (  250 251 ) resistor r=238.436 //w=0.094 //l=0.465 //layer=ply \
 //thickness=0.18 //x=31.66 //y=1.63 //x2=31.66 //y2=2.095
r1346 (  249 388 ) resistor r=39.0671 //w=0.217 //l=0.173853 //layer=ply \
 //thickness=0.18 //x=31.66 //y=1.4 //x2=31.62 //y2=1.555
r1347 (  248 387 ) resistor r=45.1352 //w=0.168 //l=0.173853 //layer=ply \
 //thickness=0.18 //x=31.66 //y=1.09 //x2=31.62 //y2=0.935
r1348 (  248 249 ) resistor r=158.957 //w=0.094 //l=0.31 //layer=ply \
 //thickness=0.18 //x=31.66 //y=1.09 //x2=31.66 //y2=1.4
r1349 (  243 381 ) resistor r=5.52526 //w=0.168 //l=0.115 //layer=ply \
 //thickness=0.18 //x=31.29 //y=1.555 //x2=31.175 //y2=1.555
r1350 (  242 388 ) resistor r=11.4558 //w=0.217 //l=0.115 //layer=ply \
 //thickness=0.18 //x=31.505 //y=1.555 //x2=31.62 //y2=1.555
r1351 (  241 380 ) resistor r=5.52526 //w=0.168 //l=0.115 //layer=ply \
 //thickness=0.18 //x=31.29 //y=0.935 //x2=31.175 //y2=0.935
r1352 (  240 387 ) resistor r=5.52526 //w=0.168 //l=0.115 //layer=ply \
 //thickness=0.18 //x=31.505 //y=0.935 //x2=31.62 //y2=0.935
r1353 (  240 241 ) resistor r=110.245 //w=0.094 //l=0.215 //layer=ply \
 //thickness=0.18 //x=31.505 //y=0.935 //x2=31.29 //y2=0.935
r1354 (  239 381 ) resistor r=45.1352 //w=0.168 //l=0.173853 //layer=ply \
 //thickness=0.18 //x=31.135 //y=1.4 //x2=31.175 //y2=1.555
r1355 (  238 380 ) resistor r=45.1352 //w=0.168 //l=0.173853 //layer=ply \
 //thickness=0.18 //x=31.135 //y=1.09 //x2=31.175 //y2=0.935
r1356 (  238 239 ) resistor r=158.957 //w=0.094 //l=0.31 //layer=ply \
 //thickness=0.18 //x=31.135 //y=1.09 //x2=31.135 //y2=1.4
r1357 (  234 374 ) resistor r=16.5046 //w=0.27 //l=0.135 //layer=ply \
 //thickness=0.18 //x=22.085 //y=4.97 //x2=21.95 //y2=4.97
r1358 (  233 235 ) resistor r=26.9307 //w=0.15 //l=0.106066 //layer=ply \
 //thickness=0.18 //x=22.285 //y=4.97 //x2=22.36 //y2=5.045
r1359 (  233 234 ) resistor r=102.553 //w=0.094 //l=0.2 //layer=ply \
 //thickness=0.18 //x=22.285 //y=4.97 //x2=22.085 //y2=4.97
r1360 (  232 379 ) resistor r=38.6777 //w=0.284 //l=0.198997 //layer=ply \
 //thickness=0.18 //x=22.04 //y=2.095 //x2=21.965 //y2=2.26
r1361 (  231 377 ) resistor r=21.2976 //w=0.217 //l=0.0928709 //layer=ply \
 //thickness=0.18 //x=22.04 //y=1.63 //x2=22 //y2=1.555
r1362 (  231 232 ) resistor r=238.436 //w=0.094 //l=0.465 //layer=ply \
 //thickness=0.18 //x=22.04 //y=1.63 //x2=22.04 //y2=2.095
r1363 (  230 377 ) resistor r=39.0671 //w=0.217 //l=0.173853 //layer=ply \
 //thickness=0.18 //x=22.04 //y=1.4 //x2=22 //y2=1.555
r1364 (  229 376 ) resistor r=45.1352 //w=0.168 //l=0.173853 //layer=ply \
 //thickness=0.18 //x=22.04 //y=1.09 //x2=22 //y2=0.935
r1365 (  229 230 ) resistor r=158.957 //w=0.094 //l=0.31 //layer=ply \
 //thickness=0.18 //x=22.04 //y=1.09 //x2=22.04 //y2=1.4
r1366 (  224 370 ) resistor r=5.52526 //w=0.168 //l=0.115 //layer=ply \
 //thickness=0.18 //x=21.67 //y=1.555 //x2=21.555 //y2=1.555
r1367 (  223 377 ) resistor r=11.4558 //w=0.217 //l=0.115 //layer=ply \
 //thickness=0.18 //x=21.885 //y=1.555 //x2=22 //y2=1.555
r1368 (  222 369 ) resistor r=5.52526 //w=0.168 //l=0.115 //layer=ply \
 //thickness=0.18 //x=21.67 //y=0.935 //x2=21.555 //y2=0.935
r1369 (  221 376 ) resistor r=5.52526 //w=0.168 //l=0.115 //layer=ply \
 //thickness=0.18 //x=21.885 //y=0.935 //x2=22 //y2=0.935
r1370 (  221 222 ) resistor r=110.245 //w=0.094 //l=0.215 //layer=ply \
 //thickness=0.18 //x=21.885 //y=0.935 //x2=21.67 //y2=0.935
r1371 (  220 370 ) resistor r=45.1352 //w=0.168 //l=0.173853 //layer=ply \
 //thickness=0.18 //x=21.515 //y=1.4 //x2=21.555 //y2=1.555
r1372 (  219 369 ) resistor r=45.1352 //w=0.168 //l=0.173853 //layer=ply \
 //thickness=0.18 //x=21.515 //y=1.09 //x2=21.555 //y2=0.935
r1373 (  219 220 ) resistor r=158.957 //w=0.094 //l=0.31 //layer=ply \
 //thickness=0.18 //x=21.515 //y=1.09 //x2=21.515 //y2=1.4
r1374 (  218 368 ) resistor r=45.1352 //w=0.168 //l=0.173853 //layer=ply \
 //thickness=0.18 //x=18.77 //y=1.44 //x2=18.73 //y2=1.595
r1375 (  217 367 ) resistor r=45.1352 //w=0.168 //l=0.173853 //layer=ply \
 //thickness=0.18 //x=18.77 //y=1.095 //x2=18.73 //y2=0.94
r1376 (  217 218 ) resistor r=176.904 //w=0.094 //l=0.345 //layer=ply \
 //thickness=0.18 //x=18.77 //y=1.095 //x2=18.77 //y2=1.44
r1377 (  215 364 ) resistor r=10.701 //w=0.21 //l=0.115 //layer=ply \
 //thickness=0.18 //x=18.395 //y=1.595 //x2=18.28 //y2=1.595
r1378 (  214 368 ) resistor r=5.52526 //w=0.168 //l=0.115 //layer=ply \
 //thickness=0.18 //x=18.615 //y=1.595 //x2=18.73 //y2=1.595
r1379 (  213 363 ) resistor r=5.52526 //w=0.168 //l=0.115 //layer=ply \
 //thickness=0.18 //x=18.395 //y=0.94 //x2=18.28 //y2=0.94
r1380 (  212 367 ) resistor r=5.52526 //w=0.168 //l=0.115 //layer=ply \
 //thickness=0.18 //x=18.615 //y=0.94 //x2=18.73 //y2=0.94
r1381 (  212 213 ) resistor r=112.809 //w=0.094 //l=0.22 //layer=ply \
 //thickness=0.18 //x=18.615 //y=0.94 //x2=18.395 //y2=0.94
r1382 (  209 366 ) resistor r=37.236 //w=0.233 //l=0.249199 //layer=ply \
 //thickness=0.18 //x=18.43 //y=5.045 //x2=18.25 //y2=4.88
r1383 (  207 364 ) resistor r=39.5823 //w=0.21 //l=0.173853 //layer=ply \
 //thickness=0.18 //x=18.24 //y=1.75 //x2=18.28 //y2=1.595
r1384 (  207 361 ) resistor r=176.904 //w=0.094 //l=0.345 //layer=ply \
 //thickness=0.18 //x=18.24 //y=1.75 //x2=18.24 //y2=2.095
r1385 (  206 364 ) resistor r=39.5823 //w=0.21 //l=0.173853 //layer=ply \
 //thickness=0.18 //x=18.24 //y=1.44 //x2=18.28 //y2=1.595
r1386 (  205 363 ) resistor r=45.1352 //w=0.168 //l=0.173853 //layer=ply \
 //thickness=0.18 //x=18.24 //y=1.095 //x2=18.28 //y2=0.94
r1387 (  205 206 ) resistor r=176.904 //w=0.094 //l=0.345 //layer=ply \
 //thickness=0.18 //x=18.24 //y=1.095 //x2=18.24 //y2=1.44
r1388 (  202 366 ) resistor r=53.7854 //w=0.233 //l=0.332415 //layer=ply \
 //thickness=0.18 //x=17.99 //y=5.045 //x2=18.25 //y2=4.88
r1389 (  198 353 ) resistor r=16.5046 //w=0.27 //l=0.135 //layer=ply \
 //thickness=0.18 //x=2.845 //y=4.97 //x2=2.71 //y2=4.97
r1390 (  197 199 ) resistor r=26.9307 //w=0.15 //l=0.106066 //layer=ply \
 //thickness=0.18 //x=3.045 //y=4.97 //x2=3.12 //y2=5.045
r1391 (  197 198 ) resistor r=102.553 //w=0.094 //l=0.2 //layer=ply \
 //thickness=0.18 //x=3.045 //y=4.97 //x2=2.845 //y2=4.97
r1392 (  196 358 ) resistor r=38.6777 //w=0.284 //l=0.198997 //layer=ply \
 //thickness=0.18 //x=2.8 //y=2.095 //x2=2.725 //y2=2.26
r1393 (  195 356 ) resistor r=21.2976 //w=0.217 //l=0.0928709 //layer=ply \
 //thickness=0.18 //x=2.8 //y=1.63 //x2=2.76 //y2=1.555
r1394 (  195 196 ) resistor r=238.436 //w=0.094 //l=0.465 //layer=ply \
 //thickness=0.18 //x=2.8 //y=1.63 //x2=2.8 //y2=2.095
r1395 (  194 356 ) resistor r=39.0671 //w=0.217 //l=0.173853 //layer=ply \
 //thickness=0.18 //x=2.8 //y=1.4 //x2=2.76 //y2=1.555
r1396 (  193 355 ) resistor r=45.1352 //w=0.168 //l=0.173853 //layer=ply \
 //thickness=0.18 //x=2.8 //y=1.09 //x2=2.76 //y2=0.935
r1397 (  193 194 ) resistor r=158.957 //w=0.094 //l=0.31 //layer=ply \
 //thickness=0.18 //x=2.8 //y=1.09 //x2=2.8 //y2=1.4
r1398 (  188 349 ) resistor r=5.52526 //w=0.168 //l=0.115 //layer=ply \
 //thickness=0.18 //x=2.43 //y=1.555 //x2=2.315 //y2=1.555
r1399 (  187 356 ) resistor r=11.4558 //w=0.217 //l=0.115 //layer=ply \
 //thickness=0.18 //x=2.645 //y=1.555 //x2=2.76 //y2=1.555
r1400 (  186 348 ) resistor r=5.52526 //w=0.168 //l=0.115 //layer=ply \
 //thickness=0.18 //x=2.43 //y=0.935 //x2=2.315 //y2=0.935
r1401 (  185 355 ) resistor r=5.52526 //w=0.168 //l=0.115 //layer=ply \
 //thickness=0.18 //x=2.645 //y=0.935 //x2=2.76 //y2=0.935
r1402 (  185 186 ) resistor r=110.245 //w=0.094 //l=0.215 //layer=ply \
 //thickness=0.18 //x=2.645 //y=0.935 //x2=2.43 //y2=0.935
r1403 (  184 349 ) resistor r=45.1352 //w=0.168 //l=0.173853 //layer=ply \
 //thickness=0.18 //x=2.275 //y=1.4 //x2=2.315 //y2=1.555
r1404 (  183 348 ) resistor r=45.1352 //w=0.168 //l=0.173853 //layer=ply \
 //thickness=0.18 //x=2.275 //y=1.09 //x2=2.315 //y2=0.935
r1405 (  183 184 ) resistor r=158.957 //w=0.094 //l=0.31 //layer=ply \
 //thickness=0.18 //x=2.275 //y=1.09 //x2=2.275 //y2=1.4
r1406 (  182 345 ) resistor r=592.245 //w=0.094 //l=1.155 //layer=ply \
 //thickness=0.18 //x=80.08 //y=6.2 //x2=80.08 //y2=5.045
r1407 (  181 439 ) resistor r=592.245 //w=0.094 //l=1.155 //layer=ply \
 //thickness=0.18 //x=79.64 //y=6.2 //x2=79.64 //y2=5.045
r1408 (  180 319 ) resistor r=592.245 //w=0.094 //l=1.155 //layer=ply \
 //thickness=0.18 //x=76.15 //y=6.2 //x2=76.15 //y2=5.045
r1409 (  179 312 ) resistor r=592.245 //w=0.094 //l=1.155 //layer=ply \
 //thickness=0.18 //x=75.71 //y=6.2 //x2=75.71 //y2=5.045
r1410 (  178 309 ) resistor r=592.245 //w=0.094 //l=1.155 //layer=ply \
 //thickness=0.18 //x=60.84 //y=6.2 //x2=60.84 //y2=5.045
r1411 (  177 418 ) resistor r=592.245 //w=0.094 //l=1.155 //layer=ply \
 //thickness=0.18 //x=60.4 //y=6.2 //x2=60.4 //y2=5.045
r1412 (  176 290 ) resistor r=592.245 //w=0.094 //l=1.155 //layer=ply \
 //thickness=0.18 //x=51.22 //y=6.2 //x2=51.22 //y2=5.045
r1413 (  175 407 ) resistor r=592.245 //w=0.094 //l=1.155 //layer=ply \
 //thickness=0.18 //x=50.78 //y=6.2 //x2=50.78 //y2=5.045
r1414 (  174 264 ) resistor r=592.245 //w=0.094 //l=1.155 //layer=ply \
 //thickness=0.18 //x=47.29 //y=6.2 //x2=47.29 //y2=5.045
r1415 (  173 257 ) resistor r=592.245 //w=0.094 //l=1.155 //layer=ply \
 //thickness=0.18 //x=46.85 //y=6.2 //x2=46.85 //y2=5.045
r1416 (  172 254 ) resistor r=592.245 //w=0.094 //l=1.155 //layer=ply \
 //thickness=0.18 //x=31.98 //y=6.2 //x2=31.98 //y2=5.045
r1417 (  171 386 ) resistor r=592.245 //w=0.094 //l=1.155 //layer=ply \
 //thickness=0.18 //x=31.54 //y=6.2 //x2=31.54 //y2=5.045
r1418 (  170 235 ) resistor r=592.245 //w=0.094 //l=1.155 //layer=ply \
 //thickness=0.18 //x=22.36 //y=6.2 //x2=22.36 //y2=5.045
r1419 (  169 375 ) resistor r=592.245 //w=0.094 //l=1.155 //layer=ply \
 //thickness=0.18 //x=21.92 //y=6.2 //x2=21.92 //y2=5.045
r1420 (  168 209 ) resistor r=592.245 //w=0.094 //l=1.155 //layer=ply \
 //thickness=0.18 //x=18.43 //y=6.2 //x2=18.43 //y2=5.045
r1421 (  167 202 ) resistor r=592.245 //w=0.094 //l=1.155 //layer=ply \
 //thickness=0.18 //x=17.99 //y=6.2 //x2=17.99 //y2=5.045
r1422 (  166 199 ) resistor r=592.245 //w=0.094 //l=1.155 //layer=ply \
 //thickness=0.18 //x=3.12 //y=6.2 //x2=3.12 //y2=5.045
r1423 (  165 354 ) resistor r=592.245 //w=0.094 //l=1.155 //layer=ply \
 //thickness=0.18 //x=2.68 //y=6.2 //x2=2.68 //y2=5.045
r1424 (  164 333 ) resistor r=55.3787 //w=0.094 //l=0.108 //layer=ply \
 //thickness=0.18 //x=79.497 //y=1.555 //x2=79.605 //y2=1.555
r1425 (  164 334 ) resistor r=54.866 //w=0.094 //l=0.107 //layer=ply \
 //thickness=0.18 //x=79.497 //y=1.555 //x2=79.39 //y2=1.555
r1426 (  163 324 ) resistor r=56.4043 //w=0.094 //l=0.11 //layer=ply \
 //thickness=0.18 //x=76.225 //y=1.595 //x2=76.335 //y2=1.595
r1427 (  163 325 ) resistor r=56.4043 //w=0.094 //l=0.11 //layer=ply \
 //thickness=0.18 //x=76.225 //y=1.595 //x2=76.115 //y2=1.595
r1428 (  162 297 ) resistor r=55.3787 //w=0.094 //l=0.108 //layer=ply \
 //thickness=0.18 //x=60.257 //y=1.555 //x2=60.365 //y2=1.555
r1429 (  162 298 ) resistor r=54.866 //w=0.094 //l=0.107 //layer=ply \
 //thickness=0.18 //x=60.257 //y=1.555 //x2=60.15 //y2=1.555
r1430 (  161 278 ) resistor r=55.3787 //w=0.094 //l=0.108 //layer=ply \
 //thickness=0.18 //x=50.637 //y=1.555 //x2=50.745 //y2=1.555
r1431 (  161 279 ) resistor r=54.866 //w=0.094 //l=0.107 //layer=ply \
 //thickness=0.18 //x=50.637 //y=1.555 //x2=50.53 //y2=1.555
r1432 (  160 269 ) resistor r=56.4043 //w=0.094 //l=0.11 //layer=ply \
 //thickness=0.18 //x=47.365 //y=1.595 //x2=47.475 //y2=1.595
r1433 (  160 270 ) resistor r=56.4043 //w=0.094 //l=0.11 //layer=ply \
 //thickness=0.18 //x=47.365 //y=1.595 //x2=47.255 //y2=1.595
r1434 (  159 242 ) resistor r=55.3787 //w=0.094 //l=0.108 //layer=ply \
 //thickness=0.18 //x=31.397 //y=1.555 //x2=31.505 //y2=1.555
r1435 (  159 243 ) resistor r=54.866 //w=0.094 //l=0.107 //layer=ply \
 //thickness=0.18 //x=31.397 //y=1.555 //x2=31.29 //y2=1.555
r1436 (  158 223 ) resistor r=55.3787 //w=0.094 //l=0.108 //layer=ply \
 //thickness=0.18 //x=21.777 //y=1.555 //x2=21.885 //y2=1.555
r1437 (  158 224 ) resistor r=54.866 //w=0.094 //l=0.107 //layer=ply \
 //thickness=0.18 //x=21.777 //y=1.555 //x2=21.67 //y2=1.555
r1438 (  157 214 ) resistor r=56.4043 //w=0.094 //l=0.11 //layer=ply \
 //thickness=0.18 //x=18.505 //y=1.595 //x2=18.615 //y2=1.595
r1439 (  157 215 ) resistor r=56.4043 //w=0.094 //l=0.11 //layer=ply \
 //thickness=0.18 //x=18.505 //y=1.595 //x2=18.395 //y2=1.595
r1440 (  156 187 ) resistor r=55.3787 //w=0.094 //l=0.108 //layer=ply \
 //thickness=0.18 //x=2.537 //y=1.555 //x2=2.645 //y2=1.555
r1441 (  156 188 ) resistor r=54.866 //w=0.094 //l=0.107 //layer=ply \
 //thickness=0.18 //x=2.537 //y=1.555 //x2=2.43 //y2=1.555
r1442 (  154 436 ) resistor r=152 //w=0.17 //l=0.17 //layer=licon //count=1 \
 //x=79.67 //y=4.88 //x2=79.67 //y2=4.88
r1443 (  147 443 ) resistor r=152 //w=0.17 //l=0.17 //layer=licon //count=1 \
 //x=79.67 //y=2.26 //x2=79.67 //y2=2.26
r1444 (  144 430 ) resistor r=152 //w=0.17 //l=0.17 //layer=licon //count=1 \
 //x=75.97 //y=4.88 //x2=75.97 //y2=4.88
r1445 (  138 424 ) resistor r=152 //w=0.17 //l=0.17 //layer=licon //count=1 \
 //x=75.97 //y=2.26 //x2=75.97 //y2=2.26
r1446 (  135 415 ) resistor r=152 //w=0.17 //l=0.17 //layer=licon //count=1 \
 //x=60.43 //y=4.88 //x2=60.43 //y2=4.88
r1447 (  127 422 ) resistor r=152 //w=0.17 //l=0.17 //layer=licon //count=1 \
 //x=60.43 //y=2.26 //x2=60.43 //y2=2.26
r1448 (  124 404 ) resistor r=152 //w=0.17 //l=0.17 //layer=licon //count=1 \
 //x=50.81 //y=4.88 //x2=50.81 //y2=4.88
r1449 (  117 411 ) resistor r=152 //w=0.17 //l=0.17 //layer=licon //count=1 \
 //x=50.81 //y=2.26 //x2=50.81 //y2=2.26
r1450 (  114 398 ) resistor r=152 //w=0.17 //l=0.17 //layer=licon //count=1 \
 //x=47.11 //y=4.88 //x2=47.11 //y2=4.88
r1451 (  108 392 ) resistor r=152 //w=0.17 //l=0.17 //layer=licon //count=1 \
 //x=47.11 //y=2.26 //x2=47.11 //y2=2.26
r1452 (  105 383 ) resistor r=152 //w=0.17 //l=0.17 //layer=licon //count=1 \
 //x=31.57 //y=4.88 //x2=31.57 //y2=4.88
r1453 (  97 390 ) resistor r=152 //w=0.17 //l=0.17 //layer=licon //count=1 \
 //x=31.57 //y=2.26 //x2=31.57 //y2=2.26
r1454 (  94 372 ) resistor r=152 //w=0.17 //l=0.17 //layer=licon //count=1 \
 //x=21.95 //y=4.88 //x2=21.95 //y2=4.88
r1455 (  87 379 ) resistor r=152 //w=0.17 //l=0.17 //layer=licon //count=1 \
 //x=21.95 //y=2.26 //x2=21.95 //y2=2.26
r1456 (  84 366 ) resistor r=152 //w=0.17 //l=0.17 //layer=licon //count=1 \
 //x=18.25 //y=4.88 //x2=18.25 //y2=4.88
r1457 (  78 360 ) resistor r=152 //w=0.17 //l=0.17 //layer=licon //count=1 \
 //x=18.25 //y=2.26 //x2=18.25 //y2=2.26
r1458 (  75 351 ) resistor r=152 //w=0.17 //l=0.17 //layer=licon //count=1 \
 //x=2.71 //y=4.88 //x2=2.71 //y2=4.88
r1459 (  65 358 ) resistor r=152 //w=0.17 //l=0.17 //layer=licon //count=1 \
 //x=2.71 //y=2.26 //x2=2.71 //y2=2.26
r1460 (  63 154 ) resistor r=93.7754 //w=0.187 //l=1.37 //layer=li \
 //thickness=0.1 //x=79.67 //y=3.51 //x2=79.67 //y2=4.88
r1461 (  62 63 ) resistor r=50.6524 //w=0.187 //l=0.74 //layer=li \
 //thickness=0.1 //x=79.67 //y=2.77 //x2=79.67 //y2=3.51
r1462 (  61 62 ) resistor r=25.3262 //w=0.187 //l=0.37 //layer=li \
 //thickness=0.1 //x=79.67 //y=2.4 //x2=79.67 //y2=2.77
r1463 (  61 147 ) resistor r=9.58289 //w=0.187 //l=0.14 //layer=li \
 //thickness=0.1 //x=79.67 //y=2.4 //x2=79.67 //y2=2.26
r1464 (  60 144 ) resistor r=144.428 //w=0.187 //l=2.11 //layer=li \
 //thickness=0.1 //x=75.97 //y=2.77 //x2=75.97 //y2=4.88
r1465 (  59 60 ) resistor r=25.3262 //w=0.187 //l=0.37 //layer=li \
 //thickness=0.1 //x=75.97 //y=2.4 //x2=75.97 //y2=2.77
r1466 (  59 138 ) resistor r=9.58289 //w=0.187 //l=0.14 //layer=li \
 //thickness=0.1 //x=75.97 //y=2.4 //x2=75.97 //y2=2.26
r1467 (  58 135 ) resistor r=43.123 //w=0.187 //l=0.63 //layer=li \
 //thickness=0.1 //x=60.43 //y=4.25 //x2=60.43 //y2=4.88
r1468 (  57 58 ) resistor r=50.6524 //w=0.187 //l=0.74 //layer=li \
 //thickness=0.1 //x=60.43 //y=3.51 //x2=60.43 //y2=4.25
r1469 (  56 57 ) resistor r=50.6524 //w=0.187 //l=0.74 //layer=li \
 //thickness=0.1 //x=60.43 //y=2.77 //x2=60.43 //y2=3.51
r1470 (  55 56 ) resistor r=25.3262 //w=0.187 //l=0.37 //layer=li \
 //thickness=0.1 //x=60.43 //y=2.4 //x2=60.43 //y2=2.77
r1471 (  55 127 ) resistor r=9.58289 //w=0.187 //l=0.14 //layer=li \
 //thickness=0.1 //x=60.43 //y=2.4 //x2=60.43 //y2=2.26
r1472 (  54 124 ) resistor r=93.7754 //w=0.187 //l=1.37 //layer=li \
 //thickness=0.1 //x=50.81 //y=3.51 //x2=50.81 //y2=4.88
r1473 (  53 54 ) resistor r=50.6524 //w=0.187 //l=0.74 //layer=li \
 //thickness=0.1 //x=50.81 //y=2.77 //x2=50.81 //y2=3.51
r1474 (  52 53 ) resistor r=25.3262 //w=0.187 //l=0.37 //layer=li \
 //thickness=0.1 //x=50.81 //y=2.4 //x2=50.81 //y2=2.77
r1475 (  52 117 ) resistor r=9.58289 //w=0.187 //l=0.14 //layer=li \
 //thickness=0.1 //x=50.81 //y=2.4 //x2=50.81 //y2=2.26
r1476 (  51 114 ) resistor r=144.428 //w=0.187 //l=2.11 //layer=li \
 //thickness=0.1 //x=47.11 //y=2.77 //x2=47.11 //y2=4.88
r1477 (  50 51 ) resistor r=25.3262 //w=0.187 //l=0.37 //layer=li \
 //thickness=0.1 //x=47.11 //y=2.4 //x2=47.11 //y2=2.77
r1478 (  50 108 ) resistor r=9.58289 //w=0.187 //l=0.14 //layer=li \
 //thickness=0.1 //x=47.11 //y=2.4 //x2=47.11 //y2=2.26
r1479 (  49 105 ) resistor r=68.4492 //w=0.187 //l=1 //layer=li \
 //thickness=0.1 //x=31.57 //y=3.88 //x2=31.57 //y2=4.88
r1480 (  48 49 ) resistor r=25.3262 //w=0.187 //l=0.37 //layer=li \
 //thickness=0.1 //x=31.57 //y=3.51 //x2=31.57 //y2=3.88
r1481 (  47 48 ) resistor r=50.6524 //w=0.187 //l=0.74 //layer=li \
 //thickness=0.1 //x=31.57 //y=2.77 //x2=31.57 //y2=3.51
r1482 (  46 47 ) resistor r=25.3262 //w=0.187 //l=0.37 //layer=li \
 //thickness=0.1 //x=31.57 //y=2.4 //x2=31.57 //y2=2.77
r1483 (  46 97 ) resistor r=9.58289 //w=0.187 //l=0.14 //layer=li \
 //thickness=0.1 //x=31.57 //y=2.4 //x2=31.57 //y2=2.26
r1484 (  45 94 ) resistor r=93.7754 //w=0.187 //l=1.37 //layer=li \
 //thickness=0.1 //x=21.95 //y=3.51 //x2=21.95 //y2=4.88
r1485 (  44 45 ) resistor r=50.6524 //w=0.187 //l=0.74 //layer=li \
 //thickness=0.1 //x=21.95 //y=2.77 //x2=21.95 //y2=3.51
r1486 (  43 44 ) resistor r=25.3262 //w=0.187 //l=0.37 //layer=li \
 //thickness=0.1 //x=21.95 //y=2.4 //x2=21.95 //y2=2.77
r1487 (  43 87 ) resistor r=9.58289 //w=0.187 //l=0.14 //layer=li \
 //thickness=0.1 //x=21.95 //y=2.4 //x2=21.95 //y2=2.26
r1488 (  42 84 ) resistor r=144.428 //w=0.187 //l=2.11 //layer=li \
 //thickness=0.1 //x=18.25 //y=2.77 //x2=18.25 //y2=4.88
r1489 (  41 42 ) resistor r=25.3262 //w=0.187 //l=0.37 //layer=li \
 //thickness=0.1 //x=18.25 //y=2.4 //x2=18.25 //y2=2.77
r1490 (  41 78 ) resistor r=9.58289 //w=0.187 //l=0.14 //layer=li \
 //thickness=0.1 //x=18.25 //y=2.4 //x2=18.25 //y2=2.26
r1491 (  40 75 ) resistor r=17.7968 //w=0.187 //l=0.26 //layer=li \
 //thickness=0.1 //x=2.71 //y=4.62 //x2=2.71 //y2=4.88
r1492 (  39 40 ) resistor r=50.6524 //w=0.187 //l=0.74 //layer=li \
 //thickness=0.1 //x=2.71 //y=3.88 //x2=2.71 //y2=4.62
r1493 (  38 39 ) resistor r=25.3262 //w=0.187 //l=0.37 //layer=li \
 //thickness=0.1 //x=2.71 //y=3.51 //x2=2.71 //y2=3.88
r1494 (  37 38 ) resistor r=25.3262 //w=0.187 //l=0.37 //layer=li \
 //thickness=0.1 //x=2.71 //y=3.14 //x2=2.71 //y2=3.51
r1495 (  36 37 ) resistor r=25.3262 //w=0.187 //l=0.37 //layer=li \
 //thickness=0.1 //x=2.71 //y=2.77 //x2=2.71 //y2=3.14
r1496 (  35 36 ) resistor r=25.3262 //w=0.187 //l=0.37 //layer=li \
 //thickness=0.1 //x=2.71 //y=2.4 //x2=2.71 //y2=2.77
r1497 (  35 65 ) resistor r=9.58289 //w=0.187 //l=0.14 //layer=li \
 //thickness=0.1 //x=2.71 //y=2.4 //x2=2.71 //y2=2.26
r1498 (  34 61 ) resistor r=9.3 //w=0.17 //l=0.17 //layer=mcon //count=1 \
 //x=79.67 //y=2.4 //x2=79.67 //y2=2.4
r1499 (  32 59 ) resistor r=9.3 //w=0.17 //l=0.17 //layer=mcon //count=1 \
 //x=75.97 //y=2.4 //x2=75.97 //y2=2.4
r1500 (  30 55 ) resistor r=9.3 //w=0.17 //l=0.17 //layer=mcon //count=1 \
 //x=60.43 //y=2.4 //x2=60.43 //y2=2.4
r1501 (  28 52 ) resistor r=9.3 //w=0.17 //l=0.17 //layer=mcon //count=1 \
 //x=50.81 //y=2.4 //x2=50.81 //y2=2.4
r1502 (  26 50 ) resistor r=9.3 //w=0.17 //l=0.17 //layer=mcon //count=1 \
 //x=47.11 //y=2.4 //x2=47.11 //y2=2.4
r1503 (  24 46 ) resistor r=9.3 //w=0.17 //l=0.17 //layer=mcon //count=1 \
 //x=31.57 //y=2.4 //x2=31.57 //y2=2.4
r1504 (  22 43 ) resistor r=9.3 //w=0.17 //l=0.17 //layer=mcon //count=1 \
 //x=21.95 //y=2.4 //x2=21.95 //y2=2.4
r1505 (  20 41 ) resistor r=9.3 //w=0.17 //l=0.17 //layer=mcon //count=1 \
 //x=18.25 //y=2.4 //x2=18.25 //y2=2.4
r1506 (  18 35 ) resistor r=9.3 //w=0.17 //l=0.17 //layer=mcon //count=1 \
 //x=2.71 //y=2.4 //x2=2.71 //y2=2.4
r1507 (  16 32 ) resistor r=0.0880901 //w=0.191 //l=0.115 //layer=m1 \
 //thickness=0.36 //x=76.085 //y=2.4 //x2=75.97 //y2=2.4
r1508 (  15 34 ) resistor r=0.0717383 //w=0.224 //l=0.115 //layer=m1 \
 //thickness=0.36 //x=79.555 //y=2.4 //x2=79.67 //y2=2.4
r1509 (  15 16 ) resistor r=3.31107 //w=0.131 //l=3.47 //layer=m1 \
 //thickness=0.36 //x=79.555 //y=2.4 //x2=76.085 //y2=2.4
r1510 (  14 30 ) resistor r=0.0880901 //w=0.191 //l=0.115 //layer=m1 \
 //thickness=0.36 //x=60.545 //y=2.4 //x2=60.43 //y2=2.4
r1511 (  13 32 ) resistor r=0.0880901 //w=0.191 //l=0.115 //layer=m1 \
 //thickness=0.36 //x=75.855 //y=2.4 //x2=75.97 //y2=2.4
r1512 (  13 14 ) resistor r=14.6088 //w=0.131 //l=15.31 //layer=m1 \
 //thickness=0.36 //x=75.855 //y=2.4 //x2=60.545 //y2=2.4
r1513 (  12 28 ) resistor r=0.0880901 //w=0.191 //l=0.115 //layer=m1 \
 //thickness=0.36 //x=50.925 //y=2.4 //x2=50.81 //y2=2.4
r1514 (  11 30 ) resistor r=0.0880901 //w=0.191 //l=0.115 //layer=m1 \
 //thickness=0.36 //x=60.315 //y=2.4 //x2=60.43 //y2=2.4
r1515 (  11 12 ) resistor r=8.95992 //w=0.131 //l=9.39 //layer=m1 \
 //thickness=0.36 //x=60.315 //y=2.4 //x2=50.925 //y2=2.4
r1516 (  10 26 ) resistor r=0.0880901 //w=0.191 //l=0.115 //layer=m1 \
 //thickness=0.36 //x=47.225 //y=2.4 //x2=47.11 //y2=2.4
r1517 (  9 28 ) resistor r=0.0880901 //w=0.191 //l=0.115 //layer=m1 \
 //thickness=0.36 //x=50.695 //y=2.4 //x2=50.81 //y2=2.4
r1518 (  9 10 ) resistor r=3.31107 //w=0.131 //l=3.47 //layer=m1 \
 //thickness=0.36 //x=50.695 //y=2.4 //x2=47.225 //y2=2.4
r1519 (  8 24 ) resistor r=0.0880901 //w=0.191 //l=0.115 //layer=m1 \
 //thickness=0.36 //x=31.685 //y=2.4 //x2=31.57 //y2=2.4
r1520 (  7 26 ) resistor r=0.0880901 //w=0.191 //l=0.115 //layer=m1 \
 //thickness=0.36 //x=46.995 //y=2.4 //x2=47.11 //y2=2.4
r1521 (  7 8 ) resistor r=14.6088 //w=0.131 //l=15.31 //layer=m1 \
 //thickness=0.36 //x=46.995 //y=2.4 //x2=31.685 //y2=2.4
r1522 (  6 22 ) resistor r=0.0880901 //w=0.191 //l=0.115 //layer=m1 \
 //thickness=0.36 //x=22.065 //y=2.4 //x2=21.95 //y2=2.4
r1523 (  5 24 ) resistor r=0.0880901 //w=0.191 //l=0.115 //layer=m1 \
 //thickness=0.36 //x=31.455 //y=2.4 //x2=31.57 //y2=2.4
r1524 (  5 6 ) resistor r=8.95992 //w=0.131 //l=9.39 //layer=m1 \
 //thickness=0.36 //x=31.455 //y=2.4 //x2=22.065 //y2=2.4
r1525 (  4 20 ) resistor r=0.0880901 //w=0.191 //l=0.115 //layer=m1 \
 //thickness=0.36 //x=18.365 //y=2.4 //x2=18.25 //y2=2.4
r1526 (  3 22 ) resistor r=0.0880901 //w=0.191 //l=0.115 //layer=m1 \
 //thickness=0.36 //x=21.835 //y=2.4 //x2=21.95 //y2=2.4
r1527 (  3 4 ) resistor r=3.31107 //w=0.131 //l=3.47 //layer=m1 \
 //thickness=0.36 //x=21.835 //y=2.4 //x2=18.365 //y2=2.4
r1528 (  2 18 ) resistor r=0.0717383 //w=0.224 //l=0.115 //layer=m1 \
 //thickness=0.36 //x=2.825 //y=2.4 //x2=2.71 //y2=2.4
r1529 (  1 20 ) resistor r=0.0880901 //w=0.191 //l=0.115 //layer=m1 \
 //thickness=0.36 //x=18.135 //y=2.4 //x2=18.25 //y2=2.4
r1530 (  1 2 ) resistor r=14.6088 //w=0.131 //l=15.31 //layer=m1 \
 //thickness=0.36 //x=18.135 //y=2.4 //x2=2.825 //y2=2.4
ends PM_TMRDFFSNRNQX1\%RN

subckt PM_TMRDFFSNRNQX1\%noxref_21 ( 1 2 13 14 21 29 35 36 40 42 49 50 51 52 \
 53 54 55 56 57 58 60 66 67 68 69 81 83 84 85 )
c161 ( 85 0 ) capacitor c=0.023087f //x=80.595 //y=5.2
c162 ( 84 0 ) capacitor c=0.023519f //x=79.715 //y=5.2
c163 ( 83 0 ) capacitor c=0.0224735f //x=78.835 //y=5.2
c164 ( 81 0 ) capacitor c=0.00853354f //x=80.845 //y=1.095
c165 ( 69 0 ) capacitor c=0.0556143f //x=83.645 //y=4.97
c166 ( 68 0 ) capacitor c=0.0293157f //x=83.935 //y=4.97
c167 ( 67 0 ) capacitor c=0.0347816f //x=83.6 //y=1.4
c168 ( 66 0 ) capacitor c=0.0187487f //x=83.6 //y=1.055
c169 ( 60 0 ) capacitor c=0.0137055f //x=83.445 //y=1.555
c170 ( 58 0 ) capacitor c=0.0149861f //x=83.445 //y=0.9
c171 ( 57 0 ) capacitor c=0.096037f //x=83.07 //y=2.095
c172 ( 56 0 ) capacitor c=0.0228993f //x=83.07 //y=1.71
c173 ( 55 0 ) capacitor c=0.0234352f //x=83.07 //y=1.4
c174 ( 54 0 ) capacitor c=0.0198724f //x=83.07 //y=1.055
c175 ( 53 0 ) capacitor c=0.110114f //x=84.01 //y=6.2
c176 ( 52 0 ) capacitor c=0.158956f //x=83.57 //y=6.2
c177 ( 50 0 ) capacitor c=0.00106608f //x=80.74 //y=5.335
c178 ( 49 0 ) capacitor c=0.00207319f //x=79.86 //y=5.335
c179 ( 42 0 ) capacitor c=0.0971623f //x=83.37 //y=2.26
c180 ( 40 0 ) capacitor c=0.106761f //x=81.52 //y=2.77
c181 ( 36 0 ) capacitor c=0.00398962f //x=81.12 //y=1.845
c182 ( 35 0 ) capacitor c=0.0137288f //x=81.435 //y=1.845
c183 ( 29 0 ) capacitor c=0.0283082f //x=81.435 //y=5.335
c184 ( 21 0 ) capacitor c=0.0176454f //x=80.655 //y=5.335
c185 ( 14 0 ) capacitor c=0.00332903f //x=79.065 //y=5.335
c186 ( 13 0 ) capacitor c=0.0148427f //x=79.775 //y=5.335
c187 ( 2 0 ) capacitor c=0.0116088f //x=81.635 //y=2.77
c188 ( 1 0 ) capacitor c=0.0352679f //x=83.255 //y=2.77
r189 (  68 70 ) resistor r=26.9307 //w=0.15 //l=0.106066 //layer=ply \
 //thickness=0.18 //x=83.935 //y=4.97 //x2=84.01 //y2=5.045
r190 (  68 69 ) resistor r=148.702 //w=0.094 //l=0.29 //layer=ply \
 //thickness=0.18 //x=83.935 //y=4.97 //x2=83.645 //y2=4.97
r191 (  67 80 ) resistor r=45.1352 //w=0.168 //l=0.173853 //layer=ply \
 //thickness=0.18 //x=83.6 //y=1.4 //x2=83.56 //y2=1.555
r192 (  66 79 ) resistor r=45.1352 //w=0.168 //l=0.173853 //layer=ply \
 //thickness=0.18 //x=83.6 //y=1.055 //x2=83.56 //y2=0.9
r193 (  66 67 ) resistor r=176.904 //w=0.094 //l=0.345 //layer=ply \
 //thickness=0.18 //x=83.6 //y=1.055 //x2=83.6 //y2=1.4
r194 (  63 69 ) resistor r=22.7971 //w=0.269 //l=0.106066 //layer=ply \
 //thickness=0.18 //x=83.57 //y=5.045 //x2=83.645 //y2=4.97
r195 (  63 78 ) resistor r=35.8364 //w=0.269 //l=0.270185 //layer=ply \
 //thickness=0.18 //x=83.57 //y=5.045 //x2=83.37 //y2=4.88
r196 (  61 74 ) resistor r=10.701 //w=0.21 //l=0.115 //layer=ply \
 //thickness=0.18 //x=83.225 //y=1.555 //x2=83.11 //y2=1.555
r197 (  60 80 ) resistor r=5.52526 //w=0.168 //l=0.115 //layer=ply \
 //thickness=0.18 //x=83.445 //y=1.555 //x2=83.56 //y2=1.555
r198 (  59 73 ) resistor r=5.52526 //w=0.168 //l=0.115 //layer=ply \
 //thickness=0.18 //x=83.225 //y=0.9 //x2=83.11 //y2=0.9
r199 (  58 79 ) resistor r=5.52526 //w=0.168 //l=0.115 //layer=ply \
 //thickness=0.18 //x=83.445 //y=0.9 //x2=83.56 //y2=0.9
r200 (  58 59 ) resistor r=112.809 //w=0.094 //l=0.22 //layer=ply \
 //thickness=0.18 //x=83.445 //y=0.9 //x2=83.225 //y2=0.9
r201 (  57 76 ) resistor r=58.7805 //w=0.246 //l=0.373497 //layer=ply \
 //thickness=0.18 //x=83.07 //y=2.095 //x2=83.37 //y2=2.26
r202 (  56 74 ) resistor r=39.5823 //w=0.21 //l=0.173853 //layer=ply \
 //thickness=0.18 //x=83.07 //y=1.71 //x2=83.11 //y2=1.555
r203 (  56 57 ) resistor r=197.415 //w=0.094 //l=0.385 //layer=ply \
 //thickness=0.18 //x=83.07 //y=1.71 //x2=83.07 //y2=2.095
r204 (  55 74 ) resistor r=39.5823 //w=0.21 //l=0.173853 //layer=ply \
 //thickness=0.18 //x=83.07 //y=1.4 //x2=83.11 //y2=1.555
r205 (  54 73 ) resistor r=45.1352 //w=0.168 //l=0.173853 //layer=ply \
 //thickness=0.18 //x=83.07 //y=1.055 //x2=83.11 //y2=0.9
r206 (  54 55 ) resistor r=176.904 //w=0.094 //l=0.345 //layer=ply \
 //thickness=0.18 //x=83.07 //y=1.055 //x2=83.07 //y2=1.4
r207 (  53 70 ) resistor r=592.245 //w=0.094 //l=1.155 //layer=ply \
 //thickness=0.18 //x=84.01 //y=6.2 //x2=84.01 //y2=5.045
r208 (  52 63 ) resistor r=592.245 //w=0.094 //l=1.155 //layer=ply \
 //thickness=0.18 //x=83.57 //y=6.2 //x2=83.57 //y2=5.045
r209 (  51 60 ) resistor r=56.4043 //w=0.094 //l=0.11 //layer=ply \
 //thickness=0.18 //x=83.335 //y=1.555 //x2=83.445 //y2=1.555
r210 (  51 61 ) resistor r=56.4043 //w=0.094 //l=0.11 //layer=ply \
 //thickness=0.18 //x=83.335 //y=1.555 //x2=83.225 //y2=1.555
r211 (  47 78 ) resistor r=152 //w=0.17 //l=0.17 //layer=licon //count=1 \
 //x=83.37 //y=4.88 //x2=83.37 //y2=4.88
r212 (  45 47 ) resistor r=144.428 //w=0.187 //l=2.11 //layer=li \
 //thickness=0.1 //x=83.37 //y=2.77 //x2=83.37 //y2=4.88
r213 (  42 76 ) resistor r=152 //w=0.17 //l=0.17 //layer=licon //count=1 \
 //x=83.37 //y=2.26 //x2=83.37 //y2=2.26
r214 (  42 45 ) resistor r=34.9091 //w=0.187 //l=0.51 //layer=li \
 //thickness=0.1 //x=83.37 //y=2.26 //x2=83.37 //y2=2.77
r215 (  38 40 ) resistor r=169.754 //w=0.187 //l=2.48 //layer=li \
 //thickness=0.1 //x=81.52 //y=5.25 //x2=81.52 //y2=2.77
r216 (  37 40 ) resistor r=57.4973 //w=0.187 //l=0.84 //layer=li \
 //thickness=0.1 //x=81.52 //y=1.93 //x2=81.52 //y2=2.77
r217 (  35 37 ) resistor r=7.15173 //w=0.17 //l=0.120208 //layer=li \
 //thickness=0.1 //x=81.435 //y=1.845 //x2=81.52 //y2=1.93
r218 (  35 36 ) resistor r=21.5615 //w=0.187 //l=0.315 //layer=li \
 //thickness=0.1 //x=81.435 //y=1.845 //x2=81.12 //y2=1.845
r219 (  31 36 ) resistor r=7.15173 //w=0.17 //l=0.120208 //layer=li \
 //thickness=0.1 //x=81.035 //y=1.76 //x2=81.12 //y2=1.845
r220 (  31 81 ) resistor r=39.016 //w=0.187 //l=0.57 //layer=li \
 //thickness=0.1 //x=81.035 //y=1.76 //x2=81.035 //y2=1.19
r221 (  30 50 ) resistor r=5.4201 //w=0.17 //l=0.085 //layer=li \
 //thickness=0.1 //x=80.825 //y=5.335 //x2=80.74 //y2=5.335
r222 (  29 38 ) resistor r=7.15173 //w=0.17 //l=0.120208 //layer=li \
 //thickness=0.1 //x=81.435 //y=5.335 //x2=81.52 //y2=5.25
r223 (  29 30 ) resistor r=41.754 //w=0.187 //l=0.61 //layer=li \
 //thickness=0.1 //x=81.435 //y=5.335 //x2=80.825 //y2=5.335
r224 (  23 50 ) resistor r=1.40859 //w=0.34 //l=0.085 //layer=li \
 //thickness=0.1 //x=80.74 //y=5.42 //x2=80.74 //y2=5.335
r225 (  23 85 ) resistor r=33.1979 //w=0.187 //l=0.485 //layer=li \
 //thickness=0.1 //x=80.74 //y=5.42 //x2=80.74 //y2=5.905
r226 (  22 49 ) resistor r=5.4201 //w=0.17 //l=0.085 //layer=li \
 //thickness=0.1 //x=79.945 //y=5.335 //x2=79.86 //y2=5.335
r227 (  21 50 ) resistor r=5.4201 //w=0.17 //l=0.085 //layer=li \
 //thickness=0.1 //x=80.655 //y=5.335 //x2=80.74 //y2=5.335
r228 (  21 22 ) resistor r=48.5989 //w=0.187 //l=0.71 //layer=li \
 //thickness=0.1 //x=80.655 //y=5.335 //x2=79.945 //y2=5.335
r229 (  15 49 ) resistor r=1.40859 //w=0.34 //l=0.085 //layer=li \
 //thickness=0.1 //x=79.86 //y=5.42 //x2=79.86 //y2=5.335
r230 (  15 84 ) resistor r=33.1979 //w=0.187 //l=0.485 //layer=li \
 //thickness=0.1 //x=79.86 //y=5.42 //x2=79.86 //y2=5.905
r231 (  13 49 ) resistor r=5.4201 //w=0.17 //l=0.085 //layer=li \
 //thickness=0.1 //x=79.775 //y=5.335 //x2=79.86 //y2=5.335
r232 (  13 14 ) resistor r=48.5989 //w=0.187 //l=0.71 //layer=li \
 //thickness=0.1 //x=79.775 //y=5.335 //x2=79.065 //y2=5.335
r233 (  7 14 ) resistor r=7.15173 //w=0.17 //l=0.120208 //layer=li \
 //thickness=0.1 //x=78.98 //y=5.42 //x2=79.065 //y2=5.335
r234 (  7 83 ) resistor r=33.1979 //w=0.187 //l=0.485 //layer=li \
 //thickness=0.1 //x=78.98 //y=5.42 //x2=78.98 //y2=5.905
r235 (  6 45 ) resistor r=9.3 //w=0.17 //l=0.17 //layer=mcon //count=1 \
 //x=83.37 //y=2.77 //x2=83.37 //y2=2.77
r236 (  4 40 ) resistor r=9.3 //w=0.17 //l=0.17 //layer=mcon //count=1 \
 //x=81.52 //y=2.77 //x2=81.52 //y2=2.77
r237 (  2 4 ) resistor r=0.0717383 //w=0.224 //l=0.115 //layer=m1 \
 //thickness=0.36 //x=81.635 //y=2.77 //x2=81.52 //y2=2.77
r238 (  1 6 ) resistor r=0.0717383 //w=0.224 //l=0.115 //layer=m1 \
 //thickness=0.36 //x=83.255 //y=2.77 //x2=83.37 //y2=2.77
r239 (  1 2 ) resistor r=1.5458 //w=0.131 //l=1.62 //layer=m1 //thickness=0.36 \
 //x=83.255 //y=2.77 //x2=81.635 //y2=2.77
ends PM_TMRDFFSNRNQX1\%noxref_21

subckt PM_TMRDFFSNRNQX1\%SN ( 1 2 3 4 5 6 7 8 9 10 23 24 25 26 27 28 29 30 31 \
 32 34 43 52 61 70 79 86 87 88 89 90 91 92 93 94 95 96 97 98 99 100 101 102 \
 103 104 105 106 108 114 115 116 117 118 123 124 125 127 133 134 135 136 137 \
 142 143 144 146 152 153 154 155 156 161 162 163 165 171 172 173 174 175 180 \
 181 182 184 190 191 192 193 194 199 200 201 203 209 210 211 212 213 221 232 \
 243 254 265 276 )
c687 ( 276 0 ) capacitor c=0.0335551f //x=84.48 //y=4.88
c688 ( 265 0 ) capacitor c=0.0333886f //x=70.05 //y=4.88
c689 ( 254 0 ) capacitor c=0.0333886f //x=55.62 //y=4.88
c690 ( 243 0 ) capacitor c=0.0333886f //x=41.19 //y=4.88
c691 ( 232 0 ) capacitor c=0.0335551f //x=26.76 //y=4.88
c692 ( 221 0 ) capacitor c=0.0335551f //x=12.33 //y=4.88
c693 ( 213 0 ) capacitor c=0.0245352f //x=84.815 //y=4.97
c694 ( 212 0 ) capacitor c=0.0825763f //x=84.57 //y=2.095
c695 ( 211 0 ) capacitor c=0.0170266f //x=84.57 //y=1.63
c696 ( 210 0 ) capacitor c=0.018609f //x=84.57 //y=1.4
c697 ( 209 0 ) capacitor c=0.0187309f //x=84.57 //y=1.09
c698 ( 203 0 ) capacitor c=0.014725f //x=84.415 //y=1.555
c699 ( 201 0 ) capacitor c=0.0146567f //x=84.415 //y=0.935
c700 ( 200 0 ) capacitor c=0.0335408f //x=84.045 //y=1.4
c701 ( 199 0 ) capacitor c=0.0173761f //x=84.045 //y=1.09
c702 ( 194 0 ) capacitor c=0.0246783f //x=70.385 //y=4.97
c703 ( 193 0 ) capacitor c=0.0825763f //x=70.14 //y=2.095
c704 ( 192 0 ) capacitor c=0.0170266f //x=70.14 //y=1.63
c705 ( 191 0 ) capacitor c=0.018609f //x=70.14 //y=1.4
c706 ( 190 0 ) capacitor c=0.0187309f //x=70.14 //y=1.09
c707 ( 184 0 ) capacitor c=0.014725f //x=69.985 //y=1.555
c708 ( 182 0 ) capacitor c=0.0146567f //x=69.985 //y=0.935
c709 ( 181 0 ) capacitor c=0.0335408f //x=69.615 //y=1.4
c710 ( 180 0 ) capacitor c=0.0173761f //x=69.615 //y=1.09
c711 ( 175 0 ) capacitor c=0.0246783f //x=55.955 //y=4.97
c712 ( 174 0 ) capacitor c=0.0825763f //x=55.71 //y=2.095
c713 ( 173 0 ) capacitor c=0.0170266f //x=55.71 //y=1.63
c714 ( 172 0 ) capacitor c=0.018609f //x=55.71 //y=1.4
c715 ( 171 0 ) capacitor c=0.0187309f //x=55.71 //y=1.09
c716 ( 165 0 ) capacitor c=0.014725f //x=55.555 //y=1.555
c717 ( 163 0 ) capacitor c=0.0146567f //x=55.555 //y=0.935
c718 ( 162 0 ) capacitor c=0.0335408f //x=55.185 //y=1.4
c719 ( 161 0 ) capacitor c=0.0173761f //x=55.185 //y=1.09
c720 ( 156 0 ) capacitor c=0.0246783f //x=41.525 //y=4.97
c721 ( 155 0 ) capacitor c=0.0825763f //x=41.28 //y=2.095
c722 ( 154 0 ) capacitor c=0.0170266f //x=41.28 //y=1.63
c723 ( 153 0 ) capacitor c=0.018609f //x=41.28 //y=1.4
c724 ( 152 0 ) capacitor c=0.0187309f //x=41.28 //y=1.09
c725 ( 146 0 ) capacitor c=0.014725f //x=41.125 //y=1.555
c726 ( 144 0 ) capacitor c=0.0146567f //x=41.125 //y=0.935
c727 ( 143 0 ) capacitor c=0.0335408f //x=40.755 //y=1.4
c728 ( 142 0 ) capacitor c=0.0173761f //x=40.755 //y=1.09
c729 ( 137 0 ) capacitor c=0.0245352f //x=27.095 //y=4.97
c730 ( 136 0 ) capacitor c=0.0825763f //x=26.85 //y=2.095
c731 ( 135 0 ) capacitor c=0.0170266f //x=26.85 //y=1.63
c732 ( 134 0 ) capacitor c=0.018609f //x=26.85 //y=1.4
c733 ( 133 0 ) capacitor c=0.0187309f //x=26.85 //y=1.09
c734 ( 127 0 ) capacitor c=0.014725f //x=26.695 //y=1.555
c735 ( 125 0 ) capacitor c=0.0146567f //x=26.695 //y=0.935
c736 ( 124 0 ) capacitor c=0.0335408f //x=26.325 //y=1.4
c737 ( 123 0 ) capacitor c=0.0173761f //x=26.325 //y=1.09
c738 ( 118 0 ) capacitor c=0.0245352f //x=12.665 //y=4.97
c739 ( 117 0 ) capacitor c=0.0825763f //x=12.42 //y=2.095
c740 ( 116 0 ) capacitor c=0.0170266f //x=12.42 //y=1.63
c741 ( 115 0 ) capacitor c=0.018609f //x=12.42 //y=1.4
c742 ( 114 0 ) capacitor c=0.0187309f //x=12.42 //y=1.09
c743 ( 108 0 ) capacitor c=0.014725f //x=12.265 //y=1.555
c744 ( 106 0 ) capacitor c=0.0146567f //x=12.265 //y=0.935
c745 ( 105 0 ) capacitor c=0.0335408f //x=11.895 //y=1.4
c746 ( 104 0 ) capacitor c=0.0173761f //x=11.895 //y=1.09
c747 ( 103 0 ) capacitor c=0.110114f //x=84.89 //y=6.2
c748 ( 102 0 ) capacitor c=0.11012f //x=84.45 //y=6.2
c749 ( 101 0 ) capacitor c=0.109949f //x=70.46 //y=6.2
c750 ( 100 0 ) capacitor c=0.109956f //x=70.02 //y=6.2
c751 ( 99 0 ) capacitor c=0.109949f //x=56.03 //y=6.2
c752 ( 98 0 ) capacitor c=0.109956f //x=55.59 //y=6.2
c753 ( 97 0 ) capacitor c=0.109949f //x=41.6 //y=6.2
c754 ( 96 0 ) capacitor c=0.109956f //x=41.16 //y=6.2
c755 ( 95 0 ) capacitor c=0.110114f //x=27.17 //y=6.2
c756 ( 94 0 ) capacitor c=0.11012f //x=26.73 //y=6.2
c757 ( 93 0 ) capacitor c=0.110114f //x=12.74 //y=6.2
c758 ( 92 0 ) capacitor c=0.11012f //x=12.3 //y=6.2
c759 ( 79 0 ) capacitor c=0.0925663f //x=84.48 //y=2.26
c760 ( 70 0 ) capacitor c=0.0877967f //x=70.05 //y=2.26
c761 ( 61 0 ) capacitor c=0.0881699f //x=55.62 //y=2.26
c762 ( 52 0 ) capacitor c=0.0877967f //x=41.19 //y=2.26
c763 ( 43 0 ) capacitor c=0.089887f //x=26.76 //y=2.26
c764 ( 34 0 ) capacitor c=0.0895139f //x=12.33 //y=2.26
c765 ( 10 0 ) capacitor c=0.00568147f //x=70.165 //y=3.14
c766 ( 9 0 ) capacitor c=0.267214f //x=84.365 //y=3.14
c767 ( 8 0 ) capacitor c=0.00568147f //x=55.735 //y=3.14
c768 ( 7 0 ) capacitor c=0.231482f //x=69.935 //y=3.14
c769 ( 6 0 ) capacitor c=0.00568147f //x=41.305 //y=3.14
c770 ( 5 0 ) capacitor c=0.230801f //x=55.505 //y=3.14
c771 ( 4 0 ) capacitor c=0.00579855f //x=26.875 //y=3.14
c772 ( 3 0 ) capacitor c=0.242173f //x=41.075 //y=3.14
c773 ( 2 0 ) capacitor c=0.0141295f //x=12.445 //y=3.14
c774 ( 1 0 ) capacitor c=0.231794f //x=26.645 //y=3.14
r775 (  278 279 ) resistor r=32.4568 //w=0.214 //l=0.075 //layer=ply \
 //thickness=0.18 //x=84.48 //y=4.97 //x2=84.48 //y2=5.045
r776 (  276 278 ) resistor r=20.271 //w=0.214 //l=0.09 //layer=ply \
 //thickness=0.18 //x=84.48 //y=4.88 //x2=84.48 //y2=4.97
r777 (  267 268 ) resistor r=32.4568 //w=0.214 //l=0.075 //layer=ply \
 //thickness=0.18 //x=70.05 //y=4.97 //x2=70.05 //y2=5.045
r778 (  265 267 ) resistor r=20.271 //w=0.214 //l=0.09 //layer=ply \
 //thickness=0.18 //x=70.05 //y=4.88 //x2=70.05 //y2=4.97
r779 (  256 257 ) resistor r=32.4568 //w=0.214 //l=0.075 //layer=ply \
 //thickness=0.18 //x=55.62 //y=4.97 //x2=55.62 //y2=5.045
r780 (  254 256 ) resistor r=20.271 //w=0.214 //l=0.09 //layer=ply \
 //thickness=0.18 //x=55.62 //y=4.88 //x2=55.62 //y2=4.97
r781 (  245 246 ) resistor r=32.4568 //w=0.214 //l=0.075 //layer=ply \
 //thickness=0.18 //x=41.19 //y=4.97 //x2=41.19 //y2=5.045
r782 (  243 245 ) resistor r=20.271 //w=0.214 //l=0.09 //layer=ply \
 //thickness=0.18 //x=41.19 //y=4.88 //x2=41.19 //y2=4.97
r783 (  234 235 ) resistor r=32.4568 //w=0.214 //l=0.075 //layer=ply \
 //thickness=0.18 //x=26.76 //y=4.97 //x2=26.76 //y2=5.045
r784 (  232 234 ) resistor r=20.271 //w=0.214 //l=0.09 //layer=ply \
 //thickness=0.18 //x=26.76 //y=4.88 //x2=26.76 //y2=4.97
r785 (  223 224 ) resistor r=32.4568 //w=0.214 //l=0.075 //layer=ply \
 //thickness=0.18 //x=12.33 //y=4.97 //x2=12.33 //y2=5.045
r786 (  221 223 ) resistor r=20.271 //w=0.214 //l=0.09 //layer=ply \
 //thickness=0.18 //x=12.33 //y=4.88 //x2=12.33 //y2=4.97
r787 (  214 278 ) resistor r=16.5046 //w=0.27 //l=0.135 //layer=ply \
 //thickness=0.18 //x=84.615 //y=4.97 //x2=84.48 //y2=4.97
r788 (  213 215 ) resistor r=26.9307 //w=0.15 //l=0.106066 //layer=ply \
 //thickness=0.18 //x=84.815 //y=4.97 //x2=84.89 //y2=5.045
r789 (  213 214 ) resistor r=102.553 //w=0.094 //l=0.2 //layer=ply \
 //thickness=0.18 //x=84.815 //y=4.97 //x2=84.615 //y2=4.97
r790 (  212 283 ) resistor r=38.6777 //w=0.284 //l=0.198997 //layer=ply \
 //thickness=0.18 //x=84.57 //y=2.095 //x2=84.495 //y2=2.26
r791 (  211 281 ) resistor r=21.2976 //w=0.217 //l=0.0928709 //layer=ply \
 //thickness=0.18 //x=84.57 //y=1.63 //x2=84.53 //y2=1.555
r792 (  211 212 ) resistor r=238.436 //w=0.094 //l=0.465 //layer=ply \
 //thickness=0.18 //x=84.57 //y=1.63 //x2=84.57 //y2=2.095
r793 (  210 281 ) resistor r=39.0671 //w=0.217 //l=0.173853 //layer=ply \
 //thickness=0.18 //x=84.57 //y=1.4 //x2=84.53 //y2=1.555
r794 (  209 280 ) resistor r=45.1352 //w=0.168 //l=0.173853 //layer=ply \
 //thickness=0.18 //x=84.57 //y=1.09 //x2=84.53 //y2=0.935
r795 (  209 210 ) resistor r=158.957 //w=0.094 //l=0.31 //layer=ply \
 //thickness=0.18 //x=84.57 //y=1.09 //x2=84.57 //y2=1.4
r796 (  204 274 ) resistor r=5.52526 //w=0.168 //l=0.115 //layer=ply \
 //thickness=0.18 //x=84.2 //y=1.555 //x2=84.085 //y2=1.555
r797 (  203 281 ) resistor r=11.4558 //w=0.217 //l=0.115 //layer=ply \
 //thickness=0.18 //x=84.415 //y=1.555 //x2=84.53 //y2=1.555
r798 (  202 273 ) resistor r=5.52526 //w=0.168 //l=0.115 //layer=ply \
 //thickness=0.18 //x=84.2 //y=0.935 //x2=84.085 //y2=0.935
r799 (  201 280 ) resistor r=5.52526 //w=0.168 //l=0.115 //layer=ply \
 //thickness=0.18 //x=84.415 //y=0.935 //x2=84.53 //y2=0.935
r800 (  201 202 ) resistor r=110.245 //w=0.094 //l=0.215 //layer=ply \
 //thickness=0.18 //x=84.415 //y=0.935 //x2=84.2 //y2=0.935
r801 (  200 274 ) resistor r=45.1352 //w=0.168 //l=0.173853 //layer=ply \
 //thickness=0.18 //x=84.045 //y=1.4 //x2=84.085 //y2=1.555
r802 (  199 273 ) resistor r=45.1352 //w=0.168 //l=0.173853 //layer=ply \
 //thickness=0.18 //x=84.045 //y=1.09 //x2=84.085 //y2=0.935
r803 (  199 200 ) resistor r=158.957 //w=0.094 //l=0.31 //layer=ply \
 //thickness=0.18 //x=84.045 //y=1.09 //x2=84.045 //y2=1.4
r804 (  195 267 ) resistor r=16.5046 //w=0.27 //l=0.135 //layer=ply \
 //thickness=0.18 //x=70.185 //y=4.97 //x2=70.05 //y2=4.97
r805 (  194 196 ) resistor r=26.9307 //w=0.15 //l=0.106066 //layer=ply \
 //thickness=0.18 //x=70.385 //y=4.97 //x2=70.46 //y2=5.045
r806 (  194 195 ) resistor r=102.553 //w=0.094 //l=0.2 //layer=ply \
 //thickness=0.18 //x=70.385 //y=4.97 //x2=70.185 //y2=4.97
r807 (  193 272 ) resistor r=38.6777 //w=0.284 //l=0.198997 //layer=ply \
 //thickness=0.18 //x=70.14 //y=2.095 //x2=70.065 //y2=2.26
r808 (  192 270 ) resistor r=21.2976 //w=0.217 //l=0.0928709 //layer=ply \
 //thickness=0.18 //x=70.14 //y=1.63 //x2=70.1 //y2=1.555
r809 (  192 193 ) resistor r=238.436 //w=0.094 //l=0.465 //layer=ply \
 //thickness=0.18 //x=70.14 //y=1.63 //x2=70.14 //y2=2.095
r810 (  191 270 ) resistor r=39.0671 //w=0.217 //l=0.173853 //layer=ply \
 //thickness=0.18 //x=70.14 //y=1.4 //x2=70.1 //y2=1.555
r811 (  190 269 ) resistor r=45.1352 //w=0.168 //l=0.173853 //layer=ply \
 //thickness=0.18 //x=70.14 //y=1.09 //x2=70.1 //y2=0.935
r812 (  190 191 ) resistor r=158.957 //w=0.094 //l=0.31 //layer=ply \
 //thickness=0.18 //x=70.14 //y=1.09 //x2=70.14 //y2=1.4
r813 (  185 263 ) resistor r=5.52526 //w=0.168 //l=0.115 //layer=ply \
 //thickness=0.18 //x=69.77 //y=1.555 //x2=69.655 //y2=1.555
r814 (  184 270 ) resistor r=11.4558 //w=0.217 //l=0.115 //layer=ply \
 //thickness=0.18 //x=69.985 //y=1.555 //x2=70.1 //y2=1.555
r815 (  183 262 ) resistor r=5.52526 //w=0.168 //l=0.115 //layer=ply \
 //thickness=0.18 //x=69.77 //y=0.935 //x2=69.655 //y2=0.935
r816 (  182 269 ) resistor r=5.52526 //w=0.168 //l=0.115 //layer=ply \
 //thickness=0.18 //x=69.985 //y=0.935 //x2=70.1 //y2=0.935
r817 (  182 183 ) resistor r=110.245 //w=0.094 //l=0.215 //layer=ply \
 //thickness=0.18 //x=69.985 //y=0.935 //x2=69.77 //y2=0.935
r818 (  181 263 ) resistor r=45.1352 //w=0.168 //l=0.173853 //layer=ply \
 //thickness=0.18 //x=69.615 //y=1.4 //x2=69.655 //y2=1.555
r819 (  180 262 ) resistor r=45.1352 //w=0.168 //l=0.173853 //layer=ply \
 //thickness=0.18 //x=69.615 //y=1.09 //x2=69.655 //y2=0.935
r820 (  180 181 ) resistor r=158.957 //w=0.094 //l=0.31 //layer=ply \
 //thickness=0.18 //x=69.615 //y=1.09 //x2=69.615 //y2=1.4
r821 (  176 256 ) resistor r=16.5046 //w=0.27 //l=0.135 //layer=ply \
 //thickness=0.18 //x=55.755 //y=4.97 //x2=55.62 //y2=4.97
r822 (  175 177 ) resistor r=26.9307 //w=0.15 //l=0.106066 //layer=ply \
 //thickness=0.18 //x=55.955 //y=4.97 //x2=56.03 //y2=5.045
r823 (  175 176 ) resistor r=102.553 //w=0.094 //l=0.2 //layer=ply \
 //thickness=0.18 //x=55.955 //y=4.97 //x2=55.755 //y2=4.97
r824 (  174 261 ) resistor r=38.6777 //w=0.284 //l=0.198997 //layer=ply \
 //thickness=0.18 //x=55.71 //y=2.095 //x2=55.635 //y2=2.26
r825 (  173 259 ) resistor r=21.2976 //w=0.217 //l=0.0928709 //layer=ply \
 //thickness=0.18 //x=55.71 //y=1.63 //x2=55.67 //y2=1.555
r826 (  173 174 ) resistor r=238.436 //w=0.094 //l=0.465 //layer=ply \
 //thickness=0.18 //x=55.71 //y=1.63 //x2=55.71 //y2=2.095
r827 (  172 259 ) resistor r=39.0671 //w=0.217 //l=0.173853 //layer=ply \
 //thickness=0.18 //x=55.71 //y=1.4 //x2=55.67 //y2=1.555
r828 (  171 258 ) resistor r=45.1352 //w=0.168 //l=0.173853 //layer=ply \
 //thickness=0.18 //x=55.71 //y=1.09 //x2=55.67 //y2=0.935
r829 (  171 172 ) resistor r=158.957 //w=0.094 //l=0.31 //layer=ply \
 //thickness=0.18 //x=55.71 //y=1.09 //x2=55.71 //y2=1.4
r830 (  166 252 ) resistor r=5.52526 //w=0.168 //l=0.115 //layer=ply \
 //thickness=0.18 //x=55.34 //y=1.555 //x2=55.225 //y2=1.555
r831 (  165 259 ) resistor r=11.4558 //w=0.217 //l=0.115 //layer=ply \
 //thickness=0.18 //x=55.555 //y=1.555 //x2=55.67 //y2=1.555
r832 (  164 251 ) resistor r=5.52526 //w=0.168 //l=0.115 //layer=ply \
 //thickness=0.18 //x=55.34 //y=0.935 //x2=55.225 //y2=0.935
r833 (  163 258 ) resistor r=5.52526 //w=0.168 //l=0.115 //layer=ply \
 //thickness=0.18 //x=55.555 //y=0.935 //x2=55.67 //y2=0.935
r834 (  163 164 ) resistor r=110.245 //w=0.094 //l=0.215 //layer=ply \
 //thickness=0.18 //x=55.555 //y=0.935 //x2=55.34 //y2=0.935
r835 (  162 252 ) resistor r=45.1352 //w=0.168 //l=0.173853 //layer=ply \
 //thickness=0.18 //x=55.185 //y=1.4 //x2=55.225 //y2=1.555
r836 (  161 251 ) resistor r=45.1352 //w=0.168 //l=0.173853 //layer=ply \
 //thickness=0.18 //x=55.185 //y=1.09 //x2=55.225 //y2=0.935
r837 (  161 162 ) resistor r=158.957 //w=0.094 //l=0.31 //layer=ply \
 //thickness=0.18 //x=55.185 //y=1.09 //x2=55.185 //y2=1.4
r838 (  157 245 ) resistor r=16.5046 //w=0.27 //l=0.135 //layer=ply \
 //thickness=0.18 //x=41.325 //y=4.97 //x2=41.19 //y2=4.97
r839 (  156 158 ) resistor r=26.9307 //w=0.15 //l=0.106066 //layer=ply \
 //thickness=0.18 //x=41.525 //y=4.97 //x2=41.6 //y2=5.045
r840 (  156 157 ) resistor r=102.553 //w=0.094 //l=0.2 //layer=ply \
 //thickness=0.18 //x=41.525 //y=4.97 //x2=41.325 //y2=4.97
r841 (  155 250 ) resistor r=38.6777 //w=0.284 //l=0.198997 //layer=ply \
 //thickness=0.18 //x=41.28 //y=2.095 //x2=41.205 //y2=2.26
r842 (  154 248 ) resistor r=21.2976 //w=0.217 //l=0.0928709 //layer=ply \
 //thickness=0.18 //x=41.28 //y=1.63 //x2=41.24 //y2=1.555
r843 (  154 155 ) resistor r=238.436 //w=0.094 //l=0.465 //layer=ply \
 //thickness=0.18 //x=41.28 //y=1.63 //x2=41.28 //y2=2.095
r844 (  153 248 ) resistor r=39.0671 //w=0.217 //l=0.173853 //layer=ply \
 //thickness=0.18 //x=41.28 //y=1.4 //x2=41.24 //y2=1.555
r845 (  152 247 ) resistor r=45.1352 //w=0.168 //l=0.173853 //layer=ply \
 //thickness=0.18 //x=41.28 //y=1.09 //x2=41.24 //y2=0.935
r846 (  152 153 ) resistor r=158.957 //w=0.094 //l=0.31 //layer=ply \
 //thickness=0.18 //x=41.28 //y=1.09 //x2=41.28 //y2=1.4
r847 (  147 241 ) resistor r=5.52526 //w=0.168 //l=0.115 //layer=ply \
 //thickness=0.18 //x=40.91 //y=1.555 //x2=40.795 //y2=1.555
r848 (  146 248 ) resistor r=11.4558 //w=0.217 //l=0.115 //layer=ply \
 //thickness=0.18 //x=41.125 //y=1.555 //x2=41.24 //y2=1.555
r849 (  145 240 ) resistor r=5.52526 //w=0.168 //l=0.115 //layer=ply \
 //thickness=0.18 //x=40.91 //y=0.935 //x2=40.795 //y2=0.935
r850 (  144 247 ) resistor r=5.52526 //w=0.168 //l=0.115 //layer=ply \
 //thickness=0.18 //x=41.125 //y=0.935 //x2=41.24 //y2=0.935
r851 (  144 145 ) resistor r=110.245 //w=0.094 //l=0.215 //layer=ply \
 //thickness=0.18 //x=41.125 //y=0.935 //x2=40.91 //y2=0.935
r852 (  143 241 ) resistor r=45.1352 //w=0.168 //l=0.173853 //layer=ply \
 //thickness=0.18 //x=40.755 //y=1.4 //x2=40.795 //y2=1.555
r853 (  142 240 ) resistor r=45.1352 //w=0.168 //l=0.173853 //layer=ply \
 //thickness=0.18 //x=40.755 //y=1.09 //x2=40.795 //y2=0.935
r854 (  142 143 ) resistor r=158.957 //w=0.094 //l=0.31 //layer=ply \
 //thickness=0.18 //x=40.755 //y=1.09 //x2=40.755 //y2=1.4
r855 (  138 234 ) resistor r=16.5046 //w=0.27 //l=0.135 //layer=ply \
 //thickness=0.18 //x=26.895 //y=4.97 //x2=26.76 //y2=4.97
r856 (  137 139 ) resistor r=26.9307 //w=0.15 //l=0.106066 //layer=ply \
 //thickness=0.18 //x=27.095 //y=4.97 //x2=27.17 //y2=5.045
r857 (  137 138 ) resistor r=102.553 //w=0.094 //l=0.2 //layer=ply \
 //thickness=0.18 //x=27.095 //y=4.97 //x2=26.895 //y2=4.97
r858 (  136 239 ) resistor r=38.6777 //w=0.284 //l=0.198997 //layer=ply \
 //thickness=0.18 //x=26.85 //y=2.095 //x2=26.775 //y2=2.26
r859 (  135 237 ) resistor r=21.2976 //w=0.217 //l=0.0928709 //layer=ply \
 //thickness=0.18 //x=26.85 //y=1.63 //x2=26.81 //y2=1.555
r860 (  135 136 ) resistor r=238.436 //w=0.094 //l=0.465 //layer=ply \
 //thickness=0.18 //x=26.85 //y=1.63 //x2=26.85 //y2=2.095
r861 (  134 237 ) resistor r=39.0671 //w=0.217 //l=0.173853 //layer=ply \
 //thickness=0.18 //x=26.85 //y=1.4 //x2=26.81 //y2=1.555
r862 (  133 236 ) resistor r=45.1352 //w=0.168 //l=0.173853 //layer=ply \
 //thickness=0.18 //x=26.85 //y=1.09 //x2=26.81 //y2=0.935
r863 (  133 134 ) resistor r=158.957 //w=0.094 //l=0.31 //layer=ply \
 //thickness=0.18 //x=26.85 //y=1.09 //x2=26.85 //y2=1.4
r864 (  128 230 ) resistor r=5.52526 //w=0.168 //l=0.115 //layer=ply \
 //thickness=0.18 //x=26.48 //y=1.555 //x2=26.365 //y2=1.555
r865 (  127 237 ) resistor r=11.4558 //w=0.217 //l=0.115 //layer=ply \
 //thickness=0.18 //x=26.695 //y=1.555 //x2=26.81 //y2=1.555
r866 (  126 229 ) resistor r=5.52526 //w=0.168 //l=0.115 //layer=ply \
 //thickness=0.18 //x=26.48 //y=0.935 //x2=26.365 //y2=0.935
r867 (  125 236 ) resistor r=5.52526 //w=0.168 //l=0.115 //layer=ply \
 //thickness=0.18 //x=26.695 //y=0.935 //x2=26.81 //y2=0.935
r868 (  125 126 ) resistor r=110.245 //w=0.094 //l=0.215 //layer=ply \
 //thickness=0.18 //x=26.695 //y=0.935 //x2=26.48 //y2=0.935
r869 (  124 230 ) resistor r=45.1352 //w=0.168 //l=0.173853 //layer=ply \
 //thickness=0.18 //x=26.325 //y=1.4 //x2=26.365 //y2=1.555
r870 (  123 229 ) resistor r=45.1352 //w=0.168 //l=0.173853 //layer=ply \
 //thickness=0.18 //x=26.325 //y=1.09 //x2=26.365 //y2=0.935
r871 (  123 124 ) resistor r=158.957 //w=0.094 //l=0.31 //layer=ply \
 //thickness=0.18 //x=26.325 //y=1.09 //x2=26.325 //y2=1.4
r872 (  119 223 ) resistor r=16.5046 //w=0.27 //l=0.135 //layer=ply \
 //thickness=0.18 //x=12.465 //y=4.97 //x2=12.33 //y2=4.97
r873 (  118 120 ) resistor r=26.9307 //w=0.15 //l=0.106066 //layer=ply \
 //thickness=0.18 //x=12.665 //y=4.97 //x2=12.74 //y2=5.045
r874 (  118 119 ) resistor r=102.553 //w=0.094 //l=0.2 //layer=ply \
 //thickness=0.18 //x=12.665 //y=4.97 //x2=12.465 //y2=4.97
r875 (  117 228 ) resistor r=38.6777 //w=0.284 //l=0.198997 //layer=ply \
 //thickness=0.18 //x=12.42 //y=2.095 //x2=12.345 //y2=2.26
r876 (  116 226 ) resistor r=21.2976 //w=0.217 //l=0.0928709 //layer=ply \
 //thickness=0.18 //x=12.42 //y=1.63 //x2=12.38 //y2=1.555
r877 (  116 117 ) resistor r=238.436 //w=0.094 //l=0.465 //layer=ply \
 //thickness=0.18 //x=12.42 //y=1.63 //x2=12.42 //y2=2.095
r878 (  115 226 ) resistor r=39.0671 //w=0.217 //l=0.173853 //layer=ply \
 //thickness=0.18 //x=12.42 //y=1.4 //x2=12.38 //y2=1.555
r879 (  114 225 ) resistor r=45.1352 //w=0.168 //l=0.173853 //layer=ply \
 //thickness=0.18 //x=12.42 //y=1.09 //x2=12.38 //y2=0.935
r880 (  114 115 ) resistor r=158.957 //w=0.094 //l=0.31 //layer=ply \
 //thickness=0.18 //x=12.42 //y=1.09 //x2=12.42 //y2=1.4
r881 (  109 219 ) resistor r=5.52526 //w=0.168 //l=0.115 //layer=ply \
 //thickness=0.18 //x=12.05 //y=1.555 //x2=11.935 //y2=1.555
r882 (  108 226 ) resistor r=11.4558 //w=0.217 //l=0.115 //layer=ply \
 //thickness=0.18 //x=12.265 //y=1.555 //x2=12.38 //y2=1.555
r883 (  107 218 ) resistor r=5.52526 //w=0.168 //l=0.115 //layer=ply \
 //thickness=0.18 //x=12.05 //y=0.935 //x2=11.935 //y2=0.935
r884 (  106 225 ) resistor r=5.52526 //w=0.168 //l=0.115 //layer=ply \
 //thickness=0.18 //x=12.265 //y=0.935 //x2=12.38 //y2=0.935
r885 (  106 107 ) resistor r=110.245 //w=0.094 //l=0.215 //layer=ply \
 //thickness=0.18 //x=12.265 //y=0.935 //x2=12.05 //y2=0.935
r886 (  105 219 ) resistor r=45.1352 //w=0.168 //l=0.173853 //layer=ply \
 //thickness=0.18 //x=11.895 //y=1.4 //x2=11.935 //y2=1.555
r887 (  104 218 ) resistor r=45.1352 //w=0.168 //l=0.173853 //layer=ply \
 //thickness=0.18 //x=11.895 //y=1.09 //x2=11.935 //y2=0.935
r888 (  104 105 ) resistor r=158.957 //w=0.094 //l=0.31 //layer=ply \
 //thickness=0.18 //x=11.895 //y=1.09 //x2=11.895 //y2=1.4
r889 (  103 215 ) resistor r=592.245 //w=0.094 //l=1.155 //layer=ply \
 //thickness=0.18 //x=84.89 //y=6.2 //x2=84.89 //y2=5.045
r890 (  102 279 ) resistor r=592.245 //w=0.094 //l=1.155 //layer=ply \
 //thickness=0.18 //x=84.45 //y=6.2 //x2=84.45 //y2=5.045
r891 (  101 196 ) resistor r=592.245 //w=0.094 //l=1.155 //layer=ply \
 //thickness=0.18 //x=70.46 //y=6.2 //x2=70.46 //y2=5.045
r892 (  100 268 ) resistor r=592.245 //w=0.094 //l=1.155 //layer=ply \
 //thickness=0.18 //x=70.02 //y=6.2 //x2=70.02 //y2=5.045
r893 (  99 177 ) resistor r=592.245 //w=0.094 //l=1.155 //layer=ply \
 //thickness=0.18 //x=56.03 //y=6.2 //x2=56.03 //y2=5.045
r894 (  98 257 ) resistor r=592.245 //w=0.094 //l=1.155 //layer=ply \
 //thickness=0.18 //x=55.59 //y=6.2 //x2=55.59 //y2=5.045
r895 (  97 158 ) resistor r=592.245 //w=0.094 //l=1.155 //layer=ply \
 //thickness=0.18 //x=41.6 //y=6.2 //x2=41.6 //y2=5.045
r896 (  96 246 ) resistor r=592.245 //w=0.094 //l=1.155 //layer=ply \
 //thickness=0.18 //x=41.16 //y=6.2 //x2=41.16 //y2=5.045
r897 (  95 139 ) resistor r=592.245 //w=0.094 //l=1.155 //layer=ply \
 //thickness=0.18 //x=27.17 //y=6.2 //x2=27.17 //y2=5.045
r898 (  94 235 ) resistor r=592.245 //w=0.094 //l=1.155 //layer=ply \
 //thickness=0.18 //x=26.73 //y=6.2 //x2=26.73 //y2=5.045
r899 (  93 120 ) resistor r=592.245 //w=0.094 //l=1.155 //layer=ply \
 //thickness=0.18 //x=12.74 //y=6.2 //x2=12.74 //y2=5.045
r900 (  92 224 ) resistor r=592.245 //w=0.094 //l=1.155 //layer=ply \
 //thickness=0.18 //x=12.3 //y=6.2 //x2=12.3 //y2=5.045
r901 (  91 203 ) resistor r=55.3787 //w=0.094 //l=0.108 //layer=ply \
 //thickness=0.18 //x=84.307 //y=1.555 //x2=84.415 //y2=1.555
r902 (  91 204 ) resistor r=54.866 //w=0.094 //l=0.107 //layer=ply \
 //thickness=0.18 //x=84.307 //y=1.555 //x2=84.2 //y2=1.555
r903 (  90 184 ) resistor r=55.3787 //w=0.094 //l=0.108 //layer=ply \
 //thickness=0.18 //x=69.877 //y=1.555 //x2=69.985 //y2=1.555
r904 (  90 185 ) resistor r=54.866 //w=0.094 //l=0.107 //layer=ply \
 //thickness=0.18 //x=69.877 //y=1.555 //x2=69.77 //y2=1.555
r905 (  89 165 ) resistor r=55.3787 //w=0.094 //l=0.108 //layer=ply \
 //thickness=0.18 //x=55.447 //y=1.555 //x2=55.555 //y2=1.555
r906 (  89 166 ) resistor r=54.866 //w=0.094 //l=0.107 //layer=ply \
 //thickness=0.18 //x=55.447 //y=1.555 //x2=55.34 //y2=1.555
r907 (  88 146 ) resistor r=55.3787 //w=0.094 //l=0.108 //layer=ply \
 //thickness=0.18 //x=41.017 //y=1.555 //x2=41.125 //y2=1.555
r908 (  88 147 ) resistor r=54.866 //w=0.094 //l=0.107 //layer=ply \
 //thickness=0.18 //x=41.017 //y=1.555 //x2=40.91 //y2=1.555
r909 (  87 127 ) resistor r=55.3787 //w=0.094 //l=0.108 //layer=ply \
 //thickness=0.18 //x=26.587 //y=1.555 //x2=26.695 //y2=1.555
r910 (  87 128 ) resistor r=54.866 //w=0.094 //l=0.107 //layer=ply \
 //thickness=0.18 //x=26.587 //y=1.555 //x2=26.48 //y2=1.555
r911 (  86 108 ) resistor r=55.3787 //w=0.094 //l=0.108 //layer=ply \
 //thickness=0.18 //x=12.157 //y=1.555 //x2=12.265 //y2=1.555
r912 (  86 109 ) resistor r=54.866 //w=0.094 //l=0.107 //layer=ply \
 //thickness=0.18 //x=12.157 //y=1.555 //x2=12.05 //y2=1.555
r913 (  84 276 ) resistor r=152 //w=0.17 //l=0.17 //layer=licon //count=1 \
 //x=84.48 //y=4.88 //x2=84.48 //y2=4.88
r914 (  82 84 ) resistor r=119.102 //w=0.187 //l=1.74 //layer=li \
 //thickness=0.1 //x=84.48 //y=3.14 //x2=84.48 //y2=4.88
r915 (  79 283 ) resistor r=152 //w=0.17 //l=0.17 //layer=licon //count=1 \
 //x=84.48 //y=2.26 //x2=84.48 //y2=2.26
r916 (  79 82 ) resistor r=60.2353 //w=0.187 //l=0.88 //layer=li \
 //thickness=0.1 //x=84.48 //y=2.26 //x2=84.48 //y2=3.14
r917 (  76 265 ) resistor r=152 //w=0.17 //l=0.17 //layer=licon //count=1 \
 //x=70.05 //y=4.88 //x2=70.05 //y2=4.88
r918 (  70 272 ) resistor r=152 //w=0.17 //l=0.17 //layer=licon //count=1 \
 //x=70.05 //y=2.26 //x2=70.05 //y2=2.26
r919 (  67 254 ) resistor r=152 //w=0.17 //l=0.17 //layer=licon //count=1 \
 //x=55.62 //y=4.88 //x2=55.62 //y2=4.88
r920 (  61 261 ) resistor r=152 //w=0.17 //l=0.17 //layer=licon //count=1 \
 //x=55.62 //y=2.26 //x2=55.62 //y2=2.26
r921 (  58 243 ) resistor r=152 //w=0.17 //l=0.17 //layer=licon //count=1 \
 //x=41.19 //y=4.88 //x2=41.19 //y2=4.88
r922 (  52 250 ) resistor r=152 //w=0.17 //l=0.17 //layer=licon //count=1 \
 //x=41.19 //y=2.26 //x2=41.19 //y2=2.26
r923 (  49 232 ) resistor r=152 //w=0.17 //l=0.17 //layer=licon //count=1 \
 //x=26.76 //y=4.88 //x2=26.76 //y2=4.88
r924 (  43 239 ) resistor r=152 //w=0.17 //l=0.17 //layer=licon //count=1 \
 //x=26.76 //y=2.26 //x2=26.76 //y2=2.26
r925 (  40 221 ) resistor r=152 //w=0.17 //l=0.17 //layer=licon //count=1 \
 //x=12.33 //y=4.88 //x2=12.33 //y2=4.88
r926 (  34 228 ) resistor r=152 //w=0.17 //l=0.17 //layer=licon //count=1 \
 //x=12.33 //y=2.26 //x2=12.33 //y2=2.26
r927 (  32 76 ) resistor r=119.102 //w=0.187 //l=1.74 //layer=li \
 //thickness=0.1 //x=70.05 //y=3.14 //x2=70.05 //y2=4.88
r928 (  31 32 ) resistor r=25.3262 //w=0.187 //l=0.37 //layer=li \
 //thickness=0.1 //x=70.05 //y=2.77 //x2=70.05 //y2=3.14
r929 (  31 70 ) resistor r=34.9091 //w=0.187 //l=0.51 //layer=li \
 //thickness=0.1 //x=70.05 //y=2.77 //x2=70.05 //y2=2.26
r930 (  30 67 ) resistor r=119.102 //w=0.187 //l=1.74 //layer=li \
 //thickness=0.1 //x=55.62 //y=3.14 //x2=55.62 //y2=4.88
r931 (  29 30 ) resistor r=25.3262 //w=0.187 //l=0.37 //layer=li \
 //thickness=0.1 //x=55.62 //y=2.77 //x2=55.62 //y2=3.14
r932 (  29 61 ) resistor r=34.9091 //w=0.187 //l=0.51 //layer=li \
 //thickness=0.1 //x=55.62 //y=2.77 //x2=55.62 //y2=2.26
r933 (  28 58 ) resistor r=119.102 //w=0.187 //l=1.74 //layer=li \
 //thickness=0.1 //x=41.19 //y=3.14 //x2=41.19 //y2=4.88
r934 (  27 28 ) resistor r=25.3262 //w=0.187 //l=0.37 //layer=li \
 //thickness=0.1 //x=41.19 //y=2.77 //x2=41.19 //y2=3.14
r935 (  27 52 ) resistor r=34.9091 //w=0.187 //l=0.51 //layer=li \
 //thickness=0.1 //x=41.19 //y=2.77 //x2=41.19 //y2=2.26
r936 (  26 49 ) resistor r=119.102 //w=0.187 //l=1.74 //layer=li \
 //thickness=0.1 //x=26.76 //y=3.14 //x2=26.76 //y2=4.88
r937 (  25 26 ) resistor r=25.3262 //w=0.187 //l=0.37 //layer=li \
 //thickness=0.1 //x=26.76 //y=2.77 //x2=26.76 //y2=3.14
r938 (  25 43 ) resistor r=34.9091 //w=0.187 //l=0.51 //layer=li \
 //thickness=0.1 //x=26.76 //y=2.77 //x2=26.76 //y2=2.26
r939 (  24 40 ) resistor r=119.102 //w=0.187 //l=1.74 //layer=li \
 //thickness=0.1 //x=12.33 //y=3.14 //x2=12.33 //y2=4.88
r940 (  23 24 ) resistor r=25.3262 //w=0.187 //l=0.37 //layer=li \
 //thickness=0.1 //x=12.33 //y=2.77 //x2=12.33 //y2=3.14
r941 (  23 34 ) resistor r=34.9091 //w=0.187 //l=0.51 //layer=li \
 //thickness=0.1 //x=12.33 //y=2.77 //x2=12.33 //y2=2.26
r942 (  22 82 ) resistor r=9.3 //w=0.17 //l=0.17 //layer=mcon //count=1 \
 //x=84.48 //y=3.14 //x2=84.48 //y2=3.14
r943 (  20 32 ) resistor r=9.3 //w=0.17 //l=0.17 //layer=mcon //count=1 \
 //x=70.05 //y=3.14 //x2=70.05 //y2=3.14
r944 (  18 30 ) resistor r=9.3 //w=0.17 //l=0.17 //layer=mcon //count=1 \
 //x=55.62 //y=3.14 //x2=55.62 //y2=3.14
r945 (  16 28 ) resistor r=9.3 //w=0.17 //l=0.17 //layer=mcon //count=1 \
 //x=41.19 //y=3.14 //x2=41.19 //y2=3.14
r946 (  14 26 ) resistor r=9.3 //w=0.17 //l=0.17 //layer=mcon //count=1 \
 //x=26.76 //y=3.14 //x2=26.76 //y2=3.14
r947 (  12 24 ) resistor r=9.3 //w=0.17 //l=0.17 //layer=mcon //count=1 \
 //x=12.33 //y=3.14 //x2=12.33 //y2=3.14
r948 (  10 20 ) resistor r=0.0880901 //w=0.191 //l=0.115 //layer=m1 \
 //thickness=0.36 //x=70.165 //y=3.14 //x2=70.05 //y2=3.14
r949 (  9 22 ) resistor r=0.0717383 //w=0.224 //l=0.115 //layer=m1 \
 //thickness=0.36 //x=84.365 //y=3.14 //x2=84.48 //y2=3.14
r950 (  9 10 ) resistor r=13.5496 //w=0.131 //l=14.2 //layer=m1 \
 //thickness=0.36 //x=84.365 //y=3.14 //x2=70.165 //y2=3.14
r951 (  8 18 ) resistor r=0.0880901 //w=0.191 //l=0.115 //layer=m1 \
 //thickness=0.36 //x=55.735 //y=3.14 //x2=55.62 //y2=3.14
r952 (  7 20 ) resistor r=0.0880901 //w=0.191 //l=0.115 //layer=m1 \
 //thickness=0.36 //x=69.935 //y=3.14 //x2=70.05 //y2=3.14
r953 (  7 8 ) resistor r=13.5496 //w=0.131 //l=14.2 //layer=m1 \
 //thickness=0.36 //x=69.935 //y=3.14 //x2=55.735 //y2=3.14
r954 (  6 16 ) resistor r=0.0880901 //w=0.191 //l=0.115 //layer=m1 \
 //thickness=0.36 //x=41.305 //y=3.14 //x2=41.19 //y2=3.14
r955 (  5 18 ) resistor r=0.0880901 //w=0.191 //l=0.115 //layer=m1 \
 //thickness=0.36 //x=55.505 //y=3.14 //x2=55.62 //y2=3.14
r956 (  5 6 ) resistor r=13.5496 //w=0.131 //l=14.2 //layer=m1 \
 //thickness=0.36 //x=55.505 //y=3.14 //x2=41.305 //y2=3.14
r957 (  4 14 ) resistor r=0.0880901 //w=0.191 //l=0.115 //layer=m1 \
 //thickness=0.36 //x=26.875 //y=3.14 //x2=26.76 //y2=3.14
r958 (  3 16 ) resistor r=0.0880901 //w=0.191 //l=0.115 //layer=m1 \
 //thickness=0.36 //x=41.075 //y=3.14 //x2=41.19 //y2=3.14
r959 (  3 4 ) resistor r=13.5496 //w=0.131 //l=14.2 //layer=m1 \
 //thickness=0.36 //x=41.075 //y=3.14 //x2=26.875 //y2=3.14
r960 (  2 12 ) resistor r=0.0717383 //w=0.224 //l=0.115 //layer=m1 \
 //thickness=0.36 //x=12.445 //y=3.14 //x2=12.33 //y2=3.14
r961 (  1 14 ) resistor r=0.0880901 //w=0.191 //l=0.115 //layer=m1 \
 //thickness=0.36 //x=26.645 //y=3.14 //x2=26.76 //y2=3.14
r962 (  1 2 ) resistor r=13.5496 //w=0.131 //l=14.2 //layer=m1 \
 //thickness=0.36 //x=26.645 //y=3.14 //x2=12.445 //y2=3.14
ends PM_TMRDFFSNRNQX1\%SN

subckt PM_TMRDFFSNRNQX1\%noxref_23 ( 1 2 3 4 5 6 16 24 37 38 45 53 59 60 64 66 \
 73 74 75 76 77 78 79 80 81 82 83 87 88 89 94 96 99 100 104 105 106 111 113 \
 116 117 121 122 123 128 130 133 134 136 137 142 146 147 152 156 157 162 165 \
 167 168 169 )
c345 ( 169 0 ) capacitor c=0.023087f //x=75.785 //y=5.2
c346 ( 168 0 ) capacitor c=0.023519f //x=74.905 //y=5.2
c347 ( 167 0 ) capacitor c=0.0224735f //x=74.025 //y=5.2
c348 ( 165 0 ) capacitor c=0.00853354f //x=76.035 //y=1.095
c349 ( 162 0 ) capacitor c=0.0587755f //x=85.59 //y=4.88
c350 ( 157 0 ) capacitor c=0.0273931f //x=85.59 //y=2.095
c351 ( 156 0 ) capacitor c=0.0462455f //x=85.59 //y=2.26
c352 ( 152 0 ) capacitor c=0.0588394f //x=71.16 //y=4.88
c353 ( 147 0 ) capacitor c=0.0273931f //x=71.16 //y=2.095
c354 ( 146 0 ) capacitor c=0.0456313f //x=71.16 //y=2.26
c355 ( 142 0 ) capacitor c=0.0589949f //x=66.35 //y=4.88
c356 ( 137 0 ) capacitor c=0.0273931f //x=66.35 //y=2.095
c357 ( 136 0 ) capacitor c=0.0456313f //x=66.35 //y=2.26
c358 ( 134 0 ) capacitor c=0.0432517f //x=86.11 //y=1.44
c359 ( 133 0 ) capacitor c=0.0200379f //x=86.11 //y=1.095
c360 ( 130 0 ) capacitor c=0.0148873f //x=85.955 //y=1.595
c361 ( 128 0 ) capacitor c=0.0157803f //x=85.955 //y=0.94
c362 ( 123 0 ) capacitor c=0.0218028f //x=85.58 //y=1.75
c363 ( 122 0 ) capacitor c=0.0207459f //x=85.58 //y=1.44
c364 ( 121 0 ) capacitor c=0.0194308f //x=85.58 //y=1.095
c365 ( 117 0 ) capacitor c=0.0432517f //x=71.68 //y=1.44
c366 ( 116 0 ) capacitor c=0.0200379f //x=71.68 //y=1.095
c367 ( 113 0 ) capacitor c=0.0148873f //x=71.525 //y=1.595
c368 ( 111 0 ) capacitor c=0.0157803f //x=71.525 //y=0.94
c369 ( 106 0 ) capacitor c=0.0218028f //x=71.15 //y=1.75
c370 ( 105 0 ) capacitor c=0.0207459f //x=71.15 //y=1.44
c371 ( 104 0 ) capacitor c=0.0194308f //x=71.15 //y=1.095
c372 ( 100 0 ) capacitor c=0.0432517f //x=66.87 //y=1.44
c373 ( 99 0 ) capacitor c=0.0200379f //x=66.87 //y=1.095
c374 ( 96 0 ) capacitor c=0.0148873f //x=66.715 //y=1.595
c375 ( 94 0 ) capacitor c=0.0157803f //x=66.715 //y=0.94
c376 ( 89 0 ) capacitor c=0.0218028f //x=66.34 //y=1.75
c377 ( 88 0 ) capacitor c=0.0207459f //x=66.34 //y=1.44
c378 ( 87 0 ) capacitor c=0.0194308f //x=66.34 //y=1.095
c379 ( 83 0 ) capacitor c=0.158794f //x=85.77 //y=6.2
c380 ( 82 0 ) capacitor c=0.110114f //x=85.33 //y=6.2
c381 ( 81 0 ) capacitor c=0.158754f //x=71.34 //y=6.2
c382 ( 80 0 ) capacitor c=0.109949f //x=70.9 //y=6.2
c383 ( 79 0 ) capacitor c=0.158754f //x=66.53 //y=6.2
c384 ( 78 0 ) capacitor c=0.109949f //x=66.09 //y=6.2
c385 ( 74 0 ) capacitor c=0.00106608f //x=75.93 //y=5.335
c386 ( 73 0 ) capacitor c=0.00191414f //x=75.05 //y=5.335
c387 ( 66 0 ) capacitor c=0.0857665f //x=85.59 //y=2.26
c388 ( 64 0 ) capacitor c=0.10494f //x=76.71 //y=3.88
c389 ( 60 0 ) capacitor c=0.00398962f //x=76.31 //y=1.845
c390 ( 59 0 ) capacitor c=0.0137288f //x=76.625 //y=1.845
c391 ( 53 0 ) capacitor c=0.0283082f //x=76.625 //y=5.335
c392 ( 45 0 ) capacitor c=0.0170864f //x=75.845 //y=5.335
c393 ( 38 0 ) capacitor c=0.00316998f //x=74.255 //y=5.335
c394 ( 37 0 ) capacitor c=0.014258f //x=74.965 //y=5.335
c395 ( 24 0 ) capacitor c=0.0790362f //x=71.16 //y=2.26
c396 ( 16 0 ) capacitor c=0.076565f //x=66.35 //y=2.26
c397 ( 6 0 ) capacitor c=0.0055354f //x=76.825 //y=3.88
c398 ( 5 0 ) capacitor c=0.167028f //x=85.475 //y=3.88
c399 ( 4 0 ) capacitor c=0.00533183f //x=71.275 //y=3.88
c400 ( 3 0 ) capacitor c=0.0753575f //x=76.595 //y=3.88
c401 ( 2 0 ) capacitor c=0.00692093f //x=66.465 //y=3.88
c402 ( 1 0 ) capacitor c=0.0665749f //x=71.045 //y=3.88
r403 (  156 157 ) resistor r=52.7279 //w=0.214 //l=0.165 //layer=ply \
 //thickness=0.18 //x=85.59 //y=2.26 //x2=85.59 //y2=2.095
r404 (  146 147 ) resistor r=52.7279 //w=0.214 //l=0.165 //layer=ply \
 //thickness=0.18 //x=71.16 //y=2.26 //x2=71.16 //y2=2.095
r405 (  136 137 ) resistor r=52.7279 //w=0.214 //l=0.165 //layer=ply \
 //thickness=0.18 //x=66.35 //y=2.26 //x2=66.35 //y2=2.095
r406 (  134 164 ) resistor r=45.1352 //w=0.168 //l=0.173853 //layer=ply \
 //thickness=0.18 //x=86.11 //y=1.44 //x2=86.07 //y2=1.595
r407 (  133 163 ) resistor r=45.1352 //w=0.168 //l=0.173853 //layer=ply \
 //thickness=0.18 //x=86.11 //y=1.095 //x2=86.07 //y2=0.94
r408 (  133 134 ) resistor r=176.904 //w=0.094 //l=0.345 //layer=ply \
 //thickness=0.18 //x=86.11 //y=1.095 //x2=86.11 //y2=1.44
r409 (  131 160 ) resistor r=10.701 //w=0.21 //l=0.115 //layer=ply \
 //thickness=0.18 //x=85.735 //y=1.595 //x2=85.62 //y2=1.595
r410 (  130 164 ) resistor r=5.52526 //w=0.168 //l=0.115 //layer=ply \
 //thickness=0.18 //x=85.955 //y=1.595 //x2=86.07 //y2=1.595
r411 (  129 159 ) resistor r=5.52526 //w=0.168 //l=0.115 //layer=ply \
 //thickness=0.18 //x=85.735 //y=0.94 //x2=85.62 //y2=0.94
r412 (  128 163 ) resistor r=5.52526 //w=0.168 //l=0.115 //layer=ply \
 //thickness=0.18 //x=85.955 //y=0.94 //x2=86.07 //y2=0.94
r413 (  128 129 ) resistor r=112.809 //w=0.094 //l=0.22 //layer=ply \
 //thickness=0.18 //x=85.955 //y=0.94 //x2=85.735 //y2=0.94
r414 (  125 162 ) resistor r=37.236 //w=0.233 //l=0.249199 //layer=ply \
 //thickness=0.18 //x=85.77 //y=5.045 //x2=85.59 //y2=4.88
r415 (  123 160 ) resistor r=39.5823 //w=0.21 //l=0.173853 //layer=ply \
 //thickness=0.18 //x=85.58 //y=1.75 //x2=85.62 //y2=1.595
r416 (  123 157 ) resistor r=176.904 //w=0.094 //l=0.345 //layer=ply \
 //thickness=0.18 //x=85.58 //y=1.75 //x2=85.58 //y2=2.095
r417 (  122 160 ) resistor r=39.5823 //w=0.21 //l=0.173853 //layer=ply \
 //thickness=0.18 //x=85.58 //y=1.44 //x2=85.62 //y2=1.595
r418 (  121 159 ) resistor r=45.1352 //w=0.168 //l=0.173853 //layer=ply \
 //thickness=0.18 //x=85.58 //y=1.095 //x2=85.62 //y2=0.94
r419 (  121 122 ) resistor r=176.904 //w=0.094 //l=0.345 //layer=ply \
 //thickness=0.18 //x=85.58 //y=1.095 //x2=85.58 //y2=1.44
r420 (  118 162 ) resistor r=53.7854 //w=0.233 //l=0.332415 //layer=ply \
 //thickness=0.18 //x=85.33 //y=5.045 //x2=85.59 //y2=4.88
r421 (  117 154 ) resistor r=45.1352 //w=0.168 //l=0.173853 //layer=ply \
 //thickness=0.18 //x=71.68 //y=1.44 //x2=71.64 //y2=1.595
r422 (  116 153 ) resistor r=45.1352 //w=0.168 //l=0.173853 //layer=ply \
 //thickness=0.18 //x=71.68 //y=1.095 //x2=71.64 //y2=0.94
r423 (  116 117 ) resistor r=176.904 //w=0.094 //l=0.345 //layer=ply \
 //thickness=0.18 //x=71.68 //y=1.095 //x2=71.68 //y2=1.44
r424 (  114 150 ) resistor r=10.701 //w=0.21 //l=0.115 //layer=ply \
 //thickness=0.18 //x=71.305 //y=1.595 //x2=71.19 //y2=1.595
r425 (  113 154 ) resistor r=5.52526 //w=0.168 //l=0.115 //layer=ply \
 //thickness=0.18 //x=71.525 //y=1.595 //x2=71.64 //y2=1.595
r426 (  112 149 ) resistor r=5.52526 //w=0.168 //l=0.115 //layer=ply \
 //thickness=0.18 //x=71.305 //y=0.94 //x2=71.19 //y2=0.94
r427 (  111 153 ) resistor r=5.52526 //w=0.168 //l=0.115 //layer=ply \
 //thickness=0.18 //x=71.525 //y=0.94 //x2=71.64 //y2=0.94
r428 (  111 112 ) resistor r=112.809 //w=0.094 //l=0.22 //layer=ply \
 //thickness=0.18 //x=71.525 //y=0.94 //x2=71.305 //y2=0.94
r429 (  108 152 ) resistor r=37.236 //w=0.233 //l=0.249199 //layer=ply \
 //thickness=0.18 //x=71.34 //y=5.045 //x2=71.16 //y2=4.88
r430 (  106 150 ) resistor r=39.5823 //w=0.21 //l=0.173853 //layer=ply \
 //thickness=0.18 //x=71.15 //y=1.75 //x2=71.19 //y2=1.595
r431 (  106 147 ) resistor r=176.904 //w=0.094 //l=0.345 //layer=ply \
 //thickness=0.18 //x=71.15 //y=1.75 //x2=71.15 //y2=2.095
r432 (  105 150 ) resistor r=39.5823 //w=0.21 //l=0.173853 //layer=ply \
 //thickness=0.18 //x=71.15 //y=1.44 //x2=71.19 //y2=1.595
r433 (  104 149 ) resistor r=45.1352 //w=0.168 //l=0.173853 //layer=ply \
 //thickness=0.18 //x=71.15 //y=1.095 //x2=71.19 //y2=0.94
r434 (  104 105 ) resistor r=176.904 //w=0.094 //l=0.345 //layer=ply \
 //thickness=0.18 //x=71.15 //y=1.095 //x2=71.15 //y2=1.44
r435 (  101 152 ) resistor r=53.7854 //w=0.233 //l=0.332415 //layer=ply \
 //thickness=0.18 //x=70.9 //y=5.045 //x2=71.16 //y2=4.88
r436 (  100 144 ) resistor r=45.1352 //w=0.168 //l=0.173853 //layer=ply \
 //thickness=0.18 //x=66.87 //y=1.44 //x2=66.83 //y2=1.595
r437 (  99 143 ) resistor r=45.1352 //w=0.168 //l=0.173853 //layer=ply \
 //thickness=0.18 //x=66.87 //y=1.095 //x2=66.83 //y2=0.94
r438 (  99 100 ) resistor r=176.904 //w=0.094 //l=0.345 //layer=ply \
 //thickness=0.18 //x=66.87 //y=1.095 //x2=66.87 //y2=1.44
r439 (  97 140 ) resistor r=10.701 //w=0.21 //l=0.115 //layer=ply \
 //thickness=0.18 //x=66.495 //y=1.595 //x2=66.38 //y2=1.595
r440 (  96 144 ) resistor r=5.52526 //w=0.168 //l=0.115 //layer=ply \
 //thickness=0.18 //x=66.715 //y=1.595 //x2=66.83 //y2=1.595
r441 (  95 139 ) resistor r=5.52526 //w=0.168 //l=0.115 //layer=ply \
 //thickness=0.18 //x=66.495 //y=0.94 //x2=66.38 //y2=0.94
r442 (  94 143 ) resistor r=5.52526 //w=0.168 //l=0.115 //layer=ply \
 //thickness=0.18 //x=66.715 //y=0.94 //x2=66.83 //y2=0.94
r443 (  94 95 ) resistor r=112.809 //w=0.094 //l=0.22 //layer=ply \
 //thickness=0.18 //x=66.715 //y=0.94 //x2=66.495 //y2=0.94
r444 (  91 142 ) resistor r=37.236 //w=0.233 //l=0.249199 //layer=ply \
 //thickness=0.18 //x=66.53 //y=5.045 //x2=66.35 //y2=4.88
r445 (  89 140 ) resistor r=39.5823 //w=0.21 //l=0.173853 //layer=ply \
 //thickness=0.18 //x=66.34 //y=1.75 //x2=66.38 //y2=1.595
r446 (  89 137 ) resistor r=176.904 //w=0.094 //l=0.345 //layer=ply \
 //thickness=0.18 //x=66.34 //y=1.75 //x2=66.34 //y2=2.095
r447 (  88 140 ) resistor r=39.5823 //w=0.21 //l=0.173853 //layer=ply \
 //thickness=0.18 //x=66.34 //y=1.44 //x2=66.38 //y2=1.595
r448 (  87 139 ) resistor r=45.1352 //w=0.168 //l=0.173853 //layer=ply \
 //thickness=0.18 //x=66.34 //y=1.095 //x2=66.38 //y2=0.94
r449 (  87 88 ) resistor r=176.904 //w=0.094 //l=0.345 //layer=ply \
 //thickness=0.18 //x=66.34 //y=1.095 //x2=66.34 //y2=1.44
r450 (  84 142 ) resistor r=53.7854 //w=0.233 //l=0.332415 //layer=ply \
 //thickness=0.18 //x=66.09 //y=5.045 //x2=66.35 //y2=4.88
r451 (  83 125 ) resistor r=592.245 //w=0.094 //l=1.155 //layer=ply \
 //thickness=0.18 //x=85.77 //y=6.2 //x2=85.77 //y2=5.045
r452 (  82 118 ) resistor r=592.245 //w=0.094 //l=1.155 //layer=ply \
 //thickness=0.18 //x=85.33 //y=6.2 //x2=85.33 //y2=5.045
r453 (  81 108 ) resistor r=592.245 //w=0.094 //l=1.155 //layer=ply \
 //thickness=0.18 //x=71.34 //y=6.2 //x2=71.34 //y2=5.045
r454 (  80 101 ) resistor r=592.245 //w=0.094 //l=1.155 //layer=ply \
 //thickness=0.18 //x=70.9 //y=6.2 //x2=70.9 //y2=5.045
r455 (  79 91 ) resistor r=592.245 //w=0.094 //l=1.155 //layer=ply \
 //thickness=0.18 //x=66.53 //y=6.2 //x2=66.53 //y2=5.045
r456 (  78 84 ) resistor r=592.245 //w=0.094 //l=1.155 //layer=ply \
 //thickness=0.18 //x=66.09 //y=6.2 //x2=66.09 //y2=5.045
r457 (  77 130 ) resistor r=56.4043 //w=0.094 //l=0.11 //layer=ply \
 //thickness=0.18 //x=85.845 //y=1.595 //x2=85.955 //y2=1.595
r458 (  77 131 ) resistor r=56.4043 //w=0.094 //l=0.11 //layer=ply \
 //thickness=0.18 //x=85.845 //y=1.595 //x2=85.735 //y2=1.595
r459 (  76 113 ) resistor r=56.4043 //w=0.094 //l=0.11 //layer=ply \
 //thickness=0.18 //x=71.415 //y=1.595 //x2=71.525 //y2=1.595
r460 (  76 114 ) resistor r=56.4043 //w=0.094 //l=0.11 //layer=ply \
 //thickness=0.18 //x=71.415 //y=1.595 //x2=71.305 //y2=1.595
r461 (  75 96 ) resistor r=56.4043 //w=0.094 //l=0.11 //layer=ply \
 //thickness=0.18 //x=66.605 //y=1.595 //x2=66.715 //y2=1.595
r462 (  75 97 ) resistor r=56.4043 //w=0.094 //l=0.11 //layer=ply \
 //thickness=0.18 //x=66.605 //y=1.595 //x2=66.495 //y2=1.595
r463 (  71 162 ) resistor r=152 //w=0.17 //l=0.17 //layer=licon //count=1 \
 //x=85.59 //y=4.88 //x2=85.59 //y2=4.88
r464 (  69 71 ) resistor r=68.4492 //w=0.187 //l=1 //layer=li //thickness=0.1 \
 //x=85.59 //y=3.88 //x2=85.59 //y2=4.88
r465 (  66 156 ) resistor r=152 //w=0.17 //l=0.17 //layer=licon //count=1 \
 //x=85.59 //y=2.26 //x2=85.59 //y2=2.26
r466 (  66 69 ) resistor r=110.888 //w=0.187 //l=1.62 //layer=li \
 //thickness=0.1 //x=85.59 //y=2.26 //x2=85.59 //y2=3.88
r467 (  62 64 ) resistor r=93.7754 //w=0.187 //l=1.37 //layer=li \
 //thickness=0.1 //x=76.71 //y=5.25 //x2=76.71 //y2=3.88
r468 (  61 64 ) resistor r=133.476 //w=0.187 //l=1.95 //layer=li \
 //thickness=0.1 //x=76.71 //y=1.93 //x2=76.71 //y2=3.88
r469 (  59 61 ) resistor r=7.15173 //w=0.17 //l=0.120208 //layer=li \
 //thickness=0.1 //x=76.625 //y=1.845 //x2=76.71 //y2=1.93
r470 (  59 60 ) resistor r=21.5615 //w=0.187 //l=0.315 //layer=li \
 //thickness=0.1 //x=76.625 //y=1.845 //x2=76.31 //y2=1.845
r471 (  55 60 ) resistor r=7.15173 //w=0.17 //l=0.120208 //layer=li \
 //thickness=0.1 //x=76.225 //y=1.76 //x2=76.31 //y2=1.845
r472 (  55 165 ) resistor r=39.016 //w=0.187 //l=0.57 //layer=li \
 //thickness=0.1 //x=76.225 //y=1.76 //x2=76.225 //y2=1.19
r473 (  54 74 ) resistor r=5.4201 //w=0.17 //l=0.085 //layer=li \
 //thickness=0.1 //x=76.015 //y=5.335 //x2=75.93 //y2=5.335
r474 (  53 62 ) resistor r=7.15173 //w=0.17 //l=0.120208 //layer=li \
 //thickness=0.1 //x=76.625 //y=5.335 //x2=76.71 //y2=5.25
r475 (  53 54 ) resistor r=41.754 //w=0.187 //l=0.61 //layer=li \
 //thickness=0.1 //x=76.625 //y=5.335 //x2=76.015 //y2=5.335
r476 (  47 74 ) resistor r=1.40859 //w=0.34 //l=0.085 //layer=li \
 //thickness=0.1 //x=75.93 //y=5.42 //x2=75.93 //y2=5.335
r477 (  47 169 ) resistor r=33.1979 //w=0.187 //l=0.485 //layer=li \
 //thickness=0.1 //x=75.93 //y=5.42 //x2=75.93 //y2=5.905
r478 (  46 73 ) resistor r=5.4201 //w=0.17 //l=0.085 //layer=li \
 //thickness=0.1 //x=75.135 //y=5.335 //x2=75.05 //y2=5.335
r479 (  45 74 ) resistor r=5.4201 //w=0.17 //l=0.085 //layer=li \
 //thickness=0.1 //x=75.845 //y=5.335 //x2=75.93 //y2=5.335
r480 (  45 46 ) resistor r=48.5989 //w=0.187 //l=0.71 //layer=li \
 //thickness=0.1 //x=75.845 //y=5.335 //x2=75.135 //y2=5.335
r481 (  39 73 ) resistor r=1.40859 //w=0.34 //l=0.085 //layer=li \
 //thickness=0.1 //x=75.05 //y=5.42 //x2=75.05 //y2=5.335
r482 (  39 168 ) resistor r=33.1979 //w=0.187 //l=0.485 //layer=li \
 //thickness=0.1 //x=75.05 //y=5.42 //x2=75.05 //y2=5.905
r483 (  37 73 ) resistor r=5.4201 //w=0.17 //l=0.085 //layer=li \
 //thickness=0.1 //x=74.965 //y=5.335 //x2=75.05 //y2=5.335
r484 (  37 38 ) resistor r=48.5989 //w=0.187 //l=0.71 //layer=li \
 //thickness=0.1 //x=74.965 //y=5.335 //x2=74.255 //y2=5.335
r485 (  31 38 ) resistor r=7.15173 //w=0.17 //l=0.120208 //layer=li \
 //thickness=0.1 //x=74.17 //y=5.42 //x2=74.255 //y2=5.335
r486 (  31 167 ) resistor r=33.1979 //w=0.187 //l=0.485 //layer=li \
 //thickness=0.1 //x=74.17 //y=5.42 //x2=74.17 //y2=5.905
r487 (  29 152 ) resistor r=152 //w=0.17 //l=0.17 //layer=licon //count=1 \
 //x=71.16 //y=4.88 //x2=71.16 //y2=4.88
r488 (  27 29 ) resistor r=68.4492 //w=0.187 //l=1 //layer=li //thickness=0.1 \
 //x=71.16 //y=3.88 //x2=71.16 //y2=4.88
r489 (  24 146 ) resistor r=152 //w=0.17 //l=0.17 //layer=licon //count=1 \
 //x=71.16 //y=2.26 //x2=71.16 //y2=2.26
r490 (  24 27 ) resistor r=110.888 //w=0.187 //l=1.62 //layer=li \
 //thickness=0.1 //x=71.16 //y=2.26 //x2=71.16 //y2=3.88
r491 (  21 142 ) resistor r=152 //w=0.17 //l=0.17 //layer=licon //count=1 \
 //x=66.35 //y=4.88 //x2=66.35 //y2=4.88
r492 (  19 21 ) resistor r=68.4492 //w=0.187 //l=1 //layer=li //thickness=0.1 \
 //x=66.35 //y=3.88 //x2=66.35 //y2=4.88
r493 (  16 136 ) resistor r=152 //w=0.17 //l=0.17 //layer=licon //count=1 \
 //x=66.35 //y=2.26 //x2=66.35 //y2=2.26
r494 (  16 19 ) resistor r=110.888 //w=0.187 //l=1.62 //layer=li \
 //thickness=0.1 //x=66.35 //y=2.26 //x2=66.35 //y2=3.88
r495 (  14 69 ) resistor r=9.3 //w=0.17 //l=0.17 //layer=mcon //count=1 \
 //x=85.59 //y=3.88 //x2=85.59 //y2=3.88
r496 (  12 64 ) resistor r=9.3 //w=0.17 //l=0.17 //layer=mcon //count=1 \
 //x=76.71 //y=3.88 //x2=76.71 //y2=3.88
r497 (  10 27 ) resistor r=9.3 //w=0.17 //l=0.17 //layer=mcon //count=1 \
 //x=71.16 //y=3.88 //x2=71.16 //y2=3.88
r498 (  8 19 ) resistor r=9.3 //w=0.17 //l=0.17 //layer=mcon //count=1 \
 //x=66.35 //y=3.88 //x2=66.35 //y2=3.88
r499 (  6 12 ) resistor r=0.0880901 //w=0.191 //l=0.115 //layer=m1 \
 //thickness=0.36 //x=76.825 //y=3.88 //x2=76.71 //y2=3.88
r500 (  5 14 ) resistor r=0.0717383 //w=0.224 //l=0.115 //layer=m1 \
 //thickness=0.36 //x=85.475 //y=3.88 //x2=85.59 //y2=3.88
r501 (  5 6 ) resistor r=8.25382 //w=0.131 //l=8.65 //layer=m1 \
 //thickness=0.36 //x=85.475 //y=3.88 //x2=76.825 //y2=3.88
r502 (  4 10 ) resistor r=0.0880901 //w=0.191 //l=0.115 //layer=m1 \
 //thickness=0.36 //x=71.275 //y=3.88 //x2=71.16 //y2=3.88
r503 (  3 12 ) resistor r=0.0880901 //w=0.191 //l=0.115 //layer=m1 \
 //thickness=0.36 //x=76.595 //y=3.88 //x2=76.71 //y2=3.88
r504 (  3 4 ) resistor r=5.07634 //w=0.131 //l=5.32 //layer=m1 \
 //thickness=0.36 //x=76.595 //y=3.88 //x2=71.275 //y2=3.88
r505 (  2 8 ) resistor r=0.0717383 //w=0.224 //l=0.115 //layer=m1 \
 //thickness=0.36 //x=66.465 //y=3.88 //x2=66.35 //y2=3.88
r506 (  1 10 ) resistor r=0.0880901 //w=0.191 //l=0.115 //layer=m1 \
 //thickness=0.36 //x=71.045 //y=3.88 //x2=71.16 //y2=3.88
r507 (  1 2 ) resistor r=4.37023 //w=0.131 //l=4.58 //layer=m1 \
 //thickness=0.36 //x=71.045 //y=3.88 //x2=66.465 //y2=3.88
ends PM_TMRDFFSNRNQX1\%noxref_23

subckt PM_TMRDFFSNRNQX1\%noxref_24 ( 1 2 13 14 15 23 29 30 37 50 51 52 53 54 )
c91 ( 54 0 ) capacitor c=0.034295f //x=92.795 //y=5.205
c92 ( 53 0 ) capacitor c=0.0174957f //x=91.915 //y=5.205
c93 ( 51 0 ) capacitor c=0.0214849f //x=89.035 //y=5.205
c94 ( 50 0 ) capacitor c=0.0217161f //x=88.155 //y=5.205
c95 ( 49 0 ) capacitor c=0.00115294f //x=92.06 //y=7.09
c96 ( 37 0 ) capacitor c=0.0131238f //x=92.855 //y=7.09
c97 ( 30 0 ) capacitor c=0.00386507f //x=91.265 //y=7.09
c98 ( 29 0 ) capacitor c=0.00951687f //x=91.975 //y=7.09
c99 ( 23 0 ) capacitor c=0.0455351f //x=91.18 //y=5.39
c100 ( 15 0 ) capacitor c=0.00871244f //x=89.18 //y=5.475
c101 ( 14 0 ) capacitor c=0.00290434f //x=88.385 //y=5.39
c102 ( 13 0 ) capacitor c=0.0139202f //x=89.095 //y=5.39
c103 ( 2 0 ) capacitor c=0.0091252f //x=89.295 //y=5.39
c104 ( 1 0 ) capacitor c=0.0484159f //x=91.065 //y=5.39
r105 (  39 54 ) resistor r=5.81818 //w=0.187 //l=0.085 //layer=li \
 //thickness=0.1 //x=92.94 //y=7.005 //x2=92.94 //y2=6.92
r106 (  38 49 ) resistor r=5.4201 //w=0.17 //l=0.085 //layer=li \
 //thickness=0.1 //x=92.145 //y=7.09 //x2=92.06 //y2=7.09
r107 (  37 39 ) resistor r=7.15173 //w=0.17 //l=0.120208 //layer=li \
 //thickness=0.1 //x=92.855 //y=7.09 //x2=92.94 //y2=7.005
r108 (  37 38 ) resistor r=48.5989 //w=0.187 //l=0.71 //layer=li \
 //thickness=0.1 //x=92.855 //y=7.09 //x2=92.145 //y2=7.09
r109 (  31 49 ) resistor r=1.40859 //w=0.34 //l=0.085 //layer=li \
 //thickness=0.1 //x=92.06 //y=7.005 //x2=92.06 //y2=7.09
r110 (  31 53 ) resistor r=5.81818 //w=0.187 //l=0.085 //layer=li \
 //thickness=0.1 //x=92.06 //y=7.005 //x2=92.06 //y2=6.92
r111 (  29 49 ) resistor r=5.4201 //w=0.17 //l=0.085 //layer=li \
 //thickness=0.1 //x=91.975 //y=7.09 //x2=92.06 //y2=7.09
r112 (  29 30 ) resistor r=48.5989 //w=0.187 //l=0.71 //layer=li \
 //thickness=0.1 //x=91.975 //y=7.09 //x2=91.265 //y2=7.09
r113 (  23 52 ) resistor r=58.1818 //w=0.187 //l=0.85 //layer=li \
 //thickness=0.1 //x=91.18 //y=5.39 //x2=91.18 //y2=6.24
r114 (  21 30 ) resistor r=7.15173 //w=0.17 //l=0.120208 //layer=li \
 //thickness=0.1 //x=91.18 //y=7.005 //x2=91.265 //y2=7.09
r115 (  21 52 ) resistor r=5.81818 //w=0.187 //l=0.085 //layer=li \
 //thickness=0.1 //x=91.18 //y=7.005 //x2=91.18 //y2=6.92
r116 (  15 48 ) resistor r=3.57586 //w=0.17 //l=0.125 //layer=li \
 //thickness=0.1 //x=89.18 //y=5.475 //x2=89.18 //y2=5.35
r117 (  15 51 ) resistor r=52.3636 //w=0.187 //l=0.765 //layer=li \
 //thickness=0.1 //x=89.18 //y=5.475 //x2=89.18 //y2=6.24
r118 (  13 48 ) resistor r=3.57586 //w=0.17 //l=0.103078 //layer=li \
 //thickness=0.1 //x=89.095 //y=5.39 //x2=89.18 //y2=5.35
r119 (  13 14 ) resistor r=48.5989 //w=0.187 //l=0.71 //layer=li \
 //thickness=0.1 //x=89.095 //y=5.39 //x2=88.385 //y2=5.39
r120 (  7 14 ) resistor r=7.15173 //w=0.17 //l=0.120208 //layer=li \
 //thickness=0.1 //x=88.3 //y=5.475 //x2=88.385 //y2=5.39
r121 (  7 50 ) resistor r=29.0909 //w=0.187 //l=0.425 //layer=li \
 //thickness=0.1 //x=88.3 //y=5.475 //x2=88.3 //y2=5.9
r122 (  6 23 ) resistor r=9.3 //w=0.17 //l=0.17 //layer=mcon //count=1 \
 //x=91.18 //y=5.39 //x2=91.18 //y2=5.39
r123 (  4 48 ) resistor r=9.3 //w=0.17 //l=0.17 //layer=mcon //count=1 \
 //x=89.18 //y=5.39 //x2=89.18 //y2=5.39
r124 (  2 4 ) resistor r=0.0717383 //w=0.224 //l=0.115 //layer=m1 \
 //thickness=0.36 //x=89.295 //y=5.39 //x2=89.18 //y2=5.39
r125 (  1 6 ) resistor r=0.0717383 //w=0.224 //l=0.115 //layer=m1 \
 //thickness=0.36 //x=91.065 //y=5.39 //x2=91.18 //y2=5.39
r126 (  1 2 ) resistor r=1.68893 //w=0.131 //l=1.77 //layer=m1 \
 //thickness=0.36 //x=91.065 //y=5.39 //x2=89.295 //y2=5.39
ends PM_TMRDFFSNRNQX1\%noxref_24

subckt PM_TMRDFFSNRNQX1\%noxref_25 ( 1 2 3 4 5 12 17 30 31 38 46 52 53 57 59 \
 66 72 73 74 75 76 77 78 79 80 81 82 86 87 88 93 95 98 99 103 104 105 106 107 \
 109 112 115 116 117 118 119 120 121 122 126 128 131 132 133 134 139 140 145 \
 157 164 166 167 168 )
c390 ( 168 0 ) capacitor c=0.023087f //x=85.405 //y=5.2
c391 ( 167 0 ) capacitor c=0.023519f //x=84.525 //y=5.2
c392 ( 166 0 ) capacitor c=0.0224735f //x=83.645 //y=5.2
c393 ( 164 0 ) capacitor c=0.0087111f //x=85.655 //y=1.095
c394 ( 157 0 ) capacitor c=0.0583848f //x=94.47 //y=2.26
c395 ( 145 0 ) capacitor c=0.0587755f //x=80.78 //y=4.88
c396 ( 140 0 ) capacitor c=0.0273931f //x=80.78 //y=2.095
c397 ( 139 0 ) capacitor c=0.0457326f //x=80.78 //y=2.26
c398 ( 134 0 ) capacitor c=0.0316774f //x=95.175 //y=1.39
c399 ( 133 0 ) capacitor c=0.0187384f //x=95.175 //y=1.045
c400 ( 132 0 ) capacitor c=0.0590362f //x=94.815 //y=4.975
c401 ( 131 0 ) capacitor c=0.0296075f //x=95.105 //y=4.975
c402 ( 128 0 ) capacitor c=0.0157912f //x=95.02 //y=1.545
c403 ( 126 0 ) capacitor c=0.0149844f //x=95.02 //y=0.89
c404 ( 122 0 ) capacitor c=0.0302441f //x=94.645 //y=2.095
c405 ( 121 0 ) capacitor c=0.0234157f //x=94.645 //y=1.7
c406 ( 120 0 ) capacitor c=0.0234376f //x=94.645 //y=1.39
c407 ( 119 0 ) capacitor c=0.0199931f //x=94.645 //y=1.045
c408 ( 118 0 ) capacitor c=0.092271f //x=92.815 //y=2.095
c409 ( 117 0 ) capacitor c=0.0249466f //x=92.815 //y=1.74
c410 ( 116 0 ) capacitor c=0.0234397f //x=92.815 //y=1.43
c411 ( 115 0 ) capacitor c=0.0193195f //x=92.815 //y=1.085
c412 ( 112 0 ) capacitor c=0.0631944f //x=92.72 //y=5.05
c413 ( 109 0 ) capacitor c=0.0164325f //x=92.66 //y=1.585
c414 ( 107 0 ) capacitor c=0.0157803f //x=92.66 //y=0.93
c415 ( 106 0 ) capacitor c=0.010629f //x=92.355 //y=4.975
c416 ( 105 0 ) capacitor c=0.0194269f //x=92.645 //y=4.975
c417 ( 104 0 ) capacitor c=0.0353695f //x=92.285 //y=1.43
c418 ( 103 0 ) capacitor c=0.0175988f //x=92.285 //y=1.085
c419 ( 99 0 ) capacitor c=0.0432517f //x=81.3 //y=1.44
c420 ( 98 0 ) capacitor c=0.0200379f //x=81.3 //y=1.095
c421 ( 95 0 ) capacitor c=0.0148873f //x=81.145 //y=1.595
c422 ( 93 0 ) capacitor c=0.0157803f //x=81.145 //y=0.94
c423 ( 88 0 ) capacitor c=0.0218028f //x=80.77 //y=1.75
c424 ( 87 0 ) capacitor c=0.0207459f //x=80.77 //y=1.44
c425 ( 86 0 ) capacitor c=0.0194308f //x=80.77 //y=1.095
c426 ( 82 0 ) capacitor c=0.110622f //x=95.18 //y=6.205
c427 ( 81 0 ) capacitor c=0.154068f //x=94.74 //y=6.205
c428 ( 80 0 ) capacitor c=0.154291f //x=92.72 //y=6.205
c429 ( 79 0 ) capacitor c=0.110404f //x=92.28 //y=6.205
c430 ( 78 0 ) capacitor c=0.158794f //x=80.96 //y=6.2
c431 ( 77 0 ) capacitor c=0.110114f //x=80.52 //y=6.2
c432 ( 73 0 ) capacitor c=0.00106608f //x=85.55 //y=5.335
c433 ( 72 0 ) capacitor c=0.00207319f //x=84.67 //y=5.335
c434 ( 66 0 ) capacitor c=0.100793f //x=94.47 //y=2.26
c435 ( 59 0 ) capacitor c=0.107544f //x=92.99 //y=2.26
c436 ( 57 0 ) capacitor c=0.110556f //x=86.33 //y=2.4
c437 ( 53 0 ) capacitor c=0.00398962f //x=85.93 //y=1.845
c438 ( 52 0 ) capacitor c=0.0137249f //x=86.245 //y=1.845
c439 ( 46 0 ) capacitor c=0.0281866f //x=86.245 //y=5.335
c440 ( 38 0 ) capacitor c=0.0176454f //x=85.465 //y=5.335
c441 ( 31 0 ) capacitor c=0.00332903f //x=83.875 //y=5.335
c442 ( 30 0 ) capacitor c=0.0148427f //x=84.585 //y=5.335
c443 ( 17 0 ) capacitor c=0.0838223f //x=80.78 //y=2.26
c444 ( 12 0 ) capacitor c=0.0148272f //x=92.99 //y=2.26
c445 ( 5 0 ) capacitor c=0.0465668f //x=94.355 //y=2.26
c446 ( 4 0 ) capacitor c=0.0078573f //x=86.445 //y=2.4
c447 ( 3 0 ) capacitor c=0.190117f //x=92.845 //y=2.4
c448 ( 2 0 ) capacitor c=0.00906111f //x=80.895 //y=2.4
c449 ( 1 0 ) capacitor c=0.122867f //x=86.215 //y=2.4
r450 (  139 140 ) resistor r=52.7279 //w=0.214 //l=0.165 //layer=ply \
 //thickness=0.18 //x=80.78 //y=2.26 //x2=80.78 //y2=2.095
r451 (  134 163 ) resistor r=45.1352 //w=0.168 //l=0.173853 //layer=ply \
 //thickness=0.18 //x=95.175 //y=1.39 //x2=95.135 //y2=1.545
r452 (  133 162 ) resistor r=45.1352 //w=0.168 //l=0.173853 //layer=ply \
 //thickness=0.18 //x=95.175 //y=1.045 //x2=95.135 //y2=0.89
r453 (  133 134 ) resistor r=176.904 //w=0.094 //l=0.345 //layer=ply \
 //thickness=0.18 //x=95.175 //y=1.045 //x2=95.175 //y2=1.39
r454 (  131 135 ) resistor r=26.9307 //w=0.15 //l=0.106066 //layer=ply \
 //thickness=0.18 //x=95.105 //y=4.975 //x2=95.18 //y2=5.05
r455 (  131 132 ) resistor r=148.702 //w=0.094 //l=0.29 //layer=ply \
 //thickness=0.18 //x=95.105 //y=4.975 //x2=94.815 //y2=4.975
r456 (  129 161 ) resistor r=10.701 //w=0.21 //l=0.115 //layer=ply \
 //thickness=0.18 //x=94.8 //y=1.545 //x2=94.685 //y2=1.545
r457 (  128 163 ) resistor r=5.52526 //w=0.168 //l=0.115 //layer=ply \
 //thickness=0.18 //x=95.02 //y=1.545 //x2=95.135 //y2=1.545
r458 (  127 160 ) resistor r=5.52526 //w=0.168 //l=0.115 //layer=ply \
 //thickness=0.18 //x=94.8 //y=0.89 //x2=94.685 //y2=0.89
r459 (  126 162 ) resistor r=5.52526 //w=0.168 //l=0.115 //layer=ply \
 //thickness=0.18 //x=95.02 //y=0.89 //x2=95.135 //y2=0.89
r460 (  126 127 ) resistor r=112.809 //w=0.094 //l=0.22 //layer=ply \
 //thickness=0.18 //x=95.02 //y=0.89 //x2=94.8 //y2=0.89
r461 (  123 132 ) resistor r=22.1787 //w=0.252 //l=0.106066 //layer=ply \
 //thickness=0.18 //x=94.74 //y=5.05 //x2=94.815 //y2=4.975
r462 (  123 159 ) resistor r=51.6429 //w=0.252 //l=0.34271 //layer=ply \
 //thickness=0.18 //x=94.74 //y=5.05 //x2=94.47 //y2=4.885
r463 (  122 157 ) resistor r=30.4513 //w=0.277 //l=0.243926 //layer=ply \
 //thickness=0.18 //x=94.645 //y=2.095 //x2=94.47 //y2=2.26
r464 (  121 161 ) resistor r=39.5823 //w=0.21 //l=0.173853 //layer=ply \
 //thickness=0.18 //x=94.645 //y=1.7 //x2=94.685 //y2=1.545
r465 (  121 122 ) resistor r=202.543 //w=0.094 //l=0.395 //layer=ply \
 //thickness=0.18 //x=94.645 //y=1.7 //x2=94.645 //y2=2.095
r466 (  120 161 ) resistor r=39.5823 //w=0.21 //l=0.173853 //layer=ply \
 //thickness=0.18 //x=94.645 //y=1.39 //x2=94.685 //y2=1.545
r467 (  119 160 ) resistor r=45.1352 //w=0.168 //l=0.173853 //layer=ply \
 //thickness=0.18 //x=94.645 //y=1.045 //x2=94.685 //y2=0.89
r468 (  119 120 ) resistor r=176.904 //w=0.094 //l=0.345 //layer=ply \
 //thickness=0.18 //x=94.645 //y=1.045 //x2=94.645 //y2=1.39
r469 (  118 153 ) resistor r=30.4513 //w=0.277 //l=0.243926 //layer=ply \
 //thickness=0.18 //x=92.815 //y=2.095 //x2=92.99 //y2=2.26
r470 (  117 151 ) resistor r=39.5823 //w=0.21 //l=0.173853 //layer=ply \
 //thickness=0.18 //x=92.815 //y=1.74 //x2=92.775 //y2=1.585
r471 (  117 118 ) resistor r=182.032 //w=0.094 //l=0.355 //layer=ply \
 //thickness=0.18 //x=92.815 //y=1.74 //x2=92.815 //y2=2.095
r472 (  116 151 ) resistor r=39.5823 //w=0.21 //l=0.173853 //layer=ply \
 //thickness=0.18 //x=92.815 //y=1.43 //x2=92.775 //y2=1.585
r473 (  115 150 ) resistor r=45.1352 //w=0.168 //l=0.173853 //layer=ply \
 //thickness=0.18 //x=92.815 //y=1.085 //x2=92.775 //y2=0.93
r474 (  115 116 ) resistor r=176.904 //w=0.094 //l=0.345 //layer=ply \
 //thickness=0.18 //x=92.815 //y=1.085 //x2=92.815 //y2=1.43
r475 (  112 155 ) resistor r=51.6429 //w=0.252 //l=0.34271 //layer=ply \
 //thickness=0.18 //x=92.72 //y=5.05 //x2=92.99 //y2=4.885
r476 (  110 149 ) resistor r=5.52526 //w=0.168 //l=0.115 //layer=ply \
 //thickness=0.18 //x=92.44 //y=1.585 //x2=92.325 //y2=1.585
r477 (  109 151 ) resistor r=10.701 //w=0.21 //l=0.115 //layer=ply \
 //thickness=0.18 //x=92.66 //y=1.585 //x2=92.775 //y2=1.585
r478 (  108 148 ) resistor r=5.52526 //w=0.168 //l=0.115 //layer=ply \
 //thickness=0.18 //x=92.44 //y=0.93 //x2=92.325 //y2=0.93
r479 (  107 150 ) resistor r=5.52526 //w=0.168 //l=0.115 //layer=ply \
 //thickness=0.18 //x=92.66 //y=0.93 //x2=92.775 //y2=0.93
r480 (  107 108 ) resistor r=112.809 //w=0.094 //l=0.22 //layer=ply \
 //thickness=0.18 //x=92.66 //y=0.93 //x2=92.44 //y2=0.93
r481 (  105 112 ) resistor r=22.1787 //w=0.252 //l=0.106066 //layer=ply \
 //thickness=0.18 //x=92.645 //y=4.975 //x2=92.72 //y2=5.05
r482 (  105 106 ) resistor r=148.702 //w=0.094 //l=0.29 //layer=ply \
 //thickness=0.18 //x=92.645 //y=4.975 //x2=92.355 //y2=4.975
r483 (  104 149 ) resistor r=45.1352 //w=0.168 //l=0.173853 //layer=ply \
 //thickness=0.18 //x=92.285 //y=1.43 //x2=92.325 //y2=1.585
r484 (  103 148 ) resistor r=45.1352 //w=0.168 //l=0.173853 //layer=ply \
 //thickness=0.18 //x=92.285 //y=1.085 //x2=92.325 //y2=0.93
r485 (  103 104 ) resistor r=176.904 //w=0.094 //l=0.345 //layer=ply \
 //thickness=0.18 //x=92.285 //y=1.085 //x2=92.285 //y2=1.43
r486 (  100 106 ) resistor r=26.9307 //w=0.15 //l=0.106066 //layer=ply \
 //thickness=0.18 //x=92.28 //y=5.05 //x2=92.355 //y2=4.975
r487 (  99 147 ) resistor r=45.1352 //w=0.168 //l=0.173853 //layer=ply \
 //thickness=0.18 //x=81.3 //y=1.44 //x2=81.26 //y2=1.595
r488 (  98 146 ) resistor r=45.1352 //w=0.168 //l=0.173853 //layer=ply \
 //thickness=0.18 //x=81.3 //y=1.095 //x2=81.26 //y2=0.94
r489 (  98 99 ) resistor r=176.904 //w=0.094 //l=0.345 //layer=ply \
 //thickness=0.18 //x=81.3 //y=1.095 //x2=81.3 //y2=1.44
r490 (  96 143 ) resistor r=10.701 //w=0.21 //l=0.115 //layer=ply \
 //thickness=0.18 //x=80.925 //y=1.595 //x2=80.81 //y2=1.595
r491 (  95 147 ) resistor r=5.52526 //w=0.168 //l=0.115 //layer=ply \
 //thickness=0.18 //x=81.145 //y=1.595 //x2=81.26 //y2=1.595
r492 (  94 142 ) resistor r=5.52526 //w=0.168 //l=0.115 //layer=ply \
 //thickness=0.18 //x=80.925 //y=0.94 //x2=80.81 //y2=0.94
r493 (  93 146 ) resistor r=5.52526 //w=0.168 //l=0.115 //layer=ply \
 //thickness=0.18 //x=81.145 //y=0.94 //x2=81.26 //y2=0.94
r494 (  93 94 ) resistor r=112.809 //w=0.094 //l=0.22 //layer=ply \
 //thickness=0.18 //x=81.145 //y=0.94 //x2=80.925 //y2=0.94
r495 (  90 145 ) resistor r=37.236 //w=0.233 //l=0.249199 //layer=ply \
 //thickness=0.18 //x=80.96 //y=5.045 //x2=80.78 //y2=4.88
r496 (  88 143 ) resistor r=39.5823 //w=0.21 //l=0.173853 //layer=ply \
 //thickness=0.18 //x=80.77 //y=1.75 //x2=80.81 //y2=1.595
r497 (  88 140 ) resistor r=176.904 //w=0.094 //l=0.345 //layer=ply \
 //thickness=0.18 //x=80.77 //y=1.75 //x2=80.77 //y2=2.095
r498 (  87 143 ) resistor r=39.5823 //w=0.21 //l=0.173853 //layer=ply \
 //thickness=0.18 //x=80.77 //y=1.44 //x2=80.81 //y2=1.595
r499 (  86 142 ) resistor r=45.1352 //w=0.168 //l=0.173853 //layer=ply \
 //thickness=0.18 //x=80.77 //y=1.095 //x2=80.81 //y2=0.94
r500 (  86 87 ) resistor r=176.904 //w=0.094 //l=0.345 //layer=ply \
 //thickness=0.18 //x=80.77 //y=1.095 //x2=80.77 //y2=1.44
r501 (  83 145 ) resistor r=53.7854 //w=0.233 //l=0.332415 //layer=ply \
 //thickness=0.18 //x=80.52 //y=5.045 //x2=80.78 //y2=4.88
r502 (  82 135 ) resistor r=592.245 //w=0.094 //l=1.155 //layer=ply \
 //thickness=0.18 //x=95.18 //y=6.205 //x2=95.18 //y2=5.05
r503 (  81 123 ) resistor r=592.245 //w=0.094 //l=1.155 //layer=ply \
 //thickness=0.18 //x=94.74 //y=6.205 //x2=94.74 //y2=5.05
r504 (  80 112 ) resistor r=592.245 //w=0.094 //l=1.155 //layer=ply \
 //thickness=0.18 //x=92.72 //y=6.205 //x2=92.72 //y2=5.05
r505 (  79 100 ) resistor r=592.245 //w=0.094 //l=1.155 //layer=ply \
 //thickness=0.18 //x=92.28 //y=6.205 //x2=92.28 //y2=5.05
r506 (  78 90 ) resistor r=592.245 //w=0.094 //l=1.155 //layer=ply \
 //thickness=0.18 //x=80.96 //y=6.2 //x2=80.96 //y2=5.045
r507 (  77 83 ) resistor r=592.245 //w=0.094 //l=1.155 //layer=ply \
 //thickness=0.18 //x=80.52 //y=6.2 //x2=80.52 //y2=5.045
r508 (  76 128 ) resistor r=56.4043 //w=0.094 //l=0.11 //layer=ply \
 //thickness=0.18 //x=94.91 //y=1.545 //x2=95.02 //y2=1.545
r509 (  76 129 ) resistor r=56.4043 //w=0.094 //l=0.11 //layer=ply \
 //thickness=0.18 //x=94.91 //y=1.545 //x2=94.8 //y2=1.545
r510 (  75 109 ) resistor r=56.4043 //w=0.094 //l=0.11 //layer=ply \
 //thickness=0.18 //x=92.55 //y=1.585 //x2=92.66 //y2=1.585
r511 (  75 110 ) resistor r=56.4043 //w=0.094 //l=0.11 //layer=ply \
 //thickness=0.18 //x=92.55 //y=1.585 //x2=92.44 //y2=1.585
r512 (  74 95 ) resistor r=56.4043 //w=0.094 //l=0.11 //layer=ply \
 //thickness=0.18 //x=81.035 //y=1.595 //x2=81.145 //y2=1.595
r513 (  74 96 ) resistor r=56.4043 //w=0.094 //l=0.11 //layer=ply \
 //thickness=0.18 //x=81.035 //y=1.595 //x2=80.925 //y2=1.595
r514 (  70 159 ) resistor r=152 //w=0.17 //l=0.17 //layer=licon //count=1 \
 //x=94.47 //y=4.885 //x2=94.47 //y2=4.885
r515 (  66 157 ) resistor r=152 //w=0.17 //l=0.17 //layer=licon //count=1 \
 //x=94.47 //y=2.26 //x2=94.47 //y2=2.26
r516 (  66 70 ) resistor r=179.679 //w=0.187 //l=2.625 //layer=li \
 //thickness=0.1 //x=94.47 //y=2.26 //x2=94.47 //y2=4.885
r517 (  63 155 ) resistor r=152 //w=0.17 //l=0.17 //layer=licon //count=1 \
 //x=92.99 //y=4.885 //x2=92.99 //y2=4.885
r518 (  59 153 ) resistor r=152 //w=0.17 //l=0.17 //layer=licon //count=1 \
 //x=92.99 //y=2.26 //x2=92.99 //y2=2.26
r519 (  59 63 ) resistor r=179.679 //w=0.187 //l=2.625 //layer=li \
 //thickness=0.1 //x=92.99 //y=2.26 //x2=92.99 //y2=4.885
r520 (  55 57 ) resistor r=195.08 //w=0.187 //l=2.85 //layer=li \
 //thickness=0.1 //x=86.33 //y=5.25 //x2=86.33 //y2=2.4
r521 (  54 57 ) resistor r=32.1711 //w=0.187 //l=0.47 //layer=li \
 //thickness=0.1 //x=86.33 //y=1.93 //x2=86.33 //y2=2.4
r522 (  52 54 ) resistor r=7.15173 //w=0.17 //l=0.120208 //layer=li \
 //thickness=0.1 //x=86.245 //y=1.845 //x2=86.33 //y2=1.93
r523 (  52 53 ) resistor r=21.5615 //w=0.187 //l=0.315 //layer=li \
 //thickness=0.1 //x=86.245 //y=1.845 //x2=85.93 //y2=1.845
r524 (  48 53 ) resistor r=7.15173 //w=0.17 //l=0.120208 //layer=li \
 //thickness=0.1 //x=85.845 //y=1.76 //x2=85.93 //y2=1.845
r525 (  48 164 ) resistor r=39.016 //w=0.187 //l=0.57 //layer=li \
 //thickness=0.1 //x=85.845 //y=1.76 //x2=85.845 //y2=1.19
r526 (  47 73 ) resistor r=5.4201 //w=0.17 //l=0.085 //layer=li \
 //thickness=0.1 //x=85.635 //y=5.335 //x2=85.55 //y2=5.335
r527 (  46 55 ) resistor r=7.15173 //w=0.17 //l=0.120208 //layer=li \
 //thickness=0.1 //x=86.245 //y=5.335 //x2=86.33 //y2=5.25
r528 (  46 47 ) resistor r=41.754 //w=0.187 //l=0.61 //layer=li \
 //thickness=0.1 //x=86.245 //y=5.335 //x2=85.635 //y2=5.335
r529 (  40 73 ) resistor r=1.40859 //w=0.34 //l=0.085 //layer=li \
 //thickness=0.1 //x=85.55 //y=5.42 //x2=85.55 //y2=5.335
r530 (  40 168 ) resistor r=33.1979 //w=0.187 //l=0.485 //layer=li \
 //thickness=0.1 //x=85.55 //y=5.42 //x2=85.55 //y2=5.905
r531 (  39 72 ) resistor r=5.4201 //w=0.17 //l=0.085 //layer=li \
 //thickness=0.1 //x=84.755 //y=5.335 //x2=84.67 //y2=5.335
r532 (  38 73 ) resistor r=5.4201 //w=0.17 //l=0.085 //layer=li \
 //thickness=0.1 //x=85.465 //y=5.335 //x2=85.55 //y2=5.335
r533 (  38 39 ) resistor r=48.5989 //w=0.187 //l=0.71 //layer=li \
 //thickness=0.1 //x=85.465 //y=5.335 //x2=84.755 //y2=5.335
r534 (  32 72 ) resistor r=1.40859 //w=0.34 //l=0.085 //layer=li \
 //thickness=0.1 //x=84.67 //y=5.42 //x2=84.67 //y2=5.335
r535 (  32 167 ) resistor r=33.1979 //w=0.187 //l=0.485 //layer=li \
 //thickness=0.1 //x=84.67 //y=5.42 //x2=84.67 //y2=5.905
r536 (  30 72 ) resistor r=5.4201 //w=0.17 //l=0.085 //layer=li \
 //thickness=0.1 //x=84.585 //y=5.335 //x2=84.67 //y2=5.335
r537 (  30 31 ) resistor r=48.5989 //w=0.187 //l=0.71 //layer=li \
 //thickness=0.1 //x=84.585 //y=5.335 //x2=83.875 //y2=5.335
r538 (  24 31 ) resistor r=7.15173 //w=0.17 //l=0.120208 //layer=li \
 //thickness=0.1 //x=83.79 //y=5.42 //x2=83.875 //y2=5.335
r539 (  24 166 ) resistor r=33.1979 //w=0.187 //l=0.485 //layer=li \
 //thickness=0.1 //x=83.79 //y=5.42 //x2=83.79 //y2=5.905
r540 (  22 145 ) resistor r=152 //w=0.17 //l=0.17 //layer=licon //count=1 \
 //x=80.78 //y=4.88 //x2=80.78 //y2=4.88
r541 (  20 22 ) resistor r=169.754 //w=0.187 //l=2.48 //layer=li \
 //thickness=0.1 //x=80.78 //y=2.4 //x2=80.78 //y2=4.88
r542 (  17 139 ) resistor r=152 //w=0.17 //l=0.17 //layer=licon //count=1 \
 //x=80.78 //y=2.26 //x2=80.78 //y2=2.26
r543 (  17 20 ) resistor r=9.58289 //w=0.187 //l=0.14 //layer=li \
 //thickness=0.1 //x=80.78 //y=2.26 //x2=80.78 //y2=2.4
r544 (  15 66 ) resistor r=9.3 //w=0.17 //l=0.17 //layer=mcon //count=1 \
 //x=94.47 //y=2.26 //x2=94.47 //y2=2.26
r545 (  12 59 ) resistor r=9.3 //w=0.17 //l=0.17 //layer=mcon //count=1 \
 //x=92.99 //y=2.26 //x2=92.99 //y2=2.26
r546 (  12 13 ) resistor r=0.0678295 //w=0.258 //l=0.14 //layer=m1 \
 //thickness=0.36 //x=92.975 //y=2.26 //x2=92.975 //y2=2.4
r547 (  10 57 ) resistor r=9.3 //w=0.17 //l=0.17 //layer=mcon //count=1 \
 //x=86.33 //y=2.4 //x2=86.33 //y2=2.4
r548 (  8 20 ) resistor r=9.3 //w=0.17 //l=0.17 //layer=mcon //count=1 \
 //x=80.78 //y=2.4 //x2=80.78 //y2=2.4
r549 (  6 12 ) resistor r=0.032569 //w=0.258 //l=0.13 //layer=m1 \
 //thickness=0.36 //x=93.105 //y=2.26 //x2=92.975 //y2=2.26
r550 (  5 15 ) resistor r=0.0717383 //w=0.224 //l=0.115 //layer=m1 \
 //thickness=0.36 //x=94.355 //y=2.26 //x2=94.47 //y2=2.26
r551 (  5 6 ) resistor r=1.19275 //w=0.131 //l=1.25 //layer=m1 \
 //thickness=0.36 //x=94.355 //y=2.26 //x2=93.105 //y2=2.26
r552 (  4 10 ) resistor r=0.0880901 //w=0.191 //l=0.115 //layer=m1 \
 //thickness=0.36 //x=86.445 //y=2.4 //x2=86.33 //y2=2.4
r553 (  3 13 ) resistor r=0.032569 //w=0.258 //l=0.13 //layer=m1 \
 //thickness=0.36 //x=92.845 //y=2.4 //x2=92.975 //y2=2.4
r554 (  3 4 ) resistor r=6.10687 //w=0.131 //l=6.4 //layer=m1 //thickness=0.36 \
 //x=92.845 //y=2.4 //x2=86.445 //y2=2.4
r555 (  2 8 ) resistor r=0.0717383 //w=0.224 //l=0.115 //layer=m1 \
 //thickness=0.36 //x=80.895 //y=2.4 //x2=80.78 //y2=2.4
r556 (  1 10 ) resistor r=0.0880901 //w=0.191 //l=0.115 //layer=m1 \
 //thickness=0.36 //x=86.215 //y=2.4 //x2=86.33 //y2=2.4
r557 (  1 2 ) resistor r=5.07634 //w=0.131 //l=5.32 //layer=m1 \
 //thickness=0.36 //x=86.215 //y=2.4 //x2=80.895 //y2=2.4
ends PM_TMRDFFSNRNQX1\%noxref_25

subckt PM_TMRDFFSNRNQX1\%noxref_26 ( 1 2 13 14 15 21 27 28 35 46 47 48 49 50 )
c90 ( 50 0 ) capacitor c=0.0306574f //x=96.135 //y=5.205
c91 ( 49 0 ) capacitor c=0.0173945f //x=95.255 //y=5.205
c92 ( 47 0 ) capacitor c=0.0169278f //x=92.355 //y=5.205
c93 ( 46 0 ) capacitor c=0.0166762f //x=91.475 //y=5.205
c94 ( 45 0 ) capacitor c=0.00115294f //x=95.4 //y=7.09
c95 ( 35 0 ) capacitor c=0.0132983f //x=96.195 //y=7.09
c96 ( 28 0 ) capacitor c=0.00388794f //x=94.605 //y=7.09
c97 ( 27 0 ) capacitor c=0.00985708f //x=95.315 //y=7.09
c98 ( 21 0 ) capacitor c=0.0442221f //x=94.52 //y=5.39
c99 ( 15 0 ) capacitor c=0.0105083f //x=92.5 //y=5.475
c100 ( 14 0 ) capacitor c=0.00227812f //x=91.705 //y=5.39
c101 ( 13 0 ) capacitor c=0.0174384f //x=92.415 //y=5.39
c102 ( 2 0 ) capacitor c=0.00682032f //x=92.615 //y=5.39
c103 ( 1 0 ) capacitor c=0.0573196f //x=94.405 //y=5.39
r104 (  37 50 ) resistor r=5.81818 //w=0.187 //l=0.085 //layer=li \
 //thickness=0.1 //x=96.28 //y=7.005 //x2=96.28 //y2=6.92
r105 (  36 45 ) resistor r=5.4201 //w=0.17 //l=0.085 //layer=li \
 //thickness=0.1 //x=95.485 //y=7.09 //x2=95.4 //y2=7.09
r106 (  35 37 ) resistor r=7.15173 //w=0.17 //l=0.120208 //layer=li \
 //thickness=0.1 //x=96.195 //y=7.09 //x2=96.28 //y2=7.005
r107 (  35 36 ) resistor r=48.5989 //w=0.187 //l=0.71 //layer=li \
 //thickness=0.1 //x=96.195 //y=7.09 //x2=95.485 //y2=7.09
r108 (  29 45 ) resistor r=1.40859 //w=0.34 //l=0.085 //layer=li \
 //thickness=0.1 //x=95.4 //y=7.005 //x2=95.4 //y2=7.09
r109 (  29 49 ) resistor r=5.81818 //w=0.187 //l=0.085 //layer=li \
 //thickness=0.1 //x=95.4 //y=7.005 //x2=95.4 //y2=6.92
r110 (  27 45 ) resistor r=5.4201 //w=0.17 //l=0.085 //layer=li \
 //thickness=0.1 //x=95.315 //y=7.09 //x2=95.4 //y2=7.09
r111 (  27 28 ) resistor r=48.5989 //w=0.187 //l=0.71 //layer=li \
 //thickness=0.1 //x=95.315 //y=7.09 //x2=94.605 //y2=7.09
r112 (  21 48 ) resistor r=58.1818 //w=0.187 //l=0.85 //layer=li \
 //thickness=0.1 //x=94.52 //y=5.39 //x2=94.52 //y2=6.24
r113 (  19 28 ) resistor r=7.15173 //w=0.17 //l=0.120208 //layer=li \
 //thickness=0.1 //x=94.52 //y=7.005 //x2=94.605 //y2=7.09
r114 (  19 48 ) resistor r=5.81818 //w=0.187 //l=0.085 //layer=li \
 //thickness=0.1 //x=94.52 //y=7.005 //x2=94.52 //y2=6.92
r115 (  15 44 ) resistor r=3.57586 //w=0.17 //l=0.125 //layer=li \
 //thickness=0.1 //x=92.5 //y=5.475 //x2=92.5 //y2=5.35
r116 (  15 47 ) resistor r=52.3636 //w=0.187 //l=0.765 //layer=li \
 //thickness=0.1 //x=92.5 //y=5.475 //x2=92.5 //y2=6.24
r117 (  13 44 ) resistor r=3.57586 //w=0.17 //l=0.103078 //layer=li \
 //thickness=0.1 //x=92.415 //y=5.39 //x2=92.5 //y2=5.35
r118 (  13 14 ) resistor r=48.5989 //w=0.187 //l=0.71 //layer=li \
 //thickness=0.1 //x=92.415 //y=5.39 //x2=91.705 //y2=5.39
r119 (  7 14 ) resistor r=7.15173 //w=0.17 //l=0.120208 //layer=li \
 //thickness=0.1 //x=91.62 //y=5.475 //x2=91.705 //y2=5.39
r120 (  7 46 ) resistor r=29.0909 //w=0.187 //l=0.425 //layer=li \
 //thickness=0.1 //x=91.62 //y=5.475 //x2=91.62 //y2=5.9
r121 (  6 21 ) resistor r=9.3 //w=0.17 //l=0.17 //layer=mcon //count=1 \
 //x=94.52 //y=5.39 //x2=94.52 //y2=5.39
r122 (  4 44 ) resistor r=9.3 //w=0.17 //l=0.17 //layer=mcon //count=1 \
 //x=92.5 //y=5.39 //x2=92.5 //y2=5.39
r123 (  2 4 ) resistor r=0.0717383 //w=0.224 //l=0.115 //layer=m1 \
 //thickness=0.36 //x=92.615 //y=5.39 //x2=92.5 //y2=5.39
r124 (  1 6 ) resistor r=0.0717383 //w=0.224 //l=0.115 //layer=m1 \
 //thickness=0.36 //x=94.405 //y=5.39 //x2=94.52 //y2=5.39
r125 (  1 2 ) resistor r=1.70802 //w=0.131 //l=1.79 //layer=m1 \
 //thickness=0.36 //x=94.405 //y=5.39 //x2=92.615 //y2=5.39
ends PM_TMRDFFSNRNQX1\%noxref_26

subckt PM_TMRDFFSNRNQX1\%noxref_27 ( 1 2 3 4 5 6 29 30 43 45 46 50 52 63 64 65 \
 66 67 68 69 70 74 75 76 78 84 85 87 95 96 97 101 102 )
c242 ( 102 0 ) capacitor c=0.0167617f //x=95.695 //y=5.205
c243 ( 101 0 ) capacitor c=0.0164812f //x=94.815 //y=5.205
c244 ( 97 0 ) capacitor c=0.0110092f //x=95.69 //y=1.085
c245 ( 96 0 ) capacitor c=0.0131637f //x=92.36 //y=1.085
c246 ( 95 0 ) capacitor c=0.0131367f //x=89.03 //y=1.085
c247 ( 87 0 ) capacitor c=0.0537799f //x=97.8 //y=2.265
c248 ( 85 0 ) capacitor c=0.0435629f //x=98.44 //y=1.435
c249 ( 84 0 ) capacitor c=0.0200386f //x=98.44 //y=1.09
c250 ( 78 0 ) capacitor c=0.0152946f //x=98.285 //y=1.59
c251 ( 76 0 ) capacitor c=0.0157804f //x=98.285 //y=0.935
c252 ( 75 0 ) capacitor c=0.05065f //x=98.03 //y=4.97
c253 ( 74 0 ) capacitor c=0.0322983f //x=98.32 //y=4.97
c254 ( 70 0 ) capacitor c=0.0290017f //x=97.91 //y=2.1
c255 ( 69 0 ) capacitor c=0.0250027f //x=97.91 //y=1.745
c256 ( 68 0 ) capacitor c=0.0234316f //x=97.91 //y=1.435
c257 ( 67 0 ) capacitor c=0.0200596f //x=97.91 //y=1.09
c258 ( 66 0 ) capacitor c=0.154218f //x=98.395 //y=6.2
c259 ( 65 0 ) capacitor c=0.154243f //x=97.955 //y=6.2
c260 ( 63 0 ) capacitor c=0.00421476f //x=95.84 //y=5.39
c261 ( 52 0 ) capacitor c=0.0944201f //x=97.8 //y=2.265
c262 ( 50 0 ) capacitor c=0.113028f //x=96.32 //y=4.25
c263 ( 46 0 ) capacitor c=0.00775877f //x=95.965 //y=1.825
c264 ( 45 0 ) capacitor c=0.0161066f //x=96.235 //y=1.825
c265 ( 43 0 ) capacitor c=0.0151634f //x=96.235 //y=5.39
c266 ( 30 0 ) capacitor c=0.0029383f //x=95.045 //y=5.39
c267 ( 29 0 ) capacitor c=0.0155464f //x=95.755 //y=5.39
c268 ( 6 0 ) capacitor c=0.00875763f //x=96.435 //y=4.25
c269 ( 5 0 ) capacitor c=0.0716061f //x=97.685 //y=4.25
c270 ( 4 0 ) capacitor c=0.00436966f //x=92.665 //y=1.36
c271 ( 3 0 ) capacitor c=0.069473f //x=95.765 //y=1.36
c272 ( 2 0 ) capacitor c=0.0141674f //x=89.335 //y=1.36
c273 ( 1 0 ) capacitor c=0.0494873f //x=92.435 //y=1.36
r274 (  87 88 ) resistor r=17.5563 //w=0.302 //l=0.11 //layer=ply \
 //thickness=0.18 //x=97.8 //y=2.265 //x2=97.91 //y2=2.265
r275 (  85 94 ) resistor r=45.1352 //w=0.168 //l=0.173853 //layer=ply \
 //thickness=0.18 //x=98.44 //y=1.435 //x2=98.4 //y2=1.59
r276 (  84 93 ) resistor r=45.1352 //w=0.168 //l=0.173853 //layer=ply \
 //thickness=0.18 //x=98.44 //y=1.09 //x2=98.4 //y2=0.935
r277 (  84 85 ) resistor r=176.904 //w=0.094 //l=0.345 //layer=ply \
 //thickness=0.18 //x=98.44 //y=1.09 //x2=98.44 //y2=1.435
r278 (  79 92 ) resistor r=10.701 //w=0.21 //l=0.115 //layer=ply \
 //thickness=0.18 //x=98.065 //y=1.59 //x2=97.95 //y2=1.59
r279 (  78 94 ) resistor r=5.52526 //w=0.168 //l=0.115 //layer=ply \
 //thickness=0.18 //x=98.285 //y=1.59 //x2=98.4 //y2=1.59
r280 (  77 91 ) resistor r=5.52526 //w=0.168 //l=0.115 //layer=ply \
 //thickness=0.18 //x=98.065 //y=0.935 //x2=97.95 //y2=0.935
r281 (  76 93 ) resistor r=5.52526 //w=0.168 //l=0.115 //layer=ply \
 //thickness=0.18 //x=98.285 //y=0.935 //x2=98.4 //y2=0.935
r282 (  76 77 ) resistor r=112.809 //w=0.094 //l=0.22 //layer=ply \
 //thickness=0.18 //x=98.285 //y=0.935 //x2=98.065 //y2=0.935
r283 (  74 81 ) resistor r=26.9307 //w=0.15 //l=0.106066 //layer=ply \
 //thickness=0.18 //x=98.32 //y=4.97 //x2=98.395 //y2=5.045
r284 (  74 75 ) resistor r=148.702 //w=0.094 //l=0.29 //layer=ply \
 //thickness=0.18 //x=98.32 //y=4.97 //x2=98.03 //y2=4.97
r285 (  71 75 ) resistor r=23.403 //w=0.284 //l=0.106066 //layer=ply \
 //thickness=0.18 //x=97.955 //y=5.045 //x2=98.03 //y2=4.97
r286 (  71 90 ) resistor r=26.3063 //w=0.284 //l=0.229783 //layer=ply \
 //thickness=0.18 //x=97.955 //y=5.045 //x2=97.8 //y2=4.88
r287 (  70 88 ) resistor r=19.1248 //w=0.302 //l=0.165 //layer=ply \
 //thickness=0.18 //x=97.91 //y=2.1 //x2=97.91 //y2=2.265
r288 (  69 92 ) resistor r=39.5823 //w=0.21 //l=0.173853 //layer=ply \
 //thickness=0.18 //x=97.91 //y=1.745 //x2=97.95 //y2=1.59
r289 (  69 70 ) resistor r=182.032 //w=0.094 //l=0.355 //layer=ply \
 //thickness=0.18 //x=97.91 //y=1.745 //x2=97.91 //y2=2.1
r290 (  68 92 ) resistor r=39.5823 //w=0.21 //l=0.173853 //layer=ply \
 //thickness=0.18 //x=97.91 //y=1.435 //x2=97.95 //y2=1.59
r291 (  67 91 ) resistor r=45.1352 //w=0.168 //l=0.173853 //layer=ply \
 //thickness=0.18 //x=97.91 //y=1.09 //x2=97.95 //y2=0.935
r292 (  67 68 ) resistor r=176.904 //w=0.094 //l=0.345 //layer=ply \
 //thickness=0.18 //x=97.91 //y=1.09 //x2=97.91 //y2=1.435
r293 (  66 81 ) resistor r=592.245 //w=0.094 //l=1.155 //layer=ply \
 //thickness=0.18 //x=98.395 //y=6.2 //x2=98.395 //y2=5.045
r294 (  65 71 ) resistor r=592.245 //w=0.094 //l=1.155 //layer=ply \
 //thickness=0.18 //x=97.955 //y=6.2 //x2=97.955 //y2=5.045
r295 (  64 78 ) resistor r=56.4043 //w=0.094 //l=0.11 //layer=ply \
 //thickness=0.18 //x=98.175 //y=1.59 //x2=98.285 //y2=1.59
r296 (  64 79 ) resistor r=56.4043 //w=0.094 //l=0.11 //layer=ply \
 //thickness=0.18 //x=98.175 //y=1.59 //x2=98.065 //y2=1.59
r297 (  62 95 ) resistor r=13.3953 //w=0.172 //l=0.18 //layer=li \
 //thickness=0.1 //x=89.217 //y=1.36 //x2=89.217 //y2=1.18
r298 (  57 90 ) resistor r=152 //w=0.17 //l=0.17 //layer=licon //count=1 \
 //x=97.8 //y=4.88 //x2=97.8 //y2=4.88
r299 (  55 57 ) resistor r=43.123 //w=0.187 //l=0.63 //layer=li \
 //thickness=0.1 //x=97.8 //y=4.25 //x2=97.8 //y2=4.88
r300 (  52 87 ) resistor r=152 //w=0.17 //l=0.17 //layer=licon //count=1 \
 //x=97.8 //y=2.265 //x2=97.8 //y2=2.265
r301 (  52 55 ) resistor r=135.872 //w=0.187 //l=1.985 //layer=li \
 //thickness=0.1 //x=97.8 //y=2.265 //x2=97.8 //y2=4.25
r302 (  48 50 ) resistor r=72.2139 //w=0.187 //l=1.055 //layer=li \
 //thickness=0.1 //x=96.32 //y=5.305 //x2=96.32 //y2=4.25
r303 (  47 50 ) resistor r=160.171 //w=0.187 //l=2.34 //layer=li \
 //thickness=0.1 //x=96.32 //y=1.91 //x2=96.32 //y2=4.25
r304 (  45 47 ) resistor r=7.15173 //w=0.17 //l=0.120208 //layer=li \
 //thickness=0.1 //x=96.235 //y=1.825 //x2=96.32 //y2=1.91
r305 (  45 46 ) resistor r=18.4813 //w=0.187 //l=0.27 //layer=li \
 //thickness=0.1 //x=96.235 //y=1.825 //x2=95.965 //y2=1.825
r306 (  44 63 ) resistor r=5.4201 //w=0.17 //l=0.085 //layer=li \
 //thickness=0.1 //x=95.925 //y=5.39 //x2=95.84 //y2=5.39
r307 (  43 48 ) resistor r=7.15173 //w=0.17 //l=0.120208 //layer=li \
 //thickness=0.1 //x=96.235 //y=5.39 //x2=96.32 //y2=5.305
r308 (  43 44 ) resistor r=21.2193 //w=0.187 //l=0.31 //layer=li \
 //thickness=0.1 //x=96.235 //y=5.39 //x2=95.925 //y2=5.39
r309 (  42 97 ) resistor r=12.3209 //w=0.187 //l=0.18 //layer=li \
 //thickness=0.1 //x=95.88 //y=1.36 //x2=95.88 //y2=1.18
r310 (  37 46 ) resistor r=7.15173 //w=0.17 //l=0.120208 //layer=li \
 //thickness=0.1 //x=95.88 //y=1.74 //x2=95.965 //y2=1.825
r311 (  37 42 ) resistor r=26.0107 //w=0.187 //l=0.38 //layer=li \
 //thickness=0.1 //x=95.88 //y=1.74 //x2=95.88 //y2=1.36
r312 (  31 63 ) resistor r=1.40859 //w=0.34 //l=0.085 //layer=li \
 //thickness=0.1 //x=95.84 //y=5.475 //x2=95.84 //y2=5.39
r313 (  31 102 ) resistor r=29.0909 //w=0.187 //l=0.425 //layer=li \
 //thickness=0.1 //x=95.84 //y=5.475 //x2=95.84 //y2=5.9
r314 (  29 63 ) resistor r=5.4201 //w=0.17 //l=0.085 //layer=li \
 //thickness=0.1 //x=95.755 //y=5.39 //x2=95.84 //y2=5.39
r315 (  29 30 ) resistor r=48.5989 //w=0.187 //l=0.71 //layer=li \
 //thickness=0.1 //x=95.755 //y=5.39 //x2=95.045 //y2=5.39
r316 (  23 30 ) resistor r=7.15173 //w=0.17 //l=0.120208 //layer=li \
 //thickness=0.1 //x=94.96 //y=5.475 //x2=95.045 //y2=5.39
r317 (  23 101 ) resistor r=29.0909 //w=0.187 //l=0.425 //layer=li \
 //thickness=0.1 //x=94.96 //y=5.475 //x2=94.96 //y2=5.9
r318 (  21 96 ) resistor r=12.3209 //w=0.187 //l=0.18 //layer=li \
 //thickness=0.1 //x=92.55 //y=1.36 //x2=92.55 //y2=1.18
r319 (  16 55 ) resistor r=9.3 //w=0.17 //l=0.17 //layer=mcon //count=1 \
 //x=97.8 //y=4.25 //x2=97.8 //y2=4.25
r320 (  14 50 ) resistor r=9.3 //w=0.17 //l=0.17 //layer=mcon //count=1 \
 //x=96.32 //y=4.25 //x2=96.32 //y2=4.25
r321 (  12 42 ) resistor r=9.3 //w=0.17 //l=0.17 //layer=mcon //count=1 \
 //x=95.88 //y=1.36 //x2=95.88 //y2=1.36
r322 (  10 21 ) resistor r=9.3 //w=0.17 //l=0.17 //layer=mcon //count=1 \
 //x=92.55 //y=1.36 //x2=92.55 //y2=1.36
r323 (  8 62 ) resistor r=9.3 //w=0.17 //l=0.17 //layer=mcon //count=1 \
 //x=89.22 //y=1.36 //x2=89.22 //y2=1.36
r324 (  6 14 ) resistor r=0.0717383 //w=0.224 //l=0.115 //layer=m1 \
 //thickness=0.36 //x=96.435 //y=4.25 //x2=96.32 //y2=4.25
r325 (  5 16 ) resistor r=0.0717383 //w=0.224 //l=0.115 //layer=m1 \
 //thickness=0.36 //x=97.685 //y=4.25 //x2=97.8 //y2=4.25
r326 (  5 6 ) resistor r=1.19275 //w=0.131 //l=1.25 //layer=m1 \
 //thickness=0.36 //x=97.685 //y=4.25 //x2=96.435 //y2=4.25
r327 (  4 10 ) resistor r=0.0880901 //w=0.191 //l=0.115 //layer=m1 \
 //thickness=0.36 //x=92.665 //y=1.36 //x2=92.55 //y2=1.36
r328 (  3 12 ) resistor r=0.0717383 //w=0.224 //l=0.115 //layer=m1 \
 //thickness=0.36 //x=95.765 //y=1.36 //x2=95.88 //y2=1.36
r329 (  3 4 ) resistor r=2.95802 //w=0.131 //l=3.1 //layer=m1 //thickness=0.36 \
 //x=95.765 //y=1.36 //x2=92.665 //y2=1.36
r330 (  2 8 ) resistor r=0.0717383 //w=0.224 //l=0.115 //layer=m1 \
 //thickness=0.36 //x=89.335 //y=1.36 //x2=89.22 //y2=1.36
r331 (  1 10 ) resistor r=0.0880901 //w=0.191 //l=0.115 //layer=m1 \
 //thickness=0.36 //x=92.435 //y=1.36 //x2=92.55 //y2=1.36
r332 (  1 2 ) resistor r=2.95802 //w=0.131 //l=3.1 //layer=m1 //thickness=0.36 \
 //x=92.435 //y=1.36 //x2=89.335 //y2=1.36
ends PM_TMRDFFSNRNQX1\%noxref_27

subckt PM_TMRDFFSNRNQX1\%Q ( 1 14 15 16 17 21 22 24 )
c52 ( 24 0 ) capacitor c=0.028734f //x=98.03 //y=5.2
c53 ( 22 0 ) capacitor c=0.0172744f //x=97.985 //y=1.09
c54 ( 21 0 ) capacitor c=0.102881f //x=98.54 //y=4.25
c55 ( 17 0 ) capacitor c=0.00575887f //x=98.26 //y=4.76
c56 ( 16 0 ) capacitor c=0.0131256f //x=98.455 //y=4.76
c57 ( 15 0 ) capacitor c=0.00636159f //x=98.255 //y=2.26
c58 ( 14 0 ) capacitor c=0.0140466f //x=98.455 //y=2.26
c59 ( 1 0 ) capacitor c=0.0237773f //x=98.54 //y=4.25
r60 (  19 21 ) resistor r=29.0909 //w=0.187 //l=0.425 //layer=li \
 //thickness=0.1 //x=98.54 //y=4.675 //x2=98.54 //y2=4.25
r61 (  18 21 ) resistor r=130.396 //w=0.187 //l=1.905 //layer=li \
 //thickness=0.1 //x=98.54 //y=2.345 //x2=98.54 //y2=4.25
r62 (  16 19 ) resistor r=7.15173 //w=0.17 //l=0.120208 //layer=li \
 //thickness=0.1 //x=98.455 //y=4.76 //x2=98.54 //y2=4.675
r63 (  16 17 ) resistor r=13.3476 //w=0.187 //l=0.195 //layer=li \
 //thickness=0.1 //x=98.455 //y=4.76 //x2=98.26 //y2=4.76
r64 (  14 18 ) resistor r=7.15173 //w=0.17 //l=0.120208 //layer=li \
 //thickness=0.1 //x=98.455 //y=2.26 //x2=98.54 //y2=2.345
r65 (  14 15 ) resistor r=13.6898 //w=0.187 //l=0.2 //layer=li //thickness=0.1 \
 //x=98.455 //y=2.26 //x2=98.255 //y2=2.26
r66 (  8 17 ) resistor r=7.15173 //w=0.17 //l=0.120208 //layer=li \
 //thickness=0.1 //x=98.175 //y=4.845 //x2=98.26 //y2=4.76
r67 (  8 24 ) resistor r=72.5562 //w=0.187 //l=1.06 //layer=li //thickness=0.1 \
 //x=98.175 //y=4.845 //x2=98.175 //y2=5.905
r68 (  4 15 ) resistor r=7.15173 //w=0.17 //l=0.120208 //layer=li \
 //thickness=0.1 //x=98.17 //y=2.175 //x2=98.255 //y2=2.26
r69 (  4 22 ) resistor r=67.7647 //w=0.187 //l=0.99 //layer=li //thickness=0.1 \
 //x=98.17 //y=2.175 //x2=98.17 //y2=1.185
r70 (  1 21 ) resistor r=9.3 //w=0.17 //l=0.17 //layer=mcon //count=1 \
 //x=98.54 //y=4.25 //x2=98.54 //y2=4.25
ends PM_TMRDFFSNRNQX1\%Q

subckt PM_TMRDFFSNRNQX1\%noxref_29 ( 1 5 9 13 17 35 )
c49 ( 35 0 ) capacitor c=0.0687824f //x=0.945 //y=0.555
c50 ( 17 0 ) capacitor c=0.0213512f //x=2.935 //y=1.77
c51 ( 13 0 ) capacitor c=0.015523f //x=2.935 //y=0.72
c52 ( 9 0 ) capacitor c=0.00678203f //x=2.05 //y=0.805
c53 ( 5 0 ) capacitor c=0.0204181f //x=1.965 //y=1.77
c54 ( 1 0 ) capacitor c=0.0109947f //x=1.08 //y=1.685
r55 (  18 35 ) resistor r=5.4201 //w=0.17 //l=0.103078 //layer=li \
 //thickness=0.1 //x=2.135 //y=1.77 //x2=2.05 //y2=1.81
r56 (  18 35 ) resistor r=27.3797 //w=0.187 //l=0.4 //layer=li //thickness=0.1 \
 //x=2.135 //y=1.77 //x2=2.535 //y2=1.77
r57 (  17 35 ) resistor r=0.751729 //w=0.17 //l=0.085 //layer=li \
 //thickness=0.1 //x=2.935 //y=1.77 //x2=3.02 //y2=1.77
r58 (  17 35 ) resistor r=27.3797 //w=0.187 //l=0.4 //layer=li //thickness=0.1 \
 //x=2.935 //y=1.77 //x2=2.535 //y2=1.77
r59 (  14 35 ) resistor r=3.57586 //w=0.17 //l=0.103078 //layer=li \
 //thickness=0.1 //x=2.135 //y=0.72 //x2=2.05 //y2=0.68
r60 (  14 35 ) resistor r=27.3797 //w=0.187 //l=0.4 //layer=li //thickness=0.1 \
 //x=2.135 //y=0.72 //x2=2.535 //y2=0.72
r61 (  13 35 ) resistor r=0.751729 //w=0.17 //l=0.085 //layer=li \
 //thickness=0.1 //x=2.935 //y=0.72 //x2=3.02 //y2=0.72
r62 (  13 35 ) resistor r=27.3797 //w=0.187 //l=0.4 //layer=li //thickness=0.1 \
 //x=2.935 //y=0.72 //x2=2.535 //y2=0.72
r63 (  10 35 ) resistor r=1.40859 //w=0.34 //l=0.125 //layer=li \
 //thickness=0.1 //x=2.05 //y=1.685 //x2=2.05 //y2=1.81
r64 (  10 35 ) resistor r=42.0963 //w=0.187 //l=0.615 //layer=li \
 //thickness=0.1 //x=2.05 //y=1.685 //x2=2.05 //y2=1.07
r65 (  9 35 ) resistor r=3.57586 //w=0.17 //l=0.125 //layer=li //thickness=0.1 \
 //x=2.05 //y=0.805 //x2=2.05 //y2=0.68
r66 (  9 35 ) resistor r=18.139 //w=0.187 //l=0.265 //layer=li //thickness=0.1 \
 //x=2.05 //y=0.805 //x2=2.05 //y2=1.07
r67 (  6 35 ) resistor r=3.57586 //w=0.17 //l=0.103078 //layer=li \
 //thickness=0.1 //x=1.165 //y=1.77 //x2=1.08 //y2=1.81
r68 (  6 35 ) resistor r=27.3797 //w=0.187 //l=0.4 //layer=li //thickness=0.1 \
 //x=1.165 //y=1.77 //x2=1.565 //y2=1.77
r69 (  5 35 ) resistor r=5.4201 //w=0.17 //l=0.103078 //layer=li \
 //thickness=0.1 //x=1.965 //y=1.77 //x2=2.05 //y2=1.81
r70 (  5 35 ) resistor r=27.3797 //w=0.187 //l=0.4 //layer=li //thickness=0.1 \
 //x=1.965 //y=1.77 //x2=1.565 //y2=1.77
r71 (  1 35 ) resistor r=3.57586 //w=0.17 //l=0.125 //layer=li //thickness=0.1 \
 //x=1.08 //y=1.685 //x2=1.08 //y2=1.81
r72 (  1 35 ) resistor r=42.0963 //w=0.187 //l=0.615 //layer=li \
 //thickness=0.1 //x=1.08 //y=1.685 //x2=1.08 //y2=1.07
ends PM_TMRDFFSNRNQX1\%noxref_29

subckt PM_TMRDFFSNRNQX1\%noxref_30 ( 1 3 11 15 25 28 29 )
c52 ( 29 0 ) capacitor c=0.0414744f //x=3.455 //y=0.555
c53 ( 28 0 ) capacitor c=0.00462395f //x=2.35 //y=1.09
c54 ( 25 0 ) capacitor c=0.00156479f //x=3.59 //y=1.175
c55 ( 15 0 ) capacitor c=0.00737666f //x=4.56 //y=0.805
c56 ( 11 0 ) capacitor c=0.0144274f //x=4.475 //y=0.72
c57 ( 3 0 ) capacitor c=0.00718386f //x=3.59 //y=0.805
c58 ( 1 0 ) capacitor c=0.0218873f //x=3.505 //y=1.175
r59 (  15 29 ) resistor r=3.57586 //w=0.17 //l=0.125 //layer=li \
 //thickness=0.1 //x=4.56 //y=0.805 //x2=4.56 //y2=0.68
r60 (  15 29 ) resistor r=18.139 //w=0.187 //l=0.265 //layer=li \
 //thickness=0.1 //x=4.56 //y=0.805 //x2=4.56 //y2=1.07
r61 (  12 29 ) resistor r=3.57586 //w=0.17 //l=0.103078 //layer=li \
 //thickness=0.1 //x=3.675 //y=0.72 //x2=3.59 //y2=0.68
r62 (  12 29 ) resistor r=27.3797 //w=0.187 //l=0.4 //layer=li //thickness=0.1 \
 //x=3.675 //y=0.72 //x2=4.075 //y2=0.72
r63 (  11 29 ) resistor r=3.57586 //w=0.17 //l=0.103078 //layer=li \
 //thickness=0.1 //x=4.475 //y=0.72 //x2=4.56 //y2=0.68
r64 (  11 29 ) resistor r=27.3797 //w=0.187 //l=0.4 //layer=li //thickness=0.1 \
 //x=4.475 //y=0.72 //x2=4.075 //y2=0.72
r65 (  7 25 ) resistor r=5.4201 //w=0.17 //l=0.085 //layer=li //thickness=0.1 \
 //x=3.59 //y=1.26 //x2=3.59 //y2=1.175
r66 (  7 29 ) resistor r=10.2674 //w=0.187 //l=0.15 //layer=li //thickness=0.1 \
 //x=3.59 //y=1.26 //x2=3.59 //y2=1.41
r67 (  4 25 ) resistor r=5.4201 //w=0.17 //l=0.085 //layer=li //thickness=0.1 \
 //x=3.59 //y=1.09 //x2=3.59 //y2=1.175
r68 (  4 29 ) resistor r=1.36898 //w=0.187 //l=0.02 //layer=li //thickness=0.1 \
 //x=3.59 //y=1.09 //x2=3.59 //y2=1.07
r69 (  3 29 ) resistor r=3.57586 //w=0.17 //l=0.125 //layer=li //thickness=0.1 \
 //x=3.59 //y=0.805 //x2=3.59 //y2=0.68
r70 (  3 29 ) resistor r=18.139 //w=0.187 //l=0.265 //layer=li //thickness=0.1 \
 //x=3.59 //y=0.805 //x2=3.59 //y2=1.07
r71 (  2 28 ) resistor r=0.751729 //w=0.17 //l=0.085 //layer=li \
 //thickness=0.1 //x=2.625 //y=1.175 //x2=2.54 //y2=1.175
r72 (  1 25 ) resistor r=1.40859 //w=0.34 //l=0.085 //layer=li //thickness=0.1 \
 //x=3.505 //y=1.175 //x2=3.59 //y2=1.175
r73 (  1 2 ) resistor r=60.2353 //w=0.187 //l=0.88 //layer=li //thickness=0.1 \
 //x=3.505 //y=1.175 //x2=2.625 //y2=1.175
ends PM_TMRDFFSNRNQX1\%noxref_30

subckt PM_TMRDFFSNRNQX1\%noxref_31 ( 1 5 9 13 17 35 )
c49 ( 35 0 ) capacitor c=0.0673029f //x=5.755 //y=0.555
c50 ( 17 0 ) capacitor c=0.0178317f //x=7.745 //y=1.77
c51 ( 13 0 ) capacitor c=0.0154936f //x=7.745 //y=0.72
c52 ( 9 0 ) capacitor c=0.00678203f //x=6.86 //y=0.805
c53 ( 5 0 ) capacitor c=0.0164013f //x=6.775 //y=1.77
c54 ( 1 0 ) capacitor c=0.00696517f //x=5.89 //y=1.685
r55 (  18 35 ) resistor r=5.4201 //w=0.17 //l=0.103078 //layer=li \
 //thickness=0.1 //x=6.945 //y=1.77 //x2=6.86 //y2=1.81
r56 (  18 35 ) resistor r=27.3797 //w=0.187 //l=0.4 //layer=li //thickness=0.1 \
 //x=6.945 //y=1.77 //x2=7.345 //y2=1.77
r57 (  17 35 ) resistor r=0.751729 //w=0.17 //l=0.085 //layer=li \
 //thickness=0.1 //x=7.745 //y=1.77 //x2=7.83 //y2=1.77
r58 (  17 35 ) resistor r=27.3797 //w=0.187 //l=0.4 //layer=li //thickness=0.1 \
 //x=7.745 //y=1.77 //x2=7.345 //y2=1.77
r59 (  14 35 ) resistor r=3.57586 //w=0.17 //l=0.103078 //layer=li \
 //thickness=0.1 //x=6.945 //y=0.72 //x2=6.86 //y2=0.68
r60 (  14 35 ) resistor r=27.3797 //w=0.187 //l=0.4 //layer=li //thickness=0.1 \
 //x=6.945 //y=0.72 //x2=7.345 //y2=0.72
r61 (  13 35 ) resistor r=0.751729 //w=0.17 //l=0.085 //layer=li \
 //thickness=0.1 //x=7.745 //y=0.72 //x2=7.83 //y2=0.72
r62 (  13 35 ) resistor r=27.3797 //w=0.187 //l=0.4 //layer=li //thickness=0.1 \
 //x=7.745 //y=0.72 //x2=7.345 //y2=0.72
r63 (  10 35 ) resistor r=1.40859 //w=0.34 //l=0.125 //layer=li \
 //thickness=0.1 //x=6.86 //y=1.685 //x2=6.86 //y2=1.81
r64 (  10 35 ) resistor r=42.0963 //w=0.187 //l=0.615 //layer=li \
 //thickness=0.1 //x=6.86 //y=1.685 //x2=6.86 //y2=1.07
r65 (  9 35 ) resistor r=3.57586 //w=0.17 //l=0.125 //layer=li //thickness=0.1 \
 //x=6.86 //y=0.805 //x2=6.86 //y2=0.68
r66 (  9 35 ) resistor r=18.139 //w=0.187 //l=0.265 //layer=li //thickness=0.1 \
 //x=6.86 //y=0.805 //x2=6.86 //y2=1.07
r67 (  6 35 ) resistor r=3.57586 //w=0.17 //l=0.103078 //layer=li \
 //thickness=0.1 //x=5.975 //y=1.77 //x2=5.89 //y2=1.81
r68 (  6 35 ) resistor r=27.3797 //w=0.187 //l=0.4 //layer=li //thickness=0.1 \
 //x=5.975 //y=1.77 //x2=6.375 //y2=1.77
r69 (  5 35 ) resistor r=5.4201 //w=0.17 //l=0.103078 //layer=li \
 //thickness=0.1 //x=6.775 //y=1.77 //x2=6.86 //y2=1.81
r70 (  5 35 ) resistor r=27.3797 //w=0.187 //l=0.4 //layer=li //thickness=0.1 \
 //x=6.775 //y=1.77 //x2=6.375 //y2=1.77
r71 (  1 35 ) resistor r=3.57586 //w=0.17 //l=0.125 //layer=li //thickness=0.1 \
 //x=5.89 //y=1.685 //x2=5.89 //y2=1.81
r72 (  1 35 ) resistor r=42.0963 //w=0.187 //l=0.615 //layer=li \
 //thickness=0.1 //x=5.89 //y=1.685 //x2=5.89 //y2=1.07
ends PM_TMRDFFSNRNQX1\%noxref_31

subckt PM_TMRDFFSNRNQX1\%noxref_32 ( 1 3 11 15 25 28 29 )
c52 ( 29 0 ) capacitor c=0.0413887f //x=8.265 //y=0.555
c53 ( 28 0 ) capacitor c=0.0045748f //x=7.16 //y=1.09
c54 ( 25 0 ) capacitor c=0.00156479f //x=8.4 //y=1.175
c55 ( 15 0 ) capacitor c=0.00737666f //x=9.37 //y=0.805
c56 ( 11 0 ) capacitor c=0.0144274f //x=9.285 //y=0.72
c57 ( 3 0 ) capacitor c=0.00718386f //x=8.4 //y=0.805
c58 ( 1 0 ) capacitor c=0.0218888f //x=8.315 //y=1.175
r59 (  15 29 ) resistor r=3.57586 //w=0.17 //l=0.125 //layer=li \
 //thickness=0.1 //x=9.37 //y=0.805 //x2=9.37 //y2=0.68
r60 (  15 29 ) resistor r=18.139 //w=0.187 //l=0.265 //layer=li \
 //thickness=0.1 //x=9.37 //y=0.805 //x2=9.37 //y2=1.07
r61 (  12 29 ) resistor r=3.57586 //w=0.17 //l=0.103078 //layer=li \
 //thickness=0.1 //x=8.485 //y=0.72 //x2=8.4 //y2=0.68
r62 (  12 29 ) resistor r=27.3797 //w=0.187 //l=0.4 //layer=li //thickness=0.1 \
 //x=8.485 //y=0.72 //x2=8.885 //y2=0.72
r63 (  11 29 ) resistor r=3.57586 //w=0.17 //l=0.103078 //layer=li \
 //thickness=0.1 //x=9.285 //y=0.72 //x2=9.37 //y2=0.68
r64 (  11 29 ) resistor r=27.3797 //w=0.187 //l=0.4 //layer=li //thickness=0.1 \
 //x=9.285 //y=0.72 //x2=8.885 //y2=0.72
r65 (  7 25 ) resistor r=5.4201 //w=0.17 //l=0.085 //layer=li //thickness=0.1 \
 //x=8.4 //y=1.26 //x2=8.4 //y2=1.175
r66 (  7 29 ) resistor r=10.2674 //w=0.187 //l=0.15 //layer=li //thickness=0.1 \
 //x=8.4 //y=1.26 //x2=8.4 //y2=1.41
r67 (  4 25 ) resistor r=5.4201 //w=0.17 //l=0.085 //layer=li //thickness=0.1 \
 //x=8.4 //y=1.09 //x2=8.4 //y2=1.175
r68 (  4 29 ) resistor r=1.36898 //w=0.187 //l=0.02 //layer=li //thickness=0.1 \
 //x=8.4 //y=1.09 //x2=8.4 //y2=1.07
r69 (  3 29 ) resistor r=3.57586 //w=0.17 //l=0.125 //layer=li //thickness=0.1 \
 //x=8.4 //y=0.805 //x2=8.4 //y2=0.68
r70 (  3 29 ) resistor r=18.139 //w=0.187 //l=0.265 //layer=li //thickness=0.1 \
 //x=8.4 //y=0.805 //x2=8.4 //y2=1.07
r71 (  2 28 ) resistor r=0.751729 //w=0.17 //l=0.085 //layer=li \
 //thickness=0.1 //x=7.435 //y=1.175 //x2=7.35 //y2=1.175
r72 (  1 25 ) resistor r=1.40859 //w=0.34 //l=0.085 //layer=li //thickness=0.1 \
 //x=8.315 //y=1.175 //x2=8.4 //y2=1.175
r73 (  1 2 ) resistor r=60.2353 //w=0.187 //l=0.88 //layer=li //thickness=0.1 \
 //x=8.315 //y=1.175 //x2=7.435 //y2=1.175
ends PM_TMRDFFSNRNQX1\%noxref_32

subckt PM_TMRDFFSNRNQX1\%noxref_33 ( 1 5 9 13 17 35 )
c49 ( 35 0 ) capacitor c=0.0673029f //x=10.565 //y=0.555
c50 ( 17 0 ) capacitor c=0.0178317f //x=12.555 //y=1.77
c51 ( 13 0 ) capacitor c=0.0154936f //x=12.555 //y=0.72
c52 ( 9 0 ) capacitor c=0.00678203f //x=11.67 //y=0.805
c53 ( 5 0 ) capacitor c=0.0164013f //x=11.585 //y=1.77
c54 ( 1 0 ) capacitor c=0.00696517f //x=10.7 //y=1.685
r55 (  18 35 ) resistor r=5.4201 //w=0.17 //l=0.103078 //layer=li \
 //thickness=0.1 //x=11.755 //y=1.77 //x2=11.67 //y2=1.81
r56 (  18 35 ) resistor r=27.3797 //w=0.187 //l=0.4 //layer=li //thickness=0.1 \
 //x=11.755 //y=1.77 //x2=12.155 //y2=1.77
r57 (  17 35 ) resistor r=0.751729 //w=0.17 //l=0.085 //layer=li \
 //thickness=0.1 //x=12.555 //y=1.77 //x2=12.64 //y2=1.77
r58 (  17 35 ) resistor r=27.3797 //w=0.187 //l=0.4 //layer=li //thickness=0.1 \
 //x=12.555 //y=1.77 //x2=12.155 //y2=1.77
r59 (  14 35 ) resistor r=3.57586 //w=0.17 //l=0.103078 //layer=li \
 //thickness=0.1 //x=11.755 //y=0.72 //x2=11.67 //y2=0.68
r60 (  14 35 ) resistor r=27.3797 //w=0.187 //l=0.4 //layer=li //thickness=0.1 \
 //x=11.755 //y=0.72 //x2=12.155 //y2=0.72
r61 (  13 35 ) resistor r=0.751729 //w=0.17 //l=0.085 //layer=li \
 //thickness=0.1 //x=12.555 //y=0.72 //x2=12.64 //y2=0.72
r62 (  13 35 ) resistor r=27.3797 //w=0.187 //l=0.4 //layer=li //thickness=0.1 \
 //x=12.555 //y=0.72 //x2=12.155 //y2=0.72
r63 (  10 35 ) resistor r=1.40859 //w=0.34 //l=0.125 //layer=li \
 //thickness=0.1 //x=11.67 //y=1.685 //x2=11.67 //y2=1.81
r64 (  10 35 ) resistor r=42.0963 //w=0.187 //l=0.615 //layer=li \
 //thickness=0.1 //x=11.67 //y=1.685 //x2=11.67 //y2=1.07
r65 (  9 35 ) resistor r=3.57586 //w=0.17 //l=0.125 //layer=li //thickness=0.1 \
 //x=11.67 //y=0.805 //x2=11.67 //y2=0.68
r66 (  9 35 ) resistor r=18.139 //w=0.187 //l=0.265 //layer=li //thickness=0.1 \
 //x=11.67 //y=0.805 //x2=11.67 //y2=1.07
r67 (  6 35 ) resistor r=3.57586 //w=0.17 //l=0.103078 //layer=li \
 //thickness=0.1 //x=10.785 //y=1.77 //x2=10.7 //y2=1.81
r68 (  6 35 ) resistor r=27.3797 //w=0.187 //l=0.4 //layer=li //thickness=0.1 \
 //x=10.785 //y=1.77 //x2=11.185 //y2=1.77
r69 (  5 35 ) resistor r=5.4201 //w=0.17 //l=0.103078 //layer=li \
 //thickness=0.1 //x=11.585 //y=1.77 //x2=11.67 //y2=1.81
r70 (  5 35 ) resistor r=27.3797 //w=0.187 //l=0.4 //layer=li //thickness=0.1 \
 //x=11.585 //y=1.77 //x2=11.185 //y2=1.77
r71 (  1 35 ) resistor r=3.57586 //w=0.17 //l=0.125 //layer=li //thickness=0.1 \
 //x=10.7 //y=1.685 //x2=10.7 //y2=1.81
r72 (  1 35 ) resistor r=42.0963 //w=0.187 //l=0.615 //layer=li \
 //thickness=0.1 //x=10.7 //y=1.685 //x2=10.7 //y2=1.07
ends PM_TMRDFFSNRNQX1\%noxref_33

subckt PM_TMRDFFSNRNQX1\%noxref_34 ( 1 3 11 15 25 28 29 )
c52 ( 29 0 ) capacitor c=0.0414744f //x=13.075 //y=0.555
c53 ( 28 0 ) capacitor c=0.0045748f //x=11.97 //y=1.09
c54 ( 25 0 ) capacitor c=0.00156479f //x=13.21 //y=1.175
c55 ( 15 0 ) capacitor c=0.00737666f //x=14.18 //y=0.805
c56 ( 11 0 ) capacitor c=0.0144274f //x=14.095 //y=0.72
c57 ( 3 0 ) capacitor c=0.00718386f //x=13.21 //y=0.805
c58 ( 1 0 ) capacitor c=0.0218888f //x=13.125 //y=1.175
r59 (  15 29 ) resistor r=3.57586 //w=0.17 //l=0.125 //layer=li \
 //thickness=0.1 //x=14.18 //y=0.805 //x2=14.18 //y2=0.68
r60 (  15 29 ) resistor r=18.139 //w=0.187 //l=0.265 //layer=li \
 //thickness=0.1 //x=14.18 //y=0.805 //x2=14.18 //y2=1.07
r61 (  12 29 ) resistor r=3.57586 //w=0.17 //l=0.103078 //layer=li \
 //thickness=0.1 //x=13.295 //y=0.72 //x2=13.21 //y2=0.68
r62 (  12 29 ) resistor r=27.3797 //w=0.187 //l=0.4 //layer=li //thickness=0.1 \
 //x=13.295 //y=0.72 //x2=13.695 //y2=0.72
r63 (  11 29 ) resistor r=3.57586 //w=0.17 //l=0.103078 //layer=li \
 //thickness=0.1 //x=14.095 //y=0.72 //x2=14.18 //y2=0.68
r64 (  11 29 ) resistor r=27.3797 //w=0.187 //l=0.4 //layer=li //thickness=0.1 \
 //x=14.095 //y=0.72 //x2=13.695 //y2=0.72
r65 (  7 25 ) resistor r=5.4201 //w=0.17 //l=0.085 //layer=li //thickness=0.1 \
 //x=13.21 //y=1.26 //x2=13.21 //y2=1.175
r66 (  7 29 ) resistor r=10.2674 //w=0.187 //l=0.15 //layer=li //thickness=0.1 \
 //x=13.21 //y=1.26 //x2=13.21 //y2=1.41
r67 (  4 25 ) resistor r=5.4201 //w=0.17 //l=0.085 //layer=li //thickness=0.1 \
 //x=13.21 //y=1.09 //x2=13.21 //y2=1.175
r68 (  4 29 ) resistor r=1.36898 //w=0.187 //l=0.02 //layer=li //thickness=0.1 \
 //x=13.21 //y=1.09 //x2=13.21 //y2=1.07
r69 (  3 29 ) resistor r=3.57586 //w=0.17 //l=0.125 //layer=li //thickness=0.1 \
 //x=13.21 //y=0.805 //x2=13.21 //y2=0.68
r70 (  3 29 ) resistor r=18.139 //w=0.187 //l=0.265 //layer=li //thickness=0.1 \
 //x=13.21 //y=0.805 //x2=13.21 //y2=1.07
r71 (  2 28 ) resistor r=0.751729 //w=0.17 //l=0.085 //layer=li \
 //thickness=0.1 //x=12.245 //y=1.175 //x2=12.16 //y2=1.175
r72 (  1 25 ) resistor r=1.40859 //w=0.34 //l=0.085 //layer=li //thickness=0.1 \
 //x=13.125 //y=1.175 //x2=13.21 //y2=1.175
r73 (  1 2 ) resistor r=60.2353 //w=0.187 //l=0.88 //layer=li //thickness=0.1 \
 //x=13.125 //y=1.175 //x2=12.245 //y2=1.175
ends PM_TMRDFFSNRNQX1\%noxref_34

subckt PM_TMRDFFSNRNQX1\%noxref_35 ( 1 5 9 13 17 35 )
c49 ( 35 0 ) capacitor c=0.0673029f //x=15.375 //y=0.555
c50 ( 17 0 ) capacitor c=0.0178317f //x=17.365 //y=1.77
c51 ( 13 0 ) capacitor c=0.0154936f //x=17.365 //y=0.72
c52 ( 9 0 ) capacitor c=0.00678203f //x=16.48 //y=0.805
c53 ( 5 0 ) capacitor c=0.0164013f //x=16.395 //y=1.77
c54 ( 1 0 ) capacitor c=0.00696517f //x=15.51 //y=1.685
r55 (  18 35 ) resistor r=5.4201 //w=0.17 //l=0.103078 //layer=li \
 //thickness=0.1 //x=16.565 //y=1.77 //x2=16.48 //y2=1.81
r56 (  18 35 ) resistor r=27.3797 //w=0.187 //l=0.4 //layer=li //thickness=0.1 \
 //x=16.565 //y=1.77 //x2=16.965 //y2=1.77
r57 (  17 35 ) resistor r=0.751729 //w=0.17 //l=0.085 //layer=li \
 //thickness=0.1 //x=17.365 //y=1.77 //x2=17.45 //y2=1.77
r58 (  17 35 ) resistor r=27.3797 //w=0.187 //l=0.4 //layer=li //thickness=0.1 \
 //x=17.365 //y=1.77 //x2=16.965 //y2=1.77
r59 (  14 35 ) resistor r=3.57586 //w=0.17 //l=0.103078 //layer=li \
 //thickness=0.1 //x=16.565 //y=0.72 //x2=16.48 //y2=0.68
r60 (  14 35 ) resistor r=27.3797 //w=0.187 //l=0.4 //layer=li //thickness=0.1 \
 //x=16.565 //y=0.72 //x2=16.965 //y2=0.72
r61 (  13 35 ) resistor r=0.751729 //w=0.17 //l=0.085 //layer=li \
 //thickness=0.1 //x=17.365 //y=0.72 //x2=17.45 //y2=0.72
r62 (  13 35 ) resistor r=27.3797 //w=0.187 //l=0.4 //layer=li //thickness=0.1 \
 //x=17.365 //y=0.72 //x2=16.965 //y2=0.72
r63 (  10 35 ) resistor r=1.40859 //w=0.34 //l=0.125 //layer=li \
 //thickness=0.1 //x=16.48 //y=1.685 //x2=16.48 //y2=1.81
r64 (  10 35 ) resistor r=42.0963 //w=0.187 //l=0.615 //layer=li \
 //thickness=0.1 //x=16.48 //y=1.685 //x2=16.48 //y2=1.07
r65 (  9 35 ) resistor r=3.57586 //w=0.17 //l=0.125 //layer=li //thickness=0.1 \
 //x=16.48 //y=0.805 //x2=16.48 //y2=0.68
r66 (  9 35 ) resistor r=18.139 //w=0.187 //l=0.265 //layer=li //thickness=0.1 \
 //x=16.48 //y=0.805 //x2=16.48 //y2=1.07
r67 (  6 35 ) resistor r=3.57586 //w=0.17 //l=0.103078 //layer=li \
 //thickness=0.1 //x=15.595 //y=1.77 //x2=15.51 //y2=1.81
r68 (  6 35 ) resistor r=27.3797 //w=0.187 //l=0.4 //layer=li //thickness=0.1 \
 //x=15.595 //y=1.77 //x2=15.995 //y2=1.77
r69 (  5 35 ) resistor r=5.4201 //w=0.17 //l=0.103078 //layer=li \
 //thickness=0.1 //x=16.395 //y=1.77 //x2=16.48 //y2=1.81
r70 (  5 35 ) resistor r=27.3797 //w=0.187 //l=0.4 //layer=li //thickness=0.1 \
 //x=16.395 //y=1.77 //x2=15.995 //y2=1.77
r71 (  1 35 ) resistor r=3.57586 //w=0.17 //l=0.125 //layer=li //thickness=0.1 \
 //x=15.51 //y=1.685 //x2=15.51 //y2=1.81
r72 (  1 35 ) resistor r=42.0963 //w=0.187 //l=0.615 //layer=li \
 //thickness=0.1 //x=15.51 //y=1.685 //x2=15.51 //y2=1.07
ends PM_TMRDFFSNRNQX1\%noxref_35

subckt PM_TMRDFFSNRNQX1\%noxref_36 ( 1 3 11 15 25 28 29 )
c53 ( 29 0 ) capacitor c=0.0413887f //x=17.885 //y=0.555
c54 ( 28 0 ) capacitor c=0.0045748f //x=16.78 //y=1.09
c55 ( 25 0 ) capacitor c=0.00156479f //x=18.02 //y=1.175
c56 ( 15 0 ) capacitor c=0.00737666f //x=18.99 //y=0.805
c57 ( 11 0 ) capacitor c=0.0144218f //x=18.905 //y=0.72
c58 ( 3 0 ) capacitor c=0.00718386f //x=18.02 //y=0.805
c59 ( 1 0 ) capacitor c=0.0218888f //x=17.935 //y=1.175
r60 (  15 29 ) resistor r=3.57586 //w=0.17 //l=0.125 //layer=li \
 //thickness=0.1 //x=18.99 //y=0.805 //x2=18.99 //y2=0.68
r61 (  15 29 ) resistor r=18.139 //w=0.187 //l=0.265 //layer=li \
 //thickness=0.1 //x=18.99 //y=0.805 //x2=18.99 //y2=1.07
r62 (  12 29 ) resistor r=3.57586 //w=0.17 //l=0.103078 //layer=li \
 //thickness=0.1 //x=18.105 //y=0.72 //x2=18.02 //y2=0.68
r63 (  12 29 ) resistor r=27.3797 //w=0.187 //l=0.4 //layer=li //thickness=0.1 \
 //x=18.105 //y=0.72 //x2=18.505 //y2=0.72
r64 (  11 29 ) resistor r=3.57586 //w=0.17 //l=0.103078 //layer=li \
 //thickness=0.1 //x=18.905 //y=0.72 //x2=18.99 //y2=0.68
r65 (  11 29 ) resistor r=27.3797 //w=0.187 //l=0.4 //layer=li //thickness=0.1 \
 //x=18.905 //y=0.72 //x2=18.505 //y2=0.72
r66 (  7 25 ) resistor r=5.4201 //w=0.17 //l=0.085 //layer=li //thickness=0.1 \
 //x=18.02 //y=1.26 //x2=18.02 //y2=1.175
r67 (  7 29 ) resistor r=10.2674 //w=0.187 //l=0.15 //layer=li //thickness=0.1 \
 //x=18.02 //y=1.26 //x2=18.02 //y2=1.41
r68 (  4 25 ) resistor r=5.4201 //w=0.17 //l=0.085 //layer=li //thickness=0.1 \
 //x=18.02 //y=1.09 //x2=18.02 //y2=1.175
r69 (  4 29 ) resistor r=1.36898 //w=0.187 //l=0.02 //layer=li //thickness=0.1 \
 //x=18.02 //y=1.09 //x2=18.02 //y2=1.07
r70 (  3 29 ) resistor r=3.57586 //w=0.17 //l=0.125 //layer=li //thickness=0.1 \
 //x=18.02 //y=0.805 //x2=18.02 //y2=0.68
r71 (  3 29 ) resistor r=18.139 //w=0.187 //l=0.265 //layer=li //thickness=0.1 \
 //x=18.02 //y=0.805 //x2=18.02 //y2=1.07
r72 (  2 28 ) resistor r=0.751729 //w=0.17 //l=0.085 //layer=li \
 //thickness=0.1 //x=17.055 //y=1.175 //x2=16.97 //y2=1.175
r73 (  1 25 ) resistor r=1.40859 //w=0.34 //l=0.085 //layer=li //thickness=0.1 \
 //x=17.935 //y=1.175 //x2=18.02 //y2=1.175
r74 (  1 2 ) resistor r=60.2353 //w=0.187 //l=0.88 //layer=li //thickness=0.1 \
 //x=17.935 //y=1.175 //x2=17.055 //y2=1.175
ends PM_TMRDFFSNRNQX1\%noxref_36

subckt PM_TMRDFFSNRNQX1\%noxref_37 ( 1 5 9 13 17 35 )
c52 ( 35 0 ) capacitor c=0.0673029f //x=20.185 //y=0.555
c53 ( 17 0 ) capacitor c=0.0178286f //x=22.175 //y=1.77
c54 ( 13 0 ) capacitor c=0.0154917f //x=22.175 //y=0.72
c55 ( 9 0 ) capacitor c=0.00678203f //x=21.29 //y=0.805
c56 ( 5 0 ) capacitor c=0.0164013f //x=21.205 //y=1.77
c57 ( 1 0 ) capacitor c=0.00696517f //x=20.32 //y=1.685
r58 (  18 35 ) resistor r=5.4201 //w=0.17 //l=0.103078 //layer=li \
 //thickness=0.1 //x=21.375 //y=1.77 //x2=21.29 //y2=1.81
r59 (  18 35 ) resistor r=27.3797 //w=0.187 //l=0.4 //layer=li //thickness=0.1 \
 //x=21.375 //y=1.77 //x2=21.775 //y2=1.77
r60 (  17 35 ) resistor r=0.751729 //w=0.17 //l=0.085 //layer=li \
 //thickness=0.1 //x=22.175 //y=1.77 //x2=22.26 //y2=1.77
r61 (  17 35 ) resistor r=27.3797 //w=0.187 //l=0.4 //layer=li //thickness=0.1 \
 //x=22.175 //y=1.77 //x2=21.775 //y2=1.77
r62 (  14 35 ) resistor r=3.57586 //w=0.17 //l=0.103078 //layer=li \
 //thickness=0.1 //x=21.375 //y=0.72 //x2=21.29 //y2=0.68
r63 (  14 35 ) resistor r=27.3797 //w=0.187 //l=0.4 //layer=li //thickness=0.1 \
 //x=21.375 //y=0.72 //x2=21.775 //y2=0.72
r64 (  13 35 ) resistor r=0.751729 //w=0.17 //l=0.085 //layer=li \
 //thickness=0.1 //x=22.175 //y=0.72 //x2=22.26 //y2=0.72
r65 (  13 35 ) resistor r=27.3797 //w=0.187 //l=0.4 //layer=li //thickness=0.1 \
 //x=22.175 //y=0.72 //x2=21.775 //y2=0.72
r66 (  10 35 ) resistor r=1.40859 //w=0.34 //l=0.125 //layer=li \
 //thickness=0.1 //x=21.29 //y=1.685 //x2=21.29 //y2=1.81
r67 (  10 35 ) resistor r=42.0963 //w=0.187 //l=0.615 //layer=li \
 //thickness=0.1 //x=21.29 //y=1.685 //x2=21.29 //y2=1.07
r68 (  9 35 ) resistor r=3.57586 //w=0.17 //l=0.125 //layer=li //thickness=0.1 \
 //x=21.29 //y=0.805 //x2=21.29 //y2=0.68
r69 (  9 35 ) resistor r=18.139 //w=0.187 //l=0.265 //layer=li //thickness=0.1 \
 //x=21.29 //y=0.805 //x2=21.29 //y2=1.07
r70 (  6 35 ) resistor r=3.57586 //w=0.17 //l=0.103078 //layer=li \
 //thickness=0.1 //x=20.405 //y=1.77 //x2=20.32 //y2=1.81
r71 (  6 35 ) resistor r=27.3797 //w=0.187 //l=0.4 //layer=li //thickness=0.1 \
 //x=20.405 //y=1.77 //x2=20.805 //y2=1.77
r72 (  5 35 ) resistor r=5.4201 //w=0.17 //l=0.103078 //layer=li \
 //thickness=0.1 //x=21.205 //y=1.77 //x2=21.29 //y2=1.81
r73 (  5 35 ) resistor r=27.3797 //w=0.187 //l=0.4 //layer=li //thickness=0.1 \
 //x=21.205 //y=1.77 //x2=20.805 //y2=1.77
r74 (  1 35 ) resistor r=3.57586 //w=0.17 //l=0.125 //layer=li //thickness=0.1 \
 //x=20.32 //y=1.685 //x2=20.32 //y2=1.81
r75 (  1 35 ) resistor r=42.0963 //w=0.187 //l=0.615 //layer=li \
 //thickness=0.1 //x=20.32 //y=1.685 //x2=20.32 //y2=1.07
ends PM_TMRDFFSNRNQX1\%noxref_37

subckt PM_TMRDFFSNRNQX1\%noxref_38 ( 1 3 11 15 25 28 29 )
c52 ( 29 0 ) capacitor c=0.0414744f //x=22.695 //y=0.555
c53 ( 28 0 ) capacitor c=0.00457437f //x=21.59 //y=1.09
c54 ( 25 0 ) capacitor c=0.00156479f //x=22.83 //y=1.175
c55 ( 15 0 ) capacitor c=0.00737666f //x=23.8 //y=0.805
c56 ( 11 0 ) capacitor c=0.0144274f //x=23.715 //y=0.72
c57 ( 3 0 ) capacitor c=0.00718386f //x=22.83 //y=0.805
c58 ( 1 0 ) capacitor c=0.0218873f //x=22.745 //y=1.175
r59 (  15 29 ) resistor r=3.57586 //w=0.17 //l=0.125 //layer=li \
 //thickness=0.1 //x=23.8 //y=0.805 //x2=23.8 //y2=0.68
r60 (  15 29 ) resistor r=18.139 //w=0.187 //l=0.265 //layer=li \
 //thickness=0.1 //x=23.8 //y=0.805 //x2=23.8 //y2=1.07
r61 (  12 29 ) resistor r=3.57586 //w=0.17 //l=0.103078 //layer=li \
 //thickness=0.1 //x=22.915 //y=0.72 //x2=22.83 //y2=0.68
r62 (  12 29 ) resistor r=27.3797 //w=0.187 //l=0.4 //layer=li //thickness=0.1 \
 //x=22.915 //y=0.72 //x2=23.315 //y2=0.72
r63 (  11 29 ) resistor r=3.57586 //w=0.17 //l=0.103078 //layer=li \
 //thickness=0.1 //x=23.715 //y=0.72 //x2=23.8 //y2=0.68
r64 (  11 29 ) resistor r=27.3797 //w=0.187 //l=0.4 //layer=li //thickness=0.1 \
 //x=23.715 //y=0.72 //x2=23.315 //y2=0.72
r65 (  7 25 ) resistor r=5.4201 //w=0.17 //l=0.085 //layer=li //thickness=0.1 \
 //x=22.83 //y=1.26 //x2=22.83 //y2=1.175
r66 (  7 29 ) resistor r=10.2674 //w=0.187 //l=0.15 //layer=li //thickness=0.1 \
 //x=22.83 //y=1.26 //x2=22.83 //y2=1.41
r67 (  4 25 ) resistor r=5.4201 //w=0.17 //l=0.085 //layer=li //thickness=0.1 \
 //x=22.83 //y=1.09 //x2=22.83 //y2=1.175
r68 (  4 29 ) resistor r=1.36898 //w=0.187 //l=0.02 //layer=li //thickness=0.1 \
 //x=22.83 //y=1.09 //x2=22.83 //y2=1.07
r69 (  3 29 ) resistor r=3.57586 //w=0.17 //l=0.125 //layer=li //thickness=0.1 \
 //x=22.83 //y=0.805 //x2=22.83 //y2=0.68
r70 (  3 29 ) resistor r=18.139 //w=0.187 //l=0.265 //layer=li //thickness=0.1 \
 //x=22.83 //y=0.805 //x2=22.83 //y2=1.07
r71 (  2 28 ) resistor r=0.751729 //w=0.17 //l=0.085 //layer=li \
 //thickness=0.1 //x=21.865 //y=1.175 //x2=21.78 //y2=1.175
r72 (  1 25 ) resistor r=1.40859 //w=0.34 //l=0.085 //layer=li //thickness=0.1 \
 //x=22.745 //y=1.175 //x2=22.83 //y2=1.175
r73 (  1 2 ) resistor r=60.2353 //w=0.187 //l=0.88 //layer=li //thickness=0.1 \
 //x=22.745 //y=1.175 //x2=21.865 //y2=1.175
ends PM_TMRDFFSNRNQX1\%noxref_38

subckt PM_TMRDFFSNRNQX1\%noxref_39 ( 1 5 9 13 17 35 )
c49 ( 35 0 ) capacitor c=0.0673029f //x=24.995 //y=0.555
c50 ( 17 0 ) capacitor c=0.0178317f //x=26.985 //y=1.77
c51 ( 13 0 ) capacitor c=0.0154936f //x=26.985 //y=0.72
c52 ( 9 0 ) capacitor c=0.00678203f //x=26.1 //y=0.805
c53 ( 5 0 ) capacitor c=0.0164013f //x=26.015 //y=1.77
c54 ( 1 0 ) capacitor c=0.00696517f //x=25.13 //y=1.685
r55 (  18 35 ) resistor r=5.4201 //w=0.17 //l=0.103078 //layer=li \
 //thickness=0.1 //x=26.185 //y=1.77 //x2=26.1 //y2=1.81
r56 (  18 35 ) resistor r=27.3797 //w=0.187 //l=0.4 //layer=li //thickness=0.1 \
 //x=26.185 //y=1.77 //x2=26.585 //y2=1.77
r57 (  17 35 ) resistor r=0.751729 //w=0.17 //l=0.085 //layer=li \
 //thickness=0.1 //x=26.985 //y=1.77 //x2=27.07 //y2=1.77
r58 (  17 35 ) resistor r=27.3797 //w=0.187 //l=0.4 //layer=li //thickness=0.1 \
 //x=26.985 //y=1.77 //x2=26.585 //y2=1.77
r59 (  14 35 ) resistor r=3.57586 //w=0.17 //l=0.103078 //layer=li \
 //thickness=0.1 //x=26.185 //y=0.72 //x2=26.1 //y2=0.68
r60 (  14 35 ) resistor r=27.3797 //w=0.187 //l=0.4 //layer=li //thickness=0.1 \
 //x=26.185 //y=0.72 //x2=26.585 //y2=0.72
r61 (  13 35 ) resistor r=0.751729 //w=0.17 //l=0.085 //layer=li \
 //thickness=0.1 //x=26.985 //y=0.72 //x2=27.07 //y2=0.72
r62 (  13 35 ) resistor r=27.3797 //w=0.187 //l=0.4 //layer=li //thickness=0.1 \
 //x=26.985 //y=0.72 //x2=26.585 //y2=0.72
r63 (  10 35 ) resistor r=1.40859 //w=0.34 //l=0.125 //layer=li \
 //thickness=0.1 //x=26.1 //y=1.685 //x2=26.1 //y2=1.81
r64 (  10 35 ) resistor r=42.0963 //w=0.187 //l=0.615 //layer=li \
 //thickness=0.1 //x=26.1 //y=1.685 //x2=26.1 //y2=1.07
r65 (  9 35 ) resistor r=3.57586 //w=0.17 //l=0.125 //layer=li //thickness=0.1 \
 //x=26.1 //y=0.805 //x2=26.1 //y2=0.68
r66 (  9 35 ) resistor r=18.139 //w=0.187 //l=0.265 //layer=li //thickness=0.1 \
 //x=26.1 //y=0.805 //x2=26.1 //y2=1.07
r67 (  6 35 ) resistor r=3.57586 //w=0.17 //l=0.103078 //layer=li \
 //thickness=0.1 //x=25.215 //y=1.77 //x2=25.13 //y2=1.81
r68 (  6 35 ) resistor r=27.3797 //w=0.187 //l=0.4 //layer=li //thickness=0.1 \
 //x=25.215 //y=1.77 //x2=25.615 //y2=1.77
r69 (  5 35 ) resistor r=5.4201 //w=0.17 //l=0.103078 //layer=li \
 //thickness=0.1 //x=26.015 //y=1.77 //x2=26.1 //y2=1.81
r70 (  5 35 ) resistor r=27.3797 //w=0.187 //l=0.4 //layer=li //thickness=0.1 \
 //x=26.015 //y=1.77 //x2=25.615 //y2=1.77
r71 (  1 35 ) resistor r=3.57586 //w=0.17 //l=0.125 //layer=li //thickness=0.1 \
 //x=25.13 //y=1.685 //x2=25.13 //y2=1.81
r72 (  1 35 ) resistor r=42.0963 //w=0.187 //l=0.615 //layer=li \
 //thickness=0.1 //x=25.13 //y=1.685 //x2=25.13 //y2=1.07
ends PM_TMRDFFSNRNQX1\%noxref_39

subckt PM_TMRDFFSNRNQX1\%noxref_40 ( 1 3 11 15 25 28 29 )
c52 ( 29 0 ) capacitor c=0.0413887f //x=27.505 //y=0.555
c53 ( 28 0 ) capacitor c=0.0045748f //x=26.4 //y=1.09
c54 ( 25 0 ) capacitor c=0.00156479f //x=27.64 //y=1.175
c55 ( 15 0 ) capacitor c=0.00737666f //x=28.61 //y=0.805
c56 ( 11 0 ) capacitor c=0.0144274f //x=28.525 //y=0.72
c57 ( 3 0 ) capacitor c=0.00718386f //x=27.64 //y=0.805
c58 ( 1 0 ) capacitor c=0.0218888f //x=27.555 //y=1.175
r59 (  15 29 ) resistor r=3.57586 //w=0.17 //l=0.125 //layer=li \
 //thickness=0.1 //x=28.61 //y=0.805 //x2=28.61 //y2=0.68
r60 (  15 29 ) resistor r=18.139 //w=0.187 //l=0.265 //layer=li \
 //thickness=0.1 //x=28.61 //y=0.805 //x2=28.61 //y2=1.07
r61 (  12 29 ) resistor r=3.57586 //w=0.17 //l=0.103078 //layer=li \
 //thickness=0.1 //x=27.725 //y=0.72 //x2=27.64 //y2=0.68
r62 (  12 29 ) resistor r=27.3797 //w=0.187 //l=0.4 //layer=li //thickness=0.1 \
 //x=27.725 //y=0.72 //x2=28.125 //y2=0.72
r63 (  11 29 ) resistor r=3.57586 //w=0.17 //l=0.103078 //layer=li \
 //thickness=0.1 //x=28.525 //y=0.72 //x2=28.61 //y2=0.68
r64 (  11 29 ) resistor r=27.3797 //w=0.187 //l=0.4 //layer=li //thickness=0.1 \
 //x=28.525 //y=0.72 //x2=28.125 //y2=0.72
r65 (  7 25 ) resistor r=5.4201 //w=0.17 //l=0.085 //layer=li //thickness=0.1 \
 //x=27.64 //y=1.26 //x2=27.64 //y2=1.175
r66 (  7 29 ) resistor r=10.2674 //w=0.187 //l=0.15 //layer=li //thickness=0.1 \
 //x=27.64 //y=1.26 //x2=27.64 //y2=1.41
r67 (  4 25 ) resistor r=5.4201 //w=0.17 //l=0.085 //layer=li //thickness=0.1 \
 //x=27.64 //y=1.09 //x2=27.64 //y2=1.175
r68 (  4 29 ) resistor r=1.36898 //w=0.187 //l=0.02 //layer=li //thickness=0.1 \
 //x=27.64 //y=1.09 //x2=27.64 //y2=1.07
r69 (  3 29 ) resistor r=3.57586 //w=0.17 //l=0.125 //layer=li //thickness=0.1 \
 //x=27.64 //y=0.805 //x2=27.64 //y2=0.68
r70 (  3 29 ) resistor r=18.139 //w=0.187 //l=0.265 //layer=li //thickness=0.1 \
 //x=27.64 //y=0.805 //x2=27.64 //y2=1.07
r71 (  2 28 ) resistor r=0.751729 //w=0.17 //l=0.085 //layer=li \
 //thickness=0.1 //x=26.675 //y=1.175 //x2=26.59 //y2=1.175
r72 (  1 25 ) resistor r=1.40859 //w=0.34 //l=0.085 //layer=li //thickness=0.1 \
 //x=27.555 //y=1.175 //x2=27.64 //y2=1.175
r73 (  1 2 ) resistor r=60.2353 //w=0.187 //l=0.88 //layer=li //thickness=0.1 \
 //x=27.555 //y=1.175 //x2=26.675 //y2=1.175
ends PM_TMRDFFSNRNQX1\%noxref_40

subckt PM_TMRDFFSNRNQX1\%noxref_41 ( 1 5 9 13 17 35 )
c52 ( 35 0 ) capacitor c=0.0673029f //x=29.805 //y=0.555
c53 ( 17 0 ) capacitor c=0.0178286f //x=31.795 //y=1.77
c54 ( 13 0 ) capacitor c=0.0154917f //x=31.795 //y=0.72
c55 ( 9 0 ) capacitor c=0.00678203f //x=30.91 //y=0.805
c56 ( 5 0 ) capacitor c=0.0164013f //x=30.825 //y=1.77
c57 ( 1 0 ) capacitor c=0.00696517f //x=29.94 //y=1.685
r58 (  18 35 ) resistor r=5.4201 //w=0.17 //l=0.103078 //layer=li \
 //thickness=0.1 //x=30.995 //y=1.77 //x2=30.91 //y2=1.81
r59 (  18 35 ) resistor r=27.3797 //w=0.187 //l=0.4 //layer=li //thickness=0.1 \
 //x=30.995 //y=1.77 //x2=31.395 //y2=1.77
r60 (  17 35 ) resistor r=0.751729 //w=0.17 //l=0.085 //layer=li \
 //thickness=0.1 //x=31.795 //y=1.77 //x2=31.88 //y2=1.77
r61 (  17 35 ) resistor r=27.3797 //w=0.187 //l=0.4 //layer=li //thickness=0.1 \
 //x=31.795 //y=1.77 //x2=31.395 //y2=1.77
r62 (  14 35 ) resistor r=3.57586 //w=0.17 //l=0.103078 //layer=li \
 //thickness=0.1 //x=30.995 //y=0.72 //x2=30.91 //y2=0.68
r63 (  14 35 ) resistor r=27.3797 //w=0.187 //l=0.4 //layer=li //thickness=0.1 \
 //x=30.995 //y=0.72 //x2=31.395 //y2=0.72
r64 (  13 35 ) resistor r=0.751729 //w=0.17 //l=0.085 //layer=li \
 //thickness=0.1 //x=31.795 //y=0.72 //x2=31.88 //y2=0.72
r65 (  13 35 ) resistor r=27.3797 //w=0.187 //l=0.4 //layer=li //thickness=0.1 \
 //x=31.795 //y=0.72 //x2=31.395 //y2=0.72
r66 (  10 35 ) resistor r=1.40859 //w=0.34 //l=0.125 //layer=li \
 //thickness=0.1 //x=30.91 //y=1.685 //x2=30.91 //y2=1.81
r67 (  10 35 ) resistor r=42.0963 //w=0.187 //l=0.615 //layer=li \
 //thickness=0.1 //x=30.91 //y=1.685 //x2=30.91 //y2=1.07
r68 (  9 35 ) resistor r=3.57586 //w=0.17 //l=0.125 //layer=li //thickness=0.1 \
 //x=30.91 //y=0.805 //x2=30.91 //y2=0.68
r69 (  9 35 ) resistor r=18.139 //w=0.187 //l=0.265 //layer=li //thickness=0.1 \
 //x=30.91 //y=0.805 //x2=30.91 //y2=1.07
r70 (  6 35 ) resistor r=3.57586 //w=0.17 //l=0.103078 //layer=li \
 //thickness=0.1 //x=30.025 //y=1.77 //x2=29.94 //y2=1.81
r71 (  6 35 ) resistor r=27.3797 //w=0.187 //l=0.4 //layer=li //thickness=0.1 \
 //x=30.025 //y=1.77 //x2=30.425 //y2=1.77
r72 (  5 35 ) resistor r=5.4201 //w=0.17 //l=0.103078 //layer=li \
 //thickness=0.1 //x=30.825 //y=1.77 //x2=30.91 //y2=1.81
r73 (  5 35 ) resistor r=27.3797 //w=0.187 //l=0.4 //layer=li //thickness=0.1 \
 //x=30.825 //y=1.77 //x2=30.425 //y2=1.77
r74 (  1 35 ) resistor r=3.57586 //w=0.17 //l=0.125 //layer=li //thickness=0.1 \
 //x=29.94 //y=1.685 //x2=29.94 //y2=1.81
r75 (  1 35 ) resistor r=42.0963 //w=0.187 //l=0.615 //layer=li \
 //thickness=0.1 //x=29.94 //y=1.685 //x2=29.94 //y2=1.07
ends PM_TMRDFFSNRNQX1\%noxref_41

subckt PM_TMRDFFSNRNQX1\%noxref_42 ( 1 3 11 15 25 28 29 )
c52 ( 29 0 ) capacitor c=0.0414744f //x=32.315 //y=0.555
c53 ( 28 0 ) capacitor c=0.00457437f //x=31.21 //y=1.09
c54 ( 25 0 ) capacitor c=0.00156479f //x=32.45 //y=1.175
c55 ( 15 0 ) capacitor c=0.00737666f //x=33.42 //y=0.805
c56 ( 11 0 ) capacitor c=0.0144274f //x=33.335 //y=0.72
c57 ( 3 0 ) capacitor c=0.00718386f //x=32.45 //y=0.805
c58 ( 1 0 ) capacitor c=0.0218873f //x=32.365 //y=1.175
r59 (  15 29 ) resistor r=3.57586 //w=0.17 //l=0.125 //layer=li \
 //thickness=0.1 //x=33.42 //y=0.805 //x2=33.42 //y2=0.68
r60 (  15 29 ) resistor r=18.139 //w=0.187 //l=0.265 //layer=li \
 //thickness=0.1 //x=33.42 //y=0.805 //x2=33.42 //y2=1.07
r61 (  12 29 ) resistor r=3.57586 //w=0.17 //l=0.103078 //layer=li \
 //thickness=0.1 //x=32.535 //y=0.72 //x2=32.45 //y2=0.68
r62 (  12 29 ) resistor r=27.3797 //w=0.187 //l=0.4 //layer=li //thickness=0.1 \
 //x=32.535 //y=0.72 //x2=32.935 //y2=0.72
r63 (  11 29 ) resistor r=3.57586 //w=0.17 //l=0.103078 //layer=li \
 //thickness=0.1 //x=33.335 //y=0.72 //x2=33.42 //y2=0.68
r64 (  11 29 ) resistor r=27.3797 //w=0.187 //l=0.4 //layer=li //thickness=0.1 \
 //x=33.335 //y=0.72 //x2=32.935 //y2=0.72
r65 (  7 25 ) resistor r=5.4201 //w=0.17 //l=0.085 //layer=li //thickness=0.1 \
 //x=32.45 //y=1.26 //x2=32.45 //y2=1.175
r66 (  7 29 ) resistor r=10.2674 //w=0.187 //l=0.15 //layer=li //thickness=0.1 \
 //x=32.45 //y=1.26 //x2=32.45 //y2=1.41
r67 (  4 25 ) resistor r=5.4201 //w=0.17 //l=0.085 //layer=li //thickness=0.1 \
 //x=32.45 //y=1.09 //x2=32.45 //y2=1.175
r68 (  4 29 ) resistor r=1.36898 //w=0.187 //l=0.02 //layer=li //thickness=0.1 \
 //x=32.45 //y=1.09 //x2=32.45 //y2=1.07
r69 (  3 29 ) resistor r=3.57586 //w=0.17 //l=0.125 //layer=li //thickness=0.1 \
 //x=32.45 //y=0.805 //x2=32.45 //y2=0.68
r70 (  3 29 ) resistor r=18.139 //w=0.187 //l=0.265 //layer=li //thickness=0.1 \
 //x=32.45 //y=0.805 //x2=32.45 //y2=1.07
r71 (  2 28 ) resistor r=0.751729 //w=0.17 //l=0.085 //layer=li \
 //thickness=0.1 //x=31.485 //y=1.175 //x2=31.4 //y2=1.175
r72 (  1 25 ) resistor r=1.40859 //w=0.34 //l=0.085 //layer=li //thickness=0.1 \
 //x=32.365 //y=1.175 //x2=32.45 //y2=1.175
r73 (  1 2 ) resistor r=60.2353 //w=0.187 //l=0.88 //layer=li //thickness=0.1 \
 //x=32.365 //y=1.175 //x2=31.485 //y2=1.175
ends PM_TMRDFFSNRNQX1\%noxref_42

subckt PM_TMRDFFSNRNQX1\%noxref_43 ( 1 5 9 13 17 35 )
c49 ( 35 0 ) capacitor c=0.0673029f //x=34.615 //y=0.555
c50 ( 17 0 ) capacitor c=0.0178317f //x=36.605 //y=1.77
c51 ( 13 0 ) capacitor c=0.0154936f //x=36.605 //y=0.72
c52 ( 9 0 ) capacitor c=0.00678203f //x=35.72 //y=0.805
c53 ( 5 0 ) capacitor c=0.0164013f //x=35.635 //y=1.77
c54 ( 1 0 ) capacitor c=0.00696517f //x=34.75 //y=1.685
r55 (  18 35 ) resistor r=5.4201 //w=0.17 //l=0.103078 //layer=li \
 //thickness=0.1 //x=35.805 //y=1.77 //x2=35.72 //y2=1.81
r56 (  18 35 ) resistor r=27.3797 //w=0.187 //l=0.4 //layer=li //thickness=0.1 \
 //x=35.805 //y=1.77 //x2=36.205 //y2=1.77
r57 (  17 35 ) resistor r=0.751729 //w=0.17 //l=0.085 //layer=li \
 //thickness=0.1 //x=36.605 //y=1.77 //x2=36.69 //y2=1.77
r58 (  17 35 ) resistor r=27.3797 //w=0.187 //l=0.4 //layer=li //thickness=0.1 \
 //x=36.605 //y=1.77 //x2=36.205 //y2=1.77
r59 (  14 35 ) resistor r=3.57586 //w=0.17 //l=0.103078 //layer=li \
 //thickness=0.1 //x=35.805 //y=0.72 //x2=35.72 //y2=0.68
r60 (  14 35 ) resistor r=27.3797 //w=0.187 //l=0.4 //layer=li //thickness=0.1 \
 //x=35.805 //y=0.72 //x2=36.205 //y2=0.72
r61 (  13 35 ) resistor r=0.751729 //w=0.17 //l=0.085 //layer=li \
 //thickness=0.1 //x=36.605 //y=0.72 //x2=36.69 //y2=0.72
r62 (  13 35 ) resistor r=27.3797 //w=0.187 //l=0.4 //layer=li //thickness=0.1 \
 //x=36.605 //y=0.72 //x2=36.205 //y2=0.72
r63 (  10 35 ) resistor r=1.40859 //w=0.34 //l=0.125 //layer=li \
 //thickness=0.1 //x=35.72 //y=1.685 //x2=35.72 //y2=1.81
r64 (  10 35 ) resistor r=42.0963 //w=0.187 //l=0.615 //layer=li \
 //thickness=0.1 //x=35.72 //y=1.685 //x2=35.72 //y2=1.07
r65 (  9 35 ) resistor r=3.57586 //w=0.17 //l=0.125 //layer=li //thickness=0.1 \
 //x=35.72 //y=0.805 //x2=35.72 //y2=0.68
r66 (  9 35 ) resistor r=18.139 //w=0.187 //l=0.265 //layer=li //thickness=0.1 \
 //x=35.72 //y=0.805 //x2=35.72 //y2=1.07
r67 (  6 35 ) resistor r=3.57586 //w=0.17 //l=0.103078 //layer=li \
 //thickness=0.1 //x=34.835 //y=1.77 //x2=34.75 //y2=1.81
r68 (  6 35 ) resistor r=27.3797 //w=0.187 //l=0.4 //layer=li //thickness=0.1 \
 //x=34.835 //y=1.77 //x2=35.235 //y2=1.77
r69 (  5 35 ) resistor r=5.4201 //w=0.17 //l=0.103078 //layer=li \
 //thickness=0.1 //x=35.635 //y=1.77 //x2=35.72 //y2=1.81
r70 (  5 35 ) resistor r=27.3797 //w=0.187 //l=0.4 //layer=li //thickness=0.1 \
 //x=35.635 //y=1.77 //x2=35.235 //y2=1.77
r71 (  1 35 ) resistor r=3.57586 //w=0.17 //l=0.125 //layer=li //thickness=0.1 \
 //x=34.75 //y=1.685 //x2=34.75 //y2=1.81
r72 (  1 35 ) resistor r=42.0963 //w=0.187 //l=0.615 //layer=li \
 //thickness=0.1 //x=34.75 //y=1.685 //x2=34.75 //y2=1.07
ends PM_TMRDFFSNRNQX1\%noxref_43

subckt PM_TMRDFFSNRNQX1\%noxref_44 ( 1 3 11 15 25 28 29 )
c52 ( 29 0 ) capacitor c=0.0413887f //x=37.125 //y=0.555
c53 ( 28 0 ) capacitor c=0.0045748f //x=36.02 //y=1.09
c54 ( 25 0 ) capacitor c=0.00156479f //x=37.26 //y=1.175
c55 ( 15 0 ) capacitor c=0.00737666f //x=38.23 //y=0.805
c56 ( 11 0 ) capacitor c=0.0144274f //x=38.145 //y=0.72
c57 ( 3 0 ) capacitor c=0.00718386f //x=37.26 //y=0.805
c58 ( 1 0 ) capacitor c=0.0218888f //x=37.175 //y=1.175
r59 (  15 29 ) resistor r=3.57586 //w=0.17 //l=0.125 //layer=li \
 //thickness=0.1 //x=38.23 //y=0.805 //x2=38.23 //y2=0.68
r60 (  15 29 ) resistor r=18.139 //w=0.187 //l=0.265 //layer=li \
 //thickness=0.1 //x=38.23 //y=0.805 //x2=38.23 //y2=1.07
r61 (  12 29 ) resistor r=3.57586 //w=0.17 //l=0.103078 //layer=li \
 //thickness=0.1 //x=37.345 //y=0.72 //x2=37.26 //y2=0.68
r62 (  12 29 ) resistor r=27.3797 //w=0.187 //l=0.4 //layer=li //thickness=0.1 \
 //x=37.345 //y=0.72 //x2=37.745 //y2=0.72
r63 (  11 29 ) resistor r=3.57586 //w=0.17 //l=0.103078 //layer=li \
 //thickness=0.1 //x=38.145 //y=0.72 //x2=38.23 //y2=0.68
r64 (  11 29 ) resistor r=27.3797 //w=0.187 //l=0.4 //layer=li //thickness=0.1 \
 //x=38.145 //y=0.72 //x2=37.745 //y2=0.72
r65 (  7 25 ) resistor r=5.4201 //w=0.17 //l=0.085 //layer=li //thickness=0.1 \
 //x=37.26 //y=1.26 //x2=37.26 //y2=1.175
r66 (  7 29 ) resistor r=10.2674 //w=0.187 //l=0.15 //layer=li //thickness=0.1 \
 //x=37.26 //y=1.26 //x2=37.26 //y2=1.41
r67 (  4 25 ) resistor r=5.4201 //w=0.17 //l=0.085 //layer=li //thickness=0.1 \
 //x=37.26 //y=1.09 //x2=37.26 //y2=1.175
r68 (  4 29 ) resistor r=1.36898 //w=0.187 //l=0.02 //layer=li //thickness=0.1 \
 //x=37.26 //y=1.09 //x2=37.26 //y2=1.07
r69 (  3 29 ) resistor r=3.57586 //w=0.17 //l=0.125 //layer=li //thickness=0.1 \
 //x=37.26 //y=0.805 //x2=37.26 //y2=0.68
r70 (  3 29 ) resistor r=18.139 //w=0.187 //l=0.265 //layer=li //thickness=0.1 \
 //x=37.26 //y=0.805 //x2=37.26 //y2=1.07
r71 (  2 28 ) resistor r=0.751729 //w=0.17 //l=0.085 //layer=li \
 //thickness=0.1 //x=36.295 //y=1.175 //x2=36.21 //y2=1.175
r72 (  1 25 ) resistor r=1.40859 //w=0.34 //l=0.085 //layer=li //thickness=0.1 \
 //x=37.175 //y=1.175 //x2=37.26 //y2=1.175
r73 (  1 2 ) resistor r=60.2353 //w=0.187 //l=0.88 //layer=li //thickness=0.1 \
 //x=37.175 //y=1.175 //x2=36.295 //y2=1.175
ends PM_TMRDFFSNRNQX1\%noxref_44

subckt PM_TMRDFFSNRNQX1\%noxref_45 ( 1 5 9 13 17 35 )
c49 ( 35 0 ) capacitor c=0.0673029f //x=39.425 //y=0.555
c50 ( 17 0 ) capacitor c=0.0178317f //x=41.415 //y=1.77
c51 ( 13 0 ) capacitor c=0.0154936f //x=41.415 //y=0.72
c52 ( 9 0 ) capacitor c=0.00678203f //x=40.53 //y=0.805
c53 ( 5 0 ) capacitor c=0.0164013f //x=40.445 //y=1.77
c54 ( 1 0 ) capacitor c=0.00696517f //x=39.56 //y=1.685
r55 (  18 35 ) resistor r=5.4201 //w=0.17 //l=0.103078 //layer=li \
 //thickness=0.1 //x=40.615 //y=1.77 //x2=40.53 //y2=1.81
r56 (  18 35 ) resistor r=27.3797 //w=0.187 //l=0.4 //layer=li //thickness=0.1 \
 //x=40.615 //y=1.77 //x2=41.015 //y2=1.77
r57 (  17 35 ) resistor r=0.751729 //w=0.17 //l=0.085 //layer=li \
 //thickness=0.1 //x=41.415 //y=1.77 //x2=41.5 //y2=1.77
r58 (  17 35 ) resistor r=27.3797 //w=0.187 //l=0.4 //layer=li //thickness=0.1 \
 //x=41.415 //y=1.77 //x2=41.015 //y2=1.77
r59 (  14 35 ) resistor r=3.57586 //w=0.17 //l=0.103078 //layer=li \
 //thickness=0.1 //x=40.615 //y=0.72 //x2=40.53 //y2=0.68
r60 (  14 35 ) resistor r=27.3797 //w=0.187 //l=0.4 //layer=li //thickness=0.1 \
 //x=40.615 //y=0.72 //x2=41.015 //y2=0.72
r61 (  13 35 ) resistor r=0.751729 //w=0.17 //l=0.085 //layer=li \
 //thickness=0.1 //x=41.415 //y=0.72 //x2=41.5 //y2=0.72
r62 (  13 35 ) resistor r=27.3797 //w=0.187 //l=0.4 //layer=li //thickness=0.1 \
 //x=41.415 //y=0.72 //x2=41.015 //y2=0.72
r63 (  10 35 ) resistor r=1.40859 //w=0.34 //l=0.125 //layer=li \
 //thickness=0.1 //x=40.53 //y=1.685 //x2=40.53 //y2=1.81
r64 (  10 35 ) resistor r=42.0963 //w=0.187 //l=0.615 //layer=li \
 //thickness=0.1 //x=40.53 //y=1.685 //x2=40.53 //y2=1.07
r65 (  9 35 ) resistor r=3.57586 //w=0.17 //l=0.125 //layer=li //thickness=0.1 \
 //x=40.53 //y=0.805 //x2=40.53 //y2=0.68
r66 (  9 35 ) resistor r=18.139 //w=0.187 //l=0.265 //layer=li //thickness=0.1 \
 //x=40.53 //y=0.805 //x2=40.53 //y2=1.07
r67 (  6 35 ) resistor r=3.57586 //w=0.17 //l=0.103078 //layer=li \
 //thickness=0.1 //x=39.645 //y=1.77 //x2=39.56 //y2=1.81
r68 (  6 35 ) resistor r=27.3797 //w=0.187 //l=0.4 //layer=li //thickness=0.1 \
 //x=39.645 //y=1.77 //x2=40.045 //y2=1.77
r69 (  5 35 ) resistor r=5.4201 //w=0.17 //l=0.103078 //layer=li \
 //thickness=0.1 //x=40.445 //y=1.77 //x2=40.53 //y2=1.81
r70 (  5 35 ) resistor r=27.3797 //w=0.187 //l=0.4 //layer=li //thickness=0.1 \
 //x=40.445 //y=1.77 //x2=40.045 //y2=1.77
r71 (  1 35 ) resistor r=3.57586 //w=0.17 //l=0.125 //layer=li //thickness=0.1 \
 //x=39.56 //y=1.685 //x2=39.56 //y2=1.81
r72 (  1 35 ) resistor r=42.0963 //w=0.187 //l=0.615 //layer=li \
 //thickness=0.1 //x=39.56 //y=1.685 //x2=39.56 //y2=1.07
ends PM_TMRDFFSNRNQX1\%noxref_45

subckt PM_TMRDFFSNRNQX1\%noxref_46 ( 1 3 11 15 25 28 29 )
c52 ( 29 0 ) capacitor c=0.0414744f //x=41.935 //y=0.555
c53 ( 28 0 ) capacitor c=0.0045748f //x=40.83 //y=1.09
c54 ( 25 0 ) capacitor c=0.00156479f //x=42.07 //y=1.175
c55 ( 15 0 ) capacitor c=0.00737666f //x=43.04 //y=0.805
c56 ( 11 0 ) capacitor c=0.0144274f //x=42.955 //y=0.72
c57 ( 3 0 ) capacitor c=0.00718386f //x=42.07 //y=0.805
c58 ( 1 0 ) capacitor c=0.0218888f //x=41.985 //y=1.175
r59 (  15 29 ) resistor r=3.57586 //w=0.17 //l=0.125 //layer=li \
 //thickness=0.1 //x=43.04 //y=0.805 //x2=43.04 //y2=0.68
r60 (  15 29 ) resistor r=18.139 //w=0.187 //l=0.265 //layer=li \
 //thickness=0.1 //x=43.04 //y=0.805 //x2=43.04 //y2=1.07
r61 (  12 29 ) resistor r=3.57586 //w=0.17 //l=0.103078 //layer=li \
 //thickness=0.1 //x=42.155 //y=0.72 //x2=42.07 //y2=0.68
r62 (  12 29 ) resistor r=27.3797 //w=0.187 //l=0.4 //layer=li //thickness=0.1 \
 //x=42.155 //y=0.72 //x2=42.555 //y2=0.72
r63 (  11 29 ) resistor r=3.57586 //w=0.17 //l=0.103078 //layer=li \
 //thickness=0.1 //x=42.955 //y=0.72 //x2=43.04 //y2=0.68
r64 (  11 29 ) resistor r=27.3797 //w=0.187 //l=0.4 //layer=li //thickness=0.1 \
 //x=42.955 //y=0.72 //x2=42.555 //y2=0.72
r65 (  7 25 ) resistor r=5.4201 //w=0.17 //l=0.085 //layer=li //thickness=0.1 \
 //x=42.07 //y=1.26 //x2=42.07 //y2=1.175
r66 (  7 29 ) resistor r=10.2674 //w=0.187 //l=0.15 //layer=li //thickness=0.1 \
 //x=42.07 //y=1.26 //x2=42.07 //y2=1.41
r67 (  4 25 ) resistor r=5.4201 //w=0.17 //l=0.085 //layer=li //thickness=0.1 \
 //x=42.07 //y=1.09 //x2=42.07 //y2=1.175
r68 (  4 29 ) resistor r=1.36898 //w=0.187 //l=0.02 //layer=li //thickness=0.1 \
 //x=42.07 //y=1.09 //x2=42.07 //y2=1.07
r69 (  3 29 ) resistor r=3.57586 //w=0.17 //l=0.125 //layer=li //thickness=0.1 \
 //x=42.07 //y=0.805 //x2=42.07 //y2=0.68
r70 (  3 29 ) resistor r=18.139 //w=0.187 //l=0.265 //layer=li //thickness=0.1 \
 //x=42.07 //y=0.805 //x2=42.07 //y2=1.07
r71 (  2 28 ) resistor r=0.751729 //w=0.17 //l=0.085 //layer=li \
 //thickness=0.1 //x=41.105 //y=1.175 //x2=41.02 //y2=1.175
r72 (  1 25 ) resistor r=1.40859 //w=0.34 //l=0.085 //layer=li //thickness=0.1 \
 //x=41.985 //y=1.175 //x2=42.07 //y2=1.175
r73 (  1 2 ) resistor r=60.2353 //w=0.187 //l=0.88 //layer=li //thickness=0.1 \
 //x=41.985 //y=1.175 //x2=41.105 //y2=1.175
ends PM_TMRDFFSNRNQX1\%noxref_46

subckt PM_TMRDFFSNRNQX1\%noxref_47 ( 1 5 9 13 17 35 )
c49 ( 35 0 ) capacitor c=0.0673029f //x=44.235 //y=0.555
c50 ( 17 0 ) capacitor c=0.0178317f //x=46.225 //y=1.77
c51 ( 13 0 ) capacitor c=0.0154936f //x=46.225 //y=0.72
c52 ( 9 0 ) capacitor c=0.00678203f //x=45.34 //y=0.805
c53 ( 5 0 ) capacitor c=0.0164013f //x=45.255 //y=1.77
c54 ( 1 0 ) capacitor c=0.00696517f //x=44.37 //y=1.685
r55 (  18 35 ) resistor r=5.4201 //w=0.17 //l=0.103078 //layer=li \
 //thickness=0.1 //x=45.425 //y=1.77 //x2=45.34 //y2=1.81
r56 (  18 35 ) resistor r=27.3797 //w=0.187 //l=0.4 //layer=li //thickness=0.1 \
 //x=45.425 //y=1.77 //x2=45.825 //y2=1.77
r57 (  17 35 ) resistor r=0.751729 //w=0.17 //l=0.085 //layer=li \
 //thickness=0.1 //x=46.225 //y=1.77 //x2=46.31 //y2=1.77
r58 (  17 35 ) resistor r=27.3797 //w=0.187 //l=0.4 //layer=li //thickness=0.1 \
 //x=46.225 //y=1.77 //x2=45.825 //y2=1.77
r59 (  14 35 ) resistor r=3.57586 //w=0.17 //l=0.103078 //layer=li \
 //thickness=0.1 //x=45.425 //y=0.72 //x2=45.34 //y2=0.68
r60 (  14 35 ) resistor r=27.3797 //w=0.187 //l=0.4 //layer=li //thickness=0.1 \
 //x=45.425 //y=0.72 //x2=45.825 //y2=0.72
r61 (  13 35 ) resistor r=0.751729 //w=0.17 //l=0.085 //layer=li \
 //thickness=0.1 //x=46.225 //y=0.72 //x2=46.31 //y2=0.72
r62 (  13 35 ) resistor r=27.3797 //w=0.187 //l=0.4 //layer=li //thickness=0.1 \
 //x=46.225 //y=0.72 //x2=45.825 //y2=0.72
r63 (  10 35 ) resistor r=1.40859 //w=0.34 //l=0.125 //layer=li \
 //thickness=0.1 //x=45.34 //y=1.685 //x2=45.34 //y2=1.81
r64 (  10 35 ) resistor r=42.0963 //w=0.187 //l=0.615 //layer=li \
 //thickness=0.1 //x=45.34 //y=1.685 //x2=45.34 //y2=1.07
r65 (  9 35 ) resistor r=3.57586 //w=0.17 //l=0.125 //layer=li //thickness=0.1 \
 //x=45.34 //y=0.805 //x2=45.34 //y2=0.68
r66 (  9 35 ) resistor r=18.139 //w=0.187 //l=0.265 //layer=li //thickness=0.1 \
 //x=45.34 //y=0.805 //x2=45.34 //y2=1.07
r67 (  6 35 ) resistor r=3.57586 //w=0.17 //l=0.103078 //layer=li \
 //thickness=0.1 //x=44.455 //y=1.77 //x2=44.37 //y2=1.81
r68 (  6 35 ) resistor r=27.3797 //w=0.187 //l=0.4 //layer=li //thickness=0.1 \
 //x=44.455 //y=1.77 //x2=44.855 //y2=1.77
r69 (  5 35 ) resistor r=5.4201 //w=0.17 //l=0.103078 //layer=li \
 //thickness=0.1 //x=45.255 //y=1.77 //x2=45.34 //y2=1.81
r70 (  5 35 ) resistor r=27.3797 //w=0.187 //l=0.4 //layer=li //thickness=0.1 \
 //x=45.255 //y=1.77 //x2=44.855 //y2=1.77
r71 (  1 35 ) resistor r=3.57586 //w=0.17 //l=0.125 //layer=li //thickness=0.1 \
 //x=44.37 //y=1.685 //x2=44.37 //y2=1.81
r72 (  1 35 ) resistor r=42.0963 //w=0.187 //l=0.615 //layer=li \
 //thickness=0.1 //x=44.37 //y=1.685 //x2=44.37 //y2=1.07
ends PM_TMRDFFSNRNQX1\%noxref_47

subckt PM_TMRDFFSNRNQX1\%noxref_48 ( 1 3 11 15 25 28 29 )
c53 ( 29 0 ) capacitor c=0.0413887f //x=46.745 //y=0.555
c54 ( 28 0 ) capacitor c=0.0045748f //x=45.64 //y=1.09
c55 ( 25 0 ) capacitor c=0.00156479f //x=46.88 //y=1.175
c56 ( 15 0 ) capacitor c=0.00737666f //x=47.85 //y=0.805
c57 ( 11 0 ) capacitor c=0.0144218f //x=47.765 //y=0.72
c58 ( 3 0 ) capacitor c=0.00718386f //x=46.88 //y=0.805
c59 ( 1 0 ) capacitor c=0.0218888f //x=46.795 //y=1.175
r60 (  15 29 ) resistor r=3.57586 //w=0.17 //l=0.125 //layer=li \
 //thickness=0.1 //x=47.85 //y=0.805 //x2=47.85 //y2=0.68
r61 (  15 29 ) resistor r=18.139 //w=0.187 //l=0.265 //layer=li \
 //thickness=0.1 //x=47.85 //y=0.805 //x2=47.85 //y2=1.07
r62 (  12 29 ) resistor r=3.57586 //w=0.17 //l=0.103078 //layer=li \
 //thickness=0.1 //x=46.965 //y=0.72 //x2=46.88 //y2=0.68
r63 (  12 29 ) resistor r=27.3797 //w=0.187 //l=0.4 //layer=li //thickness=0.1 \
 //x=46.965 //y=0.72 //x2=47.365 //y2=0.72
r64 (  11 29 ) resistor r=3.57586 //w=0.17 //l=0.103078 //layer=li \
 //thickness=0.1 //x=47.765 //y=0.72 //x2=47.85 //y2=0.68
r65 (  11 29 ) resistor r=27.3797 //w=0.187 //l=0.4 //layer=li //thickness=0.1 \
 //x=47.765 //y=0.72 //x2=47.365 //y2=0.72
r66 (  7 25 ) resistor r=5.4201 //w=0.17 //l=0.085 //layer=li //thickness=0.1 \
 //x=46.88 //y=1.26 //x2=46.88 //y2=1.175
r67 (  7 29 ) resistor r=10.2674 //w=0.187 //l=0.15 //layer=li //thickness=0.1 \
 //x=46.88 //y=1.26 //x2=46.88 //y2=1.41
r68 (  4 25 ) resistor r=5.4201 //w=0.17 //l=0.085 //layer=li //thickness=0.1 \
 //x=46.88 //y=1.09 //x2=46.88 //y2=1.175
r69 (  4 29 ) resistor r=1.36898 //w=0.187 //l=0.02 //layer=li //thickness=0.1 \
 //x=46.88 //y=1.09 //x2=46.88 //y2=1.07
r70 (  3 29 ) resistor r=3.57586 //w=0.17 //l=0.125 //layer=li //thickness=0.1 \
 //x=46.88 //y=0.805 //x2=46.88 //y2=0.68
r71 (  3 29 ) resistor r=18.139 //w=0.187 //l=0.265 //layer=li //thickness=0.1 \
 //x=46.88 //y=0.805 //x2=46.88 //y2=1.07
r72 (  2 28 ) resistor r=0.751729 //w=0.17 //l=0.085 //layer=li \
 //thickness=0.1 //x=45.915 //y=1.175 //x2=45.83 //y2=1.175
r73 (  1 25 ) resistor r=1.40859 //w=0.34 //l=0.085 //layer=li //thickness=0.1 \
 //x=46.795 //y=1.175 //x2=46.88 //y2=1.175
r74 (  1 2 ) resistor r=60.2353 //w=0.187 //l=0.88 //layer=li //thickness=0.1 \
 //x=46.795 //y=1.175 //x2=45.915 //y2=1.175
ends PM_TMRDFFSNRNQX1\%noxref_48

subckt PM_TMRDFFSNRNQX1\%noxref_49 ( 1 5 9 13 17 35 )
c52 ( 35 0 ) capacitor c=0.0673029f //x=49.045 //y=0.555
c53 ( 17 0 ) capacitor c=0.0178286f //x=51.035 //y=1.77
c54 ( 13 0 ) capacitor c=0.0154917f //x=51.035 //y=0.72
c55 ( 9 0 ) capacitor c=0.00678203f //x=50.15 //y=0.805
c56 ( 5 0 ) capacitor c=0.0164013f //x=50.065 //y=1.77
c57 ( 1 0 ) capacitor c=0.00696517f //x=49.18 //y=1.685
r58 (  18 35 ) resistor r=5.4201 //w=0.17 //l=0.103078 //layer=li \
 //thickness=0.1 //x=50.235 //y=1.77 //x2=50.15 //y2=1.81
r59 (  18 35 ) resistor r=27.3797 //w=0.187 //l=0.4 //layer=li //thickness=0.1 \
 //x=50.235 //y=1.77 //x2=50.635 //y2=1.77
r60 (  17 35 ) resistor r=0.751729 //w=0.17 //l=0.085 //layer=li \
 //thickness=0.1 //x=51.035 //y=1.77 //x2=51.12 //y2=1.77
r61 (  17 35 ) resistor r=27.3797 //w=0.187 //l=0.4 //layer=li //thickness=0.1 \
 //x=51.035 //y=1.77 //x2=50.635 //y2=1.77
r62 (  14 35 ) resistor r=3.57586 //w=0.17 //l=0.103078 //layer=li \
 //thickness=0.1 //x=50.235 //y=0.72 //x2=50.15 //y2=0.68
r63 (  14 35 ) resistor r=27.3797 //w=0.187 //l=0.4 //layer=li //thickness=0.1 \
 //x=50.235 //y=0.72 //x2=50.635 //y2=0.72
r64 (  13 35 ) resistor r=0.751729 //w=0.17 //l=0.085 //layer=li \
 //thickness=0.1 //x=51.035 //y=0.72 //x2=51.12 //y2=0.72
r65 (  13 35 ) resistor r=27.3797 //w=0.187 //l=0.4 //layer=li //thickness=0.1 \
 //x=51.035 //y=0.72 //x2=50.635 //y2=0.72
r66 (  10 35 ) resistor r=1.40859 //w=0.34 //l=0.125 //layer=li \
 //thickness=0.1 //x=50.15 //y=1.685 //x2=50.15 //y2=1.81
r67 (  10 35 ) resistor r=42.0963 //w=0.187 //l=0.615 //layer=li \
 //thickness=0.1 //x=50.15 //y=1.685 //x2=50.15 //y2=1.07
r68 (  9 35 ) resistor r=3.57586 //w=0.17 //l=0.125 //layer=li //thickness=0.1 \
 //x=50.15 //y=0.805 //x2=50.15 //y2=0.68
r69 (  9 35 ) resistor r=18.139 //w=0.187 //l=0.265 //layer=li //thickness=0.1 \
 //x=50.15 //y=0.805 //x2=50.15 //y2=1.07
r70 (  6 35 ) resistor r=3.57586 //w=0.17 //l=0.103078 //layer=li \
 //thickness=0.1 //x=49.265 //y=1.77 //x2=49.18 //y2=1.81
r71 (  6 35 ) resistor r=27.3797 //w=0.187 //l=0.4 //layer=li //thickness=0.1 \
 //x=49.265 //y=1.77 //x2=49.665 //y2=1.77
r72 (  5 35 ) resistor r=5.4201 //w=0.17 //l=0.103078 //layer=li \
 //thickness=0.1 //x=50.065 //y=1.77 //x2=50.15 //y2=1.81
r73 (  5 35 ) resistor r=27.3797 //w=0.187 //l=0.4 //layer=li //thickness=0.1 \
 //x=50.065 //y=1.77 //x2=49.665 //y2=1.77
r74 (  1 35 ) resistor r=3.57586 //w=0.17 //l=0.125 //layer=li //thickness=0.1 \
 //x=49.18 //y=1.685 //x2=49.18 //y2=1.81
r75 (  1 35 ) resistor r=42.0963 //w=0.187 //l=0.615 //layer=li \
 //thickness=0.1 //x=49.18 //y=1.685 //x2=49.18 //y2=1.07
ends PM_TMRDFFSNRNQX1\%noxref_49

subckt PM_TMRDFFSNRNQX1\%noxref_50 ( 1 3 11 15 25 28 29 )
c52 ( 29 0 ) capacitor c=0.0414744f //x=51.555 //y=0.555
c53 ( 28 0 ) capacitor c=0.00457437f //x=50.45 //y=1.09
c54 ( 25 0 ) capacitor c=0.00156479f //x=51.69 //y=1.175
c55 ( 15 0 ) capacitor c=0.00737666f //x=52.66 //y=0.805
c56 ( 11 0 ) capacitor c=0.0144274f //x=52.575 //y=0.72
c57 ( 3 0 ) capacitor c=0.00718386f //x=51.69 //y=0.805
c58 ( 1 0 ) capacitor c=0.0218873f //x=51.605 //y=1.175
r59 (  15 29 ) resistor r=3.57586 //w=0.17 //l=0.125 //layer=li \
 //thickness=0.1 //x=52.66 //y=0.805 //x2=52.66 //y2=0.68
r60 (  15 29 ) resistor r=18.139 //w=0.187 //l=0.265 //layer=li \
 //thickness=0.1 //x=52.66 //y=0.805 //x2=52.66 //y2=1.07
r61 (  12 29 ) resistor r=3.57586 //w=0.17 //l=0.103078 //layer=li \
 //thickness=0.1 //x=51.775 //y=0.72 //x2=51.69 //y2=0.68
r62 (  12 29 ) resistor r=27.3797 //w=0.187 //l=0.4 //layer=li //thickness=0.1 \
 //x=51.775 //y=0.72 //x2=52.175 //y2=0.72
r63 (  11 29 ) resistor r=3.57586 //w=0.17 //l=0.103078 //layer=li \
 //thickness=0.1 //x=52.575 //y=0.72 //x2=52.66 //y2=0.68
r64 (  11 29 ) resistor r=27.3797 //w=0.187 //l=0.4 //layer=li //thickness=0.1 \
 //x=52.575 //y=0.72 //x2=52.175 //y2=0.72
r65 (  7 25 ) resistor r=5.4201 //w=0.17 //l=0.085 //layer=li //thickness=0.1 \
 //x=51.69 //y=1.26 //x2=51.69 //y2=1.175
r66 (  7 29 ) resistor r=10.2674 //w=0.187 //l=0.15 //layer=li //thickness=0.1 \
 //x=51.69 //y=1.26 //x2=51.69 //y2=1.41
r67 (  4 25 ) resistor r=5.4201 //w=0.17 //l=0.085 //layer=li //thickness=0.1 \
 //x=51.69 //y=1.09 //x2=51.69 //y2=1.175
r68 (  4 29 ) resistor r=1.36898 //w=0.187 //l=0.02 //layer=li //thickness=0.1 \
 //x=51.69 //y=1.09 //x2=51.69 //y2=1.07
r69 (  3 29 ) resistor r=3.57586 //w=0.17 //l=0.125 //layer=li //thickness=0.1 \
 //x=51.69 //y=0.805 //x2=51.69 //y2=0.68
r70 (  3 29 ) resistor r=18.139 //w=0.187 //l=0.265 //layer=li //thickness=0.1 \
 //x=51.69 //y=0.805 //x2=51.69 //y2=1.07
r71 (  2 28 ) resistor r=0.751729 //w=0.17 //l=0.085 //layer=li \
 //thickness=0.1 //x=50.725 //y=1.175 //x2=50.64 //y2=1.175
r72 (  1 25 ) resistor r=1.40859 //w=0.34 //l=0.085 //layer=li //thickness=0.1 \
 //x=51.605 //y=1.175 //x2=51.69 //y2=1.175
r73 (  1 2 ) resistor r=60.2353 //w=0.187 //l=0.88 //layer=li //thickness=0.1 \
 //x=51.605 //y=1.175 //x2=50.725 //y2=1.175
ends PM_TMRDFFSNRNQX1\%noxref_50

subckt PM_TMRDFFSNRNQX1\%noxref_51 ( 1 5 9 13 17 35 )
c49 ( 35 0 ) capacitor c=0.0673029f //x=53.855 //y=0.555
c50 ( 17 0 ) capacitor c=0.0178317f //x=55.845 //y=1.77
c51 ( 13 0 ) capacitor c=0.0154936f //x=55.845 //y=0.72
c52 ( 9 0 ) capacitor c=0.00678203f //x=54.96 //y=0.805
c53 ( 5 0 ) capacitor c=0.0164013f //x=54.875 //y=1.77
c54 ( 1 0 ) capacitor c=0.00696517f //x=53.99 //y=1.685
r55 (  18 35 ) resistor r=5.4201 //w=0.17 //l=0.103078 //layer=li \
 //thickness=0.1 //x=55.045 //y=1.77 //x2=54.96 //y2=1.81
r56 (  18 35 ) resistor r=27.3797 //w=0.187 //l=0.4 //layer=li //thickness=0.1 \
 //x=55.045 //y=1.77 //x2=55.445 //y2=1.77
r57 (  17 35 ) resistor r=0.751729 //w=0.17 //l=0.085 //layer=li \
 //thickness=0.1 //x=55.845 //y=1.77 //x2=55.93 //y2=1.77
r58 (  17 35 ) resistor r=27.3797 //w=0.187 //l=0.4 //layer=li //thickness=0.1 \
 //x=55.845 //y=1.77 //x2=55.445 //y2=1.77
r59 (  14 35 ) resistor r=3.57586 //w=0.17 //l=0.103078 //layer=li \
 //thickness=0.1 //x=55.045 //y=0.72 //x2=54.96 //y2=0.68
r60 (  14 35 ) resistor r=27.3797 //w=0.187 //l=0.4 //layer=li //thickness=0.1 \
 //x=55.045 //y=0.72 //x2=55.445 //y2=0.72
r61 (  13 35 ) resistor r=0.751729 //w=0.17 //l=0.085 //layer=li \
 //thickness=0.1 //x=55.845 //y=0.72 //x2=55.93 //y2=0.72
r62 (  13 35 ) resistor r=27.3797 //w=0.187 //l=0.4 //layer=li //thickness=0.1 \
 //x=55.845 //y=0.72 //x2=55.445 //y2=0.72
r63 (  10 35 ) resistor r=1.40859 //w=0.34 //l=0.125 //layer=li \
 //thickness=0.1 //x=54.96 //y=1.685 //x2=54.96 //y2=1.81
r64 (  10 35 ) resistor r=42.0963 //w=0.187 //l=0.615 //layer=li \
 //thickness=0.1 //x=54.96 //y=1.685 //x2=54.96 //y2=1.07
r65 (  9 35 ) resistor r=3.57586 //w=0.17 //l=0.125 //layer=li //thickness=0.1 \
 //x=54.96 //y=0.805 //x2=54.96 //y2=0.68
r66 (  9 35 ) resistor r=18.139 //w=0.187 //l=0.265 //layer=li //thickness=0.1 \
 //x=54.96 //y=0.805 //x2=54.96 //y2=1.07
r67 (  6 35 ) resistor r=3.57586 //w=0.17 //l=0.103078 //layer=li \
 //thickness=0.1 //x=54.075 //y=1.77 //x2=53.99 //y2=1.81
r68 (  6 35 ) resistor r=27.3797 //w=0.187 //l=0.4 //layer=li //thickness=0.1 \
 //x=54.075 //y=1.77 //x2=54.475 //y2=1.77
r69 (  5 35 ) resistor r=5.4201 //w=0.17 //l=0.103078 //layer=li \
 //thickness=0.1 //x=54.875 //y=1.77 //x2=54.96 //y2=1.81
r70 (  5 35 ) resistor r=27.3797 //w=0.187 //l=0.4 //layer=li //thickness=0.1 \
 //x=54.875 //y=1.77 //x2=54.475 //y2=1.77
r71 (  1 35 ) resistor r=3.57586 //w=0.17 //l=0.125 //layer=li //thickness=0.1 \
 //x=53.99 //y=1.685 //x2=53.99 //y2=1.81
r72 (  1 35 ) resistor r=42.0963 //w=0.187 //l=0.615 //layer=li \
 //thickness=0.1 //x=53.99 //y=1.685 //x2=53.99 //y2=1.07
ends PM_TMRDFFSNRNQX1\%noxref_51

subckt PM_TMRDFFSNRNQX1\%noxref_52 ( 1 3 11 15 25 28 29 )
c52 ( 29 0 ) capacitor c=0.0413887f //x=56.365 //y=0.555
c53 ( 28 0 ) capacitor c=0.0045748f //x=55.26 //y=1.09
c54 ( 25 0 ) capacitor c=0.00156479f //x=56.5 //y=1.175
c55 ( 15 0 ) capacitor c=0.00737666f //x=57.47 //y=0.805
c56 ( 11 0 ) capacitor c=0.0144274f //x=57.385 //y=0.72
c57 ( 3 0 ) capacitor c=0.00718386f //x=56.5 //y=0.805
c58 ( 1 0 ) capacitor c=0.0218888f //x=56.415 //y=1.175
r59 (  15 29 ) resistor r=3.57586 //w=0.17 //l=0.125 //layer=li \
 //thickness=0.1 //x=57.47 //y=0.805 //x2=57.47 //y2=0.68
r60 (  15 29 ) resistor r=18.139 //w=0.187 //l=0.265 //layer=li \
 //thickness=0.1 //x=57.47 //y=0.805 //x2=57.47 //y2=1.07
r61 (  12 29 ) resistor r=3.57586 //w=0.17 //l=0.103078 //layer=li \
 //thickness=0.1 //x=56.585 //y=0.72 //x2=56.5 //y2=0.68
r62 (  12 29 ) resistor r=27.3797 //w=0.187 //l=0.4 //layer=li //thickness=0.1 \
 //x=56.585 //y=0.72 //x2=56.985 //y2=0.72
r63 (  11 29 ) resistor r=3.57586 //w=0.17 //l=0.103078 //layer=li \
 //thickness=0.1 //x=57.385 //y=0.72 //x2=57.47 //y2=0.68
r64 (  11 29 ) resistor r=27.3797 //w=0.187 //l=0.4 //layer=li //thickness=0.1 \
 //x=57.385 //y=0.72 //x2=56.985 //y2=0.72
r65 (  7 25 ) resistor r=5.4201 //w=0.17 //l=0.085 //layer=li //thickness=0.1 \
 //x=56.5 //y=1.26 //x2=56.5 //y2=1.175
r66 (  7 29 ) resistor r=10.2674 //w=0.187 //l=0.15 //layer=li //thickness=0.1 \
 //x=56.5 //y=1.26 //x2=56.5 //y2=1.41
r67 (  4 25 ) resistor r=5.4201 //w=0.17 //l=0.085 //layer=li //thickness=0.1 \
 //x=56.5 //y=1.09 //x2=56.5 //y2=1.175
r68 (  4 29 ) resistor r=1.36898 //w=0.187 //l=0.02 //layer=li //thickness=0.1 \
 //x=56.5 //y=1.09 //x2=56.5 //y2=1.07
r69 (  3 29 ) resistor r=3.57586 //w=0.17 //l=0.125 //layer=li //thickness=0.1 \
 //x=56.5 //y=0.805 //x2=56.5 //y2=0.68
r70 (  3 29 ) resistor r=18.139 //w=0.187 //l=0.265 //layer=li //thickness=0.1 \
 //x=56.5 //y=0.805 //x2=56.5 //y2=1.07
r71 (  2 28 ) resistor r=0.751729 //w=0.17 //l=0.085 //layer=li \
 //thickness=0.1 //x=55.535 //y=1.175 //x2=55.45 //y2=1.175
r72 (  1 25 ) resistor r=1.40859 //w=0.34 //l=0.085 //layer=li //thickness=0.1 \
 //x=56.415 //y=1.175 //x2=56.5 //y2=1.175
r73 (  1 2 ) resistor r=60.2353 //w=0.187 //l=0.88 //layer=li //thickness=0.1 \
 //x=56.415 //y=1.175 //x2=55.535 //y2=1.175
ends PM_TMRDFFSNRNQX1\%noxref_52

subckt PM_TMRDFFSNRNQX1\%noxref_53 ( 1 5 9 13 17 35 )
c52 ( 35 0 ) capacitor c=0.0673029f //x=58.665 //y=0.555
c53 ( 17 0 ) capacitor c=0.0178286f //x=60.655 //y=1.77
c54 ( 13 0 ) capacitor c=0.0154917f //x=60.655 //y=0.72
c55 ( 9 0 ) capacitor c=0.00678203f //x=59.77 //y=0.805
c56 ( 5 0 ) capacitor c=0.0164013f //x=59.685 //y=1.77
c57 ( 1 0 ) capacitor c=0.00696517f //x=58.8 //y=1.685
r58 (  18 35 ) resistor r=5.4201 //w=0.17 //l=0.103078 //layer=li \
 //thickness=0.1 //x=59.855 //y=1.77 //x2=59.77 //y2=1.81
r59 (  18 35 ) resistor r=27.3797 //w=0.187 //l=0.4 //layer=li //thickness=0.1 \
 //x=59.855 //y=1.77 //x2=60.255 //y2=1.77
r60 (  17 35 ) resistor r=0.751729 //w=0.17 //l=0.085 //layer=li \
 //thickness=0.1 //x=60.655 //y=1.77 //x2=60.74 //y2=1.77
r61 (  17 35 ) resistor r=27.3797 //w=0.187 //l=0.4 //layer=li //thickness=0.1 \
 //x=60.655 //y=1.77 //x2=60.255 //y2=1.77
r62 (  14 35 ) resistor r=3.57586 //w=0.17 //l=0.103078 //layer=li \
 //thickness=0.1 //x=59.855 //y=0.72 //x2=59.77 //y2=0.68
r63 (  14 35 ) resistor r=27.3797 //w=0.187 //l=0.4 //layer=li //thickness=0.1 \
 //x=59.855 //y=0.72 //x2=60.255 //y2=0.72
r64 (  13 35 ) resistor r=0.751729 //w=0.17 //l=0.085 //layer=li \
 //thickness=0.1 //x=60.655 //y=0.72 //x2=60.74 //y2=0.72
r65 (  13 35 ) resistor r=27.3797 //w=0.187 //l=0.4 //layer=li //thickness=0.1 \
 //x=60.655 //y=0.72 //x2=60.255 //y2=0.72
r66 (  10 35 ) resistor r=1.40859 //w=0.34 //l=0.125 //layer=li \
 //thickness=0.1 //x=59.77 //y=1.685 //x2=59.77 //y2=1.81
r67 (  10 35 ) resistor r=42.0963 //w=0.187 //l=0.615 //layer=li \
 //thickness=0.1 //x=59.77 //y=1.685 //x2=59.77 //y2=1.07
r68 (  9 35 ) resistor r=3.57586 //w=0.17 //l=0.125 //layer=li //thickness=0.1 \
 //x=59.77 //y=0.805 //x2=59.77 //y2=0.68
r69 (  9 35 ) resistor r=18.139 //w=0.187 //l=0.265 //layer=li //thickness=0.1 \
 //x=59.77 //y=0.805 //x2=59.77 //y2=1.07
r70 (  6 35 ) resistor r=3.57586 //w=0.17 //l=0.103078 //layer=li \
 //thickness=0.1 //x=58.885 //y=1.77 //x2=58.8 //y2=1.81
r71 (  6 35 ) resistor r=27.3797 //w=0.187 //l=0.4 //layer=li //thickness=0.1 \
 //x=58.885 //y=1.77 //x2=59.285 //y2=1.77
r72 (  5 35 ) resistor r=5.4201 //w=0.17 //l=0.103078 //layer=li \
 //thickness=0.1 //x=59.685 //y=1.77 //x2=59.77 //y2=1.81
r73 (  5 35 ) resistor r=27.3797 //w=0.187 //l=0.4 //layer=li //thickness=0.1 \
 //x=59.685 //y=1.77 //x2=59.285 //y2=1.77
r74 (  1 35 ) resistor r=3.57586 //w=0.17 //l=0.125 //layer=li //thickness=0.1 \
 //x=58.8 //y=1.685 //x2=58.8 //y2=1.81
r75 (  1 35 ) resistor r=42.0963 //w=0.187 //l=0.615 //layer=li \
 //thickness=0.1 //x=58.8 //y=1.685 //x2=58.8 //y2=1.07
ends PM_TMRDFFSNRNQX1\%noxref_53

subckt PM_TMRDFFSNRNQX1\%noxref_54 ( 1 3 11 15 25 28 29 )
c52 ( 29 0 ) capacitor c=0.0414744f //x=61.175 //y=0.555
c53 ( 28 0 ) capacitor c=0.00457437f //x=60.07 //y=1.09
c54 ( 25 0 ) capacitor c=0.00156479f //x=61.31 //y=1.175
c55 ( 15 0 ) capacitor c=0.00737666f //x=62.28 //y=0.805
c56 ( 11 0 ) capacitor c=0.0144274f //x=62.195 //y=0.72
c57 ( 3 0 ) capacitor c=0.00718386f //x=61.31 //y=0.805
c58 ( 1 0 ) capacitor c=0.0218873f //x=61.225 //y=1.175
r59 (  15 29 ) resistor r=3.57586 //w=0.17 //l=0.125 //layer=li \
 //thickness=0.1 //x=62.28 //y=0.805 //x2=62.28 //y2=0.68
r60 (  15 29 ) resistor r=18.139 //w=0.187 //l=0.265 //layer=li \
 //thickness=0.1 //x=62.28 //y=0.805 //x2=62.28 //y2=1.07
r61 (  12 29 ) resistor r=3.57586 //w=0.17 //l=0.103078 //layer=li \
 //thickness=0.1 //x=61.395 //y=0.72 //x2=61.31 //y2=0.68
r62 (  12 29 ) resistor r=27.3797 //w=0.187 //l=0.4 //layer=li //thickness=0.1 \
 //x=61.395 //y=0.72 //x2=61.795 //y2=0.72
r63 (  11 29 ) resistor r=3.57586 //w=0.17 //l=0.103078 //layer=li \
 //thickness=0.1 //x=62.195 //y=0.72 //x2=62.28 //y2=0.68
r64 (  11 29 ) resistor r=27.3797 //w=0.187 //l=0.4 //layer=li //thickness=0.1 \
 //x=62.195 //y=0.72 //x2=61.795 //y2=0.72
r65 (  7 25 ) resistor r=5.4201 //w=0.17 //l=0.085 //layer=li //thickness=0.1 \
 //x=61.31 //y=1.26 //x2=61.31 //y2=1.175
r66 (  7 29 ) resistor r=10.2674 //w=0.187 //l=0.15 //layer=li //thickness=0.1 \
 //x=61.31 //y=1.26 //x2=61.31 //y2=1.41
r67 (  4 25 ) resistor r=5.4201 //w=0.17 //l=0.085 //layer=li //thickness=0.1 \
 //x=61.31 //y=1.09 //x2=61.31 //y2=1.175
r68 (  4 29 ) resistor r=1.36898 //w=0.187 //l=0.02 //layer=li //thickness=0.1 \
 //x=61.31 //y=1.09 //x2=61.31 //y2=1.07
r69 (  3 29 ) resistor r=3.57586 //w=0.17 //l=0.125 //layer=li //thickness=0.1 \
 //x=61.31 //y=0.805 //x2=61.31 //y2=0.68
r70 (  3 29 ) resistor r=18.139 //w=0.187 //l=0.265 //layer=li //thickness=0.1 \
 //x=61.31 //y=0.805 //x2=61.31 //y2=1.07
r71 (  2 28 ) resistor r=0.751729 //w=0.17 //l=0.085 //layer=li \
 //thickness=0.1 //x=60.345 //y=1.175 //x2=60.26 //y2=1.175
r72 (  1 25 ) resistor r=1.40859 //w=0.34 //l=0.085 //layer=li //thickness=0.1 \
 //x=61.225 //y=1.175 //x2=61.31 //y2=1.175
r73 (  1 2 ) resistor r=60.2353 //w=0.187 //l=0.88 //layer=li //thickness=0.1 \
 //x=61.225 //y=1.175 //x2=60.345 //y2=1.175
ends PM_TMRDFFSNRNQX1\%noxref_54

subckt PM_TMRDFFSNRNQX1\%noxref_55 ( 1 5 9 13 17 35 )
c49 ( 35 0 ) capacitor c=0.0673029f //x=63.475 //y=0.555
c50 ( 17 0 ) capacitor c=0.0178317f //x=65.465 //y=1.77
c51 ( 13 0 ) capacitor c=0.0154936f //x=65.465 //y=0.72
c52 ( 9 0 ) capacitor c=0.00678203f //x=64.58 //y=0.805
c53 ( 5 0 ) capacitor c=0.0164013f //x=64.495 //y=1.77
c54 ( 1 0 ) capacitor c=0.00696517f //x=63.61 //y=1.685
r55 (  18 35 ) resistor r=5.4201 //w=0.17 //l=0.103078 //layer=li \
 //thickness=0.1 //x=64.665 //y=1.77 //x2=64.58 //y2=1.81
r56 (  18 35 ) resistor r=27.3797 //w=0.187 //l=0.4 //layer=li //thickness=0.1 \
 //x=64.665 //y=1.77 //x2=65.065 //y2=1.77
r57 (  17 35 ) resistor r=0.751729 //w=0.17 //l=0.085 //layer=li \
 //thickness=0.1 //x=65.465 //y=1.77 //x2=65.55 //y2=1.77
r58 (  17 35 ) resistor r=27.3797 //w=0.187 //l=0.4 //layer=li //thickness=0.1 \
 //x=65.465 //y=1.77 //x2=65.065 //y2=1.77
r59 (  14 35 ) resistor r=3.57586 //w=0.17 //l=0.103078 //layer=li \
 //thickness=0.1 //x=64.665 //y=0.72 //x2=64.58 //y2=0.68
r60 (  14 35 ) resistor r=27.3797 //w=0.187 //l=0.4 //layer=li //thickness=0.1 \
 //x=64.665 //y=0.72 //x2=65.065 //y2=0.72
r61 (  13 35 ) resistor r=0.751729 //w=0.17 //l=0.085 //layer=li \
 //thickness=0.1 //x=65.465 //y=0.72 //x2=65.55 //y2=0.72
r62 (  13 35 ) resistor r=27.3797 //w=0.187 //l=0.4 //layer=li //thickness=0.1 \
 //x=65.465 //y=0.72 //x2=65.065 //y2=0.72
r63 (  10 35 ) resistor r=1.40859 //w=0.34 //l=0.125 //layer=li \
 //thickness=0.1 //x=64.58 //y=1.685 //x2=64.58 //y2=1.81
r64 (  10 35 ) resistor r=42.0963 //w=0.187 //l=0.615 //layer=li \
 //thickness=0.1 //x=64.58 //y=1.685 //x2=64.58 //y2=1.07
r65 (  9 35 ) resistor r=3.57586 //w=0.17 //l=0.125 //layer=li //thickness=0.1 \
 //x=64.58 //y=0.805 //x2=64.58 //y2=0.68
r66 (  9 35 ) resistor r=18.139 //w=0.187 //l=0.265 //layer=li //thickness=0.1 \
 //x=64.58 //y=0.805 //x2=64.58 //y2=1.07
r67 (  6 35 ) resistor r=3.57586 //w=0.17 //l=0.103078 //layer=li \
 //thickness=0.1 //x=63.695 //y=1.77 //x2=63.61 //y2=1.81
r68 (  6 35 ) resistor r=27.3797 //w=0.187 //l=0.4 //layer=li //thickness=0.1 \
 //x=63.695 //y=1.77 //x2=64.095 //y2=1.77
r69 (  5 35 ) resistor r=5.4201 //w=0.17 //l=0.103078 //layer=li \
 //thickness=0.1 //x=64.495 //y=1.77 //x2=64.58 //y2=1.81
r70 (  5 35 ) resistor r=27.3797 //w=0.187 //l=0.4 //layer=li //thickness=0.1 \
 //x=64.495 //y=1.77 //x2=64.095 //y2=1.77
r71 (  1 35 ) resistor r=3.57586 //w=0.17 //l=0.125 //layer=li //thickness=0.1 \
 //x=63.61 //y=1.685 //x2=63.61 //y2=1.81
r72 (  1 35 ) resistor r=42.0963 //w=0.187 //l=0.615 //layer=li \
 //thickness=0.1 //x=63.61 //y=1.685 //x2=63.61 //y2=1.07
ends PM_TMRDFFSNRNQX1\%noxref_55

subckt PM_TMRDFFSNRNQX1\%noxref_56 ( 1 3 11 15 25 28 29 )
c52 ( 29 0 ) capacitor c=0.0413887f //x=65.985 //y=0.555
c53 ( 28 0 ) capacitor c=0.0045748f //x=64.88 //y=1.09
c54 ( 25 0 ) capacitor c=0.00156479f //x=66.12 //y=1.175
c55 ( 15 0 ) capacitor c=0.00737666f //x=67.09 //y=0.805
c56 ( 11 0 ) capacitor c=0.0144274f //x=67.005 //y=0.72
c57 ( 3 0 ) capacitor c=0.00718386f //x=66.12 //y=0.805
c58 ( 1 0 ) capacitor c=0.0218888f //x=66.035 //y=1.175
r59 (  15 29 ) resistor r=3.57586 //w=0.17 //l=0.125 //layer=li \
 //thickness=0.1 //x=67.09 //y=0.805 //x2=67.09 //y2=0.68
r60 (  15 29 ) resistor r=18.139 //w=0.187 //l=0.265 //layer=li \
 //thickness=0.1 //x=67.09 //y=0.805 //x2=67.09 //y2=1.07
r61 (  12 29 ) resistor r=3.57586 //w=0.17 //l=0.103078 //layer=li \
 //thickness=0.1 //x=66.205 //y=0.72 //x2=66.12 //y2=0.68
r62 (  12 29 ) resistor r=27.3797 //w=0.187 //l=0.4 //layer=li //thickness=0.1 \
 //x=66.205 //y=0.72 //x2=66.605 //y2=0.72
r63 (  11 29 ) resistor r=3.57586 //w=0.17 //l=0.103078 //layer=li \
 //thickness=0.1 //x=67.005 //y=0.72 //x2=67.09 //y2=0.68
r64 (  11 29 ) resistor r=27.3797 //w=0.187 //l=0.4 //layer=li //thickness=0.1 \
 //x=67.005 //y=0.72 //x2=66.605 //y2=0.72
r65 (  7 25 ) resistor r=5.4201 //w=0.17 //l=0.085 //layer=li //thickness=0.1 \
 //x=66.12 //y=1.26 //x2=66.12 //y2=1.175
r66 (  7 29 ) resistor r=10.2674 //w=0.187 //l=0.15 //layer=li //thickness=0.1 \
 //x=66.12 //y=1.26 //x2=66.12 //y2=1.41
r67 (  4 25 ) resistor r=5.4201 //w=0.17 //l=0.085 //layer=li //thickness=0.1 \
 //x=66.12 //y=1.09 //x2=66.12 //y2=1.175
r68 (  4 29 ) resistor r=1.36898 //w=0.187 //l=0.02 //layer=li //thickness=0.1 \
 //x=66.12 //y=1.09 //x2=66.12 //y2=1.07
r69 (  3 29 ) resistor r=3.57586 //w=0.17 //l=0.125 //layer=li //thickness=0.1 \
 //x=66.12 //y=0.805 //x2=66.12 //y2=0.68
r70 (  3 29 ) resistor r=18.139 //w=0.187 //l=0.265 //layer=li //thickness=0.1 \
 //x=66.12 //y=0.805 //x2=66.12 //y2=1.07
r71 (  2 28 ) resistor r=0.751729 //w=0.17 //l=0.085 //layer=li \
 //thickness=0.1 //x=65.155 //y=1.175 //x2=65.07 //y2=1.175
r72 (  1 25 ) resistor r=1.40859 //w=0.34 //l=0.085 //layer=li //thickness=0.1 \
 //x=66.035 //y=1.175 //x2=66.12 //y2=1.175
r73 (  1 2 ) resistor r=60.2353 //w=0.187 //l=0.88 //layer=li //thickness=0.1 \
 //x=66.035 //y=1.175 //x2=65.155 //y2=1.175
ends PM_TMRDFFSNRNQX1\%noxref_56

subckt PM_TMRDFFSNRNQX1\%noxref_57 ( 1 5 9 13 17 35 )
c49 ( 35 0 ) capacitor c=0.0673029f //x=68.285 //y=0.555
c50 ( 17 0 ) capacitor c=0.0178317f //x=70.275 //y=1.77
c51 ( 13 0 ) capacitor c=0.0154936f //x=70.275 //y=0.72
c52 ( 9 0 ) capacitor c=0.00678203f //x=69.39 //y=0.805
c53 ( 5 0 ) capacitor c=0.0164013f //x=69.305 //y=1.77
c54 ( 1 0 ) capacitor c=0.00696517f //x=68.42 //y=1.685
r55 (  18 35 ) resistor r=5.4201 //w=0.17 //l=0.103078 //layer=li \
 //thickness=0.1 //x=69.475 //y=1.77 //x2=69.39 //y2=1.81
r56 (  18 35 ) resistor r=27.3797 //w=0.187 //l=0.4 //layer=li //thickness=0.1 \
 //x=69.475 //y=1.77 //x2=69.875 //y2=1.77
r57 (  17 35 ) resistor r=0.751729 //w=0.17 //l=0.085 //layer=li \
 //thickness=0.1 //x=70.275 //y=1.77 //x2=70.36 //y2=1.77
r58 (  17 35 ) resistor r=27.3797 //w=0.187 //l=0.4 //layer=li //thickness=0.1 \
 //x=70.275 //y=1.77 //x2=69.875 //y2=1.77
r59 (  14 35 ) resistor r=3.57586 //w=0.17 //l=0.103078 //layer=li \
 //thickness=0.1 //x=69.475 //y=0.72 //x2=69.39 //y2=0.68
r60 (  14 35 ) resistor r=27.3797 //w=0.187 //l=0.4 //layer=li //thickness=0.1 \
 //x=69.475 //y=0.72 //x2=69.875 //y2=0.72
r61 (  13 35 ) resistor r=0.751729 //w=0.17 //l=0.085 //layer=li \
 //thickness=0.1 //x=70.275 //y=0.72 //x2=70.36 //y2=0.72
r62 (  13 35 ) resistor r=27.3797 //w=0.187 //l=0.4 //layer=li //thickness=0.1 \
 //x=70.275 //y=0.72 //x2=69.875 //y2=0.72
r63 (  10 35 ) resistor r=1.40859 //w=0.34 //l=0.125 //layer=li \
 //thickness=0.1 //x=69.39 //y=1.685 //x2=69.39 //y2=1.81
r64 (  10 35 ) resistor r=42.0963 //w=0.187 //l=0.615 //layer=li \
 //thickness=0.1 //x=69.39 //y=1.685 //x2=69.39 //y2=1.07
r65 (  9 35 ) resistor r=3.57586 //w=0.17 //l=0.125 //layer=li //thickness=0.1 \
 //x=69.39 //y=0.805 //x2=69.39 //y2=0.68
r66 (  9 35 ) resistor r=18.139 //w=0.187 //l=0.265 //layer=li //thickness=0.1 \
 //x=69.39 //y=0.805 //x2=69.39 //y2=1.07
r67 (  6 35 ) resistor r=3.57586 //w=0.17 //l=0.103078 //layer=li \
 //thickness=0.1 //x=68.505 //y=1.77 //x2=68.42 //y2=1.81
r68 (  6 35 ) resistor r=27.3797 //w=0.187 //l=0.4 //layer=li //thickness=0.1 \
 //x=68.505 //y=1.77 //x2=68.905 //y2=1.77
r69 (  5 35 ) resistor r=5.4201 //w=0.17 //l=0.103078 //layer=li \
 //thickness=0.1 //x=69.305 //y=1.77 //x2=69.39 //y2=1.81
r70 (  5 35 ) resistor r=27.3797 //w=0.187 //l=0.4 //layer=li //thickness=0.1 \
 //x=69.305 //y=1.77 //x2=68.905 //y2=1.77
r71 (  1 35 ) resistor r=3.57586 //w=0.17 //l=0.125 //layer=li //thickness=0.1 \
 //x=68.42 //y=1.685 //x2=68.42 //y2=1.81
r72 (  1 35 ) resistor r=42.0963 //w=0.187 //l=0.615 //layer=li \
 //thickness=0.1 //x=68.42 //y=1.685 //x2=68.42 //y2=1.07
ends PM_TMRDFFSNRNQX1\%noxref_57

subckt PM_TMRDFFSNRNQX1\%noxref_58 ( 1 3 11 15 25 28 29 )
c52 ( 29 0 ) capacitor c=0.0414744f //x=70.795 //y=0.555
c53 ( 28 0 ) capacitor c=0.0045748f //x=69.69 //y=1.09
c54 ( 25 0 ) capacitor c=0.00156479f //x=70.93 //y=1.175
c55 ( 15 0 ) capacitor c=0.00737666f //x=71.9 //y=0.805
c56 ( 11 0 ) capacitor c=0.0144274f //x=71.815 //y=0.72
c57 ( 3 0 ) capacitor c=0.00718386f //x=70.93 //y=0.805
c58 ( 1 0 ) capacitor c=0.0218888f //x=70.845 //y=1.175
r59 (  15 29 ) resistor r=3.57586 //w=0.17 //l=0.125 //layer=li \
 //thickness=0.1 //x=71.9 //y=0.805 //x2=71.9 //y2=0.68
r60 (  15 29 ) resistor r=18.139 //w=0.187 //l=0.265 //layer=li \
 //thickness=0.1 //x=71.9 //y=0.805 //x2=71.9 //y2=1.07
r61 (  12 29 ) resistor r=3.57586 //w=0.17 //l=0.103078 //layer=li \
 //thickness=0.1 //x=71.015 //y=0.72 //x2=70.93 //y2=0.68
r62 (  12 29 ) resistor r=27.3797 //w=0.187 //l=0.4 //layer=li //thickness=0.1 \
 //x=71.015 //y=0.72 //x2=71.415 //y2=0.72
r63 (  11 29 ) resistor r=3.57586 //w=0.17 //l=0.103078 //layer=li \
 //thickness=0.1 //x=71.815 //y=0.72 //x2=71.9 //y2=0.68
r64 (  11 29 ) resistor r=27.3797 //w=0.187 //l=0.4 //layer=li //thickness=0.1 \
 //x=71.815 //y=0.72 //x2=71.415 //y2=0.72
r65 (  7 25 ) resistor r=5.4201 //w=0.17 //l=0.085 //layer=li //thickness=0.1 \
 //x=70.93 //y=1.26 //x2=70.93 //y2=1.175
r66 (  7 29 ) resistor r=10.2674 //w=0.187 //l=0.15 //layer=li //thickness=0.1 \
 //x=70.93 //y=1.26 //x2=70.93 //y2=1.41
r67 (  4 25 ) resistor r=5.4201 //w=0.17 //l=0.085 //layer=li //thickness=0.1 \
 //x=70.93 //y=1.09 //x2=70.93 //y2=1.175
r68 (  4 29 ) resistor r=1.36898 //w=0.187 //l=0.02 //layer=li //thickness=0.1 \
 //x=70.93 //y=1.09 //x2=70.93 //y2=1.07
r69 (  3 29 ) resistor r=3.57586 //w=0.17 //l=0.125 //layer=li //thickness=0.1 \
 //x=70.93 //y=0.805 //x2=70.93 //y2=0.68
r70 (  3 29 ) resistor r=18.139 //w=0.187 //l=0.265 //layer=li //thickness=0.1 \
 //x=70.93 //y=0.805 //x2=70.93 //y2=1.07
r71 (  2 28 ) resistor r=0.751729 //w=0.17 //l=0.085 //layer=li \
 //thickness=0.1 //x=69.965 //y=1.175 //x2=69.88 //y2=1.175
r72 (  1 25 ) resistor r=1.40859 //w=0.34 //l=0.085 //layer=li //thickness=0.1 \
 //x=70.845 //y=1.175 //x2=70.93 //y2=1.175
r73 (  1 2 ) resistor r=60.2353 //w=0.187 //l=0.88 //layer=li //thickness=0.1 \
 //x=70.845 //y=1.175 //x2=69.965 //y2=1.175
ends PM_TMRDFFSNRNQX1\%noxref_58

subckt PM_TMRDFFSNRNQX1\%noxref_59 ( 1 5 9 13 17 35 )
c49 ( 35 0 ) capacitor c=0.0673029f //x=73.095 //y=0.555
c50 ( 17 0 ) capacitor c=0.0178317f //x=75.085 //y=1.77
c51 ( 13 0 ) capacitor c=0.0154936f //x=75.085 //y=0.72
c52 ( 9 0 ) capacitor c=0.00678203f //x=74.2 //y=0.805
c53 ( 5 0 ) capacitor c=0.0164013f //x=74.115 //y=1.77
c54 ( 1 0 ) capacitor c=0.00696517f //x=73.23 //y=1.685
r55 (  18 35 ) resistor r=5.4201 //w=0.17 //l=0.103078 //layer=li \
 //thickness=0.1 //x=74.285 //y=1.77 //x2=74.2 //y2=1.81
r56 (  18 35 ) resistor r=27.3797 //w=0.187 //l=0.4 //layer=li //thickness=0.1 \
 //x=74.285 //y=1.77 //x2=74.685 //y2=1.77
r57 (  17 35 ) resistor r=0.751729 //w=0.17 //l=0.085 //layer=li \
 //thickness=0.1 //x=75.085 //y=1.77 //x2=75.17 //y2=1.77
r58 (  17 35 ) resistor r=27.3797 //w=0.187 //l=0.4 //layer=li //thickness=0.1 \
 //x=75.085 //y=1.77 //x2=74.685 //y2=1.77
r59 (  14 35 ) resistor r=3.57586 //w=0.17 //l=0.103078 //layer=li \
 //thickness=0.1 //x=74.285 //y=0.72 //x2=74.2 //y2=0.68
r60 (  14 35 ) resistor r=27.3797 //w=0.187 //l=0.4 //layer=li //thickness=0.1 \
 //x=74.285 //y=0.72 //x2=74.685 //y2=0.72
r61 (  13 35 ) resistor r=0.751729 //w=0.17 //l=0.085 //layer=li \
 //thickness=0.1 //x=75.085 //y=0.72 //x2=75.17 //y2=0.72
r62 (  13 35 ) resistor r=27.3797 //w=0.187 //l=0.4 //layer=li //thickness=0.1 \
 //x=75.085 //y=0.72 //x2=74.685 //y2=0.72
r63 (  10 35 ) resistor r=1.40859 //w=0.34 //l=0.125 //layer=li \
 //thickness=0.1 //x=74.2 //y=1.685 //x2=74.2 //y2=1.81
r64 (  10 35 ) resistor r=42.0963 //w=0.187 //l=0.615 //layer=li \
 //thickness=0.1 //x=74.2 //y=1.685 //x2=74.2 //y2=1.07
r65 (  9 35 ) resistor r=3.57586 //w=0.17 //l=0.125 //layer=li //thickness=0.1 \
 //x=74.2 //y=0.805 //x2=74.2 //y2=0.68
r66 (  9 35 ) resistor r=18.139 //w=0.187 //l=0.265 //layer=li //thickness=0.1 \
 //x=74.2 //y=0.805 //x2=74.2 //y2=1.07
r67 (  6 35 ) resistor r=3.57586 //w=0.17 //l=0.103078 //layer=li \
 //thickness=0.1 //x=73.315 //y=1.77 //x2=73.23 //y2=1.81
r68 (  6 35 ) resistor r=27.3797 //w=0.187 //l=0.4 //layer=li //thickness=0.1 \
 //x=73.315 //y=1.77 //x2=73.715 //y2=1.77
r69 (  5 35 ) resistor r=5.4201 //w=0.17 //l=0.103078 //layer=li \
 //thickness=0.1 //x=74.115 //y=1.77 //x2=74.2 //y2=1.81
r70 (  5 35 ) resistor r=27.3797 //w=0.187 //l=0.4 //layer=li //thickness=0.1 \
 //x=74.115 //y=1.77 //x2=73.715 //y2=1.77
r71 (  1 35 ) resistor r=3.57586 //w=0.17 //l=0.125 //layer=li //thickness=0.1 \
 //x=73.23 //y=1.685 //x2=73.23 //y2=1.81
r72 (  1 35 ) resistor r=42.0963 //w=0.187 //l=0.615 //layer=li \
 //thickness=0.1 //x=73.23 //y=1.685 //x2=73.23 //y2=1.07
ends PM_TMRDFFSNRNQX1\%noxref_59

subckt PM_TMRDFFSNRNQX1\%noxref_60 ( 1 3 11 15 25 28 29 )
c53 ( 29 0 ) capacitor c=0.0413887f //x=75.605 //y=0.555
c54 ( 28 0 ) capacitor c=0.0045748f //x=74.5 //y=1.09
c55 ( 25 0 ) capacitor c=0.00156479f //x=75.74 //y=1.175
c56 ( 15 0 ) capacitor c=0.00737666f //x=76.71 //y=0.805
c57 ( 11 0 ) capacitor c=0.0144218f //x=76.625 //y=0.72
c58 ( 3 0 ) capacitor c=0.00718386f //x=75.74 //y=0.805
c59 ( 1 0 ) capacitor c=0.0218888f //x=75.655 //y=1.175
r60 (  15 29 ) resistor r=3.57586 //w=0.17 //l=0.125 //layer=li \
 //thickness=0.1 //x=76.71 //y=0.805 //x2=76.71 //y2=0.68
r61 (  15 29 ) resistor r=18.139 //w=0.187 //l=0.265 //layer=li \
 //thickness=0.1 //x=76.71 //y=0.805 //x2=76.71 //y2=1.07
r62 (  12 29 ) resistor r=3.57586 //w=0.17 //l=0.103078 //layer=li \
 //thickness=0.1 //x=75.825 //y=0.72 //x2=75.74 //y2=0.68
r63 (  12 29 ) resistor r=27.3797 //w=0.187 //l=0.4 //layer=li //thickness=0.1 \
 //x=75.825 //y=0.72 //x2=76.225 //y2=0.72
r64 (  11 29 ) resistor r=3.57586 //w=0.17 //l=0.103078 //layer=li \
 //thickness=0.1 //x=76.625 //y=0.72 //x2=76.71 //y2=0.68
r65 (  11 29 ) resistor r=27.3797 //w=0.187 //l=0.4 //layer=li //thickness=0.1 \
 //x=76.625 //y=0.72 //x2=76.225 //y2=0.72
r66 (  7 25 ) resistor r=5.4201 //w=0.17 //l=0.085 //layer=li //thickness=0.1 \
 //x=75.74 //y=1.26 //x2=75.74 //y2=1.175
r67 (  7 29 ) resistor r=10.2674 //w=0.187 //l=0.15 //layer=li //thickness=0.1 \
 //x=75.74 //y=1.26 //x2=75.74 //y2=1.41
r68 (  4 25 ) resistor r=5.4201 //w=0.17 //l=0.085 //layer=li //thickness=0.1 \
 //x=75.74 //y=1.09 //x2=75.74 //y2=1.175
r69 (  4 29 ) resistor r=1.36898 //w=0.187 //l=0.02 //layer=li //thickness=0.1 \
 //x=75.74 //y=1.09 //x2=75.74 //y2=1.07
r70 (  3 29 ) resistor r=3.57586 //w=0.17 //l=0.125 //layer=li //thickness=0.1 \
 //x=75.74 //y=0.805 //x2=75.74 //y2=0.68
r71 (  3 29 ) resistor r=18.139 //w=0.187 //l=0.265 //layer=li //thickness=0.1 \
 //x=75.74 //y=0.805 //x2=75.74 //y2=1.07
r72 (  2 28 ) resistor r=0.751729 //w=0.17 //l=0.085 //layer=li \
 //thickness=0.1 //x=74.775 //y=1.175 //x2=74.69 //y2=1.175
r73 (  1 25 ) resistor r=1.40859 //w=0.34 //l=0.085 //layer=li //thickness=0.1 \
 //x=75.655 //y=1.175 //x2=75.74 //y2=1.175
r74 (  1 2 ) resistor r=60.2353 //w=0.187 //l=0.88 //layer=li //thickness=0.1 \
 //x=75.655 //y=1.175 //x2=74.775 //y2=1.175
ends PM_TMRDFFSNRNQX1\%noxref_60

subckt PM_TMRDFFSNRNQX1\%noxref_61 ( 1 5 9 13 17 35 )
c51 ( 35 0 ) capacitor c=0.0680259f //x=77.905 //y=0.555
c52 ( 17 0 ) capacitor c=0.0180446f //x=79.895 //y=1.77
c53 ( 13 0 ) capacitor c=0.0155283f //x=79.895 //y=0.72
c54 ( 9 0 ) capacitor c=0.00678203f //x=79.01 //y=0.805
c55 ( 5 0 ) capacitor c=0.0164013f //x=78.925 //y=1.77
c56 ( 1 0 ) capacitor c=0.00696517f //x=78.04 //y=1.685
r57 (  18 35 ) resistor r=5.4201 //w=0.17 //l=0.103078 //layer=li \
 //thickness=0.1 //x=79.095 //y=1.77 //x2=79.01 //y2=1.81
r58 (  18 35 ) resistor r=27.3797 //w=0.187 //l=0.4 //layer=li //thickness=0.1 \
 //x=79.095 //y=1.77 //x2=79.495 //y2=1.77
r59 (  17 35 ) resistor r=0.751729 //w=0.17 //l=0.085 //layer=li \
 //thickness=0.1 //x=79.895 //y=1.77 //x2=79.98 //y2=1.77
r60 (  17 35 ) resistor r=27.3797 //w=0.187 //l=0.4 //layer=li //thickness=0.1 \
 //x=79.895 //y=1.77 //x2=79.495 //y2=1.77
r61 (  14 35 ) resistor r=3.57586 //w=0.17 //l=0.103078 //layer=li \
 //thickness=0.1 //x=79.095 //y=0.72 //x2=79.01 //y2=0.68
r62 (  14 35 ) resistor r=27.3797 //w=0.187 //l=0.4 //layer=li //thickness=0.1 \
 //x=79.095 //y=0.72 //x2=79.495 //y2=0.72
r63 (  13 35 ) resistor r=0.751729 //w=0.17 //l=0.085 //layer=li \
 //thickness=0.1 //x=79.895 //y=0.72 //x2=79.98 //y2=0.72
r64 (  13 35 ) resistor r=27.3797 //w=0.187 //l=0.4 //layer=li //thickness=0.1 \
 //x=79.895 //y=0.72 //x2=79.495 //y2=0.72
r65 (  10 35 ) resistor r=1.40859 //w=0.34 //l=0.125 //layer=li \
 //thickness=0.1 //x=79.01 //y=1.685 //x2=79.01 //y2=1.81
r66 (  10 35 ) resistor r=42.0963 //w=0.187 //l=0.615 //layer=li \
 //thickness=0.1 //x=79.01 //y=1.685 //x2=79.01 //y2=1.07
r67 (  9 35 ) resistor r=3.57586 //w=0.17 //l=0.125 //layer=li //thickness=0.1 \
 //x=79.01 //y=0.805 //x2=79.01 //y2=0.68
r68 (  9 35 ) resistor r=18.139 //w=0.187 //l=0.265 //layer=li //thickness=0.1 \
 //x=79.01 //y=0.805 //x2=79.01 //y2=1.07
r69 (  6 35 ) resistor r=3.57586 //w=0.17 //l=0.103078 //layer=li \
 //thickness=0.1 //x=78.125 //y=1.77 //x2=78.04 //y2=1.81
r70 (  6 35 ) resistor r=27.3797 //w=0.187 //l=0.4 //layer=li //thickness=0.1 \
 //x=78.125 //y=1.77 //x2=78.525 //y2=1.77
r71 (  5 35 ) resistor r=5.4201 //w=0.17 //l=0.103078 //layer=li \
 //thickness=0.1 //x=78.925 //y=1.77 //x2=79.01 //y2=1.81
r72 (  5 35 ) resistor r=27.3797 //w=0.187 //l=0.4 //layer=li //thickness=0.1 \
 //x=78.925 //y=1.77 //x2=78.525 //y2=1.77
r73 (  1 35 ) resistor r=3.57586 //w=0.17 //l=0.125 //layer=li //thickness=0.1 \
 //x=78.04 //y=1.685 //x2=78.04 //y2=1.81
r74 (  1 35 ) resistor r=42.0963 //w=0.187 //l=0.615 //layer=li \
 //thickness=0.1 //x=78.04 //y=1.685 //x2=78.04 //y2=1.07
ends PM_TMRDFFSNRNQX1\%noxref_61

subckt PM_TMRDFFSNRNQX1\%noxref_62 ( 1 3 11 15 25 28 29 )
c53 ( 29 0 ) capacitor c=0.0421259f //x=80.415 //y=0.555
c54 ( 28 0 ) capacitor c=0.00457437f //x=79.31 //y=1.09
c55 ( 25 0 ) capacitor c=0.00156479f //x=80.55 //y=1.175
c56 ( 15 0 ) capacitor c=0.00737666f //x=81.52 //y=0.805
c57 ( 11 0 ) capacitor c=0.0144218f //x=81.435 //y=0.72
c58 ( 3 0 ) capacitor c=0.00718386f //x=80.55 //y=0.805
c59 ( 1 0 ) capacitor c=0.0234159f //x=80.465 //y=1.175
r60 (  15 29 ) resistor r=3.57586 //w=0.17 //l=0.125 //layer=li \
 //thickness=0.1 //x=81.52 //y=0.805 //x2=81.52 //y2=0.68
r61 (  15 29 ) resistor r=18.139 //w=0.187 //l=0.265 //layer=li \
 //thickness=0.1 //x=81.52 //y=0.805 //x2=81.52 //y2=1.07
r62 (  12 29 ) resistor r=3.57586 //w=0.17 //l=0.103078 //layer=li \
 //thickness=0.1 //x=80.635 //y=0.72 //x2=80.55 //y2=0.68
r63 (  12 29 ) resistor r=27.3797 //w=0.187 //l=0.4 //layer=li //thickness=0.1 \
 //x=80.635 //y=0.72 //x2=81.035 //y2=0.72
r64 (  11 29 ) resistor r=3.57586 //w=0.17 //l=0.103078 //layer=li \
 //thickness=0.1 //x=81.435 //y=0.72 //x2=81.52 //y2=0.68
r65 (  11 29 ) resistor r=27.3797 //w=0.187 //l=0.4 //layer=li //thickness=0.1 \
 //x=81.435 //y=0.72 //x2=81.035 //y2=0.72
r66 (  7 25 ) resistor r=5.4201 //w=0.17 //l=0.085 //layer=li //thickness=0.1 \
 //x=80.55 //y=1.26 //x2=80.55 //y2=1.175
r67 (  7 29 ) resistor r=10.2674 //w=0.187 //l=0.15 //layer=li //thickness=0.1 \
 //x=80.55 //y=1.26 //x2=80.55 //y2=1.41
r68 (  4 25 ) resistor r=5.4201 //w=0.17 //l=0.085 //layer=li //thickness=0.1 \
 //x=80.55 //y=1.09 //x2=80.55 //y2=1.175
r69 (  4 29 ) resistor r=1.36898 //w=0.187 //l=0.02 //layer=li //thickness=0.1 \
 //x=80.55 //y=1.09 //x2=80.55 //y2=1.07
r70 (  3 29 ) resistor r=3.57586 //w=0.17 //l=0.125 //layer=li //thickness=0.1 \
 //x=80.55 //y=0.805 //x2=80.55 //y2=0.68
r71 (  3 29 ) resistor r=18.139 //w=0.187 //l=0.265 //layer=li //thickness=0.1 \
 //x=80.55 //y=0.805 //x2=80.55 //y2=1.07
r72 (  2 28 ) resistor r=0.751729 //w=0.17 //l=0.085 //layer=li \
 //thickness=0.1 //x=79.585 //y=1.175 //x2=79.5 //y2=1.175
r73 (  1 25 ) resistor r=1.40859 //w=0.34 //l=0.085 //layer=li //thickness=0.1 \
 //x=80.465 //y=1.175 //x2=80.55 //y2=1.175
r74 (  1 2 ) resistor r=60.2353 //w=0.187 //l=0.88 //layer=li //thickness=0.1 \
 //x=80.465 //y=1.175 //x2=79.585 //y2=1.175
ends PM_TMRDFFSNRNQX1\%noxref_62

subckt PM_TMRDFFSNRNQX1\%noxref_63 ( 1 5 9 13 17 35 )
c49 ( 35 0 ) capacitor c=0.0673029f //x=82.715 //y=0.555
c50 ( 17 0 ) capacitor c=0.0178317f //x=84.705 //y=1.77
c51 ( 13 0 ) capacitor c=0.0154936f //x=84.705 //y=0.72
c52 ( 9 0 ) capacitor c=0.00678203f //x=83.82 //y=0.805
c53 ( 5 0 ) capacitor c=0.0164013f //x=83.735 //y=1.77
c54 ( 1 0 ) capacitor c=0.00696517f //x=82.85 //y=1.685
r55 (  18 35 ) resistor r=5.4201 //w=0.17 //l=0.103078 //layer=li \
 //thickness=0.1 //x=83.905 //y=1.77 //x2=83.82 //y2=1.81
r56 (  18 35 ) resistor r=27.3797 //w=0.187 //l=0.4 //layer=li //thickness=0.1 \
 //x=83.905 //y=1.77 //x2=84.305 //y2=1.77
r57 (  17 35 ) resistor r=0.751729 //w=0.17 //l=0.085 //layer=li \
 //thickness=0.1 //x=84.705 //y=1.77 //x2=84.79 //y2=1.77
r58 (  17 35 ) resistor r=27.3797 //w=0.187 //l=0.4 //layer=li //thickness=0.1 \
 //x=84.705 //y=1.77 //x2=84.305 //y2=1.77
r59 (  14 35 ) resistor r=3.57586 //w=0.17 //l=0.103078 //layer=li \
 //thickness=0.1 //x=83.905 //y=0.72 //x2=83.82 //y2=0.68
r60 (  14 35 ) resistor r=27.3797 //w=0.187 //l=0.4 //layer=li //thickness=0.1 \
 //x=83.905 //y=0.72 //x2=84.305 //y2=0.72
r61 (  13 35 ) resistor r=0.751729 //w=0.17 //l=0.085 //layer=li \
 //thickness=0.1 //x=84.705 //y=0.72 //x2=84.79 //y2=0.72
r62 (  13 35 ) resistor r=27.3797 //w=0.187 //l=0.4 //layer=li //thickness=0.1 \
 //x=84.705 //y=0.72 //x2=84.305 //y2=0.72
r63 (  10 35 ) resistor r=1.40859 //w=0.34 //l=0.125 //layer=li \
 //thickness=0.1 //x=83.82 //y=1.685 //x2=83.82 //y2=1.81
r64 (  10 35 ) resistor r=42.0963 //w=0.187 //l=0.615 //layer=li \
 //thickness=0.1 //x=83.82 //y=1.685 //x2=83.82 //y2=1.07
r65 (  9 35 ) resistor r=3.57586 //w=0.17 //l=0.125 //layer=li //thickness=0.1 \
 //x=83.82 //y=0.805 //x2=83.82 //y2=0.68
r66 (  9 35 ) resistor r=18.139 //w=0.187 //l=0.265 //layer=li //thickness=0.1 \
 //x=83.82 //y=0.805 //x2=83.82 //y2=1.07
r67 (  6 35 ) resistor r=3.57586 //w=0.17 //l=0.103078 //layer=li \
 //thickness=0.1 //x=82.935 //y=1.77 //x2=82.85 //y2=1.81
r68 (  6 35 ) resistor r=27.3797 //w=0.187 //l=0.4 //layer=li //thickness=0.1 \
 //x=82.935 //y=1.77 //x2=83.335 //y2=1.77
r69 (  5 35 ) resistor r=5.4201 //w=0.17 //l=0.103078 //layer=li \
 //thickness=0.1 //x=83.735 //y=1.77 //x2=83.82 //y2=1.81
r70 (  5 35 ) resistor r=27.3797 //w=0.187 //l=0.4 //layer=li //thickness=0.1 \
 //x=83.735 //y=1.77 //x2=83.335 //y2=1.77
r71 (  1 35 ) resistor r=3.57586 //w=0.17 //l=0.125 //layer=li //thickness=0.1 \
 //x=82.85 //y=1.685 //x2=82.85 //y2=1.81
r72 (  1 35 ) resistor r=42.0963 //w=0.187 //l=0.615 //layer=li \
 //thickness=0.1 //x=82.85 //y=1.685 //x2=82.85 //y2=1.07
ends PM_TMRDFFSNRNQX1\%noxref_63

subckt PM_TMRDFFSNRNQX1\%noxref_64 ( 1 3 11 15 25 28 29 )
c53 ( 29 0 ) capacitor c=0.0412521f //x=85.225 //y=0.555
c54 ( 28 0 ) capacitor c=0.0045748f //x=84.12 //y=1.09
c55 ( 25 0 ) capacitor c=0.00156479f //x=85.36 //y=1.175
c56 ( 15 0 ) capacitor c=0.00737666f //x=86.33 //y=0.805
c57 ( 11 0 ) capacitor c=0.0144274f //x=86.245 //y=0.72
c58 ( 3 0 ) capacitor c=0.00718386f //x=85.36 //y=0.805
c59 ( 1 0 ) capacitor c=0.0218888f //x=85.275 //y=1.175
r60 (  15 29 ) resistor r=3.57586 //w=0.17 //l=0.125 //layer=li \
 //thickness=0.1 //x=86.33 //y=0.805 //x2=86.33 //y2=0.68
r61 (  15 29 ) resistor r=18.139 //w=0.187 //l=0.265 //layer=li \
 //thickness=0.1 //x=86.33 //y=0.805 //x2=86.33 //y2=1.07
r62 (  12 29 ) resistor r=3.57586 //w=0.17 //l=0.103078 //layer=li \
 //thickness=0.1 //x=85.445 //y=0.72 //x2=85.36 //y2=0.68
r63 (  12 29 ) resistor r=27.3797 //w=0.187 //l=0.4 //layer=li //thickness=0.1 \
 //x=85.445 //y=0.72 //x2=85.845 //y2=0.72
r64 (  11 29 ) resistor r=3.57586 //w=0.17 //l=0.103078 //layer=li \
 //thickness=0.1 //x=86.245 //y=0.72 //x2=86.33 //y2=0.68
r65 (  11 29 ) resistor r=27.3797 //w=0.187 //l=0.4 //layer=li //thickness=0.1 \
 //x=86.245 //y=0.72 //x2=85.845 //y2=0.72
r66 (  7 25 ) resistor r=5.4201 //w=0.17 //l=0.085 //layer=li //thickness=0.1 \
 //x=85.36 //y=1.26 //x2=85.36 //y2=1.175
r67 (  7 29 ) resistor r=10.2674 //w=0.187 //l=0.15 //layer=li //thickness=0.1 \
 //x=85.36 //y=1.26 //x2=85.36 //y2=1.41
r68 (  4 25 ) resistor r=5.4201 //w=0.17 //l=0.085 //layer=li //thickness=0.1 \
 //x=85.36 //y=1.09 //x2=85.36 //y2=1.175
r69 (  4 29 ) resistor r=1.36898 //w=0.187 //l=0.02 //layer=li //thickness=0.1 \
 //x=85.36 //y=1.09 //x2=85.36 //y2=1.07
r70 (  3 29 ) resistor r=3.57586 //w=0.17 //l=0.125 //layer=li //thickness=0.1 \
 //x=85.36 //y=0.805 //x2=85.36 //y2=0.68
r71 (  3 29 ) resistor r=18.139 //w=0.187 //l=0.265 //layer=li //thickness=0.1 \
 //x=85.36 //y=0.805 //x2=85.36 //y2=1.07
r72 (  2 28 ) resistor r=0.751729 //w=0.17 //l=0.085 //layer=li \
 //thickness=0.1 //x=84.395 //y=1.175 //x2=84.31 //y2=1.175
r73 (  1 25 ) resistor r=1.40859 //w=0.34 //l=0.085 //layer=li //thickness=0.1 \
 //x=85.275 //y=1.175 //x2=85.36 //y2=1.175
r74 (  1 2 ) resistor r=60.2353 //w=0.187 //l=0.88 //layer=li //thickness=0.1 \
 //x=85.275 //y=1.175 //x2=84.395 //y2=1.175
ends PM_TMRDFFSNRNQX1\%noxref_64

subckt PM_TMRDFFSNRNQX1\%noxref_65 ( 1 5 9 10 13 17 29 )
c57 ( 29 0 ) capacitor c=0.0751624f //x=87.63 //y=0.545
c58 ( 17 0 ) capacitor c=0.0072249f //x=89.705 //y=0.795
c59 ( 13 0 ) capacitor c=0.0152499f //x=89.62 //y=0.71
c60 ( 10 0 ) capacitor c=0.00698291f //x=88.735 //y=1.675
c61 ( 9 0 ) capacitor c=0.006761f //x=88.735 //y=0.795
c62 ( 5 0 ) capacitor c=0.0191191f //x=88.65 //y=1.76
c63 ( 1 0 ) capacitor c=0.00483164f //x=87.765 //y=1.675
r64 (  17 29 ) resistor r=3.57586 //w=0.17 //l=0.125 //layer=li \
 //thickness=0.1 //x=89.705 //y=0.795 //x2=89.705 //y2=0.67
r65 (  17 29 ) resistor r=41.4118 //w=0.187 //l=0.605 //layer=li \
 //thickness=0.1 //x=89.705 //y=0.795 //x2=89.705 //y2=1.4
r66 (  14 29 ) resistor r=3.57586 //w=0.17 //l=0.103078 //layer=li \
 //thickness=0.1 //x=88.82 //y=0.71 //x2=88.735 //y2=0.67
r67 (  14 29 ) resistor r=27.0374 //w=0.187 //l=0.395 //layer=li \
 //thickness=0.1 //x=88.82 //y=0.71 //x2=89.215 //y2=0.71
r68 (  13 29 ) resistor r=3.57586 //w=0.17 //l=0.103078 //layer=li \
 //thickness=0.1 //x=89.62 //y=0.71 //x2=89.705 //y2=0.67
r69 (  13 29 ) resistor r=27.7219 //w=0.187 //l=0.405 //layer=li \
 //thickness=0.1 //x=89.62 //y=0.71 //x2=89.215 //y2=0.71
r70 (  10 29 ) resistor r=3.57586 //w=0.17 //l=0.125 //layer=li \
 //thickness=0.1 //x=88.735 //y=1.675 //x2=88.735 //y2=1.8
r71 (  10 29 ) resistor r=42.0963 //w=0.187 //l=0.615 //layer=li \
 //thickness=0.1 //x=88.735 //y=1.675 //x2=88.735 //y2=1.06
r72 (  9 29 ) resistor r=3.57586 //w=0.17 //l=0.125 //layer=li //thickness=0.1 \
 //x=88.735 //y=0.795 //x2=88.735 //y2=0.67
r73 (  9 29 ) resistor r=18.139 //w=0.187 //l=0.265 //layer=li //thickness=0.1 \
 //x=88.735 //y=0.795 //x2=88.735 //y2=1.06
r74 (  6 29 ) resistor r=3.57586 //w=0.17 //l=0.103078 //layer=li \
 //thickness=0.1 //x=87.85 //y=1.76 //x2=87.765 //y2=1.8
r75 (  6 29 ) resistor r=27.3797 //w=0.187 //l=0.4 //layer=li //thickness=0.1 \
 //x=87.85 //y=1.76 //x2=88.25 //y2=1.76
r76 (  5 29 ) resistor r=3.57586 //w=0.17 //l=0.103078 //layer=li \
 //thickness=0.1 //x=88.65 //y=1.76 //x2=88.735 //y2=1.8
r77 (  5 29 ) resistor r=27.3797 //w=0.187 //l=0.4 //layer=li //thickness=0.1 \
 //x=88.65 //y=1.76 //x2=88.25 //y2=1.76
r78 (  1 29 ) resistor r=3.57586 //w=0.17 //l=0.125 //layer=li //thickness=0.1 \
 //x=87.765 //y=1.675 //x2=87.765 //y2=1.8
r79 (  1 29 ) resistor r=42.0963 //w=0.187 //l=0.615 //layer=li \
 //thickness=0.1 //x=87.765 //y=1.675 //x2=87.765 //y2=1.06
ends PM_TMRDFFSNRNQX1\%noxref_65

subckt PM_TMRDFFSNRNQX1\%noxref_66 ( 1 5 9 10 13 17 29 )
c55 ( 29 0 ) capacitor c=0.0723103f //x=90.96 //y=0.545
c56 ( 17 0 ) capacitor c=0.0072249f //x=93.035 //y=0.795
c57 ( 13 0 ) capacitor c=0.0155051f //x=92.95 //y=0.71
c58 ( 10 0 ) capacitor c=0.00811719f //x=92.065 //y=1.675
c59 ( 9 0 ) capacitor c=0.006761f //x=92.065 //y=0.795
c60 ( 5 0 ) capacitor c=0.0166789f //x=91.98 //y=1.76
c61 ( 1 0 ) capacitor c=0.00788388f //x=91.095 //y=1.675
r62 (  17 29 ) resistor r=3.57586 //w=0.17 //l=0.125 //layer=li \
 //thickness=0.1 //x=93.035 //y=0.795 //x2=93.035 //y2=0.67
r63 (  17 29 ) resistor r=41.4118 //w=0.187 //l=0.605 //layer=li \
 //thickness=0.1 //x=93.035 //y=0.795 //x2=93.035 //y2=1.4
r64 (  14 29 ) resistor r=3.57586 //w=0.17 //l=0.103078 //layer=li \
 //thickness=0.1 //x=92.15 //y=0.71 //x2=92.065 //y2=0.67
r65 (  14 29 ) resistor r=27.3797 //w=0.187 //l=0.4 //layer=li //thickness=0.1 \
 //x=92.15 //y=0.71 //x2=92.55 //y2=0.71
r66 (  13 29 ) resistor r=3.57586 //w=0.17 //l=0.103078 //layer=li \
 //thickness=0.1 //x=92.95 //y=0.71 //x2=93.035 //y2=0.67
r67 (  13 29 ) resistor r=27.3797 //w=0.187 //l=0.4 //layer=li //thickness=0.1 \
 //x=92.95 //y=0.71 //x2=92.55 //y2=0.71
r68 (  10 29 ) resistor r=3.57586 //w=0.17 //l=0.125 //layer=li \
 //thickness=0.1 //x=92.065 //y=1.675 //x2=92.065 //y2=1.8
r69 (  10 29 ) resistor r=42.0963 //w=0.187 //l=0.615 //layer=li \
 //thickness=0.1 //x=92.065 //y=1.675 //x2=92.065 //y2=1.06
r70 (  9 29 ) resistor r=3.57586 //w=0.17 //l=0.125 //layer=li //thickness=0.1 \
 //x=92.065 //y=0.795 //x2=92.065 //y2=0.67
r71 (  9 29 ) resistor r=18.139 //w=0.187 //l=0.265 //layer=li //thickness=0.1 \
 //x=92.065 //y=0.795 //x2=92.065 //y2=1.06
r72 (  6 29 ) resistor r=3.57586 //w=0.17 //l=0.103078 //layer=li \
 //thickness=0.1 //x=91.18 //y=1.76 //x2=91.095 //y2=1.8
r73 (  6 29 ) resistor r=27.3797 //w=0.187 //l=0.4 //layer=li //thickness=0.1 \
 //x=91.18 //y=1.76 //x2=91.58 //y2=1.76
r74 (  5 29 ) resistor r=3.57586 //w=0.17 //l=0.103078 //layer=li \
 //thickness=0.1 //x=91.98 //y=1.76 //x2=92.065 //y2=1.8
r75 (  5 29 ) resistor r=27.3797 //w=0.187 //l=0.4 //layer=li //thickness=0.1 \
 //x=91.98 //y=1.76 //x2=91.58 //y2=1.76
r76 (  1 29 ) resistor r=3.57586 //w=0.17 //l=0.125 //layer=li //thickness=0.1 \
 //x=91.095 //y=1.675 //x2=91.095 //y2=1.8
r77 (  1 29 ) resistor r=42.0963 //w=0.187 //l=0.615 //layer=li \
 //thickness=0.1 //x=91.095 //y=1.675 //x2=91.095 //y2=1.06
ends PM_TMRDFFSNRNQX1\%noxref_66

subckt PM_TMRDFFSNRNQX1\%noxref_67 ( 1 5 9 10 13 17 29 )
c56 ( 29 0 ) capacitor c=0.0637832f //x=94.29 //y=0.545
c57 ( 17 0 ) capacitor c=0.00722228f //x=96.365 //y=0.795
c58 ( 13 0 ) capacitor c=0.0141607f //x=96.28 //y=0.71
c59 ( 10 0 ) capacitor c=0.00712138f //x=95.395 //y=1.675
c60 ( 9 0 ) capacitor c=0.006761f //x=95.395 //y=0.795
c61 ( 5 0 ) capacitor c=0.0233454f //x=95.31 //y=1.76
c62 ( 1 0 ) capacitor c=0.00481264f //x=94.425 //y=1.675
r63 (  17 29 ) resistor r=3.57586 //w=0.17 //l=0.125 //layer=li \
 //thickness=0.1 //x=96.365 //y=0.795 //x2=96.365 //y2=0.67
r64 (  17 29 ) resistor r=18.139 //w=0.187 //l=0.265 //layer=li \
 //thickness=0.1 //x=96.365 //y=0.795 //x2=96.365 //y2=1.06
r65 (  14 29 ) resistor r=3.57586 //w=0.17 //l=0.103078 //layer=li \
 //thickness=0.1 //x=95.48 //y=0.71 //x2=95.395 //y2=0.67
r66 (  14 29 ) resistor r=27.3797 //w=0.187 //l=0.4 //layer=li //thickness=0.1 \
 //x=95.48 //y=0.71 //x2=95.88 //y2=0.71
r67 (  13 29 ) resistor r=3.57586 //w=0.17 //l=0.103078 //layer=li \
 //thickness=0.1 //x=96.28 //y=0.71 //x2=96.365 //y2=0.67
r68 (  13 29 ) resistor r=27.3797 //w=0.187 //l=0.4 //layer=li //thickness=0.1 \
 //x=96.28 //y=0.71 //x2=95.88 //y2=0.71
r69 (  10 29 ) resistor r=3.57586 //w=0.17 //l=0.125 //layer=li \
 //thickness=0.1 //x=95.395 //y=1.675 //x2=95.395 //y2=1.8
r70 (  10 29 ) resistor r=42.0963 //w=0.187 //l=0.615 //layer=li \
 //thickness=0.1 //x=95.395 //y=1.675 //x2=95.395 //y2=1.06
r71 (  9 29 ) resistor r=3.57586 //w=0.17 //l=0.125 //layer=li //thickness=0.1 \
 //x=95.395 //y=0.795 //x2=95.395 //y2=0.67
r72 (  9 29 ) resistor r=18.139 //w=0.187 //l=0.265 //layer=li //thickness=0.1 \
 //x=95.395 //y=0.795 //x2=95.395 //y2=1.06
r73 (  6 29 ) resistor r=3.57586 //w=0.17 //l=0.103078 //layer=li \
 //thickness=0.1 //x=94.51 //y=1.76 //x2=94.425 //y2=1.8
r74 (  6 29 ) resistor r=27.3797 //w=0.187 //l=0.4 //layer=li //thickness=0.1 \
 //x=94.51 //y=1.76 //x2=94.91 //y2=1.76
r75 (  5 29 ) resistor r=3.57586 //w=0.17 //l=0.103078 //layer=li \
 //thickness=0.1 //x=95.31 //y=1.76 //x2=95.395 //y2=1.8
r76 (  5 29 ) resistor r=27.3797 //w=0.187 //l=0.4 //layer=li //thickness=0.1 \
 //x=95.31 //y=1.76 //x2=94.91 //y2=1.76
r77 (  1 29 ) resistor r=3.57586 //w=0.17 //l=0.125 //layer=li //thickness=0.1 \
 //x=94.425 //y=1.675 //x2=94.425 //y2=1.8
r78 (  1 29 ) resistor r=42.0963 //w=0.187 //l=0.615 //layer=li \
 //thickness=0.1 //x=94.425 //y=1.675 //x2=94.425 //y2=1.06
ends PM_TMRDFFSNRNQX1\%noxref_67
