// File: TMRDFFSNRNQX1.spi.pex
// Created: Fri Feb 20 10:16:52 2026
// Program "Calibre xRC"
// Version "v2023.2_27.15"
// Nominal Temperature: 30C
// Circuit Temperature: 30C
//
simulator lang=spectre
subckt PM_TMRDFFSNRNQX1\%noxref_1 ( 1 3 6 7 9 10 11 12 14 15 16 17 18 19 20 21 \
 22 23 24 25 28 31 37 45 49 63 66 67 69 70 73 81 89 106 115 120 129 133 134 \
 135 136 137 138 139 140 141 142 143 145 151 152 153 154 158 159 160 161 162 \
 164 170 171 172 173 193 195 196 197 )
c412 ( 193 0 ) capacitor c=0.00885916f //x=3.885 //y=1.095
c413 ( 173 0 ) capacitor c=0.0612936f //x=11.495 //y=4.97
c414 ( 172 0 ) capacitor c=0.0376642f //x=11.785 //y=4.97
c415 ( 171 0 ) capacitor c=0.0346489f //x=11.45 //y=1.4
c416 ( 170 0 ) capacitor c=0.018692f //x=11.45 //y=1.055
c417 ( 164 0 ) capacitor c=0.0137077f //x=11.295 //y=1.555
c418 ( 162 0 ) capacitor c=0.0158585f //x=11.295 //y=0.9
c419 ( 161 0 ) capacitor c=0.0979536f //x=10.92 //y=2.095
c420 ( 160 0 ) capacitor c=0.0229444f //x=10.92 //y=1.71
c421 ( 159 0 ) capacitor c=0.0234359f //x=10.92 //y=1.4
c422 ( 158 0 ) capacitor c=0.019815f //x=10.92 //y=1.055
c423 ( 154 0 ) capacitor c=0.0612936f //x=6.685 //y=4.97
c424 ( 153 0 ) capacitor c=0.0376642f //x=6.975 //y=4.97
c425 ( 152 0 ) capacitor c=0.0346489f //x=6.64 //y=1.4
c426 ( 151 0 ) capacitor c=0.018692f //x=6.64 //y=1.055
c427 ( 145 0 ) capacitor c=0.0137077f //x=6.485 //y=1.555
c428 ( 143 0 ) capacitor c=0.0158585f //x=6.485 //y=0.9
c429 ( 142 0 ) capacitor c=0.0996161f //x=6.11 //y=2.095
c430 ( 141 0 ) capacitor c=0.0229444f //x=6.11 //y=1.71
c431 ( 140 0 ) capacitor c=0.0234359f //x=6.11 //y=1.4
c432 ( 139 0 ) capacitor c=0.019815f //x=6.11 //y=1.055
c433 ( 138 0 ) capacitor c=0.110208f //x=11.86 //y=6.2
c434 ( 137 0 ) capacitor c=0.158957f //x=11.42 //y=6.2
c435 ( 136 0 ) capacitor c=0.110208f //x=7.05 //y=6.2
c436 ( 135 0 ) capacitor c=0.158957f //x=6.61 //y=6.2
c437 ( 129 0 ) capacitor c=0.0014751f //x=11.22 //y=4.88
c438 ( 120 0 ) capacitor c=9.93222e-19 //x=11.22 //y=2.26
c439 ( 115 0 ) capacitor c=0.0014751f //x=6.41 //y=4.88
c440 ( 106 0 ) capacitor c=9.93222e-19 //x=6.41 //y=2.26
c441 ( 89 0 ) capacitor c=0.0293562f //x=3.78 //y=5.56
c442 ( 81 0 ) capacitor c=0.029137f //x=2.9 //y=5.56
c443 ( 73 0 ) capacitor c=0.0278099f //x=2.02 //y=5.56
c444 ( 70 0 ) capacitor c=0.0487028f //x=11.06 //y=2.785
c445 ( 69 0 ) capacitor c=7.81966e-19 //x=11.22 //y=2.785
c446 ( 67 0 ) capacitor c=7.81966e-19 //x=6.575 //y=2.785
c447 ( 66 0 ) capacitor c=0.0212437f //x=6.255 //y=2.785
c448 ( 63 0 ) capacitor c=0.00113895f //x=4.725 //y=2.785
c449 ( 49 0 ) capacitor c=0.0154699f //x=11.22 //y=2.77
c450 ( 45 0 ) capacitor c=0.0148628f //x=6.41 //y=2.77
c451 ( 37 0 ) capacitor c=0.0144706f //x=4.56 //y=2.77
c452 ( 31 0 ) capacitor c=0.00103877f //x=3.78 //y=5.335
c453 ( 28 0 ) capacitor c=0.00794348f //x=2.9 //y=5.335
c454 ( 25 0 ) capacitor c=0.0123281f //x=2.022 //y=5.335
c455 ( 24 0 ) capacitor c=0.0598642f //x=11.22 //y=4.755
c456 ( 23 0 ) capacitor c=0.0130987f //x=11.22 //y=2.945
c457 ( 22 0 ) capacitor c=0.00473602f //x=11.22 //y=2.625
c458 ( 21 0 ) capacitor c=0.00495287f //x=11.22 //y=2.375
c459 ( 20 0 ) capacitor c=0.0665949f //x=6.41 //y=4.755
c460 ( 19 0 ) capacitor c=0.0129702f //x=6.41 //y=2.945
c461 ( 18 0 ) capacitor c=0.00482124f //x=6.41 //y=2.625
c462 ( 17 0 ) capacitor c=0.00495287f //x=6.41 //y=2.375
c463 ( 16 0 ) capacitor c=0.070752f //x=4.56 //y=5.25
c464 ( 15 0 ) capacitor c=0.0123217f //x=4.56 //y=2.945
c465 ( 14 0 ) capacitor c=0.0179579f //x=4.56 //y=2.625
c466 ( 12 0 ) capacitor c=0.00584263f //x=4.16 //y=1.845
c467 ( 11 0 ) capacitor c=0.0129788f //x=4.475 //y=1.845
c468 ( 10 0 ) capacitor c=0.0167992f //x=4.075 //y=1.76
c469 ( 9 0 ) capacitor c=0.0110957f //x=4.075 //y=1.305
c470 ( 7 0 ) capacitor c=0.0248757f //x=4.475 //y=5.335
c471 ( 6 0 ) capacitor c=0.00933983f //x=3.78 //y=5.56
c472 ( 3 0 ) capacitor c=0.0200404f //x=3.665 //y=5.335
c473 ( 1 0 ) capacitor c=0.0155354f //x=2.78 //y=5.335
r474 (  172 174 ) resistor r=26.9307 //w=0.15 //l=0.106066 //layer=ply \
 //thickness=0.18 //x=11.785 //y=4.97 //x2=11.86 //y2=5.045
r475 (  172 173 ) resistor r=148.702 //w=0.094 //l=0.29 //layer=ply \
 //thickness=0.18 //x=11.785 //y=4.97 //x2=11.495 //y2=4.97
r476 (  171 192 ) resistor r=45.1352 //w=0.168 //l=0.173853 //layer=ply \
 //thickness=0.18 //x=11.45 //y=1.4 //x2=11.41 //y2=1.555
r477 (  170 191 ) resistor r=45.1352 //w=0.168 //l=0.173853 //layer=ply \
 //thickness=0.18 //x=11.45 //y=1.055 //x2=11.41 //y2=0.9
r478 (  170 171 ) resistor r=176.904 //w=0.094 //l=0.345 //layer=ply \
 //thickness=0.18 //x=11.45 //y=1.055 //x2=11.45 //y2=1.4
r479 (  167 173 ) resistor r=22.7971 //w=0.269 //l=0.106066 //layer=ply \
 //thickness=0.18 //x=11.42 //y=5.045 //x2=11.495 //y2=4.97
r480 (  167 190 ) resistor r=35.8364 //w=0.269 //l=0.270185 //layer=ply \
 //thickness=0.18 //x=11.42 //y=5.045 //x2=11.22 //y2=4.88
r481 (  165 186 ) resistor r=10.701 //w=0.21 //l=0.115 //layer=ply \
 //thickness=0.18 //x=11.075 //y=1.555 //x2=10.96 //y2=1.555
r482 (  164 192 ) resistor r=5.52526 //w=0.168 //l=0.115 //layer=ply \
 //thickness=0.18 //x=11.295 //y=1.555 //x2=11.41 //y2=1.555
r483 (  163 185 ) resistor r=5.52526 //w=0.168 //l=0.115 //layer=ply \
 //thickness=0.18 //x=11.075 //y=0.9 //x2=10.96 //y2=0.9
r484 (  162 191 ) resistor r=5.52526 //w=0.168 //l=0.115 //layer=ply \
 //thickness=0.18 //x=11.295 //y=0.9 //x2=11.41 //y2=0.9
r485 (  162 163 ) resistor r=112.809 //w=0.094 //l=0.22 //layer=ply \
 //thickness=0.18 //x=11.295 //y=0.9 //x2=11.075 //y2=0.9
r486 (  161 188 ) resistor r=58.7805 //w=0.246 //l=0.373497 //layer=ply \
 //thickness=0.18 //x=10.92 //y=2.095 //x2=11.22 //y2=2.26
r487 (  160 186 ) resistor r=39.5823 //w=0.21 //l=0.173853 //layer=ply \
 //thickness=0.18 //x=10.92 //y=1.71 //x2=10.96 //y2=1.555
r488 (  160 161 ) resistor r=197.415 //w=0.094 //l=0.385 //layer=ply \
 //thickness=0.18 //x=10.92 //y=1.71 //x2=10.92 //y2=2.095
r489 (  159 186 ) resistor r=39.5823 //w=0.21 //l=0.173853 //layer=ply \
 //thickness=0.18 //x=10.92 //y=1.4 //x2=10.96 //y2=1.555
r490 (  158 185 ) resistor r=45.1352 //w=0.168 //l=0.173853 //layer=ply \
 //thickness=0.18 //x=10.92 //y=1.055 //x2=10.96 //y2=0.9
r491 (  158 159 ) resistor r=176.904 //w=0.094 //l=0.345 //layer=ply \
 //thickness=0.18 //x=10.92 //y=1.055 //x2=10.92 //y2=1.4
r492 (  153 155 ) resistor r=26.9307 //w=0.15 //l=0.106066 //layer=ply \
 //thickness=0.18 //x=6.975 //y=4.97 //x2=7.05 //y2=5.045
r493 (  153 154 ) resistor r=148.702 //w=0.094 //l=0.29 //layer=ply \
 //thickness=0.18 //x=6.975 //y=4.97 //x2=6.685 //y2=4.97
r494 (  152 184 ) resistor r=45.1352 //w=0.168 //l=0.173853 //layer=ply \
 //thickness=0.18 //x=6.64 //y=1.4 //x2=6.6 //y2=1.555
r495 (  151 183 ) resistor r=45.1352 //w=0.168 //l=0.173853 //layer=ply \
 //thickness=0.18 //x=6.64 //y=1.055 //x2=6.6 //y2=0.9
r496 (  151 152 ) resistor r=176.904 //w=0.094 //l=0.345 //layer=ply \
 //thickness=0.18 //x=6.64 //y=1.055 //x2=6.64 //y2=1.4
r497 (  148 154 ) resistor r=22.7971 //w=0.269 //l=0.106066 //layer=ply \
 //thickness=0.18 //x=6.61 //y=5.045 //x2=6.685 //y2=4.97
r498 (  148 182 ) resistor r=35.8364 //w=0.269 //l=0.270185 //layer=ply \
 //thickness=0.18 //x=6.61 //y=5.045 //x2=6.41 //y2=4.88
r499 (  146 178 ) resistor r=10.701 //w=0.21 //l=0.115 //layer=ply \
 //thickness=0.18 //x=6.265 //y=1.555 //x2=6.15 //y2=1.555
r500 (  145 184 ) resistor r=5.52526 //w=0.168 //l=0.115 //layer=ply \
 //thickness=0.18 //x=6.485 //y=1.555 //x2=6.6 //y2=1.555
r501 (  144 177 ) resistor r=5.52526 //w=0.168 //l=0.115 //layer=ply \
 //thickness=0.18 //x=6.265 //y=0.9 //x2=6.15 //y2=0.9
r502 (  143 183 ) resistor r=5.52526 //w=0.168 //l=0.115 //layer=ply \
 //thickness=0.18 //x=6.485 //y=0.9 //x2=6.6 //y2=0.9
r503 (  143 144 ) resistor r=112.809 //w=0.094 //l=0.22 //layer=ply \
 //thickness=0.18 //x=6.485 //y=0.9 //x2=6.265 //y2=0.9
r504 (  142 180 ) resistor r=58.7805 //w=0.246 //l=0.373497 //layer=ply \
 //thickness=0.18 //x=6.11 //y=2.095 //x2=6.41 //y2=2.26
r505 (  141 178 ) resistor r=39.5823 //w=0.21 //l=0.173853 //layer=ply \
 //thickness=0.18 //x=6.11 //y=1.71 //x2=6.15 //y2=1.555
r506 (  141 142 ) resistor r=197.415 //w=0.094 //l=0.385 //layer=ply \
 //thickness=0.18 //x=6.11 //y=1.71 //x2=6.11 //y2=2.095
r507 (  140 178 ) resistor r=39.5823 //w=0.21 //l=0.173853 //layer=ply \
 //thickness=0.18 //x=6.11 //y=1.4 //x2=6.15 //y2=1.555
r508 (  139 177 ) resistor r=45.1352 //w=0.168 //l=0.173853 //layer=ply \
 //thickness=0.18 //x=6.11 //y=1.055 //x2=6.15 //y2=0.9
r509 (  139 140 ) resistor r=176.904 //w=0.094 //l=0.345 //layer=ply \
 //thickness=0.18 //x=6.11 //y=1.055 //x2=6.11 //y2=1.4
r510 (  138 174 ) resistor r=592.245 //w=0.094 //l=1.155 //layer=ply \
 //thickness=0.18 //x=11.86 //y=6.2 //x2=11.86 //y2=5.045
r511 (  137 167 ) resistor r=592.245 //w=0.094 //l=1.155 //layer=ply \
 //thickness=0.18 //x=11.42 //y=6.2 //x2=11.42 //y2=5.045
r512 (  136 155 ) resistor r=592.245 //w=0.094 //l=1.155 //layer=ply \
 //thickness=0.18 //x=7.05 //y=6.2 //x2=7.05 //y2=5.045
r513 (  135 148 ) resistor r=592.245 //w=0.094 //l=1.155 //layer=ply \
 //thickness=0.18 //x=6.61 //y=6.2 //x2=6.61 //y2=5.045
r514 (  134 164 ) resistor r=56.4043 //w=0.094 //l=0.11 //layer=ply \
 //thickness=0.18 //x=11.185 //y=1.555 //x2=11.295 //y2=1.555
r515 (  134 165 ) resistor r=56.4043 //w=0.094 //l=0.11 //layer=ply \
 //thickness=0.18 //x=11.185 //y=1.555 //x2=11.075 //y2=1.555
r516 (  133 145 ) resistor r=56.4043 //w=0.094 //l=0.11 //layer=ply \
 //thickness=0.18 //x=6.375 //y=1.555 //x2=6.485 //y2=1.555
r517 (  133 146 ) resistor r=56.4043 //w=0.094 //l=0.11 //layer=ply \
 //thickness=0.18 //x=6.375 //y=1.555 //x2=6.265 //y2=1.555
r518 (  129 190 ) resistor r=152 //w=0.17 //l=0.17 //layer=licon //count=1 \
 //x=11.22 //y=4.88 //x2=11.22 //y2=4.88
r519 (  120 188 ) resistor r=152 //w=0.17 //l=0.17 //layer=licon //count=1 \
 //x=11.22 //y=2.26 //x2=11.22 //y2=2.26
r520 (  115 182 ) resistor r=152 //w=0.17 //l=0.17 //layer=licon //count=1 \
 //x=6.41 //y=4.88 //x2=6.41 //y2=4.88
r521 (  106 180 ) resistor r=152 //w=0.17 //l=0.17 //layer=licon //count=1 \
 //x=6.41 //y=2.26 //x2=6.41 //y2=2.26
r522 (  89 197 ) resistor r=23.615 //w=0.187 //l=0.345 //layer=li \
 //thickness=0.1 //x=3.78 //y=5.56 //x2=3.78 //y2=5.905
r523 (  81 196 ) resistor r=23.615 //w=0.187 //l=0.345 //layer=li \
 //thickness=0.1 //x=2.9 //y=5.56 //x2=2.9 //y2=5.905
r524 (  73 195 ) resistor r=23.615 //w=0.187 //l=0.345 //layer=li \
 //thickness=0.1 //x=2.02 //y=5.56 //x2=2.02 //y2=5.905
r525 (  69 70 ) resistor r=0.10734 //w=0.281 //l=0.16 //layer=m2 \
 //thickness=0.36 //x=11.22 //y=2.785 //x2=11.06 //y2=2.785
r526 (  67 70 ) resistor r=4.27958 //w=0.131 //l=4.485 //layer=m2 \
 //thickness=0.36 //x=6.575 //y=2.77 //x2=11.06 //y2=2.77
r527 (  65 67 ) resistor r=0.10734 //w=0.281 //l=0.16 //layer=m2 \
 //thickness=0.36 //x=6.415 //y=2.785 //x2=6.575 //y2=2.785
r528 (  65 66 ) resistor r=0.10734 //w=0.281 //l=0.16 //layer=m2 \
 //thickness=0.36 //x=6.415 //y=2.785 //x2=6.255 //y2=2.785
r529 (  63 66 ) resistor r=1.45992 //w=0.131 //l=1.53 //layer=m2 \
 //thickness=0.36 //x=4.725 //y=2.77 //x2=6.255 //y2=2.77
r530 (  61 63 ) resistor r=0.10734 //w=0.281 //l=0.16 //layer=m2 \
 //thickness=0.36 //x=4.565 //y=2.785 //x2=4.725 //y2=2.785
r531 (  55 129 ) resistor r=9.3 //w=0.17 //l=0.17 //layer=mcon //count=1 \
 //x=11.22 //y=4.88 //x2=11.22 //y2=4.88
r532 (  53 120 ) resistor r=9.3 //w=0.17 //l=0.17 //layer=mcon //count=1 \
 //x=11.22 //y=2.26 //x2=11.22 //y2=2.26
r533 (  51 69 ) resistor r=4.5 //w=0.15 //l=0.15 //layer=via1 //count=1 \
 //x=11.22 //y=2.785 //x2=11.22 //y2=2.785
r534 (  49 51 ) resistor r=0.0049867 //w=0.376 //l=0.015 //layer=m1 \
 //thickness=0.36 //x=11.167 //y=2.77 //x2=11.167 //y2=2.785
r535 (  47 65 ) resistor r=4.5 //w=0.15 //l=0.15 //layer=via1 //count=1 \
 //x=6.415 //y=2.785 //x2=6.415 //y2=2.785
r536 (  45 47 ) resistor r=0.00501337 //w=0.374 //l=0.015 //layer=m1 \
 //thickness=0.36 //x=6.465 //y=2.77 //x2=6.465 //y2=2.785
r537 (  43 115 ) resistor r=9.3 //w=0.17 //l=0.17 //layer=mcon //count=1 \
 //x=6.41 //y=4.88 //x2=6.41 //y2=4.88
r538 (  41 106 ) resistor r=9.3 //w=0.17 //l=0.17 //layer=mcon //count=1 \
 //x=6.41 //y=2.26 //x2=6.41 //y2=2.26
r539 (  39 61 ) resistor r=4.5 //w=0.15 //l=0.15 //layer=via1 //count=1 \
 //x=4.565 //y=2.785 //x2=4.565 //y2=2.785
r540 (  37 39 ) resistor r=0.00501337 //w=0.374 //l=0.015 //layer=m1 \
 //thickness=0.36 //x=4.615 //y=2.77 //x2=4.615 //y2=2.785
r541 (  35 193 ) resistor r=9.3 //w=0.17 //l=0.17 //layer=mcon //count=1 \
 //x=4.075 //y=1.19 //x2=4.075 //y2=1.19
r542 (  33 89 ) resistor r=9.3 //w=0.17 //l=0.17 //layer=mcon //count=1 \
 //x=3.78 //y=5.56 //x2=3.78 //y2=5.56
r543 (  30 81 ) resistor r=9.3 //w=0.17 //l=0.17 //layer=mcon //count=1 \
 //x=2.9 //y=5.56 //x2=2.9 //y2=5.56
r544 (  28 30 ) resistor r=0.121228 //w=0.232 //l=0.225 //layer=m1 \
 //thickness=0.36 //x=2.9 //y=5.335 //x2=2.9 //y2=5.56
r545 (  27 73 ) resistor r=9.3 //w=0.17 //l=0.17 //layer=mcon //count=1 \
 //x=2.02 //y=5.56 //x2=2.02 //y2=5.56
r546 (  25 27 ) resistor r=0.129608 //w=0.217 //l=0.225 //layer=m1 \
 //thickness=0.36 //x=2.022 //y=5.335 //x2=2.022 //y2=5.56
r547 (  24 55 ) resistor r=0.0760407 //w=0.238 //l=0.125 //layer=m1 \
 //thickness=0.36 //x=11.22 //y=4.755 //x2=11.22 //y2=4.88
r548 (  23 51 ) resistor r=0.0911593 //w=0.376 //l=0.184608 //layer=m1 \
 //thickness=0.36 //x=11.22 //y=2.945 //x2=11.167 //y2=2.785
r549 (  23 24 ) resistor r=1.7271 //w=0.131 //l=1.81 //layer=m1 \
 //thickness=0.36 //x=11.22 //y=2.945 //x2=11.22 //y2=4.755
r550 (  22 49 ) resistor r=0.0861726 //w=0.376 //l=0.16944 //layer=m1 \
 //thickness=0.36 //x=11.22 //y=2.625 //x2=11.167 //y2=2.77
r551 (  21 53 ) resistor r=0.0719237 //w=0.222 //l=0.115 //layer=m1 \
 //thickness=0.36 //x=11.22 //y=2.375 //x2=11.22 //y2=2.26
r552 (  21 22 ) resistor r=0.23855 //w=0.131 //l=0.25 //layer=m1 \
 //thickness=0.36 //x=11.22 //y=2.375 //x2=11.22 //y2=2.625
r553 (  20 43 ) resistor r=0.0760407 //w=0.238 //l=0.125 //layer=m1 \
 //thickness=0.36 //x=6.41 //y=4.755 //x2=6.41 //y2=4.88
r554 (  19 47 ) resistor r=0.0910802 //w=0.374 //l=0.185472 //layer=m1 \
 //thickness=0.36 //x=6.41 //y=2.945 //x2=6.465 //y2=2.785
r555 (  19 20 ) resistor r=1.7271 //w=0.131 //l=1.81 //layer=m1 \
 //thickness=0.36 //x=6.41 //y=2.945 //x2=6.41 //y2=4.755
r556 (  18 45 ) resistor r=0.0860668 //w=0.374 //l=0.170294 //layer=m1 \
 //thickness=0.36 //x=6.41 //y=2.625 //x2=6.465 //y2=2.77
r557 (  17 41 ) resistor r=0.0719237 //w=0.222 //l=0.115 //layer=m1 \
 //thickness=0.36 //x=6.41 //y=2.375 //x2=6.41 //y2=2.26
r558 (  17 18 ) resistor r=0.23855 //w=0.131 //l=0.25 //layer=m1 \
 //thickness=0.36 //x=6.41 //y=2.375 //x2=6.41 //y2=2.625
r559 (  15 39 ) resistor r=0.0910802 //w=0.374 //l=0.185472 //layer=m1 \
 //thickness=0.36 //x=4.56 //y=2.945 //x2=4.615 //y2=2.785
r560 (  15 16 ) resistor r=2.19943 //w=0.131 //l=2.305 //layer=m1 \
 //thickness=0.36 //x=4.56 //y=2.945 //x2=4.56 //y2=5.25
r561 (  14 37 ) resistor r=0.0860668 //w=0.374 //l=0.170294 //layer=m1 \
 //thickness=0.36 //x=4.56 //y=2.625 //x2=4.615 //y2=2.77
r562 (  13 14 ) resistor r=0.663168 //w=0.131 //l=0.695 //layer=m1 \
 //thickness=0.36 //x=4.56 //y=1.93 //x2=4.56 //y2=2.625
r563 (  11 13 ) resistor r=0.0698411 //w=0.17 //l=0.120208 //layer=m1 \
 //thickness=0.36 //x=4.475 //y=1.845 //x2=4.56 //y2=1.93
r564 (  11 12 ) resistor r=0.300573 //w=0.131 //l=0.315 //layer=m1 \
 //thickness=0.36 //x=4.475 //y=1.845 //x2=4.16 //y2=1.845
r565 (  10 12 ) resistor r=0.0698411 //w=0.17 //l=0.120208 //layer=m1 \
 //thickness=0.36 //x=4.075 //y=1.76 //x2=4.16 //y2=1.845
r566 (  9 35 ) resistor r=0.0717383 //w=0.224 //l=0.115 //layer=m1 \
 //thickness=0.36 //x=4.075 //y=1.305 //x2=4.075 //y2=1.19
r567 (  9 10 ) resistor r=0.43416 //w=0.131 //l=0.455 //layer=m1 \
 //thickness=0.36 //x=4.075 //y=1.305 //x2=4.075 //y2=1.76
r568 (  8 31 ) resistor r=0.0675342 //w=0.23 //l=0.115 //layer=m1 \
 //thickness=0.36 //x=3.895 //y=5.335 //x2=3.78 //y2=5.335
r569 (  7 16 ) resistor r=0.0698411 //w=0.17 //l=0.120208 //layer=m1 \
 //thickness=0.36 //x=4.475 //y=5.335 //x2=4.56 //y2=5.25
r570 (  7 8 ) resistor r=0.553435 //w=0.131 //l=0.58 //layer=m1 \
 //thickness=0.36 //x=4.475 //y=5.335 //x2=3.895 //y2=5.335
r571 (  6 33 ) resistor r=0.00118313 //w=0.23 //layer=m1 //thickness=0.36 \
 //x=3.78 //y=5.56 //x2=3.78 //y2=5.56
r572 (  5 31 ) resistor r=0.002872 //w=0.34 //l=0.085 //layer=m1 \
 //thickness=0.36 //x=3.78 //y=5.42 //x2=3.78 //y2=5.335
r573 (  5 6 ) resistor r=0.091623 //w=0.191 //l=0.14 //layer=m1 \
 //thickness=0.36 //x=3.78 //y=5.42 //x2=3.78 //y2=5.56
r574 (  4 28 ) resistor r=0.0262263 //w=0.232 //l=0.12 //layer=m1 \
 //thickness=0.36 //x=3.02 //y=5.335 //x2=2.9 //y2=5.335
r575 (  3 31 ) resistor r=0.0675342 //w=0.23 //l=0.115 //layer=m1 \
 //thickness=0.36 //x=3.665 //y=5.335 //x2=3.78 //y2=5.335
r576 (  3 4 ) resistor r=0.615458 //w=0.131 //l=0.645 //layer=m1 \
 //thickness=0.36 //x=3.665 //y=5.335 //x2=3.02 //y2=5.335
r577 (  2 25 ) resistor r=0.0222262 //w=0.217 //l=0.118 //layer=m1 \
 //thickness=0.36 //x=2.14 //y=5.335 //x2=2.022 //y2=5.335
r578 (  1 28 ) resistor r=0.0262263 //w=0.232 //l=0.12 //layer=m1 \
 //thickness=0.36 //x=2.78 //y=5.335 //x2=2.9 //y2=5.335
r579 (  1 2 ) resistor r=0.610687 //w=0.131 //l=0.64 //layer=m1 \
 //thickness=0.36 //x=2.78 //y=5.335 //x2=2.14 //y2=5.335
ends PM_TMRDFFSNRNQX1\%noxref_1

subckt PM_TMRDFFSNRNQX1\%noxref_2 ( 1 3 6 7 9 10 11 12 14 15 16 17 18 19 20 21 \
 24 27 33 36 42 43 48 51 59 67 84 93 97 98 99 100 101 102 103 104 106 112 113 \
 114 115 127 129 130 131 )
c293 ( 127 0 ) capacitor c=0.00885916f //x=13.505 //y=1.095
c294 ( 115 0 ) capacitor c=0.0612936f //x=16.305 //y=4.97
c295 ( 114 0 ) capacitor c=0.0376642f //x=16.595 //y=4.97
c296 ( 113 0 ) capacitor c=0.0346489f //x=16.26 //y=1.4
c297 ( 112 0 ) capacitor c=0.018692f //x=16.26 //y=1.055
c298 ( 106 0 ) capacitor c=0.0137077f //x=16.105 //y=1.555
c299 ( 104 0 ) capacitor c=0.0158585f //x=16.105 //y=0.9
c300 ( 103 0 ) capacitor c=0.0979523f //x=15.73 //y=2.095
c301 ( 102 0 ) capacitor c=0.0229444f //x=15.73 //y=1.71
c302 ( 101 0 ) capacitor c=0.0234359f //x=15.73 //y=1.4
c303 ( 100 0 ) capacitor c=0.019815f //x=15.73 //y=1.055
c304 ( 99 0 ) capacitor c=0.110208f //x=16.67 //y=6.2
c305 ( 98 0 ) capacitor c=0.158957f //x=16.23 //y=6.2
c306 ( 93 0 ) capacitor c=0.0014751f //x=16.03 //y=4.88
c307 ( 84 0 ) capacitor c=9.93222e-19 //x=16.03 //y=2.26
c308 ( 67 0 ) capacitor c=0.0293723f //x=13.4 //y=5.56
c309 ( 59 0 ) capacitor c=0.029137f //x=12.52 //y=5.56
c310 ( 51 0 ) capacitor c=0.0278099f //x=11.64 //y=5.56
c311 ( 48 0 ) capacitor c=6.57651e-19 //x=16.04 //y=2.77
c312 ( 43 0 ) capacitor c=9.44624e-19 //x=14.34 //y=2.77
c313 ( 42 0 ) capacitor c=0.0155215f //x=15.88 //y=2.77
c314 ( 36 0 ) capacitor c=0.0146045f //x=16.03 //y=2.77
c315 ( 33 0 ) capacitor c=0.0146969f //x=14.18 //y=2.77
c316 ( 27 0 ) capacitor c=8.8245e-19 //x=13.4 //y=5.335
c317 ( 24 0 ) capacitor c=0.00726074f //x=12.52 //y=5.335
c318 ( 21 0 ) capacitor c=0.0111234f //x=11.642 //y=5.335
c319 ( 20 0 ) capacitor c=0.0633726f //x=16.03 //y=4.755
c320 ( 19 0 ) capacitor c=0.0131932f //x=16.03 //y=2.93
c321 ( 18 0 ) capacitor c=0.00432188f //x=16.03 //y=2.61
c322 ( 17 0 ) capacitor c=0.00485584f //x=16.03 //y=2.375
c323 ( 16 0 ) capacitor c=0.064515f //x=14.18 //y=5.25
c324 ( 15 0 ) capacitor c=0.0122936f //x=14.18 //y=2.93
c325 ( 14 0 ) capacitor c=0.0181662f //x=14.18 //y=2.61
c326 ( 12 0 ) capacitor c=0.00493487f //x=13.78 //y=1.845
c327 ( 11 0 ) capacitor c=0.0129068f //x=14.095 //y=1.845
c328 ( 10 0 ) capacitor c=0.0167992f //x=13.695 //y=1.76
c329 ( 9 0 ) capacitor c=0.0112867f //x=13.695 //y=1.305
c330 ( 7 0 ) capacitor c=0.0236685f //x=14.095 //y=5.335
c331 ( 6 0 ) capacitor c=0.00933983f //x=13.4 //y=5.56
c332 ( 3 0 ) capacitor c=0.0180822f //x=13.285 //y=5.335
c333 ( 1 0 ) capacitor c=0.0151332f //x=12.4 //y=5.335
r334 (  114 116 ) resistor r=26.9307 //w=0.15 //l=0.106066 //layer=ply \
 //thickness=0.18 //x=16.595 //y=4.97 //x2=16.67 //y2=5.045
r335 (  114 115 ) resistor r=148.702 //w=0.094 //l=0.29 //layer=ply \
 //thickness=0.18 //x=16.595 //y=4.97 //x2=16.305 //y2=4.97
r336 (  113 126 ) resistor r=45.1352 //w=0.168 //l=0.173853 //layer=ply \
 //thickness=0.18 //x=16.26 //y=1.4 //x2=16.22 //y2=1.555
r337 (  112 125 ) resistor r=45.1352 //w=0.168 //l=0.173853 //layer=ply \
 //thickness=0.18 //x=16.26 //y=1.055 //x2=16.22 //y2=0.9
r338 (  112 113 ) resistor r=176.904 //w=0.094 //l=0.345 //layer=ply \
 //thickness=0.18 //x=16.26 //y=1.055 //x2=16.26 //y2=1.4
r339 (  109 115 ) resistor r=22.7971 //w=0.269 //l=0.106066 //layer=ply \
 //thickness=0.18 //x=16.23 //y=5.045 //x2=16.305 //y2=4.97
r340 (  109 124 ) resistor r=35.8364 //w=0.269 //l=0.270185 //layer=ply \
 //thickness=0.18 //x=16.23 //y=5.045 //x2=16.03 //y2=4.88
r341 (  107 120 ) resistor r=10.701 //w=0.21 //l=0.115 //layer=ply \
 //thickness=0.18 //x=15.885 //y=1.555 //x2=15.77 //y2=1.555
r342 (  106 126 ) resistor r=5.52526 //w=0.168 //l=0.115 //layer=ply \
 //thickness=0.18 //x=16.105 //y=1.555 //x2=16.22 //y2=1.555
r343 (  105 119 ) resistor r=5.52526 //w=0.168 //l=0.115 //layer=ply \
 //thickness=0.18 //x=15.885 //y=0.9 //x2=15.77 //y2=0.9
r344 (  104 125 ) resistor r=5.52526 //w=0.168 //l=0.115 //layer=ply \
 //thickness=0.18 //x=16.105 //y=0.9 //x2=16.22 //y2=0.9
r345 (  104 105 ) resistor r=112.809 //w=0.094 //l=0.22 //layer=ply \
 //thickness=0.18 //x=16.105 //y=0.9 //x2=15.885 //y2=0.9
r346 (  103 122 ) resistor r=58.7805 //w=0.246 //l=0.373497 //layer=ply \
 //thickness=0.18 //x=15.73 //y=2.095 //x2=16.03 //y2=2.26
r347 (  102 120 ) resistor r=39.5823 //w=0.21 //l=0.173853 //layer=ply \
 //thickness=0.18 //x=15.73 //y=1.71 //x2=15.77 //y2=1.555
r348 (  102 103 ) resistor r=197.415 //w=0.094 //l=0.385 //layer=ply \
 //thickness=0.18 //x=15.73 //y=1.71 //x2=15.73 //y2=2.095
r349 (  101 120 ) resistor r=39.5823 //w=0.21 //l=0.173853 //layer=ply \
 //thickness=0.18 //x=15.73 //y=1.4 //x2=15.77 //y2=1.555
r350 (  100 119 ) resistor r=45.1352 //w=0.168 //l=0.173853 //layer=ply \
 //thickness=0.18 //x=15.73 //y=1.055 //x2=15.77 //y2=0.9
r351 (  100 101 ) resistor r=176.904 //w=0.094 //l=0.345 //layer=ply \
 //thickness=0.18 //x=15.73 //y=1.055 //x2=15.73 //y2=1.4
r352 (  99 116 ) resistor r=592.245 //w=0.094 //l=1.155 //layer=ply \
 //thickness=0.18 //x=16.67 //y=6.2 //x2=16.67 //y2=5.045
r353 (  98 109 ) resistor r=592.245 //w=0.094 //l=1.155 //layer=ply \
 //thickness=0.18 //x=16.23 //y=6.2 //x2=16.23 //y2=5.045
r354 (  97 106 ) resistor r=56.4043 //w=0.094 //l=0.11 //layer=ply \
 //thickness=0.18 //x=15.995 //y=1.555 //x2=16.105 //y2=1.555
r355 (  97 107 ) resistor r=56.4043 //w=0.094 //l=0.11 //layer=ply \
 //thickness=0.18 //x=15.995 //y=1.555 //x2=15.885 //y2=1.555
r356 (  93 124 ) resistor r=152 //w=0.17 //l=0.17 //layer=licon //count=1 \
 //x=16.03 //y=4.88 //x2=16.03 //y2=4.88
r357 (  84 122 ) resistor r=152 //w=0.17 //l=0.17 //layer=licon //count=1 \
 //x=16.03 //y=2.26 //x2=16.03 //y2=2.26
r358 (  67 131 ) resistor r=23.615 //w=0.187 //l=0.345 //layer=li \
 //thickness=0.1 //x=13.4 //y=5.56 //x2=13.4 //y2=5.905
r359 (  59 130 ) resistor r=23.615 //w=0.187 //l=0.345 //layer=li \
 //thickness=0.1 //x=12.52 //y=5.56 //x2=12.52 //y2=5.905
r360 (  51 129 ) resistor r=23.615 //w=0.187 //l=0.345 //layer=li \
 //thickness=0.1 //x=11.64 //y=5.56 //x2=11.64 //y2=5.905
r361 (  43 45 ) resistor r=0.10734 //w=0.281 //l=0.16 //layer=m2 \
 //thickness=0.36 //x=14.34 //y=2.77 //x2=14.18 //y2=2.77
r362 (  42 48 ) resistor r=0.10734 //w=0.281 //l=0.16 //layer=m2 \
 //thickness=0.36 //x=15.88 //y=2.77 //x2=16.04 //y2=2.77
r363 (  42 43 ) resistor r=1.46947 //w=0.131 //l=1.54 //layer=m2 \
 //thickness=0.36 //x=15.88 //y=2.77 //x2=14.34 //y2=2.77
r364 (  41 93 ) resistor r=9.3 //w=0.17 //l=0.17 //layer=mcon //count=1 \
 //x=16.03 //y=4.88 //x2=16.03 //y2=4.88
r365 (  39 84 ) resistor r=9.3 //w=0.17 //l=0.17 //layer=mcon //count=1 \
 //x=16.03 //y=2.26 //x2=16.03 //y2=2.26
r366 (  36 48 ) resistor r=4.5 //w=0.15 //l=0.15 //layer=via1 //count=1 \
 //x=16.04 //y=2.77 //x2=16.04 //y2=2.77
r367 (  33 45 ) resistor r=4.5 //w=0.15 //l=0.15 //layer=via1 //count=1 \
 //x=14.18 //y=2.77 //x2=14.18 //y2=2.77
r368 (  31 127 ) resistor r=9.3 //w=0.17 //l=0.17 //layer=mcon //count=1 \
 //x=13.695 //y=1.19 //x2=13.695 //y2=1.19
r369 (  29 67 ) resistor r=9.3 //w=0.17 //l=0.17 //layer=mcon //count=1 \
 //x=13.4 //y=5.56 //x2=13.4 //y2=5.56
r370 (  26 59 ) resistor r=9.3 //w=0.17 //l=0.17 //layer=mcon //count=1 \
 //x=12.52 //y=5.56 //x2=12.52 //y2=5.56
r371 (  24 26 ) resistor r=0.121228 //w=0.232 //l=0.225 //layer=m1 \
 //thickness=0.36 //x=12.52 //y=5.335 //x2=12.52 //y2=5.56
r372 (  23 51 ) resistor r=9.3 //w=0.17 //l=0.17 //layer=mcon //count=1 \
 //x=11.64 //y=5.56 //x2=11.64 //y2=5.56
r373 (  21 23 ) resistor r=0.129608 //w=0.217 //l=0.225 //layer=m1 \
 //thickness=0.36 //x=11.642 //y=5.335 //x2=11.642 //y2=5.56
r374 (  20 41 ) resistor r=0.0760407 //w=0.238 //l=0.125 //layer=m1 \
 //thickness=0.36 //x=16.03 //y=4.755 //x2=16.03 //y2=4.88
r375 (  19 36 ) resistor r=0.0914072 //w=0.382 //l=0.182428 //layer=m1 \
 //thickness=0.36 //x=16.03 //y=2.93 //x2=15.982 //y2=2.77
r376 (  19 20 ) resistor r=1.74141 //w=0.131 //l=1.825 //layer=m1 \
 //thickness=0.36 //x=16.03 //y=2.93 //x2=16.03 //y2=4.755
r377 (  18 36 ) resistor r=0.0914072 //w=0.382 //l=0.182428 //layer=m1 \
 //thickness=0.36 //x=16.03 //y=2.61 //x2=15.982 //y2=2.77
r378 (  17 39 ) resistor r=0.0719237 //w=0.222 //l=0.115 //layer=m1 \
 //thickness=0.36 //x=16.03 //y=2.375 //x2=16.03 //y2=2.26
r379 (  17 18 ) resistor r=0.224237 //w=0.131 //l=0.235 //layer=m1 \
 //thickness=0.36 //x=16.03 //y=2.375 //x2=16.03 //y2=2.61
r380 (  15 33 ) resistor r=0.0911593 //w=0.376 //l=0.184174 //layer=m1 \
 //thickness=0.36 //x=14.18 //y=2.93 //x2=14.232 //y2=2.77
r381 (  15 16 ) resistor r=2.21374 //w=0.131 //l=2.32 //layer=m1 \
 //thickness=0.36 //x=14.18 //y=2.93 //x2=14.18 //y2=5.25
r382 (  14 33 ) resistor r=0.0911593 //w=0.376 //l=0.184174 //layer=m1 \
 //thickness=0.36 //x=14.18 //y=2.61 //x2=14.232 //y2=2.77
r383 (  13 14 ) resistor r=0.648855 //w=0.131 //l=0.68 //layer=m1 \
 //thickness=0.36 //x=14.18 //y=1.93 //x2=14.18 //y2=2.61
r384 (  11 13 ) resistor r=0.0698411 //w=0.17 //l=0.120208 //layer=m1 \
 //thickness=0.36 //x=14.095 //y=1.845 //x2=14.18 //y2=1.93
r385 (  11 12 ) resistor r=0.300573 //w=0.131 //l=0.315 //layer=m1 \
 //thickness=0.36 //x=14.095 //y=1.845 //x2=13.78 //y2=1.845
r386 (  10 12 ) resistor r=0.0698411 //w=0.17 //l=0.120208 //layer=m1 \
 //thickness=0.36 //x=13.695 //y=1.76 //x2=13.78 //y2=1.845
r387 (  9 31 ) resistor r=0.0717383 //w=0.224 //l=0.115 //layer=m1 \
 //thickness=0.36 //x=13.695 //y=1.305 //x2=13.695 //y2=1.19
r388 (  9 10 ) resistor r=0.43416 //w=0.131 //l=0.455 //layer=m1 \
 //thickness=0.36 //x=13.695 //y=1.305 //x2=13.695 //y2=1.76
r389 (  8 27 ) resistor r=0.0675342 //w=0.23 //l=0.115 //layer=m1 \
 //thickness=0.36 //x=13.515 //y=5.335 //x2=13.4 //y2=5.335
r390 (  7 16 ) resistor r=0.0698411 //w=0.17 //l=0.120208 //layer=m1 \
 //thickness=0.36 //x=14.095 //y=5.335 //x2=14.18 //y2=5.25
r391 (  7 8 ) resistor r=0.553435 //w=0.131 //l=0.58 //layer=m1 \
 //thickness=0.36 //x=14.095 //y=5.335 //x2=13.515 //y2=5.335
r392 (  6 29 ) resistor r=0.00118313 //w=0.23 //layer=m1 //thickness=0.36 \
 //x=13.4 //y=5.56 //x2=13.4 //y2=5.56
r393 (  5 27 ) resistor r=0.002872 //w=0.34 //l=0.085 //layer=m1 \
 //thickness=0.36 //x=13.4 //y=5.42 //x2=13.4 //y2=5.335
r394 (  5 6 ) resistor r=0.091623 //w=0.191 //l=0.14 //layer=m1 \
 //thickness=0.36 //x=13.4 //y=5.42 //x2=13.4 //y2=5.56
r395 (  4 24 ) resistor r=0.0262263 //w=0.232 //l=0.12 //layer=m1 \
 //thickness=0.36 //x=12.64 //y=5.335 //x2=12.52 //y2=5.335
r396 (  3 27 ) resistor r=0.0675342 //w=0.23 //l=0.115 //layer=m1 \
 //thickness=0.36 //x=13.285 //y=5.335 //x2=13.4 //y2=5.335
r397 (  3 4 ) resistor r=0.615458 //w=0.131 //l=0.645 //layer=m1 \
 //thickness=0.36 //x=13.285 //y=5.335 //x2=12.64 //y2=5.335
r398 (  2 21 ) resistor r=0.0222262 //w=0.217 //l=0.118 //layer=m1 \
 //thickness=0.36 //x=11.76 //y=5.335 //x2=11.642 //y2=5.335
r399 (  1 24 ) resistor r=0.0262263 //w=0.232 //l=0.12 //layer=m1 \
 //thickness=0.36 //x=12.4 //y=5.335 //x2=12.52 //y2=5.335
r400 (  1 2 ) resistor r=0.610687 //w=0.131 //l=0.64 //layer=m1 \
 //thickness=0.36 //x=12.4 //y=5.335 //x2=11.76 //y2=5.335
ends PM_TMRDFFSNRNQX1\%noxref_2

subckt PM_TMRDFFSNRNQX1\%noxref_3 ( 1 2 3 4 5 7 10 11 13 14 15 16 18 19 20 21 \
 22 23 24 30 33 36 39 47 49 57 62 65 66 68 71 80 85 93 101 118 127 131 132 133 \
 134 135 136 140 141 142 147 149 152 153 154 155 156 157 158 160 166 167 168 \
 169 174 175 180 191 193 194 195 )
c471 ( 191 0 ) capacitor c=0.00885916f //x=8.695 //y=1.095
c472 ( 180 0 ) capacitor c=0.0710579f //x=3.82 //y=4.88
c473 ( 175 0 ) capacitor c=0.0278202f //x=3.82 //y=2.095
c474 ( 174 0 ) capacitor c=0.0479349f //x=3.82 //y=2.26
c475 ( 169 0 ) capacitor c=0.0612936f //x=21.115 //y=4.97
c476 ( 168 0 ) capacitor c=0.0376642f //x=21.405 //y=4.97
c477 ( 167 0 ) capacitor c=0.0346489f //x=21.07 //y=1.4
c478 ( 166 0 ) capacitor c=0.018692f //x=21.07 //y=1.055
c479 ( 160 0 ) capacitor c=0.0137077f //x=20.915 //y=1.555
c480 ( 158 0 ) capacitor c=0.0158585f //x=20.915 //y=0.9
c481 ( 157 0 ) capacitor c=0.10101f //x=20.54 //y=2.095
c482 ( 156 0 ) capacitor c=0.0229444f //x=20.54 //y=1.71
c483 ( 155 0 ) capacitor c=0.0234359f //x=20.54 //y=1.4
c484 ( 154 0 ) capacitor c=0.019815f //x=20.54 //y=1.055
c485 ( 153 0 ) capacitor c=0.0443175f //x=4.34 //y=1.44
c486 ( 152 0 ) capacitor c=0.0199703f //x=4.34 //y=1.095
c487 ( 149 0 ) capacitor c=0.0162526f //x=4.185 //y=1.595
c488 ( 147 0 ) capacitor c=0.0157807f //x=4.185 //y=0.94
c489 ( 142 0 ) capacitor c=0.0220935f //x=3.81 //y=1.75
c490 ( 141 0 ) capacitor c=0.0207489f //x=3.81 //y=1.44
c491 ( 140 0 ) capacitor c=0.0194091f //x=3.81 //y=1.095
c492 ( 136 0 ) capacitor c=0.110208f //x=21.48 //y=6.2
c493 ( 135 0 ) capacitor c=0.158957f //x=21.04 //y=6.2
c494 ( 134 0 ) capacitor c=0.159671f //x=4 //y=6.2
c495 ( 133 0 ) capacitor c=0.110208f //x=3.56 //y=6.2
c496 ( 127 0 ) capacitor c=0.0014751f //x=20.84 //y=4.88
c497 ( 118 0 ) capacitor c=0.0012618f //x=20.84 //y=2.26
c498 ( 101 0 ) capacitor c=0.0293723f //x=8.59 //y=5.56
c499 ( 93 0 ) capacitor c=0.029137f //x=7.71 //y=5.56
c500 ( 85 0 ) capacitor c=0.0278099f //x=6.83 //y=5.56
c501 ( 80 0 ) capacitor c=7.7417e-19 //x=3.82 //y=4.88
c502 ( 71 0 ) capacitor c=0.00101179f //x=3.82 //y=2.26
c503 ( 68 0 ) capacitor c=4.92288e-19 //x=20.835 //y=3.51
c504 ( 66 0 ) capacitor c=8.37596e-19 //x=9.53 //y=3.495
c505 ( 65 0 ) capacitor c=0.071237f //x=9.21 //y=3.495
c506 ( 62 0 ) capacitor c=9.84133e-19 //x=3.99 //y=3.515
c507 ( 57 0 ) capacitor c=0.121226f //x=20.675 //y=3.51
c508 ( 49 0 ) capacitor c=0.0169562f //x=20.835 //y=3.51
c509 ( 47 0 ) capacitor c=0.0158593f //x=9.37 //y=3.51
c510 ( 39 0 ) capacitor c=8.8245e-19 //x=8.59 //y=5.335
c511 ( 36 0 ) capacitor c=0.00740623f //x=7.71 //y=5.335
c512 ( 33 0 ) capacitor c=0.0113499f //x=6.832 //y=5.335
c513 ( 30 0 ) capacitor c=0.0150828f //x=3.82 //y=3.51
c514 ( 24 0 ) capacitor c=0.037614f //x=20.84 //y=4.755
c515 ( 23 0 ) capacitor c=0.0144231f //x=20.84 //y=3.67
c516 ( 22 0 ) capacitor c=0.0280962f //x=20.84 //y=3.35
c517 ( 21 0 ) capacitor c=0.00493552f //x=20.84 //y=2.375
c518 ( 20 0 ) capacitor c=0.0426794f //x=9.37 //y=5.25
c519 ( 19 0 ) capacitor c=0.0133594f //x=9.37 //y=3.655
c520 ( 18 0 ) capacitor c=0.0401079f //x=9.37 //y=3.335
c521 ( 16 0 ) capacitor c=0.0048771f //x=8.97 //y=1.845
c522 ( 15 0 ) capacitor c=0.0132685f //x=9.285 //y=1.845
c523 ( 14 0 ) capacitor c=0.0167992f //x=8.885 //y=1.76
c524 ( 13 0 ) capacitor c=0.0113147f //x=8.885 //y=1.305
c525 ( 11 0 ) capacitor c=0.0228465f //x=9.285 //y=5.335
c526 ( 10 0 ) capacitor c=0.00933983f //x=8.59 //y=5.56
c527 ( 7 0 ) capacitor c=0.019444f //x=8.475 //y=5.335
c528 ( 5 0 ) capacitor c=0.0149475f //x=7.59 //y=5.335
c529 ( 4 0 ) capacitor c=0.0329808f //x=3.82 //y=4.75
c530 ( 3 0 ) capacitor c=0.0122381f //x=3.82 //y=3.675
c531 ( 2 0 ) capacitor c=0.0243464f //x=3.82 //y=3.355
c532 ( 1 0 ) capacitor c=0.005545f //x=3.82 //y=2.375
r533 (  174 175 ) resistor r=52.7279 //w=0.214 //l=0.165 //layer=ply \
 //thickness=0.18 //x=3.82 //y=2.26 //x2=3.82 //y2=2.095
r534 (  168 170 ) resistor r=26.9307 //w=0.15 //l=0.106066 //layer=ply \
 //thickness=0.18 //x=21.405 //y=4.97 //x2=21.48 //y2=5.045
r535 (  168 169 ) resistor r=148.702 //w=0.094 //l=0.29 //layer=ply \
 //thickness=0.18 //x=21.405 //y=4.97 //x2=21.115 //y2=4.97
r536 (  167 190 ) resistor r=45.1352 //w=0.168 //l=0.173853 //layer=ply \
 //thickness=0.18 //x=21.07 //y=1.4 //x2=21.03 //y2=1.555
r537 (  166 189 ) resistor r=45.1352 //w=0.168 //l=0.173853 //layer=ply \
 //thickness=0.18 //x=21.07 //y=1.055 //x2=21.03 //y2=0.9
r538 (  166 167 ) resistor r=176.904 //w=0.094 //l=0.345 //layer=ply \
 //thickness=0.18 //x=21.07 //y=1.055 //x2=21.07 //y2=1.4
r539 (  163 169 ) resistor r=22.7971 //w=0.269 //l=0.106066 //layer=ply \
 //thickness=0.18 //x=21.04 //y=5.045 //x2=21.115 //y2=4.97
r540 (  163 188 ) resistor r=35.8364 //w=0.269 //l=0.270185 //layer=ply \
 //thickness=0.18 //x=21.04 //y=5.045 //x2=20.84 //y2=4.88
r541 (  161 184 ) resistor r=10.701 //w=0.21 //l=0.115 //layer=ply \
 //thickness=0.18 //x=20.695 //y=1.555 //x2=20.58 //y2=1.555
r542 (  160 190 ) resistor r=5.52526 //w=0.168 //l=0.115 //layer=ply \
 //thickness=0.18 //x=20.915 //y=1.555 //x2=21.03 //y2=1.555
r543 (  159 183 ) resistor r=5.52526 //w=0.168 //l=0.115 //layer=ply \
 //thickness=0.18 //x=20.695 //y=0.9 //x2=20.58 //y2=0.9
r544 (  158 189 ) resistor r=5.52526 //w=0.168 //l=0.115 //layer=ply \
 //thickness=0.18 //x=20.915 //y=0.9 //x2=21.03 //y2=0.9
r545 (  158 159 ) resistor r=112.809 //w=0.094 //l=0.22 //layer=ply \
 //thickness=0.18 //x=20.915 //y=0.9 //x2=20.695 //y2=0.9
r546 (  157 186 ) resistor r=58.7805 //w=0.246 //l=0.373497 //layer=ply \
 //thickness=0.18 //x=20.54 //y=2.095 //x2=20.84 //y2=2.26
r547 (  156 184 ) resistor r=39.5823 //w=0.21 //l=0.173853 //layer=ply \
 //thickness=0.18 //x=20.54 //y=1.71 //x2=20.58 //y2=1.555
r548 (  156 157 ) resistor r=197.415 //w=0.094 //l=0.385 //layer=ply \
 //thickness=0.18 //x=20.54 //y=1.71 //x2=20.54 //y2=2.095
r549 (  155 184 ) resistor r=39.5823 //w=0.21 //l=0.173853 //layer=ply \
 //thickness=0.18 //x=20.54 //y=1.4 //x2=20.58 //y2=1.555
r550 (  154 183 ) resistor r=45.1352 //w=0.168 //l=0.173853 //layer=ply \
 //thickness=0.18 //x=20.54 //y=1.055 //x2=20.58 //y2=0.9
r551 (  154 155 ) resistor r=176.904 //w=0.094 //l=0.345 //layer=ply \
 //thickness=0.18 //x=20.54 //y=1.055 //x2=20.54 //y2=1.4
r552 (  153 182 ) resistor r=45.1352 //w=0.168 //l=0.173853 //layer=ply \
 //thickness=0.18 //x=4.34 //y=1.44 //x2=4.3 //y2=1.595
r553 (  152 181 ) resistor r=45.1352 //w=0.168 //l=0.173853 //layer=ply \
 //thickness=0.18 //x=4.34 //y=1.095 //x2=4.3 //y2=0.94
r554 (  152 153 ) resistor r=176.904 //w=0.094 //l=0.345 //layer=ply \
 //thickness=0.18 //x=4.34 //y=1.095 //x2=4.34 //y2=1.44
r555 (  150 178 ) resistor r=10.701 //w=0.21 //l=0.115 //layer=ply \
 //thickness=0.18 //x=3.965 //y=1.595 //x2=3.85 //y2=1.595
r556 (  149 182 ) resistor r=5.52526 //w=0.168 //l=0.115 //layer=ply \
 //thickness=0.18 //x=4.185 //y=1.595 //x2=4.3 //y2=1.595
r557 (  148 177 ) resistor r=5.52526 //w=0.168 //l=0.115 //layer=ply \
 //thickness=0.18 //x=3.965 //y=0.94 //x2=3.85 //y2=0.94
r558 (  147 181 ) resistor r=5.52526 //w=0.168 //l=0.115 //layer=ply \
 //thickness=0.18 //x=4.185 //y=0.94 //x2=4.3 //y2=0.94
r559 (  147 148 ) resistor r=112.809 //w=0.094 //l=0.22 //layer=ply \
 //thickness=0.18 //x=4.185 //y=0.94 //x2=3.965 //y2=0.94
r560 (  144 180 ) resistor r=37.236 //w=0.233 //l=0.249199 //layer=ply \
 //thickness=0.18 //x=4 //y=5.045 //x2=3.82 //y2=4.88
r561 (  142 178 ) resistor r=39.5823 //w=0.21 //l=0.173853 //layer=ply \
 //thickness=0.18 //x=3.81 //y=1.75 //x2=3.85 //y2=1.595
r562 (  142 175 ) resistor r=176.904 //w=0.094 //l=0.345 //layer=ply \
 //thickness=0.18 //x=3.81 //y=1.75 //x2=3.81 //y2=2.095
r563 (  141 178 ) resistor r=39.5823 //w=0.21 //l=0.173853 //layer=ply \
 //thickness=0.18 //x=3.81 //y=1.44 //x2=3.85 //y2=1.595
r564 (  140 177 ) resistor r=45.1352 //w=0.168 //l=0.173853 //layer=ply \
 //thickness=0.18 //x=3.81 //y=1.095 //x2=3.85 //y2=0.94
r565 (  140 141 ) resistor r=176.904 //w=0.094 //l=0.345 //layer=ply \
 //thickness=0.18 //x=3.81 //y=1.095 //x2=3.81 //y2=1.44
r566 (  137 180 ) resistor r=53.7854 //w=0.233 //l=0.332415 //layer=ply \
 //thickness=0.18 //x=3.56 //y=5.045 //x2=3.82 //y2=4.88
r567 (  136 170 ) resistor r=592.245 //w=0.094 //l=1.155 //layer=ply \
 //thickness=0.18 //x=21.48 //y=6.2 //x2=21.48 //y2=5.045
r568 (  135 163 ) resistor r=592.245 //w=0.094 //l=1.155 //layer=ply \
 //thickness=0.18 //x=21.04 //y=6.2 //x2=21.04 //y2=5.045
r569 (  134 144 ) resistor r=592.245 //w=0.094 //l=1.155 //layer=ply \
 //thickness=0.18 //x=4 //y=6.2 //x2=4 //y2=5.045
r570 (  133 137 ) resistor r=592.245 //w=0.094 //l=1.155 //layer=ply \
 //thickness=0.18 //x=3.56 //y=6.2 //x2=3.56 //y2=5.045
r571 (  132 160 ) resistor r=56.4043 //w=0.094 //l=0.11 //layer=ply \
 //thickness=0.18 //x=20.805 //y=1.555 //x2=20.915 //y2=1.555
r572 (  132 161 ) resistor r=56.4043 //w=0.094 //l=0.11 //layer=ply \
 //thickness=0.18 //x=20.805 //y=1.555 //x2=20.695 //y2=1.555
r573 (  131 149 ) resistor r=56.4043 //w=0.094 //l=0.11 //layer=ply \
 //thickness=0.18 //x=4.075 //y=1.595 //x2=4.185 //y2=1.595
r574 (  131 150 ) resistor r=56.4043 //w=0.094 //l=0.11 //layer=ply \
 //thickness=0.18 //x=4.075 //y=1.595 //x2=3.965 //y2=1.595
r575 (  127 188 ) resistor r=152 //w=0.17 //l=0.17 //layer=licon //count=1 \
 //x=20.84 //y=4.88 //x2=20.84 //y2=4.88
r576 (  118 186 ) resistor r=152 //w=0.17 //l=0.17 //layer=licon //count=1 \
 //x=20.84 //y=2.26 //x2=20.84 //y2=2.26
r577 (  101 195 ) resistor r=23.615 //w=0.187 //l=0.345 //layer=li \
 //thickness=0.1 //x=8.59 //y=5.56 //x2=8.59 //y2=5.905
r578 (  93 194 ) resistor r=23.615 //w=0.187 //l=0.345 //layer=li \
 //thickness=0.1 //x=7.71 //y=5.56 //x2=7.71 //y2=5.905
r579 (  85 193 ) resistor r=23.615 //w=0.187 //l=0.345 //layer=li \
 //thickness=0.1 //x=6.83 //y=5.56 //x2=6.83 //y2=5.905
r580 (  80 180 ) resistor r=152 //w=0.17 //l=0.17 //layer=licon //count=1 \
 //x=3.82 //y=4.88 //x2=3.82 //y2=4.88
r581 (  71 174 ) resistor r=152 //w=0.17 //l=0.17 //layer=licon //count=1 \
 //x=3.82 //y=2.26 //x2=3.82 //y2=2.26
r582 (  64 66 ) resistor r=0.10734 //w=0.281 //l=0.16 //layer=m2 \
 //thickness=0.36 //x=9.37 //y=3.495 //x2=9.53 //y2=3.495
r583 (  64 65 ) resistor r=0.10734 //w=0.281 //l=0.16 //layer=m2 \
 //thickness=0.36 //x=9.37 //y=3.495 //x2=9.21 //y2=3.495
r584 (  62 65 ) resistor r=4.98092 //w=0.131 //l=5.22 //layer=m2 \
 //thickness=0.36 //x=3.99 //y=3.51 //x2=9.21 //y2=3.51
r585 (  60 62 ) resistor r=0.10734 //w=0.281 //l=0.16 //layer=m2 \
 //thickness=0.36 //x=3.83 //y=3.515 //x2=3.99 //y2=3.515
r586 (  57 68 ) resistor r=0.10734 //w=0.281 //l=0.16 //layer=m2 \
 //thickness=0.36 //x=20.675 //y=3.51 //x2=20.835 //y2=3.51
r587 (  57 66 ) resistor r=10.6345 //w=0.131 //l=11.145 //layer=m2 \
 //thickness=0.36 //x=20.675 //y=3.51 //x2=9.53 //y2=3.51
r588 (  54 127 ) resistor r=9.3 //w=0.17 //l=0.17 //layer=mcon //count=1 \
 //x=20.84 //y=4.88 //x2=20.84 //y2=4.88
r589 (  52 118 ) resistor r=9.3 //w=0.17 //l=0.17 //layer=mcon //count=1 \
 //x=20.84 //y=2.26 //x2=20.84 //y2=2.26
r590 (  49 68 ) resistor r=4.5 //w=0.15 //l=0.15 //layer=via1 //count=1 \
 //x=20.835 //y=3.51 //x2=20.835 //y2=3.51
r591 (  45 64 ) resistor r=4.5 //w=0.15 //l=0.15 //layer=via1 //count=1 \
 //x=9.37 //y=3.495 //x2=9.37 //y2=3.495
r592 (  45 47 ) resistor r=0.0049867 //w=0.376 //l=0.015 //layer=m1 \
 //thickness=0.36 //x=9.422 //y=3.495 //x2=9.422 //y2=3.51
r593 (  43 191 ) resistor r=9.3 //w=0.17 //l=0.17 //layer=mcon //count=1 \
 //x=8.885 //y=1.19 //x2=8.885 //y2=1.19
r594 (  41 101 ) resistor r=9.3 //w=0.17 //l=0.17 //layer=mcon //count=1 \
 //x=8.59 //y=5.56 //x2=8.59 //y2=5.56
r595 (  38 93 ) resistor r=9.3 //w=0.17 //l=0.17 //layer=mcon //count=1 \
 //x=7.71 //y=5.56 //x2=7.71 //y2=5.56
r596 (  36 38 ) resistor r=0.121228 //w=0.232 //l=0.225 //layer=m1 \
 //thickness=0.36 //x=7.71 //y=5.335 //x2=7.71 //y2=5.56
r597 (  35 85 ) resistor r=9.3 //w=0.17 //l=0.17 //layer=mcon //count=1 \
 //x=6.83 //y=5.56 //x2=6.83 //y2=5.56
r598 (  33 35 ) resistor r=0.129608 //w=0.217 //l=0.225 //layer=m1 \
 //thickness=0.36 //x=6.832 //y=5.335 //x2=6.832 //y2=5.56
r599 (  32 60 ) resistor r=4.5 //w=0.15 //l=0.15 //layer=via1 //count=1 \
 //x=3.83 //y=3.515 //x2=3.83 //y2=3.515
r600 (  30 32 ) resistor r=0.00168464 //w=0.371 //l=0.005 //layer=m1 \
 //thickness=0.36 //x=3.877 //y=3.51 //x2=3.877 //y2=3.515
r601 (  28 80 ) resistor r=9.3 //w=0.17 //l=0.17 //layer=mcon //count=1 \
 //x=3.82 //y=4.88 //x2=3.82 //y2=4.88
r602 (  26 71 ) resistor r=9.3 //w=0.17 //l=0.17 //layer=mcon //count=1 \
 //x=3.82 //y=2.26 //x2=3.82 //y2=2.26
r603 (  24 54 ) resistor r=0.0760407 //w=0.238 //l=0.125 //layer=m1 \
 //thickness=0.36 //x=20.84 //y=4.755 //x2=20.84 //y2=4.88
r604 (  23 49 ) resistor r=0.0910802 //w=0.374 //l=0.185472 //layer=m1 \
 //thickness=0.36 //x=20.84 //y=3.67 //x2=20.785 //y2=3.51
r605 (  23 24 ) resistor r=1.03531 //w=0.131 //l=1.085 //layer=m1 \
 //thickness=0.36 //x=20.84 //y=3.67 //x2=20.84 //y2=4.755
r606 (  22 49 ) resistor r=0.0910802 //w=0.374 //l=0.185472 //layer=m1 \
 //thickness=0.36 //x=20.84 //y=3.35 //x2=20.785 //y2=3.51
r607 (  21 52 ) resistor r=0.0719237 //w=0.222 //l=0.115 //layer=m1 \
 //thickness=0.36 //x=20.84 //y=2.375 //x2=20.84 //y2=2.26
r608 (  21 22 ) resistor r=0.930344 //w=0.131 //l=0.975 //layer=m1 \
 //thickness=0.36 //x=20.84 //y=2.375 //x2=20.84 //y2=3.35
r609 (  19 47 ) resistor r=0.0861726 //w=0.376 //l=0.169012 //layer=m1 \
 //thickness=0.36 //x=9.37 //y=3.655 //x2=9.422 //y2=3.51
r610 (  19 20 ) resistor r=1.52195 //w=0.131 //l=1.595 //layer=m1 \
 //thickness=0.36 //x=9.37 //y=3.655 //x2=9.37 //y2=5.25
r611 (  18 45 ) resistor r=0.0911593 //w=0.376 //l=0.184174 //layer=m1 \
 //thickness=0.36 //x=9.37 //y=3.335 //x2=9.422 //y2=3.495
r612 (  17 18 ) resistor r=1.34065 //w=0.131 //l=1.405 //layer=m1 \
 //thickness=0.36 //x=9.37 //y=1.93 //x2=9.37 //y2=3.335
r613 (  15 17 ) resistor r=0.0698411 //w=0.17 //l=0.120208 //layer=m1 \
 //thickness=0.36 //x=9.285 //y=1.845 //x2=9.37 //y2=1.93
r614 (  15 16 ) resistor r=0.300573 //w=0.131 //l=0.315 //layer=m1 \
 //thickness=0.36 //x=9.285 //y=1.845 //x2=8.97 //y2=1.845
r615 (  14 16 ) resistor r=0.0698411 //w=0.17 //l=0.120208 //layer=m1 \
 //thickness=0.36 //x=8.885 //y=1.76 //x2=8.97 //y2=1.845
r616 (  13 43 ) resistor r=0.0717383 //w=0.224 //l=0.115 //layer=m1 \
 //thickness=0.36 //x=8.885 //y=1.305 //x2=8.885 //y2=1.19
r617 (  13 14 ) resistor r=0.43416 //w=0.131 //l=0.455 //layer=m1 \
 //thickness=0.36 //x=8.885 //y=1.305 //x2=8.885 //y2=1.76
r618 (  12 39 ) resistor r=0.0675342 //w=0.23 //l=0.115 //layer=m1 \
 //thickness=0.36 //x=8.705 //y=5.335 //x2=8.59 //y2=5.335
r619 (  11 20 ) resistor r=0.0698411 //w=0.17 //l=0.120208 //layer=m1 \
 //thickness=0.36 //x=9.285 //y=5.335 //x2=9.37 //y2=5.25
r620 (  11 12 ) resistor r=0.553435 //w=0.131 //l=0.58 //layer=m1 \
 //thickness=0.36 //x=9.285 //y=5.335 //x2=8.705 //y2=5.335
r621 (  10 41 ) resistor r=0.00118313 //w=0.23 //layer=m1 //thickness=0.36 \
 //x=8.59 //y=5.56 //x2=8.59 //y2=5.56
r622 (  9 39 ) resistor r=0.002872 //w=0.34 //l=0.085 //layer=m1 \
 //thickness=0.36 //x=8.59 //y=5.42 //x2=8.59 //y2=5.335
r623 (  9 10 ) resistor r=0.091623 //w=0.191 //l=0.14 //layer=m1 \
 //thickness=0.36 //x=8.59 //y=5.42 //x2=8.59 //y2=5.56
r624 (  8 36 ) resistor r=0.0262263 //w=0.232 //l=0.12 //layer=m1 \
 //thickness=0.36 //x=7.83 //y=5.335 //x2=7.71 //y2=5.335
r625 (  7 39 ) resistor r=0.0675342 //w=0.23 //l=0.115 //layer=m1 \
 //thickness=0.36 //x=8.475 //y=5.335 //x2=8.59 //y2=5.335
r626 (  7 8 ) resistor r=0.615458 //w=0.131 //l=0.645 //layer=m1 \
 //thickness=0.36 //x=8.475 //y=5.335 //x2=7.83 //y2=5.335
r627 (  6 33 ) resistor r=0.0222262 //w=0.217 //l=0.118 //layer=m1 \
 //thickness=0.36 //x=6.95 //y=5.335 //x2=6.832 //y2=5.335
r628 (  5 36 ) resistor r=0.0262263 //w=0.232 //l=0.12 //layer=m1 \
 //thickness=0.36 //x=7.59 //y=5.335 //x2=7.71 //y2=5.335
r629 (  5 6 ) resistor r=0.610687 //w=0.131 //l=0.64 //layer=m1 \
 //thickness=0.36 //x=7.59 //y=5.335 //x2=6.95 //y2=5.335
r630 (  4 28 ) resistor r=0.0801089 //w=0.224 //l=0.13 //layer=m1 \
 //thickness=0.36 //x=3.82 //y=4.75 //x2=3.82 //y2=4.88
r631 (  3 32 ) resistor r=0.0909648 //w=0.371 //l=0.186333 //layer=m1 \
 //thickness=0.36 //x=3.82 //y=3.675 //x2=3.877 //y2=3.515
r632 (  3 4 ) resistor r=1.02576 //w=0.131 //l=1.075 //layer=m1 \
 //thickness=0.36 //x=3.82 //y=3.675 //x2=3.82 //y2=4.75
r633 (  2 30 ) resistor r=0.0892801 //w=0.371 //l=0.181273 //layer=m1 \
 //thickness=0.36 //x=3.82 //y=3.355 //x2=3.877 //y2=3.51
r634 (  1 26 ) resistor r=0.0719237 //w=0.222 //l=0.115 //layer=m1 \
 //thickness=0.36 //x=3.82 //y=2.375 //x2=3.82 //y2=2.26
r635 (  1 2 ) resistor r=0.935115 //w=0.131 //l=0.98 //layer=m1 \
 //thickness=0.36 //x=3.82 //y=2.375 //x2=3.82 //y2=3.355
ends PM_TMRDFFSNRNQX1\%noxref_3

subckt PM_TMRDFFSNRNQX1\%noxref_4 ( 1 3 6 7 9 10 11 12 14 15 16 17 18 19 20 21 \
 24 27 35 39 49 51 52 55 63 71 88 97 101 102 103 104 105 106 107 108 110 116 \
 117 118 119 131 133 134 135 )
c291 ( 131 0 ) capacitor c=0.00885916f //x=23.125 //y=1.095
c292 ( 119 0 ) capacitor c=0.0612936f //x=25.925 //y=4.97
c293 ( 118 0 ) capacitor c=0.0376642f //x=26.215 //y=4.97
c294 ( 117 0 ) capacitor c=0.0346489f //x=25.88 //y=1.4
c295 ( 116 0 ) capacitor c=0.018692f //x=25.88 //y=1.055
c296 ( 110 0 ) capacitor c=0.0137077f //x=25.725 //y=1.555
c297 ( 108 0 ) capacitor c=0.0158585f //x=25.725 //y=0.9
c298 ( 107 0 ) capacitor c=0.0979464f //x=25.35 //y=2.095
c299 ( 106 0 ) capacitor c=0.0229444f //x=25.35 //y=1.71
c300 ( 105 0 ) capacitor c=0.0234359f //x=25.35 //y=1.4
c301 ( 104 0 ) capacitor c=0.019815f //x=25.35 //y=1.055
c302 ( 103 0 ) capacitor c=0.110208f //x=26.29 //y=6.2
c303 ( 102 0 ) capacitor c=0.158957f //x=25.85 //y=6.2
c304 ( 97 0 ) capacitor c=0.0014751f //x=25.65 //y=4.88
c305 ( 88 0 ) capacitor c=9.93222e-19 //x=25.65 //y=2.26
c306 ( 71 0 ) capacitor c=0.0293555f //x=23.02 //y=5.56
c307 ( 63 0 ) capacitor c=0.029137f //x=22.14 //y=5.56
c308 ( 55 0 ) capacitor c=0.0278099f //x=21.26 //y=5.56
c309 ( 52 0 ) capacitor c=0.0155627f //x=25.49 //y=2.755
c310 ( 51 0 ) capacitor c=6.61167e-19 //x=25.65 //y=2.755
c311 ( 49 0 ) capacitor c=9.01227e-19 //x=23.945 //y=2.755
c312 ( 39 0 ) capacitor c=0.0148615f //x=25.65 //y=2.77
c313 ( 35 0 ) capacitor c=0.0144534f //x=23.8 //y=2.77
c314 ( 27 0 ) capacitor c=9.58516e-19 //x=23.02 //y=5.335
c315 ( 24 0 ) capacitor c=0.00778188f //x=22.14 //y=5.335
c316 ( 21 0 ) capacitor c=0.0111234f //x=21.262 //y=5.335
c317 ( 20 0 ) capacitor c=0.0609075f //x=25.65 //y=4.755
c318 ( 19 0 ) capacitor c=0.0129174f //x=25.65 //y=2.915
c319 ( 18 0 ) capacitor c=0.00426674f //x=25.65 //y=2.595
c320 ( 17 0 ) capacitor c=0.00437465f //x=25.65 //y=2.375
c321 ( 16 0 ) capacitor c=0.0659613f //x=23.8 //y=5.25
c322 ( 15 0 ) capacitor c=0.0126937f //x=23.8 //y=2.915
c323 ( 14 0 ) capacitor c=0.0174955f //x=23.8 //y=2.595
c324 ( 12 0 ) capacitor c=0.0047266f //x=23.4 //y=1.845
c325 ( 11 0 ) capacitor c=0.0127862f //x=23.715 //y=1.845
c326 ( 10 0 ) capacitor c=0.0167992f //x=23.315 //y=1.76
c327 ( 9 0 ) capacitor c=0.0110975f //x=23.315 //y=1.305
c328 ( 7 0 ) capacitor c=0.0231753f //x=23.715 //y=5.335
c329 ( 6 0 ) capacitor c=0.00933983f //x=23.02 //y=5.56
c330 ( 3 0 ) capacitor c=0.019444f //x=22.905 //y=5.335
c331 ( 1 0 ) capacitor c=0.0151997f //x=22.02 //y=5.335
r332 (  118 120 ) resistor r=26.9307 //w=0.15 //l=0.106066 //layer=ply \
 //thickness=0.18 //x=26.215 //y=4.97 //x2=26.29 //y2=5.045
r333 (  118 119 ) resistor r=148.702 //w=0.094 //l=0.29 //layer=ply \
 //thickness=0.18 //x=26.215 //y=4.97 //x2=25.925 //y2=4.97
r334 (  117 130 ) resistor r=45.1352 //w=0.168 //l=0.173853 //layer=ply \
 //thickness=0.18 //x=25.88 //y=1.4 //x2=25.84 //y2=1.555
r335 (  116 129 ) resistor r=45.1352 //w=0.168 //l=0.173853 //layer=ply \
 //thickness=0.18 //x=25.88 //y=1.055 //x2=25.84 //y2=0.9
r336 (  116 117 ) resistor r=176.904 //w=0.094 //l=0.345 //layer=ply \
 //thickness=0.18 //x=25.88 //y=1.055 //x2=25.88 //y2=1.4
r337 (  113 119 ) resistor r=22.7971 //w=0.269 //l=0.106066 //layer=ply \
 //thickness=0.18 //x=25.85 //y=5.045 //x2=25.925 //y2=4.97
r338 (  113 128 ) resistor r=35.8364 //w=0.269 //l=0.270185 //layer=ply \
 //thickness=0.18 //x=25.85 //y=5.045 //x2=25.65 //y2=4.88
r339 (  111 124 ) resistor r=10.701 //w=0.21 //l=0.115 //layer=ply \
 //thickness=0.18 //x=25.505 //y=1.555 //x2=25.39 //y2=1.555
r340 (  110 130 ) resistor r=5.52526 //w=0.168 //l=0.115 //layer=ply \
 //thickness=0.18 //x=25.725 //y=1.555 //x2=25.84 //y2=1.555
r341 (  109 123 ) resistor r=5.52526 //w=0.168 //l=0.115 //layer=ply \
 //thickness=0.18 //x=25.505 //y=0.9 //x2=25.39 //y2=0.9
r342 (  108 129 ) resistor r=5.52526 //w=0.168 //l=0.115 //layer=ply \
 //thickness=0.18 //x=25.725 //y=0.9 //x2=25.84 //y2=0.9
r343 (  108 109 ) resistor r=112.809 //w=0.094 //l=0.22 //layer=ply \
 //thickness=0.18 //x=25.725 //y=0.9 //x2=25.505 //y2=0.9
r344 (  107 126 ) resistor r=58.7805 //w=0.246 //l=0.373497 //layer=ply \
 //thickness=0.18 //x=25.35 //y=2.095 //x2=25.65 //y2=2.26
r345 (  106 124 ) resistor r=39.5823 //w=0.21 //l=0.173853 //layer=ply \
 //thickness=0.18 //x=25.35 //y=1.71 //x2=25.39 //y2=1.555
r346 (  106 107 ) resistor r=197.415 //w=0.094 //l=0.385 //layer=ply \
 //thickness=0.18 //x=25.35 //y=1.71 //x2=25.35 //y2=2.095
r347 (  105 124 ) resistor r=39.5823 //w=0.21 //l=0.173853 //layer=ply \
 //thickness=0.18 //x=25.35 //y=1.4 //x2=25.39 //y2=1.555
r348 (  104 123 ) resistor r=45.1352 //w=0.168 //l=0.173853 //layer=ply \
 //thickness=0.18 //x=25.35 //y=1.055 //x2=25.39 //y2=0.9
r349 (  104 105 ) resistor r=176.904 //w=0.094 //l=0.345 //layer=ply \
 //thickness=0.18 //x=25.35 //y=1.055 //x2=25.35 //y2=1.4
r350 (  103 120 ) resistor r=592.245 //w=0.094 //l=1.155 //layer=ply \
 //thickness=0.18 //x=26.29 //y=6.2 //x2=26.29 //y2=5.045
r351 (  102 113 ) resistor r=592.245 //w=0.094 //l=1.155 //layer=ply \
 //thickness=0.18 //x=25.85 //y=6.2 //x2=25.85 //y2=5.045
r352 (  101 110 ) resistor r=56.4043 //w=0.094 //l=0.11 //layer=ply \
 //thickness=0.18 //x=25.615 //y=1.555 //x2=25.725 //y2=1.555
r353 (  101 111 ) resistor r=56.4043 //w=0.094 //l=0.11 //layer=ply \
 //thickness=0.18 //x=25.615 //y=1.555 //x2=25.505 //y2=1.555
r354 (  97 128 ) resistor r=152 //w=0.17 //l=0.17 //layer=licon //count=1 \
 //x=25.65 //y=4.88 //x2=25.65 //y2=4.88
r355 (  88 126 ) resistor r=152 //w=0.17 //l=0.17 //layer=licon //count=1 \
 //x=25.65 //y=2.26 //x2=25.65 //y2=2.26
r356 (  71 135 ) resistor r=23.615 //w=0.187 //l=0.345 //layer=li \
 //thickness=0.1 //x=23.02 //y=5.56 //x2=23.02 //y2=5.905
r357 (  63 134 ) resistor r=23.615 //w=0.187 //l=0.345 //layer=li \
 //thickness=0.1 //x=22.14 //y=5.56 //x2=22.14 //y2=5.905
r358 (  55 133 ) resistor r=23.615 //w=0.187 //l=0.345 //layer=li \
 //thickness=0.1 //x=21.26 //y=5.56 //x2=21.26 //y2=5.905
r359 (  51 52 ) resistor r=0.10734 //w=0.281 //l=0.16 //layer=m2 \
 //thickness=0.36 //x=25.65 //y=2.755 //x2=25.49 //y2=2.755
r360 (  49 52 ) resistor r=1.47424 //w=0.131 //l=1.545 //layer=m2 \
 //thickness=0.36 //x=23.945 //y=2.77 //x2=25.49 //y2=2.77
r361 (  47 49 ) resistor r=0.10734 //w=0.281 //l=0.16 //layer=m2 \
 //thickness=0.36 //x=23.785 //y=2.755 //x2=23.945 //y2=2.755
r362 (  43 97 ) resistor r=9.3 //w=0.17 //l=0.17 //layer=mcon //count=1 \
 //x=25.65 //y=4.88 //x2=25.65 //y2=4.88
r363 (  41 88 ) resistor r=9.3 //w=0.17 //l=0.17 //layer=mcon //count=1 \
 //x=25.65 //y=2.26 //x2=25.65 //y2=2.26
r364 (  37 51 ) resistor r=4.5 //w=0.15 //l=0.15 //layer=via1 //count=1 \
 //x=25.65 //y=2.755 //x2=25.65 //y2=2.755
r365 (  37 39 ) resistor r=0.0049867 //w=0.376 //l=0.015 //layer=m1 \
 //thickness=0.36 //x=25.597 //y=2.755 //x2=25.597 //y2=2.77
r366 (  33 47 ) resistor r=4.5 //w=0.15 //l=0.15 //layer=via1 //count=1 \
 //x=23.785 //y=2.755 //x2=23.785 //y2=2.755
r367 (  33 35 ) resistor r=0.00488281 //w=0.384 //l=0.015 //layer=m1 \
 //thickness=0.36 //x=23.845 //y=2.755 //x2=23.845 //y2=2.77
r368 (  31 131 ) resistor r=9.3 //w=0.17 //l=0.17 //layer=mcon //count=1 \
 //x=23.315 //y=1.19 //x2=23.315 //y2=1.19
r369 (  29 71 ) resistor r=9.3 //w=0.17 //l=0.17 //layer=mcon //count=1 \
 //x=23.02 //y=5.56 //x2=23.02 //y2=5.56
r370 (  26 63 ) resistor r=9.3 //w=0.17 //l=0.17 //layer=mcon //count=1 \
 //x=22.14 //y=5.56 //x2=22.14 //y2=5.56
r371 (  24 26 ) resistor r=0.121228 //w=0.232 //l=0.225 //layer=m1 \
 //thickness=0.36 //x=22.14 //y=5.335 //x2=22.14 //y2=5.56
r372 (  23 55 ) resistor r=9.3 //w=0.17 //l=0.17 //layer=mcon //count=1 \
 //x=21.26 //y=5.56 //x2=21.26 //y2=5.56
r373 (  21 23 ) resistor r=0.129608 //w=0.217 //l=0.225 //layer=m1 \
 //thickness=0.36 //x=21.262 //y=5.335 //x2=21.262 //y2=5.56
r374 (  20 43 ) resistor r=0.0760407 //w=0.238 //l=0.125 //layer=m1 \
 //thickness=0.36 //x=25.65 //y=4.755 //x2=25.65 //y2=4.88
r375 (  19 39 ) resistor r=0.0861726 //w=0.376 //l=0.16944 //layer=m1 \
 //thickness=0.36 //x=25.65 //y=2.915 //x2=25.597 //y2=2.77
r376 (  19 20 ) resistor r=1.75573 //w=0.131 //l=1.84 //layer=m1 \
 //thickness=0.36 //x=25.65 //y=2.915 //x2=25.65 //y2=4.755
r377 (  18 37 ) resistor r=0.0911593 //w=0.376 //l=0.184608 //layer=m1 \
 //thickness=0.36 //x=25.65 //y=2.595 //x2=25.597 //y2=2.755
r378 (  17 41 ) resistor r=0.0719237 //w=0.222 //l=0.115 //layer=m1 \
 //thickness=0.36 //x=25.65 //y=2.375 //x2=25.65 //y2=2.26
r379 (  17 18 ) resistor r=0.209924 //w=0.131 //l=0.22 //layer=m1 \
 //thickness=0.36 //x=25.65 //y=2.375 //x2=25.65 //y2=2.595
r380 (  15 35 ) resistor r=0.0866104 //w=0.384 //l=0.165982 //layer=m1 \
 //thickness=0.36 //x=23.8 //y=2.915 //x2=23.845 //y2=2.77
r381 (  15 16 ) resistor r=2.22805 //w=0.131 //l=2.335 //layer=m1 \
 //thickness=0.36 //x=23.8 //y=2.915 //x2=23.8 //y2=5.25
r382 (  14 33 ) resistor r=0.0914932 //w=0.384 //l=0.181108 //layer=m1 \
 //thickness=0.36 //x=23.8 //y=2.595 //x2=23.845 //y2=2.755
r383 (  13 14 ) resistor r=0.634542 //w=0.131 //l=0.665 //layer=m1 \
 //thickness=0.36 //x=23.8 //y=1.93 //x2=23.8 //y2=2.595
r384 (  11 13 ) resistor r=0.0698411 //w=0.17 //l=0.120208 //layer=m1 \
 //thickness=0.36 //x=23.715 //y=1.845 //x2=23.8 //y2=1.93
r385 (  11 12 ) resistor r=0.300573 //w=0.131 //l=0.315 //layer=m1 \
 //thickness=0.36 //x=23.715 //y=1.845 //x2=23.4 //y2=1.845
r386 (  10 12 ) resistor r=0.0698411 //w=0.17 //l=0.120208 //layer=m1 \
 //thickness=0.36 //x=23.315 //y=1.76 //x2=23.4 //y2=1.845
r387 (  9 31 ) resistor r=0.0717383 //w=0.224 //l=0.115 //layer=m1 \
 //thickness=0.36 //x=23.315 //y=1.305 //x2=23.315 //y2=1.19
r388 (  9 10 ) resistor r=0.43416 //w=0.131 //l=0.455 //layer=m1 \
 //thickness=0.36 //x=23.315 //y=1.305 //x2=23.315 //y2=1.76
r389 (  8 27 ) resistor r=0.0675342 //w=0.23 //l=0.115 //layer=m1 \
 //thickness=0.36 //x=23.135 //y=5.335 //x2=23.02 //y2=5.335
r390 (  7 16 ) resistor r=0.0698411 //w=0.17 //l=0.120208 //layer=m1 \
 //thickness=0.36 //x=23.715 //y=5.335 //x2=23.8 //y2=5.25
r391 (  7 8 ) resistor r=0.553435 //w=0.131 //l=0.58 //layer=m1 \
 //thickness=0.36 //x=23.715 //y=5.335 //x2=23.135 //y2=5.335
r392 (  6 29 ) resistor r=0.00118313 //w=0.23 //layer=m1 //thickness=0.36 \
 //x=23.02 //y=5.56 //x2=23.02 //y2=5.56
r393 (  5 27 ) resistor r=0.002872 //w=0.34 //l=0.085 //layer=m1 \
 //thickness=0.36 //x=23.02 //y=5.42 //x2=23.02 //y2=5.335
r394 (  5 6 ) resistor r=0.091623 //w=0.191 //l=0.14 //layer=m1 \
 //thickness=0.36 //x=23.02 //y=5.42 //x2=23.02 //y2=5.56
r395 (  4 24 ) resistor r=0.0262263 //w=0.232 //l=0.12 //layer=m1 \
 //thickness=0.36 //x=22.26 //y=5.335 //x2=22.14 //y2=5.335
r396 (  3 27 ) resistor r=0.0675342 //w=0.23 //l=0.115 //layer=m1 \
 //thickness=0.36 //x=22.905 //y=5.335 //x2=23.02 //y2=5.335
r397 (  3 4 ) resistor r=0.615458 //w=0.131 //l=0.645 //layer=m1 \
 //thickness=0.36 //x=22.905 //y=5.335 //x2=22.26 //y2=5.335
r398 (  2 21 ) resistor r=0.0222262 //w=0.217 //l=0.118 //layer=m1 \
 //thickness=0.36 //x=21.38 //y=5.335 //x2=21.262 //y2=5.335
r399 (  1 24 ) resistor r=0.0262263 //w=0.232 //l=0.12 //layer=m1 \
 //thickness=0.36 //x=22.02 //y=5.335 //x2=22.14 //y2=5.335
r400 (  1 2 ) resistor r=0.610687 //w=0.131 //l=0.64 //layer=m1 \
 //thickness=0.36 //x=22.02 //y=5.335 //x2=21.38 //y2=5.335
ends PM_TMRDFFSNRNQX1\%noxref_4

subckt PM_TMRDFFSNRNQX1\%noxref_5 ( 1 2 3 4 5 6 7 8 9 11 14 15 17 18 19 20 22 \
 23 24 25 26 27 28 34 38 45 48 51 57 61 70 72 73 77 80 81 87 96 101 110 115 \
 123 131 148 157 161 162 163 164 165 166 167 168 169 173 174 175 180 182 185 \
 186 190 191 192 197 199 202 203 207 208 209 214 216 219 220 222 223 228 232 \
 233 238 242 243 248 251 253 254 255 )
c601 ( 251 0 ) capacitor c=0.00885916f //x=18.315 //y=1.095
c602 ( 248 0 ) capacitor c=0.0634276f //x=27.87 //y=4.88
c603 ( 243 0 ) capacitor c=0.0278202f //x=27.87 //y=2.095
c604 ( 242 0 ) capacitor c=0.0503043f //x=27.87 //y=2.26
c605 ( 238 0 ) capacitor c=0.0651406f //x=13.44 //y=4.88
c606 ( 233 0 ) capacitor c=0.0278202f //x=13.44 //y=2.095
c607 ( 232 0 ) capacitor c=0.0503043f //x=13.44 //y=2.26
c608 ( 228 0 ) capacitor c=0.0653609f //x=8.63 //y=4.88
c609 ( 223 0 ) capacitor c=0.0278202f //x=8.63 //y=2.095
c610 ( 222 0 ) capacitor c=0.0503043f //x=8.63 //y=2.26
c611 ( 220 0 ) capacitor c=0.0443175f //x=28.39 //y=1.44
c612 ( 219 0 ) capacitor c=0.0199703f //x=28.39 //y=1.095
c613 ( 216 0 ) capacitor c=0.0162526f //x=28.235 //y=1.595
c614 ( 214 0 ) capacitor c=0.0157807f //x=28.235 //y=0.94
c615 ( 209 0 ) capacitor c=0.0220935f //x=27.86 //y=1.75
c616 ( 208 0 ) capacitor c=0.0207489f //x=27.86 //y=1.44
c617 ( 207 0 ) capacitor c=0.0194091f //x=27.86 //y=1.095
c618 ( 203 0 ) capacitor c=0.0443175f //x=13.96 //y=1.44
c619 ( 202 0 ) capacitor c=0.0199703f //x=13.96 //y=1.095
c620 ( 199 0 ) capacitor c=0.0162526f //x=13.805 //y=1.595
c621 ( 197 0 ) capacitor c=0.0157807f //x=13.805 //y=0.94
c622 ( 192 0 ) capacitor c=0.0220935f //x=13.43 //y=1.75
c623 ( 191 0 ) capacitor c=0.0207489f //x=13.43 //y=1.44
c624 ( 190 0 ) capacitor c=0.0194091f //x=13.43 //y=1.095
c625 ( 186 0 ) capacitor c=0.0443175f //x=9.15 //y=1.44
c626 ( 185 0 ) capacitor c=0.0199703f //x=9.15 //y=1.095
c627 ( 182 0 ) capacitor c=0.0162526f //x=8.995 //y=1.595
c628 ( 180 0 ) capacitor c=0.0157807f //x=8.995 //y=0.94
c629 ( 175 0 ) capacitor c=0.0220935f //x=8.62 //y=1.75
c630 ( 174 0 ) capacitor c=0.0207489f //x=8.62 //y=1.44
c631 ( 173 0 ) capacitor c=0.0194091f //x=8.62 //y=1.095
c632 ( 169 0 ) capacitor c=0.159331f //x=28.05 //y=6.2
c633 ( 168 0 ) capacitor c=0.110208f //x=27.61 //y=6.2
c634 ( 167 0 ) capacitor c=0.159671f //x=13.62 //y=6.2
c635 ( 166 0 ) capacitor c=0.110208f //x=13.18 //y=6.2
c636 ( 165 0 ) capacitor c=0.159671f //x=8.81 //y=6.2
c637 ( 164 0 ) capacitor c=0.110208f //x=8.37 //y=6.2
c638 ( 157 0 ) capacitor c=7.7417e-19 //x=27.87 //y=4.88
c639 ( 148 0 ) capacitor c=0.00101179f //x=27.87 //y=2.26
c640 ( 131 0 ) capacitor c=0.0293124f //x=18.21 //y=5.56
c641 ( 123 0 ) capacitor c=0.029137f //x=17.33 //y=5.56
c642 ( 115 0 ) capacitor c=0.0278099f //x=16.45 //y=5.56
c643 ( 110 0 ) capacitor c=7.7417e-19 //x=13.44 //y=4.88
c644 ( 101 0 ) capacitor c=0.00101179f //x=13.44 //y=2.26
c645 ( 96 0 ) capacitor c=7.7417e-19 //x=8.63 //y=4.88
c646 ( 87 0 ) capacitor c=0.00101179f //x=8.63 //y=2.26
c647 ( 81 0 ) capacitor c=6.2466e-19 //x=13.6 //y=3.895
c648 ( 80 0 ) capacitor c=0.0446269f //x=13.28 //y=3.895
c649 ( 77 0 ) capacitor c=6.16295e-19 //x=8.79 //y=3.895
c650 ( 73 0 ) capacitor c=0.0212158f //x=20.705 //y=3.895
c651 ( 72 0 ) capacitor c=0.0724152f //x=21.05 //y=3.895
c652 ( 70 0 ) capacitor c=0.0535679f //x=18.82 //y=3.88
c653 ( 61 0 ) capacitor c=0.0149589f //x=27.87 //y=3.88
c654 ( 57 0 ) capacitor c=0.0158949f //x=18.99 //y=3.88
c655 ( 51 0 ) capacitor c=0.00111241f //x=18.21 //y=5.335
c656 ( 48 0 ) capacitor c=0.00731246f //x=17.33 //y=5.335
c657 ( 45 0 ) capacitor c=0.0111234f //x=16.452 //y=5.335
c658 ( 38 0 ) capacitor c=0.0149589f //x=13.44 //y=3.88
c659 ( 34 0 ) capacitor c=0.0149589f //x=8.63 //y=3.88
c660 ( 28 0 ) capacitor c=0.0194115f //x=27.87 //y=4.75
c661 ( 27 0 ) capacitor c=0.011467f //x=27.87 //y=4.045
c662 ( 26 0 ) capacitor c=0.0290894f //x=27.87 //y=3.725
c663 ( 25 0 ) capacitor c=0.00556102f //x=27.87 //y=2.375
c664 ( 24 0 ) capacitor c=0.0323149f //x=18.99 //y=5.25
c665 ( 23 0 ) capacitor c=0.0138897f //x=18.99 //y=4.055
c666 ( 22 0 ) capacitor c=0.0490588f //x=18.99 //y=3.735
c667 ( 20 0 ) capacitor c=0.00493487f //x=18.59 //y=1.845
c668 ( 19 0 ) capacitor c=0.0133342f //x=18.905 //y=1.845
c669 ( 18 0 ) capacitor c=0.0167992f //x=18.505 //y=1.76
c670 ( 17 0 ) capacitor c=0.0111491f //x=18.505 //y=1.305
c671 ( 15 0 ) capacitor c=0.0238276f //x=18.905 //y=5.335
c672 ( 14 0 ) capacitor c=0.00933983f //x=18.21 //y=5.56
c673 ( 11 0 ) capacitor c=0.019596f //x=18.095 //y=5.335
c674 ( 9 0 ) capacitor c=0.0148057f //x=17.21 //y=5.335
c675 ( 8 0 ) capacitor c=0.0195876f //x=13.44 //y=4.75
c676 ( 7 0 ) capacitor c=0.011494f //x=13.44 //y=4.055
c677 ( 6 0 ) capacitor c=0.029293f //x=13.44 //y=3.735
c678 ( 5 0 ) capacitor c=0.00556102f //x=13.44 //y=2.375
c679 ( 4 0 ) capacitor c=0.019633f //x=8.63 //y=4.75
c680 ( 3 0 ) capacitor c=0.0115187f //x=8.63 //y=4.055
c681 ( 2 0 ) capacitor c=0.0329467f //x=8.63 //y=3.735
c682 ( 1 0 ) capacitor c=0.00556102f //x=8.63 //y=2.375
r683 (  242 243 ) resistor r=52.7279 //w=0.214 //l=0.165 //layer=ply \
 //thickness=0.18 //x=27.87 //y=2.26 //x2=27.87 //y2=2.095
r684 (  232 233 ) resistor r=52.7279 //w=0.214 //l=0.165 //layer=ply \
 //thickness=0.18 //x=13.44 //y=2.26 //x2=13.44 //y2=2.095
r685 (  222 223 ) resistor r=52.7279 //w=0.214 //l=0.165 //layer=ply \
 //thickness=0.18 //x=8.63 //y=2.26 //x2=8.63 //y2=2.095
r686 (  220 250 ) resistor r=45.1352 //w=0.168 //l=0.173853 //layer=ply \
 //thickness=0.18 //x=28.39 //y=1.44 //x2=28.35 //y2=1.595
r687 (  219 249 ) resistor r=45.1352 //w=0.168 //l=0.173853 //layer=ply \
 //thickness=0.18 //x=28.39 //y=1.095 //x2=28.35 //y2=0.94
r688 (  219 220 ) resistor r=176.904 //w=0.094 //l=0.345 //layer=ply \
 //thickness=0.18 //x=28.39 //y=1.095 //x2=28.39 //y2=1.44
r689 (  217 246 ) resistor r=10.701 //w=0.21 //l=0.115 //layer=ply \
 //thickness=0.18 //x=28.015 //y=1.595 //x2=27.9 //y2=1.595
r690 (  216 250 ) resistor r=5.52526 //w=0.168 //l=0.115 //layer=ply \
 //thickness=0.18 //x=28.235 //y=1.595 //x2=28.35 //y2=1.595
r691 (  215 245 ) resistor r=5.52526 //w=0.168 //l=0.115 //layer=ply \
 //thickness=0.18 //x=28.015 //y=0.94 //x2=27.9 //y2=0.94
r692 (  214 249 ) resistor r=5.52526 //w=0.168 //l=0.115 //layer=ply \
 //thickness=0.18 //x=28.235 //y=0.94 //x2=28.35 //y2=0.94
r693 (  214 215 ) resistor r=112.809 //w=0.094 //l=0.22 //layer=ply \
 //thickness=0.18 //x=28.235 //y=0.94 //x2=28.015 //y2=0.94
r694 (  211 248 ) resistor r=37.236 //w=0.233 //l=0.249199 //layer=ply \
 //thickness=0.18 //x=28.05 //y=5.045 //x2=27.87 //y2=4.88
r695 (  209 246 ) resistor r=39.5823 //w=0.21 //l=0.173853 //layer=ply \
 //thickness=0.18 //x=27.86 //y=1.75 //x2=27.9 //y2=1.595
r696 (  209 243 ) resistor r=176.904 //w=0.094 //l=0.345 //layer=ply \
 //thickness=0.18 //x=27.86 //y=1.75 //x2=27.86 //y2=2.095
r697 (  208 246 ) resistor r=39.5823 //w=0.21 //l=0.173853 //layer=ply \
 //thickness=0.18 //x=27.86 //y=1.44 //x2=27.9 //y2=1.595
r698 (  207 245 ) resistor r=45.1352 //w=0.168 //l=0.173853 //layer=ply \
 //thickness=0.18 //x=27.86 //y=1.095 //x2=27.9 //y2=0.94
r699 (  207 208 ) resistor r=176.904 //w=0.094 //l=0.345 //layer=ply \
 //thickness=0.18 //x=27.86 //y=1.095 //x2=27.86 //y2=1.44
r700 (  204 248 ) resistor r=53.7854 //w=0.233 //l=0.332415 //layer=ply \
 //thickness=0.18 //x=27.61 //y=5.045 //x2=27.87 //y2=4.88
r701 (  203 240 ) resistor r=45.1352 //w=0.168 //l=0.173853 //layer=ply \
 //thickness=0.18 //x=13.96 //y=1.44 //x2=13.92 //y2=1.595
r702 (  202 239 ) resistor r=45.1352 //w=0.168 //l=0.173853 //layer=ply \
 //thickness=0.18 //x=13.96 //y=1.095 //x2=13.92 //y2=0.94
r703 (  202 203 ) resistor r=176.904 //w=0.094 //l=0.345 //layer=ply \
 //thickness=0.18 //x=13.96 //y=1.095 //x2=13.96 //y2=1.44
r704 (  200 236 ) resistor r=10.701 //w=0.21 //l=0.115 //layer=ply \
 //thickness=0.18 //x=13.585 //y=1.595 //x2=13.47 //y2=1.595
r705 (  199 240 ) resistor r=5.52526 //w=0.168 //l=0.115 //layer=ply \
 //thickness=0.18 //x=13.805 //y=1.595 //x2=13.92 //y2=1.595
r706 (  198 235 ) resistor r=5.52526 //w=0.168 //l=0.115 //layer=ply \
 //thickness=0.18 //x=13.585 //y=0.94 //x2=13.47 //y2=0.94
r707 (  197 239 ) resistor r=5.52526 //w=0.168 //l=0.115 //layer=ply \
 //thickness=0.18 //x=13.805 //y=0.94 //x2=13.92 //y2=0.94
r708 (  197 198 ) resistor r=112.809 //w=0.094 //l=0.22 //layer=ply \
 //thickness=0.18 //x=13.805 //y=0.94 //x2=13.585 //y2=0.94
r709 (  194 238 ) resistor r=37.236 //w=0.233 //l=0.249199 //layer=ply \
 //thickness=0.18 //x=13.62 //y=5.045 //x2=13.44 //y2=4.88
r710 (  192 236 ) resistor r=39.5823 //w=0.21 //l=0.173853 //layer=ply \
 //thickness=0.18 //x=13.43 //y=1.75 //x2=13.47 //y2=1.595
r711 (  192 233 ) resistor r=176.904 //w=0.094 //l=0.345 //layer=ply \
 //thickness=0.18 //x=13.43 //y=1.75 //x2=13.43 //y2=2.095
r712 (  191 236 ) resistor r=39.5823 //w=0.21 //l=0.173853 //layer=ply \
 //thickness=0.18 //x=13.43 //y=1.44 //x2=13.47 //y2=1.595
r713 (  190 235 ) resistor r=45.1352 //w=0.168 //l=0.173853 //layer=ply \
 //thickness=0.18 //x=13.43 //y=1.095 //x2=13.47 //y2=0.94
r714 (  190 191 ) resistor r=176.904 //w=0.094 //l=0.345 //layer=ply \
 //thickness=0.18 //x=13.43 //y=1.095 //x2=13.43 //y2=1.44
r715 (  187 238 ) resistor r=53.7854 //w=0.233 //l=0.332415 //layer=ply \
 //thickness=0.18 //x=13.18 //y=5.045 //x2=13.44 //y2=4.88
r716 (  186 230 ) resistor r=45.1352 //w=0.168 //l=0.173853 //layer=ply \
 //thickness=0.18 //x=9.15 //y=1.44 //x2=9.11 //y2=1.595
r717 (  185 229 ) resistor r=45.1352 //w=0.168 //l=0.173853 //layer=ply \
 //thickness=0.18 //x=9.15 //y=1.095 //x2=9.11 //y2=0.94
r718 (  185 186 ) resistor r=176.904 //w=0.094 //l=0.345 //layer=ply \
 //thickness=0.18 //x=9.15 //y=1.095 //x2=9.15 //y2=1.44
r719 (  183 226 ) resistor r=10.701 //w=0.21 //l=0.115 //layer=ply \
 //thickness=0.18 //x=8.775 //y=1.595 //x2=8.66 //y2=1.595
r720 (  182 230 ) resistor r=5.52526 //w=0.168 //l=0.115 //layer=ply \
 //thickness=0.18 //x=8.995 //y=1.595 //x2=9.11 //y2=1.595
r721 (  181 225 ) resistor r=5.52526 //w=0.168 //l=0.115 //layer=ply \
 //thickness=0.18 //x=8.775 //y=0.94 //x2=8.66 //y2=0.94
r722 (  180 229 ) resistor r=5.52526 //w=0.168 //l=0.115 //layer=ply \
 //thickness=0.18 //x=8.995 //y=0.94 //x2=9.11 //y2=0.94
r723 (  180 181 ) resistor r=112.809 //w=0.094 //l=0.22 //layer=ply \
 //thickness=0.18 //x=8.995 //y=0.94 //x2=8.775 //y2=0.94
r724 (  177 228 ) resistor r=37.236 //w=0.233 //l=0.249199 //layer=ply \
 //thickness=0.18 //x=8.81 //y=5.045 //x2=8.63 //y2=4.88
r725 (  175 226 ) resistor r=39.5823 //w=0.21 //l=0.173853 //layer=ply \
 //thickness=0.18 //x=8.62 //y=1.75 //x2=8.66 //y2=1.595
r726 (  175 223 ) resistor r=176.904 //w=0.094 //l=0.345 //layer=ply \
 //thickness=0.18 //x=8.62 //y=1.75 //x2=8.62 //y2=2.095
r727 (  174 226 ) resistor r=39.5823 //w=0.21 //l=0.173853 //layer=ply \
 //thickness=0.18 //x=8.62 //y=1.44 //x2=8.66 //y2=1.595
r728 (  173 225 ) resistor r=45.1352 //w=0.168 //l=0.173853 //layer=ply \
 //thickness=0.18 //x=8.62 //y=1.095 //x2=8.66 //y2=0.94
r729 (  173 174 ) resistor r=176.904 //w=0.094 //l=0.345 //layer=ply \
 //thickness=0.18 //x=8.62 //y=1.095 //x2=8.62 //y2=1.44
r730 (  170 228 ) resistor r=53.7854 //w=0.233 //l=0.332415 //layer=ply \
 //thickness=0.18 //x=8.37 //y=5.045 //x2=8.63 //y2=4.88
r731 (  169 211 ) resistor r=592.245 //w=0.094 //l=1.155 //layer=ply \
 //thickness=0.18 //x=28.05 //y=6.2 //x2=28.05 //y2=5.045
r732 (  168 204 ) resistor r=592.245 //w=0.094 //l=1.155 //layer=ply \
 //thickness=0.18 //x=27.61 //y=6.2 //x2=27.61 //y2=5.045
r733 (  167 194 ) resistor r=592.245 //w=0.094 //l=1.155 //layer=ply \
 //thickness=0.18 //x=13.62 //y=6.2 //x2=13.62 //y2=5.045
r734 (  166 187 ) resistor r=592.245 //w=0.094 //l=1.155 //layer=ply \
 //thickness=0.18 //x=13.18 //y=6.2 //x2=13.18 //y2=5.045
r735 (  165 177 ) resistor r=592.245 //w=0.094 //l=1.155 //layer=ply \
 //thickness=0.18 //x=8.81 //y=6.2 //x2=8.81 //y2=5.045
r736 (  164 170 ) resistor r=592.245 //w=0.094 //l=1.155 //layer=ply \
 //thickness=0.18 //x=8.37 //y=6.2 //x2=8.37 //y2=5.045
r737 (  163 216 ) resistor r=56.4043 //w=0.094 //l=0.11 //layer=ply \
 //thickness=0.18 //x=28.125 //y=1.595 //x2=28.235 //y2=1.595
r738 (  163 217 ) resistor r=56.4043 //w=0.094 //l=0.11 //layer=ply \
 //thickness=0.18 //x=28.125 //y=1.595 //x2=28.015 //y2=1.595
r739 (  162 199 ) resistor r=56.4043 //w=0.094 //l=0.11 //layer=ply \
 //thickness=0.18 //x=13.695 //y=1.595 //x2=13.805 //y2=1.595
r740 (  162 200 ) resistor r=56.4043 //w=0.094 //l=0.11 //layer=ply \
 //thickness=0.18 //x=13.695 //y=1.595 //x2=13.585 //y2=1.595
r741 (  161 182 ) resistor r=56.4043 //w=0.094 //l=0.11 //layer=ply \
 //thickness=0.18 //x=8.885 //y=1.595 //x2=8.995 //y2=1.595
r742 (  161 183 ) resistor r=56.4043 //w=0.094 //l=0.11 //layer=ply \
 //thickness=0.18 //x=8.885 //y=1.595 //x2=8.775 //y2=1.595
r743 (  157 248 ) resistor r=152 //w=0.17 //l=0.17 //layer=licon //count=1 \
 //x=27.87 //y=4.88 //x2=27.87 //y2=4.88
r744 (  148 242 ) resistor r=152 //w=0.17 //l=0.17 //layer=licon //count=1 \
 //x=27.87 //y=2.26 //x2=27.87 //y2=2.26
r745 (  131 255 ) resistor r=23.615 //w=0.187 //l=0.345 //layer=li \
 //thickness=0.1 //x=18.21 //y=5.56 //x2=18.21 //y2=5.905
r746 (  123 254 ) resistor r=23.615 //w=0.187 //l=0.345 //layer=li \
 //thickness=0.1 //x=17.33 //y=5.56 //x2=17.33 //y2=5.905
r747 (  115 253 ) resistor r=23.615 //w=0.187 //l=0.345 //layer=li \
 //thickness=0.1 //x=16.45 //y=5.56 //x2=16.45 //y2=5.905
r748 (  110 238 ) resistor r=152 //w=0.17 //l=0.17 //layer=licon //count=1 \
 //x=13.44 //y=4.88 //x2=13.44 //y2=4.88
r749 (  101 232 ) resistor r=152 //w=0.17 //l=0.17 //layer=licon //count=1 \
 //x=13.44 //y=2.26 //x2=13.44 //y2=2.26
r750 (  96 228 ) resistor r=152 //w=0.17 //l=0.17 //layer=licon //count=1 \
 //x=8.63 //y=4.88 //x2=8.63 //y2=4.88
r751 (  87 222 ) resistor r=152 //w=0.17 //l=0.17 //layer=licon //count=1 \
 //x=8.63 //y=2.26 //x2=8.63 //y2=2.26
r752 (  79 81 ) resistor r=0.10734 //w=0.281 //l=0.16 //layer=m2 \
 //thickness=0.36 //x=13.44 //y=3.895 //x2=13.6 //y2=3.895
r753 (  79 80 ) resistor r=0.10734 //w=0.281 //l=0.16 //layer=m2 \
 //thickness=0.36 //x=13.44 //y=3.895 //x2=13.28 //y2=3.895
r754 (  77 80 ) resistor r=4.28435 //w=0.131 //l=4.49 //layer=m2 \
 //thickness=0.36 //x=8.79 //y=3.88 //x2=13.28 //y2=3.88
r755 (  75 77 ) resistor r=0.10734 //w=0.281 //l=0.16 //layer=m2 \
 //thickness=0.36 //x=8.63 //y=3.895 //x2=8.79 //y2=3.895
r756 (  73 83 ) resistor r=1.10266 //w=0.196 //l=1.725 //layer=m2 \
 //thickness=0.36 //x=20.705 //y=3.895 //x2=18.98 //y2=3.895
r757 (  72 85 ) resistor r=4.81638 //w=0.177 //l=6.825 //layer=m2 \
 //thickness=0.36 //x=21.05 //y=3.895 //x2=27.87 //y2=3.885
r758 (  72 73 ) resistor r=0.329198 //w=0.131 //l=0.345 //layer=m2 \
 //thickness=0.36 //x=21.05 //y=3.895 //x2=20.705 //y2=3.895
r759 (  70 83 ) resistor r=0.104578 //w=0.196 //l=0.167332 //layer=m2 \
 //thickness=0.36 //x=18.82 //y=3.88 //x2=18.98 //y2=3.895
r760 (  70 81 ) resistor r=4.98092 //w=0.131 //l=5.22 //layer=m2 \
 //thickness=0.36 //x=18.82 //y=3.88 //x2=13.6 //y2=3.88
r761 (  67 157 ) resistor r=9.3 //w=0.17 //l=0.17 //layer=mcon //count=1 \
 //x=27.87 //y=4.88 //x2=27.87 //y2=4.88
r762 (  65 148 ) resistor r=9.3 //w=0.17 //l=0.17 //layer=mcon //count=1 \
 //x=27.87 //y=2.26 //x2=27.87 //y2=2.26
r763 (  63 85 ) resistor r=4.5 //w=0.15 //l=0.15 //layer=via1 //count=1 \
 //x=27.87 //y=3.885 //x2=27.87 //y2=3.885
r764 (  61 63 ) resistor r=0.00166223 //w=0.376 //l=0.005 //layer=m1 \
 //thickness=0.36 //x=27.817 //y=3.88 //x2=27.817 //y2=3.885
r765 (  59 83 ) resistor r=4.5 //w=0.15 //l=0.15 //layer=via1 //count=1 \
 //x=18.98 //y=3.895 //x2=18.98 //y2=3.895
r766 (  57 59 ) resistor r=0.00490838 //w=0.382 //l=0.015 //layer=m1 \
 //thickness=0.36 //x=19.037 //y=3.88 //x2=19.037 //y2=3.895
r767 (  55 251 ) resistor r=9.3 //w=0.17 //l=0.17 //layer=mcon //count=1 \
 //x=18.505 //y=1.19 //x2=18.505 //y2=1.19
r768 (  53 131 ) resistor r=9.3 //w=0.17 //l=0.17 //layer=mcon //count=1 \
 //x=18.21 //y=5.56 //x2=18.21 //y2=5.56
r769 (  50 123 ) resistor r=9.3 //w=0.17 //l=0.17 //layer=mcon //count=1 \
 //x=17.33 //y=5.56 //x2=17.33 //y2=5.56
r770 (  48 50 ) resistor r=0.121228 //w=0.232 //l=0.225 //layer=m1 \
 //thickness=0.36 //x=17.33 //y=5.335 //x2=17.33 //y2=5.56
r771 (  47 115 ) resistor r=9.3 //w=0.17 //l=0.17 //layer=mcon //count=1 \
 //x=16.45 //y=5.56 //x2=16.45 //y2=5.56
r772 (  45 47 ) resistor r=0.129608 //w=0.217 //l=0.225 //layer=m1 \
 //thickness=0.36 //x=16.452 //y=5.335 //x2=16.452 //y2=5.56
r773 (  44 110 ) resistor r=9.3 //w=0.17 //l=0.17 //layer=mcon //count=1 \
 //x=13.44 //y=4.88 //x2=13.44 //y2=4.88
r774 (  42 101 ) resistor r=9.3 //w=0.17 //l=0.17 //layer=mcon //count=1 \
 //x=13.44 //y=2.26 //x2=13.44 //y2=2.26
r775 (  40 79 ) resistor r=4.5 //w=0.15 //l=0.15 //layer=via1 //count=1 \
 //x=13.44 //y=3.895 //x2=13.44 //y2=3.895
r776 (  38 40 ) resistor r=0.0049867 //w=0.376 //l=0.015 //layer=m1 \
 //thickness=0.36 //x=13.387 //y=3.88 //x2=13.387 //y2=3.895
r777 (  36 75 ) resistor r=4.5 //w=0.15 //l=0.15 //layer=via1 //count=1 \
 //x=8.63 //y=3.895 //x2=8.63 //y2=3.895
r778 (  34 36 ) resistor r=0.0049867 //w=0.376 //l=0.015 //layer=m1 \
 //thickness=0.36 //x=8.682 //y=3.88 //x2=8.682 //y2=3.895
r779 (  32 96 ) resistor r=9.3 //w=0.17 //l=0.17 //layer=mcon //count=1 \
 //x=8.63 //y=4.88 //x2=8.63 //y2=4.88
r780 (  30 87 ) resistor r=9.3 //w=0.17 //l=0.17 //layer=mcon //count=1 \
 //x=8.63 //y=2.26 //x2=8.63 //y2=2.26
r781 (  28 67 ) resistor r=0.0801089 //w=0.224 //l=0.13 //layer=m1 \
 //thickness=0.36 //x=27.87 //y=4.75 //x2=27.87 //y2=4.88
r782 (  27 63 ) resistor r=0.0911593 //w=0.376 //l=0.184608 //layer=m1 \
 //thickness=0.36 //x=27.87 //y=4.045 //x2=27.817 //y2=3.885
r783 (  27 28 ) resistor r=0.67271 //w=0.131 //l=0.705 //layer=m1 \
 //thickness=0.36 //x=27.87 //y=4.045 //x2=27.87 //y2=4.75
r784 (  26 61 ) resistor r=0.0894971 //w=0.376 //l=0.179555 //layer=m1 \
 //thickness=0.36 //x=27.87 //y=3.725 //x2=27.817 //y2=3.88
r785 (  25 65 ) resistor r=0.0719237 //w=0.222 //l=0.115 //layer=m1 \
 //thickness=0.36 //x=27.87 //y=2.375 //x2=27.87 //y2=2.26
r786 (  25 26 ) resistor r=1.28817 //w=0.131 //l=1.35 //layer=m1 \
 //thickness=0.36 //x=27.87 //y=2.375 //x2=27.87 //y2=3.725
r787 (  23 59 ) resistor r=0.0914072 //w=0.382 //l=0.181989 //layer=m1 \
 //thickness=0.36 //x=18.99 //y=4.055 //x2=19.037 //y2=3.895
r788 (  23 24 ) resistor r=1.14027 //w=0.131 //l=1.195 //layer=m1 \
 //thickness=0.36 //x=18.99 //y=4.055 //x2=18.99 //y2=5.25
r789 (  22 57 ) resistor r=0.0864989 //w=0.382 //l=0.166853 //layer=m1 \
 //thickness=0.36 //x=18.99 //y=3.735 //x2=19.037 //y2=3.88
r790 (  21 22 ) resistor r=1.72233 //w=0.131 //l=1.805 //layer=m1 \
 //thickness=0.36 //x=18.99 //y=1.93 //x2=18.99 //y2=3.735
r791 (  19 21 ) resistor r=0.0698411 //w=0.17 //l=0.120208 //layer=m1 \
 //thickness=0.36 //x=18.905 //y=1.845 //x2=18.99 //y2=1.93
r792 (  19 20 ) resistor r=0.300573 //w=0.131 //l=0.315 //layer=m1 \
 //thickness=0.36 //x=18.905 //y=1.845 //x2=18.59 //y2=1.845
r793 (  18 20 ) resistor r=0.0698411 //w=0.17 //l=0.120208 //layer=m1 \
 //thickness=0.36 //x=18.505 //y=1.76 //x2=18.59 //y2=1.845
r794 (  17 55 ) resistor r=0.0717383 //w=0.224 //l=0.115 //layer=m1 \
 //thickness=0.36 //x=18.505 //y=1.305 //x2=18.505 //y2=1.19
r795 (  17 18 ) resistor r=0.43416 //w=0.131 //l=0.455 //layer=m1 \
 //thickness=0.36 //x=18.505 //y=1.305 //x2=18.505 //y2=1.76
r796 (  16 51 ) resistor r=0.0675342 //w=0.23 //l=0.115 //layer=m1 \
 //thickness=0.36 //x=18.325 //y=5.335 //x2=18.21 //y2=5.335
r797 (  15 24 ) resistor r=0.0698411 //w=0.17 //l=0.120208 //layer=m1 \
 //thickness=0.36 //x=18.905 //y=5.335 //x2=18.99 //y2=5.25
r798 (  15 16 ) resistor r=0.553435 //w=0.131 //l=0.58 //layer=m1 \
 //thickness=0.36 //x=18.905 //y=5.335 //x2=18.325 //y2=5.335
r799 (  14 53 ) resistor r=0.00118313 //w=0.23 //layer=m1 //thickness=0.36 \
 //x=18.21 //y=5.56 //x2=18.21 //y2=5.56
r800 (  13 51 ) resistor r=0.002872 //w=0.34 //l=0.085 //layer=m1 \
 //thickness=0.36 //x=18.21 //y=5.42 //x2=18.21 //y2=5.335
r801 (  13 14 ) resistor r=0.091623 //w=0.191 //l=0.14 //layer=m1 \
 //thickness=0.36 //x=18.21 //y=5.42 //x2=18.21 //y2=5.56
r802 (  12 48 ) resistor r=0.0262263 //w=0.232 //l=0.12 //layer=m1 \
 //thickness=0.36 //x=17.45 //y=5.335 //x2=17.33 //y2=5.335
r803 (  11 51 ) resistor r=0.0675342 //w=0.23 //l=0.115 //layer=m1 \
 //thickness=0.36 //x=18.095 //y=5.335 //x2=18.21 //y2=5.335
r804 (  11 12 ) resistor r=0.615458 //w=0.131 //l=0.645 //layer=m1 \
 //thickness=0.36 //x=18.095 //y=5.335 //x2=17.45 //y2=5.335
r805 (  10 45 ) resistor r=0.0222262 //w=0.217 //l=0.118 //layer=m1 \
 //thickness=0.36 //x=16.57 //y=5.335 //x2=16.452 //y2=5.335
r806 (  9 48 ) resistor r=0.0262263 //w=0.232 //l=0.12 //layer=m1 \
 //thickness=0.36 //x=17.21 //y=5.335 //x2=17.33 //y2=5.335
r807 (  9 10 ) resistor r=0.610687 //w=0.131 //l=0.64 //layer=m1 \
 //thickness=0.36 //x=17.21 //y=5.335 //x2=16.57 //y2=5.335
r808 (  8 44 ) resistor r=0.0801089 //w=0.224 //l=0.13 //layer=m1 \
 //thickness=0.36 //x=13.44 //y=4.75 //x2=13.44 //y2=4.88
r809 (  7 40 ) resistor r=0.0911593 //w=0.376 //l=0.184608 //layer=m1 \
 //thickness=0.36 //x=13.44 //y=4.055 //x2=13.387 //y2=3.895
r810 (  7 8 ) resistor r=0.663168 //w=0.131 //l=0.695 //layer=m1 \
 //thickness=0.36 //x=13.44 //y=4.055 //x2=13.44 //y2=4.75
r811 (  6 38 ) resistor r=0.0861726 //w=0.376 //l=0.16944 //layer=m1 \
 //thickness=0.36 //x=13.44 //y=3.735 //x2=13.387 //y2=3.88
r812 (  5 42 ) resistor r=0.0719237 //w=0.222 //l=0.115 //layer=m1 \
 //thickness=0.36 //x=13.44 //y=2.375 //x2=13.44 //y2=2.26
r813 (  5 6 ) resistor r=1.29771 //w=0.131 //l=1.36 //layer=m1 \
 //thickness=0.36 //x=13.44 //y=2.375 //x2=13.44 //y2=3.735
r814 (  4 32 ) resistor r=0.0801089 //w=0.224 //l=0.13 //layer=m1 \
 //thickness=0.36 //x=8.63 //y=4.75 //x2=8.63 //y2=4.88
r815 (  3 36 ) resistor r=0.0911593 //w=0.376 //l=0.184174 //layer=m1 \
 //thickness=0.36 //x=8.63 //y=4.055 //x2=8.682 //y2=3.895
r816 (  3 4 ) resistor r=0.663168 //w=0.131 //l=0.695 //layer=m1 \
 //thickness=0.36 //x=8.63 //y=4.055 //x2=8.63 //y2=4.75
r817 (  2 34 ) resistor r=0.0861726 //w=0.376 //l=0.169012 //layer=m1 \
 //thickness=0.36 //x=8.63 //y=3.735 //x2=8.682 //y2=3.88
r818 (  1 30 ) resistor r=0.0719237 //w=0.222 //l=0.115 //layer=m1 \
 //thickness=0.36 //x=8.63 //y=2.375 //x2=8.63 //y2=2.26
r819 (  1 2 ) resistor r=1.29771 //w=0.131 //l=1.36 //layer=m1 \
 //thickness=0.36 //x=8.63 //y=2.375 //x2=8.63 //y2=3.735
ends PM_TMRDFFSNRNQX1\%noxref_5

subckt PM_TMRDFFSNRNQX1\%noxref_6 ( 1 2 3 4 5 7 10 11 13 14 15 16 18 19 20 21 \
 22 30 31 34 37 43 47 48 49 50 52 54 62 71 76 84 92 112 113 114 118 119 120 \
 125 127 130 131 133 134 139 142 144 145 146 )
c335 ( 142 0 ) capacitor c=0.00885916f //x=27.935 //y=1.095
c336 ( 139 0 ) capacitor c=0.0710579f //x=23.06 //y=4.88
c337 ( 134 0 ) capacitor c=0.0278202f //x=23.06 //y=2.095
c338 ( 133 0 ) capacitor c=0.0479397f //x=23.06 //y=2.26
c339 ( 131 0 ) capacitor c=0.0443175f //x=23.58 //y=1.44
c340 ( 130 0 ) capacitor c=0.0199703f //x=23.58 //y=1.095
c341 ( 127 0 ) capacitor c=0.0162526f //x=23.425 //y=1.595
c342 ( 125 0 ) capacitor c=0.0157807f //x=23.425 //y=0.94
c343 ( 120 0 ) capacitor c=0.0220935f //x=23.05 //y=1.75
c344 ( 119 0 ) capacitor c=0.0207489f //x=23.05 //y=1.44
c345 ( 118 0 ) capacitor c=0.0194091f //x=23.05 //y=1.095
c346 ( 114 0 ) capacitor c=0.159671f //x=23.24 //y=6.2
c347 ( 113 0 ) capacitor c=0.110208f //x=22.8 //y=6.2
c348 ( 92 0 ) capacitor c=0.0293719f //x=27.83 //y=5.56
c349 ( 84 0 ) capacitor c=0.0292879f //x=26.95 //y=5.56
c350 ( 76 0 ) capacitor c=0.0278099f //x=26.07 //y=5.56
c351 ( 71 0 ) capacitor c=7.7417e-19 //x=23.06 //y=4.88
c352 ( 62 0 ) capacitor c=0.00101179f //x=23.06 //y=2.26
c353 ( 54 0 ) capacitor c=0.00585961f //x=28.085 //y=3.5
c354 ( 52 0 ) capacitor c=0.00520791f //x=27.485 //y=3.51
c355 ( 50 0 ) capacitor c=0.00334385f //x=26.975 //y=3.53
c356 ( 49 0 ) capacitor c=5.50259e-19 //x=23.22 //y=3.51
c357 ( 48 0 ) capacitor c=0.0359656f //x=26.375 //y=3.51
c358 ( 47 0 ) capacitor c=0.0141989f //x=28.61 //y=4.99
c359 ( 43 0 ) capacitor c=0.0155922f //x=28.61 //y=3.51
c360 ( 37 0 ) capacitor c=8.84507e-19 //x=27.83 //y=5.335
c361 ( 34 0 ) capacitor c=0.00768617f //x=26.95 //y=5.335
c362 ( 31 0 ) capacitor c=0.0111234f //x=26.072 //y=5.335
c363 ( 30 0 ) capacitor c=0.0166445f //x=23.06 //y=3.51
c364 ( 22 0 ) capacitor c=0.00384593f //x=28.61 //y=5.25
c365 ( 21 0 ) capacitor c=0.0149249f //x=28.61 //y=5.105
c366 ( 20 0 ) capacitor c=0.028596f //x=28.61 //y=4.875
c367 ( 19 0 ) capacitor c=0.0135501f //x=28.61 //y=3.685
c368 ( 18 0 ) capacitor c=0.0389407f //x=28.61 //y=3.365
c369 ( 16 0 ) capacitor c=0.00493487f //x=28.21 //y=1.845
c370 ( 15 0 ) capacitor c=0.0132914f //x=28.525 //y=1.845
c371 ( 14 0 ) capacitor c=0.0167992f //x=28.125 //y=1.76
c372 ( 13 0 ) capacitor c=0.0112869f //x=28.125 //y=1.305
c373 ( 11 0 ) capacitor c=0.0227225f //x=28.525 //y=5.335
c374 ( 10 0 ) capacitor c=0.00933983f //x=27.83 //y=5.56
c375 ( 7 0 ) capacitor c=0.0180822f //x=27.715 //y=5.335
c376 ( 5 0 ) capacitor c=0.0146396f //x=26.83 //y=5.335
c377 ( 4 0 ) capacitor c=0.0307975f //x=23.06 //y=4.75
c378 ( 3 0 ) capacitor c=0.0121604f //x=23.06 //y=3.655
c379 ( 2 0 ) capacitor c=0.0220998f //x=23.06 //y=3.365
c380 ( 1 0 ) capacitor c=0.00554887f //x=23.06 //y=2.375
r381 (  133 134 ) resistor r=52.7279 //w=0.214 //l=0.165 //layer=ply \
 //thickness=0.18 //x=23.06 //y=2.26 //x2=23.06 //y2=2.095
r382 (  131 141 ) resistor r=45.1352 //w=0.168 //l=0.173853 //layer=ply \
 //thickness=0.18 //x=23.58 //y=1.44 //x2=23.54 //y2=1.595
r383 (  130 140 ) resistor r=45.1352 //w=0.168 //l=0.173853 //layer=ply \
 //thickness=0.18 //x=23.58 //y=1.095 //x2=23.54 //y2=0.94
r384 (  130 131 ) resistor r=176.904 //w=0.094 //l=0.345 //layer=ply \
 //thickness=0.18 //x=23.58 //y=1.095 //x2=23.58 //y2=1.44
r385 (  128 137 ) resistor r=10.701 //w=0.21 //l=0.115 //layer=ply \
 //thickness=0.18 //x=23.205 //y=1.595 //x2=23.09 //y2=1.595
r386 (  127 141 ) resistor r=5.52526 //w=0.168 //l=0.115 //layer=ply \
 //thickness=0.18 //x=23.425 //y=1.595 //x2=23.54 //y2=1.595
r387 (  126 136 ) resistor r=5.52526 //w=0.168 //l=0.115 //layer=ply \
 //thickness=0.18 //x=23.205 //y=0.94 //x2=23.09 //y2=0.94
r388 (  125 140 ) resistor r=5.52526 //w=0.168 //l=0.115 //layer=ply \
 //thickness=0.18 //x=23.425 //y=0.94 //x2=23.54 //y2=0.94
r389 (  125 126 ) resistor r=112.809 //w=0.094 //l=0.22 //layer=ply \
 //thickness=0.18 //x=23.425 //y=0.94 //x2=23.205 //y2=0.94
r390 (  122 139 ) resistor r=37.236 //w=0.233 //l=0.249199 //layer=ply \
 //thickness=0.18 //x=23.24 //y=5.045 //x2=23.06 //y2=4.88
r391 (  120 137 ) resistor r=39.5823 //w=0.21 //l=0.173853 //layer=ply \
 //thickness=0.18 //x=23.05 //y=1.75 //x2=23.09 //y2=1.595
r392 (  120 134 ) resistor r=176.904 //w=0.094 //l=0.345 //layer=ply \
 //thickness=0.18 //x=23.05 //y=1.75 //x2=23.05 //y2=2.095
r393 (  119 137 ) resistor r=39.5823 //w=0.21 //l=0.173853 //layer=ply \
 //thickness=0.18 //x=23.05 //y=1.44 //x2=23.09 //y2=1.595
r394 (  118 136 ) resistor r=45.1352 //w=0.168 //l=0.173853 //layer=ply \
 //thickness=0.18 //x=23.05 //y=1.095 //x2=23.09 //y2=0.94
r395 (  118 119 ) resistor r=176.904 //w=0.094 //l=0.345 //layer=ply \
 //thickness=0.18 //x=23.05 //y=1.095 //x2=23.05 //y2=1.44
r396 (  115 139 ) resistor r=53.7854 //w=0.233 //l=0.332415 //layer=ply \
 //thickness=0.18 //x=22.8 //y=5.045 //x2=23.06 //y2=4.88
r397 (  114 122 ) resistor r=592.245 //w=0.094 //l=1.155 //layer=ply \
 //thickness=0.18 //x=23.24 //y=6.2 //x2=23.24 //y2=5.045
r398 (  113 115 ) resistor r=592.245 //w=0.094 //l=1.155 //layer=ply \
 //thickness=0.18 //x=22.8 //y=6.2 //x2=22.8 //y2=5.045
r399 (  112 127 ) resistor r=56.4043 //w=0.094 //l=0.11 //layer=ply \
 //thickness=0.18 //x=23.315 //y=1.595 //x2=23.425 //y2=1.595
r400 (  112 128 ) resistor r=56.4043 //w=0.094 //l=0.11 //layer=ply \
 //thickness=0.18 //x=23.315 //y=1.595 //x2=23.205 //y2=1.595
r401 (  92 146 ) resistor r=23.615 //w=0.187 //l=0.345 //layer=li \
 //thickness=0.1 //x=27.83 //y=5.56 //x2=27.83 //y2=5.905
r402 (  84 145 ) resistor r=23.615 //w=0.187 //l=0.345 //layer=li \
 //thickness=0.1 //x=26.95 //y=5.56 //x2=26.95 //y2=5.905
r403 (  76 144 ) resistor r=23.615 //w=0.187 //l=0.345 //layer=li \
 //thickness=0.1 //x=26.07 //y=5.56 //x2=26.07 //y2=5.905
r404 (  71 139 ) resistor r=152 //w=0.17 //l=0.17 //layer=licon //count=1 \
 //x=23.06 //y=4.88 //x2=23.06 //y2=4.88
r405 (  62 133 ) resistor r=152 //w=0.17 //l=0.17 //layer=licon //count=1 \
 //x=23.06 //y=2.26 //x2=23.06 //y2=2.26
r406 (  54 60 ) resistor r=0.293022 //w=0.239 //l=0.552359 //layer=m2 \
 //thickness=0.36 //x=28.085 //y=3.5 //x2=28.625 //y2=3.525
r407 (  54 55 ) resistor r=0.410305 //w=0.131 //l=0.43 //layer=m2 \
 //thickness=0.36 //x=28.085 //y=3.5 //x2=27.655 //y2=3.5
r408 (  52 55 ) resistor r=0.125 //w=0.17 //l=0.174929 //layer=m2 \
 //thickness=0.36 //x=27.485 //y=3.51 //x2=27.655 //y2=3.5
r409 (  52 53 ) resistor r=0.324427 //w=0.131 //l=0.34 //layer=m2 \
 //thickness=0.36 //x=27.485 //y=3.51 //x2=27.145 //y2=3.51
r410 (  50 53 ) resistor r=0.125 //w=0.17 //l=0.179722 //layer=m2 \
 //thickness=0.36 //x=26.975 //y=3.53 //x2=27.145 //y2=3.51
r411 (  50 51 ) resistor r=0.329198 //w=0.131 //l=0.345 //layer=m2 \
 //thickness=0.36 //x=26.975 //y=3.53 //x2=26.63 //y2=3.53
r412 (  49 57 ) resistor r=0.108362 //w=0.251 //l=0.16 //layer=m2 \
 //thickness=0.36 //x=23.22 //y=3.51 //x2=23.06 //y2=3.51
r413 (  48 51 ) resistor r=0.1875 //w=0.17 //l=0.264811 //layer=m2 \
 //thickness=0.36 //x=26.375 //y=3.51 //x2=26.63 //y2=3.53
r414 (  48 49 ) resistor r=3.0105 //w=0.131 //l=3.155 //layer=m2 \
 //thickness=0.36 //x=26.375 //y=3.51 //x2=23.22 //y2=3.51
r415 (  45 60 ) resistor r=4.5 //w=0.15 //l=0.15 //layer=via1 //count=1 \
 //x=28.625 //y=3.525 //x2=28.625 //y2=3.525
r416 (  43 45 ) resistor r=0.00488281 //w=0.384 //l=0.015 //layer=m1 \
 //thickness=0.36 //x=28.565 //y=3.51 //x2=28.565 //y2=3.525
r417 (  41 142 ) resistor r=9.3 //w=0.17 //l=0.17 //layer=mcon //count=1 \
 //x=28.125 //y=1.19 //x2=28.125 //y2=1.19
r418 (  39 92 ) resistor r=9.3 //w=0.17 //l=0.17 //layer=mcon //count=1 \
 //x=27.83 //y=5.56 //x2=27.83 //y2=5.56
r419 (  36 84 ) resistor r=9.3 //w=0.17 //l=0.17 //layer=mcon //count=1 \
 //x=26.95 //y=5.56 //x2=26.95 //y2=5.56
r420 (  34 36 ) resistor r=0.121228 //w=0.232 //l=0.225 //layer=m1 \
 //thickness=0.36 //x=26.95 //y=5.335 //x2=26.95 //y2=5.56
r421 (  33 76 ) resistor r=9.3 //w=0.17 //l=0.17 //layer=mcon //count=1 \
 //x=26.07 //y=5.56 //x2=26.07 //y2=5.56
r422 (  31 33 ) resistor r=0.129608 //w=0.217 //l=0.225 //layer=m1 \
 //thickness=0.36 //x=26.072 //y=5.335 //x2=26.072 //y2=5.56
r423 (  28 57 ) resistor r=4.5 //w=0.15 //l=0.15 //layer=via1 //count=1 \
 //x=23.06 //y=3.495 //x2=23.06 //y2=3.495
r424 (  28 30 ) resistor r=0.00490838 //w=0.382 //l=0.015 //layer=m1 \
 //thickness=0.36 //x=23.112 //y=3.495 //x2=23.112 //y2=3.51
r425 (  26 71 ) resistor r=9.3 //w=0.17 //l=0.17 //layer=mcon //count=1 \
 //x=23.06 //y=4.88 //x2=23.06 //y2=4.88
r426 (  24 62 ) resistor r=9.3 //w=0.17 //l=0.17 //layer=mcon //count=1 \
 //x=23.06 //y=2.26 //x2=23.06 //y2=2.26
r427 (  21 47 ) resistor r=0.0752589 //w=0.364 //l=0.141863 //layer=m1 \
 //thickness=0.36 //x=28.61 //y=5.105 //x2=28.67 //y2=4.99
r428 (  21 22 ) resistor r=0.138359 //w=0.131 //l=0.145 //layer=m1 \
 //thickness=0.36 //x=28.61 //y=5.105 //x2=28.61 //y2=5.25
r429 (  20 47 ) resistor r=0.0752589 //w=0.364 //l=0.141863 //layer=m1 \
 //thickness=0.36 //x=28.61 //y=4.875 //x2=28.67 //y2=4.99
r430 (  19 45 ) resistor r=0.0914932 //w=0.384 //l=0.181108 //layer=m1 \
 //thickness=0.36 //x=28.61 //y=3.685 //x2=28.565 //y2=3.525
r431 (  19 20 ) resistor r=1.1355 //w=0.131 //l=1.19 //layer=m1 \
 //thickness=0.36 //x=28.61 //y=3.685 //x2=28.61 //y2=4.875
r432 (  18 43 ) resistor r=0.0866104 //w=0.384 //l=0.165982 //layer=m1 \
 //thickness=0.36 //x=28.61 //y=3.365 //x2=28.565 //y2=3.51
r433 (  17 18 ) resistor r=1.36927 //w=0.131 //l=1.435 //layer=m1 \
 //thickness=0.36 //x=28.61 //y=1.93 //x2=28.61 //y2=3.365
r434 (  15 17 ) resistor r=0.0698411 //w=0.17 //l=0.120208 //layer=m1 \
 //thickness=0.36 //x=28.525 //y=1.845 //x2=28.61 //y2=1.93
r435 (  15 16 ) resistor r=0.300573 //w=0.131 //l=0.315 //layer=m1 \
 //thickness=0.36 //x=28.525 //y=1.845 //x2=28.21 //y2=1.845
r436 (  14 16 ) resistor r=0.0698411 //w=0.17 //l=0.120208 //layer=m1 \
 //thickness=0.36 //x=28.125 //y=1.76 //x2=28.21 //y2=1.845
r437 (  13 41 ) resistor r=0.0717383 //w=0.224 //l=0.115 //layer=m1 \
 //thickness=0.36 //x=28.125 //y=1.305 //x2=28.125 //y2=1.19
r438 (  13 14 ) resistor r=0.43416 //w=0.131 //l=0.455 //layer=m1 \
 //thickness=0.36 //x=28.125 //y=1.305 //x2=28.125 //y2=1.76
r439 (  12 37 ) resistor r=0.0675342 //w=0.23 //l=0.115 //layer=m1 \
 //thickness=0.36 //x=27.945 //y=5.335 //x2=27.83 //y2=5.335
r440 (  11 22 ) resistor r=0.0698411 //w=0.17 //l=0.120208 //layer=m1 \
 //thickness=0.36 //x=28.525 //y=5.335 //x2=28.61 //y2=5.25
r441 (  11 12 ) resistor r=0.553435 //w=0.131 //l=0.58 //layer=m1 \
 //thickness=0.36 //x=28.525 //y=5.335 //x2=27.945 //y2=5.335
r442 (  10 39 ) resistor r=0.00118313 //w=0.23 //layer=m1 //thickness=0.36 \
 //x=27.83 //y=5.56 //x2=27.83 //y2=5.56
r443 (  9 37 ) resistor r=0.002872 //w=0.34 //l=0.085 //layer=m1 \
 //thickness=0.36 //x=27.83 //y=5.42 //x2=27.83 //y2=5.335
r444 (  9 10 ) resistor r=0.091623 //w=0.191 //l=0.14 //layer=m1 \
 //thickness=0.36 //x=27.83 //y=5.42 //x2=27.83 //y2=5.56
r445 (  8 34 ) resistor r=0.0262263 //w=0.232 //l=0.12 //layer=m1 \
 //thickness=0.36 //x=27.07 //y=5.335 //x2=26.95 //y2=5.335
r446 (  7 37 ) resistor r=0.0675342 //w=0.23 //l=0.115 //layer=m1 \
 //thickness=0.36 //x=27.715 //y=5.335 //x2=27.83 //y2=5.335
r447 (  7 8 ) resistor r=0.615458 //w=0.131 //l=0.645 //layer=m1 \
 //thickness=0.36 //x=27.715 //y=5.335 //x2=27.07 //y2=5.335
r448 (  6 31 ) resistor r=0.0222262 //w=0.217 //l=0.118 //layer=m1 \
 //thickness=0.36 //x=26.19 //y=5.335 //x2=26.072 //y2=5.335
r449 (  5 34 ) resistor r=0.0262263 //w=0.232 //l=0.12 //layer=m1 \
 //thickness=0.36 //x=26.83 //y=5.335 //x2=26.95 //y2=5.335
r450 (  5 6 ) resistor r=0.610687 //w=0.131 //l=0.64 //layer=m1 \
 //thickness=0.36 //x=26.83 //y=5.335 //x2=26.19 //y2=5.335
r451 (  4 26 ) resistor r=0.0801089 //w=0.224 //l=0.13 //layer=m1 \
 //thickness=0.36 //x=23.06 //y=4.75 //x2=23.06 //y2=4.88
r452 (  3 30 ) resistor r=0.0864989 //w=0.382 //l=0.169012 //layer=m1 \
 //thickness=0.36 //x=23.06 //y=3.655 //x2=23.112 //y2=3.51
r453 (  3 4 ) resistor r=1.04485 //w=0.131 //l=1.095 //layer=m1 \
 //thickness=0.36 //x=23.06 //y=3.655 //x2=23.06 //y2=4.75
r454 (  2 28 ) resistor r=0.0815905 //w=0.382 //l=0.153818 //layer=m1 \
 //thickness=0.36 //x=23.06 //y=3.365 //x2=23.112 //y2=3.495
r455 (  1 24 ) resistor r=0.0719237 //w=0.222 //l=0.115 //layer=m1 \
 //thickness=0.36 //x=23.06 //y=2.375 //x2=23.06 //y2=2.26
r456 (  1 2 ) resistor r=0.944656 //w=0.131 //l=0.99 //layer=m1 \
 //thickness=0.36 //x=23.06 //y=2.375 //x2=23.06 //y2=3.365
ends PM_TMRDFFSNRNQX1\%noxref_6

subckt PM_TMRDFFSNRNQX1\%noxref_7 ( 1 3 6 7 9 10 11 12 14 15 16 17 18 19 20 21 \
 22 23 24 25 28 31 37 45 49 63 66 67 69 70 73 81 89 106 115 120 129 133 134 \
 135 136 137 138 139 140 141 142 143 145 151 152 153 154 158 159 160 161 162 \
 164 170 171 172 173 193 195 196 197 )
c439 ( 193 0 ) capacitor c=0.00885916f //x=32.745 //y=1.095
c440 ( 173 0 ) capacitor c=0.0612936f //x=40.355 //y=4.97
c441 ( 172 0 ) capacitor c=0.0376642f //x=40.645 //y=4.97
c442 ( 171 0 ) capacitor c=0.0346489f //x=40.31 //y=1.4
c443 ( 170 0 ) capacitor c=0.018692f //x=40.31 //y=1.055
c444 ( 164 0 ) capacitor c=0.0137077f //x=40.155 //y=1.555
c445 ( 162 0 ) capacitor c=0.0158585f //x=40.155 //y=0.9
c446 ( 161 0 ) capacitor c=0.0979536f //x=39.78 //y=2.095
c447 ( 160 0 ) capacitor c=0.0229444f //x=39.78 //y=1.71
c448 ( 159 0 ) capacitor c=0.0234359f //x=39.78 //y=1.4
c449 ( 158 0 ) capacitor c=0.019815f //x=39.78 //y=1.055
c450 ( 154 0 ) capacitor c=0.0614625f //x=35.545 //y=4.97
c451 ( 153 0 ) capacitor c=0.0376642f //x=35.835 //y=4.97
c452 ( 152 0 ) capacitor c=0.0346489f //x=35.5 //y=1.4
c453 ( 151 0 ) capacitor c=0.018692f //x=35.5 //y=1.055
c454 ( 145 0 ) capacitor c=0.0137077f //x=35.345 //y=1.555
c455 ( 143 0 ) capacitor c=0.0158585f //x=35.345 //y=0.9
c456 ( 142 0 ) capacitor c=0.0996161f //x=34.97 //y=2.095
c457 ( 141 0 ) capacitor c=0.0229444f //x=34.97 //y=1.71
c458 ( 140 0 ) capacitor c=0.0234359f //x=34.97 //y=1.4
c459 ( 139 0 ) capacitor c=0.019815f //x=34.97 //y=1.055
c460 ( 138 0 ) capacitor c=0.110208f //x=40.72 //y=6.2
c461 ( 137 0 ) capacitor c=0.158957f //x=40.28 //y=6.2
c462 ( 136 0 ) capacitor c=0.110409f //x=35.91 //y=6.2
c463 ( 135 0 ) capacitor c=0.158957f //x=35.47 //y=6.2
c464 ( 129 0 ) capacitor c=0.00159026f //x=40.08 //y=4.88
c465 ( 120 0 ) capacitor c=9.93222e-19 //x=40.08 //y=2.26
c466 ( 115 0 ) capacitor c=0.00157871f //x=35.27 //y=4.88
c467 ( 106 0 ) capacitor c=9.93222e-19 //x=35.27 //y=2.26
c468 ( 89 0 ) capacitor c=0.0293562f //x=32.64 //y=5.56
c469 ( 81 0 ) capacitor c=0.029137f //x=31.76 //y=5.56
c470 ( 73 0 ) capacitor c=0.0278099f //x=30.88 //y=5.56
c471 ( 70 0 ) capacitor c=0.0392804f //x=39.92 //y=2.785
c472 ( 69 0 ) capacitor c=5.7546e-19 //x=40.08 //y=2.785
c473 ( 67 0 ) capacitor c=5.7546e-19 //x=35.435 //y=2.785
c474 ( 66 0 ) capacitor c=0.016756f //x=35.115 //y=2.785
c475 ( 63 0 ) capacitor c=9.56892e-19 //x=33.585 //y=2.785
c476 ( 49 0 ) capacitor c=0.0154699f //x=40.08 //y=2.77
c477 ( 45 0 ) capacitor c=0.0148628f //x=35.27 //y=2.77
c478 ( 37 0 ) capacitor c=0.0144706f //x=33.42 //y=2.77
c479 ( 31 0 ) capacitor c=9.37498e-19 //x=32.64 //y=5.335
c480 ( 28 0 ) capacitor c=0.0076134f //x=31.76 //y=5.335
c481 ( 25 0 ) capacitor c=0.0109203f //x=30.882 //y=5.335
c482 ( 24 0 ) capacitor c=0.0553534f //x=40.08 //y=4.755
c483 ( 23 0 ) capacitor c=0.0130763f //x=40.08 //y=2.945
c484 ( 22 0 ) capacitor c=0.00473602f //x=40.08 //y=2.625
c485 ( 21 0 ) capacitor c=0.00495287f //x=40.08 //y=2.375
c486 ( 20 0 ) capacitor c=0.0601638f //x=35.27 //y=4.755
c487 ( 19 0 ) capacitor c=0.0129478f //x=35.27 //y=2.945
c488 ( 18 0 ) capacitor c=0.00482124f //x=35.27 //y=2.625
c489 ( 17 0 ) capacitor c=0.00495287f //x=35.27 //y=2.375
c490 ( 16 0 ) capacitor c=0.0657411f //x=33.42 //y=5.25
c491 ( 15 0 ) capacitor c=0.0123004f //x=33.42 //y=2.945
c492 ( 14 0 ) capacitor c=0.0179579f //x=33.42 //y=2.625
c493 ( 12 0 ) capacitor c=0.0047266f //x=33.02 //y=1.845
c494 ( 11 0 ) capacitor c=0.0129788f //x=33.335 //y=1.845
c495 ( 10 0 ) capacitor c=0.0167992f //x=32.935 //y=1.76
c496 ( 9 0 ) capacitor c=0.0110957f //x=32.935 //y=1.305
c497 ( 7 0 ) capacitor c=0.0203685f //x=33.335 //y=5.335
c498 ( 6 0 ) capacitor c=0.00933983f //x=32.64 //y=5.56
c499 ( 3 0 ) capacitor c=0.0192055f //x=32.525 //y=5.335
c500 ( 1 0 ) capacitor c=0.0149267f //x=31.64 //y=5.335
r501 (  172 174 ) resistor r=26.9307 //w=0.15 //l=0.106066 //layer=ply \
 //thickness=0.18 //x=40.645 //y=4.97 //x2=40.72 //y2=5.045
r502 (  172 173 ) resistor r=148.702 //w=0.094 //l=0.29 //layer=ply \
 //thickness=0.18 //x=40.645 //y=4.97 //x2=40.355 //y2=4.97
r503 (  171 192 ) resistor r=45.1352 //w=0.168 //l=0.173853 //layer=ply \
 //thickness=0.18 //x=40.31 //y=1.4 //x2=40.27 //y2=1.555
r504 (  170 191 ) resistor r=45.1352 //w=0.168 //l=0.173853 //layer=ply \
 //thickness=0.18 //x=40.31 //y=1.055 //x2=40.27 //y2=0.9
r505 (  170 171 ) resistor r=176.904 //w=0.094 //l=0.345 //layer=ply \
 //thickness=0.18 //x=40.31 //y=1.055 //x2=40.31 //y2=1.4
r506 (  167 173 ) resistor r=22.7971 //w=0.269 //l=0.106066 //layer=ply \
 //thickness=0.18 //x=40.28 //y=5.045 //x2=40.355 //y2=4.97
r507 (  167 190 ) resistor r=35.8364 //w=0.269 //l=0.270185 //layer=ply \
 //thickness=0.18 //x=40.28 //y=5.045 //x2=40.08 //y2=4.88
r508 (  165 186 ) resistor r=10.701 //w=0.21 //l=0.115 //layer=ply \
 //thickness=0.18 //x=39.935 //y=1.555 //x2=39.82 //y2=1.555
r509 (  164 192 ) resistor r=5.52526 //w=0.168 //l=0.115 //layer=ply \
 //thickness=0.18 //x=40.155 //y=1.555 //x2=40.27 //y2=1.555
r510 (  163 185 ) resistor r=5.52526 //w=0.168 //l=0.115 //layer=ply \
 //thickness=0.18 //x=39.935 //y=0.9 //x2=39.82 //y2=0.9
r511 (  162 191 ) resistor r=5.52526 //w=0.168 //l=0.115 //layer=ply \
 //thickness=0.18 //x=40.155 //y=0.9 //x2=40.27 //y2=0.9
r512 (  162 163 ) resistor r=112.809 //w=0.094 //l=0.22 //layer=ply \
 //thickness=0.18 //x=40.155 //y=0.9 //x2=39.935 //y2=0.9
r513 (  161 188 ) resistor r=58.7805 //w=0.246 //l=0.373497 //layer=ply \
 //thickness=0.18 //x=39.78 //y=2.095 //x2=40.08 //y2=2.26
r514 (  160 186 ) resistor r=39.5823 //w=0.21 //l=0.173853 //layer=ply \
 //thickness=0.18 //x=39.78 //y=1.71 //x2=39.82 //y2=1.555
r515 (  160 161 ) resistor r=197.415 //w=0.094 //l=0.385 //layer=ply \
 //thickness=0.18 //x=39.78 //y=1.71 //x2=39.78 //y2=2.095
r516 (  159 186 ) resistor r=39.5823 //w=0.21 //l=0.173853 //layer=ply \
 //thickness=0.18 //x=39.78 //y=1.4 //x2=39.82 //y2=1.555
r517 (  158 185 ) resistor r=45.1352 //w=0.168 //l=0.173853 //layer=ply \
 //thickness=0.18 //x=39.78 //y=1.055 //x2=39.82 //y2=0.9
r518 (  158 159 ) resistor r=176.904 //w=0.094 //l=0.345 //layer=ply \
 //thickness=0.18 //x=39.78 //y=1.055 //x2=39.78 //y2=1.4
r519 (  153 155 ) resistor r=26.9307 //w=0.15 //l=0.106066 //layer=ply \
 //thickness=0.18 //x=35.835 //y=4.97 //x2=35.91 //y2=5.045
r520 (  153 154 ) resistor r=148.702 //w=0.094 //l=0.29 //layer=ply \
 //thickness=0.18 //x=35.835 //y=4.97 //x2=35.545 //y2=4.97
r521 (  152 184 ) resistor r=45.1352 //w=0.168 //l=0.173853 //layer=ply \
 //thickness=0.18 //x=35.5 //y=1.4 //x2=35.46 //y2=1.555
r522 (  151 183 ) resistor r=45.1352 //w=0.168 //l=0.173853 //layer=ply \
 //thickness=0.18 //x=35.5 //y=1.055 //x2=35.46 //y2=0.9
r523 (  151 152 ) resistor r=176.904 //w=0.094 //l=0.345 //layer=ply \
 //thickness=0.18 //x=35.5 //y=1.055 //x2=35.5 //y2=1.4
r524 (  148 154 ) resistor r=22.7971 //w=0.269 //l=0.106066 //layer=ply \
 //thickness=0.18 //x=35.47 //y=5.045 //x2=35.545 //y2=4.97
r525 (  148 182 ) resistor r=35.8364 //w=0.269 //l=0.270185 //layer=ply \
 //thickness=0.18 //x=35.47 //y=5.045 //x2=35.27 //y2=4.88
r526 (  146 178 ) resistor r=10.701 //w=0.21 //l=0.115 //layer=ply \
 //thickness=0.18 //x=35.125 //y=1.555 //x2=35.01 //y2=1.555
r527 (  145 184 ) resistor r=5.52526 //w=0.168 //l=0.115 //layer=ply \
 //thickness=0.18 //x=35.345 //y=1.555 //x2=35.46 //y2=1.555
r528 (  144 177 ) resistor r=5.52526 //w=0.168 //l=0.115 //layer=ply \
 //thickness=0.18 //x=35.125 //y=0.9 //x2=35.01 //y2=0.9
r529 (  143 183 ) resistor r=5.52526 //w=0.168 //l=0.115 //layer=ply \
 //thickness=0.18 //x=35.345 //y=0.9 //x2=35.46 //y2=0.9
r530 (  143 144 ) resistor r=112.809 //w=0.094 //l=0.22 //layer=ply \
 //thickness=0.18 //x=35.345 //y=0.9 //x2=35.125 //y2=0.9
r531 (  142 180 ) resistor r=58.7805 //w=0.246 //l=0.373497 //layer=ply \
 //thickness=0.18 //x=34.97 //y=2.095 //x2=35.27 //y2=2.26
r532 (  141 178 ) resistor r=39.5823 //w=0.21 //l=0.173853 //layer=ply \
 //thickness=0.18 //x=34.97 //y=1.71 //x2=35.01 //y2=1.555
r533 (  141 142 ) resistor r=197.415 //w=0.094 //l=0.385 //layer=ply \
 //thickness=0.18 //x=34.97 //y=1.71 //x2=34.97 //y2=2.095
r534 (  140 178 ) resistor r=39.5823 //w=0.21 //l=0.173853 //layer=ply \
 //thickness=0.18 //x=34.97 //y=1.4 //x2=35.01 //y2=1.555
r535 (  139 177 ) resistor r=45.1352 //w=0.168 //l=0.173853 //layer=ply \
 //thickness=0.18 //x=34.97 //y=1.055 //x2=35.01 //y2=0.9
r536 (  139 140 ) resistor r=176.904 //w=0.094 //l=0.345 //layer=ply \
 //thickness=0.18 //x=34.97 //y=1.055 //x2=34.97 //y2=1.4
r537 (  138 174 ) resistor r=592.245 //w=0.094 //l=1.155 //layer=ply \
 //thickness=0.18 //x=40.72 //y=6.2 //x2=40.72 //y2=5.045
r538 (  137 167 ) resistor r=592.245 //w=0.094 //l=1.155 //layer=ply \
 //thickness=0.18 //x=40.28 //y=6.2 //x2=40.28 //y2=5.045
r539 (  136 155 ) resistor r=592.245 //w=0.094 //l=1.155 //layer=ply \
 //thickness=0.18 //x=35.91 //y=6.2 //x2=35.91 //y2=5.045
r540 (  135 148 ) resistor r=592.245 //w=0.094 //l=1.155 //layer=ply \
 //thickness=0.18 //x=35.47 //y=6.2 //x2=35.47 //y2=5.045
r541 (  134 164 ) resistor r=56.4043 //w=0.094 //l=0.11 //layer=ply \
 //thickness=0.18 //x=40.045 //y=1.555 //x2=40.155 //y2=1.555
r542 (  134 165 ) resistor r=56.4043 //w=0.094 //l=0.11 //layer=ply \
 //thickness=0.18 //x=40.045 //y=1.555 //x2=39.935 //y2=1.555
r543 (  133 145 ) resistor r=56.4043 //w=0.094 //l=0.11 //layer=ply \
 //thickness=0.18 //x=35.235 //y=1.555 //x2=35.345 //y2=1.555
r544 (  133 146 ) resistor r=56.4043 //w=0.094 //l=0.11 //layer=ply \
 //thickness=0.18 //x=35.235 //y=1.555 //x2=35.125 //y2=1.555
r545 (  129 190 ) resistor r=152 //w=0.17 //l=0.17 //layer=licon //count=1 \
 //x=40.08 //y=4.88 //x2=40.08 //y2=4.88
r546 (  120 188 ) resistor r=152 //w=0.17 //l=0.17 //layer=licon //count=1 \
 //x=40.08 //y=2.26 //x2=40.08 //y2=2.26
r547 (  115 182 ) resistor r=152 //w=0.17 //l=0.17 //layer=licon //count=1 \
 //x=35.27 //y=4.88 //x2=35.27 //y2=4.88
r548 (  106 180 ) resistor r=152 //w=0.17 //l=0.17 //layer=licon //count=1 \
 //x=35.27 //y=2.26 //x2=35.27 //y2=2.26
r549 (  89 197 ) resistor r=23.615 //w=0.187 //l=0.345 //layer=li \
 //thickness=0.1 //x=32.64 //y=5.56 //x2=32.64 //y2=5.905
r550 (  81 196 ) resistor r=23.615 //w=0.187 //l=0.345 //layer=li \
 //thickness=0.1 //x=31.76 //y=5.56 //x2=31.76 //y2=5.905
r551 (  73 195 ) resistor r=23.615 //w=0.187 //l=0.345 //layer=li \
 //thickness=0.1 //x=30.88 //y=5.56 //x2=30.88 //y2=5.905
r552 (  69 70 ) resistor r=0.10734 //w=0.281 //l=0.16 //layer=m2 \
 //thickness=0.36 //x=40.08 //y=2.785 //x2=39.92 //y2=2.785
r553 (  67 70 ) resistor r=4.27958 //w=0.131 //l=4.485 //layer=m2 \
 //thickness=0.36 //x=35.435 //y=2.77 //x2=39.92 //y2=2.77
r554 (  65 67 ) resistor r=0.10734 //w=0.281 //l=0.16 //layer=m2 \
 //thickness=0.36 //x=35.275 //y=2.785 //x2=35.435 //y2=2.785
r555 (  65 66 ) resistor r=0.10734 //w=0.281 //l=0.16 //layer=m2 \
 //thickness=0.36 //x=35.275 //y=2.785 //x2=35.115 //y2=2.785
r556 (  63 66 ) resistor r=1.45992 //w=0.131 //l=1.53 //layer=m2 \
 //thickness=0.36 //x=33.585 //y=2.77 //x2=35.115 //y2=2.77
r557 (  61 63 ) resistor r=0.10734 //w=0.281 //l=0.16 //layer=m2 \
 //thickness=0.36 //x=33.425 //y=2.785 //x2=33.585 //y2=2.785
r558 (  55 129 ) resistor r=9.3 //w=0.17 //l=0.17 //layer=mcon //count=1 \
 //x=40.08 //y=4.88 //x2=40.08 //y2=4.88
r559 (  53 120 ) resistor r=9.3 //w=0.17 //l=0.17 //layer=mcon //count=1 \
 //x=40.08 //y=2.26 //x2=40.08 //y2=2.26
r560 (  51 69 ) resistor r=4.5 //w=0.15 //l=0.15 //layer=via1 //count=1 \
 //x=40.08 //y=2.785 //x2=40.08 //y2=2.785
r561 (  49 51 ) resistor r=0.0049867 //w=0.376 //l=0.015 //layer=m1 \
 //thickness=0.36 //x=40.027 //y=2.77 //x2=40.027 //y2=2.785
r562 (  47 65 ) resistor r=4.5 //w=0.15 //l=0.15 //layer=via1 //count=1 \
 //x=35.275 //y=2.785 //x2=35.275 //y2=2.785
r563 (  45 47 ) resistor r=0.00501337 //w=0.374 //l=0.015 //layer=m1 \
 //thickness=0.36 //x=35.325 //y=2.77 //x2=35.325 //y2=2.785
r564 (  43 115 ) resistor r=9.3 //w=0.17 //l=0.17 //layer=mcon //count=1 \
 //x=35.27 //y=4.88 //x2=35.27 //y2=4.88
r565 (  41 106 ) resistor r=9.3 //w=0.17 //l=0.17 //layer=mcon //count=1 \
 //x=35.27 //y=2.26 //x2=35.27 //y2=2.26
r566 (  39 61 ) resistor r=4.5 //w=0.15 //l=0.15 //layer=via1 //count=1 \
 //x=33.425 //y=2.785 //x2=33.425 //y2=2.785
r567 (  37 39 ) resistor r=0.00501337 //w=0.374 //l=0.015 //layer=m1 \
 //thickness=0.36 //x=33.475 //y=2.77 //x2=33.475 //y2=2.785
r568 (  35 193 ) resistor r=9.3 //w=0.17 //l=0.17 //layer=mcon //count=1 \
 //x=32.935 //y=1.19 //x2=32.935 //y2=1.19
r569 (  33 89 ) resistor r=9.3 //w=0.17 //l=0.17 //layer=mcon //count=1 \
 //x=32.64 //y=5.56 //x2=32.64 //y2=5.56
r570 (  30 81 ) resistor r=9.3 //w=0.17 //l=0.17 //layer=mcon //count=1 \
 //x=31.76 //y=5.56 //x2=31.76 //y2=5.56
r571 (  28 30 ) resistor r=0.121228 //w=0.232 //l=0.225 //layer=m1 \
 //thickness=0.36 //x=31.76 //y=5.335 //x2=31.76 //y2=5.56
r572 (  27 73 ) resistor r=9.3 //w=0.17 //l=0.17 //layer=mcon //count=1 \
 //x=30.88 //y=5.56 //x2=30.88 //y2=5.56
r573 (  25 27 ) resistor r=0.129608 //w=0.217 //l=0.225 //layer=m1 \
 //thickness=0.36 //x=30.882 //y=5.335 //x2=30.882 //y2=5.56
r574 (  24 55 ) resistor r=0.0760407 //w=0.238 //l=0.125 //layer=m1 \
 //thickness=0.36 //x=40.08 //y=4.755 //x2=40.08 //y2=4.88
r575 (  23 51 ) resistor r=0.0911593 //w=0.376 //l=0.184608 //layer=m1 \
 //thickness=0.36 //x=40.08 //y=2.945 //x2=40.027 //y2=2.785
r576 (  23 24 ) resistor r=1.7271 //w=0.131 //l=1.81 //layer=m1 \
 //thickness=0.36 //x=40.08 //y=2.945 //x2=40.08 //y2=4.755
r577 (  22 49 ) resistor r=0.0861726 //w=0.376 //l=0.16944 //layer=m1 \
 //thickness=0.36 //x=40.08 //y=2.625 //x2=40.027 //y2=2.77
r578 (  21 53 ) resistor r=0.0719237 //w=0.222 //l=0.115 //layer=m1 \
 //thickness=0.36 //x=40.08 //y=2.375 //x2=40.08 //y2=2.26
r579 (  21 22 ) resistor r=0.23855 //w=0.131 //l=0.25 //layer=m1 \
 //thickness=0.36 //x=40.08 //y=2.375 //x2=40.08 //y2=2.625
r580 (  20 43 ) resistor r=0.0760407 //w=0.238 //l=0.125 //layer=m1 \
 //thickness=0.36 //x=35.27 //y=4.755 //x2=35.27 //y2=4.88
r581 (  19 47 ) resistor r=0.0910802 //w=0.374 //l=0.185472 //layer=m1 \
 //thickness=0.36 //x=35.27 //y=2.945 //x2=35.325 //y2=2.785
r582 (  19 20 ) resistor r=1.7271 //w=0.131 //l=1.81 //layer=m1 \
 //thickness=0.36 //x=35.27 //y=2.945 //x2=35.27 //y2=4.755
r583 (  18 45 ) resistor r=0.0860668 //w=0.374 //l=0.170294 //layer=m1 \
 //thickness=0.36 //x=35.27 //y=2.625 //x2=35.325 //y2=2.77
r584 (  17 41 ) resistor r=0.0719237 //w=0.222 //l=0.115 //layer=m1 \
 //thickness=0.36 //x=35.27 //y=2.375 //x2=35.27 //y2=2.26
r585 (  17 18 ) resistor r=0.23855 //w=0.131 //l=0.25 //layer=m1 \
 //thickness=0.36 //x=35.27 //y=2.375 //x2=35.27 //y2=2.625
r586 (  15 39 ) resistor r=0.0910802 //w=0.374 //l=0.185472 //layer=m1 \
 //thickness=0.36 //x=33.42 //y=2.945 //x2=33.475 //y2=2.785
r587 (  15 16 ) resistor r=2.19943 //w=0.131 //l=2.305 //layer=m1 \
 //thickness=0.36 //x=33.42 //y=2.945 //x2=33.42 //y2=5.25
r588 (  14 37 ) resistor r=0.0860668 //w=0.374 //l=0.170294 //layer=m1 \
 //thickness=0.36 //x=33.42 //y=2.625 //x2=33.475 //y2=2.77
r589 (  13 14 ) resistor r=0.663168 //w=0.131 //l=0.695 //layer=m1 \
 //thickness=0.36 //x=33.42 //y=1.93 //x2=33.42 //y2=2.625
r590 (  11 13 ) resistor r=0.0698411 //w=0.17 //l=0.120208 //layer=m1 \
 //thickness=0.36 //x=33.335 //y=1.845 //x2=33.42 //y2=1.93
r591 (  11 12 ) resistor r=0.300573 //w=0.131 //l=0.315 //layer=m1 \
 //thickness=0.36 //x=33.335 //y=1.845 //x2=33.02 //y2=1.845
r592 (  10 12 ) resistor r=0.0698411 //w=0.17 //l=0.120208 //layer=m1 \
 //thickness=0.36 //x=32.935 //y=1.76 //x2=33.02 //y2=1.845
r593 (  9 35 ) resistor r=0.0717383 //w=0.224 //l=0.115 //layer=m1 \
 //thickness=0.36 //x=32.935 //y=1.305 //x2=32.935 //y2=1.19
r594 (  9 10 ) resistor r=0.43416 //w=0.131 //l=0.455 //layer=m1 \
 //thickness=0.36 //x=32.935 //y=1.305 //x2=32.935 //y2=1.76
r595 (  8 31 ) resistor r=0.0675342 //w=0.23 //l=0.115 //layer=m1 \
 //thickness=0.36 //x=32.755 //y=5.335 //x2=32.64 //y2=5.335
r596 (  7 16 ) resistor r=0.0698411 //w=0.17 //l=0.120208 //layer=m1 \
 //thickness=0.36 //x=33.335 //y=5.335 //x2=33.42 //y2=5.25
r597 (  7 8 ) resistor r=0.553435 //w=0.131 //l=0.58 //layer=m1 \
 //thickness=0.36 //x=33.335 //y=5.335 //x2=32.755 //y2=5.335
r598 (  6 33 ) resistor r=0.00118313 //w=0.23 //layer=m1 //thickness=0.36 \
 //x=32.64 //y=5.56 //x2=32.64 //y2=5.56
r599 (  5 31 ) resistor r=0.002872 //w=0.34 //l=0.085 //layer=m1 \
 //thickness=0.36 //x=32.64 //y=5.42 //x2=32.64 //y2=5.335
r600 (  5 6 ) resistor r=0.091623 //w=0.191 //l=0.14 //layer=m1 \
 //thickness=0.36 //x=32.64 //y=5.42 //x2=32.64 //y2=5.56
r601 (  4 28 ) resistor r=0.0262263 //w=0.232 //l=0.12 //layer=m1 \
 //thickness=0.36 //x=31.88 //y=5.335 //x2=31.76 //y2=5.335
r602 (  3 31 ) resistor r=0.0675342 //w=0.23 //l=0.115 //layer=m1 \
 //thickness=0.36 //x=32.525 //y=5.335 //x2=32.64 //y2=5.335
r603 (  3 4 ) resistor r=0.615458 //w=0.131 //l=0.645 //layer=m1 \
 //thickness=0.36 //x=32.525 //y=5.335 //x2=31.88 //y2=5.335
r604 (  2 25 ) resistor r=0.0222262 //w=0.217 //l=0.118 //layer=m1 \
 //thickness=0.36 //x=31 //y=5.335 //x2=30.882 //y2=5.335
r605 (  1 28 ) resistor r=0.0262263 //w=0.232 //l=0.12 //layer=m1 \
 //thickness=0.36 //x=31.64 //y=5.335 //x2=31.76 //y2=5.335
r606 (  1 2 ) resistor r=0.610687 //w=0.131 //l=0.64 //layer=m1 \
 //thickness=0.36 //x=31.64 //y=5.335 //x2=31 //y2=5.335
ends PM_TMRDFFSNRNQX1\%noxref_7

subckt PM_TMRDFFSNRNQX1\%noxref_8 ( 1 3 6 7 9 10 11 12 14 15 16 17 18 19 20 21 \
 24 27 33 36 42 43 48 51 59 67 84 93 97 98 99 100 101 102 103 104 106 112 113 \
 114 115 127 129 130 131 )
c298 ( 127 0 ) capacitor c=0.00885916f //x=42.365 //y=1.095
c299 ( 115 0 ) capacitor c=0.0612936f //x=45.165 //y=4.97
c300 ( 114 0 ) capacitor c=0.0376642f //x=45.455 //y=4.97
c301 ( 113 0 ) capacitor c=0.0346489f //x=45.12 //y=1.4
c302 ( 112 0 ) capacitor c=0.018692f //x=45.12 //y=1.055
c303 ( 106 0 ) capacitor c=0.0137077f //x=44.965 //y=1.555
c304 ( 104 0 ) capacitor c=0.0158585f //x=44.965 //y=0.9
c305 ( 103 0 ) capacitor c=0.0979523f //x=44.59 //y=2.095
c306 ( 102 0 ) capacitor c=0.0229444f //x=44.59 //y=1.71
c307 ( 101 0 ) capacitor c=0.0234359f //x=44.59 //y=1.4
c308 ( 100 0 ) capacitor c=0.019815f //x=44.59 //y=1.055
c309 ( 99 0 ) capacitor c=0.110208f //x=45.53 //y=6.2
c310 ( 98 0 ) capacitor c=0.158957f //x=45.09 //y=6.2
c311 ( 93 0 ) capacitor c=0.00157537f //x=44.89 //y=4.88
c312 ( 84 0 ) capacitor c=9.93222e-19 //x=44.89 //y=2.26
c313 ( 67 0 ) capacitor c=0.0293723f //x=42.26 //y=5.56
c314 ( 59 0 ) capacitor c=0.029137f //x=41.38 //y=5.56
c315 ( 51 0 ) capacitor c=0.0278099f //x=40.5 //y=5.56
c316 ( 48 0 ) capacitor c=5.79974e-19 //x=44.9 //y=2.77
c317 ( 43 0 ) capacitor c=9.44624e-19 //x=43.2 //y=2.77
c318 ( 42 0 ) capacitor c=0.0155215f //x=44.74 //y=2.77
c319 ( 36 0 ) capacitor c=0.0146045f //x=44.89 //y=2.77
c320 ( 33 0 ) capacitor c=0.0146969f //x=43.04 //y=2.77
c321 ( 27 0 ) capacitor c=8.40513e-19 //x=42.26 //y=5.335
c322 ( 24 0 ) capacitor c=0.00712803f //x=41.38 //y=5.335
c323 ( 21 0 ) capacitor c=0.0109203f //x=40.502 //y=5.335
c324 ( 20 0 ) capacitor c=0.0604534f //x=44.89 //y=4.755
c325 ( 19 0 ) capacitor c=0.0131932f //x=44.89 //y=2.93
c326 ( 18 0 ) capacitor c=0.00432188f //x=44.89 //y=2.61
c327 ( 17 0 ) capacitor c=0.00485584f //x=44.89 //y=2.375
c328 ( 16 0 ) capacitor c=0.0632504f //x=43.04 //y=5.25
c329 ( 15 0 ) capacitor c=0.0122936f //x=43.04 //y=2.93
c330 ( 14 0 ) capacitor c=0.0181662f //x=43.04 //y=2.61
c331 ( 12 0 ) capacitor c=0.00493487f //x=42.64 //y=1.845
c332 ( 11 0 ) capacitor c=0.0129068f //x=42.955 //y=1.845
c333 ( 10 0 ) capacitor c=0.0167992f //x=42.555 //y=1.76
c334 ( 9 0 ) capacitor c=0.0112867f //x=42.555 //y=1.305
c335 ( 7 0 ) capacitor c=0.020812f //x=42.955 //y=5.335
c336 ( 6 0 ) capacitor c=0.00933983f //x=42.26 //y=5.56
c337 ( 3 0 ) capacitor c=0.0177111f //x=42.145 //y=5.335
c338 ( 1 0 ) capacitor c=0.0148498f //x=41.26 //y=5.335
r339 (  114 116 ) resistor r=26.9307 //w=0.15 //l=0.106066 //layer=ply \
 //thickness=0.18 //x=45.455 //y=4.97 //x2=45.53 //y2=5.045
r340 (  114 115 ) resistor r=148.702 //w=0.094 //l=0.29 //layer=ply \
 //thickness=0.18 //x=45.455 //y=4.97 //x2=45.165 //y2=4.97
r341 (  113 126 ) resistor r=45.1352 //w=0.168 //l=0.173853 //layer=ply \
 //thickness=0.18 //x=45.12 //y=1.4 //x2=45.08 //y2=1.555
r342 (  112 125 ) resistor r=45.1352 //w=0.168 //l=0.173853 //layer=ply \
 //thickness=0.18 //x=45.12 //y=1.055 //x2=45.08 //y2=0.9
r343 (  112 113 ) resistor r=176.904 //w=0.094 //l=0.345 //layer=ply \
 //thickness=0.18 //x=45.12 //y=1.055 //x2=45.12 //y2=1.4
r344 (  109 115 ) resistor r=22.7971 //w=0.269 //l=0.106066 //layer=ply \
 //thickness=0.18 //x=45.09 //y=5.045 //x2=45.165 //y2=4.97
r345 (  109 124 ) resistor r=35.8364 //w=0.269 //l=0.270185 //layer=ply \
 //thickness=0.18 //x=45.09 //y=5.045 //x2=44.89 //y2=4.88
r346 (  107 120 ) resistor r=10.701 //w=0.21 //l=0.115 //layer=ply \
 //thickness=0.18 //x=44.745 //y=1.555 //x2=44.63 //y2=1.555
r347 (  106 126 ) resistor r=5.52526 //w=0.168 //l=0.115 //layer=ply \
 //thickness=0.18 //x=44.965 //y=1.555 //x2=45.08 //y2=1.555
r348 (  105 119 ) resistor r=5.52526 //w=0.168 //l=0.115 //layer=ply \
 //thickness=0.18 //x=44.745 //y=0.9 //x2=44.63 //y2=0.9
r349 (  104 125 ) resistor r=5.52526 //w=0.168 //l=0.115 //layer=ply \
 //thickness=0.18 //x=44.965 //y=0.9 //x2=45.08 //y2=0.9
r350 (  104 105 ) resistor r=112.809 //w=0.094 //l=0.22 //layer=ply \
 //thickness=0.18 //x=44.965 //y=0.9 //x2=44.745 //y2=0.9
r351 (  103 122 ) resistor r=58.7805 //w=0.246 //l=0.373497 //layer=ply \
 //thickness=0.18 //x=44.59 //y=2.095 //x2=44.89 //y2=2.26
r352 (  102 120 ) resistor r=39.5823 //w=0.21 //l=0.173853 //layer=ply \
 //thickness=0.18 //x=44.59 //y=1.71 //x2=44.63 //y2=1.555
r353 (  102 103 ) resistor r=197.415 //w=0.094 //l=0.385 //layer=ply \
 //thickness=0.18 //x=44.59 //y=1.71 //x2=44.59 //y2=2.095
r354 (  101 120 ) resistor r=39.5823 //w=0.21 //l=0.173853 //layer=ply \
 //thickness=0.18 //x=44.59 //y=1.4 //x2=44.63 //y2=1.555
r355 (  100 119 ) resistor r=45.1352 //w=0.168 //l=0.173853 //layer=ply \
 //thickness=0.18 //x=44.59 //y=1.055 //x2=44.63 //y2=0.9
r356 (  100 101 ) resistor r=176.904 //w=0.094 //l=0.345 //layer=ply \
 //thickness=0.18 //x=44.59 //y=1.055 //x2=44.59 //y2=1.4
r357 (  99 116 ) resistor r=592.245 //w=0.094 //l=1.155 //layer=ply \
 //thickness=0.18 //x=45.53 //y=6.2 //x2=45.53 //y2=5.045
r358 (  98 109 ) resistor r=592.245 //w=0.094 //l=1.155 //layer=ply \
 //thickness=0.18 //x=45.09 //y=6.2 //x2=45.09 //y2=5.045
r359 (  97 106 ) resistor r=56.4043 //w=0.094 //l=0.11 //layer=ply \
 //thickness=0.18 //x=44.855 //y=1.555 //x2=44.965 //y2=1.555
r360 (  97 107 ) resistor r=56.4043 //w=0.094 //l=0.11 //layer=ply \
 //thickness=0.18 //x=44.855 //y=1.555 //x2=44.745 //y2=1.555
r361 (  93 124 ) resistor r=152 //w=0.17 //l=0.17 //layer=licon //count=1 \
 //x=44.89 //y=4.88 //x2=44.89 //y2=4.88
r362 (  84 122 ) resistor r=152 //w=0.17 //l=0.17 //layer=licon //count=1 \
 //x=44.89 //y=2.26 //x2=44.89 //y2=2.26
r363 (  67 131 ) resistor r=23.615 //w=0.187 //l=0.345 //layer=li \
 //thickness=0.1 //x=42.26 //y=5.56 //x2=42.26 //y2=5.905
r364 (  59 130 ) resistor r=23.615 //w=0.187 //l=0.345 //layer=li \
 //thickness=0.1 //x=41.38 //y=5.56 //x2=41.38 //y2=5.905
r365 (  51 129 ) resistor r=23.615 //w=0.187 //l=0.345 //layer=li \
 //thickness=0.1 //x=40.5 //y=5.56 //x2=40.5 //y2=5.905
r366 (  43 45 ) resistor r=0.10734 //w=0.281 //l=0.16 //layer=m2 \
 //thickness=0.36 //x=43.2 //y=2.77 //x2=43.04 //y2=2.77
r367 (  42 48 ) resistor r=0.10734 //w=0.281 //l=0.16 //layer=m2 \
 //thickness=0.36 //x=44.74 //y=2.77 //x2=44.9 //y2=2.77
r368 (  42 43 ) resistor r=1.46947 //w=0.131 //l=1.54 //layer=m2 \
 //thickness=0.36 //x=44.74 //y=2.77 //x2=43.2 //y2=2.77
r369 (  41 93 ) resistor r=9.3 //w=0.17 //l=0.17 //layer=mcon //count=1 \
 //x=44.89 //y=4.88 //x2=44.89 //y2=4.88
r370 (  39 84 ) resistor r=9.3 //w=0.17 //l=0.17 //layer=mcon //count=1 \
 //x=44.89 //y=2.26 //x2=44.89 //y2=2.26
r371 (  36 48 ) resistor r=4.5 //w=0.15 //l=0.15 //layer=via1 //count=1 \
 //x=44.9 //y=2.77 //x2=44.9 //y2=2.77
r372 (  33 45 ) resistor r=4.5 //w=0.15 //l=0.15 //layer=via1 //count=1 \
 //x=43.04 //y=2.77 //x2=43.04 //y2=2.77
r373 (  31 127 ) resistor r=9.3 //w=0.17 //l=0.17 //layer=mcon //count=1 \
 //x=42.555 //y=1.19 //x2=42.555 //y2=1.19
r374 (  29 67 ) resistor r=9.3 //w=0.17 //l=0.17 //layer=mcon //count=1 \
 //x=42.26 //y=5.56 //x2=42.26 //y2=5.56
r375 (  26 59 ) resistor r=9.3 //w=0.17 //l=0.17 //layer=mcon //count=1 \
 //x=41.38 //y=5.56 //x2=41.38 //y2=5.56
r376 (  24 26 ) resistor r=0.121228 //w=0.232 //l=0.225 //layer=m1 \
 //thickness=0.36 //x=41.38 //y=5.335 //x2=41.38 //y2=5.56
r377 (  23 51 ) resistor r=9.3 //w=0.17 //l=0.17 //layer=mcon //count=1 \
 //x=40.5 //y=5.56 //x2=40.5 //y2=5.56
r378 (  21 23 ) resistor r=0.129608 //w=0.217 //l=0.225 //layer=m1 \
 //thickness=0.36 //x=40.502 //y=5.335 //x2=40.502 //y2=5.56
r379 (  20 41 ) resistor r=0.0760407 //w=0.238 //l=0.125 //layer=m1 \
 //thickness=0.36 //x=44.89 //y=4.755 //x2=44.89 //y2=4.88
r380 (  19 36 ) resistor r=0.0914072 //w=0.382 //l=0.182428 //layer=m1 \
 //thickness=0.36 //x=44.89 //y=2.93 //x2=44.842 //y2=2.77
r381 (  19 20 ) resistor r=1.74141 //w=0.131 //l=1.825 //layer=m1 \
 //thickness=0.36 //x=44.89 //y=2.93 //x2=44.89 //y2=4.755
r382 (  18 36 ) resistor r=0.0914072 //w=0.382 //l=0.182428 //layer=m1 \
 //thickness=0.36 //x=44.89 //y=2.61 //x2=44.842 //y2=2.77
r383 (  17 39 ) resistor r=0.0719237 //w=0.222 //l=0.115 //layer=m1 \
 //thickness=0.36 //x=44.89 //y=2.375 //x2=44.89 //y2=2.26
r384 (  17 18 ) resistor r=0.224237 //w=0.131 //l=0.235 //layer=m1 \
 //thickness=0.36 //x=44.89 //y=2.375 //x2=44.89 //y2=2.61
r385 (  15 33 ) resistor r=0.0911593 //w=0.376 //l=0.184174 //layer=m1 \
 //thickness=0.36 //x=43.04 //y=2.93 //x2=43.092 //y2=2.77
r386 (  15 16 ) resistor r=2.21374 //w=0.131 //l=2.32 //layer=m1 \
 //thickness=0.36 //x=43.04 //y=2.93 //x2=43.04 //y2=5.25
r387 (  14 33 ) resistor r=0.0911593 //w=0.376 //l=0.184174 //layer=m1 \
 //thickness=0.36 //x=43.04 //y=2.61 //x2=43.092 //y2=2.77
r388 (  13 14 ) resistor r=0.648855 //w=0.131 //l=0.68 //layer=m1 \
 //thickness=0.36 //x=43.04 //y=1.93 //x2=43.04 //y2=2.61
r389 (  11 13 ) resistor r=0.0698411 //w=0.17 //l=0.120208 //layer=m1 \
 //thickness=0.36 //x=42.955 //y=1.845 //x2=43.04 //y2=1.93
r390 (  11 12 ) resistor r=0.300573 //w=0.131 //l=0.315 //layer=m1 \
 //thickness=0.36 //x=42.955 //y=1.845 //x2=42.64 //y2=1.845
r391 (  10 12 ) resistor r=0.0698411 //w=0.17 //l=0.120208 //layer=m1 \
 //thickness=0.36 //x=42.555 //y=1.76 //x2=42.64 //y2=1.845
r392 (  9 31 ) resistor r=0.0717383 //w=0.224 //l=0.115 //layer=m1 \
 //thickness=0.36 //x=42.555 //y=1.305 //x2=42.555 //y2=1.19
r393 (  9 10 ) resistor r=0.43416 //w=0.131 //l=0.455 //layer=m1 \
 //thickness=0.36 //x=42.555 //y=1.305 //x2=42.555 //y2=1.76
r394 (  8 27 ) resistor r=0.0675342 //w=0.23 //l=0.115 //layer=m1 \
 //thickness=0.36 //x=42.375 //y=5.335 //x2=42.26 //y2=5.335
r395 (  7 16 ) resistor r=0.0698411 //w=0.17 //l=0.120208 //layer=m1 \
 //thickness=0.36 //x=42.955 //y=5.335 //x2=43.04 //y2=5.25
r396 (  7 8 ) resistor r=0.553435 //w=0.131 //l=0.58 //layer=m1 \
 //thickness=0.36 //x=42.955 //y=5.335 //x2=42.375 //y2=5.335
r397 (  6 29 ) resistor r=0.00118313 //w=0.23 //layer=m1 //thickness=0.36 \
 //x=42.26 //y=5.56 //x2=42.26 //y2=5.56
r398 (  5 27 ) resistor r=0.002872 //w=0.34 //l=0.085 //layer=m1 \
 //thickness=0.36 //x=42.26 //y=5.42 //x2=42.26 //y2=5.335
r399 (  5 6 ) resistor r=0.091623 //w=0.191 //l=0.14 //layer=m1 \
 //thickness=0.36 //x=42.26 //y=5.42 //x2=42.26 //y2=5.56
r400 (  4 24 ) resistor r=0.0262263 //w=0.232 //l=0.12 //layer=m1 \
 //thickness=0.36 //x=41.5 //y=5.335 //x2=41.38 //y2=5.335
r401 (  3 27 ) resistor r=0.0675342 //w=0.23 //l=0.115 //layer=m1 \
 //thickness=0.36 //x=42.145 //y=5.335 //x2=42.26 //y2=5.335
r402 (  3 4 ) resistor r=0.615458 //w=0.131 //l=0.645 //layer=m1 \
 //thickness=0.36 //x=42.145 //y=5.335 //x2=41.5 //y2=5.335
r403 (  2 21 ) resistor r=0.0222262 //w=0.217 //l=0.118 //layer=m1 \
 //thickness=0.36 //x=40.62 //y=5.335 //x2=40.502 //y2=5.335
r404 (  1 24 ) resistor r=0.0262263 //w=0.232 //l=0.12 //layer=m1 \
 //thickness=0.36 //x=41.26 //y=5.335 //x2=41.38 //y2=5.335
r405 (  1 2 ) resistor r=0.610687 //w=0.131 //l=0.64 //layer=m1 \
 //thickness=0.36 //x=41.26 //y=5.335 //x2=40.62 //y2=5.335
ends PM_TMRDFFSNRNQX1\%noxref_8

subckt PM_TMRDFFSNRNQX1\%noxref_9 ( 1 2 3 4 5 7 10 11 13 14 15 16 18 19 20 21 \
 22 23 24 30 33 36 39 47 49 57 62 65 66 68 71 80 85 93 101 118 127 131 132 133 \
 134 135 136 140 141 142 147 149 152 153 154 155 156 157 158 160 166 167 168 \
 169 174 175 180 191 193 194 195 )
c480 ( 191 0 ) capacitor c=0.00885916f //x=37.555 //y=1.095
c481 ( 180 0 ) capacitor c=0.0710579f //x=32.68 //y=4.88
c482 ( 175 0 ) capacitor c=0.0278202f //x=32.68 //y=2.095
c483 ( 174 0 ) capacitor c=0.0479349f //x=32.68 //y=2.26
c484 ( 169 0 ) capacitor c=0.0612936f //x=49.975 //y=4.97
c485 ( 168 0 ) capacitor c=0.0376642f //x=50.265 //y=4.97
c486 ( 167 0 ) capacitor c=0.0346489f //x=49.93 //y=1.4
c487 ( 166 0 ) capacitor c=0.018692f //x=49.93 //y=1.055
c488 ( 160 0 ) capacitor c=0.0137077f //x=49.775 //y=1.555
c489 ( 158 0 ) capacitor c=0.0158585f //x=49.775 //y=0.9
c490 ( 157 0 ) capacitor c=0.10101f //x=49.4 //y=2.095
c491 ( 156 0 ) capacitor c=0.0229444f //x=49.4 //y=1.71
c492 ( 155 0 ) capacitor c=0.0234359f //x=49.4 //y=1.4
c493 ( 154 0 ) capacitor c=0.019815f //x=49.4 //y=1.055
c494 ( 153 0 ) capacitor c=0.0443175f //x=33.2 //y=1.44
c495 ( 152 0 ) capacitor c=0.0199703f //x=33.2 //y=1.095
c496 ( 149 0 ) capacitor c=0.0162526f //x=33.045 //y=1.595
c497 ( 147 0 ) capacitor c=0.0157807f //x=33.045 //y=0.94
c498 ( 142 0 ) capacitor c=0.0220935f //x=32.67 //y=1.75
c499 ( 141 0 ) capacitor c=0.0207489f //x=32.67 //y=1.44
c500 ( 140 0 ) capacitor c=0.0194091f //x=32.67 //y=1.095
c501 ( 136 0 ) capacitor c=0.110208f //x=50.34 //y=6.2
c502 ( 135 0 ) capacitor c=0.158957f //x=49.9 //y=6.2
c503 ( 134 0 ) capacitor c=0.159671f //x=32.86 //y=6.2
c504 ( 133 0 ) capacitor c=0.110208f //x=32.42 //y=6.2
c505 ( 127 0 ) capacitor c=0.00159026f //x=49.7 //y=4.88
c506 ( 118 0 ) capacitor c=0.0012618f //x=49.7 //y=2.26
c507 ( 101 0 ) capacitor c=0.0293723f //x=37.45 //y=5.56
c508 ( 93 0 ) capacitor c=0.029137f //x=36.57 //y=5.56
c509 ( 85 0 ) capacitor c=0.0278099f //x=35.69 //y=5.56
c510 ( 80 0 ) capacitor c=9.5006e-19 //x=32.68 //y=4.88
c511 ( 71 0 ) capacitor c=0.00101179f //x=32.68 //y=2.26
c512 ( 68 0 ) capacitor c=3.39224e-19 //x=49.695 //y=3.51
c513 ( 66 0 ) capacitor c=6.97864e-19 //x=38.39 //y=3.495
c514 ( 65 0 ) capacitor c=0.0608112f //x=38.07 //y=3.495
c515 ( 62 0 ) capacitor c=4.31985e-19 //x=32.85 //y=3.515
c516 ( 57 0 ) capacitor c=0.113477f //x=49.535 //y=3.51
c517 ( 49 0 ) capacitor c=0.0169562f //x=49.695 //y=3.51
c518 ( 47 0 ) capacitor c=0.0158593f //x=38.23 //y=3.51
c519 ( 39 0 ) capacitor c=8.40513e-19 //x=37.45 //y=5.335
c520 ( 36 0 ) capacitor c=0.00746333f //x=36.57 //y=5.335
c521 ( 33 0 ) capacitor c=0.0120388f //x=35.692 //y=5.335
c522 ( 30 0 ) capacitor c=0.0150828f //x=32.68 //y=3.51
c523 ( 24 0 ) capacitor c=0.0346814f //x=49.7 //y=4.755
c524 ( 23 0 ) capacitor c=0.0144231f //x=49.7 //y=3.67
c525 ( 22 0 ) capacitor c=0.0280194f //x=49.7 //y=3.35
c526 ( 21 0 ) capacitor c=0.00493552f //x=49.7 //y=2.375
c527 ( 20 0 ) capacitor c=0.0410619f //x=38.23 //y=5.25
c528 ( 19 0 ) capacitor c=0.0133594f //x=38.23 //y=3.655
c529 ( 18 0 ) capacitor c=0.0372096f //x=38.23 //y=3.335
c530 ( 16 0 ) capacitor c=0.0048771f //x=37.83 //y=1.845
c531 ( 15 0 ) capacitor c=0.0132685f //x=38.145 //y=1.845
c532 ( 14 0 ) capacitor c=0.0167992f //x=37.745 //y=1.76
c533 ( 13 0 ) capacitor c=0.0113147f //x=37.745 //y=1.305
c534 ( 11 0 ) capacitor c=0.0205277f //x=38.145 //y=5.335
c535 ( 10 0 ) capacitor c=0.00933983f //x=37.45 //y=5.56
c536 ( 7 0 ) capacitor c=0.0172149f //x=37.335 //y=5.335
c537 ( 5 0 ) capacitor c=0.0148649f //x=36.45 //y=5.335
c538 ( 4 0 ) capacitor c=0.0303408f //x=32.68 //y=4.75
c539 ( 3 0 ) capacitor c=0.0122376f //x=32.68 //y=3.675
c540 ( 2 0 ) capacitor c=0.0217874f //x=32.68 //y=3.355
c541 ( 1 0 ) capacitor c=0.005545f //x=32.68 //y=2.375
r542 (  174 175 ) resistor r=52.7279 //w=0.214 //l=0.165 //layer=ply \
 //thickness=0.18 //x=32.68 //y=2.26 //x2=32.68 //y2=2.095
r543 (  168 170 ) resistor r=26.9307 //w=0.15 //l=0.106066 //layer=ply \
 //thickness=0.18 //x=50.265 //y=4.97 //x2=50.34 //y2=5.045
r544 (  168 169 ) resistor r=148.702 //w=0.094 //l=0.29 //layer=ply \
 //thickness=0.18 //x=50.265 //y=4.97 //x2=49.975 //y2=4.97
r545 (  167 190 ) resistor r=45.1352 //w=0.168 //l=0.173853 //layer=ply \
 //thickness=0.18 //x=49.93 //y=1.4 //x2=49.89 //y2=1.555
r546 (  166 189 ) resistor r=45.1352 //w=0.168 //l=0.173853 //layer=ply \
 //thickness=0.18 //x=49.93 //y=1.055 //x2=49.89 //y2=0.9
r547 (  166 167 ) resistor r=176.904 //w=0.094 //l=0.345 //layer=ply \
 //thickness=0.18 //x=49.93 //y=1.055 //x2=49.93 //y2=1.4
r548 (  163 169 ) resistor r=22.7971 //w=0.269 //l=0.106066 //layer=ply \
 //thickness=0.18 //x=49.9 //y=5.045 //x2=49.975 //y2=4.97
r549 (  163 188 ) resistor r=35.8364 //w=0.269 //l=0.270185 //layer=ply \
 //thickness=0.18 //x=49.9 //y=5.045 //x2=49.7 //y2=4.88
r550 (  161 184 ) resistor r=10.701 //w=0.21 //l=0.115 //layer=ply \
 //thickness=0.18 //x=49.555 //y=1.555 //x2=49.44 //y2=1.555
r551 (  160 190 ) resistor r=5.52526 //w=0.168 //l=0.115 //layer=ply \
 //thickness=0.18 //x=49.775 //y=1.555 //x2=49.89 //y2=1.555
r552 (  159 183 ) resistor r=5.52526 //w=0.168 //l=0.115 //layer=ply \
 //thickness=0.18 //x=49.555 //y=0.9 //x2=49.44 //y2=0.9
r553 (  158 189 ) resistor r=5.52526 //w=0.168 //l=0.115 //layer=ply \
 //thickness=0.18 //x=49.775 //y=0.9 //x2=49.89 //y2=0.9
r554 (  158 159 ) resistor r=112.809 //w=0.094 //l=0.22 //layer=ply \
 //thickness=0.18 //x=49.775 //y=0.9 //x2=49.555 //y2=0.9
r555 (  157 186 ) resistor r=58.7805 //w=0.246 //l=0.373497 //layer=ply \
 //thickness=0.18 //x=49.4 //y=2.095 //x2=49.7 //y2=2.26
r556 (  156 184 ) resistor r=39.5823 //w=0.21 //l=0.173853 //layer=ply \
 //thickness=0.18 //x=49.4 //y=1.71 //x2=49.44 //y2=1.555
r557 (  156 157 ) resistor r=197.415 //w=0.094 //l=0.385 //layer=ply \
 //thickness=0.18 //x=49.4 //y=1.71 //x2=49.4 //y2=2.095
r558 (  155 184 ) resistor r=39.5823 //w=0.21 //l=0.173853 //layer=ply \
 //thickness=0.18 //x=49.4 //y=1.4 //x2=49.44 //y2=1.555
r559 (  154 183 ) resistor r=45.1352 //w=0.168 //l=0.173853 //layer=ply \
 //thickness=0.18 //x=49.4 //y=1.055 //x2=49.44 //y2=0.9
r560 (  154 155 ) resistor r=176.904 //w=0.094 //l=0.345 //layer=ply \
 //thickness=0.18 //x=49.4 //y=1.055 //x2=49.4 //y2=1.4
r561 (  153 182 ) resistor r=45.1352 //w=0.168 //l=0.173853 //layer=ply \
 //thickness=0.18 //x=33.2 //y=1.44 //x2=33.16 //y2=1.595
r562 (  152 181 ) resistor r=45.1352 //w=0.168 //l=0.173853 //layer=ply \
 //thickness=0.18 //x=33.2 //y=1.095 //x2=33.16 //y2=0.94
r563 (  152 153 ) resistor r=176.904 //w=0.094 //l=0.345 //layer=ply \
 //thickness=0.18 //x=33.2 //y=1.095 //x2=33.2 //y2=1.44
r564 (  150 178 ) resistor r=10.701 //w=0.21 //l=0.115 //layer=ply \
 //thickness=0.18 //x=32.825 //y=1.595 //x2=32.71 //y2=1.595
r565 (  149 182 ) resistor r=5.52526 //w=0.168 //l=0.115 //layer=ply \
 //thickness=0.18 //x=33.045 //y=1.595 //x2=33.16 //y2=1.595
r566 (  148 177 ) resistor r=5.52526 //w=0.168 //l=0.115 //layer=ply \
 //thickness=0.18 //x=32.825 //y=0.94 //x2=32.71 //y2=0.94
r567 (  147 181 ) resistor r=5.52526 //w=0.168 //l=0.115 //layer=ply \
 //thickness=0.18 //x=33.045 //y=0.94 //x2=33.16 //y2=0.94
r568 (  147 148 ) resistor r=112.809 //w=0.094 //l=0.22 //layer=ply \
 //thickness=0.18 //x=33.045 //y=0.94 //x2=32.825 //y2=0.94
r569 (  144 180 ) resistor r=37.236 //w=0.233 //l=0.249199 //layer=ply \
 //thickness=0.18 //x=32.86 //y=5.045 //x2=32.68 //y2=4.88
r570 (  142 178 ) resistor r=39.5823 //w=0.21 //l=0.173853 //layer=ply \
 //thickness=0.18 //x=32.67 //y=1.75 //x2=32.71 //y2=1.595
r571 (  142 175 ) resistor r=176.904 //w=0.094 //l=0.345 //layer=ply \
 //thickness=0.18 //x=32.67 //y=1.75 //x2=32.67 //y2=2.095
r572 (  141 178 ) resistor r=39.5823 //w=0.21 //l=0.173853 //layer=ply \
 //thickness=0.18 //x=32.67 //y=1.44 //x2=32.71 //y2=1.595
r573 (  140 177 ) resistor r=45.1352 //w=0.168 //l=0.173853 //layer=ply \
 //thickness=0.18 //x=32.67 //y=1.095 //x2=32.71 //y2=0.94
r574 (  140 141 ) resistor r=176.904 //w=0.094 //l=0.345 //layer=ply \
 //thickness=0.18 //x=32.67 //y=1.095 //x2=32.67 //y2=1.44
r575 (  137 180 ) resistor r=53.7854 //w=0.233 //l=0.332415 //layer=ply \
 //thickness=0.18 //x=32.42 //y=5.045 //x2=32.68 //y2=4.88
r576 (  136 170 ) resistor r=592.245 //w=0.094 //l=1.155 //layer=ply \
 //thickness=0.18 //x=50.34 //y=6.2 //x2=50.34 //y2=5.045
r577 (  135 163 ) resistor r=592.245 //w=0.094 //l=1.155 //layer=ply \
 //thickness=0.18 //x=49.9 //y=6.2 //x2=49.9 //y2=5.045
r578 (  134 144 ) resistor r=592.245 //w=0.094 //l=1.155 //layer=ply \
 //thickness=0.18 //x=32.86 //y=6.2 //x2=32.86 //y2=5.045
r579 (  133 137 ) resistor r=592.245 //w=0.094 //l=1.155 //layer=ply \
 //thickness=0.18 //x=32.42 //y=6.2 //x2=32.42 //y2=5.045
r580 (  132 160 ) resistor r=56.4043 //w=0.094 //l=0.11 //layer=ply \
 //thickness=0.18 //x=49.665 //y=1.555 //x2=49.775 //y2=1.555
r581 (  132 161 ) resistor r=56.4043 //w=0.094 //l=0.11 //layer=ply \
 //thickness=0.18 //x=49.665 //y=1.555 //x2=49.555 //y2=1.555
r582 (  131 149 ) resistor r=56.4043 //w=0.094 //l=0.11 //layer=ply \
 //thickness=0.18 //x=32.935 //y=1.595 //x2=33.045 //y2=1.595
r583 (  131 150 ) resistor r=56.4043 //w=0.094 //l=0.11 //layer=ply \
 //thickness=0.18 //x=32.935 //y=1.595 //x2=32.825 //y2=1.595
r584 (  127 188 ) resistor r=152 //w=0.17 //l=0.17 //layer=licon //count=1 \
 //x=49.7 //y=4.88 //x2=49.7 //y2=4.88
r585 (  118 186 ) resistor r=152 //w=0.17 //l=0.17 //layer=licon //count=1 \
 //x=49.7 //y=2.26 //x2=49.7 //y2=2.26
r586 (  101 195 ) resistor r=23.615 //w=0.187 //l=0.345 //layer=li \
 //thickness=0.1 //x=37.45 //y=5.56 //x2=37.45 //y2=5.905
r587 (  93 194 ) resistor r=23.615 //w=0.187 //l=0.345 //layer=li \
 //thickness=0.1 //x=36.57 //y=5.56 //x2=36.57 //y2=5.905
r588 (  85 193 ) resistor r=23.615 //w=0.187 //l=0.345 //layer=li \
 //thickness=0.1 //x=35.69 //y=5.56 //x2=35.69 //y2=5.905
r589 (  80 180 ) resistor r=152 //w=0.17 //l=0.17 //layer=licon //count=1 \
 //x=32.68 //y=4.88 //x2=32.68 //y2=4.88
r590 (  71 174 ) resistor r=152 //w=0.17 //l=0.17 //layer=licon //count=1 \
 //x=32.68 //y=2.26 //x2=32.68 //y2=2.26
r591 (  64 66 ) resistor r=0.10734 //w=0.281 //l=0.16 //layer=m2 \
 //thickness=0.36 //x=38.23 //y=3.495 //x2=38.39 //y2=3.495
r592 (  64 65 ) resistor r=0.10734 //w=0.281 //l=0.16 //layer=m2 \
 //thickness=0.36 //x=38.23 //y=3.495 //x2=38.07 //y2=3.495
r593 (  62 65 ) resistor r=4.98092 //w=0.131 //l=5.22 //layer=m2 \
 //thickness=0.36 //x=32.85 //y=3.51 //x2=38.07 //y2=3.51
r594 (  60 62 ) resistor r=0.10734 //w=0.281 //l=0.16 //layer=m2 \
 //thickness=0.36 //x=32.69 //y=3.515 //x2=32.85 //y2=3.515
r595 (  57 68 ) resistor r=0.10734 //w=0.281 //l=0.16 //layer=m2 \
 //thickness=0.36 //x=49.535 //y=3.51 //x2=49.695 //y2=3.51
r596 (  57 66 ) resistor r=10.6345 //w=0.131 //l=11.145 //layer=m2 \
 //thickness=0.36 //x=49.535 //y=3.51 //x2=38.39 //y2=3.51
r597 (  54 127 ) resistor r=9.3 //w=0.17 //l=0.17 //layer=mcon //count=1 \
 //x=49.7 //y=4.88 //x2=49.7 //y2=4.88
r598 (  52 118 ) resistor r=9.3 //w=0.17 //l=0.17 //layer=mcon //count=1 \
 //x=49.7 //y=2.26 //x2=49.7 //y2=2.26
r599 (  49 68 ) resistor r=4.5 //w=0.15 //l=0.15 //layer=via1 //count=1 \
 //x=49.695 //y=3.51 //x2=49.695 //y2=3.51
r600 (  45 64 ) resistor r=4.5 //w=0.15 //l=0.15 //layer=via1 //count=1 \
 //x=38.23 //y=3.495 //x2=38.23 //y2=3.495
r601 (  45 47 ) resistor r=0.0049867 //w=0.376 //l=0.015 //layer=m1 \
 //thickness=0.36 //x=38.282 //y=3.495 //x2=38.282 //y2=3.51
r602 (  43 191 ) resistor r=9.3 //w=0.17 //l=0.17 //layer=mcon //count=1 \
 //x=37.745 //y=1.19 //x2=37.745 //y2=1.19
r603 (  41 101 ) resistor r=9.3 //w=0.17 //l=0.17 //layer=mcon //count=1 \
 //x=37.45 //y=5.56 //x2=37.45 //y2=5.56
r604 (  38 93 ) resistor r=9.3 //w=0.17 //l=0.17 //layer=mcon //count=1 \
 //x=36.57 //y=5.56 //x2=36.57 //y2=5.56
r605 (  36 38 ) resistor r=0.121228 //w=0.232 //l=0.225 //layer=m1 \
 //thickness=0.36 //x=36.57 //y=5.335 //x2=36.57 //y2=5.56
r606 (  35 85 ) resistor r=9.3 //w=0.17 //l=0.17 //layer=mcon //count=1 \
 //x=35.69 //y=5.56 //x2=35.69 //y2=5.56
r607 (  33 35 ) resistor r=0.129608 //w=0.217 //l=0.225 //layer=m1 \
 //thickness=0.36 //x=35.692 //y=5.335 //x2=35.692 //y2=5.56
r608 (  32 60 ) resistor r=4.5 //w=0.15 //l=0.15 //layer=via1 //count=1 \
 //x=32.69 //y=3.515 //x2=32.69 //y2=3.515
r609 (  30 32 ) resistor r=0.00168464 //w=0.371 //l=0.005 //layer=m1 \
 //thickness=0.36 //x=32.737 //y=3.51 //x2=32.737 //y2=3.515
r610 (  28 80 ) resistor r=9.3 //w=0.17 //l=0.17 //layer=mcon //count=1 \
 //x=32.68 //y=4.88 //x2=32.68 //y2=4.88
r611 (  26 71 ) resistor r=9.3 //w=0.17 //l=0.17 //layer=mcon //count=1 \
 //x=32.68 //y=2.26 //x2=32.68 //y2=2.26
r612 (  24 54 ) resistor r=0.0760407 //w=0.238 //l=0.125 //layer=m1 \
 //thickness=0.36 //x=49.7 //y=4.755 //x2=49.7 //y2=4.88
r613 (  23 49 ) resistor r=0.0910802 //w=0.374 //l=0.185472 //layer=m1 \
 //thickness=0.36 //x=49.7 //y=3.67 //x2=49.645 //y2=3.51
r614 (  23 24 ) resistor r=1.03531 //w=0.131 //l=1.085 //layer=m1 \
 //thickness=0.36 //x=49.7 //y=3.67 //x2=49.7 //y2=4.755
r615 (  22 49 ) resistor r=0.0910802 //w=0.374 //l=0.185472 //layer=m1 \
 //thickness=0.36 //x=49.7 //y=3.35 //x2=49.645 //y2=3.51
r616 (  21 52 ) resistor r=0.0719237 //w=0.222 //l=0.115 //layer=m1 \
 //thickness=0.36 //x=49.7 //y=2.375 //x2=49.7 //y2=2.26
r617 (  21 22 ) resistor r=0.930344 //w=0.131 //l=0.975 //layer=m1 \
 //thickness=0.36 //x=49.7 //y=2.375 //x2=49.7 //y2=3.35
r618 (  19 47 ) resistor r=0.0861726 //w=0.376 //l=0.169012 //layer=m1 \
 //thickness=0.36 //x=38.23 //y=3.655 //x2=38.282 //y2=3.51
r619 (  19 20 ) resistor r=1.52195 //w=0.131 //l=1.595 //layer=m1 \
 //thickness=0.36 //x=38.23 //y=3.655 //x2=38.23 //y2=5.25
r620 (  18 45 ) resistor r=0.0911593 //w=0.376 //l=0.184174 //layer=m1 \
 //thickness=0.36 //x=38.23 //y=3.335 //x2=38.282 //y2=3.495
r621 (  17 18 ) resistor r=1.34065 //w=0.131 //l=1.405 //layer=m1 \
 //thickness=0.36 //x=38.23 //y=1.93 //x2=38.23 //y2=3.335
r622 (  15 17 ) resistor r=0.0698411 //w=0.17 //l=0.120208 //layer=m1 \
 //thickness=0.36 //x=38.145 //y=1.845 //x2=38.23 //y2=1.93
r623 (  15 16 ) resistor r=0.300573 //w=0.131 //l=0.315 //layer=m1 \
 //thickness=0.36 //x=38.145 //y=1.845 //x2=37.83 //y2=1.845
r624 (  14 16 ) resistor r=0.0698411 //w=0.17 //l=0.120208 //layer=m1 \
 //thickness=0.36 //x=37.745 //y=1.76 //x2=37.83 //y2=1.845
r625 (  13 43 ) resistor r=0.0717383 //w=0.224 //l=0.115 //layer=m1 \
 //thickness=0.36 //x=37.745 //y=1.305 //x2=37.745 //y2=1.19
r626 (  13 14 ) resistor r=0.43416 //w=0.131 //l=0.455 //layer=m1 \
 //thickness=0.36 //x=37.745 //y=1.305 //x2=37.745 //y2=1.76
r627 (  12 39 ) resistor r=0.0675342 //w=0.23 //l=0.115 //layer=m1 \
 //thickness=0.36 //x=37.565 //y=5.335 //x2=37.45 //y2=5.335
r628 (  11 20 ) resistor r=0.0698411 //w=0.17 //l=0.120208 //layer=m1 \
 //thickness=0.36 //x=38.145 //y=5.335 //x2=38.23 //y2=5.25
r629 (  11 12 ) resistor r=0.553435 //w=0.131 //l=0.58 //layer=m1 \
 //thickness=0.36 //x=38.145 //y=5.335 //x2=37.565 //y2=5.335
r630 (  10 41 ) resistor r=0.00118313 //w=0.23 //layer=m1 //thickness=0.36 \
 //x=37.45 //y=5.56 //x2=37.45 //y2=5.56
r631 (  9 39 ) resistor r=0.002872 //w=0.34 //l=0.085 //layer=m1 \
 //thickness=0.36 //x=37.45 //y=5.42 //x2=37.45 //y2=5.335
r632 (  9 10 ) resistor r=0.091623 //w=0.191 //l=0.14 //layer=m1 \
 //thickness=0.36 //x=37.45 //y=5.42 //x2=37.45 //y2=5.56
r633 (  8 36 ) resistor r=0.0262263 //w=0.232 //l=0.12 //layer=m1 \
 //thickness=0.36 //x=36.69 //y=5.335 //x2=36.57 //y2=5.335
r634 (  7 39 ) resistor r=0.0675342 //w=0.23 //l=0.115 //layer=m1 \
 //thickness=0.36 //x=37.335 //y=5.335 //x2=37.45 //y2=5.335
r635 (  7 8 ) resistor r=0.615458 //w=0.131 //l=0.645 //layer=m1 \
 //thickness=0.36 //x=37.335 //y=5.335 //x2=36.69 //y2=5.335
r636 (  6 33 ) resistor r=0.0222262 //w=0.217 //l=0.118 //layer=m1 \
 //thickness=0.36 //x=35.81 //y=5.335 //x2=35.692 //y2=5.335
r637 (  5 36 ) resistor r=0.0262263 //w=0.232 //l=0.12 //layer=m1 \
 //thickness=0.36 //x=36.45 //y=5.335 //x2=36.57 //y2=5.335
r638 (  5 6 ) resistor r=0.610687 //w=0.131 //l=0.64 //layer=m1 \
 //thickness=0.36 //x=36.45 //y=5.335 //x2=35.81 //y2=5.335
r639 (  4 28 ) resistor r=0.0801089 //w=0.224 //l=0.13 //layer=m1 \
 //thickness=0.36 //x=32.68 //y=4.75 //x2=32.68 //y2=4.88
r640 (  3 32 ) resistor r=0.0909648 //w=0.371 //l=0.186333 //layer=m1 \
 //thickness=0.36 //x=32.68 //y=3.675 //x2=32.737 //y2=3.515
r641 (  3 4 ) resistor r=1.02576 //w=0.131 //l=1.075 //layer=m1 \
 //thickness=0.36 //x=32.68 //y=3.675 //x2=32.68 //y2=4.75
r642 (  2 30 ) resistor r=0.0892801 //w=0.371 //l=0.181273 //layer=m1 \
 //thickness=0.36 //x=32.68 //y=3.355 //x2=32.737 //y2=3.51
r643 (  1 26 ) resistor r=0.0719237 //w=0.222 //l=0.115 //layer=m1 \
 //thickness=0.36 //x=32.68 //y=2.375 //x2=32.68 //y2=2.26
r644 (  1 2 ) resistor r=0.935115 //w=0.131 //l=0.98 //layer=m1 \
 //thickness=0.36 //x=32.68 //y=2.375 //x2=32.68 //y2=3.355
ends PM_TMRDFFSNRNQX1\%noxref_9

subckt PM_TMRDFFSNRNQX1\%noxref_10 ( 1 3 6 7 9 10 11 12 14 15 16 17 18 19 20 \
 21 24 27 35 43 49 51 52 55 63 71 88 97 101 102 103 104 105 106 107 108 110 \
 116 117 118 119 131 133 134 135 )
c299 ( 131 0 ) capacitor c=0.00885916f //x=51.985 //y=1.095
c300 ( 119 0 ) capacitor c=0.0612936f //x=54.785 //y=4.97
c301 ( 118 0 ) capacitor c=0.0376642f //x=55.075 //y=4.97
c302 ( 117 0 ) capacitor c=0.0346489f //x=54.74 //y=1.4
c303 ( 116 0 ) capacitor c=0.018692f //x=54.74 //y=1.055
c304 ( 110 0 ) capacitor c=0.0137077f //x=54.585 //y=1.555
c305 ( 108 0 ) capacitor c=0.0158585f //x=54.585 //y=0.9
c306 ( 107 0 ) capacitor c=0.097937f //x=54.21 //y=2.095
c307 ( 106 0 ) capacitor c=0.0229364f //x=54.21 //y=1.71
c308 ( 105 0 ) capacitor c=0.0234359f //x=54.21 //y=1.4
c309 ( 104 0 ) capacitor c=0.019815f //x=54.21 //y=1.055
c310 ( 103 0 ) capacitor c=0.110208f //x=55.15 //y=6.2
c311 ( 102 0 ) capacitor c=0.158957f //x=54.71 //y=6.2
c312 ( 97 0 ) capacitor c=0.00159026f //x=54.51 //y=4.88
c313 ( 88 0 ) capacitor c=9.93222e-19 //x=54.51 //y=2.26
c314 ( 71 0 ) capacitor c=0.0293555f //x=51.88 //y=5.56
c315 ( 63 0 ) capacitor c=0.029137f //x=51 //y=5.56
c316 ( 55 0 ) capacitor c=0.0278099f //x=50.12 //y=5.56
c317 ( 52 0 ) capacitor c=0.0150338f //x=54.305 //y=2.755
c318 ( 51 0 ) capacitor c=0.00484623f //x=54.465 //y=2.755
c319 ( 49 0 ) capacitor c=0.00533437f //x=52.865 //y=2.755
c320 ( 43 0 ) capacitor c=0.0148553f //x=54.51 //y=2.77
c321 ( 35 0 ) capacitor c=0.0144499f //x=52.66 //y=2.77
c322 ( 27 0 ) capacitor c=9.12964e-19 //x=51.88 //y=5.335
c323 ( 24 0 ) capacitor c=0.00762667f //x=51 //y=5.335
c324 ( 21 0 ) capacitor c=0.0109203f //x=50.122 //y=5.335
c325 ( 20 0 ) capacitor c=0.0579757f //x=54.51 //y=4.755
c326 ( 19 0 ) capacitor c=0.0139549f //x=54.51 //y=2.915
c327 ( 18 0 ) capacitor c=0.00427649f //x=54.51 //y=2.595
c328 ( 17 0 ) capacitor c=0.00437465f //x=54.51 //y=2.375
c329 ( 16 0 ) capacitor c=0.0654285f //x=52.66 //y=5.25
c330 ( 15 0 ) capacitor c=0.0129881f //x=52.66 //y=2.915
c331 ( 14 0 ) capacitor c=0.017505f //x=52.66 //y=2.595
c332 ( 12 0 ) capacitor c=0.0047266f //x=52.26 //y=1.845
c333 ( 11 0 ) capacitor c=0.012967f //x=52.575 //y=1.845
c334 ( 10 0 ) capacitor c=0.0167992f //x=52.175 //y=1.76
c335 ( 9 0 ) capacitor c=0.0110975f //x=52.175 //y=1.305
c336 ( 7 0 ) capacitor c=0.0207192f //x=52.575 //y=5.335
c337 ( 6 0 ) capacitor c=0.00933983f //x=51.88 //y=5.56
c338 ( 3 0 ) capacitor c=0.0190581f //x=51.765 //y=5.335
c339 ( 1 0 ) capacitor c=0.0149131f //x=50.88 //y=5.335
r340 (  118 120 ) resistor r=26.9307 //w=0.15 //l=0.106066 //layer=ply \
 //thickness=0.18 //x=55.075 //y=4.97 //x2=55.15 //y2=5.045
r341 (  118 119 ) resistor r=148.702 //w=0.094 //l=0.29 //layer=ply \
 //thickness=0.18 //x=55.075 //y=4.97 //x2=54.785 //y2=4.97
r342 (  117 130 ) resistor r=45.1352 //w=0.168 //l=0.173853 //layer=ply \
 //thickness=0.18 //x=54.74 //y=1.4 //x2=54.7 //y2=1.555
r343 (  116 129 ) resistor r=45.1352 //w=0.168 //l=0.173853 //layer=ply \
 //thickness=0.18 //x=54.74 //y=1.055 //x2=54.7 //y2=0.9
r344 (  116 117 ) resistor r=176.904 //w=0.094 //l=0.345 //layer=ply \
 //thickness=0.18 //x=54.74 //y=1.055 //x2=54.74 //y2=1.4
r345 (  113 119 ) resistor r=22.7971 //w=0.269 //l=0.106066 //layer=ply \
 //thickness=0.18 //x=54.71 //y=5.045 //x2=54.785 //y2=4.97
r346 (  113 128 ) resistor r=35.8364 //w=0.269 //l=0.270185 //layer=ply \
 //thickness=0.18 //x=54.71 //y=5.045 //x2=54.51 //y2=4.88
r347 (  111 124 ) resistor r=10.701 //w=0.21 //l=0.115 //layer=ply \
 //thickness=0.18 //x=54.365 //y=1.555 //x2=54.25 //y2=1.555
r348 (  110 130 ) resistor r=5.52526 //w=0.168 //l=0.115 //layer=ply \
 //thickness=0.18 //x=54.585 //y=1.555 //x2=54.7 //y2=1.555
r349 (  109 123 ) resistor r=5.52526 //w=0.168 //l=0.115 //layer=ply \
 //thickness=0.18 //x=54.365 //y=0.9 //x2=54.25 //y2=0.9
r350 (  108 129 ) resistor r=5.52526 //w=0.168 //l=0.115 //layer=ply \
 //thickness=0.18 //x=54.585 //y=0.9 //x2=54.7 //y2=0.9
r351 (  108 109 ) resistor r=112.809 //w=0.094 //l=0.22 //layer=ply \
 //thickness=0.18 //x=54.585 //y=0.9 //x2=54.365 //y2=0.9
r352 (  107 126 ) resistor r=58.7805 //w=0.246 //l=0.373497 //layer=ply \
 //thickness=0.18 //x=54.21 //y=2.095 //x2=54.51 //y2=2.26
r353 (  106 124 ) resistor r=39.5823 //w=0.21 //l=0.173853 //layer=ply \
 //thickness=0.18 //x=54.21 //y=1.71 //x2=54.25 //y2=1.555
r354 (  106 107 ) resistor r=197.415 //w=0.094 //l=0.385 //layer=ply \
 //thickness=0.18 //x=54.21 //y=1.71 //x2=54.21 //y2=2.095
r355 (  105 124 ) resistor r=39.5823 //w=0.21 //l=0.173853 //layer=ply \
 //thickness=0.18 //x=54.21 //y=1.4 //x2=54.25 //y2=1.555
r356 (  104 123 ) resistor r=45.1352 //w=0.168 //l=0.173853 //layer=ply \
 //thickness=0.18 //x=54.21 //y=1.055 //x2=54.25 //y2=0.9
r357 (  104 105 ) resistor r=176.904 //w=0.094 //l=0.345 //layer=ply \
 //thickness=0.18 //x=54.21 //y=1.055 //x2=54.21 //y2=1.4
r358 (  103 120 ) resistor r=592.245 //w=0.094 //l=1.155 //layer=ply \
 //thickness=0.18 //x=55.15 //y=6.2 //x2=55.15 //y2=5.045
r359 (  102 113 ) resistor r=592.245 //w=0.094 //l=1.155 //layer=ply \
 //thickness=0.18 //x=54.71 //y=6.2 //x2=54.71 //y2=5.045
r360 (  101 110 ) resistor r=56.4043 //w=0.094 //l=0.11 //layer=ply \
 //thickness=0.18 //x=54.475 //y=1.555 //x2=54.585 //y2=1.555
r361 (  101 111 ) resistor r=56.4043 //w=0.094 //l=0.11 //layer=ply \
 //thickness=0.18 //x=54.475 //y=1.555 //x2=54.365 //y2=1.555
r362 (  97 128 ) resistor r=152 //w=0.17 //l=0.17 //layer=licon //count=1 \
 //x=54.51 //y=4.88 //x2=54.51 //y2=4.88
r363 (  88 126 ) resistor r=152 //w=0.17 //l=0.17 //layer=licon //count=1 \
 //x=54.51 //y=2.26 //x2=54.51 //y2=2.26
r364 (  71 135 ) resistor r=23.615 //w=0.187 //l=0.345 //layer=li \
 //thickness=0.1 //x=51.88 //y=5.56 //x2=51.88 //y2=5.905
r365 (  63 134 ) resistor r=23.615 //w=0.187 //l=0.345 //layer=li \
 //thickness=0.1 //x=51 //y=5.56 //x2=51 //y2=5.905
r366 (  55 133 ) resistor r=23.615 //w=0.187 //l=0.345 //layer=li \
 //thickness=0.1 //x=50.12 //y=5.56 //x2=50.12 //y2=5.905
r367 (  51 52 ) resistor r=0.10734 //w=0.281 //l=0.16 //layer=m2 \
 //thickness=0.36 //x=54.465 //y=2.755 //x2=54.305 //y2=2.755
r368 (  49 52 ) resistor r=1.37405 //w=0.131 //l=1.44 //layer=m2 \
 //thickness=0.36 //x=52.865 //y=2.77 //x2=54.305 //y2=2.77
r369 (  47 49 ) resistor r=0.10734 //w=0.281 //l=0.16 //layer=m2 \
 //thickness=0.36 //x=52.705 //y=2.755 //x2=52.865 //y2=2.755
r370 (  41 51 ) resistor r=4.5 //w=0.15 //l=0.15 //layer=via1 //count=1 \
 //x=54.465 //y=2.755 //x2=54.465 //y2=2.755
r371 (  41 43 ) resistor r=0.00509511 //w=0.368 //l=0.015 //layer=m1 \
 //thickness=0.36 //x=54.45 //y=2.755 //x2=54.45 //y2=2.77
r372 (  39 97 ) resistor r=9.3 //w=0.17 //l=0.17 //layer=mcon //count=1 \
 //x=54.51 //y=4.88 //x2=54.51 //y2=4.88
r373 (  37 88 ) resistor r=9.3 //w=0.17 //l=0.17 //layer=mcon //count=1 \
 //x=54.51 //y=2.26 //x2=54.51 //y2=2.26
r374 (  33 47 ) resistor r=4.5 //w=0.15 //l=0.15 //layer=via1 //count=1 \
 //x=52.705 //y=2.755 //x2=52.705 //y2=2.755
r375 (  33 35 ) resistor r=0.00509511 //w=0.368 //l=0.015 //layer=m1 \
 //thickness=0.36 //x=52.72 //y=2.755 //x2=52.72 //y2=2.77
r376 (  31 131 ) resistor r=9.3 //w=0.17 //l=0.17 //layer=mcon //count=1 \
 //x=52.175 //y=1.19 //x2=52.175 //y2=1.19
r377 (  29 71 ) resistor r=9.3 //w=0.17 //l=0.17 //layer=mcon //count=1 \
 //x=51.88 //y=5.56 //x2=51.88 //y2=5.56
r378 (  26 63 ) resistor r=9.3 //w=0.17 //l=0.17 //layer=mcon //count=1 //x=51 \
 //y=5.56 //x2=51 //y2=5.56
r379 (  24 26 ) resistor r=0.121228 //w=0.232 //l=0.225 //layer=m1 \
 //thickness=0.36 //x=51 //y=5.335 //x2=51 //y2=5.56
r380 (  23 55 ) resistor r=9.3 //w=0.17 //l=0.17 //layer=mcon //count=1 \
 //x=50.12 //y=5.56 //x2=50.12 //y2=5.56
r381 (  21 23 ) resistor r=0.129608 //w=0.217 //l=0.225 //layer=m1 \
 //thickness=0.36 //x=50.122 //y=5.335 //x2=50.122 //y2=5.56
r382 (  20 39 ) resistor r=0.0760407 //w=0.238 //l=0.125 //layer=m1 \
 //thickness=0.36 //x=54.51 //y=4.755 //x2=54.51 //y2=4.88
r383 (  19 43 ) resistor r=0.0857585 //w=0.368 //l=0.172409 //layer=m1 \
 //thickness=0.36 //x=54.51 //y=2.915 //x2=54.45 //y2=2.77
r384 (  19 20 ) resistor r=1.75573 //w=0.131 //l=1.84 //layer=m1 \
 //thickness=0.36 //x=54.51 //y=2.915 //x2=54.51 //y2=4.755
r385 (  18 41 ) resistor r=0.0908536 //w=0.368 //l=0.187617 //layer=m1 \
 //thickness=0.36 //x=54.51 //y=2.595 //x2=54.45 //y2=2.755
r386 (  17 37 ) resistor r=0.0719237 //w=0.222 //l=0.115 //layer=m1 \
 //thickness=0.36 //x=54.51 //y=2.375 //x2=54.51 //y2=2.26
r387 (  17 18 ) resistor r=0.209924 //w=0.131 //l=0.22 //layer=m1 \
 //thickness=0.36 //x=54.51 //y=2.375 //x2=54.51 //y2=2.595
r388 (  15 35 ) resistor r=0.0857585 //w=0.368 //l=0.172409 //layer=m1 \
 //thickness=0.36 //x=52.66 //y=2.915 //x2=52.72 //y2=2.77
r389 (  15 16 ) resistor r=2.22805 //w=0.131 //l=2.335 //layer=m1 \
 //thickness=0.36 //x=52.66 //y=2.915 //x2=52.66 //y2=5.25
r390 (  14 33 ) resistor r=0.0908536 //w=0.368 //l=0.187617 //layer=m1 \
 //thickness=0.36 //x=52.66 //y=2.595 //x2=52.72 //y2=2.755
r391 (  13 14 ) resistor r=0.634542 //w=0.131 //l=0.665 //layer=m1 \
 //thickness=0.36 //x=52.66 //y=1.93 //x2=52.66 //y2=2.595
r392 (  11 13 ) resistor r=0.0698411 //w=0.17 //l=0.120208 //layer=m1 \
 //thickness=0.36 //x=52.575 //y=1.845 //x2=52.66 //y2=1.93
r393 (  11 12 ) resistor r=0.300573 //w=0.131 //l=0.315 //layer=m1 \
 //thickness=0.36 //x=52.575 //y=1.845 //x2=52.26 //y2=1.845
r394 (  10 12 ) resistor r=0.0698411 //w=0.17 //l=0.120208 //layer=m1 \
 //thickness=0.36 //x=52.175 //y=1.76 //x2=52.26 //y2=1.845
r395 (  9 31 ) resistor r=0.0717383 //w=0.224 //l=0.115 //layer=m1 \
 //thickness=0.36 //x=52.175 //y=1.305 //x2=52.175 //y2=1.19
r396 (  9 10 ) resistor r=0.43416 //w=0.131 //l=0.455 //layer=m1 \
 //thickness=0.36 //x=52.175 //y=1.305 //x2=52.175 //y2=1.76
r397 (  8 27 ) resistor r=0.0675342 //w=0.23 //l=0.115 //layer=m1 \
 //thickness=0.36 //x=51.995 //y=5.335 //x2=51.88 //y2=5.335
r398 (  7 16 ) resistor r=0.0698411 //w=0.17 //l=0.120208 //layer=m1 \
 //thickness=0.36 //x=52.575 //y=5.335 //x2=52.66 //y2=5.25
r399 (  7 8 ) resistor r=0.553435 //w=0.131 //l=0.58 //layer=m1 \
 //thickness=0.36 //x=52.575 //y=5.335 //x2=51.995 //y2=5.335
r400 (  6 29 ) resistor r=0.00118313 //w=0.23 //layer=m1 //thickness=0.36 \
 //x=51.88 //y=5.56 //x2=51.88 //y2=5.56
r401 (  5 27 ) resistor r=0.002872 //w=0.34 //l=0.085 //layer=m1 \
 //thickness=0.36 //x=51.88 //y=5.42 //x2=51.88 //y2=5.335
r402 (  5 6 ) resistor r=0.091623 //w=0.191 //l=0.14 //layer=m1 \
 //thickness=0.36 //x=51.88 //y=5.42 //x2=51.88 //y2=5.56
r403 (  4 24 ) resistor r=0.0262263 //w=0.232 //l=0.12 //layer=m1 \
 //thickness=0.36 //x=51.12 //y=5.335 //x2=51 //y2=5.335
r404 (  3 27 ) resistor r=0.0675342 //w=0.23 //l=0.115 //layer=m1 \
 //thickness=0.36 //x=51.765 //y=5.335 //x2=51.88 //y2=5.335
r405 (  3 4 ) resistor r=0.615458 //w=0.131 //l=0.645 //layer=m1 \
 //thickness=0.36 //x=51.765 //y=5.335 //x2=51.12 //y2=5.335
r406 (  2 21 ) resistor r=0.0222262 //w=0.217 //l=0.118 //layer=m1 \
 //thickness=0.36 //x=50.24 //y=5.335 //x2=50.122 //y2=5.335
r407 (  1 24 ) resistor r=0.0262263 //w=0.232 //l=0.12 //layer=m1 \
 //thickness=0.36 //x=50.88 //y=5.335 //x2=51 //y2=5.335
r408 (  1 2 ) resistor r=0.610687 //w=0.131 //l=0.64 //layer=m1 \
 //thickness=0.36 //x=50.88 //y=5.335 //x2=50.24 //y2=5.335
ends PM_TMRDFFSNRNQX1\%noxref_10

subckt PM_TMRDFFSNRNQX1\%noxref_11 ( 1 2 3 4 5 6 7 8 9 11 14 15 17 18 19 20 22 \
 23 24 25 26 27 28 34 38 45 48 51 57 61 70 72 73 77 80 81 87 96 101 110 115 \
 123 131 148 157 161 162 163 164 165 166 167 168 169 173 174 175 180 182 185 \
 186 190 191 192 197 199 202 203 207 208 209 214 216 219 220 222 223 228 232 \
 233 238 242 243 248 251 253 254 255 )
c606 ( 251 0 ) capacitor c=0.00885916f //x=47.175 //y=1.095
c607 ( 248 0 ) capacitor c=0.0651477f //x=56.73 //y=4.88
c608 ( 243 0 ) capacitor c=0.0278202f //x=56.73 //y=2.095
c609 ( 242 0 ) capacitor c=0.0503043f //x=56.73 //y=2.26
c610 ( 238 0 ) capacitor c=0.0651406f //x=42.3 //y=4.88
c611 ( 233 0 ) capacitor c=0.0278202f //x=42.3 //y=2.095
c612 ( 232 0 ) capacitor c=0.0503043f //x=42.3 //y=2.26
c613 ( 228 0 ) capacitor c=0.0653609f //x=37.49 //y=4.88
c614 ( 223 0 ) capacitor c=0.0278202f //x=37.49 //y=2.095
c615 ( 222 0 ) capacitor c=0.0503043f //x=37.49 //y=2.26
c616 ( 220 0 ) capacitor c=0.0443175f //x=57.25 //y=1.44
c617 ( 219 0 ) capacitor c=0.0199703f //x=57.25 //y=1.095
c618 ( 216 0 ) capacitor c=0.0162526f //x=57.095 //y=1.595
c619 ( 214 0 ) capacitor c=0.0157807f //x=57.095 //y=0.94
c620 ( 209 0 ) capacitor c=0.0220935f //x=56.72 //y=1.75
c621 ( 208 0 ) capacitor c=0.0207489f //x=56.72 //y=1.44
c622 ( 207 0 ) capacitor c=0.0194091f //x=56.72 //y=1.095
c623 ( 203 0 ) capacitor c=0.0443175f //x=42.82 //y=1.44
c624 ( 202 0 ) capacitor c=0.0199703f //x=42.82 //y=1.095
c625 ( 199 0 ) capacitor c=0.0162526f //x=42.665 //y=1.595
c626 ( 197 0 ) capacitor c=0.0157807f //x=42.665 //y=0.94
c627 ( 192 0 ) capacitor c=0.0220935f //x=42.29 //y=1.75
c628 ( 191 0 ) capacitor c=0.0207489f //x=42.29 //y=1.44
c629 ( 190 0 ) capacitor c=0.0194091f //x=42.29 //y=1.095
c630 ( 186 0 ) capacitor c=0.0443175f //x=38.01 //y=1.44
c631 ( 185 0 ) capacitor c=0.0199703f //x=38.01 //y=1.095
c632 ( 182 0 ) capacitor c=0.0162526f //x=37.855 //y=1.595
c633 ( 180 0 ) capacitor c=0.0157807f //x=37.855 //y=0.94
c634 ( 175 0 ) capacitor c=0.0220935f //x=37.48 //y=1.75
c635 ( 174 0 ) capacitor c=0.0207489f //x=37.48 //y=1.44
c636 ( 173 0 ) capacitor c=0.0194091f //x=37.48 //y=1.095
c637 ( 169 0 ) capacitor c=0.159671f //x=56.91 //y=6.2
c638 ( 168 0 ) capacitor c=0.110208f //x=56.47 //y=6.2
c639 ( 167 0 ) capacitor c=0.159671f //x=42.48 //y=6.2
c640 ( 166 0 ) capacitor c=0.110208f //x=42.04 //y=6.2
c641 ( 165 0 ) capacitor c=0.159671f //x=37.67 //y=6.2
c642 ( 164 0 ) capacitor c=0.110208f //x=37.23 //y=6.2
c643 ( 157 0 ) capacitor c=9.5006e-19 //x=56.73 //y=4.88
c644 ( 148 0 ) capacitor c=0.00101179f //x=56.73 //y=2.26
c645 ( 131 0 ) capacitor c=0.0293124f //x=47.07 //y=5.56
c646 ( 123 0 ) capacitor c=0.029137f //x=46.19 //y=5.56
c647 ( 115 0 ) capacitor c=0.0278099f //x=45.31 //y=5.56
c648 ( 110 0 ) capacitor c=9.5006e-19 //x=42.3 //y=4.88
c649 ( 101 0 ) capacitor c=0.00101179f //x=42.3 //y=2.26
c650 ( 96 0 ) capacitor c=9.16663e-19 //x=37.49 //y=4.88
c651 ( 87 0 ) capacitor c=0.00101179f //x=37.49 //y=2.26
c652 ( 81 0 ) capacitor c=3.98458e-19 //x=42.46 //y=3.895
c653 ( 80 0 ) capacitor c=0.0441962f //x=42.14 //y=3.895
c654 ( 77 0 ) capacitor c=3.98458e-19 //x=37.65 //y=3.895
c655 ( 73 0 ) capacitor c=0.0212158f //x=49.565 //y=3.895
c656 ( 72 0 ) capacitor c=0.0711918f //x=49.91 //y=3.895
c657 ( 70 0 ) capacitor c=0.0531395f //x=47.68 //y=3.88
c658 ( 61 0 ) capacitor c=0.0149589f //x=56.73 //y=3.88
c659 ( 57 0 ) capacitor c=0.0158949f //x=47.85 //y=3.88
c660 ( 51 0 ) capacitor c=0.00105955f //x=47.07 //y=5.335
c661 ( 48 0 ) capacitor c=0.00737416f //x=46.19 //y=5.335
c662 ( 45 0 ) capacitor c=0.0119858f //x=45.312 //y=5.335
c663 ( 38 0 ) capacitor c=0.0149589f //x=42.3 //y=3.88
c664 ( 34 0 ) capacitor c=0.0149589f //x=37.49 //y=3.88
c665 ( 28 0 ) capacitor c=0.01807f //x=56.73 //y=4.75
c666 ( 27 0 ) capacitor c=0.013506f //x=56.73 //y=4.045
c667 ( 26 0 ) capacitor c=0.0289311f //x=56.73 //y=3.725
c668 ( 25 0 ) capacitor c=0.00556102f //x=56.73 //y=2.375
c669 ( 24 0 ) capacitor c=0.0306735f //x=47.85 //y=5.25
c670 ( 23 0 ) capacitor c=0.0138897f //x=47.85 //y=4.055
c671 ( 22 0 ) capacitor c=0.0490588f //x=47.85 //y=3.735
c672 ( 20 0 ) capacitor c=0.00493487f //x=47.45 //y=1.845
c673 ( 19 0 ) capacitor c=0.0133342f //x=47.765 //y=1.845
c674 ( 18 0 ) capacitor c=0.0167992f //x=47.365 //y=1.76
c675 ( 17 0 ) capacitor c=0.0111491f //x=47.365 //y=1.305
c676 ( 15 0 ) capacitor c=0.0215649f //x=47.765 //y=5.335
c677 ( 14 0 ) capacitor c=0.00933983f //x=47.07 //y=5.56
c678 ( 11 0 ) capacitor c=0.0187547f //x=46.955 //y=5.335
c679 ( 9 0 ) capacitor c=0.0158429f //x=46.07 //y=5.335
c680 ( 8 0 ) capacitor c=0.0181659f //x=42.3 //y=4.75
c681 ( 7 0 ) capacitor c=0.011494f //x=42.3 //y=4.055
c682 ( 6 0 ) capacitor c=0.029293f //x=42.3 //y=3.735
c683 ( 5 0 ) capacitor c=0.00556102f //x=42.3 //y=2.375
c684 ( 4 0 ) capacitor c=0.0180724f //x=37.49 //y=4.75
c685 ( 3 0 ) capacitor c=0.0115187f //x=37.49 //y=4.055
c686 ( 2 0 ) capacitor c=0.0302473f //x=37.49 //y=3.735
c687 ( 1 0 ) capacitor c=0.00556102f //x=37.49 //y=2.375
r688 (  242 243 ) resistor r=52.7279 //w=0.214 //l=0.165 //layer=ply \
 //thickness=0.18 //x=56.73 //y=2.26 //x2=56.73 //y2=2.095
r689 (  232 233 ) resistor r=52.7279 //w=0.214 //l=0.165 //layer=ply \
 //thickness=0.18 //x=42.3 //y=2.26 //x2=42.3 //y2=2.095
r690 (  222 223 ) resistor r=52.7279 //w=0.214 //l=0.165 //layer=ply \
 //thickness=0.18 //x=37.49 //y=2.26 //x2=37.49 //y2=2.095
r691 (  220 250 ) resistor r=45.1352 //w=0.168 //l=0.173853 //layer=ply \
 //thickness=0.18 //x=57.25 //y=1.44 //x2=57.21 //y2=1.595
r692 (  219 249 ) resistor r=45.1352 //w=0.168 //l=0.173853 //layer=ply \
 //thickness=0.18 //x=57.25 //y=1.095 //x2=57.21 //y2=0.94
r693 (  219 220 ) resistor r=176.904 //w=0.094 //l=0.345 //layer=ply \
 //thickness=0.18 //x=57.25 //y=1.095 //x2=57.25 //y2=1.44
r694 (  217 246 ) resistor r=10.701 //w=0.21 //l=0.115 //layer=ply \
 //thickness=0.18 //x=56.875 //y=1.595 //x2=56.76 //y2=1.595
r695 (  216 250 ) resistor r=5.52526 //w=0.168 //l=0.115 //layer=ply \
 //thickness=0.18 //x=57.095 //y=1.595 //x2=57.21 //y2=1.595
r696 (  215 245 ) resistor r=5.52526 //w=0.168 //l=0.115 //layer=ply \
 //thickness=0.18 //x=56.875 //y=0.94 //x2=56.76 //y2=0.94
r697 (  214 249 ) resistor r=5.52526 //w=0.168 //l=0.115 //layer=ply \
 //thickness=0.18 //x=57.095 //y=0.94 //x2=57.21 //y2=0.94
r698 (  214 215 ) resistor r=112.809 //w=0.094 //l=0.22 //layer=ply \
 //thickness=0.18 //x=57.095 //y=0.94 //x2=56.875 //y2=0.94
r699 (  211 248 ) resistor r=37.236 //w=0.233 //l=0.249199 //layer=ply \
 //thickness=0.18 //x=56.91 //y=5.045 //x2=56.73 //y2=4.88
r700 (  209 246 ) resistor r=39.5823 //w=0.21 //l=0.173853 //layer=ply \
 //thickness=0.18 //x=56.72 //y=1.75 //x2=56.76 //y2=1.595
r701 (  209 243 ) resistor r=176.904 //w=0.094 //l=0.345 //layer=ply \
 //thickness=0.18 //x=56.72 //y=1.75 //x2=56.72 //y2=2.095
r702 (  208 246 ) resistor r=39.5823 //w=0.21 //l=0.173853 //layer=ply \
 //thickness=0.18 //x=56.72 //y=1.44 //x2=56.76 //y2=1.595
r703 (  207 245 ) resistor r=45.1352 //w=0.168 //l=0.173853 //layer=ply \
 //thickness=0.18 //x=56.72 //y=1.095 //x2=56.76 //y2=0.94
r704 (  207 208 ) resistor r=176.904 //w=0.094 //l=0.345 //layer=ply \
 //thickness=0.18 //x=56.72 //y=1.095 //x2=56.72 //y2=1.44
r705 (  204 248 ) resistor r=53.7854 //w=0.233 //l=0.332415 //layer=ply \
 //thickness=0.18 //x=56.47 //y=5.045 //x2=56.73 //y2=4.88
r706 (  203 240 ) resistor r=45.1352 //w=0.168 //l=0.173853 //layer=ply \
 //thickness=0.18 //x=42.82 //y=1.44 //x2=42.78 //y2=1.595
r707 (  202 239 ) resistor r=45.1352 //w=0.168 //l=0.173853 //layer=ply \
 //thickness=0.18 //x=42.82 //y=1.095 //x2=42.78 //y2=0.94
r708 (  202 203 ) resistor r=176.904 //w=0.094 //l=0.345 //layer=ply \
 //thickness=0.18 //x=42.82 //y=1.095 //x2=42.82 //y2=1.44
r709 (  200 236 ) resistor r=10.701 //w=0.21 //l=0.115 //layer=ply \
 //thickness=0.18 //x=42.445 //y=1.595 //x2=42.33 //y2=1.595
r710 (  199 240 ) resistor r=5.52526 //w=0.168 //l=0.115 //layer=ply \
 //thickness=0.18 //x=42.665 //y=1.595 //x2=42.78 //y2=1.595
r711 (  198 235 ) resistor r=5.52526 //w=0.168 //l=0.115 //layer=ply \
 //thickness=0.18 //x=42.445 //y=0.94 //x2=42.33 //y2=0.94
r712 (  197 239 ) resistor r=5.52526 //w=0.168 //l=0.115 //layer=ply \
 //thickness=0.18 //x=42.665 //y=0.94 //x2=42.78 //y2=0.94
r713 (  197 198 ) resistor r=112.809 //w=0.094 //l=0.22 //layer=ply \
 //thickness=0.18 //x=42.665 //y=0.94 //x2=42.445 //y2=0.94
r714 (  194 238 ) resistor r=37.236 //w=0.233 //l=0.249199 //layer=ply \
 //thickness=0.18 //x=42.48 //y=5.045 //x2=42.3 //y2=4.88
r715 (  192 236 ) resistor r=39.5823 //w=0.21 //l=0.173853 //layer=ply \
 //thickness=0.18 //x=42.29 //y=1.75 //x2=42.33 //y2=1.595
r716 (  192 233 ) resistor r=176.904 //w=0.094 //l=0.345 //layer=ply \
 //thickness=0.18 //x=42.29 //y=1.75 //x2=42.29 //y2=2.095
r717 (  191 236 ) resistor r=39.5823 //w=0.21 //l=0.173853 //layer=ply \
 //thickness=0.18 //x=42.29 //y=1.44 //x2=42.33 //y2=1.595
r718 (  190 235 ) resistor r=45.1352 //w=0.168 //l=0.173853 //layer=ply \
 //thickness=0.18 //x=42.29 //y=1.095 //x2=42.33 //y2=0.94
r719 (  190 191 ) resistor r=176.904 //w=0.094 //l=0.345 //layer=ply \
 //thickness=0.18 //x=42.29 //y=1.095 //x2=42.29 //y2=1.44
r720 (  187 238 ) resistor r=53.7854 //w=0.233 //l=0.332415 //layer=ply \
 //thickness=0.18 //x=42.04 //y=5.045 //x2=42.3 //y2=4.88
r721 (  186 230 ) resistor r=45.1352 //w=0.168 //l=0.173853 //layer=ply \
 //thickness=0.18 //x=38.01 //y=1.44 //x2=37.97 //y2=1.595
r722 (  185 229 ) resistor r=45.1352 //w=0.168 //l=0.173853 //layer=ply \
 //thickness=0.18 //x=38.01 //y=1.095 //x2=37.97 //y2=0.94
r723 (  185 186 ) resistor r=176.904 //w=0.094 //l=0.345 //layer=ply \
 //thickness=0.18 //x=38.01 //y=1.095 //x2=38.01 //y2=1.44
r724 (  183 226 ) resistor r=10.701 //w=0.21 //l=0.115 //layer=ply \
 //thickness=0.18 //x=37.635 //y=1.595 //x2=37.52 //y2=1.595
r725 (  182 230 ) resistor r=5.52526 //w=0.168 //l=0.115 //layer=ply \
 //thickness=0.18 //x=37.855 //y=1.595 //x2=37.97 //y2=1.595
r726 (  181 225 ) resistor r=5.52526 //w=0.168 //l=0.115 //layer=ply \
 //thickness=0.18 //x=37.635 //y=0.94 //x2=37.52 //y2=0.94
r727 (  180 229 ) resistor r=5.52526 //w=0.168 //l=0.115 //layer=ply \
 //thickness=0.18 //x=37.855 //y=0.94 //x2=37.97 //y2=0.94
r728 (  180 181 ) resistor r=112.809 //w=0.094 //l=0.22 //layer=ply \
 //thickness=0.18 //x=37.855 //y=0.94 //x2=37.635 //y2=0.94
r729 (  177 228 ) resistor r=37.236 //w=0.233 //l=0.249199 //layer=ply \
 //thickness=0.18 //x=37.67 //y=5.045 //x2=37.49 //y2=4.88
r730 (  175 226 ) resistor r=39.5823 //w=0.21 //l=0.173853 //layer=ply \
 //thickness=0.18 //x=37.48 //y=1.75 //x2=37.52 //y2=1.595
r731 (  175 223 ) resistor r=176.904 //w=0.094 //l=0.345 //layer=ply \
 //thickness=0.18 //x=37.48 //y=1.75 //x2=37.48 //y2=2.095
r732 (  174 226 ) resistor r=39.5823 //w=0.21 //l=0.173853 //layer=ply \
 //thickness=0.18 //x=37.48 //y=1.44 //x2=37.52 //y2=1.595
r733 (  173 225 ) resistor r=45.1352 //w=0.168 //l=0.173853 //layer=ply \
 //thickness=0.18 //x=37.48 //y=1.095 //x2=37.52 //y2=0.94
r734 (  173 174 ) resistor r=176.904 //w=0.094 //l=0.345 //layer=ply \
 //thickness=0.18 //x=37.48 //y=1.095 //x2=37.48 //y2=1.44
r735 (  170 228 ) resistor r=53.7854 //w=0.233 //l=0.332415 //layer=ply \
 //thickness=0.18 //x=37.23 //y=5.045 //x2=37.49 //y2=4.88
r736 (  169 211 ) resistor r=592.245 //w=0.094 //l=1.155 //layer=ply \
 //thickness=0.18 //x=56.91 //y=6.2 //x2=56.91 //y2=5.045
r737 (  168 204 ) resistor r=592.245 //w=0.094 //l=1.155 //layer=ply \
 //thickness=0.18 //x=56.47 //y=6.2 //x2=56.47 //y2=5.045
r738 (  167 194 ) resistor r=592.245 //w=0.094 //l=1.155 //layer=ply \
 //thickness=0.18 //x=42.48 //y=6.2 //x2=42.48 //y2=5.045
r739 (  166 187 ) resistor r=592.245 //w=0.094 //l=1.155 //layer=ply \
 //thickness=0.18 //x=42.04 //y=6.2 //x2=42.04 //y2=5.045
r740 (  165 177 ) resistor r=592.245 //w=0.094 //l=1.155 //layer=ply \
 //thickness=0.18 //x=37.67 //y=6.2 //x2=37.67 //y2=5.045
r741 (  164 170 ) resistor r=592.245 //w=0.094 //l=1.155 //layer=ply \
 //thickness=0.18 //x=37.23 //y=6.2 //x2=37.23 //y2=5.045
r742 (  163 216 ) resistor r=56.4043 //w=0.094 //l=0.11 //layer=ply \
 //thickness=0.18 //x=56.985 //y=1.595 //x2=57.095 //y2=1.595
r743 (  163 217 ) resistor r=56.4043 //w=0.094 //l=0.11 //layer=ply \
 //thickness=0.18 //x=56.985 //y=1.595 //x2=56.875 //y2=1.595
r744 (  162 199 ) resistor r=56.4043 //w=0.094 //l=0.11 //layer=ply \
 //thickness=0.18 //x=42.555 //y=1.595 //x2=42.665 //y2=1.595
r745 (  162 200 ) resistor r=56.4043 //w=0.094 //l=0.11 //layer=ply \
 //thickness=0.18 //x=42.555 //y=1.595 //x2=42.445 //y2=1.595
r746 (  161 182 ) resistor r=56.4043 //w=0.094 //l=0.11 //layer=ply \
 //thickness=0.18 //x=37.745 //y=1.595 //x2=37.855 //y2=1.595
r747 (  161 183 ) resistor r=56.4043 //w=0.094 //l=0.11 //layer=ply \
 //thickness=0.18 //x=37.745 //y=1.595 //x2=37.635 //y2=1.595
r748 (  157 248 ) resistor r=152 //w=0.17 //l=0.17 //layer=licon //count=1 \
 //x=56.73 //y=4.88 //x2=56.73 //y2=4.88
r749 (  148 242 ) resistor r=152 //w=0.17 //l=0.17 //layer=licon //count=1 \
 //x=56.73 //y=2.26 //x2=56.73 //y2=2.26
r750 (  131 255 ) resistor r=23.615 //w=0.187 //l=0.345 //layer=li \
 //thickness=0.1 //x=47.07 //y=5.56 //x2=47.07 //y2=5.905
r751 (  123 254 ) resistor r=23.615 //w=0.187 //l=0.345 //layer=li \
 //thickness=0.1 //x=46.19 //y=5.56 //x2=46.19 //y2=5.905
r752 (  115 253 ) resistor r=23.615 //w=0.187 //l=0.345 //layer=li \
 //thickness=0.1 //x=45.31 //y=5.56 //x2=45.31 //y2=5.905
r753 (  110 238 ) resistor r=152 //w=0.17 //l=0.17 //layer=licon //count=1 \
 //x=42.3 //y=4.88 //x2=42.3 //y2=4.88
r754 (  101 232 ) resistor r=152 //w=0.17 //l=0.17 //layer=licon //count=1 \
 //x=42.3 //y=2.26 //x2=42.3 //y2=2.26
r755 (  96 228 ) resistor r=152 //w=0.17 //l=0.17 //layer=licon //count=1 \
 //x=37.49 //y=4.88 //x2=37.49 //y2=4.88
r756 (  87 222 ) resistor r=152 //w=0.17 //l=0.17 //layer=licon //count=1 \
 //x=37.49 //y=2.26 //x2=37.49 //y2=2.26
r757 (  79 81 ) resistor r=0.10734 //w=0.281 //l=0.16 //layer=m2 \
 //thickness=0.36 //x=42.3 //y=3.895 //x2=42.46 //y2=3.895
r758 (  79 80 ) resistor r=0.10734 //w=0.281 //l=0.16 //layer=m2 \
 //thickness=0.36 //x=42.3 //y=3.895 //x2=42.14 //y2=3.895
r759 (  77 80 ) resistor r=4.28435 //w=0.131 //l=4.49 //layer=m2 \
 //thickness=0.36 //x=37.65 //y=3.88 //x2=42.14 //y2=3.88
r760 (  75 77 ) resistor r=0.10734 //w=0.281 //l=0.16 //layer=m2 \
 //thickness=0.36 //x=37.49 //y=3.895 //x2=37.65 //y2=3.895
r761 (  73 83 ) resistor r=1.10266 //w=0.196 //l=1.725 //layer=m2 \
 //thickness=0.36 //x=49.565 //y=3.895 //x2=47.84 //y2=3.895
r762 (  72 85 ) resistor r=4.81638 //w=0.177 //l=6.825 //layer=m2 \
 //thickness=0.36 //x=49.91 //y=3.895 //x2=56.73 //y2=3.885
r763 (  72 73 ) resistor r=0.329198 //w=0.131 //l=0.345 //layer=m2 \
 //thickness=0.36 //x=49.91 //y=3.895 //x2=49.565 //y2=3.895
r764 (  70 83 ) resistor r=0.104578 //w=0.196 //l=0.167332 //layer=m2 \
 //thickness=0.36 //x=47.68 //y=3.88 //x2=47.84 //y2=3.895
r765 (  70 81 ) resistor r=4.98092 //w=0.131 //l=5.22 //layer=m2 \
 //thickness=0.36 //x=47.68 //y=3.88 //x2=42.46 //y2=3.88
r766 (  67 157 ) resistor r=9.3 //w=0.17 //l=0.17 //layer=mcon //count=1 \
 //x=56.73 //y=4.88 //x2=56.73 //y2=4.88
r767 (  65 148 ) resistor r=9.3 //w=0.17 //l=0.17 //layer=mcon //count=1 \
 //x=56.73 //y=2.26 //x2=56.73 //y2=2.26
r768 (  63 85 ) resistor r=4.5 //w=0.15 //l=0.15 //layer=via1 //count=1 \
 //x=56.73 //y=3.885 //x2=56.73 //y2=3.885
r769 (  61 63 ) resistor r=0.00166223 //w=0.376 //l=0.005 //layer=m1 \
 //thickness=0.36 //x=56.677 //y=3.88 //x2=56.677 //y2=3.885
r770 (  59 83 ) resistor r=4.5 //w=0.15 //l=0.15 //layer=via1 //count=1 \
 //x=47.84 //y=3.895 //x2=47.84 //y2=3.895
r771 (  57 59 ) resistor r=0.00490838 //w=0.382 //l=0.015 //layer=m1 \
 //thickness=0.36 //x=47.897 //y=3.88 //x2=47.897 //y2=3.895
r772 (  55 251 ) resistor r=9.3 //w=0.17 //l=0.17 //layer=mcon //count=1 \
 //x=47.365 //y=1.19 //x2=47.365 //y2=1.19
r773 (  53 131 ) resistor r=9.3 //w=0.17 //l=0.17 //layer=mcon //count=1 \
 //x=47.07 //y=5.56 //x2=47.07 //y2=5.56
r774 (  50 123 ) resistor r=9.3 //w=0.17 //l=0.17 //layer=mcon //count=1 \
 //x=46.19 //y=5.56 //x2=46.19 //y2=5.56
r775 (  48 50 ) resistor r=0.121228 //w=0.232 //l=0.225 //layer=m1 \
 //thickness=0.36 //x=46.19 //y=5.335 //x2=46.19 //y2=5.56
r776 (  47 115 ) resistor r=9.3 //w=0.17 //l=0.17 //layer=mcon //count=1 \
 //x=45.31 //y=5.56 //x2=45.31 //y2=5.56
r777 (  45 47 ) resistor r=0.129608 //w=0.217 //l=0.225 //layer=m1 \
 //thickness=0.36 //x=45.312 //y=5.335 //x2=45.312 //y2=5.56
r778 (  44 110 ) resistor r=9.3 //w=0.17 //l=0.17 //layer=mcon //count=1 \
 //x=42.3 //y=4.88 //x2=42.3 //y2=4.88
r779 (  42 101 ) resistor r=9.3 //w=0.17 //l=0.17 //layer=mcon //count=1 \
 //x=42.3 //y=2.26 //x2=42.3 //y2=2.26
r780 (  40 79 ) resistor r=4.5 //w=0.15 //l=0.15 //layer=via1 //count=1 \
 //x=42.3 //y=3.895 //x2=42.3 //y2=3.895
r781 (  38 40 ) resistor r=0.0049867 //w=0.376 //l=0.015 //layer=m1 \
 //thickness=0.36 //x=42.247 //y=3.88 //x2=42.247 //y2=3.895
r782 (  36 75 ) resistor r=4.5 //w=0.15 //l=0.15 //layer=via1 //count=1 \
 //x=37.49 //y=3.895 //x2=37.49 //y2=3.895
r783 (  34 36 ) resistor r=0.0049867 //w=0.376 //l=0.015 //layer=m1 \
 //thickness=0.36 //x=37.542 //y=3.88 //x2=37.542 //y2=3.895
r784 (  32 96 ) resistor r=9.3 //w=0.17 //l=0.17 //layer=mcon //count=1 \
 //x=37.49 //y=4.88 //x2=37.49 //y2=4.88
r785 (  30 87 ) resistor r=9.3 //w=0.17 //l=0.17 //layer=mcon //count=1 \
 //x=37.49 //y=2.26 //x2=37.49 //y2=2.26
r786 (  28 67 ) resistor r=0.0801089 //w=0.224 //l=0.13 //layer=m1 \
 //thickness=0.36 //x=56.73 //y=4.75 //x2=56.73 //y2=4.88
r787 (  27 63 ) resistor r=0.0911593 //w=0.376 //l=0.184608 //layer=m1 \
 //thickness=0.36 //x=56.73 //y=4.045 //x2=56.677 //y2=3.885
r788 (  27 28 ) resistor r=0.67271 //w=0.131 //l=0.705 //layer=m1 \
 //thickness=0.36 //x=56.73 //y=4.045 //x2=56.73 //y2=4.75
r789 (  26 61 ) resistor r=0.0894971 //w=0.376 //l=0.179555 //layer=m1 \
 //thickness=0.36 //x=56.73 //y=3.725 //x2=56.677 //y2=3.88
r790 (  25 65 ) resistor r=0.0719237 //w=0.222 //l=0.115 //layer=m1 \
 //thickness=0.36 //x=56.73 //y=2.375 //x2=56.73 //y2=2.26
r791 (  25 26 ) resistor r=1.28817 //w=0.131 //l=1.35 //layer=m1 \
 //thickness=0.36 //x=56.73 //y=2.375 //x2=56.73 //y2=3.725
r792 (  23 59 ) resistor r=0.0914072 //w=0.382 //l=0.181989 //layer=m1 \
 //thickness=0.36 //x=47.85 //y=4.055 //x2=47.897 //y2=3.895
r793 (  23 24 ) resistor r=1.14027 //w=0.131 //l=1.195 //layer=m1 \
 //thickness=0.36 //x=47.85 //y=4.055 //x2=47.85 //y2=5.25
r794 (  22 57 ) resistor r=0.0864989 //w=0.382 //l=0.166853 //layer=m1 \
 //thickness=0.36 //x=47.85 //y=3.735 //x2=47.897 //y2=3.88
r795 (  21 22 ) resistor r=1.72233 //w=0.131 //l=1.805 //layer=m1 \
 //thickness=0.36 //x=47.85 //y=1.93 //x2=47.85 //y2=3.735
r796 (  19 21 ) resistor r=0.0698411 //w=0.17 //l=0.120208 //layer=m1 \
 //thickness=0.36 //x=47.765 //y=1.845 //x2=47.85 //y2=1.93
r797 (  19 20 ) resistor r=0.300573 //w=0.131 //l=0.315 //layer=m1 \
 //thickness=0.36 //x=47.765 //y=1.845 //x2=47.45 //y2=1.845
r798 (  18 20 ) resistor r=0.0698411 //w=0.17 //l=0.120208 //layer=m1 \
 //thickness=0.36 //x=47.365 //y=1.76 //x2=47.45 //y2=1.845
r799 (  17 55 ) resistor r=0.0717383 //w=0.224 //l=0.115 //layer=m1 \
 //thickness=0.36 //x=47.365 //y=1.305 //x2=47.365 //y2=1.19
r800 (  17 18 ) resistor r=0.43416 //w=0.131 //l=0.455 //layer=m1 \
 //thickness=0.36 //x=47.365 //y=1.305 //x2=47.365 //y2=1.76
r801 (  16 51 ) resistor r=0.0675342 //w=0.23 //l=0.115 //layer=m1 \
 //thickness=0.36 //x=47.185 //y=5.335 //x2=47.07 //y2=5.335
r802 (  15 24 ) resistor r=0.0698411 //w=0.17 //l=0.120208 //layer=m1 \
 //thickness=0.36 //x=47.765 //y=5.335 //x2=47.85 //y2=5.25
r803 (  15 16 ) resistor r=0.553435 //w=0.131 //l=0.58 //layer=m1 \
 //thickness=0.36 //x=47.765 //y=5.335 //x2=47.185 //y2=5.335
r804 (  14 53 ) resistor r=0.00118313 //w=0.23 //layer=m1 //thickness=0.36 \
 //x=47.07 //y=5.56 //x2=47.07 //y2=5.56
r805 (  13 51 ) resistor r=0.002872 //w=0.34 //l=0.085 //layer=m1 \
 //thickness=0.36 //x=47.07 //y=5.42 //x2=47.07 //y2=5.335
r806 (  13 14 ) resistor r=0.091623 //w=0.191 //l=0.14 //layer=m1 \
 //thickness=0.36 //x=47.07 //y=5.42 //x2=47.07 //y2=5.56
r807 (  12 48 ) resistor r=0.0262263 //w=0.232 //l=0.12 //layer=m1 \
 //thickness=0.36 //x=46.31 //y=5.335 //x2=46.19 //y2=5.335
r808 (  11 51 ) resistor r=0.0675342 //w=0.23 //l=0.115 //layer=m1 \
 //thickness=0.36 //x=46.955 //y=5.335 //x2=47.07 //y2=5.335
r809 (  11 12 ) resistor r=0.615458 //w=0.131 //l=0.645 //layer=m1 \
 //thickness=0.36 //x=46.955 //y=5.335 //x2=46.31 //y2=5.335
r810 (  10 45 ) resistor r=0.0222262 //w=0.217 //l=0.118 //layer=m1 \
 //thickness=0.36 //x=45.43 //y=5.335 //x2=45.312 //y2=5.335
r811 (  9 48 ) resistor r=0.0262263 //w=0.232 //l=0.12 //layer=m1 \
 //thickness=0.36 //x=46.07 //y=5.335 //x2=46.19 //y2=5.335
r812 (  9 10 ) resistor r=0.610687 //w=0.131 //l=0.64 //layer=m1 \
 //thickness=0.36 //x=46.07 //y=5.335 //x2=45.43 //y2=5.335
r813 (  8 44 ) resistor r=0.0801089 //w=0.224 //l=0.13 //layer=m1 \
 //thickness=0.36 //x=42.3 //y=4.75 //x2=42.3 //y2=4.88
r814 (  7 40 ) resistor r=0.0911593 //w=0.376 //l=0.184608 //layer=m1 \
 //thickness=0.36 //x=42.3 //y=4.055 //x2=42.247 //y2=3.895
r815 (  7 8 ) resistor r=0.663168 //w=0.131 //l=0.695 //layer=m1 \
 //thickness=0.36 //x=42.3 //y=4.055 //x2=42.3 //y2=4.75
r816 (  6 38 ) resistor r=0.0861726 //w=0.376 //l=0.16944 //layer=m1 \
 //thickness=0.36 //x=42.3 //y=3.735 //x2=42.247 //y2=3.88
r817 (  5 42 ) resistor r=0.0719237 //w=0.222 //l=0.115 //layer=m1 \
 //thickness=0.36 //x=42.3 //y=2.375 //x2=42.3 //y2=2.26
r818 (  5 6 ) resistor r=1.29771 //w=0.131 //l=1.36 //layer=m1 \
 //thickness=0.36 //x=42.3 //y=2.375 //x2=42.3 //y2=3.735
r819 (  4 32 ) resistor r=0.0801089 //w=0.224 //l=0.13 //layer=m1 \
 //thickness=0.36 //x=37.49 //y=4.75 //x2=37.49 //y2=4.88
r820 (  3 36 ) resistor r=0.0911593 //w=0.376 //l=0.184174 //layer=m1 \
 //thickness=0.36 //x=37.49 //y=4.055 //x2=37.542 //y2=3.895
r821 (  3 4 ) resistor r=0.663168 //w=0.131 //l=0.695 //layer=m1 \
 //thickness=0.36 //x=37.49 //y=4.055 //x2=37.49 //y2=4.75
r822 (  2 34 ) resistor r=0.0861726 //w=0.376 //l=0.169012 //layer=m1 \
 //thickness=0.36 //x=37.49 //y=3.735 //x2=37.542 //y2=3.88
r823 (  1 30 ) resistor r=0.0719237 //w=0.222 //l=0.115 //layer=m1 \
 //thickness=0.36 //x=37.49 //y=2.375 //x2=37.49 //y2=2.26
r824 (  1 2 ) resistor r=1.29771 //w=0.131 //l=1.36 //layer=m1 \
 //thickness=0.36 //x=37.49 //y=2.375 //x2=37.49 //y2=3.735
ends PM_TMRDFFSNRNQX1\%noxref_11

subckt PM_TMRDFFSNRNQX1\%D ( 1 2 3 4 5 6 7 8 9 10 11 12 13 14 15 22 23 25 30 \
 31 32 36 37 61 63 65 67 69 71 73 75 76 77 79 81 83 85 90 96 105 110 119 124 \
 133 137 138 139 140 141 142 143 144 145 146 147 148 149 150 152 158 159 160 \
 161 165 166 167 168 169 171 177 178 179 180 184 185 186 187 188 190 196 197 \
 198 199 )
c553 ( 199 0 ) capacitor c=0.0571309f //x=59.595 //y=4.97
c554 ( 198 0 ) capacitor c=0.0376642f //x=59.885 //y=4.97
c555 ( 197 0 ) capacitor c=0.0346489f //x=59.55 //y=1.4
c556 ( 196 0 ) capacitor c=0.018692f //x=59.55 //y=1.055
c557 ( 190 0 ) capacitor c=0.0137077f //x=59.395 //y=1.555
c558 ( 188 0 ) capacitor c=0.0158585f //x=59.395 //y=0.9
c559 ( 187 0 ) capacitor c=0.103534f //x=59.02 //y=2.095
c560 ( 186 0 ) capacitor c=0.0229444f //x=59.02 //y=1.71
c561 ( 185 0 ) capacitor c=0.0234359f //x=59.02 //y=1.4
c562 ( 184 0 ) capacitor c=0.019815f //x=59.02 //y=1.055
c563 ( 180 0 ) capacitor c=0.0553397f //x=30.735 //y=4.97
c564 ( 179 0 ) capacitor c=0.0376642f //x=31.025 //y=4.97
c565 ( 178 0 ) capacitor c=0.0346489f //x=30.69 //y=1.4
c566 ( 177 0 ) capacitor c=0.018692f //x=30.69 //y=1.055
c567 ( 171 0 ) capacitor c=0.0137077f //x=30.535 //y=1.555
c568 ( 169 0 ) capacitor c=0.0158585f //x=30.535 //y=0.9
c569 ( 168 0 ) capacitor c=0.103534f //x=30.16 //y=2.095
c570 ( 167 0 ) capacitor c=0.0229444f //x=30.16 //y=1.71
c571 ( 166 0 ) capacitor c=0.0234359f //x=30.16 //y=1.4
c572 ( 165 0 ) capacitor c=0.019815f //x=30.16 //y=1.055
c573 ( 161 0 ) capacitor c=0.0571068f //x=1.875 //y=4.97
c574 ( 160 0 ) capacitor c=0.0376642f //x=2.165 //y=4.97
c575 ( 159 0 ) capacitor c=0.0346489f //x=1.83 //y=1.4
c576 ( 158 0 ) capacitor c=0.018692f //x=1.83 //y=1.055
c577 ( 152 0 ) capacitor c=0.0137077f //x=1.675 //y=1.555
c578 ( 150 0 ) capacitor c=0.0158585f //x=1.675 //y=0.9
c579 ( 149 0 ) capacitor c=0.103534f //x=1.3 //y=2.095
c580 ( 148 0 ) capacitor c=0.0229444f //x=1.3 //y=1.71
c581 ( 147 0 ) capacitor c=0.0234359f //x=1.3 //y=1.4
c582 ( 146 0 ) capacitor c=0.019815f //x=1.3 //y=1.055
c583 ( 145 0 ) capacitor c=0.110208f //x=59.96 //y=6.2
c584 ( 144 0 ) capacitor c=0.158957f //x=59.52 //y=6.2
c585 ( 143 0 ) capacitor c=0.110208f //x=31.1 //y=6.2
c586 ( 142 0 ) capacitor c=0.158957f //x=30.66 //y=6.2
c587 ( 141 0 ) capacitor c=0.110208f //x=2.24 //y=6.2
c588 ( 140 0 ) capacitor c=0.158957f //x=1.8 //y=6.2
c589 ( 133 0 ) capacitor c=0.00135387f //x=59.32 //y=4.88
c590 ( 124 0 ) capacitor c=0.0012618f //x=59.32 //y=2.26
c591 ( 119 0 ) capacitor c=0.00132168f //x=30.46 //y=4.88
c592 ( 110 0 ) capacitor c=0.0012618f //x=30.46 //y=2.26
c593 ( 105 0 ) capacitor c=0.00120653f //x=1.6 //y=4.88
c594 ( 96 0 ) capacitor c=0.0012618f //x=1.6 //y=2.26
c595 ( 90 0 ) capacitor c=0.0117734f //x=1.76 //y=4.26
c596 ( 85 0 ) capacitor c=0.0259999f //x=56.945 //y=4.27
c597 ( 83 0 ) capacitor c=0.0806608f //x=56.345 //y=4.25
c598 ( 81 0 ) capacitor c=0.00430603f //x=48.055 //y=4.28
c599 ( 79 0 ) capacitor c=0.0480868f //x=47.455 //y=4.25
c600 ( 77 0 ) capacitor c=0.00480596f //x=42.595 //y=4.3
c601 ( 76 0 ) capacitor c=0.114658f //x=37.36 //y=4.28
c602 ( 75 0 ) capacitor c=0.0435675f //x=37.705 //y=4.28
c603 ( 73 0 ) capacitor c=0.00155499f //x=28.085 //y=4.27
c604 ( 71 0 ) capacitor c=0.082117f //x=27.485 //y=4.25
c605 ( 69 0 ) capacitor c=0.00430603f //x=19.195 //y=4.28
c606 ( 67 0 ) capacitor c=0.0486924f //x=18.595 //y=4.25
c607 ( 65 0 ) capacitor c=0.00434239f //x=13.655 //y=4.31
c608 ( 63 0 ) capacitor c=0.045907f //x=8.845 //y=4.28
c609 ( 61 0 ) capacitor c=0.182353f //x=8.245 //y=4.25
c610 ( 37 0 ) capacitor c=0.0113035f //x=59.32 //y=4.755
c611 ( 36 0 ) capacitor c=0.0128489f //x=59.32 //y=4.41
c612 ( 32 0 ) capacitor c=0.00493485f //x=59.32 //y=2.375
c613 ( 31 0 ) capacitor c=0.0116887f //x=30.46 //y=4.755
c614 ( 30 0 ) capacitor c=0.0125206f //x=30.46 //y=4.395
c615 ( 25 0 ) capacitor c=0.00493485f //x=30.46 //y=2.375
c616 ( 23 0 ) capacitor c=0.0109328f //x=1.6 //y=4.755
c617 ( 22 0 ) capacitor c=0.0204476f //x=1.6 //y=4.42
c618 ( 15 0 ) capacitor c=0.0113096f //x=1.6 //y=2.375
c619 ( 14 0 ) capacitor c=0.0146142f //x=59.32 //y=4.25
c620 ( 13 0 ) capacitor c=0.0148084f //x=30.46 //y=4.25
c621 ( 12 0 ) capacitor c=0.0158351f //x=1.6 //y=4.25
c622 ( 10 0 ) capacitor c=0.0498201f //x=59.32 //y=2.77
c623 ( 7 0 ) capacitor c=0.0516154f //x=30.46 //y=2.77
c624 ( 6 0 ) capacitor c=0.0128805f //x=1.6 //y=4.62
c625 ( 1 0 ) capacitor c=0.0854947f //x=1.6 //y=2.4
r626 (  198 200 ) resistor r=26.9307 //w=0.15 //l=0.106066 //layer=ply \
 //thickness=0.18 //x=59.885 //y=4.97 //x2=59.96 //y2=5.045
r627 (  198 199 ) resistor r=148.702 //w=0.094 //l=0.29 //layer=ply \
 //thickness=0.18 //x=59.885 //y=4.97 //x2=59.595 //y2=4.97
r628 (  197 226 ) resistor r=45.1352 //w=0.168 //l=0.173853 //layer=ply \
 //thickness=0.18 //x=59.55 //y=1.4 //x2=59.51 //y2=1.555
r629 (  196 225 ) resistor r=45.1352 //w=0.168 //l=0.173853 //layer=ply \
 //thickness=0.18 //x=59.55 //y=1.055 //x2=59.51 //y2=0.9
r630 (  196 197 ) resistor r=176.904 //w=0.094 //l=0.345 //layer=ply \
 //thickness=0.18 //x=59.55 //y=1.055 //x2=59.55 //y2=1.4
r631 (  193 199 ) resistor r=22.7971 //w=0.269 //l=0.106066 //layer=ply \
 //thickness=0.18 //x=59.52 //y=5.045 //x2=59.595 //y2=4.97
r632 (  193 224 ) resistor r=35.8364 //w=0.269 //l=0.270185 //layer=ply \
 //thickness=0.18 //x=59.52 //y=5.045 //x2=59.32 //y2=4.88
r633 (  191 220 ) resistor r=10.701 //w=0.21 //l=0.115 //layer=ply \
 //thickness=0.18 //x=59.175 //y=1.555 //x2=59.06 //y2=1.555
r634 (  190 226 ) resistor r=5.52526 //w=0.168 //l=0.115 //layer=ply \
 //thickness=0.18 //x=59.395 //y=1.555 //x2=59.51 //y2=1.555
r635 (  189 219 ) resistor r=5.52526 //w=0.168 //l=0.115 //layer=ply \
 //thickness=0.18 //x=59.175 //y=0.9 //x2=59.06 //y2=0.9
r636 (  188 225 ) resistor r=5.52526 //w=0.168 //l=0.115 //layer=ply \
 //thickness=0.18 //x=59.395 //y=0.9 //x2=59.51 //y2=0.9
r637 (  188 189 ) resistor r=112.809 //w=0.094 //l=0.22 //layer=ply \
 //thickness=0.18 //x=59.395 //y=0.9 //x2=59.175 //y2=0.9
r638 (  187 222 ) resistor r=58.7805 //w=0.246 //l=0.373497 //layer=ply \
 //thickness=0.18 //x=59.02 //y=2.095 //x2=59.32 //y2=2.26
r639 (  186 220 ) resistor r=39.5823 //w=0.21 //l=0.173853 //layer=ply \
 //thickness=0.18 //x=59.02 //y=1.71 //x2=59.06 //y2=1.555
r640 (  186 187 ) resistor r=197.415 //w=0.094 //l=0.385 //layer=ply \
 //thickness=0.18 //x=59.02 //y=1.71 //x2=59.02 //y2=2.095
r641 (  185 220 ) resistor r=39.5823 //w=0.21 //l=0.173853 //layer=ply \
 //thickness=0.18 //x=59.02 //y=1.4 //x2=59.06 //y2=1.555
r642 (  184 219 ) resistor r=45.1352 //w=0.168 //l=0.173853 //layer=ply \
 //thickness=0.18 //x=59.02 //y=1.055 //x2=59.06 //y2=0.9
r643 (  184 185 ) resistor r=176.904 //w=0.094 //l=0.345 //layer=ply \
 //thickness=0.18 //x=59.02 //y=1.055 //x2=59.02 //y2=1.4
r644 (  179 181 ) resistor r=26.9307 //w=0.15 //l=0.106066 //layer=ply \
 //thickness=0.18 //x=31.025 //y=4.97 //x2=31.1 //y2=5.045
r645 (  179 180 ) resistor r=148.702 //w=0.094 //l=0.29 //layer=ply \
 //thickness=0.18 //x=31.025 //y=4.97 //x2=30.735 //y2=4.97
r646 (  178 218 ) resistor r=45.1352 //w=0.168 //l=0.173853 //layer=ply \
 //thickness=0.18 //x=30.69 //y=1.4 //x2=30.65 //y2=1.555
r647 (  177 217 ) resistor r=45.1352 //w=0.168 //l=0.173853 //layer=ply \
 //thickness=0.18 //x=30.69 //y=1.055 //x2=30.65 //y2=0.9
r648 (  177 178 ) resistor r=176.904 //w=0.094 //l=0.345 //layer=ply \
 //thickness=0.18 //x=30.69 //y=1.055 //x2=30.69 //y2=1.4
r649 (  174 180 ) resistor r=22.7971 //w=0.269 //l=0.106066 //layer=ply \
 //thickness=0.18 //x=30.66 //y=5.045 //x2=30.735 //y2=4.97
r650 (  174 216 ) resistor r=35.8364 //w=0.269 //l=0.270185 //layer=ply \
 //thickness=0.18 //x=30.66 //y=5.045 //x2=30.46 //y2=4.88
r651 (  172 212 ) resistor r=10.701 //w=0.21 //l=0.115 //layer=ply \
 //thickness=0.18 //x=30.315 //y=1.555 //x2=30.2 //y2=1.555
r652 (  171 218 ) resistor r=5.52526 //w=0.168 //l=0.115 //layer=ply \
 //thickness=0.18 //x=30.535 //y=1.555 //x2=30.65 //y2=1.555
r653 (  170 211 ) resistor r=5.52526 //w=0.168 //l=0.115 //layer=ply \
 //thickness=0.18 //x=30.315 //y=0.9 //x2=30.2 //y2=0.9
r654 (  169 217 ) resistor r=5.52526 //w=0.168 //l=0.115 //layer=ply \
 //thickness=0.18 //x=30.535 //y=0.9 //x2=30.65 //y2=0.9
r655 (  169 170 ) resistor r=112.809 //w=0.094 //l=0.22 //layer=ply \
 //thickness=0.18 //x=30.535 //y=0.9 //x2=30.315 //y2=0.9
r656 (  168 214 ) resistor r=58.7805 //w=0.246 //l=0.373497 //layer=ply \
 //thickness=0.18 //x=30.16 //y=2.095 //x2=30.46 //y2=2.26
r657 (  167 212 ) resistor r=39.5823 //w=0.21 //l=0.173853 //layer=ply \
 //thickness=0.18 //x=30.16 //y=1.71 //x2=30.2 //y2=1.555
r658 (  167 168 ) resistor r=197.415 //w=0.094 //l=0.385 //layer=ply \
 //thickness=0.18 //x=30.16 //y=1.71 //x2=30.16 //y2=2.095
r659 (  166 212 ) resistor r=39.5823 //w=0.21 //l=0.173853 //layer=ply \
 //thickness=0.18 //x=30.16 //y=1.4 //x2=30.2 //y2=1.555
r660 (  165 211 ) resistor r=45.1352 //w=0.168 //l=0.173853 //layer=ply \
 //thickness=0.18 //x=30.16 //y=1.055 //x2=30.2 //y2=0.9
r661 (  165 166 ) resistor r=176.904 //w=0.094 //l=0.345 //layer=ply \
 //thickness=0.18 //x=30.16 //y=1.055 //x2=30.16 //y2=1.4
r662 (  160 162 ) resistor r=26.9307 //w=0.15 //l=0.106066 //layer=ply \
 //thickness=0.18 //x=2.165 //y=4.97 //x2=2.24 //y2=5.045
r663 (  160 161 ) resistor r=148.702 //w=0.094 //l=0.29 //layer=ply \
 //thickness=0.18 //x=2.165 //y=4.97 //x2=1.875 //y2=4.97
r664 (  159 210 ) resistor r=45.1352 //w=0.168 //l=0.173853 //layer=ply \
 //thickness=0.18 //x=1.83 //y=1.4 //x2=1.79 //y2=1.555
r665 (  158 209 ) resistor r=45.1352 //w=0.168 //l=0.173853 //layer=ply \
 //thickness=0.18 //x=1.83 //y=1.055 //x2=1.79 //y2=0.9
r666 (  158 159 ) resistor r=176.904 //w=0.094 //l=0.345 //layer=ply \
 //thickness=0.18 //x=1.83 //y=1.055 //x2=1.83 //y2=1.4
r667 (  155 161 ) resistor r=22.7971 //w=0.269 //l=0.106066 //layer=ply \
 //thickness=0.18 //x=1.8 //y=5.045 //x2=1.875 //y2=4.97
r668 (  155 208 ) resistor r=35.8364 //w=0.269 //l=0.270185 //layer=ply \
 //thickness=0.18 //x=1.8 //y=5.045 //x2=1.6 //y2=4.88
r669 (  153 204 ) resistor r=10.701 //w=0.21 //l=0.115 //layer=ply \
 //thickness=0.18 //x=1.455 //y=1.555 //x2=1.34 //y2=1.555
r670 (  152 210 ) resistor r=5.52526 //w=0.168 //l=0.115 //layer=ply \
 //thickness=0.18 //x=1.675 //y=1.555 //x2=1.79 //y2=1.555
r671 (  151 203 ) resistor r=5.52526 //w=0.168 //l=0.115 //layer=ply \
 //thickness=0.18 //x=1.455 //y=0.9 //x2=1.34 //y2=0.9
r672 (  150 209 ) resistor r=5.52526 //w=0.168 //l=0.115 //layer=ply \
 //thickness=0.18 //x=1.675 //y=0.9 //x2=1.79 //y2=0.9
r673 (  150 151 ) resistor r=112.809 //w=0.094 //l=0.22 //layer=ply \
 //thickness=0.18 //x=1.675 //y=0.9 //x2=1.455 //y2=0.9
r674 (  149 206 ) resistor r=58.7805 //w=0.246 //l=0.373497 //layer=ply \
 //thickness=0.18 //x=1.3 //y=2.095 //x2=1.6 //y2=2.26
r675 (  148 204 ) resistor r=39.5823 //w=0.21 //l=0.173853 //layer=ply \
 //thickness=0.18 //x=1.3 //y=1.71 //x2=1.34 //y2=1.555
r676 (  148 149 ) resistor r=197.415 //w=0.094 //l=0.385 //layer=ply \
 //thickness=0.18 //x=1.3 //y=1.71 //x2=1.3 //y2=2.095
r677 (  147 204 ) resistor r=39.5823 //w=0.21 //l=0.173853 //layer=ply \
 //thickness=0.18 //x=1.3 //y=1.4 //x2=1.34 //y2=1.555
r678 (  146 203 ) resistor r=45.1352 //w=0.168 //l=0.173853 //layer=ply \
 //thickness=0.18 //x=1.3 //y=1.055 //x2=1.34 //y2=0.9
r679 (  146 147 ) resistor r=176.904 //w=0.094 //l=0.345 //layer=ply \
 //thickness=0.18 //x=1.3 //y=1.055 //x2=1.3 //y2=1.4
r680 (  145 200 ) resistor r=592.245 //w=0.094 //l=1.155 //layer=ply \
 //thickness=0.18 //x=59.96 //y=6.2 //x2=59.96 //y2=5.045
r681 (  144 193 ) resistor r=592.245 //w=0.094 //l=1.155 //layer=ply \
 //thickness=0.18 //x=59.52 //y=6.2 //x2=59.52 //y2=5.045
r682 (  143 181 ) resistor r=592.245 //w=0.094 //l=1.155 //layer=ply \
 //thickness=0.18 //x=31.1 //y=6.2 //x2=31.1 //y2=5.045
r683 (  142 174 ) resistor r=592.245 //w=0.094 //l=1.155 //layer=ply \
 //thickness=0.18 //x=30.66 //y=6.2 //x2=30.66 //y2=5.045
r684 (  141 162 ) resistor r=592.245 //w=0.094 //l=1.155 //layer=ply \
 //thickness=0.18 //x=2.24 //y=6.2 //x2=2.24 //y2=5.045
r685 (  140 155 ) resistor r=592.245 //w=0.094 //l=1.155 //layer=ply \
 //thickness=0.18 //x=1.8 //y=6.2 //x2=1.8 //y2=5.045
r686 (  139 190 ) resistor r=56.4043 //w=0.094 //l=0.11 //layer=ply \
 //thickness=0.18 //x=59.285 //y=1.555 //x2=59.395 //y2=1.555
r687 (  139 191 ) resistor r=56.4043 //w=0.094 //l=0.11 //layer=ply \
 //thickness=0.18 //x=59.285 //y=1.555 //x2=59.175 //y2=1.555
r688 (  138 171 ) resistor r=56.4043 //w=0.094 //l=0.11 //layer=ply \
 //thickness=0.18 //x=30.425 //y=1.555 //x2=30.535 //y2=1.555
r689 (  138 172 ) resistor r=56.4043 //w=0.094 //l=0.11 //layer=ply \
 //thickness=0.18 //x=30.425 //y=1.555 //x2=30.315 //y2=1.555
r690 (  137 152 ) resistor r=56.4043 //w=0.094 //l=0.11 //layer=ply \
 //thickness=0.18 //x=1.565 //y=1.555 //x2=1.675 //y2=1.555
r691 (  137 153 ) resistor r=56.4043 //w=0.094 //l=0.11 //layer=ply \
 //thickness=0.18 //x=1.565 //y=1.555 //x2=1.455 //y2=1.555
r692 (  133 224 ) resistor r=152 //w=0.17 //l=0.17 //layer=licon //count=1 \
 //x=59.32 //y=4.88 //x2=59.32 //y2=4.88
r693 (  124 222 ) resistor r=152 //w=0.17 //l=0.17 //layer=licon //count=1 \
 //x=59.32 //y=2.26 //x2=59.32 //y2=2.26
r694 (  119 216 ) resistor r=152 //w=0.17 //l=0.17 //layer=licon //count=1 \
 //x=30.46 //y=4.88 //x2=30.46 //y2=4.88
r695 (  110 214 ) resistor r=152 //w=0.17 //l=0.17 //layer=licon //count=1 \
 //x=30.46 //y=2.26 //x2=30.46 //y2=2.26
r696 (  105 208 ) resistor r=152 //w=0.17 //l=0.17 //layer=licon //count=1 \
 //x=1.6 //y=4.88 //x2=1.6 //y2=4.88
r697 (  96 206 ) resistor r=152 //w=0.17 //l=0.17 //layer=licon //count=1 \
 //x=1.6 //y=2.26 //x2=1.6 //y2=2.26
r698 (  88 90 ) resistor r=0.10734 //w=0.281 //l=0.16 //layer=m2 \
 //thickness=0.36 //x=1.6 //y=4.26 //x2=1.76 //y2=4.26
r699 (  85 94 ) resistor r=1.5723 //w=0.189 //l=2.38498 //layer=m2 \
 //thickness=0.36 //x=56.945 //y=4.27 //x2=59.32 //y2=4.25
r700 (  85 86 ) resistor r=0.329198 //w=0.131 //l=0.345 //layer=m2 \
 //thickness=0.36 //x=56.945 //y=4.27 //x2=56.6 //y2=4.27
r701 (  83 86 ) resistor r=0.1875 //w=0.17 //l=0.264811 //layer=m2 \
 //thickness=0.36 //x=56.345 //y=4.25 //x2=56.6 //y2=4.27
r702 (  83 84 ) resistor r=7.74809 //w=0.131 //l=8.12 //layer=m2 \
 //thickness=0.36 //x=56.345 //y=4.25 //x2=48.225 //y2=4.25
r703 (  81 84 ) resistor r=0.125 //w=0.17 //l=0.184391 //layer=m2 \
 //thickness=0.36 //x=48.055 //y=4.28 //x2=48.225 //y2=4.25
r704 (  81 82 ) resistor r=0.329198 //w=0.131 //l=0.345 //layer=m2 \
 //thickness=0.36 //x=48.055 //y=4.28 //x2=47.71 //y2=4.28
r705 (  79 82 ) resistor r=0.1875 //w=0.17 //l=0.269583 //layer=m2 \
 //thickness=0.36 //x=47.455 //y=4.25 //x2=47.71 //y2=4.28
r706 (  79 80 ) resistor r=4.49905 //w=0.131 //l=4.715 //layer=m2 \
 //thickness=0.36 //x=47.455 //y=4.25 //x2=42.74 //y2=4.25
r707 (  77 80 ) resistor r=0.088848 //w=0.204 //l=0.168152 //layer=m2 \
 //thickness=0.36 //x=42.595 //y=4.3 //x2=42.74 //y2=4.25
r708 (  77 78 ) resistor r=0.736386 //w=0.101 //l=0.595 //layer=m2 \
 //thickness=0.36 //x=42.595 //y=4.3 //x2=42 //y2=4.3
r709 (  76 92 ) resistor r=4.89347 //w=0.176 //l=6.91246 //layer=m2 \
 //thickness=0.36 //x=37.36 //y=4.28 //x2=30.47 //y2=4.235
r710 (  75 78 ) resistor r=3.12137 //w=0.172 //l=4.30499 //layer=m2 \
 //thickness=0.36 //x=37.705 //y=4.28 //x2=42 //y2=4.3
r711 (  75 76 ) resistor r=0.329198 //w=0.131 //l=0.345 //layer=m2 \
 //thickness=0.36 //x=37.705 //y=4.28 //x2=37.36 //y2=4.28
r712 (  73 92 ) resistor r=1.69389 //w=0.176 //l=2.40244 //layer=m2 \
 //thickness=0.36 //x=28.085 //y=4.27 //x2=30.47 //y2=4.235
r713 (  73 74 ) resistor r=0.329198 //w=0.131 //l=0.345 //layer=m2 \
 //thickness=0.36 //x=28.085 //y=4.27 //x2=27.74 //y2=4.27
r714 (  71 74 ) resistor r=0.1875 //w=0.17 //l=0.264811 //layer=m2 \
 //thickness=0.36 //x=27.485 //y=4.25 //x2=27.74 //y2=4.27
r715 (  71 72 ) resistor r=7.74809 //w=0.131 //l=8.12 //layer=m2 \
 //thickness=0.36 //x=27.485 //y=4.25 //x2=19.365 //y2=4.25
r716 (  69 72 ) resistor r=0.125 //w=0.17 //l=0.184391 //layer=m2 \
 //thickness=0.36 //x=19.195 //y=4.28 //x2=19.365 //y2=4.25
r717 (  69 70 ) resistor r=0.329198 //w=0.131 //l=0.345 //layer=m2 \
 //thickness=0.36 //x=19.195 //y=4.28 //x2=18.85 //y2=4.28
r718 (  67 70 ) resistor r=0.1875 //w=0.17 //l=0.269583 //layer=m2 \
 //thickness=0.36 //x=18.595 //y=4.25 //x2=18.85 //y2=4.28
r719 (  67 68 ) resistor r=4.49905 //w=0.131 //l=4.715 //layer=m2 \
 //thickness=0.36 //x=18.595 //y=4.25 //x2=13.88 //y2=4.25
r720 (  65 68 ) resistor r=0.14881 //w=0.189 //l=0.253229 //layer=m2 \
 //thickness=0.36 //x=13.655 //y=4.31 //x2=13.88 //y2=4.25
r721 (  65 66 ) resistor r=0.329198 //w=0.131 //l=0.345 //layer=m2 \
 //thickness=0.36 //x=13.655 //y=4.31 //x2=13.31 //y2=4.31
r722 (  63 66 ) resistor r=3.26389 //w=0.171 //l=4.47998 //layer=m2 \
 //thickness=0.36 //x=8.845 //y=4.28 //x2=13.31 //y2=4.31
r723 (  63 64 ) resistor r=0.329198 //w=0.131 //l=0.345 //layer=m2 \
 //thickness=0.36 //x=8.845 //y=4.28 //x2=8.5 //y2=4.28
r724 (  61 64 ) resistor r=0.1875 //w=0.17 //l=0.269583 //layer=m2 \
 //thickness=0.36 //x=8.245 //y=4.25 //x2=8.5 //y2=4.28
r725 (  61 90 ) resistor r=6.18798 //w=0.131 //l=6.485 //layer=m2 \
 //thickness=0.36 //x=8.245 //y=4.25 //x2=1.76 //y2=4.25
r726 (  60 133 ) resistor r=9.3 //w=0.17 //l=0.17 //layer=mcon //count=1 \
 //x=59.32 //y=4.88 //x2=59.32 //y2=4.88
r727 (  58 124 ) resistor r=9.3 //w=0.17 //l=0.17 //layer=mcon //count=1 \
 //x=59.32 //y=2.26 //x2=59.32 //y2=2.26
r728 (  51 92 ) resistor r=4.5 //w=0.15 //l=0.15 //layer=via1 //count=1 \
 //x=30.47 //y=4.235 //x2=30.47 //y2=4.235
r729 (  49 119 ) resistor r=9.3 //w=0.17 //l=0.17 //layer=mcon //count=1 \
 //x=30.46 //y=4.88 //x2=30.46 //y2=4.88
r730 (  47 110 ) resistor r=9.3 //w=0.17 //l=0.17 //layer=mcon //count=1 \
 //x=30.46 //y=2.26 //x2=30.46 //y2=2.26
r731 (  45 105 ) resistor r=9.3 //w=0.17 //l=0.17 //layer=mcon //count=1 \
 //x=1.6 //y=4.88 //x2=1.6 //y2=4.88
r732 (  43 96 ) resistor r=9.3 //w=0.17 //l=0.17 //layer=mcon //count=1 \
 //x=1.6 //y=2.26 //x2=1.6 //y2=2.26
r733 (  41 88 ) resistor r=4.5 //w=0.15 //l=0.15 //layer=via1 //count=1 \
 //x=1.6 //y=4.26 //x2=1.6 //y2=4.26
r734 (  37 60 ) resistor r=0.0760407 //w=0.238 //l=0.125 //layer=m1 \
 //thickness=0.36 //x=59.32 //y=4.755 //x2=59.32 //y2=4.88
r735 (  36 37 ) resistor r=0.329198 //w=0.131 //l=0.345 //layer=m1 \
 //thickness=0.36 //x=59.32 //y=4.41 //x2=59.32 //y2=4.755
r736 (  32 58 ) resistor r=0.0719237 //w=0.222 //l=0.115 //layer=m1 \
 //thickness=0.36 //x=59.32 //y=2.375 //x2=59.32 //y2=2.26
r737 (  31 49 ) resistor r=0.0760407 //w=0.238 //l=0.125 //layer=m1 \
 //thickness=0.36 //x=30.46 //y=4.755 //x2=30.46 //y2=4.88
r738 (  30 31 ) resistor r=0.343511 //w=0.131 //l=0.36 //layer=m1 \
 //thickness=0.36 //x=30.46 //y=4.395 //x2=30.46 //y2=4.755
r739 (  26 51 ) resistor r=0.0909648 //w=0.371 //l=0.186333 //layer=m1 \
 //thickness=0.36 //x=30.46 //y=4.075 //x2=30.517 //y2=4.235
r740 (  25 47 ) resistor r=0.0719237 //w=0.222 //l=0.115 //layer=m1 \
 //thickness=0.36 //x=30.46 //y=2.375 //x2=30.46 //y2=2.26
r741 (  23 45 ) resistor r=0.0760407 //w=0.238 //l=0.125 //layer=m1 \
 //thickness=0.36 //x=1.6 //y=4.755 //x2=1.6 //y2=4.88
r742 (  22 41 ) resistor r=0.0911593 //w=0.376 //l=0.184608 //layer=m1 \
 //thickness=0.36 //x=1.6 //y=4.42 //x2=1.547 //y2=4.26
r743 (  15 43 ) resistor r=0.0719237 //w=0.222 //l=0.115 //layer=m1 \
 //thickness=0.36 //x=1.6 //y=2.375 //x2=1.6 //y2=2.26
r744 (  14 94 ) resistor r=4.5 //w=0.15 //l=0.15 //layer=via1 //count=1 \
 //x=59.32 //y=4.25 //x2=59.32 //y2=4.25
r745 (  14 36 ) resistor r=0.0911593 //w=0.376 //l=0.184608 //layer=m1 \
 //thickness=0.36 //x=59.267 //y=4.25 //x2=59.32 //y2=4.41
r746 (  14 33 ) resistor r=0.0911593 //w=0.376 //l=0.184608 //layer=m1 \
 //thickness=0.36 //x=59.267 //y=4.25 //x2=59.32 //y2=4.09
r747 (  13 30 ) resistor r=0.0859108 //w=0.371 //l=0.171143 //layer=m1 \
 //thickness=0.36 //x=30.517 //y=4.25 //x2=30.46 //y2=4.395
r748 (  13 51 ) resistor r=0.00505391 //w=0.371 //l=0.015 //layer=m1 \
 //thickness=0.36 //x=30.517 //y=4.25 //x2=30.517 //y2=4.235
r749 (  12 41 ) resistor r=0.00332447 //w=0.376 //l=0.01 //layer=m1 \
 //thickness=0.36 //x=1.547 //y=4.25 //x2=1.547 //y2=4.26
r750 (  12 16 ) resistor r=0.0878349 //w=0.376 //l=0.174499 //layer=m1 \
 //thickness=0.36 //x=1.547 //y=4.25 //x2=1.6 //y2=4.1
r751 (  11 33 ) resistor r=0.553435 //w=0.131 //l=0.58 //layer=m1 \
 //thickness=0.36 //x=59.32 //y=3.51 //x2=59.32 //y2=4.09
r752 (  10 11 ) resistor r=0.706107 //w=0.131 //l=0.74 //layer=m1 \
 //thickness=0.36 //x=59.32 //y=2.77 //x2=59.32 //y2=3.51
r753 (  10 32 ) resistor r=0.376908 //w=0.131 //l=0.395 //layer=m1 \
 //thickness=0.36 //x=59.32 //y=2.77 //x2=59.32 //y2=2.375
r754 (  9 26 ) resistor r=0.186069 //w=0.131 //l=0.195 //layer=m1 \
 //thickness=0.36 //x=30.46 //y=3.88 //x2=30.46 //y2=4.075
r755 (  8 9 ) resistor r=0.353053 //w=0.131 //l=0.37 //layer=m1 \
 //thickness=0.36 //x=30.46 //y=3.51 //x2=30.46 //y2=3.88
r756 (  7 8 ) resistor r=0.706107 //w=0.131 //l=0.74 //layer=m1 \
 //thickness=0.36 //x=30.46 //y=2.77 //x2=30.46 //y2=3.51
r757 (  7 25 ) resistor r=0.376908 //w=0.131 //l=0.395 //layer=m1 \
 //thickness=0.36 //x=30.46 //y=2.77 //x2=30.46 //y2=2.375
r758 (  6 23 ) resistor r=0.128817 //w=0.131 //l=0.135 //layer=m1 \
 //thickness=0.36 //x=1.6 //y=4.62 //x2=1.6 //y2=4.755
r759 (  6 22 ) resistor r=0.19084 //w=0.131 //l=0.2 //layer=m1 \
 //thickness=0.36 //x=1.6 //y=4.62 //x2=1.6 //y2=4.42
r760 (  5 16 ) resistor r=0.209924 //w=0.131 //l=0.22 //layer=m1 \
 //thickness=0.36 //x=1.6 //y=3.88 //x2=1.6 //y2=4.1
r761 (  4 5 ) resistor r=0.353053 //w=0.131 //l=0.37 //layer=m1 \
 //thickness=0.36 //x=1.6 //y=3.51 //x2=1.6 //y2=3.88
r762 (  3 4 ) resistor r=0.353053 //w=0.131 //l=0.37 //layer=m1 \
 //thickness=0.36 //x=1.6 //y=3.14 //x2=1.6 //y2=3.51
r763 (  2 3 ) resistor r=0.353053 //w=0.131 //l=0.37 //layer=m1 \
 //thickness=0.36 //x=1.6 //y=2.77 //x2=1.6 //y2=3.14
r764 (  1 2 ) resistor r=0.353053 //w=0.131 //l=0.37 //layer=m1 \
 //thickness=0.36 //x=1.6 //y=2.4 //x2=1.6 //y2=2.77
r765 (  1 15 ) resistor r=0.023855 //w=0.131 //l=0.025 //layer=m1 \
 //thickness=0.36 //x=1.6 //y=2.4 //x2=1.6 //y2=2.375
ends PM_TMRDFFSNRNQX1\%D

subckt PM_TMRDFFSNRNQX1\%noxref_13 ( 1 3 6 7 9 10 11 12 14 15 16 17 18 19 20 \
 21 22 23 24 25 28 31 37 45 49 63 66 67 69 70 73 81 89 106 115 120 129 133 134 \
 135 136 137 138 139 140 141 142 143 145 151 152 153 154 158 159 160 161 162 \
 164 170 171 172 173 193 195 196 197 )
c438 ( 193 0 ) capacitor c=0.00885916f //x=61.605 //y=1.095
c439 ( 173 0 ) capacitor c=0.0612936f //x=69.215 //y=4.97
c440 ( 172 0 ) capacitor c=0.0376642f //x=69.505 //y=4.97
c441 ( 171 0 ) capacitor c=0.0346489f //x=69.17 //y=1.4
c442 ( 170 0 ) capacitor c=0.018692f //x=69.17 //y=1.055
c443 ( 164 0 ) capacitor c=0.0137077f //x=69.015 //y=1.555
c444 ( 162 0 ) capacitor c=0.0158585f //x=69.015 //y=0.9
c445 ( 161 0 ) capacitor c=0.0979536f //x=68.64 //y=2.095
c446 ( 160 0 ) capacitor c=0.0229444f //x=68.64 //y=1.71
c447 ( 159 0 ) capacitor c=0.0234359f //x=68.64 //y=1.4
c448 ( 158 0 ) capacitor c=0.019815f //x=68.64 //y=1.055
c449 ( 154 0 ) capacitor c=0.0614625f //x=64.405 //y=4.97
c450 ( 153 0 ) capacitor c=0.0376642f //x=64.695 //y=4.97
c451 ( 152 0 ) capacitor c=0.0346489f //x=64.36 //y=1.4
c452 ( 151 0 ) capacitor c=0.018692f //x=64.36 //y=1.055
c453 ( 145 0 ) capacitor c=0.0137077f //x=64.205 //y=1.555
c454 ( 143 0 ) capacitor c=0.0158585f //x=64.205 //y=0.9
c455 ( 142 0 ) capacitor c=0.0996161f //x=63.83 //y=2.095
c456 ( 141 0 ) capacitor c=0.0229444f //x=63.83 //y=1.71
c457 ( 140 0 ) capacitor c=0.0234359f //x=63.83 //y=1.4
c458 ( 139 0 ) capacitor c=0.019815f //x=63.83 //y=1.055
c459 ( 138 0 ) capacitor c=0.110208f //x=69.58 //y=6.2
c460 ( 137 0 ) capacitor c=0.158957f //x=69.14 //y=6.2
c461 ( 136 0 ) capacitor c=0.110229f //x=64.77 //y=6.2
c462 ( 135 0 ) capacitor c=0.158957f //x=64.33 //y=6.2
c463 ( 129 0 ) capacitor c=0.00159026f //x=68.94 //y=4.88
c464 ( 120 0 ) capacitor c=9.93222e-19 //x=68.94 //y=2.26
c465 ( 115 0 ) capacitor c=0.00157452f //x=64.13 //y=4.88
c466 ( 106 0 ) capacitor c=9.93222e-19 //x=64.13 //y=2.26
c467 ( 89 0 ) capacitor c=0.0293562f //x=61.5 //y=5.56
c468 ( 81 0 ) capacitor c=0.029137f //x=60.62 //y=5.56
c469 ( 73 0 ) capacitor c=0.0278099f //x=59.74 //y=5.56
c470 ( 70 0 ) capacitor c=0.0392804f //x=68.78 //y=2.785
c471 ( 69 0 ) capacitor c=5.7546e-19 //x=68.94 //y=2.785
c472 ( 67 0 ) capacitor c=5.7546e-19 //x=64.295 //y=2.785
c473 ( 66 0 ) capacitor c=0.016756f //x=63.975 //y=2.785
c474 ( 63 0 ) capacitor c=9.56892e-19 //x=62.445 //y=2.785
c475 ( 49 0 ) capacitor c=0.0154699f //x=68.94 //y=2.77
c476 ( 45 0 ) capacitor c=0.0148628f //x=64.13 //y=2.77
c477 ( 37 0 ) capacitor c=0.0144706f //x=62.28 //y=2.77
c478 ( 31 0 ) capacitor c=9.37498e-19 //x=61.5 //y=5.335
c479 ( 28 0 ) capacitor c=0.0076134f //x=60.62 //y=5.335
c480 ( 25 0 ) capacitor c=0.0109203f //x=59.742 //y=5.335
c481 ( 24 0 ) capacitor c=0.0552261f //x=68.94 //y=4.755
c482 ( 23 0 ) capacitor c=0.0130763f //x=68.94 //y=2.945
c483 ( 22 0 ) capacitor c=0.00473602f //x=68.94 //y=2.625
c484 ( 21 0 ) capacitor c=0.00495287f //x=68.94 //y=2.375
c485 ( 20 0 ) capacitor c=0.0593148f //x=64.13 //y=4.755
c486 ( 19 0 ) capacitor c=0.0129478f //x=64.13 //y=2.945
c487 ( 18 0 ) capacitor c=0.00482124f //x=64.13 //y=2.625
c488 ( 17 0 ) capacitor c=0.00495287f //x=64.13 //y=2.375
c489 ( 16 0 ) capacitor c=0.0647359f //x=62.28 //y=5.25
c490 ( 15 0 ) capacitor c=0.0123004f //x=62.28 //y=2.945
c491 ( 14 0 ) capacitor c=0.0179579f //x=62.28 //y=2.625
c492 ( 12 0 ) capacitor c=0.0047266f //x=61.88 //y=1.845
c493 ( 11 0 ) capacitor c=0.0129788f //x=62.195 //y=1.845
c494 ( 10 0 ) capacitor c=0.0167992f //x=61.795 //y=1.76
c495 ( 9 0 ) capacitor c=0.0110957f //x=61.795 //y=1.305
c496 ( 7 0 ) capacitor c=0.0202915f //x=62.195 //y=5.335
c497 ( 6 0 ) capacitor c=0.00933983f //x=61.5 //y=5.56
c498 ( 3 0 ) capacitor c=0.0192055f //x=61.385 //y=5.335
c499 ( 1 0 ) capacitor c=0.0149267f //x=60.5 //y=5.335
r500 (  172 174 ) resistor r=26.9307 //w=0.15 //l=0.106066 //layer=ply \
 //thickness=0.18 //x=69.505 //y=4.97 //x2=69.58 //y2=5.045
r501 (  172 173 ) resistor r=148.702 //w=0.094 //l=0.29 //layer=ply \
 //thickness=0.18 //x=69.505 //y=4.97 //x2=69.215 //y2=4.97
r502 (  171 192 ) resistor r=45.1352 //w=0.168 //l=0.173853 //layer=ply \
 //thickness=0.18 //x=69.17 //y=1.4 //x2=69.13 //y2=1.555
r503 (  170 191 ) resistor r=45.1352 //w=0.168 //l=0.173853 //layer=ply \
 //thickness=0.18 //x=69.17 //y=1.055 //x2=69.13 //y2=0.9
r504 (  170 171 ) resistor r=176.904 //w=0.094 //l=0.345 //layer=ply \
 //thickness=0.18 //x=69.17 //y=1.055 //x2=69.17 //y2=1.4
r505 (  167 173 ) resistor r=22.7971 //w=0.269 //l=0.106066 //layer=ply \
 //thickness=0.18 //x=69.14 //y=5.045 //x2=69.215 //y2=4.97
r506 (  167 190 ) resistor r=35.8364 //w=0.269 //l=0.270185 //layer=ply \
 //thickness=0.18 //x=69.14 //y=5.045 //x2=68.94 //y2=4.88
r507 (  165 186 ) resistor r=10.701 //w=0.21 //l=0.115 //layer=ply \
 //thickness=0.18 //x=68.795 //y=1.555 //x2=68.68 //y2=1.555
r508 (  164 192 ) resistor r=5.52526 //w=0.168 //l=0.115 //layer=ply \
 //thickness=0.18 //x=69.015 //y=1.555 //x2=69.13 //y2=1.555
r509 (  163 185 ) resistor r=5.52526 //w=0.168 //l=0.115 //layer=ply \
 //thickness=0.18 //x=68.795 //y=0.9 //x2=68.68 //y2=0.9
r510 (  162 191 ) resistor r=5.52526 //w=0.168 //l=0.115 //layer=ply \
 //thickness=0.18 //x=69.015 //y=0.9 //x2=69.13 //y2=0.9
r511 (  162 163 ) resistor r=112.809 //w=0.094 //l=0.22 //layer=ply \
 //thickness=0.18 //x=69.015 //y=0.9 //x2=68.795 //y2=0.9
r512 (  161 188 ) resistor r=58.7805 //w=0.246 //l=0.373497 //layer=ply \
 //thickness=0.18 //x=68.64 //y=2.095 //x2=68.94 //y2=2.26
r513 (  160 186 ) resistor r=39.5823 //w=0.21 //l=0.173853 //layer=ply \
 //thickness=0.18 //x=68.64 //y=1.71 //x2=68.68 //y2=1.555
r514 (  160 161 ) resistor r=197.415 //w=0.094 //l=0.385 //layer=ply \
 //thickness=0.18 //x=68.64 //y=1.71 //x2=68.64 //y2=2.095
r515 (  159 186 ) resistor r=39.5823 //w=0.21 //l=0.173853 //layer=ply \
 //thickness=0.18 //x=68.64 //y=1.4 //x2=68.68 //y2=1.555
r516 (  158 185 ) resistor r=45.1352 //w=0.168 //l=0.173853 //layer=ply \
 //thickness=0.18 //x=68.64 //y=1.055 //x2=68.68 //y2=0.9
r517 (  158 159 ) resistor r=176.904 //w=0.094 //l=0.345 //layer=ply \
 //thickness=0.18 //x=68.64 //y=1.055 //x2=68.64 //y2=1.4
r518 (  153 155 ) resistor r=26.9307 //w=0.15 //l=0.106066 //layer=ply \
 //thickness=0.18 //x=64.695 //y=4.97 //x2=64.77 //y2=5.045
r519 (  153 154 ) resistor r=148.702 //w=0.094 //l=0.29 //layer=ply \
 //thickness=0.18 //x=64.695 //y=4.97 //x2=64.405 //y2=4.97
r520 (  152 184 ) resistor r=45.1352 //w=0.168 //l=0.173853 //layer=ply \
 //thickness=0.18 //x=64.36 //y=1.4 //x2=64.32 //y2=1.555
r521 (  151 183 ) resistor r=45.1352 //w=0.168 //l=0.173853 //layer=ply \
 //thickness=0.18 //x=64.36 //y=1.055 //x2=64.32 //y2=0.9
r522 (  151 152 ) resistor r=176.904 //w=0.094 //l=0.345 //layer=ply \
 //thickness=0.18 //x=64.36 //y=1.055 //x2=64.36 //y2=1.4
r523 (  148 154 ) resistor r=22.7971 //w=0.269 //l=0.106066 //layer=ply \
 //thickness=0.18 //x=64.33 //y=5.045 //x2=64.405 //y2=4.97
r524 (  148 182 ) resistor r=35.8364 //w=0.269 //l=0.270185 //layer=ply \
 //thickness=0.18 //x=64.33 //y=5.045 //x2=64.13 //y2=4.88
r525 (  146 178 ) resistor r=10.701 //w=0.21 //l=0.115 //layer=ply \
 //thickness=0.18 //x=63.985 //y=1.555 //x2=63.87 //y2=1.555
r526 (  145 184 ) resistor r=5.52526 //w=0.168 //l=0.115 //layer=ply \
 //thickness=0.18 //x=64.205 //y=1.555 //x2=64.32 //y2=1.555
r527 (  144 177 ) resistor r=5.52526 //w=0.168 //l=0.115 //layer=ply \
 //thickness=0.18 //x=63.985 //y=0.9 //x2=63.87 //y2=0.9
r528 (  143 183 ) resistor r=5.52526 //w=0.168 //l=0.115 //layer=ply \
 //thickness=0.18 //x=64.205 //y=0.9 //x2=64.32 //y2=0.9
r529 (  143 144 ) resistor r=112.809 //w=0.094 //l=0.22 //layer=ply \
 //thickness=0.18 //x=64.205 //y=0.9 //x2=63.985 //y2=0.9
r530 (  142 180 ) resistor r=58.7805 //w=0.246 //l=0.373497 //layer=ply \
 //thickness=0.18 //x=63.83 //y=2.095 //x2=64.13 //y2=2.26
r531 (  141 178 ) resistor r=39.5823 //w=0.21 //l=0.173853 //layer=ply \
 //thickness=0.18 //x=63.83 //y=1.71 //x2=63.87 //y2=1.555
r532 (  141 142 ) resistor r=197.415 //w=0.094 //l=0.385 //layer=ply \
 //thickness=0.18 //x=63.83 //y=1.71 //x2=63.83 //y2=2.095
r533 (  140 178 ) resistor r=39.5823 //w=0.21 //l=0.173853 //layer=ply \
 //thickness=0.18 //x=63.83 //y=1.4 //x2=63.87 //y2=1.555
r534 (  139 177 ) resistor r=45.1352 //w=0.168 //l=0.173853 //layer=ply \
 //thickness=0.18 //x=63.83 //y=1.055 //x2=63.87 //y2=0.9
r535 (  139 140 ) resistor r=176.904 //w=0.094 //l=0.345 //layer=ply \
 //thickness=0.18 //x=63.83 //y=1.055 //x2=63.83 //y2=1.4
r536 (  138 174 ) resistor r=592.245 //w=0.094 //l=1.155 //layer=ply \
 //thickness=0.18 //x=69.58 //y=6.2 //x2=69.58 //y2=5.045
r537 (  137 167 ) resistor r=592.245 //w=0.094 //l=1.155 //layer=ply \
 //thickness=0.18 //x=69.14 //y=6.2 //x2=69.14 //y2=5.045
r538 (  136 155 ) resistor r=592.245 //w=0.094 //l=1.155 //layer=ply \
 //thickness=0.18 //x=64.77 //y=6.2 //x2=64.77 //y2=5.045
r539 (  135 148 ) resistor r=592.245 //w=0.094 //l=1.155 //layer=ply \
 //thickness=0.18 //x=64.33 //y=6.2 //x2=64.33 //y2=5.045
r540 (  134 164 ) resistor r=56.4043 //w=0.094 //l=0.11 //layer=ply \
 //thickness=0.18 //x=68.905 //y=1.555 //x2=69.015 //y2=1.555
r541 (  134 165 ) resistor r=56.4043 //w=0.094 //l=0.11 //layer=ply \
 //thickness=0.18 //x=68.905 //y=1.555 //x2=68.795 //y2=1.555
r542 (  133 145 ) resistor r=56.4043 //w=0.094 //l=0.11 //layer=ply \
 //thickness=0.18 //x=64.095 //y=1.555 //x2=64.205 //y2=1.555
r543 (  133 146 ) resistor r=56.4043 //w=0.094 //l=0.11 //layer=ply \
 //thickness=0.18 //x=64.095 //y=1.555 //x2=63.985 //y2=1.555
r544 (  129 190 ) resistor r=152 //w=0.17 //l=0.17 //layer=licon //count=1 \
 //x=68.94 //y=4.88 //x2=68.94 //y2=4.88
r545 (  120 188 ) resistor r=152 //w=0.17 //l=0.17 //layer=licon //count=1 \
 //x=68.94 //y=2.26 //x2=68.94 //y2=2.26
r546 (  115 182 ) resistor r=152 //w=0.17 //l=0.17 //layer=licon //count=1 \
 //x=64.13 //y=4.88 //x2=64.13 //y2=4.88
r547 (  106 180 ) resistor r=152 //w=0.17 //l=0.17 //layer=licon //count=1 \
 //x=64.13 //y=2.26 //x2=64.13 //y2=2.26
r548 (  89 197 ) resistor r=23.615 //w=0.187 //l=0.345 //layer=li \
 //thickness=0.1 //x=61.5 //y=5.56 //x2=61.5 //y2=5.905
r549 (  81 196 ) resistor r=23.615 //w=0.187 //l=0.345 //layer=li \
 //thickness=0.1 //x=60.62 //y=5.56 //x2=60.62 //y2=5.905
r550 (  73 195 ) resistor r=23.615 //w=0.187 //l=0.345 //layer=li \
 //thickness=0.1 //x=59.74 //y=5.56 //x2=59.74 //y2=5.905
r551 (  69 70 ) resistor r=0.10734 //w=0.281 //l=0.16 //layer=m2 \
 //thickness=0.36 //x=68.94 //y=2.785 //x2=68.78 //y2=2.785
r552 (  67 70 ) resistor r=4.27958 //w=0.131 //l=4.485 //layer=m2 \
 //thickness=0.36 //x=64.295 //y=2.77 //x2=68.78 //y2=2.77
r553 (  65 67 ) resistor r=0.10734 //w=0.281 //l=0.16 //layer=m2 \
 //thickness=0.36 //x=64.135 //y=2.785 //x2=64.295 //y2=2.785
r554 (  65 66 ) resistor r=0.10734 //w=0.281 //l=0.16 //layer=m2 \
 //thickness=0.36 //x=64.135 //y=2.785 //x2=63.975 //y2=2.785
r555 (  63 66 ) resistor r=1.45992 //w=0.131 //l=1.53 //layer=m2 \
 //thickness=0.36 //x=62.445 //y=2.77 //x2=63.975 //y2=2.77
r556 (  61 63 ) resistor r=0.10734 //w=0.281 //l=0.16 //layer=m2 \
 //thickness=0.36 //x=62.285 //y=2.785 //x2=62.445 //y2=2.785
r557 (  55 129 ) resistor r=9.3 //w=0.17 //l=0.17 //layer=mcon //count=1 \
 //x=68.94 //y=4.88 //x2=68.94 //y2=4.88
r558 (  53 120 ) resistor r=9.3 //w=0.17 //l=0.17 //layer=mcon //count=1 \
 //x=68.94 //y=2.26 //x2=68.94 //y2=2.26
r559 (  51 69 ) resistor r=4.5 //w=0.15 //l=0.15 //layer=via1 //count=1 \
 //x=68.94 //y=2.785 //x2=68.94 //y2=2.785
r560 (  49 51 ) resistor r=0.0049867 //w=0.376 //l=0.015 //layer=m1 \
 //thickness=0.36 //x=68.887 //y=2.77 //x2=68.887 //y2=2.785
r561 (  47 65 ) resistor r=4.5 //w=0.15 //l=0.15 //layer=via1 //count=1 \
 //x=64.135 //y=2.785 //x2=64.135 //y2=2.785
r562 (  45 47 ) resistor r=0.00501337 //w=0.374 //l=0.015 //layer=m1 \
 //thickness=0.36 //x=64.185 //y=2.77 //x2=64.185 //y2=2.785
r563 (  43 115 ) resistor r=9.3 //w=0.17 //l=0.17 //layer=mcon //count=1 \
 //x=64.13 //y=4.88 //x2=64.13 //y2=4.88
r564 (  41 106 ) resistor r=9.3 //w=0.17 //l=0.17 //layer=mcon //count=1 \
 //x=64.13 //y=2.26 //x2=64.13 //y2=2.26
r565 (  39 61 ) resistor r=4.5 //w=0.15 //l=0.15 //layer=via1 //count=1 \
 //x=62.285 //y=2.785 //x2=62.285 //y2=2.785
r566 (  37 39 ) resistor r=0.00501337 //w=0.374 //l=0.015 //layer=m1 \
 //thickness=0.36 //x=62.335 //y=2.77 //x2=62.335 //y2=2.785
r567 (  35 193 ) resistor r=9.3 //w=0.17 //l=0.17 //layer=mcon //count=1 \
 //x=61.795 //y=1.19 //x2=61.795 //y2=1.19
r568 (  33 89 ) resistor r=9.3 //w=0.17 //l=0.17 //layer=mcon //count=1 \
 //x=61.5 //y=5.56 //x2=61.5 //y2=5.56
r569 (  30 81 ) resistor r=9.3 //w=0.17 //l=0.17 //layer=mcon //count=1 \
 //x=60.62 //y=5.56 //x2=60.62 //y2=5.56
r570 (  28 30 ) resistor r=0.121228 //w=0.232 //l=0.225 //layer=m1 \
 //thickness=0.36 //x=60.62 //y=5.335 //x2=60.62 //y2=5.56
r571 (  27 73 ) resistor r=9.3 //w=0.17 //l=0.17 //layer=mcon //count=1 \
 //x=59.74 //y=5.56 //x2=59.74 //y2=5.56
r572 (  25 27 ) resistor r=0.129608 //w=0.217 //l=0.225 //layer=m1 \
 //thickness=0.36 //x=59.742 //y=5.335 //x2=59.742 //y2=5.56
r573 (  24 55 ) resistor r=0.0760407 //w=0.238 //l=0.125 //layer=m1 \
 //thickness=0.36 //x=68.94 //y=4.755 //x2=68.94 //y2=4.88
r574 (  23 51 ) resistor r=0.0911593 //w=0.376 //l=0.184608 //layer=m1 \
 //thickness=0.36 //x=68.94 //y=2.945 //x2=68.887 //y2=2.785
r575 (  23 24 ) resistor r=1.7271 //w=0.131 //l=1.81 //layer=m1 \
 //thickness=0.36 //x=68.94 //y=2.945 //x2=68.94 //y2=4.755
r576 (  22 49 ) resistor r=0.0861726 //w=0.376 //l=0.16944 //layer=m1 \
 //thickness=0.36 //x=68.94 //y=2.625 //x2=68.887 //y2=2.77
r577 (  21 53 ) resistor r=0.0719237 //w=0.222 //l=0.115 //layer=m1 \
 //thickness=0.36 //x=68.94 //y=2.375 //x2=68.94 //y2=2.26
r578 (  21 22 ) resistor r=0.23855 //w=0.131 //l=0.25 //layer=m1 \
 //thickness=0.36 //x=68.94 //y=2.375 //x2=68.94 //y2=2.625
r579 (  20 43 ) resistor r=0.0760407 //w=0.238 //l=0.125 //layer=m1 \
 //thickness=0.36 //x=64.13 //y=4.755 //x2=64.13 //y2=4.88
r580 (  19 47 ) resistor r=0.0910802 //w=0.374 //l=0.185472 //layer=m1 \
 //thickness=0.36 //x=64.13 //y=2.945 //x2=64.185 //y2=2.785
r581 (  19 20 ) resistor r=1.7271 //w=0.131 //l=1.81 //layer=m1 \
 //thickness=0.36 //x=64.13 //y=2.945 //x2=64.13 //y2=4.755
r582 (  18 45 ) resistor r=0.0860668 //w=0.374 //l=0.170294 //layer=m1 \
 //thickness=0.36 //x=64.13 //y=2.625 //x2=64.185 //y2=2.77
r583 (  17 41 ) resistor r=0.0719237 //w=0.222 //l=0.115 //layer=m1 \
 //thickness=0.36 //x=64.13 //y=2.375 //x2=64.13 //y2=2.26
r584 (  17 18 ) resistor r=0.23855 //w=0.131 //l=0.25 //layer=m1 \
 //thickness=0.36 //x=64.13 //y=2.375 //x2=64.13 //y2=2.625
r585 (  15 39 ) resistor r=0.0910802 //w=0.374 //l=0.185472 //layer=m1 \
 //thickness=0.36 //x=62.28 //y=2.945 //x2=62.335 //y2=2.785
r586 (  15 16 ) resistor r=2.19943 //w=0.131 //l=2.305 //layer=m1 \
 //thickness=0.36 //x=62.28 //y=2.945 //x2=62.28 //y2=5.25
r587 (  14 37 ) resistor r=0.0860668 //w=0.374 //l=0.170294 //layer=m1 \
 //thickness=0.36 //x=62.28 //y=2.625 //x2=62.335 //y2=2.77
r588 (  13 14 ) resistor r=0.663168 //w=0.131 //l=0.695 //layer=m1 \
 //thickness=0.36 //x=62.28 //y=1.93 //x2=62.28 //y2=2.625
r589 (  11 13 ) resistor r=0.0698411 //w=0.17 //l=0.120208 //layer=m1 \
 //thickness=0.36 //x=62.195 //y=1.845 //x2=62.28 //y2=1.93
r590 (  11 12 ) resistor r=0.300573 //w=0.131 //l=0.315 //layer=m1 \
 //thickness=0.36 //x=62.195 //y=1.845 //x2=61.88 //y2=1.845
r591 (  10 12 ) resistor r=0.0698411 //w=0.17 //l=0.120208 //layer=m1 \
 //thickness=0.36 //x=61.795 //y=1.76 //x2=61.88 //y2=1.845
r592 (  9 35 ) resistor r=0.0717383 //w=0.224 //l=0.115 //layer=m1 \
 //thickness=0.36 //x=61.795 //y=1.305 //x2=61.795 //y2=1.19
r593 (  9 10 ) resistor r=0.43416 //w=0.131 //l=0.455 //layer=m1 \
 //thickness=0.36 //x=61.795 //y=1.305 //x2=61.795 //y2=1.76
r594 (  8 31 ) resistor r=0.0675342 //w=0.23 //l=0.115 //layer=m1 \
 //thickness=0.36 //x=61.615 //y=5.335 //x2=61.5 //y2=5.335
r595 (  7 16 ) resistor r=0.0698411 //w=0.17 //l=0.120208 //layer=m1 \
 //thickness=0.36 //x=62.195 //y=5.335 //x2=62.28 //y2=5.25
r596 (  7 8 ) resistor r=0.553435 //w=0.131 //l=0.58 //layer=m1 \
 //thickness=0.36 //x=62.195 //y=5.335 //x2=61.615 //y2=5.335
r597 (  6 33 ) resistor r=0.00118313 //w=0.23 //layer=m1 //thickness=0.36 \
 //x=61.5 //y=5.56 //x2=61.5 //y2=5.56
r598 (  5 31 ) resistor r=0.002872 //w=0.34 //l=0.085 //layer=m1 \
 //thickness=0.36 //x=61.5 //y=5.42 //x2=61.5 //y2=5.335
r599 (  5 6 ) resistor r=0.091623 //w=0.191 //l=0.14 //layer=m1 \
 //thickness=0.36 //x=61.5 //y=5.42 //x2=61.5 //y2=5.56
r600 (  4 28 ) resistor r=0.0262263 //w=0.232 //l=0.12 //layer=m1 \
 //thickness=0.36 //x=60.74 //y=5.335 //x2=60.62 //y2=5.335
r601 (  3 31 ) resistor r=0.0675342 //w=0.23 //l=0.115 //layer=m1 \
 //thickness=0.36 //x=61.385 //y=5.335 //x2=61.5 //y2=5.335
r602 (  3 4 ) resistor r=0.615458 //w=0.131 //l=0.645 //layer=m1 \
 //thickness=0.36 //x=61.385 //y=5.335 //x2=60.74 //y2=5.335
r603 (  2 25 ) resistor r=0.0222262 //w=0.217 //l=0.118 //layer=m1 \
 //thickness=0.36 //x=59.86 //y=5.335 //x2=59.742 //y2=5.335
r604 (  1 28 ) resistor r=0.0262263 //w=0.232 //l=0.12 //layer=m1 \
 //thickness=0.36 //x=60.5 //y=5.335 //x2=60.62 //y2=5.335
r605 (  1 2 ) resistor r=0.610687 //w=0.131 //l=0.64 //layer=m1 \
 //thickness=0.36 //x=60.5 //y=5.335 //x2=59.86 //y2=5.335
ends PM_TMRDFFSNRNQX1\%noxref_13

subckt PM_TMRDFFSNRNQX1\%noxref_14 ( 1 3 6 7 9 10 11 12 14 15 16 17 18 19 20 \
 21 24 27 33 36 42 43 48 51 59 67 84 93 97 98 99 100 101 102 103 104 106 112 \
 113 114 115 127 129 130 131 )
c298 ( 127 0 ) capacitor c=0.00885916f //x=71.225 //y=1.095
c299 ( 115 0 ) capacitor c=0.0612936f //x=74.025 //y=4.97
c300 ( 114 0 ) capacitor c=0.0376642f //x=74.315 //y=4.97
c301 ( 113 0 ) capacitor c=0.0346489f //x=73.98 //y=1.4
c302 ( 112 0 ) capacitor c=0.018692f //x=73.98 //y=1.055
c303 ( 106 0 ) capacitor c=0.0137077f //x=73.825 //y=1.555
c304 ( 104 0 ) capacitor c=0.0158585f //x=73.825 //y=0.9
c305 ( 103 0 ) capacitor c=0.0979523f //x=73.45 //y=2.095
c306 ( 102 0 ) capacitor c=0.0229444f //x=73.45 //y=1.71
c307 ( 101 0 ) capacitor c=0.0234359f //x=73.45 //y=1.4
c308 ( 100 0 ) capacitor c=0.019815f //x=73.45 //y=1.055
c309 ( 99 0 ) capacitor c=0.110286f //x=74.39 //y=6.2
c310 ( 98 0 ) capacitor c=0.158957f //x=73.95 //y=6.2
c311 ( 93 0 ) capacitor c=0.00157756f //x=73.75 //y=4.88
c312 ( 84 0 ) capacitor c=9.93222e-19 //x=73.75 //y=2.26
c313 ( 67 0 ) capacitor c=0.0293723f //x=71.12 //y=5.56
c314 ( 59 0 ) capacitor c=0.029137f //x=70.24 //y=5.56
c315 ( 51 0 ) capacitor c=0.0278099f //x=69.36 //y=5.56
c316 ( 48 0 ) capacitor c=5.79974e-19 //x=73.76 //y=2.77
c317 ( 43 0 ) capacitor c=9.44624e-19 //x=72.06 //y=2.77
c318 ( 42 0 ) capacitor c=0.0155215f //x=73.6 //y=2.77
c319 ( 36 0 ) capacitor c=0.0146045f //x=73.75 //y=2.77
c320 ( 33 0 ) capacitor c=0.0146969f //x=71.9 //y=2.77
c321 ( 27 0 ) capacitor c=8.40513e-19 //x=71.12 //y=5.335
c322 ( 24 0 ) capacitor c=0.00712803f //x=70.24 //y=5.335
c323 ( 21 0 ) capacitor c=0.0109203f //x=69.362 //y=5.335
c324 ( 20 0 ) capacitor c=0.0604532f //x=73.75 //y=4.755
c325 ( 19 0 ) capacitor c=0.0131932f //x=73.75 //y=2.93
c326 ( 18 0 ) capacitor c=0.00432188f //x=73.75 //y=2.61
c327 ( 17 0 ) capacitor c=0.00485584f //x=73.75 //y=2.375
c328 ( 16 0 ) capacitor c=0.0631244f //x=71.9 //y=5.25
c329 ( 15 0 ) capacitor c=0.0122936f //x=71.9 //y=2.93
c330 ( 14 0 ) capacitor c=0.0181662f //x=71.9 //y=2.61
c331 ( 12 0 ) capacitor c=0.00493487f //x=71.5 //y=1.845
c332 ( 11 0 ) capacitor c=0.0129068f //x=71.815 //y=1.845
c333 ( 10 0 ) capacitor c=0.0167992f //x=71.415 //y=1.76
c334 ( 9 0 ) capacitor c=0.0112867f //x=71.415 //y=1.305
c335 ( 7 0 ) capacitor c=0.0208188f //x=71.815 //y=5.335
c336 ( 6 0 ) capacitor c=0.00933983f //x=71.12 //y=5.56
c337 ( 3 0 ) capacitor c=0.0177111f //x=71.005 //y=5.335
c338 ( 1 0 ) capacitor c=0.0148498f //x=70.12 //y=5.335
r339 (  114 116 ) resistor r=26.9307 //w=0.15 //l=0.106066 //layer=ply \
 //thickness=0.18 //x=74.315 //y=4.97 //x2=74.39 //y2=5.045
r340 (  114 115 ) resistor r=148.702 //w=0.094 //l=0.29 //layer=ply \
 //thickness=0.18 //x=74.315 //y=4.97 //x2=74.025 //y2=4.97
r341 (  113 126 ) resistor r=45.1352 //w=0.168 //l=0.173853 //layer=ply \
 //thickness=0.18 //x=73.98 //y=1.4 //x2=73.94 //y2=1.555
r342 (  112 125 ) resistor r=45.1352 //w=0.168 //l=0.173853 //layer=ply \
 //thickness=0.18 //x=73.98 //y=1.055 //x2=73.94 //y2=0.9
r343 (  112 113 ) resistor r=176.904 //w=0.094 //l=0.345 //layer=ply \
 //thickness=0.18 //x=73.98 //y=1.055 //x2=73.98 //y2=1.4
r344 (  109 115 ) resistor r=22.7971 //w=0.269 //l=0.106066 //layer=ply \
 //thickness=0.18 //x=73.95 //y=5.045 //x2=74.025 //y2=4.97
r345 (  109 124 ) resistor r=35.8364 //w=0.269 //l=0.270185 //layer=ply \
 //thickness=0.18 //x=73.95 //y=5.045 //x2=73.75 //y2=4.88
r346 (  107 120 ) resistor r=10.701 //w=0.21 //l=0.115 //layer=ply \
 //thickness=0.18 //x=73.605 //y=1.555 //x2=73.49 //y2=1.555
r347 (  106 126 ) resistor r=5.52526 //w=0.168 //l=0.115 //layer=ply \
 //thickness=0.18 //x=73.825 //y=1.555 //x2=73.94 //y2=1.555
r348 (  105 119 ) resistor r=5.52526 //w=0.168 //l=0.115 //layer=ply \
 //thickness=0.18 //x=73.605 //y=0.9 //x2=73.49 //y2=0.9
r349 (  104 125 ) resistor r=5.52526 //w=0.168 //l=0.115 //layer=ply \
 //thickness=0.18 //x=73.825 //y=0.9 //x2=73.94 //y2=0.9
r350 (  104 105 ) resistor r=112.809 //w=0.094 //l=0.22 //layer=ply \
 //thickness=0.18 //x=73.825 //y=0.9 //x2=73.605 //y2=0.9
r351 (  103 122 ) resistor r=58.7805 //w=0.246 //l=0.373497 //layer=ply \
 //thickness=0.18 //x=73.45 //y=2.095 //x2=73.75 //y2=2.26
r352 (  102 120 ) resistor r=39.5823 //w=0.21 //l=0.173853 //layer=ply \
 //thickness=0.18 //x=73.45 //y=1.71 //x2=73.49 //y2=1.555
r353 (  102 103 ) resistor r=197.415 //w=0.094 //l=0.385 //layer=ply \
 //thickness=0.18 //x=73.45 //y=1.71 //x2=73.45 //y2=2.095
r354 (  101 120 ) resistor r=39.5823 //w=0.21 //l=0.173853 //layer=ply \
 //thickness=0.18 //x=73.45 //y=1.4 //x2=73.49 //y2=1.555
r355 (  100 119 ) resistor r=45.1352 //w=0.168 //l=0.173853 //layer=ply \
 //thickness=0.18 //x=73.45 //y=1.055 //x2=73.49 //y2=0.9
r356 (  100 101 ) resistor r=176.904 //w=0.094 //l=0.345 //layer=ply \
 //thickness=0.18 //x=73.45 //y=1.055 //x2=73.45 //y2=1.4
r357 (  99 116 ) resistor r=592.245 //w=0.094 //l=1.155 //layer=ply \
 //thickness=0.18 //x=74.39 //y=6.2 //x2=74.39 //y2=5.045
r358 (  98 109 ) resistor r=592.245 //w=0.094 //l=1.155 //layer=ply \
 //thickness=0.18 //x=73.95 //y=6.2 //x2=73.95 //y2=5.045
r359 (  97 106 ) resistor r=56.4043 //w=0.094 //l=0.11 //layer=ply \
 //thickness=0.18 //x=73.715 //y=1.555 //x2=73.825 //y2=1.555
r360 (  97 107 ) resistor r=56.4043 //w=0.094 //l=0.11 //layer=ply \
 //thickness=0.18 //x=73.715 //y=1.555 //x2=73.605 //y2=1.555
r361 (  93 124 ) resistor r=152 //w=0.17 //l=0.17 //layer=licon //count=1 \
 //x=73.75 //y=4.88 //x2=73.75 //y2=4.88
r362 (  84 122 ) resistor r=152 //w=0.17 //l=0.17 //layer=licon //count=1 \
 //x=73.75 //y=2.26 //x2=73.75 //y2=2.26
r363 (  67 131 ) resistor r=23.615 //w=0.187 //l=0.345 //layer=li \
 //thickness=0.1 //x=71.12 //y=5.56 //x2=71.12 //y2=5.905
r364 (  59 130 ) resistor r=23.615 //w=0.187 //l=0.345 //layer=li \
 //thickness=0.1 //x=70.24 //y=5.56 //x2=70.24 //y2=5.905
r365 (  51 129 ) resistor r=23.615 //w=0.187 //l=0.345 //layer=li \
 //thickness=0.1 //x=69.36 //y=5.56 //x2=69.36 //y2=5.905
r366 (  43 45 ) resistor r=0.10734 //w=0.281 //l=0.16 //layer=m2 \
 //thickness=0.36 //x=72.06 //y=2.77 //x2=71.9 //y2=2.77
r367 (  42 48 ) resistor r=0.10734 //w=0.281 //l=0.16 //layer=m2 \
 //thickness=0.36 //x=73.6 //y=2.77 //x2=73.76 //y2=2.77
r368 (  42 43 ) resistor r=1.46947 //w=0.131 //l=1.54 //layer=m2 \
 //thickness=0.36 //x=73.6 //y=2.77 //x2=72.06 //y2=2.77
r369 (  41 93 ) resistor r=9.3 //w=0.17 //l=0.17 //layer=mcon //count=1 \
 //x=73.75 //y=4.88 //x2=73.75 //y2=4.88
r370 (  39 84 ) resistor r=9.3 //w=0.17 //l=0.17 //layer=mcon //count=1 \
 //x=73.75 //y=2.26 //x2=73.75 //y2=2.26
r371 (  36 48 ) resistor r=4.5 //w=0.15 //l=0.15 //layer=via1 //count=1 \
 //x=73.76 //y=2.77 //x2=73.76 //y2=2.77
r372 (  33 45 ) resistor r=4.5 //w=0.15 //l=0.15 //layer=via1 //count=1 \
 //x=71.9 //y=2.77 //x2=71.9 //y2=2.77
r373 (  31 127 ) resistor r=9.3 //w=0.17 //l=0.17 //layer=mcon //count=1 \
 //x=71.415 //y=1.19 //x2=71.415 //y2=1.19
r374 (  29 67 ) resistor r=9.3 //w=0.17 //l=0.17 //layer=mcon //count=1 \
 //x=71.12 //y=5.56 //x2=71.12 //y2=5.56
r375 (  26 59 ) resistor r=9.3 //w=0.17 //l=0.17 //layer=mcon //count=1 \
 //x=70.24 //y=5.56 //x2=70.24 //y2=5.56
r376 (  24 26 ) resistor r=0.121228 //w=0.232 //l=0.225 //layer=m1 \
 //thickness=0.36 //x=70.24 //y=5.335 //x2=70.24 //y2=5.56
r377 (  23 51 ) resistor r=9.3 //w=0.17 //l=0.17 //layer=mcon //count=1 \
 //x=69.36 //y=5.56 //x2=69.36 //y2=5.56
r378 (  21 23 ) resistor r=0.129608 //w=0.217 //l=0.225 //layer=m1 \
 //thickness=0.36 //x=69.362 //y=5.335 //x2=69.362 //y2=5.56
r379 (  20 41 ) resistor r=0.0760407 //w=0.238 //l=0.125 //layer=m1 \
 //thickness=0.36 //x=73.75 //y=4.755 //x2=73.75 //y2=4.88
r380 (  19 36 ) resistor r=0.0914072 //w=0.382 //l=0.182428 //layer=m1 \
 //thickness=0.36 //x=73.75 //y=2.93 //x2=73.702 //y2=2.77
r381 (  19 20 ) resistor r=1.74141 //w=0.131 //l=1.825 //layer=m1 \
 //thickness=0.36 //x=73.75 //y=2.93 //x2=73.75 //y2=4.755
r382 (  18 36 ) resistor r=0.0914072 //w=0.382 //l=0.182428 //layer=m1 \
 //thickness=0.36 //x=73.75 //y=2.61 //x2=73.702 //y2=2.77
r383 (  17 39 ) resistor r=0.0719237 //w=0.222 //l=0.115 //layer=m1 \
 //thickness=0.36 //x=73.75 //y=2.375 //x2=73.75 //y2=2.26
r384 (  17 18 ) resistor r=0.224237 //w=0.131 //l=0.235 //layer=m1 \
 //thickness=0.36 //x=73.75 //y=2.375 //x2=73.75 //y2=2.61
r385 (  15 33 ) resistor r=0.0911593 //w=0.376 //l=0.184174 //layer=m1 \
 //thickness=0.36 //x=71.9 //y=2.93 //x2=71.952 //y2=2.77
r386 (  15 16 ) resistor r=2.21374 //w=0.131 //l=2.32 //layer=m1 \
 //thickness=0.36 //x=71.9 //y=2.93 //x2=71.9 //y2=5.25
r387 (  14 33 ) resistor r=0.0911593 //w=0.376 //l=0.184174 //layer=m1 \
 //thickness=0.36 //x=71.9 //y=2.61 //x2=71.952 //y2=2.77
r388 (  13 14 ) resistor r=0.648855 //w=0.131 //l=0.68 //layer=m1 \
 //thickness=0.36 //x=71.9 //y=1.93 //x2=71.9 //y2=2.61
r389 (  11 13 ) resistor r=0.0698411 //w=0.17 //l=0.120208 //layer=m1 \
 //thickness=0.36 //x=71.815 //y=1.845 //x2=71.9 //y2=1.93
r390 (  11 12 ) resistor r=0.300573 //w=0.131 //l=0.315 //layer=m1 \
 //thickness=0.36 //x=71.815 //y=1.845 //x2=71.5 //y2=1.845
r391 (  10 12 ) resistor r=0.0698411 //w=0.17 //l=0.120208 //layer=m1 \
 //thickness=0.36 //x=71.415 //y=1.76 //x2=71.5 //y2=1.845
r392 (  9 31 ) resistor r=0.0717383 //w=0.224 //l=0.115 //layer=m1 \
 //thickness=0.36 //x=71.415 //y=1.305 //x2=71.415 //y2=1.19
r393 (  9 10 ) resistor r=0.43416 //w=0.131 //l=0.455 //layer=m1 \
 //thickness=0.36 //x=71.415 //y=1.305 //x2=71.415 //y2=1.76
r394 (  8 27 ) resistor r=0.0675342 //w=0.23 //l=0.115 //layer=m1 \
 //thickness=0.36 //x=71.235 //y=5.335 //x2=71.12 //y2=5.335
r395 (  7 16 ) resistor r=0.0698411 //w=0.17 //l=0.120208 //layer=m1 \
 //thickness=0.36 //x=71.815 //y=5.335 //x2=71.9 //y2=5.25
r396 (  7 8 ) resistor r=0.553435 //w=0.131 //l=0.58 //layer=m1 \
 //thickness=0.36 //x=71.815 //y=5.335 //x2=71.235 //y2=5.335
r397 (  6 29 ) resistor r=0.00118313 //w=0.23 //layer=m1 //thickness=0.36 \
 //x=71.12 //y=5.56 //x2=71.12 //y2=5.56
r398 (  5 27 ) resistor r=0.002872 //w=0.34 //l=0.085 //layer=m1 \
 //thickness=0.36 //x=71.12 //y=5.42 //x2=71.12 //y2=5.335
r399 (  5 6 ) resistor r=0.091623 //w=0.191 //l=0.14 //layer=m1 \
 //thickness=0.36 //x=71.12 //y=5.42 //x2=71.12 //y2=5.56
r400 (  4 24 ) resistor r=0.0262263 //w=0.232 //l=0.12 //layer=m1 \
 //thickness=0.36 //x=70.36 //y=5.335 //x2=70.24 //y2=5.335
r401 (  3 27 ) resistor r=0.0675342 //w=0.23 //l=0.115 //layer=m1 \
 //thickness=0.36 //x=71.005 //y=5.335 //x2=71.12 //y2=5.335
r402 (  3 4 ) resistor r=0.615458 //w=0.131 //l=0.645 //layer=m1 \
 //thickness=0.36 //x=71.005 //y=5.335 //x2=70.36 //y2=5.335
r403 (  2 21 ) resistor r=0.0222262 //w=0.217 //l=0.118 //layer=m1 \
 //thickness=0.36 //x=69.48 //y=5.335 //x2=69.362 //y2=5.335
r404 (  1 24 ) resistor r=0.0262263 //w=0.232 //l=0.12 //layer=m1 \
 //thickness=0.36 //x=70.12 //y=5.335 //x2=70.24 //y2=5.335
r405 (  1 2 ) resistor r=0.610687 //w=0.131 //l=0.64 //layer=m1 \
 //thickness=0.36 //x=70.12 //y=5.335 //x2=69.48 //y2=5.335
ends PM_TMRDFFSNRNQX1\%noxref_14

subckt PM_TMRDFFSNRNQX1\%CLK ( 1 2 3 4 5 6 7 8 9 10 11 12 13 18 22 26 30 33 40 \
 46 52 58 64 70 73 75 77 79 80 81 82 83 86 91 100 104 109 114 119 124 129 134 \
 139 144 149 154 159 163 164 165 166 167 168 169 170 171 172 173 174 175 176 \
 177 178 179 180 181 182 183 185 191 192 193 194 195 200 201 202 204 210 211 \
 212 213 214 219 220 221 223 229 230 231 232 233 238 239 240 242 248 249 250 \
 251 252 257 258 259 261 267 268 269 270 271 276 277 278 280 286 287 288 289 \
 290 298 309 320 331 342 353 )
c934 ( 353 0 ) capacitor c=0.0357082f //x=74.86 //y=4.88
c935 ( 342 0 ) capacitor c=0.0355326f //x=65.24 //y=4.88
c936 ( 331 0 ) capacitor c=0.0357436f //x=46 //y=4.88
c937 ( 320 0 ) capacitor c=0.0357436f //x=36.38 //y=4.88
c938 ( 309 0 ) capacitor c=0.0357436f //x=17.14 //y=4.88
c939 ( 298 0 ) capacitor c=0.0357436f //x=7.52 //y=4.88
c940 ( 290 0 ) capacitor c=0.0305218f //x=75.195 //y=4.97
c941 ( 289 0 ) capacitor c=0.0863671f //x=74.95 //y=2.095
c942 ( 288 0 ) capacitor c=0.0170266f //x=74.95 //y=1.63
c943 ( 287 0 ) capacitor c=0.018609f //x=74.95 //y=1.4
c944 ( 286 0 ) capacitor c=0.0186599f //x=74.95 //y=1.09
c945 ( 280 0 ) capacitor c=0.0146988f //x=74.795 //y=1.555
c946 ( 278 0 ) capacitor c=0.0148531f //x=74.795 //y=0.935
c947 ( 277 0 ) capacitor c=0.0334406f //x=74.425 //y=1.4
c948 ( 276 0 ) capacitor c=0.0173191f //x=74.425 //y=1.09
c949 ( 271 0 ) capacitor c=0.0306608f //x=65.575 //y=4.97
c950 ( 270 0 ) capacitor c=0.0863671f //x=65.33 //y=2.095
c951 ( 269 0 ) capacitor c=0.0170266f //x=65.33 //y=1.63
c952 ( 268 0 ) capacitor c=0.018609f //x=65.33 //y=1.4
c953 ( 267 0 ) capacitor c=0.0186599f //x=65.33 //y=1.09
c954 ( 261 0 ) capacitor c=0.0146988f //x=65.175 //y=1.555
c955 ( 259 0 ) capacitor c=0.0148531f //x=65.175 //y=0.935
c956 ( 258 0 ) capacitor c=0.0334406f //x=64.805 //y=1.4
c957 ( 257 0 ) capacitor c=0.0173191f //x=64.805 //y=1.09
c958 ( 252 0 ) capacitor c=0.0305218f //x=46.335 //y=4.97
c959 ( 251 0 ) capacitor c=0.0863671f //x=46.09 //y=2.095
c960 ( 250 0 ) capacitor c=0.0170266f //x=46.09 //y=1.63
c961 ( 249 0 ) capacitor c=0.018609f //x=46.09 //y=1.4
c962 ( 248 0 ) capacitor c=0.0186599f //x=46.09 //y=1.09
c963 ( 242 0 ) capacitor c=0.0146988f //x=45.935 //y=1.555
c964 ( 240 0 ) capacitor c=0.0148531f //x=45.935 //y=0.935
c965 ( 239 0 ) capacitor c=0.0334406f //x=45.565 //y=1.4
c966 ( 238 0 ) capacitor c=0.0173191f //x=45.565 //y=1.09
c967 ( 233 0 ) capacitor c=0.0306608f //x=36.715 //y=4.97
c968 ( 232 0 ) capacitor c=0.0863671f //x=36.47 //y=2.095
c969 ( 231 0 ) capacitor c=0.0170266f //x=36.47 //y=1.63
c970 ( 230 0 ) capacitor c=0.018609f //x=36.47 //y=1.4
c971 ( 229 0 ) capacitor c=0.0186599f //x=36.47 //y=1.09
c972 ( 223 0 ) capacitor c=0.0146988f //x=36.315 //y=1.555
c973 ( 221 0 ) capacitor c=0.0148531f //x=36.315 //y=0.935
c974 ( 220 0 ) capacitor c=0.0334406f //x=35.945 //y=1.4
c975 ( 219 0 ) capacitor c=0.0173191f //x=35.945 //y=1.09
c976 ( 214 0 ) capacitor c=0.0305218f //x=17.475 //y=4.97
c977 ( 213 0 ) capacitor c=0.0863671f //x=17.23 //y=2.095
c978 ( 212 0 ) capacitor c=0.0170266f //x=17.23 //y=1.63
c979 ( 211 0 ) capacitor c=0.018609f //x=17.23 //y=1.4
c980 ( 210 0 ) capacitor c=0.0186599f //x=17.23 //y=1.09
c981 ( 204 0 ) capacitor c=0.0146988f //x=17.075 //y=1.555
c982 ( 202 0 ) capacitor c=0.0148531f //x=17.075 //y=0.935
c983 ( 201 0 ) capacitor c=0.0334406f //x=16.705 //y=1.4
c984 ( 200 0 ) capacitor c=0.0173191f //x=16.705 //y=1.09
c985 ( 195 0 ) capacitor c=0.0306608f //x=7.855 //y=4.97
c986 ( 194 0 ) capacitor c=0.0863671f //x=7.61 //y=2.095
c987 ( 193 0 ) capacitor c=0.0170266f //x=7.61 //y=1.63
c988 ( 192 0 ) capacitor c=0.018609f //x=7.61 //y=1.4
c989 ( 191 0 ) capacitor c=0.0186599f //x=7.61 //y=1.09
c990 ( 185 0 ) capacitor c=0.0146988f //x=7.455 //y=1.555
c991 ( 183 0 ) capacitor c=0.0148531f //x=7.455 //y=0.935
c992 ( 182 0 ) capacitor c=0.0334406f //x=7.085 //y=1.4
c993 ( 181 0 ) capacitor c=0.0173191f //x=7.085 //y=1.09
c994 ( 180 0 ) capacitor c=0.110296f //x=75.27 //y=6.2
c995 ( 179 0 ) capacitor c=0.110214f //x=74.83 //y=6.2
c996 ( 178 0 ) capacitor c=0.110229f //x=65.65 //y=6.2
c997 ( 177 0 ) capacitor c=0.110235f //x=65.21 //y=6.2
c998 ( 176 0 ) capacitor c=0.110208f //x=46.41 //y=6.2
c999 ( 175 0 ) capacitor c=0.110214f //x=45.97 //y=6.2
c1000 ( 174 0 ) capacitor c=0.110293f //x=36.79 //y=6.2
c1001 ( 173 0 ) capacitor c=0.110214f //x=36.35 //y=6.2
c1002 ( 172 0 ) capacitor c=0.110208f //x=17.55 //y=6.2
c1003 ( 171 0 ) capacitor c=0.110214f //x=17.11 //y=6.2
c1004 ( 170 0 ) capacitor c=0.110208f //x=7.93 //y=6.2
c1005 ( 169 0 ) capacitor c=0.110214f //x=7.49 //y=6.2
c1006 ( 159 0 ) capacitor c=0.00129935f //x=74.86 //y=4.88
c1007 ( 154 0 ) capacitor c=0.00121786f //x=74.86 //y=2.26
c1008 ( 149 0 ) capacitor c=0.00129936f //x=65.24 //y=4.88
c1009 ( 144 0 ) capacitor c=0.00121786f //x=65.24 //y=2.26
c1010 ( 139 0 ) capacitor c=0.00129935f //x=46 //y=4.88
c1011 ( 134 0 ) capacitor c=0.00121786f //x=46 //y=2.26
c1012 ( 129 0 ) capacitor c=0.00129935f //x=36.38 //y=4.88
c1013 ( 124 0 ) capacitor c=0.00121786f //x=36.38 //y=2.26
c1014 ( 119 0 ) capacitor c=0.00129935f //x=17.14 //y=4.88
c1015 ( 114 0 ) capacitor c=0.00121786f //x=17.14 //y=2.26
c1016 ( 109 0 ) capacitor c=0.00129935f //x=7.52 //y=4.88
c1017 ( 104 0 ) capacitor c=0.00121786f //x=7.52 //y=2.26
c1018 ( 100 0 ) capacitor c=0.00135422f //x=74.865 //y=4.62
c1019 ( 91 0 ) capacitor c=0.00155f //x=36.375 //y=4.62
c1020 ( 86 0 ) capacitor c=0.00466776f //x=17.145 //y=4.62
c1021 ( 83 0 ) capacitor c=0.0105362f //x=7.515 //y=4.62
c1022 ( 82 0 ) capacitor c=0.0727985f //x=65.395 //y=4.62
c1023 ( 81 0 ) capacitor c=0.0884716f //x=74.705 //y=4.62
c1024 ( 80 0 ) capacitor c=0.123854f //x=59.19 //y=4.635
c1025 ( 79 0 ) capacitor c=0.00143977f //x=59.535 //y=4.635
c1026 ( 77 0 ) capacitor c=0.0879978f //x=45.845 //y=4.62
c1027 ( 75 0 ) capacitor c=0.346491f //x=36.215 //y=4.62
c1028 ( 73 0 ) capacitor c=0.232869f //x=16.985 //y=4.62
c1029 ( 70 0 ) capacitor c=0.00773203f //x=74.865 //y=4.835
c1030 ( 64 0 ) capacitor c=0.00797683f //x=65.235 //y=4.835
c1031 ( 58 0 ) capacitor c=0.00773203f //x=46.005 //y=4.835
c1032 ( 52 0 ) capacitor c=0.00786073f //x=36.375 //y=4.835
c1033 ( 46 0 ) capacitor c=0.0077588f //x=17.145 //y=4.835
c1034 ( 40 0 ) capacitor c=0.00779217f //x=7.515 //y=4.835
c1035 ( 33 0 ) capacitor c=0.00378707f //x=74.86 //y=2.375
c1036 ( 30 0 ) capacitor c=0.00380207f //x=65.24 //y=2.375
c1037 ( 26 0 ) capacitor c=0.00378707f //x=46 //y=2.375
c1038 ( 22 0 ) capacitor c=0.00380207f //x=36.38 //y=2.375
c1039 ( 18 0 ) capacitor c=0.00378707f //x=17.14 //y=2.375
c1040 ( 13 0 ) capacitor c=0.00380207f //x=7.52 //y=2.375
c1041 ( 11 0 ) capacitor c=0.0615601f //x=74.86 //y=2.77
c1042 ( 10 0 ) capacitor c=0.0599742f //x=65.24 //y=4.62
c1043 ( 8 0 ) capacitor c=0.0617495f //x=46 //y=2.77
c1044 ( 6 0 ) capacitor c=0.0604932f //x=36.38 //y=3.88
c1045 ( 4 0 ) capacitor c=0.0617495f //x=17.14 //y=2.77
c1046 ( 1 0 ) capacitor c=0.0633306f //x=7.52 //y=3.14
r1047 (  355 356 ) resistor r=32.4568 //w=0.214 //l=0.075 //layer=ply \
 //thickness=0.18 //x=74.86 //y=4.97 //x2=74.86 //y2=5.045
r1048 (  353 355 ) resistor r=20.271 //w=0.214 //l=0.09 //layer=ply \
 //thickness=0.18 //x=74.86 //y=4.88 //x2=74.86 //y2=4.97
r1049 (  344 345 ) resistor r=32.4568 //w=0.214 //l=0.075 //layer=ply \
 //thickness=0.18 //x=65.24 //y=4.97 //x2=65.24 //y2=5.045
r1050 (  342 344 ) resistor r=20.271 //w=0.214 //l=0.09 //layer=ply \
 //thickness=0.18 //x=65.24 //y=4.88 //x2=65.24 //y2=4.97
r1051 (  333 334 ) resistor r=32.4568 //w=0.214 //l=0.075 //layer=ply \
 //thickness=0.18 //x=46 //y=4.97 //x2=46 //y2=5.045
r1052 (  331 333 ) resistor r=20.271 //w=0.214 //l=0.09 //layer=ply \
 //thickness=0.18 //x=46 //y=4.88 //x2=46 //y2=4.97
r1053 (  322 323 ) resistor r=32.4568 //w=0.214 //l=0.075 //layer=ply \
 //thickness=0.18 //x=36.38 //y=4.97 //x2=36.38 //y2=5.045
r1054 (  320 322 ) resistor r=20.271 //w=0.214 //l=0.09 //layer=ply \
 //thickness=0.18 //x=36.38 //y=4.88 //x2=36.38 //y2=4.97
r1055 (  311 312 ) resistor r=32.4568 //w=0.214 //l=0.075 //layer=ply \
 //thickness=0.18 //x=17.14 //y=4.97 //x2=17.14 //y2=5.045
r1056 (  309 311 ) resistor r=20.271 //w=0.214 //l=0.09 //layer=ply \
 //thickness=0.18 //x=17.14 //y=4.88 //x2=17.14 //y2=4.97
r1057 (  300 301 ) resistor r=32.4568 //w=0.214 //l=0.075 //layer=ply \
 //thickness=0.18 //x=7.52 //y=4.97 //x2=7.52 //y2=5.045
r1058 (  298 300 ) resistor r=20.271 //w=0.214 //l=0.09 //layer=ply \
 //thickness=0.18 //x=7.52 //y=4.88 //x2=7.52 //y2=4.97
r1059 (  291 355 ) resistor r=16.5046 //w=0.27 //l=0.135 //layer=ply \
 //thickness=0.18 //x=74.995 //y=4.97 //x2=74.86 //y2=4.97
r1060 (  290 292 ) resistor r=26.9307 //w=0.15 //l=0.106066 //layer=ply \
 //thickness=0.18 //x=75.195 //y=4.97 //x2=75.27 //y2=5.045
r1061 (  290 291 ) resistor r=102.553 //w=0.094 //l=0.2 //layer=ply \
 //thickness=0.18 //x=75.195 //y=4.97 //x2=74.995 //y2=4.97
r1062 (  289 360 ) resistor r=38.6777 //w=0.284 //l=0.198997 //layer=ply \
 //thickness=0.18 //x=74.95 //y=2.095 //x2=74.875 //y2=2.26
r1063 (  288 358 ) resistor r=21.2976 //w=0.217 //l=0.0928709 //layer=ply \
 //thickness=0.18 //x=74.95 //y=1.63 //x2=74.91 //y2=1.555
r1064 (  288 289 ) resistor r=238.436 //w=0.094 //l=0.465 //layer=ply \
 //thickness=0.18 //x=74.95 //y=1.63 //x2=74.95 //y2=2.095
r1065 (  287 358 ) resistor r=39.0671 //w=0.217 //l=0.173853 //layer=ply \
 //thickness=0.18 //x=74.95 //y=1.4 //x2=74.91 //y2=1.555
r1066 (  286 357 ) resistor r=45.1352 //w=0.168 //l=0.173853 //layer=ply \
 //thickness=0.18 //x=74.95 //y=1.09 //x2=74.91 //y2=0.935
r1067 (  286 287 ) resistor r=158.957 //w=0.094 //l=0.31 //layer=ply \
 //thickness=0.18 //x=74.95 //y=1.09 //x2=74.95 //y2=1.4
r1068 (  281 351 ) resistor r=5.52526 //w=0.168 //l=0.115 //layer=ply \
 //thickness=0.18 //x=74.58 //y=1.555 //x2=74.465 //y2=1.555
r1069 (  280 358 ) resistor r=11.4558 //w=0.217 //l=0.115 //layer=ply \
 //thickness=0.18 //x=74.795 //y=1.555 //x2=74.91 //y2=1.555
r1070 (  279 350 ) resistor r=5.52526 //w=0.168 //l=0.115 //layer=ply \
 //thickness=0.18 //x=74.58 //y=0.935 //x2=74.465 //y2=0.935
r1071 (  278 357 ) resistor r=5.52526 //w=0.168 //l=0.115 //layer=ply \
 //thickness=0.18 //x=74.795 //y=0.935 //x2=74.91 //y2=0.935
r1072 (  278 279 ) resistor r=110.245 //w=0.094 //l=0.215 //layer=ply \
 //thickness=0.18 //x=74.795 //y=0.935 //x2=74.58 //y2=0.935
r1073 (  277 351 ) resistor r=45.1352 //w=0.168 //l=0.173853 //layer=ply \
 //thickness=0.18 //x=74.425 //y=1.4 //x2=74.465 //y2=1.555
r1074 (  276 350 ) resistor r=45.1352 //w=0.168 //l=0.173853 //layer=ply \
 //thickness=0.18 //x=74.425 //y=1.09 //x2=74.465 //y2=0.935
r1075 (  276 277 ) resistor r=158.957 //w=0.094 //l=0.31 //layer=ply \
 //thickness=0.18 //x=74.425 //y=1.09 //x2=74.425 //y2=1.4
r1076 (  272 344 ) resistor r=16.5046 //w=0.27 //l=0.135 //layer=ply \
 //thickness=0.18 //x=65.375 //y=4.97 //x2=65.24 //y2=4.97
r1077 (  271 273 ) resistor r=26.9307 //w=0.15 //l=0.106066 //layer=ply \
 //thickness=0.18 //x=65.575 //y=4.97 //x2=65.65 //y2=5.045
r1078 (  271 272 ) resistor r=102.553 //w=0.094 //l=0.2 //layer=ply \
 //thickness=0.18 //x=65.575 //y=4.97 //x2=65.375 //y2=4.97
r1079 (  270 349 ) resistor r=38.6777 //w=0.284 //l=0.198997 //layer=ply \
 //thickness=0.18 //x=65.33 //y=2.095 //x2=65.255 //y2=2.26
r1080 (  269 347 ) resistor r=21.2976 //w=0.217 //l=0.0928709 //layer=ply \
 //thickness=0.18 //x=65.33 //y=1.63 //x2=65.29 //y2=1.555
r1081 (  269 270 ) resistor r=238.436 //w=0.094 //l=0.465 //layer=ply \
 //thickness=0.18 //x=65.33 //y=1.63 //x2=65.33 //y2=2.095
r1082 (  268 347 ) resistor r=39.0671 //w=0.217 //l=0.173853 //layer=ply \
 //thickness=0.18 //x=65.33 //y=1.4 //x2=65.29 //y2=1.555
r1083 (  267 346 ) resistor r=45.1352 //w=0.168 //l=0.173853 //layer=ply \
 //thickness=0.18 //x=65.33 //y=1.09 //x2=65.29 //y2=0.935
r1084 (  267 268 ) resistor r=158.957 //w=0.094 //l=0.31 //layer=ply \
 //thickness=0.18 //x=65.33 //y=1.09 //x2=65.33 //y2=1.4
r1085 (  262 340 ) resistor r=5.52526 //w=0.168 //l=0.115 //layer=ply \
 //thickness=0.18 //x=64.96 //y=1.555 //x2=64.845 //y2=1.555
r1086 (  261 347 ) resistor r=11.4558 //w=0.217 //l=0.115 //layer=ply \
 //thickness=0.18 //x=65.175 //y=1.555 //x2=65.29 //y2=1.555
r1087 (  260 339 ) resistor r=5.52526 //w=0.168 //l=0.115 //layer=ply \
 //thickness=0.18 //x=64.96 //y=0.935 //x2=64.845 //y2=0.935
r1088 (  259 346 ) resistor r=5.52526 //w=0.168 //l=0.115 //layer=ply \
 //thickness=0.18 //x=65.175 //y=0.935 //x2=65.29 //y2=0.935
r1089 (  259 260 ) resistor r=110.245 //w=0.094 //l=0.215 //layer=ply \
 //thickness=0.18 //x=65.175 //y=0.935 //x2=64.96 //y2=0.935
r1090 (  258 340 ) resistor r=45.1352 //w=0.168 //l=0.173853 //layer=ply \
 //thickness=0.18 //x=64.805 //y=1.4 //x2=64.845 //y2=1.555
r1091 (  257 339 ) resistor r=45.1352 //w=0.168 //l=0.173853 //layer=ply \
 //thickness=0.18 //x=64.805 //y=1.09 //x2=64.845 //y2=0.935
r1092 (  257 258 ) resistor r=158.957 //w=0.094 //l=0.31 //layer=ply \
 //thickness=0.18 //x=64.805 //y=1.09 //x2=64.805 //y2=1.4
r1093 (  253 333 ) resistor r=16.5046 //w=0.27 //l=0.135 //layer=ply \
 //thickness=0.18 //x=46.135 //y=4.97 //x2=46 //y2=4.97
r1094 (  252 254 ) resistor r=26.9307 //w=0.15 //l=0.106066 //layer=ply \
 //thickness=0.18 //x=46.335 //y=4.97 //x2=46.41 //y2=5.045
r1095 (  252 253 ) resistor r=102.553 //w=0.094 //l=0.2 //layer=ply \
 //thickness=0.18 //x=46.335 //y=4.97 //x2=46.135 //y2=4.97
r1096 (  251 338 ) resistor r=38.6777 //w=0.284 //l=0.198997 //layer=ply \
 //thickness=0.18 //x=46.09 //y=2.095 //x2=46.015 //y2=2.26
r1097 (  250 336 ) resistor r=21.2976 //w=0.217 //l=0.0928709 //layer=ply \
 //thickness=0.18 //x=46.09 //y=1.63 //x2=46.05 //y2=1.555
r1098 (  250 251 ) resistor r=238.436 //w=0.094 //l=0.465 //layer=ply \
 //thickness=0.18 //x=46.09 //y=1.63 //x2=46.09 //y2=2.095
r1099 (  249 336 ) resistor r=39.0671 //w=0.217 //l=0.173853 //layer=ply \
 //thickness=0.18 //x=46.09 //y=1.4 //x2=46.05 //y2=1.555
r1100 (  248 335 ) resistor r=45.1352 //w=0.168 //l=0.173853 //layer=ply \
 //thickness=0.18 //x=46.09 //y=1.09 //x2=46.05 //y2=0.935
r1101 (  248 249 ) resistor r=158.957 //w=0.094 //l=0.31 //layer=ply \
 //thickness=0.18 //x=46.09 //y=1.09 //x2=46.09 //y2=1.4
r1102 (  243 329 ) resistor r=5.52526 //w=0.168 //l=0.115 //layer=ply \
 //thickness=0.18 //x=45.72 //y=1.555 //x2=45.605 //y2=1.555
r1103 (  242 336 ) resistor r=11.4558 //w=0.217 //l=0.115 //layer=ply \
 //thickness=0.18 //x=45.935 //y=1.555 //x2=46.05 //y2=1.555
r1104 (  241 328 ) resistor r=5.52526 //w=0.168 //l=0.115 //layer=ply \
 //thickness=0.18 //x=45.72 //y=0.935 //x2=45.605 //y2=0.935
r1105 (  240 335 ) resistor r=5.52526 //w=0.168 //l=0.115 //layer=ply \
 //thickness=0.18 //x=45.935 //y=0.935 //x2=46.05 //y2=0.935
r1106 (  240 241 ) resistor r=110.245 //w=0.094 //l=0.215 //layer=ply \
 //thickness=0.18 //x=45.935 //y=0.935 //x2=45.72 //y2=0.935
r1107 (  239 329 ) resistor r=45.1352 //w=0.168 //l=0.173853 //layer=ply \
 //thickness=0.18 //x=45.565 //y=1.4 //x2=45.605 //y2=1.555
r1108 (  238 328 ) resistor r=45.1352 //w=0.168 //l=0.173853 //layer=ply \
 //thickness=0.18 //x=45.565 //y=1.09 //x2=45.605 //y2=0.935
r1109 (  238 239 ) resistor r=158.957 //w=0.094 //l=0.31 //layer=ply \
 //thickness=0.18 //x=45.565 //y=1.09 //x2=45.565 //y2=1.4
r1110 (  234 322 ) resistor r=16.5046 //w=0.27 //l=0.135 //layer=ply \
 //thickness=0.18 //x=36.515 //y=4.97 //x2=36.38 //y2=4.97
r1111 (  233 235 ) resistor r=26.9307 //w=0.15 //l=0.106066 //layer=ply \
 //thickness=0.18 //x=36.715 //y=4.97 //x2=36.79 //y2=5.045
r1112 (  233 234 ) resistor r=102.553 //w=0.094 //l=0.2 //layer=ply \
 //thickness=0.18 //x=36.715 //y=4.97 //x2=36.515 //y2=4.97
r1113 (  232 327 ) resistor r=38.6777 //w=0.284 //l=0.198997 //layer=ply \
 //thickness=0.18 //x=36.47 //y=2.095 //x2=36.395 //y2=2.26
r1114 (  231 325 ) resistor r=21.2976 //w=0.217 //l=0.0928709 //layer=ply \
 //thickness=0.18 //x=36.47 //y=1.63 //x2=36.43 //y2=1.555
r1115 (  231 232 ) resistor r=238.436 //w=0.094 //l=0.465 //layer=ply \
 //thickness=0.18 //x=36.47 //y=1.63 //x2=36.47 //y2=2.095
r1116 (  230 325 ) resistor r=39.0671 //w=0.217 //l=0.173853 //layer=ply \
 //thickness=0.18 //x=36.47 //y=1.4 //x2=36.43 //y2=1.555
r1117 (  229 324 ) resistor r=45.1352 //w=0.168 //l=0.173853 //layer=ply \
 //thickness=0.18 //x=36.47 //y=1.09 //x2=36.43 //y2=0.935
r1118 (  229 230 ) resistor r=158.957 //w=0.094 //l=0.31 //layer=ply \
 //thickness=0.18 //x=36.47 //y=1.09 //x2=36.47 //y2=1.4
r1119 (  224 318 ) resistor r=5.52526 //w=0.168 //l=0.115 //layer=ply \
 //thickness=0.18 //x=36.1 //y=1.555 //x2=35.985 //y2=1.555
r1120 (  223 325 ) resistor r=11.4558 //w=0.217 //l=0.115 //layer=ply \
 //thickness=0.18 //x=36.315 //y=1.555 //x2=36.43 //y2=1.555
r1121 (  222 317 ) resistor r=5.52526 //w=0.168 //l=0.115 //layer=ply \
 //thickness=0.18 //x=36.1 //y=0.935 //x2=35.985 //y2=0.935
r1122 (  221 324 ) resistor r=5.52526 //w=0.168 //l=0.115 //layer=ply \
 //thickness=0.18 //x=36.315 //y=0.935 //x2=36.43 //y2=0.935
r1123 (  221 222 ) resistor r=110.245 //w=0.094 //l=0.215 //layer=ply \
 //thickness=0.18 //x=36.315 //y=0.935 //x2=36.1 //y2=0.935
r1124 (  220 318 ) resistor r=45.1352 //w=0.168 //l=0.173853 //layer=ply \
 //thickness=0.18 //x=35.945 //y=1.4 //x2=35.985 //y2=1.555
r1125 (  219 317 ) resistor r=45.1352 //w=0.168 //l=0.173853 //layer=ply \
 //thickness=0.18 //x=35.945 //y=1.09 //x2=35.985 //y2=0.935
r1126 (  219 220 ) resistor r=158.957 //w=0.094 //l=0.31 //layer=ply \
 //thickness=0.18 //x=35.945 //y=1.09 //x2=35.945 //y2=1.4
r1127 (  215 311 ) resistor r=16.5046 //w=0.27 //l=0.135 //layer=ply \
 //thickness=0.18 //x=17.275 //y=4.97 //x2=17.14 //y2=4.97
r1128 (  214 216 ) resistor r=26.9307 //w=0.15 //l=0.106066 //layer=ply \
 //thickness=0.18 //x=17.475 //y=4.97 //x2=17.55 //y2=5.045
r1129 (  214 215 ) resistor r=102.553 //w=0.094 //l=0.2 //layer=ply \
 //thickness=0.18 //x=17.475 //y=4.97 //x2=17.275 //y2=4.97
r1130 (  213 316 ) resistor r=38.6777 //w=0.284 //l=0.198997 //layer=ply \
 //thickness=0.18 //x=17.23 //y=2.095 //x2=17.155 //y2=2.26
r1131 (  212 314 ) resistor r=21.2976 //w=0.217 //l=0.0928709 //layer=ply \
 //thickness=0.18 //x=17.23 //y=1.63 //x2=17.19 //y2=1.555
r1132 (  212 213 ) resistor r=238.436 //w=0.094 //l=0.465 //layer=ply \
 //thickness=0.18 //x=17.23 //y=1.63 //x2=17.23 //y2=2.095
r1133 (  211 314 ) resistor r=39.0671 //w=0.217 //l=0.173853 //layer=ply \
 //thickness=0.18 //x=17.23 //y=1.4 //x2=17.19 //y2=1.555
r1134 (  210 313 ) resistor r=45.1352 //w=0.168 //l=0.173853 //layer=ply \
 //thickness=0.18 //x=17.23 //y=1.09 //x2=17.19 //y2=0.935
r1135 (  210 211 ) resistor r=158.957 //w=0.094 //l=0.31 //layer=ply \
 //thickness=0.18 //x=17.23 //y=1.09 //x2=17.23 //y2=1.4
r1136 (  205 307 ) resistor r=5.52526 //w=0.168 //l=0.115 //layer=ply \
 //thickness=0.18 //x=16.86 //y=1.555 //x2=16.745 //y2=1.555
r1137 (  204 314 ) resistor r=11.4558 //w=0.217 //l=0.115 //layer=ply \
 //thickness=0.18 //x=17.075 //y=1.555 //x2=17.19 //y2=1.555
r1138 (  203 306 ) resistor r=5.52526 //w=0.168 //l=0.115 //layer=ply \
 //thickness=0.18 //x=16.86 //y=0.935 //x2=16.745 //y2=0.935
r1139 (  202 313 ) resistor r=5.52526 //w=0.168 //l=0.115 //layer=ply \
 //thickness=0.18 //x=17.075 //y=0.935 //x2=17.19 //y2=0.935
r1140 (  202 203 ) resistor r=110.245 //w=0.094 //l=0.215 //layer=ply \
 //thickness=0.18 //x=17.075 //y=0.935 //x2=16.86 //y2=0.935
r1141 (  201 307 ) resistor r=45.1352 //w=0.168 //l=0.173853 //layer=ply \
 //thickness=0.18 //x=16.705 //y=1.4 //x2=16.745 //y2=1.555
r1142 (  200 306 ) resistor r=45.1352 //w=0.168 //l=0.173853 //layer=ply \
 //thickness=0.18 //x=16.705 //y=1.09 //x2=16.745 //y2=0.935
r1143 (  200 201 ) resistor r=158.957 //w=0.094 //l=0.31 //layer=ply \
 //thickness=0.18 //x=16.705 //y=1.09 //x2=16.705 //y2=1.4
r1144 (  196 300 ) resistor r=16.5046 //w=0.27 //l=0.135 //layer=ply \
 //thickness=0.18 //x=7.655 //y=4.97 //x2=7.52 //y2=4.97
r1145 (  195 197 ) resistor r=26.9307 //w=0.15 //l=0.106066 //layer=ply \
 //thickness=0.18 //x=7.855 //y=4.97 //x2=7.93 //y2=5.045
r1146 (  195 196 ) resistor r=102.553 //w=0.094 //l=0.2 //layer=ply \
 //thickness=0.18 //x=7.855 //y=4.97 //x2=7.655 //y2=4.97
r1147 (  194 305 ) resistor r=38.6777 //w=0.284 //l=0.198997 //layer=ply \
 //thickness=0.18 //x=7.61 //y=2.095 //x2=7.535 //y2=2.26
r1148 (  193 303 ) resistor r=21.2976 //w=0.217 //l=0.0928709 //layer=ply \
 //thickness=0.18 //x=7.61 //y=1.63 //x2=7.57 //y2=1.555
r1149 (  193 194 ) resistor r=238.436 //w=0.094 //l=0.465 //layer=ply \
 //thickness=0.18 //x=7.61 //y=1.63 //x2=7.61 //y2=2.095
r1150 (  192 303 ) resistor r=39.0671 //w=0.217 //l=0.173853 //layer=ply \
 //thickness=0.18 //x=7.61 //y=1.4 //x2=7.57 //y2=1.555
r1151 (  191 302 ) resistor r=45.1352 //w=0.168 //l=0.173853 //layer=ply \
 //thickness=0.18 //x=7.61 //y=1.09 //x2=7.57 //y2=0.935
r1152 (  191 192 ) resistor r=158.957 //w=0.094 //l=0.31 //layer=ply \
 //thickness=0.18 //x=7.61 //y=1.09 //x2=7.61 //y2=1.4
r1153 (  186 296 ) resistor r=5.52526 //w=0.168 //l=0.115 //layer=ply \
 //thickness=0.18 //x=7.24 //y=1.555 //x2=7.125 //y2=1.555
r1154 (  185 303 ) resistor r=11.4558 //w=0.217 //l=0.115 //layer=ply \
 //thickness=0.18 //x=7.455 //y=1.555 //x2=7.57 //y2=1.555
r1155 (  184 295 ) resistor r=5.52526 //w=0.168 //l=0.115 //layer=ply \
 //thickness=0.18 //x=7.24 //y=0.935 //x2=7.125 //y2=0.935
r1156 (  183 302 ) resistor r=5.52526 //w=0.168 //l=0.115 //layer=ply \
 //thickness=0.18 //x=7.455 //y=0.935 //x2=7.57 //y2=0.935
r1157 (  183 184 ) resistor r=110.245 //w=0.094 //l=0.215 //layer=ply \
 //thickness=0.18 //x=7.455 //y=0.935 //x2=7.24 //y2=0.935
r1158 (  182 296 ) resistor r=45.1352 //w=0.168 //l=0.173853 //layer=ply \
 //thickness=0.18 //x=7.085 //y=1.4 //x2=7.125 //y2=1.555
r1159 (  181 295 ) resistor r=45.1352 //w=0.168 //l=0.173853 //layer=ply \
 //thickness=0.18 //x=7.085 //y=1.09 //x2=7.125 //y2=0.935
r1160 (  181 182 ) resistor r=158.957 //w=0.094 //l=0.31 //layer=ply \
 //thickness=0.18 //x=7.085 //y=1.09 //x2=7.085 //y2=1.4
r1161 (  180 292 ) resistor r=592.245 //w=0.094 //l=1.155 //layer=ply \
 //thickness=0.18 //x=75.27 //y=6.2 //x2=75.27 //y2=5.045
r1162 (  179 356 ) resistor r=592.245 //w=0.094 //l=1.155 //layer=ply \
 //thickness=0.18 //x=74.83 //y=6.2 //x2=74.83 //y2=5.045
r1163 (  178 273 ) resistor r=592.245 //w=0.094 //l=1.155 //layer=ply \
 //thickness=0.18 //x=65.65 //y=6.2 //x2=65.65 //y2=5.045
r1164 (  177 345 ) resistor r=592.245 //w=0.094 //l=1.155 //layer=ply \
 //thickness=0.18 //x=65.21 //y=6.2 //x2=65.21 //y2=5.045
r1165 (  176 254 ) resistor r=592.245 //w=0.094 //l=1.155 //layer=ply \
 //thickness=0.18 //x=46.41 //y=6.2 //x2=46.41 //y2=5.045
r1166 (  175 334 ) resistor r=592.245 //w=0.094 //l=1.155 //layer=ply \
 //thickness=0.18 //x=45.97 //y=6.2 //x2=45.97 //y2=5.045
r1167 (  174 235 ) resistor r=592.245 //w=0.094 //l=1.155 //layer=ply \
 //thickness=0.18 //x=36.79 //y=6.2 //x2=36.79 //y2=5.045
r1168 (  173 323 ) resistor r=592.245 //w=0.094 //l=1.155 //layer=ply \
 //thickness=0.18 //x=36.35 //y=6.2 //x2=36.35 //y2=5.045
r1169 (  172 216 ) resistor r=592.245 //w=0.094 //l=1.155 //layer=ply \
 //thickness=0.18 //x=17.55 //y=6.2 //x2=17.55 //y2=5.045
r1170 (  171 312 ) resistor r=592.245 //w=0.094 //l=1.155 //layer=ply \
 //thickness=0.18 //x=17.11 //y=6.2 //x2=17.11 //y2=5.045
r1171 (  170 197 ) resistor r=592.245 //w=0.094 //l=1.155 //layer=ply \
 //thickness=0.18 //x=7.93 //y=6.2 //x2=7.93 //y2=5.045
r1172 (  169 301 ) resistor r=592.245 //w=0.094 //l=1.155 //layer=ply \
 //thickness=0.18 //x=7.49 //y=6.2 //x2=7.49 //y2=5.045
r1173 (  168 280 ) resistor r=55.3787 //w=0.094 //l=0.108 //layer=ply \
 //thickness=0.18 //x=74.687 //y=1.555 //x2=74.795 //y2=1.555
r1174 (  168 281 ) resistor r=54.866 //w=0.094 //l=0.107 //layer=ply \
 //thickness=0.18 //x=74.687 //y=1.555 //x2=74.58 //y2=1.555
r1175 (  167 261 ) resistor r=55.3787 //w=0.094 //l=0.108 //layer=ply \
 //thickness=0.18 //x=65.067 //y=1.555 //x2=65.175 //y2=1.555
r1176 (  167 262 ) resistor r=54.866 //w=0.094 //l=0.107 //layer=ply \
 //thickness=0.18 //x=65.067 //y=1.555 //x2=64.96 //y2=1.555
r1177 (  166 242 ) resistor r=55.3787 //w=0.094 //l=0.108 //layer=ply \
 //thickness=0.18 //x=45.827 //y=1.555 //x2=45.935 //y2=1.555
r1178 (  166 243 ) resistor r=54.866 //w=0.094 //l=0.107 //layer=ply \
 //thickness=0.18 //x=45.827 //y=1.555 //x2=45.72 //y2=1.555
r1179 (  165 223 ) resistor r=55.3787 //w=0.094 //l=0.108 //layer=ply \
 //thickness=0.18 //x=36.207 //y=1.555 //x2=36.315 //y2=1.555
r1180 (  165 224 ) resistor r=54.866 //w=0.094 //l=0.107 //layer=ply \
 //thickness=0.18 //x=36.207 //y=1.555 //x2=36.1 //y2=1.555
r1181 (  164 204 ) resistor r=55.3787 //w=0.094 //l=0.108 //layer=ply \
 //thickness=0.18 //x=16.967 //y=1.555 //x2=17.075 //y2=1.555
r1182 (  164 205 ) resistor r=54.866 //w=0.094 //l=0.107 //layer=ply \
 //thickness=0.18 //x=16.967 //y=1.555 //x2=16.86 //y2=1.555
r1183 (  163 185 ) resistor r=55.3787 //w=0.094 //l=0.108 //layer=ply \
 //thickness=0.18 //x=7.347 //y=1.555 //x2=7.455 //y2=1.555
r1184 (  163 186 ) resistor r=54.866 //w=0.094 //l=0.107 //layer=ply \
 //thickness=0.18 //x=7.347 //y=1.555 //x2=7.24 //y2=1.555
r1185 (  159 353 ) resistor r=152 //w=0.17 //l=0.17 //layer=licon //count=1 \
 //x=74.86 //y=4.88 //x2=74.86 //y2=4.88
r1186 (  154 360 ) resistor r=152 //w=0.17 //l=0.17 //layer=licon //count=1 \
 //x=74.86 //y=2.26 //x2=74.86 //y2=2.26
r1187 (  149 342 ) resistor r=152 //w=0.17 //l=0.17 //layer=licon //count=1 \
 //x=65.24 //y=4.88 //x2=65.24 //y2=4.88
r1188 (  144 349 ) resistor r=152 //w=0.17 //l=0.17 //layer=licon //count=1 \
 //x=65.24 //y=2.26 //x2=65.24 //y2=2.26
r1189 (  139 331 ) resistor r=152 //w=0.17 //l=0.17 //layer=licon //count=1 \
 //x=46 //y=4.88 //x2=46 //y2=4.88
r1190 (  134 338 ) resistor r=152 //w=0.17 //l=0.17 //layer=licon //count=1 \
 //x=46 //y=2.26 //x2=46 //y2=2.26
r1191 (  129 320 ) resistor r=152 //w=0.17 //l=0.17 //layer=licon //count=1 \
 //x=36.38 //y=4.88 //x2=36.38 //y2=4.88
r1192 (  124 327 ) resistor r=152 //w=0.17 //l=0.17 //layer=licon //count=1 \
 //x=36.38 //y=2.26 //x2=36.38 //y2=2.26
r1193 (  119 309 ) resistor r=152 //w=0.17 //l=0.17 //layer=licon //count=1 \
 //x=17.14 //y=4.88 //x2=17.14 //y2=4.88
r1194 (  114 316 ) resistor r=152 //w=0.17 //l=0.17 //layer=licon //count=1 \
 //x=17.14 //y=2.26 //x2=17.14 //y2=2.26
r1195 (  109 298 ) resistor r=152 //w=0.17 //l=0.17 //layer=licon //count=1 \
 //x=7.52 //y=4.88 //x2=7.52 //y2=4.88
r1196 (  104 305 ) resistor r=152 //w=0.17 //l=0.17 //layer=licon //count=1 \
 //x=7.52 //y=2.26 //x2=7.52 //y2=2.26
r1197 (  100 102 ) resistor r=0.0911017 //w=0.295 //l=0.215 //layer=m2 \
 //thickness=0.36 //x=74.865 //y=4.62 //x2=74.865 //y2=4.835
r1198 (  91 94 ) resistor r=0.0956406 //w=0.281 //l=0.215 //layer=m2 \
 //thickness=0.36 //x=36.375 //y=4.62 //x2=36.375 //y2=4.835
r1199 (  86 89 ) resistor r=0.0956406 //w=0.281 //l=0.215 //layer=m2 \
 //thickness=0.36 //x=17.145 //y=4.62 //x2=17.145 //y2=4.835
r1200 (  83 85 ) resistor r=0.0875407 //w=0.307 //l=0.215 //layer=m2 \
 //thickness=0.36 //x=7.515 //y=4.62 //x2=7.515 //y2=4.835
r1201 (  82 99 ) resistor r=0.108687 //w=0.186 //l=0.19799 //layer=m2 \
 //thickness=0.36 //x=65.395 //y=4.62 //x2=65.235 //y2=4.705
r1202 (  81 100 ) resistor r=0.040597 //w=0.295 //l=0.16 //layer=m2 \
 //thickness=0.36 //x=74.705 //y=4.62 //x2=74.865 //y2=4.62
r1203 (  81 82 ) resistor r=8.88359 //w=0.131 //l=9.31 //layer=m2 \
 //thickness=0.36 //x=74.705 //y=4.62 //x2=65.395 //y2=4.62
r1204 (  80 97 ) resistor r=9.31144 //w=0.177 //l=13.22 //layer=m2 \
 //thickness=0.36 //x=59.19 //y=4.635 //x2=46.005 //y2=4.705
r1205 (  79 99 ) resistor r=3.83181 //w=0.186 //l=5.73489 //layer=m2 \
 //thickness=0.36 //x=59.535 //y=4.635 //x2=65.235 //y2=4.705
r1206 (  79 80 ) resistor r=0.329198 //w=0.131 //l=0.345 //layer=m2 \
 //thickness=0.36 //x=59.535 //y=4.635 //x2=59.19 //y2=4.635
r1207 (  78 91 ) resistor r=0.0455071 //w=0.32 //l=0.16 //layer=m2 \
 //thickness=0.36 //x=36.535 //y=4.62 //x2=36.375 //y2=4.62
r1208 (  77 97 ) resistor r=0.112994 //w=0.177 //l=0.19799 //layer=m2 \
 //thickness=0.36 //x=45.845 //y=4.62 //x2=46.005 //y2=4.705
r1209 (  77 78 ) resistor r=8.88359 //w=0.131 //l=9.31 //layer=m2 \
 //thickness=0.36 //x=45.845 //y=4.62 //x2=36.535 //y2=4.62
r1210 (  76 86 ) resistor r=0.0455071 //w=0.32 //l=0.16 //layer=m2 \
 //thickness=0.36 //x=17.305 //y=4.62 //x2=17.145 //y2=4.62
r1211 (  75 91 ) resistor r=0.0455071 //w=0.32 //l=0.16 //layer=m2 \
 //thickness=0.36 //x=36.215 //y=4.62 //x2=36.375 //y2=4.62
r1212 (  75 76 ) resistor r=18.0439 //w=0.131 //l=18.91 //layer=m2 \
 //thickness=0.36 //x=36.215 //y=4.62 //x2=17.305 //y2=4.62
r1213 (  74 83 ) resistor r=0.0429992 //w=0.307 //l=0.16 //layer=m2 \
 //thickness=0.36 //x=7.675 //y=4.62 //x2=7.515 //y2=4.62
r1214 (  73 86 ) resistor r=0.0455071 //w=0.32 //l=0.16 //layer=m2 \
 //thickness=0.36 //x=16.985 //y=4.62 //x2=17.145 //y2=4.62
r1215 (  73 74 ) resistor r=8.88359 //w=0.131 //l=9.31 //layer=m2 \
 //thickness=0.36 //x=16.985 //y=4.62 //x2=7.675 //y2=4.62
r1216 (  72 159 ) resistor r=9.3 //w=0.17 //l=0.17 //layer=mcon //count=1 \
 //x=74.86 //y=4.88 //x2=74.86 //y2=4.88
r1217 (  70 102 ) resistor r=4.5 //w=0.15 //l=0.15 //layer=via1 //count=1 \
 //x=74.865 //y=4.835 //x2=74.865 //y2=4.835
r1218 (  70 72 ) resistor r=0.018263 //w=0.308 //l=0.045 //layer=m1 \
 //thickness=0.36 //x=74.865 //y=4.835 //x2=74.865 //y2=4.88
r1219 (  68 154 ) resistor r=9.3 //w=0.17 //l=0.17 //layer=mcon //count=1 \
 //x=74.86 //y=2.26 //x2=74.86 //y2=2.26
r1220 (  66 149 ) resistor r=9.3 //w=0.17 //l=0.17 //layer=mcon //count=1 \
 //x=65.24 //y=4.88 //x2=65.24 //y2=4.88
r1221 (  64 99 ) resistor r=4.5 //w=0.15 //l=0.15 //layer=via1 //count=1 \
 //x=65.235 //y=4.835 //x2=65.235 //y2=4.835
r1222 (  64 66 ) resistor r=0.018263 //w=0.308 //l=0.045 //layer=m1 \
 //thickness=0.36 //x=65.235 //y=4.835 //x2=65.235 //y2=4.88
r1223 (  62 144 ) resistor r=9.3 //w=0.17 //l=0.17 //layer=mcon //count=1 \
 //x=65.24 //y=2.26 //x2=65.24 //y2=2.26
r1224 (  60 139 ) resistor r=9.3 //w=0.17 //l=0.17 //layer=mcon //count=1 \
 //x=46 //y=4.88 //x2=46 //y2=4.88
r1225 (  58 97 ) resistor r=4.5 //w=0.15 //l=0.15 //layer=via1 //count=1 \
 //x=46.005 //y=4.835 //x2=46.005 //y2=4.835
r1226 (  58 60 ) resistor r=0.018263 //w=0.308 //l=0.045 //layer=m1 \
 //thickness=0.36 //x=46.005 //y=4.835 //x2=46.005 //y2=4.88
r1227 (  56 134 ) resistor r=9.3 //w=0.17 //l=0.17 //layer=mcon //count=1 \
 //x=46 //y=2.26 //x2=46 //y2=2.26
r1228 (  54 129 ) resistor r=9.3 //w=0.17 //l=0.17 //layer=mcon //count=1 \
 //x=36.38 //y=4.88 //x2=36.38 //y2=4.88
r1229 (  52 94 ) resistor r=4.5 //w=0.15 //l=0.15 //layer=via1 //count=1 \
 //x=36.375 //y=4.835 //x2=36.375 //y2=4.835
r1230 (  52 54 ) resistor r=0.018263 //w=0.308 //l=0.045 //layer=m1 \
 //thickness=0.36 //x=36.375 //y=4.835 //x2=36.375 //y2=4.88
r1231 (  50 124 ) resistor r=9.3 //w=0.17 //l=0.17 //layer=mcon //count=1 \
 //x=36.38 //y=2.26 //x2=36.38 //y2=2.26
r1232 (  48 119 ) resistor r=9.3 //w=0.17 //l=0.17 //layer=mcon //count=1 \
 //x=17.14 //y=4.88 //x2=17.14 //y2=4.88
r1233 (  46 89 ) resistor r=4.5 //w=0.15 //l=0.15 //layer=via1 //count=1 \
 //x=17.145 //y=4.835 //x2=17.145 //y2=4.835
r1234 (  46 48 ) resistor r=0.018263 //w=0.308 //l=0.045 //layer=m1 \
 //thickness=0.36 //x=17.145 //y=4.835 //x2=17.145 //y2=4.88
r1235 (  44 114 ) resistor r=9.3 //w=0.17 //l=0.17 //layer=mcon //count=1 \
 //x=17.14 //y=2.26 //x2=17.14 //y2=2.26
r1236 (  42 109 ) resistor r=9.3 //w=0.17 //l=0.17 //layer=mcon //count=1 \
 //x=7.52 //y=4.88 //x2=7.52 //y2=4.88
r1237 (  40 85 ) resistor r=4.5 //w=0.15 //l=0.15 //layer=via1 //count=1 \
 //x=7.515 //y=4.835 //x2=7.515 //y2=4.835
r1238 (  40 42 ) resistor r=0.018263 //w=0.308 //l=0.045 //layer=m1 \
 //thickness=0.36 //x=7.515 //y=4.835 //x2=7.515 //y2=4.88
r1239 (  38 104 ) resistor r=9.3 //w=0.17 //l=0.17 //layer=mcon //count=1 \
 //x=7.52 //y=2.26 //x2=7.52 //y2=2.26
r1240 (  34 70 ) resistor r=0.0898396 //w=0.308 //l=0.162481 //layer=m1 \
 //thickness=0.36 //x=74.86 //y=4.675 //x2=74.865 //y2=4.835
r1241 (  33 68 ) resistor r=0.0715665 //w=0.226 //l=0.115996 //layer=m1 \
 //thickness=0.36 //x=74.86 //y=2.375 //x2=74.862 //y2=2.26
r1242 (  31 64 ) resistor r=0.0898396 //w=0.308 //l=0.162481 //layer=m1 \
 //thickness=0.36 //x=65.24 //y=4.675 //x2=65.235 //y2=4.835
r1243 (  30 62 ) resistor r=0.0715665 //w=0.226 //l=0.115996 //layer=m1 \
 //thickness=0.36 //x=65.24 //y=2.375 //x2=65.242 //y2=2.26
r1244 (  27 58 ) resistor r=0.0898396 //w=0.308 //l=0.162481 //layer=m1 \
 //thickness=0.36 //x=46 //y=4.675 //x2=46.005 //y2=4.835
r1245 (  26 56 ) resistor r=0.0715665 //w=0.226 //l=0.115996 //layer=m1 \
 //thickness=0.36 //x=46 //y=2.375 //x2=46.002 //y2=2.26
r1246 (  23 52 ) resistor r=0.0898396 //w=0.308 //l=0.162481 //layer=m1 \
 //thickness=0.36 //x=36.38 //y=4.675 //x2=36.375 //y2=4.835
r1247 (  22 50 ) resistor r=0.0715665 //w=0.226 //l=0.115996 //layer=m1 \
 //thickness=0.36 //x=36.38 //y=2.375 //x2=36.382 //y2=2.26
r1248 (  19 46 ) resistor r=0.0898396 //w=0.308 //l=0.162481 //layer=m1 \
 //thickness=0.36 //x=17.14 //y=4.675 //x2=17.145 //y2=4.835
r1249 (  18 44 ) resistor r=0.0715665 //w=0.226 //l=0.115996 //layer=m1 \
 //thickness=0.36 //x=17.14 //y=2.375 //x2=17.142 //y2=2.26
r1250 (  14 40 ) resistor r=0.0898396 //w=0.308 //l=0.162481 //layer=m1 \
 //thickness=0.36 //x=7.52 //y=4.675 //x2=7.515 //y2=4.835
r1251 (  13 38 ) resistor r=0.0715665 //w=0.226 //l=0.115996 //layer=m1 \
 //thickness=0.36 //x=7.52 //y=2.375 //x2=7.522 //y2=2.26
r1252 (  12 34 ) resistor r=0.0524809 //w=0.131 //l=0.055 //layer=m1 \
 //thickness=0.36 //x=74.86 //y=4.62 //x2=74.86 //y2=4.675
r1253 (  11 12 ) resistor r=1.76527 //w=0.131 //l=1.85 //layer=m1 \
 //thickness=0.36 //x=74.86 //y=2.77 //x2=74.86 //y2=4.62
r1254 (  11 33 ) resistor r=0.376908 //w=0.131 //l=0.395 //layer=m1 \
 //thickness=0.36 //x=74.86 //y=2.77 //x2=74.86 //y2=2.375
r1255 (  10 31 ) resistor r=0.0524809 //w=0.131 //l=0.055 //layer=m1 \
 //thickness=0.36 //x=65.24 //y=4.62 //x2=65.24 //y2=4.675
r1256 (  10 30 ) resistor r=2.14218 //w=0.131 //l=2.245 //layer=m1 \
 //thickness=0.36 //x=65.24 //y=4.62 //x2=65.24 //y2=2.375
r1257 (  9 27 ) resistor r=0.0524809 //w=0.131 //l=0.055 //layer=m1 \
 //thickness=0.36 //x=46 //y=4.62 //x2=46 //y2=4.675
r1258 (  8 9 ) resistor r=1.76527 //w=0.131 //l=1.85 //layer=m1 \
 //thickness=0.36 //x=46 //y=2.77 //x2=46 //y2=4.62
r1259 (  8 26 ) resistor r=0.376908 //w=0.131 //l=0.395 //layer=m1 \
 //thickness=0.36 //x=46 //y=2.77 //x2=46 //y2=2.375
r1260 (  7 23 ) resistor r=0.0524809 //w=0.131 //l=0.055 //layer=m1 \
 //thickness=0.36 //x=36.38 //y=4.62 //x2=36.38 //y2=4.675
r1261 (  6 7 ) resistor r=0.706107 //w=0.131 //l=0.74 //layer=m1 \
 //thickness=0.36 //x=36.38 //y=3.88 //x2=36.38 //y2=4.62
r1262 (  6 22 ) resistor r=1.43607 //w=0.131 //l=1.505 //layer=m1 \
 //thickness=0.36 //x=36.38 //y=3.88 //x2=36.38 //y2=2.375
r1263 (  5 19 ) resistor r=0.0524809 //w=0.131 //l=0.055 //layer=m1 \
 //thickness=0.36 //x=17.14 //y=4.62 //x2=17.14 //y2=4.675
r1264 (  4 5 ) resistor r=1.76527 //w=0.131 //l=1.85 //layer=m1 \
 //thickness=0.36 //x=17.14 //y=2.77 //x2=17.14 //y2=4.62
r1265 (  4 18 ) resistor r=0.376908 //w=0.131 //l=0.395 //layer=m1 \
 //thickness=0.36 //x=17.14 //y=2.77 //x2=17.14 //y2=2.375
r1266 (  3 14 ) resistor r=0.0524809 //w=0.131 //l=0.055 //layer=m1 \
 //thickness=0.36 //x=7.52 //y=4.62 //x2=7.52 //y2=4.675
r1267 (  2 3 ) resistor r=0.706107 //w=0.131 //l=0.74 //layer=m1 \
 //thickness=0.36 //x=7.52 //y=3.88 //x2=7.52 //y2=4.62
r1268 (  1 2 ) resistor r=0.706107 //w=0.131 //l=0.74 //layer=m1 \
 //thickness=0.36 //x=7.52 //y=3.14 //x2=7.52 //y2=3.88
r1269 (  1 13 ) resistor r=0.729962 //w=0.131 //l=0.765 //layer=m1 \
 //thickness=0.36 //x=7.52 //y=3.14 //x2=7.52 //y2=2.375
ends PM_TMRDFFSNRNQX1\%CLK

subckt PM_TMRDFFSNRNQX1\%noxref_16 ( 1 2 3 4 5 7 10 11 13 14 15 16 18 19 20 21 \
 22 23 24 30 33 36 39 47 49 57 62 65 66 68 71 80 85 93 101 118 127 131 132 133 \
 134 135 136 140 141 142 147 149 152 153 154 155 156 157 158 160 166 167 168 \
 169 174 175 180 191 193 194 195 )
c474 ( 191 0 ) capacitor c=0.00885916f //x=66.415 //y=1.095
c475 ( 180 0 ) capacitor c=0.0710579f //x=61.54 //y=4.88
c476 ( 175 0 ) capacitor c=0.0278202f //x=61.54 //y=2.095
c477 ( 174 0 ) capacitor c=0.0479349f //x=61.54 //y=2.26
c478 ( 169 0 ) capacitor c=0.0612936f //x=78.835 //y=4.97
c479 ( 168 0 ) capacitor c=0.0376642f //x=79.125 //y=4.97
c480 ( 167 0 ) capacitor c=0.0346489f //x=78.79 //y=1.4
c481 ( 166 0 ) capacitor c=0.018692f //x=78.79 //y=1.055
c482 ( 160 0 ) capacitor c=0.0137077f //x=78.635 //y=1.555
c483 ( 158 0 ) capacitor c=0.0158585f //x=78.635 //y=0.9
c484 ( 157 0 ) capacitor c=0.10101f //x=78.26 //y=2.095
c485 ( 156 0 ) capacitor c=0.0229444f //x=78.26 //y=1.71
c486 ( 155 0 ) capacitor c=0.0234359f //x=78.26 //y=1.4
c487 ( 154 0 ) capacitor c=0.019815f //x=78.26 //y=1.055
c488 ( 153 0 ) capacitor c=0.0443175f //x=62.06 //y=1.44
c489 ( 152 0 ) capacitor c=0.0199703f //x=62.06 //y=1.095
c490 ( 149 0 ) capacitor c=0.0162526f //x=61.905 //y=1.595
c491 ( 147 0 ) capacitor c=0.0157807f //x=61.905 //y=0.94
c492 ( 142 0 ) capacitor c=0.0220935f //x=61.53 //y=1.75
c493 ( 141 0 ) capacitor c=0.0207489f //x=61.53 //y=1.44
c494 ( 140 0 ) capacitor c=0.0194091f //x=61.53 //y=1.095
c495 ( 136 0 ) capacitor c=0.110208f //x=79.2 //y=6.2
c496 ( 135 0 ) capacitor c=0.158957f //x=78.76 //y=6.2
c497 ( 134 0 ) capacitor c=0.159671f //x=61.72 //y=6.2
c498 ( 133 0 ) capacitor c=0.110208f //x=61.28 //y=6.2
c499 ( 127 0 ) capacitor c=0.0014751f //x=78.56 //y=4.88
c500 ( 118 0 ) capacitor c=0.0012618f //x=78.56 //y=2.26
c501 ( 101 0 ) capacitor c=0.0293723f //x=66.31 //y=5.56
c502 ( 93 0 ) capacitor c=0.029137f //x=65.43 //y=5.56
c503 ( 85 0 ) capacitor c=0.0278099f //x=64.55 //y=5.56
c504 ( 80 0 ) capacitor c=9.5006e-19 //x=61.54 //y=4.88
c505 ( 71 0 ) capacitor c=0.00101179f //x=61.54 //y=2.26
c506 ( 68 0 ) capacitor c=4.92288e-19 //x=78.555 //y=3.51
c507 ( 66 0 ) capacitor c=6.97864e-19 //x=67.25 //y=3.495
c508 ( 65 0 ) capacitor c=0.0517493f //x=66.93 //y=3.495
c509 ( 62 0 ) capacitor c=4.31985e-19 //x=61.71 //y=3.515
c510 ( 57 0 ) capacitor c=0.113633f //x=78.395 //y=3.51
c511 ( 49 0 ) capacitor c=0.015408f //x=78.555 //y=3.51
c512 ( 47 0 ) capacitor c=0.0158593f //x=67.09 //y=3.51
c513 ( 39 0 ) capacitor c=8.40513e-19 //x=66.31 //y=5.335
c514 ( 36 0 ) capacitor c=0.0086931f //x=65.43 //y=5.335
c515 ( 33 0 ) capacitor c=0.013006f //x=64.552 //y=5.335
c516 ( 30 0 ) capacitor c=0.0150828f //x=61.54 //y=3.51
c517 ( 24 0 ) capacitor c=0.037614f //x=78.56 //y=4.755
c518 ( 23 0 ) capacitor c=0.0144231f //x=78.56 //y=3.67
c519 ( 22 0 ) capacitor c=0.0280962f //x=78.56 //y=3.35
c520 ( 21 0 ) capacitor c=0.00493552f //x=78.56 //y=2.375
c521 ( 20 0 ) capacitor c=0.0405271f //x=67.09 //y=5.25
c522 ( 19 0 ) capacitor c=0.0133594f //x=67.09 //y=3.655
c523 ( 18 0 ) capacitor c=0.0372096f //x=67.09 //y=3.335
c524 ( 16 0 ) capacitor c=0.0048771f //x=66.69 //y=1.845
c525 ( 15 0 ) capacitor c=0.0132685f //x=67.005 //y=1.845
c526 ( 14 0 ) capacitor c=0.0167992f //x=66.605 //y=1.76
c527 ( 13 0 ) capacitor c=0.0113147f //x=66.605 //y=1.305
c528 ( 11 0 ) capacitor c=0.0205277f //x=67.005 //y=5.335
c529 ( 10 0 ) capacitor c=0.00933983f //x=66.31 //y=5.56
c530 ( 7 0 ) capacitor c=0.0153994f //x=66.195 //y=5.335
c531 ( 5 0 ) capacitor c=0.0106433f //x=65.31 //y=5.335
c532 ( 4 0 ) capacitor c=0.0285803f //x=61.54 //y=4.75
c533 ( 3 0 ) capacitor c=0.0121725f //x=61.54 //y=3.675
c534 ( 2 0 ) capacitor c=0.0217874f //x=61.54 //y=3.355
c535 ( 1 0 ) capacitor c=0.005545f //x=61.54 //y=2.375
r536 (  174 175 ) resistor r=52.7279 //w=0.214 //l=0.165 //layer=ply \
 //thickness=0.18 //x=61.54 //y=2.26 //x2=61.54 //y2=2.095
r537 (  168 170 ) resistor r=26.9307 //w=0.15 //l=0.106066 //layer=ply \
 //thickness=0.18 //x=79.125 //y=4.97 //x2=79.2 //y2=5.045
r538 (  168 169 ) resistor r=148.702 //w=0.094 //l=0.29 //layer=ply \
 //thickness=0.18 //x=79.125 //y=4.97 //x2=78.835 //y2=4.97
r539 (  167 190 ) resistor r=45.1352 //w=0.168 //l=0.173853 //layer=ply \
 //thickness=0.18 //x=78.79 //y=1.4 //x2=78.75 //y2=1.555
r540 (  166 189 ) resistor r=45.1352 //w=0.168 //l=0.173853 //layer=ply \
 //thickness=0.18 //x=78.79 //y=1.055 //x2=78.75 //y2=0.9
r541 (  166 167 ) resistor r=176.904 //w=0.094 //l=0.345 //layer=ply \
 //thickness=0.18 //x=78.79 //y=1.055 //x2=78.79 //y2=1.4
r542 (  163 169 ) resistor r=22.7971 //w=0.269 //l=0.106066 //layer=ply \
 //thickness=0.18 //x=78.76 //y=5.045 //x2=78.835 //y2=4.97
r543 (  163 188 ) resistor r=35.8364 //w=0.269 //l=0.270185 //layer=ply \
 //thickness=0.18 //x=78.76 //y=5.045 //x2=78.56 //y2=4.88
r544 (  161 184 ) resistor r=10.701 //w=0.21 //l=0.115 //layer=ply \
 //thickness=0.18 //x=78.415 //y=1.555 //x2=78.3 //y2=1.555
r545 (  160 190 ) resistor r=5.52526 //w=0.168 //l=0.115 //layer=ply \
 //thickness=0.18 //x=78.635 //y=1.555 //x2=78.75 //y2=1.555
r546 (  159 183 ) resistor r=5.52526 //w=0.168 //l=0.115 //layer=ply \
 //thickness=0.18 //x=78.415 //y=0.9 //x2=78.3 //y2=0.9
r547 (  158 189 ) resistor r=5.52526 //w=0.168 //l=0.115 //layer=ply \
 //thickness=0.18 //x=78.635 //y=0.9 //x2=78.75 //y2=0.9
r548 (  158 159 ) resistor r=112.809 //w=0.094 //l=0.22 //layer=ply \
 //thickness=0.18 //x=78.635 //y=0.9 //x2=78.415 //y2=0.9
r549 (  157 186 ) resistor r=58.7805 //w=0.246 //l=0.373497 //layer=ply \
 //thickness=0.18 //x=78.26 //y=2.095 //x2=78.56 //y2=2.26
r550 (  156 184 ) resistor r=39.5823 //w=0.21 //l=0.173853 //layer=ply \
 //thickness=0.18 //x=78.26 //y=1.71 //x2=78.3 //y2=1.555
r551 (  156 157 ) resistor r=197.415 //w=0.094 //l=0.385 //layer=ply \
 //thickness=0.18 //x=78.26 //y=1.71 //x2=78.26 //y2=2.095
r552 (  155 184 ) resistor r=39.5823 //w=0.21 //l=0.173853 //layer=ply \
 //thickness=0.18 //x=78.26 //y=1.4 //x2=78.3 //y2=1.555
r553 (  154 183 ) resistor r=45.1352 //w=0.168 //l=0.173853 //layer=ply \
 //thickness=0.18 //x=78.26 //y=1.055 //x2=78.3 //y2=0.9
r554 (  154 155 ) resistor r=176.904 //w=0.094 //l=0.345 //layer=ply \
 //thickness=0.18 //x=78.26 //y=1.055 //x2=78.26 //y2=1.4
r555 (  153 182 ) resistor r=45.1352 //w=0.168 //l=0.173853 //layer=ply \
 //thickness=0.18 //x=62.06 //y=1.44 //x2=62.02 //y2=1.595
r556 (  152 181 ) resistor r=45.1352 //w=0.168 //l=0.173853 //layer=ply \
 //thickness=0.18 //x=62.06 //y=1.095 //x2=62.02 //y2=0.94
r557 (  152 153 ) resistor r=176.904 //w=0.094 //l=0.345 //layer=ply \
 //thickness=0.18 //x=62.06 //y=1.095 //x2=62.06 //y2=1.44
r558 (  150 178 ) resistor r=10.701 //w=0.21 //l=0.115 //layer=ply \
 //thickness=0.18 //x=61.685 //y=1.595 //x2=61.57 //y2=1.595
r559 (  149 182 ) resistor r=5.52526 //w=0.168 //l=0.115 //layer=ply \
 //thickness=0.18 //x=61.905 //y=1.595 //x2=62.02 //y2=1.595
r560 (  148 177 ) resistor r=5.52526 //w=0.168 //l=0.115 //layer=ply \
 //thickness=0.18 //x=61.685 //y=0.94 //x2=61.57 //y2=0.94
r561 (  147 181 ) resistor r=5.52526 //w=0.168 //l=0.115 //layer=ply \
 //thickness=0.18 //x=61.905 //y=0.94 //x2=62.02 //y2=0.94
r562 (  147 148 ) resistor r=112.809 //w=0.094 //l=0.22 //layer=ply \
 //thickness=0.18 //x=61.905 //y=0.94 //x2=61.685 //y2=0.94
r563 (  144 180 ) resistor r=37.236 //w=0.233 //l=0.249199 //layer=ply \
 //thickness=0.18 //x=61.72 //y=5.045 //x2=61.54 //y2=4.88
r564 (  142 178 ) resistor r=39.5823 //w=0.21 //l=0.173853 //layer=ply \
 //thickness=0.18 //x=61.53 //y=1.75 //x2=61.57 //y2=1.595
r565 (  142 175 ) resistor r=176.904 //w=0.094 //l=0.345 //layer=ply \
 //thickness=0.18 //x=61.53 //y=1.75 //x2=61.53 //y2=2.095
r566 (  141 178 ) resistor r=39.5823 //w=0.21 //l=0.173853 //layer=ply \
 //thickness=0.18 //x=61.53 //y=1.44 //x2=61.57 //y2=1.595
r567 (  140 177 ) resistor r=45.1352 //w=0.168 //l=0.173853 //layer=ply \
 //thickness=0.18 //x=61.53 //y=1.095 //x2=61.57 //y2=0.94
r568 (  140 141 ) resistor r=176.904 //w=0.094 //l=0.345 //layer=ply \
 //thickness=0.18 //x=61.53 //y=1.095 //x2=61.53 //y2=1.44
r569 (  137 180 ) resistor r=53.7854 //w=0.233 //l=0.332415 //layer=ply \
 //thickness=0.18 //x=61.28 //y=5.045 //x2=61.54 //y2=4.88
r570 (  136 170 ) resistor r=592.245 //w=0.094 //l=1.155 //layer=ply \
 //thickness=0.18 //x=79.2 //y=6.2 //x2=79.2 //y2=5.045
r571 (  135 163 ) resistor r=592.245 //w=0.094 //l=1.155 //layer=ply \
 //thickness=0.18 //x=78.76 //y=6.2 //x2=78.76 //y2=5.045
r572 (  134 144 ) resistor r=592.245 //w=0.094 //l=1.155 //layer=ply \
 //thickness=0.18 //x=61.72 //y=6.2 //x2=61.72 //y2=5.045
r573 (  133 137 ) resistor r=592.245 //w=0.094 //l=1.155 //layer=ply \
 //thickness=0.18 //x=61.28 //y=6.2 //x2=61.28 //y2=5.045
r574 (  132 160 ) resistor r=56.4043 //w=0.094 //l=0.11 //layer=ply \
 //thickness=0.18 //x=78.525 //y=1.555 //x2=78.635 //y2=1.555
r575 (  132 161 ) resistor r=56.4043 //w=0.094 //l=0.11 //layer=ply \
 //thickness=0.18 //x=78.525 //y=1.555 //x2=78.415 //y2=1.555
r576 (  131 149 ) resistor r=56.4043 //w=0.094 //l=0.11 //layer=ply \
 //thickness=0.18 //x=61.795 //y=1.595 //x2=61.905 //y2=1.595
r577 (  131 150 ) resistor r=56.4043 //w=0.094 //l=0.11 //layer=ply \
 //thickness=0.18 //x=61.795 //y=1.595 //x2=61.685 //y2=1.595
r578 (  127 188 ) resistor r=152 //w=0.17 //l=0.17 //layer=licon //count=1 \
 //x=78.56 //y=4.88 //x2=78.56 //y2=4.88
r579 (  118 186 ) resistor r=152 //w=0.17 //l=0.17 //layer=licon //count=1 \
 //x=78.56 //y=2.26 //x2=78.56 //y2=2.26
r580 (  101 195 ) resistor r=23.615 //w=0.187 //l=0.345 //layer=li \
 //thickness=0.1 //x=66.31 //y=5.56 //x2=66.31 //y2=5.905
r581 (  93 194 ) resistor r=23.615 //w=0.187 //l=0.345 //layer=li \
 //thickness=0.1 //x=65.43 //y=5.56 //x2=65.43 //y2=5.905
r582 (  85 193 ) resistor r=23.615 //w=0.187 //l=0.345 //layer=li \
 //thickness=0.1 //x=64.55 //y=5.56 //x2=64.55 //y2=5.905
r583 (  80 180 ) resistor r=152 //w=0.17 //l=0.17 //layer=licon //count=1 \
 //x=61.54 //y=4.88 //x2=61.54 //y2=4.88
r584 (  71 174 ) resistor r=152 //w=0.17 //l=0.17 //layer=licon //count=1 \
 //x=61.54 //y=2.26 //x2=61.54 //y2=2.26
r585 (  64 66 ) resistor r=0.10734 //w=0.281 //l=0.16 //layer=m2 \
 //thickness=0.36 //x=67.09 //y=3.495 //x2=67.25 //y2=3.495
r586 (  64 65 ) resistor r=0.10734 //w=0.281 //l=0.16 //layer=m2 \
 //thickness=0.36 //x=67.09 //y=3.495 //x2=66.93 //y2=3.495
r587 (  62 65 ) resistor r=4.98092 //w=0.131 //l=5.22 //layer=m2 \
 //thickness=0.36 //x=61.71 //y=3.51 //x2=66.93 //y2=3.51
r588 (  60 62 ) resistor r=0.10734 //w=0.281 //l=0.16 //layer=m2 \
 //thickness=0.36 //x=61.55 //y=3.515 //x2=61.71 //y2=3.515
r589 (  57 68 ) resistor r=0.10734 //w=0.281 //l=0.16 //layer=m2 \
 //thickness=0.36 //x=78.395 //y=3.51 //x2=78.555 //y2=3.51
r590 (  57 66 ) resistor r=10.6345 //w=0.131 //l=11.145 //layer=m2 \
 //thickness=0.36 //x=78.395 //y=3.51 //x2=67.25 //y2=3.51
r591 (  54 127 ) resistor r=9.3 //w=0.17 //l=0.17 //layer=mcon //count=1 \
 //x=78.56 //y=4.88 //x2=78.56 //y2=4.88
r592 (  52 118 ) resistor r=9.3 //w=0.17 //l=0.17 //layer=mcon //count=1 \
 //x=78.56 //y=2.26 //x2=78.56 //y2=2.26
r593 (  49 68 ) resistor r=4.5 //w=0.15 //l=0.15 //layer=via1 //count=1 \
 //x=78.555 //y=3.51 //x2=78.555 //y2=3.51
r594 (  45 64 ) resistor r=4.5 //w=0.15 //l=0.15 //layer=via1 //count=1 \
 //x=67.09 //y=3.495 //x2=67.09 //y2=3.495
r595 (  45 47 ) resistor r=0.0049867 //w=0.376 //l=0.015 //layer=m1 \
 //thickness=0.36 //x=67.142 //y=3.495 //x2=67.142 //y2=3.51
r596 (  43 191 ) resistor r=9.3 //w=0.17 //l=0.17 //layer=mcon //count=1 \
 //x=66.605 //y=1.19 //x2=66.605 //y2=1.19
r597 (  41 101 ) resistor r=9.3 //w=0.17 //l=0.17 //layer=mcon //count=1 \
 //x=66.31 //y=5.56 //x2=66.31 //y2=5.56
r598 (  38 93 ) resistor r=9.3 //w=0.17 //l=0.17 //layer=mcon //count=1 \
 //x=65.43 //y=5.56 //x2=65.43 //y2=5.56
r599 (  36 38 ) resistor r=0.121228 //w=0.232 //l=0.225 //layer=m1 \
 //thickness=0.36 //x=65.43 //y=5.335 //x2=65.43 //y2=5.56
r600 (  35 85 ) resistor r=9.3 //w=0.17 //l=0.17 //layer=mcon //count=1 \
 //x=64.55 //y=5.56 //x2=64.55 //y2=5.56
r601 (  33 35 ) resistor r=0.129608 //w=0.217 //l=0.225 //layer=m1 \
 //thickness=0.36 //x=64.552 //y=5.335 //x2=64.552 //y2=5.56
r602 (  32 60 ) resistor r=4.5 //w=0.15 //l=0.15 //layer=via1 //count=1 \
 //x=61.55 //y=3.515 //x2=61.55 //y2=3.515
r603 (  30 32 ) resistor r=0.00168464 //w=0.371 //l=0.005 //layer=m1 \
 //thickness=0.36 //x=61.597 //y=3.51 //x2=61.597 //y2=3.515
r604 (  28 80 ) resistor r=9.3 //w=0.17 //l=0.17 //layer=mcon //count=1 \
 //x=61.54 //y=4.88 //x2=61.54 //y2=4.88
r605 (  26 71 ) resistor r=9.3 //w=0.17 //l=0.17 //layer=mcon //count=1 \
 //x=61.54 //y=2.26 //x2=61.54 //y2=2.26
r606 (  24 54 ) resistor r=0.0760407 //w=0.238 //l=0.125 //layer=m1 \
 //thickness=0.36 //x=78.56 //y=4.755 //x2=78.56 //y2=4.88
r607 (  23 49 ) resistor r=0.0910802 //w=0.374 //l=0.185472 //layer=m1 \
 //thickness=0.36 //x=78.56 //y=3.67 //x2=78.505 //y2=3.51
r608 (  23 24 ) resistor r=1.03531 //w=0.131 //l=1.085 //layer=m1 \
 //thickness=0.36 //x=78.56 //y=3.67 //x2=78.56 //y2=4.755
r609 (  22 49 ) resistor r=0.0910802 //w=0.374 //l=0.185472 //layer=m1 \
 //thickness=0.36 //x=78.56 //y=3.35 //x2=78.505 //y2=3.51
r610 (  21 52 ) resistor r=0.0719237 //w=0.222 //l=0.115 //layer=m1 \
 //thickness=0.36 //x=78.56 //y=2.375 //x2=78.56 //y2=2.26
r611 (  21 22 ) resistor r=0.930344 //w=0.131 //l=0.975 //layer=m1 \
 //thickness=0.36 //x=78.56 //y=2.375 //x2=78.56 //y2=3.35
r612 (  19 47 ) resistor r=0.0861726 //w=0.376 //l=0.169012 //layer=m1 \
 //thickness=0.36 //x=67.09 //y=3.655 //x2=67.142 //y2=3.51
r613 (  19 20 ) resistor r=1.52195 //w=0.131 //l=1.595 //layer=m1 \
 //thickness=0.36 //x=67.09 //y=3.655 //x2=67.09 //y2=5.25
r614 (  18 45 ) resistor r=0.0911593 //w=0.376 //l=0.184174 //layer=m1 \
 //thickness=0.36 //x=67.09 //y=3.335 //x2=67.142 //y2=3.495
r615 (  17 18 ) resistor r=1.34065 //w=0.131 //l=1.405 //layer=m1 \
 //thickness=0.36 //x=67.09 //y=1.93 //x2=67.09 //y2=3.335
r616 (  15 17 ) resistor r=0.0698411 //w=0.17 //l=0.120208 //layer=m1 \
 //thickness=0.36 //x=67.005 //y=1.845 //x2=67.09 //y2=1.93
r617 (  15 16 ) resistor r=0.300573 //w=0.131 //l=0.315 //layer=m1 \
 //thickness=0.36 //x=67.005 //y=1.845 //x2=66.69 //y2=1.845
r618 (  14 16 ) resistor r=0.0698411 //w=0.17 //l=0.120208 //layer=m1 \
 //thickness=0.36 //x=66.605 //y=1.76 //x2=66.69 //y2=1.845
r619 (  13 43 ) resistor r=0.0717383 //w=0.224 //l=0.115 //layer=m1 \
 //thickness=0.36 //x=66.605 //y=1.305 //x2=66.605 //y2=1.19
r620 (  13 14 ) resistor r=0.43416 //w=0.131 //l=0.455 //layer=m1 \
 //thickness=0.36 //x=66.605 //y=1.305 //x2=66.605 //y2=1.76
r621 (  12 39 ) resistor r=0.0675342 //w=0.23 //l=0.115 //layer=m1 \
 //thickness=0.36 //x=66.425 //y=5.335 //x2=66.31 //y2=5.335
r622 (  11 20 ) resistor r=0.0698411 //w=0.17 //l=0.120208 //layer=m1 \
 //thickness=0.36 //x=67.005 //y=5.335 //x2=67.09 //y2=5.25
r623 (  11 12 ) resistor r=0.553435 //w=0.131 //l=0.58 //layer=m1 \
 //thickness=0.36 //x=67.005 //y=5.335 //x2=66.425 //y2=5.335
r624 (  10 41 ) resistor r=0.00118313 //w=0.23 //layer=m1 //thickness=0.36 \
 //x=66.31 //y=5.56 //x2=66.31 //y2=5.56
r625 (  9 39 ) resistor r=0.002872 //w=0.34 //l=0.085 //layer=m1 \
 //thickness=0.36 //x=66.31 //y=5.42 //x2=66.31 //y2=5.335
r626 (  9 10 ) resistor r=0.091623 //w=0.191 //l=0.14 //layer=m1 \
 //thickness=0.36 //x=66.31 //y=5.42 //x2=66.31 //y2=5.56
r627 (  8 36 ) resistor r=0.0262263 //w=0.232 //l=0.12 //layer=m1 \
 //thickness=0.36 //x=65.55 //y=5.335 //x2=65.43 //y2=5.335
r628 (  7 39 ) resistor r=0.0675342 //w=0.23 //l=0.115 //layer=m1 \
 //thickness=0.36 //x=66.195 //y=5.335 //x2=66.31 //y2=5.335
r629 (  7 8 ) resistor r=0.615458 //w=0.131 //l=0.645 //layer=m1 \
 //thickness=0.36 //x=66.195 //y=5.335 //x2=65.55 //y2=5.335
r630 (  6 33 ) resistor r=0.0222262 //w=0.217 //l=0.118 //layer=m1 \
 //thickness=0.36 //x=64.67 //y=5.335 //x2=64.552 //y2=5.335
r631 (  5 36 ) resistor r=0.0262263 //w=0.232 //l=0.12 //layer=m1 \
 //thickness=0.36 //x=65.31 //y=5.335 //x2=65.43 //y2=5.335
r632 (  5 6 ) resistor r=0.610687 //w=0.131 //l=0.64 //layer=m1 \
 //thickness=0.36 //x=65.31 //y=5.335 //x2=64.67 //y2=5.335
r633 (  4 28 ) resistor r=0.0801089 //w=0.224 //l=0.13 //layer=m1 \
 //thickness=0.36 //x=61.54 //y=4.75 //x2=61.54 //y2=4.88
r634 (  3 32 ) resistor r=0.0909648 //w=0.371 //l=0.186333 //layer=m1 \
 //thickness=0.36 //x=61.54 //y=3.675 //x2=61.597 //y2=3.515
r635 (  3 4 ) resistor r=1.02576 //w=0.131 //l=1.075 //layer=m1 \
 //thickness=0.36 //x=61.54 //y=3.675 //x2=61.54 //y2=4.75
r636 (  2 30 ) resistor r=0.0892801 //w=0.371 //l=0.181273 //layer=m1 \
 //thickness=0.36 //x=61.54 //y=3.355 //x2=61.597 //y2=3.51
r637 (  1 26 ) resistor r=0.0719237 //w=0.222 //l=0.115 //layer=m1 \
 //thickness=0.36 //x=61.54 //y=2.375 //x2=61.54 //y2=2.26
r638 (  1 2 ) resistor r=0.935115 //w=0.131 //l=0.98 //layer=m1 \
 //thickness=0.36 //x=61.54 //y=2.375 //x2=61.54 //y2=3.355
ends PM_TMRDFFSNRNQX1\%noxref_16

subckt PM_TMRDFFSNRNQX1\%RN ( 1 2 3 4 5 6 7 8 9 10 11 12 13 14 15 16 17 18 19 \
 20 21 22 23 24 25 26 27 28 29 30 31 37 38 40 41 44 45 49 50 52 53 56 57 61 62 \
 64 65 128 129 130 132 134 136 137 138 139 140 142 144 145 146 148 150 151 152 \
 153 154 156 158 159 160 162 165 184 185 188 193 198 203 208 213 218 223 228 \
 233 238 243 248 253 258 263 268 273 277 278 279 280 281 282 283 284 285 286 \
 287 288 289 290 291 292 293 294 295 296 297 298 299 300 301 302 303 304 305 \
 306 308 314 315 316 317 318 326 327 328 333 335 338 339 340 341 342 344 350 \
 351 352 353 354 359 360 361 363 369 370 371 372 373 381 382 383 388 390 393 \
 394 395 396 397 399 405 406 407 408 409 414 415 416 418 424 425 426 427 428 \
 436 437 438 443 445 448 449 450 451 452 454 460 461 462 463 464 472 481 482 \
 487 493 504 513 514 519 525 536 545 546 551 557 )
c1701 ( 557 0 ) capacitor c=0.0369044f //x=79.67 //y=4.88
c1702 ( 551 0 ) capacitor c=0.0711095f //x=75.97 //y=4.88
c1703 ( 546 0 ) capacitor c=0.0278202f //x=75.97 //y=2.095
c1704 ( 545 0 ) capacitor c=0.0491433f //x=75.97 //y=2.26
c1705 ( 536 0 ) capacitor c=0.0369628f //x=60.43 //y=4.88
c1706 ( 525 0 ) capacitor c=0.0369628f //x=50.81 //y=4.88
c1707 ( 519 0 ) capacitor c=0.0710579f //x=47.11 //y=4.88
c1708 ( 514 0 ) capacitor c=0.0278202f //x=47.11 //y=2.095
c1709 ( 513 0 ) capacitor c=0.0491433f //x=47.11 //y=2.26
c1710 ( 504 0 ) capacitor c=0.0369628f //x=31.57 //y=4.88
c1711 ( 493 0 ) capacitor c=0.0369044f //x=21.95 //y=4.88
c1712 ( 487 0 ) capacitor c=0.0710579f //x=18.25 //y=4.88
c1713 ( 482 0 ) capacitor c=0.0278202f //x=18.25 //y=2.095
c1714 ( 481 0 ) capacitor c=0.0491433f //x=18.25 //y=2.26
c1715 ( 472 0 ) capacitor c=0.0369044f //x=2.71 //y=4.88
c1716 ( 464 0 ) capacitor c=0.0309248f //x=80.005 //y=4.97
c1717 ( 463 0 ) capacitor c=0.0846044f //x=79.76 //y=2.095
c1718 ( 462 0 ) capacitor c=0.0170266f //x=79.76 //y=1.63
c1719 ( 461 0 ) capacitor c=0.018609f //x=79.76 //y=1.4
c1720 ( 460 0 ) capacitor c=0.0186599f //x=79.76 //y=1.09
c1721 ( 454 0 ) capacitor c=0.0146988f //x=79.605 //y=1.555
c1722 ( 452 0 ) capacitor c=0.0148531f //x=79.605 //y=0.935
c1723 ( 451 0 ) capacitor c=0.0334406f //x=79.235 //y=1.4
c1724 ( 450 0 ) capacitor c=0.0173191f //x=79.235 //y=1.09
c1725 ( 449 0 ) capacitor c=0.0443175f //x=76.49 //y=1.44
c1726 ( 448 0 ) capacitor c=0.0199703f //x=76.49 //y=1.095
c1727 ( 445 0 ) capacitor c=0.0160404f //x=76.335 //y=1.595
c1728 ( 443 0 ) capacitor c=0.0157807f //x=76.335 //y=0.94
c1729 ( 438 0 ) capacitor c=0.0220935f //x=75.96 //y=1.75
c1730 ( 437 0 ) capacitor c=0.0207489f //x=75.96 //y=1.44
c1731 ( 436 0 ) capacitor c=0.0194091f //x=75.96 //y=1.095
c1732 ( 428 0 ) capacitor c=0.0309248f //x=60.765 //y=4.97
c1733 ( 427 0 ) capacitor c=0.0844916f //x=60.52 //y=2.095
c1734 ( 426 0 ) capacitor c=0.0170266f //x=60.52 //y=1.63
c1735 ( 425 0 ) capacitor c=0.018609f //x=60.52 //y=1.4
c1736 ( 424 0 ) capacitor c=0.0186599f //x=60.52 //y=1.09
c1737 ( 418 0 ) capacitor c=0.0146988f //x=60.365 //y=1.555
c1738 ( 416 0 ) capacitor c=0.0148531f //x=60.365 //y=0.935
c1739 ( 415 0 ) capacitor c=0.0334406f //x=59.995 //y=1.4
c1740 ( 414 0 ) capacitor c=0.0173191f //x=59.995 //y=1.09
c1741 ( 409 0 ) capacitor c=0.0309248f //x=51.145 //y=4.97
c1742 ( 408 0 ) capacitor c=0.0846044f //x=50.9 //y=2.095
c1743 ( 407 0 ) capacitor c=0.0170266f //x=50.9 //y=1.63
c1744 ( 406 0 ) capacitor c=0.018609f //x=50.9 //y=1.4
c1745 ( 405 0 ) capacitor c=0.0186599f //x=50.9 //y=1.09
c1746 ( 399 0 ) capacitor c=0.0146988f //x=50.745 //y=1.555
c1747 ( 397 0 ) capacitor c=0.0148531f //x=50.745 //y=0.935
c1748 ( 396 0 ) capacitor c=0.0334406f //x=50.375 //y=1.4
c1749 ( 395 0 ) capacitor c=0.0173191f //x=50.375 //y=1.09
c1750 ( 394 0 ) capacitor c=0.0443175f //x=47.63 //y=1.44
c1751 ( 393 0 ) capacitor c=0.0199703f //x=47.63 //y=1.095
c1752 ( 390 0 ) capacitor c=0.0160404f //x=47.475 //y=1.595
c1753 ( 388 0 ) capacitor c=0.0157807f //x=47.475 //y=0.94
c1754 ( 383 0 ) capacitor c=0.0220935f //x=47.1 //y=1.75
c1755 ( 382 0 ) capacitor c=0.0207489f //x=47.1 //y=1.44
c1756 ( 381 0 ) capacitor c=0.0194091f //x=47.1 //y=1.095
c1757 ( 373 0 ) capacitor c=0.0309248f //x=31.905 //y=4.97
c1758 ( 372 0 ) capacitor c=0.0844916f //x=31.66 //y=2.095
c1759 ( 371 0 ) capacitor c=0.0170266f //x=31.66 //y=1.63
c1760 ( 370 0 ) capacitor c=0.018609f //x=31.66 //y=1.4
c1761 ( 369 0 ) capacitor c=0.0186599f //x=31.66 //y=1.09
c1762 ( 363 0 ) capacitor c=0.0146988f //x=31.505 //y=1.555
c1763 ( 361 0 ) capacitor c=0.0148531f //x=31.505 //y=0.935
c1764 ( 360 0 ) capacitor c=0.0334406f //x=31.135 //y=1.4
c1765 ( 359 0 ) capacitor c=0.0173191f //x=31.135 //y=1.09
c1766 ( 354 0 ) capacitor c=0.0309248f //x=22.285 //y=4.97
c1767 ( 353 0 ) capacitor c=0.0846044f //x=22.04 //y=2.095
c1768 ( 352 0 ) capacitor c=0.0170266f //x=22.04 //y=1.63
c1769 ( 351 0 ) capacitor c=0.018609f //x=22.04 //y=1.4
c1770 ( 350 0 ) capacitor c=0.0186599f //x=22.04 //y=1.09
c1771 ( 344 0 ) capacitor c=0.0146988f //x=21.885 //y=1.555
c1772 ( 342 0 ) capacitor c=0.0148531f //x=21.885 //y=0.935
c1773 ( 341 0 ) capacitor c=0.0334406f //x=21.515 //y=1.4
c1774 ( 340 0 ) capacitor c=0.0173191f //x=21.515 //y=1.09
c1775 ( 339 0 ) capacitor c=0.0443175f //x=18.77 //y=1.44
c1776 ( 338 0 ) capacitor c=0.0199703f //x=18.77 //y=1.095
c1777 ( 335 0 ) capacitor c=0.0160404f //x=18.615 //y=1.595
c1778 ( 333 0 ) capacitor c=0.0157807f //x=18.615 //y=0.94
c1779 ( 328 0 ) capacitor c=0.0220935f //x=18.24 //y=1.75
c1780 ( 327 0 ) capacitor c=0.0207489f //x=18.24 //y=1.44
c1781 ( 326 0 ) capacitor c=0.0194091f //x=18.24 //y=1.095
c1782 ( 318 0 ) capacitor c=0.0309248f //x=3.045 //y=4.97
c1783 ( 317 0 ) capacitor c=0.0844916f //x=2.8 //y=2.095
c1784 ( 316 0 ) capacitor c=0.0170266f //x=2.8 //y=1.63
c1785 ( 315 0 ) capacitor c=0.018609f //x=2.8 //y=1.4
c1786 ( 314 0 ) capacitor c=0.0186599f //x=2.8 //y=1.09
c1787 ( 308 0 ) capacitor c=0.0146988f //x=2.645 //y=1.555
c1788 ( 306 0 ) capacitor c=0.0148531f //x=2.645 //y=0.935
c1789 ( 305 0 ) capacitor c=0.0334406f //x=2.275 //y=1.4
c1790 ( 304 0 ) capacitor c=0.0173191f //x=2.275 //y=1.09
c1791 ( 303 0 ) capacitor c=0.110208f //x=80.08 //y=6.2
c1792 ( 302 0 ) capacitor c=0.110214f //x=79.64 //y=6.2
c1793 ( 301 0 ) capacitor c=0.159671f //x=76.15 //y=6.2
c1794 ( 300 0 ) capacitor c=0.110208f //x=75.71 //y=6.2
c1795 ( 299 0 ) capacitor c=0.110208f //x=60.84 //y=6.2
c1796 ( 298 0 ) capacitor c=0.110214f //x=60.4 //y=6.2
c1797 ( 297 0 ) capacitor c=0.110208f //x=51.22 //y=6.2
c1798 ( 296 0 ) capacitor c=0.110214f //x=50.78 //y=6.2
c1799 ( 295 0 ) capacitor c=0.159671f //x=47.29 //y=6.2
c1800 ( 294 0 ) capacitor c=0.110208f //x=46.85 //y=6.2
c1801 ( 293 0 ) capacitor c=0.110208f //x=31.98 //y=6.2
c1802 ( 292 0 ) capacitor c=0.110214f //x=31.54 //y=6.2
c1803 ( 291 0 ) capacitor c=0.110208f //x=22.36 //y=6.2
c1804 ( 290 0 ) capacitor c=0.110214f //x=21.92 //y=6.2
c1805 ( 289 0 ) capacitor c=0.159671f //x=18.43 //y=6.2
c1806 ( 288 0 ) capacitor c=0.110208f //x=17.99 //y=6.2
c1807 ( 287 0 ) capacitor c=0.110208f //x=3.12 //y=6.2
c1808 ( 286 0 ) capacitor c=0.110214f //x=2.68 //y=6.2
c1809 ( 273 0 ) capacitor c=0.00129935f //x=79.67 //y=4.88
c1810 ( 268 0 ) capacitor c=0.00121786f //x=79.67 //y=2.26
c1811 ( 263 0 ) capacitor c=7.7417e-19 //x=75.97 //y=4.88
c1812 ( 258 0 ) capacitor c=0.00101179f //x=75.97 //y=2.26
c1813 ( 253 0 ) capacitor c=0.00129935f //x=60.43 //y=4.88
c1814 ( 248 0 ) capacitor c=0.00121786f //x=60.43 //y=2.26
c1815 ( 243 0 ) capacitor c=0.00129935f //x=50.81 //y=4.88
c1816 ( 238 0 ) capacitor c=0.00121786f //x=50.81 //y=2.26
c1817 ( 233 0 ) capacitor c=9.08755e-19 //x=47.11 //y=4.88
c1818 ( 228 0 ) capacitor c=0.00101179f //x=47.11 //y=2.26
c1819 ( 223 0 ) capacitor c=0.00129935f //x=31.57 //y=4.88
c1820 ( 218 0 ) capacitor c=0.00121786f //x=31.57 //y=2.26
c1821 ( 213 0 ) capacitor c=0.00129935f //x=21.95 //y=4.88
c1822 ( 208 0 ) capacitor c=0.00121786f //x=21.95 //y=2.26
c1823 ( 203 0 ) capacitor c=7.7417e-19 //x=18.25 //y=4.88
c1824 ( 198 0 ) capacitor c=0.00101179f //x=18.25 //y=2.26
c1825 ( 193 0 ) capacitor c=0.00129935f //x=2.71 //y=4.88
c1826 ( 188 0 ) capacitor c=0.00121786f //x=2.71 //y=2.26
c1827 ( 185 0 ) capacitor c=0.0856406f //x=79.505 //y=2.41
c1828 ( 184 0 ) capacitor c=0.00498615f //x=79.665 //y=2.41
c1829 ( 165 0 ) capacitor c=0.0572044f //x=76.135 //y=2.4
c1830 ( 162 0 ) capacitor c=0.00875699f //x=73.975 //y=2.385
c1831 ( 160 0 ) capacitor c=0.0264842f //x=73.375 //y=2.4
c1832 ( 159 0 ) capacitor c=0.411959f //x=71.685 //y=2.385
c1833 ( 158 0 ) capacitor c=0.0147324f //x=72.115 //y=2.385
c1834 ( 156 0 ) capacitor c=0.00856815f //x=54.68 //y=2.37
c1835 ( 154 0 ) capacitor c=0.0240914f //x=54.08 //y=2.4
c1836 ( 153 0 ) capacitor c=0.0449876f //x=52.49 //y=2.37
c1837 ( 152 0 ) capacitor c=0.0149878f //x=52.92 //y=2.37
c1838 ( 151 0 ) capacitor c=0.0572008f //x=47.275 //y=2.4
c1839 ( 150 0 ) capacitor c=0.0856406f //x=50.645 //y=2.4
c1840 ( 148 0 ) capacitor c=0.00875699f //x=45.115 //y=2.385
c1841 ( 146 0 ) capacitor c=0.0264842f //x=44.515 //y=2.4
c1842 ( 145 0 ) capacitor c=0.410189f //x=42.825 //y=2.385
c1843 ( 144 0 ) capacitor c=0.0147324f //x=43.255 //y=2.385
c1844 ( 142 0 ) capacitor c=0.00882412f //x=25.865 //y=2.37
c1845 ( 140 0 ) capacitor c=0.0268658f //x=25.265 //y=2.4
c1846 ( 139 0 ) capacitor c=0.0435481f //x=23.57 //y=2.37
c1847 ( 138 0 ) capacitor c=0.0145033f //x=24 //y=2.37
c1848 ( 137 0 ) capacitor c=0.0572008f //x=18.415 //y=2.4
c1849 ( 136 0 ) capacitor c=0.0856406f //x=21.785 //y=2.4
c1850 ( 134 0 ) capacitor c=0.00875699f //x=16.255 //y=2.385
c1851 ( 132 0 ) capacitor c=0.0264842f //x=15.655 //y=2.4
c1852 ( 130 0 ) capacitor c=0.0147324f //x=14.395 //y=2.385
c1853 ( 129 0 ) capacitor c=0.00551787f //x=2.87 //y=2.4
c1854 ( 128 0 ) capacitor c=0.271118f //x=13.795 //y=2.4
c1855 ( 65 0 ) capacitor c=0.00504675f //x=79.67 //y=4.765
c1856 ( 64 0 ) capacitor c=0.0122282f //x=79.67 //y=2.57
c1857 ( 62 0 ) capacitor c=0.00443476f //x=75.97 //y=4.75
c1858 ( 61 0 ) capacitor c=0.0133066f //x=75.97 //y=2.565
c1859 ( 57 0 ) capacitor c=0.00295423f //x=60.43 //y=4.765
c1860 ( 56 0 ) capacitor c=0.0115735f //x=60.43 //y=2.56
c1861 ( 53 0 ) capacitor c=0.00295171f //x=50.81 //y=4.765
c1862 ( 52 0 ) capacitor c=0.0121708f //x=50.81 //y=2.57
c1863 ( 50 0 ) capacitor c=0.00287846f //x=47.11 //y=4.75
c1864 ( 49 0 ) capacitor c=0.0132863f //x=47.11 //y=2.565
c1865 ( 45 0 ) capacitor c=0.00295423f //x=31.57 //y=4.765
c1866 ( 44 0 ) capacitor c=0.0115735f //x=31.57 //y=2.56
c1867 ( 41 0 ) capacitor c=0.00504675f //x=21.95 //y=4.765
c1868 ( 40 0 ) capacitor c=0.0121708f //x=21.95 //y=2.57
c1869 ( 38 0 ) capacitor c=0.00443476f //x=18.25 //y=4.75
c1870 ( 37 0 ) capacitor c=0.0133066f //x=18.25 //y=2.565
c1871 ( 31 0 ) capacitor c=0.00504926f //x=2.71 //y=4.765
c1872 ( 30 0 ) capacitor c=0.0116271f //x=2.71 //y=2.56
c1873 ( 19 0 ) capacitor c=0.0609005f //x=79.67 //y=2.77
c1874 ( 18 0 ) capacitor c=0.0530105f //x=75.97 //y=2.77
c1875 ( 15 0 ) capacitor c=0.0596398f //x=60.43 //y=2.77
c1876 ( 13 0 ) capacitor c=0.0572866f //x=50.81 //y=2.77
c1877 ( 12 0 ) capacitor c=0.0530147f //x=47.11 //y=2.77
c1878 ( 9 0 ) capacitor c=0.0616868f //x=31.57 //y=2.77
c1879 ( 7 0 ) capacitor c=0.0574648f //x=21.95 //y=2.77
c1880 ( 6 0 ) capacitor c=0.0530147f //x=18.25 //y=2.77
c1881 ( 1 0 ) capacitor c=0.0666298f //x=2.71 //y=2.77
r1882 (  559 560 ) resistor r=32.4568 //w=0.214 //l=0.075 //layer=ply \
 //thickness=0.18 //x=79.67 //y=4.97 //x2=79.67 //y2=5.045
r1883 (  557 559 ) resistor r=20.271 //w=0.214 //l=0.09 //layer=ply \
 //thickness=0.18 //x=79.67 //y=4.88 //x2=79.67 //y2=4.97
r1884 (  545 546 ) resistor r=52.7279 //w=0.214 //l=0.165 //layer=ply \
 //thickness=0.18 //x=75.97 //y=2.26 //x2=75.97 //y2=2.095
r1885 (  538 539 ) resistor r=32.4568 //w=0.214 //l=0.075 //layer=ply \
 //thickness=0.18 //x=60.43 //y=4.97 //x2=60.43 //y2=5.045
r1886 (  536 538 ) resistor r=20.271 //w=0.214 //l=0.09 //layer=ply \
 //thickness=0.18 //x=60.43 //y=4.88 //x2=60.43 //y2=4.97
r1887 (  527 528 ) resistor r=32.4568 //w=0.214 //l=0.075 //layer=ply \
 //thickness=0.18 //x=50.81 //y=4.97 //x2=50.81 //y2=5.045
r1888 (  525 527 ) resistor r=20.271 //w=0.214 //l=0.09 //layer=ply \
 //thickness=0.18 //x=50.81 //y=4.88 //x2=50.81 //y2=4.97
r1889 (  513 514 ) resistor r=52.7279 //w=0.214 //l=0.165 //layer=ply \
 //thickness=0.18 //x=47.11 //y=2.26 //x2=47.11 //y2=2.095
r1890 (  506 507 ) resistor r=32.4568 //w=0.214 //l=0.075 //layer=ply \
 //thickness=0.18 //x=31.57 //y=4.97 //x2=31.57 //y2=5.045
r1891 (  504 506 ) resistor r=20.271 //w=0.214 //l=0.09 //layer=ply \
 //thickness=0.18 //x=31.57 //y=4.88 //x2=31.57 //y2=4.97
r1892 (  495 496 ) resistor r=32.4568 //w=0.214 //l=0.075 //layer=ply \
 //thickness=0.18 //x=21.95 //y=4.97 //x2=21.95 //y2=5.045
r1893 (  493 495 ) resistor r=20.271 //w=0.214 //l=0.09 //layer=ply \
 //thickness=0.18 //x=21.95 //y=4.88 //x2=21.95 //y2=4.97
r1894 (  481 482 ) resistor r=52.7279 //w=0.214 //l=0.165 //layer=ply \
 //thickness=0.18 //x=18.25 //y=2.26 //x2=18.25 //y2=2.095
r1895 (  474 475 ) resistor r=32.4568 //w=0.214 //l=0.075 //layer=ply \
 //thickness=0.18 //x=2.71 //y=4.97 //x2=2.71 //y2=5.045
r1896 (  472 474 ) resistor r=20.271 //w=0.214 //l=0.09 //layer=ply \
 //thickness=0.18 //x=2.71 //y=4.88 //x2=2.71 //y2=4.97
r1897 (  465 559 ) resistor r=16.5046 //w=0.27 //l=0.135 //layer=ply \
 //thickness=0.18 //x=79.805 //y=4.97 //x2=79.67 //y2=4.97
r1898 (  464 466 ) resistor r=26.9307 //w=0.15 //l=0.106066 //layer=ply \
 //thickness=0.18 //x=80.005 //y=4.97 //x2=80.08 //y2=5.045
r1899 (  464 465 ) resistor r=102.553 //w=0.094 //l=0.2 //layer=ply \
 //thickness=0.18 //x=80.005 //y=4.97 //x2=79.805 //y2=4.97
r1900 (  463 564 ) resistor r=38.6777 //w=0.284 //l=0.198997 //layer=ply \
 //thickness=0.18 //x=79.76 //y=2.095 //x2=79.685 //y2=2.26
r1901 (  462 562 ) resistor r=21.2976 //w=0.217 //l=0.0928709 //layer=ply \
 //thickness=0.18 //x=79.76 //y=1.63 //x2=79.72 //y2=1.555
r1902 (  462 463 ) resistor r=238.436 //w=0.094 //l=0.465 //layer=ply \
 //thickness=0.18 //x=79.76 //y=1.63 //x2=79.76 //y2=2.095
r1903 (  461 562 ) resistor r=39.0671 //w=0.217 //l=0.173853 //layer=ply \
 //thickness=0.18 //x=79.76 //y=1.4 //x2=79.72 //y2=1.555
r1904 (  460 561 ) resistor r=45.1352 //w=0.168 //l=0.173853 //layer=ply \
 //thickness=0.18 //x=79.76 //y=1.09 //x2=79.72 //y2=0.935
r1905 (  460 461 ) resistor r=158.957 //w=0.094 //l=0.31 //layer=ply \
 //thickness=0.18 //x=79.76 //y=1.09 //x2=79.76 //y2=1.4
r1906 (  455 555 ) resistor r=5.52526 //w=0.168 //l=0.115 //layer=ply \
 //thickness=0.18 //x=79.39 //y=1.555 //x2=79.275 //y2=1.555
r1907 (  454 562 ) resistor r=11.4558 //w=0.217 //l=0.115 //layer=ply \
 //thickness=0.18 //x=79.605 //y=1.555 //x2=79.72 //y2=1.555
r1908 (  453 554 ) resistor r=5.52526 //w=0.168 //l=0.115 //layer=ply \
 //thickness=0.18 //x=79.39 //y=0.935 //x2=79.275 //y2=0.935
r1909 (  452 561 ) resistor r=5.52526 //w=0.168 //l=0.115 //layer=ply \
 //thickness=0.18 //x=79.605 //y=0.935 //x2=79.72 //y2=0.935
r1910 (  452 453 ) resistor r=110.245 //w=0.094 //l=0.215 //layer=ply \
 //thickness=0.18 //x=79.605 //y=0.935 //x2=79.39 //y2=0.935
r1911 (  451 555 ) resistor r=45.1352 //w=0.168 //l=0.173853 //layer=ply \
 //thickness=0.18 //x=79.235 //y=1.4 //x2=79.275 //y2=1.555
r1912 (  450 554 ) resistor r=45.1352 //w=0.168 //l=0.173853 //layer=ply \
 //thickness=0.18 //x=79.235 //y=1.09 //x2=79.275 //y2=0.935
r1913 (  450 451 ) resistor r=158.957 //w=0.094 //l=0.31 //layer=ply \
 //thickness=0.18 //x=79.235 //y=1.09 //x2=79.235 //y2=1.4
r1914 (  449 553 ) resistor r=45.1352 //w=0.168 //l=0.173853 //layer=ply \
 //thickness=0.18 //x=76.49 //y=1.44 //x2=76.45 //y2=1.595
r1915 (  448 552 ) resistor r=45.1352 //w=0.168 //l=0.173853 //layer=ply \
 //thickness=0.18 //x=76.49 //y=1.095 //x2=76.45 //y2=0.94
r1916 (  448 449 ) resistor r=176.904 //w=0.094 //l=0.345 //layer=ply \
 //thickness=0.18 //x=76.49 //y=1.095 //x2=76.49 //y2=1.44
r1917 (  446 549 ) resistor r=10.701 //w=0.21 //l=0.115 //layer=ply \
 //thickness=0.18 //x=76.115 //y=1.595 //x2=76 //y2=1.595
r1918 (  445 553 ) resistor r=5.52526 //w=0.168 //l=0.115 //layer=ply \
 //thickness=0.18 //x=76.335 //y=1.595 //x2=76.45 //y2=1.595
r1919 (  444 548 ) resistor r=5.52526 //w=0.168 //l=0.115 //layer=ply \
 //thickness=0.18 //x=76.115 //y=0.94 //x2=76 //y2=0.94
r1920 (  443 552 ) resistor r=5.52526 //w=0.168 //l=0.115 //layer=ply \
 //thickness=0.18 //x=76.335 //y=0.94 //x2=76.45 //y2=0.94
r1921 (  443 444 ) resistor r=112.809 //w=0.094 //l=0.22 //layer=ply \
 //thickness=0.18 //x=76.335 //y=0.94 //x2=76.115 //y2=0.94
r1922 (  440 551 ) resistor r=37.236 //w=0.233 //l=0.249199 //layer=ply \
 //thickness=0.18 //x=76.15 //y=5.045 //x2=75.97 //y2=4.88
r1923 (  438 549 ) resistor r=39.5823 //w=0.21 //l=0.173853 //layer=ply \
 //thickness=0.18 //x=75.96 //y=1.75 //x2=76 //y2=1.595
r1924 (  438 546 ) resistor r=176.904 //w=0.094 //l=0.345 //layer=ply \
 //thickness=0.18 //x=75.96 //y=1.75 //x2=75.96 //y2=2.095
r1925 (  437 549 ) resistor r=39.5823 //w=0.21 //l=0.173853 //layer=ply \
 //thickness=0.18 //x=75.96 //y=1.44 //x2=76 //y2=1.595
r1926 (  436 548 ) resistor r=45.1352 //w=0.168 //l=0.173853 //layer=ply \
 //thickness=0.18 //x=75.96 //y=1.095 //x2=76 //y2=0.94
r1927 (  436 437 ) resistor r=176.904 //w=0.094 //l=0.345 //layer=ply \
 //thickness=0.18 //x=75.96 //y=1.095 //x2=75.96 //y2=1.44
r1928 (  433 551 ) resistor r=53.7854 //w=0.233 //l=0.332415 //layer=ply \
 //thickness=0.18 //x=75.71 //y=5.045 //x2=75.97 //y2=4.88
r1929 (  429 538 ) resistor r=16.5046 //w=0.27 //l=0.135 //layer=ply \
 //thickness=0.18 //x=60.565 //y=4.97 //x2=60.43 //y2=4.97
r1930 (  428 430 ) resistor r=26.9307 //w=0.15 //l=0.106066 //layer=ply \
 //thickness=0.18 //x=60.765 //y=4.97 //x2=60.84 //y2=5.045
r1931 (  428 429 ) resistor r=102.553 //w=0.094 //l=0.2 //layer=ply \
 //thickness=0.18 //x=60.765 //y=4.97 //x2=60.565 //y2=4.97
r1932 (  427 543 ) resistor r=38.6777 //w=0.284 //l=0.198997 //layer=ply \
 //thickness=0.18 //x=60.52 //y=2.095 //x2=60.445 //y2=2.26
r1933 (  426 541 ) resistor r=21.2976 //w=0.217 //l=0.0928709 //layer=ply \
 //thickness=0.18 //x=60.52 //y=1.63 //x2=60.48 //y2=1.555
r1934 (  426 427 ) resistor r=238.436 //w=0.094 //l=0.465 //layer=ply \
 //thickness=0.18 //x=60.52 //y=1.63 //x2=60.52 //y2=2.095
r1935 (  425 541 ) resistor r=39.0671 //w=0.217 //l=0.173853 //layer=ply \
 //thickness=0.18 //x=60.52 //y=1.4 //x2=60.48 //y2=1.555
r1936 (  424 540 ) resistor r=45.1352 //w=0.168 //l=0.173853 //layer=ply \
 //thickness=0.18 //x=60.52 //y=1.09 //x2=60.48 //y2=0.935
r1937 (  424 425 ) resistor r=158.957 //w=0.094 //l=0.31 //layer=ply \
 //thickness=0.18 //x=60.52 //y=1.09 //x2=60.52 //y2=1.4
r1938 (  419 534 ) resistor r=5.52526 //w=0.168 //l=0.115 //layer=ply \
 //thickness=0.18 //x=60.15 //y=1.555 //x2=60.035 //y2=1.555
r1939 (  418 541 ) resistor r=11.4558 //w=0.217 //l=0.115 //layer=ply \
 //thickness=0.18 //x=60.365 //y=1.555 //x2=60.48 //y2=1.555
r1940 (  417 533 ) resistor r=5.52526 //w=0.168 //l=0.115 //layer=ply \
 //thickness=0.18 //x=60.15 //y=0.935 //x2=60.035 //y2=0.935
r1941 (  416 540 ) resistor r=5.52526 //w=0.168 //l=0.115 //layer=ply \
 //thickness=0.18 //x=60.365 //y=0.935 //x2=60.48 //y2=0.935
r1942 (  416 417 ) resistor r=110.245 //w=0.094 //l=0.215 //layer=ply \
 //thickness=0.18 //x=60.365 //y=0.935 //x2=60.15 //y2=0.935
r1943 (  415 534 ) resistor r=45.1352 //w=0.168 //l=0.173853 //layer=ply \
 //thickness=0.18 //x=59.995 //y=1.4 //x2=60.035 //y2=1.555
r1944 (  414 533 ) resistor r=45.1352 //w=0.168 //l=0.173853 //layer=ply \
 //thickness=0.18 //x=59.995 //y=1.09 //x2=60.035 //y2=0.935
r1945 (  414 415 ) resistor r=158.957 //w=0.094 //l=0.31 //layer=ply \
 //thickness=0.18 //x=59.995 //y=1.09 //x2=59.995 //y2=1.4
r1946 (  410 527 ) resistor r=16.5046 //w=0.27 //l=0.135 //layer=ply \
 //thickness=0.18 //x=50.945 //y=4.97 //x2=50.81 //y2=4.97
r1947 (  409 411 ) resistor r=26.9307 //w=0.15 //l=0.106066 //layer=ply \
 //thickness=0.18 //x=51.145 //y=4.97 //x2=51.22 //y2=5.045
r1948 (  409 410 ) resistor r=102.553 //w=0.094 //l=0.2 //layer=ply \
 //thickness=0.18 //x=51.145 //y=4.97 //x2=50.945 //y2=4.97
r1949 (  408 532 ) resistor r=38.6777 //w=0.284 //l=0.198997 //layer=ply \
 //thickness=0.18 //x=50.9 //y=2.095 //x2=50.825 //y2=2.26
r1950 (  407 530 ) resistor r=21.2976 //w=0.217 //l=0.0928709 //layer=ply \
 //thickness=0.18 //x=50.9 //y=1.63 //x2=50.86 //y2=1.555
r1951 (  407 408 ) resistor r=238.436 //w=0.094 //l=0.465 //layer=ply \
 //thickness=0.18 //x=50.9 //y=1.63 //x2=50.9 //y2=2.095
r1952 (  406 530 ) resistor r=39.0671 //w=0.217 //l=0.173853 //layer=ply \
 //thickness=0.18 //x=50.9 //y=1.4 //x2=50.86 //y2=1.555
r1953 (  405 529 ) resistor r=45.1352 //w=0.168 //l=0.173853 //layer=ply \
 //thickness=0.18 //x=50.9 //y=1.09 //x2=50.86 //y2=0.935
r1954 (  405 406 ) resistor r=158.957 //w=0.094 //l=0.31 //layer=ply \
 //thickness=0.18 //x=50.9 //y=1.09 //x2=50.9 //y2=1.4
r1955 (  400 523 ) resistor r=5.52526 //w=0.168 //l=0.115 //layer=ply \
 //thickness=0.18 //x=50.53 //y=1.555 //x2=50.415 //y2=1.555
r1956 (  399 530 ) resistor r=11.4558 //w=0.217 //l=0.115 //layer=ply \
 //thickness=0.18 //x=50.745 //y=1.555 //x2=50.86 //y2=1.555
r1957 (  398 522 ) resistor r=5.52526 //w=0.168 //l=0.115 //layer=ply \
 //thickness=0.18 //x=50.53 //y=0.935 //x2=50.415 //y2=0.935
r1958 (  397 529 ) resistor r=5.52526 //w=0.168 //l=0.115 //layer=ply \
 //thickness=0.18 //x=50.745 //y=0.935 //x2=50.86 //y2=0.935
r1959 (  397 398 ) resistor r=110.245 //w=0.094 //l=0.215 //layer=ply \
 //thickness=0.18 //x=50.745 //y=0.935 //x2=50.53 //y2=0.935
r1960 (  396 523 ) resistor r=45.1352 //w=0.168 //l=0.173853 //layer=ply \
 //thickness=0.18 //x=50.375 //y=1.4 //x2=50.415 //y2=1.555
r1961 (  395 522 ) resistor r=45.1352 //w=0.168 //l=0.173853 //layer=ply \
 //thickness=0.18 //x=50.375 //y=1.09 //x2=50.415 //y2=0.935
r1962 (  395 396 ) resistor r=158.957 //w=0.094 //l=0.31 //layer=ply \
 //thickness=0.18 //x=50.375 //y=1.09 //x2=50.375 //y2=1.4
r1963 (  394 521 ) resistor r=45.1352 //w=0.168 //l=0.173853 //layer=ply \
 //thickness=0.18 //x=47.63 //y=1.44 //x2=47.59 //y2=1.595
r1964 (  393 520 ) resistor r=45.1352 //w=0.168 //l=0.173853 //layer=ply \
 //thickness=0.18 //x=47.63 //y=1.095 //x2=47.59 //y2=0.94
r1965 (  393 394 ) resistor r=176.904 //w=0.094 //l=0.345 //layer=ply \
 //thickness=0.18 //x=47.63 //y=1.095 //x2=47.63 //y2=1.44
r1966 (  391 517 ) resistor r=10.701 //w=0.21 //l=0.115 //layer=ply \
 //thickness=0.18 //x=47.255 //y=1.595 //x2=47.14 //y2=1.595
r1967 (  390 521 ) resistor r=5.52526 //w=0.168 //l=0.115 //layer=ply \
 //thickness=0.18 //x=47.475 //y=1.595 //x2=47.59 //y2=1.595
r1968 (  389 516 ) resistor r=5.52526 //w=0.168 //l=0.115 //layer=ply \
 //thickness=0.18 //x=47.255 //y=0.94 //x2=47.14 //y2=0.94
r1969 (  388 520 ) resistor r=5.52526 //w=0.168 //l=0.115 //layer=ply \
 //thickness=0.18 //x=47.475 //y=0.94 //x2=47.59 //y2=0.94
r1970 (  388 389 ) resistor r=112.809 //w=0.094 //l=0.22 //layer=ply \
 //thickness=0.18 //x=47.475 //y=0.94 //x2=47.255 //y2=0.94
r1971 (  385 519 ) resistor r=37.236 //w=0.233 //l=0.249199 //layer=ply \
 //thickness=0.18 //x=47.29 //y=5.045 //x2=47.11 //y2=4.88
r1972 (  383 517 ) resistor r=39.5823 //w=0.21 //l=0.173853 //layer=ply \
 //thickness=0.18 //x=47.1 //y=1.75 //x2=47.14 //y2=1.595
r1973 (  383 514 ) resistor r=176.904 //w=0.094 //l=0.345 //layer=ply \
 //thickness=0.18 //x=47.1 //y=1.75 //x2=47.1 //y2=2.095
r1974 (  382 517 ) resistor r=39.5823 //w=0.21 //l=0.173853 //layer=ply \
 //thickness=0.18 //x=47.1 //y=1.44 //x2=47.14 //y2=1.595
r1975 (  381 516 ) resistor r=45.1352 //w=0.168 //l=0.173853 //layer=ply \
 //thickness=0.18 //x=47.1 //y=1.095 //x2=47.14 //y2=0.94
r1976 (  381 382 ) resistor r=176.904 //w=0.094 //l=0.345 //layer=ply \
 //thickness=0.18 //x=47.1 //y=1.095 //x2=47.1 //y2=1.44
r1977 (  378 519 ) resistor r=53.7854 //w=0.233 //l=0.332415 //layer=ply \
 //thickness=0.18 //x=46.85 //y=5.045 //x2=47.11 //y2=4.88
r1978 (  374 506 ) resistor r=16.5046 //w=0.27 //l=0.135 //layer=ply \
 //thickness=0.18 //x=31.705 //y=4.97 //x2=31.57 //y2=4.97
r1979 (  373 375 ) resistor r=26.9307 //w=0.15 //l=0.106066 //layer=ply \
 //thickness=0.18 //x=31.905 //y=4.97 //x2=31.98 //y2=5.045
r1980 (  373 374 ) resistor r=102.553 //w=0.094 //l=0.2 //layer=ply \
 //thickness=0.18 //x=31.905 //y=4.97 //x2=31.705 //y2=4.97
r1981 (  372 511 ) resistor r=38.6777 //w=0.284 //l=0.198997 //layer=ply \
 //thickness=0.18 //x=31.66 //y=2.095 //x2=31.585 //y2=2.26
r1982 (  371 509 ) resistor r=21.2976 //w=0.217 //l=0.0928709 //layer=ply \
 //thickness=0.18 //x=31.66 //y=1.63 //x2=31.62 //y2=1.555
r1983 (  371 372 ) resistor r=238.436 //w=0.094 //l=0.465 //layer=ply \
 //thickness=0.18 //x=31.66 //y=1.63 //x2=31.66 //y2=2.095
r1984 (  370 509 ) resistor r=39.0671 //w=0.217 //l=0.173853 //layer=ply \
 //thickness=0.18 //x=31.66 //y=1.4 //x2=31.62 //y2=1.555
r1985 (  369 508 ) resistor r=45.1352 //w=0.168 //l=0.173853 //layer=ply \
 //thickness=0.18 //x=31.66 //y=1.09 //x2=31.62 //y2=0.935
r1986 (  369 370 ) resistor r=158.957 //w=0.094 //l=0.31 //layer=ply \
 //thickness=0.18 //x=31.66 //y=1.09 //x2=31.66 //y2=1.4
r1987 (  364 502 ) resistor r=5.52526 //w=0.168 //l=0.115 //layer=ply \
 //thickness=0.18 //x=31.29 //y=1.555 //x2=31.175 //y2=1.555
r1988 (  363 509 ) resistor r=11.4558 //w=0.217 //l=0.115 //layer=ply \
 //thickness=0.18 //x=31.505 //y=1.555 //x2=31.62 //y2=1.555
r1989 (  362 501 ) resistor r=5.52526 //w=0.168 //l=0.115 //layer=ply \
 //thickness=0.18 //x=31.29 //y=0.935 //x2=31.175 //y2=0.935
r1990 (  361 508 ) resistor r=5.52526 //w=0.168 //l=0.115 //layer=ply \
 //thickness=0.18 //x=31.505 //y=0.935 //x2=31.62 //y2=0.935
r1991 (  361 362 ) resistor r=110.245 //w=0.094 //l=0.215 //layer=ply \
 //thickness=0.18 //x=31.505 //y=0.935 //x2=31.29 //y2=0.935
r1992 (  360 502 ) resistor r=45.1352 //w=0.168 //l=0.173853 //layer=ply \
 //thickness=0.18 //x=31.135 //y=1.4 //x2=31.175 //y2=1.555
r1993 (  359 501 ) resistor r=45.1352 //w=0.168 //l=0.173853 //layer=ply \
 //thickness=0.18 //x=31.135 //y=1.09 //x2=31.175 //y2=0.935
r1994 (  359 360 ) resistor r=158.957 //w=0.094 //l=0.31 //layer=ply \
 //thickness=0.18 //x=31.135 //y=1.09 //x2=31.135 //y2=1.4
r1995 (  355 495 ) resistor r=16.5046 //w=0.27 //l=0.135 //layer=ply \
 //thickness=0.18 //x=22.085 //y=4.97 //x2=21.95 //y2=4.97
r1996 (  354 356 ) resistor r=26.9307 //w=0.15 //l=0.106066 //layer=ply \
 //thickness=0.18 //x=22.285 //y=4.97 //x2=22.36 //y2=5.045
r1997 (  354 355 ) resistor r=102.553 //w=0.094 //l=0.2 //layer=ply \
 //thickness=0.18 //x=22.285 //y=4.97 //x2=22.085 //y2=4.97
r1998 (  353 500 ) resistor r=38.6777 //w=0.284 //l=0.198997 //layer=ply \
 //thickness=0.18 //x=22.04 //y=2.095 //x2=21.965 //y2=2.26
r1999 (  352 498 ) resistor r=21.2976 //w=0.217 //l=0.0928709 //layer=ply \
 //thickness=0.18 //x=22.04 //y=1.63 //x2=22 //y2=1.555
r2000 (  352 353 ) resistor r=238.436 //w=0.094 //l=0.465 //layer=ply \
 //thickness=0.18 //x=22.04 //y=1.63 //x2=22.04 //y2=2.095
r2001 (  351 498 ) resistor r=39.0671 //w=0.217 //l=0.173853 //layer=ply \
 //thickness=0.18 //x=22.04 //y=1.4 //x2=22 //y2=1.555
r2002 (  350 497 ) resistor r=45.1352 //w=0.168 //l=0.173853 //layer=ply \
 //thickness=0.18 //x=22.04 //y=1.09 //x2=22 //y2=0.935
r2003 (  350 351 ) resistor r=158.957 //w=0.094 //l=0.31 //layer=ply \
 //thickness=0.18 //x=22.04 //y=1.09 //x2=22.04 //y2=1.4
r2004 (  345 491 ) resistor r=5.52526 //w=0.168 //l=0.115 //layer=ply \
 //thickness=0.18 //x=21.67 //y=1.555 //x2=21.555 //y2=1.555
r2005 (  344 498 ) resistor r=11.4558 //w=0.217 //l=0.115 //layer=ply \
 //thickness=0.18 //x=21.885 //y=1.555 //x2=22 //y2=1.555
r2006 (  343 490 ) resistor r=5.52526 //w=0.168 //l=0.115 //layer=ply \
 //thickness=0.18 //x=21.67 //y=0.935 //x2=21.555 //y2=0.935
r2007 (  342 497 ) resistor r=5.52526 //w=0.168 //l=0.115 //layer=ply \
 //thickness=0.18 //x=21.885 //y=0.935 //x2=22 //y2=0.935
r2008 (  342 343 ) resistor r=110.245 //w=0.094 //l=0.215 //layer=ply \
 //thickness=0.18 //x=21.885 //y=0.935 //x2=21.67 //y2=0.935
r2009 (  341 491 ) resistor r=45.1352 //w=0.168 //l=0.173853 //layer=ply \
 //thickness=0.18 //x=21.515 //y=1.4 //x2=21.555 //y2=1.555
r2010 (  340 490 ) resistor r=45.1352 //w=0.168 //l=0.173853 //layer=ply \
 //thickness=0.18 //x=21.515 //y=1.09 //x2=21.555 //y2=0.935
r2011 (  340 341 ) resistor r=158.957 //w=0.094 //l=0.31 //layer=ply \
 //thickness=0.18 //x=21.515 //y=1.09 //x2=21.515 //y2=1.4
r2012 (  339 489 ) resistor r=45.1352 //w=0.168 //l=0.173853 //layer=ply \
 //thickness=0.18 //x=18.77 //y=1.44 //x2=18.73 //y2=1.595
r2013 (  338 488 ) resistor r=45.1352 //w=0.168 //l=0.173853 //layer=ply \
 //thickness=0.18 //x=18.77 //y=1.095 //x2=18.73 //y2=0.94
r2014 (  338 339 ) resistor r=176.904 //w=0.094 //l=0.345 //layer=ply \
 //thickness=0.18 //x=18.77 //y=1.095 //x2=18.77 //y2=1.44
r2015 (  336 485 ) resistor r=10.701 //w=0.21 //l=0.115 //layer=ply \
 //thickness=0.18 //x=18.395 //y=1.595 //x2=18.28 //y2=1.595
r2016 (  335 489 ) resistor r=5.52526 //w=0.168 //l=0.115 //layer=ply \
 //thickness=0.18 //x=18.615 //y=1.595 //x2=18.73 //y2=1.595
r2017 (  334 484 ) resistor r=5.52526 //w=0.168 //l=0.115 //layer=ply \
 //thickness=0.18 //x=18.395 //y=0.94 //x2=18.28 //y2=0.94
r2018 (  333 488 ) resistor r=5.52526 //w=0.168 //l=0.115 //layer=ply \
 //thickness=0.18 //x=18.615 //y=0.94 //x2=18.73 //y2=0.94
r2019 (  333 334 ) resistor r=112.809 //w=0.094 //l=0.22 //layer=ply \
 //thickness=0.18 //x=18.615 //y=0.94 //x2=18.395 //y2=0.94
r2020 (  330 487 ) resistor r=37.236 //w=0.233 //l=0.249199 //layer=ply \
 //thickness=0.18 //x=18.43 //y=5.045 //x2=18.25 //y2=4.88
r2021 (  328 485 ) resistor r=39.5823 //w=0.21 //l=0.173853 //layer=ply \
 //thickness=0.18 //x=18.24 //y=1.75 //x2=18.28 //y2=1.595
r2022 (  328 482 ) resistor r=176.904 //w=0.094 //l=0.345 //layer=ply \
 //thickness=0.18 //x=18.24 //y=1.75 //x2=18.24 //y2=2.095
r2023 (  327 485 ) resistor r=39.5823 //w=0.21 //l=0.173853 //layer=ply \
 //thickness=0.18 //x=18.24 //y=1.44 //x2=18.28 //y2=1.595
r2024 (  326 484 ) resistor r=45.1352 //w=0.168 //l=0.173853 //layer=ply \
 //thickness=0.18 //x=18.24 //y=1.095 //x2=18.28 //y2=0.94
r2025 (  326 327 ) resistor r=176.904 //w=0.094 //l=0.345 //layer=ply \
 //thickness=0.18 //x=18.24 //y=1.095 //x2=18.24 //y2=1.44
r2026 (  323 487 ) resistor r=53.7854 //w=0.233 //l=0.332415 //layer=ply \
 //thickness=0.18 //x=17.99 //y=5.045 //x2=18.25 //y2=4.88
r2027 (  319 474 ) resistor r=16.5046 //w=0.27 //l=0.135 //layer=ply \
 //thickness=0.18 //x=2.845 //y=4.97 //x2=2.71 //y2=4.97
r2028 (  318 320 ) resistor r=26.9307 //w=0.15 //l=0.106066 //layer=ply \
 //thickness=0.18 //x=3.045 //y=4.97 //x2=3.12 //y2=5.045
r2029 (  318 319 ) resistor r=102.553 //w=0.094 //l=0.2 //layer=ply \
 //thickness=0.18 //x=3.045 //y=4.97 //x2=2.845 //y2=4.97
r2030 (  317 479 ) resistor r=38.6777 //w=0.284 //l=0.198997 //layer=ply \
 //thickness=0.18 //x=2.8 //y=2.095 //x2=2.725 //y2=2.26
r2031 (  316 477 ) resistor r=21.2976 //w=0.217 //l=0.0928709 //layer=ply \
 //thickness=0.18 //x=2.8 //y=1.63 //x2=2.76 //y2=1.555
r2032 (  316 317 ) resistor r=238.436 //w=0.094 //l=0.465 //layer=ply \
 //thickness=0.18 //x=2.8 //y=1.63 //x2=2.8 //y2=2.095
r2033 (  315 477 ) resistor r=39.0671 //w=0.217 //l=0.173853 //layer=ply \
 //thickness=0.18 //x=2.8 //y=1.4 //x2=2.76 //y2=1.555
r2034 (  314 476 ) resistor r=45.1352 //w=0.168 //l=0.173853 //layer=ply \
 //thickness=0.18 //x=2.8 //y=1.09 //x2=2.76 //y2=0.935
r2035 (  314 315 ) resistor r=158.957 //w=0.094 //l=0.31 //layer=ply \
 //thickness=0.18 //x=2.8 //y=1.09 //x2=2.8 //y2=1.4
r2036 (  309 470 ) resistor r=5.52526 //w=0.168 //l=0.115 //layer=ply \
 //thickness=0.18 //x=2.43 //y=1.555 //x2=2.315 //y2=1.555
r2037 (  308 477 ) resistor r=11.4558 //w=0.217 //l=0.115 //layer=ply \
 //thickness=0.18 //x=2.645 //y=1.555 //x2=2.76 //y2=1.555
r2038 (  307 469 ) resistor r=5.52526 //w=0.168 //l=0.115 //layer=ply \
 //thickness=0.18 //x=2.43 //y=0.935 //x2=2.315 //y2=0.935
r2039 (  306 476 ) resistor r=5.52526 //w=0.168 //l=0.115 //layer=ply \
 //thickness=0.18 //x=2.645 //y=0.935 //x2=2.76 //y2=0.935
r2040 (  306 307 ) resistor r=110.245 //w=0.094 //l=0.215 //layer=ply \
 //thickness=0.18 //x=2.645 //y=0.935 //x2=2.43 //y2=0.935
r2041 (  305 470 ) resistor r=45.1352 //w=0.168 //l=0.173853 //layer=ply \
 //thickness=0.18 //x=2.275 //y=1.4 //x2=2.315 //y2=1.555
r2042 (  304 469 ) resistor r=45.1352 //w=0.168 //l=0.173853 //layer=ply \
 //thickness=0.18 //x=2.275 //y=1.09 //x2=2.315 //y2=0.935
r2043 (  304 305 ) resistor r=158.957 //w=0.094 //l=0.31 //layer=ply \
 //thickness=0.18 //x=2.275 //y=1.09 //x2=2.275 //y2=1.4
r2044 (  303 466 ) resistor r=592.245 //w=0.094 //l=1.155 //layer=ply \
 //thickness=0.18 //x=80.08 //y=6.2 //x2=80.08 //y2=5.045
r2045 (  302 560 ) resistor r=592.245 //w=0.094 //l=1.155 //layer=ply \
 //thickness=0.18 //x=79.64 //y=6.2 //x2=79.64 //y2=5.045
r2046 (  301 440 ) resistor r=592.245 //w=0.094 //l=1.155 //layer=ply \
 //thickness=0.18 //x=76.15 //y=6.2 //x2=76.15 //y2=5.045
r2047 (  300 433 ) resistor r=592.245 //w=0.094 //l=1.155 //layer=ply \
 //thickness=0.18 //x=75.71 //y=6.2 //x2=75.71 //y2=5.045
r2048 (  299 430 ) resistor r=592.245 //w=0.094 //l=1.155 //layer=ply \
 //thickness=0.18 //x=60.84 //y=6.2 //x2=60.84 //y2=5.045
r2049 (  298 539 ) resistor r=592.245 //w=0.094 //l=1.155 //layer=ply \
 //thickness=0.18 //x=60.4 //y=6.2 //x2=60.4 //y2=5.045
r2050 (  297 411 ) resistor r=592.245 //w=0.094 //l=1.155 //layer=ply \
 //thickness=0.18 //x=51.22 //y=6.2 //x2=51.22 //y2=5.045
r2051 (  296 528 ) resistor r=592.245 //w=0.094 //l=1.155 //layer=ply \
 //thickness=0.18 //x=50.78 //y=6.2 //x2=50.78 //y2=5.045
r2052 (  295 385 ) resistor r=592.245 //w=0.094 //l=1.155 //layer=ply \
 //thickness=0.18 //x=47.29 //y=6.2 //x2=47.29 //y2=5.045
r2053 (  294 378 ) resistor r=592.245 //w=0.094 //l=1.155 //layer=ply \
 //thickness=0.18 //x=46.85 //y=6.2 //x2=46.85 //y2=5.045
r2054 (  293 375 ) resistor r=592.245 //w=0.094 //l=1.155 //layer=ply \
 //thickness=0.18 //x=31.98 //y=6.2 //x2=31.98 //y2=5.045
r2055 (  292 507 ) resistor r=592.245 //w=0.094 //l=1.155 //layer=ply \
 //thickness=0.18 //x=31.54 //y=6.2 //x2=31.54 //y2=5.045
r2056 (  291 356 ) resistor r=592.245 //w=0.094 //l=1.155 //layer=ply \
 //thickness=0.18 //x=22.36 //y=6.2 //x2=22.36 //y2=5.045
r2057 (  290 496 ) resistor r=592.245 //w=0.094 //l=1.155 //layer=ply \
 //thickness=0.18 //x=21.92 //y=6.2 //x2=21.92 //y2=5.045
r2058 (  289 330 ) resistor r=592.245 //w=0.094 //l=1.155 //layer=ply \
 //thickness=0.18 //x=18.43 //y=6.2 //x2=18.43 //y2=5.045
r2059 (  288 323 ) resistor r=592.245 //w=0.094 //l=1.155 //layer=ply \
 //thickness=0.18 //x=17.99 //y=6.2 //x2=17.99 //y2=5.045
r2060 (  287 320 ) resistor r=592.245 //w=0.094 //l=1.155 //layer=ply \
 //thickness=0.18 //x=3.12 //y=6.2 //x2=3.12 //y2=5.045
r2061 (  286 475 ) resistor r=592.245 //w=0.094 //l=1.155 //layer=ply \
 //thickness=0.18 //x=2.68 //y=6.2 //x2=2.68 //y2=5.045
r2062 (  285 454 ) resistor r=55.3787 //w=0.094 //l=0.108 //layer=ply \
 //thickness=0.18 //x=79.497 //y=1.555 //x2=79.605 //y2=1.555
r2063 (  285 455 ) resistor r=54.866 //w=0.094 //l=0.107 //layer=ply \
 //thickness=0.18 //x=79.497 //y=1.555 //x2=79.39 //y2=1.555
r2064 (  284 445 ) resistor r=56.4043 //w=0.094 //l=0.11 //layer=ply \
 //thickness=0.18 //x=76.225 //y=1.595 //x2=76.335 //y2=1.595
r2065 (  284 446 ) resistor r=56.4043 //w=0.094 //l=0.11 //layer=ply \
 //thickness=0.18 //x=76.225 //y=1.595 //x2=76.115 //y2=1.595
r2066 (  283 418 ) resistor r=55.3787 //w=0.094 //l=0.108 //layer=ply \
 //thickness=0.18 //x=60.257 //y=1.555 //x2=60.365 //y2=1.555
r2067 (  283 419 ) resistor r=54.866 //w=0.094 //l=0.107 //layer=ply \
 //thickness=0.18 //x=60.257 //y=1.555 //x2=60.15 //y2=1.555
r2068 (  282 399 ) resistor r=55.3787 //w=0.094 //l=0.108 //layer=ply \
 //thickness=0.18 //x=50.637 //y=1.555 //x2=50.745 //y2=1.555
r2069 (  282 400 ) resistor r=54.866 //w=0.094 //l=0.107 //layer=ply \
 //thickness=0.18 //x=50.637 //y=1.555 //x2=50.53 //y2=1.555
r2070 (  281 390 ) resistor r=56.4043 //w=0.094 //l=0.11 //layer=ply \
 //thickness=0.18 //x=47.365 //y=1.595 //x2=47.475 //y2=1.595
r2071 (  281 391 ) resistor r=56.4043 //w=0.094 //l=0.11 //layer=ply \
 //thickness=0.18 //x=47.365 //y=1.595 //x2=47.255 //y2=1.595
r2072 (  280 363 ) resistor r=55.3787 //w=0.094 //l=0.108 //layer=ply \
 //thickness=0.18 //x=31.397 //y=1.555 //x2=31.505 //y2=1.555
r2073 (  280 364 ) resistor r=54.866 //w=0.094 //l=0.107 //layer=ply \
 //thickness=0.18 //x=31.397 //y=1.555 //x2=31.29 //y2=1.555
r2074 (  279 344 ) resistor r=55.3787 //w=0.094 //l=0.108 //layer=ply \
 //thickness=0.18 //x=21.777 //y=1.555 //x2=21.885 //y2=1.555
r2075 (  279 345 ) resistor r=54.866 //w=0.094 //l=0.107 //layer=ply \
 //thickness=0.18 //x=21.777 //y=1.555 //x2=21.67 //y2=1.555
r2076 (  278 335 ) resistor r=56.4043 //w=0.094 //l=0.11 //layer=ply \
 //thickness=0.18 //x=18.505 //y=1.595 //x2=18.615 //y2=1.595
r2077 (  278 336 ) resistor r=56.4043 //w=0.094 //l=0.11 //layer=ply \
 //thickness=0.18 //x=18.505 //y=1.595 //x2=18.395 //y2=1.595
r2078 (  277 308 ) resistor r=55.3787 //w=0.094 //l=0.108 //layer=ply \
 //thickness=0.18 //x=2.537 //y=1.555 //x2=2.645 //y2=1.555
r2079 (  277 309 ) resistor r=54.866 //w=0.094 //l=0.107 //layer=ply \
 //thickness=0.18 //x=2.537 //y=1.555 //x2=2.43 //y2=1.555
r2080 (  273 557 ) resistor r=152 //w=0.17 //l=0.17 //layer=licon //count=1 \
 //x=79.67 //y=4.88 //x2=79.67 //y2=4.88
r2081 (  268 564 ) resistor r=152 //w=0.17 //l=0.17 //layer=licon //count=1 \
 //x=79.67 //y=2.26 //x2=79.67 //y2=2.26
r2082 (  263 551 ) resistor r=152 //w=0.17 //l=0.17 //layer=licon //count=1 \
 //x=75.97 //y=4.88 //x2=75.97 //y2=4.88
r2083 (  258 545 ) resistor r=152 //w=0.17 //l=0.17 //layer=licon //count=1 \
 //x=75.97 //y=2.26 //x2=75.97 //y2=2.26
r2084 (  253 536 ) resistor r=152 //w=0.17 //l=0.17 //layer=licon //count=1 \
 //x=60.43 //y=4.88 //x2=60.43 //y2=4.88
r2085 (  248 543 ) resistor r=152 //w=0.17 //l=0.17 //layer=licon //count=1 \
 //x=60.43 //y=2.26 //x2=60.43 //y2=2.26
r2086 (  243 525 ) resistor r=152 //w=0.17 //l=0.17 //layer=licon //count=1 \
 //x=50.81 //y=4.88 //x2=50.81 //y2=4.88
r2087 (  238 532 ) resistor r=152 //w=0.17 //l=0.17 //layer=licon //count=1 \
 //x=50.81 //y=2.26 //x2=50.81 //y2=2.26
r2088 (  233 519 ) resistor r=152 //w=0.17 //l=0.17 //layer=licon //count=1 \
 //x=47.11 //y=4.88 //x2=47.11 //y2=4.88
r2089 (  228 513 ) resistor r=152 //w=0.17 //l=0.17 //layer=licon //count=1 \
 //x=47.11 //y=2.26 //x2=47.11 //y2=2.26
r2090 (  223 504 ) resistor r=152 //w=0.17 //l=0.17 //layer=licon //count=1 \
 //x=31.57 //y=4.88 //x2=31.57 //y2=4.88
r2091 (  218 511 ) resistor r=152 //w=0.17 //l=0.17 //layer=licon //count=1 \
 //x=31.57 //y=2.26 //x2=31.57 //y2=2.26
r2092 (  213 493 ) resistor r=152 //w=0.17 //l=0.17 //layer=licon //count=1 \
 //x=21.95 //y=4.88 //x2=21.95 //y2=4.88
r2093 (  208 500 ) resistor r=152 //w=0.17 //l=0.17 //layer=licon //count=1 \
 //x=21.95 //y=2.26 //x2=21.95 //y2=2.26
r2094 (  203 487 ) resistor r=152 //w=0.17 //l=0.17 //layer=licon //count=1 \
 //x=18.25 //y=4.88 //x2=18.25 //y2=4.88
r2095 (  198 481 ) resistor r=152 //w=0.17 //l=0.17 //layer=licon //count=1 \
 //x=18.25 //y=2.26 //x2=18.25 //y2=2.26
r2096 (  193 472 ) resistor r=152 //w=0.17 //l=0.17 //layer=licon //count=1 \
 //x=2.71 //y=4.88 //x2=2.71 //y2=4.88
r2097 (  188 479 ) resistor r=152 //w=0.17 //l=0.17 //layer=licon //count=1 \
 //x=2.71 //y=2.26 //x2=2.71 //y2=2.26
r2098 (  184 185 ) resistor r=0.10734 //w=0.281 //l=0.16 //layer=m2 \
 //thickness=0.36 //x=79.665 //y=2.41 //x2=79.505 //y2=2.41
r2099 (  165 182 ) resistor r=0.105717 //w=0.193 //l=0.162481 //layer=m2 \
 //thickness=0.36 //x=76.135 //y=2.4 //x2=75.975 //y2=2.405
r2100 (  165 185 ) resistor r=3.21565 //w=0.131 //l=3.37 //layer=m2 \
 //thickness=0.36 //x=76.135 //y=2.4 //x2=79.505 //y2=2.4
r2101 (  162 182 ) resistor r=1.29743 //w=0.193 //l=2.00998 //layer=m2 \
 //thickness=0.36 //x=73.975 //y=2.385 //x2=75.975 //y2=2.405
r2102 (  162 163 ) resistor r=0.410305 //w=0.131 //l=0.43 //layer=m2 \
 //thickness=0.36 //x=73.975 //y=2.385 //x2=73.545 //y2=2.385
r2103 (  160 163 ) resistor r=0.125 //w=0.17 //l=0.177341 //layer=m2 \
 //thickness=0.36 //x=73.375 //y=2.4 //x2=73.545 //y2=2.385
r2104 (  160 161 ) resistor r=0.958969 //w=0.131 //l=1.005 //layer=m2 \
 //thickness=0.36 //x=73.375 //y=2.4 //x2=72.37 //y2=2.4
r2105 (  159 180 ) resistor r=8.13223 //w=0.173 //l=11.2625 //layer=m2 \
 //thickness=0.36 //x=71.685 //y=2.385 //x2=60.43 //y2=2.4
r2106 (  158 161 ) resistor r=0.1875 //w=0.17 //l=0.262393 //layer=m2 \
 //thickness=0.36 //x=72.115 //y=2.385 //x2=72.37 //y2=2.4
r2107 (  158 159 ) resistor r=0.410305 //w=0.131 //l=0.43 //layer=m2 \
 //thickness=0.36 //x=72.115 //y=2.385 //x2=71.685 //y2=2.385
r2108 (  156 180 ) resistor r=4.15462 //w=0.173 //l=5.76498 //layer=m2 \
 //thickness=0.36 //x=54.68 //y=2.37 //x2=60.43 //y2=2.4
r2109 (  156 157 ) resistor r=0.410305 //w=0.131 //l=0.43 //layer=m2 \
 //thickness=0.36 //x=54.68 //y=2.37 //x2=54.25 //y2=2.37
r2110 (  154 157 ) resistor r=0.125 //w=0.17 //l=0.184391 //layer=m2 \
 //thickness=0.36 //x=54.08 //y=2.4 //x2=54.25 //y2=2.37
r2111 (  154 155 ) resistor r=0.86355 //w=0.131 //l=0.905 //layer=m2 \
 //thickness=0.36 //x=54.08 //y=2.4 //x2=53.175 //y2=2.4
r2112 (  153 178 ) resistor r=1.07185 //w=0.197 //l=1.70488 //layer=m2 \
 //thickness=0.36 //x=52.49 //y=2.37 //x2=50.805 //y2=2.41
r2113 (  152 155 ) resistor r=0.1875 //w=0.17 //l=0.269583 //layer=m2 \
 //thickness=0.36 //x=52.92 //y=2.37 //x2=53.175 //y2=2.4
r2114 (  152 153 ) resistor r=0.410305 //w=0.131 //l=0.43 //layer=m2 \
 //thickness=0.36 //x=52.92 //y=2.37 //x2=52.49 //y2=2.37
r2115 (  151 176 ) resistor r=0.105717 //w=0.193 //l=0.162481 //layer=m2 \
 //thickness=0.36 //x=47.275 //y=2.4 //x2=47.115 //y2=2.405
r2116 (  150 178 ) resistor r=0.104215 //w=0.197 //l=0.164924 //layer=m2 \
 //thickness=0.36 //x=50.645 //y=2.4 //x2=50.805 //y2=2.41
r2117 (  150 151 ) resistor r=3.21565 //w=0.131 //l=3.37 //layer=m2 \
 //thickness=0.36 //x=50.645 //y=2.4 //x2=47.275 //y2=2.4
r2118 (  148 176 ) resistor r=1.29743 //w=0.193 //l=2.00998 //layer=m2 \
 //thickness=0.36 //x=45.115 //y=2.385 //x2=47.115 //y2=2.405
r2119 (  148 149 ) resistor r=0.410305 //w=0.131 //l=0.43 //layer=m2 \
 //thickness=0.36 //x=45.115 //y=2.385 //x2=44.685 //y2=2.385
r2120 (  146 149 ) resistor r=0.125 //w=0.17 //l=0.177341 //layer=m2 \
 //thickness=0.36 //x=44.515 //y=2.4 //x2=44.685 //y2=2.385
r2121 (  146 147 ) resistor r=0.958969 //w=0.131 //l=1.005 //layer=m2 \
 //thickness=0.36 //x=44.515 //y=2.4 //x2=43.51 //y2=2.4
r2122 (  145 174 ) resistor r=8.13223 //w=0.173 //l=11.2625 //layer=m2 \
 //thickness=0.36 //x=42.825 //y=2.385 //x2=31.57 //y2=2.4
r2123 (  144 147 ) resistor r=0.1875 //w=0.17 //l=0.262393 //layer=m2 \
 //thickness=0.36 //x=43.255 //y=2.385 //x2=43.51 //y2=2.4
r2124 (  144 145 ) resistor r=0.410305 //w=0.131 //l=0.43 //layer=m2 \
 //thickness=0.36 //x=43.255 //y=2.385 //x2=42.825 //y2=2.385
r2125 (  142 174 ) resistor r=4.12211 //w=0.173 //l=5.71998 //layer=m2 \
 //thickness=0.36 //x=25.865 //y=2.37 //x2=31.57 //y2=2.4
r2126 (  142 143 ) resistor r=0.410305 //w=0.131 //l=0.43 //layer=m2 \
 //thickness=0.36 //x=25.865 //y=2.37 //x2=25.435 //y2=2.37
r2127 (  140 143 ) resistor r=0.125 //w=0.17 //l=0.184391 //layer=m2 \
 //thickness=0.36 //x=25.265 //y=2.4 //x2=25.435 //y2=2.37
r2128 (  140 141 ) resistor r=0.96374 //w=0.131 //l=1.01 //layer=m2 \
 //thickness=0.36 //x=25.265 //y=2.4 //x2=24.255 //y2=2.4
r2129 (  139 172 ) resistor r=1.03378 //w=0.197 //l=1.64488 //layer=m2 \
 //thickness=0.36 //x=23.57 //y=2.37 //x2=21.945 //y2=2.41
r2130 (  138 141 ) resistor r=0.1875 //w=0.17 //l=0.269583 //layer=m2 \
 //thickness=0.36 //x=24 //y=2.37 //x2=24.255 //y2=2.4
r2131 (  138 139 ) resistor r=0.410305 //w=0.131 //l=0.43 //layer=m2 \
 //thickness=0.36 //x=24 //y=2.37 //x2=23.57 //y2=2.37
r2132 (  137 170 ) resistor r=0.105717 //w=0.193 //l=0.162481 //layer=m2 \
 //thickness=0.36 //x=18.415 //y=2.4 //x2=18.255 //y2=2.405
r2133 (  136 172 ) resistor r=0.104215 //w=0.197 //l=0.164924 //layer=m2 \
 //thickness=0.36 //x=21.785 //y=2.4 //x2=21.945 //y2=2.41
r2134 (  136 137 ) resistor r=3.21565 //w=0.131 //l=3.37 //layer=m2 \
 //thickness=0.36 //x=21.785 //y=2.4 //x2=18.415 //y2=2.4
r2135 (  134 170 ) resistor r=1.29743 //w=0.193 //l=2.00998 //layer=m2 \
 //thickness=0.36 //x=16.255 //y=2.385 //x2=18.255 //y2=2.405
r2136 (  134 135 ) resistor r=0.410305 //w=0.131 //l=0.43 //layer=m2 \
 //thickness=0.36 //x=16.255 //y=2.385 //x2=15.825 //y2=2.385
r2137 (  132 135 ) resistor r=0.125 //w=0.17 //l=0.177341 //layer=m2 \
 //thickness=0.36 //x=15.655 //y=2.4 //x2=15.825 //y2=2.385
r2138 (  132 133 ) resistor r=0.958969 //w=0.131 //l=1.005 //layer=m2 \
 //thickness=0.36 //x=15.655 //y=2.4 //x2=14.65 //y2=2.4
r2139 (  130 133 ) resistor r=0.1875 //w=0.17 //l=0.262393 //layer=m2 \
 //thickness=0.36 //x=14.395 //y=2.385 //x2=14.65 //y2=2.4
r2140 (  130 131 ) resistor r=0.410305 //w=0.131 //l=0.43 //layer=m2 \
 //thickness=0.36 //x=14.395 //y=2.385 //x2=13.965 //y2=2.385
r2141 (  129 167 ) resistor r=0.10734 //w=0.281 //l=0.16 //layer=m2 \
 //thickness=0.36 //x=2.87 //y=2.4 //x2=2.71 //y2=2.4
r2142 (  128 131 ) resistor r=0.125 //w=0.17 //l=0.177341 //layer=m2 \
 //thickness=0.36 //x=13.795 //y=2.4 //x2=13.965 //y2=2.385
r2143 (  128 129 ) resistor r=10.4246 //w=0.131 //l=10.925 //layer=m2 \
 //thickness=0.36 //x=13.795 //y=2.4 //x2=2.87 //y2=2.4
r2144 (  127 184 ) resistor r=4.5 //w=0.15 //l=0.15 //layer=via1 //count=1 \
 //x=79.665 //y=2.41 //x2=79.665 //y2=2.41
r2145 (  124 268 ) resistor r=9.3 //w=0.17 //l=0.17 //layer=mcon //count=1 \
 //x=79.67 //y=2.26 //x2=79.67 //y2=2.26
r2146 (  122 273 ) resistor r=9.3 //w=0.17 //l=0.17 //layer=mcon //count=1 \
 //x=79.67 //y=4.88 //x2=79.67 //y2=4.88
r2147 (  120 182 ) resistor r=4.5 //w=0.15 //l=0.15 //layer=via1 //count=1 \
 //x=75.975 //y=2.405 //x2=75.975 //y2=2.405
r2148 (  117 258 ) resistor r=9.3 //w=0.17 //l=0.17 //layer=mcon //count=1 \
 //x=75.97 //y=2.26 //x2=75.97 //y2=2.26
r2149 (  115 263 ) resistor r=9.3 //w=0.17 //l=0.17 //layer=mcon //count=1 \
 //x=75.97 //y=4.88 //x2=75.97 //y2=4.88
r2150 (  111 248 ) resistor r=9.3 //w=0.17 //l=0.17 //layer=mcon //count=1 \
 //x=60.43 //y=2.26 //x2=60.43 //y2=2.26
r2151 (  109 253 ) resistor r=9.3 //w=0.17 //l=0.17 //layer=mcon //count=1 \
 //x=60.43 //y=4.88 //x2=60.43 //y2=4.88
r2152 (  107 178 ) resistor r=4.5 //w=0.15 //l=0.15 //layer=via1 //count=1 \
 //x=50.805 //y=2.41 //x2=50.805 //y2=2.41
r2153 (  104 238 ) resistor r=9.3 //w=0.17 //l=0.17 //layer=mcon //count=1 \
 //x=50.81 //y=2.26 //x2=50.81 //y2=2.26
r2154 (  102 243 ) resistor r=9.3 //w=0.17 //l=0.17 //layer=mcon //count=1 \
 //x=50.81 //y=4.88 //x2=50.81 //y2=4.88
r2155 (  100 176 ) resistor r=4.5 //w=0.15 //l=0.15 //layer=via1 //count=1 \
 //x=47.115 //y=2.405 //x2=47.115 //y2=2.405
r2156 (  97 228 ) resistor r=9.3 //w=0.17 //l=0.17 //layer=mcon //count=1 \
 //x=47.11 //y=2.26 //x2=47.11 //y2=2.26
r2157 (  95 233 ) resistor r=9.3 //w=0.17 //l=0.17 //layer=mcon //count=1 \
 //x=47.11 //y=4.88 //x2=47.11 //y2=4.88
r2158 (  91 218 ) resistor r=9.3 //w=0.17 //l=0.17 //layer=mcon //count=1 \
 //x=31.57 //y=2.26 //x2=31.57 //y2=2.26
r2159 (  89 223 ) resistor r=9.3 //w=0.17 //l=0.17 //layer=mcon //count=1 \
 //x=31.57 //y=4.88 //x2=31.57 //y2=4.88
r2160 (  87 172 ) resistor r=4.5 //w=0.15 //l=0.15 //layer=via1 //count=1 \
 //x=21.945 //y=2.41 //x2=21.945 //y2=2.41
r2161 (  84 208 ) resistor r=9.3 //w=0.17 //l=0.17 //layer=mcon //count=1 \
 //x=21.95 //y=2.26 //x2=21.95 //y2=2.26
r2162 (  82 213 ) resistor r=9.3 //w=0.17 //l=0.17 //layer=mcon //count=1 \
 //x=21.95 //y=4.88 //x2=21.95 //y2=4.88
r2163 (  80 170 ) resistor r=4.5 //w=0.15 //l=0.15 //layer=via1 //count=1 \
 //x=18.255 //y=2.405 //x2=18.255 //y2=2.405
r2164 (  77 198 ) resistor r=9.3 //w=0.17 //l=0.17 //layer=mcon //count=1 \
 //x=18.25 //y=2.26 //x2=18.25 //y2=2.26
r2165 (  75 203 ) resistor r=9.3 //w=0.17 //l=0.17 //layer=mcon //count=1 \
 //x=18.25 //y=4.88 //x2=18.25 //y2=4.88
r2166 (  71 188 ) resistor r=9.3 //w=0.17 //l=0.17 //layer=mcon //count=1 \
 //x=2.71 //y=2.26 //x2=2.71 //y2=2.26
r2167 (  69 193 ) resistor r=9.3 //w=0.17 //l=0.17 //layer=mcon //count=1 \
 //x=2.71 //y=4.88 //x2=2.71 //y2=4.88
r2168 (  65 122 ) resistor r=0.0717383 //w=0.224 //l=0.115 //layer=m1 \
 //thickness=0.36 //x=79.67 //y=4.765 //x2=79.67 //y2=4.88
r2169 (  64 127 ) resistor r=0.0902915 //w=0.287 //l=0.162481 //layer=m1 \
 //thickness=0.36 //x=79.67 //y=2.57 //x2=79.665 //y2=2.41
r2170 (  62 115 ) resistor r=0.0801089 //w=0.224 //l=0.13 //layer=m1 \
 //thickness=0.36 //x=75.97 //y=4.75 //x2=75.97 //y2=4.88
r2171 (  61 120 ) resistor r=0.0902915 //w=0.287 //l=0.162481 //layer=m1 \
 //thickness=0.36 //x=75.97 //y=2.565 //x2=75.975 //y2=2.405
r2172 (  57 109 ) resistor r=0.0717383 //w=0.224 //l=0.115 //layer=m1 \
 //thickness=0.36 //x=60.43 //y=4.765 //x2=60.43 //y2=4.88
r2173 (  53 102 ) resistor r=0.0717383 //w=0.224 //l=0.115 //layer=m1 \
 //thickness=0.36 //x=50.81 //y=4.765 //x2=50.81 //y2=4.88
r2174 (  52 107 ) resistor r=0.0902915 //w=0.287 //l=0.162481 //layer=m1 \
 //thickness=0.36 //x=50.81 //y=2.57 //x2=50.805 //y2=2.41
r2175 (  50 95 ) resistor r=0.0801089 //w=0.224 //l=0.13 //layer=m1 \
 //thickness=0.36 //x=47.11 //y=4.75 //x2=47.11 //y2=4.88
r2176 (  49 100 ) resistor r=0.0902915 //w=0.287 //l=0.162481 //layer=m1 \
 //thickness=0.36 //x=47.11 //y=2.565 //x2=47.115 //y2=2.405
r2177 (  45 89 ) resistor r=0.0717383 //w=0.224 //l=0.115 //layer=m1 \
 //thickness=0.36 //x=31.57 //y=4.765 //x2=31.57 //y2=4.88
r2178 (  41 82 ) resistor r=0.0717383 //w=0.224 //l=0.115 //layer=m1 \
 //thickness=0.36 //x=21.95 //y=4.765 //x2=21.95 //y2=4.88
r2179 (  40 87 ) resistor r=0.0902915 //w=0.287 //l=0.162481 //layer=m1 \
 //thickness=0.36 //x=21.95 //y=2.57 //x2=21.945 //y2=2.41
r2180 (  38 75 ) resistor r=0.0801089 //w=0.224 //l=0.13 //layer=m1 \
 //thickness=0.36 //x=18.25 //y=4.75 //x2=18.25 //y2=4.88
r2181 (  37 80 ) resistor r=0.0902915 //w=0.287 //l=0.162481 //layer=m1 \
 //thickness=0.36 //x=18.25 //y=2.565 //x2=18.255 //y2=2.405
r2182 (  31 69 ) resistor r=0.0717383 //w=0.224 //l=0.115 //layer=m1 \
 //thickness=0.36 //x=2.71 //y=4.765 //x2=2.71 //y2=4.88
r2183 (  29 127 ) resistor r=0.0043554 //w=0.287 //l=0.01 //layer=m1 \
 //thickness=0.36 //x=79.665 //y=2.4 //x2=79.665 //y2=2.41
r2184 (  29 124 ) resistor r=0.0609756 //w=0.287 //l=0.14 //layer=m1 \
 //thickness=0.36 //x=79.665 //y=2.4 //x2=79.665 //y2=2.26
r2185 (  28 120 ) resistor r=0.0021777 //w=0.287 //l=0.005 //layer=m1 \
 //thickness=0.36 //x=75.975 //y=2.4 //x2=75.975 //y2=2.405
r2186 (  28 117 ) resistor r=0.0609756 //w=0.287 //l=0.14 //layer=m1 \
 //thickness=0.36 //x=75.975 //y=2.4 //x2=75.975 //y2=2.26
r2187 (  27 180 ) resistor r=4.5 //w=0.15 //l=0.15 //layer=via1 //count=1 \
 //x=60.43 //y=2.4 //x2=60.43 //y2=2.4
r2188 (  27 56 ) resistor r=0.0902565 //w=0.288 //l=0.16 //layer=m1 \
 //thickness=0.36 //x=60.43 //y=2.4 //x2=60.43 //y2=2.56
r2189 (  27 111 ) resistor r=0.0607639 //w=0.288 //l=0.14 //layer=m1 \
 //thickness=0.36 //x=60.43 //y=2.4 //x2=60.43 //y2=2.26
r2190 (  26 107 ) resistor r=0.0043554 //w=0.287 //l=0.01 //layer=m1 \
 //thickness=0.36 //x=50.805 //y=2.4 //x2=50.805 //y2=2.41
r2191 (  26 104 ) resistor r=0.0609756 //w=0.287 //l=0.14 //layer=m1 \
 //thickness=0.36 //x=50.805 //y=2.4 //x2=50.805 //y2=2.26
r2192 (  25 100 ) resistor r=0.0021777 //w=0.287 //l=0.005 //layer=m1 \
 //thickness=0.36 //x=47.115 //y=2.4 //x2=47.115 //y2=2.405
r2193 (  25 97 ) resistor r=0.0609756 //w=0.287 //l=0.14 //layer=m1 \
 //thickness=0.36 //x=47.115 //y=2.4 //x2=47.115 //y2=2.26
r2194 (  24 174 ) resistor r=4.5 //w=0.15 //l=0.15 //layer=via1 //count=1 \
 //x=31.57 //y=2.4 //x2=31.57 //y2=2.4
r2195 (  24 44 ) resistor r=0.0902565 //w=0.288 //l=0.16 //layer=m1 \
 //thickness=0.36 //x=31.57 //y=2.4 //x2=31.57 //y2=2.56
r2196 (  24 91 ) resistor r=0.0607639 //w=0.288 //l=0.14 //layer=m1 \
 //thickness=0.36 //x=31.57 //y=2.4 //x2=31.57 //y2=2.26
r2197 (  23 87 ) resistor r=0.0043554 //w=0.287 //l=0.01 //layer=m1 \
 //thickness=0.36 //x=21.945 //y=2.4 //x2=21.945 //y2=2.41
r2198 (  23 84 ) resistor r=0.0609756 //w=0.287 //l=0.14 //layer=m1 \
 //thickness=0.36 //x=21.945 //y=2.4 //x2=21.945 //y2=2.26
r2199 (  22 80 ) resistor r=0.0021777 //w=0.287 //l=0.005 //layer=m1 \
 //thickness=0.36 //x=18.255 //y=2.4 //x2=18.255 //y2=2.405
r2200 (  22 77 ) resistor r=0.0609756 //w=0.287 //l=0.14 //layer=m1 \
 //thickness=0.36 //x=18.255 //y=2.4 //x2=18.255 //y2=2.26
r2201 (  21 167 ) resistor r=4.5 //w=0.15 //l=0.15 //layer=via1 //count=1 \
 //x=2.71 //y=2.4 //x2=2.71 //y2=2.4
r2202 (  21 30 ) resistor r=0.0902565 //w=0.288 //l=0.16 //layer=m1 \
 //thickness=0.36 //x=2.71 //y=2.4 //x2=2.71 //y2=2.56
r2203 (  21 71 ) resistor r=0.0607639 //w=0.288 //l=0.14 //layer=m1 \
 //thickness=0.36 //x=2.71 //y=2.4 //x2=2.71 //y2=2.26
r2204 (  20 65 ) resistor r=1.19752 //w=0.131 //l=1.255 //layer=m1 \
 //thickness=0.36 //x=79.67 //y=3.51 //x2=79.67 //y2=4.765
r2205 (  19 20 ) resistor r=0.706107 //w=0.131 //l=0.74 //layer=m1 \
 //thickness=0.36 //x=79.67 //y=2.77 //x2=79.67 //y2=3.51
r2206 (  19 64 ) resistor r=0.19084 //w=0.131 //l=0.2 //layer=m1 \
 //thickness=0.36 //x=79.67 //y=2.77 //x2=79.67 //y2=2.57
r2207 (  18 62 ) resistor r=1.88931 //w=0.131 //l=1.98 //layer=m1 \
 //thickness=0.36 //x=75.97 //y=2.77 //x2=75.97 //y2=4.75
r2208 (  18 61 ) resistor r=0.195611 //w=0.131 //l=0.205 //layer=m1 \
 //thickness=0.36 //x=75.97 //y=2.77 //x2=75.97 //y2=2.565
r2209 (  17 57 ) resistor r=0.491412 //w=0.131 //l=0.515 //layer=m1 \
 //thickness=0.36 //x=60.43 //y=4.25 //x2=60.43 //y2=4.765
r2210 (  16 17 ) resistor r=0.706107 //w=0.131 //l=0.74 //layer=m1 \
 //thickness=0.36 //x=60.43 //y=3.51 //x2=60.43 //y2=4.25
r2211 (  15 16 ) resistor r=0.706107 //w=0.131 //l=0.74 //layer=m1 \
 //thickness=0.36 //x=60.43 //y=2.77 //x2=60.43 //y2=3.51
r2212 (  15 56 ) resistor r=0.200382 //w=0.131 //l=0.21 //layer=m1 \
 //thickness=0.36 //x=60.43 //y=2.77 //x2=60.43 //y2=2.56
r2213 (  14 53 ) resistor r=1.19752 //w=0.131 //l=1.255 //layer=m1 \
 //thickness=0.36 //x=50.81 //y=3.51 //x2=50.81 //y2=4.765
r2214 (  13 14 ) resistor r=0.706107 //w=0.131 //l=0.74 //layer=m1 \
 //thickness=0.36 //x=50.81 //y=2.77 //x2=50.81 //y2=3.51
r2215 (  13 52 ) resistor r=0.19084 //w=0.131 //l=0.2 //layer=m1 \
 //thickness=0.36 //x=50.81 //y=2.77 //x2=50.81 //y2=2.57
r2216 (  12 50 ) resistor r=1.88931 //w=0.131 //l=1.98 //layer=m1 \
 //thickness=0.36 //x=47.11 //y=2.77 //x2=47.11 //y2=4.75
r2217 (  12 49 ) resistor r=0.195611 //w=0.131 //l=0.205 //layer=m1 \
 //thickness=0.36 //x=47.11 //y=2.77 //x2=47.11 //y2=2.565
r2218 (  11 45 ) resistor r=0.844466 //w=0.131 //l=0.885 //layer=m1 \
 //thickness=0.36 //x=31.57 //y=3.88 //x2=31.57 //y2=4.765
r2219 (  10 11 ) resistor r=0.353053 //w=0.131 //l=0.37 //layer=m1 \
 //thickness=0.36 //x=31.57 //y=3.51 //x2=31.57 //y2=3.88
r2220 (  9 10 ) resistor r=0.706107 //w=0.131 //l=0.74 //layer=m1 \
 //thickness=0.36 //x=31.57 //y=2.77 //x2=31.57 //y2=3.51
r2221 (  9 44 ) resistor r=0.200382 //w=0.131 //l=0.21 //layer=m1 \
 //thickness=0.36 //x=31.57 //y=2.77 //x2=31.57 //y2=2.56
r2222 (  8 41 ) resistor r=1.19752 //w=0.131 //l=1.255 //layer=m1 \
 //thickness=0.36 //x=21.95 //y=3.51 //x2=21.95 //y2=4.765
r2223 (  7 8 ) resistor r=0.706107 //w=0.131 //l=0.74 //layer=m1 \
 //thickness=0.36 //x=21.95 //y=2.77 //x2=21.95 //y2=3.51
r2224 (  7 40 ) resistor r=0.19084 //w=0.131 //l=0.2 //layer=m1 \
 //thickness=0.36 //x=21.95 //y=2.77 //x2=21.95 //y2=2.57
r2225 (  6 38 ) resistor r=1.88931 //w=0.131 //l=1.98 //layer=m1 \
 //thickness=0.36 //x=18.25 //y=2.77 //x2=18.25 //y2=4.75
r2226 (  6 37 ) resistor r=0.195611 //w=0.131 //l=0.205 //layer=m1 \
 //thickness=0.36 //x=18.25 //y=2.77 //x2=18.25 //y2=2.565
r2227 (  5 31 ) resistor r=0.138359 //w=0.131 //l=0.145 //layer=m1 \
 //thickness=0.36 //x=2.71 //y=4.62 //x2=2.71 //y2=4.765
r2228 (  4 5 ) resistor r=0.706107 //w=0.131 //l=0.74 //layer=m1 \
 //thickness=0.36 //x=2.71 //y=3.88 //x2=2.71 //y2=4.62
r2229 (  3 4 ) resistor r=0.353053 //w=0.131 //l=0.37 //layer=m1 \
 //thickness=0.36 //x=2.71 //y=3.51 //x2=2.71 //y2=3.88
r2230 (  2 3 ) resistor r=0.353053 //w=0.131 //l=0.37 //layer=m1 \
 //thickness=0.36 //x=2.71 //y=3.14 //x2=2.71 //y2=3.51
r2231 (  1 2 ) resistor r=0.353053 //w=0.131 //l=0.37 //layer=m1 \
 //thickness=0.36 //x=2.71 //y=2.77 //x2=2.71 //y2=3.14
r2232 (  1 30 ) resistor r=0.200382 //w=0.131 //l=0.21 //layer=m1 \
 //thickness=0.36 //x=2.71 //y=2.77 //x2=2.71 //y2=2.56
ends PM_TMRDFFSNRNQX1\%RN

subckt PM_TMRDFFSNRNQX1\%noxref_18 ( 1 3 6 7 9 10 11 12 14 15 16 17 18 19 20 \
 21 24 27 35 39 49 51 52 55 63 71 88 97 101 102 103 104 105 106 107 108 110 \
 116 117 118 119 131 133 134 135 )
c283 ( 131 0 ) capacitor c=0.00885916f //x=80.845 //y=1.095
c284 ( 119 0 ) capacitor c=0.0612936f //x=83.645 //y=4.97
c285 ( 118 0 ) capacitor c=0.0376642f //x=83.935 //y=4.97
c286 ( 117 0 ) capacitor c=0.0346489f //x=83.6 //y=1.4
c287 ( 116 0 ) capacitor c=0.018692f //x=83.6 //y=1.055
c288 ( 110 0 ) capacitor c=0.0137077f //x=83.445 //y=1.555
c289 ( 108 0 ) capacitor c=0.0158585f //x=83.445 //y=0.9
c290 ( 107 0 ) capacitor c=0.0979449f //x=83.07 //y=2.095
c291 ( 106 0 ) capacitor c=0.0229444f //x=83.07 //y=1.71
c292 ( 105 0 ) capacitor c=0.0234359f //x=83.07 //y=1.4
c293 ( 104 0 ) capacitor c=0.019815f //x=83.07 //y=1.055
c294 ( 103 0 ) capacitor c=0.110208f //x=84.01 //y=6.2
c295 ( 102 0 ) capacitor c=0.158957f //x=83.57 //y=6.2
c296 ( 97 0 ) capacitor c=0.0014751f //x=83.37 //y=4.88
c297 ( 88 0 ) capacitor c=9.93222e-19 //x=83.37 //y=2.26
c298 ( 71 0 ) capacitor c=0.0293124f //x=80.74 //y=5.56
c299 ( 63 0 ) capacitor c=0.029137f //x=79.86 //y=5.56
c300 ( 55 0 ) capacitor c=0.0278099f //x=78.98 //y=5.56
c301 ( 52 0 ) capacitor c=0.0154606f //x=83.205 //y=2.755
c302 ( 51 0 ) capacitor c=6.61167e-19 //x=83.365 //y=2.755
c303 ( 49 0 ) capacitor c=9.47991e-19 //x=81.68 //y=2.755
c304 ( 39 0 ) capacitor c=0.01486f //x=83.37 //y=2.77
c305 ( 35 0 ) capacitor c=0.014453f //x=81.52 //y=2.77
c306 ( 27 0 ) capacitor c=0.00112123f //x=80.74 //y=5.335
c307 ( 24 0 ) capacitor c=0.00778188f //x=79.86 //y=5.335
c308 ( 21 0 ) capacitor c=0.0111234f //x=78.982 //y=5.335
c309 ( 20 0 ) capacitor c=0.0644992f //x=83.37 //y=4.755
c310 ( 19 0 ) capacitor c=0.0128847f //x=83.37 //y=2.915
c311 ( 18 0 ) capacitor c=0.00404338f //x=83.37 //y=2.595
c312 ( 17 0 ) capacitor c=0.00437465f //x=83.37 //y=2.375
c313 ( 16 0 ) capacitor c=0.0695756f //x=81.52 //y=5.25
c314 ( 15 0 ) capacitor c=0.0123378f //x=81.52 //y=2.915
c315 ( 14 0 ) capacitor c=0.017221f //x=81.52 //y=2.595
c316 ( 12 0 ) capacitor c=0.00493487f //x=81.12 //y=1.845
c317 ( 11 0 ) capacitor c=0.0128562f //x=81.435 //y=1.845
c318 ( 10 0 ) capacitor c=0.0167992f //x=81.035 //y=1.76
c319 ( 9 0 ) capacitor c=0.0113118f //x=81.035 //y=1.305
c320 ( 7 0 ) capacitor c=0.024101f //x=81.435 //y=5.335
c321 ( 6 0 ) capacitor c=0.00933983f //x=80.74 //y=5.56
c322 ( 3 0 ) capacitor c=0.0195594f //x=80.625 //y=5.335
c323 ( 1 0 ) capacitor c=0.0151997f //x=79.74 //y=5.335
r324 (  118 120 ) resistor r=26.9307 //w=0.15 //l=0.106066 //layer=ply \
 //thickness=0.18 //x=83.935 //y=4.97 //x2=84.01 //y2=5.045
r325 (  118 119 ) resistor r=148.702 //w=0.094 //l=0.29 //layer=ply \
 //thickness=0.18 //x=83.935 //y=4.97 //x2=83.645 //y2=4.97
r326 (  117 130 ) resistor r=45.1352 //w=0.168 //l=0.173853 //layer=ply \
 //thickness=0.18 //x=83.6 //y=1.4 //x2=83.56 //y2=1.555
r327 (  116 129 ) resistor r=45.1352 //w=0.168 //l=0.173853 //layer=ply \
 //thickness=0.18 //x=83.6 //y=1.055 //x2=83.56 //y2=0.9
r328 (  116 117 ) resistor r=176.904 //w=0.094 //l=0.345 //layer=ply \
 //thickness=0.18 //x=83.6 //y=1.055 //x2=83.6 //y2=1.4
r329 (  113 119 ) resistor r=22.7971 //w=0.269 //l=0.106066 //layer=ply \
 //thickness=0.18 //x=83.57 //y=5.045 //x2=83.645 //y2=4.97
r330 (  113 128 ) resistor r=35.8364 //w=0.269 //l=0.270185 //layer=ply \
 //thickness=0.18 //x=83.57 //y=5.045 //x2=83.37 //y2=4.88
r331 (  111 124 ) resistor r=10.701 //w=0.21 //l=0.115 //layer=ply \
 //thickness=0.18 //x=83.225 //y=1.555 //x2=83.11 //y2=1.555
r332 (  110 130 ) resistor r=5.52526 //w=0.168 //l=0.115 //layer=ply \
 //thickness=0.18 //x=83.445 //y=1.555 //x2=83.56 //y2=1.555
r333 (  109 123 ) resistor r=5.52526 //w=0.168 //l=0.115 //layer=ply \
 //thickness=0.18 //x=83.225 //y=0.9 //x2=83.11 //y2=0.9
r334 (  108 129 ) resistor r=5.52526 //w=0.168 //l=0.115 //layer=ply \
 //thickness=0.18 //x=83.445 //y=0.9 //x2=83.56 //y2=0.9
r335 (  108 109 ) resistor r=112.809 //w=0.094 //l=0.22 //layer=ply \
 //thickness=0.18 //x=83.445 //y=0.9 //x2=83.225 //y2=0.9
r336 (  107 126 ) resistor r=58.7805 //w=0.246 //l=0.373497 //layer=ply \
 //thickness=0.18 //x=83.07 //y=2.095 //x2=83.37 //y2=2.26
r337 (  106 124 ) resistor r=39.5823 //w=0.21 //l=0.173853 //layer=ply \
 //thickness=0.18 //x=83.07 //y=1.71 //x2=83.11 //y2=1.555
r338 (  106 107 ) resistor r=197.415 //w=0.094 //l=0.385 //layer=ply \
 //thickness=0.18 //x=83.07 //y=1.71 //x2=83.07 //y2=2.095
r339 (  105 124 ) resistor r=39.5823 //w=0.21 //l=0.173853 //layer=ply \
 //thickness=0.18 //x=83.07 //y=1.4 //x2=83.11 //y2=1.555
r340 (  104 123 ) resistor r=45.1352 //w=0.168 //l=0.173853 //layer=ply \
 //thickness=0.18 //x=83.07 //y=1.055 //x2=83.11 //y2=0.9
r341 (  104 105 ) resistor r=176.904 //w=0.094 //l=0.345 //layer=ply \
 //thickness=0.18 //x=83.07 //y=1.055 //x2=83.07 //y2=1.4
r342 (  103 120 ) resistor r=592.245 //w=0.094 //l=1.155 //layer=ply \
 //thickness=0.18 //x=84.01 //y=6.2 //x2=84.01 //y2=5.045
r343 (  102 113 ) resistor r=592.245 //w=0.094 //l=1.155 //layer=ply \
 //thickness=0.18 //x=83.57 //y=6.2 //x2=83.57 //y2=5.045
r344 (  101 110 ) resistor r=56.4043 //w=0.094 //l=0.11 //layer=ply \
 //thickness=0.18 //x=83.335 //y=1.555 //x2=83.445 //y2=1.555
r345 (  101 111 ) resistor r=56.4043 //w=0.094 //l=0.11 //layer=ply \
 //thickness=0.18 //x=83.335 //y=1.555 //x2=83.225 //y2=1.555
r346 (  97 128 ) resistor r=152 //w=0.17 //l=0.17 //layer=licon //count=1 \
 //x=83.37 //y=4.88 //x2=83.37 //y2=4.88
r347 (  88 126 ) resistor r=152 //w=0.17 //l=0.17 //layer=licon //count=1 \
 //x=83.37 //y=2.26 //x2=83.37 //y2=2.26
r348 (  71 135 ) resistor r=23.615 //w=0.187 //l=0.345 //layer=li \
 //thickness=0.1 //x=80.74 //y=5.56 //x2=80.74 //y2=5.905
r349 (  63 134 ) resistor r=23.615 //w=0.187 //l=0.345 //layer=li \
 //thickness=0.1 //x=79.86 //y=5.56 //x2=79.86 //y2=5.905
r350 (  55 133 ) resistor r=23.615 //w=0.187 //l=0.345 //layer=li \
 //thickness=0.1 //x=78.98 //y=5.56 //x2=78.98 //y2=5.905
r351 (  51 52 ) resistor r=0.10734 //w=0.281 //l=0.16 //layer=m2 \
 //thickness=0.36 //x=83.365 //y=2.755 //x2=83.205 //y2=2.755
r352 (  49 52 ) resistor r=1.45515 //w=0.131 //l=1.525 //layer=m2 \
 //thickness=0.36 //x=81.68 //y=2.77 //x2=83.205 //y2=2.77
r353 (  47 49 ) resistor r=0.10734 //w=0.281 //l=0.16 //layer=m2 \
 //thickness=0.36 //x=81.52 //y=2.755 //x2=81.68 //y2=2.755
r354 (  43 97 ) resistor r=9.3 //w=0.17 //l=0.17 //layer=mcon //count=1 \
 //x=83.37 //y=4.88 //x2=83.37 //y2=4.88
r355 (  41 88 ) resistor r=9.3 //w=0.17 //l=0.17 //layer=mcon //count=1 \
 //x=83.37 //y=2.26 //x2=83.37 //y2=2.26
r356 (  37 51 ) resistor r=4.5 //w=0.15 //l=0.15 //layer=via1 //count=1 \
 //x=83.365 //y=2.755 //x2=83.365 //y2=2.755
r357 (  37 39 ) resistor r=0.00501337 //w=0.374 //l=0.015 //layer=m1 \
 //thickness=0.36 //x=83.315 //y=2.755 //x2=83.315 //y2=2.77
r358 (  33 47 ) resistor r=4.5 //w=0.15 //l=0.15 //layer=via1 //count=1 \
 //x=81.52 //y=2.755 //x2=81.52 //y2=2.755
r359 (  33 35 ) resistor r=0.0049867 //w=0.376 //l=0.015 //layer=m1 \
 //thickness=0.36 //x=81.572 //y=2.755 //x2=81.572 //y2=2.77
r360 (  31 131 ) resistor r=9.3 //w=0.17 //l=0.17 //layer=mcon //count=1 \
 //x=81.035 //y=1.19 //x2=81.035 //y2=1.19
r361 (  29 71 ) resistor r=9.3 //w=0.17 //l=0.17 //layer=mcon //count=1 \
 //x=80.74 //y=5.56 //x2=80.74 //y2=5.56
r362 (  26 63 ) resistor r=9.3 //w=0.17 //l=0.17 //layer=mcon //count=1 \
 //x=79.86 //y=5.56 //x2=79.86 //y2=5.56
r363 (  24 26 ) resistor r=0.121228 //w=0.232 //l=0.225 //layer=m1 \
 //thickness=0.36 //x=79.86 //y=5.335 //x2=79.86 //y2=5.56
r364 (  23 55 ) resistor r=9.3 //w=0.17 //l=0.17 //layer=mcon //count=1 \
 //x=78.98 //y=5.56 //x2=78.98 //y2=5.56
r365 (  21 23 ) resistor r=0.129608 //w=0.217 //l=0.225 //layer=m1 \
 //thickness=0.36 //x=78.982 //y=5.335 //x2=78.982 //y2=5.56
r366 (  20 43 ) resistor r=0.0760407 //w=0.238 //l=0.125 //layer=m1 \
 //thickness=0.36 //x=83.37 //y=4.755 //x2=83.37 //y2=4.88
r367 (  19 39 ) resistor r=0.0860668 //w=0.374 //l=0.170294 //layer=m1 \
 //thickness=0.36 //x=83.37 //y=2.915 //x2=83.315 //y2=2.77
r368 (  19 20 ) resistor r=1.75573 //w=0.131 //l=1.84 //layer=m1 \
 //thickness=0.36 //x=83.37 //y=2.915 //x2=83.37 //y2=4.755
r369 (  18 37 ) resistor r=0.0910802 //w=0.374 //l=0.185472 //layer=m1 \
 //thickness=0.36 //x=83.37 //y=2.595 //x2=83.315 //y2=2.755
r370 (  17 41 ) resistor r=0.0719237 //w=0.222 //l=0.115 //layer=m1 \
 //thickness=0.36 //x=83.37 //y=2.375 //x2=83.37 //y2=2.26
r371 (  17 18 ) resistor r=0.209924 //w=0.131 //l=0.22 //layer=m1 \
 //thickness=0.36 //x=83.37 //y=2.375 //x2=83.37 //y2=2.595
r372 (  15 35 ) resistor r=0.0861726 //w=0.376 //l=0.169012 //layer=m1 \
 //thickness=0.36 //x=81.52 //y=2.915 //x2=81.572 //y2=2.77
r373 (  15 16 ) resistor r=2.22805 //w=0.131 //l=2.335 //layer=m1 \
 //thickness=0.36 //x=81.52 //y=2.915 //x2=81.52 //y2=5.25
r374 (  14 33 ) resistor r=0.0911593 //w=0.376 //l=0.184174 //layer=m1 \
 //thickness=0.36 //x=81.52 //y=2.595 //x2=81.572 //y2=2.755
r375 (  13 14 ) resistor r=0.634542 //w=0.131 //l=0.665 //layer=m1 \
 //thickness=0.36 //x=81.52 //y=1.93 //x2=81.52 //y2=2.595
r376 (  11 13 ) resistor r=0.0698411 //w=0.17 //l=0.120208 //layer=m1 \
 //thickness=0.36 //x=81.435 //y=1.845 //x2=81.52 //y2=1.93
r377 (  11 12 ) resistor r=0.300573 //w=0.131 //l=0.315 //layer=m1 \
 //thickness=0.36 //x=81.435 //y=1.845 //x2=81.12 //y2=1.845
r378 (  10 12 ) resistor r=0.0698411 //w=0.17 //l=0.120208 //layer=m1 \
 //thickness=0.36 //x=81.035 //y=1.76 //x2=81.12 //y2=1.845
r379 (  9 31 ) resistor r=0.0717383 //w=0.224 //l=0.115 //layer=m1 \
 //thickness=0.36 //x=81.035 //y=1.305 //x2=81.035 //y2=1.19
r380 (  9 10 ) resistor r=0.43416 //w=0.131 //l=0.455 //layer=m1 \
 //thickness=0.36 //x=81.035 //y=1.305 //x2=81.035 //y2=1.76
r381 (  8 27 ) resistor r=0.0675342 //w=0.23 //l=0.115 //layer=m1 \
 //thickness=0.36 //x=80.855 //y=5.335 //x2=80.74 //y2=5.335
r382 (  7 16 ) resistor r=0.0698411 //w=0.17 //l=0.120208 //layer=m1 \
 //thickness=0.36 //x=81.435 //y=5.335 //x2=81.52 //y2=5.25
r383 (  7 8 ) resistor r=0.553435 //w=0.131 //l=0.58 //layer=m1 \
 //thickness=0.36 //x=81.435 //y=5.335 //x2=80.855 //y2=5.335
r384 (  6 29 ) resistor r=0.00118313 //w=0.23 //layer=m1 //thickness=0.36 \
 //x=80.74 //y=5.56 //x2=80.74 //y2=5.56
r385 (  5 27 ) resistor r=0.002872 //w=0.34 //l=0.085 //layer=m1 \
 //thickness=0.36 //x=80.74 //y=5.42 //x2=80.74 //y2=5.335
r386 (  5 6 ) resistor r=0.091623 //w=0.191 //l=0.14 //layer=m1 \
 //thickness=0.36 //x=80.74 //y=5.42 //x2=80.74 //y2=5.56
r387 (  4 24 ) resistor r=0.0262263 //w=0.232 //l=0.12 //layer=m1 \
 //thickness=0.36 //x=79.98 //y=5.335 //x2=79.86 //y2=5.335
r388 (  3 27 ) resistor r=0.0675342 //w=0.23 //l=0.115 //layer=m1 \
 //thickness=0.36 //x=80.625 //y=5.335 //x2=80.74 //y2=5.335
r389 (  3 4 ) resistor r=0.615458 //w=0.131 //l=0.645 //layer=m1 \
 //thickness=0.36 //x=80.625 //y=5.335 //x2=79.98 //y2=5.335
r390 (  2 21 ) resistor r=0.0222262 //w=0.217 //l=0.118 //layer=m1 \
 //thickness=0.36 //x=79.1 //y=5.335 //x2=78.982 //y2=5.335
r391 (  1 24 ) resistor r=0.0262263 //w=0.232 //l=0.12 //layer=m1 \
 //thickness=0.36 //x=79.74 //y=5.335 //x2=79.86 //y2=5.335
r392 (  1 2 ) resistor r=0.610687 //w=0.131 //l=0.64 //layer=m1 \
 //thickness=0.36 //x=79.74 //y=5.335 //x2=79.1 //y2=5.335
ends PM_TMRDFFSNRNQX1\%noxref_18

subckt PM_TMRDFFSNRNQX1\%SN ( 1 2 3 4 5 6 7 8 9 10 11 14 15 16 19 20 21 24 25 \
 26 29 30 31 34 35 36 37 38 39 81 88 90 92 94 96 98 100 101 102 104 106 108 \
 110 112 114 116 117 118 120 122 124 126 128 130 131 132 134 136 138 140 142 \
 144 146 147 148 150 152 154 159 164 172 181 186 195 200 209 214 223 228 237 \
 242 251 255 256 257 258 259 260 261 262 263 264 265 266 267 268 269 270 271 \
 272 273 274 275 277 283 284 285 286 287 292 293 294 296 302 303 304 305 306 \
 311 312 313 315 321 322 323 324 325 330 331 332 334 340 341 342 343 344 349 \
 350 351 353 359 360 361 362 363 368 369 370 372 378 379 380 381 382 390 401 \
 412 423 434 445 )
c1208 ( 445 0 ) capacitor c=0.0369044f //x=84.48 //y=4.88
c1209 ( 434 0 ) capacitor c=0.0369628f //x=70.05 //y=4.88
c1210 ( 423 0 ) capacitor c=0.0369628f //x=55.62 //y=4.88
c1211 ( 412 0 ) capacitor c=0.0369628f //x=41.19 //y=4.88
c1212 ( 401 0 ) capacitor c=0.0369044f //x=26.76 //y=4.88
c1213 ( 390 0 ) capacitor c=0.0369044f //x=12.33 //y=4.88
c1214 ( 382 0 ) capacitor c=0.0309248f //x=84.815 //y=4.97
c1215 ( 381 0 ) capacitor c=0.0819978f //x=84.57 //y=2.095
c1216 ( 380 0 ) capacitor c=0.0170266f //x=84.57 //y=1.63
c1217 ( 379 0 ) capacitor c=0.018609f //x=84.57 //y=1.4
c1218 ( 378 0 ) capacitor c=0.0186599f //x=84.57 //y=1.09
c1219 ( 372 0 ) capacitor c=0.0146988f //x=84.415 //y=1.555
c1220 ( 370 0 ) capacitor c=0.0148531f //x=84.415 //y=0.935
c1221 ( 369 0 ) capacitor c=0.0334406f //x=84.045 //y=1.4
c1222 ( 368 0 ) capacitor c=0.0173191f //x=84.045 //y=1.09
c1223 ( 363 0 ) capacitor c=0.0309248f //x=70.385 //y=4.97
c1224 ( 362 0 ) capacitor c=0.0818898f //x=70.14 //y=2.095
c1225 ( 361 0 ) capacitor c=0.0170266f //x=70.14 //y=1.63
c1226 ( 360 0 ) capacitor c=0.018609f //x=70.14 //y=1.4
c1227 ( 359 0 ) capacitor c=0.0186599f //x=70.14 //y=1.09
c1228 ( 353 0 ) capacitor c=0.0146988f //x=69.985 //y=1.555
c1229 ( 351 0 ) capacitor c=0.0148531f //x=69.985 //y=0.935
c1230 ( 350 0 ) capacitor c=0.0334406f //x=69.615 //y=1.4
c1231 ( 349 0 ) capacitor c=0.0173191f //x=69.615 //y=1.09
c1232 ( 344 0 ) capacitor c=0.0309248f //x=55.955 //y=4.97
c1233 ( 343 0 ) capacitor c=0.0819978f //x=55.71 //y=2.095
c1234 ( 342 0 ) capacitor c=0.0170266f //x=55.71 //y=1.63
c1235 ( 341 0 ) capacitor c=0.018609f //x=55.71 //y=1.4
c1236 ( 340 0 ) capacitor c=0.0186599f //x=55.71 //y=1.09
c1237 ( 334 0 ) capacitor c=0.0146988f //x=55.555 //y=1.555
c1238 ( 332 0 ) capacitor c=0.0148531f //x=55.555 //y=0.935
c1239 ( 331 0 ) capacitor c=0.0334406f //x=55.185 //y=1.4
c1240 ( 330 0 ) capacitor c=0.0173191f //x=55.185 //y=1.09
c1241 ( 325 0 ) capacitor c=0.0309248f //x=41.525 //y=4.97
c1242 ( 324 0 ) capacitor c=0.0818898f //x=41.28 //y=2.095
c1243 ( 323 0 ) capacitor c=0.0170266f //x=41.28 //y=1.63
c1244 ( 322 0 ) capacitor c=0.018609f //x=41.28 //y=1.4
c1245 ( 321 0 ) capacitor c=0.0186599f //x=41.28 //y=1.09
c1246 ( 315 0 ) capacitor c=0.0146988f //x=41.125 //y=1.555
c1247 ( 313 0 ) capacitor c=0.0148531f //x=41.125 //y=0.935
c1248 ( 312 0 ) capacitor c=0.0334406f //x=40.755 //y=1.4
c1249 ( 311 0 ) capacitor c=0.0173191f //x=40.755 //y=1.09
c1250 ( 306 0 ) capacitor c=0.0309248f //x=27.095 //y=4.97
c1251 ( 305 0 ) capacitor c=0.0819978f //x=26.85 //y=2.095
c1252 ( 304 0 ) capacitor c=0.0170266f //x=26.85 //y=1.63
c1253 ( 303 0 ) capacitor c=0.018609f //x=26.85 //y=1.4
c1254 ( 302 0 ) capacitor c=0.0186599f //x=26.85 //y=1.09
c1255 ( 296 0 ) capacitor c=0.0146988f //x=26.695 //y=1.555
c1256 ( 294 0 ) capacitor c=0.0148531f //x=26.695 //y=0.935
c1257 ( 293 0 ) capacitor c=0.0334406f //x=26.325 //y=1.4
c1258 ( 292 0 ) capacitor c=0.0173191f //x=26.325 //y=1.09
c1259 ( 287 0 ) capacitor c=0.0309248f //x=12.665 //y=4.97
c1260 ( 286 0 ) capacitor c=0.0818898f //x=12.42 //y=2.095
c1261 ( 285 0 ) capacitor c=0.0170266f //x=12.42 //y=1.63
c1262 ( 284 0 ) capacitor c=0.018609f //x=12.42 //y=1.4
c1263 ( 283 0 ) capacitor c=0.0186599f //x=12.42 //y=1.09
c1264 ( 277 0 ) capacitor c=0.0146988f //x=12.265 //y=1.555
c1265 ( 275 0 ) capacitor c=0.0148531f //x=12.265 //y=0.935
c1266 ( 274 0 ) capacitor c=0.0334406f //x=11.895 //y=1.4
c1267 ( 273 0 ) capacitor c=0.0173191f //x=11.895 //y=1.09
c1268 ( 272 0 ) capacitor c=0.110208f //x=84.89 //y=6.2
c1269 ( 271 0 ) capacitor c=0.110214f //x=84.45 //y=6.2
c1270 ( 270 0 ) capacitor c=0.110208f //x=70.46 //y=6.2
c1271 ( 269 0 ) capacitor c=0.110214f //x=70.02 //y=6.2
c1272 ( 268 0 ) capacitor c=0.110208f //x=56.03 //y=6.2
c1273 ( 267 0 ) capacitor c=0.110214f //x=55.59 //y=6.2
c1274 ( 266 0 ) capacitor c=0.110208f //x=41.6 //y=6.2
c1275 ( 265 0 ) capacitor c=0.110214f //x=41.16 //y=6.2
c1276 ( 264 0 ) capacitor c=0.110208f //x=27.17 //y=6.2
c1277 ( 263 0 ) capacitor c=0.110214f //x=26.73 //y=6.2
c1278 ( 262 0 ) capacitor c=0.110208f //x=12.74 //y=6.2
c1279 ( 261 0 ) capacitor c=0.110214f //x=12.3 //y=6.2
c1280 ( 251 0 ) capacitor c=0.00129935f //x=84.48 //y=4.88
c1281 ( 242 0 ) capacitor c=9.49278e-19 //x=84.48 //y=2.26
c1282 ( 237 0 ) capacitor c=0.00129935f //x=70.05 //y=4.88
c1283 ( 228 0 ) capacitor c=9.49278e-19 //x=70.05 //y=2.26
c1284 ( 223 0 ) capacitor c=0.00129935f //x=55.62 //y=4.88
c1285 ( 214 0 ) capacitor c=9.49278e-19 //x=55.62 //y=2.26
c1286 ( 209 0 ) capacitor c=0.00129935f //x=41.19 //y=4.88
c1287 ( 200 0 ) capacitor c=9.49278e-19 //x=41.19 //y=2.26
c1288 ( 195 0 ) capacitor c=0.00129935f //x=26.76 //y=4.88
c1289 ( 186 0 ) capacitor c=9.49278e-19 //x=26.76 //y=2.26
c1290 ( 181 0 ) capacitor c=0.00129935f //x=12.33 //y=4.88
c1291 ( 172 0 ) capacitor c=9.49278e-19 //x=12.33 //y=2.26
c1292 ( 164 0 ) capacitor c=0.00126592f //x=52.22 //y=3.125
c1293 ( 159 0 ) capacitor c=4.39244e-19 //x=12.49 //y=3.125
c1294 ( 154 0 ) capacitor c=0.0858283f //x=78.77 //y=3.125
c1295 ( 152 0 ) capacitor c=0.0514352f //x=78.17 //y=3.14
c1296 ( 150 0 ) capacitor c=0.00422942f //x=73.975 //y=3.155
c1297 ( 148 0 ) capacitor c=0.0179685f //x=73.375 //y=3.14
c1298 ( 147 0 ) capacitor c=0.024406f //x=71.77 //y=3.155
c1299 ( 146 0 ) capacitor c=0.00413636f //x=72.115 //y=3.155
c1300 ( 144 0 ) capacitor c=0.00179684f //x=69.155 //y=3.17
c1301 ( 142 0 ) capacitor c=0.0169637f //x=68.555 //y=3.14
c1302 ( 140 0 ) capacitor c=0.0064451f //x=67.305 //y=3.11
c1303 ( 138 0 ) capacitor c=0.0207078f //x=66.705 //y=3.14
c1304 ( 136 0 ) capacitor c=0.00378224f //x=64.35 //y=3.17
c1305 ( 134 0 ) capacitor c=0.0184994f //x=63.75 //y=3.14
c1306 ( 132 0 ) capacitor c=0.00429578f //x=62.5 //y=3.17
c1307 ( 131 0 ) capacitor c=0.0750592f //x=61.335 //y=3.13
c1308 ( 130 0 ) capacitor c=0.00729482f //x=61.765 //y=3.13
c1309 ( 128 0 ) capacitor c=0.0348131f //x=55.46 //y=3.14
c1310 ( 126 0 ) capacitor c=0.0024147f //x=52.12 //y=3.125
c1311 ( 124 0 ) capacitor c=0.0271038f //x=49.91 //y=3.125
c1312 ( 122 0 ) capacitor c=0.0513238f //x=49.31 //y=3.14
c1313 ( 120 0 ) capacitor c=0.00422942f //x=45.115 //y=3.155
c1314 ( 118 0 ) capacitor c=0.0179685f //x=44.515 //y=3.14
c1315 ( 117 0 ) capacitor c=0.024406f //x=42.91 //y=3.155
c1316 ( 116 0 ) capacitor c=0.00413636f //x=43.255 //y=3.155
c1317 ( 114 0 ) capacitor c=0.00179684f //x=40.295 //y=3.17
c1318 ( 112 0 ) capacitor c=0.0169637f //x=39.695 //y=3.14
c1319 ( 110 0 ) capacitor c=0.0064451f //x=38.445 //y=3.11
c1320 ( 108 0 ) capacitor c=0.0207078f //x=37.845 //y=3.14
c1321 ( 106 0 ) capacitor c=0.00378224f //x=35.49 //y=3.17
c1322 ( 104 0 ) capacitor c=0.0184994f //x=34.89 //y=3.14
c1323 ( 102 0 ) capacitor c=0.00429578f //x=33.64 //y=3.17
c1324 ( 101 0 ) capacitor c=0.143982f //x=32.475 //y=3.13
c1325 ( 100 0 ) capacitor c=0.00738852f //x=32.905 //y=3.13
c1326 ( 98 0 ) capacitor c=0.00292064f //x=21.05 //y=3.125
c1327 ( 96 0 ) capacitor c=0.0514333f //x=20.45 //y=3.14
c1328 ( 94 0 ) capacitor c=0.00433851f //x=16.255 //y=3.155
c1329 ( 92 0 ) capacitor c=0.0179685f //x=15.655 //y=3.14
c1330 ( 90 0 ) capacitor c=0.00413636f //x=14.395 //y=3.155
c1331 ( 88 0 ) capacitor c=0.0151172f //x=13.795 //y=3.14
c1332 ( 81 0 ) capacitor c=0.015039f //x=84.48 //y=3.14
c1333 ( 39 0 ) capacitor c=0.0464356f //x=84.48 //y=4.765
c1334 ( 38 0 ) capacitor c=0.012684f //x=84.48 //y=3.305
c1335 ( 37 0 ) capacitor c=0.0132667f //x=84.48 //y=2.985
c1336 ( 36 0 ) capacitor c=0.00380207f //x=84.48 //y=2.375
c1337 ( 35 0 ) capacitor c=0.0416113f //x=70.05 //y=4.765
c1338 ( 34 0 ) capacitor c=0.0130261f //x=70.05 //y=3.285
c1339 ( 31 0 ) capacitor c=0.00380207f //x=70.05 //y=2.375
c1340 ( 30 0 ) capacitor c=0.0403265f //x=55.62 //y=4.765
c1341 ( 29 0 ) capacitor c=0.0125032f //x=55.62 //y=3.305
c1342 ( 26 0 ) capacitor c=0.00380207f //x=55.62 //y=2.375
c1343 ( 25 0 ) capacitor c=0.0417289f //x=41.19 //y=4.765
c1344 ( 24 0 ) capacitor c=0.0130261f //x=41.19 //y=3.285
c1345 ( 21 0 ) capacitor c=0.00380207f //x=41.19 //y=2.375
c1346 ( 20 0 ) capacitor c=0.0426069f //x=26.76 //y=4.765
c1347 ( 19 0 ) capacitor c=0.012654f //x=26.76 //y=3.305
c1348 ( 16 0 ) capacitor c=0.00380207f //x=26.76 //y=2.375
c1349 ( 15 0 ) capacitor c=0.0437064f //x=12.33 //y=4.765
c1350 ( 14 0 ) capacitor c=0.0127247f //x=12.33 //y=3.285
c1351 ( 11 0 ) capacitor c=0.00380207f //x=12.33 //y=2.375
c1352 ( 10 0 ) capacitor c=0.015039f //x=70.05 //y=3.14
c1353 ( 9 0 ) capacitor c=0.015039f //x=55.62 //y=3.14
c1354 ( 8 0 ) capacitor c=0.015039f //x=41.19 //y=3.14
c1355 ( 7 0 ) capacitor c=0.015039f //x=26.76 //y=3.14
c1356 ( 6 0 ) capacitor c=0.015039f //x=12.33 //y=3.14
c1357 ( 5 0 ) capacitor c=0.0114361f //x=70.05 //y=2.77
c1358 ( 4 0 ) capacitor c=0.0136895f //x=55.62 //y=2.77
c1359 ( 3 0 ) capacitor c=0.0114361f //x=41.19 //y=2.77
c1360 ( 2 0 ) capacitor c=0.0136461f //x=26.76 //y=2.77
c1361 ( 1 0 ) capacitor c=0.0114361f //x=12.33 //y=2.77
r1362 (  447 448 ) resistor r=32.4568 //w=0.214 //l=0.075 //layer=ply \
 //thickness=0.18 //x=84.48 //y=4.97 //x2=84.48 //y2=5.045
r1363 (  445 447 ) resistor r=20.271 //w=0.214 //l=0.09 //layer=ply \
 //thickness=0.18 //x=84.48 //y=4.88 //x2=84.48 //y2=4.97
r1364 (  436 437 ) resistor r=32.4568 //w=0.214 //l=0.075 //layer=ply \
 //thickness=0.18 //x=70.05 //y=4.97 //x2=70.05 //y2=5.045
r1365 (  434 436 ) resistor r=20.271 //w=0.214 //l=0.09 //layer=ply \
 //thickness=0.18 //x=70.05 //y=4.88 //x2=70.05 //y2=4.97
r1366 (  425 426 ) resistor r=32.4568 //w=0.214 //l=0.075 //layer=ply \
 //thickness=0.18 //x=55.62 //y=4.97 //x2=55.62 //y2=5.045
r1367 (  423 425 ) resistor r=20.271 //w=0.214 //l=0.09 //layer=ply \
 //thickness=0.18 //x=55.62 //y=4.88 //x2=55.62 //y2=4.97
r1368 (  414 415 ) resistor r=32.4568 //w=0.214 //l=0.075 //layer=ply \
 //thickness=0.18 //x=41.19 //y=4.97 //x2=41.19 //y2=5.045
r1369 (  412 414 ) resistor r=20.271 //w=0.214 //l=0.09 //layer=ply \
 //thickness=0.18 //x=41.19 //y=4.88 //x2=41.19 //y2=4.97
r1370 (  403 404 ) resistor r=32.4568 //w=0.214 //l=0.075 //layer=ply \
 //thickness=0.18 //x=26.76 //y=4.97 //x2=26.76 //y2=5.045
r1371 (  401 403 ) resistor r=20.271 //w=0.214 //l=0.09 //layer=ply \
 //thickness=0.18 //x=26.76 //y=4.88 //x2=26.76 //y2=4.97
r1372 (  392 393 ) resistor r=32.4568 //w=0.214 //l=0.075 //layer=ply \
 //thickness=0.18 //x=12.33 //y=4.97 //x2=12.33 //y2=5.045
r1373 (  390 392 ) resistor r=20.271 //w=0.214 //l=0.09 //layer=ply \
 //thickness=0.18 //x=12.33 //y=4.88 //x2=12.33 //y2=4.97
r1374 (  383 447 ) resistor r=16.5046 //w=0.27 //l=0.135 //layer=ply \
 //thickness=0.18 //x=84.615 //y=4.97 //x2=84.48 //y2=4.97
r1375 (  382 384 ) resistor r=26.9307 //w=0.15 //l=0.106066 //layer=ply \
 //thickness=0.18 //x=84.815 //y=4.97 //x2=84.89 //y2=5.045
r1376 (  382 383 ) resistor r=102.553 //w=0.094 //l=0.2 //layer=ply \
 //thickness=0.18 //x=84.815 //y=4.97 //x2=84.615 //y2=4.97
r1377 (  381 452 ) resistor r=38.6777 //w=0.284 //l=0.198997 //layer=ply \
 //thickness=0.18 //x=84.57 //y=2.095 //x2=84.495 //y2=2.26
r1378 (  380 450 ) resistor r=21.2976 //w=0.217 //l=0.0928709 //layer=ply \
 //thickness=0.18 //x=84.57 //y=1.63 //x2=84.53 //y2=1.555
r1379 (  380 381 ) resistor r=238.436 //w=0.094 //l=0.465 //layer=ply \
 //thickness=0.18 //x=84.57 //y=1.63 //x2=84.57 //y2=2.095
r1380 (  379 450 ) resistor r=39.0671 //w=0.217 //l=0.173853 //layer=ply \
 //thickness=0.18 //x=84.57 //y=1.4 //x2=84.53 //y2=1.555
r1381 (  378 449 ) resistor r=45.1352 //w=0.168 //l=0.173853 //layer=ply \
 //thickness=0.18 //x=84.57 //y=1.09 //x2=84.53 //y2=0.935
r1382 (  378 379 ) resistor r=158.957 //w=0.094 //l=0.31 //layer=ply \
 //thickness=0.18 //x=84.57 //y=1.09 //x2=84.57 //y2=1.4
r1383 (  373 443 ) resistor r=5.52526 //w=0.168 //l=0.115 //layer=ply \
 //thickness=0.18 //x=84.2 //y=1.555 //x2=84.085 //y2=1.555
r1384 (  372 450 ) resistor r=11.4558 //w=0.217 //l=0.115 //layer=ply \
 //thickness=0.18 //x=84.415 //y=1.555 //x2=84.53 //y2=1.555
r1385 (  371 442 ) resistor r=5.52526 //w=0.168 //l=0.115 //layer=ply \
 //thickness=0.18 //x=84.2 //y=0.935 //x2=84.085 //y2=0.935
r1386 (  370 449 ) resistor r=5.52526 //w=0.168 //l=0.115 //layer=ply \
 //thickness=0.18 //x=84.415 //y=0.935 //x2=84.53 //y2=0.935
r1387 (  370 371 ) resistor r=110.245 //w=0.094 //l=0.215 //layer=ply \
 //thickness=0.18 //x=84.415 //y=0.935 //x2=84.2 //y2=0.935
r1388 (  369 443 ) resistor r=45.1352 //w=0.168 //l=0.173853 //layer=ply \
 //thickness=0.18 //x=84.045 //y=1.4 //x2=84.085 //y2=1.555
r1389 (  368 442 ) resistor r=45.1352 //w=0.168 //l=0.173853 //layer=ply \
 //thickness=0.18 //x=84.045 //y=1.09 //x2=84.085 //y2=0.935
r1390 (  368 369 ) resistor r=158.957 //w=0.094 //l=0.31 //layer=ply \
 //thickness=0.18 //x=84.045 //y=1.09 //x2=84.045 //y2=1.4
r1391 (  364 436 ) resistor r=16.5046 //w=0.27 //l=0.135 //layer=ply \
 //thickness=0.18 //x=70.185 //y=4.97 //x2=70.05 //y2=4.97
r1392 (  363 365 ) resistor r=26.9307 //w=0.15 //l=0.106066 //layer=ply \
 //thickness=0.18 //x=70.385 //y=4.97 //x2=70.46 //y2=5.045
r1393 (  363 364 ) resistor r=102.553 //w=0.094 //l=0.2 //layer=ply \
 //thickness=0.18 //x=70.385 //y=4.97 //x2=70.185 //y2=4.97
r1394 (  362 441 ) resistor r=38.6777 //w=0.284 //l=0.198997 //layer=ply \
 //thickness=0.18 //x=70.14 //y=2.095 //x2=70.065 //y2=2.26
r1395 (  361 439 ) resistor r=21.2976 //w=0.217 //l=0.0928709 //layer=ply \
 //thickness=0.18 //x=70.14 //y=1.63 //x2=70.1 //y2=1.555
r1396 (  361 362 ) resistor r=238.436 //w=0.094 //l=0.465 //layer=ply \
 //thickness=0.18 //x=70.14 //y=1.63 //x2=70.14 //y2=2.095
r1397 (  360 439 ) resistor r=39.0671 //w=0.217 //l=0.173853 //layer=ply \
 //thickness=0.18 //x=70.14 //y=1.4 //x2=70.1 //y2=1.555
r1398 (  359 438 ) resistor r=45.1352 //w=0.168 //l=0.173853 //layer=ply \
 //thickness=0.18 //x=70.14 //y=1.09 //x2=70.1 //y2=0.935
r1399 (  359 360 ) resistor r=158.957 //w=0.094 //l=0.31 //layer=ply \
 //thickness=0.18 //x=70.14 //y=1.09 //x2=70.14 //y2=1.4
r1400 (  354 432 ) resistor r=5.52526 //w=0.168 //l=0.115 //layer=ply \
 //thickness=0.18 //x=69.77 //y=1.555 //x2=69.655 //y2=1.555
r1401 (  353 439 ) resistor r=11.4558 //w=0.217 //l=0.115 //layer=ply \
 //thickness=0.18 //x=69.985 //y=1.555 //x2=70.1 //y2=1.555
r1402 (  352 431 ) resistor r=5.52526 //w=0.168 //l=0.115 //layer=ply \
 //thickness=0.18 //x=69.77 //y=0.935 //x2=69.655 //y2=0.935
r1403 (  351 438 ) resistor r=5.52526 //w=0.168 //l=0.115 //layer=ply \
 //thickness=0.18 //x=69.985 //y=0.935 //x2=70.1 //y2=0.935
r1404 (  351 352 ) resistor r=110.245 //w=0.094 //l=0.215 //layer=ply \
 //thickness=0.18 //x=69.985 //y=0.935 //x2=69.77 //y2=0.935
r1405 (  350 432 ) resistor r=45.1352 //w=0.168 //l=0.173853 //layer=ply \
 //thickness=0.18 //x=69.615 //y=1.4 //x2=69.655 //y2=1.555
r1406 (  349 431 ) resistor r=45.1352 //w=0.168 //l=0.173853 //layer=ply \
 //thickness=0.18 //x=69.615 //y=1.09 //x2=69.655 //y2=0.935
r1407 (  349 350 ) resistor r=158.957 //w=0.094 //l=0.31 //layer=ply \
 //thickness=0.18 //x=69.615 //y=1.09 //x2=69.615 //y2=1.4
r1408 (  345 425 ) resistor r=16.5046 //w=0.27 //l=0.135 //layer=ply \
 //thickness=0.18 //x=55.755 //y=4.97 //x2=55.62 //y2=4.97
r1409 (  344 346 ) resistor r=26.9307 //w=0.15 //l=0.106066 //layer=ply \
 //thickness=0.18 //x=55.955 //y=4.97 //x2=56.03 //y2=5.045
r1410 (  344 345 ) resistor r=102.553 //w=0.094 //l=0.2 //layer=ply \
 //thickness=0.18 //x=55.955 //y=4.97 //x2=55.755 //y2=4.97
r1411 (  343 430 ) resistor r=38.6777 //w=0.284 //l=0.198997 //layer=ply \
 //thickness=0.18 //x=55.71 //y=2.095 //x2=55.635 //y2=2.26
r1412 (  342 428 ) resistor r=21.2976 //w=0.217 //l=0.0928709 //layer=ply \
 //thickness=0.18 //x=55.71 //y=1.63 //x2=55.67 //y2=1.555
r1413 (  342 343 ) resistor r=238.436 //w=0.094 //l=0.465 //layer=ply \
 //thickness=0.18 //x=55.71 //y=1.63 //x2=55.71 //y2=2.095
r1414 (  341 428 ) resistor r=39.0671 //w=0.217 //l=0.173853 //layer=ply \
 //thickness=0.18 //x=55.71 //y=1.4 //x2=55.67 //y2=1.555
r1415 (  340 427 ) resistor r=45.1352 //w=0.168 //l=0.173853 //layer=ply \
 //thickness=0.18 //x=55.71 //y=1.09 //x2=55.67 //y2=0.935
r1416 (  340 341 ) resistor r=158.957 //w=0.094 //l=0.31 //layer=ply \
 //thickness=0.18 //x=55.71 //y=1.09 //x2=55.71 //y2=1.4
r1417 (  335 421 ) resistor r=5.52526 //w=0.168 //l=0.115 //layer=ply \
 //thickness=0.18 //x=55.34 //y=1.555 //x2=55.225 //y2=1.555
r1418 (  334 428 ) resistor r=11.4558 //w=0.217 //l=0.115 //layer=ply \
 //thickness=0.18 //x=55.555 //y=1.555 //x2=55.67 //y2=1.555
r1419 (  333 420 ) resistor r=5.52526 //w=0.168 //l=0.115 //layer=ply \
 //thickness=0.18 //x=55.34 //y=0.935 //x2=55.225 //y2=0.935
r1420 (  332 427 ) resistor r=5.52526 //w=0.168 //l=0.115 //layer=ply \
 //thickness=0.18 //x=55.555 //y=0.935 //x2=55.67 //y2=0.935
r1421 (  332 333 ) resistor r=110.245 //w=0.094 //l=0.215 //layer=ply \
 //thickness=0.18 //x=55.555 //y=0.935 //x2=55.34 //y2=0.935
r1422 (  331 421 ) resistor r=45.1352 //w=0.168 //l=0.173853 //layer=ply \
 //thickness=0.18 //x=55.185 //y=1.4 //x2=55.225 //y2=1.555
r1423 (  330 420 ) resistor r=45.1352 //w=0.168 //l=0.173853 //layer=ply \
 //thickness=0.18 //x=55.185 //y=1.09 //x2=55.225 //y2=0.935
r1424 (  330 331 ) resistor r=158.957 //w=0.094 //l=0.31 //layer=ply \
 //thickness=0.18 //x=55.185 //y=1.09 //x2=55.185 //y2=1.4
r1425 (  326 414 ) resistor r=16.5046 //w=0.27 //l=0.135 //layer=ply \
 //thickness=0.18 //x=41.325 //y=4.97 //x2=41.19 //y2=4.97
r1426 (  325 327 ) resistor r=26.9307 //w=0.15 //l=0.106066 //layer=ply \
 //thickness=0.18 //x=41.525 //y=4.97 //x2=41.6 //y2=5.045
r1427 (  325 326 ) resistor r=102.553 //w=0.094 //l=0.2 //layer=ply \
 //thickness=0.18 //x=41.525 //y=4.97 //x2=41.325 //y2=4.97
r1428 (  324 419 ) resistor r=38.6777 //w=0.284 //l=0.198997 //layer=ply \
 //thickness=0.18 //x=41.28 //y=2.095 //x2=41.205 //y2=2.26
r1429 (  323 417 ) resistor r=21.2976 //w=0.217 //l=0.0928709 //layer=ply \
 //thickness=0.18 //x=41.28 //y=1.63 //x2=41.24 //y2=1.555
r1430 (  323 324 ) resistor r=238.436 //w=0.094 //l=0.465 //layer=ply \
 //thickness=0.18 //x=41.28 //y=1.63 //x2=41.28 //y2=2.095
r1431 (  322 417 ) resistor r=39.0671 //w=0.217 //l=0.173853 //layer=ply \
 //thickness=0.18 //x=41.28 //y=1.4 //x2=41.24 //y2=1.555
r1432 (  321 416 ) resistor r=45.1352 //w=0.168 //l=0.173853 //layer=ply \
 //thickness=0.18 //x=41.28 //y=1.09 //x2=41.24 //y2=0.935
r1433 (  321 322 ) resistor r=158.957 //w=0.094 //l=0.31 //layer=ply \
 //thickness=0.18 //x=41.28 //y=1.09 //x2=41.28 //y2=1.4
r1434 (  316 410 ) resistor r=5.52526 //w=0.168 //l=0.115 //layer=ply \
 //thickness=0.18 //x=40.91 //y=1.555 //x2=40.795 //y2=1.555
r1435 (  315 417 ) resistor r=11.4558 //w=0.217 //l=0.115 //layer=ply \
 //thickness=0.18 //x=41.125 //y=1.555 //x2=41.24 //y2=1.555
r1436 (  314 409 ) resistor r=5.52526 //w=0.168 //l=0.115 //layer=ply \
 //thickness=0.18 //x=40.91 //y=0.935 //x2=40.795 //y2=0.935
r1437 (  313 416 ) resistor r=5.52526 //w=0.168 //l=0.115 //layer=ply \
 //thickness=0.18 //x=41.125 //y=0.935 //x2=41.24 //y2=0.935
r1438 (  313 314 ) resistor r=110.245 //w=0.094 //l=0.215 //layer=ply \
 //thickness=0.18 //x=41.125 //y=0.935 //x2=40.91 //y2=0.935
r1439 (  312 410 ) resistor r=45.1352 //w=0.168 //l=0.173853 //layer=ply \
 //thickness=0.18 //x=40.755 //y=1.4 //x2=40.795 //y2=1.555
r1440 (  311 409 ) resistor r=45.1352 //w=0.168 //l=0.173853 //layer=ply \
 //thickness=0.18 //x=40.755 //y=1.09 //x2=40.795 //y2=0.935
r1441 (  311 312 ) resistor r=158.957 //w=0.094 //l=0.31 //layer=ply \
 //thickness=0.18 //x=40.755 //y=1.09 //x2=40.755 //y2=1.4
r1442 (  307 403 ) resistor r=16.5046 //w=0.27 //l=0.135 //layer=ply \
 //thickness=0.18 //x=26.895 //y=4.97 //x2=26.76 //y2=4.97
r1443 (  306 308 ) resistor r=26.9307 //w=0.15 //l=0.106066 //layer=ply \
 //thickness=0.18 //x=27.095 //y=4.97 //x2=27.17 //y2=5.045
r1444 (  306 307 ) resistor r=102.553 //w=0.094 //l=0.2 //layer=ply \
 //thickness=0.18 //x=27.095 //y=4.97 //x2=26.895 //y2=4.97
r1445 (  305 408 ) resistor r=38.6777 //w=0.284 //l=0.198997 //layer=ply \
 //thickness=0.18 //x=26.85 //y=2.095 //x2=26.775 //y2=2.26
r1446 (  304 406 ) resistor r=21.2976 //w=0.217 //l=0.0928709 //layer=ply \
 //thickness=0.18 //x=26.85 //y=1.63 //x2=26.81 //y2=1.555
r1447 (  304 305 ) resistor r=238.436 //w=0.094 //l=0.465 //layer=ply \
 //thickness=0.18 //x=26.85 //y=1.63 //x2=26.85 //y2=2.095
r1448 (  303 406 ) resistor r=39.0671 //w=0.217 //l=0.173853 //layer=ply \
 //thickness=0.18 //x=26.85 //y=1.4 //x2=26.81 //y2=1.555
r1449 (  302 405 ) resistor r=45.1352 //w=0.168 //l=0.173853 //layer=ply \
 //thickness=0.18 //x=26.85 //y=1.09 //x2=26.81 //y2=0.935
r1450 (  302 303 ) resistor r=158.957 //w=0.094 //l=0.31 //layer=ply \
 //thickness=0.18 //x=26.85 //y=1.09 //x2=26.85 //y2=1.4
r1451 (  297 399 ) resistor r=5.52526 //w=0.168 //l=0.115 //layer=ply \
 //thickness=0.18 //x=26.48 //y=1.555 //x2=26.365 //y2=1.555
r1452 (  296 406 ) resistor r=11.4558 //w=0.217 //l=0.115 //layer=ply \
 //thickness=0.18 //x=26.695 //y=1.555 //x2=26.81 //y2=1.555
r1453 (  295 398 ) resistor r=5.52526 //w=0.168 //l=0.115 //layer=ply \
 //thickness=0.18 //x=26.48 //y=0.935 //x2=26.365 //y2=0.935
r1454 (  294 405 ) resistor r=5.52526 //w=0.168 //l=0.115 //layer=ply \
 //thickness=0.18 //x=26.695 //y=0.935 //x2=26.81 //y2=0.935
r1455 (  294 295 ) resistor r=110.245 //w=0.094 //l=0.215 //layer=ply \
 //thickness=0.18 //x=26.695 //y=0.935 //x2=26.48 //y2=0.935
r1456 (  293 399 ) resistor r=45.1352 //w=0.168 //l=0.173853 //layer=ply \
 //thickness=0.18 //x=26.325 //y=1.4 //x2=26.365 //y2=1.555
r1457 (  292 398 ) resistor r=45.1352 //w=0.168 //l=0.173853 //layer=ply \
 //thickness=0.18 //x=26.325 //y=1.09 //x2=26.365 //y2=0.935
r1458 (  292 293 ) resistor r=158.957 //w=0.094 //l=0.31 //layer=ply \
 //thickness=0.18 //x=26.325 //y=1.09 //x2=26.325 //y2=1.4
r1459 (  288 392 ) resistor r=16.5046 //w=0.27 //l=0.135 //layer=ply \
 //thickness=0.18 //x=12.465 //y=4.97 //x2=12.33 //y2=4.97
r1460 (  287 289 ) resistor r=26.9307 //w=0.15 //l=0.106066 //layer=ply \
 //thickness=0.18 //x=12.665 //y=4.97 //x2=12.74 //y2=5.045
r1461 (  287 288 ) resistor r=102.553 //w=0.094 //l=0.2 //layer=ply \
 //thickness=0.18 //x=12.665 //y=4.97 //x2=12.465 //y2=4.97
r1462 (  286 397 ) resistor r=38.6777 //w=0.284 //l=0.198997 //layer=ply \
 //thickness=0.18 //x=12.42 //y=2.095 //x2=12.345 //y2=2.26
r1463 (  285 395 ) resistor r=21.2976 //w=0.217 //l=0.0928709 //layer=ply \
 //thickness=0.18 //x=12.42 //y=1.63 //x2=12.38 //y2=1.555
r1464 (  285 286 ) resistor r=238.436 //w=0.094 //l=0.465 //layer=ply \
 //thickness=0.18 //x=12.42 //y=1.63 //x2=12.42 //y2=2.095
r1465 (  284 395 ) resistor r=39.0671 //w=0.217 //l=0.173853 //layer=ply \
 //thickness=0.18 //x=12.42 //y=1.4 //x2=12.38 //y2=1.555
r1466 (  283 394 ) resistor r=45.1352 //w=0.168 //l=0.173853 //layer=ply \
 //thickness=0.18 //x=12.42 //y=1.09 //x2=12.38 //y2=0.935
r1467 (  283 284 ) resistor r=158.957 //w=0.094 //l=0.31 //layer=ply \
 //thickness=0.18 //x=12.42 //y=1.09 //x2=12.42 //y2=1.4
r1468 (  278 388 ) resistor r=5.52526 //w=0.168 //l=0.115 //layer=ply \
 //thickness=0.18 //x=12.05 //y=1.555 //x2=11.935 //y2=1.555
r1469 (  277 395 ) resistor r=11.4558 //w=0.217 //l=0.115 //layer=ply \
 //thickness=0.18 //x=12.265 //y=1.555 //x2=12.38 //y2=1.555
r1470 (  276 387 ) resistor r=5.52526 //w=0.168 //l=0.115 //layer=ply \
 //thickness=0.18 //x=12.05 //y=0.935 //x2=11.935 //y2=0.935
r1471 (  275 394 ) resistor r=5.52526 //w=0.168 //l=0.115 //layer=ply \
 //thickness=0.18 //x=12.265 //y=0.935 //x2=12.38 //y2=0.935
r1472 (  275 276 ) resistor r=110.245 //w=0.094 //l=0.215 //layer=ply \
 //thickness=0.18 //x=12.265 //y=0.935 //x2=12.05 //y2=0.935
r1473 (  274 388 ) resistor r=45.1352 //w=0.168 //l=0.173853 //layer=ply \
 //thickness=0.18 //x=11.895 //y=1.4 //x2=11.935 //y2=1.555
r1474 (  273 387 ) resistor r=45.1352 //w=0.168 //l=0.173853 //layer=ply \
 //thickness=0.18 //x=11.895 //y=1.09 //x2=11.935 //y2=0.935
r1475 (  273 274 ) resistor r=158.957 //w=0.094 //l=0.31 //layer=ply \
 //thickness=0.18 //x=11.895 //y=1.09 //x2=11.895 //y2=1.4
r1476 (  272 384 ) resistor r=592.245 //w=0.094 //l=1.155 //layer=ply \
 //thickness=0.18 //x=84.89 //y=6.2 //x2=84.89 //y2=5.045
r1477 (  271 448 ) resistor r=592.245 //w=0.094 //l=1.155 //layer=ply \
 //thickness=0.18 //x=84.45 //y=6.2 //x2=84.45 //y2=5.045
r1478 (  270 365 ) resistor r=592.245 //w=0.094 //l=1.155 //layer=ply \
 //thickness=0.18 //x=70.46 //y=6.2 //x2=70.46 //y2=5.045
r1479 (  269 437 ) resistor r=592.245 //w=0.094 //l=1.155 //layer=ply \
 //thickness=0.18 //x=70.02 //y=6.2 //x2=70.02 //y2=5.045
r1480 (  268 346 ) resistor r=592.245 //w=0.094 //l=1.155 //layer=ply \
 //thickness=0.18 //x=56.03 //y=6.2 //x2=56.03 //y2=5.045
r1481 (  267 426 ) resistor r=592.245 //w=0.094 //l=1.155 //layer=ply \
 //thickness=0.18 //x=55.59 //y=6.2 //x2=55.59 //y2=5.045
r1482 (  266 327 ) resistor r=592.245 //w=0.094 //l=1.155 //layer=ply \
 //thickness=0.18 //x=41.6 //y=6.2 //x2=41.6 //y2=5.045
r1483 (  265 415 ) resistor r=592.245 //w=0.094 //l=1.155 //layer=ply \
 //thickness=0.18 //x=41.16 //y=6.2 //x2=41.16 //y2=5.045
r1484 (  264 308 ) resistor r=592.245 //w=0.094 //l=1.155 //layer=ply \
 //thickness=0.18 //x=27.17 //y=6.2 //x2=27.17 //y2=5.045
r1485 (  263 404 ) resistor r=592.245 //w=0.094 //l=1.155 //layer=ply \
 //thickness=0.18 //x=26.73 //y=6.2 //x2=26.73 //y2=5.045
r1486 (  262 289 ) resistor r=592.245 //w=0.094 //l=1.155 //layer=ply \
 //thickness=0.18 //x=12.74 //y=6.2 //x2=12.74 //y2=5.045
r1487 (  261 393 ) resistor r=592.245 //w=0.094 //l=1.155 //layer=ply \
 //thickness=0.18 //x=12.3 //y=6.2 //x2=12.3 //y2=5.045
r1488 (  260 372 ) resistor r=55.3787 //w=0.094 //l=0.108 //layer=ply \
 //thickness=0.18 //x=84.307 //y=1.555 //x2=84.415 //y2=1.555
r1489 (  260 373 ) resistor r=54.866 //w=0.094 //l=0.107 //layer=ply \
 //thickness=0.18 //x=84.307 //y=1.555 //x2=84.2 //y2=1.555
r1490 (  259 353 ) resistor r=55.3787 //w=0.094 //l=0.108 //layer=ply \
 //thickness=0.18 //x=69.877 //y=1.555 //x2=69.985 //y2=1.555
r1491 (  259 354 ) resistor r=54.866 //w=0.094 //l=0.107 //layer=ply \
 //thickness=0.18 //x=69.877 //y=1.555 //x2=69.77 //y2=1.555
r1492 (  258 334 ) resistor r=55.3787 //w=0.094 //l=0.108 //layer=ply \
 //thickness=0.18 //x=55.447 //y=1.555 //x2=55.555 //y2=1.555
r1493 (  258 335 ) resistor r=54.866 //w=0.094 //l=0.107 //layer=ply \
 //thickness=0.18 //x=55.447 //y=1.555 //x2=55.34 //y2=1.555
r1494 (  257 315 ) resistor r=55.3787 //w=0.094 //l=0.108 //layer=ply \
 //thickness=0.18 //x=41.017 //y=1.555 //x2=41.125 //y2=1.555
r1495 (  257 316 ) resistor r=54.866 //w=0.094 //l=0.107 //layer=ply \
 //thickness=0.18 //x=41.017 //y=1.555 //x2=40.91 //y2=1.555
r1496 (  256 296 ) resistor r=55.3787 //w=0.094 //l=0.108 //layer=ply \
 //thickness=0.18 //x=26.587 //y=1.555 //x2=26.695 //y2=1.555
r1497 (  256 297 ) resistor r=54.866 //w=0.094 //l=0.107 //layer=ply \
 //thickness=0.18 //x=26.587 //y=1.555 //x2=26.48 //y2=1.555
r1498 (  255 277 ) resistor r=55.3787 //w=0.094 //l=0.108 //layer=ply \
 //thickness=0.18 //x=12.157 //y=1.555 //x2=12.265 //y2=1.555
r1499 (  255 278 ) resistor r=54.866 //w=0.094 //l=0.107 //layer=ply \
 //thickness=0.18 //x=12.157 //y=1.555 //x2=12.05 //y2=1.555
r1500 (  251 445 ) resistor r=152 //w=0.17 //l=0.17 //layer=licon //count=1 \
 //x=84.48 //y=4.88 //x2=84.48 //y2=4.88
r1501 (  242 452 ) resistor r=152 //w=0.17 //l=0.17 //layer=licon //count=1 \
 //x=84.48 //y=2.26 //x2=84.48 //y2=2.26
r1502 (  237 434 ) resistor r=152 //w=0.17 //l=0.17 //layer=licon //count=1 \
 //x=70.05 //y=4.88 //x2=70.05 //y2=4.88
r1503 (  228 441 ) resistor r=152 //w=0.17 //l=0.17 //layer=licon //count=1 \
 //x=70.05 //y=2.26 //x2=70.05 //y2=2.26
r1504 (  223 423 ) resistor r=152 //w=0.17 //l=0.17 //layer=licon //count=1 \
 //x=55.62 //y=4.88 //x2=55.62 //y2=4.88
r1505 (  214 430 ) resistor r=152 //w=0.17 //l=0.17 //layer=licon //count=1 \
 //x=55.62 //y=2.26 //x2=55.62 //y2=2.26
r1506 (  209 412 ) resistor r=152 //w=0.17 //l=0.17 //layer=licon //count=1 \
 //x=41.19 //y=4.88 //x2=41.19 //y2=4.88
r1507 (  200 419 ) resistor r=152 //w=0.17 //l=0.17 //layer=licon //count=1 \
 //x=41.19 //y=2.26 //x2=41.19 //y2=2.26
r1508 (  195 401 ) resistor r=152 //w=0.17 //l=0.17 //layer=licon //count=1 \
 //x=26.76 //y=4.88 //x2=26.76 //y2=4.88
r1509 (  186 408 ) resistor r=152 //w=0.17 //l=0.17 //layer=licon //count=1 \
 //x=26.76 //y=2.26 //x2=26.76 //y2=2.26
r1510 (  181 390 ) resistor r=152 //w=0.17 //l=0.17 //layer=licon //count=1 \
 //x=12.33 //y=4.88 //x2=12.33 //y2=4.88
r1511 (  172 397 ) resistor r=152 //w=0.17 //l=0.17 //layer=licon //count=1 \
 //x=12.33 //y=2.26 //x2=12.33 //y2=2.26
r1512 (  157 159 ) resistor r=0.10734 //w=0.281 //l=0.16 //layer=m2 \
 //thickness=0.36 //x=12.33 //y=3.125 //x2=12.49 //y2=3.125
r1513 (  154 170 ) resistor r=3.98787 //w=0.179 //l=5.71999 //layer=m2 \
 //thickness=0.36 //x=78.77 //y=3.125 //x2=84.48 //y2=3.145
r1514 (  154 155 ) resistor r=0.410305 //w=0.131 //l=0.43 //layer=m2 \
 //thickness=0.36 //x=78.77 //y=3.125 //x2=78.34 //y2=3.125
r1515 (  152 155 ) resistor r=0.125 //w=0.17 //l=0.177341 //layer=m2 \
 //thickness=0.36 //x=78.17 //y=3.14 //x2=78.34 //y2=3.125
r1516 (  152 153 ) resistor r=3.84065 //w=0.131 //l=4.025 //layer=m2 \
 //thickness=0.36 //x=78.17 //y=3.14 //x2=74.145 //y2=3.14
r1517 (  150 153 ) resistor r=0.125 //w=0.17 //l=0.177341 //layer=m2 \
 //thickness=0.36 //x=73.975 //y=3.155 //x2=74.145 //y2=3.14
r1518 (  150 151 ) resistor r=0.329198 //w=0.131 //l=0.345 //layer=m2 \
 //thickness=0.36 //x=73.975 //y=3.155 //x2=73.63 //y2=3.155
r1519 (  148 151 ) resistor r=0.1875 //w=0.17 //l=0.262393 //layer=m2 \
 //thickness=0.36 //x=73.375 //y=3.14 //x2=73.63 //y2=3.155
r1520 (  148 149 ) resistor r=1.04008 //w=0.131 //l=1.09 //layer=m2 \
 //thickness=0.36 //x=73.375 //y=3.14 //x2=72.285 //y2=3.14
r1521 (  147 168 ) resistor r=1.1391 //w=0.189 //l=1.73494 //layer=m2 \
 //thickness=0.36 //x=71.77 //y=3.155 //x2=70.05 //y2=3.125
r1522 (  146 149 ) resistor r=0.125 //w=0.17 //l=0.177341 //layer=m2 \
 //thickness=0.36 //x=72.115 //y=3.155 //x2=72.285 //y2=3.14
r1523 (  146 147 ) resistor r=0.329198 //w=0.131 //l=0.345 //layer=m2 \
 //thickness=0.36 //x=72.115 //y=3.155 //x2=71.77 //y2=3.155
r1524 (  144 168 ) resistor r=0.593468 //w=0.189 //l=0.917224 //layer=m2 \
 //thickness=0.36 //x=69.155 //y=3.17 //x2=70.05 //y2=3.125
r1525 (  144 145 ) resistor r=0.329198 //w=0.131 //l=0.345 //layer=m2 \
 //thickness=0.36 //x=69.155 //y=3.17 //x2=68.81 //y2=3.17
r1526 (  142 145 ) resistor r=0.1875 //w=0.17 //l=0.269583 //layer=m2 \
 //thickness=0.36 //x=68.555 //y=3.14 //x2=68.81 //y2=3.17
r1527 (  142 143 ) resistor r=0.949427 //w=0.131 //l=0.995 //layer=m2 \
 //thickness=0.36 //x=68.555 //y=3.14 //x2=67.56 //y2=3.14
r1528 (  140 143 ) resistor r=0.1875 //w=0.17 //l=0.269583 //layer=m2 \
 //thickness=0.36 //x=67.305 //y=3.11 //x2=67.56 //y2=3.14
r1529 (  140 141 ) resistor r=0.410305 //w=0.131 //l=0.43 //layer=m2 \
 //thickness=0.36 //x=67.305 //y=3.11 //x2=66.875 //y2=3.11
r1530 (  138 141 ) resistor r=0.125 //w=0.17 //l=0.184391 //layer=m2 \
 //thickness=0.36 //x=66.705 //y=3.14 //x2=66.875 //y2=3.11
r1531 (  138 139 ) resistor r=2.08492 //w=0.131 //l=2.185 //layer=m2 \
 //thickness=0.36 //x=66.705 //y=3.14 //x2=64.52 //y2=3.14
r1532 (  136 139 ) resistor r=0.125 //w=0.17 //l=0.184391 //layer=m2 \
 //thickness=0.36 //x=64.35 //y=3.17 //x2=64.52 //y2=3.14
r1533 (  136 137 ) resistor r=0.329198 //w=0.131 //l=0.345 //layer=m2 \
 //thickness=0.36 //x=64.35 //y=3.17 //x2=64.005 //y2=3.17
r1534 (  134 137 ) resistor r=0.1875 //w=0.17 //l=0.269583 //layer=m2 \
 //thickness=0.36 //x=63.75 //y=3.14 //x2=64.005 //y2=3.17
r1535 (  134 135 ) resistor r=1.03053 //w=0.131 //l=1.08 //layer=m2 \
 //thickness=0.36 //x=63.75 //y=3.14 //x2=62.67 //y2=3.14
r1536 (  132 135 ) resistor r=0.125 //w=0.17 //l=0.184391 //layer=m2 \
 //thickness=0.36 //x=62.5 //y=3.17 //x2=62.67 //y2=3.14
r1537 (  132 133 ) resistor r=0.329198 //w=0.131 //l=0.345 //layer=m2 \
 //thickness=0.36 //x=62.5 //y=3.17 //x2=62.155 //y2=3.17
r1538 (  131 166 ) resistor r=3.99136 //w=0.179 //l=5.7225 //layer=m2 \
 //thickness=0.36 //x=61.335 //y=3.13 //x2=55.62 //y2=3.145
r1539 (  130 133 ) resistor r=0.286765 //w=0.17 //l=0.409512 //layer=m2 \
 //thickness=0.36 //x=61.765 //y=3.13 //x2=62.155 //y2=3.17
r1540 (  130 131 ) resistor r=0.410305 //w=0.131 //l=0.43 //layer=m2 \
 //thickness=0.36 //x=61.765 //y=3.13 //x2=61.335 //y2=3.13
r1541 (  128 166 ) resistor r=0.112172 //w=0.179 //l=0.162481 //layer=m2 \
 //thickness=0.36 //x=55.46 //y=3.14 //x2=55.62 //y2=3.145
r1542 (  128 164 ) resistor r=3.0916 //w=0.131 //l=3.24 //layer=m2 \
 //thickness=0.36 //x=55.46 //y=3.14 //x2=52.22 //y2=3.14
r1543 (  126 164 ) resistor r=0.0824018 //w=0.161 //l=0.1 //layer=m2 \
 //thickness=0.36 //x=52.12 //y=3.125 //x2=52.22 //y2=3.125
r1544 (  126 127 ) resistor r=0.310559 //w=0.161 //l=0.4 //layer=m2 \
 //thickness=0.36 //x=52.12 //y=3.125 //x2=51.72 //y2=3.125
r1545 (  124 127 ) resistor r=1.31541 //w=0.172 //l=1.81 //layer=m2 \
 //thickness=0.36 //x=49.91 //y=3.125 //x2=51.72 //y2=3.125
r1546 (  124 125 ) resistor r=0.410305 //w=0.131 //l=0.43 //layer=m2 \
 //thickness=0.36 //x=49.91 //y=3.125 //x2=49.48 //y2=3.125
r1547 (  122 125 ) resistor r=0.125 //w=0.17 //l=0.177341 //layer=m2 \
 //thickness=0.36 //x=49.31 //y=3.14 //x2=49.48 //y2=3.125
r1548 (  122 123 ) resistor r=3.84065 //w=0.131 //l=4.025 //layer=m2 \
 //thickness=0.36 //x=49.31 //y=3.14 //x2=45.285 //y2=3.14
r1549 (  120 123 ) resistor r=0.125 //w=0.17 //l=0.177341 //layer=m2 \
 //thickness=0.36 //x=45.115 //y=3.155 //x2=45.285 //y2=3.14
r1550 (  120 121 ) resistor r=0.329198 //w=0.131 //l=0.345 //layer=m2 \
 //thickness=0.36 //x=45.115 //y=3.155 //x2=44.77 //y2=3.155
r1551 (  118 121 ) resistor r=0.1875 //w=0.17 //l=0.262393 //layer=m2 \
 //thickness=0.36 //x=44.515 //y=3.14 //x2=44.77 //y2=3.155
r1552 (  118 119 ) resistor r=1.04008 //w=0.131 //l=1.09 //layer=m2 \
 //thickness=0.36 //x=44.515 //y=3.14 //x2=43.425 //y2=3.14
r1553 (  117 163 ) resistor r=1.1391 //w=0.189 //l=1.73494 //layer=m2 \
 //thickness=0.36 //x=42.91 //y=3.155 //x2=41.19 //y2=3.125
r1554 (  116 119 ) resistor r=0.125 //w=0.17 //l=0.177341 //layer=m2 \
 //thickness=0.36 //x=43.255 //y=3.155 //x2=43.425 //y2=3.14
r1555 (  116 117 ) resistor r=0.329198 //w=0.131 //l=0.345 //layer=m2 \
 //thickness=0.36 //x=43.255 //y=3.155 //x2=42.91 //y2=3.155
r1556 (  114 163 ) resistor r=0.593468 //w=0.189 //l=0.917224 //layer=m2 \
 //thickness=0.36 //x=40.295 //y=3.17 //x2=41.19 //y2=3.125
r1557 (  114 115 ) resistor r=0.329198 //w=0.131 //l=0.345 //layer=m2 \
 //thickness=0.36 //x=40.295 //y=3.17 //x2=39.95 //y2=3.17
r1558 (  112 115 ) resistor r=0.1875 //w=0.17 //l=0.269583 //layer=m2 \
 //thickness=0.36 //x=39.695 //y=3.14 //x2=39.95 //y2=3.17
r1559 (  112 113 ) resistor r=0.949427 //w=0.131 //l=0.995 //layer=m2 \
 //thickness=0.36 //x=39.695 //y=3.14 //x2=38.7 //y2=3.14
r1560 (  110 113 ) resistor r=0.1875 //w=0.17 //l=0.269583 //layer=m2 \
 //thickness=0.36 //x=38.445 //y=3.11 //x2=38.7 //y2=3.14
r1561 (  110 111 ) resistor r=0.410305 //w=0.131 //l=0.43 //layer=m2 \
 //thickness=0.36 //x=38.445 //y=3.11 //x2=38.015 //y2=3.11
r1562 (  108 111 ) resistor r=0.125 //w=0.17 //l=0.184391 //layer=m2 \
 //thickness=0.36 //x=37.845 //y=3.14 //x2=38.015 //y2=3.11
r1563 (  108 109 ) resistor r=2.08492 //w=0.131 //l=2.185 //layer=m2 \
 //thickness=0.36 //x=37.845 //y=3.14 //x2=35.66 //y2=3.14
r1564 (  106 109 ) resistor r=0.125 //w=0.17 //l=0.184391 //layer=m2 \
 //thickness=0.36 //x=35.49 //y=3.17 //x2=35.66 //y2=3.14
r1565 (  106 107 ) resistor r=0.329198 //w=0.131 //l=0.345 //layer=m2 \
 //thickness=0.36 //x=35.49 //y=3.17 //x2=35.145 //y2=3.17
r1566 (  104 107 ) resistor r=0.1875 //w=0.17 //l=0.269583 //layer=m2 \
 //thickness=0.36 //x=34.89 //y=3.14 //x2=35.145 //y2=3.17
r1567 (  104 105 ) resistor r=1.03053 //w=0.131 //l=1.08 //layer=m2 \
 //thickness=0.36 //x=34.89 //y=3.14 //x2=33.81 //y2=3.14
r1568 (  102 105 ) resistor r=0.125 //w=0.17 //l=0.184391 //layer=m2 \
 //thickness=0.36 //x=33.64 //y=3.17 //x2=33.81 //y2=3.14
r1569 (  102 103 ) resistor r=0.329198 //w=0.131 //l=0.345 //layer=m2 \
 //thickness=0.36 //x=33.64 //y=3.17 //x2=33.295 //y2=3.17
r1570 (  101 161 ) resistor r=4.08214 //w=0.175 //l=5.7225 //layer=m2 \
 //thickness=0.36 //x=32.475 //y=3.13 //x2=26.76 //y2=3.145
r1571 (  100 103 ) resistor r=0.286765 //w=0.17 //l=0.409512 //layer=m2 \
 //thickness=0.36 //x=32.905 //y=3.13 //x2=33.295 //y2=3.17
r1572 (  100 101 ) resistor r=0.410305 //w=0.131 //l=0.43 //layer=m2 \
 //thickness=0.36 //x=32.905 //y=3.13 //x2=32.475 //y2=3.13
r1573 (  98 161 ) resistor r=4.07857 //w=0.175 //l=5.71999 //layer=m2 \
 //thickness=0.36 //x=21.05 //y=3.125 //x2=26.76 //y2=3.145
r1574 (  98 99 ) resistor r=0.410305 //w=0.131 //l=0.43 //layer=m2 \
 //thickness=0.36 //x=21.05 //y=3.125 //x2=20.62 //y2=3.125
r1575 (  96 99 ) resistor r=0.125 //w=0.17 //l=0.177341 //layer=m2 \
 //thickness=0.36 //x=20.45 //y=3.14 //x2=20.62 //y2=3.125
r1576 (  96 97 ) resistor r=3.84065 //w=0.131 //l=4.025 //layer=m2 \
 //thickness=0.36 //x=20.45 //y=3.14 //x2=16.425 //y2=3.14
r1577 (  94 97 ) resistor r=0.125 //w=0.17 //l=0.177341 //layer=m2 \
 //thickness=0.36 //x=16.255 //y=3.155 //x2=16.425 //y2=3.14
r1578 (  94 95 ) resistor r=0.329198 //w=0.131 //l=0.345 //layer=m2 \
 //thickness=0.36 //x=16.255 //y=3.155 //x2=15.91 //y2=3.155
r1579 (  92 95 ) resistor r=0.1875 //w=0.17 //l=0.262393 //layer=m2 \
 //thickness=0.36 //x=15.655 //y=3.14 //x2=15.91 //y2=3.155
r1580 (  92 93 ) resistor r=1.04008 //w=0.131 //l=1.09 //layer=m2 \
 //thickness=0.36 //x=15.655 //y=3.14 //x2=14.565 //y2=3.14
r1581 (  90 93 ) resistor r=0.125 //w=0.17 //l=0.177341 //layer=m2 \
 //thickness=0.36 //x=14.395 //y=3.155 //x2=14.565 //y2=3.14
r1582 (  90 91 ) resistor r=0.329198 //w=0.131 //l=0.345 //layer=m2 \
 //thickness=0.36 //x=14.395 //y=3.155 //x2=14.05 //y2=3.155
r1583 (  88 91 ) resistor r=0.1875 //w=0.17 //l=0.262393 //layer=m2 \
 //thickness=0.36 //x=13.795 //y=3.14 //x2=14.05 //y2=3.155
r1584 (  88 159 ) resistor r=1.24523 //w=0.131 //l=1.305 //layer=m2 \
 //thickness=0.36 //x=13.795 //y=3.14 //x2=12.49 //y2=3.14
r1585 (  87 251 ) resistor r=9.3 //w=0.17 //l=0.17 //layer=mcon //count=1 \
 //x=84.48 //y=4.88 //x2=84.48 //y2=4.88
r1586 (  85 242 ) resistor r=9.3 //w=0.17 //l=0.17 //layer=mcon //count=1 \
 //x=84.48 //y=2.26 //x2=84.48 //y2=2.26
r1587 (  83 170 ) resistor r=4.5 //w=0.15 //l=0.15 //layer=via1 //count=1 \
 //x=84.48 //y=3.145 //x2=84.48 //y2=3.145
r1588 (  81 83 ) resistor r=0.00166223 //w=0.376 //l=0.005 //layer=m1 \
 //thickness=0.36 //x=84.427 //y=3.14 //x2=84.427 //y2=3.145
r1589 (  77 168 ) resistor r=4.5 //w=0.15 //l=0.15 //layer=via1 //count=1 \
 //x=70.05 //y=3.125 //x2=70.05 //y2=3.125
r1590 (  75 237 ) resistor r=9.3 //w=0.17 //l=0.17 //layer=mcon //count=1 \
 //x=70.05 //y=4.88 //x2=70.05 //y2=4.88
r1591 (  73 228 ) resistor r=9.3 //w=0.17 //l=0.17 //layer=mcon //count=1 \
 //x=70.05 //y=2.26 //x2=70.05 //y2=2.26
r1592 (  71 223 ) resistor r=9.3 //w=0.17 //l=0.17 //layer=mcon //count=1 \
 //x=55.62 //y=4.88 //x2=55.62 //y2=4.88
r1593 (  69 214 ) resistor r=9.3 //w=0.17 //l=0.17 //layer=mcon //count=1 \
 //x=55.62 //y=2.26 //x2=55.62 //y2=2.26
r1594 (  67 166 ) resistor r=4.5 //w=0.15 //l=0.15 //layer=via1 //count=1 \
 //x=55.62 //y=3.145 //x2=55.62 //y2=3.145
r1595 (  61 163 ) resistor r=4.5 //w=0.15 //l=0.15 //layer=via1 //count=1 \
 //x=41.19 //y=3.125 //x2=41.19 //y2=3.125
r1596 (  59 209 ) resistor r=9.3 //w=0.17 //l=0.17 //layer=mcon //count=1 \
 //x=41.19 //y=4.88 //x2=41.19 //y2=4.88
r1597 (  57 200 ) resistor r=9.3 //w=0.17 //l=0.17 //layer=mcon //count=1 \
 //x=41.19 //y=2.26 //x2=41.19 //y2=2.26
r1598 (  55 195 ) resistor r=9.3 //w=0.17 //l=0.17 //layer=mcon //count=1 \
 //x=26.76 //y=4.88 //x2=26.76 //y2=4.88
r1599 (  53 186 ) resistor r=9.3 //w=0.17 //l=0.17 //layer=mcon //count=1 \
 //x=26.76 //y=2.26 //x2=26.76 //y2=2.26
r1600 (  51 161 ) resistor r=4.5 //w=0.15 //l=0.15 //layer=via1 //count=1 \
 //x=26.76 //y=3.145 //x2=26.76 //y2=3.145
r1601 (  45 157 ) resistor r=4.5 //w=0.15 //l=0.15 //layer=via1 //count=1 \
 //x=12.33 //y=3.125 //x2=12.33 //y2=3.125
r1602 (  43 181 ) resistor r=9.3 //w=0.17 //l=0.17 //layer=mcon //count=1 \
 //x=12.33 //y=4.88 //x2=12.33 //y2=4.88
r1603 (  41 172 ) resistor r=9.3 //w=0.17 //l=0.17 //layer=mcon //count=1 \
 //x=12.33 //y=2.26 //x2=12.33 //y2=2.26
r1604 (  39 87 ) resistor r=0.0717383 //w=0.224 //l=0.115 //layer=m1 \
 //thickness=0.36 //x=84.48 //y=4.765 //x2=84.48 //y2=4.88
r1605 (  38 83 ) resistor r=0.0911593 //w=0.376 //l=0.184608 //layer=m1 \
 //thickness=0.36 //x=84.48 //y=3.305 //x2=84.427 //y2=3.145
r1606 (  38 39 ) resistor r=1.39313 //w=0.131 //l=1.46 //layer=m1 \
 //thickness=0.36 //x=84.48 //y=3.305 //x2=84.48 //y2=4.765
r1607 (  37 81 ) resistor r=0.0894971 //w=0.376 //l=0.179555 //layer=m1 \
 //thickness=0.36 //x=84.48 //y=2.985 //x2=84.427 //y2=3.14
r1608 (  36 85 ) resistor r=0.0715665 //w=0.226 //l=0.115996 //layer=m1 \
 //thickness=0.36 //x=84.48 //y=2.375 //x2=84.482 //y2=2.26
r1609 (  36 37 ) resistor r=0.582061 //w=0.131 //l=0.61 //layer=m1 \
 //thickness=0.36 //x=84.48 //y=2.375 //x2=84.48 //y2=2.985
r1610 (  35 75 ) resistor r=0.0717383 //w=0.224 //l=0.115 //layer=m1 \
 //thickness=0.36 //x=70.05 //y=4.765 //x2=70.05 //y2=4.88
r1611 (  34 35 ) resistor r=1.41221 //w=0.131 //l=1.48 //layer=m1 \
 //thickness=0.36 //x=70.05 //y=3.285 //x2=70.05 //y2=4.765
r1612 (  32 77 ) resistor r=0.0911593 //w=0.376 //l=0.184174 //layer=m1 \
 //thickness=0.36 //x=70.05 //y=2.965 //x2=70.102 //y2=3.125
r1613 (  31 73 ) resistor r=0.0715665 //w=0.226 //l=0.115996 //layer=m1 \
 //thickness=0.36 //x=70.05 //y=2.375 //x2=70.052 //y2=2.26
r1614 (  30 71 ) resistor r=0.0717383 //w=0.224 //l=0.115 //layer=m1 \
 //thickness=0.36 //x=55.62 //y=4.765 //x2=55.62 //y2=4.88
r1615 (  29 67 ) resistor r=0.0911593 //w=0.376 //l=0.184608 //layer=m1 \
 //thickness=0.36 //x=55.62 //y=3.305 //x2=55.567 //y2=3.145
r1616 (  29 30 ) resistor r=1.39313 //w=0.131 //l=1.46 //layer=m1 \
 //thickness=0.36 //x=55.62 //y=3.305 //x2=55.62 //y2=4.765
r1617 (  26 69 ) resistor r=0.0715665 //w=0.226 //l=0.115996 //layer=m1 \
 //thickness=0.36 //x=55.62 //y=2.375 //x2=55.622 //y2=2.26
r1618 (  25 59 ) resistor r=0.0717383 //w=0.224 //l=0.115 //layer=m1 \
 //thickness=0.36 //x=41.19 //y=4.765 //x2=41.19 //y2=4.88
r1619 (  24 25 ) resistor r=1.41221 //w=0.131 //l=1.48 //layer=m1 \
 //thickness=0.36 //x=41.19 //y=3.285 //x2=41.19 //y2=4.765
r1620 (  22 61 ) resistor r=0.0911593 //w=0.376 //l=0.184174 //layer=m1 \
 //thickness=0.36 //x=41.19 //y=2.965 //x2=41.242 //y2=3.125
r1621 (  21 57 ) resistor r=0.0715665 //w=0.226 //l=0.115996 //layer=m1 \
 //thickness=0.36 //x=41.19 //y=2.375 //x2=41.192 //y2=2.26
r1622 (  20 55 ) resistor r=0.0717383 //w=0.224 //l=0.115 //layer=m1 \
 //thickness=0.36 //x=26.76 //y=4.765 //x2=26.76 //y2=4.88
r1623 (  19 51 ) resistor r=0.0911593 //w=0.376 //l=0.184608 //layer=m1 \
 //thickness=0.36 //x=26.76 //y=3.305 //x2=26.707 //y2=3.145
r1624 (  19 20 ) resistor r=1.39313 //w=0.131 //l=1.46 //layer=m1 \
 //thickness=0.36 //x=26.76 //y=3.305 //x2=26.76 //y2=4.765
r1625 (  16 53 ) resistor r=0.0715665 //w=0.226 //l=0.115996 //layer=m1 \
 //thickness=0.36 //x=26.76 //y=2.375 //x2=26.762 //y2=2.26
r1626 (  15 43 ) resistor r=0.0717383 //w=0.224 //l=0.115 //layer=m1 \
 //thickness=0.36 //x=12.33 //y=4.765 //x2=12.33 //y2=4.88
r1627 (  14 15 ) resistor r=1.41221 //w=0.131 //l=1.48 //layer=m1 \
 //thickness=0.36 //x=12.33 //y=3.285 //x2=12.33 //y2=4.765
r1628 (  12 45 ) resistor r=0.0911593 //w=0.376 //l=0.184174 //layer=m1 \
 //thickness=0.36 //x=12.33 //y=2.965 //x2=12.382 //y2=3.125
r1629 (  11 41 ) resistor r=0.0715665 //w=0.226 //l=0.115996 //layer=m1 \
 //thickness=0.36 //x=12.33 //y=2.375 //x2=12.332 //y2=2.26
r1630 (  10 34 ) resistor r=0.0861726 //w=0.376 //l=0.169012 //layer=m1 \
 //thickness=0.36 //x=70.102 //y=3.14 //x2=70.05 //y2=3.285
r1631 (  10 77 ) resistor r=0.0049867 //w=0.376 //l=0.015 //layer=m1 \
 //thickness=0.36 //x=70.102 //y=3.14 //x2=70.102 //y2=3.125
r1632 (  9 67 ) resistor r=0.00166223 //w=0.376 //l=0.005 //layer=m1 \
 //thickness=0.36 //x=55.567 //y=3.14 //x2=55.567 //y2=3.145
r1633 (  9 27 ) resistor r=0.0894971 //w=0.376 //l=0.179555 //layer=m1 \
 //thickness=0.36 //x=55.567 //y=3.14 //x2=55.62 //y2=2.985
r1634 (  8 24 ) resistor r=0.0861726 //w=0.376 //l=0.169012 //layer=m1 \
 //thickness=0.36 //x=41.242 //y=3.14 //x2=41.19 //y2=3.285
r1635 (  8 61 ) resistor r=0.0049867 //w=0.376 //l=0.015 //layer=m1 \
 //thickness=0.36 //x=41.242 //y=3.14 //x2=41.242 //y2=3.125
r1636 (  7 51 ) resistor r=0.00166223 //w=0.376 //l=0.005 //layer=m1 \
 //thickness=0.36 //x=26.707 //y=3.14 //x2=26.707 //y2=3.145
r1637 (  7 17 ) resistor r=0.0894971 //w=0.376 //l=0.179555 //layer=m1 \
 //thickness=0.36 //x=26.707 //y=3.14 //x2=26.76 //y2=2.985
r1638 (  6 14 ) resistor r=0.0861726 //w=0.376 //l=0.169012 //layer=m1 \
 //thickness=0.36 //x=12.382 //y=3.14 //x2=12.33 //y2=3.285
r1639 (  6 45 ) resistor r=0.0049867 //w=0.376 //l=0.015 //layer=m1 \
 //thickness=0.36 //x=12.382 //y=3.14 //x2=12.382 //y2=3.125
r1640 (  5 32 ) resistor r=0.186069 //w=0.131 //l=0.195 //layer=m1 \
 //thickness=0.36 //x=70.05 //y=2.77 //x2=70.05 //y2=2.965
r1641 (  5 31 ) resistor r=0.376908 //w=0.131 //l=0.395 //layer=m1 \
 //thickness=0.36 //x=70.05 //y=2.77 //x2=70.05 //y2=2.375
r1642 (  4 27 ) resistor r=0.205153 //w=0.131 //l=0.215 //layer=m1 \
 //thickness=0.36 //x=55.62 //y=2.77 //x2=55.62 //y2=2.985
r1643 (  4 26 ) resistor r=0.376908 //w=0.131 //l=0.395 //layer=m1 \
 //thickness=0.36 //x=55.62 //y=2.77 //x2=55.62 //y2=2.375
r1644 (  3 22 ) resistor r=0.186069 //w=0.131 //l=0.195 //layer=m1 \
 //thickness=0.36 //x=41.19 //y=2.77 //x2=41.19 //y2=2.965
r1645 (  3 21 ) resistor r=0.376908 //w=0.131 //l=0.395 //layer=m1 \
 //thickness=0.36 //x=41.19 //y=2.77 //x2=41.19 //y2=2.375
r1646 (  2 17 ) resistor r=0.205153 //w=0.131 //l=0.215 //layer=m1 \
 //thickness=0.36 //x=26.76 //y=2.77 //x2=26.76 //y2=2.985
r1647 (  2 16 ) resistor r=0.376908 //w=0.131 //l=0.395 //layer=m1 \
 //thickness=0.36 //x=26.76 //y=2.77 //x2=26.76 //y2=2.375
r1648 (  1 12 ) resistor r=0.186069 //w=0.131 //l=0.195 //layer=m1 \
 //thickness=0.36 //x=12.33 //y=2.77 //x2=12.33 //y2=2.965
r1649 (  1 11 ) resistor r=0.376908 //w=0.131 //l=0.395 //layer=m1 \
 //thickness=0.36 //x=12.33 //y=2.77 //x2=12.33 //y2=2.375
ends PM_TMRDFFSNRNQX1\%SN

subckt PM_TMRDFFSNRNQX1\%noxref_20 ( 1 2 3 4 5 6 7 8 9 11 14 15 17 18 19 20 22 \
 23 24 25 26 27 28 34 38 45 48 51 57 61 70 72 73 77 80 81 87 96 101 110 115 \
 123 131 148 157 161 162 163 164 165 166 167 168 169 173 174 175 180 182 185 \
 186 190 191 192 197 199 202 203 207 208 209 214 216 219 220 222 223 228 232 \
 233 238 242 243 248 251 253 254 255 )
c600 ( 251 0 ) capacitor c=0.00885916f //x=76.035 //y=1.095
c601 ( 248 0 ) capacitor c=0.0651477f //x=85.59 //y=4.88
c602 ( 243 0 ) capacitor c=0.0278202f //x=85.59 //y=2.095
c603 ( 242 0 ) capacitor c=0.0487297f //x=85.59 //y=2.26
c604 ( 238 0 ) capacitor c=0.0651406f //x=71.16 //y=4.88
c605 ( 233 0 ) capacitor c=0.0278202f //x=71.16 //y=2.095
c606 ( 232 0 ) capacitor c=0.0503043f //x=71.16 //y=2.26
c607 ( 228 0 ) capacitor c=0.0653609f //x=66.35 //y=4.88
c608 ( 223 0 ) capacitor c=0.0278202f //x=66.35 //y=2.095
c609 ( 222 0 ) capacitor c=0.0503043f //x=66.35 //y=2.26
c610 ( 220 0 ) capacitor c=0.0443175f //x=86.11 //y=1.44
c611 ( 219 0 ) capacitor c=0.0199703f //x=86.11 //y=1.095
c612 ( 216 0 ) capacitor c=0.0162526f //x=85.955 //y=1.595
c613 ( 214 0 ) capacitor c=0.0157807f //x=85.955 //y=0.94
c614 ( 209 0 ) capacitor c=0.0220935f //x=85.58 //y=1.75
c615 ( 208 0 ) capacitor c=0.0207489f //x=85.58 //y=1.44
c616 ( 207 0 ) capacitor c=0.0194091f //x=85.58 //y=1.095
c617 ( 203 0 ) capacitor c=0.0443175f //x=71.68 //y=1.44
c618 ( 202 0 ) capacitor c=0.0199703f //x=71.68 //y=1.095
c619 ( 199 0 ) capacitor c=0.0162526f //x=71.525 //y=1.595
c620 ( 197 0 ) capacitor c=0.0157807f //x=71.525 //y=0.94
c621 ( 192 0 ) capacitor c=0.0220935f //x=71.15 //y=1.75
c622 ( 191 0 ) capacitor c=0.0207489f //x=71.15 //y=1.44
c623 ( 190 0 ) capacitor c=0.0194091f //x=71.15 //y=1.095
c624 ( 186 0 ) capacitor c=0.0443175f //x=66.87 //y=1.44
c625 ( 185 0 ) capacitor c=0.0199703f //x=66.87 //y=1.095
c626 ( 182 0 ) capacitor c=0.0162526f //x=66.715 //y=1.595
c627 ( 180 0 ) capacitor c=0.0157807f //x=66.715 //y=0.94
c628 ( 175 0 ) capacitor c=0.0220935f //x=66.34 //y=1.75
c629 ( 174 0 ) capacitor c=0.0207489f //x=66.34 //y=1.44
c630 ( 173 0 ) capacitor c=0.0194091f //x=66.34 //y=1.095
c631 ( 169 0 ) capacitor c=0.159671f //x=85.77 //y=6.2
c632 ( 168 0 ) capacitor c=0.110208f //x=85.33 //y=6.2
c633 ( 167 0 ) capacitor c=0.159671f //x=71.34 //y=6.2
c634 ( 166 0 ) capacitor c=0.110208f //x=70.9 //y=6.2
c635 ( 165 0 ) capacitor c=0.159671f //x=66.53 //y=6.2
c636 ( 164 0 ) capacitor c=0.110219f //x=66.09 //y=6.2
c637 ( 157 0 ) capacitor c=7.7417e-19 //x=85.59 //y=4.88
c638 ( 148 0 ) capacitor c=0.00101179f //x=85.59 //y=2.26
c639 ( 131 0 ) capacitor c=0.0293124f //x=75.93 //y=5.56
c640 ( 123 0 ) capacitor c=0.029137f //x=75.05 //y=5.56
c641 ( 115 0 ) capacitor c=0.0278099f //x=74.17 //y=5.56
c642 ( 110 0 ) capacitor c=9.5006e-19 //x=71.16 //y=4.88
c643 ( 101 0 ) capacitor c=0.00101179f //x=71.16 //y=2.26
c644 ( 96 0 ) capacitor c=9.08283e-19 //x=66.35 //y=4.88
c645 ( 87 0 ) capacitor c=0.00101179f //x=66.35 //y=2.26
c646 ( 81 0 ) capacitor c=3.98458e-19 //x=71.32 //y=3.895
c647 ( 80 0 ) capacitor c=0.0441954f //x=71 //y=3.895
c648 ( 77 0 ) capacitor c=3.98458e-19 //x=66.51 //y=3.895
c649 ( 73 0 ) capacitor c=0.0212158f //x=78.425 //y=3.895
c650 ( 72 0 ) capacitor c=0.0867333f //x=78.77 //y=3.895
c651 ( 70 0 ) capacitor c=0.0533559f //x=76.54 //y=3.88
c652 ( 61 0 ) capacitor c=0.0149589f //x=85.59 //y=3.88
c653 ( 57 0 ) capacitor c=0.0158949f //x=76.71 //y=3.88
c654 ( 51 0 ) capacitor c=0.00111241f //x=75.93 //y=5.335
c655 ( 48 0 ) capacitor c=0.00737416f //x=75.05 //y=5.335
c656 ( 45 0 ) capacitor c=0.0119166f //x=74.172 //y=5.335
c657 ( 38 0 ) capacitor c=0.0149589f //x=71.16 //y=3.88
c658 ( 34 0 ) capacitor c=0.0149589f //x=66.35 //y=3.88
c659 ( 28 0 ) capacitor c=0.0197432f //x=85.59 //y=4.75
c660 ( 27 0 ) capacitor c=0.0115215f //x=85.59 //y=4.045
c661 ( 26 0 ) capacitor c=0.0333977f //x=85.59 //y=3.725
c662 ( 25 0 ) capacitor c=0.00553505f //x=85.59 //y=2.375
c663 ( 24 0 ) capacitor c=0.030326f //x=76.71 //y=5.25
c664 ( 23 0 ) capacitor c=0.0138897f //x=76.71 //y=4.055
c665 ( 22 0 ) capacitor c=0.0490588f //x=76.71 //y=3.735
c666 ( 20 0 ) capacitor c=0.00493487f //x=76.31 //y=1.845
c667 ( 19 0 ) capacitor c=0.0133342f //x=76.625 //y=1.845
c668 ( 18 0 ) capacitor c=0.0167992f //x=76.225 //y=1.76
c669 ( 17 0 ) capacitor c=0.0111491f //x=76.225 //y=1.305
c670 ( 15 0 ) capacitor c=0.0238276f //x=76.625 //y=5.335
c671 ( 14 0 ) capacitor c=0.00933983f //x=75.93 //y=5.56
c672 ( 11 0 ) capacitor c=0.0173034f //x=75.815 //y=5.335
c673 ( 9 0 ) capacitor c=0.0153223f //x=74.93 //y=5.335
c674 ( 8 0 ) capacitor c=0.0180102f //x=71.16 //y=4.75
c675 ( 7 0 ) capacitor c=0.011494f //x=71.16 //y=4.055
c676 ( 6 0 ) capacitor c=0.029293f //x=71.16 //y=3.735
c677 ( 5 0 ) capacitor c=0.00556102f //x=71.16 //y=2.375
c678 ( 4 0 ) capacitor c=0.0173396f //x=66.35 //y=4.75
c679 ( 3 0 ) capacitor c=0.0132847f //x=66.35 //y=4.055
c680 ( 2 0 ) capacitor c=0.0302473f //x=66.35 //y=3.735
c681 ( 1 0 ) capacitor c=0.00556102f //x=66.35 //y=2.375
r682 (  242 243 ) resistor r=52.7279 //w=0.214 //l=0.165 //layer=ply \
 //thickness=0.18 //x=85.59 //y=2.26 //x2=85.59 //y2=2.095
r683 (  232 233 ) resistor r=52.7279 //w=0.214 //l=0.165 //layer=ply \
 //thickness=0.18 //x=71.16 //y=2.26 //x2=71.16 //y2=2.095
r684 (  222 223 ) resistor r=52.7279 //w=0.214 //l=0.165 //layer=ply \
 //thickness=0.18 //x=66.35 //y=2.26 //x2=66.35 //y2=2.095
r685 (  220 250 ) resistor r=45.1352 //w=0.168 //l=0.173853 //layer=ply \
 //thickness=0.18 //x=86.11 //y=1.44 //x2=86.07 //y2=1.595
r686 (  219 249 ) resistor r=45.1352 //w=0.168 //l=0.173853 //layer=ply \
 //thickness=0.18 //x=86.11 //y=1.095 //x2=86.07 //y2=0.94
r687 (  219 220 ) resistor r=176.904 //w=0.094 //l=0.345 //layer=ply \
 //thickness=0.18 //x=86.11 //y=1.095 //x2=86.11 //y2=1.44
r688 (  217 246 ) resistor r=10.701 //w=0.21 //l=0.115 //layer=ply \
 //thickness=0.18 //x=85.735 //y=1.595 //x2=85.62 //y2=1.595
r689 (  216 250 ) resistor r=5.52526 //w=0.168 //l=0.115 //layer=ply \
 //thickness=0.18 //x=85.955 //y=1.595 //x2=86.07 //y2=1.595
r690 (  215 245 ) resistor r=5.52526 //w=0.168 //l=0.115 //layer=ply \
 //thickness=0.18 //x=85.735 //y=0.94 //x2=85.62 //y2=0.94
r691 (  214 249 ) resistor r=5.52526 //w=0.168 //l=0.115 //layer=ply \
 //thickness=0.18 //x=85.955 //y=0.94 //x2=86.07 //y2=0.94
r692 (  214 215 ) resistor r=112.809 //w=0.094 //l=0.22 //layer=ply \
 //thickness=0.18 //x=85.955 //y=0.94 //x2=85.735 //y2=0.94
r693 (  211 248 ) resistor r=37.236 //w=0.233 //l=0.249199 //layer=ply \
 //thickness=0.18 //x=85.77 //y=5.045 //x2=85.59 //y2=4.88
r694 (  209 246 ) resistor r=39.5823 //w=0.21 //l=0.173853 //layer=ply \
 //thickness=0.18 //x=85.58 //y=1.75 //x2=85.62 //y2=1.595
r695 (  209 243 ) resistor r=176.904 //w=0.094 //l=0.345 //layer=ply \
 //thickness=0.18 //x=85.58 //y=1.75 //x2=85.58 //y2=2.095
r696 (  208 246 ) resistor r=39.5823 //w=0.21 //l=0.173853 //layer=ply \
 //thickness=0.18 //x=85.58 //y=1.44 //x2=85.62 //y2=1.595
r697 (  207 245 ) resistor r=45.1352 //w=0.168 //l=0.173853 //layer=ply \
 //thickness=0.18 //x=85.58 //y=1.095 //x2=85.62 //y2=0.94
r698 (  207 208 ) resistor r=176.904 //w=0.094 //l=0.345 //layer=ply \
 //thickness=0.18 //x=85.58 //y=1.095 //x2=85.58 //y2=1.44
r699 (  204 248 ) resistor r=53.7854 //w=0.233 //l=0.332415 //layer=ply \
 //thickness=0.18 //x=85.33 //y=5.045 //x2=85.59 //y2=4.88
r700 (  203 240 ) resistor r=45.1352 //w=0.168 //l=0.173853 //layer=ply \
 //thickness=0.18 //x=71.68 //y=1.44 //x2=71.64 //y2=1.595
r701 (  202 239 ) resistor r=45.1352 //w=0.168 //l=0.173853 //layer=ply \
 //thickness=0.18 //x=71.68 //y=1.095 //x2=71.64 //y2=0.94
r702 (  202 203 ) resistor r=176.904 //w=0.094 //l=0.345 //layer=ply \
 //thickness=0.18 //x=71.68 //y=1.095 //x2=71.68 //y2=1.44
r703 (  200 236 ) resistor r=10.701 //w=0.21 //l=0.115 //layer=ply \
 //thickness=0.18 //x=71.305 //y=1.595 //x2=71.19 //y2=1.595
r704 (  199 240 ) resistor r=5.52526 //w=0.168 //l=0.115 //layer=ply \
 //thickness=0.18 //x=71.525 //y=1.595 //x2=71.64 //y2=1.595
r705 (  198 235 ) resistor r=5.52526 //w=0.168 //l=0.115 //layer=ply \
 //thickness=0.18 //x=71.305 //y=0.94 //x2=71.19 //y2=0.94
r706 (  197 239 ) resistor r=5.52526 //w=0.168 //l=0.115 //layer=ply \
 //thickness=0.18 //x=71.525 //y=0.94 //x2=71.64 //y2=0.94
r707 (  197 198 ) resistor r=112.809 //w=0.094 //l=0.22 //layer=ply \
 //thickness=0.18 //x=71.525 //y=0.94 //x2=71.305 //y2=0.94
r708 (  194 238 ) resistor r=37.236 //w=0.233 //l=0.249199 //layer=ply \
 //thickness=0.18 //x=71.34 //y=5.045 //x2=71.16 //y2=4.88
r709 (  192 236 ) resistor r=39.5823 //w=0.21 //l=0.173853 //layer=ply \
 //thickness=0.18 //x=71.15 //y=1.75 //x2=71.19 //y2=1.595
r710 (  192 233 ) resistor r=176.904 //w=0.094 //l=0.345 //layer=ply \
 //thickness=0.18 //x=71.15 //y=1.75 //x2=71.15 //y2=2.095
r711 (  191 236 ) resistor r=39.5823 //w=0.21 //l=0.173853 //layer=ply \
 //thickness=0.18 //x=71.15 //y=1.44 //x2=71.19 //y2=1.595
r712 (  190 235 ) resistor r=45.1352 //w=0.168 //l=0.173853 //layer=ply \
 //thickness=0.18 //x=71.15 //y=1.095 //x2=71.19 //y2=0.94
r713 (  190 191 ) resistor r=176.904 //w=0.094 //l=0.345 //layer=ply \
 //thickness=0.18 //x=71.15 //y=1.095 //x2=71.15 //y2=1.44
r714 (  187 238 ) resistor r=53.7854 //w=0.233 //l=0.332415 //layer=ply \
 //thickness=0.18 //x=70.9 //y=5.045 //x2=71.16 //y2=4.88
r715 (  186 230 ) resistor r=45.1352 //w=0.168 //l=0.173853 //layer=ply \
 //thickness=0.18 //x=66.87 //y=1.44 //x2=66.83 //y2=1.595
r716 (  185 229 ) resistor r=45.1352 //w=0.168 //l=0.173853 //layer=ply \
 //thickness=0.18 //x=66.87 //y=1.095 //x2=66.83 //y2=0.94
r717 (  185 186 ) resistor r=176.904 //w=0.094 //l=0.345 //layer=ply \
 //thickness=0.18 //x=66.87 //y=1.095 //x2=66.87 //y2=1.44
r718 (  183 226 ) resistor r=10.701 //w=0.21 //l=0.115 //layer=ply \
 //thickness=0.18 //x=66.495 //y=1.595 //x2=66.38 //y2=1.595
r719 (  182 230 ) resistor r=5.52526 //w=0.168 //l=0.115 //layer=ply \
 //thickness=0.18 //x=66.715 //y=1.595 //x2=66.83 //y2=1.595
r720 (  181 225 ) resistor r=5.52526 //w=0.168 //l=0.115 //layer=ply \
 //thickness=0.18 //x=66.495 //y=0.94 //x2=66.38 //y2=0.94
r721 (  180 229 ) resistor r=5.52526 //w=0.168 //l=0.115 //layer=ply \
 //thickness=0.18 //x=66.715 //y=0.94 //x2=66.83 //y2=0.94
r722 (  180 181 ) resistor r=112.809 //w=0.094 //l=0.22 //layer=ply \
 //thickness=0.18 //x=66.715 //y=0.94 //x2=66.495 //y2=0.94
r723 (  177 228 ) resistor r=37.236 //w=0.233 //l=0.249199 //layer=ply \
 //thickness=0.18 //x=66.53 //y=5.045 //x2=66.35 //y2=4.88
r724 (  175 226 ) resistor r=39.5823 //w=0.21 //l=0.173853 //layer=ply \
 //thickness=0.18 //x=66.34 //y=1.75 //x2=66.38 //y2=1.595
r725 (  175 223 ) resistor r=176.904 //w=0.094 //l=0.345 //layer=ply \
 //thickness=0.18 //x=66.34 //y=1.75 //x2=66.34 //y2=2.095
r726 (  174 226 ) resistor r=39.5823 //w=0.21 //l=0.173853 //layer=ply \
 //thickness=0.18 //x=66.34 //y=1.44 //x2=66.38 //y2=1.595
r727 (  173 225 ) resistor r=45.1352 //w=0.168 //l=0.173853 //layer=ply \
 //thickness=0.18 //x=66.34 //y=1.095 //x2=66.38 //y2=0.94
r728 (  173 174 ) resistor r=176.904 //w=0.094 //l=0.345 //layer=ply \
 //thickness=0.18 //x=66.34 //y=1.095 //x2=66.34 //y2=1.44
r729 (  170 228 ) resistor r=53.7854 //w=0.233 //l=0.332415 //layer=ply \
 //thickness=0.18 //x=66.09 //y=5.045 //x2=66.35 //y2=4.88
r730 (  169 211 ) resistor r=592.245 //w=0.094 //l=1.155 //layer=ply \
 //thickness=0.18 //x=85.77 //y=6.2 //x2=85.77 //y2=5.045
r731 (  168 204 ) resistor r=592.245 //w=0.094 //l=1.155 //layer=ply \
 //thickness=0.18 //x=85.33 //y=6.2 //x2=85.33 //y2=5.045
r732 (  167 194 ) resistor r=592.245 //w=0.094 //l=1.155 //layer=ply \
 //thickness=0.18 //x=71.34 //y=6.2 //x2=71.34 //y2=5.045
r733 (  166 187 ) resistor r=592.245 //w=0.094 //l=1.155 //layer=ply \
 //thickness=0.18 //x=70.9 //y=6.2 //x2=70.9 //y2=5.045
r734 (  165 177 ) resistor r=592.245 //w=0.094 //l=1.155 //layer=ply \
 //thickness=0.18 //x=66.53 //y=6.2 //x2=66.53 //y2=5.045
r735 (  164 170 ) resistor r=592.245 //w=0.094 //l=1.155 //layer=ply \
 //thickness=0.18 //x=66.09 //y=6.2 //x2=66.09 //y2=5.045
r736 (  163 216 ) resistor r=56.4043 //w=0.094 //l=0.11 //layer=ply \
 //thickness=0.18 //x=85.845 //y=1.595 //x2=85.955 //y2=1.595
r737 (  163 217 ) resistor r=56.4043 //w=0.094 //l=0.11 //layer=ply \
 //thickness=0.18 //x=85.845 //y=1.595 //x2=85.735 //y2=1.595
r738 (  162 199 ) resistor r=56.4043 //w=0.094 //l=0.11 //layer=ply \
 //thickness=0.18 //x=71.415 //y=1.595 //x2=71.525 //y2=1.595
r739 (  162 200 ) resistor r=56.4043 //w=0.094 //l=0.11 //layer=ply \
 //thickness=0.18 //x=71.415 //y=1.595 //x2=71.305 //y2=1.595
r740 (  161 182 ) resistor r=56.4043 //w=0.094 //l=0.11 //layer=ply \
 //thickness=0.18 //x=66.605 //y=1.595 //x2=66.715 //y2=1.595
r741 (  161 183 ) resistor r=56.4043 //w=0.094 //l=0.11 //layer=ply \
 //thickness=0.18 //x=66.605 //y=1.595 //x2=66.495 //y2=1.595
r742 (  157 248 ) resistor r=152 //w=0.17 //l=0.17 //layer=licon //count=1 \
 //x=85.59 //y=4.88 //x2=85.59 //y2=4.88
r743 (  148 242 ) resistor r=152 //w=0.17 //l=0.17 //layer=licon //count=1 \
 //x=85.59 //y=2.26 //x2=85.59 //y2=2.26
r744 (  131 255 ) resistor r=23.615 //w=0.187 //l=0.345 //layer=li \
 //thickness=0.1 //x=75.93 //y=5.56 //x2=75.93 //y2=5.905
r745 (  123 254 ) resistor r=23.615 //w=0.187 //l=0.345 //layer=li \
 //thickness=0.1 //x=75.05 //y=5.56 //x2=75.05 //y2=5.905
r746 (  115 253 ) resistor r=23.615 //w=0.187 //l=0.345 //layer=li \
 //thickness=0.1 //x=74.17 //y=5.56 //x2=74.17 //y2=5.905
r747 (  110 238 ) resistor r=152 //w=0.17 //l=0.17 //layer=licon //count=1 \
 //x=71.16 //y=4.88 //x2=71.16 //y2=4.88
r748 (  101 232 ) resistor r=152 //w=0.17 //l=0.17 //layer=licon //count=1 \
 //x=71.16 //y=2.26 //x2=71.16 //y2=2.26
r749 (  96 228 ) resistor r=152 //w=0.17 //l=0.17 //layer=licon //count=1 \
 //x=66.35 //y=4.88 //x2=66.35 //y2=4.88
r750 (  87 222 ) resistor r=152 //w=0.17 //l=0.17 //layer=licon //count=1 \
 //x=66.35 //y=2.26 //x2=66.35 //y2=2.26
r751 (  79 81 ) resistor r=0.10734 //w=0.281 //l=0.16 //layer=m2 \
 //thickness=0.36 //x=71.16 //y=3.895 //x2=71.32 //y2=3.895
r752 (  79 80 ) resistor r=0.10734 //w=0.281 //l=0.16 //layer=m2 \
 //thickness=0.36 //x=71.16 //y=3.895 //x2=71 //y2=3.895
r753 (  77 80 ) resistor r=4.28435 //w=0.131 //l=4.49 //layer=m2 \
 //thickness=0.36 //x=66.51 //y=3.88 //x2=71 //y2=3.88
r754 (  75 77 ) resistor r=0.10734 //w=0.281 //l=0.16 //layer=m2 \
 //thickness=0.36 //x=66.35 //y=3.895 //x2=66.51 //y2=3.895
r755 (  73 83 ) resistor r=1.10266 //w=0.196 //l=1.725 //layer=m2 \
 //thickness=0.36 //x=78.425 //y=3.895 //x2=76.7 //y2=3.895
r756 (  72 85 ) resistor r=4.81638 //w=0.177 //l=6.825 //layer=m2 \
 //thickness=0.36 //x=78.77 //y=3.895 //x2=85.59 //y2=3.885
r757 (  72 73 ) resistor r=0.329198 //w=0.131 //l=0.345 //layer=m2 \
 //thickness=0.36 //x=78.77 //y=3.895 //x2=78.425 //y2=3.895
r758 (  70 83 ) resistor r=0.104578 //w=0.196 //l=0.167332 //layer=m2 \
 //thickness=0.36 //x=76.54 //y=3.88 //x2=76.7 //y2=3.895
r759 (  70 81 ) resistor r=4.98092 //w=0.131 //l=5.22 //layer=m2 \
 //thickness=0.36 //x=76.54 //y=3.88 //x2=71.32 //y2=3.88
r760 (  67 157 ) resistor r=9.3 //w=0.17 //l=0.17 //layer=mcon //count=1 \
 //x=85.59 //y=4.88 //x2=85.59 //y2=4.88
r761 (  65 148 ) resistor r=9.3 //w=0.17 //l=0.17 //layer=mcon //count=1 \
 //x=85.59 //y=2.26 //x2=85.59 //y2=2.26
r762 (  63 85 ) resistor r=4.5 //w=0.15 //l=0.15 //layer=via1 //count=1 \
 //x=85.59 //y=3.885 //x2=85.59 //y2=3.885
r763 (  61 63 ) resistor r=0.00166223 //w=0.376 //l=0.005 //layer=m1 \
 //thickness=0.36 //x=85.537 //y=3.88 //x2=85.537 //y2=3.885
r764 (  59 83 ) resistor r=4.5 //w=0.15 //l=0.15 //layer=via1 //count=1 \
 //x=76.7 //y=3.895 //x2=76.7 //y2=3.895
r765 (  57 59 ) resistor r=0.00490838 //w=0.382 //l=0.015 //layer=m1 \
 //thickness=0.36 //x=76.757 //y=3.88 //x2=76.757 //y2=3.895
r766 (  55 251 ) resistor r=9.3 //w=0.17 //l=0.17 //layer=mcon //count=1 \
 //x=76.225 //y=1.19 //x2=76.225 //y2=1.19
r767 (  53 131 ) resistor r=9.3 //w=0.17 //l=0.17 //layer=mcon //count=1 \
 //x=75.93 //y=5.56 //x2=75.93 //y2=5.56
r768 (  50 123 ) resistor r=9.3 //w=0.17 //l=0.17 //layer=mcon //count=1 \
 //x=75.05 //y=5.56 //x2=75.05 //y2=5.56
r769 (  48 50 ) resistor r=0.121228 //w=0.232 //l=0.225 //layer=m1 \
 //thickness=0.36 //x=75.05 //y=5.335 //x2=75.05 //y2=5.56
r770 (  47 115 ) resistor r=9.3 //w=0.17 //l=0.17 //layer=mcon //count=1 \
 //x=74.17 //y=5.56 //x2=74.17 //y2=5.56
r771 (  45 47 ) resistor r=0.129608 //w=0.217 //l=0.225 //layer=m1 \
 //thickness=0.36 //x=74.172 //y=5.335 //x2=74.172 //y2=5.56
r772 (  44 110 ) resistor r=9.3 //w=0.17 //l=0.17 //layer=mcon //count=1 \
 //x=71.16 //y=4.88 //x2=71.16 //y2=4.88
r773 (  42 101 ) resistor r=9.3 //w=0.17 //l=0.17 //layer=mcon //count=1 \
 //x=71.16 //y=2.26 //x2=71.16 //y2=2.26
r774 (  40 79 ) resistor r=4.5 //w=0.15 //l=0.15 //layer=via1 //count=1 \
 //x=71.16 //y=3.895 //x2=71.16 //y2=3.895
r775 (  38 40 ) resistor r=0.0049867 //w=0.376 //l=0.015 //layer=m1 \
 //thickness=0.36 //x=71.107 //y=3.88 //x2=71.107 //y2=3.895
r776 (  36 75 ) resistor r=4.5 //w=0.15 //l=0.15 //layer=via1 //count=1 \
 //x=66.35 //y=3.895 //x2=66.35 //y2=3.895
r777 (  34 36 ) resistor r=0.0049867 //w=0.376 //l=0.015 //layer=m1 \
 //thickness=0.36 //x=66.402 //y=3.88 //x2=66.402 //y2=3.895
r778 (  32 96 ) resistor r=9.3 //w=0.17 //l=0.17 //layer=mcon //count=1 \
 //x=66.35 //y=4.88 //x2=66.35 //y2=4.88
r779 (  30 87 ) resistor r=9.3 //w=0.17 //l=0.17 //layer=mcon //count=1 \
 //x=66.35 //y=2.26 //x2=66.35 //y2=2.26
r780 (  28 67 ) resistor r=0.0801089 //w=0.224 //l=0.13 //layer=m1 \
 //thickness=0.36 //x=85.59 //y=4.75 //x2=85.59 //y2=4.88
r781 (  27 63 ) resistor r=0.0911593 //w=0.376 //l=0.184608 //layer=m1 \
 //thickness=0.36 //x=85.59 //y=4.045 //x2=85.537 //y2=3.885
r782 (  27 28 ) resistor r=0.67271 //w=0.131 //l=0.705 //layer=m1 \
 //thickness=0.36 //x=85.59 //y=4.045 //x2=85.59 //y2=4.75
r783 (  26 61 ) resistor r=0.0894971 //w=0.376 //l=0.179555 //layer=m1 \
 //thickness=0.36 //x=85.59 //y=3.725 //x2=85.537 //y2=3.88
r784 (  25 65 ) resistor r=0.0719237 //w=0.222 //l=0.115 //layer=m1 \
 //thickness=0.36 //x=85.59 //y=2.375 //x2=85.59 //y2=2.26
r785 (  25 26 ) resistor r=1.28817 //w=0.131 //l=1.35 //layer=m1 \
 //thickness=0.36 //x=85.59 //y=2.375 //x2=85.59 //y2=3.725
r786 (  23 59 ) resistor r=0.0914072 //w=0.382 //l=0.181989 //layer=m1 \
 //thickness=0.36 //x=76.71 //y=4.055 //x2=76.757 //y2=3.895
r787 (  23 24 ) resistor r=1.14027 //w=0.131 //l=1.195 //layer=m1 \
 //thickness=0.36 //x=76.71 //y=4.055 //x2=76.71 //y2=5.25
r788 (  22 57 ) resistor r=0.0864989 //w=0.382 //l=0.166853 //layer=m1 \
 //thickness=0.36 //x=76.71 //y=3.735 //x2=76.757 //y2=3.88
r789 (  21 22 ) resistor r=1.72233 //w=0.131 //l=1.805 //layer=m1 \
 //thickness=0.36 //x=76.71 //y=1.93 //x2=76.71 //y2=3.735
r790 (  19 21 ) resistor r=0.0698411 //w=0.17 //l=0.120208 //layer=m1 \
 //thickness=0.36 //x=76.625 //y=1.845 //x2=76.71 //y2=1.93
r791 (  19 20 ) resistor r=0.300573 //w=0.131 //l=0.315 //layer=m1 \
 //thickness=0.36 //x=76.625 //y=1.845 //x2=76.31 //y2=1.845
r792 (  18 20 ) resistor r=0.0698411 //w=0.17 //l=0.120208 //layer=m1 \
 //thickness=0.36 //x=76.225 //y=1.76 //x2=76.31 //y2=1.845
r793 (  17 55 ) resistor r=0.0717383 //w=0.224 //l=0.115 //layer=m1 \
 //thickness=0.36 //x=76.225 //y=1.305 //x2=76.225 //y2=1.19
r794 (  17 18 ) resistor r=0.43416 //w=0.131 //l=0.455 //layer=m1 \
 //thickness=0.36 //x=76.225 //y=1.305 //x2=76.225 //y2=1.76
r795 (  16 51 ) resistor r=0.0675342 //w=0.23 //l=0.115 //layer=m1 \
 //thickness=0.36 //x=76.045 //y=5.335 //x2=75.93 //y2=5.335
r796 (  15 24 ) resistor r=0.0698411 //w=0.17 //l=0.120208 //layer=m1 \
 //thickness=0.36 //x=76.625 //y=5.335 //x2=76.71 //y2=5.25
r797 (  15 16 ) resistor r=0.553435 //w=0.131 //l=0.58 //layer=m1 \
 //thickness=0.36 //x=76.625 //y=5.335 //x2=76.045 //y2=5.335
r798 (  14 53 ) resistor r=0.00118313 //w=0.23 //layer=m1 //thickness=0.36 \
 //x=75.93 //y=5.56 //x2=75.93 //y2=5.56
r799 (  13 51 ) resistor r=0.002872 //w=0.34 //l=0.085 //layer=m1 \
 //thickness=0.36 //x=75.93 //y=5.42 //x2=75.93 //y2=5.335
r800 (  13 14 ) resistor r=0.091623 //w=0.191 //l=0.14 //layer=m1 \
 //thickness=0.36 //x=75.93 //y=5.42 //x2=75.93 //y2=5.56
r801 (  12 48 ) resistor r=0.0262263 //w=0.232 //l=0.12 //layer=m1 \
 //thickness=0.36 //x=75.17 //y=5.335 //x2=75.05 //y2=5.335
r802 (  11 51 ) resistor r=0.0675342 //w=0.23 //l=0.115 //layer=m1 \
 //thickness=0.36 //x=75.815 //y=5.335 //x2=75.93 //y2=5.335
r803 (  11 12 ) resistor r=0.615458 //w=0.131 //l=0.645 //layer=m1 \
 //thickness=0.36 //x=75.815 //y=5.335 //x2=75.17 //y2=5.335
r804 (  10 45 ) resistor r=0.0222262 //w=0.217 //l=0.118 //layer=m1 \
 //thickness=0.36 //x=74.29 //y=5.335 //x2=74.172 //y2=5.335
r805 (  9 48 ) resistor r=0.0262263 //w=0.232 //l=0.12 //layer=m1 \
 //thickness=0.36 //x=74.93 //y=5.335 //x2=75.05 //y2=5.335
r806 (  9 10 ) resistor r=0.610687 //w=0.131 //l=0.64 //layer=m1 \
 //thickness=0.36 //x=74.93 //y=5.335 //x2=74.29 //y2=5.335
r807 (  8 44 ) resistor r=0.0801089 //w=0.224 //l=0.13 //layer=m1 \
 //thickness=0.36 //x=71.16 //y=4.75 //x2=71.16 //y2=4.88
r808 (  7 40 ) resistor r=0.0911593 //w=0.376 //l=0.184608 //layer=m1 \
 //thickness=0.36 //x=71.16 //y=4.055 //x2=71.107 //y2=3.895
r809 (  7 8 ) resistor r=0.663168 //w=0.131 //l=0.695 //layer=m1 \
 //thickness=0.36 //x=71.16 //y=4.055 //x2=71.16 //y2=4.75
r810 (  6 38 ) resistor r=0.0861726 //w=0.376 //l=0.16944 //layer=m1 \
 //thickness=0.36 //x=71.16 //y=3.735 //x2=71.107 //y2=3.88
r811 (  5 42 ) resistor r=0.0719237 //w=0.222 //l=0.115 //layer=m1 \
 //thickness=0.36 //x=71.16 //y=2.375 //x2=71.16 //y2=2.26
r812 (  5 6 ) resistor r=1.29771 //w=0.131 //l=1.36 //layer=m1 \
 //thickness=0.36 //x=71.16 //y=2.375 //x2=71.16 //y2=3.735
r813 (  4 32 ) resistor r=0.0801089 //w=0.224 //l=0.13 //layer=m1 \
 //thickness=0.36 //x=66.35 //y=4.75 //x2=66.35 //y2=4.88
r814 (  3 36 ) resistor r=0.0911593 //w=0.376 //l=0.184174 //layer=m1 \
 //thickness=0.36 //x=66.35 //y=4.055 //x2=66.402 //y2=3.895
r815 (  3 4 ) resistor r=0.663168 //w=0.131 //l=0.695 //layer=m1 \
 //thickness=0.36 //x=66.35 //y=4.055 //x2=66.35 //y2=4.75
r816 (  2 34 ) resistor r=0.0861726 //w=0.376 //l=0.169012 //layer=m1 \
 //thickness=0.36 //x=66.35 //y=3.735 //x2=66.402 //y2=3.88
r817 (  1 30 ) resistor r=0.0719237 //w=0.222 //l=0.115 //layer=m1 \
 //thickness=0.36 //x=66.35 //y=2.375 //x2=66.35 //y2=2.26
r818 (  1 2 ) resistor r=1.29771 //w=0.131 //l=1.36 //layer=m1 \
 //thickness=0.36 //x=66.35 //y=2.375 //x2=66.35 //y2=3.735
ends PM_TMRDFFSNRNQX1\%noxref_20

subckt PM_TMRDFFSNRNQX1\%noxref_21 ( 1 2 3 4 8 11 53 59 61 62 65 70 76 81 86 \
 87 88 89 90 91 92 93 94 95 99 101 104 105 106 107 111 112 113 114 118 120 126 \
 127 129 142 )
c496 ( 142 0 ) capacitor c=0.0692896f //x=91.51 //y=4.885
c497 ( 129 0 ) capacitor c=0.0603371f //x=87.81 //y=2.26
c498 ( 127 0 ) capacitor c=0.0344584f //x=91.845 //y=1.39
c499 ( 126 0 ) capacitor c=0.0186809f //x=91.845 //y=1.045
c500 ( 120 0 ) capacitor c=0.0141797f //x=91.69 //y=1.545
c501 ( 118 0 ) capacitor c=0.0158553f //x=91.69 //y=0.89
c502 ( 114 0 ) capacitor c=0.104052f //x=91.315 //y=2.095
c503 ( 113 0 ) capacitor c=0.0227139f //x=91.315 //y=1.7
c504 ( 112 0 ) capacitor c=0.0234352f //x=91.315 //y=1.39
c505 ( 111 0 ) capacitor c=0.0198759f //x=91.315 //y=1.045
c506 ( 107 0 ) capacitor c=0.0318956f //x=88.515 //y=1.39
c507 ( 106 0 ) capacitor c=0.0186809f //x=88.515 //y=1.045
c508 ( 105 0 ) capacitor c=0.0624333f //x=88.155 //y=4.975
c509 ( 104 0 ) capacitor c=0.0375163f //x=88.445 //y=4.975
c510 ( 101 0 ) capacitor c=0.0157936f //x=88.36 //y=1.545
c511 ( 99 0 ) capacitor c=0.0158553f //x=88.36 //y=0.89
c512 ( 95 0 ) capacitor c=0.0302441f //x=87.985 //y=2.095
c513 ( 94 0 ) capacitor c=0.0238107f //x=87.985 //y=1.7
c514 ( 93 0 ) capacitor c=0.0234359f //x=87.985 //y=1.39
c515 ( 92 0 ) capacitor c=0.0199332f //x=87.985 //y=1.045
c516 ( 91 0 ) capacitor c=0.111167f //x=91.84 //y=6.205
c517 ( 90 0 ) capacitor c=0.154978f //x=91.4 //y=6.205
c518 ( 89 0 ) capacitor c=0.110282f //x=88.52 //y=6.205
c519 ( 88 0 ) capacitor c=0.155219f //x=88.08 //y=6.205
c520 ( 81 0 ) capacitor c=0.0156727f //x=91.51 //y=4.62
c521 ( 76 0 ) capacitor c=0.00126053f //x=91.51 //y=2.26
c522 ( 70 0 ) capacitor c=0.0130807f //x=87.81 //y=4.62
c523 ( 65 0 ) capacitor c=9.6092e-19 //x=87.81 //y=2.26
c524 ( 62 0 ) capacitor c=0.0683501f //x=91.355 //y=4.64
c525 ( 61 0 ) capacitor c=0.00642399f //x=91.515 //y=4.64
c526 ( 59 0 ) capacitor c=1.42014f //x=87.815 //y=4.62
c527 ( 53 0 ) capacitor c=0.00568391f //x=87.975 //y=4.62
c528 ( 11 0 ) capacitor c=0.0127993f //x=91.51 //y=4.62
c529 ( 8 0 ) capacitor c=0.0137635f //x=87.81 //y=4.62
c530 ( 4 0 ) capacitor c=0.0838237f //x=91.51 //y=4.475
c531 ( 3 0 ) capacitor c=0.00607262f //x=91.51 //y=2.385
c532 ( 2 0 ) capacitor c=0.0636214f //x=87.81 //y=4.46
c533 ( 1 0 ) capacitor c=0.00385206f //x=87.81 //y=2.375
r534 (  140 142 ) resistor r=22.7554 //w=0.233 //l=0.11 //layer=ply \
 //thickness=0.18 //x=91.4 //y=4.885 //x2=91.51 //y2=4.885
r535 (  127 144 ) resistor r=45.1352 //w=0.168 //l=0.173853 //layer=ply \
 //thickness=0.18 //x=91.845 //y=1.39 //x2=91.805 //y2=1.545
r536 (  126 143 ) resistor r=45.1352 //w=0.168 //l=0.173853 //layer=ply \
 //thickness=0.18 //x=91.845 //y=1.045 //x2=91.805 //y2=0.89
r537 (  126 127 ) resistor r=176.904 //w=0.094 //l=0.345 //layer=ply \
 //thickness=0.18 //x=91.845 //y=1.045 //x2=91.845 //y2=1.39
r538 (  123 142 ) resistor r=68.2661 //w=0.233 //l=0.404166 //layer=ply \
 //thickness=0.18 //x=91.84 //y=5.05 //x2=91.51 //y2=4.885
r539 (  121 139 ) resistor r=10.701 //w=0.21 //l=0.115 //layer=ply \
 //thickness=0.18 //x=91.47 //y=1.545 //x2=91.355 //y2=1.545
r540 (  120 144 ) resistor r=5.52526 //w=0.168 //l=0.115 //layer=ply \
 //thickness=0.18 //x=91.69 //y=1.545 //x2=91.805 //y2=1.545
r541 (  119 138 ) resistor r=5.52526 //w=0.168 //l=0.115 //layer=ply \
 //thickness=0.18 //x=91.47 //y=0.89 //x2=91.355 //y2=0.89
r542 (  118 143 ) resistor r=5.52526 //w=0.168 //l=0.115 //layer=ply \
 //thickness=0.18 //x=91.69 //y=0.89 //x2=91.805 //y2=0.89
r543 (  118 119 ) resistor r=112.809 //w=0.094 //l=0.22 //layer=ply \
 //thickness=0.18 //x=91.69 //y=0.89 //x2=91.47 //y2=0.89
r544 (  115 140 ) resistor r=13.0941 //w=0.233 //l=0.165 //layer=ply \
 //thickness=0.18 //x=91.4 //y=5.05 //x2=91.4 //y2=4.885
r545 (  114 137 ) resistor r=34.8111 //w=0.27 //l=0.264953 //layer=ply \
 //thickness=0.18 //x=91.315 //y=2.095 //x2=91.51 //y2=2.26
r546 (  113 139 ) resistor r=39.5823 //w=0.21 //l=0.173853 //layer=ply \
 //thickness=0.18 //x=91.315 //y=1.7 //x2=91.355 //y2=1.545
r547 (  113 114 ) resistor r=202.543 //w=0.094 //l=0.395 //layer=ply \
 //thickness=0.18 //x=91.315 //y=1.7 //x2=91.315 //y2=2.095
r548 (  112 139 ) resistor r=39.5823 //w=0.21 //l=0.173853 //layer=ply \
 //thickness=0.18 //x=91.315 //y=1.39 //x2=91.355 //y2=1.545
r549 (  111 138 ) resistor r=45.1352 //w=0.168 //l=0.173853 //layer=ply \
 //thickness=0.18 //x=91.315 //y=1.045 //x2=91.355 //y2=0.89
r550 (  111 112 ) resistor r=176.904 //w=0.094 //l=0.345 //layer=ply \
 //thickness=0.18 //x=91.315 //y=1.045 //x2=91.315 //y2=1.39
r551 (  107 135 ) resistor r=45.1352 //w=0.168 //l=0.173853 //layer=ply \
 //thickness=0.18 //x=88.515 //y=1.39 //x2=88.475 //y2=1.545
r552 (  106 134 ) resistor r=45.1352 //w=0.168 //l=0.173853 //layer=ply \
 //thickness=0.18 //x=88.515 //y=1.045 //x2=88.475 //y2=0.89
r553 (  106 107 ) resistor r=176.904 //w=0.094 //l=0.345 //layer=ply \
 //thickness=0.18 //x=88.515 //y=1.045 //x2=88.515 //y2=1.39
r554 (  104 108 ) resistor r=26.9307 //w=0.15 //l=0.106066 //layer=ply \
 //thickness=0.18 //x=88.445 //y=4.975 //x2=88.52 //y2=5.05
r555 (  104 105 ) resistor r=148.702 //w=0.094 //l=0.29 //layer=ply \
 //thickness=0.18 //x=88.445 //y=4.975 //x2=88.155 //y2=4.975
r556 (  102 133 ) resistor r=10.701 //w=0.21 //l=0.115 //layer=ply \
 //thickness=0.18 //x=88.14 //y=1.545 //x2=88.025 //y2=1.545
r557 (  101 135 ) resistor r=5.52526 //w=0.168 //l=0.115 //layer=ply \
 //thickness=0.18 //x=88.36 //y=1.545 //x2=88.475 //y2=1.545
r558 (  100 132 ) resistor r=5.52526 //w=0.168 //l=0.115 //layer=ply \
 //thickness=0.18 //x=88.14 //y=0.89 //x2=88.025 //y2=0.89
r559 (  99 134 ) resistor r=5.52526 //w=0.168 //l=0.115 //layer=ply \
 //thickness=0.18 //x=88.36 //y=0.89 //x2=88.475 //y2=0.89
r560 (  99 100 ) resistor r=112.809 //w=0.094 //l=0.22 //layer=ply \
 //thickness=0.18 //x=88.36 //y=0.89 //x2=88.14 //y2=0.89
r561 (  96 105 ) resistor r=22.1787 //w=0.252 //l=0.106066 //layer=ply \
 //thickness=0.18 //x=88.08 //y=5.05 //x2=88.155 //y2=4.975
r562 (  96 131 ) resistor r=51.6429 //w=0.252 //l=0.34271 //layer=ply \
 //thickness=0.18 //x=88.08 //y=5.05 //x2=87.81 //y2=4.885
r563 (  95 129 ) resistor r=30.4513 //w=0.277 //l=0.243926 //layer=ply \
 //thickness=0.18 //x=87.985 //y=2.095 //x2=87.81 //y2=2.26
r564 (  94 133 ) resistor r=39.5823 //w=0.21 //l=0.173853 //layer=ply \
 //thickness=0.18 //x=87.985 //y=1.7 //x2=88.025 //y2=1.545
r565 (  94 95 ) resistor r=202.543 //w=0.094 //l=0.395 //layer=ply \
 //thickness=0.18 //x=87.985 //y=1.7 //x2=87.985 //y2=2.095
r566 (  93 133 ) resistor r=39.5823 //w=0.21 //l=0.173853 //layer=ply \
 //thickness=0.18 //x=87.985 //y=1.39 //x2=88.025 //y2=1.545
r567 (  92 132 ) resistor r=45.1352 //w=0.168 //l=0.173853 //layer=ply \
 //thickness=0.18 //x=87.985 //y=1.045 //x2=88.025 //y2=0.89
r568 (  92 93 ) resistor r=176.904 //w=0.094 //l=0.345 //layer=ply \
 //thickness=0.18 //x=87.985 //y=1.045 //x2=87.985 //y2=1.39
r569 (  91 123 ) resistor r=592.245 //w=0.094 //l=1.155 //layer=ply \
 //thickness=0.18 //x=91.84 //y=6.205 //x2=91.84 //y2=5.05
r570 (  90 115 ) resistor r=592.245 //w=0.094 //l=1.155 //layer=ply \
 //thickness=0.18 //x=91.4 //y=6.205 //x2=91.4 //y2=5.05
r571 (  89 108 ) resistor r=592.245 //w=0.094 //l=1.155 //layer=ply \
 //thickness=0.18 //x=88.52 //y=6.205 //x2=88.52 //y2=5.05
r572 (  88 96 ) resistor r=592.245 //w=0.094 //l=1.155 //layer=ply \
 //thickness=0.18 //x=88.08 //y=6.205 //x2=88.08 //y2=5.05
r573 (  87 120 ) resistor r=56.4043 //w=0.094 //l=0.11 //layer=ply \
 //thickness=0.18 //x=91.58 //y=1.545 //x2=91.69 //y2=1.545
r574 (  87 121 ) resistor r=56.4043 //w=0.094 //l=0.11 //layer=ply \
 //thickness=0.18 //x=91.58 //y=1.545 //x2=91.47 //y2=1.545
r575 (  86 101 ) resistor r=56.4043 //w=0.094 //l=0.11 //layer=ply \
 //thickness=0.18 //x=88.25 //y=1.545 //x2=88.36 //y2=1.545
r576 (  86 102 ) resistor r=56.4043 //w=0.094 //l=0.11 //layer=ply \
 //thickness=0.18 //x=88.25 //y=1.545 //x2=88.14 //y2=1.545
r577 (  84 142 ) resistor r=152 //w=0.17 //l=0.17 //layer=licon //count=1 \
 //x=91.51 //y=4.885 //x2=91.51 //y2=4.885
r578 (  81 84 ) resistor r=18.139 //w=0.187 //l=0.265 //layer=li \
 //thickness=0.1 //x=91.51 //y=4.62 //x2=91.51 //y2=4.885
r579 (  76 137 ) resistor r=152 //w=0.17 //l=0.17 //layer=licon //count=1 \
 //x=91.51 //y=2.26 //x2=91.51 //y2=2.26
r580 (  73 131 ) resistor r=152 //w=0.17 //l=0.17 //layer=licon //count=1 \
 //x=87.81 //y=4.885 //x2=87.81 //y2=4.885
r581 (  70 73 ) resistor r=18.139 //w=0.187 //l=0.265 //layer=li \
 //thickness=0.1 //x=87.81 //y=4.62 //x2=87.81 //y2=4.885
r582 (  65 129 ) resistor r=152 //w=0.17 //l=0.17 //layer=licon //count=1 \
 //x=87.81 //y=2.26 //x2=87.81 //y2=2.26
r583 (  61 62 ) resistor r=0.10734 //w=0.281 //l=0.16 //layer=m2 \
 //thickness=0.36 //x=91.515 //y=4.64 //x2=91.355 //y2=4.64
r584 (  53 59 ) resistor r=0.10734 //w=0.281 //l=0.16 //layer=m2 \
 //thickness=0.36 //x=87.975 //y=4.62 //x2=87.815 //y2=4.62
r585 (  53 62 ) resistor r=3.22519 //w=0.131 //l=3.38 //layer=m2 \
 //thickness=0.36 //x=87.975 //y=4.62 //x2=91.355 //y2=4.62
r586 (  15 76 ) resistor r=9.3 //w=0.17 //l=0.17 //layer=mcon //count=1 \
 //x=91.51 //y=2.26 //x2=91.51 //y2=2.26
r587 (  13 61 ) resistor r=4.5 //w=0.15 //l=0.15 //layer=via1 //count=1 \
 //x=91.515 //y=4.64 //x2=91.515 //y2=4.64
r588 (  11 81 ) resistor r=9.3 //w=0.17 //l=0.17 //layer=mcon //count=1 \
 //x=91.51 //y=4.62 //x2=91.51 //y2=4.62
r589 (  11 13 ) resistor r=0.00659631 //w=0.379 //l=0.02 //layer=m1 \
 //thickness=0.36 //x=91.46 //y=4.62 //x2=91.46 //y2=4.64
r590 (  8 70 ) resistor r=9.3 //w=0.17 //l=0.17 //layer=mcon //count=1 \
 //x=87.81 //y=4.62 //x2=87.81 //y2=4.62
r591 (  8 59 ) resistor r=4.5 //w=0.15 //l=0.15 //layer=via1 //count=1 \
 //x=87.815 //y=4.62 //x2=87.815 //y2=4.62
r592 (  6 65 ) resistor r=9.3 //w=0.17 //l=0.17 //layer=mcon //count=1 \
 //x=87.81 //y=2.26 //x2=87.81 //y2=2.26
r593 (  4 11 ) resistor r=0.0863342 //w=0.379 //l=0.168152 //layer=m1 \
 //thickness=0.36 //x=91.51 //y=4.475 //x2=91.46 //y2=4.62
r594 (  3 15 ) resistor r=0.0761125 //w=0.237 //l=0.126491 //layer=m1 \
 //thickness=0.36 //x=91.51 //y=2.385 //x2=91.507 //y2=2.26
r595 (  3 4 ) resistor r=1.99427 //w=0.131 //l=2.09 //layer=m1 \
 //thickness=0.36 //x=91.51 //y=2.385 //x2=91.51 //y2=4.475
r596 (  2 8 ) resistor r=0.0898201 //w=0.322 //l=0.185472 //layer=m1 \
 //thickness=0.36 //x=87.81 //y=4.46 //x2=87.865 //y2=4.62
r597 (  1 6 ) resistor r=0.0717383 //w=0.224 //l=0.115 //layer=m1 \
 //thickness=0.36 //x=87.81 //y=2.375 //x2=87.81 //y2=2.26
r598 (  1 2 ) resistor r=1.9895 //w=0.131 //l=2.085 //layer=m1 \
 //thickness=0.36 //x=87.81 //y=2.375 //x2=87.81 //y2=4.46
ends PM_TMRDFFSNRNQX1\%noxref_21

subckt PM_TMRDFFSNRNQX1\%noxref_22 ( 1 2 3 5 8 9 11 12 13 14 16 17 18 19 20 21 \
 22 29 32 35 41 56 58 60 62 64 65 67 69 78 79 82 87 92 100 108 125 130 135 140 \
 144 145 146 147 148 149 150 151 152 156 157 158 163 165 168 169 173 174 175 \
 176 177 179 182 185 186 187 188 189 190 191 192 196 198 201 202 203 204 209 \
 210 215 227 234 236 237 238 )
c597 ( 234 0 ) capacitor c=0.00885916f //x=85.655 //y=1.095
c598 ( 227 0 ) capacitor c=0.0586737f //x=94.47 //y=2.26
c599 ( 215 0 ) capacitor c=0.0710579f //x=80.78 //y=4.88
c600 ( 210 0 ) capacitor c=0.0278202f //x=80.78 //y=2.095
c601 ( 209 0 ) capacitor c=0.0493352f //x=80.78 //y=2.26
c602 ( 204 0 ) capacitor c=0.0318956f //x=95.175 //y=1.39
c603 ( 203 0 ) capacitor c=0.0186809f //x=95.175 //y=1.045
c604 ( 202 0 ) capacitor c=0.0659968f //x=94.815 //y=4.975
c605 ( 201 0 ) capacitor c=0.0373387f //x=95.105 //y=4.975
c606 ( 198 0 ) capacitor c=0.0157936f //x=95.02 //y=1.545
c607 ( 196 0 ) capacitor c=0.0158553f //x=95.02 //y=0.89
c608 ( 192 0 ) capacitor c=0.0302441f //x=94.645 //y=2.095
c609 ( 191 0 ) capacitor c=0.0238107f //x=94.645 //y=1.7
c610 ( 190 0 ) capacitor c=0.0234359f //x=94.645 //y=1.39
c611 ( 189 0 ) capacitor c=0.0199332f //x=94.645 //y=1.045
c612 ( 188 0 ) capacitor c=0.0972519f //x=92.815 //y=2.095
c613 ( 187 0 ) capacitor c=0.0251353f //x=92.815 //y=1.74
c614 ( 186 0 ) capacitor c=0.0234318f //x=92.815 //y=1.43
c615 ( 185 0 ) capacitor c=0.019155f //x=92.815 //y=1.085
c616 ( 182 0 ) capacitor c=0.0714656f //x=92.72 //y=5.05
c617 ( 179 0 ) capacitor c=0.0186579f //x=92.66 //y=1.585
c618 ( 177 0 ) capacitor c=0.0157803f //x=92.66 //y=0.93
c619 ( 176 0 ) capacitor c=0.0134011f //x=92.355 //y=4.975
c620 ( 175 0 ) capacitor c=0.0243282f //x=92.645 //y=4.975
c621 ( 174 0 ) capacitor c=0.0364928f //x=92.285 //y=1.43
c622 ( 173 0 ) capacitor c=0.0174823f //x=92.285 //y=1.085
c623 ( 169 0 ) capacitor c=0.0443175f //x=81.3 //y=1.44
c624 ( 168 0 ) capacitor c=0.0199703f //x=81.3 //y=1.095
c625 ( 165 0 ) capacitor c=0.0159602f //x=81.145 //y=1.595
c626 ( 163 0 ) capacitor c=0.0157807f //x=81.145 //y=0.94
c627 ( 158 0 ) capacitor c=0.0220935f //x=80.77 //y=1.75
c628 ( 157 0 ) capacitor c=0.0207489f //x=80.77 //y=1.44
c629 ( 156 0 ) capacitor c=0.0194091f //x=80.77 //y=1.095
c630 ( 152 0 ) capacitor c=0.11081f //x=95.18 //y=6.205
c631 ( 151 0 ) capacitor c=0.154997f //x=94.74 //y=6.205
c632 ( 150 0 ) capacitor c=0.155934f //x=92.72 //y=6.205
c633 ( 149 0 ) capacitor c=0.110594f //x=92.28 //y=6.205
c634 ( 148 0 ) capacitor c=0.159671f //x=80.96 //y=6.2
c635 ( 147 0 ) capacitor c=0.110208f //x=80.52 //y=6.2
c636 ( 140 0 ) capacitor c=7.7962e-19 //x=94.47 //y=4.885
c637 ( 135 0 ) capacitor c=7.43216e-19 //x=94.47 //y=2.26
c638 ( 130 0 ) capacitor c=7.79163e-19 //x=92.99 //y=4.885
c639 ( 125 0 ) capacitor c=7.43216e-19 //x=92.99 //y=2.26
c640 ( 108 0 ) capacitor c=0.0292914f //x=85.55 //y=5.56
c641 ( 100 0 ) capacitor c=0.0292489f //x=84.67 //y=5.56
c642 ( 92 0 ) capacitor c=0.0278099f //x=83.79 //y=5.56
c643 ( 87 0 ) capacitor c=7.7417e-19 //x=80.78 //y=4.88
c644 ( 82 0 ) capacitor c=0.00101179f //x=80.78 //y=2.26
c645 ( 79 0 ) capacitor c=0.0208859f //x=94.305 //y=2.27
c646 ( 78 0 ) capacitor c=0.00246433f //x=94.465 //y=2.27
c647 ( 69 0 ) capacitor c=0.00668954f //x=80.77 //y=2.325
c648 ( 67 0 ) capacitor c=0.00638151f //x=93.155 //y=2.26
c649 ( 65 0 ) capacitor c=0.075492f //x=86.485 //y=2.4
c650 ( 64 0 ) capacitor c=0.168148f //x=92.825 //y=2.4
c651 ( 62 0 ) capacitor c=0.00882412f //x=83.58 //y=2.37
c652 ( 60 0 ) capacitor c=0.0265244f //x=82.98 //y=2.4
c653 ( 58 0 ) capacitor c=0.014689f //x=81.735 //y=2.37
c654 ( 56 0 ) capacitor c=0.00958882f //x=81.135 //y=2.4
c655 ( 41 0 ) capacitor c=0.0141963f //x=86.33 //y=2.4
c656 ( 35 0 ) capacitor c=8.84507e-19 //x=85.55 //y=5.335
c657 ( 32 0 ) capacitor c=0.00788343f //x=84.67 //y=5.335
c658 ( 29 0 ) capacitor c=0.0111234f //x=83.792 //y=5.335
c659 ( 22 0 ) capacitor c=0.0783117f //x=94.47 //y=4.755
c660 ( 21 0 ) capacitor c=0.00995077f //x=94.47 //y=2.43
c661 ( 20 0 ) capacitor c=0.0863594f //x=92.99 //y=4.76
c662 ( 19 0 ) capacitor c=0.0102822f //x=92.99 //y=2.43
c663 ( 18 0 ) capacitor c=0.0754415f //x=86.33 //y=5.25
c664 ( 17 0 ) capacitor c=0.0118637f //x=86.33 //y=2.565
c665 ( 16 0 ) capacitor c=0.0098449f //x=86.33 //y=2.245
c666 ( 14 0 ) capacitor c=0.00493487f //x=85.93 //y=1.845
c667 ( 13 0 ) capacitor c=0.0127191f //x=86.245 //y=1.845
c668 ( 12 0 ) capacitor c=0.0150416f //x=85.845 //y=1.76
c669 ( 11 0 ) capacitor c=0.0113205f //x=85.845 //y=1.305
c670 ( 9 0 ) capacitor c=0.0237317f //x=86.245 //y=5.335
c671 ( 8 0 ) capacitor c=0.00906283f //x=85.55 //y=5.56
c672 ( 5 0 ) capacitor c=0.0180822f //x=85.435 //y=5.335
c673 ( 3 0 ) capacitor c=0.0146396f //x=84.55 //y=5.335
c674 ( 2 0 ) capacitor c=0.0615417f //x=80.78 //y=4.75
c675 ( 1 0 ) capacitor c=0.011862f //x=80.78 //y=2.485
r676 (  209 210 ) resistor r=52.7279 //w=0.214 //l=0.165 //layer=ply \
 //thickness=0.18 //x=80.78 //y=2.26 //x2=80.78 //y2=2.095
r677 (  204 233 ) resistor r=45.1352 //w=0.168 //l=0.173853 //layer=ply \
 //thickness=0.18 //x=95.175 //y=1.39 //x2=95.135 //y2=1.545
r678 (  203 232 ) resistor r=45.1352 //w=0.168 //l=0.173853 //layer=ply \
 //thickness=0.18 //x=95.175 //y=1.045 //x2=95.135 //y2=0.89
r679 (  203 204 ) resistor r=176.904 //w=0.094 //l=0.345 //layer=ply \
 //thickness=0.18 //x=95.175 //y=1.045 //x2=95.175 //y2=1.39
r680 (  201 205 ) resistor r=26.9307 //w=0.15 //l=0.106066 //layer=ply \
 //thickness=0.18 //x=95.105 //y=4.975 //x2=95.18 //y2=5.05
r681 (  201 202 ) resistor r=148.702 //w=0.094 //l=0.29 //layer=ply \
 //thickness=0.18 //x=95.105 //y=4.975 //x2=94.815 //y2=4.975
r682 (  199 231 ) resistor r=10.701 //w=0.21 //l=0.115 //layer=ply \
 //thickness=0.18 //x=94.8 //y=1.545 //x2=94.685 //y2=1.545
r683 (  198 233 ) resistor r=5.52526 //w=0.168 //l=0.115 //layer=ply \
 //thickness=0.18 //x=95.02 //y=1.545 //x2=95.135 //y2=1.545
r684 (  197 230 ) resistor r=5.52526 //w=0.168 //l=0.115 //layer=ply \
 //thickness=0.18 //x=94.8 //y=0.89 //x2=94.685 //y2=0.89
r685 (  196 232 ) resistor r=5.52526 //w=0.168 //l=0.115 //layer=ply \
 //thickness=0.18 //x=95.02 //y=0.89 //x2=95.135 //y2=0.89
r686 (  196 197 ) resistor r=112.809 //w=0.094 //l=0.22 //layer=ply \
 //thickness=0.18 //x=95.02 //y=0.89 //x2=94.8 //y2=0.89
r687 (  193 202 ) resistor r=22.1787 //w=0.252 //l=0.106066 //layer=ply \
 //thickness=0.18 //x=94.74 //y=5.05 //x2=94.815 //y2=4.975
r688 (  193 229 ) resistor r=51.6429 //w=0.252 //l=0.34271 //layer=ply \
 //thickness=0.18 //x=94.74 //y=5.05 //x2=94.47 //y2=4.885
r689 (  192 227 ) resistor r=30.4513 //w=0.277 //l=0.243926 //layer=ply \
 //thickness=0.18 //x=94.645 //y=2.095 //x2=94.47 //y2=2.26
r690 (  191 231 ) resistor r=39.5823 //w=0.21 //l=0.173853 //layer=ply \
 //thickness=0.18 //x=94.645 //y=1.7 //x2=94.685 //y2=1.545
r691 (  191 192 ) resistor r=202.543 //w=0.094 //l=0.395 //layer=ply \
 //thickness=0.18 //x=94.645 //y=1.7 //x2=94.645 //y2=2.095
r692 (  190 231 ) resistor r=39.5823 //w=0.21 //l=0.173853 //layer=ply \
 //thickness=0.18 //x=94.645 //y=1.39 //x2=94.685 //y2=1.545
r693 (  189 230 ) resistor r=45.1352 //w=0.168 //l=0.173853 //layer=ply \
 //thickness=0.18 //x=94.645 //y=1.045 //x2=94.685 //y2=0.89
r694 (  189 190 ) resistor r=176.904 //w=0.094 //l=0.345 //layer=ply \
 //thickness=0.18 //x=94.645 //y=1.045 //x2=94.645 //y2=1.39
r695 (  188 223 ) resistor r=30.4513 //w=0.277 //l=0.243926 //layer=ply \
 //thickness=0.18 //x=92.815 //y=2.095 //x2=92.99 //y2=2.26
r696 (  187 221 ) resistor r=39.5823 //w=0.21 //l=0.173853 //layer=ply \
 //thickness=0.18 //x=92.815 //y=1.74 //x2=92.775 //y2=1.585
r697 (  187 188 ) resistor r=182.032 //w=0.094 //l=0.355 //layer=ply \
 //thickness=0.18 //x=92.815 //y=1.74 //x2=92.815 //y2=2.095
r698 (  186 221 ) resistor r=39.5823 //w=0.21 //l=0.173853 //layer=ply \
 //thickness=0.18 //x=92.815 //y=1.43 //x2=92.775 //y2=1.585
r699 (  185 220 ) resistor r=45.1352 //w=0.168 //l=0.173853 //layer=ply \
 //thickness=0.18 //x=92.815 //y=1.085 //x2=92.775 //y2=0.93
r700 (  185 186 ) resistor r=176.904 //w=0.094 //l=0.345 //layer=ply \
 //thickness=0.18 //x=92.815 //y=1.085 //x2=92.815 //y2=1.43
r701 (  182 225 ) resistor r=51.6429 //w=0.252 //l=0.34271 //layer=ply \
 //thickness=0.18 //x=92.72 //y=5.05 //x2=92.99 //y2=4.885
r702 (  180 219 ) resistor r=5.52526 //w=0.168 //l=0.115 //layer=ply \
 //thickness=0.18 //x=92.44 //y=1.585 //x2=92.325 //y2=1.585
r703 (  179 221 ) resistor r=10.701 //w=0.21 //l=0.115 //layer=ply \
 //thickness=0.18 //x=92.66 //y=1.585 //x2=92.775 //y2=1.585
r704 (  178 218 ) resistor r=5.52526 //w=0.168 //l=0.115 //layer=ply \
 //thickness=0.18 //x=92.44 //y=0.93 //x2=92.325 //y2=0.93
r705 (  177 220 ) resistor r=5.52526 //w=0.168 //l=0.115 //layer=ply \
 //thickness=0.18 //x=92.66 //y=0.93 //x2=92.775 //y2=0.93
r706 (  177 178 ) resistor r=112.809 //w=0.094 //l=0.22 //layer=ply \
 //thickness=0.18 //x=92.66 //y=0.93 //x2=92.44 //y2=0.93
r707 (  175 182 ) resistor r=22.1787 //w=0.252 //l=0.106066 //layer=ply \
 //thickness=0.18 //x=92.645 //y=4.975 //x2=92.72 //y2=5.05
r708 (  175 176 ) resistor r=148.702 //w=0.094 //l=0.29 //layer=ply \
 //thickness=0.18 //x=92.645 //y=4.975 //x2=92.355 //y2=4.975
r709 (  174 219 ) resistor r=45.1352 //w=0.168 //l=0.173853 //layer=ply \
 //thickness=0.18 //x=92.285 //y=1.43 //x2=92.325 //y2=1.585
r710 (  173 218 ) resistor r=45.1352 //w=0.168 //l=0.173853 //layer=ply \
 //thickness=0.18 //x=92.285 //y=1.085 //x2=92.325 //y2=0.93
r711 (  173 174 ) resistor r=176.904 //w=0.094 //l=0.345 //layer=ply \
 //thickness=0.18 //x=92.285 //y=1.085 //x2=92.285 //y2=1.43
r712 (  170 176 ) resistor r=26.9307 //w=0.15 //l=0.106066 //layer=ply \
 //thickness=0.18 //x=92.28 //y=5.05 //x2=92.355 //y2=4.975
r713 (  169 217 ) resistor r=45.1352 //w=0.168 //l=0.173853 //layer=ply \
 //thickness=0.18 //x=81.3 //y=1.44 //x2=81.26 //y2=1.595
r714 (  168 216 ) resistor r=45.1352 //w=0.168 //l=0.173853 //layer=ply \
 //thickness=0.18 //x=81.3 //y=1.095 //x2=81.26 //y2=0.94
r715 (  168 169 ) resistor r=176.904 //w=0.094 //l=0.345 //layer=ply \
 //thickness=0.18 //x=81.3 //y=1.095 //x2=81.3 //y2=1.44
r716 (  166 213 ) resistor r=10.701 //w=0.21 //l=0.115 //layer=ply \
 //thickness=0.18 //x=80.925 //y=1.595 //x2=80.81 //y2=1.595
r717 (  165 217 ) resistor r=5.52526 //w=0.168 //l=0.115 //layer=ply \
 //thickness=0.18 //x=81.145 //y=1.595 //x2=81.26 //y2=1.595
r718 (  164 212 ) resistor r=5.52526 //w=0.168 //l=0.115 //layer=ply \
 //thickness=0.18 //x=80.925 //y=0.94 //x2=80.81 //y2=0.94
r719 (  163 216 ) resistor r=5.52526 //w=0.168 //l=0.115 //layer=ply \
 //thickness=0.18 //x=81.145 //y=0.94 //x2=81.26 //y2=0.94
r720 (  163 164 ) resistor r=112.809 //w=0.094 //l=0.22 //layer=ply \
 //thickness=0.18 //x=81.145 //y=0.94 //x2=80.925 //y2=0.94
r721 (  160 215 ) resistor r=37.236 //w=0.233 //l=0.249199 //layer=ply \
 //thickness=0.18 //x=80.96 //y=5.045 //x2=80.78 //y2=4.88
r722 (  158 213 ) resistor r=39.5823 //w=0.21 //l=0.173853 //layer=ply \
 //thickness=0.18 //x=80.77 //y=1.75 //x2=80.81 //y2=1.595
r723 (  158 210 ) resistor r=176.904 //w=0.094 //l=0.345 //layer=ply \
 //thickness=0.18 //x=80.77 //y=1.75 //x2=80.77 //y2=2.095
r724 (  157 213 ) resistor r=39.5823 //w=0.21 //l=0.173853 //layer=ply \
 //thickness=0.18 //x=80.77 //y=1.44 //x2=80.81 //y2=1.595
r725 (  156 212 ) resistor r=45.1352 //w=0.168 //l=0.173853 //layer=ply \
 //thickness=0.18 //x=80.77 //y=1.095 //x2=80.81 //y2=0.94
r726 (  156 157 ) resistor r=176.904 //w=0.094 //l=0.345 //layer=ply \
 //thickness=0.18 //x=80.77 //y=1.095 //x2=80.77 //y2=1.44
r727 (  153 215 ) resistor r=53.7854 //w=0.233 //l=0.332415 //layer=ply \
 //thickness=0.18 //x=80.52 //y=5.045 //x2=80.78 //y2=4.88
r728 (  152 205 ) resistor r=592.245 //w=0.094 //l=1.155 //layer=ply \
 //thickness=0.18 //x=95.18 //y=6.205 //x2=95.18 //y2=5.05
r729 (  151 193 ) resistor r=592.245 //w=0.094 //l=1.155 //layer=ply \
 //thickness=0.18 //x=94.74 //y=6.205 //x2=94.74 //y2=5.05
r730 (  150 182 ) resistor r=592.245 //w=0.094 //l=1.155 //layer=ply \
 //thickness=0.18 //x=92.72 //y=6.205 //x2=92.72 //y2=5.05
r731 (  149 170 ) resistor r=592.245 //w=0.094 //l=1.155 //layer=ply \
 //thickness=0.18 //x=92.28 //y=6.205 //x2=92.28 //y2=5.05
r732 (  148 160 ) resistor r=592.245 //w=0.094 //l=1.155 //layer=ply \
 //thickness=0.18 //x=80.96 //y=6.2 //x2=80.96 //y2=5.045
r733 (  147 153 ) resistor r=592.245 //w=0.094 //l=1.155 //layer=ply \
 //thickness=0.18 //x=80.52 //y=6.2 //x2=80.52 //y2=5.045
r734 (  146 198 ) resistor r=56.4043 //w=0.094 //l=0.11 //layer=ply \
 //thickness=0.18 //x=94.91 //y=1.545 //x2=95.02 //y2=1.545
r735 (  146 199 ) resistor r=56.4043 //w=0.094 //l=0.11 //layer=ply \
 //thickness=0.18 //x=94.91 //y=1.545 //x2=94.8 //y2=1.545
r736 (  145 179 ) resistor r=56.4043 //w=0.094 //l=0.11 //layer=ply \
 //thickness=0.18 //x=92.55 //y=1.585 //x2=92.66 //y2=1.585
r737 (  145 180 ) resistor r=56.4043 //w=0.094 //l=0.11 //layer=ply \
 //thickness=0.18 //x=92.55 //y=1.585 //x2=92.44 //y2=1.585
r738 (  144 165 ) resistor r=56.4043 //w=0.094 //l=0.11 //layer=ply \
 //thickness=0.18 //x=81.035 //y=1.595 //x2=81.145 //y2=1.595
r739 (  144 166 ) resistor r=56.4043 //w=0.094 //l=0.11 //layer=ply \
 //thickness=0.18 //x=81.035 //y=1.595 //x2=80.925 //y2=1.595
r740 (  140 229 ) resistor r=152 //w=0.17 //l=0.17 //layer=licon //count=1 \
 //x=94.47 //y=4.885 //x2=94.47 //y2=4.885
r741 (  135 227 ) resistor r=152 //w=0.17 //l=0.17 //layer=licon //count=1 \
 //x=94.47 //y=2.26 //x2=94.47 //y2=2.26
r742 (  130 225 ) resistor r=152 //w=0.17 //l=0.17 //layer=licon //count=1 \
 //x=92.99 //y=4.885 //x2=92.99 //y2=4.885
r743 (  125 223 ) resistor r=152 //w=0.17 //l=0.17 //layer=licon //count=1 \
 //x=92.99 //y=2.26 //x2=92.99 //y2=2.26
r744 (  108 238 ) resistor r=23.615 //w=0.187 //l=0.345 //layer=li \
 //thickness=0.1 //x=85.55 //y=5.56 //x2=85.55 //y2=5.905
r745 (  100 237 ) resistor r=23.615 //w=0.187 //l=0.345 //layer=li \
 //thickness=0.1 //x=84.67 //y=5.56 //x2=84.67 //y2=5.905
r746 (  92 236 ) resistor r=23.615 //w=0.187 //l=0.345 //layer=li \
 //thickness=0.1 //x=83.79 //y=5.56 //x2=83.79 //y2=5.905
r747 (  87 215 ) resistor r=152 //w=0.17 //l=0.17 //layer=licon //count=1 \
 //x=80.78 //y=4.88 //x2=80.78 //y2=4.88
r748 (  82 209 ) resistor r=152 //w=0.17 //l=0.17 //layer=licon //count=1 \
 //x=80.78 //y=2.26 //x2=80.78 //y2=2.26
r749 (  78 79 ) resistor r=0.10734 //w=0.281 //l=0.16 //layer=m2 \
 //thickness=0.36 //x=94.465 //y=2.27 //x2=94.305 //y2=2.27
r750 (  69 71 ) resistor r=0.033363 //w=0.281 //l=0.075 //layer=m2 \
 //thickness=0.36 //x=80.77 //y=2.325 //x2=80.77 //y2=2.4
r751 (  67 76 ) resistor r=0.0906114 //w=0.361 //l=0.177539 //layer=m2 \
 //thickness=0.36 //x=93.155 //y=2.26 //x2=92.995 //y2=2.297
r752 (  67 79 ) resistor r=1.09733 //w=0.131 //l=1.15 //layer=m2 \
 //thickness=0.36 //x=93.155 //y=2.26 //x2=94.305 //y2=2.26
r753 (  65 74 ) resistor r=0.108234 //w=0.187 //l=0.162481 //layer=m2 \
 //thickness=0.36 //x=86.485 //y=2.4 //x2=86.325 //y2=2.405
r754 (  64 76 ) resistor r=0.094074 //w=0.361 //l=0.21543 //layer=m2 \
 //thickness=0.36 //x=92.825 //y=2.4 //x2=92.995 //y2=2.297
r755 (  64 65 ) resistor r=6.04962 //w=0.131 //l=6.34 //layer=m2 \
 //thickness=0.36 //x=92.825 //y=2.4 //x2=86.485 //y2=2.4
r756 (  62 74 ) resistor r=1.83617 //w=0.187 //l=2.76244 //layer=m2 \
 //thickness=0.36 //x=83.58 //y=2.37 //x2=86.325 //y2=2.405
r757 (  62 63 ) resistor r=0.410305 //w=0.131 //l=0.43 //layer=m2 \
 //thickness=0.36 //x=83.58 //y=2.37 //x2=83.15 //y2=2.37
r758 (  60 63 ) resistor r=0.125 //w=0.17 //l=0.184391 //layer=m2 \
 //thickness=0.36 //x=82.98 //y=2.4 //x2=83.15 //y2=2.37
r759 (  60 61 ) resistor r=0.944656 //w=0.131 //l=0.99 //layer=m2 \
 //thickness=0.36 //x=82.98 //y=2.4 //x2=81.99 //y2=2.4
r760 (  58 61 ) resistor r=0.1875 //w=0.17 //l=0.269583 //layer=m2 \
 //thickness=0.36 //x=81.735 //y=2.37 //x2=81.99 //y2=2.4
r761 (  58 59 ) resistor r=0.410305 //w=0.131 //l=0.43 //layer=m2 \
 //thickness=0.36 //x=81.735 //y=2.37 //x2=81.305 //y2=2.37
r762 (  57 71 ) resistor r=0.0455071 //w=0.32 //l=0.16 //layer=m2 \
 //thickness=0.36 //x=80.93 //y=2.4 //x2=80.77 //y2=2.4
r763 (  56 59 ) resistor r=0.125 //w=0.17 //l=0.184391 //layer=m2 \
 //thickness=0.36 //x=81.135 //y=2.4 //x2=81.305 //y2=2.37
r764 (  56 57 ) resistor r=0.195611 //w=0.131 //l=0.205 //layer=m2 \
 //thickness=0.36 //x=81.135 //y=2.4 //x2=80.93 //y2=2.4
r765 (  55 140 ) resistor r=9.3 //w=0.17 //l=0.17 //layer=mcon //count=1 \
 //x=94.47 //y=4.885 //x2=94.47 //y2=4.885
r766 (  53 78 ) resistor r=4.5 //w=0.15 //l=0.15 //layer=via1 //count=1 \
 //x=94.465 //y=2.27 //x2=94.465 //y2=2.27
r767 (  51 135 ) resistor r=9.3 //w=0.17 //l=0.17 //layer=mcon //count=1 \
 //x=94.47 //y=2.26 //x2=94.47 //y2=2.26
r768 (  51 53 ) resistor r=0.00334225 //w=0.374 //l=0.01 //layer=m1 \
 //thickness=0.36 //x=94.415 //y=2.26 //x2=94.415 //y2=2.27
r769 (  49 76 ) resistor r=4.5 //w=0.15 //l=0.15 //layer=via1 //count=1 \
 //x=92.995 //y=2.27 //x2=92.995 //y2=2.27
r770 (  47 125 ) resistor r=9.3 //w=0.17 //l=0.17 //layer=mcon //count=1 \
 //x=92.99 //y=2.26 //x2=92.99 //y2=2.26
r771 (  47 49 ) resistor r=0.00334225 //w=0.374 //l=0.01 //layer=m1 \
 //thickness=0.36 //x=93.045 //y=2.26 //x2=93.045 //y2=2.27
r772 (  45 130 ) resistor r=9.3 //w=0.17 //l=0.17 //layer=mcon //count=1 \
 //x=92.99 //y=4.885 //x2=92.99 //y2=4.885
r773 (  43 74 ) resistor r=4.5 //w=0.15 //l=0.15 //layer=via1 //count=1 \
 //x=86.325 //y=2.405 //x2=86.325 //y2=2.405
r774 (  41 43 ) resistor r=0.00167112 //w=0.374 //l=0.005 //layer=m1 \
 //thickness=0.36 //x=86.275 //y=2.4 //x2=86.275 //y2=2.405
r775 (  39 234 ) resistor r=9.3 //w=0.17 //l=0.17 //layer=mcon //count=1 \
 //x=85.845 //y=1.19 //x2=85.845 //y2=1.19
r776 (  37 108 ) resistor r=9.3 //w=0.17 //l=0.17 //layer=mcon //count=1 \
 //x=85.55 //y=5.56 //x2=85.55 //y2=5.56
r777 (  34 100 ) resistor r=9.3 //w=0.17 //l=0.17 //layer=mcon //count=1 \
 //x=84.67 //y=5.56 //x2=84.67 //y2=5.56
r778 (  32 34 ) resistor r=0.121228 //w=0.232 //l=0.225 //layer=m1 \
 //thickness=0.36 //x=84.67 //y=5.335 //x2=84.67 //y2=5.56
r779 (  31 92 ) resistor r=9.3 //w=0.17 //l=0.17 //layer=mcon //count=1 \
 //x=83.79 //y=5.56 //x2=83.79 //y2=5.56
r780 (  29 31 ) resistor r=0.129608 //w=0.217 //l=0.225 //layer=m1 \
 //thickness=0.36 //x=83.792 //y=5.335 //x2=83.792 //y2=5.56
r781 (  28 69 ) resistor r=4.5 //w=0.15 //l=0.15 //layer=via1 //count=1 \
 //x=80.77 //y=2.325 //x2=80.77 //y2=2.325
r782 (  26 82 ) resistor r=9.3 //w=0.17 //l=0.17 //layer=mcon //count=1 \
 //x=80.78 //y=2.26 //x2=80.78 //y2=2.26
r783 (  26 28 ) resistor r=0.0272651 //w=0.298 //l=0.065 //layer=m1 \
 //thickness=0.36 //x=80.77 //y=2.26 //x2=80.77 //y2=2.325
r784 (  24 87 ) resistor r=9.3 //w=0.17 //l=0.17 //layer=mcon //count=1 \
 //x=80.78 //y=4.88 //x2=80.78 //y2=4.88
r785 (  22 55 ) resistor r=0.0777782 //w=0.252 //l=0.131491 //layer=m1 \
 //thickness=0.36 //x=94.47 //y=4.755 //x2=94.467 //y2=4.885
r786 (  21 53 ) resistor r=0.0910802 //w=0.374 //l=0.185472 //layer=m1 \
 //thickness=0.36 //x=94.47 //y=2.43 //x2=94.415 //y2=2.27
r787 (  21 22 ) resistor r=2.21851 //w=0.131 //l=2.325 //layer=m1 \
 //thickness=0.36 //x=94.47 //y=2.43 //x2=94.47 //y2=4.755
r788 (  20 45 ) resistor r=0.075298 //w=0.252 //l=0.125 //layer=m1 \
 //thickness=0.36 //x=92.99 //y=4.76 //x2=92.99 //y2=4.885
r789 (  19 49 ) resistor r=0.0910802 //w=0.374 //l=0.185472 //layer=m1 \
 //thickness=0.36 //x=92.99 //y=2.43 //x2=93.045 //y2=2.27
r790 (  19 20 ) resistor r=2.22328 //w=0.131 //l=2.33 //layer=m1 \
 //thickness=0.36 //x=92.99 //y=2.43 //x2=92.99 //y2=4.76
r791 (  17 43 ) resistor r=0.0910802 //w=0.374 //l=0.185472 //layer=m1 \
 //thickness=0.36 //x=86.33 //y=2.565 //x2=86.275 //y2=2.405
r792 (  17 18 ) resistor r=2.56202 //w=0.131 //l=2.685 //layer=m1 \
 //thickness=0.36 //x=86.33 //y=2.565 //x2=86.33 //y2=5.25
r793 (  16 41 ) resistor r=0.089409 //w=0.374 //l=0.180416 //layer=m1 \
 //thickness=0.36 //x=86.33 //y=2.245 //x2=86.275 //y2=2.4
r794 (  15 16 ) resistor r=0.300573 //w=0.131 //l=0.315 //layer=m1 \
 //thickness=0.36 //x=86.33 //y=1.93 //x2=86.33 //y2=2.245
r795 (  13 15 ) resistor r=0.0698411 //w=0.17 //l=0.120208 //layer=m1 \
 //thickness=0.36 //x=86.245 //y=1.845 //x2=86.33 //y2=1.93
r796 (  13 14 ) resistor r=0.300573 //w=0.131 //l=0.315 //layer=m1 \
 //thickness=0.36 //x=86.245 //y=1.845 //x2=85.93 //y2=1.845
r797 (  12 14 ) resistor r=0.0698411 //w=0.17 //l=0.120208 //layer=m1 \
 //thickness=0.36 //x=85.845 //y=1.76 //x2=85.93 //y2=1.845
r798 (  11 39 ) resistor r=0.0717383 //w=0.224 //l=0.115 //layer=m1 \
 //thickness=0.36 //x=85.845 //y=1.305 //x2=85.845 //y2=1.19
r799 (  11 12 ) resistor r=0.43416 //w=0.131 //l=0.455 //layer=m1 \
 //thickness=0.36 //x=85.845 //y=1.305 //x2=85.845 //y2=1.76
r800 (  10 35 ) resistor r=0.0675342 //w=0.23 //l=0.115 //layer=m1 \
 //thickness=0.36 //x=85.665 //y=5.335 //x2=85.55 //y2=5.335
r801 (  9 18 ) resistor r=0.0698411 //w=0.17 //l=0.120208 //layer=m1 \
 //thickness=0.36 //x=86.245 //y=5.335 //x2=86.33 //y2=5.25
r802 (  9 10 ) resistor r=0.553435 //w=0.131 //l=0.58 //layer=m1 \
 //thickness=0.36 //x=86.245 //y=5.335 //x2=85.665 //y2=5.335
r803 (  8 37 ) resistor r=0.00118313 //w=0.23 //layer=m1 //thickness=0.36 \
 //x=85.55 //y=5.56 //x2=85.55 //y2=5.56
r804 (  7 35 ) resistor r=0.002872 //w=0.34 //l=0.085 //layer=m1 \
 //thickness=0.36 //x=85.55 //y=5.42 //x2=85.55 //y2=5.335
r805 (  7 8 ) resistor r=0.091623 //w=0.191 //l=0.14 //layer=m1 \
 //thickness=0.36 //x=85.55 //y=5.42 //x2=85.55 //y2=5.56
r806 (  6 32 ) resistor r=0.0262263 //w=0.232 //l=0.12 //layer=m1 \
 //thickness=0.36 //x=84.79 //y=5.335 //x2=84.67 //y2=5.335
r807 (  5 35 ) resistor r=0.0675342 //w=0.23 //l=0.115 //layer=m1 \
 //thickness=0.36 //x=85.435 //y=5.335 //x2=85.55 //y2=5.335
r808 (  5 6 ) resistor r=0.615458 //w=0.131 //l=0.645 //layer=m1 \
 //thickness=0.36 //x=85.435 //y=5.335 //x2=84.79 //y2=5.335
r809 (  4 29 ) resistor r=0.0222262 //w=0.217 //l=0.118 //layer=m1 \
 //thickness=0.36 //x=83.91 //y=5.335 //x2=83.792 //y2=5.335
r810 (  3 32 ) resistor r=0.0262263 //w=0.232 //l=0.12 //layer=m1 \
 //thickness=0.36 //x=84.55 //y=5.335 //x2=84.67 //y2=5.335
r811 (  3 4 ) resistor r=0.610687 //w=0.131 //l=0.64 //layer=m1 \
 //thickness=0.36 //x=84.55 //y=5.335 //x2=83.91 //y2=5.335
r812 (  2 24 ) resistor r=0.0801089 //w=0.224 //l=0.13 //layer=m1 \
 //thickness=0.36 //x=80.78 //y=4.75 //x2=80.78 //y2=4.88
r813 (  1 28 ) resistor r=0.089984 //w=0.298 //l=0.164924 //layer=m1 \
 //thickness=0.36 //x=80.78 //y=2.485 //x2=80.77 //y2=2.325
r814 (  1 2 ) resistor r=2.16126 //w=0.131 //l=2.265 //layer=m1 \
 //thickness=0.36 //x=80.78 //y=2.485 //x2=80.78 //y2=4.75
ends PM_TMRDFFSNRNQX1\%noxref_22

subckt PM_TMRDFFSNRNQX1\%noxref_23 ( 1 2 3 4 5 7 10 11 13 14 15 16 18 19 20 21 \
 22 23 24 25 26 27 28 36 37 40 43 49 59 63 68 69 70 72 74 76 77 78 80 82 85 86 \
 87 88 90 92 94 96 98 100 102 105 115 116 119 128 133 141 149 166 175 180 189 \
 193 194 195 196 197 198 199 200 201 205 206 207 212 214 217 218 219 220 221 \
 226 228 230 236 237 238 239 240 245 247 249 255 256 258 259 264 268 269 272 \
 280 281 284 292 294 295 296 )
c737 ( 292 0 ) capacitor c=0.00885916f //x=56.795 //y=1.095
c738 ( 284 0 ) capacitor c=0.0370698f //x=95.6 //y=4.885
c739 ( 281 0 ) capacitor c=0.028421f //x=95.58 //y=2.095
c740 ( 280 0 ) capacitor c=0.0512002f //x=95.58 //y=2.26
c741 ( 272 0 ) capacitor c=0.0387879f //x=88.96 //y=4.885
c742 ( 269 0 ) capacitor c=0.0300885f //x=88.92 //y=2.095
c743 ( 268 0 ) capacitor c=0.0554483f //x=88.92 //y=2.26
c744 ( 264 0 ) capacitor c=0.0710579f //x=51.92 //y=4.88
c745 ( 259 0 ) capacitor c=0.0278202f //x=51.92 //y=2.095
c746 ( 258 0 ) capacitor c=0.0479397f //x=51.92 //y=2.26
c747 ( 256 0 ) capacitor c=0.0237734f //x=96.145 //y=1.435
c748 ( 255 0 ) capacitor c=0.0191782f //x=96.145 //y=1.085
c749 ( 249 0 ) capacitor c=0.0361171f //x=95.99 //y=1.585
c750 ( 247 0 ) capacitor c=0.0157803f //x=95.99 //y=0.93
c751 ( 245 0 ) capacitor c=0.0377178f //x=95.985 //y=4.975
c752 ( 240 0 ) capacitor c=0.020493f //x=95.615 //y=1.74
c753 ( 239 0 ) capacitor c=0.0167049f //x=95.615 //y=1.435
c754 ( 238 0 ) capacitor c=0.0174993f //x=95.615 //y=1.085
c755 ( 237 0 ) capacitor c=0.0443648f //x=89.485 //y=1.43
c756 ( 236 0 ) capacitor c=0.0192211f //x=89.485 //y=1.085
c757 ( 230 0 ) capacitor c=0.0186579f //x=89.33 //y=1.585
c758 ( 228 0 ) capacitor c=0.0157795f //x=89.33 //y=0.93
c759 ( 226 0 ) capacitor c=0.0351351f //x=89.325 //y=4.975
c760 ( 221 0 ) capacitor c=0.0209124f //x=88.955 //y=1.74
c761 ( 220 0 ) capacitor c=0.016848f //x=88.955 //y=1.43
c762 ( 219 0 ) capacitor c=0.0174777f //x=88.955 //y=1.085
c763 ( 218 0 ) capacitor c=0.0443175f //x=52.44 //y=1.44
c764 ( 217 0 ) capacitor c=0.0199703f //x=52.44 //y=1.095
c765 ( 214 0 ) capacitor c=0.0162526f //x=52.285 //y=1.595
c766 ( 212 0 ) capacitor c=0.0157807f //x=52.285 //y=0.94
c767 ( 207 0 ) capacitor c=0.0220935f //x=51.91 //y=1.75
c768 ( 206 0 ) capacitor c=0.0207489f //x=51.91 //y=1.44
c769 ( 205 0 ) capacitor c=0.0194091f //x=51.91 //y=1.095
c770 ( 201 0 ) capacitor c=0.155887f //x=96.06 //y=6.205
c771 ( 200 0 ) capacitor c=0.1106f //x=95.62 //y=6.205
c772 ( 199 0 ) capacitor c=0.154859f //x=89.4 //y=6.205
c773 ( 198 0 ) capacitor c=0.110573f //x=88.96 //y=6.205
c774 ( 197 0 ) capacitor c=0.159671f //x=52.1 //y=6.2
c775 ( 196 0 ) capacitor c=0.110208f //x=51.66 //y=6.2
c776 ( 189 0 ) capacitor c=8.10734e-19 //x=95.6 //y=4.885
c777 ( 180 0 ) capacitor c=0.00105273f //x=95.58 //y=2.26
c778 ( 175 0 ) capacitor c=0.00173056f //x=88.96 //y=4.885
c779 ( 166 0 ) capacitor c=0.00152737f //x=88.92 //y=2.26
c780 ( 149 0 ) capacitor c=0.0293719f //x=56.69 //y=5.56
c781 ( 141 0 ) capacitor c=0.0292879f //x=55.81 //y=5.56
c782 ( 133 0 ) capacitor c=0.0278099f //x=54.93 //y=5.56
c783 ( 128 0 ) capacitor c=9.5006e-19 //x=51.92 //y=4.88
c784 ( 119 0 ) capacitor c=0.00101179f //x=51.92 //y=2.26
c785 ( 116 0 ) capacitor c=0.162165f //x=95.435 //y=4.21
c786 ( 115 0 ) capacitor c=0.00479868f //x=95.595 //y=4.21
c787 ( 105 0 ) capacitor c=0.0165817f //x=89.08 //y=4.252
c788 ( 102 0 ) capacitor c=0.00498823f //x=88.03 //y=4.235
c789 ( 100 0 ) capacitor c=0.0296711f //x=87.43 //y=4.25
c790 ( 98 0 ) capacitor c=0.0049231f //x=85.805 //y=4.27
c791 ( 96 0 ) capacitor c=0.0827755f //x=85.205 //y=4.25
c792 ( 94 0 ) capacitor c=0.00430603f //x=76.915 //y=4.28
c793 ( 92 0 ) capacitor c=0.0493847f //x=76.315 //y=4.25
c794 ( 90 0 ) capacitor c=0.00404489f //x=71.375 //y=4.31
c795 ( 88 0 ) capacitor c=0.0450008f //x=66.565 //y=4.28
c796 ( 87 0 ) capacitor c=0.00292689f //x=65.695 //y=4.25
c797 ( 86 0 ) capacitor c=0.00782061f //x=65.965 //y=4.25
c798 ( 85 0 ) capacitor c=0.00460873f //x=65.61 //y=4.165
c799 ( 82 0 ) capacitor c=0.0514445f //x=61.765 //y=3.9
c800 ( 80 0 ) capacitor c=0.0218422f //x=61.165 //y=3.88
c801 ( 78 0 ) capacitor c=0.007152f //x=59.535 //y=3.865
c802 ( 77 0 ) capacitor c=0.0073781f //x=57.63 //y=3.88
c803 ( 76 0 ) capacitor c=0.0250417f //x=58.935 //y=3.88
c804 ( 74 0 ) capacitor c=0.00222613f //x=56.945 //y=3.5
c805 ( 72 0 ) capacitor c=0.00520791f //x=56.345 //y=3.51
c806 ( 70 0 ) capacitor c=0.0031901f //x=55.835 //y=3.53
c807 ( 69 0 ) capacitor c=3.99286e-19 //x=52.08 //y=3.51
c808 ( 68 0 ) capacitor c=0.0358962f //x=55.235 //y=3.51
c809 ( 63 0 ) capacitor c=0.0138506f //x=95.58 //y=4.25
c810 ( 59 0 ) capacitor c=0.0153807f //x=88.92 //y=4.25
c811 ( 49 0 ) capacitor c=0.0158263f //x=57.47 //y=3.51
c812 ( 43 0 ) capacitor c=8.42472e-19 //x=56.69 //y=5.335
c813 ( 40 0 ) capacitor c=0.00753514f //x=55.81 //y=5.335
c814 ( 37 0 ) capacitor c=0.0109203f //x=54.932 //y=5.335
c815 ( 36 0 ) capacitor c=0.0166445f //x=51.92 //y=3.51
c816 ( 28 0 ) capacitor c=0.0124358f //x=95.58 //y=4.74
c817 ( 27 0 ) capacitor c=0.0108569f //x=95.58 //y=4.37
c818 ( 26 0 ) capacitor c=0.0498276f //x=95.58 //y=4.05
c819 ( 25 0 ) capacitor c=0.00651439f //x=95.58 //y=2.38
c820 ( 24 0 ) capacitor c=0.0169891f //x=88.92 //y=4.71
c821 ( 23 0 ) capacitor c=0.0132636f //x=88.92 //y=4.365
c822 ( 22 0 ) capacitor c=0.0659761f //x=88.92 //y=4.045
c823 ( 21 0 ) capacitor c=0.00716889f //x=88.92 //y=2.375
c824 ( 20 0 ) capacitor c=0.0403689f //x=57.47 //y=5.25
c825 ( 19 0 ) capacitor c=0.0135238f //x=57.47 //y=3.685
c826 ( 18 0 ) capacitor c=0.0389407f //x=57.47 //y=3.365
c827 ( 16 0 ) capacitor c=0.00493487f //x=57.07 //y=1.845
c828 ( 15 0 ) capacitor c=0.013289f //x=57.385 //y=1.845
c829 ( 14 0 ) capacitor c=0.0167992f //x=56.985 //y=1.76
c830 ( 13 0 ) capacitor c=0.0112869f //x=56.985 //y=1.305
c831 ( 11 0 ) capacitor c=0.0213474f //x=57.385 //y=5.335
c832 ( 10 0 ) capacitor c=0.00933983f //x=56.69 //y=5.56
c833 ( 7 0 ) capacitor c=0.0177111f //x=56.575 //y=5.335
c834 ( 5 0 ) capacitor c=0.0143796f //x=55.69 //y=5.335
c835 ( 4 0 ) capacitor c=0.0292201f //x=51.92 //y=4.75
c836 ( 3 0 ) capacitor c=0.0121604f //x=51.92 //y=3.655
c837 ( 2 0 ) capacitor c=0.0218282f //x=51.92 //y=3.365
c838 ( 1 0 ) capacitor c=0.00554887f //x=51.92 //y=2.375
r839 (  286 287 ) resistor r=32.4568 //w=0.214 //l=0.075 //layer=ply \
 //thickness=0.18 //x=95.6 //y=4.975 //x2=95.6 //y2=5.05
r840 (  284 286 ) resistor r=20.271 //w=0.214 //l=0.09 //layer=ply \
 //thickness=0.18 //x=95.6 //y=4.885 //x2=95.6 //y2=4.975
r841 (  280 281 ) resistor r=52.7279 //w=0.214 //l=0.165 //layer=ply \
 //thickness=0.18 //x=95.58 //y=2.26 //x2=95.58 //y2=2.095
r842 (  272 274 ) resistor r=20.271 //w=0.214 //l=0.09 //layer=ply \
 //thickness=0.18 //x=88.96 //y=4.885 //x2=88.96 //y2=4.975
r843 (  268 269 ) resistor r=52.7279 //w=0.214 //l=0.165 //layer=ply \
 //thickness=0.18 //x=88.92 //y=2.26 //x2=88.92 //y2=2.095
r844 (  258 259 ) resistor r=52.7279 //w=0.214 //l=0.165 //layer=ply \
 //thickness=0.18 //x=51.92 //y=2.26 //x2=51.92 //y2=2.095
r845 (  256 291 ) resistor r=4.95774 //w=0.164 //l=0.112 //layer=ply \
 //thickness=0.18 //x=96.145 //y=1.435 //x2=96.145 //y2=1.547
r846 (  255 290 ) resistor r=45.1352 //w=0.168 //l=0.173853 //layer=ply \
 //thickness=0.18 //x=96.145 //y=1.085 //x2=96.105 //y2=0.93
r847 (  255 256 ) resistor r=179.468 //w=0.094 //l=0.35 //layer=ply \
 //thickness=0.18 //x=96.145 //y=1.085 //x2=96.145 //y2=1.435
r848 (  250 289 ) resistor r=10.8103 //w=0.211 //l=0.115 //layer=ply \
 //thickness=0.18 //x=95.77 //y=1.585 //x2=95.655 //y2=1.585
r849 (  249 291 ) resistor r=45.9962 //w=0.164 //l=0.17296 //layer=ply \
 //thickness=0.18 //x=95.99 //y=1.585 //x2=96.145 //y2=1.547
r850 (  248 288 ) resistor r=5.52526 //w=0.168 //l=0.115 //layer=ply \
 //thickness=0.18 //x=95.77 //y=0.93 //x2=95.655 //y2=0.93
r851 (  247 290 ) resistor r=5.52526 //w=0.168 //l=0.115 //layer=ply \
 //thickness=0.18 //x=95.99 //y=0.93 //x2=96.105 //y2=0.93
r852 (  247 248 ) resistor r=112.809 //w=0.094 //l=0.22 //layer=ply \
 //thickness=0.18 //x=95.99 //y=0.93 //x2=95.77 //y2=0.93
r853 (  246 286 ) resistor r=16.5046 //w=0.27 //l=0.135 //layer=ply \
 //thickness=0.18 //x=95.735 //y=4.975 //x2=95.6 //y2=4.975
r854 (  245 252 ) resistor r=26.9307 //w=0.15 //l=0.106066 //layer=ply \
 //thickness=0.18 //x=95.985 //y=4.975 //x2=96.06 //y2=5.05
r855 (  245 246 ) resistor r=128.191 //w=0.094 //l=0.25 //layer=ply \
 //thickness=0.18 //x=95.985 //y=4.975 //x2=95.735 //y2=4.975
r856 (  240 289 ) resistor r=39.5036 //w=0.211 //l=0.173853 //layer=ply \
 //thickness=0.18 //x=95.615 //y=1.74 //x2=95.655 //y2=1.585
r857 (  240 281 ) resistor r=182.032 //w=0.094 //l=0.355 //layer=ply \
 //thickness=0.18 //x=95.615 //y=1.74 //x2=95.615 //y2=2.095
r858 (  239 289 ) resistor r=38.3614 //w=0.211 //l=0.168819 //layer=ply \
 //thickness=0.18 //x=95.615 //y=1.435 //x2=95.655 //y2=1.585
r859 (  238 288 ) resistor r=45.1352 //w=0.168 //l=0.173853 //layer=ply \
 //thickness=0.18 //x=95.615 //y=1.085 //x2=95.655 //y2=0.93
r860 (  238 239 ) resistor r=179.468 //w=0.094 //l=0.35 //layer=ply \
 //thickness=0.18 //x=95.615 //y=1.085 //x2=95.615 //y2=1.435
r861 (  237 278 ) resistor r=45.1352 //w=0.168 //l=0.173853 //layer=ply \
 //thickness=0.18 //x=89.485 //y=1.43 //x2=89.445 //y2=1.585
r862 (  236 277 ) resistor r=45.1352 //w=0.168 //l=0.173853 //layer=ply \
 //thickness=0.18 //x=89.485 //y=1.085 //x2=89.445 //y2=0.93
r863 (  236 237 ) resistor r=176.904 //w=0.094 //l=0.345 //layer=ply \
 //thickness=0.18 //x=89.485 //y=1.085 //x2=89.485 //y2=1.43
r864 (  231 276 ) resistor r=10.701 //w=0.21 //l=0.115 //layer=ply \
 //thickness=0.18 //x=89.11 //y=1.585 //x2=88.995 //y2=1.585
r865 (  230 278 ) resistor r=5.52526 //w=0.168 //l=0.115 //layer=ply \
 //thickness=0.18 //x=89.33 //y=1.585 //x2=89.445 //y2=1.585
r866 (  229 275 ) resistor r=5.52526 //w=0.168 //l=0.115 //layer=ply \
 //thickness=0.18 //x=89.11 //y=0.93 //x2=88.995 //y2=0.93
r867 (  228 277 ) resistor r=5.52526 //w=0.168 //l=0.115 //layer=ply \
 //thickness=0.18 //x=89.33 //y=0.93 //x2=89.445 //y2=0.93
r868 (  228 229 ) resistor r=112.809 //w=0.094 //l=0.22 //layer=ply \
 //thickness=0.18 //x=89.33 //y=0.93 //x2=89.11 //y2=0.93
r869 (  227 274 ) resistor r=16.5046 //w=0.27 //l=0.135 //layer=ply \
 //thickness=0.18 //x=89.095 //y=4.975 //x2=88.96 //y2=4.975
r870 (  226 233 ) resistor r=26.9307 //w=0.15 //l=0.106066 //layer=ply \
 //thickness=0.18 //x=89.325 //y=4.975 //x2=89.4 //y2=5.05
r871 (  226 227 ) resistor r=117.936 //w=0.094 //l=0.23 //layer=ply \
 //thickness=0.18 //x=89.325 //y=4.975 //x2=89.095 //y2=4.975
r872 (  223 274 ) resistor r=32.4568 //w=0.214 //l=0.075 //layer=ply \
 //thickness=0.18 //x=88.96 //y=5.05 //x2=88.96 //y2=4.975
r873 (  221 276 ) resistor r=39.5823 //w=0.21 //l=0.173853 //layer=ply \
 //thickness=0.18 //x=88.955 //y=1.74 //x2=88.995 //y2=1.585
r874 (  221 269 ) resistor r=182.032 //w=0.094 //l=0.355 //layer=ply \
 //thickness=0.18 //x=88.955 //y=1.74 //x2=88.955 //y2=2.095
r875 (  220 276 ) resistor r=39.5823 //w=0.21 //l=0.173853 //layer=ply \
 //thickness=0.18 //x=88.955 //y=1.43 //x2=88.995 //y2=1.585
r876 (  219 275 ) resistor r=45.1352 //w=0.168 //l=0.173853 //layer=ply \
 //thickness=0.18 //x=88.955 //y=1.085 //x2=88.995 //y2=0.93
r877 (  219 220 ) resistor r=176.904 //w=0.094 //l=0.345 //layer=ply \
 //thickness=0.18 //x=88.955 //y=1.085 //x2=88.955 //y2=1.43
r878 (  218 266 ) resistor r=45.1352 //w=0.168 //l=0.173853 //layer=ply \
 //thickness=0.18 //x=52.44 //y=1.44 //x2=52.4 //y2=1.595
r879 (  217 265 ) resistor r=45.1352 //w=0.168 //l=0.173853 //layer=ply \
 //thickness=0.18 //x=52.44 //y=1.095 //x2=52.4 //y2=0.94
r880 (  217 218 ) resistor r=176.904 //w=0.094 //l=0.345 //layer=ply \
 //thickness=0.18 //x=52.44 //y=1.095 //x2=52.44 //y2=1.44
r881 (  215 262 ) resistor r=10.701 //w=0.21 //l=0.115 //layer=ply \
 //thickness=0.18 //x=52.065 //y=1.595 //x2=51.95 //y2=1.595
r882 (  214 266 ) resistor r=5.52526 //w=0.168 //l=0.115 //layer=ply \
 //thickness=0.18 //x=52.285 //y=1.595 //x2=52.4 //y2=1.595
r883 (  213 261 ) resistor r=5.52526 //w=0.168 //l=0.115 //layer=ply \
 //thickness=0.18 //x=52.065 //y=0.94 //x2=51.95 //y2=0.94
r884 (  212 265 ) resistor r=5.52526 //w=0.168 //l=0.115 //layer=ply \
 //thickness=0.18 //x=52.285 //y=0.94 //x2=52.4 //y2=0.94
r885 (  212 213 ) resistor r=112.809 //w=0.094 //l=0.22 //layer=ply \
 //thickness=0.18 //x=52.285 //y=0.94 //x2=52.065 //y2=0.94
r886 (  209 264 ) resistor r=37.236 //w=0.233 //l=0.249199 //layer=ply \
 //thickness=0.18 //x=52.1 //y=5.045 //x2=51.92 //y2=4.88
r887 (  207 262 ) resistor r=39.5823 //w=0.21 //l=0.173853 //layer=ply \
 //thickness=0.18 //x=51.91 //y=1.75 //x2=51.95 //y2=1.595
r888 (  207 259 ) resistor r=176.904 //w=0.094 //l=0.345 //layer=ply \
 //thickness=0.18 //x=51.91 //y=1.75 //x2=51.91 //y2=2.095
r889 (  206 262 ) resistor r=39.5823 //w=0.21 //l=0.173853 //layer=ply \
 //thickness=0.18 //x=51.91 //y=1.44 //x2=51.95 //y2=1.595
r890 (  205 261 ) resistor r=45.1352 //w=0.168 //l=0.173853 //layer=ply \
 //thickness=0.18 //x=51.91 //y=1.095 //x2=51.95 //y2=0.94
r891 (  205 206 ) resistor r=176.904 //w=0.094 //l=0.345 //layer=ply \
 //thickness=0.18 //x=51.91 //y=1.095 //x2=51.91 //y2=1.44
r892 (  202 264 ) resistor r=53.7854 //w=0.233 //l=0.332415 //layer=ply \
 //thickness=0.18 //x=51.66 //y=5.045 //x2=51.92 //y2=4.88
r893 (  201 252 ) resistor r=592.245 //w=0.094 //l=1.155 //layer=ply \
 //thickness=0.18 //x=96.06 //y=6.205 //x2=96.06 //y2=5.05
r894 (  200 287 ) resistor r=592.245 //w=0.094 //l=1.155 //layer=ply \
 //thickness=0.18 //x=95.62 //y=6.205 //x2=95.62 //y2=5.05
r895 (  199 233 ) resistor r=592.245 //w=0.094 //l=1.155 //layer=ply \
 //thickness=0.18 //x=89.4 //y=6.205 //x2=89.4 //y2=5.05
r896 (  198 223 ) resistor r=592.245 //w=0.094 //l=1.155 //layer=ply \
 //thickness=0.18 //x=88.96 //y=6.205 //x2=88.96 //y2=5.05
r897 (  197 209 ) resistor r=592.245 //w=0.094 //l=1.155 //layer=ply \
 //thickness=0.18 //x=52.1 //y=6.2 //x2=52.1 //y2=5.045
r898 (  196 202 ) resistor r=592.245 //w=0.094 //l=1.155 //layer=ply \
 //thickness=0.18 //x=51.66 //y=6.2 //x2=51.66 //y2=5.045
r899 (  195 249 ) resistor r=56.4043 //w=0.094 //l=0.11 //layer=ply \
 //thickness=0.18 //x=95.88 //y=1.585 //x2=95.99 //y2=1.585
r900 (  195 250 ) resistor r=56.4043 //w=0.094 //l=0.11 //layer=ply \
 //thickness=0.18 //x=95.88 //y=1.585 //x2=95.77 //y2=1.585
r901 (  194 230 ) resistor r=56.4043 //w=0.094 //l=0.11 //layer=ply \
 //thickness=0.18 //x=89.22 //y=1.585 //x2=89.33 //y2=1.585
r902 (  194 231 ) resistor r=56.4043 //w=0.094 //l=0.11 //layer=ply \
 //thickness=0.18 //x=89.22 //y=1.585 //x2=89.11 //y2=1.585
r903 (  193 214 ) resistor r=56.4043 //w=0.094 //l=0.11 //layer=ply \
 //thickness=0.18 //x=52.175 //y=1.595 //x2=52.285 //y2=1.595
r904 (  193 215 ) resistor r=56.4043 //w=0.094 //l=0.11 //layer=ply \
 //thickness=0.18 //x=52.175 //y=1.595 //x2=52.065 //y2=1.595
r905 (  189 284 ) resistor r=152 //w=0.17 //l=0.17 //layer=licon //count=1 \
 //x=95.6 //y=4.885 //x2=95.6 //y2=4.885
r906 (  180 280 ) resistor r=152 //w=0.17 //l=0.17 //layer=licon //count=1 \
 //x=95.58 //y=2.26 //x2=95.58 //y2=2.26
r907 (  175 272 ) resistor r=152 //w=0.17 //l=0.17 //layer=licon //count=1 \
 //x=88.96 //y=4.885 //x2=88.96 //y2=4.885
r908 (  166 268 ) resistor r=152 //w=0.17 //l=0.17 //layer=licon //count=1 \
 //x=88.92 //y=2.26 //x2=88.92 //y2=2.26
r909 (  149 296 ) resistor r=23.615 //w=0.187 //l=0.345 //layer=li \
 //thickness=0.1 //x=56.69 //y=5.56 //x2=56.69 //y2=5.905
r910 (  141 295 ) resistor r=23.615 //w=0.187 //l=0.345 //layer=li \
 //thickness=0.1 //x=55.81 //y=5.56 //x2=55.81 //y2=5.905
r911 (  133 294 ) resistor r=23.615 //w=0.187 //l=0.345 //layer=li \
 //thickness=0.1 //x=54.93 //y=5.56 //x2=54.93 //y2=5.905
r912 (  128 264 ) resistor r=152 //w=0.17 //l=0.17 //layer=licon //count=1 \
 //x=51.92 //y=4.88 //x2=51.92 //y2=4.88
r913 (  119 258 ) resistor r=152 //w=0.17 //l=0.17 //layer=licon //count=1 \
 //x=51.92 //y=2.26 //x2=51.92 //y2=2.26
r914 (  115 116 ) resistor r=0.104807 //w=0.281 //l=0.16 //layer=m2 \
 //thickness=0.36 //x=95.595 //y=4.21 //x2=95.435 //y2=4.21
r915 (  105 113 ) resistor r=0.0974628 //w=0.216 //l=0.181989 //layer=m2 \
 //thickness=0.36 //x=89.08 //y=4.252 //x2=88.92 //y2=4.205
r916 (  105 116 ) resistor r=5.84099 //w=0.136 //l=6.355 //layer=m2 \
 //thickness=0.36 //x=89.08 //y=4.252 //x2=95.435 //y2=4.252
r917 (  102 113 ) resistor r=0.521062 //w=0.216 //l=0.904876 //layer=m2 \
 //thickness=0.36 //x=88.03 //y=4.235 //x2=88.92 //y2=4.205
r918 (  102 103 ) resistor r=0.410305 //w=0.131 //l=0.43 //layer=m2 \
 //thickness=0.36 //x=88.03 //y=4.235 //x2=87.6 //y2=4.235
r919 (  100 103 ) resistor r=0.125 //w=0.17 //l=0.177341 //layer=m2 \
 //thickness=0.36 //x=87.43 //y=4.25 //x2=87.6 //y2=4.235
r920 (  100 101 ) resistor r=1.38836 //w=0.131 //l=1.455 //layer=m2 \
 //thickness=0.36 //x=87.43 //y=4.25 //x2=85.975 //y2=4.25
r921 (  98 101 ) resistor r=0.125 //w=0.17 //l=0.179722 //layer=m2 \
 //thickness=0.36 //x=85.805 //y=4.27 //x2=85.975 //y2=4.25
r922 (  98 99 ) resistor r=0.329198 //w=0.131 //l=0.345 //layer=m2 \
 //thickness=0.36 //x=85.805 //y=4.27 //x2=85.46 //y2=4.27
r923 (  96 99 ) resistor r=0.1875 //w=0.17 //l=0.264811 //layer=m2 \
 //thickness=0.36 //x=85.205 //y=4.25 //x2=85.46 //y2=4.27
r924 (  96 97 ) resistor r=7.74809 //w=0.131 //l=8.12 //layer=m2 \
 //thickness=0.36 //x=85.205 //y=4.25 //x2=77.085 //y2=4.25
r925 (  94 97 ) resistor r=0.125 //w=0.17 //l=0.184391 //layer=m2 \
 //thickness=0.36 //x=76.915 //y=4.28 //x2=77.085 //y2=4.25
r926 (  94 95 ) resistor r=0.329198 //w=0.131 //l=0.345 //layer=m2 \
 //thickness=0.36 //x=76.915 //y=4.28 //x2=76.57 //y2=4.28
r927 (  92 95 ) resistor r=0.1875 //w=0.17 //l=0.269583 //layer=m2 \
 //thickness=0.36 //x=76.315 //y=4.25 //x2=76.57 //y2=4.28
r928 (  92 93 ) resistor r=4.49905 //w=0.131 //l=4.715 //layer=m2 \
 //thickness=0.36 //x=76.315 //y=4.25 //x2=71.6 //y2=4.25
r929 (  90 93 ) resistor r=0.14881 //w=0.189 //l=0.253229 //layer=m2 \
 //thickness=0.36 //x=71.375 //y=4.31 //x2=71.6 //y2=4.25
r930 (  90 91 ) resistor r=0.329198 //w=0.131 //l=0.345 //layer=m2 \
 //thickness=0.36 //x=71.375 //y=4.31 //x2=71.03 //y2=4.31
r931 (  88 91 ) resistor r=3.26389 //w=0.171 //l=4.47998 //layer=m2 \
 //thickness=0.36 //x=66.565 //y=4.28 //x2=71.03 //y2=4.31
r932 (  88 89 ) resistor r=0.329198 //w=0.131 //l=0.345 //layer=m2 \
 //thickness=0.36 //x=66.565 //y=4.28 //x2=66.22 //y2=4.28
r933 (  86 89 ) resistor r=0.1875 //w=0.17 //l=0.269583 //layer=m2 \
 //thickness=0.36 //x=65.965 //y=4.25 //x2=66.22 //y2=4.28
r934 (  86 87 ) resistor r=0.257634 //w=0.131 //l=0.27 //layer=m2 \
 //thickness=0.36 //x=65.965 //y=4.25 //x2=65.695 //y2=4.25
r935 (  85 87 ) resistor r=0.0698411 //w=0.17 //l=0.120208 //layer=m2 \
 //thickness=0.36 //x=65.61 //y=4.165 //x2=65.695 //y2=4.25
r936 (  84 85 ) resistor r=0.19084 //w=0.131 //l=0.2 //layer=m2 \
 //thickness=0.36 //x=65.61 //y=3.965 //x2=65.61 //y2=4.165
r937 (  82 84 ) resistor r=2.82721 //w=0.17 //l=3.85 //layer=m2 \
 //thickness=0.36 //x=61.765 //y=3.9 //x2=65.61 //y2=3.89
r938 (  82 83 ) resistor r=0.329198 //w=0.131 //l=0.345 //layer=m2 \
 //thickness=0.36 //x=61.765 //y=3.9 //x2=61.42 //y2=3.9
r939 (  80 83 ) resistor r=0.1875 //w=0.17 //l=0.264811 //layer=m2 \
 //thickness=0.36 //x=61.165 //y=3.88 //x2=61.42 //y2=3.9
r940 (  80 81 ) resistor r=1.31202 //w=0.131 //l=1.375 //layer=m2 \
 //thickness=0.36 //x=61.165 //y=3.88 //x2=59.79 //y2=3.88
r941 (  78 81 ) resistor r=0.1875 //w=0.17 //l=0.262393 //layer=m2 \
 //thickness=0.36 //x=59.535 //y=3.865 //x2=59.79 //y2=3.88
r942 (  78 79 ) resistor r=0.410305 //w=0.131 //l=0.43 //layer=m2 \
 //thickness=0.36 //x=59.535 //y=3.865 //x2=59.105 //y2=3.865
r943 (  77 110 ) resistor r=0.0900728 //w=0.341 //l=0.309839 //layer=m2 \
 //thickness=0.36 //x=57.63 //y=3.88 //x2=57.47 //y2=3.64
r944 (  76 79 ) resistor r=0.125 //w=0.17 //l=0.177341 //layer=m2 \
 //thickness=0.36 //x=58.935 //y=3.88 //x2=59.105 //y2=3.865
r945 (  76 77 ) resistor r=1.24523 //w=0.131 //l=1.305 //layer=m2 \
 //thickness=0.36 //x=58.935 //y=3.88 //x2=57.63 //y2=3.88
r946 (  74 110 ) resistor r=0.22387 //w=0.341 //l=0.590868 //layer=m2 \
 //thickness=0.36 //x=56.945 //y=3.5 //x2=57.47 //y2=3.64
r947 (  74 75 ) resistor r=0.410305 //w=0.131 //l=0.43 //layer=m2 \
 //thickness=0.36 //x=56.945 //y=3.5 //x2=56.515 //y2=3.5
r948 (  72 75 ) resistor r=0.125 //w=0.17 //l=0.174929 //layer=m2 \
 //thickness=0.36 //x=56.345 //y=3.51 //x2=56.515 //y2=3.5
r949 (  72 73 ) resistor r=0.324427 //w=0.131 //l=0.34 //layer=m2 \
 //thickness=0.36 //x=56.345 //y=3.51 //x2=56.005 //y2=3.51
r950 (  70 73 ) resistor r=0.125 //w=0.17 //l=0.179722 //layer=m2 \
 //thickness=0.36 //x=55.835 //y=3.53 //x2=56.005 //y2=3.51
r951 (  70 71 ) resistor r=0.329198 //w=0.131 //l=0.345 //layer=m2 \
 //thickness=0.36 //x=55.835 //y=3.53 //x2=55.49 //y2=3.53
r952 (  69 107 ) resistor r=0.108362 //w=0.251 //l=0.16 //layer=m2 \
 //thickness=0.36 //x=52.08 //y=3.51 //x2=51.92 //y2=3.51
r953 (  68 71 ) resistor r=0.1875 //w=0.17 //l=0.264811 //layer=m2 \
 //thickness=0.36 //x=55.235 //y=3.51 //x2=55.49 //y2=3.53
r954 (  68 69 ) resistor r=3.0105 //w=0.131 //l=3.155 //layer=m2 \
 //thickness=0.36 //x=55.235 //y=3.51 //x2=52.08 //y2=3.51
r955 (  67 189 ) resistor r=9.3 //w=0.17 //l=0.17 //layer=mcon //count=1 \
 //x=95.6 //y=4.885 //x2=95.6 //y2=4.885
r956 (  65 180 ) resistor r=9.3 //w=0.17 //l=0.17 //layer=mcon //count=1 \
 //x=95.58 //y=2.26 //x2=95.58 //y2=2.26
r957 (  61 115 ) resistor r=4.5 //w=0.15 //l=0.15 //layer=via1 //count=1 \
 //x=95.595 //y=4.21 //x2=95.595 //y2=4.21
r958 (  61 63 ) resistor r=0.0130208 //w=0.384 //l=0.04 //layer=m1 \
 //thickness=0.36 //x=95.535 //y=4.21 //x2=95.535 //y2=4.25
r959 (  57 113 ) resistor r=4.5 //w=0.15 //l=0.15 //layer=via1 //count=1 \
 //x=88.92 //y=4.205 //x2=88.92 //y2=4.205
r960 (  57 59 ) resistor r=0.0149601 //w=0.376 //l=0.045 //layer=m1 \
 //thickness=0.36 //x=88.972 //y=4.205 //x2=88.972 //y2=4.25
r961 (  55 175 ) resistor r=9.3 //w=0.17 //l=0.17 //layer=mcon //count=1 \
 //x=88.96 //y=4.885 //x2=88.96 //y2=4.885
r962 (  53 166 ) resistor r=9.3 //w=0.17 //l=0.17 //layer=mcon //count=1 \
 //x=88.92 //y=2.26 //x2=88.92 //y2=2.26
r963 (  51 110 ) resistor r=4.5 //w=0.15 //l=0.15 //layer=via1 //count=1 \
 //x=57.47 //y=3.525 //x2=57.47 //y2=3.525
r964 (  49 51 ) resistor r=0.0049867 //w=0.376 //l=0.015 //layer=m1 \
 //thickness=0.36 //x=57.417 //y=3.51 //x2=57.417 //y2=3.525
r965 (  47 292 ) resistor r=9.3 //w=0.17 //l=0.17 //layer=mcon //count=1 \
 //x=56.985 //y=1.19 //x2=56.985 //y2=1.19
r966 (  45 149 ) resistor r=9.3 //w=0.17 //l=0.17 //layer=mcon //count=1 \
 //x=56.69 //y=5.56 //x2=56.69 //y2=5.56
r967 (  42 141 ) resistor r=9.3 //w=0.17 //l=0.17 //layer=mcon //count=1 \
 //x=55.81 //y=5.56 //x2=55.81 //y2=5.56
r968 (  40 42 ) resistor r=0.121228 //w=0.232 //l=0.225 //layer=m1 \
 //thickness=0.36 //x=55.81 //y=5.335 //x2=55.81 //y2=5.56
r969 (  39 133 ) resistor r=9.3 //w=0.17 //l=0.17 //layer=mcon //count=1 \
 //x=54.93 //y=5.56 //x2=54.93 //y2=5.56
r970 (  37 39 ) resistor r=0.129608 //w=0.217 //l=0.225 //layer=m1 \
 //thickness=0.36 //x=54.932 //y=5.335 //x2=54.932 //y2=5.56
r971 (  34 107 ) resistor r=4.5 //w=0.15 //l=0.15 //layer=via1 //count=1 \
 //x=51.92 //y=3.495 //x2=51.92 //y2=3.495
r972 (  34 36 ) resistor r=0.00490838 //w=0.382 //l=0.015 //layer=m1 \
 //thickness=0.36 //x=51.972 //y=3.495 //x2=51.972 //y2=3.51
r973 (  32 128 ) resistor r=9.3 //w=0.17 //l=0.17 //layer=mcon //count=1 \
 //x=51.92 //y=4.88 //x2=51.92 //y2=4.88
r974 (  30 119 ) resistor r=9.3 //w=0.17 //l=0.17 //layer=mcon //count=1 \
 //x=51.92 //y=2.26 //x2=51.92 //y2=2.26
r975 (  28 67 ) resistor r=0.0893515 //w=0.219 //l=0.154677 //layer=m1 \
 //thickness=0.36 //x=95.58 //y=4.74 //x2=95.6 //y2=4.885
r976 (  27 63 ) resistor r=0.0784723 //w=0.384 //l=0.140712 //layer=m1 \
 //thickness=0.36 //x=95.58 //y=4.37 //x2=95.535 //y2=4.25
r977 (  27 28 ) resistor r=0.353053 //w=0.131 //l=0.37 //layer=m1 \
 //thickness=0.36 //x=95.58 //y=4.37 //x2=95.58 //y2=4.74
r978 (  26 61 ) resistor r=0.0914932 //w=0.384 //l=0.181108 //layer=m1 \
 //thickness=0.36 //x=95.58 //y=4.05 //x2=95.535 //y2=4.21
r979 (  25 65 ) resistor r=0.0744285 //w=0.225 //l=0.12 //layer=m1 \
 //thickness=0.36 //x=95.58 //y=2.38 //x2=95.58 //y2=2.26
r980 (  25 26 ) resistor r=1.59351 //w=0.131 //l=1.67 //layer=m1 \
 //thickness=0.36 //x=95.58 //y=2.38 //x2=95.58 //y2=4.05
r981 (  24 55 ) resistor r=0.100665 //w=0.248 //l=0.193972 //layer=m1 \
 //thickness=0.36 //x=88.92 //y=4.71 //x2=88.96 //y2=4.885
r982 (  23 59 ) resistor r=0.0761992 //w=0.376 //l=0.138582 //layer=m1 \
 //thickness=0.36 //x=88.92 //y=4.365 //x2=88.972 //y2=4.25
r983 (  23 24 ) resistor r=0.329198 //w=0.131 //l=0.345 //layer=m1 \
 //thickness=0.36 //x=88.92 //y=4.365 //x2=88.92 //y2=4.71
r984 (  22 57 ) resistor r=0.0911593 //w=0.376 //l=0.184174 //layer=m1 \
 //thickness=0.36 //x=88.92 //y=4.045 //x2=88.972 //y2=4.205
r985 (  21 53 ) resistor r=0.0717383 //w=0.224 //l=0.115 //layer=m1 \
 //thickness=0.36 //x=88.92 //y=2.375 //x2=88.92 //y2=2.26
r986 (  21 22 ) resistor r=1.59351 //w=0.131 //l=1.67 //layer=m1 \
 //thickness=0.36 //x=88.92 //y=2.375 //x2=88.92 //y2=4.045
r987 (  19 51 ) resistor r=0.0911593 //w=0.376 //l=0.184608 //layer=m1 \
 //thickness=0.36 //x=57.47 //y=3.685 //x2=57.417 //y2=3.525
r988 (  19 20 ) resistor r=1.49332 //w=0.131 //l=1.565 //layer=m1 \
 //thickness=0.36 //x=57.47 //y=3.685 //x2=57.47 //y2=5.25
r989 (  18 49 ) resistor r=0.0861726 //w=0.376 //l=0.16944 //layer=m1 \
 //thickness=0.36 //x=57.47 //y=3.365 //x2=57.417 //y2=3.51
r990 (  17 18 ) resistor r=1.36927 //w=0.131 //l=1.435 //layer=m1 \
 //thickness=0.36 //x=57.47 //y=1.93 //x2=57.47 //y2=3.365
r991 (  15 17 ) resistor r=0.0698411 //w=0.17 //l=0.120208 //layer=m1 \
 //thickness=0.36 //x=57.385 //y=1.845 //x2=57.47 //y2=1.93
r992 (  15 16 ) resistor r=0.300573 //w=0.131 //l=0.315 //layer=m1 \
 //thickness=0.36 //x=57.385 //y=1.845 //x2=57.07 //y2=1.845
r993 (  14 16 ) resistor r=0.0698411 //w=0.17 //l=0.120208 //layer=m1 \
 //thickness=0.36 //x=56.985 //y=1.76 //x2=57.07 //y2=1.845
r994 (  13 47 ) resistor r=0.0717383 //w=0.224 //l=0.115 //layer=m1 \
 //thickness=0.36 //x=56.985 //y=1.305 //x2=56.985 //y2=1.19
r995 (  13 14 ) resistor r=0.43416 //w=0.131 //l=0.455 //layer=m1 \
 //thickness=0.36 //x=56.985 //y=1.305 //x2=56.985 //y2=1.76
r996 (  12 43 ) resistor r=0.0675342 //w=0.23 //l=0.115 //layer=m1 \
 //thickness=0.36 //x=56.805 //y=5.335 //x2=56.69 //y2=5.335
r997 (  11 20 ) resistor r=0.0698411 //w=0.17 //l=0.120208 //layer=m1 \
 //thickness=0.36 //x=57.385 //y=5.335 //x2=57.47 //y2=5.25
r998 (  11 12 ) resistor r=0.553435 //w=0.131 //l=0.58 //layer=m1 \
 //thickness=0.36 //x=57.385 //y=5.335 //x2=56.805 //y2=5.335
r999 (  10 45 ) resistor r=0.00118313 //w=0.23 //layer=m1 //thickness=0.36 \
 //x=56.69 //y=5.56 //x2=56.69 //y2=5.56
r1000 (  9 43 ) resistor r=0.002872 //w=0.34 //l=0.085 //layer=m1 \
 //thickness=0.36 //x=56.69 //y=5.42 //x2=56.69 //y2=5.335
r1001 (  9 10 ) resistor r=0.091623 //w=0.191 //l=0.14 //layer=m1 \
 //thickness=0.36 //x=56.69 //y=5.42 //x2=56.69 //y2=5.56
r1002 (  8 40 ) resistor r=0.0262263 //w=0.232 //l=0.12 //layer=m1 \
 //thickness=0.36 //x=55.93 //y=5.335 //x2=55.81 //y2=5.335
r1003 (  7 43 ) resistor r=0.0675342 //w=0.23 //l=0.115 //layer=m1 \
 //thickness=0.36 //x=56.575 //y=5.335 //x2=56.69 //y2=5.335
r1004 (  7 8 ) resistor r=0.615458 //w=0.131 //l=0.645 //layer=m1 \
 //thickness=0.36 //x=56.575 //y=5.335 //x2=55.93 //y2=5.335
r1005 (  6 37 ) resistor r=0.0222262 //w=0.217 //l=0.118 //layer=m1 \
 //thickness=0.36 //x=55.05 //y=5.335 //x2=54.932 //y2=5.335
r1006 (  5 40 ) resistor r=0.0262263 //w=0.232 //l=0.12 //layer=m1 \
 //thickness=0.36 //x=55.69 //y=5.335 //x2=55.81 //y2=5.335
r1007 (  5 6 ) resistor r=0.610687 //w=0.131 //l=0.64 //layer=m1 \
 //thickness=0.36 //x=55.69 //y=5.335 //x2=55.05 //y2=5.335
r1008 (  4 32 ) resistor r=0.0801089 //w=0.224 //l=0.13 //layer=m1 \
 //thickness=0.36 //x=51.92 //y=4.75 //x2=51.92 //y2=4.88
r1009 (  3 36 ) resistor r=0.0864989 //w=0.382 //l=0.169012 //layer=m1 \
 //thickness=0.36 //x=51.92 //y=3.655 //x2=51.972 //y2=3.51
r1010 (  3 4 ) resistor r=1.04485 //w=0.131 //l=1.095 //layer=m1 \
 //thickness=0.36 //x=51.92 //y=3.655 //x2=51.92 //y2=4.75
r1011 (  2 34 ) resistor r=0.0815905 //w=0.382 //l=0.153818 //layer=m1 \
 //thickness=0.36 //x=51.92 //y=3.365 //x2=51.972 //y2=3.495
r1012 (  1 30 ) resistor r=0.0719237 //w=0.222 //l=0.115 //layer=m1 \
 //thickness=0.36 //x=51.92 //y=2.375 //x2=51.92 //y2=2.26
r1013 (  1 2 ) resistor r=0.944656 //w=0.131 //l=0.99 //layer=m1 \
 //thickness=0.36 //x=51.92 //y=2.375 //x2=51.92 //y2=3.365
ends PM_TMRDFFSNRNQX1\%noxref_23

subckt PM_TMRDFFSNRNQX1\%noxref_24 ( 1 3 4 5 7 8 10 11 12 14 15 16 18 22 25 28 \
 36 40 44 57 60 61 63 64 69 71 72 81 89 107 116 124 125 126 127 128 129 130 \
 134 135 136 138 144 145 147 155 156 157 161 162 )
c344 ( 157 0 ) capacitor c=0.00985497f //x=95.69 //y=1.085
c345 ( 156 0 ) capacitor c=0.0108921f //x=92.36 //y=1.085
c346 ( 155 0 ) capacitor c=0.0110394f //x=89.03 //y=1.085
c347 ( 147 0 ) capacitor c=0.0564228f //x=97.8 //y=2.265
c348 ( 145 0 ) capacitor c=0.0439576f //x=98.44 //y=1.435
c349 ( 144 0 ) capacitor c=0.0201087f //x=98.44 //y=1.09
c350 ( 138 0 ) capacitor c=0.0161986f //x=98.285 //y=1.59
c351 ( 136 0 ) capacitor c=0.0157807f //x=98.285 //y=0.935
c352 ( 135 0 ) capacitor c=0.051108f //x=98.03 //y=4.97
c353 ( 134 0 ) capacitor c=0.0390974f //x=98.32 //y=4.97
c354 ( 130 0 ) capacitor c=0.0301471f //x=97.91 //y=2.1
c355 ( 129 0 ) capacitor c=0.0255349f //x=97.91 //y=1.745
c356 ( 128 0 ) capacitor c=0.0234346f //x=97.91 //y=1.435
c357 ( 127 0 ) capacitor c=0.02013f //x=97.91 //y=1.09
c358 ( 126 0 ) capacitor c=0.153927f //x=98.395 //y=6.2
c359 ( 125 0 ) capacitor c=0.154397f //x=97.955 //y=6.2
c360 ( 116 0 ) capacitor c=6.76693e-19 //x=97.8 //y=4.88
c361 ( 107 0 ) capacitor c=9.11699e-19 //x=97.8 //y=2.265
c362 ( 89 0 ) capacitor c=0.0265472f //x=95.84 //y=5.56
c363 ( 81 0 ) capacitor c=0.0232072f //x=94.96 //y=5.56
c364 ( 72 0 ) capacitor c=0.0554023f //x=97.64 //y=4.255
c365 ( 71 0 ) capacitor c=0.00519588f //x=97.8 //y=4.255
c366 ( 69 0 ) capacitor c=0.00713729f //x=96.48 //y=4.255
c367 ( 64 0 ) capacitor c=0.0842751f //x=95.715 //y=1.405
c368 ( 63 0 ) capacitor c=0.0257508f //x=95.875 //y=1.405
c369 ( 61 0 ) capacitor c=0.00655817f //x=92.68 //y=1.405
c370 ( 60 0 ) capacitor c=0.0744064f //x=92.42 //y=1.405
c371 ( 57 0 ) capacitor c=0.00222181f //x=89.385 //y=1.405
c372 ( 44 0 ) capacitor c=0.00786008f //x=97.8 //y=2.265
c373 ( 40 0 ) capacitor c=0.012406f //x=97.8 //y=4.25
c374 ( 36 0 ) capacitor c=0.0138558f //x=96.32 //y=4.25
c375 ( 28 0 ) capacitor c=0.0126021f //x=95.837 //y=5.39
c376 ( 25 0 ) capacitor c=0.0156957f //x=94.96 //y=5.39
c377 ( 22 0 ) capacitor c=0.00902843f //x=92.55 //y=1.36
c378 ( 18 0 ) capacitor c=0.00590002f //x=89.22 //y=1.36
c379 ( 16 0 ) capacitor c=0.00997505f //x=97.8 //y=4.76
c380 ( 15 0 ) capacitor c=0.0109955f //x=97.8 //y=4.415
c381 ( 14 0 ) capacitor c=0.0499339f //x=97.8 //y=4.095
c382 ( 12 0 ) capacitor c=0.0201925f //x=96.32 //y=5.305
c383 ( 11 0 ) capacitor c=0.0114995f //x=96.32 //y=4.415
c384 ( 10 0 ) capacitor c=0.0634551f //x=96.32 //y=4.095
c385 ( 8 0 ) capacitor c=0.00834076f //x=95.965 //y=1.825
c386 ( 7 0 ) capacitor c=0.014154f //x=96.235 //y=1.825
c387 ( 5 0 ) capacitor c=0.00996583f //x=96.235 //y=5.39
c388 ( 4 0 ) capacitor c=0.00638645f //x=95.88 //y=1.74
c389 ( 3 0 ) capacitor c=0.00623208f //x=95.88 //y=1.535
c390 ( 1 0 ) capacitor c=0.0116295f //x=95.715 //y=5.39
r391 (  147 148 ) resistor r=17.5563 //w=0.302 //l=0.11 //layer=ply \
 //thickness=0.18 //x=97.8 //y=2.265 //x2=97.91 //y2=2.265
r392 (  145 154 ) resistor r=45.1352 //w=0.168 //l=0.173853 //layer=ply \
 //thickness=0.18 //x=98.44 //y=1.435 //x2=98.4 //y2=1.59
r393 (  144 153 ) resistor r=45.1352 //w=0.168 //l=0.173853 //layer=ply \
 //thickness=0.18 //x=98.44 //y=1.09 //x2=98.4 //y2=0.935
r394 (  144 145 ) resistor r=176.904 //w=0.094 //l=0.345 //layer=ply \
 //thickness=0.18 //x=98.44 //y=1.09 //x2=98.44 //y2=1.435
r395 (  139 152 ) resistor r=10.701 //w=0.21 //l=0.115 //layer=ply \
 //thickness=0.18 //x=98.065 //y=1.59 //x2=97.95 //y2=1.59
r396 (  138 154 ) resistor r=5.52526 //w=0.168 //l=0.115 //layer=ply \
 //thickness=0.18 //x=98.285 //y=1.59 //x2=98.4 //y2=1.59
r397 (  137 151 ) resistor r=5.52526 //w=0.168 //l=0.115 //layer=ply \
 //thickness=0.18 //x=98.065 //y=0.935 //x2=97.95 //y2=0.935
r398 (  136 153 ) resistor r=5.52526 //w=0.168 //l=0.115 //layer=ply \
 //thickness=0.18 //x=98.285 //y=0.935 //x2=98.4 //y2=0.935
r399 (  136 137 ) resistor r=112.809 //w=0.094 //l=0.22 //layer=ply \
 //thickness=0.18 //x=98.285 //y=0.935 //x2=98.065 //y2=0.935
r400 (  134 141 ) resistor r=26.9307 //w=0.15 //l=0.106066 //layer=ply \
 //thickness=0.18 //x=98.32 //y=4.97 //x2=98.395 //y2=5.045
r401 (  134 135 ) resistor r=148.702 //w=0.094 //l=0.29 //layer=ply \
 //thickness=0.18 //x=98.32 //y=4.97 //x2=98.03 //y2=4.97
r402 (  131 135 ) resistor r=23.403 //w=0.284 //l=0.106066 //layer=ply \
 //thickness=0.18 //x=97.955 //y=5.045 //x2=98.03 //y2=4.97
r403 (  131 150 ) resistor r=26.3063 //w=0.284 //l=0.229783 //layer=ply \
 //thickness=0.18 //x=97.955 //y=5.045 //x2=97.8 //y2=4.88
r404 (  130 148 ) resistor r=19.1248 //w=0.302 //l=0.165 //layer=ply \
 //thickness=0.18 //x=97.91 //y=2.1 //x2=97.91 //y2=2.265
r405 (  129 152 ) resistor r=39.5823 //w=0.21 //l=0.173853 //layer=ply \
 //thickness=0.18 //x=97.91 //y=1.745 //x2=97.95 //y2=1.59
r406 (  129 130 ) resistor r=182.032 //w=0.094 //l=0.355 //layer=ply \
 //thickness=0.18 //x=97.91 //y=1.745 //x2=97.91 //y2=2.1
r407 (  128 152 ) resistor r=39.5823 //w=0.21 //l=0.173853 //layer=ply \
 //thickness=0.18 //x=97.91 //y=1.435 //x2=97.95 //y2=1.59
r408 (  127 151 ) resistor r=45.1352 //w=0.168 //l=0.173853 //layer=ply \
 //thickness=0.18 //x=97.91 //y=1.09 //x2=97.95 //y2=0.935
r409 (  127 128 ) resistor r=176.904 //w=0.094 //l=0.345 //layer=ply \
 //thickness=0.18 //x=97.91 //y=1.09 //x2=97.91 //y2=1.435
r410 (  126 141 ) resistor r=592.245 //w=0.094 //l=1.155 //layer=ply \
 //thickness=0.18 //x=98.395 //y=6.2 //x2=98.395 //y2=5.045
r411 (  125 131 ) resistor r=592.245 //w=0.094 //l=1.155 //layer=ply \
 //thickness=0.18 //x=97.955 //y=6.2 //x2=97.955 //y2=5.045
r412 (  124 138 ) resistor r=56.4043 //w=0.094 //l=0.11 //layer=ply \
 //thickness=0.18 //x=98.175 //y=1.59 //x2=98.285 //y2=1.59
r413 (  124 139 ) resistor r=56.4043 //w=0.094 //l=0.11 //layer=ply \
 //thickness=0.18 //x=98.175 //y=1.59 //x2=98.065 //y2=1.59
r414 (  123 155 ) resistor r=13.3953 //w=0.172 //l=0.18 //layer=li \
 //thickness=0.1 //x=89.217 //y=1.36 //x2=89.217 //y2=1.18
r415 (  116 150 ) resistor r=152 //w=0.17 //l=0.17 //layer=licon //count=1 \
 //x=97.8 //y=4.88 //x2=97.8 //y2=4.88
r416 (  107 147 ) resistor r=152 //w=0.17 //l=0.17 //layer=licon //count=1 \
 //x=97.8 //y=2.265 //x2=97.8 //y2=2.265
r417 (  100 157 ) resistor r=12.3209 //w=0.187 //l=0.18 //layer=li \
 //thickness=0.1 //x=95.88 //y=1.36 //x2=95.88 //y2=1.18
r418 (  89 162 ) resistor r=23.2727 //w=0.187 //l=0.34 //layer=li \
 //thickness=0.1 //x=95.84 //y=5.56 //x2=95.84 //y2=5.9
r419 (  81 161 ) resistor r=23.2727 //w=0.187 //l=0.34 //layer=li \
 //thickness=0.1 //x=94.96 //y=5.56 //x2=94.96 //y2=5.9
r420 (  78 156 ) resistor r=12.3209 //w=0.187 //l=0.18 //layer=li \
 //thickness=0.1 //x=92.55 //y=1.36 //x2=92.55 //y2=1.18
r421 (  71 72 ) resistor r=0.10734 //w=0.281 //l=0.16 //layer=m2 \
 //thickness=0.36 //x=97.8 //y=4.255 //x2=97.64 //y2=4.255
r422 (  69 72 ) resistor r=1.10687 //w=0.131 //l=1.16 //layer=m2 \
 //thickness=0.36 //x=96.48 //y=4.25 //x2=97.64 //y2=4.25
r423 (  67 69 ) resistor r=0.10734 //w=0.281 //l=0.16 //layer=m2 \
 //thickness=0.36 //x=96.32 //y=4.255 //x2=96.48 //y2=4.255
r424 (  63 64 ) resistor r=0.10734 //w=0.281 //l=0.16 //layer=m2 \
 //thickness=0.36 //x=95.875 //y=1.405 //x2=95.715 //y2=1.405
r425 (  61 64 ) resistor r=2.89599 //w=0.131 //l=3.035 //layer=m2 \
 //thickness=0.36 //x=92.68 //y=1.36 //x2=95.715 //y2=1.36
r426 (  59 61 ) resistor r=0.0942778 //w=0.221 //l=0.13 //layer=m2 \
 //thickness=0.36 //x=92.55 //y=1.405 //x2=92.68 //y2=1.405
r427 (  59 60 ) resistor r=0.0942778 //w=0.221 //l=0.13 //layer=m2 \
 //thickness=0.36 //x=92.55 //y=1.405 //x2=92.42 //y2=1.405
r428 (  57 60 ) resistor r=2.89599 //w=0.131 //l=3.035 //layer=m2 \
 //thickness=0.36 //x=89.385 //y=1.36 //x2=92.42 //y2=1.36
r429 (  55 57 ) resistor r=0.10734 //w=0.281 //l=0.16 //layer=m2 \
 //thickness=0.36 //x=89.225 //y=1.405 //x2=89.385 //y2=1.405
r430 (  47 116 ) resistor r=9.3 //w=0.17 //l=0.17 //layer=mcon //count=1 \
 //x=97.8 //y=4.88 //x2=97.8 //y2=4.88
r431 (  44 107 ) resistor r=9.3 //w=0.17 //l=0.17 //layer=mcon //count=1 \
 //x=97.8 //y=2.265 //x2=97.8 //y2=2.265
r432 (  42 71 ) resistor r=4.5 //w=0.15 //l=0.15 //layer=via1 //count=1 \
 //x=97.8 //y=4.255 //x2=97.8 //y2=4.255
r433 (  40 42 ) resistor r=0.00166223 //w=0.376 //l=0.005 //layer=m1 \
 //thickness=0.36 //x=97.747 //y=4.25 //x2=97.747 //y2=4.255
r434 (  38 67 ) resistor r=4.5 //w=0.15 //l=0.15 //layer=via1 //count=1 \
 //x=96.32 //y=4.255 //x2=96.32 //y2=4.255
r435 (  36 38 ) resistor r=0.00166223 //w=0.376 //l=0.005 //layer=m1 \
 //thickness=0.36 //x=96.372 //y=4.25 //x2=96.372 //y2=4.255
r436 (  34 63 ) resistor r=4.5 //w=0.15 //l=0.15 //layer=via1 //count=1 \
 //x=95.875 //y=1.405 //x2=95.875 //y2=1.405
r437 (  32 100 ) resistor r=9.3 //w=0.17 //l=0.17 //layer=mcon //count=1 \
 //x=95.88 //y=1.36 //x2=95.88 //y2=1.36
r438 (  32 34 ) resistor r=0.0163043 //w=0.345 //l=0.045 //layer=m1 \
 //thickness=0.36 //x=95.82 //y=1.36 //x2=95.82 //y2=1.405
r439 (  30 89 ) resistor r=9.3 //w=0.17 //l=0.17 //layer=mcon //count=1 \
 //x=95.84 //y=5.56 //x2=95.84 //y2=5.56
r440 (  28 30 ) resistor r=0.0944444 //w=0.225 //l=0.17 //layer=m1 \
 //thickness=0.36 //x=95.837 //y=5.39 //x2=95.837 //y2=5.56
r441 (  27 81 ) resistor r=9.3 //w=0.17 //l=0.17 //layer=mcon //count=1 \
 //x=94.96 //y=5.56 //x2=94.96 //y2=5.56
r442 (  25 27 ) resistor r=0.0936123 //w=0.227 //l=0.17 //layer=m1 \
 //thickness=0.36 //x=94.96 //y=5.39 //x2=94.96 //y2=5.56
r443 (  24 59 ) resistor r=4.5 //w=0.15 //l=0.15 //layer=via1 //count=1 \
 //x=92.55 //y=1.405 //x2=92.55 //y2=1.405
r444 (  22 78 ) resistor r=9.3 //w=0.17 //l=0.17 //layer=mcon //count=1 \
 //x=92.55 //y=1.36 //x2=92.55 //y2=1.36
r445 (  22 24 ) resistor r=0.0163043 //w=0.345 //l=0.045 //layer=m1 \
 //thickness=0.36 //x=92.49 //y=1.36 //x2=92.49 //y2=1.405
r446 (  20 55 ) resistor r=4.5 //w=0.15 //l=0.15 //layer=via1 //count=1 \
 //x=89.225 //y=1.405 //x2=89.225 //y2=1.405
r447 (  18 123 ) resistor r=9.3 //w=0.17 //l=0.17 //layer=mcon //count=1 \
 //x=89.22 //y=1.36 //x2=89.22 //y2=1.36
r448 (  18 20 ) resistor r=0.0150401 //w=0.374 //l=0.045 //layer=m1 \
 //thickness=0.36 //x=89.275 //y=1.36 //x2=89.275 //y2=1.405
r449 (  16 47 ) resistor r=0.0732479 //w=0.241 //l=0.122474 //layer=m1 \
 //thickness=0.36 //x=97.8 //y=4.76 //x2=97.805 //y2=4.88
r450 (  15 42 ) resistor r=0.0911593 //w=0.376 //l=0.184608 //layer=m1 \
 //thickness=0.36 //x=97.8 //y=4.415 //x2=97.747 //y2=4.255
r451 (  15 16 ) resistor r=0.329198 //w=0.131 //l=0.345 //layer=m1 \
 //thickness=0.36 //x=97.8 //y=4.415 //x2=97.8 //y2=4.76
r452 (  14 40 ) resistor r=0.0894971 //w=0.376 //l=0.179555 //layer=m1 \
 //thickness=0.36 //x=97.8 //y=4.095 //x2=97.747 //y2=4.25
r453 (  13 44 ) resistor r=0.116051 //w=0.211 //l=0.165 //layer=m1 \
 //thickness=0.36 //x=97.8 //y=2.43 //x2=97.8 //y2=2.265
r454 (  13 14 ) resistor r=1.58874 //w=0.131 //l=1.665 //layer=m1 \
 //thickness=0.36 //x=97.8 //y=2.43 //x2=97.8 //y2=4.095
r455 (  11 38 ) resistor r=0.0911593 //w=0.376 //l=0.184174 //layer=m1 \
 //thickness=0.36 //x=96.32 //y=4.415 //x2=96.372 //y2=4.255
r456 (  11 12 ) resistor r=0.849237 //w=0.131 //l=0.89 //layer=m1 \
 //thickness=0.36 //x=96.32 //y=4.415 //x2=96.32 //y2=5.305
r457 (  10 36 ) resistor r=0.0894971 //w=0.376 //l=0.179123 //layer=m1 \
 //thickness=0.36 //x=96.32 //y=4.095 //x2=96.372 //y2=4.25
r458 (  9 10 ) resistor r=2.08492 //w=0.131 //l=2.185 //layer=m1 \
 //thickness=0.36 //x=96.32 //y=1.91 //x2=96.32 //y2=4.095
r459 (  7 9 ) resistor r=0.0698411 //w=0.17 //l=0.120208 //layer=m1 \
 //thickness=0.36 //x=96.235 //y=1.825 //x2=96.32 //y2=1.91
r460 (  7 8 ) resistor r=0.257634 //w=0.131 //l=0.27 //layer=m1 \
 //thickness=0.36 //x=96.235 //y=1.825 //x2=95.965 //y2=1.825
r461 (  6 28 ) resistor r=0.0243946 //w=0.225 //l=0.123 //layer=m1 \
 //thickness=0.36 //x=95.96 //y=5.39 //x2=95.837 //y2=5.39
r462 (  5 12 ) resistor r=0.0698411 //w=0.17 //l=0.120208 //layer=m1 \
 //thickness=0.36 //x=96.235 //y=5.39 //x2=96.32 //y2=5.305
r463 (  5 6 ) resistor r=0.262405 //w=0.131 //l=0.275 //layer=m1 \
 //thickness=0.36 //x=96.235 //y=5.39 //x2=95.96 //y2=5.39
r464 (  4 8 ) resistor r=0.0698411 //w=0.17 //l=0.120208 //layer=m1 \
 //thickness=0.36 //x=95.88 //y=1.74 //x2=95.965 //y2=1.825
r465 (  3 34 ) resistor r=0.0792909 //w=0.345 //l=0.157162 //layer=m1 \
 //thickness=0.36 //x=95.88 //y=1.535 //x2=95.82 //y2=1.405
r466 (  3 4 ) resistor r=0.195611 //w=0.131 //l=0.205 //layer=m1 \
 //thickness=0.36 //x=95.88 //y=1.535 //x2=95.88 //y2=1.74
r467 (  2 25 ) resistor r=0.0249239 //w=0.227 //l=0.125 //layer=m1 \
 //thickness=0.36 //x=95.085 //y=5.39 //x2=94.96 //y2=5.39
r468 (  1 28 ) resistor r=0.0243946 //w=0.225 //l=0.122 //layer=m1 \
 //thickness=0.36 //x=95.715 //y=5.39 //x2=95.837 //y2=5.39
r469 (  1 2 ) resistor r=0.601145 //w=0.131 //l=0.63 //layer=m1 \
 //thickness=0.36 //x=95.715 //y=5.39 //x2=95.085 //y2=5.39
ends PM_TMRDFFSNRNQX1\%noxref_24

subckt PM_TMRDFFSNRNQX1\%Q ( 2 4 5 6 7 8 10 11 12 14 19 22 34 45 47 )
c100 ( 45 0 ) capacitor c=0.00875839f //x=97.985 //y=1.09
c101 ( 34 0 ) capacitor c=0.0261871f //x=98.175 //y=5.56
c102 ( 22 0 ) capacitor c=0.0106115f //x=98.54 //y=4.25
c103 ( 19 0 ) capacitor c=0.0151874f //x=98.54 //y=4.25
c104 ( 14 0 ) capacitor c=0.0196817f //x=98.17 //y=1.185
c105 ( 12 0 ) capacitor c=0.0169669f //x=98.54 //y=5.055
c106 ( 11 0 ) capacitor c=0.0193464f //x=98.54 //y=4.42
c107 ( 10 0 ) capacitor c=0.0879883f //x=98.54 //y=4.1
c108 ( 8 0 ) capacitor c=0.00557311f //x=98.26 //y=5.14
c109 ( 7 0 ) capacitor c=0.00866828f //x=98.455 //y=5.14
c110 ( 6 0 ) capacitor c=0.00724565f //x=98.255 //y=2.02
c111 ( 5 0 ) capacitor c=0.0141809f //x=98.455 //y=2.02
c112 ( 4 0 ) capacitor c=0.0117946f //x=98.175 //y=5.42
c113 ( 2 0 ) capacitor c=0.0166561f //x=98.17 //y=1.935
r114 (  34 47 ) resistor r=23.615 //w=0.187 //l=0.345 //layer=li \
 //thickness=0.1 //x=98.175 //y=5.56 //x2=98.175 //y2=5.905
r115 (  22 26 ) resistor r=0.0044484 //w=0.281 //l=0.01 //layer=m2 \
 //thickness=0.36 //x=98.535 //y=4.25 //x2=98.535 //y2=4.26
r116 (  21 26 ) resistor r=4.5 //w=0.15 //l=0.15 //layer=via1 //count=1 \
 //x=98.535 //y=4.26 //x2=98.535 //y2=4.26
r117 (  19 21 ) resistor r=0.00329815 //w=0.379 //l=0.01 //layer=m1 \
 //thickness=0.36 //x=98.59 //y=4.25 //x2=98.59 //y2=4.26
r118 (  17 34 ) resistor r=9.3 //w=0.17 //l=0.17 //layer=mcon //count=1 \
 //x=98.175 //y=5.56 //x2=98.175 //y2=5.56
r119 (  14 45 ) resistor r=9.3 //w=0.17 //l=0.17 //layer=mcon //count=1 \
 //x=98.17 //y=1.185 //x2=98.17 //y2=1.185
r120 (  11 21 ) resistor r=0.0912814 //w=0.379 //l=0.183303 //layer=m1 \
 //thickness=0.36 //x=98.54 //y=4.42 //x2=98.59 //y2=4.26
r121 (  11 12 ) resistor r=0.605916 //w=0.131 //l=0.635 //layer=m1 \
 //thickness=0.36 //x=98.54 //y=4.42 //x2=98.54 //y2=5.055
r122 (  10 19 ) resistor r=0.0879833 //w=0.379 //l=0.173205 //layer=m1 \
 //thickness=0.36 //x=98.54 //y=4.1 //x2=98.59 //y2=4.25
r123 (  9 10 ) resistor r=1.90363 //w=0.131 //l=1.995 //layer=m1 \
 //thickness=0.36 //x=98.54 //y=2.105 //x2=98.54 //y2=4.1
r124 (  7 12 ) resistor r=0.0698411 //w=0.17 //l=0.120208 //layer=m1 \
 //thickness=0.36 //x=98.455 //y=5.14 //x2=98.54 //y2=5.055
r125 (  7 8 ) resistor r=0.186069 //w=0.131 //l=0.195 //layer=m1 \
 //thickness=0.36 //x=98.455 //y=5.14 //x2=98.26 //y2=5.14
r126 (  5 9 ) resistor r=0.0698411 //w=0.17 //l=0.120208 //layer=m1 \
 //thickness=0.36 //x=98.455 //y=2.02 //x2=98.54 //y2=2.105
r127 (  5 6 ) resistor r=0.19084 //w=0.131 //l=0.2 //layer=m1 //thickness=0.36 \
 //x=98.455 //y=2.02 //x2=98.255 //y2=2.02
r128 (  4 17 ) resistor r=0.086672 //w=0.218 //l=0.14 //layer=m1 \
 //thickness=0.36 //x=98.175 //y=5.42 //x2=98.175 //y2=5.56
r129 (  3 8 ) resistor r=0.0698411 //w=0.17 //l=0.120208 //layer=m1 \
 //thickness=0.36 //x=98.175 //y=5.225 //x2=98.26 //y2=5.14
r130 (  3 4 ) resistor r=0.186069 //w=0.131 //l=0.195 //layer=m1 \
 //thickness=0.36 //x=98.175 //y=5.225 //x2=98.175 //y2=5.42
r131 (  2 6 ) resistor r=0.0698411 //w=0.17 //l=0.120208 //layer=m1 \
 //thickness=0.36 //x=98.17 //y=1.935 //x2=98.255 //y2=2.02
r132 (  1 14 ) resistor r=0.105739 //w=0.201 //l=0.145 //layer=m1 \
 //thickness=0.36 //x=98.17 //y=1.33 //x2=98.17 //y2=1.185
r133 (  1 2 ) resistor r=0.57729 //w=0.131 //l=0.605 //layer=m1 \
 //thickness=0.36 //x=98.17 //y=1.33 //x2=98.17 //y2=1.935
ends PM_TMRDFFSNRNQX1\%Q

subckt PM_TMRDFFSNRNQX1\%VDD ( 1 2 149 150 151 153 154 155 159 160 177 233 236 \
 245 255 263 273 291 301 309 319 337 347 355 365 383 393 401 411 429 439 447 \
 457 475 485 493 503 521 531 539 549 567 577 585 595 613 623 631 641 659 669 \
 677 687 705 715 723 733 751 761 769 779 785 797 807 815 825 843 853 861 871 \
 889 899 907 917 935 945 953 963 981 991 999 1009 1027 1037 1045 1055 1061 \
 1096 1104 1124 1142 1147 1152 1157 1162 1167 1172 1177 1182 1187 1192 1197 \
 1202 1207 1212 1217 1222 1227 1228 1229 1230 1234 1235 1236 1237 1238 1239 \
 1240 1241 1242 1243 1244 1245 1246 1247 1248 1249 1250 1251 1252 1253 1254 \
 1255 1256 1257 1258 1259 1260 1261 1262 1263 1264 1265 1266 1267 1268 1269 \
 1270 1271 1272 1273 1274 1275 1276 1277 1278 1279 1280 1281 1282 1283 1284 \
 1285 1286 1287 1288 1289 1290 1291 1292 1293 1294 1295 1296 1297 1298 1299 \
 1300 1301 1302 1303 1304 1305 1306 1307 1308 1309 1310 1311 )
c1440 ( 1311 0 ) capacitor c=0.0606818f //x=98.47 //y=5.2
c1441 ( 1310 0 ) capacitor c=0.0575062f //x=97.6 //y=5.2
c1442 ( 1309 0 ) capacitor c=0.0424825f //x=89.475 //y=5.205
c1443 ( 1308 0 ) capacitor c=0.0224071f //x=88.595 //y=5.205
c1444 ( 1307 0 ) capacitor c=0.051473f //x=87.725 //y=5.205
c1445 ( 1306 0 ) capacitor c=0.046689f //x=85.845 //y=5.2
c1446 ( 1305 0 ) capacitor c=0.0255621f //x=84.965 //y=5.2
c1447 ( 1304 0 ) capacitor c=0.0256114f //x=84.085 //y=5.2
c1448 ( 1303 0 ) capacitor c=0.0676549f //x=83.215 //y=5.2
c1449 ( 1302 0 ) capacitor c=0.0466891f //x=81.035 //y=5.2
c1450 ( 1301 0 ) capacitor c=0.025617f //x=80.155 //y=5.2
c1451 ( 1300 0 ) capacitor c=0.0256114f //x=79.275 //y=5.2
c1452 ( 1299 0 ) capacitor c=0.0676623f //x=78.405 //y=5.2
c1453 ( 1298 0 ) capacitor c=0.0466891f //x=76.225 //y=5.2
c1454 ( 1297 0 ) capacitor c=0.025617f //x=75.345 //y=5.2
c1455 ( 1296 0 ) capacitor c=0.0256114f //x=74.465 //y=5.2
c1456 ( 1295 0 ) capacitor c=0.0676871f //x=73.595 //y=5.2
c1457 ( 1294 0 ) capacitor c=0.0466891f //x=71.415 //y=5.2
c1458 ( 1293 0 ) capacitor c=0.025617f //x=70.535 //y=5.2
c1459 ( 1292 0 ) capacitor c=0.0256114f //x=69.655 //y=5.2
c1460 ( 1291 0 ) capacitor c=0.0676862f //x=68.785 //y=5.2
c1461 ( 1290 0 ) capacitor c=0.0466891f //x=66.605 //y=5.2
c1462 ( 1289 0 ) capacitor c=0.0256238f //x=65.725 //y=5.2
c1463 ( 1288 0 ) capacitor c=0.025619f //x=64.845 //y=5.2
c1464 ( 1287 0 ) capacitor c=0.0676862f //x=63.975 //y=5.2
c1465 ( 1286 0 ) capacitor c=0.0466891f //x=61.795 //y=5.2
c1466 ( 1285 0 ) capacitor c=0.025617f //x=60.915 //y=5.2
c1467 ( 1284 0 ) capacitor c=0.0256114f //x=60.035 //y=5.2
c1468 ( 1283 0 ) capacitor c=0.0675515f //x=59.165 //y=5.2
c1469 ( 1282 0 ) capacitor c=0.0466891f //x=56.985 //y=5.2
c1470 ( 1281 0 ) capacitor c=0.025617f //x=56.105 //y=5.2
c1471 ( 1280 0 ) capacitor c=0.0256114f //x=55.225 //y=5.2
c1472 ( 1279 0 ) capacitor c=0.0676881f //x=54.355 //y=5.2
c1473 ( 1278 0 ) capacitor c=0.0466891f //x=52.175 //y=5.2
c1474 ( 1277 0 ) capacitor c=0.025617f //x=51.295 //y=5.2
c1475 ( 1276 0 ) capacitor c=0.0256114f //x=50.415 //y=5.2
c1476 ( 1275 0 ) capacitor c=0.0676378f //x=49.545 //y=5.2
c1477 ( 1274 0 ) capacitor c=0.0466891f //x=47.365 //y=5.2
c1478 ( 1273 0 ) capacitor c=0.025617f //x=46.485 //y=5.2
c1479 ( 1272 0 ) capacitor c=0.0256114f //x=45.605 //y=5.2
c1480 ( 1271 0 ) capacitor c=0.0676871f //x=44.735 //y=5.2
c1481 ( 1270 0 ) capacitor c=0.0466891f //x=42.555 //y=5.2
c1482 ( 1269 0 ) capacitor c=0.025617f //x=41.675 //y=5.2
c1483 ( 1268 0 ) capacitor c=0.0256114f //x=40.795 //y=5.2
c1484 ( 1267 0 ) capacitor c=0.0676862f //x=39.925 //y=5.2
c1485 ( 1266 0 ) capacitor c=0.0466891f //x=37.745 //y=5.2
c1486 ( 1265 0 ) capacitor c=0.025617f //x=36.865 //y=5.2
c1487 ( 1264 0 ) capacitor c=0.0256114f //x=35.985 //y=5.2
c1488 ( 1263 0 ) capacitor c=0.0676862f //x=35.115 //y=5.2
c1489 ( 1262 0 ) capacitor c=0.0466891f //x=32.935 //y=5.2
c1490 ( 1261 0 ) capacitor c=0.025617f //x=32.055 //y=5.2
c1491 ( 1260 0 ) capacitor c=0.0256114f //x=31.175 //y=5.2
c1492 ( 1259 0 ) capacitor c=0.0675526f //x=30.305 //y=5.2
c1493 ( 1258 0 ) capacitor c=0.0466891f //x=28.125 //y=5.2
c1494 ( 1257 0 ) capacitor c=0.025617f //x=27.245 //y=5.2
c1495 ( 1256 0 ) capacitor c=0.0256114f //x=26.365 //y=5.2
c1496 ( 1255 0 ) capacitor c=0.0677148f //x=25.495 //y=5.2
c1497 ( 1254 0 ) capacitor c=0.0466891f //x=23.315 //y=5.2
c1498 ( 1253 0 ) capacitor c=0.025617f //x=22.435 //y=5.2
c1499 ( 1252 0 ) capacitor c=0.0256114f //x=21.555 //y=5.2
c1500 ( 1251 0 ) capacitor c=0.0676623f //x=20.685 //y=5.2
c1501 ( 1250 0 ) capacitor c=0.0466891f //x=18.505 //y=5.2
c1502 ( 1249 0 ) capacitor c=0.025617f //x=17.625 //y=5.2
c1503 ( 1248 0 ) capacitor c=0.0256114f //x=16.745 //y=5.2
c1504 ( 1247 0 ) capacitor c=0.0677138f //x=15.875 //y=5.2
c1505 ( 1246 0 ) capacitor c=0.0466891f //x=13.695 //y=5.2
c1506 ( 1245 0 ) capacitor c=0.025617f //x=12.815 //y=5.2
c1507 ( 1244 0 ) capacitor c=0.0256114f //x=11.935 //y=5.2
c1508 ( 1243 0 ) capacitor c=0.0676529f //x=11.065 //y=5.2
c1509 ( 1242 0 ) capacitor c=0.0466891f //x=8.885 //y=5.2
c1510 ( 1241 0 ) capacitor c=0.025617f //x=8.005 //y=5.2
c1511 ( 1240 0 ) capacitor c=0.0256114f //x=7.125 //y=5.2
c1512 ( 1239 0 ) capacitor c=0.0677384f //x=6.255 //y=5.2
c1513 ( 1238 0 ) capacitor c=0.0466891f //x=4.075 //y=5.2
c1514 ( 1237 0 ) capacitor c=0.025617f //x=3.195 //y=5.2
c1515 ( 1236 0 ) capacitor c=0.0256114f //x=2.315 //y=5.2
c1516 ( 1235 0 ) capacitor c=0.0693233f //x=1.445 //y=5.2
c1517 ( 1234 0 ) capacitor c=0.25757f //x=98.54 //y=7.58
c1518 ( 1232 0 ) capacitor c=0.00597439f //x=97.8 //y=7.58
c1519 ( 1230 0 ) capacitor c=0.117819f //x=97.06 //y=7.585
c1520 ( 1229 0 ) capacitor c=0.121201f //x=93.73 //y=7.585
c1521 ( 1228 0 ) capacitor c=0.125977f //x=90.4 //y=7.585
c1522 ( 1227 0 ) capacitor c=0.140972f //x=87.07 //y=7.585
c1523 ( 1226 0 ) capacitor c=0.00597439f //x=85.99 //y=7.585
c1524 ( 1225 0 ) capacitor c=0.00597439f //x=85.11 //y=7.585
c1525 ( 1224 0 ) capacitor c=0.00597439f //x=84.23 //y=7.585
c1526 ( 1223 0 ) capacitor c=0.00597439f //x=83.35 //y=7.585
c1527 ( 1222 0 ) capacitor c=0.163341f //x=82.26 //y=7.585
c1528 ( 1221 0 ) capacitor c=0.00597439f //x=81.18 //y=7.585
c1529 ( 1220 0 ) capacitor c=0.00597439f //x=80.3 //y=7.585
c1530 ( 1219 0 ) capacitor c=0.00597439f //x=79.42 //y=7.585
c1531 ( 1218 0 ) capacitor c=0.00597439f //x=78.54 //y=7.585
c1532 ( 1217 0 ) capacitor c=0.163341f //x=77.45 //y=7.585
c1533 ( 1216 0 ) capacitor c=0.00597439f //x=76.37 //y=7.585
c1534 ( 1215 0 ) capacitor c=0.00597439f //x=75.49 //y=7.585
c1535 ( 1214 0 ) capacitor c=0.00597439f //x=74.61 //y=7.585
c1536 ( 1213 0 ) capacitor c=0.00597439f //x=73.73 //y=7.585
c1537 ( 1212 0 ) capacitor c=0.161191f //x=72.64 //y=7.585
c1538 ( 1211 0 ) capacitor c=0.00597439f //x=71.56 //y=7.585
c1539 ( 1210 0 ) capacitor c=0.00597439f //x=70.68 //y=7.585
c1540 ( 1209 0 ) capacitor c=0.00597439f //x=69.8 //y=7.585
c1541 ( 1208 0 ) capacitor c=0.00597439f //x=68.92 //y=7.585
c1542 ( 1207 0 ) capacitor c=0.163472f //x=67.83 //y=7.585
c1543 ( 1206 0 ) capacitor c=0.00597439f //x=66.75 //y=7.585
c1544 ( 1205 0 ) capacitor c=0.00597439f //x=65.87 //y=7.585
c1545 ( 1204 0 ) capacitor c=0.00597439f //x=64.99 //y=7.585
c1546 ( 1203 0 ) capacitor c=0.00597439f //x=64.11 //y=7.585
c1547 ( 1202 0 ) capacitor c=0.162645f //x=63.02 //y=7.585
c1548 ( 1201 0 ) capacitor c=0.00597439f //x=61.94 //y=7.585
c1549 ( 1200 0 ) capacitor c=0.00597439f //x=61.06 //y=7.585
c1550 ( 1199 0 ) capacitor c=0.00597439f //x=60.18 //y=7.585
c1551 ( 1198 0 ) capacitor c=0.00597439f //x=59.3 //y=7.585
c1552 ( 1197 0 ) capacitor c=0.162703f //x=58.21 //y=7.585
c1553 ( 1196 0 ) capacitor c=0.00597439f //x=57.13 //y=7.585
c1554 ( 1195 0 ) capacitor c=0.00597439f //x=56.25 //y=7.585
c1555 ( 1194 0 ) capacitor c=0.00597439f //x=55.37 //y=7.585
c1556 ( 1193 0 ) capacitor c=0.00597439f //x=54.49 //y=7.585
c1557 ( 1192 0 ) capacitor c=0.163472f //x=53.4 //y=7.585
c1558 ( 1191 0 ) capacitor c=0.00597439f //x=52.32 //y=7.585
c1559 ( 1190 0 ) capacitor c=0.00597439f //x=51.44 //y=7.585
c1560 ( 1189 0 ) capacitor c=0.00597439f //x=50.56 //y=7.585
c1561 ( 1188 0 ) capacitor c=0.00597439f //x=49.68 //y=7.585
c1562 ( 1187 0 ) capacitor c=0.163472f //x=48.59 //y=7.585
c1563 ( 1186 0 ) capacitor c=0.00597439f //x=47.51 //y=7.585
c1564 ( 1185 0 ) capacitor c=0.00597439f //x=46.63 //y=7.585
c1565 ( 1184 0 ) capacitor c=0.00597439f //x=45.75 //y=7.585
c1566 ( 1183 0 ) capacitor c=0.00597439f //x=44.87 //y=7.585
c1567 ( 1182 0 ) capacitor c=0.161147f //x=43.78 //y=7.585
c1568 ( 1181 0 ) capacitor c=0.00597439f //x=42.7 //y=7.585
c1569 ( 1180 0 ) capacitor c=0.00597439f //x=41.82 //y=7.585
c1570 ( 1179 0 ) capacitor c=0.00597439f //x=40.94 //y=7.585
c1571 ( 1178 0 ) capacitor c=0.00597439f //x=40.06 //y=7.585
c1572 ( 1177 0 ) capacitor c=0.163472f //x=38.97 //y=7.585
c1573 ( 1176 0 ) capacitor c=0.00597439f //x=37.89 //y=7.585
c1574 ( 1175 0 ) capacitor c=0.00597439f //x=37.01 //y=7.585
c1575 ( 1174 0 ) capacitor c=0.00597439f //x=36.13 //y=7.585
c1576 ( 1173 0 ) capacitor c=0.00597439f //x=35.25 //y=7.585
c1577 ( 1172 0 ) capacitor c=0.161264f //x=34.16 //y=7.585
c1578 ( 1171 0 ) capacitor c=0.00597439f //x=33.08 //y=7.585
c1579 ( 1170 0 ) capacitor c=0.00597439f //x=32.2 //y=7.585
c1580 ( 1169 0 ) capacitor c=0.00597439f //x=31.32 //y=7.585
c1581 ( 1168 0 ) capacitor c=0.00597439f //x=30.44 //y=7.585
c1582 ( 1167 0 ) capacitor c=0.160374f //x=29.35 //y=7.585
c1583 ( 1166 0 ) capacitor c=0.00597439f //x=28.27 //y=7.585
c1584 ( 1165 0 ) capacitor c=0.00597439f //x=27.39 //y=7.585
c1585 ( 1164 0 ) capacitor c=0.00597439f //x=26.51 //y=7.585
c1586 ( 1163 0 ) capacitor c=0.00597439f //x=25.63 //y=7.585
c1587 ( 1162 0 ) capacitor c=0.163341f //x=24.54 //y=7.585
c1588 ( 1161 0 ) capacitor c=0.00597439f //x=23.46 //y=7.585
c1589 ( 1160 0 ) capacitor c=0.00597439f //x=22.58 //y=7.585
c1590 ( 1159 0 ) capacitor c=0.00597439f //x=21.7 //y=7.585
c1591 ( 1158 0 ) capacitor c=0.00597439f //x=20.82 //y=7.585
c1592 ( 1157 0 ) capacitor c=0.163341f //x=19.73 //y=7.585
c1593 ( 1156 0 ) capacitor c=0.00597439f //x=18.65 //y=7.585
c1594 ( 1155 0 ) capacitor c=0.00597439f //x=17.77 //y=7.585
c1595 ( 1154 0 ) capacitor c=0.00597439f //x=16.89 //y=7.585
c1596 ( 1153 0 ) capacitor c=0.00597439f //x=16.01 //y=7.585
c1597 ( 1152 0 ) capacitor c=0.163341f //x=14.92 //y=7.585
c1598 ( 1151 0 ) capacitor c=0.00597439f //x=13.84 //y=7.585
c1599 ( 1150 0 ) capacitor c=0.00597439f //x=12.96 //y=7.585
c1600 ( 1149 0 ) capacitor c=0.00597439f //x=12.08 //y=7.585
c1601 ( 1148 0 ) capacitor c=0.00597439f //x=11.2 //y=7.585
c1602 ( 1147 0 ) capacitor c=0.163341f //x=10.11 //y=7.585
c1603 ( 1146 0 ) capacitor c=0.00597439f //x=9.03 //y=7.585
c1604 ( 1145 0 ) capacitor c=0.00597439f //x=8.15 //y=7.585
c1605 ( 1144 0 ) capacitor c=0.00597439f //x=7.27 //y=7.585
c1606 ( 1143 0 ) capacitor c=0.00597439f //x=6.39 //y=7.585
c1607 ( 1142 0 ) capacitor c=0.163259f //x=5.3 //y=7.585
c1608 ( 1141 0 ) capacitor c=0.00597439f //x=4.22 //y=7.585
c1609 ( 1140 0 ) capacitor c=0.00597439f //x=3.34 //y=7.585
c1610 ( 1139 0 ) capacitor c=0.00597439f //x=2.46 //y=7.585
c1611 ( 1138 0 ) capacitor c=0.00597439f //x=1.58 //y=7.585
c1612 ( 1124 0 ) capacitor c=0.0291371f //x=98.53 //y=7.585
c1613 ( 1114 0 ) capacitor c=0.021306f //x=97.65 //y=7.585
c1614 ( 1104 0 ) capacitor c=0.134506f //x=96.89 //y=7.585
c1615 ( 1096 0 ) capacitor c=0.131873f //x=93.56 //y=7.585
c1616 ( 1061 0 ) capacitor c=0.133054f //x=90.23 //y=7.585
c1617 ( 1055 0 ) capacitor c=0.042257f //x=86.9 //y=7.585
c1618 ( 1045 0 ) capacitor c=0.0288858f //x=85.905 //y=7.585
c1619 ( 1037 0 ) capacitor c=0.0289326f //x=85.025 //y=7.585
c1620 ( 1027 0 ) capacitor c=0.0290299f //x=84.145 //y=7.585
c1621 ( 1015 0 ) capacitor c=0.0455283f //x=83.265 //y=7.585
c1622 ( 1009 0 ) capacitor c=0.042257f //x=82.09 //y=7.585
c1623 ( 999 0 ) capacitor c=0.0288858f //x=81.095 //y=7.585
c1624 ( 991 0 ) capacitor c=0.0289326f //x=80.215 //y=7.585
c1625 ( 981 0 ) capacitor c=0.0290299f //x=79.335 //y=7.585
c1626 ( 969 0 ) capacitor c=0.0455283f //x=78.455 //y=7.585
c1627 ( 963 0 ) capacitor c=0.042257f //x=77.28 //y=7.585
c1628 ( 953 0 ) capacitor c=0.0288858f //x=76.285 //y=7.585
c1629 ( 945 0 ) capacitor c=0.0289326f //x=75.405 //y=7.585
c1630 ( 935 0 ) capacitor c=0.0286631f //x=74.525 //y=7.585
c1631 ( 923 0 ) capacitor c=0.0386886f //x=73.645 //y=7.585
c1632 ( 917 0 ) capacitor c=0.038209f //x=72.47 //y=7.585
c1633 ( 907 0 ) capacitor c=0.0288858f //x=71.475 //y=7.585
c1634 ( 899 0 ) capacitor c=0.0289326f //x=70.595 //y=7.585
c1635 ( 889 0 ) capacitor c=0.0286631f //x=69.715 //y=7.585
c1636 ( 877 0 ) capacitor c=0.0386886f //x=68.835 //y=7.585
c1637 ( 871 0 ) capacitor c=0.038209f //x=67.66 //y=7.585
c1638 ( 861 0 ) capacitor c=0.0288858f //x=66.665 //y=7.585
c1639 ( 853 0 ) capacitor c=0.0288627f //x=65.785 //y=7.585
c1640 ( 843 0 ) capacitor c=0.0286631f //x=64.905 //y=7.585
c1641 ( 831 0 ) capacitor c=0.0386886f //x=64.025 //y=7.585
c1642 ( 825 0 ) capacitor c=0.038209f //x=62.85 //y=7.585
c1643 ( 815 0 ) capacitor c=0.0288858f //x=61.855 //y=7.585
c1644 ( 807 0 ) capacitor c=0.0289326f //x=60.975 //y=7.585
c1645 ( 797 0 ) capacitor c=0.0287535f //x=60.095 //y=7.585
c1646 ( 785 0 ) capacitor c=0.0386886f //x=59.215 //y=7.585
c1647 ( 779 0 ) capacitor c=0.038209f //x=58.04 //y=7.585
c1648 ( 769 0 ) capacitor c=0.0288858f //x=57.045 //y=7.585
c1649 ( 761 0 ) capacitor c=0.0289326f //x=56.165 //y=7.585
c1650 ( 751 0 ) capacitor c=0.0286631f //x=55.285 //y=7.585
c1651 ( 739 0 ) capacitor c=0.0386886f //x=54.405 //y=7.585
c1652 ( 733 0 ) capacitor c=0.038209f //x=53.23 //y=7.585
c1653 ( 723 0 ) capacitor c=0.0288858f //x=52.235 //y=7.585
c1654 ( 715 0 ) capacitor c=0.0289326f //x=51.355 //y=7.585
c1655 ( 705 0 ) capacitor c=0.0286631f //x=50.475 //y=7.585
c1656 ( 693 0 ) capacitor c=0.0386886f //x=49.595 //y=7.585
c1657 ( 687 0 ) capacitor c=0.038209f //x=48.42 //y=7.585
c1658 ( 677 0 ) capacitor c=0.0288858f //x=47.425 //y=7.585
c1659 ( 669 0 ) capacitor c=0.0289326f //x=46.545 //y=7.585
c1660 ( 659 0 ) capacitor c=0.0286631f //x=45.665 //y=7.585
c1661 ( 647 0 ) capacitor c=0.0386886f //x=44.785 //y=7.585
c1662 ( 641 0 ) capacitor c=0.038209f //x=43.61 //y=7.585
c1663 ( 631 0 ) capacitor c=0.0288858f //x=42.615 //y=7.585
c1664 ( 623 0 ) capacitor c=0.0289326f //x=41.735 //y=7.585
c1665 ( 613 0 ) capacitor c=0.0286631f //x=40.855 //y=7.585
c1666 ( 601 0 ) capacitor c=0.0386886f //x=39.975 //y=7.585
c1667 ( 595 0 ) capacitor c=0.038209f //x=38.8 //y=7.585
c1668 ( 585 0 ) capacitor c=0.0288858f //x=37.805 //y=7.585
c1669 ( 577 0 ) capacitor c=0.0289326f //x=36.925 //y=7.585
c1670 ( 567 0 ) capacitor c=0.0286631f //x=36.045 //y=7.585
c1671 ( 555 0 ) capacitor c=0.0386886f //x=35.165 //y=7.585
c1672 ( 549 0 ) capacitor c=0.038209f //x=33.99 //y=7.585
c1673 ( 539 0 ) capacitor c=0.0288858f //x=32.995 //y=7.585
c1674 ( 531 0 ) capacitor c=0.0289326f //x=32.115 //y=7.585
c1675 ( 521 0 ) capacitor c=0.0286631f //x=31.235 //y=7.585
c1676 ( 509 0 ) capacitor c=0.0386886f //x=30.355 //y=7.585
c1677 ( 503 0 ) capacitor c=0.0390964f //x=29.18 //y=7.585
c1678 ( 493 0 ) capacitor c=0.0288858f //x=28.185 //y=7.585
c1679 ( 485 0 ) capacitor c=0.0289326f //x=27.305 //y=7.585
c1680 ( 475 0 ) capacitor c=0.0290299f //x=26.425 //y=7.585
c1681 ( 463 0 ) capacitor c=0.0455283f //x=25.545 //y=7.585
c1682 ( 457 0 ) capacitor c=0.042257f //x=24.37 //y=7.585
c1683 ( 447 0 ) capacitor c=0.0288858f //x=23.375 //y=7.585
c1684 ( 439 0 ) capacitor c=0.0289326f //x=22.495 //y=7.585
c1685 ( 429 0 ) capacitor c=0.0290299f //x=21.615 //y=7.585
c1686 ( 417 0 ) capacitor c=0.0455283f //x=20.735 //y=7.585
c1687 ( 411 0 ) capacitor c=0.042257f //x=19.56 //y=7.585
c1688 ( 401 0 ) capacitor c=0.0288858f //x=18.565 //y=7.585
c1689 ( 393 0 ) capacitor c=0.0289326f //x=17.685 //y=7.585
c1690 ( 383 0 ) capacitor c=0.0290299f //x=16.805 //y=7.585
c1691 ( 371 0 ) capacitor c=0.0455283f //x=15.925 //y=7.585
c1692 ( 365 0 ) capacitor c=0.042257f //x=14.75 //y=7.585
c1693 ( 355 0 ) capacitor c=0.0288858f //x=13.755 //y=7.585
c1694 ( 347 0 ) capacitor c=0.0289326f //x=12.875 //y=7.585
c1695 ( 337 0 ) capacitor c=0.0290299f //x=11.995 //y=7.585
c1696 ( 325 0 ) capacitor c=0.0455283f //x=11.115 //y=7.585
c1697 ( 319 0 ) capacitor c=0.042257f //x=9.94 //y=7.585
c1698 ( 309 0 ) capacitor c=0.0288858f //x=8.945 //y=7.585
c1699 ( 301 0 ) capacitor c=0.0289326f //x=8.065 //y=7.585
c1700 ( 291 0 ) capacitor c=0.0290299f //x=7.185 //y=7.585
c1701 ( 279 0 ) capacitor c=0.0455283f //x=6.305 //y=7.585
c1702 ( 273 0 ) capacitor c=0.042257f //x=5.13 //y=7.585
c1703 ( 263 0 ) capacitor c=0.0288858f //x=4.135 //y=7.585
c1704 ( 255 0 ) capacitor c=0.0289326f //x=3.255 //y=7.585
c1705 ( 245 0 ) capacitor c=0.0290743f //x=2.375 //y=7.585
c1706 ( 236 0 ) capacitor c=0.253518f //x=1.23 //y=7.58
c1707 ( 233 0 ) capacitor c=0.0445047f //x=1.495 //y=7.585
c1708 ( 224 0 ) capacitor c=0.00499323f //x=89.62 //y=7.585
c1709 ( 221 0 ) capacitor c=0.00499323f //x=88.74 //y=7.585
c1710 ( 216 0 ) capacitor c=0.00499323f //x=87.81 //y=7.58
c1711 ( 177 0 ) capacitor c=0.347627f //x=98.54 //y=7.58
c1712 ( 160 0 ) capacitor c=0.00657976f //x=89.62 //y=7.41
c1713 ( 159 0 ) capacitor c=0.00827249f //x=89.62 //y=7.035
c1714 ( 155 0 ) capacitor c=0.0220779f //x=89.535 //y=7.585
c1715 ( 154 0 ) capacitor c=0.00369726f //x=88.74 //y=7.41
c1716 ( 153 0 ) capacitor c=0.00650208f //x=88.74 //y=7.035
c1717 ( 151 0 ) capacitor c=0.02242f //x=88.655 //y=7.585
c1718 ( 150 0 ) capacitor c=0.0090067f //x=87.86 //y=7.41
c1719 ( 149 0 ) capacitor c=0.0125184f //x=87.86 //y=7.035
c1720 ( 2 0 ) capacitor c=3.1454f //x=87.775 //y=7.585
r1721 (  1126 1234 ) resistor r=4.23183 //w=0.7 //l=0.175 //layer=li \
 //thickness=0.1 //x=98.615 //y=7.41 //x2=98.615 //y2=7.585
r1722 (  1126 1311 ) resistor r=56.4706 //w=0.187 //l=0.825 //layer=li \
 //thickness=0.1 //x=98.615 //y=7.41 //x2=98.615 //y2=6.585
r1723 (  1125 1232 ) resistor r=2.87058 //w=0.35 //l=0.085 //layer=li \
 //thickness=0.1 //x=97.82 //y=7.585 //x2=97.735 //y2=7.585
r1724 (  1124 1234 ) resistor r=2.87058 //w=0.35 //l=0.085 //layer=li \
 //thickness=0.1 //x=98.53 //y=7.585 //x2=98.615 //y2=7.585
r1725 (  1124 1125 ) resistor r=24.7629 //w=0.367 //l=0.71 //layer=li \
 //thickness=0.1 //x=98.53 //y=7.585 //x2=97.82 //y2=7.585
r1726 (  1116 1232 ) resistor r=4.23183 //w=0.7 //l=0.175 //layer=li \
 //thickness=0.1 //x=97.735 //y=7.41 //x2=97.735 //y2=7.585
r1727 (  1116 1310 ) resistor r=56.4706 //w=0.187 //l=0.825 //layer=li \
 //thickness=0.1 //x=97.735 //y=7.41 //x2=97.735 //y2=6.585
r1728 (  1115 1230 ) resistor r=5.29055 //w=0.35 //l=0.17 //layer=li \
 //thickness=0.1 //x=97.23 //y=7.585 //x2=97.06 //y2=7.585
r1729 (  1114 1232 ) resistor r=2.87058 //w=0.35 //l=0.085 //layer=li \
 //thickness=0.1 //x=97.65 //y=7.585 //x2=97.735 //y2=7.585
r1730 (  1114 1115 ) resistor r=14.6485 //w=0.367 //l=0.42 //layer=li \
 //thickness=0.1 //x=97.65 //y=7.585 //x2=97.23 //y2=7.585
r1731 (  1109 1111 ) resistor r=38.7139 //w=0.367 //l=1.11 //layer=li \
 //thickness=0.1 //x=95.21 //y=7.585 //x2=96.32 //y2=7.585
r1732 (  1107 1109 ) resistor r=38.7139 //w=0.367 //l=1.11 //layer=li \
 //thickness=0.1 //x=94.1 //y=7.585 //x2=95.21 //y2=7.585
r1733 (  1105 1229 ) resistor r=5.29055 //w=0.35 //l=0.17 //layer=li \
 //thickness=0.1 //x=93.9 //y=7.585 //x2=93.73 //y2=7.585
r1734 (  1105 1107 ) resistor r=6.97548 //w=0.367 //l=0.2 //layer=li \
 //thickness=0.1 //x=93.9 //y=7.585 //x2=94.1 //y2=7.585
r1735 (  1104 1230 ) resistor r=5.29055 //w=0.35 //l=0.17 //layer=li \
 //thickness=0.1 //x=96.89 //y=7.585 //x2=97.06 //y2=7.585
r1736 (  1104 1111 ) resistor r=19.8801 //w=0.367 //l=0.57 //layer=li \
 //thickness=0.1 //x=96.89 //y=7.585 //x2=96.32 //y2=7.585
r1737 (  1099 1101 ) resistor r=38.7139 //w=0.367 //l=1.11 //layer=li \
 //thickness=0.1 //x=91.51 //y=7.585 //x2=92.62 //y2=7.585
r1738 (  1097 1228 ) resistor r=5.29055 //w=0.35 //l=0.17 //layer=li \
 //thickness=0.1 //x=90.57 //y=7.585 //x2=90.4 //y2=7.585
r1739 (  1097 1099 ) resistor r=32.7847 //w=0.367 //l=0.94 //layer=li \
 //thickness=0.1 //x=90.57 //y=7.585 //x2=91.51 //y2=7.585
r1740 (  1096 1229 ) resistor r=5.29055 //w=0.35 //l=0.17 //layer=li \
 //thickness=0.1 //x=93.56 //y=7.585 //x2=93.73 //y2=7.585
r1741 (  1096 1101 ) resistor r=32.7847 //w=0.367 //l=0.94 //layer=li \
 //thickness=0.1 //x=93.56 //y=7.585 //x2=92.62 //y2=7.585
r1742 (  1092 1309 ) resistor r=23.2727 //w=0.187 //l=0.34 //layer=li \
 //thickness=0.1 //x=89.62 //y=6.92 //x2=89.62 //y2=6.58
r1743 (  1077 1307 ) resistor r=23.2727 //w=0.187 //l=0.34 //layer=li \
 //thickness=0.1 //x=87.86 //y=6.92 //x2=87.86 //y2=6.58
r1744 (  1066 1068 ) resistor r=38.7139 //w=0.367 //l=1.11 //layer=li \
 //thickness=0.1 //x=88.92 //y=7.585 //x2=90.03 //y2=7.585
r1745 (  1064 1066 ) resistor r=38.7139 //w=0.367 //l=1.11 //layer=li \
 //thickness=0.1 //x=87.81 //y=7.585 //x2=88.92 //y2=7.585
r1746 (  1062 1227 ) resistor r=5.29055 //w=0.35 //l=0.17 //layer=li \
 //thickness=0.1 //x=87.24 //y=7.585 //x2=87.07 //y2=7.585
r1747 (  1062 1064 ) resistor r=19.8801 //w=0.367 //l=0.57 //layer=li \
 //thickness=0.1 //x=87.24 //y=7.585 //x2=87.81 //y2=7.585
r1748 (  1061 1228 ) resistor r=5.29055 //w=0.35 //l=0.17 //layer=li \
 //thickness=0.1 //x=90.23 //y=7.585 //x2=90.4 //y2=7.585
r1749 (  1061 1068 ) resistor r=6.97548 //w=0.367 //l=0.2 //layer=li \
 //thickness=0.1 //x=90.23 //y=7.585 //x2=90.03 //y2=7.585
r1750 (  1056 1226 ) resistor r=2.87058 //w=0.35 //l=0.085 //layer=li \
 //thickness=0.1 //x=86.075 //y=7.585 //x2=85.99 //y2=7.585
r1751 (  1056 1058 ) resistor r=8.89373 //w=0.367 //l=0.255 //layer=li \
 //thickness=0.1 //x=86.075 //y=7.585 //x2=86.33 //y2=7.585
r1752 (  1055 1227 ) resistor r=5.29055 //w=0.35 //l=0.17 //layer=li \
 //thickness=0.1 //x=86.9 //y=7.585 //x2=87.07 //y2=7.585
r1753 (  1055 1058 ) resistor r=19.8801 //w=0.367 //l=0.57 //layer=li \
 //thickness=0.1 //x=86.9 //y=7.585 //x2=86.33 //y2=7.585
r1754 (  1049 1226 ) resistor r=4.23183 //w=0.7 //l=0.175 //layer=li \
 //thickness=0.1 //x=85.99 //y=7.41 //x2=85.99 //y2=7.585
r1755 (  1049 1306 ) resistor r=33.1979 //w=0.187 //l=0.485 //layer=li \
 //thickness=0.1 //x=85.99 //y=7.41 //x2=85.99 //y2=6.925
r1756 (  1046 1225 ) resistor r=2.87058 //w=0.35 //l=0.085 //layer=li \
 //thickness=0.1 //x=85.195 //y=7.585 //x2=85.11 //y2=7.585
r1757 (  1046 1048 ) resistor r=0.871935 //w=0.367 //l=0.025 //layer=li \
 //thickness=0.1 //x=85.195 //y=7.585 //x2=85.22 //y2=7.585
r1758 (  1045 1226 ) resistor r=2.87058 //w=0.35 //l=0.085 //layer=li \
 //thickness=0.1 //x=85.905 //y=7.585 //x2=85.99 //y2=7.585
r1759 (  1045 1048 ) resistor r=23.891 //w=0.367 //l=0.685 //layer=li \
 //thickness=0.1 //x=85.905 //y=7.585 //x2=85.22 //y2=7.585
r1760 (  1039 1225 ) resistor r=4.23183 //w=0.7 //l=0.175 //layer=li \
 //thickness=0.1 //x=85.11 //y=7.41 //x2=85.11 //y2=7.585
r1761 (  1039 1305 ) resistor r=33.1979 //w=0.187 //l=0.485 //layer=li \
 //thickness=0.1 //x=85.11 //y=7.41 //x2=85.11 //y2=6.925
r1762 (  1038 1224 ) resistor r=2.87058 //w=0.35 //l=0.085 //layer=li \
 //thickness=0.1 //x=84.315 //y=7.585 //x2=84.23 //y2=7.585
r1763 (  1037 1225 ) resistor r=2.87058 //w=0.35 //l=0.085 //layer=li \
 //thickness=0.1 //x=85.025 //y=7.585 //x2=85.11 //y2=7.585
r1764 (  1037 1038 ) resistor r=24.7629 //w=0.367 //l=0.71 //layer=li \
 //thickness=0.1 //x=85.025 //y=7.585 //x2=84.315 //y2=7.585
r1765 (  1031 1224 ) resistor r=4.23183 //w=0.7 //l=0.175 //layer=li \
 //thickness=0.1 //x=84.23 //y=7.41 //x2=84.23 //y2=7.585
r1766 (  1031 1304 ) resistor r=33.1979 //w=0.187 //l=0.485 //layer=li \
 //thickness=0.1 //x=84.23 //y=7.41 //x2=84.23 //y2=6.925
r1767 (  1028 1223 ) resistor r=2.87058 //w=0.35 //l=0.085 //layer=li \
 //thickness=0.1 //x=83.435 //y=7.585 //x2=83.35 //y2=7.585
r1768 (  1028 1030 ) resistor r=23.5422 //w=0.367 //l=0.675 //layer=li \
 //thickness=0.1 //x=83.435 //y=7.585 //x2=84.11 //y2=7.585
r1769 (  1027 1224 ) resistor r=2.87058 //w=0.35 //l=0.085 //layer=li \
 //thickness=0.1 //x=84.145 //y=7.585 //x2=84.23 //y2=7.585
r1770 (  1027 1030 ) resistor r=1.22071 //w=0.367 //l=0.035 //layer=li \
 //thickness=0.1 //x=84.145 //y=7.585 //x2=84.11 //y2=7.585
r1771 (  1019 1223 ) resistor r=4.23183 //w=0.7 //l=0.175 //layer=li \
 //thickness=0.1 //x=83.35 //y=7.41 //x2=83.35 //y2=7.585
r1772 (  1019 1303 ) resistor r=56.4706 //w=0.187 //l=0.825 //layer=li \
 //thickness=0.1 //x=83.35 //y=7.41 //x2=83.35 //y2=6.585
r1773 (  1016 1222 ) resistor r=5.29055 //w=0.35 //l=0.17 //layer=li \
 //thickness=0.1 //x=82.43 //y=7.585 //x2=82.26 //y2=7.585
r1774 (  1016 1018 ) resistor r=19.8801 //w=0.367 //l=0.57 //layer=li \
 //thickness=0.1 //x=82.43 //y=7.585 //x2=83 //y2=7.585
r1775 (  1015 1223 ) resistor r=2.87058 //w=0.35 //l=0.085 //layer=li \
 //thickness=0.1 //x=83.265 //y=7.585 //x2=83.35 //y2=7.585
r1776 (  1015 1018 ) resistor r=9.24251 //w=0.367 //l=0.265 //layer=li \
 //thickness=0.1 //x=83.265 //y=7.585 //x2=83 //y2=7.585
r1777 (  1010 1221 ) resistor r=2.87058 //w=0.35 //l=0.085 //layer=li \
 //thickness=0.1 //x=81.265 //y=7.585 //x2=81.18 //y2=7.585
r1778 (  1010 1012 ) resistor r=8.89373 //w=0.367 //l=0.255 //layer=li \
 //thickness=0.1 //x=81.265 //y=7.585 //x2=81.52 //y2=7.585
r1779 (  1009 1222 ) resistor r=5.29055 //w=0.35 //l=0.17 //layer=li \
 //thickness=0.1 //x=82.09 //y=7.585 //x2=82.26 //y2=7.585
r1780 (  1009 1012 ) resistor r=19.8801 //w=0.367 //l=0.57 //layer=li \
 //thickness=0.1 //x=82.09 //y=7.585 //x2=81.52 //y2=7.585
r1781 (  1003 1221 ) resistor r=4.23183 //w=0.7 //l=0.175 //layer=li \
 //thickness=0.1 //x=81.18 //y=7.41 //x2=81.18 //y2=7.585
r1782 (  1003 1302 ) resistor r=33.1979 //w=0.187 //l=0.485 //layer=li \
 //thickness=0.1 //x=81.18 //y=7.41 //x2=81.18 //y2=6.925
r1783 (  1000 1220 ) resistor r=2.87058 //w=0.35 //l=0.085 //layer=li \
 //thickness=0.1 //x=80.385 //y=7.585 //x2=80.3 //y2=7.585
r1784 (  1000 1002 ) resistor r=0.871935 //w=0.367 //l=0.025 //layer=li \
 //thickness=0.1 //x=80.385 //y=7.585 //x2=80.41 //y2=7.585
r1785 (  999 1221 ) resistor r=2.87058 //w=0.35 //l=0.085 //layer=li \
 //thickness=0.1 //x=81.095 //y=7.585 //x2=81.18 //y2=7.585
r1786 (  999 1002 ) resistor r=23.891 //w=0.367 //l=0.685 //layer=li \
 //thickness=0.1 //x=81.095 //y=7.585 //x2=80.41 //y2=7.585
r1787 (  993 1220 ) resistor r=4.23183 //w=0.7 //l=0.175 //layer=li \
 //thickness=0.1 //x=80.3 //y=7.41 //x2=80.3 //y2=7.585
r1788 (  993 1301 ) resistor r=33.1979 //w=0.187 //l=0.485 //layer=li \
 //thickness=0.1 //x=80.3 //y=7.41 //x2=80.3 //y2=6.925
r1789 (  992 1219 ) resistor r=2.87058 //w=0.35 //l=0.085 //layer=li \
 //thickness=0.1 //x=79.505 //y=7.585 //x2=79.42 //y2=7.585
r1790 (  991 1220 ) resistor r=2.87058 //w=0.35 //l=0.085 //layer=li \
 //thickness=0.1 //x=80.215 //y=7.585 //x2=80.3 //y2=7.585
r1791 (  991 992 ) resistor r=24.7629 //w=0.367 //l=0.71 //layer=li \
 //thickness=0.1 //x=80.215 //y=7.585 //x2=79.505 //y2=7.585
r1792 (  985 1219 ) resistor r=4.23183 //w=0.7 //l=0.175 //layer=li \
 //thickness=0.1 //x=79.42 //y=7.41 //x2=79.42 //y2=7.585
r1793 (  985 1300 ) resistor r=33.1979 //w=0.187 //l=0.485 //layer=li \
 //thickness=0.1 //x=79.42 //y=7.41 //x2=79.42 //y2=6.925
r1794 (  982 1218 ) resistor r=2.87058 //w=0.35 //l=0.085 //layer=li \
 //thickness=0.1 //x=78.625 //y=7.585 //x2=78.54 //y2=7.585
r1795 (  982 984 ) resistor r=23.5422 //w=0.367 //l=0.675 //layer=li \
 //thickness=0.1 //x=78.625 //y=7.585 //x2=79.3 //y2=7.585
r1796 (  981 1219 ) resistor r=2.87058 //w=0.35 //l=0.085 //layer=li \
 //thickness=0.1 //x=79.335 //y=7.585 //x2=79.42 //y2=7.585
r1797 (  981 984 ) resistor r=1.22071 //w=0.367 //l=0.035 //layer=li \
 //thickness=0.1 //x=79.335 //y=7.585 //x2=79.3 //y2=7.585
r1798 (  973 1218 ) resistor r=4.23183 //w=0.7 //l=0.175 //layer=li \
 //thickness=0.1 //x=78.54 //y=7.41 //x2=78.54 //y2=7.585
r1799 (  973 1299 ) resistor r=56.4706 //w=0.187 //l=0.825 //layer=li \
 //thickness=0.1 //x=78.54 //y=7.41 //x2=78.54 //y2=6.585
r1800 (  970 1217 ) resistor r=5.29055 //w=0.35 //l=0.17 //layer=li \
 //thickness=0.1 //x=77.62 //y=7.585 //x2=77.45 //y2=7.585
r1801 (  970 972 ) resistor r=19.8801 //w=0.367 //l=0.57 //layer=li \
 //thickness=0.1 //x=77.62 //y=7.585 //x2=78.19 //y2=7.585
r1802 (  969 1218 ) resistor r=2.87058 //w=0.35 //l=0.085 //layer=li \
 //thickness=0.1 //x=78.455 //y=7.585 //x2=78.54 //y2=7.585
r1803 (  969 972 ) resistor r=9.24251 //w=0.367 //l=0.265 //layer=li \
 //thickness=0.1 //x=78.455 //y=7.585 //x2=78.19 //y2=7.585
r1804 (  964 1216 ) resistor r=2.87058 //w=0.35 //l=0.085 //layer=li \
 //thickness=0.1 //x=76.455 //y=7.585 //x2=76.37 //y2=7.585
r1805 (  964 966 ) resistor r=8.89373 //w=0.367 //l=0.255 //layer=li \
 //thickness=0.1 //x=76.455 //y=7.585 //x2=76.71 //y2=7.585
r1806 (  963 1217 ) resistor r=5.29055 //w=0.35 //l=0.17 //layer=li \
 //thickness=0.1 //x=77.28 //y=7.585 //x2=77.45 //y2=7.585
r1807 (  963 966 ) resistor r=19.8801 //w=0.367 //l=0.57 //layer=li \
 //thickness=0.1 //x=77.28 //y=7.585 //x2=76.71 //y2=7.585
r1808 (  957 1216 ) resistor r=4.23183 //w=0.7 //l=0.175 //layer=li \
 //thickness=0.1 //x=76.37 //y=7.41 //x2=76.37 //y2=7.585
r1809 (  957 1298 ) resistor r=33.1979 //w=0.187 //l=0.485 //layer=li \
 //thickness=0.1 //x=76.37 //y=7.41 //x2=76.37 //y2=6.925
r1810 (  954 1215 ) resistor r=2.87058 //w=0.35 //l=0.085 //layer=li \
 //thickness=0.1 //x=75.575 //y=7.585 //x2=75.49 //y2=7.585
r1811 (  954 956 ) resistor r=0.871935 //w=0.367 //l=0.025 //layer=li \
 //thickness=0.1 //x=75.575 //y=7.585 //x2=75.6 //y2=7.585
r1812 (  953 1216 ) resistor r=2.87058 //w=0.35 //l=0.085 //layer=li \
 //thickness=0.1 //x=76.285 //y=7.585 //x2=76.37 //y2=7.585
r1813 (  953 956 ) resistor r=23.891 //w=0.367 //l=0.685 //layer=li \
 //thickness=0.1 //x=76.285 //y=7.585 //x2=75.6 //y2=7.585
r1814 (  947 1215 ) resistor r=4.23183 //w=0.7 //l=0.175 //layer=li \
 //thickness=0.1 //x=75.49 //y=7.41 //x2=75.49 //y2=7.585
r1815 (  947 1297 ) resistor r=33.1979 //w=0.187 //l=0.485 //layer=li \
 //thickness=0.1 //x=75.49 //y=7.41 //x2=75.49 //y2=6.925
r1816 (  946 1214 ) resistor r=2.87058 //w=0.35 //l=0.085 //layer=li \
 //thickness=0.1 //x=74.695 //y=7.585 //x2=74.61 //y2=7.585
r1817 (  945 1215 ) resistor r=2.87058 //w=0.35 //l=0.085 //layer=li \
 //thickness=0.1 //x=75.405 //y=7.585 //x2=75.49 //y2=7.585
r1818 (  945 946 ) resistor r=24.7629 //w=0.367 //l=0.71 //layer=li \
 //thickness=0.1 //x=75.405 //y=7.585 //x2=74.695 //y2=7.585
r1819 (  939 1214 ) resistor r=4.23183 //w=0.7 //l=0.175 //layer=li \
 //thickness=0.1 //x=74.61 //y=7.41 //x2=74.61 //y2=7.585
r1820 (  939 1296 ) resistor r=33.1979 //w=0.187 //l=0.485 //layer=li \
 //thickness=0.1 //x=74.61 //y=7.41 //x2=74.61 //y2=6.925
r1821 (  936 1213 ) resistor r=2.87058 //w=0.35 //l=0.085 //layer=li \
 //thickness=0.1 //x=73.815 //y=7.585 //x2=73.73 //y2=7.585
r1822 (  936 938 ) resistor r=23.5422 //w=0.367 //l=0.675 //layer=li \
 //thickness=0.1 //x=73.815 //y=7.585 //x2=74.49 //y2=7.585
r1823 (  935 1214 ) resistor r=2.87058 //w=0.35 //l=0.085 //layer=li \
 //thickness=0.1 //x=74.525 //y=7.585 //x2=74.61 //y2=7.585
r1824 (  935 938 ) resistor r=1.22071 //w=0.367 //l=0.035 //layer=li \
 //thickness=0.1 //x=74.525 //y=7.585 //x2=74.49 //y2=7.585
r1825 (  927 1213 ) resistor r=4.23183 //w=0.7 //l=0.175 //layer=li \
 //thickness=0.1 //x=73.73 //y=7.41 //x2=73.73 //y2=7.585
r1826 (  927 1295 ) resistor r=56.4706 //w=0.187 //l=0.825 //layer=li \
 //thickness=0.1 //x=73.73 //y=7.41 //x2=73.73 //y2=6.585
r1827 (  924 1212 ) resistor r=5.29055 //w=0.35 //l=0.17 //layer=li \
 //thickness=0.1 //x=72.81 //y=7.585 //x2=72.64 //y2=7.585
r1828 (  924 926 ) resistor r=19.8801 //w=0.367 //l=0.57 //layer=li \
 //thickness=0.1 //x=72.81 //y=7.585 //x2=73.38 //y2=7.585
r1829 (  923 1213 ) resistor r=2.87058 //w=0.35 //l=0.085 //layer=li \
 //thickness=0.1 //x=73.645 //y=7.585 //x2=73.73 //y2=7.585
r1830 (  923 926 ) resistor r=9.24251 //w=0.367 //l=0.265 //layer=li \
 //thickness=0.1 //x=73.645 //y=7.585 //x2=73.38 //y2=7.585
r1831 (  918 1211 ) resistor r=2.87058 //w=0.35 //l=0.085 //layer=li \
 //thickness=0.1 //x=71.645 //y=7.585 //x2=71.56 //y2=7.585
r1832 (  918 920 ) resistor r=8.89373 //w=0.367 //l=0.255 //layer=li \
 //thickness=0.1 //x=71.645 //y=7.585 //x2=71.9 //y2=7.585
r1833 (  917 1212 ) resistor r=5.29055 //w=0.35 //l=0.17 //layer=li \
 //thickness=0.1 //x=72.47 //y=7.585 //x2=72.64 //y2=7.585
r1834 (  917 920 ) resistor r=19.8801 //w=0.367 //l=0.57 //layer=li \
 //thickness=0.1 //x=72.47 //y=7.585 //x2=71.9 //y2=7.585
r1835 (  911 1211 ) resistor r=4.23183 //w=0.7 //l=0.175 //layer=li \
 //thickness=0.1 //x=71.56 //y=7.41 //x2=71.56 //y2=7.585
r1836 (  911 1294 ) resistor r=33.1979 //w=0.187 //l=0.485 //layer=li \
 //thickness=0.1 //x=71.56 //y=7.41 //x2=71.56 //y2=6.925
r1837 (  908 1210 ) resistor r=2.87058 //w=0.35 //l=0.085 //layer=li \
 //thickness=0.1 //x=70.765 //y=7.585 //x2=70.68 //y2=7.585
r1838 (  908 910 ) resistor r=0.871935 //w=0.367 //l=0.025 //layer=li \
 //thickness=0.1 //x=70.765 //y=7.585 //x2=70.79 //y2=7.585
r1839 (  907 1211 ) resistor r=2.87058 //w=0.35 //l=0.085 //layer=li \
 //thickness=0.1 //x=71.475 //y=7.585 //x2=71.56 //y2=7.585
r1840 (  907 910 ) resistor r=23.891 //w=0.367 //l=0.685 //layer=li \
 //thickness=0.1 //x=71.475 //y=7.585 //x2=70.79 //y2=7.585
r1841 (  901 1210 ) resistor r=4.23183 //w=0.7 //l=0.175 //layer=li \
 //thickness=0.1 //x=70.68 //y=7.41 //x2=70.68 //y2=7.585
r1842 (  901 1293 ) resistor r=33.1979 //w=0.187 //l=0.485 //layer=li \
 //thickness=0.1 //x=70.68 //y=7.41 //x2=70.68 //y2=6.925
r1843 (  900 1209 ) resistor r=2.87058 //w=0.35 //l=0.085 //layer=li \
 //thickness=0.1 //x=69.885 //y=7.585 //x2=69.8 //y2=7.585
r1844 (  899 1210 ) resistor r=2.87058 //w=0.35 //l=0.085 //layer=li \
 //thickness=0.1 //x=70.595 //y=7.585 //x2=70.68 //y2=7.585
r1845 (  899 900 ) resistor r=24.7629 //w=0.367 //l=0.71 //layer=li \
 //thickness=0.1 //x=70.595 //y=7.585 //x2=69.885 //y2=7.585
r1846 (  893 1209 ) resistor r=4.23183 //w=0.7 //l=0.175 //layer=li \
 //thickness=0.1 //x=69.8 //y=7.41 //x2=69.8 //y2=7.585
r1847 (  893 1292 ) resistor r=33.1979 //w=0.187 //l=0.485 //layer=li \
 //thickness=0.1 //x=69.8 //y=7.41 //x2=69.8 //y2=6.925
r1848 (  890 1208 ) resistor r=2.87058 //w=0.35 //l=0.085 //layer=li \
 //thickness=0.1 //x=69.005 //y=7.585 //x2=68.92 //y2=7.585
r1849 (  890 892 ) resistor r=23.5422 //w=0.367 //l=0.675 //layer=li \
 //thickness=0.1 //x=69.005 //y=7.585 //x2=69.68 //y2=7.585
r1850 (  889 1209 ) resistor r=2.87058 //w=0.35 //l=0.085 //layer=li \
 //thickness=0.1 //x=69.715 //y=7.585 //x2=69.8 //y2=7.585
r1851 (  889 892 ) resistor r=1.22071 //w=0.367 //l=0.035 //layer=li \
 //thickness=0.1 //x=69.715 //y=7.585 //x2=69.68 //y2=7.585
r1852 (  881 1208 ) resistor r=4.23183 //w=0.7 //l=0.175 //layer=li \
 //thickness=0.1 //x=68.92 //y=7.41 //x2=68.92 //y2=7.585
r1853 (  881 1291 ) resistor r=56.4706 //w=0.187 //l=0.825 //layer=li \
 //thickness=0.1 //x=68.92 //y=7.41 //x2=68.92 //y2=6.585
r1854 (  878 1207 ) resistor r=5.29055 //w=0.35 //l=0.17 //layer=li \
 //thickness=0.1 //x=68 //y=7.585 //x2=67.83 //y2=7.585
r1855 (  878 880 ) resistor r=19.8801 //w=0.367 //l=0.57 //layer=li \
 //thickness=0.1 //x=68 //y=7.585 //x2=68.57 //y2=7.585
r1856 (  877 1208 ) resistor r=2.87058 //w=0.35 //l=0.085 //layer=li \
 //thickness=0.1 //x=68.835 //y=7.585 //x2=68.92 //y2=7.585
r1857 (  877 880 ) resistor r=9.24251 //w=0.367 //l=0.265 //layer=li \
 //thickness=0.1 //x=68.835 //y=7.585 //x2=68.57 //y2=7.585
r1858 (  872 1206 ) resistor r=2.87058 //w=0.35 //l=0.085 //layer=li \
 //thickness=0.1 //x=66.835 //y=7.585 //x2=66.75 //y2=7.585
r1859 (  872 874 ) resistor r=8.89373 //w=0.367 //l=0.255 //layer=li \
 //thickness=0.1 //x=66.835 //y=7.585 //x2=67.09 //y2=7.585
r1860 (  871 1207 ) resistor r=5.29055 //w=0.35 //l=0.17 //layer=li \
 //thickness=0.1 //x=67.66 //y=7.585 //x2=67.83 //y2=7.585
r1861 (  871 874 ) resistor r=19.8801 //w=0.367 //l=0.57 //layer=li \
 //thickness=0.1 //x=67.66 //y=7.585 //x2=67.09 //y2=7.585
r1862 (  865 1206 ) resistor r=4.23183 //w=0.7 //l=0.175 //layer=li \
 //thickness=0.1 //x=66.75 //y=7.41 //x2=66.75 //y2=7.585
r1863 (  865 1290 ) resistor r=33.1979 //w=0.187 //l=0.485 //layer=li \
 //thickness=0.1 //x=66.75 //y=7.41 //x2=66.75 //y2=6.925
r1864 (  862 1205 ) resistor r=2.87058 //w=0.35 //l=0.085 //layer=li \
 //thickness=0.1 //x=65.955 //y=7.585 //x2=65.87 //y2=7.585
r1865 (  862 864 ) resistor r=0.871935 //w=0.367 //l=0.025 //layer=li \
 //thickness=0.1 //x=65.955 //y=7.585 //x2=65.98 //y2=7.585
r1866 (  861 1206 ) resistor r=2.87058 //w=0.35 //l=0.085 //layer=li \
 //thickness=0.1 //x=66.665 //y=7.585 //x2=66.75 //y2=7.585
r1867 (  861 864 ) resistor r=23.891 //w=0.367 //l=0.685 //layer=li \
 //thickness=0.1 //x=66.665 //y=7.585 //x2=65.98 //y2=7.585
r1868 (  855 1205 ) resistor r=4.23183 //w=0.7 //l=0.175 //layer=li \
 //thickness=0.1 //x=65.87 //y=7.41 //x2=65.87 //y2=7.585
r1869 (  855 1289 ) resistor r=33.1979 //w=0.187 //l=0.485 //layer=li \
 //thickness=0.1 //x=65.87 //y=7.41 //x2=65.87 //y2=6.925
r1870 (  854 1204 ) resistor r=2.87058 //w=0.35 //l=0.085 //layer=li \
 //thickness=0.1 //x=65.075 //y=7.585 //x2=64.99 //y2=7.585
r1871 (  853 1205 ) resistor r=2.87058 //w=0.35 //l=0.085 //layer=li \
 //thickness=0.1 //x=65.785 //y=7.585 //x2=65.87 //y2=7.585
r1872 (  853 854 ) resistor r=24.7629 //w=0.367 //l=0.71 //layer=li \
 //thickness=0.1 //x=65.785 //y=7.585 //x2=65.075 //y2=7.585
r1873 (  847 1204 ) resistor r=4.23183 //w=0.7 //l=0.175 //layer=li \
 //thickness=0.1 //x=64.99 //y=7.41 //x2=64.99 //y2=7.585
r1874 (  847 1288 ) resistor r=33.1979 //w=0.187 //l=0.485 //layer=li \
 //thickness=0.1 //x=64.99 //y=7.41 //x2=64.99 //y2=6.925
r1875 (  844 1203 ) resistor r=2.87058 //w=0.35 //l=0.085 //layer=li \
 //thickness=0.1 //x=64.195 //y=7.585 //x2=64.11 //y2=7.585
r1876 (  844 846 ) resistor r=23.5422 //w=0.367 //l=0.675 //layer=li \
 //thickness=0.1 //x=64.195 //y=7.585 //x2=64.87 //y2=7.585
r1877 (  843 1204 ) resistor r=2.87058 //w=0.35 //l=0.085 //layer=li \
 //thickness=0.1 //x=64.905 //y=7.585 //x2=64.99 //y2=7.585
r1878 (  843 846 ) resistor r=1.22071 //w=0.367 //l=0.035 //layer=li \
 //thickness=0.1 //x=64.905 //y=7.585 //x2=64.87 //y2=7.585
r1879 (  835 1203 ) resistor r=4.23183 //w=0.7 //l=0.175 //layer=li \
 //thickness=0.1 //x=64.11 //y=7.41 //x2=64.11 //y2=7.585
r1880 (  835 1287 ) resistor r=56.4706 //w=0.187 //l=0.825 //layer=li \
 //thickness=0.1 //x=64.11 //y=7.41 //x2=64.11 //y2=6.585
r1881 (  832 1202 ) resistor r=5.29055 //w=0.35 //l=0.17 //layer=li \
 //thickness=0.1 //x=63.19 //y=7.585 //x2=63.02 //y2=7.585
r1882 (  832 834 ) resistor r=19.8801 //w=0.367 //l=0.57 //layer=li \
 //thickness=0.1 //x=63.19 //y=7.585 //x2=63.76 //y2=7.585
r1883 (  831 1203 ) resistor r=2.87058 //w=0.35 //l=0.085 //layer=li \
 //thickness=0.1 //x=64.025 //y=7.585 //x2=64.11 //y2=7.585
r1884 (  831 834 ) resistor r=9.24251 //w=0.367 //l=0.265 //layer=li \
 //thickness=0.1 //x=64.025 //y=7.585 //x2=63.76 //y2=7.585
r1885 (  826 1201 ) resistor r=2.87058 //w=0.35 //l=0.085 //layer=li \
 //thickness=0.1 //x=62.025 //y=7.585 //x2=61.94 //y2=7.585
r1886 (  826 828 ) resistor r=8.89373 //w=0.367 //l=0.255 //layer=li \
 //thickness=0.1 //x=62.025 //y=7.585 //x2=62.28 //y2=7.585
r1887 (  825 1202 ) resistor r=5.29055 //w=0.35 //l=0.17 //layer=li \
 //thickness=0.1 //x=62.85 //y=7.585 //x2=63.02 //y2=7.585
r1888 (  825 828 ) resistor r=19.8801 //w=0.367 //l=0.57 //layer=li \
 //thickness=0.1 //x=62.85 //y=7.585 //x2=62.28 //y2=7.585
r1889 (  819 1201 ) resistor r=4.23183 //w=0.7 //l=0.175 //layer=li \
 //thickness=0.1 //x=61.94 //y=7.41 //x2=61.94 //y2=7.585
r1890 (  819 1286 ) resistor r=33.1979 //w=0.187 //l=0.485 //layer=li \
 //thickness=0.1 //x=61.94 //y=7.41 //x2=61.94 //y2=6.925
r1891 (  816 1200 ) resistor r=2.87058 //w=0.35 //l=0.085 //layer=li \
 //thickness=0.1 //x=61.145 //y=7.585 //x2=61.06 //y2=7.585
r1892 (  816 818 ) resistor r=0.871935 //w=0.367 //l=0.025 //layer=li \
 //thickness=0.1 //x=61.145 //y=7.585 //x2=61.17 //y2=7.585
r1893 (  815 1201 ) resistor r=2.87058 //w=0.35 //l=0.085 //layer=li \
 //thickness=0.1 //x=61.855 //y=7.585 //x2=61.94 //y2=7.585
r1894 (  815 818 ) resistor r=23.891 //w=0.367 //l=0.685 //layer=li \
 //thickness=0.1 //x=61.855 //y=7.585 //x2=61.17 //y2=7.585
r1895 (  809 1200 ) resistor r=4.23183 //w=0.7 //l=0.175 //layer=li \
 //thickness=0.1 //x=61.06 //y=7.41 //x2=61.06 //y2=7.585
r1896 (  809 1285 ) resistor r=33.1979 //w=0.187 //l=0.485 //layer=li \
 //thickness=0.1 //x=61.06 //y=7.41 //x2=61.06 //y2=6.925
r1897 (  808 1199 ) resistor r=2.87058 //w=0.35 //l=0.085 //layer=li \
 //thickness=0.1 //x=60.265 //y=7.585 //x2=60.18 //y2=7.585
r1898 (  807 1200 ) resistor r=2.87058 //w=0.35 //l=0.085 //layer=li \
 //thickness=0.1 //x=60.975 //y=7.585 //x2=61.06 //y2=7.585
r1899 (  807 808 ) resistor r=24.7629 //w=0.367 //l=0.71 //layer=li \
 //thickness=0.1 //x=60.975 //y=7.585 //x2=60.265 //y2=7.585
r1900 (  801 1199 ) resistor r=4.23183 //w=0.7 //l=0.175 //layer=li \
 //thickness=0.1 //x=60.18 //y=7.41 //x2=60.18 //y2=7.585
r1901 (  801 1284 ) resistor r=33.1979 //w=0.187 //l=0.485 //layer=li \
 //thickness=0.1 //x=60.18 //y=7.41 //x2=60.18 //y2=6.925
r1902 (  798 1198 ) resistor r=2.87058 //w=0.35 //l=0.085 //layer=li \
 //thickness=0.1 //x=59.385 //y=7.585 //x2=59.3 //y2=7.585
r1903 (  798 800 ) resistor r=23.5422 //w=0.367 //l=0.675 //layer=li \
 //thickness=0.1 //x=59.385 //y=7.585 //x2=60.06 //y2=7.585
r1904 (  797 1199 ) resistor r=2.87058 //w=0.35 //l=0.085 //layer=li \
 //thickness=0.1 //x=60.095 //y=7.585 //x2=60.18 //y2=7.585
r1905 (  797 800 ) resistor r=1.22071 //w=0.367 //l=0.035 //layer=li \
 //thickness=0.1 //x=60.095 //y=7.585 //x2=60.06 //y2=7.585
r1906 (  789 1198 ) resistor r=4.23183 //w=0.7 //l=0.175 //layer=li \
 //thickness=0.1 //x=59.3 //y=7.41 //x2=59.3 //y2=7.585
r1907 (  789 1283 ) resistor r=56.4706 //w=0.187 //l=0.825 //layer=li \
 //thickness=0.1 //x=59.3 //y=7.41 //x2=59.3 //y2=6.585
r1908 (  786 1197 ) resistor r=5.29055 //w=0.35 //l=0.17 //layer=li \
 //thickness=0.1 //x=58.38 //y=7.585 //x2=58.21 //y2=7.585
r1909 (  786 788 ) resistor r=19.8801 //w=0.367 //l=0.57 //layer=li \
 //thickness=0.1 //x=58.38 //y=7.585 //x2=58.95 //y2=7.585
r1910 (  785 1198 ) resistor r=2.87058 //w=0.35 //l=0.085 //layer=li \
 //thickness=0.1 //x=59.215 //y=7.585 //x2=59.3 //y2=7.585
r1911 (  785 788 ) resistor r=9.24251 //w=0.367 //l=0.265 //layer=li \
 //thickness=0.1 //x=59.215 //y=7.585 //x2=58.95 //y2=7.585
r1912 (  780 1196 ) resistor r=2.87058 //w=0.35 //l=0.085 //layer=li \
 //thickness=0.1 //x=57.215 //y=7.585 //x2=57.13 //y2=7.585
r1913 (  780 782 ) resistor r=8.89373 //w=0.367 //l=0.255 //layer=li \
 //thickness=0.1 //x=57.215 //y=7.585 //x2=57.47 //y2=7.585
r1914 (  779 1197 ) resistor r=5.29055 //w=0.35 //l=0.17 //layer=li \
 //thickness=0.1 //x=58.04 //y=7.585 //x2=58.21 //y2=7.585
r1915 (  779 782 ) resistor r=19.8801 //w=0.367 //l=0.57 //layer=li \
 //thickness=0.1 //x=58.04 //y=7.585 //x2=57.47 //y2=7.585
r1916 (  773 1196 ) resistor r=4.23183 //w=0.7 //l=0.175 //layer=li \
 //thickness=0.1 //x=57.13 //y=7.41 //x2=57.13 //y2=7.585
r1917 (  773 1282 ) resistor r=33.1979 //w=0.187 //l=0.485 //layer=li \
 //thickness=0.1 //x=57.13 //y=7.41 //x2=57.13 //y2=6.925
r1918 (  770 1195 ) resistor r=2.87058 //w=0.35 //l=0.085 //layer=li \
 //thickness=0.1 //x=56.335 //y=7.585 //x2=56.25 //y2=7.585
r1919 (  770 772 ) resistor r=0.871935 //w=0.367 //l=0.025 //layer=li \
 //thickness=0.1 //x=56.335 //y=7.585 //x2=56.36 //y2=7.585
r1920 (  769 1196 ) resistor r=2.87058 //w=0.35 //l=0.085 //layer=li \
 //thickness=0.1 //x=57.045 //y=7.585 //x2=57.13 //y2=7.585
r1921 (  769 772 ) resistor r=23.891 //w=0.367 //l=0.685 //layer=li \
 //thickness=0.1 //x=57.045 //y=7.585 //x2=56.36 //y2=7.585
r1922 (  763 1195 ) resistor r=4.23183 //w=0.7 //l=0.175 //layer=li \
 //thickness=0.1 //x=56.25 //y=7.41 //x2=56.25 //y2=7.585
r1923 (  763 1281 ) resistor r=33.1979 //w=0.187 //l=0.485 //layer=li \
 //thickness=0.1 //x=56.25 //y=7.41 //x2=56.25 //y2=6.925
r1924 (  762 1194 ) resistor r=2.87058 //w=0.35 //l=0.085 //layer=li \
 //thickness=0.1 //x=55.455 //y=7.585 //x2=55.37 //y2=7.585
r1925 (  761 1195 ) resistor r=2.87058 //w=0.35 //l=0.085 //layer=li \
 //thickness=0.1 //x=56.165 //y=7.585 //x2=56.25 //y2=7.585
r1926 (  761 762 ) resistor r=24.7629 //w=0.367 //l=0.71 //layer=li \
 //thickness=0.1 //x=56.165 //y=7.585 //x2=55.455 //y2=7.585
r1927 (  755 1194 ) resistor r=4.23183 //w=0.7 //l=0.175 //layer=li \
 //thickness=0.1 //x=55.37 //y=7.41 //x2=55.37 //y2=7.585
r1928 (  755 1280 ) resistor r=33.1979 //w=0.187 //l=0.485 //layer=li \
 //thickness=0.1 //x=55.37 //y=7.41 //x2=55.37 //y2=6.925
r1929 (  752 1193 ) resistor r=2.87058 //w=0.35 //l=0.085 //layer=li \
 //thickness=0.1 //x=54.575 //y=7.585 //x2=54.49 //y2=7.585
r1930 (  752 754 ) resistor r=23.5422 //w=0.367 //l=0.675 //layer=li \
 //thickness=0.1 //x=54.575 //y=7.585 //x2=55.25 //y2=7.585
r1931 (  751 1194 ) resistor r=2.87058 //w=0.35 //l=0.085 //layer=li \
 //thickness=0.1 //x=55.285 //y=7.585 //x2=55.37 //y2=7.585
r1932 (  751 754 ) resistor r=1.22071 //w=0.367 //l=0.035 //layer=li \
 //thickness=0.1 //x=55.285 //y=7.585 //x2=55.25 //y2=7.585
r1933 (  743 1193 ) resistor r=4.23183 //w=0.7 //l=0.175 //layer=li \
 //thickness=0.1 //x=54.49 //y=7.41 //x2=54.49 //y2=7.585
r1934 (  743 1279 ) resistor r=56.4706 //w=0.187 //l=0.825 //layer=li \
 //thickness=0.1 //x=54.49 //y=7.41 //x2=54.49 //y2=6.585
r1935 (  740 1192 ) resistor r=5.29055 //w=0.35 //l=0.17 //layer=li \
 //thickness=0.1 //x=53.57 //y=7.585 //x2=53.4 //y2=7.585
r1936 (  740 742 ) resistor r=19.8801 //w=0.367 //l=0.57 //layer=li \
 //thickness=0.1 //x=53.57 //y=7.585 //x2=54.14 //y2=7.585
r1937 (  739 1193 ) resistor r=2.87058 //w=0.35 //l=0.085 //layer=li \
 //thickness=0.1 //x=54.405 //y=7.585 //x2=54.49 //y2=7.585
r1938 (  739 742 ) resistor r=9.24251 //w=0.367 //l=0.265 //layer=li \
 //thickness=0.1 //x=54.405 //y=7.585 //x2=54.14 //y2=7.585
r1939 (  734 1191 ) resistor r=2.87058 //w=0.35 //l=0.085 //layer=li \
 //thickness=0.1 //x=52.405 //y=7.585 //x2=52.32 //y2=7.585
r1940 (  734 736 ) resistor r=8.89373 //w=0.367 //l=0.255 //layer=li \
 //thickness=0.1 //x=52.405 //y=7.585 //x2=52.66 //y2=7.585
r1941 (  733 1192 ) resistor r=5.29055 //w=0.35 //l=0.17 //layer=li \
 //thickness=0.1 //x=53.23 //y=7.585 //x2=53.4 //y2=7.585
r1942 (  733 736 ) resistor r=19.8801 //w=0.367 //l=0.57 //layer=li \
 //thickness=0.1 //x=53.23 //y=7.585 //x2=52.66 //y2=7.585
r1943 (  727 1191 ) resistor r=4.23183 //w=0.7 //l=0.175 //layer=li \
 //thickness=0.1 //x=52.32 //y=7.41 //x2=52.32 //y2=7.585
r1944 (  727 1278 ) resistor r=33.1979 //w=0.187 //l=0.485 //layer=li \
 //thickness=0.1 //x=52.32 //y=7.41 //x2=52.32 //y2=6.925
r1945 (  724 1190 ) resistor r=2.87058 //w=0.35 //l=0.085 //layer=li \
 //thickness=0.1 //x=51.525 //y=7.585 //x2=51.44 //y2=7.585
r1946 (  724 726 ) resistor r=0.871935 //w=0.367 //l=0.025 //layer=li \
 //thickness=0.1 //x=51.525 //y=7.585 //x2=51.55 //y2=7.585
r1947 (  723 1191 ) resistor r=2.87058 //w=0.35 //l=0.085 //layer=li \
 //thickness=0.1 //x=52.235 //y=7.585 //x2=52.32 //y2=7.585
r1948 (  723 726 ) resistor r=23.891 //w=0.367 //l=0.685 //layer=li \
 //thickness=0.1 //x=52.235 //y=7.585 //x2=51.55 //y2=7.585
r1949 (  717 1190 ) resistor r=4.23183 //w=0.7 //l=0.175 //layer=li \
 //thickness=0.1 //x=51.44 //y=7.41 //x2=51.44 //y2=7.585
r1950 (  717 1277 ) resistor r=33.1979 //w=0.187 //l=0.485 //layer=li \
 //thickness=0.1 //x=51.44 //y=7.41 //x2=51.44 //y2=6.925
r1951 (  716 1189 ) resistor r=2.87058 //w=0.35 //l=0.085 //layer=li \
 //thickness=0.1 //x=50.645 //y=7.585 //x2=50.56 //y2=7.585
r1952 (  715 1190 ) resistor r=2.87058 //w=0.35 //l=0.085 //layer=li \
 //thickness=0.1 //x=51.355 //y=7.585 //x2=51.44 //y2=7.585
r1953 (  715 716 ) resistor r=24.7629 //w=0.367 //l=0.71 //layer=li \
 //thickness=0.1 //x=51.355 //y=7.585 //x2=50.645 //y2=7.585
r1954 (  709 1189 ) resistor r=4.23183 //w=0.7 //l=0.175 //layer=li \
 //thickness=0.1 //x=50.56 //y=7.41 //x2=50.56 //y2=7.585
r1955 (  709 1276 ) resistor r=33.1979 //w=0.187 //l=0.485 //layer=li \
 //thickness=0.1 //x=50.56 //y=7.41 //x2=50.56 //y2=6.925
r1956 (  706 1188 ) resistor r=2.87058 //w=0.35 //l=0.085 //layer=li \
 //thickness=0.1 //x=49.765 //y=7.585 //x2=49.68 //y2=7.585
r1957 (  706 708 ) resistor r=23.5422 //w=0.367 //l=0.675 //layer=li \
 //thickness=0.1 //x=49.765 //y=7.585 //x2=50.44 //y2=7.585
r1958 (  705 1189 ) resistor r=2.87058 //w=0.35 //l=0.085 //layer=li \
 //thickness=0.1 //x=50.475 //y=7.585 //x2=50.56 //y2=7.585
r1959 (  705 708 ) resistor r=1.22071 //w=0.367 //l=0.035 //layer=li \
 //thickness=0.1 //x=50.475 //y=7.585 //x2=50.44 //y2=7.585
r1960 (  697 1188 ) resistor r=4.23183 //w=0.7 //l=0.175 //layer=li \
 //thickness=0.1 //x=49.68 //y=7.41 //x2=49.68 //y2=7.585
r1961 (  697 1275 ) resistor r=56.4706 //w=0.187 //l=0.825 //layer=li \
 //thickness=0.1 //x=49.68 //y=7.41 //x2=49.68 //y2=6.585
r1962 (  694 1187 ) resistor r=5.29055 //w=0.35 //l=0.17 //layer=li \
 //thickness=0.1 //x=48.76 //y=7.585 //x2=48.59 //y2=7.585
r1963 (  694 696 ) resistor r=19.8801 //w=0.367 //l=0.57 //layer=li \
 //thickness=0.1 //x=48.76 //y=7.585 //x2=49.33 //y2=7.585
r1964 (  693 1188 ) resistor r=2.87058 //w=0.35 //l=0.085 //layer=li \
 //thickness=0.1 //x=49.595 //y=7.585 //x2=49.68 //y2=7.585
r1965 (  693 696 ) resistor r=9.24251 //w=0.367 //l=0.265 //layer=li \
 //thickness=0.1 //x=49.595 //y=7.585 //x2=49.33 //y2=7.585
r1966 (  688 1186 ) resistor r=2.87058 //w=0.35 //l=0.085 //layer=li \
 //thickness=0.1 //x=47.595 //y=7.585 //x2=47.51 //y2=7.585
r1967 (  688 690 ) resistor r=8.89373 //w=0.367 //l=0.255 //layer=li \
 //thickness=0.1 //x=47.595 //y=7.585 //x2=47.85 //y2=7.585
r1968 (  687 1187 ) resistor r=5.29055 //w=0.35 //l=0.17 //layer=li \
 //thickness=0.1 //x=48.42 //y=7.585 //x2=48.59 //y2=7.585
r1969 (  687 690 ) resistor r=19.8801 //w=0.367 //l=0.57 //layer=li \
 //thickness=0.1 //x=48.42 //y=7.585 //x2=47.85 //y2=7.585
r1970 (  681 1186 ) resistor r=4.23183 //w=0.7 //l=0.175 //layer=li \
 //thickness=0.1 //x=47.51 //y=7.41 //x2=47.51 //y2=7.585
r1971 (  681 1274 ) resistor r=33.1979 //w=0.187 //l=0.485 //layer=li \
 //thickness=0.1 //x=47.51 //y=7.41 //x2=47.51 //y2=6.925
r1972 (  678 1185 ) resistor r=2.87058 //w=0.35 //l=0.085 //layer=li \
 //thickness=0.1 //x=46.715 //y=7.585 //x2=46.63 //y2=7.585
r1973 (  678 680 ) resistor r=0.871935 //w=0.367 //l=0.025 //layer=li \
 //thickness=0.1 //x=46.715 //y=7.585 //x2=46.74 //y2=7.585
r1974 (  677 1186 ) resistor r=2.87058 //w=0.35 //l=0.085 //layer=li \
 //thickness=0.1 //x=47.425 //y=7.585 //x2=47.51 //y2=7.585
r1975 (  677 680 ) resistor r=23.891 //w=0.367 //l=0.685 //layer=li \
 //thickness=0.1 //x=47.425 //y=7.585 //x2=46.74 //y2=7.585
r1976 (  671 1185 ) resistor r=4.23183 //w=0.7 //l=0.175 //layer=li \
 //thickness=0.1 //x=46.63 //y=7.41 //x2=46.63 //y2=7.585
r1977 (  671 1273 ) resistor r=33.1979 //w=0.187 //l=0.485 //layer=li \
 //thickness=0.1 //x=46.63 //y=7.41 //x2=46.63 //y2=6.925
r1978 (  670 1184 ) resistor r=2.87058 //w=0.35 //l=0.085 //layer=li \
 //thickness=0.1 //x=45.835 //y=7.585 //x2=45.75 //y2=7.585
r1979 (  669 1185 ) resistor r=2.87058 //w=0.35 //l=0.085 //layer=li \
 //thickness=0.1 //x=46.545 //y=7.585 //x2=46.63 //y2=7.585
r1980 (  669 670 ) resistor r=24.7629 //w=0.367 //l=0.71 //layer=li \
 //thickness=0.1 //x=46.545 //y=7.585 //x2=45.835 //y2=7.585
r1981 (  663 1184 ) resistor r=4.23183 //w=0.7 //l=0.175 //layer=li \
 //thickness=0.1 //x=45.75 //y=7.41 //x2=45.75 //y2=7.585
r1982 (  663 1272 ) resistor r=33.1979 //w=0.187 //l=0.485 //layer=li \
 //thickness=0.1 //x=45.75 //y=7.41 //x2=45.75 //y2=6.925
r1983 (  660 1183 ) resistor r=2.87058 //w=0.35 //l=0.085 //layer=li \
 //thickness=0.1 //x=44.955 //y=7.585 //x2=44.87 //y2=7.585
r1984 (  660 662 ) resistor r=23.5422 //w=0.367 //l=0.675 //layer=li \
 //thickness=0.1 //x=44.955 //y=7.585 //x2=45.63 //y2=7.585
r1985 (  659 1184 ) resistor r=2.87058 //w=0.35 //l=0.085 //layer=li \
 //thickness=0.1 //x=45.665 //y=7.585 //x2=45.75 //y2=7.585
r1986 (  659 662 ) resistor r=1.22071 //w=0.367 //l=0.035 //layer=li \
 //thickness=0.1 //x=45.665 //y=7.585 //x2=45.63 //y2=7.585
r1987 (  651 1183 ) resistor r=4.23183 //w=0.7 //l=0.175 //layer=li \
 //thickness=0.1 //x=44.87 //y=7.41 //x2=44.87 //y2=7.585
r1988 (  651 1271 ) resistor r=56.4706 //w=0.187 //l=0.825 //layer=li \
 //thickness=0.1 //x=44.87 //y=7.41 //x2=44.87 //y2=6.585
r1989 (  648 1182 ) resistor r=5.29055 //w=0.35 //l=0.17 //layer=li \
 //thickness=0.1 //x=43.95 //y=7.585 //x2=43.78 //y2=7.585
r1990 (  648 650 ) resistor r=19.8801 //w=0.367 //l=0.57 //layer=li \
 //thickness=0.1 //x=43.95 //y=7.585 //x2=44.52 //y2=7.585
r1991 (  647 1183 ) resistor r=2.87058 //w=0.35 //l=0.085 //layer=li \
 //thickness=0.1 //x=44.785 //y=7.585 //x2=44.87 //y2=7.585
r1992 (  647 650 ) resistor r=9.24251 //w=0.367 //l=0.265 //layer=li \
 //thickness=0.1 //x=44.785 //y=7.585 //x2=44.52 //y2=7.585
r1993 (  642 1181 ) resistor r=2.87058 //w=0.35 //l=0.085 //layer=li \
 //thickness=0.1 //x=42.785 //y=7.585 //x2=42.7 //y2=7.585
r1994 (  642 644 ) resistor r=8.89373 //w=0.367 //l=0.255 //layer=li \
 //thickness=0.1 //x=42.785 //y=7.585 //x2=43.04 //y2=7.585
r1995 (  641 1182 ) resistor r=5.29055 //w=0.35 //l=0.17 //layer=li \
 //thickness=0.1 //x=43.61 //y=7.585 //x2=43.78 //y2=7.585
r1996 (  641 644 ) resistor r=19.8801 //w=0.367 //l=0.57 //layer=li \
 //thickness=0.1 //x=43.61 //y=7.585 //x2=43.04 //y2=7.585
r1997 (  635 1181 ) resistor r=4.23183 //w=0.7 //l=0.175 //layer=li \
 //thickness=0.1 //x=42.7 //y=7.41 //x2=42.7 //y2=7.585
r1998 (  635 1270 ) resistor r=33.1979 //w=0.187 //l=0.485 //layer=li \
 //thickness=0.1 //x=42.7 //y=7.41 //x2=42.7 //y2=6.925
r1999 (  632 1180 ) resistor r=2.87058 //w=0.35 //l=0.085 //layer=li \
 //thickness=0.1 //x=41.905 //y=7.585 //x2=41.82 //y2=7.585
r2000 (  632 634 ) resistor r=0.871935 //w=0.367 //l=0.025 //layer=li \
 //thickness=0.1 //x=41.905 //y=7.585 //x2=41.93 //y2=7.585
r2001 (  631 1181 ) resistor r=2.87058 //w=0.35 //l=0.085 //layer=li \
 //thickness=0.1 //x=42.615 //y=7.585 //x2=42.7 //y2=7.585
r2002 (  631 634 ) resistor r=23.891 //w=0.367 //l=0.685 //layer=li \
 //thickness=0.1 //x=42.615 //y=7.585 //x2=41.93 //y2=7.585
r2003 (  625 1180 ) resistor r=4.23183 //w=0.7 //l=0.175 //layer=li \
 //thickness=0.1 //x=41.82 //y=7.41 //x2=41.82 //y2=7.585
r2004 (  625 1269 ) resistor r=33.1979 //w=0.187 //l=0.485 //layer=li \
 //thickness=0.1 //x=41.82 //y=7.41 //x2=41.82 //y2=6.925
r2005 (  624 1179 ) resistor r=2.87058 //w=0.35 //l=0.085 //layer=li \
 //thickness=0.1 //x=41.025 //y=7.585 //x2=40.94 //y2=7.585
r2006 (  623 1180 ) resistor r=2.87058 //w=0.35 //l=0.085 //layer=li \
 //thickness=0.1 //x=41.735 //y=7.585 //x2=41.82 //y2=7.585
r2007 (  623 624 ) resistor r=24.7629 //w=0.367 //l=0.71 //layer=li \
 //thickness=0.1 //x=41.735 //y=7.585 //x2=41.025 //y2=7.585
r2008 (  617 1179 ) resistor r=4.23183 //w=0.7 //l=0.175 //layer=li \
 //thickness=0.1 //x=40.94 //y=7.41 //x2=40.94 //y2=7.585
r2009 (  617 1268 ) resistor r=33.1979 //w=0.187 //l=0.485 //layer=li \
 //thickness=0.1 //x=40.94 //y=7.41 //x2=40.94 //y2=6.925
r2010 (  614 1178 ) resistor r=2.87058 //w=0.35 //l=0.085 //layer=li \
 //thickness=0.1 //x=40.145 //y=7.585 //x2=40.06 //y2=7.585
r2011 (  614 616 ) resistor r=23.5422 //w=0.367 //l=0.675 //layer=li \
 //thickness=0.1 //x=40.145 //y=7.585 //x2=40.82 //y2=7.585
r2012 (  613 1179 ) resistor r=2.87058 //w=0.35 //l=0.085 //layer=li \
 //thickness=0.1 //x=40.855 //y=7.585 //x2=40.94 //y2=7.585
r2013 (  613 616 ) resistor r=1.22071 //w=0.367 //l=0.035 //layer=li \
 //thickness=0.1 //x=40.855 //y=7.585 //x2=40.82 //y2=7.585
r2014 (  605 1178 ) resistor r=4.23183 //w=0.7 //l=0.175 //layer=li \
 //thickness=0.1 //x=40.06 //y=7.41 //x2=40.06 //y2=7.585
r2015 (  605 1267 ) resistor r=56.4706 //w=0.187 //l=0.825 //layer=li \
 //thickness=0.1 //x=40.06 //y=7.41 //x2=40.06 //y2=6.585
r2016 (  602 1177 ) resistor r=5.29055 //w=0.35 //l=0.17 //layer=li \
 //thickness=0.1 //x=39.14 //y=7.585 //x2=38.97 //y2=7.585
r2017 (  602 604 ) resistor r=19.8801 //w=0.367 //l=0.57 //layer=li \
 //thickness=0.1 //x=39.14 //y=7.585 //x2=39.71 //y2=7.585
r2018 (  601 1178 ) resistor r=2.87058 //w=0.35 //l=0.085 //layer=li \
 //thickness=0.1 //x=39.975 //y=7.585 //x2=40.06 //y2=7.585
r2019 (  601 604 ) resistor r=9.24251 //w=0.367 //l=0.265 //layer=li \
 //thickness=0.1 //x=39.975 //y=7.585 //x2=39.71 //y2=7.585
r2020 (  596 1176 ) resistor r=2.87058 //w=0.35 //l=0.085 //layer=li \
 //thickness=0.1 //x=37.975 //y=7.585 //x2=37.89 //y2=7.585
r2021 (  596 598 ) resistor r=8.89373 //w=0.367 //l=0.255 //layer=li \
 //thickness=0.1 //x=37.975 //y=7.585 //x2=38.23 //y2=7.585
r2022 (  595 1177 ) resistor r=5.29055 //w=0.35 //l=0.17 //layer=li \
 //thickness=0.1 //x=38.8 //y=7.585 //x2=38.97 //y2=7.585
r2023 (  595 598 ) resistor r=19.8801 //w=0.367 //l=0.57 //layer=li \
 //thickness=0.1 //x=38.8 //y=7.585 //x2=38.23 //y2=7.585
r2024 (  589 1176 ) resistor r=4.23183 //w=0.7 //l=0.175 //layer=li \
 //thickness=0.1 //x=37.89 //y=7.41 //x2=37.89 //y2=7.585
r2025 (  589 1266 ) resistor r=33.1979 //w=0.187 //l=0.485 //layer=li \
 //thickness=0.1 //x=37.89 //y=7.41 //x2=37.89 //y2=6.925
r2026 (  586 1175 ) resistor r=2.87058 //w=0.35 //l=0.085 //layer=li \
 //thickness=0.1 //x=37.095 //y=7.585 //x2=37.01 //y2=7.585
r2027 (  586 588 ) resistor r=0.871935 //w=0.367 //l=0.025 //layer=li \
 //thickness=0.1 //x=37.095 //y=7.585 //x2=37.12 //y2=7.585
r2028 (  585 1176 ) resistor r=2.87058 //w=0.35 //l=0.085 //layer=li \
 //thickness=0.1 //x=37.805 //y=7.585 //x2=37.89 //y2=7.585
r2029 (  585 588 ) resistor r=23.891 //w=0.367 //l=0.685 //layer=li \
 //thickness=0.1 //x=37.805 //y=7.585 //x2=37.12 //y2=7.585
r2030 (  579 1175 ) resistor r=4.23183 //w=0.7 //l=0.175 //layer=li \
 //thickness=0.1 //x=37.01 //y=7.41 //x2=37.01 //y2=7.585
r2031 (  579 1265 ) resistor r=33.1979 //w=0.187 //l=0.485 //layer=li \
 //thickness=0.1 //x=37.01 //y=7.41 //x2=37.01 //y2=6.925
r2032 (  578 1174 ) resistor r=2.87058 //w=0.35 //l=0.085 //layer=li \
 //thickness=0.1 //x=36.215 //y=7.585 //x2=36.13 //y2=7.585
r2033 (  577 1175 ) resistor r=2.87058 //w=0.35 //l=0.085 //layer=li \
 //thickness=0.1 //x=36.925 //y=7.585 //x2=37.01 //y2=7.585
r2034 (  577 578 ) resistor r=24.7629 //w=0.367 //l=0.71 //layer=li \
 //thickness=0.1 //x=36.925 //y=7.585 //x2=36.215 //y2=7.585
r2035 (  571 1174 ) resistor r=4.23183 //w=0.7 //l=0.175 //layer=li \
 //thickness=0.1 //x=36.13 //y=7.41 //x2=36.13 //y2=7.585
r2036 (  571 1264 ) resistor r=33.1979 //w=0.187 //l=0.485 //layer=li \
 //thickness=0.1 //x=36.13 //y=7.41 //x2=36.13 //y2=6.925
r2037 (  568 1173 ) resistor r=2.87058 //w=0.35 //l=0.085 //layer=li \
 //thickness=0.1 //x=35.335 //y=7.585 //x2=35.25 //y2=7.585
r2038 (  568 570 ) resistor r=23.5422 //w=0.367 //l=0.675 //layer=li \
 //thickness=0.1 //x=35.335 //y=7.585 //x2=36.01 //y2=7.585
r2039 (  567 1174 ) resistor r=2.87058 //w=0.35 //l=0.085 //layer=li \
 //thickness=0.1 //x=36.045 //y=7.585 //x2=36.13 //y2=7.585
r2040 (  567 570 ) resistor r=1.22071 //w=0.367 //l=0.035 //layer=li \
 //thickness=0.1 //x=36.045 //y=7.585 //x2=36.01 //y2=7.585
r2041 (  559 1173 ) resistor r=4.23183 //w=0.7 //l=0.175 //layer=li \
 //thickness=0.1 //x=35.25 //y=7.41 //x2=35.25 //y2=7.585
r2042 (  559 1263 ) resistor r=56.4706 //w=0.187 //l=0.825 //layer=li \
 //thickness=0.1 //x=35.25 //y=7.41 //x2=35.25 //y2=6.585
r2043 (  556 1172 ) resistor r=5.29055 //w=0.35 //l=0.17 //layer=li \
 //thickness=0.1 //x=34.33 //y=7.585 //x2=34.16 //y2=7.585
r2044 (  556 558 ) resistor r=19.8801 //w=0.367 //l=0.57 //layer=li \
 //thickness=0.1 //x=34.33 //y=7.585 //x2=34.9 //y2=7.585
r2045 (  555 1173 ) resistor r=2.87058 //w=0.35 //l=0.085 //layer=li \
 //thickness=0.1 //x=35.165 //y=7.585 //x2=35.25 //y2=7.585
r2046 (  555 558 ) resistor r=9.24251 //w=0.367 //l=0.265 //layer=li \
 //thickness=0.1 //x=35.165 //y=7.585 //x2=34.9 //y2=7.585
r2047 (  550 1171 ) resistor r=2.87058 //w=0.35 //l=0.085 //layer=li \
 //thickness=0.1 //x=33.165 //y=7.585 //x2=33.08 //y2=7.585
r2048 (  550 552 ) resistor r=8.89373 //w=0.367 //l=0.255 //layer=li \
 //thickness=0.1 //x=33.165 //y=7.585 //x2=33.42 //y2=7.585
r2049 (  549 1172 ) resistor r=5.29055 //w=0.35 //l=0.17 //layer=li \
 //thickness=0.1 //x=33.99 //y=7.585 //x2=34.16 //y2=7.585
r2050 (  549 552 ) resistor r=19.8801 //w=0.367 //l=0.57 //layer=li \
 //thickness=0.1 //x=33.99 //y=7.585 //x2=33.42 //y2=7.585
r2051 (  543 1171 ) resistor r=4.23183 //w=0.7 //l=0.175 //layer=li \
 //thickness=0.1 //x=33.08 //y=7.41 //x2=33.08 //y2=7.585
r2052 (  543 1262 ) resistor r=33.1979 //w=0.187 //l=0.485 //layer=li \
 //thickness=0.1 //x=33.08 //y=7.41 //x2=33.08 //y2=6.925
r2053 (  540 1170 ) resistor r=2.87058 //w=0.35 //l=0.085 //layer=li \
 //thickness=0.1 //x=32.285 //y=7.585 //x2=32.2 //y2=7.585
r2054 (  540 542 ) resistor r=0.871935 //w=0.367 //l=0.025 //layer=li \
 //thickness=0.1 //x=32.285 //y=7.585 //x2=32.31 //y2=7.585
r2055 (  539 1171 ) resistor r=2.87058 //w=0.35 //l=0.085 //layer=li \
 //thickness=0.1 //x=32.995 //y=7.585 //x2=33.08 //y2=7.585
r2056 (  539 542 ) resistor r=23.891 //w=0.367 //l=0.685 //layer=li \
 //thickness=0.1 //x=32.995 //y=7.585 //x2=32.31 //y2=7.585
r2057 (  533 1170 ) resistor r=4.23183 //w=0.7 //l=0.175 //layer=li \
 //thickness=0.1 //x=32.2 //y=7.41 //x2=32.2 //y2=7.585
r2058 (  533 1261 ) resistor r=33.1979 //w=0.187 //l=0.485 //layer=li \
 //thickness=0.1 //x=32.2 //y=7.41 //x2=32.2 //y2=6.925
r2059 (  532 1169 ) resistor r=2.87058 //w=0.35 //l=0.085 //layer=li \
 //thickness=0.1 //x=31.405 //y=7.585 //x2=31.32 //y2=7.585
r2060 (  531 1170 ) resistor r=2.87058 //w=0.35 //l=0.085 //layer=li \
 //thickness=0.1 //x=32.115 //y=7.585 //x2=32.2 //y2=7.585
r2061 (  531 532 ) resistor r=24.7629 //w=0.367 //l=0.71 //layer=li \
 //thickness=0.1 //x=32.115 //y=7.585 //x2=31.405 //y2=7.585
r2062 (  525 1169 ) resistor r=4.23183 //w=0.7 //l=0.175 //layer=li \
 //thickness=0.1 //x=31.32 //y=7.41 //x2=31.32 //y2=7.585
r2063 (  525 1260 ) resistor r=33.1979 //w=0.187 //l=0.485 //layer=li \
 //thickness=0.1 //x=31.32 //y=7.41 //x2=31.32 //y2=6.925
r2064 (  522 1168 ) resistor r=2.87058 //w=0.35 //l=0.085 //layer=li \
 //thickness=0.1 //x=30.525 //y=7.585 //x2=30.44 //y2=7.585
r2065 (  522 524 ) resistor r=23.5422 //w=0.367 //l=0.675 //layer=li \
 //thickness=0.1 //x=30.525 //y=7.585 //x2=31.2 //y2=7.585
r2066 (  521 1169 ) resistor r=2.87058 //w=0.35 //l=0.085 //layer=li \
 //thickness=0.1 //x=31.235 //y=7.585 //x2=31.32 //y2=7.585
r2067 (  521 524 ) resistor r=1.22071 //w=0.367 //l=0.035 //layer=li \
 //thickness=0.1 //x=31.235 //y=7.585 //x2=31.2 //y2=7.585
r2068 (  513 1168 ) resistor r=4.23183 //w=0.7 //l=0.175 //layer=li \
 //thickness=0.1 //x=30.44 //y=7.41 //x2=30.44 //y2=7.585
r2069 (  513 1259 ) resistor r=56.4706 //w=0.187 //l=0.825 //layer=li \
 //thickness=0.1 //x=30.44 //y=7.41 //x2=30.44 //y2=6.585
r2070 (  510 1167 ) resistor r=5.29055 //w=0.35 //l=0.17 //layer=li \
 //thickness=0.1 //x=29.52 //y=7.585 //x2=29.35 //y2=7.585
r2071 (  510 512 ) resistor r=19.8801 //w=0.367 //l=0.57 //layer=li \
 //thickness=0.1 //x=29.52 //y=7.585 //x2=30.09 //y2=7.585
r2072 (  509 1168 ) resistor r=2.87058 //w=0.35 //l=0.085 //layer=li \
 //thickness=0.1 //x=30.355 //y=7.585 //x2=30.44 //y2=7.585
r2073 (  509 512 ) resistor r=9.24251 //w=0.367 //l=0.265 //layer=li \
 //thickness=0.1 //x=30.355 //y=7.585 //x2=30.09 //y2=7.585
r2074 (  504 1166 ) resistor r=2.87058 //w=0.35 //l=0.085 //layer=li \
 //thickness=0.1 //x=28.355 //y=7.585 //x2=28.27 //y2=7.585
r2075 (  504 506 ) resistor r=8.89373 //w=0.367 //l=0.255 //layer=li \
 //thickness=0.1 //x=28.355 //y=7.585 //x2=28.61 //y2=7.585
r2076 (  503 1167 ) resistor r=5.29055 //w=0.35 //l=0.17 //layer=li \
 //thickness=0.1 //x=29.18 //y=7.585 //x2=29.35 //y2=7.585
r2077 (  503 506 ) resistor r=19.8801 //w=0.367 //l=0.57 //layer=li \
 //thickness=0.1 //x=29.18 //y=7.585 //x2=28.61 //y2=7.585
r2078 (  497 1166 ) resistor r=4.23183 //w=0.7 //l=0.175 //layer=li \
 //thickness=0.1 //x=28.27 //y=7.41 //x2=28.27 //y2=7.585
r2079 (  497 1258 ) resistor r=33.1979 //w=0.187 //l=0.485 //layer=li \
 //thickness=0.1 //x=28.27 //y=7.41 //x2=28.27 //y2=6.925
r2080 (  494 1165 ) resistor r=2.87058 //w=0.35 //l=0.085 //layer=li \
 //thickness=0.1 //x=27.475 //y=7.585 //x2=27.39 //y2=7.585
r2081 (  494 496 ) resistor r=0.871935 //w=0.367 //l=0.025 //layer=li \
 //thickness=0.1 //x=27.475 //y=7.585 //x2=27.5 //y2=7.585
r2082 (  493 1166 ) resistor r=2.87058 //w=0.35 //l=0.085 //layer=li \
 //thickness=0.1 //x=28.185 //y=7.585 //x2=28.27 //y2=7.585
r2083 (  493 496 ) resistor r=23.891 //w=0.367 //l=0.685 //layer=li \
 //thickness=0.1 //x=28.185 //y=7.585 //x2=27.5 //y2=7.585
r2084 (  487 1165 ) resistor r=4.23183 //w=0.7 //l=0.175 //layer=li \
 //thickness=0.1 //x=27.39 //y=7.41 //x2=27.39 //y2=7.585
r2085 (  487 1257 ) resistor r=33.1979 //w=0.187 //l=0.485 //layer=li \
 //thickness=0.1 //x=27.39 //y=7.41 //x2=27.39 //y2=6.925
r2086 (  486 1164 ) resistor r=2.87058 //w=0.35 //l=0.085 //layer=li \
 //thickness=0.1 //x=26.595 //y=7.585 //x2=26.51 //y2=7.585
r2087 (  485 1165 ) resistor r=2.87058 //w=0.35 //l=0.085 //layer=li \
 //thickness=0.1 //x=27.305 //y=7.585 //x2=27.39 //y2=7.585
r2088 (  485 486 ) resistor r=24.7629 //w=0.367 //l=0.71 //layer=li \
 //thickness=0.1 //x=27.305 //y=7.585 //x2=26.595 //y2=7.585
r2089 (  479 1164 ) resistor r=4.23183 //w=0.7 //l=0.175 //layer=li \
 //thickness=0.1 //x=26.51 //y=7.41 //x2=26.51 //y2=7.585
r2090 (  479 1256 ) resistor r=33.1979 //w=0.187 //l=0.485 //layer=li \
 //thickness=0.1 //x=26.51 //y=7.41 //x2=26.51 //y2=6.925
r2091 (  476 1163 ) resistor r=2.87058 //w=0.35 //l=0.085 //layer=li \
 //thickness=0.1 //x=25.715 //y=7.585 //x2=25.63 //y2=7.585
r2092 (  476 478 ) resistor r=23.5422 //w=0.367 //l=0.675 //layer=li \
 //thickness=0.1 //x=25.715 //y=7.585 //x2=26.39 //y2=7.585
r2093 (  475 1164 ) resistor r=2.87058 //w=0.35 //l=0.085 //layer=li \
 //thickness=0.1 //x=26.425 //y=7.585 //x2=26.51 //y2=7.585
r2094 (  475 478 ) resistor r=1.22071 //w=0.367 //l=0.035 //layer=li \
 //thickness=0.1 //x=26.425 //y=7.585 //x2=26.39 //y2=7.585
r2095 (  467 1163 ) resistor r=4.23183 //w=0.7 //l=0.175 //layer=li \
 //thickness=0.1 //x=25.63 //y=7.41 //x2=25.63 //y2=7.585
r2096 (  467 1255 ) resistor r=56.4706 //w=0.187 //l=0.825 //layer=li \
 //thickness=0.1 //x=25.63 //y=7.41 //x2=25.63 //y2=6.585
r2097 (  464 1162 ) resistor r=5.29055 //w=0.35 //l=0.17 //layer=li \
 //thickness=0.1 //x=24.71 //y=7.585 //x2=24.54 //y2=7.585
r2098 (  464 466 ) resistor r=19.8801 //w=0.367 //l=0.57 //layer=li \
 //thickness=0.1 //x=24.71 //y=7.585 //x2=25.28 //y2=7.585
r2099 (  463 1163 ) resistor r=2.87058 //w=0.35 //l=0.085 //layer=li \
 //thickness=0.1 //x=25.545 //y=7.585 //x2=25.63 //y2=7.585
r2100 (  463 466 ) resistor r=9.24251 //w=0.367 //l=0.265 //layer=li \
 //thickness=0.1 //x=25.545 //y=7.585 //x2=25.28 //y2=7.585
r2101 (  458 1161 ) resistor r=2.87058 //w=0.35 //l=0.085 //layer=li \
 //thickness=0.1 //x=23.545 //y=7.585 //x2=23.46 //y2=7.585
r2102 (  458 460 ) resistor r=8.89373 //w=0.367 //l=0.255 //layer=li \
 //thickness=0.1 //x=23.545 //y=7.585 //x2=23.8 //y2=7.585
r2103 (  457 1162 ) resistor r=5.29055 //w=0.35 //l=0.17 //layer=li \
 //thickness=0.1 //x=24.37 //y=7.585 //x2=24.54 //y2=7.585
r2104 (  457 460 ) resistor r=19.8801 //w=0.367 //l=0.57 //layer=li \
 //thickness=0.1 //x=24.37 //y=7.585 //x2=23.8 //y2=7.585
r2105 (  451 1161 ) resistor r=4.23183 //w=0.7 //l=0.175 //layer=li \
 //thickness=0.1 //x=23.46 //y=7.41 //x2=23.46 //y2=7.585
r2106 (  451 1254 ) resistor r=33.1979 //w=0.187 //l=0.485 //layer=li \
 //thickness=0.1 //x=23.46 //y=7.41 //x2=23.46 //y2=6.925
r2107 (  448 1160 ) resistor r=2.87058 //w=0.35 //l=0.085 //layer=li \
 //thickness=0.1 //x=22.665 //y=7.585 //x2=22.58 //y2=7.585
r2108 (  448 450 ) resistor r=0.871935 //w=0.367 //l=0.025 //layer=li \
 //thickness=0.1 //x=22.665 //y=7.585 //x2=22.69 //y2=7.585
r2109 (  447 1161 ) resistor r=2.87058 //w=0.35 //l=0.085 //layer=li \
 //thickness=0.1 //x=23.375 //y=7.585 //x2=23.46 //y2=7.585
r2110 (  447 450 ) resistor r=23.891 //w=0.367 //l=0.685 //layer=li \
 //thickness=0.1 //x=23.375 //y=7.585 //x2=22.69 //y2=7.585
r2111 (  441 1160 ) resistor r=4.23183 //w=0.7 //l=0.175 //layer=li \
 //thickness=0.1 //x=22.58 //y=7.41 //x2=22.58 //y2=7.585
r2112 (  441 1253 ) resistor r=33.1979 //w=0.187 //l=0.485 //layer=li \
 //thickness=0.1 //x=22.58 //y=7.41 //x2=22.58 //y2=6.925
r2113 (  440 1159 ) resistor r=2.87058 //w=0.35 //l=0.085 //layer=li \
 //thickness=0.1 //x=21.785 //y=7.585 //x2=21.7 //y2=7.585
r2114 (  439 1160 ) resistor r=2.87058 //w=0.35 //l=0.085 //layer=li \
 //thickness=0.1 //x=22.495 //y=7.585 //x2=22.58 //y2=7.585
r2115 (  439 440 ) resistor r=24.7629 //w=0.367 //l=0.71 //layer=li \
 //thickness=0.1 //x=22.495 //y=7.585 //x2=21.785 //y2=7.585
r2116 (  433 1159 ) resistor r=4.23183 //w=0.7 //l=0.175 //layer=li \
 //thickness=0.1 //x=21.7 //y=7.41 //x2=21.7 //y2=7.585
r2117 (  433 1252 ) resistor r=33.1979 //w=0.187 //l=0.485 //layer=li \
 //thickness=0.1 //x=21.7 //y=7.41 //x2=21.7 //y2=6.925
r2118 (  430 1158 ) resistor r=2.87058 //w=0.35 //l=0.085 //layer=li \
 //thickness=0.1 //x=20.905 //y=7.585 //x2=20.82 //y2=7.585
r2119 (  430 432 ) resistor r=23.5422 //w=0.367 //l=0.675 //layer=li \
 //thickness=0.1 //x=20.905 //y=7.585 //x2=21.58 //y2=7.585
r2120 (  429 1159 ) resistor r=2.87058 //w=0.35 //l=0.085 //layer=li \
 //thickness=0.1 //x=21.615 //y=7.585 //x2=21.7 //y2=7.585
r2121 (  429 432 ) resistor r=1.22071 //w=0.367 //l=0.035 //layer=li \
 //thickness=0.1 //x=21.615 //y=7.585 //x2=21.58 //y2=7.585
r2122 (  421 1158 ) resistor r=4.23183 //w=0.7 //l=0.175 //layer=li \
 //thickness=0.1 //x=20.82 //y=7.41 //x2=20.82 //y2=7.585
r2123 (  421 1251 ) resistor r=56.4706 //w=0.187 //l=0.825 //layer=li \
 //thickness=0.1 //x=20.82 //y=7.41 //x2=20.82 //y2=6.585
r2124 (  418 1157 ) resistor r=5.29055 //w=0.35 //l=0.17 //layer=li \
 //thickness=0.1 //x=19.9 //y=7.585 //x2=19.73 //y2=7.585
r2125 (  418 420 ) resistor r=19.8801 //w=0.367 //l=0.57 //layer=li \
 //thickness=0.1 //x=19.9 //y=7.585 //x2=20.47 //y2=7.585
r2126 (  417 1158 ) resistor r=2.87058 //w=0.35 //l=0.085 //layer=li \
 //thickness=0.1 //x=20.735 //y=7.585 //x2=20.82 //y2=7.585
r2127 (  417 420 ) resistor r=9.24251 //w=0.367 //l=0.265 //layer=li \
 //thickness=0.1 //x=20.735 //y=7.585 //x2=20.47 //y2=7.585
r2128 (  412 1156 ) resistor r=2.87058 //w=0.35 //l=0.085 //layer=li \
 //thickness=0.1 //x=18.735 //y=7.585 //x2=18.65 //y2=7.585
r2129 (  412 414 ) resistor r=8.89373 //w=0.367 //l=0.255 //layer=li \
 //thickness=0.1 //x=18.735 //y=7.585 //x2=18.99 //y2=7.585
r2130 (  411 1157 ) resistor r=5.29055 //w=0.35 //l=0.17 //layer=li \
 //thickness=0.1 //x=19.56 //y=7.585 //x2=19.73 //y2=7.585
r2131 (  411 414 ) resistor r=19.8801 //w=0.367 //l=0.57 //layer=li \
 //thickness=0.1 //x=19.56 //y=7.585 //x2=18.99 //y2=7.585
r2132 (  405 1156 ) resistor r=4.23183 //w=0.7 //l=0.175 //layer=li \
 //thickness=0.1 //x=18.65 //y=7.41 //x2=18.65 //y2=7.585
r2133 (  405 1250 ) resistor r=33.1979 //w=0.187 //l=0.485 //layer=li \
 //thickness=0.1 //x=18.65 //y=7.41 //x2=18.65 //y2=6.925
r2134 (  402 1155 ) resistor r=2.87058 //w=0.35 //l=0.085 //layer=li \
 //thickness=0.1 //x=17.855 //y=7.585 //x2=17.77 //y2=7.585
r2135 (  402 404 ) resistor r=0.871935 //w=0.367 //l=0.025 //layer=li \
 //thickness=0.1 //x=17.855 //y=7.585 //x2=17.88 //y2=7.585
r2136 (  401 1156 ) resistor r=2.87058 //w=0.35 //l=0.085 //layer=li \
 //thickness=0.1 //x=18.565 //y=7.585 //x2=18.65 //y2=7.585
r2137 (  401 404 ) resistor r=23.891 //w=0.367 //l=0.685 //layer=li \
 //thickness=0.1 //x=18.565 //y=7.585 //x2=17.88 //y2=7.585
r2138 (  395 1155 ) resistor r=4.23183 //w=0.7 //l=0.175 //layer=li \
 //thickness=0.1 //x=17.77 //y=7.41 //x2=17.77 //y2=7.585
r2139 (  395 1249 ) resistor r=33.1979 //w=0.187 //l=0.485 //layer=li \
 //thickness=0.1 //x=17.77 //y=7.41 //x2=17.77 //y2=6.925
r2140 (  394 1154 ) resistor r=2.87058 //w=0.35 //l=0.085 //layer=li \
 //thickness=0.1 //x=16.975 //y=7.585 //x2=16.89 //y2=7.585
r2141 (  393 1155 ) resistor r=2.87058 //w=0.35 //l=0.085 //layer=li \
 //thickness=0.1 //x=17.685 //y=7.585 //x2=17.77 //y2=7.585
r2142 (  393 394 ) resistor r=24.7629 //w=0.367 //l=0.71 //layer=li \
 //thickness=0.1 //x=17.685 //y=7.585 //x2=16.975 //y2=7.585
r2143 (  387 1154 ) resistor r=4.23183 //w=0.7 //l=0.175 //layer=li \
 //thickness=0.1 //x=16.89 //y=7.41 //x2=16.89 //y2=7.585
r2144 (  387 1248 ) resistor r=33.1979 //w=0.187 //l=0.485 //layer=li \
 //thickness=0.1 //x=16.89 //y=7.41 //x2=16.89 //y2=6.925
r2145 (  384 1153 ) resistor r=2.87058 //w=0.35 //l=0.085 //layer=li \
 //thickness=0.1 //x=16.095 //y=7.585 //x2=16.01 //y2=7.585
r2146 (  384 386 ) resistor r=23.5422 //w=0.367 //l=0.675 //layer=li \
 //thickness=0.1 //x=16.095 //y=7.585 //x2=16.77 //y2=7.585
r2147 (  383 1154 ) resistor r=2.87058 //w=0.35 //l=0.085 //layer=li \
 //thickness=0.1 //x=16.805 //y=7.585 //x2=16.89 //y2=7.585
r2148 (  383 386 ) resistor r=1.22071 //w=0.367 //l=0.035 //layer=li \
 //thickness=0.1 //x=16.805 //y=7.585 //x2=16.77 //y2=7.585
r2149 (  375 1153 ) resistor r=4.23183 //w=0.7 //l=0.175 //layer=li \
 //thickness=0.1 //x=16.01 //y=7.41 //x2=16.01 //y2=7.585
r2150 (  375 1247 ) resistor r=56.4706 //w=0.187 //l=0.825 //layer=li \
 //thickness=0.1 //x=16.01 //y=7.41 //x2=16.01 //y2=6.585
r2151 (  372 1152 ) resistor r=5.29055 //w=0.35 //l=0.17 //layer=li \
 //thickness=0.1 //x=15.09 //y=7.585 //x2=14.92 //y2=7.585
r2152 (  372 374 ) resistor r=19.8801 //w=0.367 //l=0.57 //layer=li \
 //thickness=0.1 //x=15.09 //y=7.585 //x2=15.66 //y2=7.585
r2153 (  371 1153 ) resistor r=2.87058 //w=0.35 //l=0.085 //layer=li \
 //thickness=0.1 //x=15.925 //y=7.585 //x2=16.01 //y2=7.585
r2154 (  371 374 ) resistor r=9.24251 //w=0.367 //l=0.265 //layer=li \
 //thickness=0.1 //x=15.925 //y=7.585 //x2=15.66 //y2=7.585
r2155 (  366 1151 ) resistor r=2.87058 //w=0.35 //l=0.085 //layer=li \
 //thickness=0.1 //x=13.925 //y=7.585 //x2=13.84 //y2=7.585
r2156 (  366 368 ) resistor r=8.89373 //w=0.367 //l=0.255 //layer=li \
 //thickness=0.1 //x=13.925 //y=7.585 //x2=14.18 //y2=7.585
r2157 (  365 1152 ) resistor r=5.29055 //w=0.35 //l=0.17 //layer=li \
 //thickness=0.1 //x=14.75 //y=7.585 //x2=14.92 //y2=7.585
r2158 (  365 368 ) resistor r=19.8801 //w=0.367 //l=0.57 //layer=li \
 //thickness=0.1 //x=14.75 //y=7.585 //x2=14.18 //y2=7.585
r2159 (  359 1151 ) resistor r=4.23183 //w=0.7 //l=0.175 //layer=li \
 //thickness=0.1 //x=13.84 //y=7.41 //x2=13.84 //y2=7.585
r2160 (  359 1246 ) resistor r=33.1979 //w=0.187 //l=0.485 //layer=li \
 //thickness=0.1 //x=13.84 //y=7.41 //x2=13.84 //y2=6.925
r2161 (  356 1150 ) resistor r=2.87058 //w=0.35 //l=0.085 //layer=li \
 //thickness=0.1 //x=13.045 //y=7.585 //x2=12.96 //y2=7.585
r2162 (  356 358 ) resistor r=0.871935 //w=0.367 //l=0.025 //layer=li \
 //thickness=0.1 //x=13.045 //y=7.585 //x2=13.07 //y2=7.585
r2163 (  355 1151 ) resistor r=2.87058 //w=0.35 //l=0.085 //layer=li \
 //thickness=0.1 //x=13.755 //y=7.585 //x2=13.84 //y2=7.585
r2164 (  355 358 ) resistor r=23.891 //w=0.367 //l=0.685 //layer=li \
 //thickness=0.1 //x=13.755 //y=7.585 //x2=13.07 //y2=7.585
r2165 (  349 1150 ) resistor r=4.23183 //w=0.7 //l=0.175 //layer=li \
 //thickness=0.1 //x=12.96 //y=7.41 //x2=12.96 //y2=7.585
r2166 (  349 1245 ) resistor r=33.1979 //w=0.187 //l=0.485 //layer=li \
 //thickness=0.1 //x=12.96 //y=7.41 //x2=12.96 //y2=6.925
r2167 (  348 1149 ) resistor r=2.87058 //w=0.35 //l=0.085 //layer=li \
 //thickness=0.1 //x=12.165 //y=7.585 //x2=12.08 //y2=7.585
r2168 (  347 1150 ) resistor r=2.87058 //w=0.35 //l=0.085 //layer=li \
 //thickness=0.1 //x=12.875 //y=7.585 //x2=12.96 //y2=7.585
r2169 (  347 348 ) resistor r=24.7629 //w=0.367 //l=0.71 //layer=li \
 //thickness=0.1 //x=12.875 //y=7.585 //x2=12.165 //y2=7.585
r2170 (  341 1149 ) resistor r=4.23183 //w=0.7 //l=0.175 //layer=li \
 //thickness=0.1 //x=12.08 //y=7.41 //x2=12.08 //y2=7.585
r2171 (  341 1244 ) resistor r=33.1979 //w=0.187 //l=0.485 //layer=li \
 //thickness=0.1 //x=12.08 //y=7.41 //x2=12.08 //y2=6.925
r2172 (  338 1148 ) resistor r=2.87058 //w=0.35 //l=0.085 //layer=li \
 //thickness=0.1 //x=11.285 //y=7.585 //x2=11.2 //y2=7.585
r2173 (  338 340 ) resistor r=23.5422 //w=0.367 //l=0.675 //layer=li \
 //thickness=0.1 //x=11.285 //y=7.585 //x2=11.96 //y2=7.585
r2174 (  337 1149 ) resistor r=2.87058 //w=0.35 //l=0.085 //layer=li \
 //thickness=0.1 //x=11.995 //y=7.585 //x2=12.08 //y2=7.585
r2175 (  337 340 ) resistor r=1.22071 //w=0.367 //l=0.035 //layer=li \
 //thickness=0.1 //x=11.995 //y=7.585 //x2=11.96 //y2=7.585
r2176 (  329 1148 ) resistor r=4.23183 //w=0.7 //l=0.175 //layer=li \
 //thickness=0.1 //x=11.2 //y=7.41 //x2=11.2 //y2=7.585
r2177 (  329 1243 ) resistor r=56.4706 //w=0.187 //l=0.825 //layer=li \
 //thickness=0.1 //x=11.2 //y=7.41 //x2=11.2 //y2=6.585
r2178 (  326 1147 ) resistor r=5.29055 //w=0.35 //l=0.17 //layer=li \
 //thickness=0.1 //x=10.28 //y=7.585 //x2=10.11 //y2=7.585
r2179 (  326 328 ) resistor r=19.8801 //w=0.367 //l=0.57 //layer=li \
 //thickness=0.1 //x=10.28 //y=7.585 //x2=10.85 //y2=7.585
r2180 (  325 1148 ) resistor r=2.87058 //w=0.35 //l=0.085 //layer=li \
 //thickness=0.1 //x=11.115 //y=7.585 //x2=11.2 //y2=7.585
r2181 (  325 328 ) resistor r=9.24251 //w=0.367 //l=0.265 //layer=li \
 //thickness=0.1 //x=11.115 //y=7.585 //x2=10.85 //y2=7.585
r2182 (  320 1146 ) resistor r=2.87058 //w=0.35 //l=0.085 //layer=li \
 //thickness=0.1 //x=9.115 //y=7.585 //x2=9.03 //y2=7.585
r2183 (  320 322 ) resistor r=8.89373 //w=0.367 //l=0.255 //layer=li \
 //thickness=0.1 //x=9.115 //y=7.585 //x2=9.37 //y2=7.585
r2184 (  319 1147 ) resistor r=5.29055 //w=0.35 //l=0.17 //layer=li \
 //thickness=0.1 //x=9.94 //y=7.585 //x2=10.11 //y2=7.585
r2185 (  319 322 ) resistor r=19.8801 //w=0.367 //l=0.57 //layer=li \
 //thickness=0.1 //x=9.94 //y=7.585 //x2=9.37 //y2=7.585
r2186 (  313 1146 ) resistor r=4.23183 //w=0.7 //l=0.175 //layer=li \
 //thickness=0.1 //x=9.03 //y=7.41 //x2=9.03 //y2=7.585
r2187 (  313 1242 ) resistor r=33.1979 //w=0.187 //l=0.485 //layer=li \
 //thickness=0.1 //x=9.03 //y=7.41 //x2=9.03 //y2=6.925
r2188 (  310 1145 ) resistor r=2.87058 //w=0.35 //l=0.085 //layer=li \
 //thickness=0.1 //x=8.235 //y=7.585 //x2=8.15 //y2=7.585
r2189 (  310 312 ) resistor r=0.871935 //w=0.367 //l=0.025 //layer=li \
 //thickness=0.1 //x=8.235 //y=7.585 //x2=8.26 //y2=7.585
r2190 (  309 1146 ) resistor r=2.87058 //w=0.35 //l=0.085 //layer=li \
 //thickness=0.1 //x=8.945 //y=7.585 //x2=9.03 //y2=7.585
r2191 (  309 312 ) resistor r=23.891 //w=0.367 //l=0.685 //layer=li \
 //thickness=0.1 //x=8.945 //y=7.585 //x2=8.26 //y2=7.585
r2192 (  303 1145 ) resistor r=4.23183 //w=0.7 //l=0.175 //layer=li \
 //thickness=0.1 //x=8.15 //y=7.41 //x2=8.15 //y2=7.585
r2193 (  303 1241 ) resistor r=33.1979 //w=0.187 //l=0.485 //layer=li \
 //thickness=0.1 //x=8.15 //y=7.41 //x2=8.15 //y2=6.925
r2194 (  302 1144 ) resistor r=2.87058 //w=0.35 //l=0.085 //layer=li \
 //thickness=0.1 //x=7.355 //y=7.585 //x2=7.27 //y2=7.585
r2195 (  301 1145 ) resistor r=2.87058 //w=0.35 //l=0.085 //layer=li \
 //thickness=0.1 //x=8.065 //y=7.585 //x2=8.15 //y2=7.585
r2196 (  301 302 ) resistor r=24.7629 //w=0.367 //l=0.71 //layer=li \
 //thickness=0.1 //x=8.065 //y=7.585 //x2=7.355 //y2=7.585
r2197 (  295 1144 ) resistor r=4.23183 //w=0.7 //l=0.175 //layer=li \
 //thickness=0.1 //x=7.27 //y=7.41 //x2=7.27 //y2=7.585
r2198 (  295 1240 ) resistor r=33.1979 //w=0.187 //l=0.485 //layer=li \
 //thickness=0.1 //x=7.27 //y=7.41 //x2=7.27 //y2=6.925
r2199 (  292 1143 ) resistor r=2.87058 //w=0.35 //l=0.085 //layer=li \
 //thickness=0.1 //x=6.475 //y=7.585 //x2=6.39 //y2=7.585
r2200 (  292 294 ) resistor r=23.5422 //w=0.367 //l=0.675 //layer=li \
 //thickness=0.1 //x=6.475 //y=7.585 //x2=7.15 //y2=7.585
r2201 (  291 1144 ) resistor r=2.87058 //w=0.35 //l=0.085 //layer=li \
 //thickness=0.1 //x=7.185 //y=7.585 //x2=7.27 //y2=7.585
r2202 (  291 294 ) resistor r=1.22071 //w=0.367 //l=0.035 //layer=li \
 //thickness=0.1 //x=7.185 //y=7.585 //x2=7.15 //y2=7.585
r2203 (  283 1143 ) resistor r=4.23183 //w=0.7 //l=0.175 //layer=li \
 //thickness=0.1 //x=6.39 //y=7.41 //x2=6.39 //y2=7.585
r2204 (  283 1239 ) resistor r=56.4706 //w=0.187 //l=0.825 //layer=li \
 //thickness=0.1 //x=6.39 //y=7.41 //x2=6.39 //y2=6.585
r2205 (  280 1142 ) resistor r=5.29055 //w=0.35 //l=0.17 //layer=li \
 //thickness=0.1 //x=5.47 //y=7.585 //x2=5.3 //y2=7.585
r2206 (  280 282 ) resistor r=19.8801 //w=0.367 //l=0.57 //layer=li \
 //thickness=0.1 //x=5.47 //y=7.585 //x2=6.04 //y2=7.585
r2207 (  279 1143 ) resistor r=2.87058 //w=0.35 //l=0.085 //layer=li \
 //thickness=0.1 //x=6.305 //y=7.585 //x2=6.39 //y2=7.585
r2208 (  279 282 ) resistor r=9.24251 //w=0.367 //l=0.265 //layer=li \
 //thickness=0.1 //x=6.305 //y=7.585 //x2=6.04 //y2=7.585
r2209 (  274 1141 ) resistor r=2.87058 //w=0.35 //l=0.085 //layer=li \
 //thickness=0.1 //x=4.305 //y=7.585 //x2=4.22 //y2=7.585
r2210 (  274 276 ) resistor r=8.89373 //w=0.367 //l=0.255 //layer=li \
 //thickness=0.1 //x=4.305 //y=7.585 //x2=4.56 //y2=7.585
r2211 (  273 1142 ) resistor r=5.29055 //w=0.35 //l=0.17 //layer=li \
 //thickness=0.1 //x=5.13 //y=7.585 //x2=5.3 //y2=7.585
r2212 (  273 276 ) resistor r=19.8801 //w=0.367 //l=0.57 //layer=li \
 //thickness=0.1 //x=5.13 //y=7.585 //x2=4.56 //y2=7.585
r2213 (  267 1141 ) resistor r=4.23183 //w=0.7 //l=0.175 //layer=li \
 //thickness=0.1 //x=4.22 //y=7.41 //x2=4.22 //y2=7.585
r2214 (  267 1238 ) resistor r=33.1979 //w=0.187 //l=0.485 //layer=li \
 //thickness=0.1 //x=4.22 //y=7.41 //x2=4.22 //y2=6.925
r2215 (  264 1140 ) resistor r=2.87058 //w=0.35 //l=0.085 //layer=li \
 //thickness=0.1 //x=3.425 //y=7.585 //x2=3.34 //y2=7.585
r2216 (  264 266 ) resistor r=0.871935 //w=0.367 //l=0.025 //layer=li \
 //thickness=0.1 //x=3.425 //y=7.585 //x2=3.45 //y2=7.585
r2217 (  263 1141 ) resistor r=2.87058 //w=0.35 //l=0.085 //layer=li \
 //thickness=0.1 //x=4.135 //y=7.585 //x2=4.22 //y2=7.585
r2218 (  263 266 ) resistor r=23.891 //w=0.367 //l=0.685 //layer=li \
 //thickness=0.1 //x=4.135 //y=7.585 //x2=3.45 //y2=7.585
r2219 (  257 1140 ) resistor r=4.23183 //w=0.7 //l=0.175 //layer=li \
 //thickness=0.1 //x=3.34 //y=7.41 //x2=3.34 //y2=7.585
r2220 (  257 1237 ) resistor r=33.1979 //w=0.187 //l=0.485 //layer=li \
 //thickness=0.1 //x=3.34 //y=7.41 //x2=3.34 //y2=6.925
r2221 (  256 1139 ) resistor r=2.87058 //w=0.35 //l=0.085 //layer=li \
 //thickness=0.1 //x=2.545 //y=7.585 //x2=2.46 //y2=7.585
r2222 (  255 1140 ) resistor r=2.87058 //w=0.35 //l=0.085 //layer=li \
 //thickness=0.1 //x=3.255 //y=7.585 //x2=3.34 //y2=7.585
r2223 (  255 256 ) resistor r=24.7629 //w=0.367 //l=0.71 //layer=li \
 //thickness=0.1 //x=3.255 //y=7.585 //x2=2.545 //y2=7.585
r2224 (  249 1139 ) resistor r=4.23183 //w=0.7 //l=0.175 //layer=li \
 //thickness=0.1 //x=2.46 //y=7.41 //x2=2.46 //y2=7.585
r2225 (  249 1236 ) resistor r=33.1979 //w=0.187 //l=0.485 //layer=li \
 //thickness=0.1 //x=2.46 //y=7.41 //x2=2.46 //y2=6.925
r2226 (  246 1138 ) resistor r=2.87058 //w=0.35 //l=0.085 //layer=li \
 //thickness=0.1 //x=1.665 //y=7.585 //x2=1.58 //y2=7.585
r2227 (  246 248 ) resistor r=23.5422 //w=0.367 //l=0.675 //layer=li \
 //thickness=0.1 //x=1.665 //y=7.585 //x2=2.34 //y2=7.585
r2228 (  245 1139 ) resistor r=2.87058 //w=0.35 //l=0.085 //layer=li \
 //thickness=0.1 //x=2.375 //y=7.585 //x2=2.46 //y2=7.585
r2229 (  245 248 ) resistor r=1.22071 //w=0.367 //l=0.035 //layer=li \
 //thickness=0.1 //x=2.375 //y=7.585 //x2=2.34 //y2=7.585
r2230 (  237 1138 ) resistor r=4.23183 //w=0.7 //l=0.175 //layer=li \
 //thickness=0.1 //x=1.58 //y=7.41 //x2=1.58 //y2=7.585
r2231 (  237 1235 ) resistor r=56.4706 //w=0.187 //l=0.825 //layer=li \
 //thickness=0.1 //x=1.58 //y=7.41 //x2=1.58 //y2=6.585
r2232 (  233 1138 ) resistor r=2.87058 //w=0.35 //l=0.085 //layer=li \
 //thickness=0.1 //x=1.495 //y=7.585 //x2=1.58 //y2=7.585
r2233 (  233 236 ) resistor r=9.24251 //w=0.367 //l=0.265 //layer=li \
 //thickness=0.1 //x=1.495 //y=7.585 //x2=1.23 //y2=7.585
r2234 (  226 1092 ) resistor r=9.3 //w=0.17 //l=0.17 //layer=mcon //count=1 \
 //x=89.62 //y=6.92 //x2=89.62 //y2=6.92
r2235 (  223 1308 ) resistor r=9.3 //w=0.17 //l=0.17 //layer=mcon //count=1 \
 //x=88.74 //y=6.92 //x2=88.74 //y2=6.92
r2236 (  220 1077 ) resistor r=9.3 //w=0.17 //l=0.17 //layer=mcon //count=1 \
 //x=87.86 //y=6.92 //x2=87.86 //y2=6.92
r2237 (  216 1064 ) resistor r=3.1 //w=0.17 //l=0.51 //layer=mcon //count=3 \
 //x=87.81 //y=7.58 //x2=87.81 //y2=7.58
r2238 (  177 1234 ) resistor r=4.65 //w=0.17 //l=0.34 //layer=mcon //count=2 \
 //x=98.54 //y=7.58 //x2=98.54 //y2=7.58
r2239 (  175 1232 ) resistor r=3.1 //w=0.17 //l=0.51 //layer=mcon //count=3 \
 //x=97.8 //y=7.58 //x2=97.8 //y2=7.58
r2240 (  175 177 ) resistor r=0.297428 //w=0.311 //l=0.74 //layer=m1 \
 //thickness=0.36 //x=97.8 //y=7.585 //x2=98.54 //y2=7.585
r2241 (  173 1111 ) resistor r=3.1 //w=0.17 //l=0.51 //layer=mcon //count=3 \
 //x=96.32 //y=7.58 //x2=96.32 //y2=7.58
r2242 (  173 175 ) resistor r=0.594855 //w=0.311 //l=1.48 //layer=m1 \
 //thickness=0.36 //x=96.32 //y=7.585 //x2=97.8 //y2=7.585
r2243 (  171 1109 ) resistor r=3.1 //w=0.17 //l=0.51 //layer=mcon //count=3 \
 //x=95.21 //y=7.58 //x2=95.21 //y2=7.58
r2244 (  171 173 ) resistor r=0.446141 //w=0.311 //l=1.11 //layer=m1 \
 //thickness=0.36 //x=95.21 //y=7.585 //x2=96.32 //y2=7.585
r2245 (  169 1107 ) resistor r=3.1 //w=0.17 //l=0.51 //layer=mcon //count=3 \
 //x=94.1 //y=7.58 //x2=94.1 //y2=7.58
r2246 (  169 171 ) resistor r=0.446141 //w=0.311 //l=1.11 //layer=m1 \
 //thickness=0.36 //x=94.1 //y=7.585 //x2=95.21 //y2=7.585
r2247 (  167 1101 ) resistor r=3.1 //w=0.17 //l=0.51 //layer=mcon //count=3 \
 //x=92.62 //y=7.58 //x2=92.62 //y2=7.58
r2248 (  167 169 ) resistor r=0.594855 //w=0.311 //l=1.48 //layer=m1 \
 //thickness=0.36 //x=92.62 //y=7.585 //x2=94.1 //y2=7.585
r2249 (  165 1099 ) resistor r=3.1 //w=0.17 //l=0.51 //layer=mcon //count=3 \
 //x=91.51 //y=7.58 //x2=91.51 //y2=7.58
r2250 (  165 167 ) resistor r=0.446141 //w=0.311 //l=1.11 //layer=m1 \
 //thickness=0.36 //x=91.51 //y=7.585 //x2=92.62 //y2=7.585
r2251 (  163 1068 ) resistor r=3.1 //w=0.17 //l=0.51 //layer=mcon //count=3 \
 //x=90.03 //y=7.58 //x2=90.03 //y2=7.58
r2252 (  163 165 ) resistor r=0.594855 //w=0.311 //l=1.48 //layer=m1 \
 //thickness=0.36 //x=90.03 //y=7.585 //x2=91.51 //y2=7.585
r2253 (  161 224 ) resistor r=0.028033 //w=0.35 //l=0.085 //layer=m1 \
 //thickness=0.36 //x=89.705 //y=7.585 //x2=89.62 //y2=7.585
r2254 (  161 163 ) resistor r=0.130627 //w=0.311 //l=0.325 //layer=m1 \
 //thickness=0.36 //x=89.705 //y=7.585 //x2=90.03 //y2=7.585
r2255 (  160 224 ) resistor r=0.0413265 //w=0.7 //l=0.175 //layer=m1 \
 //thickness=0.36 //x=89.62 //y=7.41 //x2=89.62 //y2=7.585
r2256 (  159 226 ) resistor r=0.0715665 //w=0.226 //l=0.115 //layer=m1 \
 //thickness=0.36 //x=89.62 //y=7.035 //x2=89.62 //y2=6.92
r2257 (  159 160 ) resistor r=0.357824 //w=0.131 //l=0.375 //layer=m1 \
 //thickness=0.36 //x=89.62 //y=7.035 //x2=89.62 //y2=7.41
r2258 (  158 1066 ) resistor r=3.1 //w=0.17 //l=0.51 //layer=mcon //count=3 \
 //x=88.92 //y=7.58 //x2=88.92 //y2=7.58
r2259 (  156 221 ) resistor r=0.028033 //w=0.35 //l=0.085 //layer=m1 \
 //thickness=0.36 //x=88.825 //y=7.585 //x2=88.74 //y2=7.585
r2260 (  156 158 ) resistor r=0.0381833 //w=0.311 //l=0.095 //layer=m1 \
 //thickness=0.36 //x=88.825 //y=7.585 //x2=88.92 //y2=7.585
r2261 (  155 224 ) resistor r=0.028033 //w=0.35 //l=0.085 //layer=m1 \
 //thickness=0.36 //x=89.535 //y=7.585 //x2=89.62 //y2=7.585
r2262 (  155 158 ) resistor r=0.247186 //w=0.311 //l=0.615 //layer=m1 \
 //thickness=0.36 //x=89.535 //y=7.585 //x2=88.92 //y2=7.585
r2263 (  154 221 ) resistor r=0.0413265 //w=0.7 //l=0.175 //layer=m1 \
 //thickness=0.36 //x=88.74 //y=7.41 //x2=88.74 //y2=7.585
r2264 (  153 223 ) resistor r=0.0715665 //w=0.226 //l=0.117473 //layer=m1 \
 //thickness=0.36 //x=88.74 //y=7.035 //x2=88.745 //y2=6.92
r2265 (  153 154 ) resistor r=0.357824 //w=0.131 //l=0.375 //layer=m1 \
 //thickness=0.36 //x=88.74 //y=7.035 //x2=88.74 //y2=7.41
r2266 (  152 216 ) resistor r=0.028033 //w=0.35 //l=0.085 //layer=m1 \
 //thickness=0.36 //x=87.945 //y=7.585 //x2=87.86 //y2=7.585
r2267 (  151 221 ) resistor r=0.028033 //w=0.35 //l=0.085 //layer=m1 \
 //thickness=0.36 //x=88.655 //y=7.585 //x2=88.74 //y2=7.585
r2268 (  151 152 ) resistor r=0.28537 //w=0.311 //l=0.71 //layer=m1 \
 //thickness=0.36 //x=88.655 //y=7.585 //x2=87.945 //y2=7.585
r2269 (  150 216 ) resistor r=0.0413265 //w=0.7 //l=0.175 //layer=m1 \
 //thickness=0.36 //x=87.86 //y=7.41 //x2=87.86 //y2=7.585
r2270 (  149 220 ) resistor r=0.0712609 //w=0.23 //l=0.11649 //layer=m1 \
 //thickness=0.36 //x=87.86 //y=7.035 //x2=87.857 //y2=6.92
r2271 (  149 150 ) resistor r=0.357824 //w=0.131 //l=0.375 //layer=m1 \
 //thickness=0.36 //x=87.86 //y=7.035 //x2=87.86 //y2=7.41
r2272 (  148 1058 ) resistor r=3.1 //w=0.17 //l=0.51 //layer=mcon //count=3 \
 //x=86.33 //y=7.58 //x2=86.33 //y2=7.58
r2273 (  146 1048 ) resistor r=3.1 //w=0.17 //l=0.51 //layer=mcon //count=3 \
 //x=85.22 //y=7.58 //x2=85.22 //y2=7.58
r2274 (  146 148 ) resistor r=0.446141 //w=0.311 //l=1.11 //layer=m1 \
 //thickness=0.36 //x=85.22 //y=7.585 //x2=86.33 //y2=7.585
r2275 (  144 1030 ) resistor r=3.1 //w=0.17 //l=0.51 //layer=mcon //count=3 \
 //x=84.11 //y=7.58 //x2=84.11 //y2=7.58
r2276 (  144 146 ) resistor r=0.446141 //w=0.311 //l=1.11 //layer=m1 \
 //thickness=0.36 //x=84.11 //y=7.585 //x2=85.22 //y2=7.585
r2277 (  142 1018 ) resistor r=3.1 //w=0.17 //l=0.51 //layer=mcon //count=3 \
 //x=83 //y=7.58 //x2=83 //y2=7.58
r2278 (  142 144 ) resistor r=0.446141 //w=0.311 //l=1.11 //layer=m1 \
 //thickness=0.36 //x=83 //y=7.585 //x2=84.11 //y2=7.585
r2279 (  140 1012 ) resistor r=3.1 //w=0.17 //l=0.51 //layer=mcon //count=3 \
 //x=81.52 //y=7.58 //x2=81.52 //y2=7.58
r2280 (  140 142 ) resistor r=0.594855 //w=0.311 //l=1.48 //layer=m1 \
 //thickness=0.36 //x=81.52 //y=7.585 //x2=83 //y2=7.585
r2281 (  138 1002 ) resistor r=3.1 //w=0.17 //l=0.51 //layer=mcon //count=3 \
 //x=80.41 //y=7.58 //x2=80.41 //y2=7.58
r2282 (  138 140 ) resistor r=0.446141 //w=0.311 //l=1.11 //layer=m1 \
 //thickness=0.36 //x=80.41 //y=7.585 //x2=81.52 //y2=7.585
r2283 (  136 984 ) resistor r=3.1 //w=0.17 //l=0.51 //layer=mcon //count=3 \
 //x=79.3 //y=7.58 //x2=79.3 //y2=7.58
r2284 (  136 138 ) resistor r=0.446141 //w=0.311 //l=1.11 //layer=m1 \
 //thickness=0.36 //x=79.3 //y=7.585 //x2=80.41 //y2=7.585
r2285 (  134 972 ) resistor r=3.1 //w=0.17 //l=0.51 //layer=mcon //count=3 \
 //x=78.19 //y=7.58 //x2=78.19 //y2=7.58
r2286 (  134 136 ) resistor r=0.446141 //w=0.311 //l=1.11 //layer=m1 \
 //thickness=0.36 //x=78.19 //y=7.585 //x2=79.3 //y2=7.585
r2287 (  132 966 ) resistor r=3.1 //w=0.17 //l=0.51 //layer=mcon //count=3 \
 //x=76.71 //y=7.58 //x2=76.71 //y2=7.58
r2288 (  132 134 ) resistor r=0.594855 //w=0.311 //l=1.48 //layer=m1 \
 //thickness=0.36 //x=76.71 //y=7.585 //x2=78.19 //y2=7.585
r2289 (  130 956 ) resistor r=3.1 //w=0.17 //l=0.51 //layer=mcon //count=3 \
 //x=75.6 //y=7.58 //x2=75.6 //y2=7.58
r2290 (  130 132 ) resistor r=0.446141 //w=0.311 //l=1.11 //layer=m1 \
 //thickness=0.36 //x=75.6 //y=7.585 //x2=76.71 //y2=7.585
r2291 (  128 938 ) resistor r=3.1 //w=0.17 //l=0.51 //layer=mcon //count=3 \
 //x=74.49 //y=7.58 //x2=74.49 //y2=7.58
r2292 (  128 130 ) resistor r=0.446141 //w=0.311 //l=1.11 //layer=m1 \
 //thickness=0.36 //x=74.49 //y=7.585 //x2=75.6 //y2=7.585
r2293 (  126 926 ) resistor r=3.1 //w=0.17 //l=0.51 //layer=mcon //count=3 \
 //x=73.38 //y=7.58 //x2=73.38 //y2=7.58
r2294 (  126 128 ) resistor r=0.446141 //w=0.311 //l=1.11 //layer=m1 \
 //thickness=0.36 //x=73.38 //y=7.585 //x2=74.49 //y2=7.585
r2295 (  124 920 ) resistor r=3.1 //w=0.17 //l=0.51 //layer=mcon //count=3 \
 //x=71.9 //y=7.58 //x2=71.9 //y2=7.58
r2296 (  124 126 ) resistor r=0.594855 //w=0.311 //l=1.48 //layer=m1 \
 //thickness=0.36 //x=71.9 //y=7.585 //x2=73.38 //y2=7.585
r2297 (  122 910 ) resistor r=3.1 //w=0.17 //l=0.51 //layer=mcon //count=3 \
 //x=70.79 //y=7.58 //x2=70.79 //y2=7.58
r2298 (  122 124 ) resistor r=0.446141 //w=0.311 //l=1.11 //layer=m1 \
 //thickness=0.36 //x=70.79 //y=7.585 //x2=71.9 //y2=7.585
r2299 (  120 892 ) resistor r=3.1 //w=0.17 //l=0.51 //layer=mcon //count=3 \
 //x=69.68 //y=7.58 //x2=69.68 //y2=7.58
r2300 (  120 122 ) resistor r=0.446141 //w=0.311 //l=1.11 //layer=m1 \
 //thickness=0.36 //x=69.68 //y=7.585 //x2=70.79 //y2=7.585
r2301 (  118 880 ) resistor r=3.1 //w=0.17 //l=0.51 //layer=mcon //count=3 \
 //x=68.57 //y=7.58 //x2=68.57 //y2=7.58
r2302 (  118 120 ) resistor r=0.446141 //w=0.311 //l=1.11 //layer=m1 \
 //thickness=0.36 //x=68.57 //y=7.585 //x2=69.68 //y2=7.585
r2303 (  116 874 ) resistor r=3.1 //w=0.17 //l=0.51 //layer=mcon //count=3 \
 //x=67.09 //y=7.58 //x2=67.09 //y2=7.58
r2304 (  116 118 ) resistor r=0.594855 //w=0.311 //l=1.48 //layer=m1 \
 //thickness=0.36 //x=67.09 //y=7.585 //x2=68.57 //y2=7.585
r2305 (  114 864 ) resistor r=3.1 //w=0.17 //l=0.51 //layer=mcon //count=3 \
 //x=65.98 //y=7.58 //x2=65.98 //y2=7.58
r2306 (  114 116 ) resistor r=0.446141 //w=0.311 //l=1.11 //layer=m1 \
 //thickness=0.36 //x=65.98 //y=7.585 //x2=67.09 //y2=7.585
r2307 (  112 846 ) resistor r=3.1 //w=0.17 //l=0.51 //layer=mcon //count=3 \
 //x=64.87 //y=7.58 //x2=64.87 //y2=7.58
r2308 (  112 114 ) resistor r=0.446141 //w=0.311 //l=1.11 //layer=m1 \
 //thickness=0.36 //x=64.87 //y=7.585 //x2=65.98 //y2=7.585
r2309 (  110 834 ) resistor r=3.1 //w=0.17 //l=0.51 //layer=mcon //count=3 \
 //x=63.76 //y=7.58 //x2=63.76 //y2=7.58
r2310 (  110 112 ) resistor r=0.446141 //w=0.311 //l=1.11 //layer=m1 \
 //thickness=0.36 //x=63.76 //y=7.585 //x2=64.87 //y2=7.585
r2311 (  108 828 ) resistor r=3.1 //w=0.17 //l=0.51 //layer=mcon //count=3 \
 //x=62.28 //y=7.58 //x2=62.28 //y2=7.58
r2312 (  108 110 ) resistor r=0.594855 //w=0.311 //l=1.48 //layer=m1 \
 //thickness=0.36 //x=62.28 //y=7.585 //x2=63.76 //y2=7.585
r2313 (  106 818 ) resistor r=3.1 //w=0.17 //l=0.51 //layer=mcon //count=3 \
 //x=61.17 //y=7.58 //x2=61.17 //y2=7.58
r2314 (  106 108 ) resistor r=0.446141 //w=0.311 //l=1.11 //layer=m1 \
 //thickness=0.36 //x=61.17 //y=7.585 //x2=62.28 //y2=7.585
r2315 (  104 800 ) resistor r=3.1 //w=0.17 //l=0.51 //layer=mcon //count=3 \
 //x=60.06 //y=7.58 //x2=60.06 //y2=7.58
r2316 (  104 106 ) resistor r=0.446141 //w=0.311 //l=1.11 //layer=m1 \
 //thickness=0.36 //x=60.06 //y=7.585 //x2=61.17 //y2=7.585
r2317 (  102 788 ) resistor r=3.1 //w=0.17 //l=0.51 //layer=mcon //count=3 \
 //x=58.95 //y=7.58 //x2=58.95 //y2=7.58
r2318 (  102 104 ) resistor r=0.446141 //w=0.311 //l=1.11 //layer=m1 \
 //thickness=0.36 //x=58.95 //y=7.585 //x2=60.06 //y2=7.585
r2319 (  100 782 ) resistor r=3.1 //w=0.17 //l=0.51 //layer=mcon //count=3 \
 //x=57.47 //y=7.58 //x2=57.47 //y2=7.58
r2320 (  100 102 ) resistor r=0.594855 //w=0.311 //l=1.48 //layer=m1 \
 //thickness=0.36 //x=57.47 //y=7.585 //x2=58.95 //y2=7.585
r2321 (  98 772 ) resistor r=3.1 //w=0.17 //l=0.51 //layer=mcon //count=3 \
 //x=56.36 //y=7.58 //x2=56.36 //y2=7.58
r2322 (  98 100 ) resistor r=0.446141 //w=0.311 //l=1.11 //layer=m1 \
 //thickness=0.36 //x=56.36 //y=7.585 //x2=57.47 //y2=7.585
r2323 (  96 754 ) resistor r=3.1 //w=0.17 //l=0.51 //layer=mcon //count=3 \
 //x=55.25 //y=7.58 //x2=55.25 //y2=7.58
r2324 (  96 98 ) resistor r=0.446141 //w=0.311 //l=1.11 //layer=m1 \
 //thickness=0.36 //x=55.25 //y=7.585 //x2=56.36 //y2=7.585
r2325 (  94 742 ) resistor r=3.1 //w=0.17 //l=0.51 //layer=mcon //count=3 \
 //x=54.14 //y=7.58 //x2=54.14 //y2=7.58
r2326 (  94 96 ) resistor r=0.446141 //w=0.311 //l=1.11 //layer=m1 \
 //thickness=0.36 //x=54.14 //y=7.585 //x2=55.25 //y2=7.585
r2327 (  92 736 ) resistor r=3.1 //w=0.17 //l=0.51 //layer=mcon //count=3 \
 //x=52.66 //y=7.58 //x2=52.66 //y2=7.58
r2328 (  92 94 ) resistor r=0.594855 //w=0.311 //l=1.48 //layer=m1 \
 //thickness=0.36 //x=52.66 //y=7.585 //x2=54.14 //y2=7.585
r2329 (  90 726 ) resistor r=3.1 //w=0.17 //l=0.51 //layer=mcon //count=3 \
 //x=51.55 //y=7.58 //x2=51.55 //y2=7.58
r2330 (  90 92 ) resistor r=0.446141 //w=0.311 //l=1.11 //layer=m1 \
 //thickness=0.36 //x=51.55 //y=7.585 //x2=52.66 //y2=7.585
r2331 (  88 708 ) resistor r=3.1 //w=0.17 //l=0.51 //layer=mcon //count=3 \
 //x=50.44 //y=7.58 //x2=50.44 //y2=7.58
r2332 (  88 90 ) resistor r=0.446141 //w=0.311 //l=1.11 //layer=m1 \
 //thickness=0.36 //x=50.44 //y=7.585 //x2=51.55 //y2=7.585
r2333 (  85 696 ) resistor r=3.1 //w=0.17 //l=0.51 //layer=mcon //count=3 \
 //x=49.33 //y=7.58 //x2=49.33 //y2=7.58
r2334 (  83 690 ) resistor r=3.1 //w=0.17 //l=0.51 //layer=mcon //count=3 \
 //x=47.85 //y=7.58 //x2=47.85 //y2=7.58
r2335 (  83 85 ) resistor r=0.594855 //w=0.311 //l=1.48 //layer=m1 \
 //thickness=0.36 //x=47.85 //y=7.585 //x2=49.33 //y2=7.585
r2336 (  81 680 ) resistor r=3.1 //w=0.17 //l=0.51 //layer=mcon //count=3 \
 //x=46.74 //y=7.58 //x2=46.74 //y2=7.58
r2337 (  81 83 ) resistor r=0.446141 //w=0.311 //l=1.11 //layer=m1 \
 //thickness=0.36 //x=46.74 //y=7.585 //x2=47.85 //y2=7.585
r2338 (  79 662 ) resistor r=3.1 //w=0.17 //l=0.51 //layer=mcon //count=3 \
 //x=45.63 //y=7.58 //x2=45.63 //y2=7.58
r2339 (  79 81 ) resistor r=0.446141 //w=0.311 //l=1.11 //layer=m1 \
 //thickness=0.36 //x=45.63 //y=7.585 //x2=46.74 //y2=7.585
r2340 (  77 650 ) resistor r=3.1 //w=0.17 //l=0.51 //layer=mcon //count=3 \
 //x=44.52 //y=7.58 //x2=44.52 //y2=7.58
r2341 (  77 79 ) resistor r=0.446141 //w=0.311 //l=1.11 //layer=m1 \
 //thickness=0.36 //x=44.52 //y=7.585 //x2=45.63 //y2=7.585
r2342 (  75 644 ) resistor r=3.1 //w=0.17 //l=0.51 //layer=mcon //count=3 \
 //x=43.04 //y=7.58 //x2=43.04 //y2=7.58
r2343 (  75 77 ) resistor r=0.594855 //w=0.311 //l=1.48 //layer=m1 \
 //thickness=0.36 //x=43.04 //y=7.585 //x2=44.52 //y2=7.585
r2344 (  73 634 ) resistor r=3.1 //w=0.17 //l=0.51 //layer=mcon //count=3 \
 //x=41.93 //y=7.58 //x2=41.93 //y2=7.58
r2345 (  73 75 ) resistor r=0.446141 //w=0.311 //l=1.11 //layer=m1 \
 //thickness=0.36 //x=41.93 //y=7.585 //x2=43.04 //y2=7.585
r2346 (  71 616 ) resistor r=3.1 //w=0.17 //l=0.51 //layer=mcon //count=3 \
 //x=40.82 //y=7.58 //x2=40.82 //y2=7.58
r2347 (  71 73 ) resistor r=0.446141 //w=0.311 //l=1.11 //layer=m1 \
 //thickness=0.36 //x=40.82 //y=7.585 //x2=41.93 //y2=7.585
r2348 (  69 604 ) resistor r=3.1 //w=0.17 //l=0.51 //layer=mcon //count=3 \
 //x=39.71 //y=7.58 //x2=39.71 //y2=7.58
r2349 (  69 71 ) resistor r=0.446141 //w=0.311 //l=1.11 //layer=m1 \
 //thickness=0.36 //x=39.71 //y=7.585 //x2=40.82 //y2=7.585
r2350 (  67 598 ) resistor r=3.1 //w=0.17 //l=0.51 //layer=mcon //count=3 \
 //x=38.23 //y=7.58 //x2=38.23 //y2=7.58
r2351 (  67 69 ) resistor r=0.594855 //w=0.311 //l=1.48 //layer=m1 \
 //thickness=0.36 //x=38.23 //y=7.585 //x2=39.71 //y2=7.585
r2352 (  65 588 ) resistor r=3.1 //w=0.17 //l=0.51 //layer=mcon //count=3 \
 //x=37.12 //y=7.58 //x2=37.12 //y2=7.58
r2353 (  65 67 ) resistor r=0.446141 //w=0.311 //l=1.11 //layer=m1 \
 //thickness=0.36 //x=37.12 //y=7.585 //x2=38.23 //y2=7.585
r2354 (  63 570 ) resistor r=3.1 //w=0.17 //l=0.51 //layer=mcon //count=3 \
 //x=36.01 //y=7.58 //x2=36.01 //y2=7.58
r2355 (  63 65 ) resistor r=0.446141 //w=0.311 //l=1.11 //layer=m1 \
 //thickness=0.36 //x=36.01 //y=7.585 //x2=37.12 //y2=7.585
r2356 (  61 558 ) resistor r=3.1 //w=0.17 //l=0.51 //layer=mcon //count=3 \
 //x=34.9 //y=7.58 //x2=34.9 //y2=7.58
r2357 (  61 63 ) resistor r=0.446141 //w=0.311 //l=1.11 //layer=m1 \
 //thickness=0.36 //x=34.9 //y=7.585 //x2=36.01 //y2=7.585
r2358 (  59 552 ) resistor r=3.1 //w=0.17 //l=0.51 //layer=mcon //count=3 \
 //x=33.42 //y=7.58 //x2=33.42 //y2=7.58
r2359 (  59 61 ) resistor r=0.594855 //w=0.311 //l=1.48 //layer=m1 \
 //thickness=0.36 //x=33.42 //y=7.585 //x2=34.9 //y2=7.585
r2360 (  57 542 ) resistor r=3.1 //w=0.17 //l=0.51 //layer=mcon //count=3 \
 //x=32.31 //y=7.58 //x2=32.31 //y2=7.58
r2361 (  57 59 ) resistor r=0.446141 //w=0.311 //l=1.11 //layer=m1 \
 //thickness=0.36 //x=32.31 //y=7.585 //x2=33.42 //y2=7.585
r2362 (  55 524 ) resistor r=3.1 //w=0.17 //l=0.51 //layer=mcon //count=3 \
 //x=31.2 //y=7.58 //x2=31.2 //y2=7.58
r2363 (  55 57 ) resistor r=0.446141 //w=0.311 //l=1.11 //layer=m1 \
 //thickness=0.36 //x=31.2 //y=7.585 //x2=32.31 //y2=7.585
r2364 (  53 512 ) resistor r=3.1 //w=0.17 //l=0.51 //layer=mcon //count=3 \
 //x=30.09 //y=7.58 //x2=30.09 //y2=7.58
r2365 (  53 55 ) resistor r=0.446141 //w=0.311 //l=1.11 //layer=m1 \
 //thickness=0.36 //x=30.09 //y=7.585 //x2=31.2 //y2=7.585
r2366 (  51 506 ) resistor r=3.1 //w=0.17 //l=0.51 //layer=mcon //count=3 \
 //x=28.61 //y=7.58 //x2=28.61 //y2=7.58
r2367 (  51 53 ) resistor r=0.594855 //w=0.311 //l=1.48 //layer=m1 \
 //thickness=0.36 //x=28.61 //y=7.585 //x2=30.09 //y2=7.585
r2368 (  49 496 ) resistor r=3.1 //w=0.17 //l=0.51 //layer=mcon //count=3 \
 //x=27.5 //y=7.58 //x2=27.5 //y2=7.58
r2369 (  49 51 ) resistor r=0.446141 //w=0.311 //l=1.11 //layer=m1 \
 //thickness=0.36 //x=27.5 //y=7.585 //x2=28.61 //y2=7.585
r2370 (  47 478 ) resistor r=3.1 //w=0.17 //l=0.51 //layer=mcon //count=3 \
 //x=26.39 //y=7.58 //x2=26.39 //y2=7.58
r2371 (  47 49 ) resistor r=0.446141 //w=0.311 //l=1.11 //layer=m1 \
 //thickness=0.36 //x=26.39 //y=7.585 //x2=27.5 //y2=7.585
r2372 (  45 466 ) resistor r=3.1 //w=0.17 //l=0.51 //layer=mcon //count=3 \
 //x=25.28 //y=7.58 //x2=25.28 //y2=7.58
r2373 (  45 47 ) resistor r=0.446141 //w=0.311 //l=1.11 //layer=m1 \
 //thickness=0.36 //x=25.28 //y=7.585 //x2=26.39 //y2=7.585
r2374 (  43 460 ) resistor r=3.1 //w=0.17 //l=0.51 //layer=mcon //count=3 \
 //x=23.8 //y=7.58 //x2=23.8 //y2=7.58
r2375 (  43 45 ) resistor r=0.594855 //w=0.311 //l=1.48 //layer=m1 \
 //thickness=0.36 //x=23.8 //y=7.585 //x2=25.28 //y2=7.585
r2376 (  41 450 ) resistor r=3.1 //w=0.17 //l=0.51 //layer=mcon //count=3 \
 //x=22.69 //y=7.58 //x2=22.69 //y2=7.58
r2377 (  41 43 ) resistor r=0.446141 //w=0.311 //l=1.11 //layer=m1 \
 //thickness=0.36 //x=22.69 //y=7.585 //x2=23.8 //y2=7.585
r2378 (  39 432 ) resistor r=3.1 //w=0.17 //l=0.51 //layer=mcon //count=3 \
 //x=21.58 //y=7.58 //x2=21.58 //y2=7.58
r2379 (  39 41 ) resistor r=0.446141 //w=0.311 //l=1.11 //layer=m1 \
 //thickness=0.36 //x=21.58 //y=7.585 //x2=22.69 //y2=7.585
r2380 (  37 420 ) resistor r=3.1 //w=0.17 //l=0.51 //layer=mcon //count=3 \
 //x=20.47 //y=7.58 //x2=20.47 //y2=7.58
r2381 (  37 39 ) resistor r=0.446141 //w=0.311 //l=1.11 //layer=m1 \
 //thickness=0.36 //x=20.47 //y=7.585 //x2=21.58 //y2=7.585
r2382 (  35 414 ) resistor r=3.1 //w=0.17 //l=0.51 //layer=mcon //count=3 \
 //x=18.99 //y=7.58 //x2=18.99 //y2=7.58
r2383 (  35 37 ) resistor r=0.594855 //w=0.311 //l=1.48 //layer=m1 \
 //thickness=0.36 //x=18.99 //y=7.585 //x2=20.47 //y2=7.585
r2384 (  33 404 ) resistor r=3.1 //w=0.17 //l=0.51 //layer=mcon //count=3 \
 //x=17.88 //y=7.58 //x2=17.88 //y2=7.58
r2385 (  33 35 ) resistor r=0.446141 //w=0.311 //l=1.11 //layer=m1 \
 //thickness=0.36 //x=17.88 //y=7.585 //x2=18.99 //y2=7.585
r2386 (  31 386 ) resistor r=3.1 //w=0.17 //l=0.51 //layer=mcon //count=3 \
 //x=16.77 //y=7.58 //x2=16.77 //y2=7.58
r2387 (  31 33 ) resistor r=0.446141 //w=0.311 //l=1.11 //layer=m1 \
 //thickness=0.36 //x=16.77 //y=7.585 //x2=17.88 //y2=7.585
r2388 (  29 374 ) resistor r=3.1 //w=0.17 //l=0.51 //layer=mcon //count=3 \
 //x=15.66 //y=7.58 //x2=15.66 //y2=7.58
r2389 (  29 31 ) resistor r=0.446141 //w=0.311 //l=1.11 //layer=m1 \
 //thickness=0.36 //x=15.66 //y=7.585 //x2=16.77 //y2=7.585
r2390 (  27 368 ) resistor r=3.1 //w=0.17 //l=0.51 //layer=mcon //count=3 \
 //x=14.18 //y=7.58 //x2=14.18 //y2=7.58
r2391 (  27 29 ) resistor r=0.594855 //w=0.311 //l=1.48 //layer=m1 \
 //thickness=0.36 //x=14.18 //y=7.585 //x2=15.66 //y2=7.585
r2392 (  25 358 ) resistor r=3.1 //w=0.17 //l=0.51 //layer=mcon //count=3 \
 //x=13.07 //y=7.58 //x2=13.07 //y2=7.58
r2393 (  25 27 ) resistor r=0.446141 //w=0.311 //l=1.11 //layer=m1 \
 //thickness=0.36 //x=13.07 //y=7.585 //x2=14.18 //y2=7.585
r2394 (  23 340 ) resistor r=3.1 //w=0.17 //l=0.51 //layer=mcon //count=3 \
 //x=11.96 //y=7.58 //x2=11.96 //y2=7.58
r2395 (  23 25 ) resistor r=0.446141 //w=0.311 //l=1.11 //layer=m1 \
 //thickness=0.36 //x=11.96 //y=7.585 //x2=13.07 //y2=7.585
r2396 (  21 328 ) resistor r=3.1 //w=0.17 //l=0.51 //layer=mcon //count=3 \
 //x=10.85 //y=7.58 //x2=10.85 //y2=7.58
r2397 (  21 23 ) resistor r=0.446141 //w=0.311 //l=1.11 //layer=m1 \
 //thickness=0.36 //x=10.85 //y=7.585 //x2=11.96 //y2=7.585
r2398 (  19 322 ) resistor r=3.1 //w=0.17 //l=0.51 //layer=mcon //count=3 \
 //x=9.37 //y=7.58 //x2=9.37 //y2=7.58
r2399 (  19 21 ) resistor r=0.594855 //w=0.311 //l=1.48 //layer=m1 \
 //thickness=0.36 //x=9.37 //y=7.585 //x2=10.85 //y2=7.585
r2400 (  17 312 ) resistor r=3.1 //w=0.17 //l=0.51 //layer=mcon //count=3 \
 //x=8.26 //y=7.58 //x2=8.26 //y2=7.58
r2401 (  17 19 ) resistor r=0.446141 //w=0.311 //l=1.11 //layer=m1 \
 //thickness=0.36 //x=8.26 //y=7.585 //x2=9.37 //y2=7.585
r2402 (  15 294 ) resistor r=3.1 //w=0.17 //l=0.51 //layer=mcon //count=3 \
 //x=7.15 //y=7.58 //x2=7.15 //y2=7.58
r2403 (  15 17 ) resistor r=0.446141 //w=0.311 //l=1.11 //layer=m1 \
 //thickness=0.36 //x=7.15 //y=7.585 //x2=8.26 //y2=7.585
r2404 (  13 282 ) resistor r=3.1 //w=0.17 //l=0.51 //layer=mcon //count=3 \
 //x=6.04 //y=7.58 //x2=6.04 //y2=7.58
r2405 (  13 15 ) resistor r=0.446141 //w=0.311 //l=1.11 //layer=m1 \
 //thickness=0.36 //x=6.04 //y=7.585 //x2=7.15 //y2=7.585
r2406 (  11 276 ) resistor r=3.1 //w=0.17 //l=0.51 //layer=mcon //count=3 \
 //x=4.56 //y=7.58 //x2=4.56 //y2=7.58
r2407 (  11 13 ) resistor r=0.594855 //w=0.311 //l=1.48 //layer=m1 \
 //thickness=0.36 //x=4.56 //y=7.585 //x2=6.04 //y2=7.585
r2408 (  9 266 ) resistor r=3.1 //w=0.17 //l=0.51 //layer=mcon //count=3 \
 //x=3.45 //y=7.58 //x2=3.45 //y2=7.58
r2409 (  9 11 ) resistor r=0.446141 //w=0.311 //l=1.11 //layer=m1 \
 //thickness=0.36 //x=3.45 //y=7.585 //x2=4.56 //y2=7.585
r2410 (  7 248 ) resistor r=3.1 //w=0.17 //l=0.51 //layer=mcon //count=3 \
 //x=2.34 //y=7.58 //x2=2.34 //y2=7.58
r2411 (  7 9 ) resistor r=0.446141 //w=0.311 //l=1.11 //layer=m1 \
 //thickness=0.36 //x=2.34 //y=7.585 //x2=3.45 //y2=7.585
r2412 (  4 236 ) resistor r=3.1 //w=0.17 //l=0.51 //layer=mcon //count=3 \
 //x=1.23 //y=7.58 //x2=1.23 //y2=7.58
r2413 (  4 7 ) resistor r=0.446141 //w=0.311 //l=1.11 //layer=m1 \
 //thickness=0.36 //x=1.23 //y=7.585 //x2=2.34 //y2=7.585
r2414 (  2 216 ) resistor r=0.028033 //w=0.35 //l=0.085 //layer=m1 \
 //thickness=0.36 //x=87.775 //y=7.585 //x2=87.86 //y2=7.585
r2415 (  2 148 ) resistor r=0.580788 //w=0.311 //l=1.445 //layer=m1 \
 //thickness=0.36 //x=87.775 //y=7.585 //x2=86.33 //y2=7.585
r2416 (  1 88 ) resistor r=0.223071 //w=0.311 //l=0.555 //layer=m1 \
 //thickness=0.36 //x=49.885 //y=7.585 //x2=50.44 //y2=7.585
r2417 (  1 85 ) resistor r=0.223071 //w=0.311 //l=0.555 //layer=m1 \
 //thickness=0.36 //x=49.885 //y=7.585 //x2=49.33 //y2=7.585
ends PM_TMRDFFSNRNQX1\%VDD

subckt PM_TMRDFFSNRNQX1\%noxref_27 ( 5 7 15 19 30 33 34 )
c66 ( 34 0 ) capacitor c=0.0443556f //x=3.455 //y=0.555
c67 ( 33 0 ) capacitor c=0.0194217f //x=2.35 //y=1.09
c68 ( 30 0 ) capacitor c=0.00141302f //x=3.59 //y=1.175
c69 ( 19 0 ) capacitor c=0.00692795f //x=4.56 //y=0.805
c70 ( 15 0 ) capacitor c=0.0155078f //x=4.475 //y=0.72
c71 ( 7 0 ) capacitor c=0.00689459f //x=3.59 //y=0.805
c72 ( 5 0 ) capacitor c=0.0235962f //x=3.505 //y=1.175
r73 (  19 34 ) resistor r=3.57586 //w=0.17 //l=0.125 //layer=li \
 //thickness=0.1 //x=4.56 //y=0.805 //x2=4.56 //y2=0.68
r74 (  19 34 ) resistor r=18.139 //w=0.187 //l=0.265 //layer=li \
 //thickness=0.1 //x=4.56 //y=0.805 //x2=4.56 //y2=1.07
r75 (  16 34 ) resistor r=3.57586 //w=0.17 //l=0.103078 //layer=li \
 //thickness=0.1 //x=3.675 //y=0.72 //x2=3.59 //y2=0.68
r76 (  16 34 ) resistor r=27.3797 //w=0.187 //l=0.4 //layer=li //thickness=0.1 \
 //x=3.675 //y=0.72 //x2=4.075 //y2=0.72
r77 (  15 34 ) resistor r=3.57586 //w=0.17 //l=0.103078 //layer=li \
 //thickness=0.1 //x=4.475 //y=0.72 //x2=4.56 //y2=0.68
r78 (  15 34 ) resistor r=27.3797 //w=0.187 //l=0.4 //layer=li //thickness=0.1 \
 //x=4.475 //y=0.72 //x2=4.075 //y2=0.72
r79 (  11 30 ) resistor r=5.4201 //w=0.17 //l=0.085 //layer=li //thickness=0.1 \
 //x=3.59 //y=1.26 //x2=3.59 //y2=1.175
r80 (  11 34 ) resistor r=10.2674 //w=0.187 //l=0.15 //layer=li \
 //thickness=0.1 //x=3.59 //y=1.26 //x2=3.59 //y2=1.41
r81 (  8 30 ) resistor r=5.4201 //w=0.17 //l=0.085 //layer=li //thickness=0.1 \
 //x=3.59 //y=1.09 //x2=3.59 //y2=1.175
r82 (  8 34 ) resistor r=1.36898 //w=0.187 //l=0.02 //layer=li //thickness=0.1 \
 //x=3.59 //y=1.09 //x2=3.59 //y2=1.07
r83 (  7 34 ) resistor r=3.57586 //w=0.17 //l=0.125 //layer=li //thickness=0.1 \
 //x=3.59 //y=0.805 //x2=3.59 //y2=0.68
r84 (  7 34 ) resistor r=18.139 //w=0.187 //l=0.265 //layer=li //thickness=0.1 \
 //x=3.59 //y=0.805 //x2=3.59 //y2=1.07
r85 (  6 33 ) resistor r=0.751729 //w=0.17 //l=0.085 //layer=li \
 //thickness=0.1 //x=2.625 //y=1.175 //x2=2.54 //y2=1.175
r86 (  5 30 ) resistor r=1.40859 //w=0.34 //l=0.085 //layer=li //thickness=0.1 \
 //x=3.505 //y=1.175 //x2=3.59 //y2=1.175
r87 (  5 6 ) resistor r=60.2353 //w=0.187 //l=0.88 //layer=li //thickness=0.1 \
 //x=3.505 //y=1.175 //x2=2.625 //y2=1.175
ends PM_TMRDFFSNRNQX1\%noxref_27

subckt PM_TMRDFFSNRNQX1\%noxref_28 ( 5 7 15 19 30 33 34 )
c67 ( 34 0 ) capacitor c=0.0451719f //x=8.265 //y=0.555
c68 ( 33 0 ) capacitor c=0.0194945f //x=7.16 //y=1.09
c69 ( 30 0 ) capacitor c=0.00141302f //x=8.4 //y=1.175
c70 ( 19 0 ) capacitor c=0.00692795f //x=9.37 //y=0.805
c71 ( 15 0 ) capacitor c=0.0154868f //x=9.285 //y=0.72
c72 ( 7 0 ) capacitor c=0.00689459f //x=8.4 //y=0.805
c73 ( 5 0 ) capacitor c=0.0235962f //x=8.315 //y=1.175
r74 (  19 34 ) resistor r=3.57586 //w=0.17 //l=0.125 //layer=li \
 //thickness=0.1 //x=9.37 //y=0.805 //x2=9.37 //y2=0.68
r75 (  19 34 ) resistor r=18.139 //w=0.187 //l=0.265 //layer=li \
 //thickness=0.1 //x=9.37 //y=0.805 //x2=9.37 //y2=1.07
r76 (  16 34 ) resistor r=3.57586 //w=0.17 //l=0.103078 //layer=li \
 //thickness=0.1 //x=8.485 //y=0.72 //x2=8.4 //y2=0.68
r77 (  16 34 ) resistor r=27.3797 //w=0.187 //l=0.4 //layer=li //thickness=0.1 \
 //x=8.485 //y=0.72 //x2=8.885 //y2=0.72
r78 (  15 34 ) resistor r=3.57586 //w=0.17 //l=0.103078 //layer=li \
 //thickness=0.1 //x=9.285 //y=0.72 //x2=9.37 //y2=0.68
r79 (  15 34 ) resistor r=27.3797 //w=0.187 //l=0.4 //layer=li //thickness=0.1 \
 //x=9.285 //y=0.72 //x2=8.885 //y2=0.72
r80 (  11 30 ) resistor r=5.4201 //w=0.17 //l=0.085 //layer=li //thickness=0.1 \
 //x=8.4 //y=1.26 //x2=8.4 //y2=1.175
r81 (  11 34 ) resistor r=10.2674 //w=0.187 //l=0.15 //layer=li \
 //thickness=0.1 //x=8.4 //y=1.26 //x2=8.4 //y2=1.41
r82 (  8 30 ) resistor r=5.4201 //w=0.17 //l=0.085 //layer=li //thickness=0.1 \
 //x=8.4 //y=1.09 //x2=8.4 //y2=1.175
r83 (  8 34 ) resistor r=1.36898 //w=0.187 //l=0.02 //layer=li //thickness=0.1 \
 //x=8.4 //y=1.09 //x2=8.4 //y2=1.07
r84 (  7 34 ) resistor r=3.57586 //w=0.17 //l=0.125 //layer=li //thickness=0.1 \
 //x=8.4 //y=0.805 //x2=8.4 //y2=0.68
r85 (  7 34 ) resistor r=18.139 //w=0.187 //l=0.265 //layer=li //thickness=0.1 \
 //x=8.4 //y=0.805 //x2=8.4 //y2=1.07
r86 (  6 33 ) resistor r=0.751729 //w=0.17 //l=0.085 //layer=li \
 //thickness=0.1 //x=7.435 //y=1.175 //x2=7.35 //y2=1.175
r87 (  5 30 ) resistor r=1.40859 //w=0.34 //l=0.085 //layer=li //thickness=0.1 \
 //x=8.315 //y=1.175 //x2=8.4 //y2=1.175
r88 (  5 6 ) resistor r=60.2353 //w=0.187 //l=0.88 //layer=li //thickness=0.1 \
 //x=8.315 //y=1.175 //x2=7.435 //y2=1.175
ends PM_TMRDFFSNRNQX1\%noxref_28

subckt PM_TMRDFFSNRNQX1\%noxref_29 ( 5 7 15 19 30 33 34 )
c68 ( 34 0 ) capacitor c=0.0442917f //x=13.075 //y=0.555
c69 ( 33 0 ) capacitor c=0.0193551f //x=11.97 //y=1.09
c70 ( 30 0 ) capacitor c=0.00141302f //x=13.21 //y=1.175
c71 ( 19 0 ) capacitor c=0.00692795f //x=14.18 //y=0.805
c72 ( 15 0 ) capacitor c=0.0154868f //x=14.095 //y=0.72
c73 ( 7 0 ) capacitor c=0.00689459f //x=13.21 //y=0.805
c74 ( 5 0 ) capacitor c=0.0235962f //x=13.125 //y=1.175
r75 (  19 34 ) resistor r=3.57586 //w=0.17 //l=0.125 //layer=li \
 //thickness=0.1 //x=14.18 //y=0.805 //x2=14.18 //y2=0.68
r76 (  19 34 ) resistor r=18.139 //w=0.187 //l=0.265 //layer=li \
 //thickness=0.1 //x=14.18 //y=0.805 //x2=14.18 //y2=1.07
r77 (  16 34 ) resistor r=3.57586 //w=0.17 //l=0.103078 //layer=li \
 //thickness=0.1 //x=13.295 //y=0.72 //x2=13.21 //y2=0.68
r78 (  16 34 ) resistor r=27.3797 //w=0.187 //l=0.4 //layer=li //thickness=0.1 \
 //x=13.295 //y=0.72 //x2=13.695 //y2=0.72
r79 (  15 34 ) resistor r=3.57586 //w=0.17 //l=0.103078 //layer=li \
 //thickness=0.1 //x=14.095 //y=0.72 //x2=14.18 //y2=0.68
r80 (  15 34 ) resistor r=27.3797 //w=0.187 //l=0.4 //layer=li //thickness=0.1 \
 //x=14.095 //y=0.72 //x2=13.695 //y2=0.72
r81 (  11 30 ) resistor r=5.4201 //w=0.17 //l=0.085 //layer=li //thickness=0.1 \
 //x=13.21 //y=1.26 //x2=13.21 //y2=1.175
r82 (  11 34 ) resistor r=10.2674 //w=0.187 //l=0.15 //layer=li \
 //thickness=0.1 //x=13.21 //y=1.26 //x2=13.21 //y2=1.41
r83 (  8 30 ) resistor r=5.4201 //w=0.17 //l=0.085 //layer=li //thickness=0.1 \
 //x=13.21 //y=1.09 //x2=13.21 //y2=1.175
r84 (  8 34 ) resistor r=1.36898 //w=0.187 //l=0.02 //layer=li //thickness=0.1 \
 //x=13.21 //y=1.09 //x2=13.21 //y2=1.07
r85 (  7 34 ) resistor r=3.57586 //w=0.17 //l=0.125 //layer=li //thickness=0.1 \
 //x=13.21 //y=0.805 //x2=13.21 //y2=0.68
r86 (  7 34 ) resistor r=18.139 //w=0.187 //l=0.265 //layer=li //thickness=0.1 \
 //x=13.21 //y=0.805 //x2=13.21 //y2=1.07
r87 (  6 33 ) resistor r=0.751729 //w=0.17 //l=0.085 //layer=li \
 //thickness=0.1 //x=12.245 //y=1.175 //x2=12.16 //y2=1.175
r88 (  5 30 ) resistor r=1.40859 //w=0.34 //l=0.085 //layer=li //thickness=0.1 \
 //x=13.125 //y=1.175 //x2=13.21 //y2=1.175
r89 (  5 6 ) resistor r=60.2353 //w=0.187 //l=0.88 //layer=li //thickness=0.1 \
 //x=13.125 //y=1.175 //x2=12.245 //y2=1.175
ends PM_TMRDFFSNRNQX1\%noxref_29

subckt PM_TMRDFFSNRNQX1\%noxref_30 ( 5 7 15 19 30 33 34 )
c67 ( 34 0 ) capacitor c=0.0452753f //x=17.885 //y=0.555
c68 ( 33 0 ) capacitor c=0.0194988f //x=16.78 //y=1.09
c69 ( 30 0 ) capacitor c=0.00141302f //x=18.02 //y=1.175
c70 ( 19 0 ) capacitor c=0.00692795f //x=18.99 //y=0.805
c71 ( 15 0 ) capacitor c=0.0153812f //x=18.905 //y=0.72
c72 ( 7 0 ) capacitor c=0.00689459f //x=18.02 //y=0.805
c73 ( 5 0 ) capacitor c=0.0235962f //x=17.935 //y=1.175
r74 (  19 34 ) resistor r=3.57586 //w=0.17 //l=0.125 //layer=li \
 //thickness=0.1 //x=18.99 //y=0.805 //x2=18.99 //y2=0.68
r75 (  19 34 ) resistor r=18.139 //w=0.187 //l=0.265 //layer=li \
 //thickness=0.1 //x=18.99 //y=0.805 //x2=18.99 //y2=1.07
r76 (  16 34 ) resistor r=3.57586 //w=0.17 //l=0.103078 //layer=li \
 //thickness=0.1 //x=18.105 //y=0.72 //x2=18.02 //y2=0.68
r77 (  16 34 ) resistor r=27.3797 //w=0.187 //l=0.4 //layer=li //thickness=0.1 \
 //x=18.105 //y=0.72 //x2=18.505 //y2=0.72
r78 (  15 34 ) resistor r=3.57586 //w=0.17 //l=0.103078 //layer=li \
 //thickness=0.1 //x=18.905 //y=0.72 //x2=18.99 //y2=0.68
r79 (  15 34 ) resistor r=27.3797 //w=0.187 //l=0.4 //layer=li //thickness=0.1 \
 //x=18.905 //y=0.72 //x2=18.505 //y2=0.72
r80 (  11 30 ) resistor r=5.4201 //w=0.17 //l=0.085 //layer=li //thickness=0.1 \
 //x=18.02 //y=1.26 //x2=18.02 //y2=1.175
r81 (  11 34 ) resistor r=10.2674 //w=0.187 //l=0.15 //layer=li \
 //thickness=0.1 //x=18.02 //y=1.26 //x2=18.02 //y2=1.41
r82 (  8 30 ) resistor r=5.4201 //w=0.17 //l=0.085 //layer=li //thickness=0.1 \
 //x=18.02 //y=1.09 //x2=18.02 //y2=1.175
r83 (  8 34 ) resistor r=1.36898 //w=0.187 //l=0.02 //layer=li //thickness=0.1 \
 //x=18.02 //y=1.09 //x2=18.02 //y2=1.07
r84 (  7 34 ) resistor r=3.57586 //w=0.17 //l=0.125 //layer=li //thickness=0.1 \
 //x=18.02 //y=0.805 //x2=18.02 //y2=0.68
r85 (  7 34 ) resistor r=18.139 //w=0.187 //l=0.265 //layer=li //thickness=0.1 \
 //x=18.02 //y=0.805 //x2=18.02 //y2=1.07
r86 (  6 33 ) resistor r=0.751729 //w=0.17 //l=0.085 //layer=li \
 //thickness=0.1 //x=17.055 //y=1.175 //x2=16.97 //y2=1.175
r87 (  5 30 ) resistor r=1.40859 //w=0.34 //l=0.085 //layer=li //thickness=0.1 \
 //x=17.935 //y=1.175 //x2=18.02 //y2=1.175
r88 (  5 6 ) resistor r=60.2353 //w=0.187 //l=0.88 //layer=li //thickness=0.1 \
 //x=17.935 //y=1.175 //x2=17.055 //y2=1.175
ends PM_TMRDFFSNRNQX1\%noxref_30

subckt PM_TMRDFFSNRNQX1\%noxref_31 ( 5 7 15 19 30 33 34 )
c68 ( 34 0 ) capacitor c=0.0444783f //x=22.695 //y=0.555
c69 ( 33 0 ) capacitor c=0.0190261f //x=21.59 //y=1.09
c70 ( 30 0 ) capacitor c=0.00141302f //x=22.83 //y=1.175
c71 ( 19 0 ) capacitor c=0.00692795f //x=23.8 //y=0.805
c72 ( 15 0 ) capacitor c=0.0155062f //x=23.715 //y=0.72
c73 ( 7 0 ) capacitor c=0.00689459f //x=22.83 //y=0.805
c74 ( 5 0 ) capacitor c=0.0235962f //x=22.745 //y=1.175
r75 (  19 34 ) resistor r=3.57586 //w=0.17 //l=0.125 //layer=li \
 //thickness=0.1 //x=23.8 //y=0.805 //x2=23.8 //y2=0.68
r76 (  19 34 ) resistor r=18.139 //w=0.187 //l=0.265 //layer=li \
 //thickness=0.1 //x=23.8 //y=0.805 //x2=23.8 //y2=1.07
r77 (  16 34 ) resistor r=3.57586 //w=0.17 //l=0.103078 //layer=li \
 //thickness=0.1 //x=22.915 //y=0.72 //x2=22.83 //y2=0.68
r78 (  16 34 ) resistor r=27.3797 //w=0.187 //l=0.4 //layer=li //thickness=0.1 \
 //x=22.915 //y=0.72 //x2=23.315 //y2=0.72
r79 (  15 34 ) resistor r=3.57586 //w=0.17 //l=0.103078 //layer=li \
 //thickness=0.1 //x=23.715 //y=0.72 //x2=23.8 //y2=0.68
r80 (  15 34 ) resistor r=27.3797 //w=0.187 //l=0.4 //layer=li //thickness=0.1 \
 //x=23.715 //y=0.72 //x2=23.315 //y2=0.72
r81 (  11 30 ) resistor r=5.4201 //w=0.17 //l=0.085 //layer=li //thickness=0.1 \
 //x=22.83 //y=1.26 //x2=22.83 //y2=1.175
r82 (  11 34 ) resistor r=10.2674 //w=0.187 //l=0.15 //layer=li \
 //thickness=0.1 //x=22.83 //y=1.26 //x2=22.83 //y2=1.41
r83 (  8 30 ) resistor r=5.4201 //w=0.17 //l=0.085 //layer=li //thickness=0.1 \
 //x=22.83 //y=1.09 //x2=22.83 //y2=1.175
r84 (  8 34 ) resistor r=1.36898 //w=0.187 //l=0.02 //layer=li //thickness=0.1 \
 //x=22.83 //y=1.09 //x2=22.83 //y2=1.07
r85 (  7 34 ) resistor r=3.57586 //w=0.17 //l=0.125 //layer=li //thickness=0.1 \
 //x=22.83 //y=0.805 //x2=22.83 //y2=0.68
r86 (  7 34 ) resistor r=18.139 //w=0.187 //l=0.265 //layer=li //thickness=0.1 \
 //x=22.83 //y=0.805 //x2=22.83 //y2=1.07
r87 (  6 33 ) resistor r=0.751729 //w=0.17 //l=0.085 //layer=li \
 //thickness=0.1 //x=21.865 //y=1.175 //x2=21.78 //y2=1.175
r88 (  5 30 ) resistor r=1.40859 //w=0.34 //l=0.085 //layer=li //thickness=0.1 \
 //x=22.745 //y=1.175 //x2=22.83 //y2=1.175
r89 (  5 6 ) resistor r=60.2353 //w=0.187 //l=0.88 //layer=li //thickness=0.1 \
 //x=22.745 //y=1.175 //x2=21.865 //y2=1.175
ends PM_TMRDFFSNRNQX1\%noxref_31

subckt PM_TMRDFFSNRNQX1\%noxref_32 ( 5 7 15 19 30 33 34 )
c69 ( 34 0 ) capacitor c=0.0450311f //x=27.505 //y=0.555
c70 ( 33 0 ) capacitor c=0.018587f //x=26.4 //y=1.09
c71 ( 30 0 ) capacitor c=0.00141302f //x=27.64 //y=1.175
c72 ( 19 0 ) capacitor c=0.00692795f //x=28.61 //y=0.805
c73 ( 15 0 ) capacitor c=0.0154873f //x=28.525 //y=0.72
c74 ( 7 0 ) capacitor c=0.00689459f //x=27.64 //y=0.805
c75 ( 5 0 ) capacitor c=0.0235962f //x=27.555 //y=1.175
r76 (  19 34 ) resistor r=3.57586 //w=0.17 //l=0.125 //layer=li \
 //thickness=0.1 //x=28.61 //y=0.805 //x2=28.61 //y2=0.68
r77 (  19 34 ) resistor r=18.139 //w=0.187 //l=0.265 //layer=li \
 //thickness=0.1 //x=28.61 //y=0.805 //x2=28.61 //y2=1.07
r78 (  16 34 ) resistor r=3.57586 //w=0.17 //l=0.103078 //layer=li \
 //thickness=0.1 //x=27.725 //y=0.72 //x2=27.64 //y2=0.68
r79 (  16 34 ) resistor r=27.3797 //w=0.187 //l=0.4 //layer=li //thickness=0.1 \
 //x=27.725 //y=0.72 //x2=28.125 //y2=0.72
r80 (  15 34 ) resistor r=3.57586 //w=0.17 //l=0.103078 //layer=li \
 //thickness=0.1 //x=28.525 //y=0.72 //x2=28.61 //y2=0.68
r81 (  15 34 ) resistor r=27.3797 //w=0.187 //l=0.4 //layer=li //thickness=0.1 \
 //x=28.525 //y=0.72 //x2=28.125 //y2=0.72
r82 (  11 30 ) resistor r=5.4201 //w=0.17 //l=0.085 //layer=li //thickness=0.1 \
 //x=27.64 //y=1.26 //x2=27.64 //y2=1.175
r83 (  11 34 ) resistor r=10.2674 //w=0.187 //l=0.15 //layer=li \
 //thickness=0.1 //x=27.64 //y=1.26 //x2=27.64 //y2=1.41
r84 (  8 30 ) resistor r=5.4201 //w=0.17 //l=0.085 //layer=li //thickness=0.1 \
 //x=27.64 //y=1.09 //x2=27.64 //y2=1.175
r85 (  8 34 ) resistor r=1.36898 //w=0.187 //l=0.02 //layer=li //thickness=0.1 \
 //x=27.64 //y=1.09 //x2=27.64 //y2=1.07
r86 (  7 34 ) resistor r=3.57586 //w=0.17 //l=0.125 //layer=li //thickness=0.1 \
 //x=27.64 //y=0.805 //x2=27.64 //y2=0.68
r87 (  7 34 ) resistor r=18.139 //w=0.187 //l=0.265 //layer=li //thickness=0.1 \
 //x=27.64 //y=0.805 //x2=27.64 //y2=1.07
r88 (  6 33 ) resistor r=0.751729 //w=0.17 //l=0.085 //layer=li \
 //thickness=0.1 //x=26.675 //y=1.175 //x2=26.59 //y2=1.175
r89 (  5 30 ) resistor r=1.40859 //w=0.34 //l=0.085 //layer=li //thickness=0.1 \
 //x=27.555 //y=1.175 //x2=27.64 //y2=1.175
r90 (  5 6 ) resistor r=60.2353 //w=0.187 //l=0.88 //layer=li //thickness=0.1 \
 //x=27.555 //y=1.175 //x2=26.675 //y2=1.175
ends PM_TMRDFFSNRNQX1\%noxref_32

subckt PM_TMRDFFSNRNQX1\%noxref_33 ( 5 7 15 19 30 33 34 )
c67 ( 34 0 ) capacitor c=0.0443556f //x=32.315 //y=0.555
c68 ( 33 0 ) capacitor c=0.019073f //x=31.21 //y=1.09
c69 ( 30 0 ) capacitor c=0.00141302f //x=32.45 //y=1.175
c70 ( 19 0 ) capacitor c=0.00692795f //x=33.42 //y=0.805
c71 ( 15 0 ) capacitor c=0.0155078f //x=33.335 //y=0.72
c72 ( 7 0 ) capacitor c=0.00689459f //x=32.45 //y=0.805
c73 ( 5 0 ) capacitor c=0.0235962f //x=32.365 //y=1.175
r74 (  19 34 ) resistor r=3.57586 //w=0.17 //l=0.125 //layer=li \
 //thickness=0.1 //x=33.42 //y=0.805 //x2=33.42 //y2=0.68
r75 (  19 34 ) resistor r=18.139 //w=0.187 //l=0.265 //layer=li \
 //thickness=0.1 //x=33.42 //y=0.805 //x2=33.42 //y2=1.07
r76 (  16 34 ) resistor r=3.57586 //w=0.17 //l=0.103078 //layer=li \
 //thickness=0.1 //x=32.535 //y=0.72 //x2=32.45 //y2=0.68
r77 (  16 34 ) resistor r=27.3797 //w=0.187 //l=0.4 //layer=li //thickness=0.1 \
 //x=32.535 //y=0.72 //x2=32.935 //y2=0.72
r78 (  15 34 ) resistor r=3.57586 //w=0.17 //l=0.103078 //layer=li \
 //thickness=0.1 //x=33.335 //y=0.72 //x2=33.42 //y2=0.68
r79 (  15 34 ) resistor r=27.3797 //w=0.187 //l=0.4 //layer=li //thickness=0.1 \
 //x=33.335 //y=0.72 //x2=32.935 //y2=0.72
r80 (  11 30 ) resistor r=5.4201 //w=0.17 //l=0.085 //layer=li //thickness=0.1 \
 //x=32.45 //y=1.26 //x2=32.45 //y2=1.175
r81 (  11 34 ) resistor r=10.2674 //w=0.187 //l=0.15 //layer=li \
 //thickness=0.1 //x=32.45 //y=1.26 //x2=32.45 //y2=1.41
r82 (  8 30 ) resistor r=5.4201 //w=0.17 //l=0.085 //layer=li //thickness=0.1 \
 //x=32.45 //y=1.09 //x2=32.45 //y2=1.175
r83 (  8 34 ) resistor r=1.36898 //w=0.187 //l=0.02 //layer=li //thickness=0.1 \
 //x=32.45 //y=1.09 //x2=32.45 //y2=1.07
r84 (  7 34 ) resistor r=3.57586 //w=0.17 //l=0.125 //layer=li //thickness=0.1 \
 //x=32.45 //y=0.805 //x2=32.45 //y2=0.68
r85 (  7 34 ) resistor r=18.139 //w=0.187 //l=0.265 //layer=li //thickness=0.1 \
 //x=32.45 //y=0.805 //x2=32.45 //y2=1.07
r86 (  6 33 ) resistor r=0.751729 //w=0.17 //l=0.085 //layer=li \
 //thickness=0.1 //x=31.485 //y=1.175 //x2=31.4 //y2=1.175
r87 (  5 30 ) resistor r=1.40859 //w=0.34 //l=0.085 //layer=li //thickness=0.1 \
 //x=32.365 //y=1.175 //x2=32.45 //y2=1.175
r88 (  5 6 ) resistor r=60.2353 //w=0.187 //l=0.88 //layer=li //thickness=0.1 \
 //x=32.365 //y=1.175 //x2=31.485 //y2=1.175
ends PM_TMRDFFSNRNQX1\%noxref_33

subckt PM_TMRDFFSNRNQX1\%noxref_34 ( 5 7 15 19 30 33 34 )
c67 ( 34 0 ) capacitor c=0.0451719f //x=37.125 //y=0.555
c68 ( 33 0 ) capacitor c=0.0194945f //x=36.02 //y=1.09
c69 ( 30 0 ) capacitor c=0.00141302f //x=37.26 //y=1.175
c70 ( 19 0 ) capacitor c=0.00692795f //x=38.23 //y=0.805
c71 ( 15 0 ) capacitor c=0.0154868f //x=38.145 //y=0.72
c72 ( 7 0 ) capacitor c=0.00689459f //x=37.26 //y=0.805
c73 ( 5 0 ) capacitor c=0.0235962f //x=37.175 //y=1.175
r74 (  19 34 ) resistor r=3.57586 //w=0.17 //l=0.125 //layer=li \
 //thickness=0.1 //x=38.23 //y=0.805 //x2=38.23 //y2=0.68
r75 (  19 34 ) resistor r=18.139 //w=0.187 //l=0.265 //layer=li \
 //thickness=0.1 //x=38.23 //y=0.805 //x2=38.23 //y2=1.07
r76 (  16 34 ) resistor r=3.57586 //w=0.17 //l=0.103078 //layer=li \
 //thickness=0.1 //x=37.345 //y=0.72 //x2=37.26 //y2=0.68
r77 (  16 34 ) resistor r=27.3797 //w=0.187 //l=0.4 //layer=li //thickness=0.1 \
 //x=37.345 //y=0.72 //x2=37.745 //y2=0.72
r78 (  15 34 ) resistor r=3.57586 //w=0.17 //l=0.103078 //layer=li \
 //thickness=0.1 //x=38.145 //y=0.72 //x2=38.23 //y2=0.68
r79 (  15 34 ) resistor r=27.3797 //w=0.187 //l=0.4 //layer=li //thickness=0.1 \
 //x=38.145 //y=0.72 //x2=37.745 //y2=0.72
r80 (  11 30 ) resistor r=5.4201 //w=0.17 //l=0.085 //layer=li //thickness=0.1 \
 //x=37.26 //y=1.26 //x2=37.26 //y2=1.175
r81 (  11 34 ) resistor r=10.2674 //w=0.187 //l=0.15 //layer=li \
 //thickness=0.1 //x=37.26 //y=1.26 //x2=37.26 //y2=1.41
r82 (  8 30 ) resistor r=5.4201 //w=0.17 //l=0.085 //layer=li //thickness=0.1 \
 //x=37.26 //y=1.09 //x2=37.26 //y2=1.175
r83 (  8 34 ) resistor r=1.36898 //w=0.187 //l=0.02 //layer=li //thickness=0.1 \
 //x=37.26 //y=1.09 //x2=37.26 //y2=1.07
r84 (  7 34 ) resistor r=3.57586 //w=0.17 //l=0.125 //layer=li //thickness=0.1 \
 //x=37.26 //y=0.805 //x2=37.26 //y2=0.68
r85 (  7 34 ) resistor r=18.139 //w=0.187 //l=0.265 //layer=li //thickness=0.1 \
 //x=37.26 //y=0.805 //x2=37.26 //y2=1.07
r86 (  6 33 ) resistor r=0.751729 //w=0.17 //l=0.085 //layer=li \
 //thickness=0.1 //x=36.295 //y=1.175 //x2=36.21 //y2=1.175
r87 (  5 30 ) resistor r=1.40859 //w=0.34 //l=0.085 //layer=li //thickness=0.1 \
 //x=37.175 //y=1.175 //x2=37.26 //y2=1.175
r88 (  5 6 ) resistor r=60.2353 //w=0.187 //l=0.88 //layer=li //thickness=0.1 \
 //x=37.175 //y=1.175 //x2=36.295 //y2=1.175
ends PM_TMRDFFSNRNQX1\%noxref_34

subckt PM_TMRDFFSNRNQX1\%noxref_35 ( 5 7 15 19 30 33 34 )
c68 ( 34 0 ) capacitor c=0.0442917f //x=41.935 //y=0.555
c69 ( 33 0 ) capacitor c=0.0193551f //x=40.83 //y=1.09
c70 ( 30 0 ) capacitor c=0.00141302f //x=42.07 //y=1.175
c71 ( 19 0 ) capacitor c=0.00692795f //x=43.04 //y=0.805
c72 ( 15 0 ) capacitor c=0.0154868f //x=42.955 //y=0.72
c73 ( 7 0 ) capacitor c=0.00689459f //x=42.07 //y=0.805
c74 ( 5 0 ) capacitor c=0.0235962f //x=41.985 //y=1.175
r75 (  19 34 ) resistor r=3.57586 //w=0.17 //l=0.125 //layer=li \
 //thickness=0.1 //x=43.04 //y=0.805 //x2=43.04 //y2=0.68
r76 (  19 34 ) resistor r=18.139 //w=0.187 //l=0.265 //layer=li \
 //thickness=0.1 //x=43.04 //y=0.805 //x2=43.04 //y2=1.07
r77 (  16 34 ) resistor r=3.57586 //w=0.17 //l=0.103078 //layer=li \
 //thickness=0.1 //x=42.155 //y=0.72 //x2=42.07 //y2=0.68
r78 (  16 34 ) resistor r=27.3797 //w=0.187 //l=0.4 //layer=li //thickness=0.1 \
 //x=42.155 //y=0.72 //x2=42.555 //y2=0.72
r79 (  15 34 ) resistor r=3.57586 //w=0.17 //l=0.103078 //layer=li \
 //thickness=0.1 //x=42.955 //y=0.72 //x2=43.04 //y2=0.68
r80 (  15 34 ) resistor r=27.3797 //w=0.187 //l=0.4 //layer=li //thickness=0.1 \
 //x=42.955 //y=0.72 //x2=42.555 //y2=0.72
r81 (  11 30 ) resistor r=5.4201 //w=0.17 //l=0.085 //layer=li //thickness=0.1 \
 //x=42.07 //y=1.26 //x2=42.07 //y2=1.175
r82 (  11 34 ) resistor r=10.2674 //w=0.187 //l=0.15 //layer=li \
 //thickness=0.1 //x=42.07 //y=1.26 //x2=42.07 //y2=1.41
r83 (  8 30 ) resistor r=5.4201 //w=0.17 //l=0.085 //layer=li //thickness=0.1 \
 //x=42.07 //y=1.09 //x2=42.07 //y2=1.175
r84 (  8 34 ) resistor r=1.36898 //w=0.187 //l=0.02 //layer=li //thickness=0.1 \
 //x=42.07 //y=1.09 //x2=42.07 //y2=1.07
r85 (  7 34 ) resistor r=3.57586 //w=0.17 //l=0.125 //layer=li //thickness=0.1 \
 //x=42.07 //y=0.805 //x2=42.07 //y2=0.68
r86 (  7 34 ) resistor r=18.139 //w=0.187 //l=0.265 //layer=li //thickness=0.1 \
 //x=42.07 //y=0.805 //x2=42.07 //y2=1.07
r87 (  6 33 ) resistor r=0.751729 //w=0.17 //l=0.085 //layer=li \
 //thickness=0.1 //x=41.105 //y=1.175 //x2=41.02 //y2=1.175
r88 (  5 30 ) resistor r=1.40859 //w=0.34 //l=0.085 //layer=li //thickness=0.1 \
 //x=41.985 //y=1.175 //x2=42.07 //y2=1.175
r89 (  5 6 ) resistor r=60.2353 //w=0.187 //l=0.88 //layer=li //thickness=0.1 \
 //x=41.985 //y=1.175 //x2=41.105 //y2=1.175
ends PM_TMRDFFSNRNQX1\%noxref_35

subckt PM_TMRDFFSNRNQX1\%noxref_36 ( 5 7 15 19 30 33 34 )
c67 ( 34 0 ) capacitor c=0.0452753f //x=46.745 //y=0.555
c68 ( 33 0 ) capacitor c=0.0194988f //x=45.64 //y=1.09
c69 ( 30 0 ) capacitor c=0.00141302f //x=46.88 //y=1.175
c70 ( 19 0 ) capacitor c=0.00692795f //x=47.85 //y=0.805
c71 ( 15 0 ) capacitor c=0.0153812f //x=47.765 //y=0.72
c72 ( 7 0 ) capacitor c=0.00689459f //x=46.88 //y=0.805
c73 ( 5 0 ) capacitor c=0.0235962f //x=46.795 //y=1.175
r74 (  19 34 ) resistor r=3.57586 //w=0.17 //l=0.125 //layer=li \
 //thickness=0.1 //x=47.85 //y=0.805 //x2=47.85 //y2=0.68
r75 (  19 34 ) resistor r=18.139 //w=0.187 //l=0.265 //layer=li \
 //thickness=0.1 //x=47.85 //y=0.805 //x2=47.85 //y2=1.07
r76 (  16 34 ) resistor r=3.57586 //w=0.17 //l=0.103078 //layer=li \
 //thickness=0.1 //x=46.965 //y=0.72 //x2=46.88 //y2=0.68
r77 (  16 34 ) resistor r=27.3797 //w=0.187 //l=0.4 //layer=li //thickness=0.1 \
 //x=46.965 //y=0.72 //x2=47.365 //y2=0.72
r78 (  15 34 ) resistor r=3.57586 //w=0.17 //l=0.103078 //layer=li \
 //thickness=0.1 //x=47.765 //y=0.72 //x2=47.85 //y2=0.68
r79 (  15 34 ) resistor r=27.3797 //w=0.187 //l=0.4 //layer=li //thickness=0.1 \
 //x=47.765 //y=0.72 //x2=47.365 //y2=0.72
r80 (  11 30 ) resistor r=5.4201 //w=0.17 //l=0.085 //layer=li //thickness=0.1 \
 //x=46.88 //y=1.26 //x2=46.88 //y2=1.175
r81 (  11 34 ) resistor r=10.2674 //w=0.187 //l=0.15 //layer=li \
 //thickness=0.1 //x=46.88 //y=1.26 //x2=46.88 //y2=1.41
r82 (  8 30 ) resistor r=5.4201 //w=0.17 //l=0.085 //layer=li //thickness=0.1 \
 //x=46.88 //y=1.09 //x2=46.88 //y2=1.175
r83 (  8 34 ) resistor r=1.36898 //w=0.187 //l=0.02 //layer=li //thickness=0.1 \
 //x=46.88 //y=1.09 //x2=46.88 //y2=1.07
r84 (  7 34 ) resistor r=3.57586 //w=0.17 //l=0.125 //layer=li //thickness=0.1 \
 //x=46.88 //y=0.805 //x2=46.88 //y2=0.68
r85 (  7 34 ) resistor r=18.139 //w=0.187 //l=0.265 //layer=li //thickness=0.1 \
 //x=46.88 //y=0.805 //x2=46.88 //y2=1.07
r86 (  6 33 ) resistor r=0.751729 //w=0.17 //l=0.085 //layer=li \
 //thickness=0.1 //x=45.915 //y=1.175 //x2=45.83 //y2=1.175
r87 (  5 30 ) resistor r=1.40859 //w=0.34 //l=0.085 //layer=li //thickness=0.1 \
 //x=46.795 //y=1.175 //x2=46.88 //y2=1.175
r88 (  5 6 ) resistor r=60.2353 //w=0.187 //l=0.88 //layer=li //thickness=0.1 \
 //x=46.795 //y=1.175 //x2=45.915 //y2=1.175
ends PM_TMRDFFSNRNQX1\%noxref_36

subckt PM_TMRDFFSNRNQX1\%noxref_37 ( 5 7 15 19 30 33 34 )
c68 ( 34 0 ) capacitor c=0.0444783f //x=51.555 //y=0.555
c69 ( 33 0 ) capacitor c=0.0190261f //x=50.45 //y=1.09
c70 ( 30 0 ) capacitor c=0.00141302f //x=51.69 //y=1.175
c71 ( 19 0 ) capacitor c=0.00692795f //x=52.66 //y=0.805
c72 ( 15 0 ) capacitor c=0.0155062f //x=52.575 //y=0.72
c73 ( 7 0 ) capacitor c=0.00689459f //x=51.69 //y=0.805
c74 ( 5 0 ) capacitor c=0.0235962f //x=51.605 //y=1.175
r75 (  19 34 ) resistor r=3.57586 //w=0.17 //l=0.125 //layer=li \
 //thickness=0.1 //x=52.66 //y=0.805 //x2=52.66 //y2=0.68
r76 (  19 34 ) resistor r=18.139 //w=0.187 //l=0.265 //layer=li \
 //thickness=0.1 //x=52.66 //y=0.805 //x2=52.66 //y2=1.07
r77 (  16 34 ) resistor r=3.57586 //w=0.17 //l=0.103078 //layer=li \
 //thickness=0.1 //x=51.775 //y=0.72 //x2=51.69 //y2=0.68
r78 (  16 34 ) resistor r=27.3797 //w=0.187 //l=0.4 //layer=li //thickness=0.1 \
 //x=51.775 //y=0.72 //x2=52.175 //y2=0.72
r79 (  15 34 ) resistor r=3.57586 //w=0.17 //l=0.103078 //layer=li \
 //thickness=0.1 //x=52.575 //y=0.72 //x2=52.66 //y2=0.68
r80 (  15 34 ) resistor r=27.3797 //w=0.187 //l=0.4 //layer=li //thickness=0.1 \
 //x=52.575 //y=0.72 //x2=52.175 //y2=0.72
r81 (  11 30 ) resistor r=5.4201 //w=0.17 //l=0.085 //layer=li //thickness=0.1 \
 //x=51.69 //y=1.26 //x2=51.69 //y2=1.175
r82 (  11 34 ) resistor r=10.2674 //w=0.187 //l=0.15 //layer=li \
 //thickness=0.1 //x=51.69 //y=1.26 //x2=51.69 //y2=1.41
r83 (  8 30 ) resistor r=5.4201 //w=0.17 //l=0.085 //layer=li //thickness=0.1 \
 //x=51.69 //y=1.09 //x2=51.69 //y2=1.175
r84 (  8 34 ) resistor r=1.36898 //w=0.187 //l=0.02 //layer=li //thickness=0.1 \
 //x=51.69 //y=1.09 //x2=51.69 //y2=1.07
r85 (  7 34 ) resistor r=3.57586 //w=0.17 //l=0.125 //layer=li //thickness=0.1 \
 //x=51.69 //y=0.805 //x2=51.69 //y2=0.68
r86 (  7 34 ) resistor r=18.139 //w=0.187 //l=0.265 //layer=li //thickness=0.1 \
 //x=51.69 //y=0.805 //x2=51.69 //y2=1.07
r87 (  6 33 ) resistor r=0.751729 //w=0.17 //l=0.085 //layer=li \
 //thickness=0.1 //x=50.725 //y=1.175 //x2=50.64 //y2=1.175
r88 (  5 30 ) resistor r=1.40859 //w=0.34 //l=0.085 //layer=li //thickness=0.1 \
 //x=51.605 //y=1.175 //x2=51.69 //y2=1.175
r89 (  5 6 ) resistor r=60.2353 //w=0.187 //l=0.88 //layer=li //thickness=0.1 \
 //x=51.605 //y=1.175 //x2=50.725 //y2=1.175
ends PM_TMRDFFSNRNQX1\%noxref_37

subckt PM_TMRDFFSNRNQX1\%noxref_38 ( 5 7 15 19 30 33 34 )
c69 ( 34 0 ) capacitor c=0.0450311f //x=56.365 //y=0.555
c70 ( 33 0 ) capacitor c=0.018587f //x=55.26 //y=1.09
c71 ( 30 0 ) capacitor c=0.00141302f //x=56.5 //y=1.175
c72 ( 19 0 ) capacitor c=0.00692795f //x=57.47 //y=0.805
c73 ( 15 0 ) capacitor c=0.0154873f //x=57.385 //y=0.72
c74 ( 7 0 ) capacitor c=0.00689459f //x=56.5 //y=0.805
c75 ( 5 0 ) capacitor c=0.0235962f //x=56.415 //y=1.175
r76 (  19 34 ) resistor r=3.57586 //w=0.17 //l=0.125 //layer=li \
 //thickness=0.1 //x=57.47 //y=0.805 //x2=57.47 //y2=0.68
r77 (  19 34 ) resistor r=18.139 //w=0.187 //l=0.265 //layer=li \
 //thickness=0.1 //x=57.47 //y=0.805 //x2=57.47 //y2=1.07
r78 (  16 34 ) resistor r=3.57586 //w=0.17 //l=0.103078 //layer=li \
 //thickness=0.1 //x=56.585 //y=0.72 //x2=56.5 //y2=0.68
r79 (  16 34 ) resistor r=27.3797 //w=0.187 //l=0.4 //layer=li //thickness=0.1 \
 //x=56.585 //y=0.72 //x2=56.985 //y2=0.72
r80 (  15 34 ) resistor r=3.57586 //w=0.17 //l=0.103078 //layer=li \
 //thickness=0.1 //x=57.385 //y=0.72 //x2=57.47 //y2=0.68
r81 (  15 34 ) resistor r=27.3797 //w=0.187 //l=0.4 //layer=li //thickness=0.1 \
 //x=57.385 //y=0.72 //x2=56.985 //y2=0.72
r82 (  11 30 ) resistor r=5.4201 //w=0.17 //l=0.085 //layer=li //thickness=0.1 \
 //x=56.5 //y=1.26 //x2=56.5 //y2=1.175
r83 (  11 34 ) resistor r=10.2674 //w=0.187 //l=0.15 //layer=li \
 //thickness=0.1 //x=56.5 //y=1.26 //x2=56.5 //y2=1.41
r84 (  8 30 ) resistor r=5.4201 //w=0.17 //l=0.085 //layer=li //thickness=0.1 \
 //x=56.5 //y=1.09 //x2=56.5 //y2=1.175
r85 (  8 34 ) resistor r=1.36898 //w=0.187 //l=0.02 //layer=li //thickness=0.1 \
 //x=56.5 //y=1.09 //x2=56.5 //y2=1.07
r86 (  7 34 ) resistor r=3.57586 //w=0.17 //l=0.125 //layer=li //thickness=0.1 \
 //x=56.5 //y=0.805 //x2=56.5 //y2=0.68
r87 (  7 34 ) resistor r=18.139 //w=0.187 //l=0.265 //layer=li //thickness=0.1 \
 //x=56.5 //y=0.805 //x2=56.5 //y2=1.07
r88 (  6 33 ) resistor r=0.751729 //w=0.17 //l=0.085 //layer=li \
 //thickness=0.1 //x=55.535 //y=1.175 //x2=55.45 //y2=1.175
r89 (  5 30 ) resistor r=1.40859 //w=0.34 //l=0.085 //layer=li //thickness=0.1 \
 //x=56.415 //y=1.175 //x2=56.5 //y2=1.175
r90 (  5 6 ) resistor r=60.2353 //w=0.187 //l=0.88 //layer=li //thickness=0.1 \
 //x=56.415 //y=1.175 //x2=55.535 //y2=1.175
ends PM_TMRDFFSNRNQX1\%noxref_38

subckt PM_TMRDFFSNRNQX1\%noxref_39 ( 5 7 15 19 30 33 34 )
c67 ( 34 0 ) capacitor c=0.0443556f //x=61.175 //y=0.555
c68 ( 33 0 ) capacitor c=0.019073f //x=60.07 //y=1.09
c69 ( 30 0 ) capacitor c=0.00141302f //x=61.31 //y=1.175
c70 ( 19 0 ) capacitor c=0.00692795f //x=62.28 //y=0.805
c71 ( 15 0 ) capacitor c=0.0155078f //x=62.195 //y=0.72
c72 ( 7 0 ) capacitor c=0.00689459f //x=61.31 //y=0.805
c73 ( 5 0 ) capacitor c=0.0235962f //x=61.225 //y=1.175
r74 (  19 34 ) resistor r=3.57586 //w=0.17 //l=0.125 //layer=li \
 //thickness=0.1 //x=62.28 //y=0.805 //x2=62.28 //y2=0.68
r75 (  19 34 ) resistor r=18.139 //w=0.187 //l=0.265 //layer=li \
 //thickness=0.1 //x=62.28 //y=0.805 //x2=62.28 //y2=1.07
r76 (  16 34 ) resistor r=3.57586 //w=0.17 //l=0.103078 //layer=li \
 //thickness=0.1 //x=61.395 //y=0.72 //x2=61.31 //y2=0.68
r77 (  16 34 ) resistor r=27.3797 //w=0.187 //l=0.4 //layer=li //thickness=0.1 \
 //x=61.395 //y=0.72 //x2=61.795 //y2=0.72
r78 (  15 34 ) resistor r=3.57586 //w=0.17 //l=0.103078 //layer=li \
 //thickness=0.1 //x=62.195 //y=0.72 //x2=62.28 //y2=0.68
r79 (  15 34 ) resistor r=27.3797 //w=0.187 //l=0.4 //layer=li //thickness=0.1 \
 //x=62.195 //y=0.72 //x2=61.795 //y2=0.72
r80 (  11 30 ) resistor r=5.4201 //w=0.17 //l=0.085 //layer=li //thickness=0.1 \
 //x=61.31 //y=1.26 //x2=61.31 //y2=1.175
r81 (  11 34 ) resistor r=10.2674 //w=0.187 //l=0.15 //layer=li \
 //thickness=0.1 //x=61.31 //y=1.26 //x2=61.31 //y2=1.41
r82 (  8 30 ) resistor r=5.4201 //w=0.17 //l=0.085 //layer=li //thickness=0.1 \
 //x=61.31 //y=1.09 //x2=61.31 //y2=1.175
r83 (  8 34 ) resistor r=1.36898 //w=0.187 //l=0.02 //layer=li //thickness=0.1 \
 //x=61.31 //y=1.09 //x2=61.31 //y2=1.07
r84 (  7 34 ) resistor r=3.57586 //w=0.17 //l=0.125 //layer=li //thickness=0.1 \
 //x=61.31 //y=0.805 //x2=61.31 //y2=0.68
r85 (  7 34 ) resistor r=18.139 //w=0.187 //l=0.265 //layer=li //thickness=0.1 \
 //x=61.31 //y=0.805 //x2=61.31 //y2=1.07
r86 (  6 33 ) resistor r=0.751729 //w=0.17 //l=0.085 //layer=li \
 //thickness=0.1 //x=60.345 //y=1.175 //x2=60.26 //y2=1.175
r87 (  5 30 ) resistor r=1.40859 //w=0.34 //l=0.085 //layer=li //thickness=0.1 \
 //x=61.225 //y=1.175 //x2=61.31 //y2=1.175
r88 (  5 6 ) resistor r=60.2353 //w=0.187 //l=0.88 //layer=li //thickness=0.1 \
 //x=61.225 //y=1.175 //x2=60.345 //y2=1.175
ends PM_TMRDFFSNRNQX1\%noxref_39

subckt PM_TMRDFFSNRNQX1\%noxref_40 ( 5 7 15 19 30 33 34 )
c67 ( 34 0 ) capacitor c=0.0451719f //x=65.985 //y=0.555
c68 ( 33 0 ) capacitor c=0.0194945f //x=64.88 //y=1.09
c69 ( 30 0 ) capacitor c=0.00141302f //x=66.12 //y=1.175
c70 ( 19 0 ) capacitor c=0.00692795f //x=67.09 //y=0.805
c71 ( 15 0 ) capacitor c=0.0154868f //x=67.005 //y=0.72
c72 ( 7 0 ) capacitor c=0.00689459f //x=66.12 //y=0.805
c73 ( 5 0 ) capacitor c=0.0235962f //x=66.035 //y=1.175
r74 (  19 34 ) resistor r=3.57586 //w=0.17 //l=0.125 //layer=li \
 //thickness=0.1 //x=67.09 //y=0.805 //x2=67.09 //y2=0.68
r75 (  19 34 ) resistor r=18.139 //w=0.187 //l=0.265 //layer=li \
 //thickness=0.1 //x=67.09 //y=0.805 //x2=67.09 //y2=1.07
r76 (  16 34 ) resistor r=3.57586 //w=0.17 //l=0.103078 //layer=li \
 //thickness=0.1 //x=66.205 //y=0.72 //x2=66.12 //y2=0.68
r77 (  16 34 ) resistor r=27.3797 //w=0.187 //l=0.4 //layer=li //thickness=0.1 \
 //x=66.205 //y=0.72 //x2=66.605 //y2=0.72
r78 (  15 34 ) resistor r=3.57586 //w=0.17 //l=0.103078 //layer=li \
 //thickness=0.1 //x=67.005 //y=0.72 //x2=67.09 //y2=0.68
r79 (  15 34 ) resistor r=27.3797 //w=0.187 //l=0.4 //layer=li //thickness=0.1 \
 //x=67.005 //y=0.72 //x2=66.605 //y2=0.72
r80 (  11 30 ) resistor r=5.4201 //w=0.17 //l=0.085 //layer=li //thickness=0.1 \
 //x=66.12 //y=1.26 //x2=66.12 //y2=1.175
r81 (  11 34 ) resistor r=10.2674 //w=0.187 //l=0.15 //layer=li \
 //thickness=0.1 //x=66.12 //y=1.26 //x2=66.12 //y2=1.41
r82 (  8 30 ) resistor r=5.4201 //w=0.17 //l=0.085 //layer=li //thickness=0.1 \
 //x=66.12 //y=1.09 //x2=66.12 //y2=1.175
r83 (  8 34 ) resistor r=1.36898 //w=0.187 //l=0.02 //layer=li //thickness=0.1 \
 //x=66.12 //y=1.09 //x2=66.12 //y2=1.07
r84 (  7 34 ) resistor r=3.57586 //w=0.17 //l=0.125 //layer=li //thickness=0.1 \
 //x=66.12 //y=0.805 //x2=66.12 //y2=0.68
r85 (  7 34 ) resistor r=18.139 //w=0.187 //l=0.265 //layer=li //thickness=0.1 \
 //x=66.12 //y=0.805 //x2=66.12 //y2=1.07
r86 (  6 33 ) resistor r=0.751729 //w=0.17 //l=0.085 //layer=li \
 //thickness=0.1 //x=65.155 //y=1.175 //x2=65.07 //y2=1.175
r87 (  5 30 ) resistor r=1.40859 //w=0.34 //l=0.085 //layer=li //thickness=0.1 \
 //x=66.035 //y=1.175 //x2=66.12 //y2=1.175
r88 (  5 6 ) resistor r=60.2353 //w=0.187 //l=0.88 //layer=li //thickness=0.1 \
 //x=66.035 //y=1.175 //x2=65.155 //y2=1.175
ends PM_TMRDFFSNRNQX1\%noxref_40

subckt PM_TMRDFFSNRNQX1\%noxref_41 ( 5 7 15 19 30 33 34 )
c68 ( 34 0 ) capacitor c=0.0442917f //x=70.795 //y=0.555
c69 ( 33 0 ) capacitor c=0.0193551f //x=69.69 //y=1.09
c70 ( 30 0 ) capacitor c=0.00141302f //x=70.93 //y=1.175
c71 ( 19 0 ) capacitor c=0.00692795f //x=71.9 //y=0.805
c72 ( 15 0 ) capacitor c=0.0154868f //x=71.815 //y=0.72
c73 ( 7 0 ) capacitor c=0.00689459f //x=70.93 //y=0.805
c74 ( 5 0 ) capacitor c=0.0235962f //x=70.845 //y=1.175
r75 (  19 34 ) resistor r=3.57586 //w=0.17 //l=0.125 //layer=li \
 //thickness=0.1 //x=71.9 //y=0.805 //x2=71.9 //y2=0.68
r76 (  19 34 ) resistor r=18.139 //w=0.187 //l=0.265 //layer=li \
 //thickness=0.1 //x=71.9 //y=0.805 //x2=71.9 //y2=1.07
r77 (  16 34 ) resistor r=3.57586 //w=0.17 //l=0.103078 //layer=li \
 //thickness=0.1 //x=71.015 //y=0.72 //x2=70.93 //y2=0.68
r78 (  16 34 ) resistor r=27.3797 //w=0.187 //l=0.4 //layer=li //thickness=0.1 \
 //x=71.015 //y=0.72 //x2=71.415 //y2=0.72
r79 (  15 34 ) resistor r=3.57586 //w=0.17 //l=0.103078 //layer=li \
 //thickness=0.1 //x=71.815 //y=0.72 //x2=71.9 //y2=0.68
r80 (  15 34 ) resistor r=27.3797 //w=0.187 //l=0.4 //layer=li //thickness=0.1 \
 //x=71.815 //y=0.72 //x2=71.415 //y2=0.72
r81 (  11 30 ) resistor r=5.4201 //w=0.17 //l=0.085 //layer=li //thickness=0.1 \
 //x=70.93 //y=1.26 //x2=70.93 //y2=1.175
r82 (  11 34 ) resistor r=10.2674 //w=0.187 //l=0.15 //layer=li \
 //thickness=0.1 //x=70.93 //y=1.26 //x2=70.93 //y2=1.41
r83 (  8 30 ) resistor r=5.4201 //w=0.17 //l=0.085 //layer=li //thickness=0.1 \
 //x=70.93 //y=1.09 //x2=70.93 //y2=1.175
r84 (  8 34 ) resistor r=1.36898 //w=0.187 //l=0.02 //layer=li //thickness=0.1 \
 //x=70.93 //y=1.09 //x2=70.93 //y2=1.07
r85 (  7 34 ) resistor r=3.57586 //w=0.17 //l=0.125 //layer=li //thickness=0.1 \
 //x=70.93 //y=0.805 //x2=70.93 //y2=0.68
r86 (  7 34 ) resistor r=18.139 //w=0.187 //l=0.265 //layer=li //thickness=0.1 \
 //x=70.93 //y=0.805 //x2=70.93 //y2=1.07
r87 (  6 33 ) resistor r=0.751729 //w=0.17 //l=0.085 //layer=li \
 //thickness=0.1 //x=69.965 //y=1.175 //x2=69.88 //y2=1.175
r88 (  5 30 ) resistor r=1.40859 //w=0.34 //l=0.085 //layer=li //thickness=0.1 \
 //x=70.845 //y=1.175 //x2=70.93 //y2=1.175
r89 (  5 6 ) resistor r=60.2353 //w=0.187 //l=0.88 //layer=li //thickness=0.1 \
 //x=70.845 //y=1.175 //x2=69.965 //y2=1.175
ends PM_TMRDFFSNRNQX1\%noxref_41

subckt PM_TMRDFFSNRNQX1\%noxref_42 ( 5 7 15 19 30 33 34 )
c67 ( 34 0 ) capacitor c=0.0452753f //x=75.605 //y=0.555
c68 ( 33 0 ) capacitor c=0.0194988f //x=74.5 //y=1.09
c69 ( 30 0 ) capacitor c=0.00141302f //x=75.74 //y=1.175
c70 ( 19 0 ) capacitor c=0.00692795f //x=76.71 //y=0.805
c71 ( 15 0 ) capacitor c=0.0153812f //x=76.625 //y=0.72
c72 ( 7 0 ) capacitor c=0.00689459f //x=75.74 //y=0.805
c73 ( 5 0 ) capacitor c=0.0235962f //x=75.655 //y=1.175
r74 (  19 34 ) resistor r=3.57586 //w=0.17 //l=0.125 //layer=li \
 //thickness=0.1 //x=76.71 //y=0.805 //x2=76.71 //y2=0.68
r75 (  19 34 ) resistor r=18.139 //w=0.187 //l=0.265 //layer=li \
 //thickness=0.1 //x=76.71 //y=0.805 //x2=76.71 //y2=1.07
r76 (  16 34 ) resistor r=3.57586 //w=0.17 //l=0.103078 //layer=li \
 //thickness=0.1 //x=75.825 //y=0.72 //x2=75.74 //y2=0.68
r77 (  16 34 ) resistor r=27.3797 //w=0.187 //l=0.4 //layer=li //thickness=0.1 \
 //x=75.825 //y=0.72 //x2=76.225 //y2=0.72
r78 (  15 34 ) resistor r=3.57586 //w=0.17 //l=0.103078 //layer=li \
 //thickness=0.1 //x=76.625 //y=0.72 //x2=76.71 //y2=0.68
r79 (  15 34 ) resistor r=27.3797 //w=0.187 //l=0.4 //layer=li //thickness=0.1 \
 //x=76.625 //y=0.72 //x2=76.225 //y2=0.72
r80 (  11 30 ) resistor r=5.4201 //w=0.17 //l=0.085 //layer=li //thickness=0.1 \
 //x=75.74 //y=1.26 //x2=75.74 //y2=1.175
r81 (  11 34 ) resistor r=10.2674 //w=0.187 //l=0.15 //layer=li \
 //thickness=0.1 //x=75.74 //y=1.26 //x2=75.74 //y2=1.41
r82 (  8 30 ) resistor r=5.4201 //w=0.17 //l=0.085 //layer=li //thickness=0.1 \
 //x=75.74 //y=1.09 //x2=75.74 //y2=1.175
r83 (  8 34 ) resistor r=1.36898 //w=0.187 //l=0.02 //layer=li //thickness=0.1 \
 //x=75.74 //y=1.09 //x2=75.74 //y2=1.07
r84 (  7 34 ) resistor r=3.57586 //w=0.17 //l=0.125 //layer=li //thickness=0.1 \
 //x=75.74 //y=0.805 //x2=75.74 //y2=0.68
r85 (  7 34 ) resistor r=18.139 //w=0.187 //l=0.265 //layer=li //thickness=0.1 \
 //x=75.74 //y=0.805 //x2=75.74 //y2=1.07
r86 (  6 33 ) resistor r=0.751729 //w=0.17 //l=0.085 //layer=li \
 //thickness=0.1 //x=74.775 //y=1.175 //x2=74.69 //y2=1.175
r87 (  5 30 ) resistor r=1.40859 //w=0.34 //l=0.085 //layer=li //thickness=0.1 \
 //x=75.655 //y=1.175 //x2=75.74 //y2=1.175
r88 (  5 6 ) resistor r=60.2353 //w=0.187 //l=0.88 //layer=li //thickness=0.1 \
 //x=75.655 //y=1.175 //x2=74.775 //y2=1.175
ends PM_TMRDFFSNRNQX1\%noxref_42

subckt PM_TMRDFFSNRNQX1\%noxref_43 ( 5 7 15 19 30 33 34 )
c68 ( 34 0 ) capacitor c=0.0445231f //x=80.415 //y=0.555
c69 ( 33 0 ) capacitor c=0.0190261f //x=79.31 //y=1.09
c70 ( 30 0 ) capacitor c=0.00141302f //x=80.55 //y=1.175
c71 ( 19 0 ) capacitor c=0.00692795f //x=81.52 //y=0.805
c72 ( 15 0 ) capacitor c=0.0153783f //x=81.435 //y=0.72
c73 ( 7 0 ) capacitor c=0.00689459f //x=80.55 //y=0.805
c74 ( 5 0 ) capacitor c=0.0247635f //x=80.465 //y=1.175
r75 (  19 34 ) resistor r=3.57586 //w=0.17 //l=0.125 //layer=li \
 //thickness=0.1 //x=81.52 //y=0.805 //x2=81.52 //y2=0.68
r76 (  19 34 ) resistor r=18.139 //w=0.187 //l=0.265 //layer=li \
 //thickness=0.1 //x=81.52 //y=0.805 //x2=81.52 //y2=1.07
r77 (  16 34 ) resistor r=3.57586 //w=0.17 //l=0.103078 //layer=li \
 //thickness=0.1 //x=80.635 //y=0.72 //x2=80.55 //y2=0.68
r78 (  16 34 ) resistor r=27.3797 //w=0.187 //l=0.4 //layer=li //thickness=0.1 \
 //x=80.635 //y=0.72 //x2=81.035 //y2=0.72
r79 (  15 34 ) resistor r=3.57586 //w=0.17 //l=0.103078 //layer=li \
 //thickness=0.1 //x=81.435 //y=0.72 //x2=81.52 //y2=0.68
r80 (  15 34 ) resistor r=27.3797 //w=0.187 //l=0.4 //layer=li //thickness=0.1 \
 //x=81.435 //y=0.72 //x2=81.035 //y2=0.72
r81 (  11 30 ) resistor r=5.4201 //w=0.17 //l=0.085 //layer=li //thickness=0.1 \
 //x=80.55 //y=1.26 //x2=80.55 //y2=1.175
r82 (  11 34 ) resistor r=10.2674 //w=0.187 //l=0.15 //layer=li \
 //thickness=0.1 //x=80.55 //y=1.26 //x2=80.55 //y2=1.41
r83 (  8 30 ) resistor r=5.4201 //w=0.17 //l=0.085 //layer=li //thickness=0.1 \
 //x=80.55 //y=1.09 //x2=80.55 //y2=1.175
r84 (  8 34 ) resistor r=1.36898 //w=0.187 //l=0.02 //layer=li //thickness=0.1 \
 //x=80.55 //y=1.09 //x2=80.55 //y2=1.07
r85 (  7 34 ) resistor r=3.57586 //w=0.17 //l=0.125 //layer=li //thickness=0.1 \
 //x=80.55 //y=0.805 //x2=80.55 //y2=0.68
r86 (  7 34 ) resistor r=18.139 //w=0.187 //l=0.265 //layer=li //thickness=0.1 \
 //x=80.55 //y=0.805 //x2=80.55 //y2=1.07
r87 (  6 33 ) resistor r=0.751729 //w=0.17 //l=0.085 //layer=li \
 //thickness=0.1 //x=79.585 //y=1.175 //x2=79.5 //y2=1.175
r88 (  5 30 ) resistor r=1.40859 //w=0.34 //l=0.085 //layer=li //thickness=0.1 \
 //x=80.465 //y=1.175 //x2=80.55 //y2=1.175
r89 (  5 6 ) resistor r=60.2353 //w=0.187 //l=0.88 //layer=li //thickness=0.1 \
 //x=80.465 //y=1.175 //x2=79.585 //y2=1.175
ends PM_TMRDFFSNRNQX1\%noxref_43

subckt PM_TMRDFFSNRNQX1\%noxref_44 ( 5 7 15 19 30 33 34 )
c69 ( 34 0 ) capacitor c=0.0437205f //x=85.225 //y=0.555
c70 ( 33 0 ) capacitor c=0.0185765f //x=84.12 //y=1.09
c71 ( 30 0 ) capacitor c=0.00141302f //x=85.36 //y=1.175
c72 ( 19 0 ) capacitor c=0.00695768f //x=86.33 //y=0.805
c73 ( 15 0 ) capacitor c=0.0154873f //x=86.245 //y=0.72
c74 ( 7 0 ) capacitor c=0.00689476f //x=85.36 //y=0.805
c75 ( 5 0 ) capacitor c=0.0235962f //x=85.275 //y=1.175
r76 (  19 34 ) resistor r=3.57586 //w=0.17 //l=0.125 //layer=li \
 //thickness=0.1 //x=86.33 //y=0.805 //x2=86.33 //y2=0.68
r77 (  19 34 ) resistor r=18.139 //w=0.187 //l=0.265 //layer=li \
 //thickness=0.1 //x=86.33 //y=0.805 //x2=86.33 //y2=1.07
r78 (  16 34 ) resistor r=3.57586 //w=0.17 //l=0.103078 //layer=li \
 //thickness=0.1 //x=85.445 //y=0.72 //x2=85.36 //y2=0.68
r79 (  16 34 ) resistor r=27.3797 //w=0.187 //l=0.4 //layer=li //thickness=0.1 \
 //x=85.445 //y=0.72 //x2=85.845 //y2=0.72
r80 (  15 34 ) resistor r=3.57586 //w=0.17 //l=0.103078 //layer=li \
 //thickness=0.1 //x=86.245 //y=0.72 //x2=86.33 //y2=0.68
r81 (  15 34 ) resistor r=27.3797 //w=0.187 //l=0.4 //layer=li //thickness=0.1 \
 //x=86.245 //y=0.72 //x2=85.845 //y2=0.72
r82 (  11 30 ) resistor r=5.4201 //w=0.17 //l=0.085 //layer=li //thickness=0.1 \
 //x=85.36 //y=1.26 //x2=85.36 //y2=1.175
r83 (  11 34 ) resistor r=10.2674 //w=0.187 //l=0.15 //layer=li \
 //thickness=0.1 //x=85.36 //y=1.26 //x2=85.36 //y2=1.41
r84 (  8 30 ) resistor r=5.4201 //w=0.17 //l=0.085 //layer=li //thickness=0.1 \
 //x=85.36 //y=1.09 //x2=85.36 //y2=1.175
r85 (  8 34 ) resistor r=1.36898 //w=0.187 //l=0.02 //layer=li //thickness=0.1 \
 //x=85.36 //y=1.09 //x2=85.36 //y2=1.07
r86 (  7 34 ) resistor r=3.57586 //w=0.17 //l=0.125 //layer=li //thickness=0.1 \
 //x=85.36 //y=0.805 //x2=85.36 //y2=0.68
r87 (  7 34 ) resistor r=18.139 //w=0.187 //l=0.265 //layer=li //thickness=0.1 \
 //x=85.36 //y=0.805 //x2=85.36 //y2=1.07
r88 (  6 33 ) resistor r=0.751729 //w=0.17 //l=0.085 //layer=li \
 //thickness=0.1 //x=84.395 //y=1.175 //x2=84.31 //y2=1.175
r89 (  5 30 ) resistor r=1.40859 //w=0.34 //l=0.085 //layer=li //thickness=0.1 \
 //x=85.275 //y=1.175 //x2=85.36 //y2=1.175
r90 (  5 6 ) resistor r=60.2353 //w=0.187 //l=0.88 //layer=li //thickness=0.1 \
 //x=85.275 //y=1.175 //x2=84.395 //y2=1.175
ends PM_TMRDFFSNRNQX1\%noxref_44

subckt PM_TMRDFFSNRNQX1\%noxref_45 ( 1 3 4 5 7 9 19 25 27 30 40 49 71 72 73 74 \
 75 )
c161 ( 75 0 ) capacitor c=0.0354016f //x=92.795 //y=5.205
c162 ( 74 0 ) capacitor c=0.0241107f //x=91.915 //y=5.205
c163 ( 72 0 ) capacitor c=0.00544792f //x=89.035 //y=5.205
c164 ( 71 0 ) capacitor c=0.00516996f //x=88.155 //y=5.205
c165 ( 49 0 ) capacitor c=0.0508454f //x=91.18 //y=5.39
c166 ( 40 0 ) capacitor c=0.0363228f //x=89.18 //y=5.39
c167 ( 30 0 ) capacitor c=0.0294643f //x=88.3 //y=5.56
c168 ( 27 0 ) capacitor c=0.00984489f //x=92.94 //y=6.92
c169 ( 25 0 ) capacitor c=0.0059844f //x=92.057 //y=7.09
c170 ( 19 0 ) capacitor c=0.00975753f //x=91.18 //y=6.92
c171 ( 9 0 ) capacitor c=0.014892f //x=88.302 //y=5.39
c172 ( 7 0 ) capacitor c=0.00787288f //x=92.825 //y=7.09
c173 ( 5 0 ) capacitor c=0.00659042f //x=91.94 //y=7.09
c174 ( 4 0 ) capacitor c=0.00558326f //x=89.295 //y=5.39
c175 ( 3 0 ) capacitor c=0.0636102f //x=91.065 //y=5.39
c176 ( 1 0 ) capacitor c=0.0145996f //x=89.065 //y=5.39
r177 (  49 73 ) resistor r=58.1818 //w=0.187 //l=0.85 //layer=li \
 //thickness=0.1 //x=91.18 //y=5.39 //x2=91.18 //y2=6.24
r178 (  40 72 ) resistor r=58.1818 //w=0.187 //l=0.85 //layer=li \
 //thickness=0.1 //x=89.18 //y=5.39 //x2=89.18 //y2=6.24
r179 (  30 71 ) resistor r=23.2727 //w=0.187 //l=0.34 //layer=li \
 //thickness=0.1 //x=88.3 //y=5.56 //x2=88.3 //y2=5.9
r180 (  27 75 ) resistor r=9.3 //w=0.17 //l=0.17 //layer=mcon //count=1 \
 //x=92.94 //y=6.92 //x2=92.94 //y2=6.92
r181 (  27 28 ) resistor r=0.0988372 //w=0.215 //l=0.17 //layer=m1 \
 //thickness=0.36 //x=92.942 //y=6.92 //x2=92.942 //y2=7.09
r182 (  24 74 ) resistor r=9.3 //w=0.17 //l=0.17 //layer=mcon //count=1 \
 //x=92.06 //y=6.92 //x2=92.06 //y2=6.92
r183 (  24 25 ) resistor r=0.0940266 //w=0.226 //l=0.17 //layer=m1 \
 //thickness=0.36 //x=92.057 //y=6.92 //x2=92.057 //y2=7.09
r184 (  22 49 ) resistor r=9.3 //w=0.17 //l=0.17 //layer=mcon //count=1 \
 //x=91.18 //y=5.39 //x2=91.18 //y2=5.39
r185 (  19 73 ) resistor r=9.3 //w=0.17 //l=0.17 //layer=mcon //count=1 \
 //x=91.18 //y=6.92 //x2=91.18 //y2=6.92
r186 (  19 20 ) resistor r=0.0979263 //w=0.217 //l=0.17 //layer=m1 \
 //thickness=0.36 //x=91.182 //y=6.92 //x2=91.182 //y2=7.09
r187 (  15 40 ) resistor r=9.3 //w=0.17 //l=0.17 //layer=mcon //count=1 \
 //x=89.18 //y=5.39 //x2=89.18 //y2=5.39
r188 (  11 30 ) resistor r=9.3 //w=0.17 //l=0.17 //layer=mcon //count=1 \
 //x=88.3 //y=5.56 //x2=88.3 //y2=5.56
r189 (  9 11 ) resistor r=0.0944444 //w=0.225 //l=0.17 //layer=m1 \
 //thickness=0.36 //x=88.302 //y=5.39 //x2=88.302 //y2=5.56
r190 (  8 25 ) resistor r=0.0246599 //w=0.226 //l=0.118 //layer=m1 \
 //thickness=0.36 //x=92.175 //y=7.09 //x2=92.057 //y2=7.09
r191 (  7 28 ) resistor r=0.0216707 //w=0.215 //l=0.117 //layer=m1 \
 //thickness=0.36 //x=92.825 //y=7.09 //x2=92.942 //y2=7.09
r192 (  7 8 ) resistor r=0.620229 //w=0.131 //l=0.65 //layer=m1 \
 //thickness=0.36 //x=92.825 //y=7.09 //x2=92.175 //y2=7.09
r193 (  6 20 ) resistor r=0.0222262 //w=0.217 //l=0.118 //layer=m1 \
 //thickness=0.36 //x=91.3 //y=7.09 //x2=91.182 //y2=7.09
r194 (  5 25 ) resistor r=0.0246599 //w=0.226 //l=0.117 //layer=m1 \
 //thickness=0.36 //x=91.94 //y=7.09 //x2=92.057 //y2=7.09
r195 (  5 6 ) resistor r=0.610687 //w=0.131 //l=0.64 //layer=m1 \
 //thickness=0.36 //x=91.94 //y=7.09 //x2=91.3 //y2=7.09
r196 (  4 15 ) resistor r=0.0880901 //w=0.191 //l=0.115 //layer=m1 \
 //thickness=0.36 //x=89.295 //y=5.39 //x2=89.18 //y2=5.39
r197 (  3 22 ) resistor r=0.0717383 //w=0.224 //l=0.115 //layer=m1 \
 //thickness=0.36 //x=91.065 //y=5.39 //x2=91.18 //y2=5.39
r198 (  3 4 ) resistor r=1.68893 //w=0.131 //l=1.77 //layer=m1 \
 //thickness=0.36 //x=91.065 //y=5.39 //x2=89.295 //y2=5.39
r199 (  2 9 ) resistor r=0.0243946 //w=0.225 //l=0.123 //layer=m1 \
 //thickness=0.36 //x=88.425 //y=5.39 //x2=88.302 //y2=5.39
r200 (  1 15 ) resistor r=0.0880901 //w=0.191 //l=0.115 //layer=m1 \
 //thickness=0.36 //x=89.065 //y=5.39 //x2=89.18 //y2=5.39
r201 (  1 2 ) resistor r=0.610687 //w=0.131 //l=0.64 //layer=m1 \
 //thickness=0.36 //x=89.065 //y=5.39 //x2=88.425 //y2=5.39
ends PM_TMRDFFSNRNQX1\%noxref_45

subckt PM_TMRDFFSNRNQX1\%noxref_46 ( 1 3 4 5 7 9 13 15 21 23 26 38 60 61 62 63 )
c132 ( 63 0 ) capacitor c=0.0343252f //x=96.135 //y=5.205
c133 ( 62 0 ) capacitor c=0.0239063f //x=95.255 //y=5.205
c134 ( 38 0 ) capacitor c=0.0496553f //x=94.52 //y=5.39
c135 ( 26 0 ) capacitor c=0.0229521f //x=91.62 //y=5.56
c136 ( 23 0 ) capacitor c=0.0155899f //x=96.28 //y=6.92
c137 ( 21 0 ) capacitor c=0.00566376f //x=95.4 //y=7.09
c138 ( 15 0 ) capacitor c=0.00945187f //x=94.52 //y=6.92
c139 ( 13 0 ) capacitor c=0.0163615f //x=92.5 //y=5.39
c140 ( 9 0 ) capacitor c=0.015341f //x=91.62 //y=5.39
c141 ( 7 0 ) capacitor c=0.0068287f //x=96.15 //y=7.09
c142 ( 5 0 ) capacitor c=0.00878908f //x=95.285 //y=7.09
c143 ( 4 0 ) capacitor c=0.00826388f //x=92.615 //y=5.39
c144 ( 3 0 ) capacitor c=0.0571674f //x=94.405 //y=5.39
c145 ( 1 0 ) capacitor c=0.0183133f //x=92.385 //y=5.39
r146 (  38 61 ) resistor r=58.1818 //w=0.187 //l=0.85 //layer=li \
 //thickness=0.1 //x=94.52 //y=5.39 //x2=94.52 //y2=6.24
r147 (  26 60 ) resistor r=23.2727 //w=0.187 //l=0.34 //layer=li \
 //thickness=0.1 //x=91.62 //y=5.56 //x2=91.62 //y2=5.9
r148 (  23 63 ) resistor r=9.3 //w=0.17 //l=0.17 //layer=mcon //count=1 \
 //x=96.28 //y=6.92 //x2=96.28 //y2=6.92
r149 (  23 24 ) resistor r=0.0923913 //w=0.23 //l=0.17 //layer=m1 \
 //thickness=0.36 //x=96.275 //y=6.92 //x2=96.275 //y2=7.09
r150 (  20 62 ) resistor r=9.3 //w=0.17 //l=0.17 //layer=mcon //count=1 \
 //x=95.4 //y=6.92 //x2=95.4 //y2=6.92
r151 (  20 21 ) resistor r=0.0957207 //w=0.222 //l=0.17 //layer=m1 \
 //thickness=0.36 //x=95.4 //y=6.92 //x2=95.4 //y2=7.09
r152 (  18 38 ) resistor r=9.3 //w=0.17 //l=0.17 //layer=mcon //count=1 \
 //x=94.52 //y=5.39 //x2=94.52 //y2=5.39
r153 (  15 61 ) resistor r=9.3 //w=0.17 //l=0.17 //layer=mcon //count=1 \
 //x=94.52 //y=6.92 //x2=94.52 //y2=6.92
r154 (  15 16 ) resistor r=0.100236 //w=0.212 //l=0.17 //layer=m1 \
 //thickness=0.36 //x=94.52 //y=6.92 //x2=94.52 //y2=7.09
r155 (  11 26 ) resistor r=9.3 //w=0.17 //l=0.17 //layer=mcon //count=1 \
 //x=91.62 //y=5.56 //x2=91.62 //y2=5.56
r156 (  9 11 ) resistor r=0.100236 //w=0.212 //l=0.17 //layer=m1 \
 //thickness=0.36 //x=91.62 //y=5.39 //x2=91.62 //y2=5.56
r157 (  8 21 ) resistor r=0.0235912 //w=0.222 //l=0.115 //layer=m1 \
 //thickness=0.36 //x=95.515 //y=7.09 //x2=95.4 //y2=7.09
r158 (  7 24 ) resistor r=0.0257089 //w=0.23 //l=0.125 //layer=m1 \
 //thickness=0.36 //x=96.15 //y=7.09 //x2=96.275 //y2=7.09
r159 (  7 8 ) resistor r=0.605916 //w=0.131 //l=0.635 //layer=m1 \
 //thickness=0.36 //x=96.15 //y=7.09 //x2=95.515 //y2=7.09
r160 (  6 16 ) resistor r=0.0208269 //w=0.212 //l=0.115 //layer=m1 \
 //thickness=0.36 //x=94.635 //y=7.09 //x2=94.52 //y2=7.09
r161 (  5 21 ) resistor r=0.0235912 //w=0.222 //l=0.115 //layer=m1 \
 //thickness=0.36 //x=95.285 //y=7.09 //x2=95.4 //y2=7.09
r162 (  5 6 ) resistor r=0.620229 //w=0.131 //l=0.65 //layer=m1 \
 //thickness=0.36 //x=95.285 //y=7.09 //x2=94.635 //y2=7.09
r163 (  4 13 ) resistor r=0.0880901 //w=0.191 //l=0.115 //layer=m1 \
 //thickness=0.36 //x=92.615 //y=5.39 //x2=92.5 //y2=5.39
r164 (  3 18 ) resistor r=0.0717383 //w=0.224 //l=0.115 //layer=m1 \
 //thickness=0.36 //x=94.405 //y=5.39 //x2=94.52 //y2=5.39
r165 (  3 4 ) resistor r=1.70802 //w=0.131 //l=1.79 //layer=m1 \
 //thickness=0.36 //x=94.405 //y=5.39 //x2=92.615 //y2=5.39
r166 (  2 9 ) resistor r=0.0208269 //w=0.212 //l=0.115 //layer=m1 \
 //thickness=0.36 //x=91.735 //y=5.39 //x2=91.62 //y2=5.39
r167 (  1 13 ) resistor r=0.0880901 //w=0.191 //l=0.115 //layer=m1 \
 //thickness=0.36 //x=92.385 //y=5.39 //x2=92.5 //y2=5.39
r168 (  1 2 ) resistor r=0.620229 //w=0.131 //l=0.65 //layer=m1 \
 //thickness=0.36 //x=92.385 //y=5.39 //x2=91.735 //y2=5.39
ends PM_TMRDFFSNRNQX1\%noxref_46

subckt PM_TMRDFFSNRNQX1\%GND ( 1 2 6 7 18 19 30 31 42 43 54 55 66 67 78 79 90 \
 91 102 103 114 115 126 127 139 140 151 152 163 164 175 176 187 188 199 200 \
 211 212 223 224 231 232 239 248 251 255 259 263 267 271 275 279 283 287 291 \
 295 299 303 307 311 315 319 334 337 351 368 385 402 419 436 453 470 487 504 \
 521 538 555 572 589 606 623 640 655 668 686 691 695 707 708 709 710 711 712 \
 713 714 715 716 717 718 719 720 721 722 723 724 725 726 727 734 741 742 743 \
 744 745 746 747 748 749 750 751 752 753 754 755 756 757 758 759 760 761 762 )
c1745 ( 762 0 ) capacitor c=0.0636259f //x=97.555 //y=0.55
c1746 ( 761 0 ) capacitor c=0.00828027f //x=94.72 //y=1.045
c1747 ( 760 0 ) capacitor c=0.00867576f //x=91.39 //y=1.045
c1748 ( 759 0 ) capacitor c=0.0083251f //x=88.06 //y=1.045
c1749 ( 758 0 ) capacitor c=0.00840423f //x=83.145 //y=1.055
c1750 ( 757 0 ) capacitor c=0.00840423f //x=78.335 //y=1.055
c1751 ( 756 0 ) capacitor c=0.00840423f //x=73.525 //y=1.055
c1752 ( 755 0 ) capacitor c=0.00840423f //x=68.715 //y=1.055
c1753 ( 754 0 ) capacitor c=0.00840423f //x=63.905 //y=1.055
c1754 ( 753 0 ) capacitor c=0.00840423f //x=59.095 //y=1.055
c1755 ( 752 0 ) capacitor c=0.00840423f //x=54.285 //y=1.055
c1756 ( 751 0 ) capacitor c=0.00840423f //x=49.475 //y=1.055
c1757 ( 750 0 ) capacitor c=0.00840423f //x=44.665 //y=1.055
c1758 ( 749 0 ) capacitor c=0.00840423f //x=39.855 //y=1.055
c1759 ( 748 0 ) capacitor c=0.00840423f //x=35.045 //y=1.055
c1760 ( 747 0 ) capacitor c=0.00840423f //x=30.235 //y=1.055
c1761 ( 746 0 ) capacitor c=0.00840423f //x=25.425 //y=1.055
c1762 ( 745 0 ) capacitor c=0.00840423f //x=20.615 //y=1.055
c1763 ( 744 0 ) capacitor c=0.00840423f //x=15.805 //y=1.055
c1764 ( 743 0 ) capacitor c=0.00840423f //x=10.995 //y=1.055
c1765 ( 742 0 ) capacitor c=0.00840423f //x=6.185 //y=1.055
c1766 ( 741 0 ) capacitor c=0.00840423f //x=1.375 //y=1.055
c1767 ( 734 0 ) capacitor c=0.260862f //x=98.66 //y=0.175
c1768 ( 727 0 ) capacitor c=0.113464f //x=97.06 //y=0.175
c1769 ( 726 0 ) capacitor c=0.11024f //x=93.73 //y=0.175
c1770 ( 725 0 ) capacitor c=0.1237f //x=90.4 //y=0.175
c1771 ( 724 0 ) capacitor c=0.11441f //x=87.07 //y=0.175
c1772 ( 723 0 ) capacitor c=0.109567f //x=82.26 //y=0.175
c1773 ( 722 0 ) capacitor c=0.114177f //x=77.45 //y=0.175
c1774 ( 721 0 ) capacitor c=0.109628f //x=72.64 //y=0.175
c1775 ( 720 0 ) capacitor c=0.112438f //x=67.83 //y=0.175
c1776 ( 719 0 ) capacitor c=0.109586f //x=63.02 //y=0.175
c1777 ( 718 0 ) capacitor c=0.114177f //x=58.21 //y=0.175
c1778 ( 717 0 ) capacitor c=0.109534f //x=53.4 //y=0.175
c1779 ( 716 0 ) capacitor c=0.114177f //x=48.59 //y=0.175
c1780 ( 715 0 ) capacitor c=0.109628f //x=43.78 //y=0.175
c1781 ( 714 0 ) capacitor c=0.112438f //x=38.97 //y=0.175
c1782 ( 713 0 ) capacitor c=0.109586f //x=34.16 //y=0.175
c1783 ( 712 0 ) capacitor c=0.114177f //x=29.35 //y=0.175
c1784 ( 711 0 ) capacitor c=0.109575f //x=24.54 //y=0.175
c1785 ( 710 0 ) capacitor c=0.114177f //x=19.73 //y=0.175
c1786 ( 709 0 ) capacitor c=0.109628f //x=14.92 //y=0.175
c1787 ( 708 0 ) capacitor c=0.112592f //x=10.11 //y=0.175
c1788 ( 707 0 ) capacitor c=0.10974f //x=5.3 //y=0.175
c1789 ( 698 0 ) capacitor c=0.00585268f //x=98.66 //y=0.63
c1790 ( 695 0 ) capacitor c=0.0061991f //x=98.575 //y=0.715
c1791 ( 694 0 ) capacitor c=0.00479851f //x=98.17 //y=0.63
c1792 ( 691 0 ) capacitor c=0.00645299f //x=98.085 //y=0.715
c1793 ( 686 0 ) capacitor c=0.00586769f //x=97.69 //y=0.63
c1794 ( 683 0 ) capacitor c=0.0191899f //x=97.605 //y=0.175
c1795 ( 668 0 ) capacitor c=0.122563f //x=96.89 //y=0.175
c1796 ( 655 0 ) capacitor c=0.118812f //x=93.56 //y=0.175
c1797 ( 640 0 ) capacitor c=0.119089f //x=90.23 //y=0.175
c1798 ( 623 0 ) capacitor c=0.176388f //x=86.9 //y=0.175
c1799 ( 606 0 ) capacitor c=0.174554f //x=82.09 //y=0.175
c1800 ( 589 0 ) capacitor c=0.176385f //x=77.28 //y=0.175
c1801 ( 572 0 ) capacitor c=0.176388f //x=72.47 //y=0.175
c1802 ( 555 0 ) capacitor c=0.176388f //x=67.66 //y=0.175
c1803 ( 538 0 ) capacitor c=0.17641f //x=62.85 //y=0.175
c1804 ( 521 0 ) capacitor c=0.176556f //x=58.04 //y=0.175
c1805 ( 504 0 ) capacitor c=0.176414f //x=53.23 //y=0.175
c1806 ( 487 0 ) capacitor c=0.176385f //x=48.42 //y=0.175
c1807 ( 470 0 ) capacitor c=0.176388f //x=43.61 //y=0.175
c1808 ( 453 0 ) capacitor c=0.176388f //x=38.8 //y=0.175
c1809 ( 436 0 ) capacitor c=0.17641f //x=33.99 //y=0.175
c1810 ( 419 0 ) capacitor c=0.176363f //x=29.18 //y=0.175
c1811 ( 402 0 ) capacitor c=0.176414f //x=24.37 //y=0.175
c1812 ( 385 0 ) capacitor c=0.176385f //x=19.56 //y=0.175
c1813 ( 368 0 ) capacitor c=0.176388f //x=14.75 //y=0.175
c1814 ( 351 0 ) capacitor c=0.176388f //x=9.94 //y=0.175
c1815 ( 337 0 ) capacitor c=0.197064f //x=1.23 //y=0.18
c1816 ( 334 0 ) capacitor c=0.17924f //x=5.13 //y=0.175
c1817 ( 329 0 ) capacitor c=0.00509083f //x=94.91 //y=0.175
c1818 ( 326 0 ) capacitor c=0.00510068f //x=91.51 //y=0.18
c1819 ( 322 0 ) capacitor c=0.00509083f //x=88.25 //y=0.175
c1820 ( 321 0 ) capacitor c=0.00509414f //x=83.335 //y=0.175
c1821 ( 319 0 ) capacitor c=0.0139528f //x=83.335 //y=1.145
c1822 ( 317 0 ) capacitor c=0.00509414f //x=78.525 //y=0.175
c1823 ( 315 0 ) capacitor c=0.0140686f //x=78.525 //y=1.145
c1824 ( 313 0 ) capacitor c=0.00509414f //x=73.715 //y=0.175
c1825 ( 311 0 ) capacitor c=0.0140128f //x=73.715 //y=1.145
c1826 ( 309 0 ) capacitor c=0.00509414f //x=68.905 //y=0.175
c1827 ( 307 0 ) capacitor c=0.0140132f //x=68.905 //y=1.145
c1828 ( 305 0 ) capacitor c=0.00509414f //x=64.095 //y=0.175
c1829 ( 303 0 ) capacitor c=0.0140783f //x=64.095 //y=1.145
c1830 ( 301 0 ) capacitor c=0.00509414f //x=59.285 //y=0.175
c1831 ( 299 0 ) capacitor c=0.0140577f //x=59.285 //y=1.145
c1832 ( 297 0 ) capacitor c=0.00509414f //x=54.475 //y=0.175
c1833 ( 295 0 ) capacitor c=0.0140088f //x=54.475 //y=1.145
c1834 ( 293 0 ) capacitor c=0.00509414f //x=49.665 //y=0.175
c1835 ( 291 0 ) capacitor c=0.0140644f //x=49.665 //y=1.145
c1836 ( 289 0 ) capacitor c=0.00509414f //x=44.855 //y=0.175
c1837 ( 287 0 ) capacitor c=0.0140128f //x=44.855 //y=1.145
c1838 ( 285 0 ) capacitor c=0.00509414f //x=40.045 //y=0.175
c1839 ( 283 0 ) capacitor c=0.0140132f //x=40.045 //y=1.145
c1840 ( 281 0 ) capacitor c=0.00509414f //x=35.235 //y=0.175
c1841 ( 279 0 ) capacitor c=0.0140783f //x=35.235 //y=1.145
c1842 ( 277 0 ) capacitor c=0.00509414f //x=30.425 //y=0.175
c1843 ( 275 0 ) capacitor c=0.0141231f //x=30.425 //y=1.145
c1844 ( 273 0 ) capacitor c=0.00509414f //x=25.615 //y=0.175
c1845 ( 271 0 ) capacitor c=0.0140136f //x=25.615 //y=1.145
c1846 ( 269 0 ) capacitor c=0.00509414f //x=20.805 //y=0.175
c1847 ( 267 0 ) capacitor c=0.0140686f //x=20.805 //y=1.145
c1848 ( 265 0 ) capacitor c=0.00509414f //x=15.995 //y=0.175
c1849 ( 263 0 ) capacitor c=0.0140168f //x=15.995 //y=1.145
c1850 ( 261 0 ) capacitor c=0.00509414f //x=11.185 //y=0.175
c1851 ( 259 0 ) capacitor c=0.0139572f //x=11.185 //y=1.145
c1852 ( 257 0 ) capacitor c=0.00509414f //x=6.375 //y=0.175
c1853 ( 255 0 ) capacitor c=0.0140851f //x=6.375 //y=1.145
c1854 ( 253 0 ) capacitor c=0.00509414f //x=1.565 //y=0.175
c1855 ( 251 0 ) capacitor c=0.017f //x=1.565 //y=1.145
c1856 ( 248 0 ) capacitor c=0.178677f //x=98.54 //y=0.18
c1857 ( 239 0 ) capacitor c=0.035089f //x=94.91 //y=1.02
c1858 ( 232 0 ) capacitor c=0.107294f //x=94.825 //y=0.175
c1859 ( 231 0 ) capacitor c=0.0283986f //x=91.58 //y=1.015
c1860 ( 224 0 ) capacitor c=0.112366f //x=91.495 //y=0.175
c1861 ( 223 0 ) capacitor c=0.0347805f //x=88.25 //y=1.015
c1862 ( 212 0 ) capacitor c=0.154656f //x=88.165 //y=0.175
c1863 ( 211 0 ) capacitor c=0.0302305f //x=83.335 //y=1.015
c1864 ( 200 0 ) capacitor c=0.148696f //x=83.25 //y=0.175
c1865 ( 199 0 ) capacitor c=0.0302305f //x=78.525 //y=1.015
c1866 ( 188 0 ) capacitor c=0.14916f //x=78.44 //y=0.175
c1867 ( 187 0 ) capacitor c=0.0302305f //x=73.715 //y=1.015
c1868 ( 176 0 ) capacitor c=0.148704f //x=73.63 //y=0.175
c1869 ( 175 0 ) capacitor c=0.0302305f //x=68.905 //y=1.015
c1870 ( 164 0 ) capacitor c=0.149124f //x=68.82 //y=0.175
c1871 ( 163 0 ) capacitor c=0.0302305f //x=64.095 //y=1.015
c1872 ( 152 0 ) capacitor c=0.148598f //x=64.01 //y=0.175
c1873 ( 151 0 ) capacitor c=0.0302305f //x=59.285 //y=1.015
c1874 ( 140 0 ) capacitor c=0.150478f //x=59.2 //y=0.175
c1875 ( 139 0 ) capacitor c=0.0302305f //x=54.475 //y=1.015
c1876 ( 127 0 ) capacitor c=0.148588f //x=54.39 //y=0.175
c1877 ( 126 0 ) capacitor c=0.0302305f //x=49.665 //y=1.015
c1878 ( 115 0 ) capacitor c=0.14916f //x=49.58 //y=0.175
c1879 ( 114 0 ) capacitor c=0.0302305f //x=44.855 //y=1.015
c1880 ( 103 0 ) capacitor c=0.148704f //x=44.77 //y=0.175
c1881 ( 102 0 ) capacitor c=0.0302305f //x=40.045 //y=1.015
c1882 ( 91 0 ) capacitor c=0.149124f //x=39.96 //y=0.175
c1883 ( 90 0 ) capacitor c=0.0302305f //x=35.235 //y=1.015
c1884 ( 79 0 ) capacitor c=0.148636f //x=35.15 //y=0.175
c1885 ( 78 0 ) capacitor c=0.0302305f //x=30.425 //y=1.015
c1886 ( 67 0 ) capacitor c=0.150281f //x=30.34 //y=0.175
c1887 ( 66 0 ) capacitor c=0.0302305f //x=25.615 //y=1.015
c1888 ( 55 0 ) capacitor c=0.148607f //x=25.53 //y=0.175
c1889 ( 54 0 ) capacitor c=0.0302305f //x=20.805 //y=1.015
c1890 ( 43 0 ) capacitor c=0.14916f //x=20.72 //y=0.175
c1891 ( 42 0 ) capacitor c=0.0302305f //x=15.995 //y=1.015
c1892 ( 31 0 ) capacitor c=0.148704f //x=15.91 //y=0.175
c1893 ( 30 0 ) capacitor c=0.0302305f //x=11.185 //y=1.015
c1894 ( 19 0 ) capacitor c=0.149124f //x=11.1 //y=0.175
c1895 ( 18 0 ) capacitor c=0.0302305f //x=6.375 //y=1.015
c1896 ( 7 0 ) capacitor c=0.148598f //x=6.29 //y=0.175
c1897 ( 6 0 ) capacitor c=0.0302305f //x=1.565 //y=1.015
c1898 ( 2 0 ) capacitor c=0.0710427f //x=1.48 //y=0.175
r1899 (  733 734 ) resistor r=4.18529 //w=0.367 //l=0.12 //layer=li \
 //thickness=0.1 //x=98.54 //y=0.175 //x2=98.66 //y2=0.175
r1900 (  731 733 ) resistor r=12.9046 //w=0.367 //l=0.37 //layer=li \
 //thickness=0.1 //x=98.17 //y=0.175 //x2=98.54 //y2=0.175
r1901 (  730 731 ) resistor r=12.9046 //w=0.367 //l=0.37 //layer=li \
 //thickness=0.1 //x=97.8 //y=0.175 //x2=98.17 //y2=0.175
r1902 (  728 730 ) resistor r=3.83651 //w=0.367 //l=0.11 //layer=li \
 //thickness=0.1 //x=97.69 //y=0.175 //x2=97.8 //y2=0.175
r1903 (  699 762 ) resistor r=5.4201 //w=0.17 //l=0.085 //layer=li \
 //thickness=0.1 //x=98.66 //y=0.8 //x2=98.66 //y2=0.715
r1904 (  699 762 ) resistor r=41.4118 //w=0.187 //l=0.605 //layer=li \
 //thickness=0.1 //x=98.66 //y=0.8 //x2=98.66 //y2=1.405
r1905 (  698 762 ) resistor r=5.4201 //w=0.17 //l=0.085 //layer=li \
 //thickness=0.1 //x=98.66 //y=0.63 //x2=98.66 //y2=0.715
r1906 (  697 734 ) resistor r=5.21862 //w=0.35 //l=0.175 //layer=li \
 //thickness=0.1 //x=98.66 //y=0.35 //x2=98.66 //y2=0.175
r1907 (  697 698 ) resistor r=19.1658 //w=0.187 //l=0.28 //layer=li \
 //thickness=0.1 //x=98.66 //y=0.35 //x2=98.66 //y2=0.63
r1908 (  696 762 ) resistor r=5.4201 //w=0.17 //l=0.085 //layer=li \
 //thickness=0.1 //x=98.255 //y=0.715 //x2=98.17 //y2=0.715
r1909 (  695 762 ) resistor r=1.40859 //w=0.34 //l=0.085 //layer=li \
 //thickness=0.1 //x=98.575 //y=0.715 //x2=98.66 //y2=0.715
r1910 (  695 696 ) resistor r=21.9037 //w=0.187 //l=0.32 //layer=li \
 //thickness=0.1 //x=98.575 //y=0.715 //x2=98.255 //y2=0.715
r1911 (  694 762 ) resistor r=1.40859 //w=0.34 //l=0.085 //layer=li \
 //thickness=0.1 //x=98.17 //y=0.63 //x2=98.17 //y2=0.715
r1912 (  693 731 ) resistor r=5.21862 //w=0.35 //l=0.175 //layer=li \
 //thickness=0.1 //x=98.17 //y=0.35 //x2=98.17 //y2=0.175
r1913 (  693 694 ) resistor r=19.1658 //w=0.187 //l=0.28 //layer=li \
 //thickness=0.1 //x=98.17 //y=0.35 //x2=98.17 //y2=0.63
r1914 (  692 762 ) resistor r=1.40859 //w=0.34 //l=0.085 //layer=li \
 //thickness=0.1 //x=97.775 //y=0.715 //x2=97.69 //y2=0.715
r1915 (  691 762 ) resistor r=5.4201 //w=0.17 //l=0.085 //layer=li \
 //thickness=0.1 //x=98.085 //y=0.715 //x2=98.17 //y2=0.715
r1916 (  691 692 ) resistor r=21.2193 //w=0.187 //l=0.31 //layer=li \
 //thickness=0.1 //x=98.085 //y=0.715 //x2=97.775 //y2=0.715
r1917 (  687 762 ) resistor r=5.4201 //w=0.17 //l=0.085 //layer=li \
 //thickness=0.1 //x=97.69 //y=0.8 //x2=97.69 //y2=0.715
r1918 (  687 762 ) resistor r=41.4118 //w=0.187 //l=0.605 //layer=li \
 //thickness=0.1 //x=97.69 //y=0.8 //x2=97.69 //y2=1.405
r1919 (  686 762 ) resistor r=5.4201 //w=0.17 //l=0.085 //layer=li \
 //thickness=0.1 //x=97.69 //y=0.63 //x2=97.69 //y2=0.715
r1920 (  685 728 ) resistor r=5.21862 //w=0.35 //l=0.175 //layer=li \
 //thickness=0.1 //x=97.69 //y=0.35 //x2=97.69 //y2=0.175
r1921 (  685 686 ) resistor r=19.1658 //w=0.187 //l=0.28 //layer=li \
 //thickness=0.1 //x=97.69 //y=0.35 //x2=97.69 //y2=0.63
r1922 (  684 727 ) resistor r=5.29055 //w=0.35 //l=0.17 //layer=li \
 //thickness=0.1 //x=97.23 //y=0.175 //x2=97.06 //y2=0.175
r1923 (  683 728 ) resistor r=2.96458 //w=0.367 //l=0.085 //layer=li \
 //thickness=0.1 //x=97.605 //y=0.175 //x2=97.69 //y2=0.175
r1924 (  683 684 ) resistor r=13.079 //w=0.367 //l=0.375 //layer=li \
 //thickness=0.1 //x=97.605 //y=0.175 //x2=97.23 //y2=0.175
r1925 (  673 675 ) resistor r=38.7139 //w=0.367 //l=1.11 //layer=li \
 //thickness=0.1 //x=95.21 //y=0.175 //x2=96.32 //y2=0.175
r1926 (  671 673 ) resistor r=38.7139 //w=0.367 //l=1.11 //layer=li \
 //thickness=0.1 //x=94.1 //y=0.175 //x2=95.21 //y2=0.175
r1927 (  669 726 ) resistor r=5.29055 //w=0.35 //l=0.17 //layer=li \
 //thickness=0.1 //x=93.9 //y=0.175 //x2=93.73 //y2=0.175
r1928 (  669 671 ) resistor r=6.97548 //w=0.367 //l=0.2 //layer=li \
 //thickness=0.1 //x=93.9 //y=0.175 //x2=94.1 //y2=0.175
r1929 (  668 727 ) resistor r=5.29055 //w=0.35 //l=0.17 //layer=li \
 //thickness=0.1 //x=96.89 //y=0.175 //x2=97.06 //y2=0.175
r1930 (  668 675 ) resistor r=19.8801 //w=0.367 //l=0.57 //layer=li \
 //thickness=0.1 //x=96.89 //y=0.175 //x2=96.32 //y2=0.175
r1931 (  658 660 ) resistor r=38.7139 //w=0.367 //l=1.11 //layer=li \
 //thickness=0.1 //x=91.51 //y=0.175 //x2=92.62 //y2=0.175
r1932 (  656 725 ) resistor r=5.29055 //w=0.35 //l=0.17 //layer=li \
 //thickness=0.1 //x=90.57 //y=0.175 //x2=90.4 //y2=0.175
r1933 (  656 658 ) resistor r=32.7847 //w=0.367 //l=0.94 //layer=li \
 //thickness=0.1 //x=90.57 //y=0.175 //x2=91.51 //y2=0.175
r1934 (  655 726 ) resistor r=5.29055 //w=0.35 //l=0.17 //layer=li \
 //thickness=0.1 //x=93.56 //y=0.175 //x2=93.73 //y2=0.175
r1935 (  655 660 ) resistor r=32.7847 //w=0.367 //l=0.94 //layer=li \
 //thickness=0.1 //x=93.56 //y=0.175 //x2=92.62 //y2=0.175
r1936 (  645 647 ) resistor r=38.7139 //w=0.367 //l=1.11 //layer=li \
 //thickness=0.1 //x=88.92 //y=0.175 //x2=90.03 //y2=0.175
r1937 (  643 645 ) resistor r=38.7139 //w=0.367 //l=1.11 //layer=li \
 //thickness=0.1 //x=87.81 //y=0.175 //x2=88.92 //y2=0.175
r1938 (  641 724 ) resistor r=5.29055 //w=0.35 //l=0.17 //layer=li \
 //thickness=0.1 //x=87.24 //y=0.175 //x2=87.07 //y2=0.175
r1939 (  641 643 ) resistor r=19.8801 //w=0.367 //l=0.57 //layer=li \
 //thickness=0.1 //x=87.24 //y=0.175 //x2=87.81 //y2=0.175
r1940 (  640 725 ) resistor r=5.29055 //w=0.35 //l=0.17 //layer=li \
 //thickness=0.1 //x=90.23 //y=0.175 //x2=90.4 //y2=0.175
r1941 (  640 647 ) resistor r=6.97548 //w=0.367 //l=0.2 //layer=li \
 //thickness=0.1 //x=90.23 //y=0.175 //x2=90.03 //y2=0.175
r1942 (  630 632 ) resistor r=38.7139 //w=0.367 //l=1.11 //layer=li \
 //thickness=0.1 //x=85.22 //y=0.175 //x2=86.33 //y2=0.175
r1943 (  628 630 ) resistor r=38.7139 //w=0.367 //l=1.11 //layer=li \
 //thickness=0.1 //x=84.11 //y=0.175 //x2=85.22 //y2=0.175
r1944 (  626 628 ) resistor r=38.7139 //w=0.367 //l=1.11 //layer=li \
 //thickness=0.1 //x=83 //y=0.175 //x2=84.11 //y2=0.175
r1945 (  624 723 ) resistor r=5.29055 //w=0.35 //l=0.17 //layer=li \
 //thickness=0.1 //x=82.43 //y=0.175 //x2=82.26 //y2=0.175
r1946 (  624 626 ) resistor r=19.8801 //w=0.367 //l=0.57 //layer=li \
 //thickness=0.1 //x=82.43 //y=0.175 //x2=83 //y2=0.175
r1947 (  623 724 ) resistor r=5.29055 //w=0.35 //l=0.17 //layer=li \
 //thickness=0.1 //x=86.9 //y=0.175 //x2=87.07 //y2=0.175
r1948 (  623 632 ) resistor r=19.8801 //w=0.367 //l=0.57 //layer=li \
 //thickness=0.1 //x=86.9 //y=0.175 //x2=86.33 //y2=0.175
r1949 (  613 615 ) resistor r=38.7139 //w=0.367 //l=1.11 //layer=li \
 //thickness=0.1 //x=80.41 //y=0.175 //x2=81.52 //y2=0.175
r1950 (  611 613 ) resistor r=38.7139 //w=0.367 //l=1.11 //layer=li \
 //thickness=0.1 //x=79.3 //y=0.175 //x2=80.41 //y2=0.175
r1951 (  609 611 ) resistor r=38.7139 //w=0.367 //l=1.11 //layer=li \
 //thickness=0.1 //x=78.19 //y=0.175 //x2=79.3 //y2=0.175
r1952 (  607 722 ) resistor r=5.29055 //w=0.35 //l=0.17 //layer=li \
 //thickness=0.1 //x=77.62 //y=0.175 //x2=77.45 //y2=0.175
r1953 (  607 609 ) resistor r=19.8801 //w=0.367 //l=0.57 //layer=li \
 //thickness=0.1 //x=77.62 //y=0.175 //x2=78.19 //y2=0.175
r1954 (  606 723 ) resistor r=5.29055 //w=0.35 //l=0.17 //layer=li \
 //thickness=0.1 //x=82.09 //y=0.175 //x2=82.26 //y2=0.175
r1955 (  606 615 ) resistor r=19.8801 //w=0.367 //l=0.57 //layer=li \
 //thickness=0.1 //x=82.09 //y=0.175 //x2=81.52 //y2=0.175
r1956 (  596 598 ) resistor r=38.7139 //w=0.367 //l=1.11 //layer=li \
 //thickness=0.1 //x=75.6 //y=0.175 //x2=76.71 //y2=0.175
r1957 (  594 596 ) resistor r=38.7139 //w=0.367 //l=1.11 //layer=li \
 //thickness=0.1 //x=74.49 //y=0.175 //x2=75.6 //y2=0.175
r1958 (  592 594 ) resistor r=38.7139 //w=0.367 //l=1.11 //layer=li \
 //thickness=0.1 //x=73.38 //y=0.175 //x2=74.49 //y2=0.175
r1959 (  590 721 ) resistor r=5.29055 //w=0.35 //l=0.17 //layer=li \
 //thickness=0.1 //x=72.81 //y=0.175 //x2=72.64 //y2=0.175
r1960 (  590 592 ) resistor r=19.8801 //w=0.367 //l=0.57 //layer=li \
 //thickness=0.1 //x=72.81 //y=0.175 //x2=73.38 //y2=0.175
r1961 (  589 722 ) resistor r=5.29055 //w=0.35 //l=0.17 //layer=li \
 //thickness=0.1 //x=77.28 //y=0.175 //x2=77.45 //y2=0.175
r1962 (  589 598 ) resistor r=19.8801 //w=0.367 //l=0.57 //layer=li \
 //thickness=0.1 //x=77.28 //y=0.175 //x2=76.71 //y2=0.175
r1963 (  579 581 ) resistor r=38.7139 //w=0.367 //l=1.11 //layer=li \
 //thickness=0.1 //x=70.79 //y=0.175 //x2=71.9 //y2=0.175
r1964 (  577 579 ) resistor r=38.7139 //w=0.367 //l=1.11 //layer=li \
 //thickness=0.1 //x=69.68 //y=0.175 //x2=70.79 //y2=0.175
r1965 (  575 577 ) resistor r=38.7139 //w=0.367 //l=1.11 //layer=li \
 //thickness=0.1 //x=68.57 //y=0.175 //x2=69.68 //y2=0.175
r1966 (  573 720 ) resistor r=5.29055 //w=0.35 //l=0.17 //layer=li \
 //thickness=0.1 //x=68 //y=0.175 //x2=67.83 //y2=0.175
r1967 (  573 575 ) resistor r=19.8801 //w=0.367 //l=0.57 //layer=li \
 //thickness=0.1 //x=68 //y=0.175 //x2=68.57 //y2=0.175
r1968 (  572 721 ) resistor r=5.29055 //w=0.35 //l=0.17 //layer=li \
 //thickness=0.1 //x=72.47 //y=0.175 //x2=72.64 //y2=0.175
r1969 (  572 581 ) resistor r=19.8801 //w=0.367 //l=0.57 //layer=li \
 //thickness=0.1 //x=72.47 //y=0.175 //x2=71.9 //y2=0.175
r1970 (  562 564 ) resistor r=38.7139 //w=0.367 //l=1.11 //layer=li \
 //thickness=0.1 //x=65.98 //y=0.175 //x2=67.09 //y2=0.175
r1971 (  560 562 ) resistor r=38.7139 //w=0.367 //l=1.11 //layer=li \
 //thickness=0.1 //x=64.87 //y=0.175 //x2=65.98 //y2=0.175
r1972 (  558 560 ) resistor r=38.7139 //w=0.367 //l=1.11 //layer=li \
 //thickness=0.1 //x=63.76 //y=0.175 //x2=64.87 //y2=0.175
r1973 (  556 719 ) resistor r=5.29055 //w=0.35 //l=0.17 //layer=li \
 //thickness=0.1 //x=63.19 //y=0.175 //x2=63.02 //y2=0.175
r1974 (  556 558 ) resistor r=19.8801 //w=0.367 //l=0.57 //layer=li \
 //thickness=0.1 //x=63.19 //y=0.175 //x2=63.76 //y2=0.175
r1975 (  555 720 ) resistor r=5.29055 //w=0.35 //l=0.17 //layer=li \
 //thickness=0.1 //x=67.66 //y=0.175 //x2=67.83 //y2=0.175
r1976 (  555 564 ) resistor r=19.8801 //w=0.367 //l=0.57 //layer=li \
 //thickness=0.1 //x=67.66 //y=0.175 //x2=67.09 //y2=0.175
r1977 (  545 547 ) resistor r=38.7139 //w=0.367 //l=1.11 //layer=li \
 //thickness=0.1 //x=61.17 //y=0.175 //x2=62.28 //y2=0.175
r1978 (  543 545 ) resistor r=38.7139 //w=0.367 //l=1.11 //layer=li \
 //thickness=0.1 //x=60.06 //y=0.175 //x2=61.17 //y2=0.175
r1979 (  541 543 ) resistor r=38.7139 //w=0.367 //l=1.11 //layer=li \
 //thickness=0.1 //x=58.95 //y=0.175 //x2=60.06 //y2=0.175
r1980 (  539 718 ) resistor r=5.29055 //w=0.35 //l=0.17 //layer=li \
 //thickness=0.1 //x=58.38 //y=0.175 //x2=58.21 //y2=0.175
r1981 (  539 541 ) resistor r=19.8801 //w=0.367 //l=0.57 //layer=li \
 //thickness=0.1 //x=58.38 //y=0.175 //x2=58.95 //y2=0.175
r1982 (  538 719 ) resistor r=5.29055 //w=0.35 //l=0.17 //layer=li \
 //thickness=0.1 //x=62.85 //y=0.175 //x2=63.02 //y2=0.175
r1983 (  538 547 ) resistor r=19.8801 //w=0.367 //l=0.57 //layer=li \
 //thickness=0.1 //x=62.85 //y=0.175 //x2=62.28 //y2=0.175
r1984 (  528 530 ) resistor r=38.7139 //w=0.367 //l=1.11 //layer=li \
 //thickness=0.1 //x=56.36 //y=0.175 //x2=57.47 //y2=0.175
r1985 (  526 528 ) resistor r=38.7139 //w=0.367 //l=1.11 //layer=li \
 //thickness=0.1 //x=55.25 //y=0.175 //x2=56.36 //y2=0.175
r1986 (  524 526 ) resistor r=38.7139 //w=0.367 //l=1.11 //layer=li \
 //thickness=0.1 //x=54.14 //y=0.175 //x2=55.25 //y2=0.175
r1987 (  522 717 ) resistor r=5.29055 //w=0.35 //l=0.17 //layer=li \
 //thickness=0.1 //x=53.57 //y=0.175 //x2=53.4 //y2=0.175
r1988 (  522 524 ) resistor r=19.8801 //w=0.367 //l=0.57 //layer=li \
 //thickness=0.1 //x=53.57 //y=0.175 //x2=54.14 //y2=0.175
r1989 (  521 718 ) resistor r=5.29055 //w=0.35 //l=0.17 //layer=li \
 //thickness=0.1 //x=58.04 //y=0.175 //x2=58.21 //y2=0.175
r1990 (  521 530 ) resistor r=19.8801 //w=0.367 //l=0.57 //layer=li \
 //thickness=0.1 //x=58.04 //y=0.175 //x2=57.47 //y2=0.175
r1991 (  511 513 ) resistor r=38.7139 //w=0.367 //l=1.11 //layer=li \
 //thickness=0.1 //x=51.55 //y=0.175 //x2=52.66 //y2=0.175
r1992 (  509 511 ) resistor r=38.7139 //w=0.367 //l=1.11 //layer=li \
 //thickness=0.1 //x=50.44 //y=0.175 //x2=51.55 //y2=0.175
r1993 (  507 509 ) resistor r=38.7139 //w=0.367 //l=1.11 //layer=li \
 //thickness=0.1 //x=49.33 //y=0.175 //x2=50.44 //y2=0.175
r1994 (  505 716 ) resistor r=5.29055 //w=0.35 //l=0.17 //layer=li \
 //thickness=0.1 //x=48.76 //y=0.175 //x2=48.59 //y2=0.175
r1995 (  505 507 ) resistor r=19.8801 //w=0.367 //l=0.57 //layer=li \
 //thickness=0.1 //x=48.76 //y=0.175 //x2=49.33 //y2=0.175
r1996 (  504 717 ) resistor r=5.29055 //w=0.35 //l=0.17 //layer=li \
 //thickness=0.1 //x=53.23 //y=0.175 //x2=53.4 //y2=0.175
r1997 (  504 513 ) resistor r=19.8801 //w=0.367 //l=0.57 //layer=li \
 //thickness=0.1 //x=53.23 //y=0.175 //x2=52.66 //y2=0.175
r1998 (  494 496 ) resistor r=38.7139 //w=0.367 //l=1.11 //layer=li \
 //thickness=0.1 //x=46.74 //y=0.175 //x2=47.85 //y2=0.175
r1999 (  492 494 ) resistor r=38.7139 //w=0.367 //l=1.11 //layer=li \
 //thickness=0.1 //x=45.63 //y=0.175 //x2=46.74 //y2=0.175
r2000 (  490 492 ) resistor r=38.7139 //w=0.367 //l=1.11 //layer=li \
 //thickness=0.1 //x=44.52 //y=0.175 //x2=45.63 //y2=0.175
r2001 (  488 715 ) resistor r=5.29055 //w=0.35 //l=0.17 //layer=li \
 //thickness=0.1 //x=43.95 //y=0.175 //x2=43.78 //y2=0.175
r2002 (  488 490 ) resistor r=19.8801 //w=0.367 //l=0.57 //layer=li \
 //thickness=0.1 //x=43.95 //y=0.175 //x2=44.52 //y2=0.175
r2003 (  487 716 ) resistor r=5.29055 //w=0.35 //l=0.17 //layer=li \
 //thickness=0.1 //x=48.42 //y=0.175 //x2=48.59 //y2=0.175
r2004 (  487 496 ) resistor r=19.8801 //w=0.367 //l=0.57 //layer=li \
 //thickness=0.1 //x=48.42 //y=0.175 //x2=47.85 //y2=0.175
r2005 (  477 479 ) resistor r=38.7139 //w=0.367 //l=1.11 //layer=li \
 //thickness=0.1 //x=41.93 //y=0.175 //x2=43.04 //y2=0.175
r2006 (  475 477 ) resistor r=38.7139 //w=0.367 //l=1.11 //layer=li \
 //thickness=0.1 //x=40.82 //y=0.175 //x2=41.93 //y2=0.175
r2007 (  473 475 ) resistor r=38.7139 //w=0.367 //l=1.11 //layer=li \
 //thickness=0.1 //x=39.71 //y=0.175 //x2=40.82 //y2=0.175
r2008 (  471 714 ) resistor r=5.29055 //w=0.35 //l=0.17 //layer=li \
 //thickness=0.1 //x=39.14 //y=0.175 //x2=38.97 //y2=0.175
r2009 (  471 473 ) resistor r=19.8801 //w=0.367 //l=0.57 //layer=li \
 //thickness=0.1 //x=39.14 //y=0.175 //x2=39.71 //y2=0.175
r2010 (  470 715 ) resistor r=5.29055 //w=0.35 //l=0.17 //layer=li \
 //thickness=0.1 //x=43.61 //y=0.175 //x2=43.78 //y2=0.175
r2011 (  470 479 ) resistor r=19.8801 //w=0.367 //l=0.57 //layer=li \
 //thickness=0.1 //x=43.61 //y=0.175 //x2=43.04 //y2=0.175
r2012 (  460 462 ) resistor r=38.7139 //w=0.367 //l=1.11 //layer=li \
 //thickness=0.1 //x=37.12 //y=0.175 //x2=38.23 //y2=0.175
r2013 (  458 460 ) resistor r=38.7139 //w=0.367 //l=1.11 //layer=li \
 //thickness=0.1 //x=36.01 //y=0.175 //x2=37.12 //y2=0.175
r2014 (  456 458 ) resistor r=38.7139 //w=0.367 //l=1.11 //layer=li \
 //thickness=0.1 //x=34.9 //y=0.175 //x2=36.01 //y2=0.175
r2015 (  454 713 ) resistor r=5.29055 //w=0.35 //l=0.17 //layer=li \
 //thickness=0.1 //x=34.33 //y=0.175 //x2=34.16 //y2=0.175
r2016 (  454 456 ) resistor r=19.8801 //w=0.367 //l=0.57 //layer=li \
 //thickness=0.1 //x=34.33 //y=0.175 //x2=34.9 //y2=0.175
r2017 (  453 714 ) resistor r=5.29055 //w=0.35 //l=0.17 //layer=li \
 //thickness=0.1 //x=38.8 //y=0.175 //x2=38.97 //y2=0.175
r2018 (  453 462 ) resistor r=19.8801 //w=0.367 //l=0.57 //layer=li \
 //thickness=0.1 //x=38.8 //y=0.175 //x2=38.23 //y2=0.175
r2019 (  443 445 ) resistor r=38.7139 //w=0.367 //l=1.11 //layer=li \
 //thickness=0.1 //x=32.31 //y=0.175 //x2=33.42 //y2=0.175
r2020 (  441 443 ) resistor r=38.7139 //w=0.367 //l=1.11 //layer=li \
 //thickness=0.1 //x=31.2 //y=0.175 //x2=32.31 //y2=0.175
r2021 (  439 441 ) resistor r=38.7139 //w=0.367 //l=1.11 //layer=li \
 //thickness=0.1 //x=30.09 //y=0.175 //x2=31.2 //y2=0.175
r2022 (  437 712 ) resistor r=5.29055 //w=0.35 //l=0.17 //layer=li \
 //thickness=0.1 //x=29.52 //y=0.175 //x2=29.35 //y2=0.175
r2023 (  437 439 ) resistor r=19.8801 //w=0.367 //l=0.57 //layer=li \
 //thickness=0.1 //x=29.52 //y=0.175 //x2=30.09 //y2=0.175
r2024 (  436 713 ) resistor r=5.29055 //w=0.35 //l=0.17 //layer=li \
 //thickness=0.1 //x=33.99 //y=0.175 //x2=34.16 //y2=0.175
r2025 (  436 445 ) resistor r=19.8801 //w=0.367 //l=0.57 //layer=li \
 //thickness=0.1 //x=33.99 //y=0.175 //x2=33.42 //y2=0.175
r2026 (  426 428 ) resistor r=38.7139 //w=0.367 //l=1.11 //layer=li \
 //thickness=0.1 //x=27.5 //y=0.175 //x2=28.61 //y2=0.175
r2027 (  424 426 ) resistor r=38.7139 //w=0.367 //l=1.11 //layer=li \
 //thickness=0.1 //x=26.39 //y=0.175 //x2=27.5 //y2=0.175
r2028 (  422 424 ) resistor r=38.7139 //w=0.367 //l=1.11 //layer=li \
 //thickness=0.1 //x=25.28 //y=0.175 //x2=26.39 //y2=0.175
r2029 (  420 711 ) resistor r=5.29055 //w=0.35 //l=0.17 //layer=li \
 //thickness=0.1 //x=24.71 //y=0.175 //x2=24.54 //y2=0.175
r2030 (  420 422 ) resistor r=19.8801 //w=0.367 //l=0.57 //layer=li \
 //thickness=0.1 //x=24.71 //y=0.175 //x2=25.28 //y2=0.175
r2031 (  419 712 ) resistor r=5.29055 //w=0.35 //l=0.17 //layer=li \
 //thickness=0.1 //x=29.18 //y=0.175 //x2=29.35 //y2=0.175
r2032 (  419 428 ) resistor r=19.8801 //w=0.367 //l=0.57 //layer=li \
 //thickness=0.1 //x=29.18 //y=0.175 //x2=28.61 //y2=0.175
r2033 (  409 411 ) resistor r=38.7139 //w=0.367 //l=1.11 //layer=li \
 //thickness=0.1 //x=22.69 //y=0.175 //x2=23.8 //y2=0.175
r2034 (  407 409 ) resistor r=38.7139 //w=0.367 //l=1.11 //layer=li \
 //thickness=0.1 //x=21.58 //y=0.175 //x2=22.69 //y2=0.175
r2035 (  405 407 ) resistor r=38.7139 //w=0.367 //l=1.11 //layer=li \
 //thickness=0.1 //x=20.47 //y=0.175 //x2=21.58 //y2=0.175
r2036 (  403 710 ) resistor r=5.29055 //w=0.35 //l=0.17 //layer=li \
 //thickness=0.1 //x=19.9 //y=0.175 //x2=19.73 //y2=0.175
r2037 (  403 405 ) resistor r=19.8801 //w=0.367 //l=0.57 //layer=li \
 //thickness=0.1 //x=19.9 //y=0.175 //x2=20.47 //y2=0.175
r2038 (  402 711 ) resistor r=5.29055 //w=0.35 //l=0.17 //layer=li \
 //thickness=0.1 //x=24.37 //y=0.175 //x2=24.54 //y2=0.175
r2039 (  402 411 ) resistor r=19.8801 //w=0.367 //l=0.57 //layer=li \
 //thickness=0.1 //x=24.37 //y=0.175 //x2=23.8 //y2=0.175
r2040 (  392 394 ) resistor r=38.7139 //w=0.367 //l=1.11 //layer=li \
 //thickness=0.1 //x=17.88 //y=0.175 //x2=18.99 //y2=0.175
r2041 (  390 392 ) resistor r=38.7139 //w=0.367 //l=1.11 //layer=li \
 //thickness=0.1 //x=16.77 //y=0.175 //x2=17.88 //y2=0.175
r2042 (  388 390 ) resistor r=38.7139 //w=0.367 //l=1.11 //layer=li \
 //thickness=0.1 //x=15.66 //y=0.175 //x2=16.77 //y2=0.175
r2043 (  386 709 ) resistor r=5.29055 //w=0.35 //l=0.17 //layer=li \
 //thickness=0.1 //x=15.09 //y=0.175 //x2=14.92 //y2=0.175
r2044 (  386 388 ) resistor r=19.8801 //w=0.367 //l=0.57 //layer=li \
 //thickness=0.1 //x=15.09 //y=0.175 //x2=15.66 //y2=0.175
r2045 (  385 710 ) resistor r=5.29055 //w=0.35 //l=0.17 //layer=li \
 //thickness=0.1 //x=19.56 //y=0.175 //x2=19.73 //y2=0.175
r2046 (  385 394 ) resistor r=19.8801 //w=0.367 //l=0.57 //layer=li \
 //thickness=0.1 //x=19.56 //y=0.175 //x2=18.99 //y2=0.175
r2047 (  375 377 ) resistor r=38.7139 //w=0.367 //l=1.11 //layer=li \
 //thickness=0.1 //x=13.07 //y=0.175 //x2=14.18 //y2=0.175
r2048 (  373 375 ) resistor r=38.7139 //w=0.367 //l=1.11 //layer=li \
 //thickness=0.1 //x=11.96 //y=0.175 //x2=13.07 //y2=0.175
r2049 (  371 373 ) resistor r=38.7139 //w=0.367 //l=1.11 //layer=li \
 //thickness=0.1 //x=10.85 //y=0.175 //x2=11.96 //y2=0.175
r2050 (  369 708 ) resistor r=5.29055 //w=0.35 //l=0.17 //layer=li \
 //thickness=0.1 //x=10.28 //y=0.175 //x2=10.11 //y2=0.175
r2051 (  369 371 ) resistor r=19.8801 //w=0.367 //l=0.57 //layer=li \
 //thickness=0.1 //x=10.28 //y=0.175 //x2=10.85 //y2=0.175
r2052 (  368 709 ) resistor r=5.29055 //w=0.35 //l=0.17 //layer=li \
 //thickness=0.1 //x=14.75 //y=0.175 //x2=14.92 //y2=0.175
r2053 (  368 377 ) resistor r=19.8801 //w=0.367 //l=0.57 //layer=li \
 //thickness=0.1 //x=14.75 //y=0.175 //x2=14.18 //y2=0.175
r2054 (  358 360 ) resistor r=38.7139 //w=0.367 //l=1.11 //layer=li \
 //thickness=0.1 //x=8.26 //y=0.175 //x2=9.37 //y2=0.175
r2055 (  356 358 ) resistor r=38.7139 //w=0.367 //l=1.11 //layer=li \
 //thickness=0.1 //x=7.15 //y=0.175 //x2=8.26 //y2=0.175
r2056 (  354 356 ) resistor r=38.7139 //w=0.367 //l=1.11 //layer=li \
 //thickness=0.1 //x=6.04 //y=0.175 //x2=7.15 //y2=0.175
r2057 (  352 707 ) resistor r=5.29055 //w=0.35 //l=0.17 //layer=li \
 //thickness=0.1 //x=5.47 //y=0.175 //x2=5.3 //y2=0.175
r2058 (  352 354 ) resistor r=19.8801 //w=0.367 //l=0.57 //layer=li \
 //thickness=0.1 //x=5.47 //y=0.175 //x2=6.04 //y2=0.175
r2059 (  351 708 ) resistor r=5.29055 //w=0.35 //l=0.17 //layer=li \
 //thickness=0.1 //x=9.94 //y=0.175 //x2=10.11 //y2=0.175
r2060 (  351 360 ) resistor r=19.8801 //w=0.367 //l=0.57 //layer=li \
 //thickness=0.1 //x=9.94 //y=0.175 //x2=9.37 //y2=0.175
r2061 (  341 343 ) resistor r=38.7139 //w=0.367 //l=1.11 //layer=li \
 //thickness=0.1 //x=3.45 //y=0.175 //x2=4.56 //y2=0.175
r2062 (  339 341 ) resistor r=38.7139 //w=0.367 //l=1.11 //layer=li \
 //thickness=0.1 //x=2.34 //y=0.175 //x2=3.45 //y2=0.175
r2063 (  337 339 ) resistor r=38.7139 //w=0.367 //l=1.11 //layer=li \
 //thickness=0.1 //x=1.23 //y=0.175 //x2=2.34 //y2=0.175
r2064 (  334 707 ) resistor r=5.29055 //w=0.35 //l=0.17 //layer=li \
 //thickness=0.1 //x=5.13 //y=0.175 //x2=5.3 //y2=0.175
r2065 (  334 343 ) resistor r=19.8801 //w=0.367 //l=0.57 //layer=li \
 //thickness=0.1 //x=5.13 //y=0.175 //x2=4.56 //y2=0.175
r2066 (  331 761 ) resistor r=9.3 //w=0.17 //l=0.17 //layer=mcon //count=1 \
 //x=94.91 //y=1.135 //x2=94.91 //y2=1.135
r2067 (  328 760 ) resistor r=9.3 //w=0.17 //l=0.17 //layer=mcon //count=1 \
 //x=91.58 //y=1.135 //x2=91.58 //y2=1.135
r2068 (  326 658 ) resistor r=3.1 //w=0.17 //l=0.51 //layer=mcon //count=3 \
 //x=91.51 //y=0.18 //x2=91.51 //y2=0.18
r2069 (  324 759 ) resistor r=9.3 //w=0.17 //l=0.17 //layer=mcon //count=1 \
 //x=88.25 //y=1.135 //x2=88.25 //y2=1.135
r2070 (  319 758 ) resistor r=9.3 //w=0.17 //l=0.17 //layer=mcon //count=1 \
 //x=83.335 //y=1.145 //x2=83.335 //y2=1.145
r2071 (  315 757 ) resistor r=9.3 //w=0.17 //l=0.17 //layer=mcon //count=1 \
 //x=78.525 //y=1.145 //x2=78.525 //y2=1.145
r2072 (  311 756 ) resistor r=9.3 //w=0.17 //l=0.17 //layer=mcon //count=1 \
 //x=73.715 //y=1.145 //x2=73.715 //y2=1.145
r2073 (  307 755 ) resistor r=9.3 //w=0.17 //l=0.17 //layer=mcon //count=1 \
 //x=68.905 //y=1.145 //x2=68.905 //y2=1.145
r2074 (  303 754 ) resistor r=9.3 //w=0.17 //l=0.17 //layer=mcon //count=1 \
 //x=64.095 //y=1.145 //x2=64.095 //y2=1.145
r2075 (  299 753 ) resistor r=9.3 //w=0.17 //l=0.17 //layer=mcon //count=1 \
 //x=59.285 //y=1.145 //x2=59.285 //y2=1.145
r2076 (  295 752 ) resistor r=9.3 //w=0.17 //l=0.17 //layer=mcon //count=1 \
 //x=54.475 //y=1.145 //x2=54.475 //y2=1.145
r2077 (  291 751 ) resistor r=9.3 //w=0.17 //l=0.17 //layer=mcon //count=1 \
 //x=49.665 //y=1.145 //x2=49.665 //y2=1.145
r2078 (  287 750 ) resistor r=9.3 //w=0.17 //l=0.17 //layer=mcon //count=1 \
 //x=44.855 //y=1.145 //x2=44.855 //y2=1.145
r2079 (  283 749 ) resistor r=9.3 //w=0.17 //l=0.17 //layer=mcon //count=1 \
 //x=40.045 //y=1.145 //x2=40.045 //y2=1.145
r2080 (  279 748 ) resistor r=9.3 //w=0.17 //l=0.17 //layer=mcon //count=1 \
 //x=35.235 //y=1.145 //x2=35.235 //y2=1.145
r2081 (  275 747 ) resistor r=9.3 //w=0.17 //l=0.17 //layer=mcon //count=1 \
 //x=30.425 //y=1.145 //x2=30.425 //y2=1.145
r2082 (  271 746 ) resistor r=9.3 //w=0.17 //l=0.17 //layer=mcon //count=1 \
 //x=25.615 //y=1.145 //x2=25.615 //y2=1.145
r2083 (  267 745 ) resistor r=9.3 //w=0.17 //l=0.17 //layer=mcon //count=1 \
 //x=20.805 //y=1.145 //x2=20.805 //y2=1.145
r2084 (  263 744 ) resistor r=9.3 //w=0.17 //l=0.17 //layer=mcon //count=1 \
 //x=15.995 //y=1.145 //x2=15.995 //y2=1.145
r2085 (  259 743 ) resistor r=9.3 //w=0.17 //l=0.17 //layer=mcon //count=1 \
 //x=11.185 //y=1.145 //x2=11.185 //y2=1.145
r2086 (  255 742 ) resistor r=9.3 //w=0.17 //l=0.17 //layer=mcon //count=1 \
 //x=6.375 //y=1.145 //x2=6.375 //y2=1.145
r2087 (  251 741 ) resistor r=9.3 //w=0.17 //l=0.17 //layer=mcon //count=1 \
 //x=1.565 //y=1.145 //x2=1.565 //y2=1.145
r2088 (  248 733 ) resistor r=4.65 //w=0.17 //l=0.34 //layer=mcon //count=2 \
 //x=98.54 //y=0.18 //x2=98.54 //y2=0.18
r2089 (  246 730 ) resistor r=3.1 //w=0.17 //l=0.51 //layer=mcon //count=3 \
 //x=97.8 //y=0.18 //x2=97.8 //y2=0.18
r2090 (  246 248 ) resistor r=0.297428 //w=0.311 //l=0.74 //layer=m1 \
 //thickness=0.36 //x=97.8 //y=0.175 //x2=98.54 //y2=0.175
r2091 (  244 675 ) resistor r=3.1 //w=0.17 //l=0.51 //layer=mcon //count=3 \
 //x=96.32 //y=0.18 //x2=96.32 //y2=0.18
r2092 (  244 246 ) resistor r=0.594855 //w=0.311 //l=1.48 //layer=m1 \
 //thickness=0.36 //x=96.32 //y=0.175 //x2=97.8 //y2=0.175
r2093 (  242 673 ) resistor r=3.1 //w=0.17 //l=0.51 //layer=mcon //count=3 \
 //x=95.21 //y=0.18 //x2=95.21 //y2=0.18
r2094 (  242 244 ) resistor r=0.446141 //w=0.311 //l=1.11 //layer=m1 \
 //thickness=0.36 //x=95.21 //y=0.175 //x2=96.32 //y2=0.175
r2095 (  240 329 ) resistor r=0.028033 //w=0.35 //l=0.085 //layer=m1 \
 //thickness=0.36 //x=94.995 //y=0.175 //x2=94.91 //y2=0.175
r2096 (  240 242 ) resistor r=0.0864148 //w=0.311 //l=0.215 //layer=m1 \
 //thickness=0.36 //x=94.995 //y=0.175 //x2=95.21 //y2=0.175
r2097 (  239 331 ) resistor r=0.0703067 //w=0.254 //l=0.11649 //layer=m1 \
 //thickness=0.36 //x=94.91 //y=1.02 //x2=94.907 //y2=1.135
r2098 (  238 329 ) resistor r=0.0413265 //w=0.7 //l=0.175 //layer=m1 \
 //thickness=0.36 //x=94.91 //y=0.35 //x2=94.91 //y2=0.175
r2099 (  238 239 ) resistor r=0.639313 //w=0.131 //l=0.67 //layer=m1 \
 //thickness=0.36 //x=94.91 //y=0.35 //x2=94.91 //y2=1.02
r2100 (  237 671 ) resistor r=3.1 //w=0.17 //l=0.51 //layer=mcon //count=3 \
 //x=94.1 //y=0.18 //x2=94.1 //y2=0.18
r2101 (  235 660 ) resistor r=3.1 //w=0.17 //l=0.51 //layer=mcon //count=3 \
 //x=92.62 //y=0.18 //x2=92.62 //y2=0.18
r2102 (  235 237 ) resistor r=0.594855 //w=0.311 //l=1.48 //layer=m1 \
 //thickness=0.36 //x=92.62 //y=0.175 //x2=94.1 //y2=0.175
r2103 (  233 326 ) resistor r=0.028033 //w=0.35 //l=0.085 //layer=m1 \
 //thickness=0.36 //x=91.665 //y=0.175 //x2=91.58 //y2=0.175
r2104 (  233 235 ) resistor r=0.383842 //w=0.311 //l=0.955 //layer=m1 \
 //thickness=0.36 //x=91.665 //y=0.175 //x2=92.62 //y2=0.175
r2105 (  232 329 ) resistor r=0.028033 //w=0.35 //l=0.085 //layer=m1 \
 //thickness=0.36 //x=94.825 //y=0.175 //x2=94.91 //y2=0.175
r2106 (  232 237 ) resistor r=0.291399 //w=0.311 //l=0.725 //layer=m1 \
 //thickness=0.36 //x=94.825 //y=0.175 //x2=94.1 //y2=0.175
r2107 (  231 328 ) resistor r=0.072745 //w=0.255 //l=0.122474 //layer=m1 \
 //thickness=0.36 //x=91.58 //y=1.015 //x2=91.585 //y2=1.135
r2108 (  230 326 ) resistor r=0.0413265 //w=0.7 //l=0.175 //layer=m1 \
 //thickness=0.36 //x=91.58 //y=0.35 //x2=91.58 //y2=0.175
r2109 (  230 231 ) resistor r=0.634542 //w=0.131 //l=0.665 //layer=m1 \
 //thickness=0.36 //x=91.58 //y=0.35 //x2=91.58 //y2=1.015
r2110 (  229 647 ) resistor r=3.1 //w=0.17 //l=0.51 //layer=mcon //count=3 \
 //x=90.03 //y=0.18 //x2=90.03 //y2=0.18
r2111 (  227 645 ) resistor r=3.1 //w=0.17 //l=0.51 //layer=mcon //count=3 \
 //x=88.92 //y=0.18 //x2=88.92 //y2=0.18
r2112 (  227 229 ) resistor r=0.446141 //w=0.311 //l=1.11 //layer=m1 \
 //thickness=0.36 //x=88.92 //y=0.175 //x2=90.03 //y2=0.175
r2113 (  225 322 ) resistor r=0.028033 //w=0.35 //l=0.085 //layer=m1 \
 //thickness=0.36 //x=88.335 //y=0.175 //x2=88.25 //y2=0.175
r2114 (  225 227 ) resistor r=0.235129 //w=0.311 //l=0.585 //layer=m1 \
 //thickness=0.36 //x=88.335 //y=0.175 //x2=88.92 //y2=0.175
r2115 (  224 326 ) resistor r=0.028033 //w=0.35 //l=0.085 //layer=m1 \
 //thickness=0.36 //x=91.495 //y=0.175 //x2=91.58 //y2=0.175
r2116 (  224 229 ) resistor r=0.588826 //w=0.311 //l=1.465 //layer=m1 \
 //thickness=0.36 //x=91.495 //y=0.175 //x2=90.03 //y2=0.175
r2117 (  223 324 ) resistor r=0.0729089 //w=0.249 //l=0.120996 //layer=m1 \
 //thickness=0.36 //x=88.25 //y=1.015 //x2=88.252 //y2=1.135
r2118 (  222 322 ) resistor r=0.0413265 //w=0.7 //l=0.175 //layer=m1 \
 //thickness=0.36 //x=88.25 //y=0.35 //x2=88.25 //y2=0.175
r2119 (  222 223 ) resistor r=0.634542 //w=0.131 //l=0.665 //layer=m1 \
 //thickness=0.36 //x=88.25 //y=0.35 //x2=88.25 //y2=1.015
r2120 (  221 643 ) resistor r=3.1 //w=0.17 //l=0.51 //layer=mcon //count=3 \
 //x=87.81 //y=0.18 //x2=87.81 //y2=0.18
r2121 (  219 632 ) resistor r=3.1 //w=0.17 //l=0.51 //layer=mcon //count=3 \
 //x=86.33 //y=0.18 //x2=86.33 //y2=0.18
r2122 (  219 221 ) resistor r=0.594855 //w=0.311 //l=1.48 //layer=m1 \
 //thickness=0.36 //x=86.33 //y=0.175 //x2=87.81 //y2=0.175
r2123 (  217 630 ) resistor r=3.1 //w=0.17 //l=0.51 //layer=mcon //count=3 \
 //x=85.22 //y=0.18 //x2=85.22 //y2=0.18
r2124 (  217 219 ) resistor r=0.446141 //w=0.311 //l=1.11 //layer=m1 \
 //thickness=0.36 //x=85.22 //y=0.175 //x2=86.33 //y2=0.175
r2125 (  215 628 ) resistor r=3.1 //w=0.17 //l=0.51 //layer=mcon //count=3 \
 //x=84.11 //y=0.18 //x2=84.11 //y2=0.18
r2126 (  215 217 ) resistor r=0.446141 //w=0.311 //l=1.11 //layer=m1 \
 //thickness=0.36 //x=84.11 //y=0.175 //x2=85.22 //y2=0.175
r2127 (  213 321 ) resistor r=0.028033 //w=0.35 //l=0.085 //layer=m1 \
 //thickness=0.36 //x=83.42 //y=0.175 //x2=83.335 //y2=0.175
r2128 (  213 215 ) resistor r=0.277331 //w=0.311 //l=0.69 //layer=m1 \
 //thickness=0.36 //x=83.42 //y=0.175 //x2=84.11 //y2=0.175
r2129 (  212 322 ) resistor r=0.028033 //w=0.35 //l=0.085 //layer=m1 \
 //thickness=0.36 //x=88.165 //y=0.175 //x2=88.25 //y2=0.175
r2130 (  212 221 ) resistor r=0.142685 //w=0.311 //l=0.355 //layer=m1 \
 //thickness=0.36 //x=88.165 //y=0.175 //x2=87.81 //y2=0.175
r2131 (  211 319 ) resistor r=0.0942778 //w=0.221 //l=0.13 //layer=m1 \
 //thickness=0.36 //x=83.335 //y=1.015 //x2=83.335 //y2=1.145
r2132 (  210 321 ) resistor r=0.0413265 //w=0.7 //l=0.175 //layer=m1 \
 //thickness=0.36 //x=83.335 //y=0.35 //x2=83.335 //y2=0.175
r2133 (  210 211 ) resistor r=0.634542 //w=0.131 //l=0.665 //layer=m1 \
 //thickness=0.36 //x=83.335 //y=0.35 //x2=83.335 //y2=1.015
r2134 (  209 626 ) resistor r=3.1 //w=0.17 //l=0.51 //layer=mcon //count=3 \
 //x=83 //y=0.18 //x2=83 //y2=0.18
r2135 (  207 615 ) resistor r=3.1 //w=0.17 //l=0.51 //layer=mcon //count=3 \
 //x=81.52 //y=0.18 //x2=81.52 //y2=0.18
r2136 (  207 209 ) resistor r=0.594855 //w=0.311 //l=1.48 //layer=m1 \
 //thickness=0.36 //x=81.52 //y=0.175 //x2=83 //y2=0.175
r2137 (  205 613 ) resistor r=3.1 //w=0.17 //l=0.51 //layer=mcon //count=3 \
 //x=80.41 //y=0.18 //x2=80.41 //y2=0.18
r2138 (  205 207 ) resistor r=0.446141 //w=0.311 //l=1.11 //layer=m1 \
 //thickness=0.36 //x=80.41 //y=0.175 //x2=81.52 //y2=0.175
r2139 (  203 611 ) resistor r=3.1 //w=0.17 //l=0.51 //layer=mcon //count=3 \
 //x=79.3 //y=0.18 //x2=79.3 //y2=0.18
r2140 (  203 205 ) resistor r=0.446141 //w=0.311 //l=1.11 //layer=m1 \
 //thickness=0.36 //x=79.3 //y=0.175 //x2=80.41 //y2=0.175
r2141 (  201 317 ) resistor r=0.028033 //w=0.35 //l=0.085 //layer=m1 \
 //thickness=0.36 //x=78.61 //y=0.175 //x2=78.525 //y2=0.175
r2142 (  201 203 ) resistor r=0.277331 //w=0.311 //l=0.69 //layer=m1 \
 //thickness=0.36 //x=78.61 //y=0.175 //x2=79.3 //y2=0.175
r2143 (  200 321 ) resistor r=0.028033 //w=0.35 //l=0.085 //layer=m1 \
 //thickness=0.36 //x=83.25 //y=0.175 //x2=83.335 //y2=0.175
r2144 (  200 209 ) resistor r=0.100482 //w=0.311 //l=0.25 //layer=m1 \
 //thickness=0.36 //x=83.25 //y=0.175 //x2=83 //y2=0.175
r2145 (  199 315 ) resistor r=0.0942778 //w=0.221 //l=0.13 //layer=m1 \
 //thickness=0.36 //x=78.525 //y=1.015 //x2=78.525 //y2=1.145
r2146 (  198 317 ) resistor r=0.0413265 //w=0.7 //l=0.175 //layer=m1 \
 //thickness=0.36 //x=78.525 //y=0.35 //x2=78.525 //y2=0.175
r2147 (  198 199 ) resistor r=0.634542 //w=0.131 //l=0.665 //layer=m1 \
 //thickness=0.36 //x=78.525 //y=0.35 //x2=78.525 //y2=1.015
r2148 (  197 609 ) resistor r=3.1 //w=0.17 //l=0.51 //layer=mcon //count=3 \
 //x=78.19 //y=0.18 //x2=78.19 //y2=0.18
r2149 (  195 598 ) resistor r=3.1 //w=0.17 //l=0.51 //layer=mcon //count=3 \
 //x=76.71 //y=0.18 //x2=76.71 //y2=0.18
r2150 (  195 197 ) resistor r=0.594855 //w=0.311 //l=1.48 //layer=m1 \
 //thickness=0.36 //x=76.71 //y=0.175 //x2=78.19 //y2=0.175
r2151 (  193 596 ) resistor r=3.1 //w=0.17 //l=0.51 //layer=mcon //count=3 \
 //x=75.6 //y=0.18 //x2=75.6 //y2=0.18
r2152 (  193 195 ) resistor r=0.446141 //w=0.311 //l=1.11 //layer=m1 \
 //thickness=0.36 //x=75.6 //y=0.175 //x2=76.71 //y2=0.175
r2153 (  191 594 ) resistor r=3.1 //w=0.17 //l=0.51 //layer=mcon //count=3 \
 //x=74.49 //y=0.18 //x2=74.49 //y2=0.18
r2154 (  191 193 ) resistor r=0.446141 //w=0.311 //l=1.11 //layer=m1 \
 //thickness=0.36 //x=74.49 //y=0.175 //x2=75.6 //y2=0.175
r2155 (  189 313 ) resistor r=0.028033 //w=0.35 //l=0.085 //layer=m1 \
 //thickness=0.36 //x=73.8 //y=0.175 //x2=73.715 //y2=0.175
r2156 (  189 191 ) resistor r=0.277331 //w=0.311 //l=0.69 //layer=m1 \
 //thickness=0.36 //x=73.8 //y=0.175 //x2=74.49 //y2=0.175
r2157 (  188 317 ) resistor r=0.028033 //w=0.35 //l=0.085 //layer=m1 \
 //thickness=0.36 //x=78.44 //y=0.175 //x2=78.525 //y2=0.175
r2158 (  188 197 ) resistor r=0.100482 //w=0.311 //l=0.25 //layer=m1 \
 //thickness=0.36 //x=78.44 //y=0.175 //x2=78.19 //y2=0.175
r2159 (  187 311 ) resistor r=0.0942778 //w=0.221 //l=0.13 //layer=m1 \
 //thickness=0.36 //x=73.715 //y=1.015 //x2=73.715 //y2=1.145
r2160 (  186 313 ) resistor r=0.0413265 //w=0.7 //l=0.175 //layer=m1 \
 //thickness=0.36 //x=73.715 //y=0.35 //x2=73.715 //y2=0.175
r2161 (  186 187 ) resistor r=0.634542 //w=0.131 //l=0.665 //layer=m1 \
 //thickness=0.36 //x=73.715 //y=0.35 //x2=73.715 //y2=1.015
r2162 (  185 592 ) resistor r=3.1 //w=0.17 //l=0.51 //layer=mcon //count=3 \
 //x=73.38 //y=0.18 //x2=73.38 //y2=0.18
r2163 (  183 581 ) resistor r=3.1 //w=0.17 //l=0.51 //layer=mcon //count=3 \
 //x=71.9 //y=0.18 //x2=71.9 //y2=0.18
r2164 (  183 185 ) resistor r=0.594855 //w=0.311 //l=1.48 //layer=m1 \
 //thickness=0.36 //x=71.9 //y=0.175 //x2=73.38 //y2=0.175
r2165 (  181 579 ) resistor r=3.1 //w=0.17 //l=0.51 //layer=mcon //count=3 \
 //x=70.79 //y=0.18 //x2=70.79 //y2=0.18
r2166 (  181 183 ) resistor r=0.446141 //w=0.311 //l=1.11 //layer=m1 \
 //thickness=0.36 //x=70.79 //y=0.175 //x2=71.9 //y2=0.175
r2167 (  179 577 ) resistor r=3.1 //w=0.17 //l=0.51 //layer=mcon //count=3 \
 //x=69.68 //y=0.18 //x2=69.68 //y2=0.18
r2168 (  179 181 ) resistor r=0.446141 //w=0.311 //l=1.11 //layer=m1 \
 //thickness=0.36 //x=69.68 //y=0.175 //x2=70.79 //y2=0.175
r2169 (  177 309 ) resistor r=0.028033 //w=0.35 //l=0.085 //layer=m1 \
 //thickness=0.36 //x=68.99 //y=0.175 //x2=68.905 //y2=0.175
r2170 (  177 179 ) resistor r=0.277331 //w=0.311 //l=0.69 //layer=m1 \
 //thickness=0.36 //x=68.99 //y=0.175 //x2=69.68 //y2=0.175
r2171 (  176 313 ) resistor r=0.028033 //w=0.35 //l=0.085 //layer=m1 \
 //thickness=0.36 //x=73.63 //y=0.175 //x2=73.715 //y2=0.175
r2172 (  176 185 ) resistor r=0.100482 //w=0.311 //l=0.25 //layer=m1 \
 //thickness=0.36 //x=73.63 //y=0.175 //x2=73.38 //y2=0.175
r2173 (  175 307 ) resistor r=0.0942778 //w=0.221 //l=0.13 //layer=m1 \
 //thickness=0.36 //x=68.905 //y=1.015 //x2=68.905 //y2=1.145
r2174 (  174 309 ) resistor r=0.0413265 //w=0.7 //l=0.175 //layer=m1 \
 //thickness=0.36 //x=68.905 //y=0.35 //x2=68.905 //y2=0.175
r2175 (  174 175 ) resistor r=0.634542 //w=0.131 //l=0.665 //layer=m1 \
 //thickness=0.36 //x=68.905 //y=0.35 //x2=68.905 //y2=1.015
r2176 (  173 575 ) resistor r=3.1 //w=0.17 //l=0.51 //layer=mcon //count=3 \
 //x=68.57 //y=0.18 //x2=68.57 //y2=0.18
r2177 (  171 564 ) resistor r=3.1 //w=0.17 //l=0.51 //layer=mcon //count=3 \
 //x=67.09 //y=0.18 //x2=67.09 //y2=0.18
r2178 (  171 173 ) resistor r=0.594855 //w=0.311 //l=1.48 //layer=m1 \
 //thickness=0.36 //x=67.09 //y=0.175 //x2=68.57 //y2=0.175
r2179 (  169 562 ) resistor r=3.1 //w=0.17 //l=0.51 //layer=mcon //count=3 \
 //x=65.98 //y=0.18 //x2=65.98 //y2=0.18
r2180 (  169 171 ) resistor r=0.446141 //w=0.311 //l=1.11 //layer=m1 \
 //thickness=0.36 //x=65.98 //y=0.175 //x2=67.09 //y2=0.175
r2181 (  167 560 ) resistor r=3.1 //w=0.17 //l=0.51 //layer=mcon //count=3 \
 //x=64.87 //y=0.18 //x2=64.87 //y2=0.18
r2182 (  167 169 ) resistor r=0.446141 //w=0.311 //l=1.11 //layer=m1 \
 //thickness=0.36 //x=64.87 //y=0.175 //x2=65.98 //y2=0.175
r2183 (  165 305 ) resistor r=0.028033 //w=0.35 //l=0.085 //layer=m1 \
 //thickness=0.36 //x=64.18 //y=0.175 //x2=64.095 //y2=0.175
r2184 (  165 167 ) resistor r=0.277331 //w=0.311 //l=0.69 //layer=m1 \
 //thickness=0.36 //x=64.18 //y=0.175 //x2=64.87 //y2=0.175
r2185 (  164 309 ) resistor r=0.028033 //w=0.35 //l=0.085 //layer=m1 \
 //thickness=0.36 //x=68.82 //y=0.175 //x2=68.905 //y2=0.175
r2186 (  164 173 ) resistor r=0.100482 //w=0.311 //l=0.25 //layer=m1 \
 //thickness=0.36 //x=68.82 //y=0.175 //x2=68.57 //y2=0.175
r2187 (  163 303 ) resistor r=0.0942778 //w=0.221 //l=0.13 //layer=m1 \
 //thickness=0.36 //x=64.095 //y=1.015 //x2=64.095 //y2=1.145
r2188 (  162 305 ) resistor r=0.0413265 //w=0.7 //l=0.175 //layer=m1 \
 //thickness=0.36 //x=64.095 //y=0.35 //x2=64.095 //y2=0.175
r2189 (  162 163 ) resistor r=0.634542 //w=0.131 //l=0.665 //layer=m1 \
 //thickness=0.36 //x=64.095 //y=0.35 //x2=64.095 //y2=1.015
r2190 (  161 558 ) resistor r=3.1 //w=0.17 //l=0.51 //layer=mcon //count=3 \
 //x=63.76 //y=0.18 //x2=63.76 //y2=0.18
r2191 (  159 547 ) resistor r=3.1 //w=0.17 //l=0.51 //layer=mcon //count=3 \
 //x=62.28 //y=0.18 //x2=62.28 //y2=0.18
r2192 (  159 161 ) resistor r=0.594855 //w=0.311 //l=1.48 //layer=m1 \
 //thickness=0.36 //x=62.28 //y=0.175 //x2=63.76 //y2=0.175
r2193 (  157 545 ) resistor r=3.1 //w=0.17 //l=0.51 //layer=mcon //count=3 \
 //x=61.17 //y=0.18 //x2=61.17 //y2=0.18
r2194 (  157 159 ) resistor r=0.446141 //w=0.311 //l=1.11 //layer=m1 \
 //thickness=0.36 //x=61.17 //y=0.175 //x2=62.28 //y2=0.175
r2195 (  155 543 ) resistor r=3.1 //w=0.17 //l=0.51 //layer=mcon //count=3 \
 //x=60.06 //y=0.18 //x2=60.06 //y2=0.18
r2196 (  155 157 ) resistor r=0.446141 //w=0.311 //l=1.11 //layer=m1 \
 //thickness=0.36 //x=60.06 //y=0.175 //x2=61.17 //y2=0.175
r2197 (  153 301 ) resistor r=0.028033 //w=0.35 //l=0.085 //layer=m1 \
 //thickness=0.36 //x=59.37 //y=0.175 //x2=59.285 //y2=0.175
r2198 (  153 155 ) resistor r=0.277331 //w=0.311 //l=0.69 //layer=m1 \
 //thickness=0.36 //x=59.37 //y=0.175 //x2=60.06 //y2=0.175
r2199 (  152 305 ) resistor r=0.028033 //w=0.35 //l=0.085 //layer=m1 \
 //thickness=0.36 //x=64.01 //y=0.175 //x2=64.095 //y2=0.175
r2200 (  152 161 ) resistor r=0.100482 //w=0.311 //l=0.25 //layer=m1 \
 //thickness=0.36 //x=64.01 //y=0.175 //x2=63.76 //y2=0.175
r2201 (  151 299 ) resistor r=0.0942778 //w=0.221 //l=0.13 //layer=m1 \
 //thickness=0.36 //x=59.285 //y=1.015 //x2=59.285 //y2=1.145
r2202 (  150 301 ) resistor r=0.0413265 //w=0.7 //l=0.175 //layer=m1 \
 //thickness=0.36 //x=59.285 //y=0.35 //x2=59.285 //y2=0.175
r2203 (  150 151 ) resistor r=0.634542 //w=0.131 //l=0.665 //layer=m1 \
 //thickness=0.36 //x=59.285 //y=0.35 //x2=59.285 //y2=1.015
r2204 (  149 541 ) resistor r=3.1 //w=0.17 //l=0.51 //layer=mcon //count=3 \
 //x=58.95 //y=0.18 //x2=58.95 //y2=0.18
r2205 (  147 530 ) resistor r=3.1 //w=0.17 //l=0.51 //layer=mcon //count=3 \
 //x=57.47 //y=0.18 //x2=57.47 //y2=0.18
r2206 (  147 149 ) resistor r=0.594855 //w=0.311 //l=1.48 //layer=m1 \
 //thickness=0.36 //x=57.47 //y=0.175 //x2=58.95 //y2=0.175
r2207 (  145 528 ) resistor r=3.1 //w=0.17 //l=0.51 //layer=mcon //count=3 \
 //x=56.36 //y=0.18 //x2=56.36 //y2=0.18
r2208 (  145 147 ) resistor r=0.446141 //w=0.311 //l=1.11 //layer=m1 \
 //thickness=0.36 //x=56.36 //y=0.175 //x2=57.47 //y2=0.175
r2209 (  143 526 ) resistor r=3.1 //w=0.17 //l=0.51 //layer=mcon //count=3 \
 //x=55.25 //y=0.18 //x2=55.25 //y2=0.18
r2210 (  143 145 ) resistor r=0.446141 //w=0.311 //l=1.11 //layer=m1 \
 //thickness=0.36 //x=55.25 //y=0.175 //x2=56.36 //y2=0.175
r2211 (  141 297 ) resistor r=0.028033 //w=0.35 //l=0.085 //layer=m1 \
 //thickness=0.36 //x=54.56 //y=0.175 //x2=54.475 //y2=0.175
r2212 (  141 143 ) resistor r=0.277331 //w=0.311 //l=0.69 //layer=m1 \
 //thickness=0.36 //x=54.56 //y=0.175 //x2=55.25 //y2=0.175
r2213 (  140 301 ) resistor r=0.028033 //w=0.35 //l=0.085 //layer=m1 \
 //thickness=0.36 //x=59.2 //y=0.175 //x2=59.285 //y2=0.175
r2214 (  140 149 ) resistor r=0.100482 //w=0.311 //l=0.25 //layer=m1 \
 //thickness=0.36 //x=59.2 //y=0.175 //x2=58.95 //y2=0.175
r2215 (  139 295 ) resistor r=0.0942778 //w=0.221 //l=0.13 //layer=m1 \
 //thickness=0.36 //x=54.475 //y=1.015 //x2=54.475 //y2=1.145
r2216 (  138 297 ) resistor r=0.0413265 //w=0.7 //l=0.175 //layer=m1 \
 //thickness=0.36 //x=54.475 //y=0.35 //x2=54.475 //y2=0.175
r2217 (  138 139 ) resistor r=0.634542 //w=0.131 //l=0.665 //layer=m1 \
 //thickness=0.36 //x=54.475 //y=0.35 //x2=54.475 //y2=1.015
r2218 (  137 524 ) resistor r=3.1 //w=0.17 //l=0.51 //layer=mcon //count=3 \
 //x=54.14 //y=0.18 //x2=54.14 //y2=0.18
r2219 (  135 513 ) resistor r=3.1 //w=0.17 //l=0.51 //layer=mcon //count=3 \
 //x=52.66 //y=0.18 //x2=52.66 //y2=0.18
r2220 (  135 137 ) resistor r=0.594855 //w=0.311 //l=1.48 //layer=m1 \
 //thickness=0.36 //x=52.66 //y=0.175 //x2=54.14 //y2=0.175
r2221 (  133 511 ) resistor r=3.1 //w=0.17 //l=0.51 //layer=mcon //count=3 \
 //x=51.55 //y=0.18 //x2=51.55 //y2=0.18
r2222 (  133 135 ) resistor r=0.446141 //w=0.311 //l=1.11 //layer=m1 \
 //thickness=0.36 //x=51.55 //y=0.175 //x2=52.66 //y2=0.175
r2223 (  131 509 ) resistor r=3.1 //w=0.17 //l=0.51 //layer=mcon //count=3 \
 //x=50.44 //y=0.18 //x2=50.44 //y2=0.18
r2224 (  131 133 ) resistor r=0.446141 //w=0.311 //l=1.11 //layer=m1 \
 //thickness=0.36 //x=50.44 //y=0.175 //x2=51.55 //y2=0.175
r2225 (  128 293 ) resistor r=0.028033 //w=0.35 //l=0.085 //layer=m1 \
 //thickness=0.36 //x=49.75 //y=0.175 //x2=49.665 //y2=0.175
r2226 (  127 297 ) resistor r=0.028033 //w=0.35 //l=0.085 //layer=m1 \
 //thickness=0.36 //x=54.39 //y=0.175 //x2=54.475 //y2=0.175
r2227 (  127 137 ) resistor r=0.100482 //w=0.311 //l=0.25 //layer=m1 \
 //thickness=0.36 //x=54.39 //y=0.175 //x2=54.14 //y2=0.175
r2228 (  126 291 ) resistor r=0.0942778 //w=0.221 //l=0.13 //layer=m1 \
 //thickness=0.36 //x=49.665 //y=1.015 //x2=49.665 //y2=1.145
r2229 (  125 293 ) resistor r=0.0413265 //w=0.7 //l=0.175 //layer=m1 \
 //thickness=0.36 //x=49.665 //y=0.35 //x2=49.665 //y2=0.175
r2230 (  125 126 ) resistor r=0.634542 //w=0.131 //l=0.665 //layer=m1 \
 //thickness=0.36 //x=49.665 //y=0.35 //x2=49.665 //y2=1.015
r2231 (  124 507 ) resistor r=3.1 //w=0.17 //l=0.51 //layer=mcon //count=3 \
 //x=49.33 //y=0.18 //x2=49.33 //y2=0.18
r2232 (  122 496 ) resistor r=3.1 //w=0.17 //l=0.51 //layer=mcon //count=3 \
 //x=47.85 //y=0.18 //x2=47.85 //y2=0.18
r2233 (  122 124 ) resistor r=0.594855 //w=0.311 //l=1.48 //layer=m1 \
 //thickness=0.36 //x=47.85 //y=0.175 //x2=49.33 //y2=0.175
r2234 (  120 494 ) resistor r=3.1 //w=0.17 //l=0.51 //layer=mcon //count=3 \
 //x=46.74 //y=0.18 //x2=46.74 //y2=0.18
r2235 (  120 122 ) resistor r=0.446141 //w=0.311 //l=1.11 //layer=m1 \
 //thickness=0.36 //x=46.74 //y=0.175 //x2=47.85 //y2=0.175
r2236 (  118 492 ) resistor r=3.1 //w=0.17 //l=0.51 //layer=mcon //count=3 \
 //x=45.63 //y=0.18 //x2=45.63 //y2=0.18
r2237 (  118 120 ) resistor r=0.446141 //w=0.311 //l=1.11 //layer=m1 \
 //thickness=0.36 //x=45.63 //y=0.175 //x2=46.74 //y2=0.175
r2238 (  116 289 ) resistor r=0.028033 //w=0.35 //l=0.085 //layer=m1 \
 //thickness=0.36 //x=44.94 //y=0.175 //x2=44.855 //y2=0.175
r2239 (  116 118 ) resistor r=0.277331 //w=0.311 //l=0.69 //layer=m1 \
 //thickness=0.36 //x=44.94 //y=0.175 //x2=45.63 //y2=0.175
r2240 (  115 293 ) resistor r=0.028033 //w=0.35 //l=0.085 //layer=m1 \
 //thickness=0.36 //x=49.58 //y=0.175 //x2=49.665 //y2=0.175
r2241 (  115 124 ) resistor r=0.100482 //w=0.311 //l=0.25 //layer=m1 \
 //thickness=0.36 //x=49.58 //y=0.175 //x2=49.33 //y2=0.175
r2242 (  114 287 ) resistor r=0.0942778 //w=0.221 //l=0.13 //layer=m1 \
 //thickness=0.36 //x=44.855 //y=1.015 //x2=44.855 //y2=1.145
r2243 (  113 289 ) resistor r=0.0413265 //w=0.7 //l=0.175 //layer=m1 \
 //thickness=0.36 //x=44.855 //y=0.35 //x2=44.855 //y2=0.175
r2244 (  113 114 ) resistor r=0.634542 //w=0.131 //l=0.665 //layer=m1 \
 //thickness=0.36 //x=44.855 //y=0.35 //x2=44.855 //y2=1.015
r2245 (  112 490 ) resistor r=3.1 //w=0.17 //l=0.51 //layer=mcon //count=3 \
 //x=44.52 //y=0.18 //x2=44.52 //y2=0.18
r2246 (  110 479 ) resistor r=3.1 //w=0.17 //l=0.51 //layer=mcon //count=3 \
 //x=43.04 //y=0.18 //x2=43.04 //y2=0.18
r2247 (  110 112 ) resistor r=0.594855 //w=0.311 //l=1.48 //layer=m1 \
 //thickness=0.36 //x=43.04 //y=0.175 //x2=44.52 //y2=0.175
r2248 (  108 477 ) resistor r=3.1 //w=0.17 //l=0.51 //layer=mcon //count=3 \
 //x=41.93 //y=0.18 //x2=41.93 //y2=0.18
r2249 (  108 110 ) resistor r=0.446141 //w=0.311 //l=1.11 //layer=m1 \
 //thickness=0.36 //x=41.93 //y=0.175 //x2=43.04 //y2=0.175
r2250 (  106 475 ) resistor r=3.1 //w=0.17 //l=0.51 //layer=mcon //count=3 \
 //x=40.82 //y=0.18 //x2=40.82 //y2=0.18
r2251 (  106 108 ) resistor r=0.446141 //w=0.311 //l=1.11 //layer=m1 \
 //thickness=0.36 //x=40.82 //y=0.175 //x2=41.93 //y2=0.175
r2252 (  104 285 ) resistor r=0.028033 //w=0.35 //l=0.085 //layer=m1 \
 //thickness=0.36 //x=40.13 //y=0.175 //x2=40.045 //y2=0.175
r2253 (  104 106 ) resistor r=0.277331 //w=0.311 //l=0.69 //layer=m1 \
 //thickness=0.36 //x=40.13 //y=0.175 //x2=40.82 //y2=0.175
r2254 (  103 289 ) resistor r=0.028033 //w=0.35 //l=0.085 //layer=m1 \
 //thickness=0.36 //x=44.77 //y=0.175 //x2=44.855 //y2=0.175
r2255 (  103 112 ) resistor r=0.100482 //w=0.311 //l=0.25 //layer=m1 \
 //thickness=0.36 //x=44.77 //y=0.175 //x2=44.52 //y2=0.175
r2256 (  102 283 ) resistor r=0.0942778 //w=0.221 //l=0.13 //layer=m1 \
 //thickness=0.36 //x=40.045 //y=1.015 //x2=40.045 //y2=1.145
r2257 (  101 285 ) resistor r=0.0413265 //w=0.7 //l=0.175 //layer=m1 \
 //thickness=0.36 //x=40.045 //y=0.35 //x2=40.045 //y2=0.175
r2258 (  101 102 ) resistor r=0.634542 //w=0.131 //l=0.665 //layer=m1 \
 //thickness=0.36 //x=40.045 //y=0.35 //x2=40.045 //y2=1.015
r2259 (  100 473 ) resistor r=3.1 //w=0.17 //l=0.51 //layer=mcon //count=3 \
 //x=39.71 //y=0.18 //x2=39.71 //y2=0.18
r2260 (  98 462 ) resistor r=3.1 //w=0.17 //l=0.51 //layer=mcon //count=3 \
 //x=38.23 //y=0.18 //x2=38.23 //y2=0.18
r2261 (  98 100 ) resistor r=0.594855 //w=0.311 //l=1.48 //layer=m1 \
 //thickness=0.36 //x=38.23 //y=0.175 //x2=39.71 //y2=0.175
r2262 (  96 460 ) resistor r=3.1 //w=0.17 //l=0.51 //layer=mcon //count=3 \
 //x=37.12 //y=0.18 //x2=37.12 //y2=0.18
r2263 (  96 98 ) resistor r=0.446141 //w=0.311 //l=1.11 //layer=m1 \
 //thickness=0.36 //x=37.12 //y=0.175 //x2=38.23 //y2=0.175
r2264 (  94 458 ) resistor r=3.1 //w=0.17 //l=0.51 //layer=mcon //count=3 \
 //x=36.01 //y=0.18 //x2=36.01 //y2=0.18
r2265 (  94 96 ) resistor r=0.446141 //w=0.311 //l=1.11 //layer=m1 \
 //thickness=0.36 //x=36.01 //y=0.175 //x2=37.12 //y2=0.175
r2266 (  92 281 ) resistor r=0.028033 //w=0.35 //l=0.085 //layer=m1 \
 //thickness=0.36 //x=35.32 //y=0.175 //x2=35.235 //y2=0.175
r2267 (  92 94 ) resistor r=0.277331 //w=0.311 //l=0.69 //layer=m1 \
 //thickness=0.36 //x=35.32 //y=0.175 //x2=36.01 //y2=0.175
r2268 (  91 285 ) resistor r=0.028033 //w=0.35 //l=0.085 //layer=m1 \
 //thickness=0.36 //x=39.96 //y=0.175 //x2=40.045 //y2=0.175
r2269 (  91 100 ) resistor r=0.100482 //w=0.311 //l=0.25 //layer=m1 \
 //thickness=0.36 //x=39.96 //y=0.175 //x2=39.71 //y2=0.175
r2270 (  90 279 ) resistor r=0.0942778 //w=0.221 //l=0.13 //layer=m1 \
 //thickness=0.36 //x=35.235 //y=1.015 //x2=35.235 //y2=1.145
r2271 (  89 281 ) resistor r=0.0413265 //w=0.7 //l=0.175 //layer=m1 \
 //thickness=0.36 //x=35.235 //y=0.35 //x2=35.235 //y2=0.175
r2272 (  89 90 ) resistor r=0.634542 //w=0.131 //l=0.665 //layer=m1 \
 //thickness=0.36 //x=35.235 //y=0.35 //x2=35.235 //y2=1.015
r2273 (  88 456 ) resistor r=3.1 //w=0.17 //l=0.51 //layer=mcon //count=3 \
 //x=34.9 //y=0.18 //x2=34.9 //y2=0.18
r2274 (  86 445 ) resistor r=3.1 //w=0.17 //l=0.51 //layer=mcon //count=3 \
 //x=33.42 //y=0.18 //x2=33.42 //y2=0.18
r2275 (  86 88 ) resistor r=0.594855 //w=0.311 //l=1.48 //layer=m1 \
 //thickness=0.36 //x=33.42 //y=0.175 //x2=34.9 //y2=0.175
r2276 (  84 443 ) resistor r=3.1 //w=0.17 //l=0.51 //layer=mcon //count=3 \
 //x=32.31 //y=0.18 //x2=32.31 //y2=0.18
r2277 (  84 86 ) resistor r=0.446141 //w=0.311 //l=1.11 //layer=m1 \
 //thickness=0.36 //x=32.31 //y=0.175 //x2=33.42 //y2=0.175
r2278 (  82 441 ) resistor r=3.1 //w=0.17 //l=0.51 //layer=mcon //count=3 \
 //x=31.2 //y=0.18 //x2=31.2 //y2=0.18
r2279 (  82 84 ) resistor r=0.446141 //w=0.311 //l=1.11 //layer=m1 \
 //thickness=0.36 //x=31.2 //y=0.175 //x2=32.31 //y2=0.175
r2280 (  80 277 ) resistor r=0.028033 //w=0.35 //l=0.085 //layer=m1 \
 //thickness=0.36 //x=30.51 //y=0.175 //x2=30.425 //y2=0.175
r2281 (  80 82 ) resistor r=0.277331 //w=0.311 //l=0.69 //layer=m1 \
 //thickness=0.36 //x=30.51 //y=0.175 //x2=31.2 //y2=0.175
r2282 (  79 281 ) resistor r=0.028033 //w=0.35 //l=0.085 //layer=m1 \
 //thickness=0.36 //x=35.15 //y=0.175 //x2=35.235 //y2=0.175
r2283 (  79 88 ) resistor r=0.100482 //w=0.311 //l=0.25 //layer=m1 \
 //thickness=0.36 //x=35.15 //y=0.175 //x2=34.9 //y2=0.175
r2284 (  78 275 ) resistor r=0.0942778 //w=0.221 //l=0.13 //layer=m1 \
 //thickness=0.36 //x=30.425 //y=1.015 //x2=30.425 //y2=1.145
r2285 (  77 277 ) resistor r=0.0413265 //w=0.7 //l=0.175 //layer=m1 \
 //thickness=0.36 //x=30.425 //y=0.35 //x2=30.425 //y2=0.175
r2286 (  77 78 ) resistor r=0.634542 //w=0.131 //l=0.665 //layer=m1 \
 //thickness=0.36 //x=30.425 //y=0.35 //x2=30.425 //y2=1.015
r2287 (  76 439 ) resistor r=3.1 //w=0.17 //l=0.51 //layer=mcon //count=3 \
 //x=30.09 //y=0.18 //x2=30.09 //y2=0.18
r2288 (  74 428 ) resistor r=3.1 //w=0.17 //l=0.51 //layer=mcon //count=3 \
 //x=28.61 //y=0.18 //x2=28.61 //y2=0.18
r2289 (  74 76 ) resistor r=0.594855 //w=0.311 //l=1.48 //layer=m1 \
 //thickness=0.36 //x=28.61 //y=0.175 //x2=30.09 //y2=0.175
r2290 (  72 426 ) resistor r=3.1 //w=0.17 //l=0.51 //layer=mcon //count=3 \
 //x=27.5 //y=0.18 //x2=27.5 //y2=0.18
r2291 (  72 74 ) resistor r=0.446141 //w=0.311 //l=1.11 //layer=m1 \
 //thickness=0.36 //x=27.5 //y=0.175 //x2=28.61 //y2=0.175
r2292 (  70 424 ) resistor r=3.1 //w=0.17 //l=0.51 //layer=mcon //count=3 \
 //x=26.39 //y=0.18 //x2=26.39 //y2=0.18
r2293 (  70 72 ) resistor r=0.446141 //w=0.311 //l=1.11 //layer=m1 \
 //thickness=0.36 //x=26.39 //y=0.175 //x2=27.5 //y2=0.175
r2294 (  68 273 ) resistor r=0.028033 //w=0.35 //l=0.085 //layer=m1 \
 //thickness=0.36 //x=25.7 //y=0.175 //x2=25.615 //y2=0.175
r2295 (  68 70 ) resistor r=0.277331 //w=0.311 //l=0.69 //layer=m1 \
 //thickness=0.36 //x=25.7 //y=0.175 //x2=26.39 //y2=0.175
r2296 (  67 277 ) resistor r=0.028033 //w=0.35 //l=0.085 //layer=m1 \
 //thickness=0.36 //x=30.34 //y=0.175 //x2=30.425 //y2=0.175
r2297 (  67 76 ) resistor r=0.100482 //w=0.311 //l=0.25 //layer=m1 \
 //thickness=0.36 //x=30.34 //y=0.175 //x2=30.09 //y2=0.175
r2298 (  66 271 ) resistor r=0.0942778 //w=0.221 //l=0.13 //layer=m1 \
 //thickness=0.36 //x=25.615 //y=1.015 //x2=25.615 //y2=1.145
r2299 (  65 273 ) resistor r=0.0413265 //w=0.7 //l=0.175 //layer=m1 \
 //thickness=0.36 //x=25.615 //y=0.35 //x2=25.615 //y2=0.175
r2300 (  65 66 ) resistor r=0.634542 //w=0.131 //l=0.665 //layer=m1 \
 //thickness=0.36 //x=25.615 //y=0.35 //x2=25.615 //y2=1.015
r2301 (  64 422 ) resistor r=3.1 //w=0.17 //l=0.51 //layer=mcon //count=3 \
 //x=25.28 //y=0.18 //x2=25.28 //y2=0.18
r2302 (  62 411 ) resistor r=3.1 //w=0.17 //l=0.51 //layer=mcon //count=3 \
 //x=23.8 //y=0.18 //x2=23.8 //y2=0.18
r2303 (  62 64 ) resistor r=0.594855 //w=0.311 //l=1.48 //layer=m1 \
 //thickness=0.36 //x=23.8 //y=0.175 //x2=25.28 //y2=0.175
r2304 (  60 409 ) resistor r=3.1 //w=0.17 //l=0.51 //layer=mcon //count=3 \
 //x=22.69 //y=0.18 //x2=22.69 //y2=0.18
r2305 (  60 62 ) resistor r=0.446141 //w=0.311 //l=1.11 //layer=m1 \
 //thickness=0.36 //x=22.69 //y=0.175 //x2=23.8 //y2=0.175
r2306 (  58 407 ) resistor r=3.1 //w=0.17 //l=0.51 //layer=mcon //count=3 \
 //x=21.58 //y=0.18 //x2=21.58 //y2=0.18
r2307 (  58 60 ) resistor r=0.446141 //w=0.311 //l=1.11 //layer=m1 \
 //thickness=0.36 //x=21.58 //y=0.175 //x2=22.69 //y2=0.175
r2308 (  56 269 ) resistor r=0.028033 //w=0.35 //l=0.085 //layer=m1 \
 //thickness=0.36 //x=20.89 //y=0.175 //x2=20.805 //y2=0.175
r2309 (  56 58 ) resistor r=0.277331 //w=0.311 //l=0.69 //layer=m1 \
 //thickness=0.36 //x=20.89 //y=0.175 //x2=21.58 //y2=0.175
r2310 (  55 273 ) resistor r=0.028033 //w=0.35 //l=0.085 //layer=m1 \
 //thickness=0.36 //x=25.53 //y=0.175 //x2=25.615 //y2=0.175
r2311 (  55 64 ) resistor r=0.100482 //w=0.311 //l=0.25 //layer=m1 \
 //thickness=0.36 //x=25.53 //y=0.175 //x2=25.28 //y2=0.175
r2312 (  54 267 ) resistor r=0.0942778 //w=0.221 //l=0.13 //layer=m1 \
 //thickness=0.36 //x=20.805 //y=1.015 //x2=20.805 //y2=1.145
r2313 (  53 269 ) resistor r=0.0413265 //w=0.7 //l=0.175 //layer=m1 \
 //thickness=0.36 //x=20.805 //y=0.35 //x2=20.805 //y2=0.175
r2314 (  53 54 ) resistor r=0.634542 //w=0.131 //l=0.665 //layer=m1 \
 //thickness=0.36 //x=20.805 //y=0.35 //x2=20.805 //y2=1.015
r2315 (  52 405 ) resistor r=3.1 //w=0.17 //l=0.51 //layer=mcon //count=3 \
 //x=20.47 //y=0.18 //x2=20.47 //y2=0.18
r2316 (  50 394 ) resistor r=3.1 //w=0.17 //l=0.51 //layer=mcon //count=3 \
 //x=18.99 //y=0.18 //x2=18.99 //y2=0.18
r2317 (  50 52 ) resistor r=0.594855 //w=0.311 //l=1.48 //layer=m1 \
 //thickness=0.36 //x=18.99 //y=0.175 //x2=20.47 //y2=0.175
r2318 (  48 392 ) resistor r=3.1 //w=0.17 //l=0.51 //layer=mcon //count=3 \
 //x=17.88 //y=0.18 //x2=17.88 //y2=0.18
r2319 (  48 50 ) resistor r=0.446141 //w=0.311 //l=1.11 //layer=m1 \
 //thickness=0.36 //x=17.88 //y=0.175 //x2=18.99 //y2=0.175
r2320 (  46 390 ) resistor r=3.1 //w=0.17 //l=0.51 //layer=mcon //count=3 \
 //x=16.77 //y=0.18 //x2=16.77 //y2=0.18
r2321 (  46 48 ) resistor r=0.446141 //w=0.311 //l=1.11 //layer=m1 \
 //thickness=0.36 //x=16.77 //y=0.175 //x2=17.88 //y2=0.175
r2322 (  44 265 ) resistor r=0.028033 //w=0.35 //l=0.085 //layer=m1 \
 //thickness=0.36 //x=16.08 //y=0.175 //x2=15.995 //y2=0.175
r2323 (  44 46 ) resistor r=0.277331 //w=0.311 //l=0.69 //layer=m1 \
 //thickness=0.36 //x=16.08 //y=0.175 //x2=16.77 //y2=0.175
r2324 (  43 269 ) resistor r=0.028033 //w=0.35 //l=0.085 //layer=m1 \
 //thickness=0.36 //x=20.72 //y=0.175 //x2=20.805 //y2=0.175
r2325 (  43 52 ) resistor r=0.100482 //w=0.311 //l=0.25 //layer=m1 \
 //thickness=0.36 //x=20.72 //y=0.175 //x2=20.47 //y2=0.175
r2326 (  42 263 ) resistor r=0.0942778 //w=0.221 //l=0.13 //layer=m1 \
 //thickness=0.36 //x=15.995 //y=1.015 //x2=15.995 //y2=1.145
r2327 (  41 265 ) resistor r=0.0413265 //w=0.7 //l=0.175 //layer=m1 \
 //thickness=0.36 //x=15.995 //y=0.35 //x2=15.995 //y2=0.175
r2328 (  41 42 ) resistor r=0.634542 //w=0.131 //l=0.665 //layer=m1 \
 //thickness=0.36 //x=15.995 //y=0.35 //x2=15.995 //y2=1.015
r2329 (  40 388 ) resistor r=3.1 //w=0.17 //l=0.51 //layer=mcon //count=3 \
 //x=15.66 //y=0.18 //x2=15.66 //y2=0.18
r2330 (  38 377 ) resistor r=3.1 //w=0.17 //l=0.51 //layer=mcon //count=3 \
 //x=14.18 //y=0.18 //x2=14.18 //y2=0.18
r2331 (  38 40 ) resistor r=0.594855 //w=0.311 //l=1.48 //layer=m1 \
 //thickness=0.36 //x=14.18 //y=0.175 //x2=15.66 //y2=0.175
r2332 (  36 375 ) resistor r=3.1 //w=0.17 //l=0.51 //layer=mcon //count=3 \
 //x=13.07 //y=0.18 //x2=13.07 //y2=0.18
r2333 (  36 38 ) resistor r=0.446141 //w=0.311 //l=1.11 //layer=m1 \
 //thickness=0.36 //x=13.07 //y=0.175 //x2=14.18 //y2=0.175
r2334 (  34 373 ) resistor r=3.1 //w=0.17 //l=0.51 //layer=mcon //count=3 \
 //x=11.96 //y=0.18 //x2=11.96 //y2=0.18
r2335 (  34 36 ) resistor r=0.446141 //w=0.311 //l=1.11 //layer=m1 \
 //thickness=0.36 //x=11.96 //y=0.175 //x2=13.07 //y2=0.175
r2336 (  32 261 ) resistor r=0.028033 //w=0.35 //l=0.085 //layer=m1 \
 //thickness=0.36 //x=11.27 //y=0.175 //x2=11.185 //y2=0.175
r2337 (  32 34 ) resistor r=0.277331 //w=0.311 //l=0.69 //layer=m1 \
 //thickness=0.36 //x=11.27 //y=0.175 //x2=11.96 //y2=0.175
r2338 (  31 265 ) resistor r=0.028033 //w=0.35 //l=0.085 //layer=m1 \
 //thickness=0.36 //x=15.91 //y=0.175 //x2=15.995 //y2=0.175
r2339 (  31 40 ) resistor r=0.100482 //w=0.311 //l=0.25 //layer=m1 \
 //thickness=0.36 //x=15.91 //y=0.175 //x2=15.66 //y2=0.175
r2340 (  30 259 ) resistor r=0.0942778 //w=0.221 //l=0.13 //layer=m1 \
 //thickness=0.36 //x=11.185 //y=1.015 //x2=11.185 //y2=1.145
r2341 (  29 261 ) resistor r=0.0413265 //w=0.7 //l=0.175 //layer=m1 \
 //thickness=0.36 //x=11.185 //y=0.35 //x2=11.185 //y2=0.175
r2342 (  29 30 ) resistor r=0.634542 //w=0.131 //l=0.665 //layer=m1 \
 //thickness=0.36 //x=11.185 //y=0.35 //x2=11.185 //y2=1.015
r2343 (  28 371 ) resistor r=3.1 //w=0.17 //l=0.51 //layer=mcon //count=3 \
 //x=10.85 //y=0.18 //x2=10.85 //y2=0.18
r2344 (  26 360 ) resistor r=3.1 //w=0.17 //l=0.51 //layer=mcon //count=3 \
 //x=9.37 //y=0.18 //x2=9.37 //y2=0.18
r2345 (  26 28 ) resistor r=0.594855 //w=0.311 //l=1.48 //layer=m1 \
 //thickness=0.36 //x=9.37 //y=0.175 //x2=10.85 //y2=0.175
r2346 (  24 358 ) resistor r=3.1 //w=0.17 //l=0.51 //layer=mcon //count=3 \
 //x=8.26 //y=0.18 //x2=8.26 //y2=0.18
r2347 (  24 26 ) resistor r=0.446141 //w=0.311 //l=1.11 //layer=m1 \
 //thickness=0.36 //x=8.26 //y=0.175 //x2=9.37 //y2=0.175
r2348 (  22 356 ) resistor r=3.1 //w=0.17 //l=0.51 //layer=mcon //count=3 \
 //x=7.15 //y=0.18 //x2=7.15 //y2=0.18
r2349 (  22 24 ) resistor r=0.446141 //w=0.311 //l=1.11 //layer=m1 \
 //thickness=0.36 //x=7.15 //y=0.175 //x2=8.26 //y2=0.175
r2350 (  20 257 ) resistor r=0.028033 //w=0.35 //l=0.085 //layer=m1 \
 //thickness=0.36 //x=6.46 //y=0.175 //x2=6.375 //y2=0.175
r2351 (  20 22 ) resistor r=0.277331 //w=0.311 //l=0.69 //layer=m1 \
 //thickness=0.36 //x=6.46 //y=0.175 //x2=7.15 //y2=0.175
r2352 (  19 261 ) resistor r=0.028033 //w=0.35 //l=0.085 //layer=m1 \
 //thickness=0.36 //x=11.1 //y=0.175 //x2=11.185 //y2=0.175
r2353 (  19 28 ) resistor r=0.100482 //w=0.311 //l=0.25 //layer=m1 \
 //thickness=0.36 //x=11.1 //y=0.175 //x2=10.85 //y2=0.175
r2354 (  18 255 ) resistor r=0.0942778 //w=0.221 //l=0.13 //layer=m1 \
 //thickness=0.36 //x=6.375 //y=1.015 //x2=6.375 //y2=1.145
r2355 (  17 257 ) resistor r=0.0413265 //w=0.7 //l=0.175 //layer=m1 \
 //thickness=0.36 //x=6.375 //y=0.35 //x2=6.375 //y2=0.175
r2356 (  17 18 ) resistor r=0.634542 //w=0.131 //l=0.665 //layer=m1 \
 //thickness=0.36 //x=6.375 //y=0.35 //x2=6.375 //y2=1.015
r2357 (  16 354 ) resistor r=3.1 //w=0.17 //l=0.51 //layer=mcon //count=3 \
 //x=6.04 //y=0.18 //x2=6.04 //y2=0.18
r2358 (  14 343 ) resistor r=3.1 //w=0.17 //l=0.51 //layer=mcon //count=3 \
 //x=4.56 //y=0.18 //x2=4.56 //y2=0.18
r2359 (  14 16 ) resistor r=0.594855 //w=0.311 //l=1.48 //layer=m1 \
 //thickness=0.36 //x=4.56 //y=0.175 //x2=6.04 //y2=0.175
r2360 (  12 341 ) resistor r=3.1 //w=0.17 //l=0.51 //layer=mcon //count=3 \
 //x=3.45 //y=0.18 //x2=3.45 //y2=0.18
r2361 (  12 14 ) resistor r=0.446141 //w=0.311 //l=1.11 //layer=m1 \
 //thickness=0.36 //x=3.45 //y=0.175 //x2=4.56 //y2=0.175
r2362 (  10 339 ) resistor r=3.1 //w=0.17 //l=0.51 //layer=mcon //count=3 \
 //x=2.34 //y=0.18 //x2=2.34 //y2=0.18
r2363 (  10 12 ) resistor r=0.446141 //w=0.311 //l=1.11 //layer=m1 \
 //thickness=0.36 //x=2.34 //y=0.175 //x2=3.45 //y2=0.175
r2364 (  8 253 ) resistor r=0.028033 //w=0.35 //l=0.085 //layer=m1 \
 //thickness=0.36 //x=1.65 //y=0.175 //x2=1.565 //y2=0.175
r2365 (  8 10 ) resistor r=0.277331 //w=0.311 //l=0.69 //layer=m1 \
 //thickness=0.36 //x=1.65 //y=0.175 //x2=2.34 //y2=0.175
r2366 (  7 257 ) resistor r=0.028033 //w=0.35 //l=0.085 //layer=m1 \
 //thickness=0.36 //x=6.29 //y=0.175 //x2=6.375 //y2=0.175
r2367 (  7 16 ) resistor r=0.100482 //w=0.311 //l=0.25 //layer=m1 \
 //thickness=0.36 //x=6.29 //y=0.175 //x2=6.04 //y2=0.175
r2368 (  6 251 ) resistor r=0.0942778 //w=0.221 //l=0.13 //layer=m1 \
 //thickness=0.36 //x=1.565 //y=1.015 //x2=1.565 //y2=1.145
r2369 (  5 253 ) resistor r=0.0413265 //w=0.7 //l=0.175 //layer=m1 \
 //thickness=0.36 //x=1.565 //y=0.35 //x2=1.565 //y2=0.175
r2370 (  5 6 ) resistor r=0.634542 //w=0.131 //l=0.665 //layer=m1 \
 //thickness=0.36 //x=1.565 //y=0.35 //x2=1.565 //y2=1.015
r2371 (  4 337 ) resistor r=3.1 //w=0.17 //l=0.51 //layer=mcon //count=3 \
 //x=1.23 //y=0.18 //x2=1.23 //y2=0.18
r2372 (  2 253 ) resistor r=0.028033 //w=0.35 //l=0.085 //layer=m1 \
 //thickness=0.36 //x=1.48 //y=0.175 //x2=1.565 //y2=0.175
r2373 (  2 4 ) resistor r=0.0892857 //w=0.35 //l=0.25 //layer=m1 \
 //thickness=0.36 //x=1.48 //y=0.175 //x2=1.23 //y2=0.175
r2374 (  1 131 ) resistor r=0.223071 //w=0.311 //l=0.555 //layer=m1 \
 //thickness=0.36 //x=49.885 //y=0.175 //x2=50.44 //y2=0.175
r2375 (  1 128 ) resistor r=0.0542605 //w=0.311 //l=0.135 //layer=m1 \
 //thickness=0.36 //x=49.885 //y=0.175 //x2=49.75 //y2=0.175
ends PM_TMRDFFSNRNQX1\%GND

subckt PM_TMRDFFSNRNQX1\%noxref_48 ( 1 5 9 13 17 35 )
c55 ( 35 0 ) capacitor c=0.0709164f //x=0.945 //y=0.555
c56 ( 17 0 ) capacitor c=0.0214613f //x=2.935 //y=1.77
c57 ( 13 0 ) capacitor c=0.0153216f //x=2.935 //y=0.72
c58 ( 9 0 ) capacitor c=0.00772076f //x=2.05 //y=0.805
c59 ( 5 0 ) capacitor c=0.0197381f //x=1.965 //y=1.77
c60 ( 1 0 ) capacitor c=0.0109947f //x=1.08 //y=1.685
r61 (  18 35 ) resistor r=5.4201 //w=0.17 //l=0.103078 //layer=li \
 //thickness=0.1 //x=2.135 //y=1.77 //x2=2.05 //y2=1.81
r62 (  18 35 ) resistor r=27.3797 //w=0.187 //l=0.4 //layer=li //thickness=0.1 \
 //x=2.135 //y=1.77 //x2=2.535 //y2=1.77
r63 (  17 35 ) resistor r=0.751729 //w=0.17 //l=0.085 //layer=li \
 //thickness=0.1 //x=2.935 //y=1.77 //x2=3.02 //y2=1.77
r64 (  17 35 ) resistor r=27.3797 //w=0.187 //l=0.4 //layer=li //thickness=0.1 \
 //x=2.935 //y=1.77 //x2=2.535 //y2=1.77
r65 (  14 35 ) resistor r=3.57586 //w=0.17 //l=0.103078 //layer=li \
 //thickness=0.1 //x=2.135 //y=0.72 //x2=2.05 //y2=0.68
r66 (  14 35 ) resistor r=27.3797 //w=0.187 //l=0.4 //layer=li //thickness=0.1 \
 //x=2.135 //y=0.72 //x2=2.535 //y2=0.72
r67 (  13 35 ) resistor r=0.751729 //w=0.17 //l=0.085 //layer=li \
 //thickness=0.1 //x=2.935 //y=0.72 //x2=3.02 //y2=0.72
r68 (  13 35 ) resistor r=27.3797 //w=0.187 //l=0.4 //layer=li //thickness=0.1 \
 //x=2.935 //y=0.72 //x2=2.535 //y2=0.72
r69 (  10 35 ) resistor r=1.40859 //w=0.34 //l=0.125 //layer=li \
 //thickness=0.1 //x=2.05 //y=1.685 //x2=2.05 //y2=1.81
r70 (  10 35 ) resistor r=42.0963 //w=0.187 //l=0.615 //layer=li \
 //thickness=0.1 //x=2.05 //y=1.685 //x2=2.05 //y2=1.07
r71 (  9 35 ) resistor r=3.57586 //w=0.17 //l=0.125 //layer=li //thickness=0.1 \
 //x=2.05 //y=0.805 //x2=2.05 //y2=0.68
r72 (  9 35 ) resistor r=18.139 //w=0.187 //l=0.265 //layer=li //thickness=0.1 \
 //x=2.05 //y=0.805 //x2=2.05 //y2=1.07
r73 (  6 35 ) resistor r=3.57586 //w=0.17 //l=0.103078 //layer=li \
 //thickness=0.1 //x=1.165 //y=1.77 //x2=1.08 //y2=1.81
r74 (  6 35 ) resistor r=27.3797 //w=0.187 //l=0.4 //layer=li //thickness=0.1 \
 //x=1.165 //y=1.77 //x2=1.565 //y2=1.77
r75 (  5 35 ) resistor r=5.4201 //w=0.17 //l=0.103078 //layer=li \
 //thickness=0.1 //x=1.965 //y=1.77 //x2=2.05 //y2=1.81
r76 (  5 35 ) resistor r=27.3797 //w=0.187 //l=0.4 //layer=li //thickness=0.1 \
 //x=1.965 //y=1.77 //x2=1.565 //y2=1.77
r77 (  1 35 ) resistor r=3.57586 //w=0.17 //l=0.125 //layer=li //thickness=0.1 \
 //x=1.08 //y=1.685 //x2=1.08 //y2=1.81
r78 (  1 35 ) resistor r=42.0963 //w=0.187 //l=0.615 //layer=li \
 //thickness=0.1 //x=1.08 //y=1.685 //x2=1.08 //y2=1.07
ends PM_TMRDFFSNRNQX1\%noxref_48

subckt PM_TMRDFFSNRNQX1\%noxref_49 ( 1 5 9 13 17 35 )
c57 ( 35 0 ) capacitor c=0.0691212f //x=5.755 //y=0.555
c58 ( 17 0 ) capacitor c=0.0190725f //x=7.745 //y=1.77
c59 ( 13 0 ) capacitor c=0.015325f //x=7.745 //y=0.72
c60 ( 9 0 ) capacitor c=0.00772076f //x=6.86 //y=0.805
c61 ( 5 0 ) capacitor c=0.0166941f //x=6.775 //y=1.77
c62 ( 1 0 ) capacitor c=0.00710458f //x=5.89 //y=1.685
r63 (  18 35 ) resistor r=5.4201 //w=0.17 //l=0.103078 //layer=li \
 //thickness=0.1 //x=6.945 //y=1.77 //x2=6.86 //y2=1.81
r64 (  18 35 ) resistor r=27.3797 //w=0.187 //l=0.4 //layer=li //thickness=0.1 \
 //x=6.945 //y=1.77 //x2=7.345 //y2=1.77
r65 (  17 35 ) resistor r=0.751729 //w=0.17 //l=0.085 //layer=li \
 //thickness=0.1 //x=7.745 //y=1.77 //x2=7.83 //y2=1.77
r66 (  17 35 ) resistor r=27.3797 //w=0.187 //l=0.4 //layer=li //thickness=0.1 \
 //x=7.745 //y=1.77 //x2=7.345 //y2=1.77
r67 (  14 35 ) resistor r=3.57586 //w=0.17 //l=0.103078 //layer=li \
 //thickness=0.1 //x=6.945 //y=0.72 //x2=6.86 //y2=0.68
r68 (  14 35 ) resistor r=27.3797 //w=0.187 //l=0.4 //layer=li //thickness=0.1 \
 //x=6.945 //y=0.72 //x2=7.345 //y2=0.72
r69 (  13 35 ) resistor r=0.751729 //w=0.17 //l=0.085 //layer=li \
 //thickness=0.1 //x=7.745 //y=0.72 //x2=7.83 //y2=0.72
r70 (  13 35 ) resistor r=27.3797 //w=0.187 //l=0.4 //layer=li //thickness=0.1 \
 //x=7.745 //y=0.72 //x2=7.345 //y2=0.72
r71 (  10 35 ) resistor r=1.40859 //w=0.34 //l=0.125 //layer=li \
 //thickness=0.1 //x=6.86 //y=1.685 //x2=6.86 //y2=1.81
r72 (  10 35 ) resistor r=42.0963 //w=0.187 //l=0.615 //layer=li \
 //thickness=0.1 //x=6.86 //y=1.685 //x2=6.86 //y2=1.07
r73 (  9 35 ) resistor r=3.57586 //w=0.17 //l=0.125 //layer=li //thickness=0.1 \
 //x=6.86 //y=0.805 //x2=6.86 //y2=0.68
r74 (  9 35 ) resistor r=18.139 //w=0.187 //l=0.265 //layer=li //thickness=0.1 \
 //x=6.86 //y=0.805 //x2=6.86 //y2=1.07
r75 (  6 35 ) resistor r=3.57586 //w=0.17 //l=0.103078 //layer=li \
 //thickness=0.1 //x=5.975 //y=1.77 //x2=5.89 //y2=1.81
r76 (  6 35 ) resistor r=27.3797 //w=0.187 //l=0.4 //layer=li //thickness=0.1 \
 //x=5.975 //y=1.77 //x2=6.375 //y2=1.77
r77 (  5 35 ) resistor r=5.4201 //w=0.17 //l=0.103078 //layer=li \
 //thickness=0.1 //x=6.775 //y=1.77 //x2=6.86 //y2=1.81
r78 (  5 35 ) resistor r=27.3797 //w=0.187 //l=0.4 //layer=li //thickness=0.1 \
 //x=6.775 //y=1.77 //x2=6.375 //y2=1.77
r79 (  1 35 ) resistor r=3.57586 //w=0.17 //l=0.125 //layer=li //thickness=0.1 \
 //x=5.89 //y=1.685 //x2=5.89 //y2=1.81
r80 (  1 35 ) resistor r=42.0963 //w=0.187 //l=0.615 //layer=li \
 //thickness=0.1 //x=5.89 //y=1.685 //x2=5.89 //y2=1.07
ends PM_TMRDFFSNRNQX1\%noxref_49

subckt PM_TMRDFFSNRNQX1\%noxref_50 ( 1 5 9 13 17 35 )
c58 ( 35 0 ) capacitor c=0.0691212f //x=10.565 //y=0.555
c59 ( 17 0 ) capacitor c=0.0190725f //x=12.555 //y=1.77
c60 ( 13 0 ) capacitor c=0.015325f //x=12.555 //y=0.72
c61 ( 9 0 ) capacitor c=0.00772076f //x=11.67 //y=0.805
c62 ( 5 0 ) capacitor c=0.0167789f //x=11.585 //y=1.77
c63 ( 1 0 ) capacitor c=0.00710458f //x=10.7 //y=1.685
r64 (  18 35 ) resistor r=5.4201 //w=0.17 //l=0.103078 //layer=li \
 //thickness=0.1 //x=11.755 //y=1.77 //x2=11.67 //y2=1.81
r65 (  18 35 ) resistor r=27.3797 //w=0.187 //l=0.4 //layer=li //thickness=0.1 \
 //x=11.755 //y=1.77 //x2=12.155 //y2=1.77
r66 (  17 35 ) resistor r=0.751729 //w=0.17 //l=0.085 //layer=li \
 //thickness=0.1 //x=12.555 //y=1.77 //x2=12.64 //y2=1.77
r67 (  17 35 ) resistor r=27.3797 //w=0.187 //l=0.4 //layer=li //thickness=0.1 \
 //x=12.555 //y=1.77 //x2=12.155 //y2=1.77
r68 (  14 35 ) resistor r=3.57586 //w=0.17 //l=0.103078 //layer=li \
 //thickness=0.1 //x=11.755 //y=0.72 //x2=11.67 //y2=0.68
r69 (  14 35 ) resistor r=27.3797 //w=0.187 //l=0.4 //layer=li //thickness=0.1 \
 //x=11.755 //y=0.72 //x2=12.155 //y2=0.72
r70 (  13 35 ) resistor r=0.751729 //w=0.17 //l=0.085 //layer=li \
 //thickness=0.1 //x=12.555 //y=0.72 //x2=12.64 //y2=0.72
r71 (  13 35 ) resistor r=27.3797 //w=0.187 //l=0.4 //layer=li //thickness=0.1 \
 //x=12.555 //y=0.72 //x2=12.155 //y2=0.72
r72 (  10 35 ) resistor r=1.40859 //w=0.34 //l=0.125 //layer=li \
 //thickness=0.1 //x=11.67 //y=1.685 //x2=11.67 //y2=1.81
r73 (  10 35 ) resistor r=42.0963 //w=0.187 //l=0.615 //layer=li \
 //thickness=0.1 //x=11.67 //y=1.685 //x2=11.67 //y2=1.07
r74 (  9 35 ) resistor r=3.57586 //w=0.17 //l=0.125 //layer=li //thickness=0.1 \
 //x=11.67 //y=0.805 //x2=11.67 //y2=0.68
r75 (  9 35 ) resistor r=18.139 //w=0.187 //l=0.265 //layer=li //thickness=0.1 \
 //x=11.67 //y=0.805 //x2=11.67 //y2=1.07
r76 (  6 35 ) resistor r=3.57586 //w=0.17 //l=0.103078 //layer=li \
 //thickness=0.1 //x=10.785 //y=1.77 //x2=10.7 //y2=1.81
r77 (  6 35 ) resistor r=27.3797 //w=0.187 //l=0.4 //layer=li //thickness=0.1 \
 //x=10.785 //y=1.77 //x2=11.185 //y2=1.77
r78 (  5 35 ) resistor r=5.4201 //w=0.17 //l=0.103078 //layer=li \
 //thickness=0.1 //x=11.585 //y=1.77 //x2=11.67 //y2=1.81
r79 (  5 35 ) resistor r=27.3797 //w=0.187 //l=0.4 //layer=li //thickness=0.1 \
 //x=11.585 //y=1.77 //x2=11.185 //y2=1.77
r80 (  1 35 ) resistor r=3.57586 //w=0.17 //l=0.125 //layer=li //thickness=0.1 \
 //x=10.7 //y=1.685 //x2=10.7 //y2=1.81
r81 (  1 35 ) resistor r=42.0963 //w=0.187 //l=0.615 //layer=li \
 //thickness=0.1 //x=10.7 //y=1.685 //x2=10.7 //y2=1.07
ends PM_TMRDFFSNRNQX1\%noxref_50

subckt PM_TMRDFFSNRNQX1\%noxref_51 ( 1 5 9 13 17 35 )
c59 ( 35 0 ) capacitor c=0.0691212f //x=15.375 //y=0.555
c60 ( 17 0 ) capacitor c=0.0190725f //x=17.365 //y=1.77
c61 ( 13 0 ) capacitor c=0.015325f //x=17.365 //y=0.72
c62 ( 9 0 ) capacitor c=0.00772076f //x=16.48 //y=0.805
c63 ( 5 0 ) capacitor c=0.0167589f //x=16.395 //y=1.77
c64 ( 1 0 ) capacitor c=0.00710458f //x=15.51 //y=1.685
r65 (  18 35 ) resistor r=5.4201 //w=0.17 //l=0.103078 //layer=li \
 //thickness=0.1 //x=16.565 //y=1.77 //x2=16.48 //y2=1.81
r66 (  18 35 ) resistor r=27.3797 //w=0.187 //l=0.4 //layer=li //thickness=0.1 \
 //x=16.565 //y=1.77 //x2=16.965 //y2=1.77
r67 (  17 35 ) resistor r=0.751729 //w=0.17 //l=0.085 //layer=li \
 //thickness=0.1 //x=17.365 //y=1.77 //x2=17.45 //y2=1.77
r68 (  17 35 ) resistor r=27.3797 //w=0.187 //l=0.4 //layer=li //thickness=0.1 \
 //x=17.365 //y=1.77 //x2=16.965 //y2=1.77
r69 (  14 35 ) resistor r=3.57586 //w=0.17 //l=0.103078 //layer=li \
 //thickness=0.1 //x=16.565 //y=0.72 //x2=16.48 //y2=0.68
r70 (  14 35 ) resistor r=27.3797 //w=0.187 //l=0.4 //layer=li //thickness=0.1 \
 //x=16.565 //y=0.72 //x2=16.965 //y2=0.72
r71 (  13 35 ) resistor r=0.751729 //w=0.17 //l=0.085 //layer=li \
 //thickness=0.1 //x=17.365 //y=0.72 //x2=17.45 //y2=0.72
r72 (  13 35 ) resistor r=27.3797 //w=0.187 //l=0.4 //layer=li //thickness=0.1 \
 //x=17.365 //y=0.72 //x2=16.965 //y2=0.72
r73 (  10 35 ) resistor r=1.40859 //w=0.34 //l=0.125 //layer=li \
 //thickness=0.1 //x=16.48 //y=1.685 //x2=16.48 //y2=1.81
r74 (  10 35 ) resistor r=42.0963 //w=0.187 //l=0.615 //layer=li \
 //thickness=0.1 //x=16.48 //y=1.685 //x2=16.48 //y2=1.07
r75 (  9 35 ) resistor r=3.57586 //w=0.17 //l=0.125 //layer=li //thickness=0.1 \
 //x=16.48 //y=0.805 //x2=16.48 //y2=0.68
r76 (  9 35 ) resistor r=18.139 //w=0.187 //l=0.265 //layer=li //thickness=0.1 \
 //x=16.48 //y=0.805 //x2=16.48 //y2=1.07
r77 (  6 35 ) resistor r=3.57586 //w=0.17 //l=0.103078 //layer=li \
 //thickness=0.1 //x=15.595 //y=1.77 //x2=15.51 //y2=1.81
r78 (  6 35 ) resistor r=27.3797 //w=0.187 //l=0.4 //layer=li //thickness=0.1 \
 //x=15.595 //y=1.77 //x2=15.995 //y2=1.77
r79 (  5 35 ) resistor r=5.4201 //w=0.17 //l=0.103078 //layer=li \
 //thickness=0.1 //x=16.395 //y=1.77 //x2=16.48 //y2=1.81
r80 (  5 35 ) resistor r=27.3797 //w=0.187 //l=0.4 //layer=li //thickness=0.1 \
 //x=16.395 //y=1.77 //x2=15.995 //y2=1.77
r81 (  1 35 ) resistor r=3.57586 //w=0.17 //l=0.125 //layer=li //thickness=0.1 \
 //x=15.51 //y=1.685 //x2=15.51 //y2=1.81
r82 (  1 35 ) resistor r=42.0963 //w=0.187 //l=0.615 //layer=li \
 //thickness=0.1 //x=15.51 //y=1.685 //x2=15.51 //y2=1.07
ends PM_TMRDFFSNRNQX1\%noxref_51

subckt PM_TMRDFFSNRNQX1\%noxref_52 ( 1 5 9 13 17 35 )
c58 ( 35 0 ) capacitor c=0.0691212f //x=20.185 //y=0.555
c59 ( 17 0 ) capacitor c=0.0189585f //x=22.175 //y=1.77
c60 ( 13 0 ) capacitor c=0.0153221f //x=22.175 //y=0.72
c61 ( 9 0 ) capacitor c=0.00772076f //x=21.29 //y=0.805
c62 ( 5 0 ) capacitor c=0.0168501f //x=21.205 //y=1.77
c63 ( 1 0 ) capacitor c=0.00710458f //x=20.32 //y=1.685
r64 (  18 35 ) resistor r=5.4201 //w=0.17 //l=0.103078 //layer=li \
 //thickness=0.1 //x=21.375 //y=1.77 //x2=21.29 //y2=1.81
r65 (  18 35 ) resistor r=27.3797 //w=0.187 //l=0.4 //layer=li //thickness=0.1 \
 //x=21.375 //y=1.77 //x2=21.775 //y2=1.77
r66 (  17 35 ) resistor r=0.751729 //w=0.17 //l=0.085 //layer=li \
 //thickness=0.1 //x=22.175 //y=1.77 //x2=22.26 //y2=1.77
r67 (  17 35 ) resistor r=27.3797 //w=0.187 //l=0.4 //layer=li //thickness=0.1 \
 //x=22.175 //y=1.77 //x2=21.775 //y2=1.77
r68 (  14 35 ) resistor r=3.57586 //w=0.17 //l=0.103078 //layer=li \
 //thickness=0.1 //x=21.375 //y=0.72 //x2=21.29 //y2=0.68
r69 (  14 35 ) resistor r=27.3797 //w=0.187 //l=0.4 //layer=li //thickness=0.1 \
 //x=21.375 //y=0.72 //x2=21.775 //y2=0.72
r70 (  13 35 ) resistor r=0.751729 //w=0.17 //l=0.085 //layer=li \
 //thickness=0.1 //x=22.175 //y=0.72 //x2=22.26 //y2=0.72
r71 (  13 35 ) resistor r=27.3797 //w=0.187 //l=0.4 //layer=li //thickness=0.1 \
 //x=22.175 //y=0.72 //x2=21.775 //y2=0.72
r72 (  10 35 ) resistor r=1.40859 //w=0.34 //l=0.125 //layer=li \
 //thickness=0.1 //x=21.29 //y=1.685 //x2=21.29 //y2=1.81
r73 (  10 35 ) resistor r=42.0963 //w=0.187 //l=0.615 //layer=li \
 //thickness=0.1 //x=21.29 //y=1.685 //x2=21.29 //y2=1.07
r74 (  9 35 ) resistor r=3.57586 //w=0.17 //l=0.125 //layer=li //thickness=0.1 \
 //x=21.29 //y=0.805 //x2=21.29 //y2=0.68
r75 (  9 35 ) resistor r=18.139 //w=0.187 //l=0.265 //layer=li //thickness=0.1 \
 //x=21.29 //y=0.805 //x2=21.29 //y2=1.07
r76 (  6 35 ) resistor r=3.57586 //w=0.17 //l=0.103078 //layer=li \
 //thickness=0.1 //x=20.405 //y=1.77 //x2=20.32 //y2=1.81
r77 (  6 35 ) resistor r=27.3797 //w=0.187 //l=0.4 //layer=li //thickness=0.1 \
 //x=20.405 //y=1.77 //x2=20.805 //y2=1.77
r78 (  5 35 ) resistor r=5.4201 //w=0.17 //l=0.103078 //layer=li \
 //thickness=0.1 //x=21.205 //y=1.77 //x2=21.29 //y2=1.81
r79 (  5 35 ) resistor r=27.3797 //w=0.187 //l=0.4 //layer=li //thickness=0.1 \
 //x=21.205 //y=1.77 //x2=20.805 //y2=1.77
r80 (  1 35 ) resistor r=3.57586 //w=0.17 //l=0.125 //layer=li //thickness=0.1 \
 //x=20.32 //y=1.685 //x2=20.32 //y2=1.81
r81 (  1 35 ) resistor r=42.0963 //w=0.187 //l=0.615 //layer=li \
 //thickness=0.1 //x=20.32 //y=1.685 //x2=20.32 //y2=1.07
ends PM_TMRDFFSNRNQX1\%noxref_52

subckt PM_TMRDFFSNRNQX1\%noxref_53 ( 1 5 9 13 17 35 )
c59 ( 35 0 ) capacitor c=0.0691212f //x=24.995 //y=0.555
c60 ( 17 0 ) capacitor c=0.0190725f //x=26.985 //y=1.77
c61 ( 13 0 ) capacitor c=0.015325f //x=26.985 //y=0.72
c62 ( 9 0 ) capacitor c=0.00772076f //x=26.1 //y=0.805
c63 ( 5 0 ) capacitor c=0.0167627f //x=26.015 //y=1.77
c64 ( 1 0 ) capacitor c=0.00710458f //x=25.13 //y=1.685
r65 (  18 35 ) resistor r=5.4201 //w=0.17 //l=0.103078 //layer=li \
 //thickness=0.1 //x=26.185 //y=1.77 //x2=26.1 //y2=1.81
r66 (  18 35 ) resistor r=27.3797 //w=0.187 //l=0.4 //layer=li //thickness=0.1 \
 //x=26.185 //y=1.77 //x2=26.585 //y2=1.77
r67 (  17 35 ) resistor r=0.751729 //w=0.17 //l=0.085 //layer=li \
 //thickness=0.1 //x=26.985 //y=1.77 //x2=27.07 //y2=1.77
r68 (  17 35 ) resistor r=27.3797 //w=0.187 //l=0.4 //layer=li //thickness=0.1 \
 //x=26.985 //y=1.77 //x2=26.585 //y2=1.77
r69 (  14 35 ) resistor r=3.57586 //w=0.17 //l=0.103078 //layer=li \
 //thickness=0.1 //x=26.185 //y=0.72 //x2=26.1 //y2=0.68
r70 (  14 35 ) resistor r=27.3797 //w=0.187 //l=0.4 //layer=li //thickness=0.1 \
 //x=26.185 //y=0.72 //x2=26.585 //y2=0.72
r71 (  13 35 ) resistor r=0.751729 //w=0.17 //l=0.085 //layer=li \
 //thickness=0.1 //x=26.985 //y=0.72 //x2=27.07 //y2=0.72
r72 (  13 35 ) resistor r=27.3797 //w=0.187 //l=0.4 //layer=li //thickness=0.1 \
 //x=26.985 //y=0.72 //x2=26.585 //y2=0.72
r73 (  10 35 ) resistor r=1.40859 //w=0.34 //l=0.125 //layer=li \
 //thickness=0.1 //x=26.1 //y=1.685 //x2=26.1 //y2=1.81
r74 (  10 35 ) resistor r=42.0963 //w=0.187 //l=0.615 //layer=li \
 //thickness=0.1 //x=26.1 //y=1.685 //x2=26.1 //y2=1.07
r75 (  9 35 ) resistor r=3.57586 //w=0.17 //l=0.125 //layer=li //thickness=0.1 \
 //x=26.1 //y=0.805 //x2=26.1 //y2=0.68
r76 (  9 35 ) resistor r=18.139 //w=0.187 //l=0.265 //layer=li //thickness=0.1 \
 //x=26.1 //y=0.805 //x2=26.1 //y2=1.07
r77 (  6 35 ) resistor r=3.57586 //w=0.17 //l=0.103078 //layer=li \
 //thickness=0.1 //x=25.215 //y=1.77 //x2=25.13 //y2=1.81
r78 (  6 35 ) resistor r=27.3797 //w=0.187 //l=0.4 //layer=li //thickness=0.1 \
 //x=25.215 //y=1.77 //x2=25.615 //y2=1.77
r79 (  5 35 ) resistor r=5.4201 //w=0.17 //l=0.103078 //layer=li \
 //thickness=0.1 //x=26.015 //y=1.77 //x2=26.1 //y2=1.81
r80 (  5 35 ) resistor r=27.3797 //w=0.187 //l=0.4 //layer=li //thickness=0.1 \
 //x=26.015 //y=1.77 //x2=25.615 //y2=1.77
r81 (  1 35 ) resistor r=3.57586 //w=0.17 //l=0.125 //layer=li //thickness=0.1 \
 //x=25.13 //y=1.685 //x2=25.13 //y2=1.81
r82 (  1 35 ) resistor r=42.0963 //w=0.187 //l=0.615 //layer=li \
 //thickness=0.1 //x=25.13 //y=1.685 //x2=25.13 //y2=1.07
ends PM_TMRDFFSNRNQX1\%noxref_53

subckt PM_TMRDFFSNRNQX1\%noxref_54 ( 1 5 9 13 17 35 )
c56 ( 35 0 ) capacitor c=0.0691212f //x=29.805 //y=0.555
c57 ( 17 0 ) capacitor c=0.0189725f //x=31.795 //y=1.77
c58 ( 13 0 ) capacitor c=0.0153216f //x=31.795 //y=0.72
c59 ( 9 0 ) capacitor c=0.00772076f //x=30.91 //y=0.805
c60 ( 5 0 ) capacitor c=0.0168501f //x=30.825 //y=1.77
c61 ( 1 0 ) capacitor c=0.00710458f //x=29.94 //y=1.685
r62 (  18 35 ) resistor r=5.4201 //w=0.17 //l=0.103078 //layer=li \
 //thickness=0.1 //x=30.995 //y=1.77 //x2=30.91 //y2=1.81
r63 (  18 35 ) resistor r=27.3797 //w=0.187 //l=0.4 //layer=li //thickness=0.1 \
 //x=30.995 //y=1.77 //x2=31.395 //y2=1.77
r64 (  17 35 ) resistor r=0.751729 //w=0.17 //l=0.085 //layer=li \
 //thickness=0.1 //x=31.795 //y=1.77 //x2=31.88 //y2=1.77
r65 (  17 35 ) resistor r=27.3797 //w=0.187 //l=0.4 //layer=li //thickness=0.1 \
 //x=31.795 //y=1.77 //x2=31.395 //y2=1.77
r66 (  14 35 ) resistor r=3.57586 //w=0.17 //l=0.103078 //layer=li \
 //thickness=0.1 //x=30.995 //y=0.72 //x2=30.91 //y2=0.68
r67 (  14 35 ) resistor r=27.3797 //w=0.187 //l=0.4 //layer=li //thickness=0.1 \
 //x=30.995 //y=0.72 //x2=31.395 //y2=0.72
r68 (  13 35 ) resistor r=0.751729 //w=0.17 //l=0.085 //layer=li \
 //thickness=0.1 //x=31.795 //y=0.72 //x2=31.88 //y2=0.72
r69 (  13 35 ) resistor r=27.3797 //w=0.187 //l=0.4 //layer=li //thickness=0.1 \
 //x=31.795 //y=0.72 //x2=31.395 //y2=0.72
r70 (  10 35 ) resistor r=1.40859 //w=0.34 //l=0.125 //layer=li \
 //thickness=0.1 //x=30.91 //y=1.685 //x2=30.91 //y2=1.81
r71 (  10 35 ) resistor r=42.0963 //w=0.187 //l=0.615 //layer=li \
 //thickness=0.1 //x=30.91 //y=1.685 //x2=30.91 //y2=1.07
r72 (  9 35 ) resistor r=3.57586 //w=0.17 //l=0.125 //layer=li //thickness=0.1 \
 //x=30.91 //y=0.805 //x2=30.91 //y2=0.68
r73 (  9 35 ) resistor r=18.139 //w=0.187 //l=0.265 //layer=li //thickness=0.1 \
 //x=30.91 //y=0.805 //x2=30.91 //y2=1.07
r74 (  6 35 ) resistor r=3.57586 //w=0.17 //l=0.103078 //layer=li \
 //thickness=0.1 //x=30.025 //y=1.77 //x2=29.94 //y2=1.81
r75 (  6 35 ) resistor r=27.3797 //w=0.187 //l=0.4 //layer=li //thickness=0.1 \
 //x=30.025 //y=1.77 //x2=30.425 //y2=1.77
r76 (  5 35 ) resistor r=5.4201 //w=0.17 //l=0.103078 //layer=li \
 //thickness=0.1 //x=30.825 //y=1.77 //x2=30.91 //y2=1.81
r77 (  5 35 ) resistor r=27.3797 //w=0.187 //l=0.4 //layer=li //thickness=0.1 \
 //x=30.825 //y=1.77 //x2=30.425 //y2=1.77
r78 (  1 35 ) resistor r=3.57586 //w=0.17 //l=0.125 //layer=li //thickness=0.1 \
 //x=29.94 //y=1.685 //x2=29.94 //y2=1.81
r79 (  1 35 ) resistor r=42.0963 //w=0.187 //l=0.615 //layer=li \
 //thickness=0.1 //x=29.94 //y=1.685 //x2=29.94 //y2=1.07
ends PM_TMRDFFSNRNQX1\%noxref_54

subckt PM_TMRDFFSNRNQX1\%noxref_55 ( 1 5 9 13 17 35 )
c57 ( 35 0 ) capacitor c=0.0691212f //x=34.615 //y=0.555
c58 ( 17 0 ) capacitor c=0.0190725f //x=36.605 //y=1.77
c59 ( 13 0 ) capacitor c=0.015325f //x=36.605 //y=0.72
c60 ( 9 0 ) capacitor c=0.00772076f //x=35.72 //y=0.805
c61 ( 5 0 ) capacitor c=0.0166941f //x=35.635 //y=1.77
c62 ( 1 0 ) capacitor c=0.00710458f //x=34.75 //y=1.685
r63 (  18 35 ) resistor r=5.4201 //w=0.17 //l=0.103078 //layer=li \
 //thickness=0.1 //x=35.805 //y=1.77 //x2=35.72 //y2=1.81
r64 (  18 35 ) resistor r=27.3797 //w=0.187 //l=0.4 //layer=li //thickness=0.1 \
 //x=35.805 //y=1.77 //x2=36.205 //y2=1.77
r65 (  17 35 ) resistor r=0.751729 //w=0.17 //l=0.085 //layer=li \
 //thickness=0.1 //x=36.605 //y=1.77 //x2=36.69 //y2=1.77
r66 (  17 35 ) resistor r=27.3797 //w=0.187 //l=0.4 //layer=li //thickness=0.1 \
 //x=36.605 //y=1.77 //x2=36.205 //y2=1.77
r67 (  14 35 ) resistor r=3.57586 //w=0.17 //l=0.103078 //layer=li \
 //thickness=0.1 //x=35.805 //y=0.72 //x2=35.72 //y2=0.68
r68 (  14 35 ) resistor r=27.3797 //w=0.187 //l=0.4 //layer=li //thickness=0.1 \
 //x=35.805 //y=0.72 //x2=36.205 //y2=0.72
r69 (  13 35 ) resistor r=0.751729 //w=0.17 //l=0.085 //layer=li \
 //thickness=0.1 //x=36.605 //y=0.72 //x2=36.69 //y2=0.72
r70 (  13 35 ) resistor r=27.3797 //w=0.187 //l=0.4 //layer=li //thickness=0.1 \
 //x=36.605 //y=0.72 //x2=36.205 //y2=0.72
r71 (  10 35 ) resistor r=1.40859 //w=0.34 //l=0.125 //layer=li \
 //thickness=0.1 //x=35.72 //y=1.685 //x2=35.72 //y2=1.81
r72 (  10 35 ) resistor r=42.0963 //w=0.187 //l=0.615 //layer=li \
 //thickness=0.1 //x=35.72 //y=1.685 //x2=35.72 //y2=1.07
r73 (  9 35 ) resistor r=3.57586 //w=0.17 //l=0.125 //layer=li //thickness=0.1 \
 //x=35.72 //y=0.805 //x2=35.72 //y2=0.68
r74 (  9 35 ) resistor r=18.139 //w=0.187 //l=0.265 //layer=li //thickness=0.1 \
 //x=35.72 //y=0.805 //x2=35.72 //y2=1.07
r75 (  6 35 ) resistor r=3.57586 //w=0.17 //l=0.103078 //layer=li \
 //thickness=0.1 //x=34.835 //y=1.77 //x2=34.75 //y2=1.81
r76 (  6 35 ) resistor r=27.3797 //w=0.187 //l=0.4 //layer=li //thickness=0.1 \
 //x=34.835 //y=1.77 //x2=35.235 //y2=1.77
r77 (  5 35 ) resistor r=5.4201 //w=0.17 //l=0.103078 //layer=li \
 //thickness=0.1 //x=35.635 //y=1.77 //x2=35.72 //y2=1.81
r78 (  5 35 ) resistor r=27.3797 //w=0.187 //l=0.4 //layer=li //thickness=0.1 \
 //x=35.635 //y=1.77 //x2=35.235 //y2=1.77
r79 (  1 35 ) resistor r=3.57586 //w=0.17 //l=0.125 //layer=li //thickness=0.1 \
 //x=34.75 //y=1.685 //x2=34.75 //y2=1.81
r80 (  1 35 ) resistor r=42.0963 //w=0.187 //l=0.615 //layer=li \
 //thickness=0.1 //x=34.75 //y=1.685 //x2=34.75 //y2=1.07
ends PM_TMRDFFSNRNQX1\%noxref_55

subckt PM_TMRDFFSNRNQX1\%noxref_56 ( 1 5 9 13 17 35 )
c58 ( 35 0 ) capacitor c=0.0691212f //x=39.425 //y=0.555
c59 ( 17 0 ) capacitor c=0.0190725f //x=41.415 //y=1.77
c60 ( 13 0 ) capacitor c=0.015325f //x=41.415 //y=0.72
c61 ( 9 0 ) capacitor c=0.00772076f //x=40.53 //y=0.805
c62 ( 5 0 ) capacitor c=0.0167789f //x=40.445 //y=1.77
c63 ( 1 0 ) capacitor c=0.00710458f //x=39.56 //y=1.685
r64 (  18 35 ) resistor r=5.4201 //w=0.17 //l=0.103078 //layer=li \
 //thickness=0.1 //x=40.615 //y=1.77 //x2=40.53 //y2=1.81
r65 (  18 35 ) resistor r=27.3797 //w=0.187 //l=0.4 //layer=li //thickness=0.1 \
 //x=40.615 //y=1.77 //x2=41.015 //y2=1.77
r66 (  17 35 ) resistor r=0.751729 //w=0.17 //l=0.085 //layer=li \
 //thickness=0.1 //x=41.415 //y=1.77 //x2=41.5 //y2=1.77
r67 (  17 35 ) resistor r=27.3797 //w=0.187 //l=0.4 //layer=li //thickness=0.1 \
 //x=41.415 //y=1.77 //x2=41.015 //y2=1.77
r68 (  14 35 ) resistor r=3.57586 //w=0.17 //l=0.103078 //layer=li \
 //thickness=0.1 //x=40.615 //y=0.72 //x2=40.53 //y2=0.68
r69 (  14 35 ) resistor r=27.3797 //w=0.187 //l=0.4 //layer=li //thickness=0.1 \
 //x=40.615 //y=0.72 //x2=41.015 //y2=0.72
r70 (  13 35 ) resistor r=0.751729 //w=0.17 //l=0.085 //layer=li \
 //thickness=0.1 //x=41.415 //y=0.72 //x2=41.5 //y2=0.72
r71 (  13 35 ) resistor r=27.3797 //w=0.187 //l=0.4 //layer=li //thickness=0.1 \
 //x=41.415 //y=0.72 //x2=41.015 //y2=0.72
r72 (  10 35 ) resistor r=1.40859 //w=0.34 //l=0.125 //layer=li \
 //thickness=0.1 //x=40.53 //y=1.685 //x2=40.53 //y2=1.81
r73 (  10 35 ) resistor r=42.0963 //w=0.187 //l=0.615 //layer=li \
 //thickness=0.1 //x=40.53 //y=1.685 //x2=40.53 //y2=1.07
r74 (  9 35 ) resistor r=3.57586 //w=0.17 //l=0.125 //layer=li //thickness=0.1 \
 //x=40.53 //y=0.805 //x2=40.53 //y2=0.68
r75 (  9 35 ) resistor r=18.139 //w=0.187 //l=0.265 //layer=li //thickness=0.1 \
 //x=40.53 //y=0.805 //x2=40.53 //y2=1.07
r76 (  6 35 ) resistor r=3.57586 //w=0.17 //l=0.103078 //layer=li \
 //thickness=0.1 //x=39.645 //y=1.77 //x2=39.56 //y2=1.81
r77 (  6 35 ) resistor r=27.3797 //w=0.187 //l=0.4 //layer=li //thickness=0.1 \
 //x=39.645 //y=1.77 //x2=40.045 //y2=1.77
r78 (  5 35 ) resistor r=5.4201 //w=0.17 //l=0.103078 //layer=li \
 //thickness=0.1 //x=40.445 //y=1.77 //x2=40.53 //y2=1.81
r79 (  5 35 ) resistor r=27.3797 //w=0.187 //l=0.4 //layer=li //thickness=0.1 \
 //x=40.445 //y=1.77 //x2=40.045 //y2=1.77
r80 (  1 35 ) resistor r=3.57586 //w=0.17 //l=0.125 //layer=li //thickness=0.1 \
 //x=39.56 //y=1.685 //x2=39.56 //y2=1.81
r81 (  1 35 ) resistor r=42.0963 //w=0.187 //l=0.615 //layer=li \
 //thickness=0.1 //x=39.56 //y=1.685 //x2=39.56 //y2=1.07
ends PM_TMRDFFSNRNQX1\%noxref_56

subckt PM_TMRDFFSNRNQX1\%noxref_57 ( 1 5 9 13 17 35 )
c59 ( 35 0 ) capacitor c=0.0691212f //x=44.235 //y=0.555
c60 ( 17 0 ) capacitor c=0.0190725f //x=46.225 //y=1.77
c61 ( 13 0 ) capacitor c=0.015325f //x=46.225 //y=0.72
c62 ( 9 0 ) capacitor c=0.00772076f //x=45.34 //y=0.805
c63 ( 5 0 ) capacitor c=0.0167589f //x=45.255 //y=1.77
c64 ( 1 0 ) capacitor c=0.00710458f //x=44.37 //y=1.685
r65 (  18 35 ) resistor r=5.4201 //w=0.17 //l=0.103078 //layer=li \
 //thickness=0.1 //x=45.425 //y=1.77 //x2=45.34 //y2=1.81
r66 (  18 35 ) resistor r=27.3797 //w=0.187 //l=0.4 //layer=li //thickness=0.1 \
 //x=45.425 //y=1.77 //x2=45.825 //y2=1.77
r67 (  17 35 ) resistor r=0.751729 //w=0.17 //l=0.085 //layer=li \
 //thickness=0.1 //x=46.225 //y=1.77 //x2=46.31 //y2=1.77
r68 (  17 35 ) resistor r=27.3797 //w=0.187 //l=0.4 //layer=li //thickness=0.1 \
 //x=46.225 //y=1.77 //x2=45.825 //y2=1.77
r69 (  14 35 ) resistor r=3.57586 //w=0.17 //l=0.103078 //layer=li \
 //thickness=0.1 //x=45.425 //y=0.72 //x2=45.34 //y2=0.68
r70 (  14 35 ) resistor r=27.3797 //w=0.187 //l=0.4 //layer=li //thickness=0.1 \
 //x=45.425 //y=0.72 //x2=45.825 //y2=0.72
r71 (  13 35 ) resistor r=0.751729 //w=0.17 //l=0.085 //layer=li \
 //thickness=0.1 //x=46.225 //y=0.72 //x2=46.31 //y2=0.72
r72 (  13 35 ) resistor r=27.3797 //w=0.187 //l=0.4 //layer=li //thickness=0.1 \
 //x=46.225 //y=0.72 //x2=45.825 //y2=0.72
r73 (  10 35 ) resistor r=1.40859 //w=0.34 //l=0.125 //layer=li \
 //thickness=0.1 //x=45.34 //y=1.685 //x2=45.34 //y2=1.81
r74 (  10 35 ) resistor r=42.0963 //w=0.187 //l=0.615 //layer=li \
 //thickness=0.1 //x=45.34 //y=1.685 //x2=45.34 //y2=1.07
r75 (  9 35 ) resistor r=3.57586 //w=0.17 //l=0.125 //layer=li //thickness=0.1 \
 //x=45.34 //y=0.805 //x2=45.34 //y2=0.68
r76 (  9 35 ) resistor r=18.139 //w=0.187 //l=0.265 //layer=li //thickness=0.1 \
 //x=45.34 //y=0.805 //x2=45.34 //y2=1.07
r77 (  6 35 ) resistor r=3.57586 //w=0.17 //l=0.103078 //layer=li \
 //thickness=0.1 //x=44.455 //y=1.77 //x2=44.37 //y2=1.81
r78 (  6 35 ) resistor r=27.3797 //w=0.187 //l=0.4 //layer=li //thickness=0.1 \
 //x=44.455 //y=1.77 //x2=44.855 //y2=1.77
r79 (  5 35 ) resistor r=5.4201 //w=0.17 //l=0.103078 //layer=li \
 //thickness=0.1 //x=45.255 //y=1.77 //x2=45.34 //y2=1.81
r80 (  5 35 ) resistor r=27.3797 //w=0.187 //l=0.4 //layer=li //thickness=0.1 \
 //x=45.255 //y=1.77 //x2=44.855 //y2=1.77
r81 (  1 35 ) resistor r=3.57586 //w=0.17 //l=0.125 //layer=li //thickness=0.1 \
 //x=44.37 //y=1.685 //x2=44.37 //y2=1.81
r82 (  1 35 ) resistor r=42.0963 //w=0.187 //l=0.615 //layer=li \
 //thickness=0.1 //x=44.37 //y=1.685 //x2=44.37 //y2=1.07
ends PM_TMRDFFSNRNQX1\%noxref_57

subckt PM_TMRDFFSNRNQX1\%noxref_58 ( 1 5 9 13 17 35 )
c58 ( 35 0 ) capacitor c=0.0691212f //x=49.045 //y=0.555
c59 ( 17 0 ) capacitor c=0.0189585f //x=51.035 //y=1.77
c60 ( 13 0 ) capacitor c=0.0153221f //x=51.035 //y=0.72
c61 ( 9 0 ) capacitor c=0.00772076f //x=50.15 //y=0.805
c62 ( 5 0 ) capacitor c=0.0168501f //x=50.065 //y=1.77
c63 ( 1 0 ) capacitor c=0.00710458f //x=49.18 //y=1.685
r64 (  18 35 ) resistor r=5.4201 //w=0.17 //l=0.103078 //layer=li \
 //thickness=0.1 //x=50.235 //y=1.77 //x2=50.15 //y2=1.81
r65 (  18 35 ) resistor r=27.3797 //w=0.187 //l=0.4 //layer=li //thickness=0.1 \
 //x=50.235 //y=1.77 //x2=50.635 //y2=1.77
r66 (  17 35 ) resistor r=0.751729 //w=0.17 //l=0.085 //layer=li \
 //thickness=0.1 //x=51.035 //y=1.77 //x2=51.12 //y2=1.77
r67 (  17 35 ) resistor r=27.3797 //w=0.187 //l=0.4 //layer=li //thickness=0.1 \
 //x=51.035 //y=1.77 //x2=50.635 //y2=1.77
r68 (  14 35 ) resistor r=3.57586 //w=0.17 //l=0.103078 //layer=li \
 //thickness=0.1 //x=50.235 //y=0.72 //x2=50.15 //y2=0.68
r69 (  14 35 ) resistor r=27.3797 //w=0.187 //l=0.4 //layer=li //thickness=0.1 \
 //x=50.235 //y=0.72 //x2=50.635 //y2=0.72
r70 (  13 35 ) resistor r=0.751729 //w=0.17 //l=0.085 //layer=li \
 //thickness=0.1 //x=51.035 //y=0.72 //x2=51.12 //y2=0.72
r71 (  13 35 ) resistor r=27.3797 //w=0.187 //l=0.4 //layer=li //thickness=0.1 \
 //x=51.035 //y=0.72 //x2=50.635 //y2=0.72
r72 (  10 35 ) resistor r=1.40859 //w=0.34 //l=0.125 //layer=li \
 //thickness=0.1 //x=50.15 //y=1.685 //x2=50.15 //y2=1.81
r73 (  10 35 ) resistor r=42.0963 //w=0.187 //l=0.615 //layer=li \
 //thickness=0.1 //x=50.15 //y=1.685 //x2=50.15 //y2=1.07
r74 (  9 35 ) resistor r=3.57586 //w=0.17 //l=0.125 //layer=li //thickness=0.1 \
 //x=50.15 //y=0.805 //x2=50.15 //y2=0.68
r75 (  9 35 ) resistor r=18.139 //w=0.187 //l=0.265 //layer=li //thickness=0.1 \
 //x=50.15 //y=0.805 //x2=50.15 //y2=1.07
r76 (  6 35 ) resistor r=3.57586 //w=0.17 //l=0.103078 //layer=li \
 //thickness=0.1 //x=49.265 //y=1.77 //x2=49.18 //y2=1.81
r77 (  6 35 ) resistor r=27.3797 //w=0.187 //l=0.4 //layer=li //thickness=0.1 \
 //x=49.265 //y=1.77 //x2=49.665 //y2=1.77
r78 (  5 35 ) resistor r=5.4201 //w=0.17 //l=0.103078 //layer=li \
 //thickness=0.1 //x=50.065 //y=1.77 //x2=50.15 //y2=1.81
r79 (  5 35 ) resistor r=27.3797 //w=0.187 //l=0.4 //layer=li //thickness=0.1 \
 //x=50.065 //y=1.77 //x2=49.665 //y2=1.77
r80 (  1 35 ) resistor r=3.57586 //w=0.17 //l=0.125 //layer=li //thickness=0.1 \
 //x=49.18 //y=1.685 //x2=49.18 //y2=1.81
r81 (  1 35 ) resistor r=42.0963 //w=0.187 //l=0.615 //layer=li \
 //thickness=0.1 //x=49.18 //y=1.685 //x2=49.18 //y2=1.07
ends PM_TMRDFFSNRNQX1\%noxref_58

subckt PM_TMRDFFSNRNQX1\%noxref_59 ( 1 5 9 13 17 35 )
c59 ( 35 0 ) capacitor c=0.0691212f //x=53.855 //y=0.555
c60 ( 17 0 ) capacitor c=0.0190725f //x=55.845 //y=1.77
c61 ( 13 0 ) capacitor c=0.015325f //x=55.845 //y=0.72
c62 ( 9 0 ) capacitor c=0.00772076f //x=54.96 //y=0.805
c63 ( 5 0 ) capacitor c=0.0167869f //x=54.875 //y=1.77
c64 ( 1 0 ) capacitor c=0.00710458f //x=53.99 //y=1.685
r65 (  18 35 ) resistor r=5.4201 //w=0.17 //l=0.103078 //layer=li \
 //thickness=0.1 //x=55.045 //y=1.77 //x2=54.96 //y2=1.81
r66 (  18 35 ) resistor r=27.3797 //w=0.187 //l=0.4 //layer=li //thickness=0.1 \
 //x=55.045 //y=1.77 //x2=55.445 //y2=1.77
r67 (  17 35 ) resistor r=0.751729 //w=0.17 //l=0.085 //layer=li \
 //thickness=0.1 //x=55.845 //y=1.77 //x2=55.93 //y2=1.77
r68 (  17 35 ) resistor r=27.3797 //w=0.187 //l=0.4 //layer=li //thickness=0.1 \
 //x=55.845 //y=1.77 //x2=55.445 //y2=1.77
r69 (  14 35 ) resistor r=3.57586 //w=0.17 //l=0.103078 //layer=li \
 //thickness=0.1 //x=55.045 //y=0.72 //x2=54.96 //y2=0.68
r70 (  14 35 ) resistor r=27.3797 //w=0.187 //l=0.4 //layer=li //thickness=0.1 \
 //x=55.045 //y=0.72 //x2=55.445 //y2=0.72
r71 (  13 35 ) resistor r=0.751729 //w=0.17 //l=0.085 //layer=li \
 //thickness=0.1 //x=55.845 //y=0.72 //x2=55.93 //y2=0.72
r72 (  13 35 ) resistor r=27.3797 //w=0.187 //l=0.4 //layer=li //thickness=0.1 \
 //x=55.845 //y=0.72 //x2=55.445 //y2=0.72
r73 (  10 35 ) resistor r=1.40859 //w=0.34 //l=0.125 //layer=li \
 //thickness=0.1 //x=54.96 //y=1.685 //x2=54.96 //y2=1.81
r74 (  10 35 ) resistor r=42.0963 //w=0.187 //l=0.615 //layer=li \
 //thickness=0.1 //x=54.96 //y=1.685 //x2=54.96 //y2=1.07
r75 (  9 35 ) resistor r=3.57586 //w=0.17 //l=0.125 //layer=li //thickness=0.1 \
 //x=54.96 //y=0.805 //x2=54.96 //y2=0.68
r76 (  9 35 ) resistor r=18.139 //w=0.187 //l=0.265 //layer=li //thickness=0.1 \
 //x=54.96 //y=0.805 //x2=54.96 //y2=1.07
r77 (  6 35 ) resistor r=3.57586 //w=0.17 //l=0.103078 //layer=li \
 //thickness=0.1 //x=54.075 //y=1.77 //x2=53.99 //y2=1.81
r78 (  6 35 ) resistor r=27.3797 //w=0.187 //l=0.4 //layer=li //thickness=0.1 \
 //x=54.075 //y=1.77 //x2=54.475 //y2=1.77
r79 (  5 35 ) resistor r=5.4201 //w=0.17 //l=0.103078 //layer=li \
 //thickness=0.1 //x=54.875 //y=1.77 //x2=54.96 //y2=1.81
r80 (  5 35 ) resistor r=27.3797 //w=0.187 //l=0.4 //layer=li //thickness=0.1 \
 //x=54.875 //y=1.77 //x2=54.475 //y2=1.77
r81 (  1 35 ) resistor r=3.57586 //w=0.17 //l=0.125 //layer=li //thickness=0.1 \
 //x=53.99 //y=1.685 //x2=53.99 //y2=1.81
r82 (  1 35 ) resistor r=42.0963 //w=0.187 //l=0.615 //layer=li \
 //thickness=0.1 //x=53.99 //y=1.685 //x2=53.99 //y2=1.07
ends PM_TMRDFFSNRNQX1\%noxref_59

subckt PM_TMRDFFSNRNQX1\%noxref_60 ( 1 5 9 13 17 35 )
c56 ( 35 0 ) capacitor c=0.0691212f //x=58.665 //y=0.555
c57 ( 17 0 ) capacitor c=0.0189725f //x=60.655 //y=1.77
c58 ( 13 0 ) capacitor c=0.0153216f //x=60.655 //y=0.72
c59 ( 9 0 ) capacitor c=0.00772076f //x=59.77 //y=0.805
c60 ( 5 0 ) capacitor c=0.0168501f //x=59.685 //y=1.77
c61 ( 1 0 ) capacitor c=0.00710458f //x=58.8 //y=1.685
r62 (  18 35 ) resistor r=5.4201 //w=0.17 //l=0.103078 //layer=li \
 //thickness=0.1 //x=59.855 //y=1.77 //x2=59.77 //y2=1.81
r63 (  18 35 ) resistor r=27.3797 //w=0.187 //l=0.4 //layer=li //thickness=0.1 \
 //x=59.855 //y=1.77 //x2=60.255 //y2=1.77
r64 (  17 35 ) resistor r=0.751729 //w=0.17 //l=0.085 //layer=li \
 //thickness=0.1 //x=60.655 //y=1.77 //x2=60.74 //y2=1.77
r65 (  17 35 ) resistor r=27.3797 //w=0.187 //l=0.4 //layer=li //thickness=0.1 \
 //x=60.655 //y=1.77 //x2=60.255 //y2=1.77
r66 (  14 35 ) resistor r=3.57586 //w=0.17 //l=0.103078 //layer=li \
 //thickness=0.1 //x=59.855 //y=0.72 //x2=59.77 //y2=0.68
r67 (  14 35 ) resistor r=27.3797 //w=0.187 //l=0.4 //layer=li //thickness=0.1 \
 //x=59.855 //y=0.72 //x2=60.255 //y2=0.72
r68 (  13 35 ) resistor r=0.751729 //w=0.17 //l=0.085 //layer=li \
 //thickness=0.1 //x=60.655 //y=0.72 //x2=60.74 //y2=0.72
r69 (  13 35 ) resistor r=27.3797 //w=0.187 //l=0.4 //layer=li //thickness=0.1 \
 //x=60.655 //y=0.72 //x2=60.255 //y2=0.72
r70 (  10 35 ) resistor r=1.40859 //w=0.34 //l=0.125 //layer=li \
 //thickness=0.1 //x=59.77 //y=1.685 //x2=59.77 //y2=1.81
r71 (  10 35 ) resistor r=42.0963 //w=0.187 //l=0.615 //layer=li \
 //thickness=0.1 //x=59.77 //y=1.685 //x2=59.77 //y2=1.07
r72 (  9 35 ) resistor r=3.57586 //w=0.17 //l=0.125 //layer=li //thickness=0.1 \
 //x=59.77 //y=0.805 //x2=59.77 //y2=0.68
r73 (  9 35 ) resistor r=18.139 //w=0.187 //l=0.265 //layer=li //thickness=0.1 \
 //x=59.77 //y=0.805 //x2=59.77 //y2=1.07
r74 (  6 35 ) resistor r=3.57586 //w=0.17 //l=0.103078 //layer=li \
 //thickness=0.1 //x=58.885 //y=1.77 //x2=58.8 //y2=1.81
r75 (  6 35 ) resistor r=27.3797 //w=0.187 //l=0.4 //layer=li //thickness=0.1 \
 //x=58.885 //y=1.77 //x2=59.285 //y2=1.77
r76 (  5 35 ) resistor r=5.4201 //w=0.17 //l=0.103078 //layer=li \
 //thickness=0.1 //x=59.685 //y=1.77 //x2=59.77 //y2=1.81
r77 (  5 35 ) resistor r=27.3797 //w=0.187 //l=0.4 //layer=li //thickness=0.1 \
 //x=59.685 //y=1.77 //x2=59.285 //y2=1.77
r78 (  1 35 ) resistor r=3.57586 //w=0.17 //l=0.125 //layer=li //thickness=0.1 \
 //x=58.8 //y=1.685 //x2=58.8 //y2=1.81
r79 (  1 35 ) resistor r=42.0963 //w=0.187 //l=0.615 //layer=li \
 //thickness=0.1 //x=58.8 //y=1.685 //x2=58.8 //y2=1.07
ends PM_TMRDFFSNRNQX1\%noxref_60

subckt PM_TMRDFFSNRNQX1\%noxref_61 ( 1 5 9 13 17 35 )
c57 ( 35 0 ) capacitor c=0.0691212f //x=63.475 //y=0.555
c58 ( 17 0 ) capacitor c=0.0190725f //x=65.465 //y=1.77
c59 ( 13 0 ) capacitor c=0.015325f //x=65.465 //y=0.72
c60 ( 9 0 ) capacitor c=0.00772076f //x=64.58 //y=0.805
c61 ( 5 0 ) capacitor c=0.0166941f //x=64.495 //y=1.77
c62 ( 1 0 ) capacitor c=0.00710458f //x=63.61 //y=1.685
r63 (  18 35 ) resistor r=5.4201 //w=0.17 //l=0.103078 //layer=li \
 //thickness=0.1 //x=64.665 //y=1.77 //x2=64.58 //y2=1.81
r64 (  18 35 ) resistor r=27.3797 //w=0.187 //l=0.4 //layer=li //thickness=0.1 \
 //x=64.665 //y=1.77 //x2=65.065 //y2=1.77
r65 (  17 35 ) resistor r=0.751729 //w=0.17 //l=0.085 //layer=li \
 //thickness=0.1 //x=65.465 //y=1.77 //x2=65.55 //y2=1.77
r66 (  17 35 ) resistor r=27.3797 //w=0.187 //l=0.4 //layer=li //thickness=0.1 \
 //x=65.465 //y=1.77 //x2=65.065 //y2=1.77
r67 (  14 35 ) resistor r=3.57586 //w=0.17 //l=0.103078 //layer=li \
 //thickness=0.1 //x=64.665 //y=0.72 //x2=64.58 //y2=0.68
r68 (  14 35 ) resistor r=27.3797 //w=0.187 //l=0.4 //layer=li //thickness=0.1 \
 //x=64.665 //y=0.72 //x2=65.065 //y2=0.72
r69 (  13 35 ) resistor r=0.751729 //w=0.17 //l=0.085 //layer=li \
 //thickness=0.1 //x=65.465 //y=0.72 //x2=65.55 //y2=0.72
r70 (  13 35 ) resistor r=27.3797 //w=0.187 //l=0.4 //layer=li //thickness=0.1 \
 //x=65.465 //y=0.72 //x2=65.065 //y2=0.72
r71 (  10 35 ) resistor r=1.40859 //w=0.34 //l=0.125 //layer=li \
 //thickness=0.1 //x=64.58 //y=1.685 //x2=64.58 //y2=1.81
r72 (  10 35 ) resistor r=42.0963 //w=0.187 //l=0.615 //layer=li \
 //thickness=0.1 //x=64.58 //y=1.685 //x2=64.58 //y2=1.07
r73 (  9 35 ) resistor r=3.57586 //w=0.17 //l=0.125 //layer=li //thickness=0.1 \
 //x=64.58 //y=0.805 //x2=64.58 //y2=0.68
r74 (  9 35 ) resistor r=18.139 //w=0.187 //l=0.265 //layer=li //thickness=0.1 \
 //x=64.58 //y=0.805 //x2=64.58 //y2=1.07
r75 (  6 35 ) resistor r=3.57586 //w=0.17 //l=0.103078 //layer=li \
 //thickness=0.1 //x=63.695 //y=1.77 //x2=63.61 //y2=1.81
r76 (  6 35 ) resistor r=27.3797 //w=0.187 //l=0.4 //layer=li //thickness=0.1 \
 //x=63.695 //y=1.77 //x2=64.095 //y2=1.77
r77 (  5 35 ) resistor r=5.4201 //w=0.17 //l=0.103078 //layer=li \
 //thickness=0.1 //x=64.495 //y=1.77 //x2=64.58 //y2=1.81
r78 (  5 35 ) resistor r=27.3797 //w=0.187 //l=0.4 //layer=li //thickness=0.1 \
 //x=64.495 //y=1.77 //x2=64.095 //y2=1.77
r79 (  1 35 ) resistor r=3.57586 //w=0.17 //l=0.125 //layer=li //thickness=0.1 \
 //x=63.61 //y=1.685 //x2=63.61 //y2=1.81
r80 (  1 35 ) resistor r=42.0963 //w=0.187 //l=0.615 //layer=li \
 //thickness=0.1 //x=63.61 //y=1.685 //x2=63.61 //y2=1.07
ends PM_TMRDFFSNRNQX1\%noxref_61

subckt PM_TMRDFFSNRNQX1\%noxref_62 ( 1 5 9 13 17 35 )
c58 ( 35 0 ) capacitor c=0.0691212f //x=68.285 //y=0.555
c59 ( 17 0 ) capacitor c=0.0190725f //x=70.275 //y=1.77
c60 ( 13 0 ) capacitor c=0.015325f //x=70.275 //y=0.72
c61 ( 9 0 ) capacitor c=0.00772076f //x=69.39 //y=0.805
c62 ( 5 0 ) capacitor c=0.0167789f //x=69.305 //y=1.77
c63 ( 1 0 ) capacitor c=0.00710458f //x=68.42 //y=1.685
r64 (  18 35 ) resistor r=5.4201 //w=0.17 //l=0.103078 //layer=li \
 //thickness=0.1 //x=69.475 //y=1.77 //x2=69.39 //y2=1.81
r65 (  18 35 ) resistor r=27.3797 //w=0.187 //l=0.4 //layer=li //thickness=0.1 \
 //x=69.475 //y=1.77 //x2=69.875 //y2=1.77
r66 (  17 35 ) resistor r=0.751729 //w=0.17 //l=0.085 //layer=li \
 //thickness=0.1 //x=70.275 //y=1.77 //x2=70.36 //y2=1.77
r67 (  17 35 ) resistor r=27.3797 //w=0.187 //l=0.4 //layer=li //thickness=0.1 \
 //x=70.275 //y=1.77 //x2=69.875 //y2=1.77
r68 (  14 35 ) resistor r=3.57586 //w=0.17 //l=0.103078 //layer=li \
 //thickness=0.1 //x=69.475 //y=0.72 //x2=69.39 //y2=0.68
r69 (  14 35 ) resistor r=27.3797 //w=0.187 //l=0.4 //layer=li //thickness=0.1 \
 //x=69.475 //y=0.72 //x2=69.875 //y2=0.72
r70 (  13 35 ) resistor r=0.751729 //w=0.17 //l=0.085 //layer=li \
 //thickness=0.1 //x=70.275 //y=0.72 //x2=70.36 //y2=0.72
r71 (  13 35 ) resistor r=27.3797 //w=0.187 //l=0.4 //layer=li //thickness=0.1 \
 //x=70.275 //y=0.72 //x2=69.875 //y2=0.72
r72 (  10 35 ) resistor r=1.40859 //w=0.34 //l=0.125 //layer=li \
 //thickness=0.1 //x=69.39 //y=1.685 //x2=69.39 //y2=1.81
r73 (  10 35 ) resistor r=42.0963 //w=0.187 //l=0.615 //layer=li \
 //thickness=0.1 //x=69.39 //y=1.685 //x2=69.39 //y2=1.07
r74 (  9 35 ) resistor r=3.57586 //w=0.17 //l=0.125 //layer=li //thickness=0.1 \
 //x=69.39 //y=0.805 //x2=69.39 //y2=0.68
r75 (  9 35 ) resistor r=18.139 //w=0.187 //l=0.265 //layer=li //thickness=0.1 \
 //x=69.39 //y=0.805 //x2=69.39 //y2=1.07
r76 (  6 35 ) resistor r=3.57586 //w=0.17 //l=0.103078 //layer=li \
 //thickness=0.1 //x=68.505 //y=1.77 //x2=68.42 //y2=1.81
r77 (  6 35 ) resistor r=27.3797 //w=0.187 //l=0.4 //layer=li //thickness=0.1 \
 //x=68.505 //y=1.77 //x2=68.905 //y2=1.77
r78 (  5 35 ) resistor r=5.4201 //w=0.17 //l=0.103078 //layer=li \
 //thickness=0.1 //x=69.305 //y=1.77 //x2=69.39 //y2=1.81
r79 (  5 35 ) resistor r=27.3797 //w=0.187 //l=0.4 //layer=li //thickness=0.1 \
 //x=69.305 //y=1.77 //x2=68.905 //y2=1.77
r80 (  1 35 ) resistor r=3.57586 //w=0.17 //l=0.125 //layer=li //thickness=0.1 \
 //x=68.42 //y=1.685 //x2=68.42 //y2=1.81
r81 (  1 35 ) resistor r=42.0963 //w=0.187 //l=0.615 //layer=li \
 //thickness=0.1 //x=68.42 //y=1.685 //x2=68.42 //y2=1.07
ends PM_TMRDFFSNRNQX1\%noxref_62

subckt PM_TMRDFFSNRNQX1\%noxref_63 ( 1 5 9 13 17 35 )
c59 ( 35 0 ) capacitor c=0.0691212f //x=73.095 //y=0.555
c60 ( 17 0 ) capacitor c=0.0190725f //x=75.085 //y=1.77
c61 ( 13 0 ) capacitor c=0.015325f //x=75.085 //y=0.72
c62 ( 9 0 ) capacitor c=0.00772076f //x=74.2 //y=0.805
c63 ( 5 0 ) capacitor c=0.0167589f //x=74.115 //y=1.77
c64 ( 1 0 ) capacitor c=0.00710458f //x=73.23 //y=1.685
r65 (  18 35 ) resistor r=5.4201 //w=0.17 //l=0.103078 //layer=li \
 //thickness=0.1 //x=74.285 //y=1.77 //x2=74.2 //y2=1.81
r66 (  18 35 ) resistor r=27.3797 //w=0.187 //l=0.4 //layer=li //thickness=0.1 \
 //x=74.285 //y=1.77 //x2=74.685 //y2=1.77
r67 (  17 35 ) resistor r=0.751729 //w=0.17 //l=0.085 //layer=li \
 //thickness=0.1 //x=75.085 //y=1.77 //x2=75.17 //y2=1.77
r68 (  17 35 ) resistor r=27.3797 //w=0.187 //l=0.4 //layer=li //thickness=0.1 \
 //x=75.085 //y=1.77 //x2=74.685 //y2=1.77
r69 (  14 35 ) resistor r=3.57586 //w=0.17 //l=0.103078 //layer=li \
 //thickness=0.1 //x=74.285 //y=0.72 //x2=74.2 //y2=0.68
r70 (  14 35 ) resistor r=27.3797 //w=0.187 //l=0.4 //layer=li //thickness=0.1 \
 //x=74.285 //y=0.72 //x2=74.685 //y2=0.72
r71 (  13 35 ) resistor r=0.751729 //w=0.17 //l=0.085 //layer=li \
 //thickness=0.1 //x=75.085 //y=0.72 //x2=75.17 //y2=0.72
r72 (  13 35 ) resistor r=27.3797 //w=0.187 //l=0.4 //layer=li //thickness=0.1 \
 //x=75.085 //y=0.72 //x2=74.685 //y2=0.72
r73 (  10 35 ) resistor r=1.40859 //w=0.34 //l=0.125 //layer=li \
 //thickness=0.1 //x=74.2 //y=1.685 //x2=74.2 //y2=1.81
r74 (  10 35 ) resistor r=42.0963 //w=0.187 //l=0.615 //layer=li \
 //thickness=0.1 //x=74.2 //y=1.685 //x2=74.2 //y2=1.07
r75 (  9 35 ) resistor r=3.57586 //w=0.17 //l=0.125 //layer=li //thickness=0.1 \
 //x=74.2 //y=0.805 //x2=74.2 //y2=0.68
r76 (  9 35 ) resistor r=18.139 //w=0.187 //l=0.265 //layer=li //thickness=0.1 \
 //x=74.2 //y=0.805 //x2=74.2 //y2=1.07
r77 (  6 35 ) resistor r=3.57586 //w=0.17 //l=0.103078 //layer=li \
 //thickness=0.1 //x=73.315 //y=1.77 //x2=73.23 //y2=1.81
r78 (  6 35 ) resistor r=27.3797 //w=0.187 //l=0.4 //layer=li //thickness=0.1 \
 //x=73.315 //y=1.77 //x2=73.715 //y2=1.77
r79 (  5 35 ) resistor r=5.4201 //w=0.17 //l=0.103078 //layer=li \
 //thickness=0.1 //x=74.115 //y=1.77 //x2=74.2 //y2=1.81
r80 (  5 35 ) resistor r=27.3797 //w=0.187 //l=0.4 //layer=li //thickness=0.1 \
 //x=74.115 //y=1.77 //x2=73.715 //y2=1.77
r81 (  1 35 ) resistor r=3.57586 //w=0.17 //l=0.125 //layer=li //thickness=0.1 \
 //x=73.23 //y=1.685 //x2=73.23 //y2=1.81
r82 (  1 35 ) resistor r=42.0963 //w=0.187 //l=0.615 //layer=li \
 //thickness=0.1 //x=73.23 //y=1.685 //x2=73.23 //y2=1.07
ends PM_TMRDFFSNRNQX1\%noxref_63

subckt PM_TMRDFFSNRNQX1\%noxref_64 ( 1 5 9 13 17 35 )
c58 ( 35 0 ) capacitor c=0.069559f //x=77.905 //y=0.555
c59 ( 17 0 ) capacitor c=0.0190918f //x=79.895 //y=1.77
c60 ( 13 0 ) capacitor c=0.0153483f //x=79.895 //y=0.72
c61 ( 9 0 ) capacitor c=0.00772076f //x=79.01 //y=0.805
c62 ( 5 0 ) capacitor c=0.0168501f //x=78.925 //y=1.77
c63 ( 1 0 ) capacitor c=0.00710458f //x=78.04 //y=1.685
r64 (  18 35 ) resistor r=5.4201 //w=0.17 //l=0.103078 //layer=li \
 //thickness=0.1 //x=79.095 //y=1.77 //x2=79.01 //y2=1.81
r65 (  18 35 ) resistor r=27.3797 //w=0.187 //l=0.4 //layer=li //thickness=0.1 \
 //x=79.095 //y=1.77 //x2=79.495 //y2=1.77
r66 (  17 35 ) resistor r=0.751729 //w=0.17 //l=0.085 //layer=li \
 //thickness=0.1 //x=79.895 //y=1.77 //x2=79.98 //y2=1.77
r67 (  17 35 ) resistor r=27.3797 //w=0.187 //l=0.4 //layer=li //thickness=0.1 \
 //x=79.895 //y=1.77 //x2=79.495 //y2=1.77
r68 (  14 35 ) resistor r=3.57586 //w=0.17 //l=0.103078 //layer=li \
 //thickness=0.1 //x=79.095 //y=0.72 //x2=79.01 //y2=0.68
r69 (  14 35 ) resistor r=27.3797 //w=0.187 //l=0.4 //layer=li //thickness=0.1 \
 //x=79.095 //y=0.72 //x2=79.495 //y2=0.72
r70 (  13 35 ) resistor r=0.751729 //w=0.17 //l=0.085 //layer=li \
 //thickness=0.1 //x=79.895 //y=0.72 //x2=79.98 //y2=0.72
r71 (  13 35 ) resistor r=27.3797 //w=0.187 //l=0.4 //layer=li //thickness=0.1 \
 //x=79.895 //y=0.72 //x2=79.495 //y2=0.72
r72 (  10 35 ) resistor r=1.40859 //w=0.34 //l=0.125 //layer=li \
 //thickness=0.1 //x=79.01 //y=1.685 //x2=79.01 //y2=1.81
r73 (  10 35 ) resistor r=42.0963 //w=0.187 //l=0.615 //layer=li \
 //thickness=0.1 //x=79.01 //y=1.685 //x2=79.01 //y2=1.07
r74 (  9 35 ) resistor r=3.57586 //w=0.17 //l=0.125 //layer=li //thickness=0.1 \
 //x=79.01 //y=0.805 //x2=79.01 //y2=0.68
r75 (  9 35 ) resistor r=18.139 //w=0.187 //l=0.265 //layer=li //thickness=0.1 \
 //x=79.01 //y=0.805 //x2=79.01 //y2=1.07
r76 (  6 35 ) resistor r=3.57586 //w=0.17 //l=0.103078 //layer=li \
 //thickness=0.1 //x=78.125 //y=1.77 //x2=78.04 //y2=1.81
r77 (  6 35 ) resistor r=27.3797 //w=0.187 //l=0.4 //layer=li //thickness=0.1 \
 //x=78.125 //y=1.77 //x2=78.525 //y2=1.77
r78 (  5 35 ) resistor r=5.4201 //w=0.17 //l=0.103078 //layer=li \
 //thickness=0.1 //x=78.925 //y=1.77 //x2=79.01 //y2=1.81
r79 (  5 35 ) resistor r=27.3797 //w=0.187 //l=0.4 //layer=li //thickness=0.1 \
 //x=78.925 //y=1.77 //x2=78.525 //y2=1.77
r80 (  1 35 ) resistor r=3.57586 //w=0.17 //l=0.125 //layer=li //thickness=0.1 \
 //x=78.04 //y=1.685 //x2=78.04 //y2=1.81
r81 (  1 35 ) resistor r=42.0963 //w=0.187 //l=0.615 //layer=li \
 //thickness=0.1 //x=78.04 //y=1.685 //x2=78.04 //y2=1.07
ends PM_TMRDFFSNRNQX1\%noxref_64

subckt PM_TMRDFFSNRNQX1\%noxref_65 ( 1 5 9 13 17 35 )
c59 ( 35 0 ) capacitor c=0.0691304f //x=82.715 //y=0.555
c60 ( 17 0 ) capacitor c=0.0190725f //x=84.705 //y=1.77
c61 ( 13 0 ) capacitor c=0.015325f //x=84.705 //y=0.72
c62 ( 9 0 ) capacitor c=0.00772076f //x=83.82 //y=0.805
c63 ( 5 0 ) capacitor c=0.0167688f //x=83.735 //y=1.77
c64 ( 1 0 ) capacitor c=0.00710458f //x=82.85 //y=1.685
r65 (  18 35 ) resistor r=5.4201 //w=0.17 //l=0.103078 //layer=li \
 //thickness=0.1 //x=83.905 //y=1.77 //x2=83.82 //y2=1.81
r66 (  18 35 ) resistor r=27.3797 //w=0.187 //l=0.4 //layer=li //thickness=0.1 \
 //x=83.905 //y=1.77 //x2=84.305 //y2=1.77
r67 (  17 35 ) resistor r=0.751729 //w=0.17 //l=0.085 //layer=li \
 //thickness=0.1 //x=84.705 //y=1.77 //x2=84.79 //y2=1.77
r68 (  17 35 ) resistor r=27.3797 //w=0.187 //l=0.4 //layer=li //thickness=0.1 \
 //x=84.705 //y=1.77 //x2=84.305 //y2=1.77
r69 (  14 35 ) resistor r=3.57586 //w=0.17 //l=0.103078 //layer=li \
 //thickness=0.1 //x=83.905 //y=0.72 //x2=83.82 //y2=0.68
r70 (  14 35 ) resistor r=27.3797 //w=0.187 //l=0.4 //layer=li //thickness=0.1 \
 //x=83.905 //y=0.72 //x2=84.305 //y2=0.72
r71 (  13 35 ) resistor r=0.751729 //w=0.17 //l=0.085 //layer=li \
 //thickness=0.1 //x=84.705 //y=0.72 //x2=84.79 //y2=0.72
r72 (  13 35 ) resistor r=27.3797 //w=0.187 //l=0.4 //layer=li //thickness=0.1 \
 //x=84.705 //y=0.72 //x2=84.305 //y2=0.72
r73 (  10 35 ) resistor r=1.40859 //w=0.34 //l=0.125 //layer=li \
 //thickness=0.1 //x=83.82 //y=1.685 //x2=83.82 //y2=1.81
r74 (  10 35 ) resistor r=42.0963 //w=0.187 //l=0.615 //layer=li \
 //thickness=0.1 //x=83.82 //y=1.685 //x2=83.82 //y2=1.07
r75 (  9 35 ) resistor r=3.57586 //w=0.17 //l=0.125 //layer=li //thickness=0.1 \
 //x=83.82 //y=0.805 //x2=83.82 //y2=0.68
r76 (  9 35 ) resistor r=18.139 //w=0.187 //l=0.265 //layer=li //thickness=0.1 \
 //x=83.82 //y=0.805 //x2=83.82 //y2=1.07
r77 (  6 35 ) resistor r=3.57586 //w=0.17 //l=0.103078 //layer=li \
 //thickness=0.1 //x=82.935 //y=1.77 //x2=82.85 //y2=1.81
r78 (  6 35 ) resistor r=27.3797 //w=0.187 //l=0.4 //layer=li //thickness=0.1 \
 //x=82.935 //y=1.77 //x2=83.335 //y2=1.77
r79 (  5 35 ) resistor r=5.4201 //w=0.17 //l=0.103078 //layer=li \
 //thickness=0.1 //x=83.735 //y=1.77 //x2=83.82 //y2=1.81
r80 (  5 35 ) resistor r=27.3797 //w=0.187 //l=0.4 //layer=li //thickness=0.1 \
 //x=83.735 //y=1.77 //x2=83.335 //y2=1.77
r81 (  1 35 ) resistor r=3.57586 //w=0.17 //l=0.125 //layer=li //thickness=0.1 \
 //x=82.85 //y=1.685 //x2=82.85 //y2=1.81
r82 (  1 35 ) resistor r=42.0963 //w=0.187 //l=0.615 //layer=li \
 //thickness=0.1 //x=82.85 //y=1.685 //x2=82.85 //y2=1.07
ends PM_TMRDFFSNRNQX1\%noxref_65

subckt PM_TMRDFFSNRNQX1\%noxref_66 ( 1 5 9 10 13 17 29 )
c67 ( 29 0 ) capacitor c=0.0764215f //x=87.63 //y=0.545
c68 ( 17 0 ) capacitor c=0.00678917f //x=89.705 //y=0.795
c69 ( 13 0 ) capacitor c=0.0154047f //x=89.62 //y=0.71
c70 ( 10 0 ) capacitor c=0.00748068f //x=88.735 //y=1.675
c71 ( 9 0 ) capacitor c=0.00770028f //x=88.735 //y=0.795
c72 ( 5 0 ) capacitor c=0.0203276f //x=88.65 //y=1.76
c73 ( 1 0 ) capacitor c=0.00454619f //x=87.765 //y=1.675
r74 (  17 29 ) resistor r=3.57586 //w=0.17 //l=0.125 //layer=li \
 //thickness=0.1 //x=89.705 //y=0.795 //x2=89.705 //y2=0.67
r75 (  17 29 ) resistor r=41.4118 //w=0.187 //l=0.605 //layer=li \
 //thickness=0.1 //x=89.705 //y=0.795 //x2=89.705 //y2=1.4
r76 (  14 29 ) resistor r=3.57586 //w=0.17 //l=0.103078 //layer=li \
 //thickness=0.1 //x=88.82 //y=0.71 //x2=88.735 //y2=0.67
r77 (  14 29 ) resistor r=27.0374 //w=0.187 //l=0.395 //layer=li \
 //thickness=0.1 //x=88.82 //y=0.71 //x2=89.215 //y2=0.71
r78 (  13 29 ) resistor r=3.57586 //w=0.17 //l=0.103078 //layer=li \
 //thickness=0.1 //x=89.62 //y=0.71 //x2=89.705 //y2=0.67
r79 (  13 29 ) resistor r=27.7219 //w=0.187 //l=0.405 //layer=li \
 //thickness=0.1 //x=89.62 //y=0.71 //x2=89.215 //y2=0.71
r80 (  10 29 ) resistor r=3.57586 //w=0.17 //l=0.125 //layer=li \
 //thickness=0.1 //x=88.735 //y=1.675 //x2=88.735 //y2=1.8
r81 (  10 29 ) resistor r=42.0963 //w=0.187 //l=0.615 //layer=li \
 //thickness=0.1 //x=88.735 //y=1.675 //x2=88.735 //y2=1.06
r82 (  9 29 ) resistor r=3.57586 //w=0.17 //l=0.125 //layer=li //thickness=0.1 \
 //x=88.735 //y=0.795 //x2=88.735 //y2=0.67
r83 (  9 29 ) resistor r=18.139 //w=0.187 //l=0.265 //layer=li //thickness=0.1 \
 //x=88.735 //y=0.795 //x2=88.735 //y2=1.06
r84 (  6 29 ) resistor r=3.57586 //w=0.17 //l=0.103078 //layer=li \
 //thickness=0.1 //x=87.85 //y=1.76 //x2=87.765 //y2=1.8
r85 (  6 29 ) resistor r=27.3797 //w=0.187 //l=0.4 //layer=li //thickness=0.1 \
 //x=87.85 //y=1.76 //x2=88.25 //y2=1.76
r86 (  5 29 ) resistor r=3.57586 //w=0.17 //l=0.103078 //layer=li \
 //thickness=0.1 //x=88.65 //y=1.76 //x2=88.735 //y2=1.8
r87 (  5 29 ) resistor r=27.3797 //w=0.187 //l=0.4 //layer=li //thickness=0.1 \
 //x=88.65 //y=1.76 //x2=88.25 //y2=1.76
r88 (  1 29 ) resistor r=3.57586 //w=0.17 //l=0.125 //layer=li //thickness=0.1 \
 //x=87.765 //y=1.675 //x2=87.765 //y2=1.8
r89 (  1 29 ) resistor r=42.0963 //w=0.187 //l=0.615 //layer=li \
 //thickness=0.1 //x=87.765 //y=1.675 //x2=87.765 //y2=1.06
ends PM_TMRDFFSNRNQX1\%noxref_66

subckt PM_TMRDFFSNRNQX1\%noxref_68 ( 1 5 9 10 13 17 29 )
c62 ( 29 0 ) capacitor c=0.0738181f //x=90.96 //y=0.545
c63 ( 17 0 ) capacitor c=0.00678917f //x=93.035 //y=0.795
c64 ( 13 0 ) capacitor c=0.0158009f //x=92.95 //y=0.71
c65 ( 10 0 ) capacitor c=0.00864691f //x=92.065 //y=1.675
c66 ( 9 0 ) capacitor c=0.00770028f //x=92.065 //y=0.795
c67 ( 5 0 ) capacitor c=0.0176916f //x=91.98 //y=1.76
c68 ( 1 0 ) capacitor c=0.00845775f //x=91.095 //y=1.675
r69 (  17 29 ) resistor r=3.57586 //w=0.17 //l=0.125 //layer=li \
 //thickness=0.1 //x=93.035 //y=0.795 //x2=93.035 //y2=0.67
r70 (  17 29 ) resistor r=41.4118 //w=0.187 //l=0.605 //layer=li \
 //thickness=0.1 //x=93.035 //y=0.795 //x2=93.035 //y2=1.4
r71 (  14 29 ) resistor r=3.57586 //w=0.17 //l=0.103078 //layer=li \
 //thickness=0.1 //x=92.15 //y=0.71 //x2=92.065 //y2=0.67
r72 (  14 29 ) resistor r=27.3797 //w=0.187 //l=0.4 //layer=li //thickness=0.1 \
 //x=92.15 //y=0.71 //x2=92.55 //y2=0.71
r73 (  13 29 ) resistor r=3.57586 //w=0.17 //l=0.103078 //layer=li \
 //thickness=0.1 //x=92.95 //y=0.71 //x2=93.035 //y2=0.67
r74 (  13 29 ) resistor r=27.3797 //w=0.187 //l=0.4 //layer=li //thickness=0.1 \
 //x=92.95 //y=0.71 //x2=92.55 //y2=0.71
r75 (  10 29 ) resistor r=3.57586 //w=0.17 //l=0.125 //layer=li \
 //thickness=0.1 //x=92.065 //y=1.675 //x2=92.065 //y2=1.8
r76 (  10 29 ) resistor r=42.0963 //w=0.187 //l=0.615 //layer=li \
 //thickness=0.1 //x=92.065 //y=1.675 //x2=92.065 //y2=1.06
r77 (  9 29 ) resistor r=3.57586 //w=0.17 //l=0.125 //layer=li //thickness=0.1 \
 //x=92.065 //y=0.795 //x2=92.065 //y2=0.67
r78 (  9 29 ) resistor r=18.139 //w=0.187 //l=0.265 //layer=li //thickness=0.1 \
 //x=92.065 //y=0.795 //x2=92.065 //y2=1.06
r79 (  6 29 ) resistor r=3.57586 //w=0.17 //l=0.103078 //layer=li \
 //thickness=0.1 //x=91.18 //y=1.76 //x2=91.095 //y2=1.8
r80 (  6 29 ) resistor r=27.3797 //w=0.187 //l=0.4 //layer=li //thickness=0.1 \
 //x=91.18 //y=1.76 //x2=91.58 //y2=1.76
r81 (  5 29 ) resistor r=3.57586 //w=0.17 //l=0.103078 //layer=li \
 //thickness=0.1 //x=91.98 //y=1.76 //x2=92.065 //y2=1.8
r82 (  5 29 ) resistor r=27.3797 //w=0.187 //l=0.4 //layer=li //thickness=0.1 \
 //x=91.98 //y=1.76 //x2=91.58 //y2=1.76
r83 (  1 29 ) resistor r=3.57586 //w=0.17 //l=0.125 //layer=li //thickness=0.1 \
 //x=91.095 //y=1.675 //x2=91.095 //y2=1.8
r84 (  1 29 ) resistor r=42.0963 //w=0.187 //l=0.615 //layer=li \
 //thickness=0.1 //x=91.095 //y=1.675 //x2=91.095 //y2=1.06
ends PM_TMRDFFSNRNQX1\%noxref_68

subckt PM_TMRDFFSNRNQX1\%noxref_69 ( 1 5 9 10 13 17 29 )
c69 ( 29 0 ) capacitor c=0.0677164f //x=94.29 //y=0.545
c70 ( 17 0 ) capacitor c=0.00709795f //x=96.365 //y=0.795
c71 ( 13 0 ) capacitor c=0.0152565f //x=96.28 //y=0.71
c72 ( 10 0 ) capacitor c=0.00749806f //x=95.395 //y=1.675
c73 ( 9 0 ) capacitor c=0.00770028f //x=95.395 //y=0.795
c74 ( 5 0 ) capacitor c=0.0236235f //x=95.31 //y=1.76
c75 ( 1 0 ) capacitor c=0.00498238f //x=94.425 //y=1.675
r76 (  17 29 ) resistor r=3.57586 //w=0.17 //l=0.125 //layer=li \
 //thickness=0.1 //x=96.365 //y=0.795 //x2=96.365 //y2=0.67
r77 (  17 29 ) resistor r=18.139 //w=0.187 //l=0.265 //layer=li \
 //thickness=0.1 //x=96.365 //y=0.795 //x2=96.365 //y2=1.06
r78 (  14 29 ) resistor r=3.57586 //w=0.17 //l=0.103078 //layer=li \
 //thickness=0.1 //x=95.48 //y=0.71 //x2=95.395 //y2=0.67
r79 (  14 29 ) resistor r=27.3797 //w=0.187 //l=0.4 //layer=li //thickness=0.1 \
 //x=95.48 //y=0.71 //x2=95.88 //y2=0.71
r80 (  13 29 ) resistor r=3.57586 //w=0.17 //l=0.103078 //layer=li \
 //thickness=0.1 //x=96.28 //y=0.71 //x2=96.365 //y2=0.67
r81 (  13 29 ) resistor r=27.3797 //w=0.187 //l=0.4 //layer=li //thickness=0.1 \
 //x=96.28 //y=0.71 //x2=95.88 //y2=0.71
r82 (  10 29 ) resistor r=3.57586 //w=0.17 //l=0.125 //layer=li \
 //thickness=0.1 //x=95.395 //y=1.675 //x2=95.395 //y2=1.8
r83 (  10 29 ) resistor r=42.0963 //w=0.187 //l=0.615 //layer=li \
 //thickness=0.1 //x=95.395 //y=1.675 //x2=95.395 //y2=1.06
r84 (  9 29 ) resistor r=3.57586 //w=0.17 //l=0.125 //layer=li //thickness=0.1 \
 //x=95.395 //y=0.795 //x2=95.395 //y2=0.67
r85 (  9 29 ) resistor r=18.139 //w=0.187 //l=0.265 //layer=li //thickness=0.1 \
 //x=95.395 //y=0.795 //x2=95.395 //y2=1.06
r86 (  6 29 ) resistor r=3.57586 //w=0.17 //l=0.103078 //layer=li \
 //thickness=0.1 //x=94.51 //y=1.76 //x2=94.425 //y2=1.8
r87 (  6 29 ) resistor r=27.3797 //w=0.187 //l=0.4 //layer=li //thickness=0.1 \
 //x=94.51 //y=1.76 //x2=94.91 //y2=1.76
r88 (  5 29 ) resistor r=3.57586 //w=0.17 //l=0.103078 //layer=li \
 //thickness=0.1 //x=95.31 //y=1.76 //x2=95.395 //y2=1.8
r89 (  5 29 ) resistor r=27.3797 //w=0.187 //l=0.4 //layer=li //thickness=0.1 \
 //x=95.31 //y=1.76 //x2=94.91 //y2=1.76
r90 (  1 29 ) resistor r=3.57586 //w=0.17 //l=0.125 //layer=li //thickness=0.1 \
 //x=94.425 //y=1.675 //x2=94.425 //y2=1.8
r91 (  1 29 ) resistor r=42.0963 //w=0.187 //l=0.615 //layer=li \
 //thickness=0.1 //x=94.425 //y=1.675 //x2=94.425 //y2=1.06
ends PM_TMRDFFSNRNQX1\%noxref_69
