// File: TMRDFFSNRNQX1.spi.pex
// Created: Sun Apr 12 08:37:37 2026
// Program "Calibre xRC"
// Version "v2023.2_27.15"
// Nominal Temperature: 30C
// Circuit Temperature: 30C
//
simulator lang=spectre
subckt PM_TMRDFFSNRNQX1\%noxref_1 ( 1 3 6 7 9 10 11 12 14 15 16 17 18 19 20 21 \
 22 23 24 25 28 31 37 45 49 63 66 67 69 70 73 81 89 106 115 120 129 133 134 \
 135 136 137 138 139 140 141 142 143 145 151 152 153 154 158 159 160 161 162 \
 164 170 171 172 173 193 195 196 197 )
c412 ( 193 0 ) capacitor c=0.00885916f //x=3.885 //y=1.095
c413 ( 173 0 ) capacitor c=0.0612936f //x=11.495 //y=4.97
c414 ( 172 0 ) capacitor c=0.0376642f //x=11.785 //y=4.97
c415 ( 171 0 ) capacitor c=0.0346489f //x=11.45 //y=1.4
c416 ( 170 0 ) capacitor c=0.018692f //x=11.45 //y=1.055
c417 ( 164 0 ) capacitor c=0.0137077f //x=11.295 //y=1.555
c418 ( 162 0 ) capacitor c=0.0158585f //x=11.295 //y=0.9
c419 ( 161 0 ) capacitor c=0.0979536f //x=10.92 //y=2.095
c420 ( 160 0 ) capacitor c=0.0229444f //x=10.92 //y=1.71
c421 ( 159 0 ) capacitor c=0.0234359f //x=10.92 //y=1.4
c422 ( 158 0 ) capacitor c=0.019815f //x=10.92 //y=1.055
c423 ( 154 0 ) capacitor c=0.0612936f //x=6.685 //y=4.97
c424 ( 153 0 ) capacitor c=0.0376642f //x=6.975 //y=4.97
c425 ( 152 0 ) capacitor c=0.0346489f //x=6.64 //y=1.4
c426 ( 151 0 ) capacitor c=0.018692f //x=6.64 //y=1.055
c427 ( 145 0 ) capacitor c=0.0137077f //x=6.485 //y=1.555
c428 ( 143 0 ) capacitor c=0.0158585f //x=6.485 //y=0.9
c429 ( 142 0 ) capacitor c=0.0996161f //x=6.11 //y=2.095
c430 ( 141 0 ) capacitor c=0.0229444f //x=6.11 //y=1.71
c431 ( 140 0 ) capacitor c=0.0234359f //x=6.11 //y=1.4
c432 ( 139 0 ) capacitor c=0.019815f //x=6.11 //y=1.055
c433 ( 138 0 ) capacitor c=0.110208f //x=11.86 //y=6.2
c434 ( 137 0 ) capacitor c=0.158957f //x=11.42 //y=6.2
c435 ( 136 0 ) capacitor c=0.110208f //x=7.05 //y=6.2
c436 ( 135 0 ) capacitor c=0.158957f //x=6.61 //y=6.2
c437 ( 129 0 ) capacitor c=0.0014751f //x=11.22 //y=4.88
c438 ( 120 0 ) capacitor c=9.93222e-19 //x=11.22 //y=2.26
c439 ( 115 0 ) capacitor c=0.0014751f //x=6.41 //y=4.88
c440 ( 106 0 ) capacitor c=9.93222e-19 //x=6.41 //y=2.26
c441 ( 89 0 ) capacitor c=0.0293562f //x=3.78 //y=5.56
c442 ( 81 0 ) capacitor c=0.029137f //x=2.9 //y=5.56
c443 ( 73 0 ) capacitor c=0.0278099f //x=2.02 //y=5.56
c444 ( 70 0 ) capacitor c=0.0487028f //x=11.06 //y=2.785
c445 ( 69 0 ) capacitor c=7.81966e-19 //x=11.22 //y=2.785
c446 ( 67 0 ) capacitor c=7.81966e-19 //x=6.575 //y=2.785
c447 ( 66 0 ) capacitor c=0.0212437f //x=6.255 //y=2.785
c448 ( 63 0 ) capacitor c=0.00113895f //x=4.725 //y=2.785
c449 ( 49 0 ) capacitor c=0.0154699f //x=11.22 //y=2.77
c450 ( 45 0 ) capacitor c=0.0148628f //x=6.41 //y=2.77
c451 ( 37 0 ) capacitor c=0.0144706f //x=4.56 //y=2.77
c452 ( 31 0 ) capacitor c=0.00103877f //x=3.78 //y=5.335
c453 ( 28 0 ) capacitor c=0.00794348f //x=2.9 //y=5.335
c454 ( 25 0 ) capacitor c=0.0123281f //x=2.022 //y=5.335
c455 ( 24 0 ) capacitor c=0.0598642f //x=11.22 //y=4.755
c456 ( 23 0 ) capacitor c=0.0130987f //x=11.22 //y=2.945
c457 ( 22 0 ) capacitor c=0.00473602f //x=11.22 //y=2.625
c458 ( 21 0 ) capacitor c=0.00495287f //x=11.22 //y=2.375
c459 ( 20 0 ) capacitor c=0.0665949f //x=6.41 //y=4.755
c460 ( 19 0 ) capacitor c=0.0129702f //x=6.41 //y=2.945
c461 ( 18 0 ) capacitor c=0.00482124f //x=6.41 //y=2.625
c462 ( 17 0 ) capacitor c=0.00495287f //x=6.41 //y=2.375
c463 ( 16 0 ) capacitor c=0.070752f //x=4.56 //y=5.25
c464 ( 15 0 ) capacitor c=0.0123217f //x=4.56 //y=2.945
c465 ( 14 0 ) capacitor c=0.0179579f //x=4.56 //y=2.625
c466 ( 12 0 ) capacitor c=0.00584263f //x=4.16 //y=1.845
c467 ( 11 0 ) capacitor c=0.0129788f //x=4.475 //y=1.845
c468 ( 10 0 ) capacitor c=0.0167992f //x=4.075 //y=1.76
c469 ( 9 0 ) capacitor c=0.0110957f //x=4.075 //y=1.305
c470 ( 7 0 ) capacitor c=0.0248757f //x=4.475 //y=5.335
c471 ( 6 0 ) capacitor c=0.00933983f //x=3.78 //y=5.56
c472 ( 3 0 ) capacitor c=0.0200404f //x=3.665 //y=5.335
c473 ( 1 0 ) capacitor c=0.0155354f //x=2.78 //y=5.335
r474 (  172 174 ) resistor r=26.9307 //w=0.15 //l=0.106066 //layer=ply \
 //thickness=0.18 //x=11.785 //y=4.97 //x2=11.86 //y2=5.045
r475 (  172 173 ) resistor r=148.702 //w=0.094 //l=0.29 //layer=ply \
 //thickness=0.18 //x=11.785 //y=4.97 //x2=11.495 //y2=4.97
r476 (  171 192 ) resistor r=45.1352 //w=0.168 //l=0.173853 //layer=ply \
 //thickness=0.18 //x=11.45 //y=1.4 //x2=11.41 //y2=1.555
r477 (  170 191 ) resistor r=45.1352 //w=0.168 //l=0.173853 //layer=ply \
 //thickness=0.18 //x=11.45 //y=1.055 //x2=11.41 //y2=0.9
r478 (  170 171 ) resistor r=176.904 //w=0.094 //l=0.345 //layer=ply \
 //thickness=0.18 //x=11.45 //y=1.055 //x2=11.45 //y2=1.4
r479 (  167 173 ) resistor r=22.7971 //w=0.269 //l=0.106066 //layer=ply \
 //thickness=0.18 //x=11.42 //y=5.045 //x2=11.495 //y2=4.97
r480 (  167 190 ) resistor r=35.8364 //w=0.269 //l=0.270185 //layer=ply \
 //thickness=0.18 //x=11.42 //y=5.045 //x2=11.22 //y2=4.88
r481 (  165 186 ) resistor r=10.701 //w=0.21 //l=0.115 //layer=ply \
 //thickness=0.18 //x=11.075 //y=1.555 //x2=10.96 //y2=1.555
r482 (  164 192 ) resistor r=5.52526 //w=0.168 //l=0.115 //layer=ply \
 //thickness=0.18 //x=11.295 //y=1.555 //x2=11.41 //y2=1.555
r483 (  163 185 ) resistor r=5.52526 //w=0.168 //l=0.115 //layer=ply \
 //thickness=0.18 //x=11.075 //y=0.9 //x2=10.96 //y2=0.9
r484 (  162 191 ) resistor r=5.52526 //w=0.168 //l=0.115 //layer=ply \
 //thickness=0.18 //x=11.295 //y=0.9 //x2=11.41 //y2=0.9
r485 (  162 163 ) resistor r=112.809 //w=0.094 //l=0.22 //layer=ply \
 //thickness=0.18 //x=11.295 //y=0.9 //x2=11.075 //y2=0.9
r486 (  161 188 ) resistor r=58.7805 //w=0.246 //l=0.373497 //layer=ply \
 //thickness=0.18 //x=10.92 //y=2.095 //x2=11.22 //y2=2.26
r487 (  160 186 ) resistor r=39.5823 //w=0.21 //l=0.173853 //layer=ply \
 //thickness=0.18 //x=10.92 //y=1.71 //x2=10.96 //y2=1.555
r488 (  160 161 ) resistor r=197.415 //w=0.094 //l=0.385 //layer=ply \
 //thickness=0.18 //x=10.92 //y=1.71 //x2=10.92 //y2=2.095
r489 (  159 186 ) resistor r=39.5823 //w=0.21 //l=0.173853 //layer=ply \
 //thickness=0.18 //x=10.92 //y=1.4 //x2=10.96 //y2=1.555
r490 (  158 185 ) resistor r=45.1352 //w=0.168 //l=0.173853 //layer=ply \
 //thickness=0.18 //x=10.92 //y=1.055 //x2=10.96 //y2=0.9
r491 (  158 159 ) resistor r=176.904 //w=0.094 //l=0.345 //layer=ply \
 //thickness=0.18 //x=10.92 //y=1.055 //x2=10.92 //y2=1.4
r492 (  153 155 ) resistor r=26.9307 //w=0.15 //l=0.106066 //layer=ply \
 //thickness=0.18 //x=6.975 //y=4.97 //x2=7.05 //y2=5.045
r493 (  153 154 ) resistor r=148.702 //w=0.094 //l=0.29 //layer=ply \
 //thickness=0.18 //x=6.975 //y=4.97 //x2=6.685 //y2=4.97
r494 (  152 184 ) resistor r=45.1352 //w=0.168 //l=0.173853 //layer=ply \
 //thickness=0.18 //x=6.64 //y=1.4 //x2=6.6 //y2=1.555
r495 (  151 183 ) resistor r=45.1352 //w=0.168 //l=0.173853 //layer=ply \
 //thickness=0.18 //x=6.64 //y=1.055 //x2=6.6 //y2=0.9
r496 (  151 152 ) resistor r=176.904 //w=0.094 //l=0.345 //layer=ply \
 //thickness=0.18 //x=6.64 //y=1.055 //x2=6.64 //y2=1.4
r497 (  148 154 ) resistor r=22.7971 //w=0.269 //l=0.106066 //layer=ply \
 //thickness=0.18 //x=6.61 //y=5.045 //x2=6.685 //y2=4.97
r498 (  148 182 ) resistor r=35.8364 //w=0.269 //l=0.270185 //layer=ply \
 //thickness=0.18 //x=6.61 //y=5.045 //x2=6.41 //y2=4.88
r499 (  146 178 ) resistor r=10.701 //w=0.21 //l=0.115 //layer=ply \
 //thickness=0.18 //x=6.265 //y=1.555 //x2=6.15 //y2=1.555
r500 (  145 184 ) resistor r=5.52526 //w=0.168 //l=0.115 //layer=ply \
 //thickness=0.18 //x=6.485 //y=1.555 //x2=6.6 //y2=1.555
r501 (  144 177 ) resistor r=5.52526 //w=0.168 //l=0.115 //layer=ply \
 //thickness=0.18 //x=6.265 //y=0.9 //x2=6.15 //y2=0.9
r502 (  143 183 ) resistor r=5.52526 //w=0.168 //l=0.115 //layer=ply \
 //thickness=0.18 //x=6.485 //y=0.9 //x2=6.6 //y2=0.9
r503 (  143 144 ) resistor r=112.809 //w=0.094 //l=0.22 //layer=ply \
 //thickness=0.18 //x=6.485 //y=0.9 //x2=6.265 //y2=0.9
r504 (  142 180 ) resistor r=58.7805 //w=0.246 //l=0.373497 //layer=ply \
 //thickness=0.18 //x=6.11 //y=2.095 //x2=6.41 //y2=2.26
r505 (  141 178 ) resistor r=39.5823 //w=0.21 //l=0.173853 //layer=ply \
 //thickness=0.18 //x=6.11 //y=1.71 //x2=6.15 //y2=1.555
r506 (  141 142 ) resistor r=197.415 //w=0.094 //l=0.385 //layer=ply \
 //thickness=0.18 //x=6.11 //y=1.71 //x2=6.11 //y2=2.095
r507 (  140 178 ) resistor r=39.5823 //w=0.21 //l=0.173853 //layer=ply \
 //thickness=0.18 //x=6.11 //y=1.4 //x2=6.15 //y2=1.555
r508 (  139 177 ) resistor r=45.1352 //w=0.168 //l=0.173853 //layer=ply \
 //thickness=0.18 //x=6.11 //y=1.055 //x2=6.15 //y2=0.9
r509 (  139 140 ) resistor r=176.904 //w=0.094 //l=0.345 //layer=ply \
 //thickness=0.18 //x=6.11 //y=1.055 //x2=6.11 //y2=1.4
r510 (  138 174 ) resistor r=592.245 //w=0.094 //l=1.155 //layer=ply \
 //thickness=0.18 //x=11.86 //y=6.2 //x2=11.86 //y2=5.045
r511 (  137 167 ) resistor r=592.245 //w=0.094 //l=1.155 //layer=ply \
 //thickness=0.18 //x=11.42 //y=6.2 //x2=11.42 //y2=5.045
r512 (  136 155 ) resistor r=592.245 //w=0.094 //l=1.155 //layer=ply \
 //thickness=0.18 //x=7.05 //y=6.2 //x2=7.05 //y2=5.045
r513 (  135 148 ) resistor r=592.245 //w=0.094 //l=1.155 //layer=ply \
 //thickness=0.18 //x=6.61 //y=6.2 //x2=6.61 //y2=5.045
r514 (  134 164 ) resistor r=56.4043 //w=0.094 //l=0.11 //layer=ply \
 //thickness=0.18 //x=11.185 //y=1.555 //x2=11.295 //y2=1.555
r515 (  134 165 ) resistor r=56.4043 //w=0.094 //l=0.11 //layer=ply \
 //thickness=0.18 //x=11.185 //y=1.555 //x2=11.075 //y2=1.555
r516 (  133 145 ) resistor r=56.4043 //w=0.094 //l=0.11 //layer=ply \
 //thickness=0.18 //x=6.375 //y=1.555 //x2=6.485 //y2=1.555
r517 (  133 146 ) resistor r=56.4043 //w=0.094 //l=0.11 //layer=ply \
 //thickness=0.18 //x=6.375 //y=1.555 //x2=6.265 //y2=1.555
r518 (  129 190 ) resistor r=152 //w=0.17 //l=0.17 //layer=licon //count=1 \
 //x=11.22 //y=4.88 //x2=11.22 //y2=4.88
r519 (  120 188 ) resistor r=152 //w=0.17 //l=0.17 //layer=licon //count=1 \
 //x=11.22 //y=2.26 //x2=11.22 //y2=2.26
r520 (  115 182 ) resistor r=152 //w=0.17 //l=0.17 //layer=licon //count=1 \
 //x=6.41 //y=4.88 //x2=6.41 //y2=4.88
r521 (  106 180 ) resistor r=152 //w=0.17 //l=0.17 //layer=licon //count=1 \
 //x=6.41 //y=2.26 //x2=6.41 //y2=2.26
r522 (  89 197 ) resistor r=23.615 //w=0.187 //l=0.345 //layer=li \
 //thickness=0.1 //x=3.78 //y=5.56 //x2=3.78 //y2=5.905
r523 (  81 196 ) resistor r=23.615 //w=0.187 //l=0.345 //layer=li \
 //thickness=0.1 //x=2.9 //y=5.56 //x2=2.9 //y2=5.905
r524 (  73 195 ) resistor r=23.615 //w=0.187 //l=0.345 //layer=li \
 //thickness=0.1 //x=2.02 //y=5.56 //x2=2.02 //y2=5.905
r525 (  69 70 ) resistor r=0.10734 //w=0.281 //l=0.16 //layer=m2 \
 //thickness=0.36 //x=11.22 //y=2.785 //x2=11.06 //y2=2.785
r526 (  67 70 ) resistor r=4.27958 //w=0.131 //l=4.485 //layer=m2 \
 //thickness=0.36 //x=6.575 //y=2.77 //x2=11.06 //y2=2.77
r527 (  65 67 ) resistor r=0.10734 //w=0.281 //l=0.16 //layer=m2 \
 //thickness=0.36 //x=6.415 //y=2.785 //x2=6.575 //y2=2.785
r528 (  65 66 ) resistor r=0.10734 //w=0.281 //l=0.16 //layer=m2 \
 //thickness=0.36 //x=6.415 //y=2.785 //x2=6.255 //y2=2.785
r529 (  63 66 ) resistor r=1.45992 //w=0.131 //l=1.53 //layer=m2 \
 //thickness=0.36 //x=4.725 //y=2.77 //x2=6.255 //y2=2.77
r530 (  61 63 ) resistor r=0.10734 //w=0.281 //l=0.16 //layer=m2 \
 //thickness=0.36 //x=4.565 //y=2.785 //x2=4.725 //y2=2.785
r531 (  55 129 ) resistor r=9.3 //w=0.17 //l=0.17 //layer=mcon //count=1 \
 //x=11.22 //y=4.88 //x2=11.22 //y2=4.88
r532 (  53 120 ) resistor r=9.3 //w=0.17 //l=0.17 //layer=mcon //count=1 \
 //x=11.22 //y=2.26 //x2=11.22 //y2=2.26
r533 (  51 69 ) resistor r=4.5 //w=0.15 //l=0.15 //layer=via1 //count=1 \
 //x=11.22 //y=2.785 //x2=11.22 //y2=2.785
r534 (  49 51 ) resistor r=0.0049867 //w=0.376 //l=0.015 //layer=m1 \
 //thickness=0.36 //x=11.167 //y=2.77 //x2=11.167 //y2=2.785
r535 (  47 65 ) resistor r=4.5 //w=0.15 //l=0.15 //layer=via1 //count=1 \
 //x=6.415 //y=2.785 //x2=6.415 //y2=2.785
r536 (  45 47 ) resistor r=0.00501337 //w=0.374 //l=0.015 //layer=m1 \
 //thickness=0.36 //x=6.465 //y=2.77 //x2=6.465 //y2=2.785
r537 (  43 115 ) resistor r=9.3 //w=0.17 //l=0.17 //layer=mcon //count=1 \
 //x=6.41 //y=4.88 //x2=6.41 //y2=4.88
r538 (  41 106 ) resistor r=9.3 //w=0.17 //l=0.17 //layer=mcon //count=1 \
 //x=6.41 //y=2.26 //x2=6.41 //y2=2.26
r539 (  39 61 ) resistor r=4.5 //w=0.15 //l=0.15 //layer=via1 //count=1 \
 //x=4.565 //y=2.785 //x2=4.565 //y2=2.785
r540 (  37 39 ) resistor r=0.00501337 //w=0.374 //l=0.015 //layer=m1 \
 //thickness=0.36 //x=4.615 //y=2.77 //x2=4.615 //y2=2.785
r541 (  35 193 ) resistor r=9.3 //w=0.17 //l=0.17 //layer=mcon //count=1 \
 //x=4.075 //y=1.19 //x2=4.075 //y2=1.19
r542 (  33 89 ) resistor r=9.3 //w=0.17 //l=0.17 //layer=mcon //count=1 \
 //x=3.78 //y=5.56 //x2=3.78 //y2=5.56
r543 (  30 81 ) resistor r=9.3 //w=0.17 //l=0.17 //layer=mcon //count=1 \
 //x=2.9 //y=5.56 //x2=2.9 //y2=5.56
r544 (  28 30 ) resistor r=0.121228 //w=0.232 //l=0.225 //layer=m1 \
 //thickness=0.36 //x=2.9 //y=5.335 //x2=2.9 //y2=5.56
r545 (  27 73 ) resistor r=9.3 //w=0.17 //l=0.17 //layer=mcon //count=1 \
 //x=2.02 //y=5.56 //x2=2.02 //y2=5.56
r546 (  25 27 ) resistor r=0.129608 //w=0.217 //l=0.225 //layer=m1 \
 //thickness=0.36 //x=2.022 //y=5.335 //x2=2.022 //y2=5.56
r547 (  24 55 ) resistor r=0.0760407 //w=0.238 //l=0.125 //layer=m1 \
 //thickness=0.36 //x=11.22 //y=4.755 //x2=11.22 //y2=4.88
r548 (  23 51 ) resistor r=0.0911593 //w=0.376 //l=0.184608 //layer=m1 \
 //thickness=0.36 //x=11.22 //y=2.945 //x2=11.167 //y2=2.785
r549 (  23 24 ) resistor r=1.7271 //w=0.131 //l=1.81 //layer=m1 \
 //thickness=0.36 //x=11.22 //y=2.945 //x2=11.22 //y2=4.755
r550 (  22 49 ) resistor r=0.0861726 //w=0.376 //l=0.16944 //layer=m1 \
 //thickness=0.36 //x=11.22 //y=2.625 //x2=11.167 //y2=2.77
r551 (  21 53 ) resistor r=0.0719237 //w=0.222 //l=0.115 //layer=m1 \
 //thickness=0.36 //x=11.22 //y=2.375 //x2=11.22 //y2=2.26
r552 (  21 22 ) resistor r=0.23855 //w=0.131 //l=0.25 //layer=m1 \
 //thickness=0.36 //x=11.22 //y=2.375 //x2=11.22 //y2=2.625
r553 (  20 43 ) resistor r=0.0760407 //w=0.238 //l=0.125 //layer=m1 \
 //thickness=0.36 //x=6.41 //y=4.755 //x2=6.41 //y2=4.88
r554 (  19 47 ) resistor r=0.0910802 //w=0.374 //l=0.185472 //layer=m1 \
 //thickness=0.36 //x=6.41 //y=2.945 //x2=6.465 //y2=2.785
r555 (  19 20 ) resistor r=1.7271 //w=0.131 //l=1.81 //layer=m1 \
 //thickness=0.36 //x=6.41 //y=2.945 //x2=6.41 //y2=4.755
r556 (  18 45 ) resistor r=0.0860668 //w=0.374 //l=0.170294 //layer=m1 \
 //thickness=0.36 //x=6.41 //y=2.625 //x2=6.465 //y2=2.77
r557 (  17 41 ) resistor r=0.0719237 //w=0.222 //l=0.115 //layer=m1 \
 //thickness=0.36 //x=6.41 //y=2.375 //x2=6.41 //y2=2.26
r558 (  17 18 ) resistor r=0.23855 //w=0.131 //l=0.25 //layer=m1 \
 //thickness=0.36 //x=6.41 //y=2.375 //x2=6.41 //y2=2.625
r559 (  15 39 ) resistor r=0.0910802 //w=0.374 //l=0.185472 //layer=m1 \
 //thickness=0.36 //x=4.56 //y=2.945 //x2=4.615 //y2=2.785
r560 (  15 16 ) resistor r=2.19943 //w=0.131 //l=2.305 //layer=m1 \
 //thickness=0.36 //x=4.56 //y=2.945 //x2=4.56 //y2=5.25
r561 (  14 37 ) resistor r=0.0860668 //w=0.374 //l=0.170294 //layer=m1 \
 //thickness=0.36 //x=4.56 //y=2.625 //x2=4.615 //y2=2.77
r562 (  13 14 ) resistor r=0.663168 //w=0.131 //l=0.695 //layer=m1 \
 //thickness=0.36 //x=4.56 //y=1.93 //x2=4.56 //y2=2.625
r563 (  11 13 ) resistor r=0.0698411 //w=0.17 //l=0.120208 //layer=m1 \
 //thickness=0.36 //x=4.475 //y=1.845 //x2=4.56 //y2=1.93
r564 (  11 12 ) resistor r=0.300573 //w=0.131 //l=0.315 //layer=m1 \
 //thickness=0.36 //x=4.475 //y=1.845 //x2=4.16 //y2=1.845
r565 (  10 12 ) resistor r=0.0698411 //w=0.17 //l=0.120208 //layer=m1 \
 //thickness=0.36 //x=4.075 //y=1.76 //x2=4.16 //y2=1.845
r566 (  9 35 ) resistor r=0.0717383 //w=0.224 //l=0.115 //layer=m1 \
 //thickness=0.36 //x=4.075 //y=1.305 //x2=4.075 //y2=1.19
r567 (  9 10 ) resistor r=0.43416 //w=0.131 //l=0.455 //layer=m1 \
 //thickness=0.36 //x=4.075 //y=1.305 //x2=4.075 //y2=1.76
r568 (  8 31 ) resistor r=0.0675342 //w=0.23 //l=0.115 //layer=m1 \
 //thickness=0.36 //x=3.895 //y=5.335 //x2=3.78 //y2=5.335
r569 (  7 16 ) resistor r=0.0698411 //w=0.17 //l=0.120208 //layer=m1 \
 //thickness=0.36 //x=4.475 //y=5.335 //x2=4.56 //y2=5.25
r570 (  7 8 ) resistor r=0.553435 //w=0.131 //l=0.58 //layer=m1 \
 //thickness=0.36 //x=4.475 //y=5.335 //x2=3.895 //y2=5.335
r571 (  6 33 ) resistor r=0.00118313 //w=0.23 //layer=m1 //thickness=0.36 \
 //x=3.78 //y=5.56 //x2=3.78 //y2=5.56
r572 (  5 31 ) resistor r=0.002872 //w=0.34 //l=0.085 //layer=m1 \
 //thickness=0.36 //x=3.78 //y=5.42 //x2=3.78 //y2=5.335
r573 (  5 6 ) resistor r=0.091623 //w=0.191 //l=0.14 //layer=m1 \
 //thickness=0.36 //x=3.78 //y=5.42 //x2=3.78 //y2=5.56
r574 (  4 28 ) resistor r=0.0262263 //w=0.232 //l=0.12 //layer=m1 \
 //thickness=0.36 //x=3.02 //y=5.335 //x2=2.9 //y2=5.335
r575 (  3 31 ) resistor r=0.0675342 //w=0.23 //l=0.115 //layer=m1 \
 //thickness=0.36 //x=3.665 //y=5.335 //x2=3.78 //y2=5.335
r576 (  3 4 ) resistor r=0.615458 //w=0.131 //l=0.645 //layer=m1 \
 //thickness=0.36 //x=3.665 //y=5.335 //x2=3.02 //y2=5.335
r577 (  2 25 ) resistor r=0.0222262 //w=0.217 //l=0.118 //layer=m1 \
 //thickness=0.36 //x=2.14 //y=5.335 //x2=2.022 //y2=5.335
r578 (  1 28 ) resistor r=0.0262263 //w=0.232 //l=0.12 //layer=m1 \
 //thickness=0.36 //x=2.78 //y=5.335 //x2=2.9 //y2=5.335
r579 (  1 2 ) resistor r=0.610687 //w=0.131 //l=0.64 //layer=m1 \
 //thickness=0.36 //x=2.78 //y=5.335 //x2=2.14 //y2=5.335
ends PM_TMRDFFSNRNQX1\%noxref_1

subckt PM_TMRDFFSNRNQX1\%noxref_2 ( 1 3 6 7 9 10 11 12 14 15 16 17 18 19 20 21 \
 24 27 33 36 42 43 48 51 59 67 84 93 97 98 99 100 101 102 103 104 106 112 113 \
 114 115 127 129 130 131 )
c293 ( 127 0 ) capacitor c=0.00885916f //x=13.505 //y=1.095
c294 ( 115 0 ) capacitor c=0.0612936f //x=16.305 //y=4.97
c295 ( 114 0 ) capacitor c=0.0376642f //x=16.595 //y=4.97
c296 ( 113 0 ) capacitor c=0.0346489f //x=16.26 //y=1.4
c297 ( 112 0 ) capacitor c=0.018692f //x=16.26 //y=1.055
c298 ( 106 0 ) capacitor c=0.0137077f //x=16.105 //y=1.555
c299 ( 104 0 ) capacitor c=0.0158585f //x=16.105 //y=0.9
c300 ( 103 0 ) capacitor c=0.0979523f //x=15.73 //y=2.095
c301 ( 102 0 ) capacitor c=0.0229444f //x=15.73 //y=1.71
c302 ( 101 0 ) capacitor c=0.0234359f //x=15.73 //y=1.4
c303 ( 100 0 ) capacitor c=0.019815f //x=15.73 //y=1.055
c304 ( 99 0 ) capacitor c=0.110208f //x=16.67 //y=6.2
c305 ( 98 0 ) capacitor c=0.158957f //x=16.23 //y=6.2
c306 ( 93 0 ) capacitor c=0.0014751f //x=16.03 //y=4.88
c307 ( 84 0 ) capacitor c=9.93222e-19 //x=16.03 //y=2.26
c308 ( 67 0 ) capacitor c=0.0293723f //x=13.4 //y=5.56
c309 ( 59 0 ) capacitor c=0.029137f //x=12.52 //y=5.56
c310 ( 51 0 ) capacitor c=0.0278099f //x=11.64 //y=5.56
c311 ( 48 0 ) capacitor c=6.57651e-19 //x=16.04 //y=2.77
c312 ( 43 0 ) capacitor c=9.44624e-19 //x=14.34 //y=2.77
c313 ( 42 0 ) capacitor c=0.0155215f //x=15.88 //y=2.77
c314 ( 36 0 ) capacitor c=0.0146045f //x=16.03 //y=2.77
c315 ( 33 0 ) capacitor c=0.0146969f //x=14.18 //y=2.77
c316 ( 27 0 ) capacitor c=8.8245e-19 //x=13.4 //y=5.335
c317 ( 24 0 ) capacitor c=0.00726074f //x=12.52 //y=5.335
c318 ( 21 0 ) capacitor c=0.0111234f //x=11.642 //y=5.335
c319 ( 20 0 ) capacitor c=0.0633726f //x=16.03 //y=4.755
c320 ( 19 0 ) capacitor c=0.0131932f //x=16.03 //y=2.93
c321 ( 18 0 ) capacitor c=0.00432188f //x=16.03 //y=2.61
c322 ( 17 0 ) capacitor c=0.00485584f //x=16.03 //y=2.375
c323 ( 16 0 ) capacitor c=0.064515f //x=14.18 //y=5.25
c324 ( 15 0 ) capacitor c=0.0122936f //x=14.18 //y=2.93
c325 ( 14 0 ) capacitor c=0.0181662f //x=14.18 //y=2.61
c326 ( 12 0 ) capacitor c=0.00493487f //x=13.78 //y=1.845
c327 ( 11 0 ) capacitor c=0.0129068f //x=14.095 //y=1.845
c328 ( 10 0 ) capacitor c=0.0167992f //x=13.695 //y=1.76
c329 ( 9 0 ) capacitor c=0.0112867f //x=13.695 //y=1.305
c330 ( 7 0 ) capacitor c=0.0236685f //x=14.095 //y=5.335
c331 ( 6 0 ) capacitor c=0.00933983f //x=13.4 //y=5.56
c332 ( 3 0 ) capacitor c=0.0180822f //x=13.285 //y=5.335
c333 ( 1 0 ) capacitor c=0.0151332f //x=12.4 //y=5.335
r334 (  114 116 ) resistor r=26.9307 //w=0.15 //l=0.106066 //layer=ply \
 //thickness=0.18 //x=16.595 //y=4.97 //x2=16.67 //y2=5.045
r335 (  114 115 ) resistor r=148.702 //w=0.094 //l=0.29 //layer=ply \
 //thickness=0.18 //x=16.595 //y=4.97 //x2=16.305 //y2=4.97
r336 (  113 126 ) resistor r=45.1352 //w=0.168 //l=0.173853 //layer=ply \
 //thickness=0.18 //x=16.26 //y=1.4 //x2=16.22 //y2=1.555
r337 (  112 125 ) resistor r=45.1352 //w=0.168 //l=0.173853 //layer=ply \
 //thickness=0.18 //x=16.26 //y=1.055 //x2=16.22 //y2=0.9
r338 (  112 113 ) resistor r=176.904 //w=0.094 //l=0.345 //layer=ply \
 //thickness=0.18 //x=16.26 //y=1.055 //x2=16.26 //y2=1.4
r339 (  109 115 ) resistor r=22.7971 //w=0.269 //l=0.106066 //layer=ply \
 //thickness=0.18 //x=16.23 //y=5.045 //x2=16.305 //y2=4.97
r340 (  109 124 ) resistor r=35.8364 //w=0.269 //l=0.270185 //layer=ply \
 //thickness=0.18 //x=16.23 //y=5.045 //x2=16.03 //y2=4.88
r341 (  107 120 ) resistor r=10.701 //w=0.21 //l=0.115 //layer=ply \
 //thickness=0.18 //x=15.885 //y=1.555 //x2=15.77 //y2=1.555
r342 (  106 126 ) resistor r=5.52526 //w=0.168 //l=0.115 //layer=ply \
 //thickness=0.18 //x=16.105 //y=1.555 //x2=16.22 //y2=1.555
r343 (  105 119 ) resistor r=5.52526 //w=0.168 //l=0.115 //layer=ply \
 //thickness=0.18 //x=15.885 //y=0.9 //x2=15.77 //y2=0.9
r344 (  104 125 ) resistor r=5.52526 //w=0.168 //l=0.115 //layer=ply \
 //thickness=0.18 //x=16.105 //y=0.9 //x2=16.22 //y2=0.9
r345 (  104 105 ) resistor r=112.809 //w=0.094 //l=0.22 //layer=ply \
 //thickness=0.18 //x=16.105 //y=0.9 //x2=15.885 //y2=0.9
r346 (  103 122 ) resistor r=58.7805 //w=0.246 //l=0.373497 //layer=ply \
 //thickness=0.18 //x=15.73 //y=2.095 //x2=16.03 //y2=2.26
r347 (  102 120 ) resistor r=39.5823 //w=0.21 //l=0.173853 //layer=ply \
 //thickness=0.18 //x=15.73 //y=1.71 //x2=15.77 //y2=1.555
r348 (  102 103 ) resistor r=197.415 //w=0.094 //l=0.385 //layer=ply \
 //thickness=0.18 //x=15.73 //y=1.71 //x2=15.73 //y2=2.095
r349 (  101 120 ) resistor r=39.5823 //w=0.21 //l=0.173853 //layer=ply \
 //thickness=0.18 //x=15.73 //y=1.4 //x2=15.77 //y2=1.555
r350 (  100 119 ) resistor r=45.1352 //w=0.168 //l=0.173853 //layer=ply \
 //thickness=0.18 //x=15.73 //y=1.055 //x2=15.77 //y2=0.9
r351 (  100 101 ) resistor r=176.904 //w=0.094 //l=0.345 //layer=ply \
 //thickness=0.18 //x=15.73 //y=1.055 //x2=15.73 //y2=1.4
r352 (  99 116 ) resistor r=592.245 //w=0.094 //l=1.155 //layer=ply \
 //thickness=0.18 //x=16.67 //y=6.2 //x2=16.67 //y2=5.045
r353 (  98 109 ) resistor r=592.245 //w=0.094 //l=1.155 //layer=ply \
 //thickness=0.18 //x=16.23 //y=6.2 //x2=16.23 //y2=5.045
r354 (  97 106 ) resistor r=56.4043 //w=0.094 //l=0.11 //layer=ply \
 //thickness=0.18 //x=15.995 //y=1.555 //x2=16.105 //y2=1.555
r355 (  97 107 ) resistor r=56.4043 //w=0.094 //l=0.11 //layer=ply \
 //thickness=0.18 //x=15.995 //y=1.555 //x2=15.885 //y2=1.555
r356 (  93 124 ) resistor r=152 //w=0.17 //l=0.17 //layer=licon //count=1 \
 //x=16.03 //y=4.88 //x2=16.03 //y2=4.88
r357 (  84 122 ) resistor r=152 //w=0.17 //l=0.17 //layer=licon //count=1 \
 //x=16.03 //y=2.26 //x2=16.03 //y2=2.26
r358 (  67 131 ) resistor r=23.615 //w=0.187 //l=0.345 //layer=li \
 //thickness=0.1 //x=13.4 //y=5.56 //x2=13.4 //y2=5.905
r359 (  59 130 ) resistor r=23.615 //w=0.187 //l=0.345 //layer=li \
 //thickness=0.1 //x=12.52 //y=5.56 //x2=12.52 //y2=5.905
r360 (  51 129 ) resistor r=23.615 //w=0.187 //l=0.345 //layer=li \
 //thickness=0.1 //x=11.64 //y=5.56 //x2=11.64 //y2=5.905
r361 (  43 45 ) resistor r=0.10734 //w=0.281 //l=0.16 //layer=m2 \
 //thickness=0.36 //x=14.34 //y=2.77 //x2=14.18 //y2=2.77
r362 (  42 48 ) resistor r=0.10734 //w=0.281 //l=0.16 //layer=m2 \
 //thickness=0.36 //x=15.88 //y=2.77 //x2=16.04 //y2=2.77
r363 (  42 43 ) resistor r=1.46947 //w=0.131 //l=1.54 //layer=m2 \
 //thickness=0.36 //x=15.88 //y=2.77 //x2=14.34 //y2=2.77
r364 (  41 93 ) resistor r=9.3 //w=0.17 //l=0.17 //layer=mcon //count=1 \
 //x=16.03 //y=4.88 //x2=16.03 //y2=4.88
r365 (  39 84 ) resistor r=9.3 //w=0.17 //l=0.17 //layer=mcon //count=1 \
 //x=16.03 //y=2.26 //x2=16.03 //y2=2.26
r366 (  36 48 ) resistor r=4.5 //w=0.15 //l=0.15 //layer=via1 //count=1 \
 //x=16.04 //y=2.77 //x2=16.04 //y2=2.77
r367 (  33 45 ) resistor r=4.5 //w=0.15 //l=0.15 //layer=via1 //count=1 \
 //x=14.18 //y=2.77 //x2=14.18 //y2=2.77
r368 (  31 127 ) resistor r=9.3 //w=0.17 //l=0.17 //layer=mcon //count=1 \
 //x=13.695 //y=1.19 //x2=13.695 //y2=1.19
r369 (  29 67 ) resistor r=9.3 //w=0.17 //l=0.17 //layer=mcon //count=1 \
 //x=13.4 //y=5.56 //x2=13.4 //y2=5.56
r370 (  26 59 ) resistor r=9.3 //w=0.17 //l=0.17 //layer=mcon //count=1 \
 //x=12.52 //y=5.56 //x2=12.52 //y2=5.56
r371 (  24 26 ) resistor r=0.121228 //w=0.232 //l=0.225 //layer=m1 \
 //thickness=0.36 //x=12.52 //y=5.335 //x2=12.52 //y2=5.56
r372 (  23 51 ) resistor r=9.3 //w=0.17 //l=0.17 //layer=mcon //count=1 \
 //x=11.64 //y=5.56 //x2=11.64 //y2=5.56
r373 (  21 23 ) resistor r=0.129608 //w=0.217 //l=0.225 //layer=m1 \
 //thickness=0.36 //x=11.642 //y=5.335 //x2=11.642 //y2=5.56
r374 (  20 41 ) resistor r=0.0760407 //w=0.238 //l=0.125 //layer=m1 \
 //thickness=0.36 //x=16.03 //y=4.755 //x2=16.03 //y2=4.88
r375 (  19 36 ) resistor r=0.0914072 //w=0.382 //l=0.182428 //layer=m1 \
 //thickness=0.36 //x=16.03 //y=2.93 //x2=15.982 //y2=2.77
r376 (  19 20 ) resistor r=1.74141 //w=0.131 //l=1.825 //layer=m1 \
 //thickness=0.36 //x=16.03 //y=2.93 //x2=16.03 //y2=4.755
r377 (  18 36 ) resistor r=0.0914072 //w=0.382 //l=0.182428 //layer=m1 \
 //thickness=0.36 //x=16.03 //y=2.61 //x2=15.982 //y2=2.77
r378 (  17 39 ) resistor r=0.0719237 //w=0.222 //l=0.115 //layer=m1 \
 //thickness=0.36 //x=16.03 //y=2.375 //x2=16.03 //y2=2.26
r379 (  17 18 ) resistor r=0.224237 //w=0.131 //l=0.235 //layer=m1 \
 //thickness=0.36 //x=16.03 //y=2.375 //x2=16.03 //y2=2.61
r380 (  15 33 ) resistor r=0.0911593 //w=0.376 //l=0.184174 //layer=m1 \
 //thickness=0.36 //x=14.18 //y=2.93 //x2=14.232 //y2=2.77
r381 (  15 16 ) resistor r=2.21374 //w=0.131 //l=2.32 //layer=m1 \
 //thickness=0.36 //x=14.18 //y=2.93 //x2=14.18 //y2=5.25
r382 (  14 33 ) resistor r=0.0911593 //w=0.376 //l=0.184174 //layer=m1 \
 //thickness=0.36 //x=14.18 //y=2.61 //x2=14.232 //y2=2.77
r383 (  13 14 ) resistor r=0.648855 //w=0.131 //l=0.68 //layer=m1 \
 //thickness=0.36 //x=14.18 //y=1.93 //x2=14.18 //y2=2.61
r384 (  11 13 ) resistor r=0.0698411 //w=0.17 //l=0.120208 //layer=m1 \
 //thickness=0.36 //x=14.095 //y=1.845 //x2=14.18 //y2=1.93
r385 (  11 12 ) resistor r=0.300573 //w=0.131 //l=0.315 //layer=m1 \
 //thickness=0.36 //x=14.095 //y=1.845 //x2=13.78 //y2=1.845
r386 (  10 12 ) resistor r=0.0698411 //w=0.17 //l=0.120208 //layer=m1 \
 //thickness=0.36 //x=13.695 //y=1.76 //x2=13.78 //y2=1.845
r387 (  9 31 ) resistor r=0.0717383 //w=0.224 //l=0.115 //layer=m1 \
 //thickness=0.36 //x=13.695 //y=1.305 //x2=13.695 //y2=1.19
r388 (  9 10 ) resistor r=0.43416 //w=0.131 //l=0.455 //layer=m1 \
 //thickness=0.36 //x=13.695 //y=1.305 //x2=13.695 //y2=1.76
r389 (  8 27 ) resistor r=0.0675342 //w=0.23 //l=0.115 //layer=m1 \
 //thickness=0.36 //x=13.515 //y=5.335 //x2=13.4 //y2=5.335
r390 (  7 16 ) resistor r=0.0698411 //w=0.17 //l=0.120208 //layer=m1 \
 //thickness=0.36 //x=14.095 //y=5.335 //x2=14.18 //y2=5.25
r391 (  7 8 ) resistor r=0.553435 //w=0.131 //l=0.58 //layer=m1 \
 //thickness=0.36 //x=14.095 //y=5.335 //x2=13.515 //y2=5.335
r392 (  6 29 ) resistor r=0.00118313 //w=0.23 //layer=m1 //thickness=0.36 \
 //x=13.4 //y=5.56 //x2=13.4 //y2=5.56
r393 (  5 27 ) resistor r=0.002872 //w=0.34 //l=0.085 //layer=m1 \
 //thickness=0.36 //x=13.4 //y=5.42 //x2=13.4 //y2=5.335
r394 (  5 6 ) resistor r=0.091623 //w=0.191 //l=0.14 //layer=m1 \
 //thickness=0.36 //x=13.4 //y=5.42 //x2=13.4 //y2=5.56
r395 (  4 24 ) resistor r=0.0262263 //w=0.232 //l=0.12 //layer=m1 \
 //thickness=0.36 //x=12.64 //y=5.335 //x2=12.52 //y2=5.335
r396 (  3 27 ) resistor r=0.0675342 //w=0.23 //l=0.115 //layer=m1 \
 //thickness=0.36 //x=13.285 //y=5.335 //x2=13.4 //y2=5.335
r397 (  3 4 ) resistor r=0.615458 //w=0.131 //l=0.645 //layer=m1 \
 //thickness=0.36 //x=13.285 //y=5.335 //x2=12.64 //y2=5.335
r398 (  2 21 ) resistor r=0.0222262 //w=0.217 //l=0.118 //layer=m1 \
 //thickness=0.36 //x=11.76 //y=5.335 //x2=11.642 //y2=5.335
r399 (  1 24 ) resistor r=0.0262263 //w=0.232 //l=0.12 //layer=m1 \
 //thickness=0.36 //x=12.4 //y=5.335 //x2=12.52 //y2=5.335
r400 (  1 2 ) resistor r=0.610687 //w=0.131 //l=0.64 //layer=m1 \
 //thickness=0.36 //x=12.4 //y=5.335 //x2=11.76 //y2=5.335
ends PM_TMRDFFSNRNQX1\%noxref_2

subckt PM_TMRDFFSNRNQX1\%noxref_3 ( 1 2 3 4 5 7 10 11 13 14 15 16 18 19 20 21 \
 22 23 24 30 33 36 39 47 49 57 62 65 66 68 71 80 85 93 101 118 127 131 132 133 \
 134 135 136 140 141 142 147 149 152 153 154 155 156 157 158 160 166 167 168 \
 169 174 175 180 191 193 194 195 )
c471 ( 191 0 ) capacitor c=0.00885916f //x=8.695 //y=1.095
c472 ( 180 0 ) capacitor c=0.0710579f //x=3.82 //y=4.88
c473 ( 175 0 ) capacitor c=0.0278202f //x=3.82 //y=2.095
c474 ( 174 0 ) capacitor c=0.0479349f //x=3.82 //y=2.26
c475 ( 169 0 ) capacitor c=0.0612936f //x=21.115 //y=4.97
c476 ( 168 0 ) capacitor c=0.0376642f //x=21.405 //y=4.97
c477 ( 167 0 ) capacitor c=0.0346489f //x=21.07 //y=1.4
c478 ( 166 0 ) capacitor c=0.018692f //x=21.07 //y=1.055
c479 ( 160 0 ) capacitor c=0.0137077f //x=20.915 //y=1.555
c480 ( 158 0 ) capacitor c=0.0158585f //x=20.915 //y=0.9
c481 ( 157 0 ) capacitor c=0.10101f //x=20.54 //y=2.095
c482 ( 156 0 ) capacitor c=0.0229444f //x=20.54 //y=1.71
c483 ( 155 0 ) capacitor c=0.0234359f //x=20.54 //y=1.4
c484 ( 154 0 ) capacitor c=0.019815f //x=20.54 //y=1.055
c485 ( 153 0 ) capacitor c=0.0443175f //x=4.34 //y=1.44
c486 ( 152 0 ) capacitor c=0.0199703f //x=4.34 //y=1.095
c487 ( 149 0 ) capacitor c=0.0162526f //x=4.185 //y=1.595
c488 ( 147 0 ) capacitor c=0.0157807f //x=4.185 //y=0.94
c489 ( 142 0 ) capacitor c=0.0220935f //x=3.81 //y=1.75
c490 ( 141 0 ) capacitor c=0.0207489f //x=3.81 //y=1.44
c491 ( 140 0 ) capacitor c=0.0194091f //x=3.81 //y=1.095
c492 ( 136 0 ) capacitor c=0.110208f //x=21.48 //y=6.2
c493 ( 135 0 ) capacitor c=0.158957f //x=21.04 //y=6.2
c494 ( 134 0 ) capacitor c=0.159671f //x=4 //y=6.2
c495 ( 133 0 ) capacitor c=0.110208f //x=3.56 //y=6.2
c496 ( 127 0 ) capacitor c=0.0014751f //x=20.84 //y=4.88
c497 ( 118 0 ) capacitor c=0.0012618f //x=20.84 //y=2.26
c498 ( 101 0 ) capacitor c=0.0293723f //x=8.59 //y=5.56
c499 ( 93 0 ) capacitor c=0.029137f //x=7.71 //y=5.56
c500 ( 85 0 ) capacitor c=0.0278099f //x=6.83 //y=5.56
c501 ( 80 0 ) capacitor c=7.7417e-19 //x=3.82 //y=4.88
c502 ( 71 0 ) capacitor c=0.00101179f //x=3.82 //y=2.26
c503 ( 68 0 ) capacitor c=4.92288e-19 //x=20.835 //y=3.51
c504 ( 66 0 ) capacitor c=8.37596e-19 //x=9.53 //y=3.495
c505 ( 65 0 ) capacitor c=0.071237f //x=9.21 //y=3.495
c506 ( 62 0 ) capacitor c=9.84133e-19 //x=3.99 //y=3.515
c507 ( 57 0 ) capacitor c=0.121226f //x=20.675 //y=3.51
c508 ( 49 0 ) capacitor c=0.0169562f //x=20.835 //y=3.51
c509 ( 47 0 ) capacitor c=0.0158593f //x=9.37 //y=3.51
c510 ( 39 0 ) capacitor c=8.8245e-19 //x=8.59 //y=5.335
c511 ( 36 0 ) capacitor c=0.00740623f //x=7.71 //y=5.335
c512 ( 33 0 ) capacitor c=0.0113499f //x=6.832 //y=5.335
c513 ( 30 0 ) capacitor c=0.0150828f //x=3.82 //y=3.51
c514 ( 24 0 ) capacitor c=0.037614f //x=20.84 //y=4.755
c515 ( 23 0 ) capacitor c=0.0144231f //x=20.84 //y=3.67
c516 ( 22 0 ) capacitor c=0.0280962f //x=20.84 //y=3.35
c517 ( 21 0 ) capacitor c=0.00493552f //x=20.84 //y=2.375
c518 ( 20 0 ) capacitor c=0.0426794f //x=9.37 //y=5.25
c519 ( 19 0 ) capacitor c=0.0133594f //x=9.37 //y=3.655
c520 ( 18 0 ) capacitor c=0.0401079f //x=9.37 //y=3.335
c521 ( 16 0 ) capacitor c=0.0048771f //x=8.97 //y=1.845
c522 ( 15 0 ) capacitor c=0.0132685f //x=9.285 //y=1.845
c523 ( 14 0 ) capacitor c=0.0167992f //x=8.885 //y=1.76
c524 ( 13 0 ) capacitor c=0.0113147f //x=8.885 //y=1.305
c525 ( 11 0 ) capacitor c=0.0228465f //x=9.285 //y=5.335
c526 ( 10 0 ) capacitor c=0.00933983f //x=8.59 //y=5.56
c527 ( 7 0 ) capacitor c=0.019444f //x=8.475 //y=5.335
c528 ( 5 0 ) capacitor c=0.0149475f //x=7.59 //y=5.335
c529 ( 4 0 ) capacitor c=0.0329808f //x=3.82 //y=4.75
c530 ( 3 0 ) capacitor c=0.0122381f //x=3.82 //y=3.675
c531 ( 2 0 ) capacitor c=0.0243464f //x=3.82 //y=3.355
c532 ( 1 0 ) capacitor c=0.005545f //x=3.82 //y=2.375
r533 (  174 175 ) resistor r=52.7279 //w=0.214 //l=0.165 //layer=ply \
 //thickness=0.18 //x=3.82 //y=2.26 //x2=3.82 //y2=2.095
r534 (  168 170 ) resistor r=26.9307 //w=0.15 //l=0.106066 //layer=ply \
 //thickness=0.18 //x=21.405 //y=4.97 //x2=21.48 //y2=5.045
r535 (  168 169 ) resistor r=148.702 //w=0.094 //l=0.29 //layer=ply \
 //thickness=0.18 //x=21.405 //y=4.97 //x2=21.115 //y2=4.97
r536 (  167 190 ) resistor r=45.1352 //w=0.168 //l=0.173853 //layer=ply \
 //thickness=0.18 //x=21.07 //y=1.4 //x2=21.03 //y2=1.555
r537 (  166 189 ) resistor r=45.1352 //w=0.168 //l=0.173853 //layer=ply \
 //thickness=0.18 //x=21.07 //y=1.055 //x2=21.03 //y2=0.9
r538 (  166 167 ) resistor r=176.904 //w=0.094 //l=0.345 //layer=ply \
 //thickness=0.18 //x=21.07 //y=1.055 //x2=21.07 //y2=1.4
r539 (  163 169 ) resistor r=22.7971 //w=0.269 //l=0.106066 //layer=ply \
 //thickness=0.18 //x=21.04 //y=5.045 //x2=21.115 //y2=4.97
r540 (  163 188 ) resistor r=35.8364 //w=0.269 //l=0.270185 //layer=ply \
 //thickness=0.18 //x=21.04 //y=5.045 //x2=20.84 //y2=4.88
r541 (  161 184 ) resistor r=10.701 //w=0.21 //l=0.115 //layer=ply \
 //thickness=0.18 //x=20.695 //y=1.555 //x2=20.58 //y2=1.555
r542 (  160 190 ) resistor r=5.52526 //w=0.168 //l=0.115 //layer=ply \
 //thickness=0.18 //x=20.915 //y=1.555 //x2=21.03 //y2=1.555
r543 (  159 183 ) resistor r=5.52526 //w=0.168 //l=0.115 //layer=ply \
 //thickness=0.18 //x=20.695 //y=0.9 //x2=20.58 //y2=0.9
r544 (  158 189 ) resistor r=5.52526 //w=0.168 //l=0.115 //layer=ply \
 //thickness=0.18 //x=20.915 //y=0.9 //x2=21.03 //y2=0.9
r545 (  158 159 ) resistor r=112.809 //w=0.094 //l=0.22 //layer=ply \
 //thickness=0.18 //x=20.915 //y=0.9 //x2=20.695 //y2=0.9
r546 (  157 186 ) resistor r=58.7805 //w=0.246 //l=0.373497 //layer=ply \
 //thickness=0.18 //x=20.54 //y=2.095 //x2=20.84 //y2=2.26
r547 (  156 184 ) resistor r=39.5823 //w=0.21 //l=0.173853 //layer=ply \
 //thickness=0.18 //x=20.54 //y=1.71 //x2=20.58 //y2=1.555
r548 (  156 157 ) resistor r=197.415 //w=0.094 //l=0.385 //layer=ply \
 //thickness=0.18 //x=20.54 //y=1.71 //x2=20.54 //y2=2.095
r549 (  155 184 ) resistor r=39.5823 //w=0.21 //l=0.173853 //layer=ply \
 //thickness=0.18 //x=20.54 //y=1.4 //x2=20.58 //y2=1.555
r550 (  154 183 ) resistor r=45.1352 //w=0.168 //l=0.173853 //layer=ply \
 //thickness=0.18 //x=20.54 //y=1.055 //x2=20.58 //y2=0.9
r551 (  154 155 ) resistor r=176.904 //w=0.094 //l=0.345 //layer=ply \
 //thickness=0.18 //x=20.54 //y=1.055 //x2=20.54 //y2=1.4
r552 (  153 182 ) resistor r=45.1352 //w=0.168 //l=0.173853 //layer=ply \
 //thickness=0.18 //x=4.34 //y=1.44 //x2=4.3 //y2=1.595
r553 (  152 181 ) resistor r=45.1352 //w=0.168 //l=0.173853 //layer=ply \
 //thickness=0.18 //x=4.34 //y=1.095 //x2=4.3 //y2=0.94
r554 (  152 153 ) resistor r=176.904 //w=0.094 //l=0.345 //layer=ply \
 //thickness=0.18 //x=4.34 //y=1.095 //x2=4.34 //y2=1.44
r555 (  150 178 ) resistor r=10.701 //w=0.21 //l=0.115 //layer=ply \
 //thickness=0.18 //x=3.965 //y=1.595 //x2=3.85 //y2=1.595
r556 (  149 182 ) resistor r=5.52526 //w=0.168 //l=0.115 //layer=ply \
 //thickness=0.18 //x=4.185 //y=1.595 //x2=4.3 //y2=1.595
r557 (  148 177 ) resistor r=5.52526 //w=0.168 //l=0.115 //layer=ply \
 //thickness=0.18 //x=3.965 //y=0.94 //x2=3.85 //y2=0.94
r558 (  147 181 ) resistor r=5.52526 //w=0.168 //l=0.115 //layer=ply \
 //thickness=0.18 //x=4.185 //y=0.94 //x2=4.3 //y2=0.94
r559 (  147 148 ) resistor r=112.809 //w=0.094 //l=0.22 //layer=ply \
 //thickness=0.18 //x=4.185 //y=0.94 //x2=3.965 //y2=0.94
r560 (  144 180 ) resistor r=37.236 //w=0.233 //l=0.249199 //layer=ply \
 //thickness=0.18 //x=4 //y=5.045 //x2=3.82 //y2=4.88
r561 (  142 178 ) resistor r=39.5823 //w=0.21 //l=0.173853 //layer=ply \
 //thickness=0.18 //x=3.81 //y=1.75 //x2=3.85 //y2=1.595
r562 (  142 175 ) resistor r=176.904 //w=0.094 //l=0.345 //layer=ply \
 //thickness=0.18 //x=3.81 //y=1.75 //x2=3.81 //y2=2.095
r563 (  141 178 ) resistor r=39.5823 //w=0.21 //l=0.173853 //layer=ply \
 //thickness=0.18 //x=3.81 //y=1.44 //x2=3.85 //y2=1.595
r564 (  140 177 ) resistor r=45.1352 //w=0.168 //l=0.173853 //layer=ply \
 //thickness=0.18 //x=3.81 //y=1.095 //x2=3.85 //y2=0.94
r565 (  140 141 ) resistor r=176.904 //w=0.094 //l=0.345 //layer=ply \
 //thickness=0.18 //x=3.81 //y=1.095 //x2=3.81 //y2=1.44
r566 (  137 180 ) resistor r=53.7854 //w=0.233 //l=0.332415 //layer=ply \
 //thickness=0.18 //x=3.56 //y=5.045 //x2=3.82 //y2=4.88
r567 (  136 170 ) resistor r=592.245 //w=0.094 //l=1.155 //layer=ply \
 //thickness=0.18 //x=21.48 //y=6.2 //x2=21.48 //y2=5.045
r568 (  135 163 ) resistor r=592.245 //w=0.094 //l=1.155 //layer=ply \
 //thickness=0.18 //x=21.04 //y=6.2 //x2=21.04 //y2=5.045
r569 (  134 144 ) resistor r=592.245 //w=0.094 //l=1.155 //layer=ply \
 //thickness=0.18 //x=4 //y=6.2 //x2=4 //y2=5.045
r570 (  133 137 ) resistor r=592.245 //w=0.094 //l=1.155 //layer=ply \
 //thickness=0.18 //x=3.56 //y=6.2 //x2=3.56 //y2=5.045
r571 (  132 160 ) resistor r=56.4043 //w=0.094 //l=0.11 //layer=ply \
 //thickness=0.18 //x=20.805 //y=1.555 //x2=20.915 //y2=1.555
r572 (  132 161 ) resistor r=56.4043 //w=0.094 //l=0.11 //layer=ply \
 //thickness=0.18 //x=20.805 //y=1.555 //x2=20.695 //y2=1.555
r573 (  131 149 ) resistor r=56.4043 //w=0.094 //l=0.11 //layer=ply \
 //thickness=0.18 //x=4.075 //y=1.595 //x2=4.185 //y2=1.595
r574 (  131 150 ) resistor r=56.4043 //w=0.094 //l=0.11 //layer=ply \
 //thickness=0.18 //x=4.075 //y=1.595 //x2=3.965 //y2=1.595
r575 (  127 188 ) resistor r=152 //w=0.17 //l=0.17 //layer=licon //count=1 \
 //x=20.84 //y=4.88 //x2=20.84 //y2=4.88
r576 (  118 186 ) resistor r=152 //w=0.17 //l=0.17 //layer=licon //count=1 \
 //x=20.84 //y=2.26 //x2=20.84 //y2=2.26
r577 (  101 195 ) resistor r=23.615 //w=0.187 //l=0.345 //layer=li \
 //thickness=0.1 //x=8.59 //y=5.56 //x2=8.59 //y2=5.905
r578 (  93 194 ) resistor r=23.615 //w=0.187 //l=0.345 //layer=li \
 //thickness=0.1 //x=7.71 //y=5.56 //x2=7.71 //y2=5.905
r579 (  85 193 ) resistor r=23.615 //w=0.187 //l=0.345 //layer=li \
 //thickness=0.1 //x=6.83 //y=5.56 //x2=6.83 //y2=5.905
r580 (  80 180 ) resistor r=152 //w=0.17 //l=0.17 //layer=licon //count=1 \
 //x=3.82 //y=4.88 //x2=3.82 //y2=4.88
r581 (  71 174 ) resistor r=152 //w=0.17 //l=0.17 //layer=licon //count=1 \
 //x=3.82 //y=2.26 //x2=3.82 //y2=2.26
r582 (  64 66 ) resistor r=0.10734 //w=0.281 //l=0.16 //layer=m2 \
 //thickness=0.36 //x=9.37 //y=3.495 //x2=9.53 //y2=3.495
r583 (  64 65 ) resistor r=0.10734 //w=0.281 //l=0.16 //layer=m2 \
 //thickness=0.36 //x=9.37 //y=3.495 //x2=9.21 //y2=3.495
r584 (  62 65 ) resistor r=4.98092 //w=0.131 //l=5.22 //layer=m2 \
 //thickness=0.36 //x=3.99 //y=3.51 //x2=9.21 //y2=3.51
r585 (  60 62 ) resistor r=0.10734 //w=0.281 //l=0.16 //layer=m2 \
 //thickness=0.36 //x=3.83 //y=3.515 //x2=3.99 //y2=3.515
r586 (  57 68 ) resistor r=0.10734 //w=0.281 //l=0.16 //layer=m2 \
 //thickness=0.36 //x=20.675 //y=3.51 //x2=20.835 //y2=3.51
r587 (  57 66 ) resistor r=10.6345 //w=0.131 //l=11.145 //layer=m2 \
 //thickness=0.36 //x=20.675 //y=3.51 //x2=9.53 //y2=3.51
r588 (  54 127 ) resistor r=9.3 //w=0.17 //l=0.17 //layer=mcon //count=1 \
 //x=20.84 //y=4.88 //x2=20.84 //y2=4.88
r589 (  52 118 ) resistor r=9.3 //w=0.17 //l=0.17 //layer=mcon //count=1 \
 //x=20.84 //y=2.26 //x2=20.84 //y2=2.26
r590 (  49 68 ) resistor r=4.5 //w=0.15 //l=0.15 //layer=via1 //count=1 \
 //x=20.835 //y=3.51 //x2=20.835 //y2=3.51
r591 (  45 64 ) resistor r=4.5 //w=0.15 //l=0.15 //layer=via1 //count=1 \
 //x=9.37 //y=3.495 //x2=9.37 //y2=3.495
r592 (  45 47 ) resistor r=0.0049867 //w=0.376 //l=0.015 //layer=m1 \
 //thickness=0.36 //x=9.422 //y=3.495 //x2=9.422 //y2=3.51
r593 (  43 191 ) resistor r=9.3 //w=0.17 //l=0.17 //layer=mcon //count=1 \
 //x=8.885 //y=1.19 //x2=8.885 //y2=1.19
r594 (  41 101 ) resistor r=9.3 //w=0.17 //l=0.17 //layer=mcon //count=1 \
 //x=8.59 //y=5.56 //x2=8.59 //y2=5.56
r595 (  38 93 ) resistor r=9.3 //w=0.17 //l=0.17 //layer=mcon //count=1 \
 //x=7.71 //y=5.56 //x2=7.71 //y2=5.56
r596 (  36 38 ) resistor r=0.121228 //w=0.232 //l=0.225 //layer=m1 \
 //thickness=0.36 //x=7.71 //y=5.335 //x2=7.71 //y2=5.56
r597 (  35 85 ) resistor r=9.3 //w=0.17 //l=0.17 //layer=mcon //count=1 \
 //x=6.83 //y=5.56 //x2=6.83 //y2=5.56
r598 (  33 35 ) resistor r=0.129608 //w=0.217 //l=0.225 //layer=m1 \
 //thickness=0.36 //x=6.832 //y=5.335 //x2=6.832 //y2=5.56
r599 (  32 60 ) resistor r=4.5 //w=0.15 //l=0.15 //layer=via1 //count=1 \
 //x=3.83 //y=3.515 //x2=3.83 //y2=3.515
r600 (  30 32 ) resistor r=0.00168464 //w=0.371 //l=0.005 //layer=m1 \
 //thickness=0.36 //x=3.877 //y=3.51 //x2=3.877 //y2=3.515
r601 (  28 80 ) resistor r=9.3 //w=0.17 //l=0.17 //layer=mcon //count=1 \
 //x=3.82 //y=4.88 //x2=3.82 //y2=4.88
r602 (  26 71 ) resistor r=9.3 //w=0.17 //l=0.17 //layer=mcon //count=1 \
 //x=3.82 //y=2.26 //x2=3.82 //y2=2.26
r603 (  24 54 ) resistor r=0.0760407 //w=0.238 //l=0.125 //layer=m1 \
 //thickness=0.36 //x=20.84 //y=4.755 //x2=20.84 //y2=4.88
r604 (  23 49 ) resistor r=0.0910802 //w=0.374 //l=0.185472 //layer=m1 \
 //thickness=0.36 //x=20.84 //y=3.67 //x2=20.785 //y2=3.51
r605 (  23 24 ) resistor r=1.03531 //w=0.131 //l=1.085 //layer=m1 \
 //thickness=0.36 //x=20.84 //y=3.67 //x2=20.84 //y2=4.755
r606 (  22 49 ) resistor r=0.0910802 //w=0.374 //l=0.185472 //layer=m1 \
 //thickness=0.36 //x=20.84 //y=3.35 //x2=20.785 //y2=3.51
r607 (  21 52 ) resistor r=0.0719237 //w=0.222 //l=0.115 //layer=m1 \
 //thickness=0.36 //x=20.84 //y=2.375 //x2=20.84 //y2=2.26
r608 (  21 22 ) resistor r=0.930344 //w=0.131 //l=0.975 //layer=m1 \
 //thickness=0.36 //x=20.84 //y=2.375 //x2=20.84 //y2=3.35
r609 (  19 47 ) resistor r=0.0861726 //w=0.376 //l=0.169012 //layer=m1 \
 //thickness=0.36 //x=9.37 //y=3.655 //x2=9.422 //y2=3.51
r610 (  19 20 ) resistor r=1.52195 //w=0.131 //l=1.595 //layer=m1 \
 //thickness=0.36 //x=9.37 //y=3.655 //x2=9.37 //y2=5.25
r611 (  18 45 ) resistor r=0.0911593 //w=0.376 //l=0.184174 //layer=m1 \
 //thickness=0.36 //x=9.37 //y=3.335 //x2=9.422 //y2=3.495
r612 (  17 18 ) resistor r=1.34065 //w=0.131 //l=1.405 //layer=m1 \
 //thickness=0.36 //x=9.37 //y=1.93 //x2=9.37 //y2=3.335
r613 (  15 17 ) resistor r=0.0698411 //w=0.17 //l=0.120208 //layer=m1 \
 //thickness=0.36 //x=9.285 //y=1.845 //x2=9.37 //y2=1.93
r614 (  15 16 ) resistor r=0.300573 //w=0.131 //l=0.315 //layer=m1 \
 //thickness=0.36 //x=9.285 //y=1.845 //x2=8.97 //y2=1.845
r615 (  14 16 ) resistor r=0.0698411 //w=0.17 //l=0.120208 //layer=m1 \
 //thickness=0.36 //x=8.885 //y=1.76 //x2=8.97 //y2=1.845
r616 (  13 43 ) resistor r=0.0717383 //w=0.224 //l=0.115 //layer=m1 \
 //thickness=0.36 //x=8.885 //y=1.305 //x2=8.885 //y2=1.19
r617 (  13 14 ) resistor r=0.43416 //w=0.131 //l=0.455 //layer=m1 \
 //thickness=0.36 //x=8.885 //y=1.305 //x2=8.885 //y2=1.76
r618 (  12 39 ) resistor r=0.0675342 //w=0.23 //l=0.115 //layer=m1 \
 //thickness=0.36 //x=8.705 //y=5.335 //x2=8.59 //y2=5.335
r619 (  11 20 ) resistor r=0.0698411 //w=0.17 //l=0.120208 //layer=m1 \
 //thickness=0.36 //x=9.285 //y=5.335 //x2=9.37 //y2=5.25
r620 (  11 12 ) resistor r=0.553435 //w=0.131 //l=0.58 //layer=m1 \
 //thickness=0.36 //x=9.285 //y=5.335 //x2=8.705 //y2=5.335
r621 (  10 41 ) resistor r=0.00118313 //w=0.23 //layer=m1 //thickness=0.36 \
 //x=8.59 //y=5.56 //x2=8.59 //y2=5.56
r622 (  9 39 ) resistor r=0.002872 //w=0.34 //l=0.085 //layer=m1 \
 //thickness=0.36 //x=8.59 //y=5.42 //x2=8.59 //y2=5.335
r623 (  9 10 ) resistor r=0.091623 //w=0.191 //l=0.14 //layer=m1 \
 //thickness=0.36 //x=8.59 //y=5.42 //x2=8.59 //y2=5.56
r624 (  8 36 ) resistor r=0.0262263 //w=0.232 //l=0.12 //layer=m1 \
 //thickness=0.36 //x=7.83 //y=5.335 //x2=7.71 //y2=5.335
r625 (  7 39 ) resistor r=0.0675342 //w=0.23 //l=0.115 //layer=m1 \
 //thickness=0.36 //x=8.475 //y=5.335 //x2=8.59 //y2=5.335
r626 (  7 8 ) resistor r=0.615458 //w=0.131 //l=0.645 //layer=m1 \
 //thickness=0.36 //x=8.475 //y=5.335 //x2=7.83 //y2=5.335
r627 (  6 33 ) resistor r=0.0222262 //w=0.217 //l=0.118 //layer=m1 \
 //thickness=0.36 //x=6.95 //y=5.335 //x2=6.832 //y2=5.335
r628 (  5 36 ) resistor r=0.0262263 //w=0.232 //l=0.12 //layer=m1 \
 //thickness=0.36 //x=7.59 //y=5.335 //x2=7.71 //y2=5.335
r629 (  5 6 ) resistor r=0.610687 //w=0.131 //l=0.64 //layer=m1 \
 //thickness=0.36 //x=7.59 //y=5.335 //x2=6.95 //y2=5.335
r630 (  4 28 ) resistor r=0.0801089 //w=0.224 //l=0.13 //layer=m1 \
 //thickness=0.36 //x=3.82 //y=4.75 //x2=3.82 //y2=4.88
r631 (  3 32 ) resistor r=0.0909648 //w=0.371 //l=0.186333 //layer=m1 \
 //thickness=0.36 //x=3.82 //y=3.675 //x2=3.877 //y2=3.515
r632 (  3 4 ) resistor r=1.02576 //w=0.131 //l=1.075 //layer=m1 \
 //thickness=0.36 //x=3.82 //y=3.675 //x2=3.82 //y2=4.75
r633 (  2 30 ) resistor r=0.0892801 //w=0.371 //l=0.181273 //layer=m1 \
 //thickness=0.36 //x=3.82 //y=3.355 //x2=3.877 //y2=3.51
r634 (  1 26 ) resistor r=0.0719237 //w=0.222 //l=0.115 //layer=m1 \
 //thickness=0.36 //x=3.82 //y=2.375 //x2=3.82 //y2=2.26
r635 (  1 2 ) resistor r=0.935115 //w=0.131 //l=0.98 //layer=m1 \
 //thickness=0.36 //x=3.82 //y=2.375 //x2=3.82 //y2=3.355
ends PM_TMRDFFSNRNQX1\%noxref_3

subckt PM_TMRDFFSNRNQX1\%noxref_4 ( 1 3 6 7 9 10 11 12 14 15 16 17 18 19 20 21 \
 24 27 35 39 49 51 52 55 63 71 88 97 101 102 103 104 105 106 107 108 110 116 \
 117 118 119 131 133 134 135 )
c291 ( 131 0 ) capacitor c=0.00885916f //x=23.125 //y=1.095
c292 ( 119 0 ) capacitor c=0.0612936f //x=25.925 //y=4.97
c293 ( 118 0 ) capacitor c=0.0376642f //x=26.215 //y=4.97
c294 ( 117 0 ) capacitor c=0.0346489f //x=25.88 //y=1.4
c295 ( 116 0 ) capacitor c=0.018692f //x=25.88 //y=1.055
c296 ( 110 0 ) capacitor c=0.0137077f //x=25.725 //y=1.555
c297 ( 108 0 ) capacitor c=0.0158585f //x=25.725 //y=0.9
c298 ( 107 0 ) capacitor c=0.0979464f //x=25.35 //y=2.095
c299 ( 106 0 ) capacitor c=0.0229444f //x=25.35 //y=1.71
c300 ( 105 0 ) capacitor c=0.0234359f //x=25.35 //y=1.4
c301 ( 104 0 ) capacitor c=0.019815f //x=25.35 //y=1.055
c302 ( 103 0 ) capacitor c=0.110208f //x=26.29 //y=6.2
c303 ( 102 0 ) capacitor c=0.158957f //x=25.85 //y=6.2
c304 ( 97 0 ) capacitor c=0.0014751f //x=25.65 //y=4.88
c305 ( 88 0 ) capacitor c=9.93222e-19 //x=25.65 //y=2.26
c306 ( 71 0 ) capacitor c=0.0293555f //x=23.02 //y=5.56
c307 ( 63 0 ) capacitor c=0.029137f //x=22.14 //y=5.56
c308 ( 55 0 ) capacitor c=0.0278099f //x=21.26 //y=5.56
c309 ( 52 0 ) capacitor c=0.0155627f //x=25.49 //y=2.755
c310 ( 51 0 ) capacitor c=6.61167e-19 //x=25.65 //y=2.755
c311 ( 49 0 ) capacitor c=9.01227e-19 //x=23.945 //y=2.755
c312 ( 39 0 ) capacitor c=0.0148615f //x=25.65 //y=2.77
c313 ( 35 0 ) capacitor c=0.0144534f //x=23.8 //y=2.77
c314 ( 27 0 ) capacitor c=9.58516e-19 //x=23.02 //y=5.335
c315 ( 24 0 ) capacitor c=0.00778188f //x=22.14 //y=5.335
c316 ( 21 0 ) capacitor c=0.0111234f //x=21.262 //y=5.335
c317 ( 20 0 ) capacitor c=0.0609075f //x=25.65 //y=4.755
c318 ( 19 0 ) capacitor c=0.0129174f //x=25.65 //y=2.915
c319 ( 18 0 ) capacitor c=0.00426674f //x=25.65 //y=2.595
c320 ( 17 0 ) capacitor c=0.00437465f //x=25.65 //y=2.375
c321 ( 16 0 ) capacitor c=0.0659613f //x=23.8 //y=5.25
c322 ( 15 0 ) capacitor c=0.0126937f //x=23.8 //y=2.915
c323 ( 14 0 ) capacitor c=0.0174955f //x=23.8 //y=2.595
c324 ( 12 0 ) capacitor c=0.0047266f //x=23.4 //y=1.845
c325 ( 11 0 ) capacitor c=0.0127862f //x=23.715 //y=1.845
c326 ( 10 0 ) capacitor c=0.0167992f //x=23.315 //y=1.76
c327 ( 9 0 ) capacitor c=0.0110975f //x=23.315 //y=1.305
c328 ( 7 0 ) capacitor c=0.0231753f //x=23.715 //y=5.335
c329 ( 6 0 ) capacitor c=0.00933983f //x=23.02 //y=5.56
c330 ( 3 0 ) capacitor c=0.019444f //x=22.905 //y=5.335
c331 ( 1 0 ) capacitor c=0.0151997f //x=22.02 //y=5.335
r332 (  118 120 ) resistor r=26.9307 //w=0.15 //l=0.106066 //layer=ply \
 //thickness=0.18 //x=26.215 //y=4.97 //x2=26.29 //y2=5.045
r333 (  118 119 ) resistor r=148.702 //w=0.094 //l=0.29 //layer=ply \
 //thickness=0.18 //x=26.215 //y=4.97 //x2=25.925 //y2=4.97
r334 (  117 130 ) resistor r=45.1352 //w=0.168 //l=0.173853 //layer=ply \
 //thickness=0.18 //x=25.88 //y=1.4 //x2=25.84 //y2=1.555
r335 (  116 129 ) resistor r=45.1352 //w=0.168 //l=0.173853 //layer=ply \
 //thickness=0.18 //x=25.88 //y=1.055 //x2=25.84 //y2=0.9
r336 (  116 117 ) resistor r=176.904 //w=0.094 //l=0.345 //layer=ply \
 //thickness=0.18 //x=25.88 //y=1.055 //x2=25.88 //y2=1.4
r337 (  113 119 ) resistor r=22.7971 //w=0.269 //l=0.106066 //layer=ply \
 //thickness=0.18 //x=25.85 //y=5.045 //x2=25.925 //y2=4.97
r338 (  113 128 ) resistor r=35.8364 //w=0.269 //l=0.270185 //layer=ply \
 //thickness=0.18 //x=25.85 //y=5.045 //x2=25.65 //y2=4.88
r339 (  111 124 ) resistor r=10.701 //w=0.21 //l=0.115 //layer=ply \
 //thickness=0.18 //x=25.505 //y=1.555 //x2=25.39 //y2=1.555
r340 (  110 130 ) resistor r=5.52526 //w=0.168 //l=0.115 //layer=ply \
 //thickness=0.18 //x=25.725 //y=1.555 //x2=25.84 //y2=1.555
r341 (  109 123 ) resistor r=5.52526 //w=0.168 //l=0.115 //layer=ply \
 //thickness=0.18 //x=25.505 //y=0.9 //x2=25.39 //y2=0.9
r342 (  108 129 ) resistor r=5.52526 //w=0.168 //l=0.115 //layer=ply \
 //thickness=0.18 //x=25.725 //y=0.9 //x2=25.84 //y2=0.9
r343 (  108 109 ) resistor r=112.809 //w=0.094 //l=0.22 //layer=ply \
 //thickness=0.18 //x=25.725 //y=0.9 //x2=25.505 //y2=0.9
r344 (  107 126 ) resistor r=58.7805 //w=0.246 //l=0.373497 //layer=ply \
 //thickness=0.18 //x=25.35 //y=2.095 //x2=25.65 //y2=2.26
r345 (  106 124 ) resistor r=39.5823 //w=0.21 //l=0.173853 //layer=ply \
 //thickness=0.18 //x=25.35 //y=1.71 //x2=25.39 //y2=1.555
r346 (  106 107 ) resistor r=197.415 //w=0.094 //l=0.385 //layer=ply \
 //thickness=0.18 //x=25.35 //y=1.71 //x2=25.35 //y2=2.095
r347 (  105 124 ) resistor r=39.5823 //w=0.21 //l=0.173853 //layer=ply \
 //thickness=0.18 //x=25.35 //y=1.4 //x2=25.39 //y2=1.555
r348 (  104 123 ) resistor r=45.1352 //w=0.168 //l=0.173853 //layer=ply \
 //thickness=0.18 //x=25.35 //y=1.055 //x2=25.39 //y2=0.9
r349 (  104 105 ) resistor r=176.904 //w=0.094 //l=0.345 //layer=ply \
 //thickness=0.18 //x=25.35 //y=1.055 //x2=25.35 //y2=1.4
r350 (  103 120 ) resistor r=592.245 //w=0.094 //l=1.155 //layer=ply \
 //thickness=0.18 //x=26.29 //y=6.2 //x2=26.29 //y2=5.045
r351 (  102 113 ) resistor r=592.245 //w=0.094 //l=1.155 //layer=ply \
 //thickness=0.18 //x=25.85 //y=6.2 //x2=25.85 //y2=5.045
r352 (  101 110 ) resistor r=56.4043 //w=0.094 //l=0.11 //layer=ply \
 //thickness=0.18 //x=25.615 //y=1.555 //x2=25.725 //y2=1.555
r353 (  101 111 ) resistor r=56.4043 //w=0.094 //l=0.11 //layer=ply \
 //thickness=0.18 //x=25.615 //y=1.555 //x2=25.505 //y2=1.555
r354 (  97 128 ) resistor r=152 //w=0.17 //l=0.17 //layer=licon //count=1 \
 //x=25.65 //y=4.88 //x2=25.65 //y2=4.88
r355 (  88 126 ) resistor r=152 //w=0.17 //l=0.17 //layer=licon //count=1 \
 //x=25.65 //y=2.26 //x2=25.65 //y2=2.26
r356 (  71 135 ) resistor r=23.615 //w=0.187 //l=0.345 //layer=li \
 //thickness=0.1 //x=23.02 //y=5.56 //x2=23.02 //y2=5.905
r357 (  63 134 ) resistor r=23.615 //w=0.187 //l=0.345 //layer=li \
 //thickness=0.1 //x=22.14 //y=5.56 //x2=22.14 //y2=5.905
r358 (  55 133 ) resistor r=23.615 //w=0.187 //l=0.345 //layer=li \
 //thickness=0.1 //x=21.26 //y=5.56 //x2=21.26 //y2=5.905
r359 (  51 52 ) resistor r=0.10734 //w=0.281 //l=0.16 //layer=m2 \
 //thickness=0.36 //x=25.65 //y=2.755 //x2=25.49 //y2=2.755
r360 (  49 52 ) resistor r=1.47424 //w=0.131 //l=1.545 //layer=m2 \
 //thickness=0.36 //x=23.945 //y=2.77 //x2=25.49 //y2=2.77
r361 (  47 49 ) resistor r=0.10734 //w=0.281 //l=0.16 //layer=m2 \
 //thickness=0.36 //x=23.785 //y=2.755 //x2=23.945 //y2=2.755
r362 (  43 97 ) resistor r=9.3 //w=0.17 //l=0.17 //layer=mcon //count=1 \
 //x=25.65 //y=4.88 //x2=25.65 //y2=4.88
r363 (  41 88 ) resistor r=9.3 //w=0.17 //l=0.17 //layer=mcon //count=1 \
 //x=25.65 //y=2.26 //x2=25.65 //y2=2.26
r364 (  37 51 ) resistor r=4.5 //w=0.15 //l=0.15 //layer=via1 //count=1 \
 //x=25.65 //y=2.755 //x2=25.65 //y2=2.755
r365 (  37 39 ) resistor r=0.0049867 //w=0.376 //l=0.015 //layer=m1 \
 //thickness=0.36 //x=25.597 //y=2.755 //x2=25.597 //y2=2.77
r366 (  33 47 ) resistor r=4.5 //w=0.15 //l=0.15 //layer=via1 //count=1 \
 //x=23.785 //y=2.755 //x2=23.785 //y2=2.755
r367 (  33 35 ) resistor r=0.00488281 //w=0.384 //l=0.015 //layer=m1 \
 //thickness=0.36 //x=23.845 //y=2.755 //x2=23.845 //y2=2.77
r368 (  31 131 ) resistor r=9.3 //w=0.17 //l=0.17 //layer=mcon //count=1 \
 //x=23.315 //y=1.19 //x2=23.315 //y2=1.19
r369 (  29 71 ) resistor r=9.3 //w=0.17 //l=0.17 //layer=mcon //count=1 \
 //x=23.02 //y=5.56 //x2=23.02 //y2=5.56
r370 (  26 63 ) resistor r=9.3 //w=0.17 //l=0.17 //layer=mcon //count=1 \
 //x=22.14 //y=5.56 //x2=22.14 //y2=5.56
r371 (  24 26 ) resistor r=0.121228 //w=0.232 //l=0.225 //layer=m1 \
 //thickness=0.36 //x=22.14 //y=5.335 //x2=22.14 //y2=5.56
r372 (  23 55 ) resistor r=9.3 //w=0.17 //l=0.17 //layer=mcon //count=1 \
 //x=21.26 //y=5.56 //x2=21.26 //y2=5.56
r373 (  21 23 ) resistor r=0.129608 //w=0.217 //l=0.225 //layer=m1 \
 //thickness=0.36 //x=21.262 //y=5.335 //x2=21.262 //y2=5.56
r374 (  20 43 ) resistor r=0.0760407 //w=0.238 //l=0.125 //layer=m1 \
 //thickness=0.36 //x=25.65 //y=4.755 //x2=25.65 //y2=4.88
r375 (  19 39 ) resistor r=0.0861726 //w=0.376 //l=0.16944 //layer=m1 \
 //thickness=0.36 //x=25.65 //y=2.915 //x2=25.597 //y2=2.77
r376 (  19 20 ) resistor r=1.75573 //w=0.131 //l=1.84 //layer=m1 \
 //thickness=0.36 //x=25.65 //y=2.915 //x2=25.65 //y2=4.755
r377 (  18 37 ) resistor r=0.0911593 //w=0.376 //l=0.184608 //layer=m1 \
 //thickness=0.36 //x=25.65 //y=2.595 //x2=25.597 //y2=2.755
r378 (  17 41 ) resistor r=0.0719237 //w=0.222 //l=0.115 //layer=m1 \
 //thickness=0.36 //x=25.65 //y=2.375 //x2=25.65 //y2=2.26
r379 (  17 18 ) resistor r=0.209924 //w=0.131 //l=0.22 //layer=m1 \
 //thickness=0.36 //x=25.65 //y=2.375 //x2=25.65 //y2=2.595
r380 (  15 35 ) resistor r=0.0866104 //w=0.384 //l=0.165982 //layer=m1 \
 //thickness=0.36 //x=23.8 //y=2.915 //x2=23.845 //y2=2.77
r381 (  15 16 ) resistor r=2.22805 //w=0.131 //l=2.335 //layer=m1 \
 //thickness=0.36 //x=23.8 //y=2.915 //x2=23.8 //y2=5.25
r382 (  14 33 ) resistor r=0.0914932 //w=0.384 //l=0.181108 //layer=m1 \
 //thickness=0.36 //x=23.8 //y=2.595 //x2=23.845 //y2=2.755
r383 (  13 14 ) resistor r=0.634542 //w=0.131 //l=0.665 //layer=m1 \
 //thickness=0.36 //x=23.8 //y=1.93 //x2=23.8 //y2=2.595
r384 (  11 13 ) resistor r=0.0698411 //w=0.17 //l=0.120208 //layer=m1 \
 //thickness=0.36 //x=23.715 //y=1.845 //x2=23.8 //y2=1.93
r385 (  11 12 ) resistor r=0.300573 //w=0.131 //l=0.315 //layer=m1 \
 //thickness=0.36 //x=23.715 //y=1.845 //x2=23.4 //y2=1.845
r386 (  10 12 ) resistor r=0.0698411 //w=0.17 //l=0.120208 //layer=m1 \
 //thickness=0.36 //x=23.315 //y=1.76 //x2=23.4 //y2=1.845
r387 (  9 31 ) resistor r=0.0717383 //w=0.224 //l=0.115 //layer=m1 \
 //thickness=0.36 //x=23.315 //y=1.305 //x2=23.315 //y2=1.19
r388 (  9 10 ) resistor r=0.43416 //w=0.131 //l=0.455 //layer=m1 \
 //thickness=0.36 //x=23.315 //y=1.305 //x2=23.315 //y2=1.76
r389 (  8 27 ) resistor r=0.0675342 //w=0.23 //l=0.115 //layer=m1 \
 //thickness=0.36 //x=23.135 //y=5.335 //x2=23.02 //y2=5.335
r390 (  7 16 ) resistor r=0.0698411 //w=0.17 //l=0.120208 //layer=m1 \
 //thickness=0.36 //x=23.715 //y=5.335 //x2=23.8 //y2=5.25
r391 (  7 8 ) resistor r=0.553435 //w=0.131 //l=0.58 //layer=m1 \
 //thickness=0.36 //x=23.715 //y=5.335 //x2=23.135 //y2=5.335
r392 (  6 29 ) resistor r=0.00118313 //w=0.23 //layer=m1 //thickness=0.36 \
 //x=23.02 //y=5.56 //x2=23.02 //y2=5.56
r393 (  5 27 ) resistor r=0.002872 //w=0.34 //l=0.085 //layer=m1 \
 //thickness=0.36 //x=23.02 //y=5.42 //x2=23.02 //y2=5.335
r394 (  5 6 ) resistor r=0.091623 //w=0.191 //l=0.14 //layer=m1 \
 //thickness=0.36 //x=23.02 //y=5.42 //x2=23.02 //y2=5.56
r395 (  4 24 ) resistor r=0.0262263 //w=0.232 //l=0.12 //layer=m1 \
 //thickness=0.36 //x=22.26 //y=5.335 //x2=22.14 //y2=5.335
r396 (  3 27 ) resistor r=0.0675342 //w=0.23 //l=0.115 //layer=m1 \
 //thickness=0.36 //x=22.905 //y=5.335 //x2=23.02 //y2=5.335
r397 (  3 4 ) resistor r=0.615458 //w=0.131 //l=0.645 //layer=m1 \
 //thickness=0.36 //x=22.905 //y=5.335 //x2=22.26 //y2=5.335
r398 (  2 21 ) resistor r=0.0222262 //w=0.217 //l=0.118 //layer=m1 \
 //thickness=0.36 //x=21.38 //y=5.335 //x2=21.262 //y2=5.335
r399 (  1 24 ) resistor r=0.0262263 //w=0.232 //l=0.12 //layer=m1 \
 //thickness=0.36 //x=22.02 //y=5.335 //x2=22.14 //y2=5.335
r400 (  1 2 ) resistor r=0.610687 //w=0.131 //l=0.64 //layer=m1 \
 //thickness=0.36 //x=22.02 //y=5.335 //x2=21.38 //y2=5.335
ends PM_TMRDFFSNRNQX1\%noxref_4

subckt PM_TMRDFFSNRNQX1\%noxref_5 ( 1 2 3 4 5 6 7 8 9 11 14 15 17 18 19 20 22 \
 23 24 25 26 27 28 34 38 45 48 51 57 61 70 72 73 77 80 81 87 96 101 110 115 \
 123 131 148 157 161 162 163 164 165 166 167 168 169 173 174 175 180 182 185 \
 186 190 191 192 197 199 202 203 207 208 209 214 216 219 220 222 223 228 232 \
 233 238 242 243 248 251 253 254 255 )
c597 ( 251 0 ) capacitor c=0.00885916f //x=18.315 //y=1.095
c598 ( 248 0 ) capacitor c=0.0634276f //x=27.87 //y=4.88
c599 ( 243 0 ) capacitor c=0.0278202f //x=27.87 //y=2.095
c600 ( 242 0 ) capacitor c=0.0503043f //x=27.87 //y=2.26
c601 ( 238 0 ) capacitor c=0.0651406f //x=13.44 //y=4.88
c602 ( 233 0 ) capacitor c=0.0278202f //x=13.44 //y=2.095
c603 ( 232 0 ) capacitor c=0.0503043f //x=13.44 //y=2.26
c604 ( 228 0 ) capacitor c=0.0653609f //x=8.63 //y=4.88
c605 ( 223 0 ) capacitor c=0.0278202f //x=8.63 //y=2.095
c606 ( 222 0 ) capacitor c=0.0503043f //x=8.63 //y=2.26
c607 ( 220 0 ) capacitor c=0.0443175f //x=28.39 //y=1.44
c608 ( 219 0 ) capacitor c=0.0199703f //x=28.39 //y=1.095
c609 ( 216 0 ) capacitor c=0.0162526f //x=28.235 //y=1.595
c610 ( 214 0 ) capacitor c=0.0157807f //x=28.235 //y=0.94
c611 ( 209 0 ) capacitor c=0.0220935f //x=27.86 //y=1.75
c612 ( 208 0 ) capacitor c=0.0207489f //x=27.86 //y=1.44
c613 ( 207 0 ) capacitor c=0.0194091f //x=27.86 //y=1.095
c614 ( 203 0 ) capacitor c=0.0443175f //x=13.96 //y=1.44
c615 ( 202 0 ) capacitor c=0.0199703f //x=13.96 //y=1.095
c616 ( 199 0 ) capacitor c=0.0162526f //x=13.805 //y=1.595
c617 ( 197 0 ) capacitor c=0.0157807f //x=13.805 //y=0.94
c618 ( 192 0 ) capacitor c=0.0220935f //x=13.43 //y=1.75
c619 ( 191 0 ) capacitor c=0.0207489f //x=13.43 //y=1.44
c620 ( 190 0 ) capacitor c=0.0194091f //x=13.43 //y=1.095
c621 ( 186 0 ) capacitor c=0.0443175f //x=9.15 //y=1.44
c622 ( 185 0 ) capacitor c=0.0199703f //x=9.15 //y=1.095
c623 ( 182 0 ) capacitor c=0.0162526f //x=8.995 //y=1.595
c624 ( 180 0 ) capacitor c=0.0157807f //x=8.995 //y=0.94
c625 ( 175 0 ) capacitor c=0.0220935f //x=8.62 //y=1.75
c626 ( 174 0 ) capacitor c=0.0207489f //x=8.62 //y=1.44
c627 ( 173 0 ) capacitor c=0.0194091f //x=8.62 //y=1.095
c628 ( 169 0 ) capacitor c=0.15931f //x=28.05 //y=6.2
c629 ( 168 0 ) capacitor c=0.110208f //x=27.61 //y=6.2
c630 ( 167 0 ) capacitor c=0.159671f //x=13.62 //y=6.2
c631 ( 166 0 ) capacitor c=0.110208f //x=13.18 //y=6.2
c632 ( 165 0 ) capacitor c=0.159671f //x=8.81 //y=6.2
c633 ( 164 0 ) capacitor c=0.110208f //x=8.37 //y=6.2
c634 ( 157 0 ) capacitor c=7.7417e-19 //x=27.87 //y=4.88
c635 ( 148 0 ) capacitor c=0.00101179f //x=27.87 //y=2.26
c636 ( 131 0 ) capacitor c=0.0293124f //x=18.21 //y=5.56
c637 ( 123 0 ) capacitor c=0.029137f //x=17.33 //y=5.56
c638 ( 115 0 ) capacitor c=0.0278099f //x=16.45 //y=5.56
c639 ( 110 0 ) capacitor c=7.7417e-19 //x=13.44 //y=4.88
c640 ( 101 0 ) capacitor c=0.00101179f //x=13.44 //y=2.26
c641 ( 96 0 ) capacitor c=7.7417e-19 //x=8.63 //y=4.88
c642 ( 87 0 ) capacitor c=0.00101179f //x=8.63 //y=2.26
c643 ( 81 0 ) capacitor c=6.2466e-19 //x=13.6 //y=3.895
c644 ( 80 0 ) capacitor c=0.0446269f //x=13.28 //y=3.895
c645 ( 77 0 ) capacitor c=6.16295e-19 //x=8.79 //y=3.895
c646 ( 73 0 ) capacitor c=0.0212158f //x=20.705 //y=3.895
c647 ( 72 0 ) capacitor c=0.0724152f //x=21.05 //y=3.895
c648 ( 70 0 ) capacitor c=0.0535679f //x=18.82 //y=3.88
c649 ( 61 0 ) capacitor c=0.0149589f //x=27.87 //y=3.88
c650 ( 57 0 ) capacitor c=0.0158949f //x=18.99 //y=3.88
c651 ( 51 0 ) capacitor c=0.00111241f //x=18.21 //y=5.335
c652 ( 48 0 ) capacitor c=0.00731246f //x=17.33 //y=5.335
c653 ( 45 0 ) capacitor c=0.0111234f //x=16.452 //y=5.335
c654 ( 38 0 ) capacitor c=0.0149589f //x=13.44 //y=3.88
c655 ( 34 0 ) capacitor c=0.0149589f //x=8.63 //y=3.88
c656 ( 28 0 ) capacitor c=0.019355f //x=27.87 //y=4.75
c657 ( 27 0 ) capacitor c=0.011467f //x=27.87 //y=4.045
c658 ( 26 0 ) capacitor c=0.0290894f //x=27.87 //y=3.725
c659 ( 25 0 ) capacitor c=0.00556102f //x=27.87 //y=2.375
c660 ( 24 0 ) capacitor c=0.0323149f //x=18.99 //y=5.25
c661 ( 23 0 ) capacitor c=0.0138897f //x=18.99 //y=4.055
c662 ( 22 0 ) capacitor c=0.0490588f //x=18.99 //y=3.735
c663 ( 20 0 ) capacitor c=0.00493487f //x=18.59 //y=1.845
c664 ( 19 0 ) capacitor c=0.0133342f //x=18.905 //y=1.845
c665 ( 18 0 ) capacitor c=0.0167992f //x=18.505 //y=1.76
c666 ( 17 0 ) capacitor c=0.0111491f //x=18.505 //y=1.305
c667 ( 15 0 ) capacitor c=0.0238276f //x=18.905 //y=5.335
c668 ( 14 0 ) capacitor c=0.00933983f //x=18.21 //y=5.56
c669 ( 11 0 ) capacitor c=0.019596f //x=18.095 //y=5.335
c670 ( 9 0 ) capacitor c=0.0148057f //x=17.21 //y=5.335
c671 ( 8 0 ) capacitor c=0.0195876f //x=13.44 //y=4.75
c672 ( 7 0 ) capacitor c=0.011494f //x=13.44 //y=4.055
c673 ( 6 0 ) capacitor c=0.029293f //x=13.44 //y=3.735
c674 ( 5 0 ) capacitor c=0.00556102f //x=13.44 //y=2.375
c675 ( 4 0 ) capacitor c=0.019633f //x=8.63 //y=4.75
c676 ( 3 0 ) capacitor c=0.0115187f //x=8.63 //y=4.055
c677 ( 2 0 ) capacitor c=0.0329467f //x=8.63 //y=3.735
c678 ( 1 0 ) capacitor c=0.00556102f //x=8.63 //y=2.375
r679 (  242 243 ) resistor r=52.7279 //w=0.214 //l=0.165 //layer=ply \
 //thickness=0.18 //x=27.87 //y=2.26 //x2=27.87 //y2=2.095
r680 (  232 233 ) resistor r=52.7279 //w=0.214 //l=0.165 //layer=ply \
 //thickness=0.18 //x=13.44 //y=2.26 //x2=13.44 //y2=2.095
r681 (  222 223 ) resistor r=52.7279 //w=0.214 //l=0.165 //layer=ply \
 //thickness=0.18 //x=8.63 //y=2.26 //x2=8.63 //y2=2.095
r682 (  220 250 ) resistor r=45.1352 //w=0.168 //l=0.173853 //layer=ply \
 //thickness=0.18 //x=28.39 //y=1.44 //x2=28.35 //y2=1.595
r683 (  219 249 ) resistor r=45.1352 //w=0.168 //l=0.173853 //layer=ply \
 //thickness=0.18 //x=28.39 //y=1.095 //x2=28.35 //y2=0.94
r684 (  219 220 ) resistor r=176.904 //w=0.094 //l=0.345 //layer=ply \
 //thickness=0.18 //x=28.39 //y=1.095 //x2=28.39 //y2=1.44
r685 (  217 246 ) resistor r=10.701 //w=0.21 //l=0.115 //layer=ply \
 //thickness=0.18 //x=28.015 //y=1.595 //x2=27.9 //y2=1.595
r686 (  216 250 ) resistor r=5.52526 //w=0.168 //l=0.115 //layer=ply \
 //thickness=0.18 //x=28.235 //y=1.595 //x2=28.35 //y2=1.595
r687 (  215 245 ) resistor r=5.52526 //w=0.168 //l=0.115 //layer=ply \
 //thickness=0.18 //x=28.015 //y=0.94 //x2=27.9 //y2=0.94
r688 (  214 249 ) resistor r=5.52526 //w=0.168 //l=0.115 //layer=ply \
 //thickness=0.18 //x=28.235 //y=0.94 //x2=28.35 //y2=0.94
r689 (  214 215 ) resistor r=112.809 //w=0.094 //l=0.22 //layer=ply \
 //thickness=0.18 //x=28.235 //y=0.94 //x2=28.015 //y2=0.94
r690 (  211 248 ) resistor r=37.236 //w=0.233 //l=0.249199 //layer=ply \
 //thickness=0.18 //x=28.05 //y=5.045 //x2=27.87 //y2=4.88
r691 (  209 246 ) resistor r=39.5823 //w=0.21 //l=0.173853 //layer=ply \
 //thickness=0.18 //x=27.86 //y=1.75 //x2=27.9 //y2=1.595
r692 (  209 243 ) resistor r=176.904 //w=0.094 //l=0.345 //layer=ply \
 //thickness=0.18 //x=27.86 //y=1.75 //x2=27.86 //y2=2.095
r693 (  208 246 ) resistor r=39.5823 //w=0.21 //l=0.173853 //layer=ply \
 //thickness=0.18 //x=27.86 //y=1.44 //x2=27.9 //y2=1.595
r694 (  207 245 ) resistor r=45.1352 //w=0.168 //l=0.173853 //layer=ply \
 //thickness=0.18 //x=27.86 //y=1.095 //x2=27.9 //y2=0.94
r695 (  207 208 ) resistor r=176.904 //w=0.094 //l=0.345 //layer=ply \
 //thickness=0.18 //x=27.86 //y=1.095 //x2=27.86 //y2=1.44
r696 (  204 248 ) resistor r=53.7854 //w=0.233 //l=0.332415 //layer=ply \
 //thickness=0.18 //x=27.61 //y=5.045 //x2=27.87 //y2=4.88
r697 (  203 240 ) resistor r=45.1352 //w=0.168 //l=0.173853 //layer=ply \
 //thickness=0.18 //x=13.96 //y=1.44 //x2=13.92 //y2=1.595
r698 (  202 239 ) resistor r=45.1352 //w=0.168 //l=0.173853 //layer=ply \
 //thickness=0.18 //x=13.96 //y=1.095 //x2=13.92 //y2=0.94
r699 (  202 203 ) resistor r=176.904 //w=0.094 //l=0.345 //layer=ply \
 //thickness=0.18 //x=13.96 //y=1.095 //x2=13.96 //y2=1.44
r700 (  200 236 ) resistor r=10.701 //w=0.21 //l=0.115 //layer=ply \
 //thickness=0.18 //x=13.585 //y=1.595 //x2=13.47 //y2=1.595
r701 (  199 240 ) resistor r=5.52526 //w=0.168 //l=0.115 //layer=ply \
 //thickness=0.18 //x=13.805 //y=1.595 //x2=13.92 //y2=1.595
r702 (  198 235 ) resistor r=5.52526 //w=0.168 //l=0.115 //layer=ply \
 //thickness=0.18 //x=13.585 //y=0.94 //x2=13.47 //y2=0.94
r703 (  197 239 ) resistor r=5.52526 //w=0.168 //l=0.115 //layer=ply \
 //thickness=0.18 //x=13.805 //y=0.94 //x2=13.92 //y2=0.94
r704 (  197 198 ) resistor r=112.809 //w=0.094 //l=0.22 //layer=ply \
 //thickness=0.18 //x=13.805 //y=0.94 //x2=13.585 //y2=0.94
r705 (  194 238 ) resistor r=37.236 //w=0.233 //l=0.249199 //layer=ply \
 //thickness=0.18 //x=13.62 //y=5.045 //x2=13.44 //y2=4.88
r706 (  192 236 ) resistor r=39.5823 //w=0.21 //l=0.173853 //layer=ply \
 //thickness=0.18 //x=13.43 //y=1.75 //x2=13.47 //y2=1.595
r707 (  192 233 ) resistor r=176.904 //w=0.094 //l=0.345 //layer=ply \
 //thickness=0.18 //x=13.43 //y=1.75 //x2=13.43 //y2=2.095
r708 (  191 236 ) resistor r=39.5823 //w=0.21 //l=0.173853 //layer=ply \
 //thickness=0.18 //x=13.43 //y=1.44 //x2=13.47 //y2=1.595
r709 (  190 235 ) resistor r=45.1352 //w=0.168 //l=0.173853 //layer=ply \
 //thickness=0.18 //x=13.43 //y=1.095 //x2=13.47 //y2=0.94
r710 (  190 191 ) resistor r=176.904 //w=0.094 //l=0.345 //layer=ply \
 //thickness=0.18 //x=13.43 //y=1.095 //x2=13.43 //y2=1.44
r711 (  187 238 ) resistor r=53.7854 //w=0.233 //l=0.332415 //layer=ply \
 //thickness=0.18 //x=13.18 //y=5.045 //x2=13.44 //y2=4.88
r712 (  186 230 ) resistor r=45.1352 //w=0.168 //l=0.173853 //layer=ply \
 //thickness=0.18 //x=9.15 //y=1.44 //x2=9.11 //y2=1.595
r713 (  185 229 ) resistor r=45.1352 //w=0.168 //l=0.173853 //layer=ply \
 //thickness=0.18 //x=9.15 //y=1.095 //x2=9.11 //y2=0.94
r714 (  185 186 ) resistor r=176.904 //w=0.094 //l=0.345 //layer=ply \
 //thickness=0.18 //x=9.15 //y=1.095 //x2=9.15 //y2=1.44
r715 (  183 226 ) resistor r=10.701 //w=0.21 //l=0.115 //layer=ply \
 //thickness=0.18 //x=8.775 //y=1.595 //x2=8.66 //y2=1.595
r716 (  182 230 ) resistor r=5.52526 //w=0.168 //l=0.115 //layer=ply \
 //thickness=0.18 //x=8.995 //y=1.595 //x2=9.11 //y2=1.595
r717 (  181 225 ) resistor r=5.52526 //w=0.168 //l=0.115 //layer=ply \
 //thickness=0.18 //x=8.775 //y=0.94 //x2=8.66 //y2=0.94
r718 (  180 229 ) resistor r=5.52526 //w=0.168 //l=0.115 //layer=ply \
 //thickness=0.18 //x=8.995 //y=0.94 //x2=9.11 //y2=0.94
r719 (  180 181 ) resistor r=112.809 //w=0.094 //l=0.22 //layer=ply \
 //thickness=0.18 //x=8.995 //y=0.94 //x2=8.775 //y2=0.94
r720 (  177 228 ) resistor r=37.236 //w=0.233 //l=0.249199 //layer=ply \
 //thickness=0.18 //x=8.81 //y=5.045 //x2=8.63 //y2=4.88
r721 (  175 226 ) resistor r=39.5823 //w=0.21 //l=0.173853 //layer=ply \
 //thickness=0.18 //x=8.62 //y=1.75 //x2=8.66 //y2=1.595
r722 (  175 223 ) resistor r=176.904 //w=0.094 //l=0.345 //layer=ply \
 //thickness=0.18 //x=8.62 //y=1.75 //x2=8.62 //y2=2.095
r723 (  174 226 ) resistor r=39.5823 //w=0.21 //l=0.173853 //layer=ply \
 //thickness=0.18 //x=8.62 //y=1.44 //x2=8.66 //y2=1.595
r724 (  173 225 ) resistor r=45.1352 //w=0.168 //l=0.173853 //layer=ply \
 //thickness=0.18 //x=8.62 //y=1.095 //x2=8.66 //y2=0.94
r725 (  173 174 ) resistor r=176.904 //w=0.094 //l=0.345 //layer=ply \
 //thickness=0.18 //x=8.62 //y=1.095 //x2=8.62 //y2=1.44
r726 (  170 228 ) resistor r=53.7854 //w=0.233 //l=0.332415 //layer=ply \
 //thickness=0.18 //x=8.37 //y=5.045 //x2=8.63 //y2=4.88
r727 (  169 211 ) resistor r=592.245 //w=0.094 //l=1.155 //layer=ply \
 //thickness=0.18 //x=28.05 //y=6.2 //x2=28.05 //y2=5.045
r728 (  168 204 ) resistor r=592.245 //w=0.094 //l=1.155 //layer=ply \
 //thickness=0.18 //x=27.61 //y=6.2 //x2=27.61 //y2=5.045
r729 (  167 194 ) resistor r=592.245 //w=0.094 //l=1.155 //layer=ply \
 //thickness=0.18 //x=13.62 //y=6.2 //x2=13.62 //y2=5.045
r730 (  166 187 ) resistor r=592.245 //w=0.094 //l=1.155 //layer=ply \
 //thickness=0.18 //x=13.18 //y=6.2 //x2=13.18 //y2=5.045
r731 (  165 177 ) resistor r=592.245 //w=0.094 //l=1.155 //layer=ply \
 //thickness=0.18 //x=8.81 //y=6.2 //x2=8.81 //y2=5.045
r732 (  164 170 ) resistor r=592.245 //w=0.094 //l=1.155 //layer=ply \
 //thickness=0.18 //x=8.37 //y=6.2 //x2=8.37 //y2=5.045
r733 (  163 216 ) resistor r=56.4043 //w=0.094 //l=0.11 //layer=ply \
 //thickness=0.18 //x=28.125 //y=1.595 //x2=28.235 //y2=1.595
r734 (  163 217 ) resistor r=56.4043 //w=0.094 //l=0.11 //layer=ply \
 //thickness=0.18 //x=28.125 //y=1.595 //x2=28.015 //y2=1.595
r735 (  162 199 ) resistor r=56.4043 //w=0.094 //l=0.11 //layer=ply \
 //thickness=0.18 //x=13.695 //y=1.595 //x2=13.805 //y2=1.595
r736 (  162 200 ) resistor r=56.4043 //w=0.094 //l=0.11 //layer=ply \
 //thickness=0.18 //x=13.695 //y=1.595 //x2=13.585 //y2=1.595
r737 (  161 182 ) resistor r=56.4043 //w=0.094 //l=0.11 //layer=ply \
 //thickness=0.18 //x=8.885 //y=1.595 //x2=8.995 //y2=1.595
r738 (  161 183 ) resistor r=56.4043 //w=0.094 //l=0.11 //layer=ply \
 //thickness=0.18 //x=8.885 //y=1.595 //x2=8.775 //y2=1.595
r739 (  157 248 ) resistor r=152 //w=0.17 //l=0.17 //layer=licon //count=1 \
 //x=27.87 //y=4.88 //x2=27.87 //y2=4.88
r740 (  148 242 ) resistor r=152 //w=0.17 //l=0.17 //layer=licon //count=1 \
 //x=27.87 //y=2.26 //x2=27.87 //y2=2.26
r741 (  131 255 ) resistor r=23.615 //w=0.187 //l=0.345 //layer=li \
 //thickness=0.1 //x=18.21 //y=5.56 //x2=18.21 //y2=5.905
r742 (  123 254 ) resistor r=23.615 //w=0.187 //l=0.345 //layer=li \
 //thickness=0.1 //x=17.33 //y=5.56 //x2=17.33 //y2=5.905
r743 (  115 253 ) resistor r=23.615 //w=0.187 //l=0.345 //layer=li \
 //thickness=0.1 //x=16.45 //y=5.56 //x2=16.45 //y2=5.905
r744 (  110 238 ) resistor r=152 //w=0.17 //l=0.17 //layer=licon //count=1 \
 //x=13.44 //y=4.88 //x2=13.44 //y2=4.88
r745 (  101 232 ) resistor r=152 //w=0.17 //l=0.17 //layer=licon //count=1 \
 //x=13.44 //y=2.26 //x2=13.44 //y2=2.26
r746 (  96 228 ) resistor r=152 //w=0.17 //l=0.17 //layer=licon //count=1 \
 //x=8.63 //y=4.88 //x2=8.63 //y2=4.88
r747 (  87 222 ) resistor r=152 //w=0.17 //l=0.17 //layer=licon //count=1 \
 //x=8.63 //y=2.26 //x2=8.63 //y2=2.26
r748 (  79 81 ) resistor r=0.10734 //w=0.281 //l=0.16 //layer=m2 \
 //thickness=0.36 //x=13.44 //y=3.895 //x2=13.6 //y2=3.895
r749 (  79 80 ) resistor r=0.10734 //w=0.281 //l=0.16 //layer=m2 \
 //thickness=0.36 //x=13.44 //y=3.895 //x2=13.28 //y2=3.895
r750 (  77 80 ) resistor r=4.28435 //w=0.131 //l=4.49 //layer=m2 \
 //thickness=0.36 //x=8.79 //y=3.88 //x2=13.28 //y2=3.88
r751 (  75 77 ) resistor r=0.10734 //w=0.281 //l=0.16 //layer=m2 \
 //thickness=0.36 //x=8.63 //y=3.895 //x2=8.79 //y2=3.895
r752 (  73 83 ) resistor r=1.10266 //w=0.196 //l=1.725 //layer=m2 \
 //thickness=0.36 //x=20.705 //y=3.895 //x2=18.98 //y2=3.895
r753 (  72 85 ) resistor r=4.81638 //w=0.177 //l=6.825 //layer=m2 \
 //thickness=0.36 //x=21.05 //y=3.895 //x2=27.87 //y2=3.885
r754 (  72 73 ) resistor r=0.329198 //w=0.131 //l=0.345 //layer=m2 \
 //thickness=0.36 //x=21.05 //y=3.895 //x2=20.705 //y2=3.895
r755 (  70 83 ) resistor r=0.104578 //w=0.196 //l=0.167332 //layer=m2 \
 //thickness=0.36 //x=18.82 //y=3.88 //x2=18.98 //y2=3.895
r756 (  70 81 ) resistor r=4.98092 //w=0.131 //l=5.22 //layer=m2 \
 //thickness=0.36 //x=18.82 //y=3.88 //x2=13.6 //y2=3.88
r757 (  67 157 ) resistor r=9.3 //w=0.17 //l=0.17 //layer=mcon //count=1 \
 //x=27.87 //y=4.88 //x2=27.87 //y2=4.88
r758 (  65 148 ) resistor r=9.3 //w=0.17 //l=0.17 //layer=mcon //count=1 \
 //x=27.87 //y=2.26 //x2=27.87 //y2=2.26
r759 (  63 85 ) resistor r=4.5 //w=0.15 //l=0.15 //layer=via1 //count=1 \
 //x=27.87 //y=3.885 //x2=27.87 //y2=3.885
r760 (  61 63 ) resistor r=0.00166223 //w=0.376 //l=0.005 //layer=m1 \
 //thickness=0.36 //x=27.817 //y=3.88 //x2=27.817 //y2=3.885
r761 (  59 83 ) resistor r=4.5 //w=0.15 //l=0.15 //layer=via1 //count=1 \
 //x=18.98 //y=3.895 //x2=18.98 //y2=3.895
r762 (  57 59 ) resistor r=0.00490838 //w=0.382 //l=0.015 //layer=m1 \
 //thickness=0.36 //x=19.037 //y=3.88 //x2=19.037 //y2=3.895
r763 (  55 251 ) resistor r=9.3 //w=0.17 //l=0.17 //layer=mcon //count=1 \
 //x=18.505 //y=1.19 //x2=18.505 //y2=1.19
r764 (  53 131 ) resistor r=9.3 //w=0.17 //l=0.17 //layer=mcon //count=1 \
 //x=18.21 //y=5.56 //x2=18.21 //y2=5.56
r765 (  50 123 ) resistor r=9.3 //w=0.17 //l=0.17 //layer=mcon //count=1 \
 //x=17.33 //y=5.56 //x2=17.33 //y2=5.56
r766 (  48 50 ) resistor r=0.121228 //w=0.232 //l=0.225 //layer=m1 \
 //thickness=0.36 //x=17.33 //y=5.335 //x2=17.33 //y2=5.56
r767 (  47 115 ) resistor r=9.3 //w=0.17 //l=0.17 //layer=mcon //count=1 \
 //x=16.45 //y=5.56 //x2=16.45 //y2=5.56
r768 (  45 47 ) resistor r=0.129608 //w=0.217 //l=0.225 //layer=m1 \
 //thickness=0.36 //x=16.452 //y=5.335 //x2=16.452 //y2=5.56
r769 (  44 110 ) resistor r=9.3 //w=0.17 //l=0.17 //layer=mcon //count=1 \
 //x=13.44 //y=4.88 //x2=13.44 //y2=4.88
r770 (  42 101 ) resistor r=9.3 //w=0.17 //l=0.17 //layer=mcon //count=1 \
 //x=13.44 //y=2.26 //x2=13.44 //y2=2.26
r771 (  40 79 ) resistor r=4.5 //w=0.15 //l=0.15 //layer=via1 //count=1 \
 //x=13.44 //y=3.895 //x2=13.44 //y2=3.895
r772 (  38 40 ) resistor r=0.0049867 //w=0.376 //l=0.015 //layer=m1 \
 //thickness=0.36 //x=13.387 //y=3.88 //x2=13.387 //y2=3.895
r773 (  36 75 ) resistor r=4.5 //w=0.15 //l=0.15 //layer=via1 //count=1 \
 //x=8.63 //y=3.895 //x2=8.63 //y2=3.895
r774 (  34 36 ) resistor r=0.0049867 //w=0.376 //l=0.015 //layer=m1 \
 //thickness=0.36 //x=8.682 //y=3.88 //x2=8.682 //y2=3.895
r775 (  32 96 ) resistor r=9.3 //w=0.17 //l=0.17 //layer=mcon //count=1 \
 //x=8.63 //y=4.88 //x2=8.63 //y2=4.88
r776 (  30 87 ) resistor r=9.3 //w=0.17 //l=0.17 //layer=mcon //count=1 \
 //x=8.63 //y=2.26 //x2=8.63 //y2=2.26
r777 (  28 67 ) resistor r=0.0801089 //w=0.224 //l=0.13 //layer=m1 \
 //thickness=0.36 //x=27.87 //y=4.75 //x2=27.87 //y2=4.88
r778 (  27 63 ) resistor r=0.0911593 //w=0.376 //l=0.184608 //layer=m1 \
 //thickness=0.36 //x=27.87 //y=4.045 //x2=27.817 //y2=3.885
r779 (  27 28 ) resistor r=0.67271 //w=0.131 //l=0.705 //layer=m1 \
 //thickness=0.36 //x=27.87 //y=4.045 //x2=27.87 //y2=4.75
r780 (  26 61 ) resistor r=0.0894971 //w=0.376 //l=0.179555 //layer=m1 \
 //thickness=0.36 //x=27.87 //y=3.725 //x2=27.817 //y2=3.88
r781 (  25 65 ) resistor r=0.0719237 //w=0.222 //l=0.115 //layer=m1 \
 //thickness=0.36 //x=27.87 //y=2.375 //x2=27.87 //y2=2.26
r782 (  25 26 ) resistor r=1.28817 //w=0.131 //l=1.35 //layer=m1 \
 //thickness=0.36 //x=27.87 //y=2.375 //x2=27.87 //y2=3.725
r783 (  23 59 ) resistor r=0.0914072 //w=0.382 //l=0.181989 //layer=m1 \
 //thickness=0.36 //x=18.99 //y=4.055 //x2=19.037 //y2=3.895
r784 (  23 24 ) resistor r=1.14027 //w=0.131 //l=1.195 //layer=m1 \
 //thickness=0.36 //x=18.99 //y=4.055 //x2=18.99 //y2=5.25
r785 (  22 57 ) resistor r=0.0864989 //w=0.382 //l=0.166853 //layer=m1 \
 //thickness=0.36 //x=18.99 //y=3.735 //x2=19.037 //y2=3.88
r786 (  21 22 ) resistor r=1.72233 //w=0.131 //l=1.805 //layer=m1 \
 //thickness=0.36 //x=18.99 //y=1.93 //x2=18.99 //y2=3.735
r787 (  19 21 ) resistor r=0.0698411 //w=0.17 //l=0.120208 //layer=m1 \
 //thickness=0.36 //x=18.905 //y=1.845 //x2=18.99 //y2=1.93
r788 (  19 20 ) resistor r=0.300573 //w=0.131 //l=0.315 //layer=m1 \
 //thickness=0.36 //x=18.905 //y=1.845 //x2=18.59 //y2=1.845
r789 (  18 20 ) resistor r=0.0698411 //w=0.17 //l=0.120208 //layer=m1 \
 //thickness=0.36 //x=18.505 //y=1.76 //x2=18.59 //y2=1.845
r790 (  17 55 ) resistor r=0.0717383 //w=0.224 //l=0.115 //layer=m1 \
 //thickness=0.36 //x=18.505 //y=1.305 //x2=18.505 //y2=1.19
r791 (  17 18 ) resistor r=0.43416 //w=0.131 //l=0.455 //layer=m1 \
 //thickness=0.36 //x=18.505 //y=1.305 //x2=18.505 //y2=1.76
r792 (  16 51 ) resistor r=0.0675342 //w=0.23 //l=0.115 //layer=m1 \
 //thickness=0.36 //x=18.325 //y=5.335 //x2=18.21 //y2=5.335
r793 (  15 24 ) resistor r=0.0698411 //w=0.17 //l=0.120208 //layer=m1 \
 //thickness=0.36 //x=18.905 //y=5.335 //x2=18.99 //y2=5.25
r794 (  15 16 ) resistor r=0.553435 //w=0.131 //l=0.58 //layer=m1 \
 //thickness=0.36 //x=18.905 //y=5.335 //x2=18.325 //y2=5.335
r795 (  14 53 ) resistor r=0.00118313 //w=0.23 //layer=m1 //thickness=0.36 \
 //x=18.21 //y=5.56 //x2=18.21 //y2=5.56
r796 (  13 51 ) resistor r=0.002872 //w=0.34 //l=0.085 //layer=m1 \
 //thickness=0.36 //x=18.21 //y=5.42 //x2=18.21 //y2=5.335
r797 (  13 14 ) resistor r=0.091623 //w=0.191 //l=0.14 //layer=m1 \
 //thickness=0.36 //x=18.21 //y=5.42 //x2=18.21 //y2=5.56
r798 (  12 48 ) resistor r=0.0262263 //w=0.232 //l=0.12 //layer=m1 \
 //thickness=0.36 //x=17.45 //y=5.335 //x2=17.33 //y2=5.335
r799 (  11 51 ) resistor r=0.0675342 //w=0.23 //l=0.115 //layer=m1 \
 //thickness=0.36 //x=18.095 //y=5.335 //x2=18.21 //y2=5.335
r800 (  11 12 ) resistor r=0.615458 //w=0.131 //l=0.645 //layer=m1 \
 //thickness=0.36 //x=18.095 //y=5.335 //x2=17.45 //y2=5.335
r801 (  10 45 ) resistor r=0.0222262 //w=0.217 //l=0.118 //layer=m1 \
 //thickness=0.36 //x=16.57 //y=5.335 //x2=16.452 //y2=5.335
r802 (  9 48 ) resistor r=0.0262263 //w=0.232 //l=0.12 //layer=m1 \
 //thickness=0.36 //x=17.21 //y=5.335 //x2=17.33 //y2=5.335
r803 (  9 10 ) resistor r=0.610687 //w=0.131 //l=0.64 //layer=m1 \
 //thickness=0.36 //x=17.21 //y=5.335 //x2=16.57 //y2=5.335
r804 (  8 44 ) resistor r=0.0801089 //w=0.224 //l=0.13 //layer=m1 \
 //thickness=0.36 //x=13.44 //y=4.75 //x2=13.44 //y2=4.88
r805 (  7 40 ) resistor r=0.0911593 //w=0.376 //l=0.184608 //layer=m1 \
 //thickness=0.36 //x=13.44 //y=4.055 //x2=13.387 //y2=3.895
r806 (  7 8 ) resistor r=0.663168 //w=0.131 //l=0.695 //layer=m1 \
 //thickness=0.36 //x=13.44 //y=4.055 //x2=13.44 //y2=4.75
r807 (  6 38 ) resistor r=0.0861726 //w=0.376 //l=0.16944 //layer=m1 \
 //thickness=0.36 //x=13.44 //y=3.735 //x2=13.387 //y2=3.88
r808 (  5 42 ) resistor r=0.0719237 //w=0.222 //l=0.115 //layer=m1 \
 //thickness=0.36 //x=13.44 //y=2.375 //x2=13.44 //y2=2.26
r809 (  5 6 ) resistor r=1.29771 //w=0.131 //l=1.36 //layer=m1 \
 //thickness=0.36 //x=13.44 //y=2.375 //x2=13.44 //y2=3.735
r810 (  4 32 ) resistor r=0.0801089 //w=0.224 //l=0.13 //layer=m1 \
 //thickness=0.36 //x=8.63 //y=4.75 //x2=8.63 //y2=4.88
r811 (  3 36 ) resistor r=0.0911593 //w=0.376 //l=0.184174 //layer=m1 \
 //thickness=0.36 //x=8.63 //y=4.055 //x2=8.682 //y2=3.895
r812 (  3 4 ) resistor r=0.663168 //w=0.131 //l=0.695 //layer=m1 \
 //thickness=0.36 //x=8.63 //y=4.055 //x2=8.63 //y2=4.75
r813 (  2 34 ) resistor r=0.0861726 //w=0.376 //l=0.169012 //layer=m1 \
 //thickness=0.36 //x=8.63 //y=3.735 //x2=8.682 //y2=3.88
r814 (  1 30 ) resistor r=0.0719237 //w=0.222 //l=0.115 //layer=m1 \
 //thickness=0.36 //x=8.63 //y=2.375 //x2=8.63 //y2=2.26
r815 (  1 2 ) resistor r=1.29771 //w=0.131 //l=1.36 //layer=m1 \
 //thickness=0.36 //x=8.63 //y=2.375 //x2=8.63 //y2=3.735
ends PM_TMRDFFSNRNQX1\%noxref_5

subckt PM_TMRDFFSNRNQX1\%noxref_6 ( 1 2 3 4 5 7 10 11 13 14 15 16 18 19 20 21 \
 22 23 24 32 33 36 39 45 49 51 56 59 64 65 66 68 70 72 75 76 77 79 80 81 83 84 \
 85 87 88 89 91 92 93 95 96 97 99 100 101 103 105 106 107 109 116 121 126 127 \
 130 139 144 152 160 181 186 192 197 202 203 204 205 206 207 208 209 210 214 \
 215 216 221 223 226 227 228 229 230 231 235 237 240 241 242 243 247 248 249 \
 250 254 256 262 263 265 266 271 275 288 291 293 294 295 )
c912 ( 291 0 ) capacitor c=0.00885916f //x=27.935 //y=1.095
c913 ( 288 0 ) capacitor c=0.0692896f //x=91.51 //y=4.885
c914 ( 275 0 ) capacitor c=0.0603371f //x=87.81 //y=2.26
c915 ( 271 0 ) capacitor c=0.0710579f //x=23.06 //y=4.88
c916 ( 266 0 ) capacitor c=0.0278202f //x=23.06 //y=2.095
c917 ( 265 0 ) capacitor c=0.0479397f //x=23.06 //y=2.26
c918 ( 263 0 ) capacitor c=0.0344584f //x=91.845 //y=1.39
c919 ( 262 0 ) capacitor c=0.0186809f //x=91.845 //y=1.045
c920 ( 256 0 ) capacitor c=0.0141797f //x=91.69 //y=1.545
c921 ( 254 0 ) capacitor c=0.0158553f //x=91.69 //y=0.89
c922 ( 250 0 ) capacitor c=0.104052f //x=91.315 //y=2.095
c923 ( 249 0 ) capacitor c=0.0227139f //x=91.315 //y=1.7
c924 ( 248 0 ) capacitor c=0.0234352f //x=91.315 //y=1.39
c925 ( 247 0 ) capacitor c=0.0198759f //x=91.315 //y=1.045
c926 ( 243 0 ) capacitor c=0.0318956f //x=88.515 //y=1.39
c927 ( 242 0 ) capacitor c=0.0186809f //x=88.515 //y=1.045
c928 ( 241 0 ) capacitor c=0.0624333f //x=88.155 //y=4.975
c929 ( 240 0 ) capacitor c=0.0375163f //x=88.445 //y=4.975
c930 ( 237 0 ) capacitor c=0.0157936f //x=88.36 //y=1.545
c931 ( 235 0 ) capacitor c=0.0158553f //x=88.36 //y=0.89
c932 ( 231 0 ) capacitor c=0.0302441f //x=87.985 //y=2.095
c933 ( 230 0 ) capacitor c=0.0238107f //x=87.985 //y=1.7
c934 ( 229 0 ) capacitor c=0.0234359f //x=87.985 //y=1.39
c935 ( 228 0 ) capacitor c=0.0199332f //x=87.985 //y=1.045
c936 ( 227 0 ) capacitor c=0.0443175f //x=23.58 //y=1.44
c937 ( 226 0 ) capacitor c=0.0199703f //x=23.58 //y=1.095
c938 ( 223 0 ) capacitor c=0.0162526f //x=23.425 //y=1.595
c939 ( 221 0 ) capacitor c=0.0157807f //x=23.425 //y=0.94
c940 ( 216 0 ) capacitor c=0.0220935f //x=23.05 //y=1.75
c941 ( 215 0 ) capacitor c=0.0207489f //x=23.05 //y=1.44
c942 ( 214 0 ) capacitor c=0.0194091f //x=23.05 //y=1.095
c943 ( 210 0 ) capacitor c=0.110525f //x=91.84 //y=6.205
c944 ( 209 0 ) capacitor c=0.154978f //x=91.4 //y=6.205
c945 ( 208 0 ) capacitor c=0.110282f //x=88.52 //y=6.205
c946 ( 207 0 ) capacitor c=0.155219f //x=88.08 //y=6.205
c947 ( 206 0 ) capacitor c=0.159671f //x=23.24 //y=6.2
c948 ( 205 0 ) capacitor c=0.110208f //x=22.8 //y=6.2
c949 ( 197 0 ) capacitor c=0.0156727f //x=91.51 //y=4.62
c950 ( 192 0 ) capacitor c=0.00126053f //x=91.51 //y=2.26
c951 ( 186 0 ) capacitor c=0.0130807f //x=87.81 //y=4.62
c952 ( 181 0 ) capacitor c=9.6092e-19 //x=87.81 //y=2.26
c953 ( 160 0 ) capacitor c=0.0293719f //x=27.83 //y=5.56
c954 ( 152 0 ) capacitor c=0.0292879f //x=26.95 //y=5.56
c955 ( 144 0 ) capacitor c=0.0278099f //x=26.07 //y=5.56
c956 ( 139 0 ) capacitor c=7.7417e-19 //x=23.06 //y=4.88
c957 ( 130 0 ) capacitor c=0.00101179f //x=23.06 //y=2.26
c958 ( 127 0 ) capacitor c=0.0683501f //x=91.355 //y=4.64
c959 ( 126 0 ) capacitor c=0.00642399f //x=91.515 //y=4.64
c960 ( 121 0 ) capacitor c=0.0100207f //x=75.6 //y=4.99
c961 ( 116 0 ) capacitor c=0.00873944f //x=28.77 //y=4.995
c962 ( 109 0 ) capacitor c=0.00568391f //x=87.975 //y=4.62
c963 ( 107 0 ) capacitor c=0.00204393f //x=75.685 //y=4.62
c964 ( 106 0 ) capacitor c=0.296022f //x=87.655 //y=4.62
c965 ( 105 0 ) capacitor c=0.00346713f //x=75.6 //y=4.905
c966 ( 103 0 ) capacitor c=0.00344614f //x=75.365 //y=5.215
c967 ( 101 0 ) capacitor c=0.00680441f //x=74.38 //y=5.3
c968 ( 100 0 ) capacitor c=0.0289556f //x=75.28 //y=5.3
c969 ( 99 0 ) capacitor c=0.00373464f //x=74.295 //y=5.215
c970 ( 97 0 ) capacitor c=0.00224705f //x=65.93 //y=4.99
c971 ( 96 0 ) capacitor c=0.185499f //x=74.21 //y=4.99
c972 ( 95 0 ) capacitor c=0.00479753f //x=65.845 //y=5.24
c973 ( 93 0 ) capacitor c=0.00688357f //x=64.665 //y=5.325
c974 ( 92 0 ) capacitor c=0.0250613f //x=65.76 //y=5.325
c975 ( 91 0 ) capacitor c=0.00479513f //x=64.58 //y=5.24
c976 ( 89 0 ) capacitor c=0.00222838f //x=46.685 //y=4.99
c977 ( 88 0 ) capacitor c=0.393149f //x=64.495 //y=4.99
c978 ( 87 0 ) capacitor c=0.00403339f //x=46.6 //y=5.215
c979 ( 85 0 ) capacitor c=0.00663371f //x=45.45 //y=5.3
c980 ( 84 0 ) capacitor c=0.0326814f //x=46.515 //y=5.3
c981 ( 83 0 ) capacitor c=0.00404031f //x=45.365 //y=5.215
c982 ( 81 0 ) capacitor c=0.00169467f //x=36.975 //y=4.99
c983 ( 80 0 ) capacitor c=0.186207f //x=45.28 //y=4.99
c984 ( 79 0 ) capacitor c=0.00342227f //x=36.89 //y=5.215
c985 ( 77 0 ) capacitor c=0.00683963f //x=35.94 //y=5.3
c986 ( 76 0 ) capacitor c=0.0276321f //x=36.805 //y=5.3
c987 ( 75 0 ) capacitor c=0.00375149f //x=35.855 //y=5.215
c988 ( 72 0 ) capacitor c=0.15888f //x=35.77 //y=4.99
c989 ( 70 0 ) capacitor c=0.00585961f //x=28.085 //y=3.5
c990 ( 68 0 ) capacitor c=0.00520791f //x=27.485 //y=3.51
c991 ( 66 0 ) capacitor c=0.00334385f //x=26.975 //y=3.53
c992 ( 65 0 ) capacitor c=5.50259e-19 //x=23.22 //y=3.51
c993 ( 64 0 ) capacitor c=0.0359656f //x=26.375 //y=3.51
c994 ( 59 0 ) capacitor c=0.0127993f //x=91.51 //y=4.62
c995 ( 56 0 ) capacitor c=0.0137635f //x=87.81 //y=4.62
c996 ( 51 0 ) capacitor c=0.0250678f //x=28.61 //y=4.995
c997 ( 49 0 ) capacitor c=0.0140668f //x=28.61 //y=4.99
c998 ( 45 0 ) capacitor c=0.0155922f //x=28.61 //y=3.51
c999 ( 39 0 ) capacitor c=8.84507e-19 //x=27.83 //y=5.335
c1000 ( 36 0 ) capacitor c=0.00768617f //x=26.95 //y=5.335
c1001 ( 33 0 ) capacitor c=0.0111234f //x=26.072 //y=5.335
c1002 ( 32 0 ) capacitor c=0.0166445f //x=23.06 //y=3.51
c1003 ( 24 0 ) capacitor c=0.0838237f //x=91.51 //y=4.475
c1004 ( 23 0 ) capacitor c=0.00607262f //x=91.51 //y=2.385
c1005 ( 22 0 ) capacitor c=0.0636214f //x=87.81 //y=4.46
c1006 ( 21 0 ) capacitor c=0.00385206f //x=87.81 //y=2.375
c1007 ( 20 0 ) capacitor c=0.0285037f //x=28.61 //y=4.835
c1008 ( 19 0 ) capacitor c=0.0135052f //x=28.61 //y=3.685
c1009 ( 18 0 ) capacitor c=0.0389407f //x=28.61 //y=3.365
c1010 ( 16 0 ) capacitor c=0.00493487f //x=28.21 //y=1.845
c1011 ( 15 0 ) capacitor c=0.0132914f //x=28.525 //y=1.845
c1012 ( 14 0 ) capacitor c=0.0167992f //x=28.125 //y=1.76
c1013 ( 13 0 ) capacitor c=0.0112869f //x=28.125 //y=1.305
c1014 ( 11 0 ) capacitor c=0.0141636f //x=28.45 //y=5.335
c1015 ( 10 0 ) capacitor c=0.00933983f //x=27.83 //y=5.56
c1016 ( 7 0 ) capacitor c=0.0180822f //x=27.715 //y=5.335
c1017 ( 5 0 ) capacitor c=0.0146396f //x=26.83 //y=5.335
c1018 ( 4 0 ) capacitor c=0.0307975f //x=23.06 //y=4.75
c1019 ( 3 0 ) capacitor c=0.0121604f //x=23.06 //y=3.655
c1020 ( 2 0 ) capacitor c=0.0220998f //x=23.06 //y=3.365
c1021 ( 1 0 ) capacitor c=0.00554887f //x=23.06 //y=2.375
r1022 (  286 288 ) resistor r=22.7554 //w=0.233 //l=0.11 //layer=ply \
 //thickness=0.18 //x=91.4 //y=4.885 //x2=91.51 //y2=4.885
r1023 (  265 266 ) resistor r=52.7279 //w=0.214 //l=0.165 //layer=ply \
 //thickness=0.18 //x=23.06 //y=2.26 //x2=23.06 //y2=2.095
r1024 (  263 290 ) resistor r=45.1352 //w=0.168 //l=0.173853 //layer=ply \
 //thickness=0.18 //x=91.845 //y=1.39 //x2=91.805 //y2=1.545
r1025 (  262 289 ) resistor r=45.1352 //w=0.168 //l=0.173853 //layer=ply \
 //thickness=0.18 //x=91.845 //y=1.045 //x2=91.805 //y2=0.89
r1026 (  262 263 ) resistor r=176.904 //w=0.094 //l=0.345 //layer=ply \
 //thickness=0.18 //x=91.845 //y=1.045 //x2=91.845 //y2=1.39
r1027 (  259 288 ) resistor r=68.2661 //w=0.233 //l=0.404166 //layer=ply \
 //thickness=0.18 //x=91.84 //y=5.05 //x2=91.51 //y2=4.885
r1028 (  257 285 ) resistor r=10.701 //w=0.21 //l=0.115 //layer=ply \
 //thickness=0.18 //x=91.47 //y=1.545 //x2=91.355 //y2=1.545
r1029 (  256 290 ) resistor r=5.52526 //w=0.168 //l=0.115 //layer=ply \
 //thickness=0.18 //x=91.69 //y=1.545 //x2=91.805 //y2=1.545
r1030 (  255 284 ) resistor r=5.52526 //w=0.168 //l=0.115 //layer=ply \
 //thickness=0.18 //x=91.47 //y=0.89 //x2=91.355 //y2=0.89
r1031 (  254 289 ) resistor r=5.52526 //w=0.168 //l=0.115 //layer=ply \
 //thickness=0.18 //x=91.69 //y=0.89 //x2=91.805 //y2=0.89
r1032 (  254 255 ) resistor r=112.809 //w=0.094 //l=0.22 //layer=ply \
 //thickness=0.18 //x=91.69 //y=0.89 //x2=91.47 //y2=0.89
r1033 (  251 286 ) resistor r=13.0941 //w=0.233 //l=0.165 //layer=ply \
 //thickness=0.18 //x=91.4 //y=5.05 //x2=91.4 //y2=4.885
r1034 (  250 283 ) resistor r=34.8111 //w=0.27 //l=0.264953 //layer=ply \
 //thickness=0.18 //x=91.315 //y=2.095 //x2=91.51 //y2=2.26
r1035 (  249 285 ) resistor r=39.5823 //w=0.21 //l=0.173853 //layer=ply \
 //thickness=0.18 //x=91.315 //y=1.7 //x2=91.355 //y2=1.545
r1036 (  249 250 ) resistor r=202.543 //w=0.094 //l=0.395 //layer=ply \
 //thickness=0.18 //x=91.315 //y=1.7 //x2=91.315 //y2=2.095
r1037 (  248 285 ) resistor r=39.5823 //w=0.21 //l=0.173853 //layer=ply \
 //thickness=0.18 //x=91.315 //y=1.39 //x2=91.355 //y2=1.545
r1038 (  247 284 ) resistor r=45.1352 //w=0.168 //l=0.173853 //layer=ply \
 //thickness=0.18 //x=91.315 //y=1.045 //x2=91.355 //y2=0.89
r1039 (  247 248 ) resistor r=176.904 //w=0.094 //l=0.345 //layer=ply \
 //thickness=0.18 //x=91.315 //y=1.045 //x2=91.315 //y2=1.39
r1040 (  243 281 ) resistor r=45.1352 //w=0.168 //l=0.173853 //layer=ply \
 //thickness=0.18 //x=88.515 //y=1.39 //x2=88.475 //y2=1.545
r1041 (  242 280 ) resistor r=45.1352 //w=0.168 //l=0.173853 //layer=ply \
 //thickness=0.18 //x=88.515 //y=1.045 //x2=88.475 //y2=0.89
r1042 (  242 243 ) resistor r=176.904 //w=0.094 //l=0.345 //layer=ply \
 //thickness=0.18 //x=88.515 //y=1.045 //x2=88.515 //y2=1.39
r1043 (  240 244 ) resistor r=26.9307 //w=0.15 //l=0.106066 //layer=ply \
 //thickness=0.18 //x=88.445 //y=4.975 //x2=88.52 //y2=5.05
r1044 (  240 241 ) resistor r=148.702 //w=0.094 //l=0.29 //layer=ply \
 //thickness=0.18 //x=88.445 //y=4.975 //x2=88.155 //y2=4.975
r1045 (  238 279 ) resistor r=10.701 //w=0.21 //l=0.115 //layer=ply \
 //thickness=0.18 //x=88.14 //y=1.545 //x2=88.025 //y2=1.545
r1046 (  237 281 ) resistor r=5.52526 //w=0.168 //l=0.115 //layer=ply \
 //thickness=0.18 //x=88.36 //y=1.545 //x2=88.475 //y2=1.545
r1047 (  236 278 ) resistor r=5.52526 //w=0.168 //l=0.115 //layer=ply \
 //thickness=0.18 //x=88.14 //y=0.89 //x2=88.025 //y2=0.89
r1048 (  235 280 ) resistor r=5.52526 //w=0.168 //l=0.115 //layer=ply \
 //thickness=0.18 //x=88.36 //y=0.89 //x2=88.475 //y2=0.89
r1049 (  235 236 ) resistor r=112.809 //w=0.094 //l=0.22 //layer=ply \
 //thickness=0.18 //x=88.36 //y=0.89 //x2=88.14 //y2=0.89
r1050 (  232 241 ) resistor r=22.1787 //w=0.252 //l=0.106066 //layer=ply \
 //thickness=0.18 //x=88.08 //y=5.05 //x2=88.155 //y2=4.975
r1051 (  232 277 ) resistor r=51.6429 //w=0.252 //l=0.34271 //layer=ply \
 //thickness=0.18 //x=88.08 //y=5.05 //x2=87.81 //y2=4.885
r1052 (  231 275 ) resistor r=30.4513 //w=0.277 //l=0.243926 //layer=ply \
 //thickness=0.18 //x=87.985 //y=2.095 //x2=87.81 //y2=2.26
r1053 (  230 279 ) resistor r=39.5823 //w=0.21 //l=0.173853 //layer=ply \
 //thickness=0.18 //x=87.985 //y=1.7 //x2=88.025 //y2=1.545
r1054 (  230 231 ) resistor r=202.543 //w=0.094 //l=0.395 //layer=ply \
 //thickness=0.18 //x=87.985 //y=1.7 //x2=87.985 //y2=2.095
r1055 (  229 279 ) resistor r=39.5823 //w=0.21 //l=0.173853 //layer=ply \
 //thickness=0.18 //x=87.985 //y=1.39 //x2=88.025 //y2=1.545
r1056 (  228 278 ) resistor r=45.1352 //w=0.168 //l=0.173853 //layer=ply \
 //thickness=0.18 //x=87.985 //y=1.045 //x2=88.025 //y2=0.89
r1057 (  228 229 ) resistor r=176.904 //w=0.094 //l=0.345 //layer=ply \
 //thickness=0.18 //x=87.985 //y=1.045 //x2=87.985 //y2=1.39
r1058 (  227 273 ) resistor r=45.1352 //w=0.168 //l=0.173853 //layer=ply \
 //thickness=0.18 //x=23.58 //y=1.44 //x2=23.54 //y2=1.595
r1059 (  226 272 ) resistor r=45.1352 //w=0.168 //l=0.173853 //layer=ply \
 //thickness=0.18 //x=23.58 //y=1.095 //x2=23.54 //y2=0.94
r1060 (  226 227 ) resistor r=176.904 //w=0.094 //l=0.345 //layer=ply \
 //thickness=0.18 //x=23.58 //y=1.095 //x2=23.58 //y2=1.44
r1061 (  224 269 ) resistor r=10.701 //w=0.21 //l=0.115 //layer=ply \
 //thickness=0.18 //x=23.205 //y=1.595 //x2=23.09 //y2=1.595
r1062 (  223 273 ) resistor r=5.52526 //w=0.168 //l=0.115 //layer=ply \
 //thickness=0.18 //x=23.425 //y=1.595 //x2=23.54 //y2=1.595
r1063 (  222 268 ) resistor r=5.52526 //w=0.168 //l=0.115 //layer=ply \
 //thickness=0.18 //x=23.205 //y=0.94 //x2=23.09 //y2=0.94
r1064 (  221 272 ) resistor r=5.52526 //w=0.168 //l=0.115 //layer=ply \
 //thickness=0.18 //x=23.425 //y=0.94 //x2=23.54 //y2=0.94
r1065 (  221 222 ) resistor r=112.809 //w=0.094 //l=0.22 //layer=ply \
 //thickness=0.18 //x=23.425 //y=0.94 //x2=23.205 //y2=0.94
r1066 (  218 271 ) resistor r=37.236 //w=0.233 //l=0.249199 //layer=ply \
 //thickness=0.18 //x=23.24 //y=5.045 //x2=23.06 //y2=4.88
r1067 (  216 269 ) resistor r=39.5823 //w=0.21 //l=0.173853 //layer=ply \
 //thickness=0.18 //x=23.05 //y=1.75 //x2=23.09 //y2=1.595
r1068 (  216 266 ) resistor r=176.904 //w=0.094 //l=0.345 //layer=ply \
 //thickness=0.18 //x=23.05 //y=1.75 //x2=23.05 //y2=2.095
r1069 (  215 269 ) resistor r=39.5823 //w=0.21 //l=0.173853 //layer=ply \
 //thickness=0.18 //x=23.05 //y=1.44 //x2=23.09 //y2=1.595
r1070 (  214 268 ) resistor r=45.1352 //w=0.168 //l=0.173853 //layer=ply \
 //thickness=0.18 //x=23.05 //y=1.095 //x2=23.09 //y2=0.94
r1071 (  214 215 ) resistor r=176.904 //w=0.094 //l=0.345 //layer=ply \
 //thickness=0.18 //x=23.05 //y=1.095 //x2=23.05 //y2=1.44
r1072 (  211 271 ) resistor r=53.7854 //w=0.233 //l=0.332415 //layer=ply \
 //thickness=0.18 //x=22.8 //y=5.045 //x2=23.06 //y2=4.88
r1073 (  210 259 ) resistor r=592.245 //w=0.094 //l=1.155 //layer=ply \
 //thickness=0.18 //x=91.84 //y=6.205 //x2=91.84 //y2=5.05
r1074 (  209 251 ) resistor r=592.245 //w=0.094 //l=1.155 //layer=ply \
 //thickness=0.18 //x=91.4 //y=6.205 //x2=91.4 //y2=5.05
r1075 (  208 244 ) resistor r=592.245 //w=0.094 //l=1.155 //layer=ply \
 //thickness=0.18 //x=88.52 //y=6.205 //x2=88.52 //y2=5.05
r1076 (  207 232 ) resistor r=592.245 //w=0.094 //l=1.155 //layer=ply \
 //thickness=0.18 //x=88.08 //y=6.205 //x2=88.08 //y2=5.05
r1077 (  206 218 ) resistor r=592.245 //w=0.094 //l=1.155 //layer=ply \
 //thickness=0.18 //x=23.24 //y=6.2 //x2=23.24 //y2=5.045
r1078 (  205 211 ) resistor r=592.245 //w=0.094 //l=1.155 //layer=ply \
 //thickness=0.18 //x=22.8 //y=6.2 //x2=22.8 //y2=5.045
r1079 (  204 256 ) resistor r=56.4043 //w=0.094 //l=0.11 //layer=ply \
 //thickness=0.18 //x=91.58 //y=1.545 //x2=91.69 //y2=1.545
r1080 (  204 257 ) resistor r=56.4043 //w=0.094 //l=0.11 //layer=ply \
 //thickness=0.18 //x=91.58 //y=1.545 //x2=91.47 //y2=1.545
r1081 (  203 237 ) resistor r=56.4043 //w=0.094 //l=0.11 //layer=ply \
 //thickness=0.18 //x=88.25 //y=1.545 //x2=88.36 //y2=1.545
r1082 (  203 238 ) resistor r=56.4043 //w=0.094 //l=0.11 //layer=ply \
 //thickness=0.18 //x=88.25 //y=1.545 //x2=88.14 //y2=1.545
r1083 (  202 223 ) resistor r=56.4043 //w=0.094 //l=0.11 //layer=ply \
 //thickness=0.18 //x=23.315 //y=1.595 //x2=23.425 //y2=1.595
r1084 (  202 224 ) resistor r=56.4043 //w=0.094 //l=0.11 //layer=ply \
 //thickness=0.18 //x=23.315 //y=1.595 //x2=23.205 //y2=1.595
r1085 (  200 288 ) resistor r=152 //w=0.17 //l=0.17 //layer=licon //count=1 \
 //x=91.51 //y=4.885 //x2=91.51 //y2=4.885
r1086 (  197 200 ) resistor r=18.139 //w=0.187 //l=0.265 //layer=li \
 //thickness=0.1 //x=91.51 //y=4.62 //x2=91.51 //y2=4.885
r1087 (  192 283 ) resistor r=152 //w=0.17 //l=0.17 //layer=licon //count=1 \
 //x=91.51 //y=2.26 //x2=91.51 //y2=2.26
r1088 (  189 277 ) resistor r=152 //w=0.17 //l=0.17 //layer=licon //count=1 \
 //x=87.81 //y=4.885 //x2=87.81 //y2=4.885
r1089 (  186 189 ) resistor r=18.139 //w=0.187 //l=0.265 //layer=li \
 //thickness=0.1 //x=87.81 //y=4.62 //x2=87.81 //y2=4.885
r1090 (  181 275 ) resistor r=152 //w=0.17 //l=0.17 //layer=licon //count=1 \
 //x=87.81 //y=2.26 //x2=87.81 //y2=2.26
r1091 (  160 295 ) resistor r=23.615 //w=0.187 //l=0.345 //layer=li \
 //thickness=0.1 //x=27.83 //y=5.56 //x2=27.83 //y2=5.905
r1092 (  152 294 ) resistor r=23.615 //w=0.187 //l=0.345 //layer=li \
 //thickness=0.1 //x=26.95 //y=5.56 //x2=26.95 //y2=5.905
r1093 (  144 293 ) resistor r=23.615 //w=0.187 //l=0.345 //layer=li \
 //thickness=0.1 //x=26.07 //y=5.56 //x2=26.07 //y2=5.905
r1094 (  139 271 ) resistor r=152 //w=0.17 //l=0.17 //layer=licon //count=1 \
 //x=23.06 //y=4.88 //x2=23.06 //y2=4.88
r1095 (  130 265 ) resistor r=152 //w=0.17 //l=0.17 //layer=licon //count=1 \
 //x=23.06 //y=2.26 //x2=23.06 //y2=2.26
r1096 (  126 127 ) resistor r=0.10734 //w=0.281 //l=0.16 //layer=m2 \
 //thickness=0.36 //x=91.515 //y=4.64 //x2=91.355 //y2=4.64
r1097 (  119 121 ) resistor r=0.224237 //w=0.131 //l=0.235 //layer=m2 \
 //thickness=0.36 //x=75.365 //y=4.99 //x2=75.6 //y2=4.99
r1098 (  114 116 ) resistor r=0.10734 //w=0.281 //l=0.16 //layer=m2 \
 //thickness=0.36 //x=28.61 //y=4.995 //x2=28.77 //y2=4.995
r1099 (  109 124 ) resistor r=0.10734 //w=0.281 //l=0.16 //layer=m2 \
 //thickness=0.36 //x=87.975 //y=4.62 //x2=87.815 //y2=4.62
r1100 (  109 127 ) resistor r=3.22519 //w=0.131 //l=3.38 //layer=m2 \
 //thickness=0.36 //x=87.975 //y=4.62 //x2=91.355 //y2=4.62
r1101 (  106 124 ) resistor r=0.10734 //w=0.281 //l=0.16 //layer=m2 \
 //thickness=0.36 //x=87.655 //y=4.62 //x2=87.815 //y2=4.62
r1102 (  106 107 ) resistor r=11.4218 //w=0.131 //l=11.97 //layer=m2 \
 //thickness=0.36 //x=87.655 //y=4.62 //x2=75.685 //y2=4.62
r1103 (  105 121 ) resistor r=0.0073411 //w=0.17 //l=0.085 //layer=m2 \
 //thickness=0.36 //x=75.6 //y=4.905 //x2=75.6 //y2=4.99
r1104 (  104 107 ) resistor r=0.0718295 //w=0.17 //l=0.120208 //layer=m2 \
 //thickness=0.36 //x=75.6 //y=4.705 //x2=75.685 //y2=4.62
r1105 (  104 105 ) resistor r=0.19084 //w=0.131 //l=0.2 //layer=m2 \
 //thickness=0.36 //x=75.6 //y=4.705 //x2=75.6 //y2=4.905
r1106 (  102 119 ) resistor r=0.0073411 //w=0.17 //l=0.085 //layer=m2 \
 //thickness=0.36 //x=75.365 //y=5.075 //x2=75.365 //y2=4.99
r1107 (  102 103 ) resistor r=0.133588 //w=0.131 //l=0.14 //layer=m2 \
 //thickness=0.36 //x=75.365 //y=5.075 //x2=75.365 //y2=5.215
r1108 (  100 103 ) resistor r=0.0698411 //w=0.17 //l=0.120208 //layer=m2 \
 //thickness=0.36 //x=75.28 //y=5.3 //x2=75.365 //y2=5.215
r1109 (  100 101 ) resistor r=0.858779 //w=0.131 //l=0.9 //layer=m2 \
 //thickness=0.36 //x=75.28 //y=5.3 //x2=74.38 //y2=5.3
r1110 (  99 101 ) resistor r=0.0698411 //w=0.17 //l=0.120208 //layer=m2 \
 //thickness=0.36 //x=74.295 //y=5.215 //x2=74.38 //y2=5.3
r1111 (  98 99 ) resistor r=0.133588 //w=0.131 //l=0.14 //layer=m2 \
 //thickness=0.36 //x=74.295 //y=5.075 //x2=74.295 //y2=5.215
r1112 (  96 98 ) resistor r=0.0698411 //w=0.17 //l=0.120208 //layer=m2 \
 //thickness=0.36 //x=74.21 //y=4.99 //x2=74.295 //y2=5.075
r1113 (  96 97 ) resistor r=7.90076 //w=0.131 //l=8.28 //layer=m2 \
 //thickness=0.36 //x=74.21 //y=4.99 //x2=65.93 //y2=4.99
r1114 (  94 97 ) resistor r=0.0698411 //w=0.17 //l=0.120208 //layer=m2 \
 //thickness=0.36 //x=65.845 //y=5.075 //x2=65.93 //y2=4.99
r1115 (  94 95 ) resistor r=0.157443 //w=0.131 //l=0.165 //layer=m2 \
 //thickness=0.36 //x=65.845 //y=5.075 //x2=65.845 //y2=5.24
r1116 (  92 95 ) resistor r=0.0698411 //w=0.17 //l=0.120208 //layer=m2 \
 //thickness=0.36 //x=65.76 //y=5.325 //x2=65.845 //y2=5.24
r1117 (  92 93 ) resistor r=1.04485 //w=0.131 //l=1.095 //layer=m2 \
 //thickness=0.36 //x=65.76 //y=5.325 //x2=64.665 //y2=5.325
r1118 (  91 93 ) resistor r=0.0698411 //w=0.17 //l=0.120208 //layer=m2 \
 //thickness=0.36 //x=64.58 //y=5.24 //x2=64.665 //y2=5.325
r1119 (  90 91 ) resistor r=0.157443 //w=0.131 //l=0.165 //layer=m2 \
 //thickness=0.36 //x=64.58 //y=5.075 //x2=64.58 //y2=5.24
r1120 (  88 90 ) resistor r=0.0698411 //w=0.17 //l=0.120208 //layer=m2 \
 //thickness=0.36 //x=64.495 //y=4.99 //x2=64.58 //y2=5.075
r1121 (  88 89 ) resistor r=16.9943 //w=0.131 //l=17.81 //layer=m2 \
 //thickness=0.36 //x=64.495 //y=4.99 //x2=46.685 //y2=4.99
r1122 (  86 89 ) resistor r=0.0698411 //w=0.17 //l=0.120208 //layer=m2 \
 //thickness=0.36 //x=46.6 //y=5.075 //x2=46.685 //y2=4.99
r1123 (  86 87 ) resistor r=0.133588 //w=0.131 //l=0.14 //layer=m2 \
 //thickness=0.36 //x=46.6 //y=5.075 //x2=46.6 //y2=5.215
r1124 (  84 87 ) resistor r=0.0698411 //w=0.17 //l=0.120208 //layer=m2 \
 //thickness=0.36 //x=46.515 //y=5.3 //x2=46.6 //y2=5.215
r1125 (  84 85 ) resistor r=1.01622 //w=0.131 //l=1.065 //layer=m2 \
 //thickness=0.36 //x=46.515 //y=5.3 //x2=45.45 //y2=5.3
r1126 (  83 85 ) resistor r=0.0698411 //w=0.17 //l=0.120208 //layer=m2 \
 //thickness=0.36 //x=45.365 //y=5.215 //x2=45.45 //y2=5.3
r1127 (  82 83 ) resistor r=0.133588 //w=0.131 //l=0.14 //layer=m2 \
 //thickness=0.36 //x=45.365 //y=5.075 //x2=45.365 //y2=5.215
r1128 (  80 82 ) resistor r=0.0698411 //w=0.17 //l=0.120208 //layer=m2 \
 //thickness=0.36 //x=45.28 //y=4.99 //x2=45.365 //y2=5.075
r1129 (  80 81 ) resistor r=7.92462 //w=0.131 //l=8.305 //layer=m2 \
 //thickness=0.36 //x=45.28 //y=4.99 //x2=36.975 //y2=4.99
r1130 (  78 81 ) resistor r=0.0698411 //w=0.17 //l=0.120208 //layer=m2 \
 //thickness=0.36 //x=36.89 //y=5.075 //x2=36.975 //y2=4.99
r1131 (  78 79 ) resistor r=0.133588 //w=0.131 //l=0.14 //layer=m2 \
 //thickness=0.36 //x=36.89 //y=5.075 //x2=36.89 //y2=5.215
r1132 (  76 79 ) resistor r=0.0698411 //w=0.17 //l=0.120208 //layer=m2 \
 //thickness=0.36 //x=36.805 //y=5.3 //x2=36.89 //y2=5.215
r1133 (  76 77 ) resistor r=0.825382 //w=0.131 //l=0.865 //layer=m2 \
 //thickness=0.36 //x=36.805 //y=5.3 //x2=35.94 //y2=5.3
r1134 (  75 77 ) resistor r=0.0698411 //w=0.17 //l=0.120208 //layer=m2 \
 //thickness=0.36 //x=35.855 //y=5.215 //x2=35.94 //y2=5.3
r1135 (  74 75 ) resistor r=0.133588 //w=0.131 //l=0.14 //layer=m2 \
 //thickness=0.36 //x=35.855 //y=5.075 //x2=35.855 //y2=5.215
r1136 (  72 74 ) resistor r=0.0698411 //w=0.17 //l=0.120208 //layer=m2 \
 //thickness=0.36 //x=35.77 //y=4.99 //x2=35.855 //y2=5.075
r1137 (  72 116 ) resistor r=6.67939 //w=0.131 //l=7 //layer=m2 \
 //thickness=0.36 //x=35.77 //y=4.99 //x2=28.77 //y2=4.99
r1138 (  70 118 ) resistor r=0.293022 //w=0.239 //l=0.552359 //layer=m2 \
 //thickness=0.36 //x=28.085 //y=3.5 //x2=28.625 //y2=3.525
r1139 (  70 71 ) resistor r=0.410305 //w=0.131 //l=0.43 //layer=m2 \
 //thickness=0.36 //x=28.085 //y=3.5 //x2=27.655 //y2=3.5
r1140 (  68 71 ) resistor r=0.125 //w=0.17 //l=0.174929 //layer=m2 \
 //thickness=0.36 //x=27.485 //y=3.51 //x2=27.655 //y2=3.5
r1141 (  68 69 ) resistor r=0.324427 //w=0.131 //l=0.34 //layer=m2 \
 //thickness=0.36 //x=27.485 //y=3.51 //x2=27.145 //y2=3.51
r1142 (  66 69 ) resistor r=0.125 //w=0.17 //l=0.179722 //layer=m2 \
 //thickness=0.36 //x=26.975 //y=3.53 //x2=27.145 //y2=3.51
r1143 (  66 67 ) resistor r=0.329198 //w=0.131 //l=0.345 //layer=m2 \
 //thickness=0.36 //x=26.975 //y=3.53 //x2=26.63 //y2=3.53
r1144 (  65 111 ) resistor r=0.108362 //w=0.251 //l=0.16 //layer=m2 \
 //thickness=0.36 //x=23.22 //y=3.51 //x2=23.06 //y2=3.51
r1145 (  64 67 ) resistor r=0.1875 //w=0.17 //l=0.264811 //layer=m2 \
 //thickness=0.36 //x=26.375 //y=3.51 //x2=26.63 //y2=3.53
r1146 (  64 65 ) resistor r=3.0105 //w=0.131 //l=3.155 //layer=m2 \
 //thickness=0.36 //x=26.375 //y=3.51 //x2=23.22 //y2=3.51
r1147 (  63 192 ) resistor r=9.3 //w=0.17 //l=0.17 //layer=mcon //count=1 \
 //x=91.51 //y=2.26 //x2=91.51 //y2=2.26
r1148 (  61 126 ) resistor r=4.5 //w=0.15 //l=0.15 //layer=via1 //count=1 \
 //x=91.515 //y=4.64 //x2=91.515 //y2=4.64
r1149 (  59 197 ) resistor r=9.3 //w=0.17 //l=0.17 //layer=mcon //count=1 \
 //x=91.51 //y=4.62 //x2=91.51 //y2=4.62
r1150 (  59 61 ) resistor r=0.00659631 //w=0.379 //l=0.02 //layer=m1 \
 //thickness=0.36 //x=91.46 //y=4.62 //x2=91.46 //y2=4.64
r1151 (  56 186 ) resistor r=9.3 //w=0.17 //l=0.17 //layer=mcon //count=1 \
 //x=87.81 //y=4.62 //x2=87.81 //y2=4.62
r1152 (  56 124 ) resistor r=4.5 //w=0.15 //l=0.15 //layer=via1 //count=1 \
 //x=87.815 //y=4.62 //x2=87.815 //y2=4.62
r1153 (  54 181 ) resistor r=9.3 //w=0.17 //l=0.17 //layer=mcon //count=1 \
 //x=87.81 //y=2.26 //x2=87.81 //y2=2.26
r1154 (  51 114 ) resistor r=4.5 //w=0.15 //l=0.15 //layer=via1 //count=1 \
 //x=28.61 //y=4.995 //x2=28.61 //y2=4.995
r1155 (  51 52 ) resistor r=0.134069 //w=0.317 //l=0.34 //layer=m1 \
 //thickness=0.36 //x=28.662 //y=4.995 //x2=28.662 //y2=5.335
r1156 (  49 51 ) resistor r=0.00197161 //w=0.317 //l=0.005 //layer=m1 \
 //thickness=0.36 //x=28.662 //y=4.99 //x2=28.662 //y2=4.995
r1157 (  47 118 ) resistor r=4.5 //w=0.15 //l=0.15 //layer=via1 //count=1 \
 //x=28.625 //y=3.525 //x2=28.625 //y2=3.525
r1158 (  45 47 ) resistor r=0.00488281 //w=0.384 //l=0.015 //layer=m1 \
 //thickness=0.36 //x=28.565 //y=3.51 //x2=28.565 //y2=3.525
r1159 (  43 291 ) resistor r=9.3 //w=0.17 //l=0.17 //layer=mcon //count=1 \
 //x=28.125 //y=1.19 //x2=28.125 //y2=1.19
r1160 (  41 160 ) resistor r=9.3 //w=0.17 //l=0.17 //layer=mcon //count=1 \
 //x=27.83 //y=5.56 //x2=27.83 //y2=5.56
r1161 (  38 152 ) resistor r=9.3 //w=0.17 //l=0.17 //layer=mcon //count=1 \
 //x=26.95 //y=5.56 //x2=26.95 //y2=5.56
r1162 (  36 38 ) resistor r=0.121228 //w=0.232 //l=0.225 //layer=m1 \
 //thickness=0.36 //x=26.95 //y=5.335 //x2=26.95 //y2=5.56
r1163 (  35 144 ) resistor r=9.3 //w=0.17 //l=0.17 //layer=mcon //count=1 \
 //x=26.07 //y=5.56 //x2=26.07 //y2=5.56
r1164 (  33 35 ) resistor r=0.129608 //w=0.217 //l=0.225 //layer=m1 \
 //thickness=0.36 //x=26.072 //y=5.335 //x2=26.072 //y2=5.56
r1165 (  30 111 ) resistor r=4.5 //w=0.15 //l=0.15 //layer=via1 //count=1 \
 //x=23.06 //y=3.495 //x2=23.06 //y2=3.495
r1166 (  30 32 ) resistor r=0.00490838 //w=0.382 //l=0.015 //layer=m1 \
 //thickness=0.36 //x=23.112 //y=3.495 //x2=23.112 //y2=3.51
r1167 (  28 139 ) resistor r=9.3 //w=0.17 //l=0.17 //layer=mcon //count=1 \
 //x=23.06 //y=4.88 //x2=23.06 //y2=4.88
r1168 (  26 130 ) resistor r=9.3 //w=0.17 //l=0.17 //layer=mcon //count=1 \
 //x=23.06 //y=2.26 //x2=23.06 //y2=2.26
r1169 (  24 59 ) resistor r=0.0863342 //w=0.379 //l=0.168152 //layer=m1 \
 //thickness=0.36 //x=91.51 //y=4.475 //x2=91.46 //y2=4.62
r1170 (  23 63 ) resistor r=0.0761125 //w=0.237 //l=0.126491 //layer=m1 \
 //thickness=0.36 //x=91.51 //y=2.385 //x2=91.507 //y2=2.26
r1171 (  23 24 ) resistor r=1.99427 //w=0.131 //l=2.09 //layer=m1 \
 //thickness=0.36 //x=91.51 //y=2.385 //x2=91.51 //y2=4.475
r1172 (  22 56 ) resistor r=0.0898201 //w=0.322 //l=0.185472 //layer=m1 \
 //thickness=0.36 //x=87.81 //y=4.46 //x2=87.865 //y2=4.62
r1173 (  21 54 ) resistor r=0.0717383 //w=0.224 //l=0.115 //layer=m1 \
 //thickness=0.36 //x=87.81 //y=2.375 //x2=87.81 //y2=2.26
r1174 (  21 22 ) resistor r=1.9895 //w=0.131 //l=2.085 //layer=m1 \
 //thickness=0.36 //x=87.81 //y=2.375 //x2=87.81 //y2=4.46
r1175 (  20 49 ) resistor r=0.0878332 //w=0.317 //l=0.179123 //layer=m1 \
 //thickness=0.36 //x=28.61 //y=4.835 //x2=28.662 //y2=4.99
r1176 (  19 47 ) resistor r=0.0914932 //w=0.384 //l=0.181108 //layer=m1 \
 //thickness=0.36 //x=28.61 //y=3.685 //x2=28.565 //y2=3.525
r1177 (  19 20 ) resistor r=1.09733 //w=0.131 //l=1.15 //layer=m1 \
 //thickness=0.36 //x=28.61 //y=3.685 //x2=28.61 //y2=4.835
r1178 (  18 45 ) resistor r=0.0866104 //w=0.384 //l=0.165982 //layer=m1 \
 //thickness=0.36 //x=28.61 //y=3.365 //x2=28.565 //y2=3.51
r1179 (  17 18 ) resistor r=1.36927 //w=0.131 //l=1.435 //layer=m1 \
 //thickness=0.36 //x=28.61 //y=1.93 //x2=28.61 //y2=3.365
r1180 (  15 17 ) resistor r=0.0698411 //w=0.17 //l=0.120208 //layer=m1 \
 //thickness=0.36 //x=28.525 //y=1.845 //x2=28.61 //y2=1.93
r1181 (  15 16 ) resistor r=0.300573 //w=0.131 //l=0.315 //layer=m1 \
 //thickness=0.36 //x=28.525 //y=1.845 //x2=28.21 //y2=1.845
r1182 (  14 16 ) resistor r=0.0698411 //w=0.17 //l=0.120208 //layer=m1 \
 //thickness=0.36 //x=28.125 //y=1.76 //x2=28.21 //y2=1.845
r1183 (  13 43 ) resistor r=0.0717383 //w=0.224 //l=0.115 //layer=m1 \
 //thickness=0.36 //x=28.125 //y=1.305 //x2=28.125 //y2=1.19
r1184 (  13 14 ) resistor r=0.43416 //w=0.131 //l=0.455 //layer=m1 \
 //thickness=0.36 //x=28.125 //y=1.305 //x2=28.125 //y2=1.76
r1185 (  12 39 ) resistor r=0.0675342 //w=0.23 //l=0.115 //layer=m1 \
 //thickness=0.36 //x=27.945 //y=5.335 //x2=27.83 //y2=5.335
r1186 (  11 52 ) resistor r=0.0449366 //w=0.317 //l=0.212 //layer=m1 \
 //thickness=0.36 //x=28.45 //y=5.335 //x2=28.662 //y2=5.335
r1187 (  11 12 ) resistor r=0.48187 //w=0.131 //l=0.505 //layer=m1 \
 //thickness=0.36 //x=28.45 //y=5.335 //x2=27.945 //y2=5.335
r1188 (  10 41 ) resistor r=0.00118313 //w=0.23 //layer=m1 //thickness=0.36 \
 //x=27.83 //y=5.56 //x2=27.83 //y2=5.56
r1189 (  9 39 ) resistor r=0.002872 //w=0.34 //l=0.085 //layer=m1 \
 //thickness=0.36 //x=27.83 //y=5.42 //x2=27.83 //y2=5.335
r1190 (  9 10 ) resistor r=0.091623 //w=0.191 //l=0.14 //layer=m1 \
 //thickness=0.36 //x=27.83 //y=5.42 //x2=27.83 //y2=5.56
r1191 (  8 36 ) resistor r=0.0262263 //w=0.232 //l=0.12 //layer=m1 \
 //thickness=0.36 //x=27.07 //y=5.335 //x2=26.95 //y2=5.335
r1192 (  7 39 ) resistor r=0.0675342 //w=0.23 //l=0.115 //layer=m1 \
 //thickness=0.36 //x=27.715 //y=5.335 //x2=27.83 //y2=5.335
r1193 (  7 8 ) resistor r=0.615458 //w=0.131 //l=0.645 //layer=m1 \
 //thickness=0.36 //x=27.715 //y=5.335 //x2=27.07 //y2=5.335
r1194 (  6 33 ) resistor r=0.0222262 //w=0.217 //l=0.118 //layer=m1 \
 //thickness=0.36 //x=26.19 //y=5.335 //x2=26.072 //y2=5.335
r1195 (  5 36 ) resistor r=0.0262263 //w=0.232 //l=0.12 //layer=m1 \
 //thickness=0.36 //x=26.83 //y=5.335 //x2=26.95 //y2=5.335
r1196 (  5 6 ) resistor r=0.610687 //w=0.131 //l=0.64 //layer=m1 \
 //thickness=0.36 //x=26.83 //y=5.335 //x2=26.19 //y2=5.335
r1197 (  4 28 ) resistor r=0.0801089 //w=0.224 //l=0.13 //layer=m1 \
 //thickness=0.36 //x=23.06 //y=4.75 //x2=23.06 //y2=4.88
r1198 (  3 32 ) resistor r=0.0864989 //w=0.382 //l=0.169012 //layer=m1 \
 //thickness=0.36 //x=23.06 //y=3.655 //x2=23.112 //y2=3.51
r1199 (  3 4 ) resistor r=1.04485 //w=0.131 //l=1.095 //layer=m1 \
 //thickness=0.36 //x=23.06 //y=3.655 //x2=23.06 //y2=4.75
r1200 (  2 30 ) resistor r=0.0815905 //w=0.382 //l=0.153818 //layer=m1 \
 //thickness=0.36 //x=23.06 //y=3.365 //x2=23.112 //y2=3.495
r1201 (  1 26 ) resistor r=0.0719237 //w=0.222 //l=0.115 //layer=m1 \
 //thickness=0.36 //x=23.06 //y=2.375 //x2=23.06 //y2=2.26
r1202 (  1 2 ) resistor r=0.944656 //w=0.131 //l=0.99 //layer=m1 \
 //thickness=0.36 //x=23.06 //y=2.375 //x2=23.06 //y2=3.365
ends PM_TMRDFFSNRNQX1\%noxref_6

subckt PM_TMRDFFSNRNQX1\%noxref_7 ( 1 3 6 7 9 10 11 12 14 15 16 17 18 19 20 21 \
 22 23 24 25 28 31 37 45 49 63 66 67 69 70 73 81 89 106 115 120 129 133 134 \
 135 136 137 138 139 140 141 142 143 145 151 152 153 154 158 159 160 161 162 \
 164 170 171 172 173 193 195 196 197 )
c439 ( 193 0 ) capacitor c=0.00885916f //x=32.745 //y=1.095
c440 ( 173 0 ) capacitor c=0.0612936f //x=40.355 //y=4.97
c441 ( 172 0 ) capacitor c=0.0376642f //x=40.645 //y=4.97
c442 ( 171 0 ) capacitor c=0.0346489f //x=40.31 //y=1.4
c443 ( 170 0 ) capacitor c=0.018692f //x=40.31 //y=1.055
c444 ( 164 0 ) capacitor c=0.0137077f //x=40.155 //y=1.555
c445 ( 162 0 ) capacitor c=0.0158585f //x=40.155 //y=0.9
c446 ( 161 0 ) capacitor c=0.0979536f //x=39.78 //y=2.095
c447 ( 160 0 ) capacitor c=0.0229444f //x=39.78 //y=1.71
c448 ( 159 0 ) capacitor c=0.0234359f //x=39.78 //y=1.4
c449 ( 158 0 ) capacitor c=0.019815f //x=39.78 //y=1.055
c450 ( 154 0 ) capacitor c=0.0614625f //x=35.545 //y=4.97
c451 ( 153 0 ) capacitor c=0.0376642f //x=35.835 //y=4.97
c452 ( 152 0 ) capacitor c=0.0346489f //x=35.5 //y=1.4
c453 ( 151 0 ) capacitor c=0.018692f //x=35.5 //y=1.055
c454 ( 145 0 ) capacitor c=0.0137077f //x=35.345 //y=1.555
c455 ( 143 0 ) capacitor c=0.0158585f //x=35.345 //y=0.9
c456 ( 142 0 ) capacitor c=0.0996161f //x=34.97 //y=2.095
c457 ( 141 0 ) capacitor c=0.0229444f //x=34.97 //y=1.71
c458 ( 140 0 ) capacitor c=0.0234359f //x=34.97 //y=1.4
c459 ( 139 0 ) capacitor c=0.019815f //x=34.97 //y=1.055
c460 ( 138 0 ) capacitor c=0.110208f //x=40.72 //y=6.2
c461 ( 137 0 ) capacitor c=0.158957f //x=40.28 //y=6.2
c462 ( 136 0 ) capacitor c=0.110409f //x=35.91 //y=6.2
c463 ( 135 0 ) capacitor c=0.158957f //x=35.47 //y=6.2
c464 ( 129 0 ) capacitor c=0.00159026f //x=40.08 //y=4.88
c465 ( 120 0 ) capacitor c=9.93222e-19 //x=40.08 //y=2.26
c466 ( 115 0 ) capacitor c=0.00157871f //x=35.27 //y=4.88
c467 ( 106 0 ) capacitor c=9.93222e-19 //x=35.27 //y=2.26
c468 ( 89 0 ) capacitor c=0.0293562f //x=32.64 //y=5.56
c469 ( 81 0 ) capacitor c=0.029137f //x=31.76 //y=5.56
c470 ( 73 0 ) capacitor c=0.0278099f //x=30.88 //y=5.56
c471 ( 70 0 ) capacitor c=0.0392804f //x=39.92 //y=2.785
c472 ( 69 0 ) capacitor c=5.7546e-19 //x=40.08 //y=2.785
c473 ( 67 0 ) capacitor c=5.7546e-19 //x=35.435 //y=2.785
c474 ( 66 0 ) capacitor c=0.016756f //x=35.115 //y=2.785
c475 ( 63 0 ) capacitor c=9.56892e-19 //x=33.585 //y=2.785
c476 ( 49 0 ) capacitor c=0.0154699f //x=40.08 //y=2.77
c477 ( 45 0 ) capacitor c=0.0148628f //x=35.27 //y=2.77
c478 ( 37 0 ) capacitor c=0.0144706f //x=33.42 //y=2.77
c479 ( 31 0 ) capacitor c=9.37498e-19 //x=32.64 //y=5.335
c480 ( 28 0 ) capacitor c=0.0076134f //x=31.76 //y=5.335
c481 ( 25 0 ) capacitor c=0.0109203f //x=30.882 //y=5.335
c482 ( 24 0 ) capacitor c=0.0553534f //x=40.08 //y=4.755
c483 ( 23 0 ) capacitor c=0.0130763f //x=40.08 //y=2.945
c484 ( 22 0 ) capacitor c=0.00473602f //x=40.08 //y=2.625
c485 ( 21 0 ) capacitor c=0.00495287f //x=40.08 //y=2.375
c486 ( 20 0 ) capacitor c=0.0601638f //x=35.27 //y=4.755
c487 ( 19 0 ) capacitor c=0.0129478f //x=35.27 //y=2.945
c488 ( 18 0 ) capacitor c=0.00482124f //x=35.27 //y=2.625
c489 ( 17 0 ) capacitor c=0.00495287f //x=35.27 //y=2.375
c490 ( 16 0 ) capacitor c=0.0657411f //x=33.42 //y=5.25
c491 ( 15 0 ) capacitor c=0.0123004f //x=33.42 //y=2.945
c492 ( 14 0 ) capacitor c=0.0179579f //x=33.42 //y=2.625
c493 ( 12 0 ) capacitor c=0.0047266f //x=33.02 //y=1.845
c494 ( 11 0 ) capacitor c=0.0129788f //x=33.335 //y=1.845
c495 ( 10 0 ) capacitor c=0.0167992f //x=32.935 //y=1.76
c496 ( 9 0 ) capacitor c=0.0110957f //x=32.935 //y=1.305
c497 ( 7 0 ) capacitor c=0.0203685f //x=33.335 //y=5.335
c498 ( 6 0 ) capacitor c=0.00933983f //x=32.64 //y=5.56
c499 ( 3 0 ) capacitor c=0.0192055f //x=32.525 //y=5.335
c500 ( 1 0 ) capacitor c=0.0149267f //x=31.64 //y=5.335
r501 (  172 174 ) resistor r=26.9307 //w=0.15 //l=0.106066 //layer=ply \
 //thickness=0.18 //x=40.645 //y=4.97 //x2=40.72 //y2=5.045
r502 (  172 173 ) resistor r=148.702 //w=0.094 //l=0.29 //layer=ply \
 //thickness=0.18 //x=40.645 //y=4.97 //x2=40.355 //y2=4.97
r503 (  171 192 ) resistor r=45.1352 //w=0.168 //l=0.173853 //layer=ply \
 //thickness=0.18 //x=40.31 //y=1.4 //x2=40.27 //y2=1.555
r504 (  170 191 ) resistor r=45.1352 //w=0.168 //l=0.173853 //layer=ply \
 //thickness=0.18 //x=40.31 //y=1.055 //x2=40.27 //y2=0.9
r505 (  170 171 ) resistor r=176.904 //w=0.094 //l=0.345 //layer=ply \
 //thickness=0.18 //x=40.31 //y=1.055 //x2=40.31 //y2=1.4
r506 (  167 173 ) resistor r=22.7971 //w=0.269 //l=0.106066 //layer=ply \
 //thickness=0.18 //x=40.28 //y=5.045 //x2=40.355 //y2=4.97
r507 (  167 190 ) resistor r=35.8364 //w=0.269 //l=0.270185 //layer=ply \
 //thickness=0.18 //x=40.28 //y=5.045 //x2=40.08 //y2=4.88
r508 (  165 186 ) resistor r=10.701 //w=0.21 //l=0.115 //layer=ply \
 //thickness=0.18 //x=39.935 //y=1.555 //x2=39.82 //y2=1.555
r509 (  164 192 ) resistor r=5.52526 //w=0.168 //l=0.115 //layer=ply \
 //thickness=0.18 //x=40.155 //y=1.555 //x2=40.27 //y2=1.555
r510 (  163 185 ) resistor r=5.52526 //w=0.168 //l=0.115 //layer=ply \
 //thickness=0.18 //x=39.935 //y=0.9 //x2=39.82 //y2=0.9
r511 (  162 191 ) resistor r=5.52526 //w=0.168 //l=0.115 //layer=ply \
 //thickness=0.18 //x=40.155 //y=0.9 //x2=40.27 //y2=0.9
r512 (  162 163 ) resistor r=112.809 //w=0.094 //l=0.22 //layer=ply \
 //thickness=0.18 //x=40.155 //y=0.9 //x2=39.935 //y2=0.9
r513 (  161 188 ) resistor r=58.7805 //w=0.246 //l=0.373497 //layer=ply \
 //thickness=0.18 //x=39.78 //y=2.095 //x2=40.08 //y2=2.26
r514 (  160 186 ) resistor r=39.5823 //w=0.21 //l=0.173853 //layer=ply \
 //thickness=0.18 //x=39.78 //y=1.71 //x2=39.82 //y2=1.555
r515 (  160 161 ) resistor r=197.415 //w=0.094 //l=0.385 //layer=ply \
 //thickness=0.18 //x=39.78 //y=1.71 //x2=39.78 //y2=2.095
r516 (  159 186 ) resistor r=39.5823 //w=0.21 //l=0.173853 //layer=ply \
 //thickness=0.18 //x=39.78 //y=1.4 //x2=39.82 //y2=1.555
r517 (  158 185 ) resistor r=45.1352 //w=0.168 //l=0.173853 //layer=ply \
 //thickness=0.18 //x=39.78 //y=1.055 //x2=39.82 //y2=0.9
r518 (  158 159 ) resistor r=176.904 //w=0.094 //l=0.345 //layer=ply \
 //thickness=0.18 //x=39.78 //y=1.055 //x2=39.78 //y2=1.4
r519 (  153 155 ) resistor r=26.9307 //w=0.15 //l=0.106066 //layer=ply \
 //thickness=0.18 //x=35.835 //y=4.97 //x2=35.91 //y2=5.045
r520 (  153 154 ) resistor r=148.702 //w=0.094 //l=0.29 //layer=ply \
 //thickness=0.18 //x=35.835 //y=4.97 //x2=35.545 //y2=4.97
r521 (  152 184 ) resistor r=45.1352 //w=0.168 //l=0.173853 //layer=ply \
 //thickness=0.18 //x=35.5 //y=1.4 //x2=35.46 //y2=1.555
r522 (  151 183 ) resistor r=45.1352 //w=0.168 //l=0.173853 //layer=ply \
 //thickness=0.18 //x=35.5 //y=1.055 //x2=35.46 //y2=0.9
r523 (  151 152 ) resistor r=176.904 //w=0.094 //l=0.345 //layer=ply \
 //thickness=0.18 //x=35.5 //y=1.055 //x2=35.5 //y2=1.4
r524 (  148 154 ) resistor r=22.7971 //w=0.269 //l=0.106066 //layer=ply \
 //thickness=0.18 //x=35.47 //y=5.045 //x2=35.545 //y2=4.97
r525 (  148 182 ) resistor r=35.8364 //w=0.269 //l=0.270185 //layer=ply \
 //thickness=0.18 //x=35.47 //y=5.045 //x2=35.27 //y2=4.88
r526 (  146 178 ) resistor r=10.701 //w=0.21 //l=0.115 //layer=ply \
 //thickness=0.18 //x=35.125 //y=1.555 //x2=35.01 //y2=1.555
r527 (  145 184 ) resistor r=5.52526 //w=0.168 //l=0.115 //layer=ply \
 //thickness=0.18 //x=35.345 //y=1.555 //x2=35.46 //y2=1.555
r528 (  144 177 ) resistor r=5.52526 //w=0.168 //l=0.115 //layer=ply \
 //thickness=0.18 //x=35.125 //y=0.9 //x2=35.01 //y2=0.9
r529 (  143 183 ) resistor r=5.52526 //w=0.168 //l=0.115 //layer=ply \
 //thickness=0.18 //x=35.345 //y=0.9 //x2=35.46 //y2=0.9
r530 (  143 144 ) resistor r=112.809 //w=0.094 //l=0.22 //layer=ply \
 //thickness=0.18 //x=35.345 //y=0.9 //x2=35.125 //y2=0.9
r531 (  142 180 ) resistor r=58.7805 //w=0.246 //l=0.373497 //layer=ply \
 //thickness=0.18 //x=34.97 //y=2.095 //x2=35.27 //y2=2.26
r532 (  141 178 ) resistor r=39.5823 //w=0.21 //l=0.173853 //layer=ply \
 //thickness=0.18 //x=34.97 //y=1.71 //x2=35.01 //y2=1.555
r533 (  141 142 ) resistor r=197.415 //w=0.094 //l=0.385 //layer=ply \
 //thickness=0.18 //x=34.97 //y=1.71 //x2=34.97 //y2=2.095
r534 (  140 178 ) resistor r=39.5823 //w=0.21 //l=0.173853 //layer=ply \
 //thickness=0.18 //x=34.97 //y=1.4 //x2=35.01 //y2=1.555
r535 (  139 177 ) resistor r=45.1352 //w=0.168 //l=0.173853 //layer=ply \
 //thickness=0.18 //x=34.97 //y=1.055 //x2=35.01 //y2=0.9
r536 (  139 140 ) resistor r=176.904 //w=0.094 //l=0.345 //layer=ply \
 //thickness=0.18 //x=34.97 //y=1.055 //x2=34.97 //y2=1.4
r537 (  138 174 ) resistor r=592.245 //w=0.094 //l=1.155 //layer=ply \
 //thickness=0.18 //x=40.72 //y=6.2 //x2=40.72 //y2=5.045
r538 (  137 167 ) resistor r=592.245 //w=0.094 //l=1.155 //layer=ply \
 //thickness=0.18 //x=40.28 //y=6.2 //x2=40.28 //y2=5.045
r539 (  136 155 ) resistor r=592.245 //w=0.094 //l=1.155 //layer=ply \
 //thickness=0.18 //x=35.91 //y=6.2 //x2=35.91 //y2=5.045
r540 (  135 148 ) resistor r=592.245 //w=0.094 //l=1.155 //layer=ply \
 //thickness=0.18 //x=35.47 //y=6.2 //x2=35.47 //y2=5.045
r541 (  134 164 ) resistor r=56.4043 //w=0.094 //l=0.11 //layer=ply \
 //thickness=0.18 //x=40.045 //y=1.555 //x2=40.155 //y2=1.555
r542 (  134 165 ) resistor r=56.4043 //w=0.094 //l=0.11 //layer=ply \
 //thickness=0.18 //x=40.045 //y=1.555 //x2=39.935 //y2=1.555
r543 (  133 145 ) resistor r=56.4043 //w=0.094 //l=0.11 //layer=ply \
 //thickness=0.18 //x=35.235 //y=1.555 //x2=35.345 //y2=1.555
r544 (  133 146 ) resistor r=56.4043 //w=0.094 //l=0.11 //layer=ply \
 //thickness=0.18 //x=35.235 //y=1.555 //x2=35.125 //y2=1.555
r545 (  129 190 ) resistor r=152 //w=0.17 //l=0.17 //layer=licon //count=1 \
 //x=40.08 //y=4.88 //x2=40.08 //y2=4.88
r546 (  120 188 ) resistor r=152 //w=0.17 //l=0.17 //layer=licon //count=1 \
 //x=40.08 //y=2.26 //x2=40.08 //y2=2.26
r547 (  115 182 ) resistor r=152 //w=0.17 //l=0.17 //layer=licon //count=1 \
 //x=35.27 //y=4.88 //x2=35.27 //y2=4.88
r548 (  106 180 ) resistor r=152 //w=0.17 //l=0.17 //layer=licon //count=1 \
 //x=35.27 //y=2.26 //x2=35.27 //y2=2.26
r549 (  89 197 ) resistor r=23.615 //w=0.187 //l=0.345 //layer=li \
 //thickness=0.1 //x=32.64 //y=5.56 //x2=32.64 //y2=5.905
r550 (  81 196 ) resistor r=23.615 //w=0.187 //l=0.345 //layer=li \
 //thickness=0.1 //x=31.76 //y=5.56 //x2=31.76 //y2=5.905
r551 (  73 195 ) resistor r=23.615 //w=0.187 //l=0.345 //layer=li \
 //thickness=0.1 //x=30.88 //y=5.56 //x2=30.88 //y2=5.905
r552 (  69 70 ) resistor r=0.10734 //w=0.281 //l=0.16 //layer=m2 \
 //thickness=0.36 //x=40.08 //y=2.785 //x2=39.92 //y2=2.785
r553 (  67 70 ) resistor r=4.27958 //w=0.131 //l=4.485 //layer=m2 \
 //thickness=0.36 //x=35.435 //y=2.77 //x2=39.92 //y2=2.77
r554 (  65 67 ) resistor r=0.10734 //w=0.281 //l=0.16 //layer=m2 \
 //thickness=0.36 //x=35.275 //y=2.785 //x2=35.435 //y2=2.785
r555 (  65 66 ) resistor r=0.10734 //w=0.281 //l=0.16 //layer=m2 \
 //thickness=0.36 //x=35.275 //y=2.785 //x2=35.115 //y2=2.785
r556 (  63 66 ) resistor r=1.45992 //w=0.131 //l=1.53 //layer=m2 \
 //thickness=0.36 //x=33.585 //y=2.77 //x2=35.115 //y2=2.77
r557 (  61 63 ) resistor r=0.10734 //w=0.281 //l=0.16 //layer=m2 \
 //thickness=0.36 //x=33.425 //y=2.785 //x2=33.585 //y2=2.785
r558 (  55 129 ) resistor r=9.3 //w=0.17 //l=0.17 //layer=mcon //count=1 \
 //x=40.08 //y=4.88 //x2=40.08 //y2=4.88
r559 (  53 120 ) resistor r=9.3 //w=0.17 //l=0.17 //layer=mcon //count=1 \
 //x=40.08 //y=2.26 //x2=40.08 //y2=2.26
r560 (  51 69 ) resistor r=4.5 //w=0.15 //l=0.15 //layer=via1 //count=1 \
 //x=40.08 //y=2.785 //x2=40.08 //y2=2.785
r561 (  49 51 ) resistor r=0.0049867 //w=0.376 //l=0.015 //layer=m1 \
 //thickness=0.36 //x=40.027 //y=2.77 //x2=40.027 //y2=2.785
r562 (  47 65 ) resistor r=4.5 //w=0.15 //l=0.15 //layer=via1 //count=1 \
 //x=35.275 //y=2.785 //x2=35.275 //y2=2.785
r563 (  45 47 ) resistor r=0.00501337 //w=0.374 //l=0.015 //layer=m1 \
 //thickness=0.36 //x=35.325 //y=2.77 //x2=35.325 //y2=2.785
r564 (  43 115 ) resistor r=9.3 //w=0.17 //l=0.17 //layer=mcon //count=1 \
 //x=35.27 //y=4.88 //x2=35.27 //y2=4.88
r565 (  41 106 ) resistor r=9.3 //w=0.17 //l=0.17 //layer=mcon //count=1 \
 //x=35.27 //y=2.26 //x2=35.27 //y2=2.26
r566 (  39 61 ) resistor r=4.5 //w=0.15 //l=0.15 //layer=via1 //count=1 \
 //x=33.425 //y=2.785 //x2=33.425 //y2=2.785
r567 (  37 39 ) resistor r=0.00501337 //w=0.374 //l=0.015 //layer=m1 \
 //thickness=0.36 //x=33.475 //y=2.77 //x2=33.475 //y2=2.785
r568 (  35 193 ) resistor r=9.3 //w=0.17 //l=0.17 //layer=mcon //count=1 \
 //x=32.935 //y=1.19 //x2=32.935 //y2=1.19
r569 (  33 89 ) resistor r=9.3 //w=0.17 //l=0.17 //layer=mcon //count=1 \
 //x=32.64 //y=5.56 //x2=32.64 //y2=5.56
r570 (  30 81 ) resistor r=9.3 //w=0.17 //l=0.17 //layer=mcon //count=1 \
 //x=31.76 //y=5.56 //x2=31.76 //y2=5.56
r571 (  28 30 ) resistor r=0.121228 //w=0.232 //l=0.225 //layer=m1 \
 //thickness=0.36 //x=31.76 //y=5.335 //x2=31.76 //y2=5.56
r572 (  27 73 ) resistor r=9.3 //w=0.17 //l=0.17 //layer=mcon //count=1 \
 //x=30.88 //y=5.56 //x2=30.88 //y2=5.56
r573 (  25 27 ) resistor r=0.129608 //w=0.217 //l=0.225 //layer=m1 \
 //thickness=0.36 //x=30.882 //y=5.335 //x2=30.882 //y2=5.56
r574 (  24 55 ) resistor r=0.0760407 //w=0.238 //l=0.125 //layer=m1 \
 //thickness=0.36 //x=40.08 //y=4.755 //x2=40.08 //y2=4.88
r575 (  23 51 ) resistor r=0.0911593 //w=0.376 //l=0.184608 //layer=m1 \
 //thickness=0.36 //x=40.08 //y=2.945 //x2=40.027 //y2=2.785
r576 (  23 24 ) resistor r=1.7271 //w=0.131 //l=1.81 //layer=m1 \
 //thickness=0.36 //x=40.08 //y=2.945 //x2=40.08 //y2=4.755
r577 (  22 49 ) resistor r=0.0861726 //w=0.376 //l=0.16944 //layer=m1 \
 //thickness=0.36 //x=40.08 //y=2.625 //x2=40.027 //y2=2.77
r578 (  21 53 ) resistor r=0.0719237 //w=0.222 //l=0.115 //layer=m1 \
 //thickness=0.36 //x=40.08 //y=2.375 //x2=40.08 //y2=2.26
r579 (  21 22 ) resistor r=0.23855 //w=0.131 //l=0.25 //layer=m1 \
 //thickness=0.36 //x=40.08 //y=2.375 //x2=40.08 //y2=2.625
r580 (  20 43 ) resistor r=0.0760407 //w=0.238 //l=0.125 //layer=m1 \
 //thickness=0.36 //x=35.27 //y=4.755 //x2=35.27 //y2=4.88
r581 (  19 47 ) resistor r=0.0910802 //w=0.374 //l=0.185472 //layer=m1 \
 //thickness=0.36 //x=35.27 //y=2.945 //x2=35.325 //y2=2.785
r582 (  19 20 ) resistor r=1.7271 //w=0.131 //l=1.81 //layer=m1 \
 //thickness=0.36 //x=35.27 //y=2.945 //x2=35.27 //y2=4.755
r583 (  18 45 ) resistor r=0.0860668 //w=0.374 //l=0.170294 //layer=m1 \
 //thickness=0.36 //x=35.27 //y=2.625 //x2=35.325 //y2=2.77
r584 (  17 41 ) resistor r=0.0719237 //w=0.222 //l=0.115 //layer=m1 \
 //thickness=0.36 //x=35.27 //y=2.375 //x2=35.27 //y2=2.26
r585 (  17 18 ) resistor r=0.23855 //w=0.131 //l=0.25 //layer=m1 \
 //thickness=0.36 //x=35.27 //y=2.375 //x2=35.27 //y2=2.625
r586 (  15 39 ) resistor r=0.0910802 //w=0.374 //l=0.185472 //layer=m1 \
 //thickness=0.36 //x=33.42 //y=2.945 //x2=33.475 //y2=2.785
r587 (  15 16 ) resistor r=2.19943 //w=0.131 //l=2.305 //layer=m1 \
 //thickness=0.36 //x=33.42 //y=2.945 //x2=33.42 //y2=5.25
r588 (  14 37 ) resistor r=0.0860668 //w=0.374 //l=0.170294 //layer=m1 \
 //thickness=0.36 //x=33.42 //y=2.625 //x2=33.475 //y2=2.77
r589 (  13 14 ) resistor r=0.663168 //w=0.131 //l=0.695 //layer=m1 \
 //thickness=0.36 //x=33.42 //y=1.93 //x2=33.42 //y2=2.625
r590 (  11 13 ) resistor r=0.0698411 //w=0.17 //l=0.120208 //layer=m1 \
 //thickness=0.36 //x=33.335 //y=1.845 //x2=33.42 //y2=1.93
r591 (  11 12 ) resistor r=0.300573 //w=0.131 //l=0.315 //layer=m1 \
 //thickness=0.36 //x=33.335 //y=1.845 //x2=33.02 //y2=1.845
r592 (  10 12 ) resistor r=0.0698411 //w=0.17 //l=0.120208 //layer=m1 \
 //thickness=0.36 //x=32.935 //y=1.76 //x2=33.02 //y2=1.845
r593 (  9 35 ) resistor r=0.0717383 //w=0.224 //l=0.115 //layer=m1 \
 //thickness=0.36 //x=32.935 //y=1.305 //x2=32.935 //y2=1.19
r594 (  9 10 ) resistor r=0.43416 //w=0.131 //l=0.455 //layer=m1 \
 //thickness=0.36 //x=32.935 //y=1.305 //x2=32.935 //y2=1.76
r595 (  8 31 ) resistor r=0.0675342 //w=0.23 //l=0.115 //layer=m1 \
 //thickness=0.36 //x=32.755 //y=5.335 //x2=32.64 //y2=5.335
r596 (  7 16 ) resistor r=0.0698411 //w=0.17 //l=0.120208 //layer=m1 \
 //thickness=0.36 //x=33.335 //y=5.335 //x2=33.42 //y2=5.25
r597 (  7 8 ) resistor r=0.553435 //w=0.131 //l=0.58 //layer=m1 \
 //thickness=0.36 //x=33.335 //y=5.335 //x2=32.755 //y2=5.335
r598 (  6 33 ) resistor r=0.00118313 //w=0.23 //layer=m1 //thickness=0.36 \
 //x=32.64 //y=5.56 //x2=32.64 //y2=5.56
r599 (  5 31 ) resistor r=0.002872 //w=0.34 //l=0.085 //layer=m1 \
 //thickness=0.36 //x=32.64 //y=5.42 //x2=32.64 //y2=5.335
r600 (  5 6 ) resistor r=0.091623 //w=0.191 //l=0.14 //layer=m1 \
 //thickness=0.36 //x=32.64 //y=5.42 //x2=32.64 //y2=5.56
r601 (  4 28 ) resistor r=0.0262263 //w=0.232 //l=0.12 //layer=m1 \
 //thickness=0.36 //x=31.88 //y=5.335 //x2=31.76 //y2=5.335
r602 (  3 31 ) resistor r=0.0675342 //w=0.23 //l=0.115 //layer=m1 \
 //thickness=0.36 //x=32.525 //y=5.335 //x2=32.64 //y2=5.335
r603 (  3 4 ) resistor r=0.615458 //w=0.131 //l=0.645 //layer=m1 \
 //thickness=0.36 //x=32.525 //y=5.335 //x2=31.88 //y2=5.335
r604 (  2 25 ) resistor r=0.0222262 //w=0.217 //l=0.118 //layer=m1 \
 //thickness=0.36 //x=31 //y=5.335 //x2=30.882 //y2=5.335
r605 (  1 28 ) resistor r=0.0262263 //w=0.232 //l=0.12 //layer=m1 \
 //thickness=0.36 //x=31.64 //y=5.335 //x2=31.76 //y2=5.335
r606 (  1 2 ) resistor r=0.610687 //w=0.131 //l=0.64 //layer=m1 \
 //thickness=0.36 //x=31.64 //y=5.335 //x2=31 //y2=5.335
ends PM_TMRDFFSNRNQX1\%noxref_7

subckt PM_TMRDFFSNRNQX1\%noxref_8 ( 1 3 6 7 9 10 11 12 14 15 16 17 18 19 20 21 \
 24 27 33 36 42 43 48 51 59 67 84 93 97 98 99 100 101 102 103 104 106 112 113 \
 114 115 127 129 130 131 )
c299 ( 127 0 ) capacitor c=0.00885916f //x=42.365 //y=1.095
c300 ( 115 0 ) capacitor c=0.0612936f //x=45.165 //y=4.97
c301 ( 114 0 ) capacitor c=0.0376642f //x=45.455 //y=4.97
c302 ( 113 0 ) capacitor c=0.0346489f //x=45.12 //y=1.4
c303 ( 112 0 ) capacitor c=0.018692f //x=45.12 //y=1.055
c304 ( 106 0 ) capacitor c=0.0137077f //x=44.965 //y=1.555
c305 ( 104 0 ) capacitor c=0.0158585f //x=44.965 //y=0.9
c306 ( 103 0 ) capacitor c=0.0979523f //x=44.59 //y=2.095
c307 ( 102 0 ) capacitor c=0.0229444f //x=44.59 //y=1.71
c308 ( 101 0 ) capacitor c=0.0234359f //x=44.59 //y=1.4
c309 ( 100 0 ) capacitor c=0.019815f //x=44.59 //y=1.055
c310 ( 99 0 ) capacitor c=0.110208f //x=45.53 //y=6.2
c311 ( 98 0 ) capacitor c=0.158957f //x=45.09 //y=6.2
c312 ( 93 0 ) capacitor c=0.00157537f //x=44.89 //y=4.88
c313 ( 84 0 ) capacitor c=9.93222e-19 //x=44.89 //y=2.26
c314 ( 67 0 ) capacitor c=0.0293723f //x=42.26 //y=5.56
c315 ( 59 0 ) capacitor c=0.029137f //x=41.38 //y=5.56
c316 ( 51 0 ) capacitor c=0.0278099f //x=40.5 //y=5.56
c317 ( 48 0 ) capacitor c=5.79974e-19 //x=44.9 //y=2.77
c318 ( 43 0 ) capacitor c=9.44624e-19 //x=43.2 //y=2.77
c319 ( 42 0 ) capacitor c=0.0155215f //x=44.74 //y=2.77
c320 ( 36 0 ) capacitor c=0.0146045f //x=44.89 //y=2.77
c321 ( 33 0 ) capacitor c=0.0146969f //x=43.04 //y=2.77
c322 ( 27 0 ) capacitor c=8.40513e-19 //x=42.26 //y=5.335
c323 ( 24 0 ) capacitor c=0.00712803f //x=41.38 //y=5.335
c324 ( 21 0 ) capacitor c=0.0109203f //x=40.502 //y=5.335
c325 ( 20 0 ) capacitor c=0.0604534f //x=44.89 //y=4.755
c326 ( 19 0 ) capacitor c=0.0131932f //x=44.89 //y=2.93
c327 ( 18 0 ) capacitor c=0.00432188f //x=44.89 //y=2.61
c328 ( 17 0 ) capacitor c=0.00485584f //x=44.89 //y=2.375
c329 ( 16 0 ) capacitor c=0.0632504f //x=43.04 //y=5.25
c330 ( 15 0 ) capacitor c=0.0122936f //x=43.04 //y=2.93
c331 ( 14 0 ) capacitor c=0.0181662f //x=43.04 //y=2.61
c332 ( 12 0 ) capacitor c=0.00493487f //x=42.64 //y=1.845
c333 ( 11 0 ) capacitor c=0.0129068f //x=42.955 //y=1.845
c334 ( 10 0 ) capacitor c=0.0167992f //x=42.555 //y=1.76
c335 ( 9 0 ) capacitor c=0.0112867f //x=42.555 //y=1.305
c336 ( 7 0 ) capacitor c=0.020812f //x=42.955 //y=5.335
c337 ( 6 0 ) capacitor c=0.00933983f //x=42.26 //y=5.56
c338 ( 3 0 ) capacitor c=0.0177111f //x=42.145 //y=5.335
c339 ( 1 0 ) capacitor c=0.0148498f //x=41.26 //y=5.335
r340 (  114 116 ) resistor r=26.9307 //w=0.15 //l=0.106066 //layer=ply \
 //thickness=0.18 //x=45.455 //y=4.97 //x2=45.53 //y2=5.045
r341 (  114 115 ) resistor r=148.702 //w=0.094 //l=0.29 //layer=ply \
 //thickness=0.18 //x=45.455 //y=4.97 //x2=45.165 //y2=4.97
r342 (  113 126 ) resistor r=45.1352 //w=0.168 //l=0.173853 //layer=ply \
 //thickness=0.18 //x=45.12 //y=1.4 //x2=45.08 //y2=1.555
r343 (  112 125 ) resistor r=45.1352 //w=0.168 //l=0.173853 //layer=ply \
 //thickness=0.18 //x=45.12 //y=1.055 //x2=45.08 //y2=0.9
r344 (  112 113 ) resistor r=176.904 //w=0.094 //l=0.345 //layer=ply \
 //thickness=0.18 //x=45.12 //y=1.055 //x2=45.12 //y2=1.4
r345 (  109 115 ) resistor r=22.7971 //w=0.269 //l=0.106066 //layer=ply \
 //thickness=0.18 //x=45.09 //y=5.045 //x2=45.165 //y2=4.97
r346 (  109 124 ) resistor r=35.8364 //w=0.269 //l=0.270185 //layer=ply \
 //thickness=0.18 //x=45.09 //y=5.045 //x2=44.89 //y2=4.88
r347 (  107 120 ) resistor r=10.701 //w=0.21 //l=0.115 //layer=ply \
 //thickness=0.18 //x=44.745 //y=1.555 //x2=44.63 //y2=1.555
r348 (  106 126 ) resistor r=5.52526 //w=0.168 //l=0.115 //layer=ply \
 //thickness=0.18 //x=44.965 //y=1.555 //x2=45.08 //y2=1.555
r349 (  105 119 ) resistor r=5.52526 //w=0.168 //l=0.115 //layer=ply \
 //thickness=0.18 //x=44.745 //y=0.9 //x2=44.63 //y2=0.9
r350 (  104 125 ) resistor r=5.52526 //w=0.168 //l=0.115 //layer=ply \
 //thickness=0.18 //x=44.965 //y=0.9 //x2=45.08 //y2=0.9
r351 (  104 105 ) resistor r=112.809 //w=0.094 //l=0.22 //layer=ply \
 //thickness=0.18 //x=44.965 //y=0.9 //x2=44.745 //y2=0.9
r352 (  103 122 ) resistor r=58.7805 //w=0.246 //l=0.373497 //layer=ply \
 //thickness=0.18 //x=44.59 //y=2.095 //x2=44.89 //y2=2.26
r353 (  102 120 ) resistor r=39.5823 //w=0.21 //l=0.173853 //layer=ply \
 //thickness=0.18 //x=44.59 //y=1.71 //x2=44.63 //y2=1.555
r354 (  102 103 ) resistor r=197.415 //w=0.094 //l=0.385 //layer=ply \
 //thickness=0.18 //x=44.59 //y=1.71 //x2=44.59 //y2=2.095
r355 (  101 120 ) resistor r=39.5823 //w=0.21 //l=0.173853 //layer=ply \
 //thickness=0.18 //x=44.59 //y=1.4 //x2=44.63 //y2=1.555
r356 (  100 119 ) resistor r=45.1352 //w=0.168 //l=0.173853 //layer=ply \
 //thickness=0.18 //x=44.59 //y=1.055 //x2=44.63 //y2=0.9
r357 (  100 101 ) resistor r=176.904 //w=0.094 //l=0.345 //layer=ply \
 //thickness=0.18 //x=44.59 //y=1.055 //x2=44.59 //y2=1.4
r358 (  99 116 ) resistor r=592.245 //w=0.094 //l=1.155 //layer=ply \
 //thickness=0.18 //x=45.53 //y=6.2 //x2=45.53 //y2=5.045
r359 (  98 109 ) resistor r=592.245 //w=0.094 //l=1.155 //layer=ply \
 //thickness=0.18 //x=45.09 //y=6.2 //x2=45.09 //y2=5.045
r360 (  97 106 ) resistor r=56.4043 //w=0.094 //l=0.11 //layer=ply \
 //thickness=0.18 //x=44.855 //y=1.555 //x2=44.965 //y2=1.555
r361 (  97 107 ) resistor r=56.4043 //w=0.094 //l=0.11 //layer=ply \
 //thickness=0.18 //x=44.855 //y=1.555 //x2=44.745 //y2=1.555
r362 (  93 124 ) resistor r=152 //w=0.17 //l=0.17 //layer=licon //count=1 \
 //x=44.89 //y=4.88 //x2=44.89 //y2=4.88
r363 (  84 122 ) resistor r=152 //w=0.17 //l=0.17 //layer=licon //count=1 \
 //x=44.89 //y=2.26 //x2=44.89 //y2=2.26
r364 (  67 131 ) resistor r=23.615 //w=0.187 //l=0.345 //layer=li \
 //thickness=0.1 //x=42.26 //y=5.56 //x2=42.26 //y2=5.905
r365 (  59 130 ) resistor r=23.615 //w=0.187 //l=0.345 //layer=li \
 //thickness=0.1 //x=41.38 //y=5.56 //x2=41.38 //y2=5.905
r366 (  51 129 ) resistor r=23.615 //w=0.187 //l=0.345 //layer=li \
 //thickness=0.1 //x=40.5 //y=5.56 //x2=40.5 //y2=5.905
r367 (  43 45 ) resistor r=0.10734 //w=0.281 //l=0.16 //layer=m2 \
 //thickness=0.36 //x=43.2 //y=2.77 //x2=43.04 //y2=2.77
r368 (  42 48 ) resistor r=0.10734 //w=0.281 //l=0.16 //layer=m2 \
 //thickness=0.36 //x=44.74 //y=2.77 //x2=44.9 //y2=2.77
r369 (  42 43 ) resistor r=1.46947 //w=0.131 //l=1.54 //layer=m2 \
 //thickness=0.36 //x=44.74 //y=2.77 //x2=43.2 //y2=2.77
r370 (  41 93 ) resistor r=9.3 //w=0.17 //l=0.17 //layer=mcon //count=1 \
 //x=44.89 //y=4.88 //x2=44.89 //y2=4.88
r371 (  39 84 ) resistor r=9.3 //w=0.17 //l=0.17 //layer=mcon //count=1 \
 //x=44.89 //y=2.26 //x2=44.89 //y2=2.26
r372 (  36 48 ) resistor r=4.5 //w=0.15 //l=0.15 //layer=via1 //count=1 \
 //x=44.9 //y=2.77 //x2=44.9 //y2=2.77
r373 (  33 45 ) resistor r=4.5 //w=0.15 //l=0.15 //layer=via1 //count=1 \
 //x=43.04 //y=2.77 //x2=43.04 //y2=2.77
r374 (  31 127 ) resistor r=9.3 //w=0.17 //l=0.17 //layer=mcon //count=1 \
 //x=42.555 //y=1.19 //x2=42.555 //y2=1.19
r375 (  29 67 ) resistor r=9.3 //w=0.17 //l=0.17 //layer=mcon //count=1 \
 //x=42.26 //y=5.56 //x2=42.26 //y2=5.56
r376 (  26 59 ) resistor r=9.3 //w=0.17 //l=0.17 //layer=mcon //count=1 \
 //x=41.38 //y=5.56 //x2=41.38 //y2=5.56
r377 (  24 26 ) resistor r=0.121228 //w=0.232 //l=0.225 //layer=m1 \
 //thickness=0.36 //x=41.38 //y=5.335 //x2=41.38 //y2=5.56
r378 (  23 51 ) resistor r=9.3 //w=0.17 //l=0.17 //layer=mcon //count=1 \
 //x=40.5 //y=5.56 //x2=40.5 //y2=5.56
r379 (  21 23 ) resistor r=0.129608 //w=0.217 //l=0.225 //layer=m1 \
 //thickness=0.36 //x=40.502 //y=5.335 //x2=40.502 //y2=5.56
r380 (  20 41 ) resistor r=0.0760407 //w=0.238 //l=0.125 //layer=m1 \
 //thickness=0.36 //x=44.89 //y=4.755 //x2=44.89 //y2=4.88
r381 (  19 36 ) resistor r=0.0914072 //w=0.382 //l=0.182428 //layer=m1 \
 //thickness=0.36 //x=44.89 //y=2.93 //x2=44.842 //y2=2.77
r382 (  19 20 ) resistor r=1.74141 //w=0.131 //l=1.825 //layer=m1 \
 //thickness=0.36 //x=44.89 //y=2.93 //x2=44.89 //y2=4.755
r383 (  18 36 ) resistor r=0.0914072 //w=0.382 //l=0.182428 //layer=m1 \
 //thickness=0.36 //x=44.89 //y=2.61 //x2=44.842 //y2=2.77
r384 (  17 39 ) resistor r=0.0719237 //w=0.222 //l=0.115 //layer=m1 \
 //thickness=0.36 //x=44.89 //y=2.375 //x2=44.89 //y2=2.26
r385 (  17 18 ) resistor r=0.224237 //w=0.131 //l=0.235 //layer=m1 \
 //thickness=0.36 //x=44.89 //y=2.375 //x2=44.89 //y2=2.61
r386 (  15 33 ) resistor r=0.0911593 //w=0.376 //l=0.184174 //layer=m1 \
 //thickness=0.36 //x=43.04 //y=2.93 //x2=43.092 //y2=2.77
r387 (  15 16 ) resistor r=2.21374 //w=0.131 //l=2.32 //layer=m1 \
 //thickness=0.36 //x=43.04 //y=2.93 //x2=43.04 //y2=5.25
r388 (  14 33 ) resistor r=0.0911593 //w=0.376 //l=0.184174 //layer=m1 \
 //thickness=0.36 //x=43.04 //y=2.61 //x2=43.092 //y2=2.77
r389 (  13 14 ) resistor r=0.648855 //w=0.131 //l=0.68 //layer=m1 \
 //thickness=0.36 //x=43.04 //y=1.93 //x2=43.04 //y2=2.61
r390 (  11 13 ) resistor r=0.0698411 //w=0.17 //l=0.120208 //layer=m1 \
 //thickness=0.36 //x=42.955 //y=1.845 //x2=43.04 //y2=1.93
r391 (  11 12 ) resistor r=0.300573 //w=0.131 //l=0.315 //layer=m1 \
 //thickness=0.36 //x=42.955 //y=1.845 //x2=42.64 //y2=1.845
r392 (  10 12 ) resistor r=0.0698411 //w=0.17 //l=0.120208 //layer=m1 \
 //thickness=0.36 //x=42.555 //y=1.76 //x2=42.64 //y2=1.845
r393 (  9 31 ) resistor r=0.0717383 //w=0.224 //l=0.115 //layer=m1 \
 //thickness=0.36 //x=42.555 //y=1.305 //x2=42.555 //y2=1.19
r394 (  9 10 ) resistor r=0.43416 //w=0.131 //l=0.455 //layer=m1 \
 //thickness=0.36 //x=42.555 //y=1.305 //x2=42.555 //y2=1.76
r395 (  8 27 ) resistor r=0.0675342 //w=0.23 //l=0.115 //layer=m1 \
 //thickness=0.36 //x=42.375 //y=5.335 //x2=42.26 //y2=5.335
r396 (  7 16 ) resistor r=0.0698411 //w=0.17 //l=0.120208 //layer=m1 \
 //thickness=0.36 //x=42.955 //y=5.335 //x2=43.04 //y2=5.25
r397 (  7 8 ) resistor r=0.553435 //w=0.131 //l=0.58 //layer=m1 \
 //thickness=0.36 //x=42.955 //y=5.335 //x2=42.375 //y2=5.335
r398 (  6 29 ) resistor r=0.00118313 //w=0.23 //layer=m1 //thickness=0.36 \
 //x=42.26 //y=5.56 //x2=42.26 //y2=5.56
r399 (  5 27 ) resistor r=0.002872 //w=0.34 //l=0.085 //layer=m1 \
 //thickness=0.36 //x=42.26 //y=5.42 //x2=42.26 //y2=5.335
r400 (  5 6 ) resistor r=0.091623 //w=0.191 //l=0.14 //layer=m1 \
 //thickness=0.36 //x=42.26 //y=5.42 //x2=42.26 //y2=5.56
r401 (  4 24 ) resistor r=0.0262263 //w=0.232 //l=0.12 //layer=m1 \
 //thickness=0.36 //x=41.5 //y=5.335 //x2=41.38 //y2=5.335
r402 (  3 27 ) resistor r=0.0675342 //w=0.23 //l=0.115 //layer=m1 \
 //thickness=0.36 //x=42.145 //y=5.335 //x2=42.26 //y2=5.335
r403 (  3 4 ) resistor r=0.615458 //w=0.131 //l=0.645 //layer=m1 \
 //thickness=0.36 //x=42.145 //y=5.335 //x2=41.5 //y2=5.335
r404 (  2 21 ) resistor r=0.0222262 //w=0.217 //l=0.118 //layer=m1 \
 //thickness=0.36 //x=40.62 //y=5.335 //x2=40.502 //y2=5.335
r405 (  1 24 ) resistor r=0.0262263 //w=0.232 //l=0.12 //layer=m1 \
 //thickness=0.36 //x=41.26 //y=5.335 //x2=41.38 //y2=5.335
r406 (  1 2 ) resistor r=0.610687 //w=0.131 //l=0.64 //layer=m1 \
 //thickness=0.36 //x=41.26 //y=5.335 //x2=40.62 //y2=5.335
ends PM_TMRDFFSNRNQX1\%noxref_8

subckt PM_TMRDFFSNRNQX1\%noxref_9 ( 1 2 3 4 5 7 10 11 13 14 15 16 18 19 20 21 \
 22 23 24 30 33 36 39 47 49 57 62 65 66 68 71 80 85 93 101 118 127 131 132 133 \
 134 135 136 140 141 142 147 149 152 153 154 155 156 157 158 160 166 167 168 \
 169 174 175 180 191 193 194 195 )
c485 ( 191 0 ) capacitor c=0.00885916f //x=37.555 //y=1.095
c486 ( 180 0 ) capacitor c=0.0710579f //x=32.68 //y=4.88
c487 ( 175 0 ) capacitor c=0.0278202f //x=32.68 //y=2.095
c488 ( 174 0 ) capacitor c=0.0479349f //x=32.68 //y=2.26
c489 ( 169 0 ) capacitor c=0.0612936f //x=49.975 //y=4.97
c490 ( 168 0 ) capacitor c=0.0376642f //x=50.265 //y=4.97
c491 ( 167 0 ) capacitor c=0.0346489f //x=49.93 //y=1.4
c492 ( 166 0 ) capacitor c=0.018692f //x=49.93 //y=1.055
c493 ( 160 0 ) capacitor c=0.0137077f //x=49.775 //y=1.555
c494 ( 158 0 ) capacitor c=0.0158585f //x=49.775 //y=0.9
c495 ( 157 0 ) capacitor c=0.10101f //x=49.4 //y=2.095
c496 ( 156 0 ) capacitor c=0.0229444f //x=49.4 //y=1.71
c497 ( 155 0 ) capacitor c=0.0234359f //x=49.4 //y=1.4
c498 ( 154 0 ) capacitor c=0.019815f //x=49.4 //y=1.055
c499 ( 153 0 ) capacitor c=0.0443175f //x=33.2 //y=1.44
c500 ( 152 0 ) capacitor c=0.0199703f //x=33.2 //y=1.095
c501 ( 149 0 ) capacitor c=0.0162526f //x=33.045 //y=1.595
c502 ( 147 0 ) capacitor c=0.0157807f //x=33.045 //y=0.94
c503 ( 142 0 ) capacitor c=0.0220935f //x=32.67 //y=1.75
c504 ( 141 0 ) capacitor c=0.0207489f //x=32.67 //y=1.44
c505 ( 140 0 ) capacitor c=0.0194091f //x=32.67 //y=1.095
c506 ( 136 0 ) capacitor c=0.110208f //x=50.34 //y=6.2
c507 ( 135 0 ) capacitor c=0.158957f //x=49.9 //y=6.2
c508 ( 134 0 ) capacitor c=0.159671f //x=32.86 //y=6.2
c509 ( 133 0 ) capacitor c=0.110208f //x=32.42 //y=6.2
c510 ( 127 0 ) capacitor c=0.00159026f //x=49.7 //y=4.88
c511 ( 118 0 ) capacitor c=0.0012618f //x=49.7 //y=2.26
c512 ( 101 0 ) capacitor c=0.0293723f //x=37.45 //y=5.56
c513 ( 93 0 ) capacitor c=0.029137f //x=36.57 //y=5.56
c514 ( 85 0 ) capacitor c=0.0278099f //x=35.69 //y=5.56
c515 ( 80 0 ) capacitor c=9.5006e-19 //x=32.68 //y=4.88
c516 ( 71 0 ) capacitor c=0.00101179f //x=32.68 //y=2.26
c517 ( 68 0 ) capacitor c=3.39224e-19 //x=49.695 //y=3.51
c518 ( 66 0 ) capacitor c=6.97864e-19 //x=38.39 //y=3.495
c519 ( 65 0 ) capacitor c=0.0608112f //x=38.07 //y=3.495
c520 ( 62 0 ) capacitor c=4.31985e-19 //x=32.85 //y=3.515
c521 ( 57 0 ) capacitor c=0.113477f //x=49.535 //y=3.51
c522 ( 49 0 ) capacitor c=0.0169562f //x=49.695 //y=3.51
c523 ( 47 0 ) capacitor c=0.0158593f //x=38.23 //y=3.51
c524 ( 39 0 ) capacitor c=8.40513e-19 //x=37.45 //y=5.335
c525 ( 36 0 ) capacitor c=0.00746333f //x=36.57 //y=5.335
c526 ( 33 0 ) capacitor c=0.0120388f //x=35.692 //y=5.335
c527 ( 30 0 ) capacitor c=0.0150828f //x=32.68 //y=3.51
c528 ( 24 0 ) capacitor c=0.0346814f //x=49.7 //y=4.755
c529 ( 23 0 ) capacitor c=0.0144231f //x=49.7 //y=3.67
c530 ( 22 0 ) capacitor c=0.0280194f //x=49.7 //y=3.35
c531 ( 21 0 ) capacitor c=0.00493552f //x=49.7 //y=2.375
c532 ( 20 0 ) capacitor c=0.0410619f //x=38.23 //y=5.25
c533 ( 19 0 ) capacitor c=0.0133594f //x=38.23 //y=3.655
c534 ( 18 0 ) capacitor c=0.0372096f //x=38.23 //y=3.335
c535 ( 16 0 ) capacitor c=0.0048771f //x=37.83 //y=1.845
c536 ( 15 0 ) capacitor c=0.0132685f //x=38.145 //y=1.845
c537 ( 14 0 ) capacitor c=0.0167992f //x=37.745 //y=1.76
c538 ( 13 0 ) capacitor c=0.0113147f //x=37.745 //y=1.305
c539 ( 11 0 ) capacitor c=0.0205277f //x=38.145 //y=5.335
c540 ( 10 0 ) capacitor c=0.00933983f //x=37.45 //y=5.56
c541 ( 7 0 ) capacitor c=0.0172149f //x=37.335 //y=5.335
c542 ( 5 0 ) capacitor c=0.0148649f //x=36.45 //y=5.335
c543 ( 4 0 ) capacitor c=0.0303408f //x=32.68 //y=4.75
c544 ( 3 0 ) capacitor c=0.0122376f //x=32.68 //y=3.675
c545 ( 2 0 ) capacitor c=0.0217874f //x=32.68 //y=3.355
c546 ( 1 0 ) capacitor c=0.005545f //x=32.68 //y=2.375
r547 (  174 175 ) resistor r=52.7279 //w=0.214 //l=0.165 //layer=ply \
 //thickness=0.18 //x=32.68 //y=2.26 //x2=32.68 //y2=2.095
r548 (  168 170 ) resistor r=26.9307 //w=0.15 //l=0.106066 //layer=ply \
 //thickness=0.18 //x=50.265 //y=4.97 //x2=50.34 //y2=5.045
r549 (  168 169 ) resistor r=148.702 //w=0.094 //l=0.29 //layer=ply \
 //thickness=0.18 //x=50.265 //y=4.97 //x2=49.975 //y2=4.97
r550 (  167 190 ) resistor r=45.1352 //w=0.168 //l=0.173853 //layer=ply \
 //thickness=0.18 //x=49.93 //y=1.4 //x2=49.89 //y2=1.555
r551 (  166 189 ) resistor r=45.1352 //w=0.168 //l=0.173853 //layer=ply \
 //thickness=0.18 //x=49.93 //y=1.055 //x2=49.89 //y2=0.9
r552 (  166 167 ) resistor r=176.904 //w=0.094 //l=0.345 //layer=ply \
 //thickness=0.18 //x=49.93 //y=1.055 //x2=49.93 //y2=1.4
r553 (  163 169 ) resistor r=22.7971 //w=0.269 //l=0.106066 //layer=ply \
 //thickness=0.18 //x=49.9 //y=5.045 //x2=49.975 //y2=4.97
r554 (  163 188 ) resistor r=35.8364 //w=0.269 //l=0.270185 //layer=ply \
 //thickness=0.18 //x=49.9 //y=5.045 //x2=49.7 //y2=4.88
r555 (  161 184 ) resistor r=10.701 //w=0.21 //l=0.115 //layer=ply \
 //thickness=0.18 //x=49.555 //y=1.555 //x2=49.44 //y2=1.555
r556 (  160 190 ) resistor r=5.52526 //w=0.168 //l=0.115 //layer=ply \
 //thickness=0.18 //x=49.775 //y=1.555 //x2=49.89 //y2=1.555
r557 (  159 183 ) resistor r=5.52526 //w=0.168 //l=0.115 //layer=ply \
 //thickness=0.18 //x=49.555 //y=0.9 //x2=49.44 //y2=0.9
r558 (  158 189 ) resistor r=5.52526 //w=0.168 //l=0.115 //layer=ply \
 //thickness=0.18 //x=49.775 //y=0.9 //x2=49.89 //y2=0.9
r559 (  158 159 ) resistor r=112.809 //w=0.094 //l=0.22 //layer=ply \
 //thickness=0.18 //x=49.775 //y=0.9 //x2=49.555 //y2=0.9
r560 (  157 186 ) resistor r=58.7805 //w=0.246 //l=0.373497 //layer=ply \
 //thickness=0.18 //x=49.4 //y=2.095 //x2=49.7 //y2=2.26
r561 (  156 184 ) resistor r=39.5823 //w=0.21 //l=0.173853 //layer=ply \
 //thickness=0.18 //x=49.4 //y=1.71 //x2=49.44 //y2=1.555
r562 (  156 157 ) resistor r=197.415 //w=0.094 //l=0.385 //layer=ply \
 //thickness=0.18 //x=49.4 //y=1.71 //x2=49.4 //y2=2.095
r563 (  155 184 ) resistor r=39.5823 //w=0.21 //l=0.173853 //layer=ply \
 //thickness=0.18 //x=49.4 //y=1.4 //x2=49.44 //y2=1.555
r564 (  154 183 ) resistor r=45.1352 //w=0.168 //l=0.173853 //layer=ply \
 //thickness=0.18 //x=49.4 //y=1.055 //x2=49.44 //y2=0.9
r565 (  154 155 ) resistor r=176.904 //w=0.094 //l=0.345 //layer=ply \
 //thickness=0.18 //x=49.4 //y=1.055 //x2=49.4 //y2=1.4
r566 (  153 182 ) resistor r=45.1352 //w=0.168 //l=0.173853 //layer=ply \
 //thickness=0.18 //x=33.2 //y=1.44 //x2=33.16 //y2=1.595
r567 (  152 181 ) resistor r=45.1352 //w=0.168 //l=0.173853 //layer=ply \
 //thickness=0.18 //x=33.2 //y=1.095 //x2=33.16 //y2=0.94
r568 (  152 153 ) resistor r=176.904 //w=0.094 //l=0.345 //layer=ply \
 //thickness=0.18 //x=33.2 //y=1.095 //x2=33.2 //y2=1.44
r569 (  150 178 ) resistor r=10.701 //w=0.21 //l=0.115 //layer=ply \
 //thickness=0.18 //x=32.825 //y=1.595 //x2=32.71 //y2=1.595
r570 (  149 182 ) resistor r=5.52526 //w=0.168 //l=0.115 //layer=ply \
 //thickness=0.18 //x=33.045 //y=1.595 //x2=33.16 //y2=1.595
r571 (  148 177 ) resistor r=5.52526 //w=0.168 //l=0.115 //layer=ply \
 //thickness=0.18 //x=32.825 //y=0.94 //x2=32.71 //y2=0.94
r572 (  147 181 ) resistor r=5.52526 //w=0.168 //l=0.115 //layer=ply \
 //thickness=0.18 //x=33.045 //y=0.94 //x2=33.16 //y2=0.94
r573 (  147 148 ) resistor r=112.809 //w=0.094 //l=0.22 //layer=ply \
 //thickness=0.18 //x=33.045 //y=0.94 //x2=32.825 //y2=0.94
r574 (  144 180 ) resistor r=37.236 //w=0.233 //l=0.249199 //layer=ply \
 //thickness=0.18 //x=32.86 //y=5.045 //x2=32.68 //y2=4.88
r575 (  142 178 ) resistor r=39.5823 //w=0.21 //l=0.173853 //layer=ply \
 //thickness=0.18 //x=32.67 //y=1.75 //x2=32.71 //y2=1.595
r576 (  142 175 ) resistor r=176.904 //w=0.094 //l=0.345 //layer=ply \
 //thickness=0.18 //x=32.67 //y=1.75 //x2=32.67 //y2=2.095
r577 (  141 178 ) resistor r=39.5823 //w=0.21 //l=0.173853 //layer=ply \
 //thickness=0.18 //x=32.67 //y=1.44 //x2=32.71 //y2=1.595
r578 (  140 177 ) resistor r=45.1352 //w=0.168 //l=0.173853 //layer=ply \
 //thickness=0.18 //x=32.67 //y=1.095 //x2=32.71 //y2=0.94
r579 (  140 141 ) resistor r=176.904 //w=0.094 //l=0.345 //layer=ply \
 //thickness=0.18 //x=32.67 //y=1.095 //x2=32.67 //y2=1.44
r580 (  137 180 ) resistor r=53.7854 //w=0.233 //l=0.332415 //layer=ply \
 //thickness=0.18 //x=32.42 //y=5.045 //x2=32.68 //y2=4.88
r581 (  136 170 ) resistor r=592.245 //w=0.094 //l=1.155 //layer=ply \
 //thickness=0.18 //x=50.34 //y=6.2 //x2=50.34 //y2=5.045
r582 (  135 163 ) resistor r=592.245 //w=0.094 //l=1.155 //layer=ply \
 //thickness=0.18 //x=49.9 //y=6.2 //x2=49.9 //y2=5.045
r583 (  134 144 ) resistor r=592.245 //w=0.094 //l=1.155 //layer=ply \
 //thickness=0.18 //x=32.86 //y=6.2 //x2=32.86 //y2=5.045
r584 (  133 137 ) resistor r=592.245 //w=0.094 //l=1.155 //layer=ply \
 //thickness=0.18 //x=32.42 //y=6.2 //x2=32.42 //y2=5.045
r585 (  132 160 ) resistor r=56.4043 //w=0.094 //l=0.11 //layer=ply \
 //thickness=0.18 //x=49.665 //y=1.555 //x2=49.775 //y2=1.555
r586 (  132 161 ) resistor r=56.4043 //w=0.094 //l=0.11 //layer=ply \
 //thickness=0.18 //x=49.665 //y=1.555 //x2=49.555 //y2=1.555
r587 (  131 149 ) resistor r=56.4043 //w=0.094 //l=0.11 //layer=ply \
 //thickness=0.18 //x=32.935 //y=1.595 //x2=33.045 //y2=1.595
r588 (  131 150 ) resistor r=56.4043 //w=0.094 //l=0.11 //layer=ply \
 //thickness=0.18 //x=32.935 //y=1.595 //x2=32.825 //y2=1.595
r589 (  127 188 ) resistor r=152 //w=0.17 //l=0.17 //layer=licon //count=1 \
 //x=49.7 //y=4.88 //x2=49.7 //y2=4.88
r590 (  118 186 ) resistor r=152 //w=0.17 //l=0.17 //layer=licon //count=1 \
 //x=49.7 //y=2.26 //x2=49.7 //y2=2.26
r591 (  101 195 ) resistor r=23.615 //w=0.187 //l=0.345 //layer=li \
 //thickness=0.1 //x=37.45 //y=5.56 //x2=37.45 //y2=5.905
r592 (  93 194 ) resistor r=23.615 //w=0.187 //l=0.345 //layer=li \
 //thickness=0.1 //x=36.57 //y=5.56 //x2=36.57 //y2=5.905
r593 (  85 193 ) resistor r=23.615 //w=0.187 //l=0.345 //layer=li \
 //thickness=0.1 //x=35.69 //y=5.56 //x2=35.69 //y2=5.905
r594 (  80 180 ) resistor r=152 //w=0.17 //l=0.17 //layer=licon //count=1 \
 //x=32.68 //y=4.88 //x2=32.68 //y2=4.88
r595 (  71 174 ) resistor r=152 //w=0.17 //l=0.17 //layer=licon //count=1 \
 //x=32.68 //y=2.26 //x2=32.68 //y2=2.26
r596 (  64 66 ) resistor r=0.10734 //w=0.281 //l=0.16 //layer=m2 \
 //thickness=0.36 //x=38.23 //y=3.495 //x2=38.39 //y2=3.495
r597 (  64 65 ) resistor r=0.10734 //w=0.281 //l=0.16 //layer=m2 \
 //thickness=0.36 //x=38.23 //y=3.495 //x2=38.07 //y2=3.495
r598 (  62 65 ) resistor r=4.98092 //w=0.131 //l=5.22 //layer=m2 \
 //thickness=0.36 //x=32.85 //y=3.51 //x2=38.07 //y2=3.51
r599 (  60 62 ) resistor r=0.10734 //w=0.281 //l=0.16 //layer=m2 \
 //thickness=0.36 //x=32.69 //y=3.515 //x2=32.85 //y2=3.515
r600 (  57 68 ) resistor r=0.10734 //w=0.281 //l=0.16 //layer=m2 \
 //thickness=0.36 //x=49.535 //y=3.51 //x2=49.695 //y2=3.51
r601 (  57 66 ) resistor r=10.6345 //w=0.131 //l=11.145 //layer=m2 \
 //thickness=0.36 //x=49.535 //y=3.51 //x2=38.39 //y2=3.51
r602 (  54 127 ) resistor r=9.3 //w=0.17 //l=0.17 //layer=mcon //count=1 \
 //x=49.7 //y=4.88 //x2=49.7 //y2=4.88
r603 (  52 118 ) resistor r=9.3 //w=0.17 //l=0.17 //layer=mcon //count=1 \
 //x=49.7 //y=2.26 //x2=49.7 //y2=2.26
r604 (  49 68 ) resistor r=4.5 //w=0.15 //l=0.15 //layer=via1 //count=1 \
 //x=49.695 //y=3.51 //x2=49.695 //y2=3.51
r605 (  45 64 ) resistor r=4.5 //w=0.15 //l=0.15 //layer=via1 //count=1 \
 //x=38.23 //y=3.495 //x2=38.23 //y2=3.495
r606 (  45 47 ) resistor r=0.0049867 //w=0.376 //l=0.015 //layer=m1 \
 //thickness=0.36 //x=38.282 //y=3.495 //x2=38.282 //y2=3.51
r607 (  43 191 ) resistor r=9.3 //w=0.17 //l=0.17 //layer=mcon //count=1 \
 //x=37.745 //y=1.19 //x2=37.745 //y2=1.19
r608 (  41 101 ) resistor r=9.3 //w=0.17 //l=0.17 //layer=mcon //count=1 \
 //x=37.45 //y=5.56 //x2=37.45 //y2=5.56
r609 (  38 93 ) resistor r=9.3 //w=0.17 //l=0.17 //layer=mcon //count=1 \
 //x=36.57 //y=5.56 //x2=36.57 //y2=5.56
r610 (  36 38 ) resistor r=0.121228 //w=0.232 //l=0.225 //layer=m1 \
 //thickness=0.36 //x=36.57 //y=5.335 //x2=36.57 //y2=5.56
r611 (  35 85 ) resistor r=9.3 //w=0.17 //l=0.17 //layer=mcon //count=1 \
 //x=35.69 //y=5.56 //x2=35.69 //y2=5.56
r612 (  33 35 ) resistor r=0.129608 //w=0.217 //l=0.225 //layer=m1 \
 //thickness=0.36 //x=35.692 //y=5.335 //x2=35.692 //y2=5.56
r613 (  32 60 ) resistor r=4.5 //w=0.15 //l=0.15 //layer=via1 //count=1 \
 //x=32.69 //y=3.515 //x2=32.69 //y2=3.515
r614 (  30 32 ) resistor r=0.00168464 //w=0.371 //l=0.005 //layer=m1 \
 //thickness=0.36 //x=32.737 //y=3.51 //x2=32.737 //y2=3.515
r615 (  28 80 ) resistor r=9.3 //w=0.17 //l=0.17 //layer=mcon //count=1 \
 //x=32.68 //y=4.88 //x2=32.68 //y2=4.88
r616 (  26 71 ) resistor r=9.3 //w=0.17 //l=0.17 //layer=mcon //count=1 \
 //x=32.68 //y=2.26 //x2=32.68 //y2=2.26
r617 (  24 54 ) resistor r=0.0760407 //w=0.238 //l=0.125 //layer=m1 \
 //thickness=0.36 //x=49.7 //y=4.755 //x2=49.7 //y2=4.88
r618 (  23 49 ) resistor r=0.0910802 //w=0.374 //l=0.185472 //layer=m1 \
 //thickness=0.36 //x=49.7 //y=3.67 //x2=49.645 //y2=3.51
r619 (  23 24 ) resistor r=1.03531 //w=0.131 //l=1.085 //layer=m1 \
 //thickness=0.36 //x=49.7 //y=3.67 //x2=49.7 //y2=4.755
r620 (  22 49 ) resistor r=0.0910802 //w=0.374 //l=0.185472 //layer=m1 \
 //thickness=0.36 //x=49.7 //y=3.35 //x2=49.645 //y2=3.51
r621 (  21 52 ) resistor r=0.0719237 //w=0.222 //l=0.115 //layer=m1 \
 //thickness=0.36 //x=49.7 //y=2.375 //x2=49.7 //y2=2.26
r622 (  21 22 ) resistor r=0.930344 //w=0.131 //l=0.975 //layer=m1 \
 //thickness=0.36 //x=49.7 //y=2.375 //x2=49.7 //y2=3.35
r623 (  19 47 ) resistor r=0.0861726 //w=0.376 //l=0.169012 //layer=m1 \
 //thickness=0.36 //x=38.23 //y=3.655 //x2=38.282 //y2=3.51
r624 (  19 20 ) resistor r=1.52195 //w=0.131 //l=1.595 //layer=m1 \
 //thickness=0.36 //x=38.23 //y=3.655 //x2=38.23 //y2=5.25
r625 (  18 45 ) resistor r=0.0911593 //w=0.376 //l=0.184174 //layer=m1 \
 //thickness=0.36 //x=38.23 //y=3.335 //x2=38.282 //y2=3.495
r626 (  17 18 ) resistor r=1.34065 //w=0.131 //l=1.405 //layer=m1 \
 //thickness=0.36 //x=38.23 //y=1.93 //x2=38.23 //y2=3.335
r627 (  15 17 ) resistor r=0.0698411 //w=0.17 //l=0.120208 //layer=m1 \
 //thickness=0.36 //x=38.145 //y=1.845 //x2=38.23 //y2=1.93
r628 (  15 16 ) resistor r=0.300573 //w=0.131 //l=0.315 //layer=m1 \
 //thickness=0.36 //x=38.145 //y=1.845 //x2=37.83 //y2=1.845
r629 (  14 16 ) resistor r=0.0698411 //w=0.17 //l=0.120208 //layer=m1 \
 //thickness=0.36 //x=37.745 //y=1.76 //x2=37.83 //y2=1.845
r630 (  13 43 ) resistor r=0.0717383 //w=0.224 //l=0.115 //layer=m1 \
 //thickness=0.36 //x=37.745 //y=1.305 //x2=37.745 //y2=1.19
r631 (  13 14 ) resistor r=0.43416 //w=0.131 //l=0.455 //layer=m1 \
 //thickness=0.36 //x=37.745 //y=1.305 //x2=37.745 //y2=1.76
r632 (  12 39 ) resistor r=0.0675342 //w=0.23 //l=0.115 //layer=m1 \
 //thickness=0.36 //x=37.565 //y=5.335 //x2=37.45 //y2=5.335
r633 (  11 20 ) resistor r=0.0698411 //w=0.17 //l=0.120208 //layer=m1 \
 //thickness=0.36 //x=38.145 //y=5.335 //x2=38.23 //y2=5.25
r634 (  11 12 ) resistor r=0.553435 //w=0.131 //l=0.58 //layer=m1 \
 //thickness=0.36 //x=38.145 //y=5.335 //x2=37.565 //y2=5.335
r635 (  10 41 ) resistor r=0.00118313 //w=0.23 //layer=m1 //thickness=0.36 \
 //x=37.45 //y=5.56 //x2=37.45 //y2=5.56
r636 (  9 39 ) resistor r=0.002872 //w=0.34 //l=0.085 //layer=m1 \
 //thickness=0.36 //x=37.45 //y=5.42 //x2=37.45 //y2=5.335
r637 (  9 10 ) resistor r=0.091623 //w=0.191 //l=0.14 //layer=m1 \
 //thickness=0.36 //x=37.45 //y=5.42 //x2=37.45 //y2=5.56
r638 (  8 36 ) resistor r=0.0262263 //w=0.232 //l=0.12 //layer=m1 \
 //thickness=0.36 //x=36.69 //y=5.335 //x2=36.57 //y2=5.335
r639 (  7 39 ) resistor r=0.0675342 //w=0.23 //l=0.115 //layer=m1 \
 //thickness=0.36 //x=37.335 //y=5.335 //x2=37.45 //y2=5.335
r640 (  7 8 ) resistor r=0.615458 //w=0.131 //l=0.645 //layer=m1 \
 //thickness=0.36 //x=37.335 //y=5.335 //x2=36.69 //y2=5.335
r641 (  6 33 ) resistor r=0.0222262 //w=0.217 //l=0.118 //layer=m1 \
 //thickness=0.36 //x=35.81 //y=5.335 //x2=35.692 //y2=5.335
r642 (  5 36 ) resistor r=0.0262263 //w=0.232 //l=0.12 //layer=m1 \
 //thickness=0.36 //x=36.45 //y=5.335 //x2=36.57 //y2=5.335
r643 (  5 6 ) resistor r=0.610687 //w=0.131 //l=0.64 //layer=m1 \
 //thickness=0.36 //x=36.45 //y=5.335 //x2=35.81 //y2=5.335
r644 (  4 28 ) resistor r=0.0801089 //w=0.224 //l=0.13 //layer=m1 \
 //thickness=0.36 //x=32.68 //y=4.75 //x2=32.68 //y2=4.88
r645 (  3 32 ) resistor r=0.0909648 //w=0.371 //l=0.186333 //layer=m1 \
 //thickness=0.36 //x=32.68 //y=3.675 //x2=32.737 //y2=3.515
r646 (  3 4 ) resistor r=1.02576 //w=0.131 //l=1.075 //layer=m1 \
 //thickness=0.36 //x=32.68 //y=3.675 //x2=32.68 //y2=4.75
r647 (  2 30 ) resistor r=0.0892801 //w=0.371 //l=0.181273 //layer=m1 \
 //thickness=0.36 //x=32.68 //y=3.355 //x2=32.737 //y2=3.51
r648 (  1 26 ) resistor r=0.0719237 //w=0.222 //l=0.115 //layer=m1 \
 //thickness=0.36 //x=32.68 //y=2.375 //x2=32.68 //y2=2.26
r649 (  1 2 ) resistor r=0.935115 //w=0.131 //l=0.98 //layer=m1 \
 //thickness=0.36 //x=32.68 //y=2.375 //x2=32.68 //y2=3.355
ends PM_TMRDFFSNRNQX1\%noxref_9

subckt PM_TMRDFFSNRNQX1\%noxref_10 ( 1 3 6 7 9 10 11 12 14 15 16 17 18 19 20 \
 21 24 27 35 43 49 51 52 55 63 71 88 97 101 102 103 104 105 106 107 108 110 \
 116 117 118 119 131 133 134 135 )
c299 ( 131 0 ) capacitor c=0.00885916f //x=51.985 //y=1.095
c300 ( 119 0 ) capacitor c=0.0612936f //x=54.785 //y=4.97
c301 ( 118 0 ) capacitor c=0.0376642f //x=55.075 //y=4.97
c302 ( 117 0 ) capacitor c=0.0346489f //x=54.74 //y=1.4
c303 ( 116 0 ) capacitor c=0.018692f //x=54.74 //y=1.055
c304 ( 110 0 ) capacitor c=0.0137077f //x=54.585 //y=1.555
c305 ( 108 0 ) capacitor c=0.0158585f //x=54.585 //y=0.9
c306 ( 107 0 ) capacitor c=0.097937f //x=54.21 //y=2.095
c307 ( 106 0 ) capacitor c=0.0229364f //x=54.21 //y=1.71
c308 ( 105 0 ) capacitor c=0.0234359f //x=54.21 //y=1.4
c309 ( 104 0 ) capacitor c=0.019815f //x=54.21 //y=1.055
c310 ( 103 0 ) capacitor c=0.110208f //x=55.15 //y=6.2
c311 ( 102 0 ) capacitor c=0.158957f //x=54.71 //y=6.2
c312 ( 97 0 ) capacitor c=0.00159026f //x=54.51 //y=4.88
c313 ( 88 0 ) capacitor c=9.93222e-19 //x=54.51 //y=2.26
c314 ( 71 0 ) capacitor c=0.0293555f //x=51.88 //y=5.56
c315 ( 63 0 ) capacitor c=0.029137f //x=51 //y=5.56
c316 ( 55 0 ) capacitor c=0.0278099f //x=50.12 //y=5.56
c317 ( 52 0 ) capacitor c=0.0150338f //x=54.305 //y=2.755
c318 ( 51 0 ) capacitor c=0.00484623f //x=54.465 //y=2.755
c319 ( 49 0 ) capacitor c=0.00533437f //x=52.865 //y=2.755
c320 ( 43 0 ) capacitor c=0.0148553f //x=54.51 //y=2.77
c321 ( 35 0 ) capacitor c=0.0144499f //x=52.66 //y=2.77
c322 ( 27 0 ) capacitor c=9.12964e-19 //x=51.88 //y=5.335
c323 ( 24 0 ) capacitor c=0.00762667f //x=51 //y=5.335
c324 ( 21 0 ) capacitor c=0.0109203f //x=50.122 //y=5.335
c325 ( 20 0 ) capacitor c=0.0579757f //x=54.51 //y=4.755
c326 ( 19 0 ) capacitor c=0.0139549f //x=54.51 //y=2.915
c327 ( 18 0 ) capacitor c=0.00427649f //x=54.51 //y=2.595
c328 ( 17 0 ) capacitor c=0.00437465f //x=54.51 //y=2.375
c329 ( 16 0 ) capacitor c=0.0654285f //x=52.66 //y=5.25
c330 ( 15 0 ) capacitor c=0.0129881f //x=52.66 //y=2.915
c331 ( 14 0 ) capacitor c=0.017505f //x=52.66 //y=2.595
c332 ( 12 0 ) capacitor c=0.0047266f //x=52.26 //y=1.845
c333 ( 11 0 ) capacitor c=0.012967f //x=52.575 //y=1.845
c334 ( 10 0 ) capacitor c=0.0167992f //x=52.175 //y=1.76
c335 ( 9 0 ) capacitor c=0.0110975f //x=52.175 //y=1.305
c336 ( 7 0 ) capacitor c=0.0207192f //x=52.575 //y=5.335
c337 ( 6 0 ) capacitor c=0.00933983f //x=51.88 //y=5.56
c338 ( 3 0 ) capacitor c=0.0190581f //x=51.765 //y=5.335
c339 ( 1 0 ) capacitor c=0.0149131f //x=50.88 //y=5.335
r340 (  118 120 ) resistor r=26.9307 //w=0.15 //l=0.106066 //layer=ply \
 //thickness=0.18 //x=55.075 //y=4.97 //x2=55.15 //y2=5.045
r341 (  118 119 ) resistor r=148.702 //w=0.094 //l=0.29 //layer=ply \
 //thickness=0.18 //x=55.075 //y=4.97 //x2=54.785 //y2=4.97
r342 (  117 130 ) resistor r=45.1352 //w=0.168 //l=0.173853 //layer=ply \
 //thickness=0.18 //x=54.74 //y=1.4 //x2=54.7 //y2=1.555
r343 (  116 129 ) resistor r=45.1352 //w=0.168 //l=0.173853 //layer=ply \
 //thickness=0.18 //x=54.74 //y=1.055 //x2=54.7 //y2=0.9
r344 (  116 117 ) resistor r=176.904 //w=0.094 //l=0.345 //layer=ply \
 //thickness=0.18 //x=54.74 //y=1.055 //x2=54.74 //y2=1.4
r345 (  113 119 ) resistor r=22.7971 //w=0.269 //l=0.106066 //layer=ply \
 //thickness=0.18 //x=54.71 //y=5.045 //x2=54.785 //y2=4.97
r346 (  113 128 ) resistor r=35.8364 //w=0.269 //l=0.270185 //layer=ply \
 //thickness=0.18 //x=54.71 //y=5.045 //x2=54.51 //y2=4.88
r347 (  111 124 ) resistor r=10.701 //w=0.21 //l=0.115 //layer=ply \
 //thickness=0.18 //x=54.365 //y=1.555 //x2=54.25 //y2=1.555
r348 (  110 130 ) resistor r=5.52526 //w=0.168 //l=0.115 //layer=ply \
 //thickness=0.18 //x=54.585 //y=1.555 //x2=54.7 //y2=1.555
r349 (  109 123 ) resistor r=5.52526 //w=0.168 //l=0.115 //layer=ply \
 //thickness=0.18 //x=54.365 //y=0.9 //x2=54.25 //y2=0.9
r350 (  108 129 ) resistor r=5.52526 //w=0.168 //l=0.115 //layer=ply \
 //thickness=0.18 //x=54.585 //y=0.9 //x2=54.7 //y2=0.9
r351 (  108 109 ) resistor r=112.809 //w=0.094 //l=0.22 //layer=ply \
 //thickness=0.18 //x=54.585 //y=0.9 //x2=54.365 //y2=0.9
r352 (  107 126 ) resistor r=58.7805 //w=0.246 //l=0.373497 //layer=ply \
 //thickness=0.18 //x=54.21 //y=2.095 //x2=54.51 //y2=2.26
r353 (  106 124 ) resistor r=39.5823 //w=0.21 //l=0.173853 //layer=ply \
 //thickness=0.18 //x=54.21 //y=1.71 //x2=54.25 //y2=1.555
r354 (  106 107 ) resistor r=197.415 //w=0.094 //l=0.385 //layer=ply \
 //thickness=0.18 //x=54.21 //y=1.71 //x2=54.21 //y2=2.095
r355 (  105 124 ) resistor r=39.5823 //w=0.21 //l=0.173853 //layer=ply \
 //thickness=0.18 //x=54.21 //y=1.4 //x2=54.25 //y2=1.555
r356 (  104 123 ) resistor r=45.1352 //w=0.168 //l=0.173853 //layer=ply \
 //thickness=0.18 //x=54.21 //y=1.055 //x2=54.25 //y2=0.9
r357 (  104 105 ) resistor r=176.904 //w=0.094 //l=0.345 //layer=ply \
 //thickness=0.18 //x=54.21 //y=1.055 //x2=54.21 //y2=1.4
r358 (  103 120 ) resistor r=592.245 //w=0.094 //l=1.155 //layer=ply \
 //thickness=0.18 //x=55.15 //y=6.2 //x2=55.15 //y2=5.045
r359 (  102 113 ) resistor r=592.245 //w=0.094 //l=1.155 //layer=ply \
 //thickness=0.18 //x=54.71 //y=6.2 //x2=54.71 //y2=5.045
r360 (  101 110 ) resistor r=56.4043 //w=0.094 //l=0.11 //layer=ply \
 //thickness=0.18 //x=54.475 //y=1.555 //x2=54.585 //y2=1.555
r361 (  101 111 ) resistor r=56.4043 //w=0.094 //l=0.11 //layer=ply \
 //thickness=0.18 //x=54.475 //y=1.555 //x2=54.365 //y2=1.555
r362 (  97 128 ) resistor r=152 //w=0.17 //l=0.17 //layer=licon //count=1 \
 //x=54.51 //y=4.88 //x2=54.51 //y2=4.88
r363 (  88 126 ) resistor r=152 //w=0.17 //l=0.17 //layer=licon //count=1 \
 //x=54.51 //y=2.26 //x2=54.51 //y2=2.26
r364 (  71 135 ) resistor r=23.615 //w=0.187 //l=0.345 //layer=li \
 //thickness=0.1 //x=51.88 //y=5.56 //x2=51.88 //y2=5.905
r365 (  63 134 ) resistor r=23.615 //w=0.187 //l=0.345 //layer=li \
 //thickness=0.1 //x=51 //y=5.56 //x2=51 //y2=5.905
r366 (  55 133 ) resistor r=23.615 //w=0.187 //l=0.345 //layer=li \
 //thickness=0.1 //x=50.12 //y=5.56 //x2=50.12 //y2=5.905
r367 (  51 52 ) resistor r=0.10734 //w=0.281 //l=0.16 //layer=m2 \
 //thickness=0.36 //x=54.465 //y=2.755 //x2=54.305 //y2=2.755
r368 (  49 52 ) resistor r=1.37405 //w=0.131 //l=1.44 //layer=m2 \
 //thickness=0.36 //x=52.865 //y=2.77 //x2=54.305 //y2=2.77
r369 (  47 49 ) resistor r=0.10734 //w=0.281 //l=0.16 //layer=m2 \
 //thickness=0.36 //x=52.705 //y=2.755 //x2=52.865 //y2=2.755
r370 (  41 51 ) resistor r=4.5 //w=0.15 //l=0.15 //layer=via1 //count=1 \
 //x=54.465 //y=2.755 //x2=54.465 //y2=2.755
r371 (  41 43 ) resistor r=0.00509511 //w=0.368 //l=0.015 //layer=m1 \
 //thickness=0.36 //x=54.45 //y=2.755 //x2=54.45 //y2=2.77
r372 (  39 97 ) resistor r=9.3 //w=0.17 //l=0.17 //layer=mcon //count=1 \
 //x=54.51 //y=4.88 //x2=54.51 //y2=4.88
r373 (  37 88 ) resistor r=9.3 //w=0.17 //l=0.17 //layer=mcon //count=1 \
 //x=54.51 //y=2.26 //x2=54.51 //y2=2.26
r374 (  33 47 ) resistor r=4.5 //w=0.15 //l=0.15 //layer=via1 //count=1 \
 //x=52.705 //y=2.755 //x2=52.705 //y2=2.755
r375 (  33 35 ) resistor r=0.00509511 //w=0.368 //l=0.015 //layer=m1 \
 //thickness=0.36 //x=52.72 //y=2.755 //x2=52.72 //y2=2.77
r376 (  31 131 ) resistor r=9.3 //w=0.17 //l=0.17 //layer=mcon //count=1 \
 //x=52.175 //y=1.19 //x2=52.175 //y2=1.19
r377 (  29 71 ) resistor r=9.3 //w=0.17 //l=0.17 //layer=mcon //count=1 \
 //x=51.88 //y=5.56 //x2=51.88 //y2=5.56
r378 (  26 63 ) resistor r=9.3 //w=0.17 //l=0.17 //layer=mcon //count=1 //x=51 \
 //y=5.56 //x2=51 //y2=5.56
r379 (  24 26 ) resistor r=0.121228 //w=0.232 //l=0.225 //layer=m1 \
 //thickness=0.36 //x=51 //y=5.335 //x2=51 //y2=5.56
r380 (  23 55 ) resistor r=9.3 //w=0.17 //l=0.17 //layer=mcon //count=1 \
 //x=50.12 //y=5.56 //x2=50.12 //y2=5.56
r381 (  21 23 ) resistor r=0.129608 //w=0.217 //l=0.225 //layer=m1 \
 //thickness=0.36 //x=50.122 //y=5.335 //x2=50.122 //y2=5.56
r382 (  20 39 ) resistor r=0.0760407 //w=0.238 //l=0.125 //layer=m1 \
 //thickness=0.36 //x=54.51 //y=4.755 //x2=54.51 //y2=4.88
r383 (  19 43 ) resistor r=0.0857585 //w=0.368 //l=0.172409 //layer=m1 \
 //thickness=0.36 //x=54.51 //y=2.915 //x2=54.45 //y2=2.77
r384 (  19 20 ) resistor r=1.75573 //w=0.131 //l=1.84 //layer=m1 \
 //thickness=0.36 //x=54.51 //y=2.915 //x2=54.51 //y2=4.755
r385 (  18 41 ) resistor r=0.0908536 //w=0.368 //l=0.187617 //layer=m1 \
 //thickness=0.36 //x=54.51 //y=2.595 //x2=54.45 //y2=2.755
r386 (  17 37 ) resistor r=0.0719237 //w=0.222 //l=0.115 //layer=m1 \
 //thickness=0.36 //x=54.51 //y=2.375 //x2=54.51 //y2=2.26
r387 (  17 18 ) resistor r=0.209924 //w=0.131 //l=0.22 //layer=m1 \
 //thickness=0.36 //x=54.51 //y=2.375 //x2=54.51 //y2=2.595
r388 (  15 35 ) resistor r=0.0857585 //w=0.368 //l=0.172409 //layer=m1 \
 //thickness=0.36 //x=52.66 //y=2.915 //x2=52.72 //y2=2.77
r389 (  15 16 ) resistor r=2.22805 //w=0.131 //l=2.335 //layer=m1 \
 //thickness=0.36 //x=52.66 //y=2.915 //x2=52.66 //y2=5.25
r390 (  14 33 ) resistor r=0.0908536 //w=0.368 //l=0.187617 //layer=m1 \
 //thickness=0.36 //x=52.66 //y=2.595 //x2=52.72 //y2=2.755
r391 (  13 14 ) resistor r=0.634542 //w=0.131 //l=0.665 //layer=m1 \
 //thickness=0.36 //x=52.66 //y=1.93 //x2=52.66 //y2=2.595
r392 (  11 13 ) resistor r=0.0698411 //w=0.17 //l=0.120208 //layer=m1 \
 //thickness=0.36 //x=52.575 //y=1.845 //x2=52.66 //y2=1.93
r393 (  11 12 ) resistor r=0.300573 //w=0.131 //l=0.315 //layer=m1 \
 //thickness=0.36 //x=52.575 //y=1.845 //x2=52.26 //y2=1.845
r394 (  10 12 ) resistor r=0.0698411 //w=0.17 //l=0.120208 //layer=m1 \
 //thickness=0.36 //x=52.175 //y=1.76 //x2=52.26 //y2=1.845
r395 (  9 31 ) resistor r=0.0717383 //w=0.224 //l=0.115 //layer=m1 \
 //thickness=0.36 //x=52.175 //y=1.305 //x2=52.175 //y2=1.19
r396 (  9 10 ) resistor r=0.43416 //w=0.131 //l=0.455 //layer=m1 \
 //thickness=0.36 //x=52.175 //y=1.305 //x2=52.175 //y2=1.76
r397 (  8 27 ) resistor r=0.0675342 //w=0.23 //l=0.115 //layer=m1 \
 //thickness=0.36 //x=51.995 //y=5.335 //x2=51.88 //y2=5.335
r398 (  7 16 ) resistor r=0.0698411 //w=0.17 //l=0.120208 //layer=m1 \
 //thickness=0.36 //x=52.575 //y=5.335 //x2=52.66 //y2=5.25
r399 (  7 8 ) resistor r=0.553435 //w=0.131 //l=0.58 //layer=m1 \
 //thickness=0.36 //x=52.575 //y=5.335 //x2=51.995 //y2=5.335
r400 (  6 29 ) resistor r=0.00118313 //w=0.23 //layer=m1 //thickness=0.36 \
 //x=51.88 //y=5.56 //x2=51.88 //y2=5.56
r401 (  5 27 ) resistor r=0.002872 //w=0.34 //l=0.085 //layer=m1 \
 //thickness=0.36 //x=51.88 //y=5.42 //x2=51.88 //y2=5.335
r402 (  5 6 ) resistor r=0.091623 //w=0.191 //l=0.14 //layer=m1 \
 //thickness=0.36 //x=51.88 //y=5.42 //x2=51.88 //y2=5.56
r403 (  4 24 ) resistor r=0.0262263 //w=0.232 //l=0.12 //layer=m1 \
 //thickness=0.36 //x=51.12 //y=5.335 //x2=51 //y2=5.335
r404 (  3 27 ) resistor r=0.0675342 //w=0.23 //l=0.115 //layer=m1 \
 //thickness=0.36 //x=51.765 //y=5.335 //x2=51.88 //y2=5.335
r405 (  3 4 ) resistor r=0.615458 //w=0.131 //l=0.645 //layer=m1 \
 //thickness=0.36 //x=51.765 //y=5.335 //x2=51.12 //y2=5.335
r406 (  2 21 ) resistor r=0.0222262 //w=0.217 //l=0.118 //layer=m1 \
 //thickness=0.36 //x=50.24 //y=5.335 //x2=50.122 //y2=5.335
r407 (  1 24 ) resistor r=0.0262263 //w=0.232 //l=0.12 //layer=m1 \
 //thickness=0.36 //x=50.88 //y=5.335 //x2=51 //y2=5.335
r408 (  1 2 ) resistor r=0.610687 //w=0.131 //l=0.64 //layer=m1 \
 //thickness=0.36 //x=50.88 //y=5.335 //x2=50.24 //y2=5.335
ends PM_TMRDFFSNRNQX1\%noxref_10

subckt PM_TMRDFFSNRNQX1\%noxref_11 ( 1 2 3 4 5 6 7 8 9 11 14 15 17 18 19 20 22 \
 23 24 25 26 27 28 34 38 45 48 51 57 61 70 72 73 77 80 81 87 96 101 110 115 \
 123 131 148 157 161 162 163 164 165 166 167 168 169 173 174 175 180 182 185 \
 186 190 191 192 197 199 202 203 207 208 209 214 216 219 220 222 223 228 232 \
 233 238 242 243 248 251 253 254 255 )
c611 ( 251 0 ) capacitor c=0.00885916f //x=47.175 //y=1.095
c612 ( 248 0 ) capacitor c=0.0651477f //x=56.73 //y=4.88
c613 ( 243 0 ) capacitor c=0.0278202f //x=56.73 //y=2.095
c614 ( 242 0 ) capacitor c=0.0503043f //x=56.73 //y=2.26
c615 ( 238 0 ) capacitor c=0.0651406f //x=42.3 //y=4.88
c616 ( 233 0 ) capacitor c=0.0278202f //x=42.3 //y=2.095
c617 ( 232 0 ) capacitor c=0.0503043f //x=42.3 //y=2.26
c618 ( 228 0 ) capacitor c=0.0653609f //x=37.49 //y=4.88
c619 ( 223 0 ) capacitor c=0.0278202f //x=37.49 //y=2.095
c620 ( 222 0 ) capacitor c=0.0503043f //x=37.49 //y=2.26
c621 ( 220 0 ) capacitor c=0.0443175f //x=57.25 //y=1.44
c622 ( 219 0 ) capacitor c=0.0199703f //x=57.25 //y=1.095
c623 ( 216 0 ) capacitor c=0.0162526f //x=57.095 //y=1.595
c624 ( 214 0 ) capacitor c=0.0157807f //x=57.095 //y=0.94
c625 ( 209 0 ) capacitor c=0.0220935f //x=56.72 //y=1.75
c626 ( 208 0 ) capacitor c=0.0207489f //x=56.72 //y=1.44
c627 ( 207 0 ) capacitor c=0.0194091f //x=56.72 //y=1.095
c628 ( 203 0 ) capacitor c=0.0443175f //x=42.82 //y=1.44
c629 ( 202 0 ) capacitor c=0.0199703f //x=42.82 //y=1.095
c630 ( 199 0 ) capacitor c=0.0162526f //x=42.665 //y=1.595
c631 ( 197 0 ) capacitor c=0.0157807f //x=42.665 //y=0.94
c632 ( 192 0 ) capacitor c=0.0220935f //x=42.29 //y=1.75
c633 ( 191 0 ) capacitor c=0.0207489f //x=42.29 //y=1.44
c634 ( 190 0 ) capacitor c=0.0194091f //x=42.29 //y=1.095
c635 ( 186 0 ) capacitor c=0.0443175f //x=38.01 //y=1.44
c636 ( 185 0 ) capacitor c=0.0199703f //x=38.01 //y=1.095
c637 ( 182 0 ) capacitor c=0.0162526f //x=37.855 //y=1.595
c638 ( 180 0 ) capacitor c=0.0157807f //x=37.855 //y=0.94
c639 ( 175 0 ) capacitor c=0.0220935f //x=37.48 //y=1.75
c640 ( 174 0 ) capacitor c=0.0207489f //x=37.48 //y=1.44
c641 ( 173 0 ) capacitor c=0.0194091f //x=37.48 //y=1.095
c642 ( 169 0 ) capacitor c=0.159671f //x=56.91 //y=6.2
c643 ( 168 0 ) capacitor c=0.110208f //x=56.47 //y=6.2
c644 ( 167 0 ) capacitor c=0.159671f //x=42.48 //y=6.2
c645 ( 166 0 ) capacitor c=0.110208f //x=42.04 //y=6.2
c646 ( 165 0 ) capacitor c=0.159671f //x=37.67 //y=6.2
c647 ( 164 0 ) capacitor c=0.110208f //x=37.23 //y=6.2
c648 ( 157 0 ) capacitor c=9.5006e-19 //x=56.73 //y=4.88
c649 ( 148 0 ) capacitor c=0.00101179f //x=56.73 //y=2.26
c650 ( 131 0 ) capacitor c=0.0293124f //x=47.07 //y=5.56
c651 ( 123 0 ) capacitor c=0.029137f //x=46.19 //y=5.56
c652 ( 115 0 ) capacitor c=0.0278099f //x=45.31 //y=5.56
c653 ( 110 0 ) capacitor c=9.5006e-19 //x=42.3 //y=4.88
c654 ( 101 0 ) capacitor c=0.00101179f //x=42.3 //y=2.26
c655 ( 96 0 ) capacitor c=9.16663e-19 //x=37.49 //y=4.88
c656 ( 87 0 ) capacitor c=0.00101179f //x=37.49 //y=2.26
c657 ( 81 0 ) capacitor c=3.98458e-19 //x=42.46 //y=3.895
c658 ( 80 0 ) capacitor c=0.0441962f //x=42.14 //y=3.895
c659 ( 77 0 ) capacitor c=3.98458e-19 //x=37.65 //y=3.895
c660 ( 73 0 ) capacitor c=0.0212158f //x=49.565 //y=3.895
c661 ( 72 0 ) capacitor c=0.0711918f //x=49.91 //y=3.895
c662 ( 70 0 ) capacitor c=0.0531395f //x=47.68 //y=3.88
c663 ( 61 0 ) capacitor c=0.0149589f //x=56.73 //y=3.88
c664 ( 57 0 ) capacitor c=0.0158949f //x=47.85 //y=3.88
c665 ( 51 0 ) capacitor c=0.00105955f //x=47.07 //y=5.335
c666 ( 48 0 ) capacitor c=0.00737416f //x=46.19 //y=5.335
c667 ( 45 0 ) capacitor c=0.0119858f //x=45.312 //y=5.335
c668 ( 38 0 ) capacitor c=0.0149589f //x=42.3 //y=3.88
c669 ( 34 0 ) capacitor c=0.0149589f //x=37.49 //y=3.88
c670 ( 28 0 ) capacitor c=0.01807f //x=56.73 //y=4.75
c671 ( 27 0 ) capacitor c=0.013506f //x=56.73 //y=4.045
c672 ( 26 0 ) capacitor c=0.0289311f //x=56.73 //y=3.725
c673 ( 25 0 ) capacitor c=0.00556102f //x=56.73 //y=2.375
c674 ( 24 0 ) capacitor c=0.0306735f //x=47.85 //y=5.25
c675 ( 23 0 ) capacitor c=0.0138897f //x=47.85 //y=4.055
c676 ( 22 0 ) capacitor c=0.0490588f //x=47.85 //y=3.735
c677 ( 20 0 ) capacitor c=0.00493487f //x=47.45 //y=1.845
c678 ( 19 0 ) capacitor c=0.0133342f //x=47.765 //y=1.845
c679 ( 18 0 ) capacitor c=0.0167992f //x=47.365 //y=1.76
c680 ( 17 0 ) capacitor c=0.0111491f //x=47.365 //y=1.305
c681 ( 15 0 ) capacitor c=0.0215649f //x=47.765 //y=5.335
c682 ( 14 0 ) capacitor c=0.00933983f //x=47.07 //y=5.56
c683 ( 11 0 ) capacitor c=0.0187547f //x=46.955 //y=5.335
c684 ( 9 0 ) capacitor c=0.0158429f //x=46.07 //y=5.335
c685 ( 8 0 ) capacitor c=0.0181659f //x=42.3 //y=4.75
c686 ( 7 0 ) capacitor c=0.011494f //x=42.3 //y=4.055
c687 ( 6 0 ) capacitor c=0.029293f //x=42.3 //y=3.735
c688 ( 5 0 ) capacitor c=0.00556102f //x=42.3 //y=2.375
c689 ( 4 0 ) capacitor c=0.0180724f //x=37.49 //y=4.75
c690 ( 3 0 ) capacitor c=0.0115187f //x=37.49 //y=4.055
c691 ( 2 0 ) capacitor c=0.0302473f //x=37.49 //y=3.735
c692 ( 1 0 ) capacitor c=0.00556102f //x=37.49 //y=2.375
r693 (  242 243 ) resistor r=52.7279 //w=0.214 //l=0.165 //layer=ply \
 //thickness=0.18 //x=56.73 //y=2.26 //x2=56.73 //y2=2.095
r694 (  232 233 ) resistor r=52.7279 //w=0.214 //l=0.165 //layer=ply \
 //thickness=0.18 //x=42.3 //y=2.26 //x2=42.3 //y2=2.095
r695 (  222 223 ) resistor r=52.7279 //w=0.214 //l=0.165 //layer=ply \
 //thickness=0.18 //x=37.49 //y=2.26 //x2=37.49 //y2=2.095
r696 (  220 250 ) resistor r=45.1352 //w=0.168 //l=0.173853 //layer=ply \
 //thickness=0.18 //x=57.25 //y=1.44 //x2=57.21 //y2=1.595
r697 (  219 249 ) resistor r=45.1352 //w=0.168 //l=0.173853 //layer=ply \
 //thickness=0.18 //x=57.25 //y=1.095 //x2=57.21 //y2=0.94
r698 (  219 220 ) resistor r=176.904 //w=0.094 //l=0.345 //layer=ply \
 //thickness=0.18 //x=57.25 //y=1.095 //x2=57.25 //y2=1.44
r699 (  217 246 ) resistor r=10.701 //w=0.21 //l=0.115 //layer=ply \
 //thickness=0.18 //x=56.875 //y=1.595 //x2=56.76 //y2=1.595
r700 (  216 250 ) resistor r=5.52526 //w=0.168 //l=0.115 //layer=ply \
 //thickness=0.18 //x=57.095 //y=1.595 //x2=57.21 //y2=1.595
r701 (  215 245 ) resistor r=5.52526 //w=0.168 //l=0.115 //layer=ply \
 //thickness=0.18 //x=56.875 //y=0.94 //x2=56.76 //y2=0.94
r702 (  214 249 ) resistor r=5.52526 //w=0.168 //l=0.115 //layer=ply \
 //thickness=0.18 //x=57.095 //y=0.94 //x2=57.21 //y2=0.94
r703 (  214 215 ) resistor r=112.809 //w=0.094 //l=0.22 //layer=ply \
 //thickness=0.18 //x=57.095 //y=0.94 //x2=56.875 //y2=0.94
r704 (  211 248 ) resistor r=37.236 //w=0.233 //l=0.249199 //layer=ply \
 //thickness=0.18 //x=56.91 //y=5.045 //x2=56.73 //y2=4.88
r705 (  209 246 ) resistor r=39.5823 //w=0.21 //l=0.173853 //layer=ply \
 //thickness=0.18 //x=56.72 //y=1.75 //x2=56.76 //y2=1.595
r706 (  209 243 ) resistor r=176.904 //w=0.094 //l=0.345 //layer=ply \
 //thickness=0.18 //x=56.72 //y=1.75 //x2=56.72 //y2=2.095
r707 (  208 246 ) resistor r=39.5823 //w=0.21 //l=0.173853 //layer=ply \
 //thickness=0.18 //x=56.72 //y=1.44 //x2=56.76 //y2=1.595
r708 (  207 245 ) resistor r=45.1352 //w=0.168 //l=0.173853 //layer=ply \
 //thickness=0.18 //x=56.72 //y=1.095 //x2=56.76 //y2=0.94
r709 (  207 208 ) resistor r=176.904 //w=0.094 //l=0.345 //layer=ply \
 //thickness=0.18 //x=56.72 //y=1.095 //x2=56.72 //y2=1.44
r710 (  204 248 ) resistor r=53.7854 //w=0.233 //l=0.332415 //layer=ply \
 //thickness=0.18 //x=56.47 //y=5.045 //x2=56.73 //y2=4.88
r711 (  203 240 ) resistor r=45.1352 //w=0.168 //l=0.173853 //layer=ply \
 //thickness=0.18 //x=42.82 //y=1.44 //x2=42.78 //y2=1.595
r712 (  202 239 ) resistor r=45.1352 //w=0.168 //l=0.173853 //layer=ply \
 //thickness=0.18 //x=42.82 //y=1.095 //x2=42.78 //y2=0.94
r713 (  202 203 ) resistor r=176.904 //w=0.094 //l=0.345 //layer=ply \
 //thickness=0.18 //x=42.82 //y=1.095 //x2=42.82 //y2=1.44
r714 (  200 236 ) resistor r=10.701 //w=0.21 //l=0.115 //layer=ply \
 //thickness=0.18 //x=42.445 //y=1.595 //x2=42.33 //y2=1.595
r715 (  199 240 ) resistor r=5.52526 //w=0.168 //l=0.115 //layer=ply \
 //thickness=0.18 //x=42.665 //y=1.595 //x2=42.78 //y2=1.595
r716 (  198 235 ) resistor r=5.52526 //w=0.168 //l=0.115 //layer=ply \
 //thickness=0.18 //x=42.445 //y=0.94 //x2=42.33 //y2=0.94
r717 (  197 239 ) resistor r=5.52526 //w=0.168 //l=0.115 //layer=ply \
 //thickness=0.18 //x=42.665 //y=0.94 //x2=42.78 //y2=0.94
r718 (  197 198 ) resistor r=112.809 //w=0.094 //l=0.22 //layer=ply \
 //thickness=0.18 //x=42.665 //y=0.94 //x2=42.445 //y2=0.94
r719 (  194 238 ) resistor r=37.236 //w=0.233 //l=0.249199 //layer=ply \
 //thickness=0.18 //x=42.48 //y=5.045 //x2=42.3 //y2=4.88
r720 (  192 236 ) resistor r=39.5823 //w=0.21 //l=0.173853 //layer=ply \
 //thickness=0.18 //x=42.29 //y=1.75 //x2=42.33 //y2=1.595
r721 (  192 233 ) resistor r=176.904 //w=0.094 //l=0.345 //layer=ply \
 //thickness=0.18 //x=42.29 //y=1.75 //x2=42.29 //y2=2.095
r722 (  191 236 ) resistor r=39.5823 //w=0.21 //l=0.173853 //layer=ply \
 //thickness=0.18 //x=42.29 //y=1.44 //x2=42.33 //y2=1.595
r723 (  190 235 ) resistor r=45.1352 //w=0.168 //l=0.173853 //layer=ply \
 //thickness=0.18 //x=42.29 //y=1.095 //x2=42.33 //y2=0.94
r724 (  190 191 ) resistor r=176.904 //w=0.094 //l=0.345 //layer=ply \
 //thickness=0.18 //x=42.29 //y=1.095 //x2=42.29 //y2=1.44
r725 (  187 238 ) resistor r=53.7854 //w=0.233 //l=0.332415 //layer=ply \
 //thickness=0.18 //x=42.04 //y=5.045 //x2=42.3 //y2=4.88
r726 (  186 230 ) resistor r=45.1352 //w=0.168 //l=0.173853 //layer=ply \
 //thickness=0.18 //x=38.01 //y=1.44 //x2=37.97 //y2=1.595
r727 (  185 229 ) resistor r=45.1352 //w=0.168 //l=0.173853 //layer=ply \
 //thickness=0.18 //x=38.01 //y=1.095 //x2=37.97 //y2=0.94
r728 (  185 186 ) resistor r=176.904 //w=0.094 //l=0.345 //layer=ply \
 //thickness=0.18 //x=38.01 //y=1.095 //x2=38.01 //y2=1.44
r729 (  183 226 ) resistor r=10.701 //w=0.21 //l=0.115 //layer=ply \
 //thickness=0.18 //x=37.635 //y=1.595 //x2=37.52 //y2=1.595
r730 (  182 230 ) resistor r=5.52526 //w=0.168 //l=0.115 //layer=ply \
 //thickness=0.18 //x=37.855 //y=1.595 //x2=37.97 //y2=1.595
r731 (  181 225 ) resistor r=5.52526 //w=0.168 //l=0.115 //layer=ply \
 //thickness=0.18 //x=37.635 //y=0.94 //x2=37.52 //y2=0.94
r732 (  180 229 ) resistor r=5.52526 //w=0.168 //l=0.115 //layer=ply \
 //thickness=0.18 //x=37.855 //y=0.94 //x2=37.97 //y2=0.94
r733 (  180 181 ) resistor r=112.809 //w=0.094 //l=0.22 //layer=ply \
 //thickness=0.18 //x=37.855 //y=0.94 //x2=37.635 //y2=0.94
r734 (  177 228 ) resistor r=37.236 //w=0.233 //l=0.249199 //layer=ply \
 //thickness=0.18 //x=37.67 //y=5.045 //x2=37.49 //y2=4.88
r735 (  175 226 ) resistor r=39.5823 //w=0.21 //l=0.173853 //layer=ply \
 //thickness=0.18 //x=37.48 //y=1.75 //x2=37.52 //y2=1.595
r736 (  175 223 ) resistor r=176.904 //w=0.094 //l=0.345 //layer=ply \
 //thickness=0.18 //x=37.48 //y=1.75 //x2=37.48 //y2=2.095
r737 (  174 226 ) resistor r=39.5823 //w=0.21 //l=0.173853 //layer=ply \
 //thickness=0.18 //x=37.48 //y=1.44 //x2=37.52 //y2=1.595
r738 (  173 225 ) resistor r=45.1352 //w=0.168 //l=0.173853 //layer=ply \
 //thickness=0.18 //x=37.48 //y=1.095 //x2=37.52 //y2=0.94
r739 (  173 174 ) resistor r=176.904 //w=0.094 //l=0.345 //layer=ply \
 //thickness=0.18 //x=37.48 //y=1.095 //x2=37.48 //y2=1.44
r740 (  170 228 ) resistor r=53.7854 //w=0.233 //l=0.332415 //layer=ply \
 //thickness=0.18 //x=37.23 //y=5.045 //x2=37.49 //y2=4.88
r741 (  169 211 ) resistor r=592.245 //w=0.094 //l=1.155 //layer=ply \
 //thickness=0.18 //x=56.91 //y=6.2 //x2=56.91 //y2=5.045
r742 (  168 204 ) resistor r=592.245 //w=0.094 //l=1.155 //layer=ply \
 //thickness=0.18 //x=56.47 //y=6.2 //x2=56.47 //y2=5.045
r743 (  167 194 ) resistor r=592.245 //w=0.094 //l=1.155 //layer=ply \
 //thickness=0.18 //x=42.48 //y=6.2 //x2=42.48 //y2=5.045
r744 (  166 187 ) resistor r=592.245 //w=0.094 //l=1.155 //layer=ply \
 //thickness=0.18 //x=42.04 //y=6.2 //x2=42.04 //y2=5.045
r745 (  165 177 ) resistor r=592.245 //w=0.094 //l=1.155 //layer=ply \
 //thickness=0.18 //x=37.67 //y=6.2 //x2=37.67 //y2=5.045
r746 (  164 170 ) resistor r=592.245 //w=0.094 //l=1.155 //layer=ply \
 //thickness=0.18 //x=37.23 //y=6.2 //x2=37.23 //y2=5.045
r747 (  163 216 ) resistor r=56.4043 //w=0.094 //l=0.11 //layer=ply \
 //thickness=0.18 //x=56.985 //y=1.595 //x2=57.095 //y2=1.595
r748 (  163 217 ) resistor r=56.4043 //w=0.094 //l=0.11 //layer=ply \
 //thickness=0.18 //x=56.985 //y=1.595 //x2=56.875 //y2=1.595
r749 (  162 199 ) resistor r=56.4043 //w=0.094 //l=0.11 //layer=ply \
 //thickness=0.18 //x=42.555 //y=1.595 //x2=42.665 //y2=1.595
r750 (  162 200 ) resistor r=56.4043 //w=0.094 //l=0.11 //layer=ply \
 //thickness=0.18 //x=42.555 //y=1.595 //x2=42.445 //y2=1.595
r751 (  161 182 ) resistor r=56.4043 //w=0.094 //l=0.11 //layer=ply \
 //thickness=0.18 //x=37.745 //y=1.595 //x2=37.855 //y2=1.595
r752 (  161 183 ) resistor r=56.4043 //w=0.094 //l=0.11 //layer=ply \
 //thickness=0.18 //x=37.745 //y=1.595 //x2=37.635 //y2=1.595
r753 (  157 248 ) resistor r=152 //w=0.17 //l=0.17 //layer=licon //count=1 \
 //x=56.73 //y=4.88 //x2=56.73 //y2=4.88
r754 (  148 242 ) resistor r=152 //w=0.17 //l=0.17 //layer=licon //count=1 \
 //x=56.73 //y=2.26 //x2=56.73 //y2=2.26
r755 (  131 255 ) resistor r=23.615 //w=0.187 //l=0.345 //layer=li \
 //thickness=0.1 //x=47.07 //y=5.56 //x2=47.07 //y2=5.905
r756 (  123 254 ) resistor r=23.615 //w=0.187 //l=0.345 //layer=li \
 //thickness=0.1 //x=46.19 //y=5.56 //x2=46.19 //y2=5.905
r757 (  115 253 ) resistor r=23.615 //w=0.187 //l=0.345 //layer=li \
 //thickness=0.1 //x=45.31 //y=5.56 //x2=45.31 //y2=5.905
r758 (  110 238 ) resistor r=152 //w=0.17 //l=0.17 //layer=licon //count=1 \
 //x=42.3 //y=4.88 //x2=42.3 //y2=4.88
r759 (  101 232 ) resistor r=152 //w=0.17 //l=0.17 //layer=licon //count=1 \
 //x=42.3 //y=2.26 //x2=42.3 //y2=2.26
r760 (  96 228 ) resistor r=152 //w=0.17 //l=0.17 //layer=licon //count=1 \
 //x=37.49 //y=4.88 //x2=37.49 //y2=4.88
r761 (  87 222 ) resistor r=152 //w=0.17 //l=0.17 //layer=licon //count=1 \
 //x=37.49 //y=2.26 //x2=37.49 //y2=2.26
r762 (  79 81 ) resistor r=0.10734 //w=0.281 //l=0.16 //layer=m2 \
 //thickness=0.36 //x=42.3 //y=3.895 //x2=42.46 //y2=3.895
r763 (  79 80 ) resistor r=0.10734 //w=0.281 //l=0.16 //layer=m2 \
 //thickness=0.36 //x=42.3 //y=3.895 //x2=42.14 //y2=3.895
r764 (  77 80 ) resistor r=4.28435 //w=0.131 //l=4.49 //layer=m2 \
 //thickness=0.36 //x=37.65 //y=3.88 //x2=42.14 //y2=3.88
r765 (  75 77 ) resistor r=0.10734 //w=0.281 //l=0.16 //layer=m2 \
 //thickness=0.36 //x=37.49 //y=3.895 //x2=37.65 //y2=3.895
r766 (  73 83 ) resistor r=1.10266 //w=0.196 //l=1.725 //layer=m2 \
 //thickness=0.36 //x=49.565 //y=3.895 //x2=47.84 //y2=3.895
r767 (  72 85 ) resistor r=4.81638 //w=0.177 //l=6.825 //layer=m2 \
 //thickness=0.36 //x=49.91 //y=3.895 //x2=56.73 //y2=3.885
r768 (  72 73 ) resistor r=0.329198 //w=0.131 //l=0.345 //layer=m2 \
 //thickness=0.36 //x=49.91 //y=3.895 //x2=49.565 //y2=3.895
r769 (  70 83 ) resistor r=0.104578 //w=0.196 //l=0.167332 //layer=m2 \
 //thickness=0.36 //x=47.68 //y=3.88 //x2=47.84 //y2=3.895
r770 (  70 81 ) resistor r=4.98092 //w=0.131 //l=5.22 //layer=m2 \
 //thickness=0.36 //x=47.68 //y=3.88 //x2=42.46 //y2=3.88
r771 (  67 157 ) resistor r=9.3 //w=0.17 //l=0.17 //layer=mcon //count=1 \
 //x=56.73 //y=4.88 //x2=56.73 //y2=4.88
r772 (  65 148 ) resistor r=9.3 //w=0.17 //l=0.17 //layer=mcon //count=1 \
 //x=56.73 //y=2.26 //x2=56.73 //y2=2.26
r773 (  63 85 ) resistor r=4.5 //w=0.15 //l=0.15 //layer=via1 //count=1 \
 //x=56.73 //y=3.885 //x2=56.73 //y2=3.885
r774 (  61 63 ) resistor r=0.00166223 //w=0.376 //l=0.005 //layer=m1 \
 //thickness=0.36 //x=56.677 //y=3.88 //x2=56.677 //y2=3.885
r775 (  59 83 ) resistor r=4.5 //w=0.15 //l=0.15 //layer=via1 //count=1 \
 //x=47.84 //y=3.895 //x2=47.84 //y2=3.895
r776 (  57 59 ) resistor r=0.00490838 //w=0.382 //l=0.015 //layer=m1 \
 //thickness=0.36 //x=47.897 //y=3.88 //x2=47.897 //y2=3.895
r777 (  55 251 ) resistor r=9.3 //w=0.17 //l=0.17 //layer=mcon //count=1 \
 //x=47.365 //y=1.19 //x2=47.365 //y2=1.19
r778 (  53 131 ) resistor r=9.3 //w=0.17 //l=0.17 //layer=mcon //count=1 \
 //x=47.07 //y=5.56 //x2=47.07 //y2=5.56
r779 (  50 123 ) resistor r=9.3 //w=0.17 //l=0.17 //layer=mcon //count=1 \
 //x=46.19 //y=5.56 //x2=46.19 //y2=5.56
r780 (  48 50 ) resistor r=0.121228 //w=0.232 //l=0.225 //layer=m1 \
 //thickness=0.36 //x=46.19 //y=5.335 //x2=46.19 //y2=5.56
r781 (  47 115 ) resistor r=9.3 //w=0.17 //l=0.17 //layer=mcon //count=1 \
 //x=45.31 //y=5.56 //x2=45.31 //y2=5.56
r782 (  45 47 ) resistor r=0.129608 //w=0.217 //l=0.225 //layer=m1 \
 //thickness=0.36 //x=45.312 //y=5.335 //x2=45.312 //y2=5.56
r783 (  44 110 ) resistor r=9.3 //w=0.17 //l=0.17 //layer=mcon //count=1 \
 //x=42.3 //y=4.88 //x2=42.3 //y2=4.88
r784 (  42 101 ) resistor r=9.3 //w=0.17 //l=0.17 //layer=mcon //count=1 \
 //x=42.3 //y=2.26 //x2=42.3 //y2=2.26
r785 (  40 79 ) resistor r=4.5 //w=0.15 //l=0.15 //layer=via1 //count=1 \
 //x=42.3 //y=3.895 //x2=42.3 //y2=3.895
r786 (  38 40 ) resistor r=0.0049867 //w=0.376 //l=0.015 //layer=m1 \
 //thickness=0.36 //x=42.247 //y=3.88 //x2=42.247 //y2=3.895
r787 (  36 75 ) resistor r=4.5 //w=0.15 //l=0.15 //layer=via1 //count=1 \
 //x=37.49 //y=3.895 //x2=37.49 //y2=3.895
r788 (  34 36 ) resistor r=0.0049867 //w=0.376 //l=0.015 //layer=m1 \
 //thickness=0.36 //x=37.542 //y=3.88 //x2=37.542 //y2=3.895
r789 (  32 96 ) resistor r=9.3 //w=0.17 //l=0.17 //layer=mcon //count=1 \
 //x=37.49 //y=4.88 //x2=37.49 //y2=4.88
r790 (  30 87 ) resistor r=9.3 //w=0.17 //l=0.17 //layer=mcon //count=1 \
 //x=37.49 //y=2.26 //x2=37.49 //y2=2.26
r791 (  28 67 ) resistor r=0.0801089 //w=0.224 //l=0.13 //layer=m1 \
 //thickness=0.36 //x=56.73 //y=4.75 //x2=56.73 //y2=4.88
r792 (  27 63 ) resistor r=0.0911593 //w=0.376 //l=0.184608 //layer=m1 \
 //thickness=0.36 //x=56.73 //y=4.045 //x2=56.677 //y2=3.885
r793 (  27 28 ) resistor r=0.67271 //w=0.131 //l=0.705 //layer=m1 \
 //thickness=0.36 //x=56.73 //y=4.045 //x2=56.73 //y2=4.75
r794 (  26 61 ) resistor r=0.0894971 //w=0.376 //l=0.179555 //layer=m1 \
 //thickness=0.36 //x=56.73 //y=3.725 //x2=56.677 //y2=3.88
r795 (  25 65 ) resistor r=0.0719237 //w=0.222 //l=0.115 //layer=m1 \
 //thickness=0.36 //x=56.73 //y=2.375 //x2=56.73 //y2=2.26
r796 (  25 26 ) resistor r=1.28817 //w=0.131 //l=1.35 //layer=m1 \
 //thickness=0.36 //x=56.73 //y=2.375 //x2=56.73 //y2=3.725
r797 (  23 59 ) resistor r=0.0914072 //w=0.382 //l=0.181989 //layer=m1 \
 //thickness=0.36 //x=47.85 //y=4.055 //x2=47.897 //y2=3.895
r798 (  23 24 ) resistor r=1.14027 //w=0.131 //l=1.195 //layer=m1 \
 //thickness=0.36 //x=47.85 //y=4.055 //x2=47.85 //y2=5.25
r799 (  22 57 ) resistor r=0.0864989 //w=0.382 //l=0.166853 //layer=m1 \
 //thickness=0.36 //x=47.85 //y=3.735 //x2=47.897 //y2=3.88
r800 (  21 22 ) resistor r=1.72233 //w=0.131 //l=1.805 //layer=m1 \
 //thickness=0.36 //x=47.85 //y=1.93 //x2=47.85 //y2=3.735
r801 (  19 21 ) resistor r=0.0698411 //w=0.17 //l=0.120208 //layer=m1 \
 //thickness=0.36 //x=47.765 //y=1.845 //x2=47.85 //y2=1.93
r802 (  19 20 ) resistor r=0.300573 //w=0.131 //l=0.315 //layer=m1 \
 //thickness=0.36 //x=47.765 //y=1.845 //x2=47.45 //y2=1.845
r803 (  18 20 ) resistor r=0.0698411 //w=0.17 //l=0.120208 //layer=m1 \
 //thickness=0.36 //x=47.365 //y=1.76 //x2=47.45 //y2=1.845
r804 (  17 55 ) resistor r=0.0717383 //w=0.224 //l=0.115 //layer=m1 \
 //thickness=0.36 //x=47.365 //y=1.305 //x2=47.365 //y2=1.19
r805 (  17 18 ) resistor r=0.43416 //w=0.131 //l=0.455 //layer=m1 \
 //thickness=0.36 //x=47.365 //y=1.305 //x2=47.365 //y2=1.76
r806 (  16 51 ) resistor r=0.0675342 //w=0.23 //l=0.115 //layer=m1 \
 //thickness=0.36 //x=47.185 //y=5.335 //x2=47.07 //y2=5.335
r807 (  15 24 ) resistor r=0.0698411 //w=0.17 //l=0.120208 //layer=m1 \
 //thickness=0.36 //x=47.765 //y=5.335 //x2=47.85 //y2=5.25
r808 (  15 16 ) resistor r=0.553435 //w=0.131 //l=0.58 //layer=m1 \
 //thickness=0.36 //x=47.765 //y=5.335 //x2=47.185 //y2=5.335
r809 (  14 53 ) resistor r=0.00118313 //w=0.23 //layer=m1 //thickness=0.36 \
 //x=47.07 //y=5.56 //x2=47.07 //y2=5.56
r810 (  13 51 ) resistor r=0.002872 //w=0.34 //l=0.085 //layer=m1 \
 //thickness=0.36 //x=47.07 //y=5.42 //x2=47.07 //y2=5.335
r811 (  13 14 ) resistor r=0.091623 //w=0.191 //l=0.14 //layer=m1 \
 //thickness=0.36 //x=47.07 //y=5.42 //x2=47.07 //y2=5.56
r812 (  12 48 ) resistor r=0.0262263 //w=0.232 //l=0.12 //layer=m1 \
 //thickness=0.36 //x=46.31 //y=5.335 //x2=46.19 //y2=5.335
r813 (  11 51 ) resistor r=0.0675342 //w=0.23 //l=0.115 //layer=m1 \
 //thickness=0.36 //x=46.955 //y=5.335 //x2=47.07 //y2=5.335
r814 (  11 12 ) resistor r=0.615458 //w=0.131 //l=0.645 //layer=m1 \
 //thickness=0.36 //x=46.955 //y=5.335 //x2=46.31 //y2=5.335
r815 (  10 45 ) resistor r=0.0222262 //w=0.217 //l=0.118 //layer=m1 \
 //thickness=0.36 //x=45.43 //y=5.335 //x2=45.312 //y2=5.335
r816 (  9 48 ) resistor r=0.0262263 //w=0.232 //l=0.12 //layer=m1 \
 //thickness=0.36 //x=46.07 //y=5.335 //x2=46.19 //y2=5.335
r817 (  9 10 ) resistor r=0.610687 //w=0.131 //l=0.64 //layer=m1 \
 //thickness=0.36 //x=46.07 //y=5.335 //x2=45.43 //y2=5.335
r818 (  8 44 ) resistor r=0.0801089 //w=0.224 //l=0.13 //layer=m1 \
 //thickness=0.36 //x=42.3 //y=4.75 //x2=42.3 //y2=4.88
r819 (  7 40 ) resistor r=0.0911593 //w=0.376 //l=0.184608 //layer=m1 \
 //thickness=0.36 //x=42.3 //y=4.055 //x2=42.247 //y2=3.895
r820 (  7 8 ) resistor r=0.663168 //w=0.131 //l=0.695 //layer=m1 \
 //thickness=0.36 //x=42.3 //y=4.055 //x2=42.3 //y2=4.75
r821 (  6 38 ) resistor r=0.0861726 //w=0.376 //l=0.16944 //layer=m1 \
 //thickness=0.36 //x=42.3 //y=3.735 //x2=42.247 //y2=3.88
r822 (  5 42 ) resistor r=0.0719237 //w=0.222 //l=0.115 //layer=m1 \
 //thickness=0.36 //x=42.3 //y=2.375 //x2=42.3 //y2=2.26
r823 (  5 6 ) resistor r=1.29771 //w=0.131 //l=1.36 //layer=m1 \
 //thickness=0.36 //x=42.3 //y=2.375 //x2=42.3 //y2=3.735
r824 (  4 32 ) resistor r=0.0801089 //w=0.224 //l=0.13 //layer=m1 \
 //thickness=0.36 //x=37.49 //y=4.75 //x2=37.49 //y2=4.88
r825 (  3 36 ) resistor r=0.0911593 //w=0.376 //l=0.184174 //layer=m1 \
 //thickness=0.36 //x=37.49 //y=4.055 //x2=37.542 //y2=3.895
r826 (  3 4 ) resistor r=0.663168 //w=0.131 //l=0.695 //layer=m1 \
 //thickness=0.36 //x=37.49 //y=4.055 //x2=37.49 //y2=4.75
r827 (  2 34 ) resistor r=0.0861726 //w=0.376 //l=0.169012 //layer=m1 \
 //thickness=0.36 //x=37.49 //y=3.735 //x2=37.542 //y2=3.88
r828 (  1 30 ) resistor r=0.0719237 //w=0.222 //l=0.115 //layer=m1 \
 //thickness=0.36 //x=37.49 //y=2.375 //x2=37.49 //y2=2.26
r829 (  1 2 ) resistor r=1.29771 //w=0.131 //l=1.36 //layer=m1 \
 //thickness=0.36 //x=37.49 //y=2.375 //x2=37.49 //y2=3.735
ends PM_TMRDFFSNRNQX1\%noxref_11

subckt PM_TMRDFFSNRNQX1\%D ( 1 2 3 4 5 6 7 8 9 10 11 12 13 14 15 22 23 25 30 \
 31 32 36 37 61 63 65 67 69 71 73 75 76 77 79 81 83 85 90 96 105 110 119 124 \
 133 137 138 139 140 141 142 143 144 145 146 147 148 149 150 152 158 159 160 \
 161 165 166 167 168 169 171 177 178 179 180 184 185 186 187 188 190 196 197 \
 198 199 )
c561 ( 199 0 ) capacitor c=0.0571309f //x=59.595 //y=4.97
c562 ( 198 0 ) capacitor c=0.0376642f //x=59.885 //y=4.97
c563 ( 197 0 ) capacitor c=0.0346489f //x=59.55 //y=1.4
c564 ( 196 0 ) capacitor c=0.018692f //x=59.55 //y=1.055
c565 ( 190 0 ) capacitor c=0.0137077f //x=59.395 //y=1.555
c566 ( 188 0 ) capacitor c=0.0158585f //x=59.395 //y=0.9
c567 ( 187 0 ) capacitor c=0.103534f //x=59.02 //y=2.095
c568 ( 186 0 ) capacitor c=0.0229444f //x=59.02 //y=1.71
c569 ( 185 0 ) capacitor c=0.0234359f //x=59.02 //y=1.4
c570 ( 184 0 ) capacitor c=0.019815f //x=59.02 //y=1.055
c571 ( 180 0 ) capacitor c=0.0553397f //x=30.735 //y=4.97
c572 ( 179 0 ) capacitor c=0.0376642f //x=31.025 //y=4.97
c573 ( 178 0 ) capacitor c=0.0346489f //x=30.69 //y=1.4
c574 ( 177 0 ) capacitor c=0.018692f //x=30.69 //y=1.055
c575 ( 171 0 ) capacitor c=0.0137077f //x=30.535 //y=1.555
c576 ( 169 0 ) capacitor c=0.0158585f //x=30.535 //y=0.9
c577 ( 168 0 ) capacitor c=0.103534f //x=30.16 //y=2.095
c578 ( 167 0 ) capacitor c=0.0229444f //x=30.16 //y=1.71
c579 ( 166 0 ) capacitor c=0.0234359f //x=30.16 //y=1.4
c580 ( 165 0 ) capacitor c=0.019815f //x=30.16 //y=1.055
c581 ( 161 0 ) capacitor c=0.0571068f //x=1.875 //y=4.97
c582 ( 160 0 ) capacitor c=0.0376642f //x=2.165 //y=4.97
c583 ( 159 0 ) capacitor c=0.0346489f //x=1.83 //y=1.4
c584 ( 158 0 ) capacitor c=0.018692f //x=1.83 //y=1.055
c585 ( 152 0 ) capacitor c=0.0137077f //x=1.675 //y=1.555
c586 ( 150 0 ) capacitor c=0.0158585f //x=1.675 //y=0.9
c587 ( 149 0 ) capacitor c=0.103534f //x=1.3 //y=2.095
c588 ( 148 0 ) capacitor c=0.0229444f //x=1.3 //y=1.71
c589 ( 147 0 ) capacitor c=0.0234359f //x=1.3 //y=1.4
c590 ( 146 0 ) capacitor c=0.019815f //x=1.3 //y=1.055
c591 ( 145 0 ) capacitor c=0.110208f //x=59.96 //y=6.2
c592 ( 144 0 ) capacitor c=0.158957f //x=59.52 //y=6.2
c593 ( 143 0 ) capacitor c=0.110208f //x=31.1 //y=6.2
c594 ( 142 0 ) capacitor c=0.158957f //x=30.66 //y=6.2
c595 ( 141 0 ) capacitor c=0.110208f //x=2.24 //y=6.2
c596 ( 140 0 ) capacitor c=0.158957f //x=1.8 //y=6.2
c597 ( 133 0 ) capacitor c=0.00135387f //x=59.32 //y=4.88
c598 ( 124 0 ) capacitor c=0.0012618f //x=59.32 //y=2.26
c599 ( 119 0 ) capacitor c=0.00132168f //x=30.46 //y=4.88
c600 ( 110 0 ) capacitor c=0.0012618f //x=30.46 //y=2.26
c601 ( 105 0 ) capacitor c=0.00120653f //x=1.6 //y=4.88
c602 ( 96 0 ) capacitor c=0.0012618f //x=1.6 //y=2.26
c603 ( 90 0 ) capacitor c=0.0117734f //x=1.76 //y=4.26
c604 ( 85 0 ) capacitor c=0.0259999f //x=56.945 //y=4.27
c605 ( 83 0 ) capacitor c=0.0806608f //x=56.345 //y=4.25
c606 ( 81 0 ) capacitor c=0.00430603f //x=48.055 //y=4.28
c607 ( 79 0 ) capacitor c=0.0480868f //x=47.455 //y=4.25
c608 ( 77 0 ) capacitor c=0.00480596f //x=42.595 //y=4.3
c609 ( 76 0 ) capacitor c=0.114608f //x=37.36 //y=4.28
c610 ( 75 0 ) capacitor c=0.0435675f //x=37.705 //y=4.28
c611 ( 73 0 ) capacitor c=0.00155499f //x=28.085 //y=4.27
c612 ( 71 0 ) capacitor c=0.082117f //x=27.485 //y=4.25
c613 ( 69 0 ) capacitor c=0.00430603f //x=19.195 //y=4.28
c614 ( 67 0 ) capacitor c=0.0486924f //x=18.595 //y=4.25
c615 ( 65 0 ) capacitor c=0.00434239f //x=13.655 //y=4.31
c616 ( 63 0 ) capacitor c=0.045907f //x=8.845 //y=4.28
c617 ( 61 0 ) capacitor c=0.182353f //x=8.245 //y=4.25
c618 ( 37 0 ) capacitor c=0.0113035f //x=59.32 //y=4.755
c619 ( 36 0 ) capacitor c=0.0128489f //x=59.32 //y=4.41
c620 ( 32 0 ) capacitor c=0.00493485f //x=59.32 //y=2.375
c621 ( 31 0 ) capacitor c=0.0116331f //x=30.46 //y=4.755
c622 ( 30 0 ) capacitor c=0.0125206f //x=30.46 //y=4.395
c623 ( 25 0 ) capacitor c=0.00493485f //x=30.46 //y=2.375
c624 ( 23 0 ) capacitor c=0.0109328f //x=1.6 //y=4.755
c625 ( 22 0 ) capacitor c=0.0204476f //x=1.6 //y=4.42
c626 ( 15 0 ) capacitor c=0.0113096f //x=1.6 //y=2.375
c627 ( 14 0 ) capacitor c=0.0146142f //x=59.32 //y=4.25
c628 ( 13 0 ) capacitor c=0.0148084f //x=30.46 //y=4.25
c629 ( 12 0 ) capacitor c=0.0158351f //x=1.6 //y=4.25
c630 ( 10 0 ) capacitor c=0.0498201f //x=59.32 //y=2.77
c631 ( 7 0 ) capacitor c=0.0516154f //x=30.46 //y=2.77
c632 ( 6 0 ) capacitor c=0.0128805f //x=1.6 //y=4.62
c633 ( 1 0 ) capacitor c=0.0854947f //x=1.6 //y=2.4
r634 (  198 200 ) resistor r=26.9307 //w=0.15 //l=0.106066 //layer=ply \
 //thickness=0.18 //x=59.885 //y=4.97 //x2=59.96 //y2=5.045
r635 (  198 199 ) resistor r=148.702 //w=0.094 //l=0.29 //layer=ply \
 //thickness=0.18 //x=59.885 //y=4.97 //x2=59.595 //y2=4.97
r636 (  197 226 ) resistor r=45.1352 //w=0.168 //l=0.173853 //layer=ply \
 //thickness=0.18 //x=59.55 //y=1.4 //x2=59.51 //y2=1.555
r637 (  196 225 ) resistor r=45.1352 //w=0.168 //l=0.173853 //layer=ply \
 //thickness=0.18 //x=59.55 //y=1.055 //x2=59.51 //y2=0.9
r638 (  196 197 ) resistor r=176.904 //w=0.094 //l=0.345 //layer=ply \
 //thickness=0.18 //x=59.55 //y=1.055 //x2=59.55 //y2=1.4
r639 (  193 199 ) resistor r=22.7971 //w=0.269 //l=0.106066 //layer=ply \
 //thickness=0.18 //x=59.52 //y=5.045 //x2=59.595 //y2=4.97
r640 (  193 224 ) resistor r=35.8364 //w=0.269 //l=0.270185 //layer=ply \
 //thickness=0.18 //x=59.52 //y=5.045 //x2=59.32 //y2=4.88
r641 (  191 220 ) resistor r=10.701 //w=0.21 //l=0.115 //layer=ply \
 //thickness=0.18 //x=59.175 //y=1.555 //x2=59.06 //y2=1.555
r642 (  190 226 ) resistor r=5.52526 //w=0.168 //l=0.115 //layer=ply \
 //thickness=0.18 //x=59.395 //y=1.555 //x2=59.51 //y2=1.555
r643 (  189 219 ) resistor r=5.52526 //w=0.168 //l=0.115 //layer=ply \
 //thickness=0.18 //x=59.175 //y=0.9 //x2=59.06 //y2=0.9
r644 (  188 225 ) resistor r=5.52526 //w=0.168 //l=0.115 //layer=ply \
 //thickness=0.18 //x=59.395 //y=0.9 //x2=59.51 //y2=0.9
r645 (  188 189 ) resistor r=112.809 //w=0.094 //l=0.22 //layer=ply \
 //thickness=0.18 //x=59.395 //y=0.9 //x2=59.175 //y2=0.9
r646 (  187 222 ) resistor r=58.7805 //w=0.246 //l=0.373497 //layer=ply \
 //thickness=0.18 //x=59.02 //y=2.095 //x2=59.32 //y2=2.26
r647 (  186 220 ) resistor r=39.5823 //w=0.21 //l=0.173853 //layer=ply \
 //thickness=0.18 //x=59.02 //y=1.71 //x2=59.06 //y2=1.555
r648 (  186 187 ) resistor r=197.415 //w=0.094 //l=0.385 //layer=ply \
 //thickness=0.18 //x=59.02 //y=1.71 //x2=59.02 //y2=2.095
r649 (  185 220 ) resistor r=39.5823 //w=0.21 //l=0.173853 //layer=ply \
 //thickness=0.18 //x=59.02 //y=1.4 //x2=59.06 //y2=1.555
r650 (  184 219 ) resistor r=45.1352 //w=0.168 //l=0.173853 //layer=ply \
 //thickness=0.18 //x=59.02 //y=1.055 //x2=59.06 //y2=0.9
r651 (  184 185 ) resistor r=176.904 //w=0.094 //l=0.345 //layer=ply \
 //thickness=0.18 //x=59.02 //y=1.055 //x2=59.02 //y2=1.4
r652 (  179 181 ) resistor r=26.9307 //w=0.15 //l=0.106066 //layer=ply \
 //thickness=0.18 //x=31.025 //y=4.97 //x2=31.1 //y2=5.045
r653 (  179 180 ) resistor r=148.702 //w=0.094 //l=0.29 //layer=ply \
 //thickness=0.18 //x=31.025 //y=4.97 //x2=30.735 //y2=4.97
r654 (  178 218 ) resistor r=45.1352 //w=0.168 //l=0.173853 //layer=ply \
 //thickness=0.18 //x=30.69 //y=1.4 //x2=30.65 //y2=1.555
r655 (  177 217 ) resistor r=45.1352 //w=0.168 //l=0.173853 //layer=ply \
 //thickness=0.18 //x=30.69 //y=1.055 //x2=30.65 //y2=0.9
r656 (  177 178 ) resistor r=176.904 //w=0.094 //l=0.345 //layer=ply \
 //thickness=0.18 //x=30.69 //y=1.055 //x2=30.69 //y2=1.4
r657 (  174 180 ) resistor r=22.7971 //w=0.269 //l=0.106066 //layer=ply \
 //thickness=0.18 //x=30.66 //y=5.045 //x2=30.735 //y2=4.97
r658 (  174 216 ) resistor r=35.8364 //w=0.269 //l=0.270185 //layer=ply \
 //thickness=0.18 //x=30.66 //y=5.045 //x2=30.46 //y2=4.88
r659 (  172 212 ) resistor r=10.701 //w=0.21 //l=0.115 //layer=ply \
 //thickness=0.18 //x=30.315 //y=1.555 //x2=30.2 //y2=1.555
r660 (  171 218 ) resistor r=5.52526 //w=0.168 //l=0.115 //layer=ply \
 //thickness=0.18 //x=30.535 //y=1.555 //x2=30.65 //y2=1.555
r661 (  170 211 ) resistor r=5.52526 //w=0.168 //l=0.115 //layer=ply \
 //thickness=0.18 //x=30.315 //y=0.9 //x2=30.2 //y2=0.9
r662 (  169 217 ) resistor r=5.52526 //w=0.168 //l=0.115 //layer=ply \
 //thickness=0.18 //x=30.535 //y=0.9 //x2=30.65 //y2=0.9
r663 (  169 170 ) resistor r=112.809 //w=0.094 //l=0.22 //layer=ply \
 //thickness=0.18 //x=30.535 //y=0.9 //x2=30.315 //y2=0.9
r664 (  168 214 ) resistor r=58.7805 //w=0.246 //l=0.373497 //layer=ply \
 //thickness=0.18 //x=30.16 //y=2.095 //x2=30.46 //y2=2.26
r665 (  167 212 ) resistor r=39.5823 //w=0.21 //l=0.173853 //layer=ply \
 //thickness=0.18 //x=30.16 //y=1.71 //x2=30.2 //y2=1.555
r666 (  167 168 ) resistor r=197.415 //w=0.094 //l=0.385 //layer=ply \
 //thickness=0.18 //x=30.16 //y=1.71 //x2=30.16 //y2=2.095
r667 (  166 212 ) resistor r=39.5823 //w=0.21 //l=0.173853 //layer=ply \
 //thickness=0.18 //x=30.16 //y=1.4 //x2=30.2 //y2=1.555
r668 (  165 211 ) resistor r=45.1352 //w=0.168 //l=0.173853 //layer=ply \
 //thickness=0.18 //x=30.16 //y=1.055 //x2=30.2 //y2=0.9
r669 (  165 166 ) resistor r=176.904 //w=0.094 //l=0.345 //layer=ply \
 //thickness=0.18 //x=30.16 //y=1.055 //x2=30.16 //y2=1.4
r670 (  160 162 ) resistor r=26.9307 //w=0.15 //l=0.106066 //layer=ply \
 //thickness=0.18 //x=2.165 //y=4.97 //x2=2.24 //y2=5.045
r671 (  160 161 ) resistor r=148.702 //w=0.094 //l=0.29 //layer=ply \
 //thickness=0.18 //x=2.165 //y=4.97 //x2=1.875 //y2=4.97
r672 (  159 210 ) resistor r=45.1352 //w=0.168 //l=0.173853 //layer=ply \
 //thickness=0.18 //x=1.83 //y=1.4 //x2=1.79 //y2=1.555
r673 (  158 209 ) resistor r=45.1352 //w=0.168 //l=0.173853 //layer=ply \
 //thickness=0.18 //x=1.83 //y=1.055 //x2=1.79 //y2=0.9
r674 (  158 159 ) resistor r=176.904 //w=0.094 //l=0.345 //layer=ply \
 //thickness=0.18 //x=1.83 //y=1.055 //x2=1.83 //y2=1.4
r675 (  155 161 ) resistor r=22.7971 //w=0.269 //l=0.106066 //layer=ply \
 //thickness=0.18 //x=1.8 //y=5.045 //x2=1.875 //y2=4.97
r676 (  155 208 ) resistor r=35.8364 //w=0.269 //l=0.270185 //layer=ply \
 //thickness=0.18 //x=1.8 //y=5.045 //x2=1.6 //y2=4.88
r677 (  153 204 ) resistor r=10.701 //w=0.21 //l=0.115 //layer=ply \
 //thickness=0.18 //x=1.455 //y=1.555 //x2=1.34 //y2=1.555
r678 (  152 210 ) resistor r=5.52526 //w=0.168 //l=0.115 //layer=ply \
 //thickness=0.18 //x=1.675 //y=1.555 //x2=1.79 //y2=1.555
r679 (  151 203 ) resistor r=5.52526 //w=0.168 //l=0.115 //layer=ply \
 //thickness=0.18 //x=1.455 //y=0.9 //x2=1.34 //y2=0.9
r680 (  150 209 ) resistor r=5.52526 //w=0.168 //l=0.115 //layer=ply \
 //thickness=0.18 //x=1.675 //y=0.9 //x2=1.79 //y2=0.9
r681 (  150 151 ) resistor r=112.809 //w=0.094 //l=0.22 //layer=ply \
 //thickness=0.18 //x=1.675 //y=0.9 //x2=1.455 //y2=0.9
r682 (  149 206 ) resistor r=58.7805 //w=0.246 //l=0.373497 //layer=ply \
 //thickness=0.18 //x=1.3 //y=2.095 //x2=1.6 //y2=2.26
r683 (  148 204 ) resistor r=39.5823 //w=0.21 //l=0.173853 //layer=ply \
 //thickness=0.18 //x=1.3 //y=1.71 //x2=1.34 //y2=1.555
r684 (  148 149 ) resistor r=197.415 //w=0.094 //l=0.385 //layer=ply \
 //thickness=0.18 //x=1.3 //y=1.71 //x2=1.3 //y2=2.095
r685 (  147 204 ) resistor r=39.5823 //w=0.21 //l=0.173853 //layer=ply \
 //thickness=0.18 //x=1.3 //y=1.4 //x2=1.34 //y2=1.555
r686 (  146 203 ) resistor r=45.1352 //w=0.168 //l=0.173853 //layer=ply \
 //thickness=0.18 //x=1.3 //y=1.055 //x2=1.34 //y2=0.9
r687 (  146 147 ) resistor r=176.904 //w=0.094 //l=0.345 //layer=ply \
 //thickness=0.18 //x=1.3 //y=1.055 //x2=1.3 //y2=1.4
r688 (  145 200 ) resistor r=592.245 //w=0.094 //l=1.155 //layer=ply \
 //thickness=0.18 //x=59.96 //y=6.2 //x2=59.96 //y2=5.045
r689 (  144 193 ) resistor r=592.245 //w=0.094 //l=1.155 //layer=ply \
 //thickness=0.18 //x=59.52 //y=6.2 //x2=59.52 //y2=5.045
r690 (  143 181 ) resistor r=592.245 //w=0.094 //l=1.155 //layer=ply \
 //thickness=0.18 //x=31.1 //y=6.2 //x2=31.1 //y2=5.045
r691 (  142 174 ) resistor r=592.245 //w=0.094 //l=1.155 //layer=ply \
 //thickness=0.18 //x=30.66 //y=6.2 //x2=30.66 //y2=5.045
r692 (  141 162 ) resistor r=592.245 //w=0.094 //l=1.155 //layer=ply \
 //thickness=0.18 //x=2.24 //y=6.2 //x2=2.24 //y2=5.045
r693 (  140 155 ) resistor r=592.245 //w=0.094 //l=1.155 //layer=ply \
 //thickness=0.18 //x=1.8 //y=6.2 //x2=1.8 //y2=5.045
r694 (  139 190 ) resistor r=56.4043 //w=0.094 //l=0.11 //layer=ply \
 //thickness=0.18 //x=59.285 //y=1.555 //x2=59.395 //y2=1.555
r695 (  139 191 ) resistor r=56.4043 //w=0.094 //l=0.11 //layer=ply \
 //thickness=0.18 //x=59.285 //y=1.555 //x2=59.175 //y2=1.555
r696 (  138 171 ) resistor r=56.4043 //w=0.094 //l=0.11 //layer=ply \
 //thickness=0.18 //x=30.425 //y=1.555 //x2=30.535 //y2=1.555
r697 (  138 172 ) resistor r=56.4043 //w=0.094 //l=0.11 //layer=ply \
 //thickness=0.18 //x=30.425 //y=1.555 //x2=30.315 //y2=1.555
r698 (  137 152 ) resistor r=56.4043 //w=0.094 //l=0.11 //layer=ply \
 //thickness=0.18 //x=1.565 //y=1.555 //x2=1.675 //y2=1.555
r699 (  137 153 ) resistor r=56.4043 //w=0.094 //l=0.11 //layer=ply \
 //thickness=0.18 //x=1.565 //y=1.555 //x2=1.455 //y2=1.555
r700 (  133 224 ) resistor r=152 //w=0.17 //l=0.17 //layer=licon //count=1 \
 //x=59.32 //y=4.88 //x2=59.32 //y2=4.88
r701 (  124 222 ) resistor r=152 //w=0.17 //l=0.17 //layer=licon //count=1 \
 //x=59.32 //y=2.26 //x2=59.32 //y2=2.26
r702 (  119 216 ) resistor r=152 //w=0.17 //l=0.17 //layer=licon //count=1 \
 //x=30.46 //y=4.88 //x2=30.46 //y2=4.88
r703 (  110 214 ) resistor r=152 //w=0.17 //l=0.17 //layer=licon //count=1 \
 //x=30.46 //y=2.26 //x2=30.46 //y2=2.26
r704 (  105 208 ) resistor r=152 //w=0.17 //l=0.17 //layer=licon //count=1 \
 //x=1.6 //y=4.88 //x2=1.6 //y2=4.88
r705 (  96 206 ) resistor r=152 //w=0.17 //l=0.17 //layer=licon //count=1 \
 //x=1.6 //y=2.26 //x2=1.6 //y2=2.26
r706 (  88 90 ) resistor r=0.10734 //w=0.281 //l=0.16 //layer=m2 \
 //thickness=0.36 //x=1.6 //y=4.26 //x2=1.76 //y2=4.26
r707 (  85 94 ) resistor r=1.5723 //w=0.189 //l=2.38498 //layer=m2 \
 //thickness=0.36 //x=56.945 //y=4.27 //x2=59.32 //y2=4.25
r708 (  85 86 ) resistor r=0.329198 //w=0.131 //l=0.345 //layer=m2 \
 //thickness=0.36 //x=56.945 //y=4.27 //x2=56.6 //y2=4.27
r709 (  83 86 ) resistor r=0.1875 //w=0.17 //l=0.264811 //layer=m2 \
 //thickness=0.36 //x=56.345 //y=4.25 //x2=56.6 //y2=4.27
r710 (  83 84 ) resistor r=7.74809 //w=0.131 //l=8.12 //layer=m2 \
 //thickness=0.36 //x=56.345 //y=4.25 //x2=48.225 //y2=4.25
r711 (  81 84 ) resistor r=0.125 //w=0.17 //l=0.184391 //layer=m2 \
 //thickness=0.36 //x=48.055 //y=4.28 //x2=48.225 //y2=4.25
r712 (  81 82 ) resistor r=0.329198 //w=0.131 //l=0.345 //layer=m2 \
 //thickness=0.36 //x=48.055 //y=4.28 //x2=47.71 //y2=4.28
r713 (  79 82 ) resistor r=0.1875 //w=0.17 //l=0.269583 //layer=m2 \
 //thickness=0.36 //x=47.455 //y=4.25 //x2=47.71 //y2=4.28
r714 (  79 80 ) resistor r=4.49905 //w=0.131 //l=4.715 //layer=m2 \
 //thickness=0.36 //x=47.455 //y=4.25 //x2=42.74 //y2=4.25
r715 (  77 80 ) resistor r=0.088848 //w=0.204 //l=0.168152 //layer=m2 \
 //thickness=0.36 //x=42.595 //y=4.3 //x2=42.74 //y2=4.25
r716 (  77 78 ) resistor r=0.736386 //w=0.101 //l=0.595 //layer=m2 \
 //thickness=0.36 //x=42.595 //y=4.3 //x2=42 //y2=4.3
r717 (  76 92 ) resistor r=4.89347 //w=0.176 //l=6.91246 //layer=m2 \
 //thickness=0.36 //x=37.36 //y=4.28 //x2=30.47 //y2=4.235
r718 (  75 78 ) resistor r=3.12137 //w=0.172 //l=4.30499 //layer=m2 \
 //thickness=0.36 //x=37.705 //y=4.28 //x2=42 //y2=4.3
r719 (  75 76 ) resistor r=0.329198 //w=0.131 //l=0.345 //layer=m2 \
 //thickness=0.36 //x=37.705 //y=4.28 //x2=37.36 //y2=4.28
r720 (  73 92 ) resistor r=1.69389 //w=0.176 //l=2.40244 //layer=m2 \
 //thickness=0.36 //x=28.085 //y=4.27 //x2=30.47 //y2=4.235
r721 (  73 74 ) resistor r=0.329198 //w=0.131 //l=0.345 //layer=m2 \
 //thickness=0.36 //x=28.085 //y=4.27 //x2=27.74 //y2=4.27
r722 (  71 74 ) resistor r=0.1875 //w=0.17 //l=0.264811 //layer=m2 \
 //thickness=0.36 //x=27.485 //y=4.25 //x2=27.74 //y2=4.27
r723 (  71 72 ) resistor r=7.74809 //w=0.131 //l=8.12 //layer=m2 \
 //thickness=0.36 //x=27.485 //y=4.25 //x2=19.365 //y2=4.25
r724 (  69 72 ) resistor r=0.125 //w=0.17 //l=0.184391 //layer=m2 \
 //thickness=0.36 //x=19.195 //y=4.28 //x2=19.365 //y2=4.25
r725 (  69 70 ) resistor r=0.329198 //w=0.131 //l=0.345 //layer=m2 \
 //thickness=0.36 //x=19.195 //y=4.28 //x2=18.85 //y2=4.28
r726 (  67 70 ) resistor r=0.1875 //w=0.17 //l=0.269583 //layer=m2 \
 //thickness=0.36 //x=18.595 //y=4.25 //x2=18.85 //y2=4.28
r727 (  67 68 ) resistor r=4.49905 //w=0.131 //l=4.715 //layer=m2 \
 //thickness=0.36 //x=18.595 //y=4.25 //x2=13.88 //y2=4.25
r728 (  65 68 ) resistor r=0.14881 //w=0.189 //l=0.253229 //layer=m2 \
 //thickness=0.36 //x=13.655 //y=4.31 //x2=13.88 //y2=4.25
r729 (  65 66 ) resistor r=0.329198 //w=0.131 //l=0.345 //layer=m2 \
 //thickness=0.36 //x=13.655 //y=4.31 //x2=13.31 //y2=4.31
r730 (  63 66 ) resistor r=3.26389 //w=0.171 //l=4.47998 //layer=m2 \
 //thickness=0.36 //x=8.845 //y=4.28 //x2=13.31 //y2=4.31
r731 (  63 64 ) resistor r=0.329198 //w=0.131 //l=0.345 //layer=m2 \
 //thickness=0.36 //x=8.845 //y=4.28 //x2=8.5 //y2=4.28
r732 (  61 64 ) resistor r=0.1875 //w=0.17 //l=0.269583 //layer=m2 \
 //thickness=0.36 //x=8.245 //y=4.25 //x2=8.5 //y2=4.28
r733 (  61 90 ) resistor r=6.18798 //w=0.131 //l=6.485 //layer=m2 \
 //thickness=0.36 //x=8.245 //y=4.25 //x2=1.76 //y2=4.25
r734 (  60 133 ) resistor r=9.3 //w=0.17 //l=0.17 //layer=mcon //count=1 \
 //x=59.32 //y=4.88 //x2=59.32 //y2=4.88
r735 (  58 124 ) resistor r=9.3 //w=0.17 //l=0.17 //layer=mcon //count=1 \
 //x=59.32 //y=2.26 //x2=59.32 //y2=2.26
r736 (  51 92 ) resistor r=4.5 //w=0.15 //l=0.15 //layer=via1 //count=1 \
 //x=30.47 //y=4.235 //x2=30.47 //y2=4.235
r737 (  49 119 ) resistor r=9.3 //w=0.17 //l=0.17 //layer=mcon //count=1 \
 //x=30.46 //y=4.88 //x2=30.46 //y2=4.88
r738 (  47 110 ) resistor r=9.3 //w=0.17 //l=0.17 //layer=mcon //count=1 \
 //x=30.46 //y=2.26 //x2=30.46 //y2=2.26
r739 (  45 105 ) resistor r=9.3 //w=0.17 //l=0.17 //layer=mcon //count=1 \
 //x=1.6 //y=4.88 //x2=1.6 //y2=4.88
r740 (  43 96 ) resistor r=9.3 //w=0.17 //l=0.17 //layer=mcon //count=1 \
 //x=1.6 //y=2.26 //x2=1.6 //y2=2.26
r741 (  41 88 ) resistor r=4.5 //w=0.15 //l=0.15 //layer=via1 //count=1 \
 //x=1.6 //y=4.26 //x2=1.6 //y2=4.26
r742 (  37 60 ) resistor r=0.0760407 //w=0.238 //l=0.125 //layer=m1 \
 //thickness=0.36 //x=59.32 //y=4.755 //x2=59.32 //y2=4.88
r743 (  36 37 ) resistor r=0.329198 //w=0.131 //l=0.345 //layer=m1 \
 //thickness=0.36 //x=59.32 //y=4.41 //x2=59.32 //y2=4.755
r744 (  32 58 ) resistor r=0.0719237 //w=0.222 //l=0.115 //layer=m1 \
 //thickness=0.36 //x=59.32 //y=2.375 //x2=59.32 //y2=2.26
r745 (  31 49 ) resistor r=0.0760407 //w=0.238 //l=0.125 //layer=m1 \
 //thickness=0.36 //x=30.46 //y=4.755 //x2=30.46 //y2=4.88
r746 (  30 31 ) resistor r=0.343511 //w=0.131 //l=0.36 //layer=m1 \
 //thickness=0.36 //x=30.46 //y=4.395 //x2=30.46 //y2=4.755
r747 (  26 51 ) resistor r=0.0909648 //w=0.371 //l=0.186333 //layer=m1 \
 //thickness=0.36 //x=30.46 //y=4.075 //x2=30.517 //y2=4.235
r748 (  25 47 ) resistor r=0.0719237 //w=0.222 //l=0.115 //layer=m1 \
 //thickness=0.36 //x=30.46 //y=2.375 //x2=30.46 //y2=2.26
r749 (  23 45 ) resistor r=0.0760407 //w=0.238 //l=0.125 //layer=m1 \
 //thickness=0.36 //x=1.6 //y=4.755 //x2=1.6 //y2=4.88
r750 (  22 41 ) resistor r=0.0911593 //w=0.376 //l=0.184608 //layer=m1 \
 //thickness=0.36 //x=1.6 //y=4.42 //x2=1.547 //y2=4.26
r751 (  15 43 ) resistor r=0.0719237 //w=0.222 //l=0.115 //layer=m1 \
 //thickness=0.36 //x=1.6 //y=2.375 //x2=1.6 //y2=2.26
r752 (  14 94 ) resistor r=4.5 //w=0.15 //l=0.15 //layer=via1 //count=1 \
 //x=59.32 //y=4.25 //x2=59.32 //y2=4.25
r753 (  14 36 ) resistor r=0.0911593 //w=0.376 //l=0.184608 //layer=m1 \
 //thickness=0.36 //x=59.267 //y=4.25 //x2=59.32 //y2=4.41
r754 (  14 33 ) resistor r=0.0911593 //w=0.376 //l=0.184608 //layer=m1 \
 //thickness=0.36 //x=59.267 //y=4.25 //x2=59.32 //y2=4.09
r755 (  13 30 ) resistor r=0.0859108 //w=0.371 //l=0.171143 //layer=m1 \
 //thickness=0.36 //x=30.517 //y=4.25 //x2=30.46 //y2=4.395
r756 (  13 51 ) resistor r=0.00505391 //w=0.371 //l=0.015 //layer=m1 \
 //thickness=0.36 //x=30.517 //y=4.25 //x2=30.517 //y2=4.235
r757 (  12 41 ) resistor r=0.00332447 //w=0.376 //l=0.01 //layer=m1 \
 //thickness=0.36 //x=1.547 //y=4.25 //x2=1.547 //y2=4.26
r758 (  12 16 ) resistor r=0.0878349 //w=0.376 //l=0.174499 //layer=m1 \
 //thickness=0.36 //x=1.547 //y=4.25 //x2=1.6 //y2=4.1
r759 (  11 33 ) resistor r=0.553435 //w=0.131 //l=0.58 //layer=m1 \
 //thickness=0.36 //x=59.32 //y=3.51 //x2=59.32 //y2=4.09
r760 (  10 11 ) resistor r=0.706107 //w=0.131 //l=0.74 //layer=m1 \
 //thickness=0.36 //x=59.32 //y=2.77 //x2=59.32 //y2=3.51
r761 (  10 32 ) resistor r=0.376908 //w=0.131 //l=0.395 //layer=m1 \
 //thickness=0.36 //x=59.32 //y=2.77 //x2=59.32 //y2=2.375
r762 (  9 26 ) resistor r=0.186069 //w=0.131 //l=0.195 //layer=m1 \
 //thickness=0.36 //x=30.46 //y=3.88 //x2=30.46 //y2=4.075
r763 (  8 9 ) resistor r=0.353053 //w=0.131 //l=0.37 //layer=m1 \
 //thickness=0.36 //x=30.46 //y=3.51 //x2=30.46 //y2=3.88
r764 (  7 8 ) resistor r=0.706107 //w=0.131 //l=0.74 //layer=m1 \
 //thickness=0.36 //x=30.46 //y=2.77 //x2=30.46 //y2=3.51
r765 (  7 25 ) resistor r=0.376908 //w=0.131 //l=0.395 //layer=m1 \
 //thickness=0.36 //x=30.46 //y=2.77 //x2=30.46 //y2=2.375
r766 (  6 23 ) resistor r=0.128817 //w=0.131 //l=0.135 //layer=m1 \
 //thickness=0.36 //x=1.6 //y=4.62 //x2=1.6 //y2=4.755
r767 (  6 22 ) resistor r=0.19084 //w=0.131 //l=0.2 //layer=m1 \
 //thickness=0.36 //x=1.6 //y=4.62 //x2=1.6 //y2=4.42
r768 (  5 16 ) resistor r=0.209924 //w=0.131 //l=0.22 //layer=m1 \
 //thickness=0.36 //x=1.6 //y=3.88 //x2=1.6 //y2=4.1
r769 (  4 5 ) resistor r=0.353053 //w=0.131 //l=0.37 //layer=m1 \
 //thickness=0.36 //x=1.6 //y=3.51 //x2=1.6 //y2=3.88
r770 (  3 4 ) resistor r=0.353053 //w=0.131 //l=0.37 //layer=m1 \
 //thickness=0.36 //x=1.6 //y=3.14 //x2=1.6 //y2=3.51
r771 (  2 3 ) resistor r=0.353053 //w=0.131 //l=0.37 //layer=m1 \
 //thickness=0.36 //x=1.6 //y=2.77 //x2=1.6 //y2=3.14
r772 (  1 2 ) resistor r=0.353053 //w=0.131 //l=0.37 //layer=m1 \
 //thickness=0.36 //x=1.6 //y=2.4 //x2=1.6 //y2=2.77
r773 (  1 15 ) resistor r=0.023855 //w=0.131 //l=0.025 //layer=m1 \
 //thickness=0.36 //x=1.6 //y=2.4 //x2=1.6 //y2=2.375
ends PM_TMRDFFSNRNQX1\%D

subckt PM_TMRDFFSNRNQX1\%noxref_13 ( 1 3 6 7 9 10 11 12 14 15 16 17 18 19 20 \
 21 22 23 24 25 28 31 37 45 49 63 66 67 69 70 73 81 89 106 115 120 129 133 134 \
 135 136 137 138 139 140 141 142 143 145 151 152 153 154 158 159 160 161 162 \
 164 170 171 172 173 193 195 196 197 )
c439 ( 193 0 ) capacitor c=0.00885916f //x=61.605 //y=1.095
c440 ( 173 0 ) capacitor c=0.0612936f //x=69.215 //y=4.97
c441 ( 172 0 ) capacitor c=0.0376642f //x=69.505 //y=4.97
c442 ( 171 0 ) capacitor c=0.0346489f //x=69.17 //y=1.4
c443 ( 170 0 ) capacitor c=0.018692f //x=69.17 //y=1.055
c444 ( 164 0 ) capacitor c=0.0137077f //x=69.015 //y=1.555
c445 ( 162 0 ) capacitor c=0.0158585f //x=69.015 //y=0.9
c446 ( 161 0 ) capacitor c=0.0979536f //x=68.64 //y=2.095
c447 ( 160 0 ) capacitor c=0.0229444f //x=68.64 //y=1.71
c448 ( 159 0 ) capacitor c=0.0234359f //x=68.64 //y=1.4
c449 ( 158 0 ) capacitor c=0.019815f //x=68.64 //y=1.055
c450 ( 154 0 ) capacitor c=0.0614625f //x=64.405 //y=4.97
c451 ( 153 0 ) capacitor c=0.0376642f //x=64.695 //y=4.97
c452 ( 152 0 ) capacitor c=0.0346489f //x=64.36 //y=1.4
c453 ( 151 0 ) capacitor c=0.018692f //x=64.36 //y=1.055
c454 ( 145 0 ) capacitor c=0.0137077f //x=64.205 //y=1.555
c455 ( 143 0 ) capacitor c=0.0158585f //x=64.205 //y=0.9
c456 ( 142 0 ) capacitor c=0.0996161f //x=63.83 //y=2.095
c457 ( 141 0 ) capacitor c=0.0229444f //x=63.83 //y=1.71
c458 ( 140 0 ) capacitor c=0.0234359f //x=63.83 //y=1.4
c459 ( 139 0 ) capacitor c=0.019815f //x=63.83 //y=1.055
c460 ( 138 0 ) capacitor c=0.110208f //x=69.58 //y=6.2
c461 ( 137 0 ) capacitor c=0.158957f //x=69.14 //y=6.2
c462 ( 136 0 ) capacitor c=0.110229f //x=64.77 //y=6.2
c463 ( 135 0 ) capacitor c=0.158957f //x=64.33 //y=6.2
c464 ( 129 0 ) capacitor c=0.00159026f //x=68.94 //y=4.88
c465 ( 120 0 ) capacitor c=9.93222e-19 //x=68.94 //y=2.26
c466 ( 115 0 ) capacitor c=0.00157452f //x=64.13 //y=4.88
c467 ( 106 0 ) capacitor c=9.93222e-19 //x=64.13 //y=2.26
c468 ( 89 0 ) capacitor c=0.0293562f //x=61.5 //y=5.56
c469 ( 81 0 ) capacitor c=0.029137f //x=60.62 //y=5.56
c470 ( 73 0 ) capacitor c=0.0278099f //x=59.74 //y=5.56
c471 ( 70 0 ) capacitor c=0.0392804f //x=68.78 //y=2.785
c472 ( 69 0 ) capacitor c=5.7546e-19 //x=68.94 //y=2.785
c473 ( 67 0 ) capacitor c=5.7546e-19 //x=64.295 //y=2.785
c474 ( 66 0 ) capacitor c=0.016756f //x=63.975 //y=2.785
c475 ( 63 0 ) capacitor c=9.56892e-19 //x=62.445 //y=2.785
c476 ( 49 0 ) capacitor c=0.0154699f //x=68.94 //y=2.77
c477 ( 45 0 ) capacitor c=0.0148628f //x=64.13 //y=2.77
c478 ( 37 0 ) capacitor c=0.0144706f //x=62.28 //y=2.77
c479 ( 31 0 ) capacitor c=9.37498e-19 //x=61.5 //y=5.335
c480 ( 28 0 ) capacitor c=0.0076134f //x=60.62 //y=5.335
c481 ( 25 0 ) capacitor c=0.0109203f //x=59.742 //y=5.335
c482 ( 24 0 ) capacitor c=0.0552261f //x=68.94 //y=4.755
c483 ( 23 0 ) capacitor c=0.0130763f //x=68.94 //y=2.945
c484 ( 22 0 ) capacitor c=0.00473602f //x=68.94 //y=2.625
c485 ( 21 0 ) capacitor c=0.00495287f //x=68.94 //y=2.375
c486 ( 20 0 ) capacitor c=0.0593148f //x=64.13 //y=4.755
c487 ( 19 0 ) capacitor c=0.0129478f //x=64.13 //y=2.945
c488 ( 18 0 ) capacitor c=0.00482124f //x=64.13 //y=2.625
c489 ( 17 0 ) capacitor c=0.00495287f //x=64.13 //y=2.375
c490 ( 16 0 ) capacitor c=0.0647359f //x=62.28 //y=5.25
c491 ( 15 0 ) capacitor c=0.0123004f //x=62.28 //y=2.945
c492 ( 14 0 ) capacitor c=0.0179579f //x=62.28 //y=2.625
c493 ( 12 0 ) capacitor c=0.0047266f //x=61.88 //y=1.845
c494 ( 11 0 ) capacitor c=0.0129788f //x=62.195 //y=1.845
c495 ( 10 0 ) capacitor c=0.0167992f //x=61.795 //y=1.76
c496 ( 9 0 ) capacitor c=0.0110957f //x=61.795 //y=1.305
c497 ( 7 0 ) capacitor c=0.0202915f //x=62.195 //y=5.335
c498 ( 6 0 ) capacitor c=0.00933983f //x=61.5 //y=5.56
c499 ( 3 0 ) capacitor c=0.0192055f //x=61.385 //y=5.335
c500 ( 1 0 ) capacitor c=0.0149267f //x=60.5 //y=5.335
r501 (  172 174 ) resistor r=26.9307 //w=0.15 //l=0.106066 //layer=ply \
 //thickness=0.18 //x=69.505 //y=4.97 //x2=69.58 //y2=5.045
r502 (  172 173 ) resistor r=148.702 //w=0.094 //l=0.29 //layer=ply \
 //thickness=0.18 //x=69.505 //y=4.97 //x2=69.215 //y2=4.97
r503 (  171 192 ) resistor r=45.1352 //w=0.168 //l=0.173853 //layer=ply \
 //thickness=0.18 //x=69.17 //y=1.4 //x2=69.13 //y2=1.555
r504 (  170 191 ) resistor r=45.1352 //w=0.168 //l=0.173853 //layer=ply \
 //thickness=0.18 //x=69.17 //y=1.055 //x2=69.13 //y2=0.9
r505 (  170 171 ) resistor r=176.904 //w=0.094 //l=0.345 //layer=ply \
 //thickness=0.18 //x=69.17 //y=1.055 //x2=69.17 //y2=1.4
r506 (  167 173 ) resistor r=22.7971 //w=0.269 //l=0.106066 //layer=ply \
 //thickness=0.18 //x=69.14 //y=5.045 //x2=69.215 //y2=4.97
r507 (  167 190 ) resistor r=35.8364 //w=0.269 //l=0.270185 //layer=ply \
 //thickness=0.18 //x=69.14 //y=5.045 //x2=68.94 //y2=4.88
r508 (  165 186 ) resistor r=10.701 //w=0.21 //l=0.115 //layer=ply \
 //thickness=0.18 //x=68.795 //y=1.555 //x2=68.68 //y2=1.555
r509 (  164 192 ) resistor r=5.52526 //w=0.168 //l=0.115 //layer=ply \
 //thickness=0.18 //x=69.015 //y=1.555 //x2=69.13 //y2=1.555
r510 (  163 185 ) resistor r=5.52526 //w=0.168 //l=0.115 //layer=ply \
 //thickness=0.18 //x=68.795 //y=0.9 //x2=68.68 //y2=0.9
r511 (  162 191 ) resistor r=5.52526 //w=0.168 //l=0.115 //layer=ply \
 //thickness=0.18 //x=69.015 //y=0.9 //x2=69.13 //y2=0.9
r512 (  162 163 ) resistor r=112.809 //w=0.094 //l=0.22 //layer=ply \
 //thickness=0.18 //x=69.015 //y=0.9 //x2=68.795 //y2=0.9
r513 (  161 188 ) resistor r=58.7805 //w=0.246 //l=0.373497 //layer=ply \
 //thickness=0.18 //x=68.64 //y=2.095 //x2=68.94 //y2=2.26
r514 (  160 186 ) resistor r=39.5823 //w=0.21 //l=0.173853 //layer=ply \
 //thickness=0.18 //x=68.64 //y=1.71 //x2=68.68 //y2=1.555
r515 (  160 161 ) resistor r=197.415 //w=0.094 //l=0.385 //layer=ply \
 //thickness=0.18 //x=68.64 //y=1.71 //x2=68.64 //y2=2.095
r516 (  159 186 ) resistor r=39.5823 //w=0.21 //l=0.173853 //layer=ply \
 //thickness=0.18 //x=68.64 //y=1.4 //x2=68.68 //y2=1.555
r517 (  158 185 ) resistor r=45.1352 //w=0.168 //l=0.173853 //layer=ply \
 //thickness=0.18 //x=68.64 //y=1.055 //x2=68.68 //y2=0.9
r518 (  158 159 ) resistor r=176.904 //w=0.094 //l=0.345 //layer=ply \
 //thickness=0.18 //x=68.64 //y=1.055 //x2=68.64 //y2=1.4
r519 (  153 155 ) resistor r=26.9307 //w=0.15 //l=0.106066 //layer=ply \
 //thickness=0.18 //x=64.695 //y=4.97 //x2=64.77 //y2=5.045
r520 (  153 154 ) resistor r=148.702 //w=0.094 //l=0.29 //layer=ply \
 //thickness=0.18 //x=64.695 //y=4.97 //x2=64.405 //y2=4.97
r521 (  152 184 ) resistor r=45.1352 //w=0.168 //l=0.173853 //layer=ply \
 //thickness=0.18 //x=64.36 //y=1.4 //x2=64.32 //y2=1.555
r522 (  151 183 ) resistor r=45.1352 //w=0.168 //l=0.173853 //layer=ply \
 //thickness=0.18 //x=64.36 //y=1.055 //x2=64.32 //y2=0.9
r523 (  151 152 ) resistor r=176.904 //w=0.094 //l=0.345 //layer=ply \
 //thickness=0.18 //x=64.36 //y=1.055 //x2=64.36 //y2=1.4
r524 (  148 154 ) resistor r=22.7971 //w=0.269 //l=0.106066 //layer=ply \
 //thickness=0.18 //x=64.33 //y=5.045 //x2=64.405 //y2=4.97
r525 (  148 182 ) resistor r=35.8364 //w=0.269 //l=0.270185 //layer=ply \
 //thickness=0.18 //x=64.33 //y=5.045 //x2=64.13 //y2=4.88
r526 (  146 178 ) resistor r=10.701 //w=0.21 //l=0.115 //layer=ply \
 //thickness=0.18 //x=63.985 //y=1.555 //x2=63.87 //y2=1.555
r527 (  145 184 ) resistor r=5.52526 //w=0.168 //l=0.115 //layer=ply \
 //thickness=0.18 //x=64.205 //y=1.555 //x2=64.32 //y2=1.555
r528 (  144 177 ) resistor r=5.52526 //w=0.168 //l=0.115 //layer=ply \
 //thickness=0.18 //x=63.985 //y=0.9 //x2=63.87 //y2=0.9
r529 (  143 183 ) resistor r=5.52526 //w=0.168 //l=0.115 //layer=ply \
 //thickness=0.18 //x=64.205 //y=0.9 //x2=64.32 //y2=0.9
r530 (  143 144 ) resistor r=112.809 //w=0.094 //l=0.22 //layer=ply \
 //thickness=0.18 //x=64.205 //y=0.9 //x2=63.985 //y2=0.9
r531 (  142 180 ) resistor r=58.7805 //w=0.246 //l=0.373497 //layer=ply \
 //thickness=0.18 //x=63.83 //y=2.095 //x2=64.13 //y2=2.26
r532 (  141 178 ) resistor r=39.5823 //w=0.21 //l=0.173853 //layer=ply \
 //thickness=0.18 //x=63.83 //y=1.71 //x2=63.87 //y2=1.555
r533 (  141 142 ) resistor r=197.415 //w=0.094 //l=0.385 //layer=ply \
 //thickness=0.18 //x=63.83 //y=1.71 //x2=63.83 //y2=2.095
r534 (  140 178 ) resistor r=39.5823 //w=0.21 //l=0.173853 //layer=ply \
 //thickness=0.18 //x=63.83 //y=1.4 //x2=63.87 //y2=1.555
r535 (  139 177 ) resistor r=45.1352 //w=0.168 //l=0.173853 //layer=ply \
 //thickness=0.18 //x=63.83 //y=1.055 //x2=63.87 //y2=0.9
r536 (  139 140 ) resistor r=176.904 //w=0.094 //l=0.345 //layer=ply \
 //thickness=0.18 //x=63.83 //y=1.055 //x2=63.83 //y2=1.4
r537 (  138 174 ) resistor r=592.245 //w=0.094 //l=1.155 //layer=ply \
 //thickness=0.18 //x=69.58 //y=6.2 //x2=69.58 //y2=5.045
r538 (  137 167 ) resistor r=592.245 //w=0.094 //l=1.155 //layer=ply \
 //thickness=0.18 //x=69.14 //y=6.2 //x2=69.14 //y2=5.045
r539 (  136 155 ) resistor r=592.245 //w=0.094 //l=1.155 //layer=ply \
 //thickness=0.18 //x=64.77 //y=6.2 //x2=64.77 //y2=5.045
r540 (  135 148 ) resistor r=592.245 //w=0.094 //l=1.155 //layer=ply \
 //thickness=0.18 //x=64.33 //y=6.2 //x2=64.33 //y2=5.045
r541 (  134 164 ) resistor r=56.4043 //w=0.094 //l=0.11 //layer=ply \
 //thickness=0.18 //x=68.905 //y=1.555 //x2=69.015 //y2=1.555
r542 (  134 165 ) resistor r=56.4043 //w=0.094 //l=0.11 //layer=ply \
 //thickness=0.18 //x=68.905 //y=1.555 //x2=68.795 //y2=1.555
r543 (  133 145 ) resistor r=56.4043 //w=0.094 //l=0.11 //layer=ply \
 //thickness=0.18 //x=64.095 //y=1.555 //x2=64.205 //y2=1.555
r544 (  133 146 ) resistor r=56.4043 //w=0.094 //l=0.11 //layer=ply \
 //thickness=0.18 //x=64.095 //y=1.555 //x2=63.985 //y2=1.555
r545 (  129 190 ) resistor r=152 //w=0.17 //l=0.17 //layer=licon //count=1 \
 //x=68.94 //y=4.88 //x2=68.94 //y2=4.88
r546 (  120 188 ) resistor r=152 //w=0.17 //l=0.17 //layer=licon //count=1 \
 //x=68.94 //y=2.26 //x2=68.94 //y2=2.26
r547 (  115 182 ) resistor r=152 //w=0.17 //l=0.17 //layer=licon //count=1 \
 //x=64.13 //y=4.88 //x2=64.13 //y2=4.88
r548 (  106 180 ) resistor r=152 //w=0.17 //l=0.17 //layer=licon //count=1 \
 //x=64.13 //y=2.26 //x2=64.13 //y2=2.26
r549 (  89 197 ) resistor r=23.615 //w=0.187 //l=0.345 //layer=li \
 //thickness=0.1 //x=61.5 //y=5.56 //x2=61.5 //y2=5.905
r550 (  81 196 ) resistor r=23.615 //w=0.187 //l=0.345 //layer=li \
 //thickness=0.1 //x=60.62 //y=5.56 //x2=60.62 //y2=5.905
r551 (  73 195 ) resistor r=23.615 //w=0.187 //l=0.345 //layer=li \
 //thickness=0.1 //x=59.74 //y=5.56 //x2=59.74 //y2=5.905
r552 (  69 70 ) resistor r=0.10734 //w=0.281 //l=0.16 //layer=m2 \
 //thickness=0.36 //x=68.94 //y=2.785 //x2=68.78 //y2=2.785
r553 (  67 70 ) resistor r=4.27958 //w=0.131 //l=4.485 //layer=m2 \
 //thickness=0.36 //x=64.295 //y=2.77 //x2=68.78 //y2=2.77
r554 (  65 67 ) resistor r=0.10734 //w=0.281 //l=0.16 //layer=m2 \
 //thickness=0.36 //x=64.135 //y=2.785 //x2=64.295 //y2=2.785
r555 (  65 66 ) resistor r=0.10734 //w=0.281 //l=0.16 //layer=m2 \
 //thickness=0.36 //x=64.135 //y=2.785 //x2=63.975 //y2=2.785
r556 (  63 66 ) resistor r=1.45992 //w=0.131 //l=1.53 //layer=m2 \
 //thickness=0.36 //x=62.445 //y=2.77 //x2=63.975 //y2=2.77
r557 (  61 63 ) resistor r=0.10734 //w=0.281 //l=0.16 //layer=m2 \
 //thickness=0.36 //x=62.285 //y=2.785 //x2=62.445 //y2=2.785
r558 (  55 129 ) resistor r=9.3 //w=0.17 //l=0.17 //layer=mcon //count=1 \
 //x=68.94 //y=4.88 //x2=68.94 //y2=4.88
r559 (  53 120 ) resistor r=9.3 //w=0.17 //l=0.17 //layer=mcon //count=1 \
 //x=68.94 //y=2.26 //x2=68.94 //y2=2.26
r560 (  51 69 ) resistor r=4.5 //w=0.15 //l=0.15 //layer=via1 //count=1 \
 //x=68.94 //y=2.785 //x2=68.94 //y2=2.785
r561 (  49 51 ) resistor r=0.0049867 //w=0.376 //l=0.015 //layer=m1 \
 //thickness=0.36 //x=68.887 //y=2.77 //x2=68.887 //y2=2.785
r562 (  47 65 ) resistor r=4.5 //w=0.15 //l=0.15 //layer=via1 //count=1 \
 //x=64.135 //y=2.785 //x2=64.135 //y2=2.785
r563 (  45 47 ) resistor r=0.00501337 //w=0.374 //l=0.015 //layer=m1 \
 //thickness=0.36 //x=64.185 //y=2.77 //x2=64.185 //y2=2.785
r564 (  43 115 ) resistor r=9.3 //w=0.17 //l=0.17 //layer=mcon //count=1 \
 //x=64.13 //y=4.88 //x2=64.13 //y2=4.88
r565 (  41 106 ) resistor r=9.3 //w=0.17 //l=0.17 //layer=mcon //count=1 \
 //x=64.13 //y=2.26 //x2=64.13 //y2=2.26
r566 (  39 61 ) resistor r=4.5 //w=0.15 //l=0.15 //layer=via1 //count=1 \
 //x=62.285 //y=2.785 //x2=62.285 //y2=2.785
r567 (  37 39 ) resistor r=0.00501337 //w=0.374 //l=0.015 //layer=m1 \
 //thickness=0.36 //x=62.335 //y=2.77 //x2=62.335 //y2=2.785
r568 (  35 193 ) resistor r=9.3 //w=0.17 //l=0.17 //layer=mcon //count=1 \
 //x=61.795 //y=1.19 //x2=61.795 //y2=1.19
r569 (  33 89 ) resistor r=9.3 //w=0.17 //l=0.17 //layer=mcon //count=1 \
 //x=61.5 //y=5.56 //x2=61.5 //y2=5.56
r570 (  30 81 ) resistor r=9.3 //w=0.17 //l=0.17 //layer=mcon //count=1 \
 //x=60.62 //y=5.56 //x2=60.62 //y2=5.56
r571 (  28 30 ) resistor r=0.121228 //w=0.232 //l=0.225 //layer=m1 \
 //thickness=0.36 //x=60.62 //y=5.335 //x2=60.62 //y2=5.56
r572 (  27 73 ) resistor r=9.3 //w=0.17 //l=0.17 //layer=mcon //count=1 \
 //x=59.74 //y=5.56 //x2=59.74 //y2=5.56
r573 (  25 27 ) resistor r=0.129608 //w=0.217 //l=0.225 //layer=m1 \
 //thickness=0.36 //x=59.742 //y=5.335 //x2=59.742 //y2=5.56
r574 (  24 55 ) resistor r=0.0760407 //w=0.238 //l=0.125 //layer=m1 \
 //thickness=0.36 //x=68.94 //y=4.755 //x2=68.94 //y2=4.88
r575 (  23 51 ) resistor r=0.0911593 //w=0.376 //l=0.184608 //layer=m1 \
 //thickness=0.36 //x=68.94 //y=2.945 //x2=68.887 //y2=2.785
r576 (  23 24 ) resistor r=1.7271 //w=0.131 //l=1.81 //layer=m1 \
 //thickness=0.36 //x=68.94 //y=2.945 //x2=68.94 //y2=4.755
r577 (  22 49 ) resistor r=0.0861726 //w=0.376 //l=0.16944 //layer=m1 \
 //thickness=0.36 //x=68.94 //y=2.625 //x2=68.887 //y2=2.77
r578 (  21 53 ) resistor r=0.0719237 //w=0.222 //l=0.115 //layer=m1 \
 //thickness=0.36 //x=68.94 //y=2.375 //x2=68.94 //y2=2.26
r579 (  21 22 ) resistor r=0.23855 //w=0.131 //l=0.25 //layer=m1 \
 //thickness=0.36 //x=68.94 //y=2.375 //x2=68.94 //y2=2.625
r580 (  20 43 ) resistor r=0.0760407 //w=0.238 //l=0.125 //layer=m1 \
 //thickness=0.36 //x=64.13 //y=4.755 //x2=64.13 //y2=4.88
r581 (  19 47 ) resistor r=0.0910802 //w=0.374 //l=0.185472 //layer=m1 \
 //thickness=0.36 //x=64.13 //y=2.945 //x2=64.185 //y2=2.785
r582 (  19 20 ) resistor r=1.7271 //w=0.131 //l=1.81 //layer=m1 \
 //thickness=0.36 //x=64.13 //y=2.945 //x2=64.13 //y2=4.755
r583 (  18 45 ) resistor r=0.0860668 //w=0.374 //l=0.170294 //layer=m1 \
 //thickness=0.36 //x=64.13 //y=2.625 //x2=64.185 //y2=2.77
r584 (  17 41 ) resistor r=0.0719237 //w=0.222 //l=0.115 //layer=m1 \
 //thickness=0.36 //x=64.13 //y=2.375 //x2=64.13 //y2=2.26
r585 (  17 18 ) resistor r=0.23855 //w=0.131 //l=0.25 //layer=m1 \
 //thickness=0.36 //x=64.13 //y=2.375 //x2=64.13 //y2=2.625
r586 (  15 39 ) resistor r=0.0910802 //w=0.374 //l=0.185472 //layer=m1 \
 //thickness=0.36 //x=62.28 //y=2.945 //x2=62.335 //y2=2.785
r587 (  15 16 ) resistor r=2.19943 //w=0.131 //l=2.305 //layer=m1 \
 //thickness=0.36 //x=62.28 //y=2.945 //x2=62.28 //y2=5.25
r588 (  14 37 ) resistor r=0.0860668 //w=0.374 //l=0.170294 //layer=m1 \
 //thickness=0.36 //x=62.28 //y=2.625 //x2=62.335 //y2=2.77
r589 (  13 14 ) resistor r=0.663168 //w=0.131 //l=0.695 //layer=m1 \
 //thickness=0.36 //x=62.28 //y=1.93 //x2=62.28 //y2=2.625
r590 (  11 13 ) resistor r=0.0698411 //w=0.17 //l=0.120208 //layer=m1 \
 //thickness=0.36 //x=62.195 //y=1.845 //x2=62.28 //y2=1.93
r591 (  11 12 ) resistor r=0.300573 //w=0.131 //l=0.315 //layer=m1 \
 //thickness=0.36 //x=62.195 //y=1.845 //x2=61.88 //y2=1.845
r592 (  10 12 ) resistor r=0.0698411 //w=0.17 //l=0.120208 //layer=m1 \
 //thickness=0.36 //x=61.795 //y=1.76 //x2=61.88 //y2=1.845
r593 (  9 35 ) resistor r=0.0717383 //w=0.224 //l=0.115 //layer=m1 \
 //thickness=0.36 //x=61.795 //y=1.305 //x2=61.795 //y2=1.19
r594 (  9 10 ) resistor r=0.43416 //w=0.131 //l=0.455 //layer=m1 \
 //thickness=0.36 //x=61.795 //y=1.305 //x2=61.795 //y2=1.76
r595 (  8 31 ) resistor r=0.0675342 //w=0.23 //l=0.115 //layer=m1 \
 //thickness=0.36 //x=61.615 //y=5.335 //x2=61.5 //y2=5.335
r596 (  7 16 ) resistor r=0.0698411 //w=0.17 //l=0.120208 //layer=m1 \
 //thickness=0.36 //x=62.195 //y=5.335 //x2=62.28 //y2=5.25
r597 (  7 8 ) resistor r=0.553435 //w=0.131 //l=0.58 //layer=m1 \
 //thickness=0.36 //x=62.195 //y=5.335 //x2=61.615 //y2=5.335
r598 (  6 33 ) resistor r=0.00118313 //w=0.23 //layer=m1 //thickness=0.36 \
 //x=61.5 //y=5.56 //x2=61.5 //y2=5.56
r599 (  5 31 ) resistor r=0.002872 //w=0.34 //l=0.085 //layer=m1 \
 //thickness=0.36 //x=61.5 //y=5.42 //x2=61.5 //y2=5.335
r600 (  5 6 ) resistor r=0.091623 //w=0.191 //l=0.14 //layer=m1 \
 //thickness=0.36 //x=61.5 //y=5.42 //x2=61.5 //y2=5.56
r601 (  4 28 ) resistor r=0.0262263 //w=0.232 //l=0.12 //layer=m1 \
 //thickness=0.36 //x=60.74 //y=5.335 //x2=60.62 //y2=5.335
r602 (  3 31 ) resistor r=0.0675342 //w=0.23 //l=0.115 //layer=m1 \
 //thickness=0.36 //x=61.385 //y=5.335 //x2=61.5 //y2=5.335
r603 (  3 4 ) resistor r=0.615458 //w=0.131 //l=0.645 //layer=m1 \
 //thickness=0.36 //x=61.385 //y=5.335 //x2=60.74 //y2=5.335
r604 (  2 25 ) resistor r=0.0222262 //w=0.217 //l=0.118 //layer=m1 \
 //thickness=0.36 //x=59.86 //y=5.335 //x2=59.742 //y2=5.335
r605 (  1 28 ) resistor r=0.0262263 //w=0.232 //l=0.12 //layer=m1 \
 //thickness=0.36 //x=60.5 //y=5.335 //x2=60.62 //y2=5.335
r606 (  1 2 ) resistor r=0.610687 //w=0.131 //l=0.64 //layer=m1 \
 //thickness=0.36 //x=60.5 //y=5.335 //x2=59.86 //y2=5.335
ends PM_TMRDFFSNRNQX1\%noxref_13

subckt PM_TMRDFFSNRNQX1\%noxref_14 ( 1 3 6 7 9 10 11 12 14 15 16 17 18 19 20 \
 21 24 27 33 36 42 43 48 51 59 67 84 93 97 98 99 100 101 102 103 104 106 112 \
 113 114 115 127 129 130 131 )
c300 ( 127 0 ) capacitor c=0.00885916f //x=71.225 //y=1.095
c301 ( 115 0 ) capacitor c=0.0612936f //x=74.025 //y=4.97
c302 ( 114 0 ) capacitor c=0.0376642f //x=74.315 //y=4.97
c303 ( 113 0 ) capacitor c=0.0346489f //x=73.98 //y=1.4
c304 ( 112 0 ) capacitor c=0.018692f //x=73.98 //y=1.055
c305 ( 106 0 ) capacitor c=0.0137077f //x=73.825 //y=1.555
c306 ( 104 0 ) capacitor c=0.0158585f //x=73.825 //y=0.9
c307 ( 103 0 ) capacitor c=0.0979523f //x=73.45 //y=2.095
c308 ( 102 0 ) capacitor c=0.0229444f //x=73.45 //y=1.71
c309 ( 101 0 ) capacitor c=0.0234359f //x=73.45 //y=1.4
c310 ( 100 0 ) capacitor c=0.019815f //x=73.45 //y=1.055
c311 ( 99 0 ) capacitor c=0.110286f //x=74.39 //y=6.2
c312 ( 98 0 ) capacitor c=0.158957f //x=73.95 //y=6.2
c313 ( 93 0 ) capacitor c=0.00157756f //x=73.75 //y=4.88
c314 ( 84 0 ) capacitor c=9.93222e-19 //x=73.75 //y=2.26
c315 ( 67 0 ) capacitor c=0.0293723f //x=71.12 //y=5.56
c316 ( 59 0 ) capacitor c=0.029137f //x=70.24 //y=5.56
c317 ( 51 0 ) capacitor c=0.0278099f //x=69.36 //y=5.56
c318 ( 48 0 ) capacitor c=5.79974e-19 //x=73.76 //y=2.77
c319 ( 43 0 ) capacitor c=9.44624e-19 //x=72.06 //y=2.77
c320 ( 42 0 ) capacitor c=0.0155215f //x=73.6 //y=2.77
c321 ( 36 0 ) capacitor c=0.0146045f //x=73.75 //y=2.77
c322 ( 33 0 ) capacitor c=0.0146969f //x=71.9 //y=2.77
c323 ( 27 0 ) capacitor c=8.40513e-19 //x=71.12 //y=5.335
c324 ( 24 0 ) capacitor c=0.00712803f //x=70.24 //y=5.335
c325 ( 21 0 ) capacitor c=0.0109203f //x=69.362 //y=5.335
c326 ( 20 0 ) capacitor c=0.0604532f //x=73.75 //y=4.755
c327 ( 19 0 ) capacitor c=0.0131932f //x=73.75 //y=2.93
c328 ( 18 0 ) capacitor c=0.00432188f //x=73.75 //y=2.61
c329 ( 17 0 ) capacitor c=0.00485584f //x=73.75 //y=2.375
c330 ( 16 0 ) capacitor c=0.0631244f //x=71.9 //y=5.25
c331 ( 15 0 ) capacitor c=0.0122936f //x=71.9 //y=2.93
c332 ( 14 0 ) capacitor c=0.0181662f //x=71.9 //y=2.61
c333 ( 12 0 ) capacitor c=0.00493487f //x=71.5 //y=1.845
c334 ( 11 0 ) capacitor c=0.0129068f //x=71.815 //y=1.845
c335 ( 10 0 ) capacitor c=0.0167992f //x=71.415 //y=1.76
c336 ( 9 0 ) capacitor c=0.0112867f //x=71.415 //y=1.305
c337 ( 7 0 ) capacitor c=0.0208188f //x=71.815 //y=5.335
c338 ( 6 0 ) capacitor c=0.00933983f //x=71.12 //y=5.56
c339 ( 3 0 ) capacitor c=0.0177111f //x=71.005 //y=5.335
c340 ( 1 0 ) capacitor c=0.0148498f //x=70.12 //y=5.335
r341 (  114 116 ) resistor r=26.9307 //w=0.15 //l=0.106066 //layer=ply \
 //thickness=0.18 //x=74.315 //y=4.97 //x2=74.39 //y2=5.045
r342 (  114 115 ) resistor r=148.702 //w=0.094 //l=0.29 //layer=ply \
 //thickness=0.18 //x=74.315 //y=4.97 //x2=74.025 //y2=4.97
r343 (  113 126 ) resistor r=45.1352 //w=0.168 //l=0.173853 //layer=ply \
 //thickness=0.18 //x=73.98 //y=1.4 //x2=73.94 //y2=1.555
r344 (  112 125 ) resistor r=45.1352 //w=0.168 //l=0.173853 //layer=ply \
 //thickness=0.18 //x=73.98 //y=1.055 //x2=73.94 //y2=0.9
r345 (  112 113 ) resistor r=176.904 //w=0.094 //l=0.345 //layer=ply \
 //thickness=0.18 //x=73.98 //y=1.055 //x2=73.98 //y2=1.4
r346 (  109 115 ) resistor r=22.7971 //w=0.269 //l=0.106066 //layer=ply \
 //thickness=0.18 //x=73.95 //y=5.045 //x2=74.025 //y2=4.97
r347 (  109 124 ) resistor r=35.8364 //w=0.269 //l=0.270185 //layer=ply \
 //thickness=0.18 //x=73.95 //y=5.045 //x2=73.75 //y2=4.88
r348 (  107 120 ) resistor r=10.701 //w=0.21 //l=0.115 //layer=ply \
 //thickness=0.18 //x=73.605 //y=1.555 //x2=73.49 //y2=1.555
r349 (  106 126 ) resistor r=5.52526 //w=0.168 //l=0.115 //layer=ply \
 //thickness=0.18 //x=73.825 //y=1.555 //x2=73.94 //y2=1.555
r350 (  105 119 ) resistor r=5.52526 //w=0.168 //l=0.115 //layer=ply \
 //thickness=0.18 //x=73.605 //y=0.9 //x2=73.49 //y2=0.9
r351 (  104 125 ) resistor r=5.52526 //w=0.168 //l=0.115 //layer=ply \
 //thickness=0.18 //x=73.825 //y=0.9 //x2=73.94 //y2=0.9
r352 (  104 105 ) resistor r=112.809 //w=0.094 //l=0.22 //layer=ply \
 //thickness=0.18 //x=73.825 //y=0.9 //x2=73.605 //y2=0.9
r353 (  103 122 ) resistor r=58.7805 //w=0.246 //l=0.373497 //layer=ply \
 //thickness=0.18 //x=73.45 //y=2.095 //x2=73.75 //y2=2.26
r354 (  102 120 ) resistor r=39.5823 //w=0.21 //l=0.173853 //layer=ply \
 //thickness=0.18 //x=73.45 //y=1.71 //x2=73.49 //y2=1.555
r355 (  102 103 ) resistor r=197.415 //w=0.094 //l=0.385 //layer=ply \
 //thickness=0.18 //x=73.45 //y=1.71 //x2=73.45 //y2=2.095
r356 (  101 120 ) resistor r=39.5823 //w=0.21 //l=0.173853 //layer=ply \
 //thickness=0.18 //x=73.45 //y=1.4 //x2=73.49 //y2=1.555
r357 (  100 119 ) resistor r=45.1352 //w=0.168 //l=0.173853 //layer=ply \
 //thickness=0.18 //x=73.45 //y=1.055 //x2=73.49 //y2=0.9
r358 (  100 101 ) resistor r=176.904 //w=0.094 //l=0.345 //layer=ply \
 //thickness=0.18 //x=73.45 //y=1.055 //x2=73.45 //y2=1.4
r359 (  99 116 ) resistor r=592.245 //w=0.094 //l=1.155 //layer=ply \
 //thickness=0.18 //x=74.39 //y=6.2 //x2=74.39 //y2=5.045
r360 (  98 109 ) resistor r=592.245 //w=0.094 //l=1.155 //layer=ply \
 //thickness=0.18 //x=73.95 //y=6.2 //x2=73.95 //y2=5.045
r361 (  97 106 ) resistor r=56.4043 //w=0.094 //l=0.11 //layer=ply \
 //thickness=0.18 //x=73.715 //y=1.555 //x2=73.825 //y2=1.555
r362 (  97 107 ) resistor r=56.4043 //w=0.094 //l=0.11 //layer=ply \
 //thickness=0.18 //x=73.715 //y=1.555 //x2=73.605 //y2=1.555
r363 (  93 124 ) resistor r=152 //w=0.17 //l=0.17 //layer=licon //count=1 \
 //x=73.75 //y=4.88 //x2=73.75 //y2=4.88
r364 (  84 122 ) resistor r=152 //w=0.17 //l=0.17 //layer=licon //count=1 \
 //x=73.75 //y=2.26 //x2=73.75 //y2=2.26
r365 (  67 131 ) resistor r=23.615 //w=0.187 //l=0.345 //layer=li \
 //thickness=0.1 //x=71.12 //y=5.56 //x2=71.12 //y2=5.905
r366 (  59 130 ) resistor r=23.615 //w=0.187 //l=0.345 //layer=li \
 //thickness=0.1 //x=70.24 //y=5.56 //x2=70.24 //y2=5.905
r367 (  51 129 ) resistor r=23.615 //w=0.187 //l=0.345 //layer=li \
 //thickness=0.1 //x=69.36 //y=5.56 //x2=69.36 //y2=5.905
r368 (  43 45 ) resistor r=0.10734 //w=0.281 //l=0.16 //layer=m2 \
 //thickness=0.36 //x=72.06 //y=2.77 //x2=71.9 //y2=2.77
r369 (  42 48 ) resistor r=0.10734 //w=0.281 //l=0.16 //layer=m2 \
 //thickness=0.36 //x=73.6 //y=2.77 //x2=73.76 //y2=2.77
r370 (  42 43 ) resistor r=1.46947 //w=0.131 //l=1.54 //layer=m2 \
 //thickness=0.36 //x=73.6 //y=2.77 //x2=72.06 //y2=2.77
r371 (  41 93 ) resistor r=9.3 //w=0.17 //l=0.17 //layer=mcon //count=1 \
 //x=73.75 //y=4.88 //x2=73.75 //y2=4.88
r372 (  39 84 ) resistor r=9.3 //w=0.17 //l=0.17 //layer=mcon //count=1 \
 //x=73.75 //y=2.26 //x2=73.75 //y2=2.26
r373 (  36 48 ) resistor r=4.5 //w=0.15 //l=0.15 //layer=via1 //count=1 \
 //x=73.76 //y=2.77 //x2=73.76 //y2=2.77
r374 (  33 45 ) resistor r=4.5 //w=0.15 //l=0.15 //layer=via1 //count=1 \
 //x=71.9 //y=2.77 //x2=71.9 //y2=2.77
r375 (  31 127 ) resistor r=9.3 //w=0.17 //l=0.17 //layer=mcon //count=1 \
 //x=71.415 //y=1.19 //x2=71.415 //y2=1.19
r376 (  29 67 ) resistor r=9.3 //w=0.17 //l=0.17 //layer=mcon //count=1 \
 //x=71.12 //y=5.56 //x2=71.12 //y2=5.56
r377 (  26 59 ) resistor r=9.3 //w=0.17 //l=0.17 //layer=mcon //count=1 \
 //x=70.24 //y=5.56 //x2=70.24 //y2=5.56
r378 (  24 26 ) resistor r=0.121228 //w=0.232 //l=0.225 //layer=m1 \
 //thickness=0.36 //x=70.24 //y=5.335 //x2=70.24 //y2=5.56
r379 (  23 51 ) resistor r=9.3 //w=0.17 //l=0.17 //layer=mcon //count=1 \
 //x=69.36 //y=5.56 //x2=69.36 //y2=5.56
r380 (  21 23 ) resistor r=0.129608 //w=0.217 //l=0.225 //layer=m1 \
 //thickness=0.36 //x=69.362 //y=5.335 //x2=69.362 //y2=5.56
r381 (  20 41 ) resistor r=0.0760407 //w=0.238 //l=0.125 //layer=m1 \
 //thickness=0.36 //x=73.75 //y=4.755 //x2=73.75 //y2=4.88
r382 (  19 36 ) resistor r=0.0914072 //w=0.382 //l=0.182428 //layer=m1 \
 //thickness=0.36 //x=73.75 //y=2.93 //x2=73.702 //y2=2.77
r383 (  19 20 ) resistor r=1.74141 //w=0.131 //l=1.825 //layer=m1 \
 //thickness=0.36 //x=73.75 //y=2.93 //x2=73.75 //y2=4.755
r384 (  18 36 ) resistor r=0.0914072 //w=0.382 //l=0.182428 //layer=m1 \
 //thickness=0.36 //x=73.75 //y=2.61 //x2=73.702 //y2=2.77
r385 (  17 39 ) resistor r=0.0719237 //w=0.222 //l=0.115 //layer=m1 \
 //thickness=0.36 //x=73.75 //y=2.375 //x2=73.75 //y2=2.26
r386 (  17 18 ) resistor r=0.224237 //w=0.131 //l=0.235 //layer=m1 \
 //thickness=0.36 //x=73.75 //y=2.375 //x2=73.75 //y2=2.61
r387 (  15 33 ) resistor r=0.0911593 //w=0.376 //l=0.184174 //layer=m1 \
 //thickness=0.36 //x=71.9 //y=2.93 //x2=71.952 //y2=2.77
r388 (  15 16 ) resistor r=2.21374 //w=0.131 //l=2.32 //layer=m1 \
 //thickness=0.36 //x=71.9 //y=2.93 //x2=71.9 //y2=5.25
r389 (  14 33 ) resistor r=0.0911593 //w=0.376 //l=0.184174 //layer=m1 \
 //thickness=0.36 //x=71.9 //y=2.61 //x2=71.952 //y2=2.77
r390 (  13 14 ) resistor r=0.648855 //w=0.131 //l=0.68 //layer=m1 \
 //thickness=0.36 //x=71.9 //y=1.93 //x2=71.9 //y2=2.61
r391 (  11 13 ) resistor r=0.0698411 //w=0.17 //l=0.120208 //layer=m1 \
 //thickness=0.36 //x=71.815 //y=1.845 //x2=71.9 //y2=1.93
r392 (  11 12 ) resistor r=0.300573 //w=0.131 //l=0.315 //layer=m1 \
 //thickness=0.36 //x=71.815 //y=1.845 //x2=71.5 //y2=1.845
r393 (  10 12 ) resistor r=0.0698411 //w=0.17 //l=0.120208 //layer=m1 \
 //thickness=0.36 //x=71.415 //y=1.76 //x2=71.5 //y2=1.845
r394 (  9 31 ) resistor r=0.0717383 //w=0.224 //l=0.115 //layer=m1 \
 //thickness=0.36 //x=71.415 //y=1.305 //x2=71.415 //y2=1.19
r395 (  9 10 ) resistor r=0.43416 //w=0.131 //l=0.455 //layer=m1 \
 //thickness=0.36 //x=71.415 //y=1.305 //x2=71.415 //y2=1.76
r396 (  8 27 ) resistor r=0.0675342 //w=0.23 //l=0.115 //layer=m1 \
 //thickness=0.36 //x=71.235 //y=5.335 //x2=71.12 //y2=5.335
r397 (  7 16 ) resistor r=0.0698411 //w=0.17 //l=0.120208 //layer=m1 \
 //thickness=0.36 //x=71.815 //y=5.335 //x2=71.9 //y2=5.25
r398 (  7 8 ) resistor r=0.553435 //w=0.131 //l=0.58 //layer=m1 \
 //thickness=0.36 //x=71.815 //y=5.335 //x2=71.235 //y2=5.335
r399 (  6 29 ) resistor r=0.00118313 //w=0.23 //layer=m1 //thickness=0.36 \
 //x=71.12 //y=5.56 //x2=71.12 //y2=5.56
r400 (  5 27 ) resistor r=0.002872 //w=0.34 //l=0.085 //layer=m1 \
 //thickness=0.36 //x=71.12 //y=5.42 //x2=71.12 //y2=5.335
r401 (  5 6 ) resistor r=0.091623 //w=0.191 //l=0.14 //layer=m1 \
 //thickness=0.36 //x=71.12 //y=5.42 //x2=71.12 //y2=5.56
r402 (  4 24 ) resistor r=0.0262263 //w=0.232 //l=0.12 //layer=m1 \
 //thickness=0.36 //x=70.36 //y=5.335 //x2=70.24 //y2=5.335
r403 (  3 27 ) resistor r=0.0675342 //w=0.23 //l=0.115 //layer=m1 \
 //thickness=0.36 //x=71.005 //y=5.335 //x2=71.12 //y2=5.335
r404 (  3 4 ) resistor r=0.615458 //w=0.131 //l=0.645 //layer=m1 \
 //thickness=0.36 //x=71.005 //y=5.335 //x2=70.36 //y2=5.335
r405 (  2 21 ) resistor r=0.0222262 //w=0.217 //l=0.118 //layer=m1 \
 //thickness=0.36 //x=69.48 //y=5.335 //x2=69.362 //y2=5.335
r406 (  1 24 ) resistor r=0.0262263 //w=0.232 //l=0.12 //layer=m1 \
 //thickness=0.36 //x=70.12 //y=5.335 //x2=70.24 //y2=5.335
r407 (  1 2 ) resistor r=0.610687 //w=0.131 //l=0.64 //layer=m1 \
 //thickness=0.36 //x=70.12 //y=5.335 //x2=69.48 //y2=5.335
ends PM_TMRDFFSNRNQX1\%noxref_14

subckt PM_TMRDFFSNRNQX1\%CLK ( 1 2 3 4 5 6 7 8 9 10 11 12 13 18 22 26 30 33 40 \
 46 52 58 64 70 73 75 76 77 78 79 80 81 82 83 94 98 103 108 113 118 123 128 \
 133 138 143 148 153 157 158 159 160 161 162 163 164 165 166 167 168 169 170 \
 171 172 173 174 175 176 177 179 185 186 187 188 189 194 195 196 198 204 205 \
 206 207 208 213 214 215 217 223 224 225 226 227 232 233 234 236 242 243 244 \
 245 246 251 252 253 255 261 262 263 264 265 270 271 272 274 280 281 282 283 \
 284 292 303 314 325 336 347 )
c961 ( 347 0 ) capacitor c=0.0357082f //x=74.86 //y=4.88
c962 ( 336 0 ) capacitor c=0.0355326f //x=65.24 //y=4.88
c963 ( 325 0 ) capacitor c=0.0357436f //x=46 //y=4.88
c964 ( 314 0 ) capacitor c=0.0357436f //x=36.38 //y=4.88
c965 ( 303 0 ) capacitor c=0.0357436f //x=17.14 //y=4.88
c966 ( 292 0 ) capacitor c=0.0357436f //x=7.52 //y=4.88
c967 ( 284 0 ) capacitor c=0.0305218f //x=75.195 //y=4.97
c968 ( 283 0 ) capacitor c=0.0863671f //x=74.95 //y=2.095
c969 ( 282 0 ) capacitor c=0.0170266f //x=74.95 //y=1.63
c970 ( 281 0 ) capacitor c=0.018609f //x=74.95 //y=1.4
c971 ( 280 0 ) capacitor c=0.0186599f //x=74.95 //y=1.09
c972 ( 274 0 ) capacitor c=0.0146988f //x=74.795 //y=1.555
c973 ( 272 0 ) capacitor c=0.0148531f //x=74.795 //y=0.935
c974 ( 271 0 ) capacitor c=0.0334406f //x=74.425 //y=1.4
c975 ( 270 0 ) capacitor c=0.0173191f //x=74.425 //y=1.09
c976 ( 265 0 ) capacitor c=0.0306608f //x=65.575 //y=4.97
c977 ( 264 0 ) capacitor c=0.0863671f //x=65.33 //y=2.095
c978 ( 263 0 ) capacitor c=0.0170266f //x=65.33 //y=1.63
c979 ( 262 0 ) capacitor c=0.018609f //x=65.33 //y=1.4
c980 ( 261 0 ) capacitor c=0.0186599f //x=65.33 //y=1.09
c981 ( 255 0 ) capacitor c=0.0146988f //x=65.175 //y=1.555
c982 ( 253 0 ) capacitor c=0.0148531f //x=65.175 //y=0.935
c983 ( 252 0 ) capacitor c=0.0334406f //x=64.805 //y=1.4
c984 ( 251 0 ) capacitor c=0.0173191f //x=64.805 //y=1.09
c985 ( 246 0 ) capacitor c=0.0305218f //x=46.335 //y=4.97
c986 ( 245 0 ) capacitor c=0.0863671f //x=46.09 //y=2.095
c987 ( 244 0 ) capacitor c=0.0170266f //x=46.09 //y=1.63
c988 ( 243 0 ) capacitor c=0.018609f //x=46.09 //y=1.4
c989 ( 242 0 ) capacitor c=0.0186599f //x=46.09 //y=1.09
c990 ( 236 0 ) capacitor c=0.0146988f //x=45.935 //y=1.555
c991 ( 234 0 ) capacitor c=0.0148531f //x=45.935 //y=0.935
c992 ( 233 0 ) capacitor c=0.0334406f //x=45.565 //y=1.4
c993 ( 232 0 ) capacitor c=0.0173191f //x=45.565 //y=1.09
c994 ( 227 0 ) capacitor c=0.0306608f //x=36.715 //y=4.97
c995 ( 226 0 ) capacitor c=0.0863671f //x=36.47 //y=2.095
c996 ( 225 0 ) capacitor c=0.0170266f //x=36.47 //y=1.63
c997 ( 224 0 ) capacitor c=0.018609f //x=36.47 //y=1.4
c998 ( 223 0 ) capacitor c=0.0186599f //x=36.47 //y=1.09
c999 ( 217 0 ) capacitor c=0.0146988f //x=36.315 //y=1.555
c1000 ( 215 0 ) capacitor c=0.0148531f //x=36.315 //y=0.935
c1001 ( 214 0 ) capacitor c=0.0334406f //x=35.945 //y=1.4
c1002 ( 213 0 ) capacitor c=0.0173191f //x=35.945 //y=1.09
c1003 ( 208 0 ) capacitor c=0.0305218f //x=17.475 //y=4.97
c1004 ( 207 0 ) capacitor c=0.0863671f //x=17.23 //y=2.095
c1005 ( 206 0 ) capacitor c=0.0170266f //x=17.23 //y=1.63
c1006 ( 205 0 ) capacitor c=0.018609f //x=17.23 //y=1.4
c1007 ( 204 0 ) capacitor c=0.0186599f //x=17.23 //y=1.09
c1008 ( 198 0 ) capacitor c=0.0146988f //x=17.075 //y=1.555
c1009 ( 196 0 ) capacitor c=0.0148531f //x=17.075 //y=0.935
c1010 ( 195 0 ) capacitor c=0.0334406f //x=16.705 //y=1.4
c1011 ( 194 0 ) capacitor c=0.0173191f //x=16.705 //y=1.09
c1012 ( 189 0 ) capacitor c=0.0306608f //x=7.855 //y=4.97
c1013 ( 188 0 ) capacitor c=0.0863671f //x=7.61 //y=2.095
c1014 ( 187 0 ) capacitor c=0.0170266f //x=7.61 //y=1.63
c1015 ( 186 0 ) capacitor c=0.018609f //x=7.61 //y=1.4
c1016 ( 185 0 ) capacitor c=0.0186599f //x=7.61 //y=1.09
c1017 ( 179 0 ) capacitor c=0.0146988f //x=7.455 //y=1.555
c1018 ( 177 0 ) capacitor c=0.0148531f //x=7.455 //y=0.935
c1019 ( 176 0 ) capacitor c=0.0334406f //x=7.085 //y=1.4
c1020 ( 175 0 ) capacitor c=0.0173191f //x=7.085 //y=1.09
c1021 ( 174 0 ) capacitor c=0.110296f //x=75.27 //y=6.2
c1022 ( 173 0 ) capacitor c=0.110214f //x=74.83 //y=6.2
c1023 ( 172 0 ) capacitor c=0.110229f //x=65.65 //y=6.2
c1024 ( 171 0 ) capacitor c=0.110235f //x=65.21 //y=6.2
c1025 ( 170 0 ) capacitor c=0.110208f //x=46.41 //y=6.2
c1026 ( 169 0 ) capacitor c=0.110214f //x=45.97 //y=6.2
c1027 ( 168 0 ) capacitor c=0.110293f //x=36.79 //y=6.2
c1028 ( 167 0 ) capacitor c=0.110214f //x=36.35 //y=6.2
c1029 ( 166 0 ) capacitor c=0.110208f //x=17.55 //y=6.2
c1030 ( 165 0 ) capacitor c=0.110214f //x=17.11 //y=6.2
c1031 ( 164 0 ) capacitor c=0.110208f //x=7.93 //y=6.2
c1032 ( 163 0 ) capacitor c=0.110214f //x=7.49 //y=6.2
c1033 ( 153 0 ) capacitor c=0.00129935f //x=74.86 //y=4.88
c1034 ( 148 0 ) capacitor c=0.00121786f //x=74.86 //y=2.26
c1035 ( 143 0 ) capacitor c=0.00129936f //x=65.24 //y=4.88
c1036 ( 138 0 ) capacitor c=0.00121786f //x=65.24 //y=2.26
c1037 ( 133 0 ) capacitor c=0.00129935f //x=46 //y=4.88
c1038 ( 128 0 ) capacitor c=0.00121786f //x=46 //y=2.26
c1039 ( 123 0 ) capacitor c=0.00129935f //x=36.38 //y=4.88
c1040 ( 118 0 ) capacitor c=0.00121786f //x=36.38 //y=2.26
c1041 ( 113 0 ) capacitor c=0.00129935f //x=17.14 //y=4.88
c1042 ( 108 0 ) capacitor c=0.00121786f //x=17.14 //y=2.26
c1043 ( 103 0 ) capacitor c=0.00129935f //x=7.52 //y=4.88
c1044 ( 98 0 ) capacitor c=0.00121786f //x=7.52 //y=2.26
c1045 ( 94 0 ) capacitor c=0.00135422f //x=74.865 //y=4.62
c1046 ( 83 0 ) capacitor c=0.0105362f //x=7.515 //y=4.62
c1047 ( 82 0 ) capacitor c=0.0727985f //x=65.395 //y=4.62
c1048 ( 81 0 ) capacitor c=0.0884716f //x=74.705 //y=4.62
c1049 ( 80 0 ) capacitor c=0.123854f //x=59.19 //y=4.635
c1050 ( 79 0 ) capacitor c=0.00143977f //x=59.535 //y=4.635
c1051 ( 78 0 ) capacitor c=0.0738015f //x=36.535 //y=4.62
c1052 ( 77 0 ) capacitor c=0.0879978f //x=45.845 //y=4.62
c1053 ( 76 0 ) capacitor c=0.274301f //x=28.395 //y=4.61
c1054 ( 75 0 ) capacitor c=0.00248053f //x=28.825 //y=4.61
c1055 ( 73 0 ) capacitor c=0.232869f //x=16.985 //y=4.62
c1056 ( 70 0 ) capacitor c=0.00773203f //x=74.865 //y=4.835
c1057 ( 64 0 ) capacitor c=0.00797683f //x=65.235 //y=4.835
c1058 ( 58 0 ) capacitor c=0.00773203f //x=46.005 //y=4.835
c1059 ( 52 0 ) capacitor c=0.00786073f //x=36.375 //y=4.835
c1060 ( 46 0 ) capacitor c=0.0077588f //x=17.145 //y=4.835
c1061 ( 40 0 ) capacitor c=0.00779217f //x=7.515 //y=4.835
c1062 ( 33 0 ) capacitor c=0.00378707f //x=74.86 //y=2.375
c1063 ( 30 0 ) capacitor c=0.00380207f //x=65.24 //y=2.375
c1064 ( 26 0 ) capacitor c=0.00378707f //x=46 //y=2.375
c1065 ( 22 0 ) capacitor c=0.00380207f //x=36.38 //y=2.375
c1066 ( 18 0 ) capacitor c=0.00378707f //x=17.14 //y=2.375
c1067 ( 13 0 ) capacitor c=0.00380207f //x=7.52 //y=2.375
c1068 ( 11 0 ) capacitor c=0.0615601f //x=74.86 //y=2.77
c1069 ( 10 0 ) capacitor c=0.0599742f //x=65.24 //y=4.62
c1070 ( 8 0 ) capacitor c=0.0617495f //x=46 //y=2.77
c1071 ( 6 0 ) capacitor c=0.0604932f //x=36.38 //y=3.88
c1072 ( 4 0 ) capacitor c=0.0617495f //x=17.14 //y=2.77
c1073 ( 1 0 ) capacitor c=0.0633306f //x=7.52 //y=3.14
r1074 (  349 350 ) resistor r=32.4568 //w=0.214 //l=0.075 //layer=ply \
 //thickness=0.18 //x=74.86 //y=4.97 //x2=74.86 //y2=5.045
r1075 (  347 349 ) resistor r=20.271 //w=0.214 //l=0.09 //layer=ply \
 //thickness=0.18 //x=74.86 //y=4.88 //x2=74.86 //y2=4.97
r1076 (  338 339 ) resistor r=32.4568 //w=0.214 //l=0.075 //layer=ply \
 //thickness=0.18 //x=65.24 //y=4.97 //x2=65.24 //y2=5.045
r1077 (  336 338 ) resistor r=20.271 //w=0.214 //l=0.09 //layer=ply \
 //thickness=0.18 //x=65.24 //y=4.88 //x2=65.24 //y2=4.97
r1078 (  327 328 ) resistor r=32.4568 //w=0.214 //l=0.075 //layer=ply \
 //thickness=0.18 //x=46 //y=4.97 //x2=46 //y2=5.045
r1079 (  325 327 ) resistor r=20.271 //w=0.214 //l=0.09 //layer=ply \
 //thickness=0.18 //x=46 //y=4.88 //x2=46 //y2=4.97
r1080 (  316 317 ) resistor r=32.4568 //w=0.214 //l=0.075 //layer=ply \
 //thickness=0.18 //x=36.38 //y=4.97 //x2=36.38 //y2=5.045
r1081 (  314 316 ) resistor r=20.271 //w=0.214 //l=0.09 //layer=ply \
 //thickness=0.18 //x=36.38 //y=4.88 //x2=36.38 //y2=4.97
r1082 (  305 306 ) resistor r=32.4568 //w=0.214 //l=0.075 //layer=ply \
 //thickness=0.18 //x=17.14 //y=4.97 //x2=17.14 //y2=5.045
r1083 (  303 305 ) resistor r=20.271 //w=0.214 //l=0.09 //layer=ply \
 //thickness=0.18 //x=17.14 //y=4.88 //x2=17.14 //y2=4.97
r1084 (  294 295 ) resistor r=32.4568 //w=0.214 //l=0.075 //layer=ply \
 //thickness=0.18 //x=7.52 //y=4.97 //x2=7.52 //y2=5.045
r1085 (  292 294 ) resistor r=20.271 //w=0.214 //l=0.09 //layer=ply \
 //thickness=0.18 //x=7.52 //y=4.88 //x2=7.52 //y2=4.97
r1086 (  285 349 ) resistor r=16.5046 //w=0.27 //l=0.135 //layer=ply \
 //thickness=0.18 //x=74.995 //y=4.97 //x2=74.86 //y2=4.97
r1087 (  284 286 ) resistor r=26.9307 //w=0.15 //l=0.106066 //layer=ply \
 //thickness=0.18 //x=75.195 //y=4.97 //x2=75.27 //y2=5.045
r1088 (  284 285 ) resistor r=102.553 //w=0.094 //l=0.2 //layer=ply \
 //thickness=0.18 //x=75.195 //y=4.97 //x2=74.995 //y2=4.97
r1089 (  283 354 ) resistor r=38.6777 //w=0.284 //l=0.198997 //layer=ply \
 //thickness=0.18 //x=74.95 //y=2.095 //x2=74.875 //y2=2.26
r1090 (  282 352 ) resistor r=21.2976 //w=0.217 //l=0.0928709 //layer=ply \
 //thickness=0.18 //x=74.95 //y=1.63 //x2=74.91 //y2=1.555
r1091 (  282 283 ) resistor r=238.436 //w=0.094 //l=0.465 //layer=ply \
 //thickness=0.18 //x=74.95 //y=1.63 //x2=74.95 //y2=2.095
r1092 (  281 352 ) resistor r=39.0671 //w=0.217 //l=0.173853 //layer=ply \
 //thickness=0.18 //x=74.95 //y=1.4 //x2=74.91 //y2=1.555
r1093 (  280 351 ) resistor r=45.1352 //w=0.168 //l=0.173853 //layer=ply \
 //thickness=0.18 //x=74.95 //y=1.09 //x2=74.91 //y2=0.935
r1094 (  280 281 ) resistor r=158.957 //w=0.094 //l=0.31 //layer=ply \
 //thickness=0.18 //x=74.95 //y=1.09 //x2=74.95 //y2=1.4
r1095 (  275 345 ) resistor r=5.52526 //w=0.168 //l=0.115 //layer=ply \
 //thickness=0.18 //x=74.58 //y=1.555 //x2=74.465 //y2=1.555
r1096 (  274 352 ) resistor r=11.4558 //w=0.217 //l=0.115 //layer=ply \
 //thickness=0.18 //x=74.795 //y=1.555 //x2=74.91 //y2=1.555
r1097 (  273 344 ) resistor r=5.52526 //w=0.168 //l=0.115 //layer=ply \
 //thickness=0.18 //x=74.58 //y=0.935 //x2=74.465 //y2=0.935
r1098 (  272 351 ) resistor r=5.52526 //w=0.168 //l=0.115 //layer=ply \
 //thickness=0.18 //x=74.795 //y=0.935 //x2=74.91 //y2=0.935
r1099 (  272 273 ) resistor r=110.245 //w=0.094 //l=0.215 //layer=ply \
 //thickness=0.18 //x=74.795 //y=0.935 //x2=74.58 //y2=0.935
r1100 (  271 345 ) resistor r=45.1352 //w=0.168 //l=0.173853 //layer=ply \
 //thickness=0.18 //x=74.425 //y=1.4 //x2=74.465 //y2=1.555
r1101 (  270 344 ) resistor r=45.1352 //w=0.168 //l=0.173853 //layer=ply \
 //thickness=0.18 //x=74.425 //y=1.09 //x2=74.465 //y2=0.935
r1102 (  270 271 ) resistor r=158.957 //w=0.094 //l=0.31 //layer=ply \
 //thickness=0.18 //x=74.425 //y=1.09 //x2=74.425 //y2=1.4
r1103 (  266 338 ) resistor r=16.5046 //w=0.27 //l=0.135 //layer=ply \
 //thickness=0.18 //x=65.375 //y=4.97 //x2=65.24 //y2=4.97
r1104 (  265 267 ) resistor r=26.9307 //w=0.15 //l=0.106066 //layer=ply \
 //thickness=0.18 //x=65.575 //y=4.97 //x2=65.65 //y2=5.045
r1105 (  265 266 ) resistor r=102.553 //w=0.094 //l=0.2 //layer=ply \
 //thickness=0.18 //x=65.575 //y=4.97 //x2=65.375 //y2=4.97
r1106 (  264 343 ) resistor r=38.6777 //w=0.284 //l=0.198997 //layer=ply \
 //thickness=0.18 //x=65.33 //y=2.095 //x2=65.255 //y2=2.26
r1107 (  263 341 ) resistor r=21.2976 //w=0.217 //l=0.0928709 //layer=ply \
 //thickness=0.18 //x=65.33 //y=1.63 //x2=65.29 //y2=1.555
r1108 (  263 264 ) resistor r=238.436 //w=0.094 //l=0.465 //layer=ply \
 //thickness=0.18 //x=65.33 //y=1.63 //x2=65.33 //y2=2.095
r1109 (  262 341 ) resistor r=39.0671 //w=0.217 //l=0.173853 //layer=ply \
 //thickness=0.18 //x=65.33 //y=1.4 //x2=65.29 //y2=1.555
r1110 (  261 340 ) resistor r=45.1352 //w=0.168 //l=0.173853 //layer=ply \
 //thickness=0.18 //x=65.33 //y=1.09 //x2=65.29 //y2=0.935
r1111 (  261 262 ) resistor r=158.957 //w=0.094 //l=0.31 //layer=ply \
 //thickness=0.18 //x=65.33 //y=1.09 //x2=65.33 //y2=1.4
r1112 (  256 334 ) resistor r=5.52526 //w=0.168 //l=0.115 //layer=ply \
 //thickness=0.18 //x=64.96 //y=1.555 //x2=64.845 //y2=1.555
r1113 (  255 341 ) resistor r=11.4558 //w=0.217 //l=0.115 //layer=ply \
 //thickness=0.18 //x=65.175 //y=1.555 //x2=65.29 //y2=1.555
r1114 (  254 333 ) resistor r=5.52526 //w=0.168 //l=0.115 //layer=ply \
 //thickness=0.18 //x=64.96 //y=0.935 //x2=64.845 //y2=0.935
r1115 (  253 340 ) resistor r=5.52526 //w=0.168 //l=0.115 //layer=ply \
 //thickness=0.18 //x=65.175 //y=0.935 //x2=65.29 //y2=0.935
r1116 (  253 254 ) resistor r=110.245 //w=0.094 //l=0.215 //layer=ply \
 //thickness=0.18 //x=65.175 //y=0.935 //x2=64.96 //y2=0.935
r1117 (  252 334 ) resistor r=45.1352 //w=0.168 //l=0.173853 //layer=ply \
 //thickness=0.18 //x=64.805 //y=1.4 //x2=64.845 //y2=1.555
r1118 (  251 333 ) resistor r=45.1352 //w=0.168 //l=0.173853 //layer=ply \
 //thickness=0.18 //x=64.805 //y=1.09 //x2=64.845 //y2=0.935
r1119 (  251 252 ) resistor r=158.957 //w=0.094 //l=0.31 //layer=ply \
 //thickness=0.18 //x=64.805 //y=1.09 //x2=64.805 //y2=1.4
r1120 (  247 327 ) resistor r=16.5046 //w=0.27 //l=0.135 //layer=ply \
 //thickness=0.18 //x=46.135 //y=4.97 //x2=46 //y2=4.97
r1121 (  246 248 ) resistor r=26.9307 //w=0.15 //l=0.106066 //layer=ply \
 //thickness=0.18 //x=46.335 //y=4.97 //x2=46.41 //y2=5.045
r1122 (  246 247 ) resistor r=102.553 //w=0.094 //l=0.2 //layer=ply \
 //thickness=0.18 //x=46.335 //y=4.97 //x2=46.135 //y2=4.97
r1123 (  245 332 ) resistor r=38.6777 //w=0.284 //l=0.198997 //layer=ply \
 //thickness=0.18 //x=46.09 //y=2.095 //x2=46.015 //y2=2.26
r1124 (  244 330 ) resistor r=21.2976 //w=0.217 //l=0.0928709 //layer=ply \
 //thickness=0.18 //x=46.09 //y=1.63 //x2=46.05 //y2=1.555
r1125 (  244 245 ) resistor r=238.436 //w=0.094 //l=0.465 //layer=ply \
 //thickness=0.18 //x=46.09 //y=1.63 //x2=46.09 //y2=2.095
r1126 (  243 330 ) resistor r=39.0671 //w=0.217 //l=0.173853 //layer=ply \
 //thickness=0.18 //x=46.09 //y=1.4 //x2=46.05 //y2=1.555
r1127 (  242 329 ) resistor r=45.1352 //w=0.168 //l=0.173853 //layer=ply \
 //thickness=0.18 //x=46.09 //y=1.09 //x2=46.05 //y2=0.935
r1128 (  242 243 ) resistor r=158.957 //w=0.094 //l=0.31 //layer=ply \
 //thickness=0.18 //x=46.09 //y=1.09 //x2=46.09 //y2=1.4
r1129 (  237 323 ) resistor r=5.52526 //w=0.168 //l=0.115 //layer=ply \
 //thickness=0.18 //x=45.72 //y=1.555 //x2=45.605 //y2=1.555
r1130 (  236 330 ) resistor r=11.4558 //w=0.217 //l=0.115 //layer=ply \
 //thickness=0.18 //x=45.935 //y=1.555 //x2=46.05 //y2=1.555
r1131 (  235 322 ) resistor r=5.52526 //w=0.168 //l=0.115 //layer=ply \
 //thickness=0.18 //x=45.72 //y=0.935 //x2=45.605 //y2=0.935
r1132 (  234 329 ) resistor r=5.52526 //w=0.168 //l=0.115 //layer=ply \
 //thickness=0.18 //x=45.935 //y=0.935 //x2=46.05 //y2=0.935
r1133 (  234 235 ) resistor r=110.245 //w=0.094 //l=0.215 //layer=ply \
 //thickness=0.18 //x=45.935 //y=0.935 //x2=45.72 //y2=0.935
r1134 (  233 323 ) resistor r=45.1352 //w=0.168 //l=0.173853 //layer=ply \
 //thickness=0.18 //x=45.565 //y=1.4 //x2=45.605 //y2=1.555
r1135 (  232 322 ) resistor r=45.1352 //w=0.168 //l=0.173853 //layer=ply \
 //thickness=0.18 //x=45.565 //y=1.09 //x2=45.605 //y2=0.935
r1136 (  232 233 ) resistor r=158.957 //w=0.094 //l=0.31 //layer=ply \
 //thickness=0.18 //x=45.565 //y=1.09 //x2=45.565 //y2=1.4
r1137 (  228 316 ) resistor r=16.5046 //w=0.27 //l=0.135 //layer=ply \
 //thickness=0.18 //x=36.515 //y=4.97 //x2=36.38 //y2=4.97
r1138 (  227 229 ) resistor r=26.9307 //w=0.15 //l=0.106066 //layer=ply \
 //thickness=0.18 //x=36.715 //y=4.97 //x2=36.79 //y2=5.045
r1139 (  227 228 ) resistor r=102.553 //w=0.094 //l=0.2 //layer=ply \
 //thickness=0.18 //x=36.715 //y=4.97 //x2=36.515 //y2=4.97
r1140 (  226 321 ) resistor r=38.6777 //w=0.284 //l=0.198997 //layer=ply \
 //thickness=0.18 //x=36.47 //y=2.095 //x2=36.395 //y2=2.26
r1141 (  225 319 ) resistor r=21.2976 //w=0.217 //l=0.0928709 //layer=ply \
 //thickness=0.18 //x=36.47 //y=1.63 //x2=36.43 //y2=1.555
r1142 (  225 226 ) resistor r=238.436 //w=0.094 //l=0.465 //layer=ply \
 //thickness=0.18 //x=36.47 //y=1.63 //x2=36.47 //y2=2.095
r1143 (  224 319 ) resistor r=39.0671 //w=0.217 //l=0.173853 //layer=ply \
 //thickness=0.18 //x=36.47 //y=1.4 //x2=36.43 //y2=1.555
r1144 (  223 318 ) resistor r=45.1352 //w=0.168 //l=0.173853 //layer=ply \
 //thickness=0.18 //x=36.47 //y=1.09 //x2=36.43 //y2=0.935
r1145 (  223 224 ) resistor r=158.957 //w=0.094 //l=0.31 //layer=ply \
 //thickness=0.18 //x=36.47 //y=1.09 //x2=36.47 //y2=1.4
r1146 (  218 312 ) resistor r=5.52526 //w=0.168 //l=0.115 //layer=ply \
 //thickness=0.18 //x=36.1 //y=1.555 //x2=35.985 //y2=1.555
r1147 (  217 319 ) resistor r=11.4558 //w=0.217 //l=0.115 //layer=ply \
 //thickness=0.18 //x=36.315 //y=1.555 //x2=36.43 //y2=1.555
r1148 (  216 311 ) resistor r=5.52526 //w=0.168 //l=0.115 //layer=ply \
 //thickness=0.18 //x=36.1 //y=0.935 //x2=35.985 //y2=0.935
r1149 (  215 318 ) resistor r=5.52526 //w=0.168 //l=0.115 //layer=ply \
 //thickness=0.18 //x=36.315 //y=0.935 //x2=36.43 //y2=0.935
r1150 (  215 216 ) resistor r=110.245 //w=0.094 //l=0.215 //layer=ply \
 //thickness=0.18 //x=36.315 //y=0.935 //x2=36.1 //y2=0.935
r1151 (  214 312 ) resistor r=45.1352 //w=0.168 //l=0.173853 //layer=ply \
 //thickness=0.18 //x=35.945 //y=1.4 //x2=35.985 //y2=1.555
r1152 (  213 311 ) resistor r=45.1352 //w=0.168 //l=0.173853 //layer=ply \
 //thickness=0.18 //x=35.945 //y=1.09 //x2=35.985 //y2=0.935
r1153 (  213 214 ) resistor r=158.957 //w=0.094 //l=0.31 //layer=ply \
 //thickness=0.18 //x=35.945 //y=1.09 //x2=35.945 //y2=1.4
r1154 (  209 305 ) resistor r=16.5046 //w=0.27 //l=0.135 //layer=ply \
 //thickness=0.18 //x=17.275 //y=4.97 //x2=17.14 //y2=4.97
r1155 (  208 210 ) resistor r=26.9307 //w=0.15 //l=0.106066 //layer=ply \
 //thickness=0.18 //x=17.475 //y=4.97 //x2=17.55 //y2=5.045
r1156 (  208 209 ) resistor r=102.553 //w=0.094 //l=0.2 //layer=ply \
 //thickness=0.18 //x=17.475 //y=4.97 //x2=17.275 //y2=4.97
r1157 (  207 310 ) resistor r=38.6777 //w=0.284 //l=0.198997 //layer=ply \
 //thickness=0.18 //x=17.23 //y=2.095 //x2=17.155 //y2=2.26
r1158 (  206 308 ) resistor r=21.2976 //w=0.217 //l=0.0928709 //layer=ply \
 //thickness=0.18 //x=17.23 //y=1.63 //x2=17.19 //y2=1.555
r1159 (  206 207 ) resistor r=238.436 //w=0.094 //l=0.465 //layer=ply \
 //thickness=0.18 //x=17.23 //y=1.63 //x2=17.23 //y2=2.095
r1160 (  205 308 ) resistor r=39.0671 //w=0.217 //l=0.173853 //layer=ply \
 //thickness=0.18 //x=17.23 //y=1.4 //x2=17.19 //y2=1.555
r1161 (  204 307 ) resistor r=45.1352 //w=0.168 //l=0.173853 //layer=ply \
 //thickness=0.18 //x=17.23 //y=1.09 //x2=17.19 //y2=0.935
r1162 (  204 205 ) resistor r=158.957 //w=0.094 //l=0.31 //layer=ply \
 //thickness=0.18 //x=17.23 //y=1.09 //x2=17.23 //y2=1.4
r1163 (  199 301 ) resistor r=5.52526 //w=0.168 //l=0.115 //layer=ply \
 //thickness=0.18 //x=16.86 //y=1.555 //x2=16.745 //y2=1.555
r1164 (  198 308 ) resistor r=11.4558 //w=0.217 //l=0.115 //layer=ply \
 //thickness=0.18 //x=17.075 //y=1.555 //x2=17.19 //y2=1.555
r1165 (  197 300 ) resistor r=5.52526 //w=0.168 //l=0.115 //layer=ply \
 //thickness=0.18 //x=16.86 //y=0.935 //x2=16.745 //y2=0.935
r1166 (  196 307 ) resistor r=5.52526 //w=0.168 //l=0.115 //layer=ply \
 //thickness=0.18 //x=17.075 //y=0.935 //x2=17.19 //y2=0.935
r1167 (  196 197 ) resistor r=110.245 //w=0.094 //l=0.215 //layer=ply \
 //thickness=0.18 //x=17.075 //y=0.935 //x2=16.86 //y2=0.935
r1168 (  195 301 ) resistor r=45.1352 //w=0.168 //l=0.173853 //layer=ply \
 //thickness=0.18 //x=16.705 //y=1.4 //x2=16.745 //y2=1.555
r1169 (  194 300 ) resistor r=45.1352 //w=0.168 //l=0.173853 //layer=ply \
 //thickness=0.18 //x=16.705 //y=1.09 //x2=16.745 //y2=0.935
r1170 (  194 195 ) resistor r=158.957 //w=0.094 //l=0.31 //layer=ply \
 //thickness=0.18 //x=16.705 //y=1.09 //x2=16.705 //y2=1.4
r1171 (  190 294 ) resistor r=16.5046 //w=0.27 //l=0.135 //layer=ply \
 //thickness=0.18 //x=7.655 //y=4.97 //x2=7.52 //y2=4.97
r1172 (  189 191 ) resistor r=26.9307 //w=0.15 //l=0.106066 //layer=ply \
 //thickness=0.18 //x=7.855 //y=4.97 //x2=7.93 //y2=5.045
r1173 (  189 190 ) resistor r=102.553 //w=0.094 //l=0.2 //layer=ply \
 //thickness=0.18 //x=7.855 //y=4.97 //x2=7.655 //y2=4.97
r1174 (  188 299 ) resistor r=38.6777 //w=0.284 //l=0.198997 //layer=ply \
 //thickness=0.18 //x=7.61 //y=2.095 //x2=7.535 //y2=2.26
r1175 (  187 297 ) resistor r=21.2976 //w=0.217 //l=0.0928709 //layer=ply \
 //thickness=0.18 //x=7.61 //y=1.63 //x2=7.57 //y2=1.555
r1176 (  187 188 ) resistor r=238.436 //w=0.094 //l=0.465 //layer=ply \
 //thickness=0.18 //x=7.61 //y=1.63 //x2=7.61 //y2=2.095
r1177 (  186 297 ) resistor r=39.0671 //w=0.217 //l=0.173853 //layer=ply \
 //thickness=0.18 //x=7.61 //y=1.4 //x2=7.57 //y2=1.555
r1178 (  185 296 ) resistor r=45.1352 //w=0.168 //l=0.173853 //layer=ply \
 //thickness=0.18 //x=7.61 //y=1.09 //x2=7.57 //y2=0.935
r1179 (  185 186 ) resistor r=158.957 //w=0.094 //l=0.31 //layer=ply \
 //thickness=0.18 //x=7.61 //y=1.09 //x2=7.61 //y2=1.4
r1180 (  180 290 ) resistor r=5.52526 //w=0.168 //l=0.115 //layer=ply \
 //thickness=0.18 //x=7.24 //y=1.555 //x2=7.125 //y2=1.555
r1181 (  179 297 ) resistor r=11.4558 //w=0.217 //l=0.115 //layer=ply \
 //thickness=0.18 //x=7.455 //y=1.555 //x2=7.57 //y2=1.555
r1182 (  178 289 ) resistor r=5.52526 //w=0.168 //l=0.115 //layer=ply \
 //thickness=0.18 //x=7.24 //y=0.935 //x2=7.125 //y2=0.935
r1183 (  177 296 ) resistor r=5.52526 //w=0.168 //l=0.115 //layer=ply \
 //thickness=0.18 //x=7.455 //y=0.935 //x2=7.57 //y2=0.935
r1184 (  177 178 ) resistor r=110.245 //w=0.094 //l=0.215 //layer=ply \
 //thickness=0.18 //x=7.455 //y=0.935 //x2=7.24 //y2=0.935
r1185 (  176 290 ) resistor r=45.1352 //w=0.168 //l=0.173853 //layer=ply \
 //thickness=0.18 //x=7.085 //y=1.4 //x2=7.125 //y2=1.555
r1186 (  175 289 ) resistor r=45.1352 //w=0.168 //l=0.173853 //layer=ply \
 //thickness=0.18 //x=7.085 //y=1.09 //x2=7.125 //y2=0.935
r1187 (  175 176 ) resistor r=158.957 //w=0.094 //l=0.31 //layer=ply \
 //thickness=0.18 //x=7.085 //y=1.09 //x2=7.085 //y2=1.4
r1188 (  174 286 ) resistor r=592.245 //w=0.094 //l=1.155 //layer=ply \
 //thickness=0.18 //x=75.27 //y=6.2 //x2=75.27 //y2=5.045
r1189 (  173 350 ) resistor r=592.245 //w=0.094 //l=1.155 //layer=ply \
 //thickness=0.18 //x=74.83 //y=6.2 //x2=74.83 //y2=5.045
r1190 (  172 267 ) resistor r=592.245 //w=0.094 //l=1.155 //layer=ply \
 //thickness=0.18 //x=65.65 //y=6.2 //x2=65.65 //y2=5.045
r1191 (  171 339 ) resistor r=592.245 //w=0.094 //l=1.155 //layer=ply \
 //thickness=0.18 //x=65.21 //y=6.2 //x2=65.21 //y2=5.045
r1192 (  170 248 ) resistor r=592.245 //w=0.094 //l=1.155 //layer=ply \
 //thickness=0.18 //x=46.41 //y=6.2 //x2=46.41 //y2=5.045
r1193 (  169 328 ) resistor r=592.245 //w=0.094 //l=1.155 //layer=ply \
 //thickness=0.18 //x=45.97 //y=6.2 //x2=45.97 //y2=5.045
r1194 (  168 229 ) resistor r=592.245 //w=0.094 //l=1.155 //layer=ply \
 //thickness=0.18 //x=36.79 //y=6.2 //x2=36.79 //y2=5.045
r1195 (  167 317 ) resistor r=592.245 //w=0.094 //l=1.155 //layer=ply \
 //thickness=0.18 //x=36.35 //y=6.2 //x2=36.35 //y2=5.045
r1196 (  166 210 ) resistor r=592.245 //w=0.094 //l=1.155 //layer=ply \
 //thickness=0.18 //x=17.55 //y=6.2 //x2=17.55 //y2=5.045
r1197 (  165 306 ) resistor r=592.245 //w=0.094 //l=1.155 //layer=ply \
 //thickness=0.18 //x=17.11 //y=6.2 //x2=17.11 //y2=5.045
r1198 (  164 191 ) resistor r=592.245 //w=0.094 //l=1.155 //layer=ply \
 //thickness=0.18 //x=7.93 //y=6.2 //x2=7.93 //y2=5.045
r1199 (  163 295 ) resistor r=592.245 //w=0.094 //l=1.155 //layer=ply \
 //thickness=0.18 //x=7.49 //y=6.2 //x2=7.49 //y2=5.045
r1200 (  162 274 ) resistor r=55.3787 //w=0.094 //l=0.108 //layer=ply \
 //thickness=0.18 //x=74.687 //y=1.555 //x2=74.795 //y2=1.555
r1201 (  162 275 ) resistor r=54.866 //w=0.094 //l=0.107 //layer=ply \
 //thickness=0.18 //x=74.687 //y=1.555 //x2=74.58 //y2=1.555
r1202 (  161 255 ) resistor r=55.3787 //w=0.094 //l=0.108 //layer=ply \
 //thickness=0.18 //x=65.067 //y=1.555 //x2=65.175 //y2=1.555
r1203 (  161 256 ) resistor r=54.866 //w=0.094 //l=0.107 //layer=ply \
 //thickness=0.18 //x=65.067 //y=1.555 //x2=64.96 //y2=1.555
r1204 (  160 236 ) resistor r=55.3787 //w=0.094 //l=0.108 //layer=ply \
 //thickness=0.18 //x=45.827 //y=1.555 //x2=45.935 //y2=1.555
r1205 (  160 237 ) resistor r=54.866 //w=0.094 //l=0.107 //layer=ply \
 //thickness=0.18 //x=45.827 //y=1.555 //x2=45.72 //y2=1.555
r1206 (  159 217 ) resistor r=55.3787 //w=0.094 //l=0.108 //layer=ply \
 //thickness=0.18 //x=36.207 //y=1.555 //x2=36.315 //y2=1.555
r1207 (  159 218 ) resistor r=54.866 //w=0.094 //l=0.107 //layer=ply \
 //thickness=0.18 //x=36.207 //y=1.555 //x2=36.1 //y2=1.555
r1208 (  158 198 ) resistor r=55.3787 //w=0.094 //l=0.108 //layer=ply \
 //thickness=0.18 //x=16.967 //y=1.555 //x2=17.075 //y2=1.555
r1209 (  158 199 ) resistor r=54.866 //w=0.094 //l=0.107 //layer=ply \
 //thickness=0.18 //x=16.967 //y=1.555 //x2=16.86 //y2=1.555
r1210 (  157 179 ) resistor r=55.3787 //w=0.094 //l=0.108 //layer=ply \
 //thickness=0.18 //x=7.347 //y=1.555 //x2=7.455 //y2=1.555
r1211 (  157 180 ) resistor r=54.866 //w=0.094 //l=0.107 //layer=ply \
 //thickness=0.18 //x=7.347 //y=1.555 //x2=7.24 //y2=1.555
r1212 (  153 347 ) resistor r=152 //w=0.17 //l=0.17 //layer=licon //count=1 \
 //x=74.86 //y=4.88 //x2=74.86 //y2=4.88
r1213 (  148 354 ) resistor r=152 //w=0.17 //l=0.17 //layer=licon //count=1 \
 //x=74.86 //y=2.26 //x2=74.86 //y2=2.26
r1214 (  143 336 ) resistor r=152 //w=0.17 //l=0.17 //layer=licon //count=1 \
 //x=65.24 //y=4.88 //x2=65.24 //y2=4.88
r1215 (  138 343 ) resistor r=152 //w=0.17 //l=0.17 //layer=licon //count=1 \
 //x=65.24 //y=2.26 //x2=65.24 //y2=2.26
r1216 (  133 325 ) resistor r=152 //w=0.17 //l=0.17 //layer=licon //count=1 \
 //x=46 //y=4.88 //x2=46 //y2=4.88
r1217 (  128 332 ) resistor r=152 //w=0.17 //l=0.17 //layer=licon //count=1 \
 //x=46 //y=2.26 //x2=46 //y2=2.26
r1218 (  123 314 ) resistor r=152 //w=0.17 //l=0.17 //layer=licon //count=1 \
 //x=36.38 //y=4.88 //x2=36.38 //y2=4.88
r1219 (  118 321 ) resistor r=152 //w=0.17 //l=0.17 //layer=licon //count=1 \
 //x=36.38 //y=2.26 //x2=36.38 //y2=2.26
r1220 (  113 303 ) resistor r=152 //w=0.17 //l=0.17 //layer=licon //count=1 \
 //x=17.14 //y=4.88 //x2=17.14 //y2=4.88
r1221 (  108 310 ) resistor r=152 //w=0.17 //l=0.17 //layer=licon //count=1 \
 //x=17.14 //y=2.26 //x2=17.14 //y2=2.26
r1222 (  103 292 ) resistor r=152 //w=0.17 //l=0.17 //layer=licon //count=1 \
 //x=7.52 //y=4.88 //x2=7.52 //y2=4.88
r1223 (  98 299 ) resistor r=152 //w=0.17 //l=0.17 //layer=licon //count=1 \
 //x=7.52 //y=2.26 //x2=7.52 //y2=2.26
r1224 (  94 96 ) resistor r=0.0911017 //w=0.295 //l=0.215 //layer=m2 \
 //thickness=0.36 //x=74.865 //y=4.62 //x2=74.865 //y2=4.835
r1225 (  83 85 ) resistor r=0.0875407 //w=0.307 //l=0.215 //layer=m2 \
 //thickness=0.36 //x=7.515 //y=4.62 //x2=7.515 //y2=4.835
r1226 (  82 93 ) resistor r=0.108687 //w=0.186 //l=0.19799 //layer=m2 \
 //thickness=0.36 //x=65.395 //y=4.62 //x2=65.235 //y2=4.705
r1227 (  81 94 ) resistor r=0.040597 //w=0.295 //l=0.16 //layer=m2 \
 //thickness=0.36 //x=74.705 //y=4.62 //x2=74.865 //y2=4.62
r1228 (  81 82 ) resistor r=8.88359 //w=0.131 //l=9.31 //layer=m2 \
 //thickness=0.36 //x=74.705 //y=4.62 //x2=65.395 //y2=4.62
r1229 (  80 91 ) resistor r=9.31144 //w=0.177 //l=13.22 //layer=m2 \
 //thickness=0.36 //x=59.19 //y=4.635 //x2=46.005 //y2=4.705
r1230 (  79 93 ) resistor r=3.83181 //w=0.186 //l=5.73489 //layer=m2 \
 //thickness=0.36 //x=59.535 //y=4.635 //x2=65.235 //y2=4.705
r1231 (  79 80 ) resistor r=0.329198 //w=0.131 //l=0.345 //layer=m2 \
 //thickness=0.36 //x=59.535 //y=4.635 //x2=59.19 //y2=4.635
r1232 (  78 89 ) resistor r=0.110111 //w=0.183 //l=0.19799 //layer=m2 \
 //thickness=0.36 //x=36.535 //y=4.62 //x2=36.375 //y2=4.705
r1233 (  77 91 ) resistor r=0.112994 //w=0.177 //l=0.19799 //layer=m2 \
 //thickness=0.36 //x=45.845 //y=4.62 //x2=46.005 //y2=4.705
r1234 (  77 78 ) resistor r=8.88359 //w=0.131 //l=9.31 //layer=m2 \
 //thickness=0.36 //x=45.845 //y=4.62 //x2=36.535 //y2=4.62
r1235 (  76 87 ) resistor r=7.85659 //w=0.179 //l=11.2974 //layer=m2 \
 //thickness=0.36 //x=28.395 //y=4.61 //x2=17.145 //y2=4.705
r1236 (  75 89 ) resistor r=5.15793 //w=0.183 //l=7.59735 //layer=m2 \
 //thickness=0.36 //x=28.825 //y=4.61 //x2=36.375 //y2=4.705
r1237 (  75 76 ) resistor r=0.410305 //w=0.131 //l=0.43 //layer=m2 \
 //thickness=0.36 //x=28.825 //y=4.61 //x2=28.395 //y2=4.61
r1238 (  74 83 ) resistor r=0.0429992 //w=0.307 //l=0.16 //layer=m2 \
 //thickness=0.36 //x=7.675 //y=4.62 //x2=7.515 //y2=4.62
r1239 (  73 87 ) resistor r=0.112172 //w=0.179 //l=0.19799 //layer=m2 \
 //thickness=0.36 //x=16.985 //y=4.62 //x2=17.145 //y2=4.705
r1240 (  73 74 ) resistor r=8.88359 //w=0.131 //l=9.31 //layer=m2 \
 //thickness=0.36 //x=16.985 //y=4.62 //x2=7.675 //y2=4.62
r1241 (  72 153 ) resistor r=9.3 //w=0.17 //l=0.17 //layer=mcon //count=1 \
 //x=74.86 //y=4.88 //x2=74.86 //y2=4.88
r1242 (  70 96 ) resistor r=4.5 //w=0.15 //l=0.15 //layer=via1 //count=1 \
 //x=74.865 //y=4.835 //x2=74.865 //y2=4.835
r1243 (  70 72 ) resistor r=0.018263 //w=0.308 //l=0.045 //layer=m1 \
 //thickness=0.36 //x=74.865 //y=4.835 //x2=74.865 //y2=4.88
r1244 (  68 148 ) resistor r=9.3 //w=0.17 //l=0.17 //layer=mcon //count=1 \
 //x=74.86 //y=2.26 //x2=74.86 //y2=2.26
r1245 (  66 143 ) resistor r=9.3 //w=0.17 //l=0.17 //layer=mcon //count=1 \
 //x=65.24 //y=4.88 //x2=65.24 //y2=4.88
r1246 (  64 93 ) resistor r=4.5 //w=0.15 //l=0.15 //layer=via1 //count=1 \
 //x=65.235 //y=4.835 //x2=65.235 //y2=4.835
r1247 (  64 66 ) resistor r=0.018263 //w=0.308 //l=0.045 //layer=m1 \
 //thickness=0.36 //x=65.235 //y=4.835 //x2=65.235 //y2=4.88
r1248 (  62 138 ) resistor r=9.3 //w=0.17 //l=0.17 //layer=mcon //count=1 \
 //x=65.24 //y=2.26 //x2=65.24 //y2=2.26
r1249 (  60 133 ) resistor r=9.3 //w=0.17 //l=0.17 //layer=mcon //count=1 \
 //x=46 //y=4.88 //x2=46 //y2=4.88
r1250 (  58 91 ) resistor r=4.5 //w=0.15 //l=0.15 //layer=via1 //count=1 \
 //x=46.005 //y=4.835 //x2=46.005 //y2=4.835
r1251 (  58 60 ) resistor r=0.018263 //w=0.308 //l=0.045 //layer=m1 \
 //thickness=0.36 //x=46.005 //y=4.835 //x2=46.005 //y2=4.88
r1252 (  56 128 ) resistor r=9.3 //w=0.17 //l=0.17 //layer=mcon //count=1 \
 //x=46 //y=2.26 //x2=46 //y2=2.26
r1253 (  54 123 ) resistor r=9.3 //w=0.17 //l=0.17 //layer=mcon //count=1 \
 //x=36.38 //y=4.88 //x2=36.38 //y2=4.88
r1254 (  52 89 ) resistor r=4.5 //w=0.15 //l=0.15 //layer=via1 //count=1 \
 //x=36.375 //y=4.835 //x2=36.375 //y2=4.835
r1255 (  52 54 ) resistor r=0.018263 //w=0.308 //l=0.045 //layer=m1 \
 //thickness=0.36 //x=36.375 //y=4.835 //x2=36.375 //y2=4.88
r1256 (  50 118 ) resistor r=9.3 //w=0.17 //l=0.17 //layer=mcon //count=1 \
 //x=36.38 //y=2.26 //x2=36.38 //y2=2.26
r1257 (  48 113 ) resistor r=9.3 //w=0.17 //l=0.17 //layer=mcon //count=1 \
 //x=17.14 //y=4.88 //x2=17.14 //y2=4.88
r1258 (  46 87 ) resistor r=4.5 //w=0.15 //l=0.15 //layer=via1 //count=1 \
 //x=17.145 //y=4.835 //x2=17.145 //y2=4.835
r1259 (  46 48 ) resistor r=0.018263 //w=0.308 //l=0.045 //layer=m1 \
 //thickness=0.36 //x=17.145 //y=4.835 //x2=17.145 //y2=4.88
r1260 (  44 108 ) resistor r=9.3 //w=0.17 //l=0.17 //layer=mcon //count=1 \
 //x=17.14 //y=2.26 //x2=17.14 //y2=2.26
r1261 (  42 103 ) resistor r=9.3 //w=0.17 //l=0.17 //layer=mcon //count=1 \
 //x=7.52 //y=4.88 //x2=7.52 //y2=4.88
r1262 (  40 85 ) resistor r=4.5 //w=0.15 //l=0.15 //layer=via1 //count=1 \
 //x=7.515 //y=4.835 //x2=7.515 //y2=4.835
r1263 (  40 42 ) resistor r=0.018263 //w=0.308 //l=0.045 //layer=m1 \
 //thickness=0.36 //x=7.515 //y=4.835 //x2=7.515 //y2=4.88
r1264 (  38 98 ) resistor r=9.3 //w=0.17 //l=0.17 //layer=mcon //count=1 \
 //x=7.52 //y=2.26 //x2=7.52 //y2=2.26
r1265 (  34 70 ) resistor r=0.0898396 //w=0.308 //l=0.162481 //layer=m1 \
 //thickness=0.36 //x=74.86 //y=4.675 //x2=74.865 //y2=4.835
r1266 (  33 68 ) resistor r=0.0715665 //w=0.226 //l=0.115996 //layer=m1 \
 //thickness=0.36 //x=74.86 //y=2.375 //x2=74.862 //y2=2.26
r1267 (  31 64 ) resistor r=0.0898396 //w=0.308 //l=0.162481 //layer=m1 \
 //thickness=0.36 //x=65.24 //y=4.675 //x2=65.235 //y2=4.835
r1268 (  30 62 ) resistor r=0.0715665 //w=0.226 //l=0.115996 //layer=m1 \
 //thickness=0.36 //x=65.24 //y=2.375 //x2=65.242 //y2=2.26
r1269 (  27 58 ) resistor r=0.0898396 //w=0.308 //l=0.162481 //layer=m1 \
 //thickness=0.36 //x=46 //y=4.675 //x2=46.005 //y2=4.835
r1270 (  26 56 ) resistor r=0.0715665 //w=0.226 //l=0.115996 //layer=m1 \
 //thickness=0.36 //x=46 //y=2.375 //x2=46.002 //y2=2.26
r1271 (  23 52 ) resistor r=0.0898396 //w=0.308 //l=0.162481 //layer=m1 \
 //thickness=0.36 //x=36.38 //y=4.675 //x2=36.375 //y2=4.835
r1272 (  22 50 ) resistor r=0.0715665 //w=0.226 //l=0.115996 //layer=m1 \
 //thickness=0.36 //x=36.38 //y=2.375 //x2=36.382 //y2=2.26
r1273 (  19 46 ) resistor r=0.0898396 //w=0.308 //l=0.162481 //layer=m1 \
 //thickness=0.36 //x=17.14 //y=4.675 //x2=17.145 //y2=4.835
r1274 (  18 44 ) resistor r=0.0715665 //w=0.226 //l=0.115996 //layer=m1 \
 //thickness=0.36 //x=17.14 //y=2.375 //x2=17.142 //y2=2.26
r1275 (  14 40 ) resistor r=0.0898396 //w=0.308 //l=0.162481 //layer=m1 \
 //thickness=0.36 //x=7.52 //y=4.675 //x2=7.515 //y2=4.835
r1276 (  13 38 ) resistor r=0.0715665 //w=0.226 //l=0.115996 //layer=m1 \
 //thickness=0.36 //x=7.52 //y=2.375 //x2=7.522 //y2=2.26
r1277 (  12 34 ) resistor r=0.0524809 //w=0.131 //l=0.055 //layer=m1 \
 //thickness=0.36 //x=74.86 //y=4.62 //x2=74.86 //y2=4.675
r1278 (  11 12 ) resistor r=1.76527 //w=0.131 //l=1.85 //layer=m1 \
 //thickness=0.36 //x=74.86 //y=2.77 //x2=74.86 //y2=4.62
r1279 (  11 33 ) resistor r=0.376908 //w=0.131 //l=0.395 //layer=m1 \
 //thickness=0.36 //x=74.86 //y=2.77 //x2=74.86 //y2=2.375
r1280 (  10 31 ) resistor r=0.0524809 //w=0.131 //l=0.055 //layer=m1 \
 //thickness=0.36 //x=65.24 //y=4.62 //x2=65.24 //y2=4.675
r1281 (  10 30 ) resistor r=2.14218 //w=0.131 //l=2.245 //layer=m1 \
 //thickness=0.36 //x=65.24 //y=4.62 //x2=65.24 //y2=2.375
r1282 (  9 27 ) resistor r=0.0524809 //w=0.131 //l=0.055 //layer=m1 \
 //thickness=0.36 //x=46 //y=4.62 //x2=46 //y2=4.675
r1283 (  8 9 ) resistor r=1.76527 //w=0.131 //l=1.85 //layer=m1 \
 //thickness=0.36 //x=46 //y=2.77 //x2=46 //y2=4.62
r1284 (  8 26 ) resistor r=0.376908 //w=0.131 //l=0.395 //layer=m1 \
 //thickness=0.36 //x=46 //y=2.77 //x2=46 //y2=2.375
r1285 (  7 23 ) resistor r=0.0524809 //w=0.131 //l=0.055 //layer=m1 \
 //thickness=0.36 //x=36.38 //y=4.62 //x2=36.38 //y2=4.675
r1286 (  6 7 ) resistor r=0.706107 //w=0.131 //l=0.74 //layer=m1 \
 //thickness=0.36 //x=36.38 //y=3.88 //x2=36.38 //y2=4.62
r1287 (  6 22 ) resistor r=1.43607 //w=0.131 //l=1.505 //layer=m1 \
 //thickness=0.36 //x=36.38 //y=3.88 //x2=36.38 //y2=2.375
r1288 (  5 19 ) resistor r=0.0524809 //w=0.131 //l=0.055 //layer=m1 \
 //thickness=0.36 //x=17.14 //y=4.62 //x2=17.14 //y2=4.675
r1289 (  4 5 ) resistor r=1.76527 //w=0.131 //l=1.85 //layer=m1 \
 //thickness=0.36 //x=17.14 //y=2.77 //x2=17.14 //y2=4.62
r1290 (  4 18 ) resistor r=0.376908 //w=0.131 //l=0.395 //layer=m1 \
 //thickness=0.36 //x=17.14 //y=2.77 //x2=17.14 //y2=2.375
r1291 (  3 14 ) resistor r=0.0524809 //w=0.131 //l=0.055 //layer=m1 \
 //thickness=0.36 //x=7.52 //y=4.62 //x2=7.52 //y2=4.675
r1292 (  2 3 ) resistor r=0.706107 //w=0.131 //l=0.74 //layer=m1 \
 //thickness=0.36 //x=7.52 //y=3.88 //x2=7.52 //y2=4.62
r1293 (  1 2 ) resistor r=0.706107 //w=0.131 //l=0.74 //layer=m1 \
 //thickness=0.36 //x=7.52 //y=3.14 //x2=7.52 //y2=3.88
r1294 (  1 13 ) resistor r=0.729962 //w=0.131 //l=0.765 //layer=m1 \
 //thickness=0.36 //x=7.52 //y=3.14 //x2=7.52 //y2=2.375
ends PM_TMRDFFSNRNQX1\%CLK

subckt PM_TMRDFFSNRNQX1\%noxref_16 ( 1 2 3 4 5 7 10 11 13 14 15 16 18 19 20 21 \
 22 23 24 30 33 36 39 47 49 57 62 65 66 68 71 80 85 93 101 118 127 131 132 133 \
 134 135 136 140 141 142 147 149 152 153 154 155 156 157 158 160 166 167 168 \
 169 174 175 180 191 193 194 195 )
c478 ( 191 0 ) capacitor c=0.00885916f //x=66.415 //y=1.095
c479 ( 180 0 ) capacitor c=0.0710579f //x=61.54 //y=4.88
c480 ( 175 0 ) capacitor c=0.0278202f //x=61.54 //y=2.095
c481 ( 174 0 ) capacitor c=0.0479349f //x=61.54 //y=2.26
c482 ( 169 0 ) capacitor c=0.0612936f //x=78.835 //y=4.97
c483 ( 168 0 ) capacitor c=0.0376642f //x=79.125 //y=4.97
c484 ( 167 0 ) capacitor c=0.0346489f //x=78.79 //y=1.4
c485 ( 166 0 ) capacitor c=0.018692f //x=78.79 //y=1.055
c486 ( 160 0 ) capacitor c=0.0137077f //x=78.635 //y=1.555
c487 ( 158 0 ) capacitor c=0.0158585f //x=78.635 //y=0.9
c488 ( 157 0 ) capacitor c=0.10101f //x=78.26 //y=2.095
c489 ( 156 0 ) capacitor c=0.0229444f //x=78.26 //y=1.71
c490 ( 155 0 ) capacitor c=0.0234359f //x=78.26 //y=1.4
c491 ( 154 0 ) capacitor c=0.019815f //x=78.26 //y=1.055
c492 ( 153 0 ) capacitor c=0.0443175f //x=62.06 //y=1.44
c493 ( 152 0 ) capacitor c=0.0199703f //x=62.06 //y=1.095
c494 ( 149 0 ) capacitor c=0.0162526f //x=61.905 //y=1.595
c495 ( 147 0 ) capacitor c=0.0157807f //x=61.905 //y=0.94
c496 ( 142 0 ) capacitor c=0.0220935f //x=61.53 //y=1.75
c497 ( 141 0 ) capacitor c=0.0207489f //x=61.53 //y=1.44
c498 ( 140 0 ) capacitor c=0.0194091f //x=61.53 //y=1.095
c499 ( 136 0 ) capacitor c=0.110208f //x=79.2 //y=6.2
c500 ( 135 0 ) capacitor c=0.158957f //x=78.76 //y=6.2
c501 ( 134 0 ) capacitor c=0.159671f //x=61.72 //y=6.2
c502 ( 133 0 ) capacitor c=0.110208f //x=61.28 //y=6.2
c503 ( 127 0 ) capacitor c=0.0014751f //x=78.56 //y=4.88
c504 ( 118 0 ) capacitor c=0.0012618f //x=78.56 //y=2.26
c505 ( 101 0 ) capacitor c=0.0293723f //x=66.31 //y=5.56
c506 ( 93 0 ) capacitor c=0.029137f //x=65.43 //y=5.56
c507 ( 85 0 ) capacitor c=0.0278099f //x=64.55 //y=5.56
c508 ( 80 0 ) capacitor c=9.5006e-19 //x=61.54 //y=4.88
c509 ( 71 0 ) capacitor c=0.00101179f //x=61.54 //y=2.26
c510 ( 68 0 ) capacitor c=4.92288e-19 //x=78.555 //y=3.51
c511 ( 66 0 ) capacitor c=6.97864e-19 //x=67.25 //y=3.495
c512 ( 65 0 ) capacitor c=0.0517493f //x=66.93 //y=3.495
c513 ( 62 0 ) capacitor c=4.31985e-19 //x=61.71 //y=3.515
c514 ( 57 0 ) capacitor c=0.113633f //x=78.395 //y=3.51
c515 ( 49 0 ) capacitor c=0.015408f //x=78.555 //y=3.51
c516 ( 47 0 ) capacitor c=0.0158593f //x=67.09 //y=3.51
c517 ( 39 0 ) capacitor c=8.40513e-19 //x=66.31 //y=5.335
c518 ( 36 0 ) capacitor c=0.0086931f //x=65.43 //y=5.335
c519 ( 33 0 ) capacitor c=0.013006f //x=64.552 //y=5.335
c520 ( 30 0 ) capacitor c=0.0150828f //x=61.54 //y=3.51
c521 ( 24 0 ) capacitor c=0.037614f //x=78.56 //y=4.755
c522 ( 23 0 ) capacitor c=0.0144231f //x=78.56 //y=3.67
c523 ( 22 0 ) capacitor c=0.0280962f //x=78.56 //y=3.35
c524 ( 21 0 ) capacitor c=0.00493552f //x=78.56 //y=2.375
c525 ( 20 0 ) capacitor c=0.0405271f //x=67.09 //y=5.25
c526 ( 19 0 ) capacitor c=0.0133594f //x=67.09 //y=3.655
c527 ( 18 0 ) capacitor c=0.0372096f //x=67.09 //y=3.335
c528 ( 16 0 ) capacitor c=0.0048771f //x=66.69 //y=1.845
c529 ( 15 0 ) capacitor c=0.0132685f //x=67.005 //y=1.845
c530 ( 14 0 ) capacitor c=0.0167992f //x=66.605 //y=1.76
c531 ( 13 0 ) capacitor c=0.0113147f //x=66.605 //y=1.305
c532 ( 11 0 ) capacitor c=0.0205277f //x=67.005 //y=5.335
c533 ( 10 0 ) capacitor c=0.00933983f //x=66.31 //y=5.56
c534 ( 7 0 ) capacitor c=0.0153994f //x=66.195 //y=5.335
c535 ( 5 0 ) capacitor c=0.0106433f //x=65.31 //y=5.335
c536 ( 4 0 ) capacitor c=0.0285803f //x=61.54 //y=4.75
c537 ( 3 0 ) capacitor c=0.0121725f //x=61.54 //y=3.675
c538 ( 2 0 ) capacitor c=0.0217874f //x=61.54 //y=3.355
c539 ( 1 0 ) capacitor c=0.005545f //x=61.54 //y=2.375
r540 (  174 175 ) resistor r=52.7279 //w=0.214 //l=0.165 //layer=ply \
 //thickness=0.18 //x=61.54 //y=2.26 //x2=61.54 //y2=2.095
r541 (  168 170 ) resistor r=26.9307 //w=0.15 //l=0.106066 //layer=ply \
 //thickness=0.18 //x=79.125 //y=4.97 //x2=79.2 //y2=5.045
r542 (  168 169 ) resistor r=148.702 //w=0.094 //l=0.29 //layer=ply \
 //thickness=0.18 //x=79.125 //y=4.97 //x2=78.835 //y2=4.97
r543 (  167 190 ) resistor r=45.1352 //w=0.168 //l=0.173853 //layer=ply \
 //thickness=0.18 //x=78.79 //y=1.4 //x2=78.75 //y2=1.555
r544 (  166 189 ) resistor r=45.1352 //w=0.168 //l=0.173853 //layer=ply \
 //thickness=0.18 //x=78.79 //y=1.055 //x2=78.75 //y2=0.9
r545 (  166 167 ) resistor r=176.904 //w=0.094 //l=0.345 //layer=ply \
 //thickness=0.18 //x=78.79 //y=1.055 //x2=78.79 //y2=1.4
r546 (  163 169 ) resistor r=22.7971 //w=0.269 //l=0.106066 //layer=ply \
 //thickness=0.18 //x=78.76 //y=5.045 //x2=78.835 //y2=4.97
r547 (  163 188 ) resistor r=35.8364 //w=0.269 //l=0.270185 //layer=ply \
 //thickness=0.18 //x=78.76 //y=5.045 //x2=78.56 //y2=4.88
r548 (  161 184 ) resistor r=10.701 //w=0.21 //l=0.115 //layer=ply \
 //thickness=0.18 //x=78.415 //y=1.555 //x2=78.3 //y2=1.555
r549 (  160 190 ) resistor r=5.52526 //w=0.168 //l=0.115 //layer=ply \
 //thickness=0.18 //x=78.635 //y=1.555 //x2=78.75 //y2=1.555
r550 (  159 183 ) resistor r=5.52526 //w=0.168 //l=0.115 //layer=ply \
 //thickness=0.18 //x=78.415 //y=0.9 //x2=78.3 //y2=0.9
r551 (  158 189 ) resistor r=5.52526 //w=0.168 //l=0.115 //layer=ply \
 //thickness=0.18 //x=78.635 //y=0.9 //x2=78.75 //y2=0.9
r552 (  158 159 ) resistor r=112.809 //w=0.094 //l=0.22 //layer=ply \
 //thickness=0.18 //x=78.635 //y=0.9 //x2=78.415 //y2=0.9
r553 (  157 186 ) resistor r=58.7805 //w=0.246 //l=0.373497 //layer=ply \
 //thickness=0.18 //x=78.26 //y=2.095 //x2=78.56 //y2=2.26
r554 (  156 184 ) resistor r=39.5823 //w=0.21 //l=0.173853 //layer=ply \
 //thickness=0.18 //x=78.26 //y=1.71 //x2=78.3 //y2=1.555
r555 (  156 157 ) resistor r=197.415 //w=0.094 //l=0.385 //layer=ply \
 //thickness=0.18 //x=78.26 //y=1.71 //x2=78.26 //y2=2.095
r556 (  155 184 ) resistor r=39.5823 //w=0.21 //l=0.173853 //layer=ply \
 //thickness=0.18 //x=78.26 //y=1.4 //x2=78.3 //y2=1.555
r557 (  154 183 ) resistor r=45.1352 //w=0.168 //l=0.173853 //layer=ply \
 //thickness=0.18 //x=78.26 //y=1.055 //x2=78.3 //y2=0.9
r558 (  154 155 ) resistor r=176.904 //w=0.094 //l=0.345 //layer=ply \
 //thickness=0.18 //x=78.26 //y=1.055 //x2=78.26 //y2=1.4
r559 (  153 182 ) resistor r=45.1352 //w=0.168 //l=0.173853 //layer=ply \
 //thickness=0.18 //x=62.06 //y=1.44 //x2=62.02 //y2=1.595
r560 (  152 181 ) resistor r=45.1352 //w=0.168 //l=0.173853 //layer=ply \
 //thickness=0.18 //x=62.06 //y=1.095 //x2=62.02 //y2=0.94
r561 (  152 153 ) resistor r=176.904 //w=0.094 //l=0.345 //layer=ply \
 //thickness=0.18 //x=62.06 //y=1.095 //x2=62.06 //y2=1.44
r562 (  150 178 ) resistor r=10.701 //w=0.21 //l=0.115 //layer=ply \
 //thickness=0.18 //x=61.685 //y=1.595 //x2=61.57 //y2=1.595
r563 (  149 182 ) resistor r=5.52526 //w=0.168 //l=0.115 //layer=ply \
 //thickness=0.18 //x=61.905 //y=1.595 //x2=62.02 //y2=1.595
r564 (  148 177 ) resistor r=5.52526 //w=0.168 //l=0.115 //layer=ply \
 //thickness=0.18 //x=61.685 //y=0.94 //x2=61.57 //y2=0.94
r565 (  147 181 ) resistor r=5.52526 //w=0.168 //l=0.115 //layer=ply \
 //thickness=0.18 //x=61.905 //y=0.94 //x2=62.02 //y2=0.94
r566 (  147 148 ) resistor r=112.809 //w=0.094 //l=0.22 //layer=ply \
 //thickness=0.18 //x=61.905 //y=0.94 //x2=61.685 //y2=0.94
r567 (  144 180 ) resistor r=37.236 //w=0.233 //l=0.249199 //layer=ply \
 //thickness=0.18 //x=61.72 //y=5.045 //x2=61.54 //y2=4.88
r568 (  142 178 ) resistor r=39.5823 //w=0.21 //l=0.173853 //layer=ply \
 //thickness=0.18 //x=61.53 //y=1.75 //x2=61.57 //y2=1.595
r569 (  142 175 ) resistor r=176.904 //w=0.094 //l=0.345 //layer=ply \
 //thickness=0.18 //x=61.53 //y=1.75 //x2=61.53 //y2=2.095
r570 (  141 178 ) resistor r=39.5823 //w=0.21 //l=0.173853 //layer=ply \
 //thickness=0.18 //x=61.53 //y=1.44 //x2=61.57 //y2=1.595
r571 (  140 177 ) resistor r=45.1352 //w=0.168 //l=0.173853 //layer=ply \
 //thickness=0.18 //x=61.53 //y=1.095 //x2=61.57 //y2=0.94
r572 (  140 141 ) resistor r=176.904 //w=0.094 //l=0.345 //layer=ply \
 //thickness=0.18 //x=61.53 //y=1.095 //x2=61.53 //y2=1.44
r573 (  137 180 ) resistor r=53.7854 //w=0.233 //l=0.332415 //layer=ply \
 //thickness=0.18 //x=61.28 //y=5.045 //x2=61.54 //y2=4.88
r574 (  136 170 ) resistor r=592.245 //w=0.094 //l=1.155 //layer=ply \
 //thickness=0.18 //x=79.2 //y=6.2 //x2=79.2 //y2=5.045
r575 (  135 163 ) resistor r=592.245 //w=0.094 //l=1.155 //layer=ply \
 //thickness=0.18 //x=78.76 //y=6.2 //x2=78.76 //y2=5.045
r576 (  134 144 ) resistor r=592.245 //w=0.094 //l=1.155 //layer=ply \
 //thickness=0.18 //x=61.72 //y=6.2 //x2=61.72 //y2=5.045
r577 (  133 137 ) resistor r=592.245 //w=0.094 //l=1.155 //layer=ply \
 //thickness=0.18 //x=61.28 //y=6.2 //x2=61.28 //y2=5.045
r578 (  132 160 ) resistor r=56.4043 //w=0.094 //l=0.11 //layer=ply \
 //thickness=0.18 //x=78.525 //y=1.555 //x2=78.635 //y2=1.555
r579 (  132 161 ) resistor r=56.4043 //w=0.094 //l=0.11 //layer=ply \
 //thickness=0.18 //x=78.525 //y=1.555 //x2=78.415 //y2=1.555
r580 (  131 149 ) resistor r=56.4043 //w=0.094 //l=0.11 //layer=ply \
 //thickness=0.18 //x=61.795 //y=1.595 //x2=61.905 //y2=1.595
r581 (  131 150 ) resistor r=56.4043 //w=0.094 //l=0.11 //layer=ply \
 //thickness=0.18 //x=61.795 //y=1.595 //x2=61.685 //y2=1.595
r582 (  127 188 ) resistor r=152 //w=0.17 //l=0.17 //layer=licon //count=1 \
 //x=78.56 //y=4.88 //x2=78.56 //y2=4.88
r583 (  118 186 ) resistor r=152 //w=0.17 //l=0.17 //layer=licon //count=1 \
 //x=78.56 //y=2.26 //x2=78.56 //y2=2.26
r584 (  101 195 ) resistor r=23.615 //w=0.187 //l=0.345 //layer=li \
 //thickness=0.1 //x=66.31 //y=5.56 //x2=66.31 //y2=5.905
r585 (  93 194 ) resistor r=23.615 //w=0.187 //l=0.345 //layer=li \
 //thickness=0.1 //x=65.43 //y=5.56 //x2=65.43 //y2=5.905
r586 (  85 193 ) resistor r=23.615 //w=0.187 //l=0.345 //layer=li \
 //thickness=0.1 //x=64.55 //y=5.56 //x2=64.55 //y2=5.905
r587 (  80 180 ) resistor r=152 //w=0.17 //l=0.17 //layer=licon //count=1 \
 //x=61.54 //y=4.88 //x2=61.54 //y2=4.88
r588 (  71 174 ) resistor r=152 //w=0.17 //l=0.17 //layer=licon //count=1 \
 //x=61.54 //y=2.26 //x2=61.54 //y2=2.26
r589 (  64 66 ) resistor r=0.10734 //w=0.281 //l=0.16 //layer=m2 \
 //thickness=0.36 //x=67.09 //y=3.495 //x2=67.25 //y2=3.495
r590 (  64 65 ) resistor r=0.10734 //w=0.281 //l=0.16 //layer=m2 \
 //thickness=0.36 //x=67.09 //y=3.495 //x2=66.93 //y2=3.495
r591 (  62 65 ) resistor r=4.98092 //w=0.131 //l=5.22 //layer=m2 \
 //thickness=0.36 //x=61.71 //y=3.51 //x2=66.93 //y2=3.51
r592 (  60 62 ) resistor r=0.10734 //w=0.281 //l=0.16 //layer=m2 \
 //thickness=0.36 //x=61.55 //y=3.515 //x2=61.71 //y2=3.515
r593 (  57 68 ) resistor r=0.10734 //w=0.281 //l=0.16 //layer=m2 \
 //thickness=0.36 //x=78.395 //y=3.51 //x2=78.555 //y2=3.51
r594 (  57 66 ) resistor r=10.6345 //w=0.131 //l=11.145 //layer=m2 \
 //thickness=0.36 //x=78.395 //y=3.51 //x2=67.25 //y2=3.51
r595 (  54 127 ) resistor r=9.3 //w=0.17 //l=0.17 //layer=mcon //count=1 \
 //x=78.56 //y=4.88 //x2=78.56 //y2=4.88
r596 (  52 118 ) resistor r=9.3 //w=0.17 //l=0.17 //layer=mcon //count=1 \
 //x=78.56 //y=2.26 //x2=78.56 //y2=2.26
r597 (  49 68 ) resistor r=4.5 //w=0.15 //l=0.15 //layer=via1 //count=1 \
 //x=78.555 //y=3.51 //x2=78.555 //y2=3.51
r598 (  45 64 ) resistor r=4.5 //w=0.15 //l=0.15 //layer=via1 //count=1 \
 //x=67.09 //y=3.495 //x2=67.09 //y2=3.495
r599 (  45 47 ) resistor r=0.0049867 //w=0.376 //l=0.015 //layer=m1 \
 //thickness=0.36 //x=67.142 //y=3.495 //x2=67.142 //y2=3.51
r600 (  43 191 ) resistor r=9.3 //w=0.17 //l=0.17 //layer=mcon //count=1 \
 //x=66.605 //y=1.19 //x2=66.605 //y2=1.19
r601 (  41 101 ) resistor r=9.3 //w=0.17 //l=0.17 //layer=mcon //count=1 \
 //x=66.31 //y=5.56 //x2=66.31 //y2=5.56
r602 (  38 93 ) resistor r=9.3 //w=0.17 //l=0.17 //layer=mcon //count=1 \
 //x=65.43 //y=5.56 //x2=65.43 //y2=5.56
r603 (  36 38 ) resistor r=0.121228 //w=0.232 //l=0.225 //layer=m1 \
 //thickness=0.36 //x=65.43 //y=5.335 //x2=65.43 //y2=5.56
r604 (  35 85 ) resistor r=9.3 //w=0.17 //l=0.17 //layer=mcon //count=1 \
 //x=64.55 //y=5.56 //x2=64.55 //y2=5.56
r605 (  33 35 ) resistor r=0.129608 //w=0.217 //l=0.225 //layer=m1 \
 //thickness=0.36 //x=64.552 //y=5.335 //x2=64.552 //y2=5.56
r606 (  32 60 ) resistor r=4.5 //w=0.15 //l=0.15 //layer=via1 //count=1 \
 //x=61.55 //y=3.515 //x2=61.55 //y2=3.515
r607 (  30 32 ) resistor r=0.00168464 //w=0.371 //l=0.005 //layer=m1 \
 //thickness=0.36 //x=61.597 //y=3.51 //x2=61.597 //y2=3.515
r608 (  28 80 ) resistor r=9.3 //w=0.17 //l=0.17 //layer=mcon //count=1 \
 //x=61.54 //y=4.88 //x2=61.54 //y2=4.88
r609 (  26 71 ) resistor r=9.3 //w=0.17 //l=0.17 //layer=mcon //count=1 \
 //x=61.54 //y=2.26 //x2=61.54 //y2=2.26
r610 (  24 54 ) resistor r=0.0760407 //w=0.238 //l=0.125 //layer=m1 \
 //thickness=0.36 //x=78.56 //y=4.755 //x2=78.56 //y2=4.88
r611 (  23 49 ) resistor r=0.0910802 //w=0.374 //l=0.185472 //layer=m1 \
 //thickness=0.36 //x=78.56 //y=3.67 //x2=78.505 //y2=3.51
r612 (  23 24 ) resistor r=1.03531 //w=0.131 //l=1.085 //layer=m1 \
 //thickness=0.36 //x=78.56 //y=3.67 //x2=78.56 //y2=4.755
r613 (  22 49 ) resistor r=0.0910802 //w=0.374 //l=0.185472 //layer=m1 \
 //thickness=0.36 //x=78.56 //y=3.35 //x2=78.505 //y2=3.51
r614 (  21 52 ) resistor r=0.0719237 //w=0.222 //l=0.115 //layer=m1 \
 //thickness=0.36 //x=78.56 //y=2.375 //x2=78.56 //y2=2.26
r615 (  21 22 ) resistor r=0.930344 //w=0.131 //l=0.975 //layer=m1 \
 //thickness=0.36 //x=78.56 //y=2.375 //x2=78.56 //y2=3.35
r616 (  19 47 ) resistor r=0.0861726 //w=0.376 //l=0.169012 //layer=m1 \
 //thickness=0.36 //x=67.09 //y=3.655 //x2=67.142 //y2=3.51
r617 (  19 20 ) resistor r=1.52195 //w=0.131 //l=1.595 //layer=m1 \
 //thickness=0.36 //x=67.09 //y=3.655 //x2=67.09 //y2=5.25
r618 (  18 45 ) resistor r=0.0911593 //w=0.376 //l=0.184174 //layer=m1 \
 //thickness=0.36 //x=67.09 //y=3.335 //x2=67.142 //y2=3.495
r619 (  17 18 ) resistor r=1.34065 //w=0.131 //l=1.405 //layer=m1 \
 //thickness=0.36 //x=67.09 //y=1.93 //x2=67.09 //y2=3.335
r620 (  15 17 ) resistor r=0.0698411 //w=0.17 //l=0.120208 //layer=m1 \
 //thickness=0.36 //x=67.005 //y=1.845 //x2=67.09 //y2=1.93
r621 (  15 16 ) resistor r=0.300573 //w=0.131 //l=0.315 //layer=m1 \
 //thickness=0.36 //x=67.005 //y=1.845 //x2=66.69 //y2=1.845
r622 (  14 16 ) resistor r=0.0698411 //w=0.17 //l=0.120208 //layer=m1 \
 //thickness=0.36 //x=66.605 //y=1.76 //x2=66.69 //y2=1.845
r623 (  13 43 ) resistor r=0.0717383 //w=0.224 //l=0.115 //layer=m1 \
 //thickness=0.36 //x=66.605 //y=1.305 //x2=66.605 //y2=1.19
r624 (  13 14 ) resistor r=0.43416 //w=0.131 //l=0.455 //layer=m1 \
 //thickness=0.36 //x=66.605 //y=1.305 //x2=66.605 //y2=1.76
r625 (  12 39 ) resistor r=0.0675342 //w=0.23 //l=0.115 //layer=m1 \
 //thickness=0.36 //x=66.425 //y=5.335 //x2=66.31 //y2=5.335
r626 (  11 20 ) resistor r=0.0698411 //w=0.17 //l=0.120208 //layer=m1 \
 //thickness=0.36 //x=67.005 //y=5.335 //x2=67.09 //y2=5.25
r627 (  11 12 ) resistor r=0.553435 //w=0.131 //l=0.58 //layer=m1 \
 //thickness=0.36 //x=67.005 //y=5.335 //x2=66.425 //y2=5.335
r628 (  10 41 ) resistor r=0.00118313 //w=0.23 //layer=m1 //thickness=0.36 \
 //x=66.31 //y=5.56 //x2=66.31 //y2=5.56
r629 (  9 39 ) resistor r=0.002872 //w=0.34 //l=0.085 //layer=m1 \
 //thickness=0.36 //x=66.31 //y=5.42 //x2=66.31 //y2=5.335
r630 (  9 10 ) resistor r=0.091623 //w=0.191 //l=0.14 //layer=m1 \
 //thickness=0.36 //x=66.31 //y=5.42 //x2=66.31 //y2=5.56
r631 (  8 36 ) resistor r=0.0262263 //w=0.232 //l=0.12 //layer=m1 \
 //thickness=0.36 //x=65.55 //y=5.335 //x2=65.43 //y2=5.335
r632 (  7 39 ) resistor r=0.0675342 //w=0.23 //l=0.115 //layer=m1 \
 //thickness=0.36 //x=66.195 //y=5.335 //x2=66.31 //y2=5.335
r633 (  7 8 ) resistor r=0.615458 //w=0.131 //l=0.645 //layer=m1 \
 //thickness=0.36 //x=66.195 //y=5.335 //x2=65.55 //y2=5.335
r634 (  6 33 ) resistor r=0.0222262 //w=0.217 //l=0.118 //layer=m1 \
 //thickness=0.36 //x=64.67 //y=5.335 //x2=64.552 //y2=5.335
r635 (  5 36 ) resistor r=0.0262263 //w=0.232 //l=0.12 //layer=m1 \
 //thickness=0.36 //x=65.31 //y=5.335 //x2=65.43 //y2=5.335
r636 (  5 6 ) resistor r=0.610687 //w=0.131 //l=0.64 //layer=m1 \
 //thickness=0.36 //x=65.31 //y=5.335 //x2=64.67 //y2=5.335
r637 (  4 28 ) resistor r=0.0801089 //w=0.224 //l=0.13 //layer=m1 \
 //thickness=0.36 //x=61.54 //y=4.75 //x2=61.54 //y2=4.88
r638 (  3 32 ) resistor r=0.0909648 //w=0.371 //l=0.186333 //layer=m1 \
 //thickness=0.36 //x=61.54 //y=3.675 //x2=61.597 //y2=3.515
r639 (  3 4 ) resistor r=1.02576 //w=0.131 //l=1.075 //layer=m1 \
 //thickness=0.36 //x=61.54 //y=3.675 //x2=61.54 //y2=4.75
r640 (  2 30 ) resistor r=0.0892801 //w=0.371 //l=0.181273 //layer=m1 \
 //thickness=0.36 //x=61.54 //y=3.355 //x2=61.597 //y2=3.51
r641 (  1 26 ) resistor r=0.0719237 //w=0.222 //l=0.115 //layer=m1 \
 //thickness=0.36 //x=61.54 //y=2.375 //x2=61.54 //y2=2.26
r642 (  1 2 ) resistor r=0.935115 //w=0.131 //l=0.98 //layer=m1 \
 //thickness=0.36 //x=61.54 //y=2.375 //x2=61.54 //y2=3.355
ends PM_TMRDFFSNRNQX1\%noxref_16

subckt PM_TMRDFFSNRNQX1\%RN ( 1 2 3 4 5 6 7 8 9 10 11 12 13 14 15 16 17 18 19 \
 20 21 22 23 24 25 26 27 28 29 30 31 37 38 40 41 44 45 49 50 52 53 56 57 61 62 \
 64 65 128 129 130 132 134 136 137 138 139 140 142 144 145 146 148 150 151 152 \
 153 154 156 158 159 160 162 165 184 185 188 193 198 203 208 213 218 223 228 \
 233 238 243 248 253 258 263 268 273 277 278 279 280 281 282 283 284 285 286 \
 287 288 289 290 291 292 293 294 295 296 297 298 299 300 301 302 303 304 305 \
 306 308 314 315 316 317 318 326 327 328 333 335 338 339 340 341 342 344 350 \
 351 352 353 354 359 360 361 363 369 370 371 372 373 381 382 383 388 390 393 \
 394 395 396 397 399 405 406 407 408 409 414 415 416 418 424 425 426 427 428 \
 436 437 438 443 445 448 449 450 451 452 454 460 461 462 463 464 472 481 482 \
 487 493 504 513 514 519 525 536 545 546 551 557 )
c1702 ( 557 0 ) capacitor c=0.0369044f //x=79.67 //y=4.88
c1703 ( 551 0 ) capacitor c=0.0711095f //x=75.97 //y=4.88
c1704 ( 546 0 ) capacitor c=0.0278202f //x=75.97 //y=2.095
c1705 ( 545 0 ) capacitor c=0.0491433f //x=75.97 //y=2.26
c1706 ( 536 0 ) capacitor c=0.0369628f //x=60.43 //y=4.88
c1707 ( 525 0 ) capacitor c=0.0369628f //x=50.81 //y=4.88
c1708 ( 519 0 ) capacitor c=0.0710579f //x=47.11 //y=4.88
c1709 ( 514 0 ) capacitor c=0.0278202f //x=47.11 //y=2.095
c1710 ( 513 0 ) capacitor c=0.0491433f //x=47.11 //y=2.26
c1711 ( 504 0 ) capacitor c=0.0369628f //x=31.57 //y=4.88
c1712 ( 493 0 ) capacitor c=0.0369044f //x=21.95 //y=4.88
c1713 ( 487 0 ) capacitor c=0.0710579f //x=18.25 //y=4.88
c1714 ( 482 0 ) capacitor c=0.0278202f //x=18.25 //y=2.095
c1715 ( 481 0 ) capacitor c=0.0491433f //x=18.25 //y=2.26
c1716 ( 472 0 ) capacitor c=0.0369044f //x=2.71 //y=4.88
c1717 ( 464 0 ) capacitor c=0.0309248f //x=80.005 //y=4.97
c1718 ( 463 0 ) capacitor c=0.0846044f //x=79.76 //y=2.095
c1719 ( 462 0 ) capacitor c=0.0170266f //x=79.76 //y=1.63
c1720 ( 461 0 ) capacitor c=0.018609f //x=79.76 //y=1.4
c1721 ( 460 0 ) capacitor c=0.0186599f //x=79.76 //y=1.09
c1722 ( 454 0 ) capacitor c=0.0146988f //x=79.605 //y=1.555
c1723 ( 452 0 ) capacitor c=0.0148531f //x=79.605 //y=0.935
c1724 ( 451 0 ) capacitor c=0.0334406f //x=79.235 //y=1.4
c1725 ( 450 0 ) capacitor c=0.0173191f //x=79.235 //y=1.09
c1726 ( 449 0 ) capacitor c=0.0443175f //x=76.49 //y=1.44
c1727 ( 448 0 ) capacitor c=0.0199703f //x=76.49 //y=1.095
c1728 ( 445 0 ) capacitor c=0.0160404f //x=76.335 //y=1.595
c1729 ( 443 0 ) capacitor c=0.0157807f //x=76.335 //y=0.94
c1730 ( 438 0 ) capacitor c=0.0220935f //x=75.96 //y=1.75
c1731 ( 437 0 ) capacitor c=0.0207489f //x=75.96 //y=1.44
c1732 ( 436 0 ) capacitor c=0.0194091f //x=75.96 //y=1.095
c1733 ( 428 0 ) capacitor c=0.0309248f //x=60.765 //y=4.97
c1734 ( 427 0 ) capacitor c=0.0844916f //x=60.52 //y=2.095
c1735 ( 426 0 ) capacitor c=0.0170266f //x=60.52 //y=1.63
c1736 ( 425 0 ) capacitor c=0.018609f //x=60.52 //y=1.4
c1737 ( 424 0 ) capacitor c=0.0186599f //x=60.52 //y=1.09
c1738 ( 418 0 ) capacitor c=0.0146988f //x=60.365 //y=1.555
c1739 ( 416 0 ) capacitor c=0.0148531f //x=60.365 //y=0.935
c1740 ( 415 0 ) capacitor c=0.0334406f //x=59.995 //y=1.4
c1741 ( 414 0 ) capacitor c=0.0173191f //x=59.995 //y=1.09
c1742 ( 409 0 ) capacitor c=0.0309248f //x=51.145 //y=4.97
c1743 ( 408 0 ) capacitor c=0.0846044f //x=50.9 //y=2.095
c1744 ( 407 0 ) capacitor c=0.0170266f //x=50.9 //y=1.63
c1745 ( 406 0 ) capacitor c=0.018609f //x=50.9 //y=1.4
c1746 ( 405 0 ) capacitor c=0.0186599f //x=50.9 //y=1.09
c1747 ( 399 0 ) capacitor c=0.0146988f //x=50.745 //y=1.555
c1748 ( 397 0 ) capacitor c=0.0148531f //x=50.745 //y=0.935
c1749 ( 396 0 ) capacitor c=0.0334406f //x=50.375 //y=1.4
c1750 ( 395 0 ) capacitor c=0.0173191f //x=50.375 //y=1.09
c1751 ( 394 0 ) capacitor c=0.0443175f //x=47.63 //y=1.44
c1752 ( 393 0 ) capacitor c=0.0199703f //x=47.63 //y=1.095
c1753 ( 390 0 ) capacitor c=0.0160404f //x=47.475 //y=1.595
c1754 ( 388 0 ) capacitor c=0.0157807f //x=47.475 //y=0.94
c1755 ( 383 0 ) capacitor c=0.0220935f //x=47.1 //y=1.75
c1756 ( 382 0 ) capacitor c=0.0207489f //x=47.1 //y=1.44
c1757 ( 381 0 ) capacitor c=0.0194091f //x=47.1 //y=1.095
c1758 ( 373 0 ) capacitor c=0.0309248f //x=31.905 //y=4.97
c1759 ( 372 0 ) capacitor c=0.0844916f //x=31.66 //y=2.095
c1760 ( 371 0 ) capacitor c=0.0170266f //x=31.66 //y=1.63
c1761 ( 370 0 ) capacitor c=0.018609f //x=31.66 //y=1.4
c1762 ( 369 0 ) capacitor c=0.0186599f //x=31.66 //y=1.09
c1763 ( 363 0 ) capacitor c=0.0146988f //x=31.505 //y=1.555
c1764 ( 361 0 ) capacitor c=0.0148531f //x=31.505 //y=0.935
c1765 ( 360 0 ) capacitor c=0.0334406f //x=31.135 //y=1.4
c1766 ( 359 0 ) capacitor c=0.0173191f //x=31.135 //y=1.09
c1767 ( 354 0 ) capacitor c=0.0309248f //x=22.285 //y=4.97
c1768 ( 353 0 ) capacitor c=0.0846044f //x=22.04 //y=2.095
c1769 ( 352 0 ) capacitor c=0.0170266f //x=22.04 //y=1.63
c1770 ( 351 0 ) capacitor c=0.018609f //x=22.04 //y=1.4
c1771 ( 350 0 ) capacitor c=0.0186599f //x=22.04 //y=1.09
c1772 ( 344 0 ) capacitor c=0.0146988f //x=21.885 //y=1.555
c1773 ( 342 0 ) capacitor c=0.0148531f //x=21.885 //y=0.935
c1774 ( 341 0 ) capacitor c=0.0334406f //x=21.515 //y=1.4
c1775 ( 340 0 ) capacitor c=0.0173191f //x=21.515 //y=1.09
c1776 ( 339 0 ) capacitor c=0.0443175f //x=18.77 //y=1.44
c1777 ( 338 0 ) capacitor c=0.0199703f //x=18.77 //y=1.095
c1778 ( 335 0 ) capacitor c=0.0160404f //x=18.615 //y=1.595
c1779 ( 333 0 ) capacitor c=0.0157807f //x=18.615 //y=0.94
c1780 ( 328 0 ) capacitor c=0.0220935f //x=18.24 //y=1.75
c1781 ( 327 0 ) capacitor c=0.0207489f //x=18.24 //y=1.44
c1782 ( 326 0 ) capacitor c=0.0194091f //x=18.24 //y=1.095
c1783 ( 318 0 ) capacitor c=0.0309248f //x=3.045 //y=4.97
c1784 ( 317 0 ) capacitor c=0.0844916f //x=2.8 //y=2.095
c1785 ( 316 0 ) capacitor c=0.0170266f //x=2.8 //y=1.63
c1786 ( 315 0 ) capacitor c=0.018609f //x=2.8 //y=1.4
c1787 ( 314 0 ) capacitor c=0.0186599f //x=2.8 //y=1.09
c1788 ( 308 0 ) capacitor c=0.0146988f //x=2.645 //y=1.555
c1789 ( 306 0 ) capacitor c=0.0148531f //x=2.645 //y=0.935
c1790 ( 305 0 ) capacitor c=0.0334406f //x=2.275 //y=1.4
c1791 ( 304 0 ) capacitor c=0.0173191f //x=2.275 //y=1.09
c1792 ( 303 0 ) capacitor c=0.110208f //x=80.08 //y=6.2
c1793 ( 302 0 ) capacitor c=0.110214f //x=79.64 //y=6.2
c1794 ( 301 0 ) capacitor c=0.159671f //x=76.15 //y=6.2
c1795 ( 300 0 ) capacitor c=0.110208f //x=75.71 //y=6.2
c1796 ( 299 0 ) capacitor c=0.110208f //x=60.84 //y=6.2
c1797 ( 298 0 ) capacitor c=0.110214f //x=60.4 //y=6.2
c1798 ( 297 0 ) capacitor c=0.110208f //x=51.22 //y=6.2
c1799 ( 296 0 ) capacitor c=0.110214f //x=50.78 //y=6.2
c1800 ( 295 0 ) capacitor c=0.159671f //x=47.29 //y=6.2
c1801 ( 294 0 ) capacitor c=0.110208f //x=46.85 //y=6.2
c1802 ( 293 0 ) capacitor c=0.110208f //x=31.98 //y=6.2
c1803 ( 292 0 ) capacitor c=0.110214f //x=31.54 //y=6.2
c1804 ( 291 0 ) capacitor c=0.110208f //x=22.36 //y=6.2
c1805 ( 290 0 ) capacitor c=0.110214f //x=21.92 //y=6.2
c1806 ( 289 0 ) capacitor c=0.159671f //x=18.43 //y=6.2
c1807 ( 288 0 ) capacitor c=0.110208f //x=17.99 //y=6.2
c1808 ( 287 0 ) capacitor c=0.110208f //x=3.12 //y=6.2
c1809 ( 286 0 ) capacitor c=0.110214f //x=2.68 //y=6.2
c1810 ( 273 0 ) capacitor c=0.00129935f //x=79.67 //y=4.88
c1811 ( 268 0 ) capacitor c=0.00121786f //x=79.67 //y=2.26
c1812 ( 263 0 ) capacitor c=7.7417e-19 //x=75.97 //y=4.88
c1813 ( 258 0 ) capacitor c=0.00101179f //x=75.97 //y=2.26
c1814 ( 253 0 ) capacitor c=0.00129935f //x=60.43 //y=4.88
c1815 ( 248 0 ) capacitor c=0.00121786f //x=60.43 //y=2.26
c1816 ( 243 0 ) capacitor c=0.00129935f //x=50.81 //y=4.88
c1817 ( 238 0 ) capacitor c=0.00121786f //x=50.81 //y=2.26
c1818 ( 233 0 ) capacitor c=9.08755e-19 //x=47.11 //y=4.88
c1819 ( 228 0 ) capacitor c=0.00101179f //x=47.11 //y=2.26
c1820 ( 223 0 ) capacitor c=0.00129935f //x=31.57 //y=4.88
c1821 ( 218 0 ) capacitor c=0.00121786f //x=31.57 //y=2.26
c1822 ( 213 0 ) capacitor c=0.00129935f //x=21.95 //y=4.88
c1823 ( 208 0 ) capacitor c=0.00121786f //x=21.95 //y=2.26
c1824 ( 203 0 ) capacitor c=7.7417e-19 //x=18.25 //y=4.88
c1825 ( 198 0 ) capacitor c=0.00101179f //x=18.25 //y=2.26
c1826 ( 193 0 ) capacitor c=0.00129935f //x=2.71 //y=4.88
c1827 ( 188 0 ) capacitor c=0.00121786f //x=2.71 //y=2.26
c1828 ( 185 0 ) capacitor c=0.0856406f //x=79.505 //y=2.41
c1829 ( 184 0 ) capacitor c=0.00498615f //x=79.665 //y=2.41
c1830 ( 165 0 ) capacitor c=0.0572044f //x=76.135 //y=2.4
c1831 ( 162 0 ) capacitor c=0.00875699f //x=73.975 //y=2.385
c1832 ( 160 0 ) capacitor c=0.0264842f //x=73.375 //y=2.4
c1833 ( 159 0 ) capacitor c=0.411959f //x=71.685 //y=2.385
c1834 ( 158 0 ) capacitor c=0.0147324f //x=72.115 //y=2.385
c1835 ( 156 0 ) capacitor c=0.00856815f //x=54.68 //y=2.37
c1836 ( 154 0 ) capacitor c=0.0240914f //x=54.08 //y=2.4
c1837 ( 153 0 ) capacitor c=0.0449876f //x=52.49 //y=2.37
c1838 ( 152 0 ) capacitor c=0.0149878f //x=52.92 //y=2.37
c1839 ( 151 0 ) capacitor c=0.0572008f //x=47.275 //y=2.4
c1840 ( 150 0 ) capacitor c=0.0856406f //x=50.645 //y=2.4
c1841 ( 148 0 ) capacitor c=0.00875699f //x=45.115 //y=2.385
c1842 ( 146 0 ) capacitor c=0.0264842f //x=44.515 //y=2.4
c1843 ( 145 0 ) capacitor c=0.410189f //x=42.825 //y=2.385
c1844 ( 144 0 ) capacitor c=0.0147324f //x=43.255 //y=2.385
c1845 ( 142 0 ) capacitor c=0.00882412f //x=25.865 //y=2.37
c1846 ( 140 0 ) capacitor c=0.0268658f //x=25.265 //y=2.4
c1847 ( 139 0 ) capacitor c=0.0435481f //x=23.57 //y=2.37
c1848 ( 138 0 ) capacitor c=0.0145033f //x=24 //y=2.37
c1849 ( 137 0 ) capacitor c=0.0572008f //x=18.415 //y=2.4
c1850 ( 136 0 ) capacitor c=0.0856406f //x=21.785 //y=2.4
c1851 ( 134 0 ) capacitor c=0.00875699f //x=16.255 //y=2.385
c1852 ( 132 0 ) capacitor c=0.0264842f //x=15.655 //y=2.4
c1853 ( 130 0 ) capacitor c=0.0147324f //x=14.395 //y=2.385
c1854 ( 129 0 ) capacitor c=0.00551787f //x=2.87 //y=2.4
c1855 ( 128 0 ) capacitor c=0.271118f //x=13.795 //y=2.4
c1856 ( 65 0 ) capacitor c=0.00504675f //x=79.67 //y=4.765
c1857 ( 64 0 ) capacitor c=0.0122282f //x=79.67 //y=2.57
c1858 ( 62 0 ) capacitor c=0.00443476f //x=75.97 //y=4.75
c1859 ( 61 0 ) capacitor c=0.0133066f //x=75.97 //y=2.565
c1860 ( 57 0 ) capacitor c=0.00295423f //x=60.43 //y=4.765
c1861 ( 56 0 ) capacitor c=0.0115735f //x=60.43 //y=2.56
c1862 ( 53 0 ) capacitor c=0.00295171f //x=50.81 //y=4.765
c1863 ( 52 0 ) capacitor c=0.0121708f //x=50.81 //y=2.57
c1864 ( 50 0 ) capacitor c=0.00287846f //x=47.11 //y=4.75
c1865 ( 49 0 ) capacitor c=0.0132863f //x=47.11 //y=2.565
c1866 ( 45 0 ) capacitor c=0.00295423f //x=31.57 //y=4.765
c1867 ( 44 0 ) capacitor c=0.0115735f //x=31.57 //y=2.56
c1868 ( 41 0 ) capacitor c=0.00504675f //x=21.95 //y=4.765
c1869 ( 40 0 ) capacitor c=0.0121708f //x=21.95 //y=2.57
c1870 ( 38 0 ) capacitor c=0.00443476f //x=18.25 //y=4.75
c1871 ( 37 0 ) capacitor c=0.0133066f //x=18.25 //y=2.565
c1872 ( 31 0 ) capacitor c=0.00504926f //x=2.71 //y=4.765
c1873 ( 30 0 ) capacitor c=0.0116271f //x=2.71 //y=2.56
c1874 ( 19 0 ) capacitor c=0.0609005f //x=79.67 //y=2.77
c1875 ( 18 0 ) capacitor c=0.0530105f //x=75.97 //y=2.77
c1876 ( 15 0 ) capacitor c=0.0596398f //x=60.43 //y=2.77
c1877 ( 13 0 ) capacitor c=0.0572866f //x=50.81 //y=2.77
c1878 ( 12 0 ) capacitor c=0.0530147f //x=47.11 //y=2.77
c1879 ( 9 0 ) capacitor c=0.0616868f //x=31.57 //y=2.77
c1880 ( 7 0 ) capacitor c=0.0574648f //x=21.95 //y=2.77
c1881 ( 6 0 ) capacitor c=0.0530147f //x=18.25 //y=2.77
c1882 ( 1 0 ) capacitor c=0.0666298f //x=2.71 //y=2.77
r1883 (  559 560 ) resistor r=32.4568 //w=0.214 //l=0.075 //layer=ply \
 //thickness=0.18 //x=79.67 //y=4.97 //x2=79.67 //y2=5.045
r1884 (  557 559 ) resistor r=20.271 //w=0.214 //l=0.09 //layer=ply \
 //thickness=0.18 //x=79.67 //y=4.88 //x2=79.67 //y2=4.97
r1885 (  545 546 ) resistor r=52.7279 //w=0.214 //l=0.165 //layer=ply \
 //thickness=0.18 //x=75.97 //y=2.26 //x2=75.97 //y2=2.095
r1886 (  538 539 ) resistor r=32.4568 //w=0.214 //l=0.075 //layer=ply \
 //thickness=0.18 //x=60.43 //y=4.97 //x2=60.43 //y2=5.045
r1887 (  536 538 ) resistor r=20.271 //w=0.214 //l=0.09 //layer=ply \
 //thickness=0.18 //x=60.43 //y=4.88 //x2=60.43 //y2=4.97
r1888 (  527 528 ) resistor r=32.4568 //w=0.214 //l=0.075 //layer=ply \
 //thickness=0.18 //x=50.81 //y=4.97 //x2=50.81 //y2=5.045
r1889 (  525 527 ) resistor r=20.271 //w=0.214 //l=0.09 //layer=ply \
 //thickness=0.18 //x=50.81 //y=4.88 //x2=50.81 //y2=4.97
r1890 (  513 514 ) resistor r=52.7279 //w=0.214 //l=0.165 //layer=ply \
 //thickness=0.18 //x=47.11 //y=2.26 //x2=47.11 //y2=2.095
r1891 (  506 507 ) resistor r=32.4568 //w=0.214 //l=0.075 //layer=ply \
 //thickness=0.18 //x=31.57 //y=4.97 //x2=31.57 //y2=5.045
r1892 (  504 506 ) resistor r=20.271 //w=0.214 //l=0.09 //layer=ply \
 //thickness=0.18 //x=31.57 //y=4.88 //x2=31.57 //y2=4.97
r1893 (  495 496 ) resistor r=32.4568 //w=0.214 //l=0.075 //layer=ply \
 //thickness=0.18 //x=21.95 //y=4.97 //x2=21.95 //y2=5.045
r1894 (  493 495 ) resistor r=20.271 //w=0.214 //l=0.09 //layer=ply \
 //thickness=0.18 //x=21.95 //y=4.88 //x2=21.95 //y2=4.97
r1895 (  481 482 ) resistor r=52.7279 //w=0.214 //l=0.165 //layer=ply \
 //thickness=0.18 //x=18.25 //y=2.26 //x2=18.25 //y2=2.095
r1896 (  474 475 ) resistor r=32.4568 //w=0.214 //l=0.075 //layer=ply \
 //thickness=0.18 //x=2.71 //y=4.97 //x2=2.71 //y2=5.045
r1897 (  472 474 ) resistor r=20.271 //w=0.214 //l=0.09 //layer=ply \
 //thickness=0.18 //x=2.71 //y=4.88 //x2=2.71 //y2=4.97
r1898 (  465 559 ) resistor r=16.5046 //w=0.27 //l=0.135 //layer=ply \
 //thickness=0.18 //x=79.805 //y=4.97 //x2=79.67 //y2=4.97
r1899 (  464 466 ) resistor r=26.9307 //w=0.15 //l=0.106066 //layer=ply \
 //thickness=0.18 //x=80.005 //y=4.97 //x2=80.08 //y2=5.045
r1900 (  464 465 ) resistor r=102.553 //w=0.094 //l=0.2 //layer=ply \
 //thickness=0.18 //x=80.005 //y=4.97 //x2=79.805 //y2=4.97
r1901 (  463 564 ) resistor r=38.6777 //w=0.284 //l=0.198997 //layer=ply \
 //thickness=0.18 //x=79.76 //y=2.095 //x2=79.685 //y2=2.26
r1902 (  462 562 ) resistor r=21.2976 //w=0.217 //l=0.0928709 //layer=ply \
 //thickness=0.18 //x=79.76 //y=1.63 //x2=79.72 //y2=1.555
r1903 (  462 463 ) resistor r=238.436 //w=0.094 //l=0.465 //layer=ply \
 //thickness=0.18 //x=79.76 //y=1.63 //x2=79.76 //y2=2.095
r1904 (  461 562 ) resistor r=39.0671 //w=0.217 //l=0.173853 //layer=ply \
 //thickness=0.18 //x=79.76 //y=1.4 //x2=79.72 //y2=1.555
r1905 (  460 561 ) resistor r=45.1352 //w=0.168 //l=0.173853 //layer=ply \
 //thickness=0.18 //x=79.76 //y=1.09 //x2=79.72 //y2=0.935
r1906 (  460 461 ) resistor r=158.957 //w=0.094 //l=0.31 //layer=ply \
 //thickness=0.18 //x=79.76 //y=1.09 //x2=79.76 //y2=1.4
r1907 (  455 555 ) resistor r=5.52526 //w=0.168 //l=0.115 //layer=ply \
 //thickness=0.18 //x=79.39 //y=1.555 //x2=79.275 //y2=1.555
r1908 (  454 562 ) resistor r=11.4558 //w=0.217 //l=0.115 //layer=ply \
 //thickness=0.18 //x=79.605 //y=1.555 //x2=79.72 //y2=1.555
r1909 (  453 554 ) resistor r=5.52526 //w=0.168 //l=0.115 //layer=ply \
 //thickness=0.18 //x=79.39 //y=0.935 //x2=79.275 //y2=0.935
r1910 (  452 561 ) resistor r=5.52526 //w=0.168 //l=0.115 //layer=ply \
 //thickness=0.18 //x=79.605 //y=0.935 //x2=79.72 //y2=0.935
r1911 (  452 453 ) resistor r=110.245 //w=0.094 //l=0.215 //layer=ply \
 //thickness=0.18 //x=79.605 //y=0.935 //x2=79.39 //y2=0.935
r1912 (  451 555 ) resistor r=45.1352 //w=0.168 //l=0.173853 //layer=ply \
 //thickness=0.18 //x=79.235 //y=1.4 //x2=79.275 //y2=1.555
r1913 (  450 554 ) resistor r=45.1352 //w=0.168 //l=0.173853 //layer=ply \
 //thickness=0.18 //x=79.235 //y=1.09 //x2=79.275 //y2=0.935
r1914 (  450 451 ) resistor r=158.957 //w=0.094 //l=0.31 //layer=ply \
 //thickness=0.18 //x=79.235 //y=1.09 //x2=79.235 //y2=1.4
r1915 (  449 553 ) resistor r=45.1352 //w=0.168 //l=0.173853 //layer=ply \
 //thickness=0.18 //x=76.49 //y=1.44 //x2=76.45 //y2=1.595
r1916 (  448 552 ) resistor r=45.1352 //w=0.168 //l=0.173853 //layer=ply \
 //thickness=0.18 //x=76.49 //y=1.095 //x2=76.45 //y2=0.94
r1917 (  448 449 ) resistor r=176.904 //w=0.094 //l=0.345 //layer=ply \
 //thickness=0.18 //x=76.49 //y=1.095 //x2=76.49 //y2=1.44
r1918 (  446 549 ) resistor r=10.701 //w=0.21 //l=0.115 //layer=ply \
 //thickness=0.18 //x=76.115 //y=1.595 //x2=76 //y2=1.595
r1919 (  445 553 ) resistor r=5.52526 //w=0.168 //l=0.115 //layer=ply \
 //thickness=0.18 //x=76.335 //y=1.595 //x2=76.45 //y2=1.595
r1920 (  444 548 ) resistor r=5.52526 //w=0.168 //l=0.115 //layer=ply \
 //thickness=0.18 //x=76.115 //y=0.94 //x2=76 //y2=0.94
r1921 (  443 552 ) resistor r=5.52526 //w=0.168 //l=0.115 //layer=ply \
 //thickness=0.18 //x=76.335 //y=0.94 //x2=76.45 //y2=0.94
r1922 (  443 444 ) resistor r=112.809 //w=0.094 //l=0.22 //layer=ply \
 //thickness=0.18 //x=76.335 //y=0.94 //x2=76.115 //y2=0.94
r1923 (  440 551 ) resistor r=37.236 //w=0.233 //l=0.249199 //layer=ply \
 //thickness=0.18 //x=76.15 //y=5.045 //x2=75.97 //y2=4.88
r1924 (  438 549 ) resistor r=39.5823 //w=0.21 //l=0.173853 //layer=ply \
 //thickness=0.18 //x=75.96 //y=1.75 //x2=76 //y2=1.595
r1925 (  438 546 ) resistor r=176.904 //w=0.094 //l=0.345 //layer=ply \
 //thickness=0.18 //x=75.96 //y=1.75 //x2=75.96 //y2=2.095
r1926 (  437 549 ) resistor r=39.5823 //w=0.21 //l=0.173853 //layer=ply \
 //thickness=0.18 //x=75.96 //y=1.44 //x2=76 //y2=1.595
r1927 (  436 548 ) resistor r=45.1352 //w=0.168 //l=0.173853 //layer=ply \
 //thickness=0.18 //x=75.96 //y=1.095 //x2=76 //y2=0.94
r1928 (  436 437 ) resistor r=176.904 //w=0.094 //l=0.345 //layer=ply \
 //thickness=0.18 //x=75.96 //y=1.095 //x2=75.96 //y2=1.44
r1929 (  433 551 ) resistor r=53.7854 //w=0.233 //l=0.332415 //layer=ply \
 //thickness=0.18 //x=75.71 //y=5.045 //x2=75.97 //y2=4.88
r1930 (  429 538 ) resistor r=16.5046 //w=0.27 //l=0.135 //layer=ply \
 //thickness=0.18 //x=60.565 //y=4.97 //x2=60.43 //y2=4.97
r1931 (  428 430 ) resistor r=26.9307 //w=0.15 //l=0.106066 //layer=ply \
 //thickness=0.18 //x=60.765 //y=4.97 //x2=60.84 //y2=5.045
r1932 (  428 429 ) resistor r=102.553 //w=0.094 //l=0.2 //layer=ply \
 //thickness=0.18 //x=60.765 //y=4.97 //x2=60.565 //y2=4.97
r1933 (  427 543 ) resistor r=38.6777 //w=0.284 //l=0.198997 //layer=ply \
 //thickness=0.18 //x=60.52 //y=2.095 //x2=60.445 //y2=2.26
r1934 (  426 541 ) resistor r=21.2976 //w=0.217 //l=0.0928709 //layer=ply \
 //thickness=0.18 //x=60.52 //y=1.63 //x2=60.48 //y2=1.555
r1935 (  426 427 ) resistor r=238.436 //w=0.094 //l=0.465 //layer=ply \
 //thickness=0.18 //x=60.52 //y=1.63 //x2=60.52 //y2=2.095
r1936 (  425 541 ) resistor r=39.0671 //w=0.217 //l=0.173853 //layer=ply \
 //thickness=0.18 //x=60.52 //y=1.4 //x2=60.48 //y2=1.555
r1937 (  424 540 ) resistor r=45.1352 //w=0.168 //l=0.173853 //layer=ply \
 //thickness=0.18 //x=60.52 //y=1.09 //x2=60.48 //y2=0.935
r1938 (  424 425 ) resistor r=158.957 //w=0.094 //l=0.31 //layer=ply \
 //thickness=0.18 //x=60.52 //y=1.09 //x2=60.52 //y2=1.4
r1939 (  419 534 ) resistor r=5.52526 //w=0.168 //l=0.115 //layer=ply \
 //thickness=0.18 //x=60.15 //y=1.555 //x2=60.035 //y2=1.555
r1940 (  418 541 ) resistor r=11.4558 //w=0.217 //l=0.115 //layer=ply \
 //thickness=0.18 //x=60.365 //y=1.555 //x2=60.48 //y2=1.555
r1941 (  417 533 ) resistor r=5.52526 //w=0.168 //l=0.115 //layer=ply \
 //thickness=0.18 //x=60.15 //y=0.935 //x2=60.035 //y2=0.935
r1942 (  416 540 ) resistor r=5.52526 //w=0.168 //l=0.115 //layer=ply \
 //thickness=0.18 //x=60.365 //y=0.935 //x2=60.48 //y2=0.935
r1943 (  416 417 ) resistor r=110.245 //w=0.094 //l=0.215 //layer=ply \
 //thickness=0.18 //x=60.365 //y=0.935 //x2=60.15 //y2=0.935
r1944 (  415 534 ) resistor r=45.1352 //w=0.168 //l=0.173853 //layer=ply \
 //thickness=0.18 //x=59.995 //y=1.4 //x2=60.035 //y2=1.555
r1945 (  414 533 ) resistor r=45.1352 //w=0.168 //l=0.173853 //layer=ply \
 //thickness=0.18 //x=59.995 //y=1.09 //x2=60.035 //y2=0.935
r1946 (  414 415 ) resistor r=158.957 //w=0.094 //l=0.31 //layer=ply \
 //thickness=0.18 //x=59.995 //y=1.09 //x2=59.995 //y2=1.4
r1947 (  410 527 ) resistor r=16.5046 //w=0.27 //l=0.135 //layer=ply \
 //thickness=0.18 //x=50.945 //y=4.97 //x2=50.81 //y2=4.97
r1948 (  409 411 ) resistor r=26.9307 //w=0.15 //l=0.106066 //layer=ply \
 //thickness=0.18 //x=51.145 //y=4.97 //x2=51.22 //y2=5.045
r1949 (  409 410 ) resistor r=102.553 //w=0.094 //l=0.2 //layer=ply \
 //thickness=0.18 //x=51.145 //y=4.97 //x2=50.945 //y2=4.97
r1950 (  408 532 ) resistor r=38.6777 //w=0.284 //l=0.198997 //layer=ply \
 //thickness=0.18 //x=50.9 //y=2.095 //x2=50.825 //y2=2.26
r1951 (  407 530 ) resistor r=21.2976 //w=0.217 //l=0.0928709 //layer=ply \
 //thickness=0.18 //x=50.9 //y=1.63 //x2=50.86 //y2=1.555
r1952 (  407 408 ) resistor r=238.436 //w=0.094 //l=0.465 //layer=ply \
 //thickness=0.18 //x=50.9 //y=1.63 //x2=50.9 //y2=2.095
r1953 (  406 530 ) resistor r=39.0671 //w=0.217 //l=0.173853 //layer=ply \
 //thickness=0.18 //x=50.9 //y=1.4 //x2=50.86 //y2=1.555
r1954 (  405 529 ) resistor r=45.1352 //w=0.168 //l=0.173853 //layer=ply \
 //thickness=0.18 //x=50.9 //y=1.09 //x2=50.86 //y2=0.935
r1955 (  405 406 ) resistor r=158.957 //w=0.094 //l=0.31 //layer=ply \
 //thickness=0.18 //x=50.9 //y=1.09 //x2=50.9 //y2=1.4
r1956 (  400 523 ) resistor r=5.52526 //w=0.168 //l=0.115 //layer=ply \
 //thickness=0.18 //x=50.53 //y=1.555 //x2=50.415 //y2=1.555
r1957 (  399 530 ) resistor r=11.4558 //w=0.217 //l=0.115 //layer=ply \
 //thickness=0.18 //x=50.745 //y=1.555 //x2=50.86 //y2=1.555
r1958 (  398 522 ) resistor r=5.52526 //w=0.168 //l=0.115 //layer=ply \
 //thickness=0.18 //x=50.53 //y=0.935 //x2=50.415 //y2=0.935
r1959 (  397 529 ) resistor r=5.52526 //w=0.168 //l=0.115 //layer=ply \
 //thickness=0.18 //x=50.745 //y=0.935 //x2=50.86 //y2=0.935
r1960 (  397 398 ) resistor r=110.245 //w=0.094 //l=0.215 //layer=ply \
 //thickness=0.18 //x=50.745 //y=0.935 //x2=50.53 //y2=0.935
r1961 (  396 523 ) resistor r=45.1352 //w=0.168 //l=0.173853 //layer=ply \
 //thickness=0.18 //x=50.375 //y=1.4 //x2=50.415 //y2=1.555
r1962 (  395 522 ) resistor r=45.1352 //w=0.168 //l=0.173853 //layer=ply \
 //thickness=0.18 //x=50.375 //y=1.09 //x2=50.415 //y2=0.935
r1963 (  395 396 ) resistor r=158.957 //w=0.094 //l=0.31 //layer=ply \
 //thickness=0.18 //x=50.375 //y=1.09 //x2=50.375 //y2=1.4
r1964 (  394 521 ) resistor r=45.1352 //w=0.168 //l=0.173853 //layer=ply \
 //thickness=0.18 //x=47.63 //y=1.44 //x2=47.59 //y2=1.595
r1965 (  393 520 ) resistor r=45.1352 //w=0.168 //l=0.173853 //layer=ply \
 //thickness=0.18 //x=47.63 //y=1.095 //x2=47.59 //y2=0.94
r1966 (  393 394 ) resistor r=176.904 //w=0.094 //l=0.345 //layer=ply \
 //thickness=0.18 //x=47.63 //y=1.095 //x2=47.63 //y2=1.44
r1967 (  391 517 ) resistor r=10.701 //w=0.21 //l=0.115 //layer=ply \
 //thickness=0.18 //x=47.255 //y=1.595 //x2=47.14 //y2=1.595
r1968 (  390 521 ) resistor r=5.52526 //w=0.168 //l=0.115 //layer=ply \
 //thickness=0.18 //x=47.475 //y=1.595 //x2=47.59 //y2=1.595
r1969 (  389 516 ) resistor r=5.52526 //w=0.168 //l=0.115 //layer=ply \
 //thickness=0.18 //x=47.255 //y=0.94 //x2=47.14 //y2=0.94
r1970 (  388 520 ) resistor r=5.52526 //w=0.168 //l=0.115 //layer=ply \
 //thickness=0.18 //x=47.475 //y=0.94 //x2=47.59 //y2=0.94
r1971 (  388 389 ) resistor r=112.809 //w=0.094 //l=0.22 //layer=ply \
 //thickness=0.18 //x=47.475 //y=0.94 //x2=47.255 //y2=0.94
r1972 (  385 519 ) resistor r=37.236 //w=0.233 //l=0.249199 //layer=ply \
 //thickness=0.18 //x=47.29 //y=5.045 //x2=47.11 //y2=4.88
r1973 (  383 517 ) resistor r=39.5823 //w=0.21 //l=0.173853 //layer=ply \
 //thickness=0.18 //x=47.1 //y=1.75 //x2=47.14 //y2=1.595
r1974 (  383 514 ) resistor r=176.904 //w=0.094 //l=0.345 //layer=ply \
 //thickness=0.18 //x=47.1 //y=1.75 //x2=47.1 //y2=2.095
r1975 (  382 517 ) resistor r=39.5823 //w=0.21 //l=0.173853 //layer=ply \
 //thickness=0.18 //x=47.1 //y=1.44 //x2=47.14 //y2=1.595
r1976 (  381 516 ) resistor r=45.1352 //w=0.168 //l=0.173853 //layer=ply \
 //thickness=0.18 //x=47.1 //y=1.095 //x2=47.14 //y2=0.94
r1977 (  381 382 ) resistor r=176.904 //w=0.094 //l=0.345 //layer=ply \
 //thickness=0.18 //x=47.1 //y=1.095 //x2=47.1 //y2=1.44
r1978 (  378 519 ) resistor r=53.7854 //w=0.233 //l=0.332415 //layer=ply \
 //thickness=0.18 //x=46.85 //y=5.045 //x2=47.11 //y2=4.88
r1979 (  374 506 ) resistor r=16.5046 //w=0.27 //l=0.135 //layer=ply \
 //thickness=0.18 //x=31.705 //y=4.97 //x2=31.57 //y2=4.97
r1980 (  373 375 ) resistor r=26.9307 //w=0.15 //l=0.106066 //layer=ply \
 //thickness=0.18 //x=31.905 //y=4.97 //x2=31.98 //y2=5.045
r1981 (  373 374 ) resistor r=102.553 //w=0.094 //l=0.2 //layer=ply \
 //thickness=0.18 //x=31.905 //y=4.97 //x2=31.705 //y2=4.97
r1982 (  372 511 ) resistor r=38.6777 //w=0.284 //l=0.198997 //layer=ply \
 //thickness=0.18 //x=31.66 //y=2.095 //x2=31.585 //y2=2.26
r1983 (  371 509 ) resistor r=21.2976 //w=0.217 //l=0.0928709 //layer=ply \
 //thickness=0.18 //x=31.66 //y=1.63 //x2=31.62 //y2=1.555
r1984 (  371 372 ) resistor r=238.436 //w=0.094 //l=0.465 //layer=ply \
 //thickness=0.18 //x=31.66 //y=1.63 //x2=31.66 //y2=2.095
r1985 (  370 509 ) resistor r=39.0671 //w=0.217 //l=0.173853 //layer=ply \
 //thickness=0.18 //x=31.66 //y=1.4 //x2=31.62 //y2=1.555
r1986 (  369 508 ) resistor r=45.1352 //w=0.168 //l=0.173853 //layer=ply \
 //thickness=0.18 //x=31.66 //y=1.09 //x2=31.62 //y2=0.935
r1987 (  369 370 ) resistor r=158.957 //w=0.094 //l=0.31 //layer=ply \
 //thickness=0.18 //x=31.66 //y=1.09 //x2=31.66 //y2=1.4
r1988 (  364 502 ) resistor r=5.52526 //w=0.168 //l=0.115 //layer=ply \
 //thickness=0.18 //x=31.29 //y=1.555 //x2=31.175 //y2=1.555
r1989 (  363 509 ) resistor r=11.4558 //w=0.217 //l=0.115 //layer=ply \
 //thickness=0.18 //x=31.505 //y=1.555 //x2=31.62 //y2=1.555
r1990 (  362 501 ) resistor r=5.52526 //w=0.168 //l=0.115 //layer=ply \
 //thickness=0.18 //x=31.29 //y=0.935 //x2=31.175 //y2=0.935
r1991 (  361 508 ) resistor r=5.52526 //w=0.168 //l=0.115 //layer=ply \
 //thickness=0.18 //x=31.505 //y=0.935 //x2=31.62 //y2=0.935
r1992 (  361 362 ) resistor r=110.245 //w=0.094 //l=0.215 //layer=ply \
 //thickness=0.18 //x=31.505 //y=0.935 //x2=31.29 //y2=0.935
r1993 (  360 502 ) resistor r=45.1352 //w=0.168 //l=0.173853 //layer=ply \
 //thickness=0.18 //x=31.135 //y=1.4 //x2=31.175 //y2=1.555
r1994 (  359 501 ) resistor r=45.1352 //w=0.168 //l=0.173853 //layer=ply \
 //thickness=0.18 //x=31.135 //y=1.09 //x2=31.175 //y2=0.935
r1995 (  359 360 ) resistor r=158.957 //w=0.094 //l=0.31 //layer=ply \
 //thickness=0.18 //x=31.135 //y=1.09 //x2=31.135 //y2=1.4
r1996 (  355 495 ) resistor r=16.5046 //w=0.27 //l=0.135 //layer=ply \
 //thickness=0.18 //x=22.085 //y=4.97 //x2=21.95 //y2=4.97
r1997 (  354 356 ) resistor r=26.9307 //w=0.15 //l=0.106066 //layer=ply \
 //thickness=0.18 //x=22.285 //y=4.97 //x2=22.36 //y2=5.045
r1998 (  354 355 ) resistor r=102.553 //w=0.094 //l=0.2 //layer=ply \
 //thickness=0.18 //x=22.285 //y=4.97 //x2=22.085 //y2=4.97
r1999 (  353 500 ) resistor r=38.6777 //w=0.284 //l=0.198997 //layer=ply \
 //thickness=0.18 //x=22.04 //y=2.095 //x2=21.965 //y2=2.26
r2000 (  352 498 ) resistor r=21.2976 //w=0.217 //l=0.0928709 //layer=ply \
 //thickness=0.18 //x=22.04 //y=1.63 //x2=22 //y2=1.555
r2001 (  352 353 ) resistor r=238.436 //w=0.094 //l=0.465 //layer=ply \
 //thickness=0.18 //x=22.04 //y=1.63 //x2=22.04 //y2=2.095
r2002 (  351 498 ) resistor r=39.0671 //w=0.217 //l=0.173853 //layer=ply \
 //thickness=0.18 //x=22.04 //y=1.4 //x2=22 //y2=1.555
r2003 (  350 497 ) resistor r=45.1352 //w=0.168 //l=0.173853 //layer=ply \
 //thickness=0.18 //x=22.04 //y=1.09 //x2=22 //y2=0.935
r2004 (  350 351 ) resistor r=158.957 //w=0.094 //l=0.31 //layer=ply \
 //thickness=0.18 //x=22.04 //y=1.09 //x2=22.04 //y2=1.4
r2005 (  345 491 ) resistor r=5.52526 //w=0.168 //l=0.115 //layer=ply \
 //thickness=0.18 //x=21.67 //y=1.555 //x2=21.555 //y2=1.555
r2006 (  344 498 ) resistor r=11.4558 //w=0.217 //l=0.115 //layer=ply \
 //thickness=0.18 //x=21.885 //y=1.555 //x2=22 //y2=1.555
r2007 (  343 490 ) resistor r=5.52526 //w=0.168 //l=0.115 //layer=ply \
 //thickness=0.18 //x=21.67 //y=0.935 //x2=21.555 //y2=0.935
r2008 (  342 497 ) resistor r=5.52526 //w=0.168 //l=0.115 //layer=ply \
 //thickness=0.18 //x=21.885 //y=0.935 //x2=22 //y2=0.935
r2009 (  342 343 ) resistor r=110.245 //w=0.094 //l=0.215 //layer=ply \
 //thickness=0.18 //x=21.885 //y=0.935 //x2=21.67 //y2=0.935
r2010 (  341 491 ) resistor r=45.1352 //w=0.168 //l=0.173853 //layer=ply \
 //thickness=0.18 //x=21.515 //y=1.4 //x2=21.555 //y2=1.555
r2011 (  340 490 ) resistor r=45.1352 //w=0.168 //l=0.173853 //layer=ply \
 //thickness=0.18 //x=21.515 //y=1.09 //x2=21.555 //y2=0.935
r2012 (  340 341 ) resistor r=158.957 //w=0.094 //l=0.31 //layer=ply \
 //thickness=0.18 //x=21.515 //y=1.09 //x2=21.515 //y2=1.4
r2013 (  339 489 ) resistor r=45.1352 //w=0.168 //l=0.173853 //layer=ply \
 //thickness=0.18 //x=18.77 //y=1.44 //x2=18.73 //y2=1.595
r2014 (  338 488 ) resistor r=45.1352 //w=0.168 //l=0.173853 //layer=ply \
 //thickness=0.18 //x=18.77 //y=1.095 //x2=18.73 //y2=0.94
r2015 (  338 339 ) resistor r=176.904 //w=0.094 //l=0.345 //layer=ply \
 //thickness=0.18 //x=18.77 //y=1.095 //x2=18.77 //y2=1.44
r2016 (  336 485 ) resistor r=10.701 //w=0.21 //l=0.115 //layer=ply \
 //thickness=0.18 //x=18.395 //y=1.595 //x2=18.28 //y2=1.595
r2017 (  335 489 ) resistor r=5.52526 //w=0.168 //l=0.115 //layer=ply \
 //thickness=0.18 //x=18.615 //y=1.595 //x2=18.73 //y2=1.595
r2018 (  334 484 ) resistor r=5.52526 //w=0.168 //l=0.115 //layer=ply \
 //thickness=0.18 //x=18.395 //y=0.94 //x2=18.28 //y2=0.94
r2019 (  333 488 ) resistor r=5.52526 //w=0.168 //l=0.115 //layer=ply \
 //thickness=0.18 //x=18.615 //y=0.94 //x2=18.73 //y2=0.94
r2020 (  333 334 ) resistor r=112.809 //w=0.094 //l=0.22 //layer=ply \
 //thickness=0.18 //x=18.615 //y=0.94 //x2=18.395 //y2=0.94
r2021 (  330 487 ) resistor r=37.236 //w=0.233 //l=0.249199 //layer=ply \
 //thickness=0.18 //x=18.43 //y=5.045 //x2=18.25 //y2=4.88
r2022 (  328 485 ) resistor r=39.5823 //w=0.21 //l=0.173853 //layer=ply \
 //thickness=0.18 //x=18.24 //y=1.75 //x2=18.28 //y2=1.595
r2023 (  328 482 ) resistor r=176.904 //w=0.094 //l=0.345 //layer=ply \
 //thickness=0.18 //x=18.24 //y=1.75 //x2=18.24 //y2=2.095
r2024 (  327 485 ) resistor r=39.5823 //w=0.21 //l=0.173853 //layer=ply \
 //thickness=0.18 //x=18.24 //y=1.44 //x2=18.28 //y2=1.595
r2025 (  326 484 ) resistor r=45.1352 //w=0.168 //l=0.173853 //layer=ply \
 //thickness=0.18 //x=18.24 //y=1.095 //x2=18.28 //y2=0.94
r2026 (  326 327 ) resistor r=176.904 //w=0.094 //l=0.345 //layer=ply \
 //thickness=0.18 //x=18.24 //y=1.095 //x2=18.24 //y2=1.44
r2027 (  323 487 ) resistor r=53.7854 //w=0.233 //l=0.332415 //layer=ply \
 //thickness=0.18 //x=17.99 //y=5.045 //x2=18.25 //y2=4.88
r2028 (  319 474 ) resistor r=16.5046 //w=0.27 //l=0.135 //layer=ply \
 //thickness=0.18 //x=2.845 //y=4.97 //x2=2.71 //y2=4.97
r2029 (  318 320 ) resistor r=26.9307 //w=0.15 //l=0.106066 //layer=ply \
 //thickness=0.18 //x=3.045 //y=4.97 //x2=3.12 //y2=5.045
r2030 (  318 319 ) resistor r=102.553 //w=0.094 //l=0.2 //layer=ply \
 //thickness=0.18 //x=3.045 //y=4.97 //x2=2.845 //y2=4.97
r2031 (  317 479 ) resistor r=38.6777 //w=0.284 //l=0.198997 //layer=ply \
 //thickness=0.18 //x=2.8 //y=2.095 //x2=2.725 //y2=2.26
r2032 (  316 477 ) resistor r=21.2976 //w=0.217 //l=0.0928709 //layer=ply \
 //thickness=0.18 //x=2.8 //y=1.63 //x2=2.76 //y2=1.555
r2033 (  316 317 ) resistor r=238.436 //w=0.094 //l=0.465 //layer=ply \
 //thickness=0.18 //x=2.8 //y=1.63 //x2=2.8 //y2=2.095
r2034 (  315 477 ) resistor r=39.0671 //w=0.217 //l=0.173853 //layer=ply \
 //thickness=0.18 //x=2.8 //y=1.4 //x2=2.76 //y2=1.555
r2035 (  314 476 ) resistor r=45.1352 //w=0.168 //l=0.173853 //layer=ply \
 //thickness=0.18 //x=2.8 //y=1.09 //x2=2.76 //y2=0.935
r2036 (  314 315 ) resistor r=158.957 //w=0.094 //l=0.31 //layer=ply \
 //thickness=0.18 //x=2.8 //y=1.09 //x2=2.8 //y2=1.4
r2037 (  309 470 ) resistor r=5.52526 //w=0.168 //l=0.115 //layer=ply \
 //thickness=0.18 //x=2.43 //y=1.555 //x2=2.315 //y2=1.555
r2038 (  308 477 ) resistor r=11.4558 //w=0.217 //l=0.115 //layer=ply \
 //thickness=0.18 //x=2.645 //y=1.555 //x2=2.76 //y2=1.555
r2039 (  307 469 ) resistor r=5.52526 //w=0.168 //l=0.115 //layer=ply \
 //thickness=0.18 //x=2.43 //y=0.935 //x2=2.315 //y2=0.935
r2040 (  306 476 ) resistor r=5.52526 //w=0.168 //l=0.115 //layer=ply \
 //thickness=0.18 //x=2.645 //y=0.935 //x2=2.76 //y2=0.935
r2041 (  306 307 ) resistor r=110.245 //w=0.094 //l=0.215 //layer=ply \
 //thickness=0.18 //x=2.645 //y=0.935 //x2=2.43 //y2=0.935
r2042 (  305 470 ) resistor r=45.1352 //w=0.168 //l=0.173853 //layer=ply \
 //thickness=0.18 //x=2.275 //y=1.4 //x2=2.315 //y2=1.555
r2043 (  304 469 ) resistor r=45.1352 //w=0.168 //l=0.173853 //layer=ply \
 //thickness=0.18 //x=2.275 //y=1.09 //x2=2.315 //y2=0.935
r2044 (  304 305 ) resistor r=158.957 //w=0.094 //l=0.31 //layer=ply \
 //thickness=0.18 //x=2.275 //y=1.09 //x2=2.275 //y2=1.4
r2045 (  303 466 ) resistor r=592.245 //w=0.094 //l=1.155 //layer=ply \
 //thickness=0.18 //x=80.08 //y=6.2 //x2=80.08 //y2=5.045
r2046 (  302 560 ) resistor r=592.245 //w=0.094 //l=1.155 //layer=ply \
 //thickness=0.18 //x=79.64 //y=6.2 //x2=79.64 //y2=5.045
r2047 (  301 440 ) resistor r=592.245 //w=0.094 //l=1.155 //layer=ply \
 //thickness=0.18 //x=76.15 //y=6.2 //x2=76.15 //y2=5.045
r2048 (  300 433 ) resistor r=592.245 //w=0.094 //l=1.155 //layer=ply \
 //thickness=0.18 //x=75.71 //y=6.2 //x2=75.71 //y2=5.045
r2049 (  299 430 ) resistor r=592.245 //w=0.094 //l=1.155 //layer=ply \
 //thickness=0.18 //x=60.84 //y=6.2 //x2=60.84 //y2=5.045
r2050 (  298 539 ) resistor r=592.245 //w=0.094 //l=1.155 //layer=ply \
 //thickness=0.18 //x=60.4 //y=6.2 //x2=60.4 //y2=5.045
r2051 (  297 411 ) resistor r=592.245 //w=0.094 //l=1.155 //layer=ply \
 //thickness=0.18 //x=51.22 //y=6.2 //x2=51.22 //y2=5.045
r2052 (  296 528 ) resistor r=592.245 //w=0.094 //l=1.155 //layer=ply \
 //thickness=0.18 //x=50.78 //y=6.2 //x2=50.78 //y2=5.045
r2053 (  295 385 ) resistor r=592.245 //w=0.094 //l=1.155 //layer=ply \
 //thickness=0.18 //x=47.29 //y=6.2 //x2=47.29 //y2=5.045
r2054 (  294 378 ) resistor r=592.245 //w=0.094 //l=1.155 //layer=ply \
 //thickness=0.18 //x=46.85 //y=6.2 //x2=46.85 //y2=5.045
r2055 (  293 375 ) resistor r=592.245 //w=0.094 //l=1.155 //layer=ply \
 //thickness=0.18 //x=31.98 //y=6.2 //x2=31.98 //y2=5.045
r2056 (  292 507 ) resistor r=592.245 //w=0.094 //l=1.155 //layer=ply \
 //thickness=0.18 //x=31.54 //y=6.2 //x2=31.54 //y2=5.045
r2057 (  291 356 ) resistor r=592.245 //w=0.094 //l=1.155 //layer=ply \
 //thickness=0.18 //x=22.36 //y=6.2 //x2=22.36 //y2=5.045
r2058 (  290 496 ) resistor r=592.245 //w=0.094 //l=1.155 //layer=ply \
 //thickness=0.18 //x=21.92 //y=6.2 //x2=21.92 //y2=5.045
r2059 (  289 330 ) resistor r=592.245 //w=0.094 //l=1.155 //layer=ply \
 //thickness=0.18 //x=18.43 //y=6.2 //x2=18.43 //y2=5.045
r2060 (  288 323 ) resistor r=592.245 //w=0.094 //l=1.155 //layer=ply \
 //thickness=0.18 //x=17.99 //y=6.2 //x2=17.99 //y2=5.045
r2061 (  287 320 ) resistor r=592.245 //w=0.094 //l=1.155 //layer=ply \
 //thickness=0.18 //x=3.12 //y=6.2 //x2=3.12 //y2=5.045
r2062 (  286 475 ) resistor r=592.245 //w=0.094 //l=1.155 //layer=ply \
 //thickness=0.18 //x=2.68 //y=6.2 //x2=2.68 //y2=5.045
r2063 (  285 454 ) resistor r=55.3787 //w=0.094 //l=0.108 //layer=ply \
 //thickness=0.18 //x=79.497 //y=1.555 //x2=79.605 //y2=1.555
r2064 (  285 455 ) resistor r=54.866 //w=0.094 //l=0.107 //layer=ply \
 //thickness=0.18 //x=79.497 //y=1.555 //x2=79.39 //y2=1.555
r2065 (  284 445 ) resistor r=56.4043 //w=0.094 //l=0.11 //layer=ply \
 //thickness=0.18 //x=76.225 //y=1.595 //x2=76.335 //y2=1.595
r2066 (  284 446 ) resistor r=56.4043 //w=0.094 //l=0.11 //layer=ply \
 //thickness=0.18 //x=76.225 //y=1.595 //x2=76.115 //y2=1.595
r2067 (  283 418 ) resistor r=55.3787 //w=0.094 //l=0.108 //layer=ply \
 //thickness=0.18 //x=60.257 //y=1.555 //x2=60.365 //y2=1.555
r2068 (  283 419 ) resistor r=54.866 //w=0.094 //l=0.107 //layer=ply \
 //thickness=0.18 //x=60.257 //y=1.555 //x2=60.15 //y2=1.555
r2069 (  282 399 ) resistor r=55.3787 //w=0.094 //l=0.108 //layer=ply \
 //thickness=0.18 //x=50.637 //y=1.555 //x2=50.745 //y2=1.555
r2070 (  282 400 ) resistor r=54.866 //w=0.094 //l=0.107 //layer=ply \
 //thickness=0.18 //x=50.637 //y=1.555 //x2=50.53 //y2=1.555
r2071 (  281 390 ) resistor r=56.4043 //w=0.094 //l=0.11 //layer=ply \
 //thickness=0.18 //x=47.365 //y=1.595 //x2=47.475 //y2=1.595
r2072 (  281 391 ) resistor r=56.4043 //w=0.094 //l=0.11 //layer=ply \
 //thickness=0.18 //x=47.365 //y=1.595 //x2=47.255 //y2=1.595
r2073 (  280 363 ) resistor r=55.3787 //w=0.094 //l=0.108 //layer=ply \
 //thickness=0.18 //x=31.397 //y=1.555 //x2=31.505 //y2=1.555
r2074 (  280 364 ) resistor r=54.866 //w=0.094 //l=0.107 //layer=ply \
 //thickness=0.18 //x=31.397 //y=1.555 //x2=31.29 //y2=1.555
r2075 (  279 344 ) resistor r=55.3787 //w=0.094 //l=0.108 //layer=ply \
 //thickness=0.18 //x=21.777 //y=1.555 //x2=21.885 //y2=1.555
r2076 (  279 345 ) resistor r=54.866 //w=0.094 //l=0.107 //layer=ply \
 //thickness=0.18 //x=21.777 //y=1.555 //x2=21.67 //y2=1.555
r2077 (  278 335 ) resistor r=56.4043 //w=0.094 //l=0.11 //layer=ply \
 //thickness=0.18 //x=18.505 //y=1.595 //x2=18.615 //y2=1.595
r2078 (  278 336 ) resistor r=56.4043 //w=0.094 //l=0.11 //layer=ply \
 //thickness=0.18 //x=18.505 //y=1.595 //x2=18.395 //y2=1.595
r2079 (  277 308 ) resistor r=55.3787 //w=0.094 //l=0.108 //layer=ply \
 //thickness=0.18 //x=2.537 //y=1.555 //x2=2.645 //y2=1.555
r2080 (  277 309 ) resistor r=54.866 //w=0.094 //l=0.107 //layer=ply \
 //thickness=0.18 //x=2.537 //y=1.555 //x2=2.43 //y2=1.555
r2081 (  273 557 ) resistor r=152 //w=0.17 //l=0.17 //layer=licon //count=1 \
 //x=79.67 //y=4.88 //x2=79.67 //y2=4.88
r2082 (  268 564 ) resistor r=152 //w=0.17 //l=0.17 //layer=licon //count=1 \
 //x=79.67 //y=2.26 //x2=79.67 //y2=2.26
r2083 (  263 551 ) resistor r=152 //w=0.17 //l=0.17 //layer=licon //count=1 \
 //x=75.97 //y=4.88 //x2=75.97 //y2=4.88
r2084 (  258 545 ) resistor r=152 //w=0.17 //l=0.17 //layer=licon //count=1 \
 //x=75.97 //y=2.26 //x2=75.97 //y2=2.26
r2085 (  253 536 ) resistor r=152 //w=0.17 //l=0.17 //layer=licon //count=1 \
 //x=60.43 //y=4.88 //x2=60.43 //y2=4.88
r2086 (  248 543 ) resistor r=152 //w=0.17 //l=0.17 //layer=licon //count=1 \
 //x=60.43 //y=2.26 //x2=60.43 //y2=2.26
r2087 (  243 525 ) resistor r=152 //w=0.17 //l=0.17 //layer=licon //count=1 \
 //x=50.81 //y=4.88 //x2=50.81 //y2=4.88
r2088 (  238 532 ) resistor r=152 //w=0.17 //l=0.17 //layer=licon //count=1 \
 //x=50.81 //y=2.26 //x2=50.81 //y2=2.26
r2089 (  233 519 ) resistor r=152 //w=0.17 //l=0.17 //layer=licon //count=1 \
 //x=47.11 //y=4.88 //x2=47.11 //y2=4.88
r2090 (  228 513 ) resistor r=152 //w=0.17 //l=0.17 //layer=licon //count=1 \
 //x=47.11 //y=2.26 //x2=47.11 //y2=2.26
r2091 (  223 504 ) resistor r=152 //w=0.17 //l=0.17 //layer=licon //count=1 \
 //x=31.57 //y=4.88 //x2=31.57 //y2=4.88
r2092 (  218 511 ) resistor r=152 //w=0.17 //l=0.17 //layer=licon //count=1 \
 //x=31.57 //y=2.26 //x2=31.57 //y2=2.26
r2093 (  213 493 ) resistor r=152 //w=0.17 //l=0.17 //layer=licon //count=1 \
 //x=21.95 //y=4.88 //x2=21.95 //y2=4.88
r2094 (  208 500 ) resistor r=152 //w=0.17 //l=0.17 //layer=licon //count=1 \
 //x=21.95 //y=2.26 //x2=21.95 //y2=2.26
r2095 (  203 487 ) resistor r=152 //w=0.17 //l=0.17 //layer=licon //count=1 \
 //x=18.25 //y=4.88 //x2=18.25 //y2=4.88
r2096 (  198 481 ) resistor r=152 //w=0.17 //l=0.17 //layer=licon //count=1 \
 //x=18.25 //y=2.26 //x2=18.25 //y2=2.26
r2097 (  193 472 ) resistor r=152 //w=0.17 //l=0.17 //layer=licon //count=1 \
 //x=2.71 //y=4.88 //x2=2.71 //y2=4.88
r2098 (  188 479 ) resistor r=152 //w=0.17 //l=0.17 //layer=licon //count=1 \
 //x=2.71 //y=2.26 //x2=2.71 //y2=2.26
r2099 (  184 185 ) resistor r=0.10734 //w=0.281 //l=0.16 //layer=m2 \
 //thickness=0.36 //x=79.665 //y=2.41 //x2=79.505 //y2=2.41
r2100 (  165 182 ) resistor r=0.105717 //w=0.193 //l=0.162481 //layer=m2 \
 //thickness=0.36 //x=76.135 //y=2.4 //x2=75.975 //y2=2.405
r2101 (  165 185 ) resistor r=3.21565 //w=0.131 //l=3.37 //layer=m2 \
 //thickness=0.36 //x=76.135 //y=2.4 //x2=79.505 //y2=2.4
r2102 (  162 182 ) resistor r=1.29743 //w=0.193 //l=2.00998 //layer=m2 \
 //thickness=0.36 //x=73.975 //y=2.385 //x2=75.975 //y2=2.405
r2103 (  162 163 ) resistor r=0.410305 //w=0.131 //l=0.43 //layer=m2 \
 //thickness=0.36 //x=73.975 //y=2.385 //x2=73.545 //y2=2.385
r2104 (  160 163 ) resistor r=0.125 //w=0.17 //l=0.177341 //layer=m2 \
 //thickness=0.36 //x=73.375 //y=2.4 //x2=73.545 //y2=2.385
r2105 (  160 161 ) resistor r=0.958969 //w=0.131 //l=1.005 //layer=m2 \
 //thickness=0.36 //x=73.375 //y=2.4 //x2=72.37 //y2=2.4
r2106 (  159 180 ) resistor r=8.13223 //w=0.173 //l=11.2625 //layer=m2 \
 //thickness=0.36 //x=71.685 //y=2.385 //x2=60.43 //y2=2.4
r2107 (  158 161 ) resistor r=0.1875 //w=0.17 //l=0.262393 //layer=m2 \
 //thickness=0.36 //x=72.115 //y=2.385 //x2=72.37 //y2=2.4
r2108 (  158 159 ) resistor r=0.410305 //w=0.131 //l=0.43 //layer=m2 \
 //thickness=0.36 //x=72.115 //y=2.385 //x2=71.685 //y2=2.385
r2109 (  156 180 ) resistor r=4.15462 //w=0.173 //l=5.76498 //layer=m2 \
 //thickness=0.36 //x=54.68 //y=2.37 //x2=60.43 //y2=2.4
r2110 (  156 157 ) resistor r=0.410305 //w=0.131 //l=0.43 //layer=m2 \
 //thickness=0.36 //x=54.68 //y=2.37 //x2=54.25 //y2=2.37
r2111 (  154 157 ) resistor r=0.125 //w=0.17 //l=0.184391 //layer=m2 \
 //thickness=0.36 //x=54.08 //y=2.4 //x2=54.25 //y2=2.37
r2112 (  154 155 ) resistor r=0.86355 //w=0.131 //l=0.905 //layer=m2 \
 //thickness=0.36 //x=54.08 //y=2.4 //x2=53.175 //y2=2.4
r2113 (  153 178 ) resistor r=1.07185 //w=0.197 //l=1.70488 //layer=m2 \
 //thickness=0.36 //x=52.49 //y=2.37 //x2=50.805 //y2=2.41
r2114 (  152 155 ) resistor r=0.1875 //w=0.17 //l=0.269583 //layer=m2 \
 //thickness=0.36 //x=52.92 //y=2.37 //x2=53.175 //y2=2.4
r2115 (  152 153 ) resistor r=0.410305 //w=0.131 //l=0.43 //layer=m2 \
 //thickness=0.36 //x=52.92 //y=2.37 //x2=52.49 //y2=2.37
r2116 (  151 176 ) resistor r=0.105717 //w=0.193 //l=0.162481 //layer=m2 \
 //thickness=0.36 //x=47.275 //y=2.4 //x2=47.115 //y2=2.405
r2117 (  150 178 ) resistor r=0.104215 //w=0.197 //l=0.164924 //layer=m2 \
 //thickness=0.36 //x=50.645 //y=2.4 //x2=50.805 //y2=2.41
r2118 (  150 151 ) resistor r=3.21565 //w=0.131 //l=3.37 //layer=m2 \
 //thickness=0.36 //x=50.645 //y=2.4 //x2=47.275 //y2=2.4
r2119 (  148 176 ) resistor r=1.29743 //w=0.193 //l=2.00998 //layer=m2 \
 //thickness=0.36 //x=45.115 //y=2.385 //x2=47.115 //y2=2.405
r2120 (  148 149 ) resistor r=0.410305 //w=0.131 //l=0.43 //layer=m2 \
 //thickness=0.36 //x=45.115 //y=2.385 //x2=44.685 //y2=2.385
r2121 (  146 149 ) resistor r=0.125 //w=0.17 //l=0.177341 //layer=m2 \
 //thickness=0.36 //x=44.515 //y=2.4 //x2=44.685 //y2=2.385
r2122 (  146 147 ) resistor r=0.958969 //w=0.131 //l=1.005 //layer=m2 \
 //thickness=0.36 //x=44.515 //y=2.4 //x2=43.51 //y2=2.4
r2123 (  145 174 ) resistor r=8.13223 //w=0.173 //l=11.2625 //layer=m2 \
 //thickness=0.36 //x=42.825 //y=2.385 //x2=31.57 //y2=2.4
r2124 (  144 147 ) resistor r=0.1875 //w=0.17 //l=0.262393 //layer=m2 \
 //thickness=0.36 //x=43.255 //y=2.385 //x2=43.51 //y2=2.4
r2125 (  144 145 ) resistor r=0.410305 //w=0.131 //l=0.43 //layer=m2 \
 //thickness=0.36 //x=43.255 //y=2.385 //x2=42.825 //y2=2.385
r2126 (  142 174 ) resistor r=4.12211 //w=0.173 //l=5.71998 //layer=m2 \
 //thickness=0.36 //x=25.865 //y=2.37 //x2=31.57 //y2=2.4
r2127 (  142 143 ) resistor r=0.410305 //w=0.131 //l=0.43 //layer=m2 \
 //thickness=0.36 //x=25.865 //y=2.37 //x2=25.435 //y2=2.37
r2128 (  140 143 ) resistor r=0.125 //w=0.17 //l=0.184391 //layer=m2 \
 //thickness=0.36 //x=25.265 //y=2.4 //x2=25.435 //y2=2.37
r2129 (  140 141 ) resistor r=0.96374 //w=0.131 //l=1.01 //layer=m2 \
 //thickness=0.36 //x=25.265 //y=2.4 //x2=24.255 //y2=2.4
r2130 (  139 172 ) resistor r=1.03378 //w=0.197 //l=1.64488 //layer=m2 \
 //thickness=0.36 //x=23.57 //y=2.37 //x2=21.945 //y2=2.41
r2131 (  138 141 ) resistor r=0.1875 //w=0.17 //l=0.269583 //layer=m2 \
 //thickness=0.36 //x=24 //y=2.37 //x2=24.255 //y2=2.4
r2132 (  138 139 ) resistor r=0.410305 //w=0.131 //l=0.43 //layer=m2 \
 //thickness=0.36 //x=24 //y=2.37 //x2=23.57 //y2=2.37
r2133 (  137 170 ) resistor r=0.105717 //w=0.193 //l=0.162481 //layer=m2 \
 //thickness=0.36 //x=18.415 //y=2.4 //x2=18.255 //y2=2.405
r2134 (  136 172 ) resistor r=0.104215 //w=0.197 //l=0.164924 //layer=m2 \
 //thickness=0.36 //x=21.785 //y=2.4 //x2=21.945 //y2=2.41
r2135 (  136 137 ) resistor r=3.21565 //w=0.131 //l=3.37 //layer=m2 \
 //thickness=0.36 //x=21.785 //y=2.4 //x2=18.415 //y2=2.4
r2136 (  134 170 ) resistor r=1.29743 //w=0.193 //l=2.00998 //layer=m2 \
 //thickness=0.36 //x=16.255 //y=2.385 //x2=18.255 //y2=2.405
r2137 (  134 135 ) resistor r=0.410305 //w=0.131 //l=0.43 //layer=m2 \
 //thickness=0.36 //x=16.255 //y=2.385 //x2=15.825 //y2=2.385
r2138 (  132 135 ) resistor r=0.125 //w=0.17 //l=0.177341 //layer=m2 \
 //thickness=0.36 //x=15.655 //y=2.4 //x2=15.825 //y2=2.385
r2139 (  132 133 ) resistor r=0.958969 //w=0.131 //l=1.005 //layer=m2 \
 //thickness=0.36 //x=15.655 //y=2.4 //x2=14.65 //y2=2.4
r2140 (  130 133 ) resistor r=0.1875 //w=0.17 //l=0.262393 //layer=m2 \
 //thickness=0.36 //x=14.395 //y=2.385 //x2=14.65 //y2=2.4
r2141 (  130 131 ) resistor r=0.410305 //w=0.131 //l=0.43 //layer=m2 \
 //thickness=0.36 //x=14.395 //y=2.385 //x2=13.965 //y2=2.385
r2142 (  129 167 ) resistor r=0.10734 //w=0.281 //l=0.16 //layer=m2 \
 //thickness=0.36 //x=2.87 //y=2.4 //x2=2.71 //y2=2.4
r2143 (  128 131 ) resistor r=0.125 //w=0.17 //l=0.177341 //layer=m2 \
 //thickness=0.36 //x=13.795 //y=2.4 //x2=13.965 //y2=2.385
r2144 (  128 129 ) resistor r=10.4246 //w=0.131 //l=10.925 //layer=m2 \
 //thickness=0.36 //x=13.795 //y=2.4 //x2=2.87 //y2=2.4
r2145 (  127 184 ) resistor r=4.5 //w=0.15 //l=0.15 //layer=via1 //count=1 \
 //x=79.665 //y=2.41 //x2=79.665 //y2=2.41
r2146 (  124 268 ) resistor r=9.3 //w=0.17 //l=0.17 //layer=mcon //count=1 \
 //x=79.67 //y=2.26 //x2=79.67 //y2=2.26
r2147 (  122 273 ) resistor r=9.3 //w=0.17 //l=0.17 //layer=mcon //count=1 \
 //x=79.67 //y=4.88 //x2=79.67 //y2=4.88
r2148 (  120 182 ) resistor r=4.5 //w=0.15 //l=0.15 //layer=via1 //count=1 \
 //x=75.975 //y=2.405 //x2=75.975 //y2=2.405
r2149 (  117 258 ) resistor r=9.3 //w=0.17 //l=0.17 //layer=mcon //count=1 \
 //x=75.97 //y=2.26 //x2=75.97 //y2=2.26
r2150 (  115 263 ) resistor r=9.3 //w=0.17 //l=0.17 //layer=mcon //count=1 \
 //x=75.97 //y=4.88 //x2=75.97 //y2=4.88
r2151 (  111 248 ) resistor r=9.3 //w=0.17 //l=0.17 //layer=mcon //count=1 \
 //x=60.43 //y=2.26 //x2=60.43 //y2=2.26
r2152 (  109 253 ) resistor r=9.3 //w=0.17 //l=0.17 //layer=mcon //count=1 \
 //x=60.43 //y=4.88 //x2=60.43 //y2=4.88
r2153 (  107 178 ) resistor r=4.5 //w=0.15 //l=0.15 //layer=via1 //count=1 \
 //x=50.805 //y=2.41 //x2=50.805 //y2=2.41
r2154 (  104 238 ) resistor r=9.3 //w=0.17 //l=0.17 //layer=mcon //count=1 \
 //x=50.81 //y=2.26 //x2=50.81 //y2=2.26
r2155 (  102 243 ) resistor r=9.3 //w=0.17 //l=0.17 //layer=mcon //count=1 \
 //x=50.81 //y=4.88 //x2=50.81 //y2=4.88
r2156 (  100 176 ) resistor r=4.5 //w=0.15 //l=0.15 //layer=via1 //count=1 \
 //x=47.115 //y=2.405 //x2=47.115 //y2=2.405
r2157 (  97 228 ) resistor r=9.3 //w=0.17 //l=0.17 //layer=mcon //count=1 \
 //x=47.11 //y=2.26 //x2=47.11 //y2=2.26
r2158 (  95 233 ) resistor r=9.3 //w=0.17 //l=0.17 //layer=mcon //count=1 \
 //x=47.11 //y=4.88 //x2=47.11 //y2=4.88
r2159 (  91 218 ) resistor r=9.3 //w=0.17 //l=0.17 //layer=mcon //count=1 \
 //x=31.57 //y=2.26 //x2=31.57 //y2=2.26
r2160 (  89 223 ) resistor r=9.3 //w=0.17 //l=0.17 //layer=mcon //count=1 \
 //x=31.57 //y=4.88 //x2=31.57 //y2=4.88
r2161 (  87 172 ) resistor r=4.5 //w=0.15 //l=0.15 //layer=via1 //count=1 \
 //x=21.945 //y=2.41 //x2=21.945 //y2=2.41
r2162 (  84 208 ) resistor r=9.3 //w=0.17 //l=0.17 //layer=mcon //count=1 \
 //x=21.95 //y=2.26 //x2=21.95 //y2=2.26
r2163 (  82 213 ) resistor r=9.3 //w=0.17 //l=0.17 //layer=mcon //count=1 \
 //x=21.95 //y=4.88 //x2=21.95 //y2=4.88
r2164 (  80 170 ) resistor r=4.5 //w=0.15 //l=0.15 //layer=via1 //count=1 \
 //x=18.255 //y=2.405 //x2=18.255 //y2=2.405
r2165 (  77 198 ) resistor r=9.3 //w=0.17 //l=0.17 //layer=mcon //count=1 \
 //x=18.25 //y=2.26 //x2=18.25 //y2=2.26
r2166 (  75 203 ) resistor r=9.3 //w=0.17 //l=0.17 //layer=mcon //count=1 \
 //x=18.25 //y=4.88 //x2=18.25 //y2=4.88
r2167 (  71 188 ) resistor r=9.3 //w=0.17 //l=0.17 //layer=mcon //count=1 \
 //x=2.71 //y=2.26 //x2=2.71 //y2=2.26
r2168 (  69 193 ) resistor r=9.3 //w=0.17 //l=0.17 //layer=mcon //count=1 \
 //x=2.71 //y=4.88 //x2=2.71 //y2=4.88
r2169 (  65 122 ) resistor r=0.0717383 //w=0.224 //l=0.115 //layer=m1 \
 //thickness=0.36 //x=79.67 //y=4.765 //x2=79.67 //y2=4.88
r2170 (  64 127 ) resistor r=0.0902915 //w=0.287 //l=0.162481 //layer=m1 \
 //thickness=0.36 //x=79.67 //y=2.57 //x2=79.665 //y2=2.41
r2171 (  62 115 ) resistor r=0.0801089 //w=0.224 //l=0.13 //layer=m1 \
 //thickness=0.36 //x=75.97 //y=4.75 //x2=75.97 //y2=4.88
r2172 (  61 120 ) resistor r=0.0902915 //w=0.287 //l=0.162481 //layer=m1 \
 //thickness=0.36 //x=75.97 //y=2.565 //x2=75.975 //y2=2.405
r2173 (  57 109 ) resistor r=0.0717383 //w=0.224 //l=0.115 //layer=m1 \
 //thickness=0.36 //x=60.43 //y=4.765 //x2=60.43 //y2=4.88
r2174 (  53 102 ) resistor r=0.0717383 //w=0.224 //l=0.115 //layer=m1 \
 //thickness=0.36 //x=50.81 //y=4.765 //x2=50.81 //y2=4.88
r2175 (  52 107 ) resistor r=0.0902915 //w=0.287 //l=0.162481 //layer=m1 \
 //thickness=0.36 //x=50.81 //y=2.57 //x2=50.805 //y2=2.41
r2176 (  50 95 ) resistor r=0.0801089 //w=0.224 //l=0.13 //layer=m1 \
 //thickness=0.36 //x=47.11 //y=4.75 //x2=47.11 //y2=4.88
r2177 (  49 100 ) resistor r=0.0902915 //w=0.287 //l=0.162481 //layer=m1 \
 //thickness=0.36 //x=47.11 //y=2.565 //x2=47.115 //y2=2.405
r2178 (  45 89 ) resistor r=0.0717383 //w=0.224 //l=0.115 //layer=m1 \
 //thickness=0.36 //x=31.57 //y=4.765 //x2=31.57 //y2=4.88
r2179 (  41 82 ) resistor r=0.0717383 //w=0.224 //l=0.115 //layer=m1 \
 //thickness=0.36 //x=21.95 //y=4.765 //x2=21.95 //y2=4.88
r2180 (  40 87 ) resistor r=0.0902915 //w=0.287 //l=0.162481 //layer=m1 \
 //thickness=0.36 //x=21.95 //y=2.57 //x2=21.945 //y2=2.41
r2181 (  38 75 ) resistor r=0.0801089 //w=0.224 //l=0.13 //layer=m1 \
 //thickness=0.36 //x=18.25 //y=4.75 //x2=18.25 //y2=4.88
r2182 (  37 80 ) resistor r=0.0902915 //w=0.287 //l=0.162481 //layer=m1 \
 //thickness=0.36 //x=18.25 //y=2.565 //x2=18.255 //y2=2.405
r2183 (  31 69 ) resistor r=0.0717383 //w=0.224 //l=0.115 //layer=m1 \
 //thickness=0.36 //x=2.71 //y=4.765 //x2=2.71 //y2=4.88
r2184 (  29 127 ) resistor r=0.0043554 //w=0.287 //l=0.01 //layer=m1 \
 //thickness=0.36 //x=79.665 //y=2.4 //x2=79.665 //y2=2.41
r2185 (  29 124 ) resistor r=0.0609756 //w=0.287 //l=0.14 //layer=m1 \
 //thickness=0.36 //x=79.665 //y=2.4 //x2=79.665 //y2=2.26
r2186 (  28 120 ) resistor r=0.0021777 //w=0.287 //l=0.005 //layer=m1 \
 //thickness=0.36 //x=75.975 //y=2.4 //x2=75.975 //y2=2.405
r2187 (  28 117 ) resistor r=0.0609756 //w=0.287 //l=0.14 //layer=m1 \
 //thickness=0.36 //x=75.975 //y=2.4 //x2=75.975 //y2=2.26
r2188 (  27 180 ) resistor r=4.5 //w=0.15 //l=0.15 //layer=via1 //count=1 \
 //x=60.43 //y=2.4 //x2=60.43 //y2=2.4
r2189 (  27 56 ) resistor r=0.0902565 //w=0.288 //l=0.16 //layer=m1 \
 //thickness=0.36 //x=60.43 //y=2.4 //x2=60.43 //y2=2.56
r2190 (  27 111 ) resistor r=0.0607639 //w=0.288 //l=0.14 //layer=m1 \
 //thickness=0.36 //x=60.43 //y=2.4 //x2=60.43 //y2=2.26
r2191 (  26 107 ) resistor r=0.0043554 //w=0.287 //l=0.01 //layer=m1 \
 //thickness=0.36 //x=50.805 //y=2.4 //x2=50.805 //y2=2.41
r2192 (  26 104 ) resistor r=0.0609756 //w=0.287 //l=0.14 //layer=m1 \
 //thickness=0.36 //x=50.805 //y=2.4 //x2=50.805 //y2=2.26
r2193 (  25 100 ) resistor r=0.0021777 //w=0.287 //l=0.005 //layer=m1 \
 //thickness=0.36 //x=47.115 //y=2.4 //x2=47.115 //y2=2.405
r2194 (  25 97 ) resistor r=0.0609756 //w=0.287 //l=0.14 //layer=m1 \
 //thickness=0.36 //x=47.115 //y=2.4 //x2=47.115 //y2=2.26
r2195 (  24 174 ) resistor r=4.5 //w=0.15 //l=0.15 //layer=via1 //count=1 \
 //x=31.57 //y=2.4 //x2=31.57 //y2=2.4
r2196 (  24 44 ) resistor r=0.0902565 //w=0.288 //l=0.16 //layer=m1 \
 //thickness=0.36 //x=31.57 //y=2.4 //x2=31.57 //y2=2.56
r2197 (  24 91 ) resistor r=0.0607639 //w=0.288 //l=0.14 //layer=m1 \
 //thickness=0.36 //x=31.57 //y=2.4 //x2=31.57 //y2=2.26
r2198 (  23 87 ) resistor r=0.0043554 //w=0.287 //l=0.01 //layer=m1 \
 //thickness=0.36 //x=21.945 //y=2.4 //x2=21.945 //y2=2.41
r2199 (  23 84 ) resistor r=0.0609756 //w=0.287 //l=0.14 //layer=m1 \
 //thickness=0.36 //x=21.945 //y=2.4 //x2=21.945 //y2=2.26
r2200 (  22 80 ) resistor r=0.0021777 //w=0.287 //l=0.005 //layer=m1 \
 //thickness=0.36 //x=18.255 //y=2.4 //x2=18.255 //y2=2.405
r2201 (  22 77 ) resistor r=0.0609756 //w=0.287 //l=0.14 //layer=m1 \
 //thickness=0.36 //x=18.255 //y=2.4 //x2=18.255 //y2=2.26
r2202 (  21 167 ) resistor r=4.5 //w=0.15 //l=0.15 //layer=via1 //count=1 \
 //x=2.71 //y=2.4 //x2=2.71 //y2=2.4
r2203 (  21 30 ) resistor r=0.0902565 //w=0.288 //l=0.16 //layer=m1 \
 //thickness=0.36 //x=2.71 //y=2.4 //x2=2.71 //y2=2.56
r2204 (  21 71 ) resistor r=0.0607639 //w=0.288 //l=0.14 //layer=m1 \
 //thickness=0.36 //x=2.71 //y=2.4 //x2=2.71 //y2=2.26
r2205 (  20 65 ) resistor r=1.19752 //w=0.131 //l=1.255 //layer=m1 \
 //thickness=0.36 //x=79.67 //y=3.51 //x2=79.67 //y2=4.765
r2206 (  19 20 ) resistor r=0.706107 //w=0.131 //l=0.74 //layer=m1 \
 //thickness=0.36 //x=79.67 //y=2.77 //x2=79.67 //y2=3.51
r2207 (  19 64 ) resistor r=0.19084 //w=0.131 //l=0.2 //layer=m1 \
 //thickness=0.36 //x=79.67 //y=2.77 //x2=79.67 //y2=2.57
r2208 (  18 62 ) resistor r=1.88931 //w=0.131 //l=1.98 //layer=m1 \
 //thickness=0.36 //x=75.97 //y=2.77 //x2=75.97 //y2=4.75
r2209 (  18 61 ) resistor r=0.195611 //w=0.131 //l=0.205 //layer=m1 \
 //thickness=0.36 //x=75.97 //y=2.77 //x2=75.97 //y2=2.565
r2210 (  17 57 ) resistor r=0.491412 //w=0.131 //l=0.515 //layer=m1 \
 //thickness=0.36 //x=60.43 //y=4.25 //x2=60.43 //y2=4.765
r2211 (  16 17 ) resistor r=0.706107 //w=0.131 //l=0.74 //layer=m1 \
 //thickness=0.36 //x=60.43 //y=3.51 //x2=60.43 //y2=4.25
r2212 (  15 16 ) resistor r=0.706107 //w=0.131 //l=0.74 //layer=m1 \
 //thickness=0.36 //x=60.43 //y=2.77 //x2=60.43 //y2=3.51
r2213 (  15 56 ) resistor r=0.200382 //w=0.131 //l=0.21 //layer=m1 \
 //thickness=0.36 //x=60.43 //y=2.77 //x2=60.43 //y2=2.56
r2214 (  14 53 ) resistor r=1.19752 //w=0.131 //l=1.255 //layer=m1 \
 //thickness=0.36 //x=50.81 //y=3.51 //x2=50.81 //y2=4.765
r2215 (  13 14 ) resistor r=0.706107 //w=0.131 //l=0.74 //layer=m1 \
 //thickness=0.36 //x=50.81 //y=2.77 //x2=50.81 //y2=3.51
r2216 (  13 52 ) resistor r=0.19084 //w=0.131 //l=0.2 //layer=m1 \
 //thickness=0.36 //x=50.81 //y=2.77 //x2=50.81 //y2=2.57
r2217 (  12 50 ) resistor r=1.88931 //w=0.131 //l=1.98 //layer=m1 \
 //thickness=0.36 //x=47.11 //y=2.77 //x2=47.11 //y2=4.75
r2218 (  12 49 ) resistor r=0.195611 //w=0.131 //l=0.205 //layer=m1 \
 //thickness=0.36 //x=47.11 //y=2.77 //x2=47.11 //y2=2.565
r2219 (  11 45 ) resistor r=0.844466 //w=0.131 //l=0.885 //layer=m1 \
 //thickness=0.36 //x=31.57 //y=3.88 //x2=31.57 //y2=4.765
r2220 (  10 11 ) resistor r=0.353053 //w=0.131 //l=0.37 //layer=m1 \
 //thickness=0.36 //x=31.57 //y=3.51 //x2=31.57 //y2=3.88
r2221 (  9 10 ) resistor r=0.706107 //w=0.131 //l=0.74 //layer=m1 \
 //thickness=0.36 //x=31.57 //y=2.77 //x2=31.57 //y2=3.51
r2222 (  9 44 ) resistor r=0.200382 //w=0.131 //l=0.21 //layer=m1 \
 //thickness=0.36 //x=31.57 //y=2.77 //x2=31.57 //y2=2.56
r2223 (  8 41 ) resistor r=1.19752 //w=0.131 //l=1.255 //layer=m1 \
 //thickness=0.36 //x=21.95 //y=3.51 //x2=21.95 //y2=4.765
r2224 (  7 8 ) resistor r=0.706107 //w=0.131 //l=0.74 //layer=m1 \
 //thickness=0.36 //x=21.95 //y=2.77 //x2=21.95 //y2=3.51
r2225 (  7 40 ) resistor r=0.19084 //w=0.131 //l=0.2 //layer=m1 \
 //thickness=0.36 //x=21.95 //y=2.77 //x2=21.95 //y2=2.57
r2226 (  6 38 ) resistor r=1.88931 //w=0.131 //l=1.98 //layer=m1 \
 //thickness=0.36 //x=18.25 //y=2.77 //x2=18.25 //y2=4.75
r2227 (  6 37 ) resistor r=0.195611 //w=0.131 //l=0.205 //layer=m1 \
 //thickness=0.36 //x=18.25 //y=2.77 //x2=18.25 //y2=2.565
r2228 (  5 31 ) resistor r=0.138359 //w=0.131 //l=0.145 //layer=m1 \
 //thickness=0.36 //x=2.71 //y=4.62 //x2=2.71 //y2=4.765
r2229 (  4 5 ) resistor r=0.706107 //w=0.131 //l=0.74 //layer=m1 \
 //thickness=0.36 //x=2.71 //y=3.88 //x2=2.71 //y2=4.62
r2230 (  3 4 ) resistor r=0.353053 //w=0.131 //l=0.37 //layer=m1 \
 //thickness=0.36 //x=2.71 //y=3.51 //x2=2.71 //y2=3.88
r2231 (  2 3 ) resistor r=0.353053 //w=0.131 //l=0.37 //layer=m1 \
 //thickness=0.36 //x=2.71 //y=3.14 //x2=2.71 //y2=3.51
r2232 (  1 2 ) resistor r=0.353053 //w=0.131 //l=0.37 //layer=m1 \
 //thickness=0.36 //x=2.71 //y=2.77 //x2=2.71 //y2=3.14
r2233 (  1 30 ) resistor r=0.200382 //w=0.131 //l=0.21 //layer=m1 \
 //thickness=0.36 //x=2.71 //y=2.77 //x2=2.71 //y2=2.56
ends PM_TMRDFFSNRNQX1\%RN

subckt PM_TMRDFFSNRNQX1\%noxref_18 ( 1 3 6 7 9 10 11 12 14 15 16 17 18 19 20 \
 21 24 27 35 39 49 51 52 55 63 71 88 97 101 102 103 104 105 106 107 108 110 \
 116 117 118 119 131 133 134 135 )
c283 ( 131 0 ) capacitor c=0.00885916f //x=80.845 //y=1.095
c284 ( 119 0 ) capacitor c=0.0612936f //x=83.645 //y=4.97
c285 ( 118 0 ) capacitor c=0.0376642f //x=83.935 //y=4.97
c286 ( 117 0 ) capacitor c=0.0346489f //x=83.6 //y=1.4
c287 ( 116 0 ) capacitor c=0.018692f //x=83.6 //y=1.055
c288 ( 110 0 ) capacitor c=0.0137077f //x=83.445 //y=1.555
c289 ( 108 0 ) capacitor c=0.0158585f //x=83.445 //y=0.9
c290 ( 107 0 ) capacitor c=0.0979449f //x=83.07 //y=2.095
c291 ( 106 0 ) capacitor c=0.0229444f //x=83.07 //y=1.71
c292 ( 105 0 ) capacitor c=0.0234359f //x=83.07 //y=1.4
c293 ( 104 0 ) capacitor c=0.019815f //x=83.07 //y=1.055
c294 ( 103 0 ) capacitor c=0.110208f //x=84.01 //y=6.2
c295 ( 102 0 ) capacitor c=0.158957f //x=83.57 //y=6.2
c296 ( 97 0 ) capacitor c=0.0014751f //x=83.37 //y=4.88
c297 ( 88 0 ) capacitor c=9.93222e-19 //x=83.37 //y=2.26
c298 ( 71 0 ) capacitor c=0.0293124f //x=80.74 //y=5.56
c299 ( 63 0 ) capacitor c=0.029137f //x=79.86 //y=5.56
c300 ( 55 0 ) capacitor c=0.0278099f //x=78.98 //y=5.56
c301 ( 52 0 ) capacitor c=0.0154606f //x=83.205 //y=2.755
c302 ( 51 0 ) capacitor c=6.61167e-19 //x=83.365 //y=2.755
c303 ( 49 0 ) capacitor c=9.47991e-19 //x=81.68 //y=2.755
c304 ( 39 0 ) capacitor c=0.01486f //x=83.37 //y=2.77
c305 ( 35 0 ) capacitor c=0.014453f //x=81.52 //y=2.77
c306 ( 27 0 ) capacitor c=0.00112123f //x=80.74 //y=5.335
c307 ( 24 0 ) capacitor c=0.00778188f //x=79.86 //y=5.335
c308 ( 21 0 ) capacitor c=0.0111234f //x=78.982 //y=5.335
c309 ( 20 0 ) capacitor c=0.0644992f //x=83.37 //y=4.755
c310 ( 19 0 ) capacitor c=0.0128847f //x=83.37 //y=2.915
c311 ( 18 0 ) capacitor c=0.00404338f //x=83.37 //y=2.595
c312 ( 17 0 ) capacitor c=0.00437465f //x=83.37 //y=2.375
c313 ( 16 0 ) capacitor c=0.0695756f //x=81.52 //y=5.25
c314 ( 15 0 ) capacitor c=0.0123378f //x=81.52 //y=2.915
c315 ( 14 0 ) capacitor c=0.017221f //x=81.52 //y=2.595
c316 ( 12 0 ) capacitor c=0.00493487f //x=81.12 //y=1.845
c317 ( 11 0 ) capacitor c=0.0128562f //x=81.435 //y=1.845
c318 ( 10 0 ) capacitor c=0.0167992f //x=81.035 //y=1.76
c319 ( 9 0 ) capacitor c=0.0113118f //x=81.035 //y=1.305
c320 ( 7 0 ) capacitor c=0.024101f //x=81.435 //y=5.335
c321 ( 6 0 ) capacitor c=0.00933983f //x=80.74 //y=5.56
c322 ( 3 0 ) capacitor c=0.0195594f //x=80.625 //y=5.335
c323 ( 1 0 ) capacitor c=0.0151997f //x=79.74 //y=5.335
r324 (  118 120 ) resistor r=26.9307 //w=0.15 //l=0.106066 //layer=ply \
 //thickness=0.18 //x=83.935 //y=4.97 //x2=84.01 //y2=5.045
r325 (  118 119 ) resistor r=148.702 //w=0.094 //l=0.29 //layer=ply \
 //thickness=0.18 //x=83.935 //y=4.97 //x2=83.645 //y2=4.97
r326 (  117 130 ) resistor r=45.1352 //w=0.168 //l=0.173853 //layer=ply \
 //thickness=0.18 //x=83.6 //y=1.4 //x2=83.56 //y2=1.555
r327 (  116 129 ) resistor r=45.1352 //w=0.168 //l=0.173853 //layer=ply \
 //thickness=0.18 //x=83.6 //y=1.055 //x2=83.56 //y2=0.9
r328 (  116 117 ) resistor r=176.904 //w=0.094 //l=0.345 //layer=ply \
 //thickness=0.18 //x=83.6 //y=1.055 //x2=83.6 //y2=1.4
r329 (  113 119 ) resistor r=22.7971 //w=0.269 //l=0.106066 //layer=ply \
 //thickness=0.18 //x=83.57 //y=5.045 //x2=83.645 //y2=4.97
r330 (  113 128 ) resistor r=35.8364 //w=0.269 //l=0.270185 //layer=ply \
 //thickness=0.18 //x=83.57 //y=5.045 //x2=83.37 //y2=4.88
r331 (  111 124 ) resistor r=10.701 //w=0.21 //l=0.115 //layer=ply \
 //thickness=0.18 //x=83.225 //y=1.555 //x2=83.11 //y2=1.555
r332 (  110 130 ) resistor r=5.52526 //w=0.168 //l=0.115 //layer=ply \
 //thickness=0.18 //x=83.445 //y=1.555 //x2=83.56 //y2=1.555
r333 (  109 123 ) resistor r=5.52526 //w=0.168 //l=0.115 //layer=ply \
 //thickness=0.18 //x=83.225 //y=0.9 //x2=83.11 //y2=0.9
r334 (  108 129 ) resistor r=5.52526 //w=0.168 //l=0.115 //layer=ply \
 //thickness=0.18 //x=83.445 //y=0.9 //x2=83.56 //y2=0.9
r335 (  108 109 ) resistor r=112.809 //w=0.094 //l=0.22 //layer=ply \
 //thickness=0.18 //x=83.445 //y=0.9 //x2=83.225 //y2=0.9
r336 (  107 126 ) resistor r=58.7805 //w=0.246 //l=0.373497 //layer=ply \
 //thickness=0.18 //x=83.07 //y=2.095 //x2=83.37 //y2=2.26
r337 (  106 124 ) resistor r=39.5823 //w=0.21 //l=0.173853 //layer=ply \
 //thickness=0.18 //x=83.07 //y=1.71 //x2=83.11 //y2=1.555
r338 (  106 107 ) resistor r=197.415 //w=0.094 //l=0.385 //layer=ply \
 //thickness=0.18 //x=83.07 //y=1.71 //x2=83.07 //y2=2.095
r339 (  105 124 ) resistor r=39.5823 //w=0.21 //l=0.173853 //layer=ply \
 //thickness=0.18 //x=83.07 //y=1.4 //x2=83.11 //y2=1.555
r340 (  104 123 ) resistor r=45.1352 //w=0.168 //l=0.173853 //layer=ply \
 //thickness=0.18 //x=83.07 //y=1.055 //x2=83.11 //y2=0.9
r341 (  104 105 ) resistor r=176.904 //w=0.094 //l=0.345 //layer=ply \
 //thickness=0.18 //x=83.07 //y=1.055 //x2=83.07 //y2=1.4
r342 (  103 120 ) resistor r=592.245 //w=0.094 //l=1.155 //layer=ply \
 //thickness=0.18 //x=84.01 //y=6.2 //x2=84.01 //y2=5.045
r343 (  102 113 ) resistor r=592.245 //w=0.094 //l=1.155 //layer=ply \
 //thickness=0.18 //x=83.57 //y=6.2 //x2=83.57 //y2=5.045
r344 (  101 110 ) resistor r=56.4043 //w=0.094 //l=0.11 //layer=ply \
 //thickness=0.18 //x=83.335 //y=1.555 //x2=83.445 //y2=1.555
r345 (  101 111 ) resistor r=56.4043 //w=0.094 //l=0.11 //layer=ply \
 //thickness=0.18 //x=83.335 //y=1.555 //x2=83.225 //y2=1.555
r346 (  97 128 ) resistor r=152 //w=0.17 //l=0.17 //layer=licon //count=1 \
 //x=83.37 //y=4.88 //x2=83.37 //y2=4.88
r347 (  88 126 ) resistor r=152 //w=0.17 //l=0.17 //layer=licon //count=1 \
 //x=83.37 //y=2.26 //x2=83.37 //y2=2.26
r348 (  71 135 ) resistor r=23.615 //w=0.187 //l=0.345 //layer=li \
 //thickness=0.1 //x=80.74 //y=5.56 //x2=80.74 //y2=5.905
r349 (  63 134 ) resistor r=23.615 //w=0.187 //l=0.345 //layer=li \
 //thickness=0.1 //x=79.86 //y=5.56 //x2=79.86 //y2=5.905
r350 (  55 133 ) resistor r=23.615 //w=0.187 //l=0.345 //layer=li \
 //thickness=0.1 //x=78.98 //y=5.56 //x2=78.98 //y2=5.905
r351 (  51 52 ) resistor r=0.10734 //w=0.281 //l=0.16 //layer=m2 \
 //thickness=0.36 //x=83.365 //y=2.755 //x2=83.205 //y2=2.755
r352 (  49 52 ) resistor r=1.45515 //w=0.131 //l=1.525 //layer=m2 \
 //thickness=0.36 //x=81.68 //y=2.77 //x2=83.205 //y2=2.77
r353 (  47 49 ) resistor r=0.10734 //w=0.281 //l=0.16 //layer=m2 \
 //thickness=0.36 //x=81.52 //y=2.755 //x2=81.68 //y2=2.755
r354 (  43 97 ) resistor r=9.3 //w=0.17 //l=0.17 //layer=mcon //count=1 \
 //x=83.37 //y=4.88 //x2=83.37 //y2=4.88
r355 (  41 88 ) resistor r=9.3 //w=0.17 //l=0.17 //layer=mcon //count=1 \
 //x=83.37 //y=2.26 //x2=83.37 //y2=2.26
r356 (  37 51 ) resistor r=4.5 //w=0.15 //l=0.15 //layer=via1 //count=1 \
 //x=83.365 //y=2.755 //x2=83.365 //y2=2.755
r357 (  37 39 ) resistor r=0.00501337 //w=0.374 //l=0.015 //layer=m1 \
 //thickness=0.36 //x=83.315 //y=2.755 //x2=83.315 //y2=2.77
r358 (  33 47 ) resistor r=4.5 //w=0.15 //l=0.15 //layer=via1 //count=1 \
 //x=81.52 //y=2.755 //x2=81.52 //y2=2.755
r359 (  33 35 ) resistor r=0.0049867 //w=0.376 //l=0.015 //layer=m1 \
 //thickness=0.36 //x=81.572 //y=2.755 //x2=81.572 //y2=2.77
r360 (  31 131 ) resistor r=9.3 //w=0.17 //l=0.17 //layer=mcon //count=1 \
 //x=81.035 //y=1.19 //x2=81.035 //y2=1.19
r361 (  29 71 ) resistor r=9.3 //w=0.17 //l=0.17 //layer=mcon //count=1 \
 //x=80.74 //y=5.56 //x2=80.74 //y2=5.56
r362 (  26 63 ) resistor r=9.3 //w=0.17 //l=0.17 //layer=mcon //count=1 \
 //x=79.86 //y=5.56 //x2=79.86 //y2=5.56
r363 (  24 26 ) resistor r=0.121228 //w=0.232 //l=0.225 //layer=m1 \
 //thickness=0.36 //x=79.86 //y=5.335 //x2=79.86 //y2=5.56
r364 (  23 55 ) resistor r=9.3 //w=0.17 //l=0.17 //layer=mcon //count=1 \
 //x=78.98 //y=5.56 //x2=78.98 //y2=5.56
r365 (  21 23 ) resistor r=0.129608 //w=0.217 //l=0.225 //layer=m1 \
 //thickness=0.36 //x=78.982 //y=5.335 //x2=78.982 //y2=5.56
r366 (  20 43 ) resistor r=0.0760407 //w=0.238 //l=0.125 //layer=m1 \
 //thickness=0.36 //x=83.37 //y=4.755 //x2=83.37 //y2=4.88
r367 (  19 39 ) resistor r=0.0860668 //w=0.374 //l=0.170294 //layer=m1 \
 //thickness=0.36 //x=83.37 //y=2.915 //x2=83.315 //y2=2.77
r368 (  19 20 ) resistor r=1.75573 //w=0.131 //l=1.84 //layer=m1 \
 //thickness=0.36 //x=83.37 //y=2.915 //x2=83.37 //y2=4.755
r369 (  18 37 ) resistor r=0.0910802 //w=0.374 //l=0.185472 //layer=m1 \
 //thickness=0.36 //x=83.37 //y=2.595 //x2=83.315 //y2=2.755
r370 (  17 41 ) resistor r=0.0719237 //w=0.222 //l=0.115 //layer=m1 \
 //thickness=0.36 //x=83.37 //y=2.375 //x2=83.37 //y2=2.26
r371 (  17 18 ) resistor r=0.209924 //w=0.131 //l=0.22 //layer=m1 \
 //thickness=0.36 //x=83.37 //y=2.375 //x2=83.37 //y2=2.595
r372 (  15 35 ) resistor r=0.0861726 //w=0.376 //l=0.169012 //layer=m1 \
 //thickness=0.36 //x=81.52 //y=2.915 //x2=81.572 //y2=2.77
r373 (  15 16 ) resistor r=2.22805 //w=0.131 //l=2.335 //layer=m1 \
 //thickness=0.36 //x=81.52 //y=2.915 //x2=81.52 //y2=5.25
r374 (  14 33 ) resistor r=0.0911593 //w=0.376 //l=0.184174 //layer=m1 \
 //thickness=0.36 //x=81.52 //y=2.595 //x2=81.572 //y2=2.755
r375 (  13 14 ) resistor r=0.634542 //w=0.131 //l=0.665 //layer=m1 \
 //thickness=0.36 //x=81.52 //y=1.93 //x2=81.52 //y2=2.595
r376 (  11 13 ) resistor r=0.0698411 //w=0.17 //l=0.120208 //layer=m1 \
 //thickness=0.36 //x=81.435 //y=1.845 //x2=81.52 //y2=1.93
r377 (  11 12 ) resistor r=0.300573 //w=0.131 //l=0.315 //layer=m1 \
 //thickness=0.36 //x=81.435 //y=1.845 //x2=81.12 //y2=1.845
r378 (  10 12 ) resistor r=0.0698411 //w=0.17 //l=0.120208 //layer=m1 \
 //thickness=0.36 //x=81.035 //y=1.76 //x2=81.12 //y2=1.845
r379 (  9 31 ) resistor r=0.0717383 //w=0.224 //l=0.115 //layer=m1 \
 //thickness=0.36 //x=81.035 //y=1.305 //x2=81.035 //y2=1.19
r380 (  9 10 ) resistor r=0.43416 //w=0.131 //l=0.455 //layer=m1 \
 //thickness=0.36 //x=81.035 //y=1.305 //x2=81.035 //y2=1.76
r381 (  8 27 ) resistor r=0.0675342 //w=0.23 //l=0.115 //layer=m1 \
 //thickness=0.36 //x=80.855 //y=5.335 //x2=80.74 //y2=5.335
r382 (  7 16 ) resistor r=0.0698411 //w=0.17 //l=0.120208 //layer=m1 \
 //thickness=0.36 //x=81.435 //y=5.335 //x2=81.52 //y2=5.25
r383 (  7 8 ) resistor r=0.553435 //w=0.131 //l=0.58 //layer=m1 \
 //thickness=0.36 //x=81.435 //y=5.335 //x2=80.855 //y2=5.335
r384 (  6 29 ) resistor r=0.00118313 //w=0.23 //layer=m1 //thickness=0.36 \
 //x=80.74 //y=5.56 //x2=80.74 //y2=5.56
r385 (  5 27 ) resistor r=0.002872 //w=0.34 //l=0.085 //layer=m1 \
 //thickness=0.36 //x=80.74 //y=5.42 //x2=80.74 //y2=5.335
r386 (  5 6 ) resistor r=0.091623 //w=0.191 //l=0.14 //layer=m1 \
 //thickness=0.36 //x=80.74 //y=5.42 //x2=80.74 //y2=5.56
r387 (  4 24 ) resistor r=0.0262263 //w=0.232 //l=0.12 //layer=m1 \
 //thickness=0.36 //x=79.98 //y=5.335 //x2=79.86 //y2=5.335
r388 (  3 27 ) resistor r=0.0675342 //w=0.23 //l=0.115 //layer=m1 \
 //thickness=0.36 //x=80.625 //y=5.335 //x2=80.74 //y2=5.335
r389 (  3 4 ) resistor r=0.615458 //w=0.131 //l=0.645 //layer=m1 \
 //thickness=0.36 //x=80.625 //y=5.335 //x2=79.98 //y2=5.335
r390 (  2 21 ) resistor r=0.0222262 //w=0.217 //l=0.118 //layer=m1 \
 //thickness=0.36 //x=79.1 //y=5.335 //x2=78.982 //y2=5.335
r391 (  1 24 ) resistor r=0.0262263 //w=0.232 //l=0.12 //layer=m1 \
 //thickness=0.36 //x=79.74 //y=5.335 //x2=79.86 //y2=5.335
r392 (  1 2 ) resistor r=0.610687 //w=0.131 //l=0.64 //layer=m1 \
 //thickness=0.36 //x=79.74 //y=5.335 //x2=79.1 //y2=5.335
ends PM_TMRDFFSNRNQX1\%noxref_18

subckt PM_TMRDFFSNRNQX1\%SN ( 1 2 3 4 5 6 7 8 9 10 11 14 15 16 19 20 21 24 25 \
 26 29 30 31 34 35 36 37 38 39 81 88 90 92 94 96 98 100 101 102 104 106 108 \
 110 112 114 116 117 118 120 122 124 126 128 130 131 132 134 136 138 140 142 \
 144 146 147 148 150 152 154 159 164 172 181 186 195 200 209 214 223 228 237 \
 242 251 255 256 257 258 259 260 261 262 263 264 265 266 267 268 269 270 271 \
 272 273 274 275 277 283 284 285 286 287 292 293 294 296 302 303 304 305 306 \
 311 312 313 315 321 322 323 324 325 330 331 332 334 340 341 342 343 344 349 \
 350 351 353 359 360 361 362 363 368 369 370 372 378 379 380 381 382 390 401 \
 412 423 434 445 )
c1209 ( 445 0 ) capacitor c=0.0369044f //x=84.48 //y=4.88
c1210 ( 434 0 ) capacitor c=0.0369628f //x=70.05 //y=4.88
c1211 ( 423 0 ) capacitor c=0.0369628f //x=55.62 //y=4.88
c1212 ( 412 0 ) capacitor c=0.0369628f //x=41.19 //y=4.88
c1213 ( 401 0 ) capacitor c=0.0369044f //x=26.76 //y=4.88
c1214 ( 390 0 ) capacitor c=0.0369044f //x=12.33 //y=4.88
c1215 ( 382 0 ) capacitor c=0.0309248f //x=84.815 //y=4.97
c1216 ( 381 0 ) capacitor c=0.0819978f //x=84.57 //y=2.095
c1217 ( 380 0 ) capacitor c=0.0170266f //x=84.57 //y=1.63
c1218 ( 379 0 ) capacitor c=0.018609f //x=84.57 //y=1.4
c1219 ( 378 0 ) capacitor c=0.0186599f //x=84.57 //y=1.09
c1220 ( 372 0 ) capacitor c=0.0146988f //x=84.415 //y=1.555
c1221 ( 370 0 ) capacitor c=0.0148531f //x=84.415 //y=0.935
c1222 ( 369 0 ) capacitor c=0.0334406f //x=84.045 //y=1.4
c1223 ( 368 0 ) capacitor c=0.0173191f //x=84.045 //y=1.09
c1224 ( 363 0 ) capacitor c=0.0309248f //x=70.385 //y=4.97
c1225 ( 362 0 ) capacitor c=0.0818898f //x=70.14 //y=2.095
c1226 ( 361 0 ) capacitor c=0.0170266f //x=70.14 //y=1.63
c1227 ( 360 0 ) capacitor c=0.018609f //x=70.14 //y=1.4
c1228 ( 359 0 ) capacitor c=0.0186599f //x=70.14 //y=1.09
c1229 ( 353 0 ) capacitor c=0.0146988f //x=69.985 //y=1.555
c1230 ( 351 0 ) capacitor c=0.0148531f //x=69.985 //y=0.935
c1231 ( 350 0 ) capacitor c=0.0334406f //x=69.615 //y=1.4
c1232 ( 349 0 ) capacitor c=0.0173191f //x=69.615 //y=1.09
c1233 ( 344 0 ) capacitor c=0.0309248f //x=55.955 //y=4.97
c1234 ( 343 0 ) capacitor c=0.0819978f //x=55.71 //y=2.095
c1235 ( 342 0 ) capacitor c=0.0170266f //x=55.71 //y=1.63
c1236 ( 341 0 ) capacitor c=0.018609f //x=55.71 //y=1.4
c1237 ( 340 0 ) capacitor c=0.0186599f //x=55.71 //y=1.09
c1238 ( 334 0 ) capacitor c=0.0146988f //x=55.555 //y=1.555
c1239 ( 332 0 ) capacitor c=0.0148531f //x=55.555 //y=0.935
c1240 ( 331 0 ) capacitor c=0.0334406f //x=55.185 //y=1.4
c1241 ( 330 0 ) capacitor c=0.0173191f //x=55.185 //y=1.09
c1242 ( 325 0 ) capacitor c=0.0309248f //x=41.525 //y=4.97
c1243 ( 324 0 ) capacitor c=0.0818898f //x=41.28 //y=2.095
c1244 ( 323 0 ) capacitor c=0.0170266f //x=41.28 //y=1.63
c1245 ( 322 0 ) capacitor c=0.018609f //x=41.28 //y=1.4
c1246 ( 321 0 ) capacitor c=0.0186599f //x=41.28 //y=1.09
c1247 ( 315 0 ) capacitor c=0.0146988f //x=41.125 //y=1.555
c1248 ( 313 0 ) capacitor c=0.0148531f //x=41.125 //y=0.935
c1249 ( 312 0 ) capacitor c=0.0334406f //x=40.755 //y=1.4
c1250 ( 311 0 ) capacitor c=0.0173191f //x=40.755 //y=1.09
c1251 ( 306 0 ) capacitor c=0.0309248f //x=27.095 //y=4.97
c1252 ( 305 0 ) capacitor c=0.0819978f //x=26.85 //y=2.095
c1253 ( 304 0 ) capacitor c=0.0170266f //x=26.85 //y=1.63
c1254 ( 303 0 ) capacitor c=0.018609f //x=26.85 //y=1.4
c1255 ( 302 0 ) capacitor c=0.0186599f //x=26.85 //y=1.09
c1256 ( 296 0 ) capacitor c=0.0146988f //x=26.695 //y=1.555
c1257 ( 294 0 ) capacitor c=0.0148531f //x=26.695 //y=0.935
c1258 ( 293 0 ) capacitor c=0.0334406f //x=26.325 //y=1.4
c1259 ( 292 0 ) capacitor c=0.0173191f //x=26.325 //y=1.09
c1260 ( 287 0 ) capacitor c=0.0309248f //x=12.665 //y=4.97
c1261 ( 286 0 ) capacitor c=0.0818898f //x=12.42 //y=2.095
c1262 ( 285 0 ) capacitor c=0.0170266f //x=12.42 //y=1.63
c1263 ( 284 0 ) capacitor c=0.018609f //x=12.42 //y=1.4
c1264 ( 283 0 ) capacitor c=0.0186599f //x=12.42 //y=1.09
c1265 ( 277 0 ) capacitor c=0.0146988f //x=12.265 //y=1.555
c1266 ( 275 0 ) capacitor c=0.0148531f //x=12.265 //y=0.935
c1267 ( 274 0 ) capacitor c=0.0334406f //x=11.895 //y=1.4
c1268 ( 273 0 ) capacitor c=0.0173191f //x=11.895 //y=1.09
c1269 ( 272 0 ) capacitor c=0.110208f //x=84.89 //y=6.2
c1270 ( 271 0 ) capacitor c=0.110214f //x=84.45 //y=6.2
c1271 ( 270 0 ) capacitor c=0.110208f //x=70.46 //y=6.2
c1272 ( 269 0 ) capacitor c=0.110214f //x=70.02 //y=6.2
c1273 ( 268 0 ) capacitor c=0.110208f //x=56.03 //y=6.2
c1274 ( 267 0 ) capacitor c=0.110214f //x=55.59 //y=6.2
c1275 ( 266 0 ) capacitor c=0.110208f //x=41.6 //y=6.2
c1276 ( 265 0 ) capacitor c=0.110214f //x=41.16 //y=6.2
c1277 ( 264 0 ) capacitor c=0.110208f //x=27.17 //y=6.2
c1278 ( 263 0 ) capacitor c=0.110214f //x=26.73 //y=6.2
c1279 ( 262 0 ) capacitor c=0.110208f //x=12.74 //y=6.2
c1280 ( 261 0 ) capacitor c=0.110214f //x=12.3 //y=6.2
c1281 ( 251 0 ) capacitor c=0.00129935f //x=84.48 //y=4.88
c1282 ( 242 0 ) capacitor c=9.49278e-19 //x=84.48 //y=2.26
c1283 ( 237 0 ) capacitor c=0.00129935f //x=70.05 //y=4.88
c1284 ( 228 0 ) capacitor c=9.49278e-19 //x=70.05 //y=2.26
c1285 ( 223 0 ) capacitor c=0.00129935f //x=55.62 //y=4.88
c1286 ( 214 0 ) capacitor c=9.49278e-19 //x=55.62 //y=2.26
c1287 ( 209 0 ) capacitor c=0.00129935f //x=41.19 //y=4.88
c1288 ( 200 0 ) capacitor c=9.49278e-19 //x=41.19 //y=2.26
c1289 ( 195 0 ) capacitor c=0.00129935f //x=26.76 //y=4.88
c1290 ( 186 0 ) capacitor c=9.49278e-19 //x=26.76 //y=2.26
c1291 ( 181 0 ) capacitor c=0.00129935f //x=12.33 //y=4.88
c1292 ( 172 0 ) capacitor c=9.49278e-19 //x=12.33 //y=2.26
c1293 ( 164 0 ) capacitor c=0.00126592f //x=52.22 //y=3.125
c1294 ( 159 0 ) capacitor c=4.39244e-19 //x=12.49 //y=3.125
c1295 ( 154 0 ) capacitor c=0.0858283f //x=78.77 //y=3.125
c1296 ( 152 0 ) capacitor c=0.0514352f //x=78.17 //y=3.14
c1297 ( 150 0 ) capacitor c=0.00422942f //x=73.975 //y=3.155
c1298 ( 148 0 ) capacitor c=0.0179685f //x=73.375 //y=3.14
c1299 ( 147 0 ) capacitor c=0.024406f //x=71.77 //y=3.155
c1300 ( 146 0 ) capacitor c=0.00413636f //x=72.115 //y=3.155
c1301 ( 144 0 ) capacitor c=0.00179684f //x=69.155 //y=3.17
c1302 ( 142 0 ) capacitor c=0.0169637f //x=68.555 //y=3.14
c1303 ( 140 0 ) capacitor c=0.0064451f //x=67.305 //y=3.11
c1304 ( 138 0 ) capacitor c=0.0207078f //x=66.705 //y=3.14
c1305 ( 136 0 ) capacitor c=0.00378224f //x=64.35 //y=3.17
c1306 ( 134 0 ) capacitor c=0.0184994f //x=63.75 //y=3.14
c1307 ( 132 0 ) capacitor c=0.00429578f //x=62.5 //y=3.17
c1308 ( 131 0 ) capacitor c=0.0750592f //x=61.335 //y=3.13
c1309 ( 130 0 ) capacitor c=0.00729482f //x=61.765 //y=3.13
c1310 ( 128 0 ) capacitor c=0.0348131f //x=55.46 //y=3.14
c1311 ( 126 0 ) capacitor c=0.0024147f //x=52.12 //y=3.125
c1312 ( 124 0 ) capacitor c=0.0271038f //x=49.91 //y=3.125
c1313 ( 122 0 ) capacitor c=0.0513238f //x=49.31 //y=3.14
c1314 ( 120 0 ) capacitor c=0.00422942f //x=45.115 //y=3.155
c1315 ( 118 0 ) capacitor c=0.0179685f //x=44.515 //y=3.14
c1316 ( 117 0 ) capacitor c=0.024406f //x=42.91 //y=3.155
c1317 ( 116 0 ) capacitor c=0.00413636f //x=43.255 //y=3.155
c1318 ( 114 0 ) capacitor c=0.00179684f //x=40.295 //y=3.17
c1319 ( 112 0 ) capacitor c=0.0169637f //x=39.695 //y=3.14
c1320 ( 110 0 ) capacitor c=0.0064451f //x=38.445 //y=3.11
c1321 ( 108 0 ) capacitor c=0.0207078f //x=37.845 //y=3.14
c1322 ( 106 0 ) capacitor c=0.00378224f //x=35.49 //y=3.17
c1323 ( 104 0 ) capacitor c=0.0184994f //x=34.89 //y=3.14
c1324 ( 102 0 ) capacitor c=0.00429578f //x=33.64 //y=3.17
c1325 ( 101 0 ) capacitor c=0.143982f //x=32.475 //y=3.13
c1326 ( 100 0 ) capacitor c=0.00738852f //x=32.905 //y=3.13
c1327 ( 98 0 ) capacitor c=0.00292064f //x=21.05 //y=3.125
c1328 ( 96 0 ) capacitor c=0.0514333f //x=20.45 //y=3.14
c1329 ( 94 0 ) capacitor c=0.00433851f //x=16.255 //y=3.155
c1330 ( 92 0 ) capacitor c=0.0179685f //x=15.655 //y=3.14
c1331 ( 90 0 ) capacitor c=0.00413636f //x=14.395 //y=3.155
c1332 ( 88 0 ) capacitor c=0.0151172f //x=13.795 //y=3.14
c1333 ( 81 0 ) capacitor c=0.015039f //x=84.48 //y=3.14
c1334 ( 39 0 ) capacitor c=0.0464356f //x=84.48 //y=4.765
c1335 ( 38 0 ) capacitor c=0.012684f //x=84.48 //y=3.305
c1336 ( 37 0 ) capacitor c=0.0132667f //x=84.48 //y=2.985
c1337 ( 36 0 ) capacitor c=0.00380207f //x=84.48 //y=2.375
c1338 ( 35 0 ) capacitor c=0.0416113f //x=70.05 //y=4.765
c1339 ( 34 0 ) capacitor c=0.0130261f //x=70.05 //y=3.285
c1340 ( 31 0 ) capacitor c=0.00380207f //x=70.05 //y=2.375
c1341 ( 30 0 ) capacitor c=0.0403265f //x=55.62 //y=4.765
c1342 ( 29 0 ) capacitor c=0.0125032f //x=55.62 //y=3.305
c1343 ( 26 0 ) capacitor c=0.00380207f //x=55.62 //y=2.375
c1344 ( 25 0 ) capacitor c=0.0417289f //x=41.19 //y=4.765
c1345 ( 24 0 ) capacitor c=0.0130261f //x=41.19 //y=3.285
c1346 ( 21 0 ) capacitor c=0.00380207f //x=41.19 //y=2.375
c1347 ( 20 0 ) capacitor c=0.0425678f //x=26.76 //y=4.765
c1348 ( 19 0 ) capacitor c=0.012654f //x=26.76 //y=3.305
c1349 ( 16 0 ) capacitor c=0.00380207f //x=26.76 //y=2.375
c1350 ( 15 0 ) capacitor c=0.0437064f //x=12.33 //y=4.765
c1351 ( 14 0 ) capacitor c=0.0127247f //x=12.33 //y=3.285
c1352 ( 11 0 ) capacitor c=0.00380207f //x=12.33 //y=2.375
c1353 ( 10 0 ) capacitor c=0.015039f //x=70.05 //y=3.14
c1354 ( 9 0 ) capacitor c=0.015039f //x=55.62 //y=3.14
c1355 ( 8 0 ) capacitor c=0.015039f //x=41.19 //y=3.14
c1356 ( 7 0 ) capacitor c=0.015039f //x=26.76 //y=3.14
c1357 ( 6 0 ) capacitor c=0.015039f //x=12.33 //y=3.14
c1358 ( 5 0 ) capacitor c=0.0114361f //x=70.05 //y=2.77
c1359 ( 4 0 ) capacitor c=0.0136895f //x=55.62 //y=2.77
c1360 ( 3 0 ) capacitor c=0.0114361f //x=41.19 //y=2.77
c1361 ( 2 0 ) capacitor c=0.0136461f //x=26.76 //y=2.77
c1362 ( 1 0 ) capacitor c=0.0114361f //x=12.33 //y=2.77
r1363 (  447 448 ) resistor r=32.4568 //w=0.214 //l=0.075 //layer=ply \
 //thickness=0.18 //x=84.48 //y=4.97 //x2=84.48 //y2=5.045
r1364 (  445 447 ) resistor r=20.271 //w=0.214 //l=0.09 //layer=ply \
 //thickness=0.18 //x=84.48 //y=4.88 //x2=84.48 //y2=4.97
r1365 (  436 437 ) resistor r=32.4568 //w=0.214 //l=0.075 //layer=ply \
 //thickness=0.18 //x=70.05 //y=4.97 //x2=70.05 //y2=5.045
r1366 (  434 436 ) resistor r=20.271 //w=0.214 //l=0.09 //layer=ply \
 //thickness=0.18 //x=70.05 //y=4.88 //x2=70.05 //y2=4.97
r1367 (  425 426 ) resistor r=32.4568 //w=0.214 //l=0.075 //layer=ply \
 //thickness=0.18 //x=55.62 //y=4.97 //x2=55.62 //y2=5.045
r1368 (  423 425 ) resistor r=20.271 //w=0.214 //l=0.09 //layer=ply \
 //thickness=0.18 //x=55.62 //y=4.88 //x2=55.62 //y2=4.97
r1369 (  414 415 ) resistor r=32.4568 //w=0.214 //l=0.075 //layer=ply \
 //thickness=0.18 //x=41.19 //y=4.97 //x2=41.19 //y2=5.045
r1370 (  412 414 ) resistor r=20.271 //w=0.214 //l=0.09 //layer=ply \
 //thickness=0.18 //x=41.19 //y=4.88 //x2=41.19 //y2=4.97
r1371 (  403 404 ) resistor r=32.4568 //w=0.214 //l=0.075 //layer=ply \
 //thickness=0.18 //x=26.76 //y=4.97 //x2=26.76 //y2=5.045
r1372 (  401 403 ) resistor r=20.271 //w=0.214 //l=0.09 //layer=ply \
 //thickness=0.18 //x=26.76 //y=4.88 //x2=26.76 //y2=4.97
r1373 (  392 393 ) resistor r=32.4568 //w=0.214 //l=0.075 //layer=ply \
 //thickness=0.18 //x=12.33 //y=4.97 //x2=12.33 //y2=5.045
r1374 (  390 392 ) resistor r=20.271 //w=0.214 //l=0.09 //layer=ply \
 //thickness=0.18 //x=12.33 //y=4.88 //x2=12.33 //y2=4.97
r1375 (  383 447 ) resistor r=16.5046 //w=0.27 //l=0.135 //layer=ply \
 //thickness=0.18 //x=84.615 //y=4.97 //x2=84.48 //y2=4.97
r1376 (  382 384 ) resistor r=26.9307 //w=0.15 //l=0.106066 //layer=ply \
 //thickness=0.18 //x=84.815 //y=4.97 //x2=84.89 //y2=5.045
r1377 (  382 383 ) resistor r=102.553 //w=0.094 //l=0.2 //layer=ply \
 //thickness=0.18 //x=84.815 //y=4.97 //x2=84.615 //y2=4.97
r1378 (  381 452 ) resistor r=38.6777 //w=0.284 //l=0.198997 //layer=ply \
 //thickness=0.18 //x=84.57 //y=2.095 //x2=84.495 //y2=2.26
r1379 (  380 450 ) resistor r=21.2976 //w=0.217 //l=0.0928709 //layer=ply \
 //thickness=0.18 //x=84.57 //y=1.63 //x2=84.53 //y2=1.555
r1380 (  380 381 ) resistor r=238.436 //w=0.094 //l=0.465 //layer=ply \
 //thickness=0.18 //x=84.57 //y=1.63 //x2=84.57 //y2=2.095
r1381 (  379 450 ) resistor r=39.0671 //w=0.217 //l=0.173853 //layer=ply \
 //thickness=0.18 //x=84.57 //y=1.4 //x2=84.53 //y2=1.555
r1382 (  378 449 ) resistor r=45.1352 //w=0.168 //l=0.173853 //layer=ply \
 //thickness=0.18 //x=84.57 //y=1.09 //x2=84.53 //y2=0.935
r1383 (  378 379 ) resistor r=158.957 //w=0.094 //l=0.31 //layer=ply \
 //thickness=0.18 //x=84.57 //y=1.09 //x2=84.57 //y2=1.4
r1384 (  373 443 ) resistor r=5.52526 //w=0.168 //l=0.115 //layer=ply \
 //thickness=0.18 //x=84.2 //y=1.555 //x2=84.085 //y2=1.555
r1385 (  372 450 ) resistor r=11.4558 //w=0.217 //l=0.115 //layer=ply \
 //thickness=0.18 //x=84.415 //y=1.555 //x2=84.53 //y2=1.555
r1386 (  371 442 ) resistor r=5.52526 //w=0.168 //l=0.115 //layer=ply \
 //thickness=0.18 //x=84.2 //y=0.935 //x2=84.085 //y2=0.935
r1387 (  370 449 ) resistor r=5.52526 //w=0.168 //l=0.115 //layer=ply \
 //thickness=0.18 //x=84.415 //y=0.935 //x2=84.53 //y2=0.935
r1388 (  370 371 ) resistor r=110.245 //w=0.094 //l=0.215 //layer=ply \
 //thickness=0.18 //x=84.415 //y=0.935 //x2=84.2 //y2=0.935
r1389 (  369 443 ) resistor r=45.1352 //w=0.168 //l=0.173853 //layer=ply \
 //thickness=0.18 //x=84.045 //y=1.4 //x2=84.085 //y2=1.555
r1390 (  368 442 ) resistor r=45.1352 //w=0.168 //l=0.173853 //layer=ply \
 //thickness=0.18 //x=84.045 //y=1.09 //x2=84.085 //y2=0.935
r1391 (  368 369 ) resistor r=158.957 //w=0.094 //l=0.31 //layer=ply \
 //thickness=0.18 //x=84.045 //y=1.09 //x2=84.045 //y2=1.4
r1392 (  364 436 ) resistor r=16.5046 //w=0.27 //l=0.135 //layer=ply \
 //thickness=0.18 //x=70.185 //y=4.97 //x2=70.05 //y2=4.97
r1393 (  363 365 ) resistor r=26.9307 //w=0.15 //l=0.106066 //layer=ply \
 //thickness=0.18 //x=70.385 //y=4.97 //x2=70.46 //y2=5.045
r1394 (  363 364 ) resistor r=102.553 //w=0.094 //l=0.2 //layer=ply \
 //thickness=0.18 //x=70.385 //y=4.97 //x2=70.185 //y2=4.97
r1395 (  362 441 ) resistor r=38.6777 //w=0.284 //l=0.198997 //layer=ply \
 //thickness=0.18 //x=70.14 //y=2.095 //x2=70.065 //y2=2.26
r1396 (  361 439 ) resistor r=21.2976 //w=0.217 //l=0.0928709 //layer=ply \
 //thickness=0.18 //x=70.14 //y=1.63 //x2=70.1 //y2=1.555
r1397 (  361 362 ) resistor r=238.436 //w=0.094 //l=0.465 //layer=ply \
 //thickness=0.18 //x=70.14 //y=1.63 //x2=70.14 //y2=2.095
r1398 (  360 439 ) resistor r=39.0671 //w=0.217 //l=0.173853 //layer=ply \
 //thickness=0.18 //x=70.14 //y=1.4 //x2=70.1 //y2=1.555
r1399 (  359 438 ) resistor r=45.1352 //w=0.168 //l=0.173853 //layer=ply \
 //thickness=0.18 //x=70.14 //y=1.09 //x2=70.1 //y2=0.935
r1400 (  359 360 ) resistor r=158.957 //w=0.094 //l=0.31 //layer=ply \
 //thickness=0.18 //x=70.14 //y=1.09 //x2=70.14 //y2=1.4
r1401 (  354 432 ) resistor r=5.52526 //w=0.168 //l=0.115 //layer=ply \
 //thickness=0.18 //x=69.77 //y=1.555 //x2=69.655 //y2=1.555
r1402 (  353 439 ) resistor r=11.4558 //w=0.217 //l=0.115 //layer=ply \
 //thickness=0.18 //x=69.985 //y=1.555 //x2=70.1 //y2=1.555
r1403 (  352 431 ) resistor r=5.52526 //w=0.168 //l=0.115 //layer=ply \
 //thickness=0.18 //x=69.77 //y=0.935 //x2=69.655 //y2=0.935
r1404 (  351 438 ) resistor r=5.52526 //w=0.168 //l=0.115 //layer=ply \
 //thickness=0.18 //x=69.985 //y=0.935 //x2=70.1 //y2=0.935
r1405 (  351 352 ) resistor r=110.245 //w=0.094 //l=0.215 //layer=ply \
 //thickness=0.18 //x=69.985 //y=0.935 //x2=69.77 //y2=0.935
r1406 (  350 432 ) resistor r=45.1352 //w=0.168 //l=0.173853 //layer=ply \
 //thickness=0.18 //x=69.615 //y=1.4 //x2=69.655 //y2=1.555
r1407 (  349 431 ) resistor r=45.1352 //w=0.168 //l=0.173853 //layer=ply \
 //thickness=0.18 //x=69.615 //y=1.09 //x2=69.655 //y2=0.935
r1408 (  349 350 ) resistor r=158.957 //w=0.094 //l=0.31 //layer=ply \
 //thickness=0.18 //x=69.615 //y=1.09 //x2=69.615 //y2=1.4
r1409 (  345 425 ) resistor r=16.5046 //w=0.27 //l=0.135 //layer=ply \
 //thickness=0.18 //x=55.755 //y=4.97 //x2=55.62 //y2=4.97
r1410 (  344 346 ) resistor r=26.9307 //w=0.15 //l=0.106066 //layer=ply \
 //thickness=0.18 //x=55.955 //y=4.97 //x2=56.03 //y2=5.045
r1411 (  344 345 ) resistor r=102.553 //w=0.094 //l=0.2 //layer=ply \
 //thickness=0.18 //x=55.955 //y=4.97 //x2=55.755 //y2=4.97
r1412 (  343 430 ) resistor r=38.6777 //w=0.284 //l=0.198997 //layer=ply \
 //thickness=0.18 //x=55.71 //y=2.095 //x2=55.635 //y2=2.26
r1413 (  342 428 ) resistor r=21.2976 //w=0.217 //l=0.0928709 //layer=ply \
 //thickness=0.18 //x=55.71 //y=1.63 //x2=55.67 //y2=1.555
r1414 (  342 343 ) resistor r=238.436 //w=0.094 //l=0.465 //layer=ply \
 //thickness=0.18 //x=55.71 //y=1.63 //x2=55.71 //y2=2.095
r1415 (  341 428 ) resistor r=39.0671 //w=0.217 //l=0.173853 //layer=ply \
 //thickness=0.18 //x=55.71 //y=1.4 //x2=55.67 //y2=1.555
r1416 (  340 427 ) resistor r=45.1352 //w=0.168 //l=0.173853 //layer=ply \
 //thickness=0.18 //x=55.71 //y=1.09 //x2=55.67 //y2=0.935
r1417 (  340 341 ) resistor r=158.957 //w=0.094 //l=0.31 //layer=ply \
 //thickness=0.18 //x=55.71 //y=1.09 //x2=55.71 //y2=1.4
r1418 (  335 421 ) resistor r=5.52526 //w=0.168 //l=0.115 //layer=ply \
 //thickness=0.18 //x=55.34 //y=1.555 //x2=55.225 //y2=1.555
r1419 (  334 428 ) resistor r=11.4558 //w=0.217 //l=0.115 //layer=ply \
 //thickness=0.18 //x=55.555 //y=1.555 //x2=55.67 //y2=1.555
r1420 (  333 420 ) resistor r=5.52526 //w=0.168 //l=0.115 //layer=ply \
 //thickness=0.18 //x=55.34 //y=0.935 //x2=55.225 //y2=0.935
r1421 (  332 427 ) resistor r=5.52526 //w=0.168 //l=0.115 //layer=ply \
 //thickness=0.18 //x=55.555 //y=0.935 //x2=55.67 //y2=0.935
r1422 (  332 333 ) resistor r=110.245 //w=0.094 //l=0.215 //layer=ply \
 //thickness=0.18 //x=55.555 //y=0.935 //x2=55.34 //y2=0.935
r1423 (  331 421 ) resistor r=45.1352 //w=0.168 //l=0.173853 //layer=ply \
 //thickness=0.18 //x=55.185 //y=1.4 //x2=55.225 //y2=1.555
r1424 (  330 420 ) resistor r=45.1352 //w=0.168 //l=0.173853 //layer=ply \
 //thickness=0.18 //x=55.185 //y=1.09 //x2=55.225 //y2=0.935
r1425 (  330 331 ) resistor r=158.957 //w=0.094 //l=0.31 //layer=ply \
 //thickness=0.18 //x=55.185 //y=1.09 //x2=55.185 //y2=1.4
r1426 (  326 414 ) resistor r=16.5046 //w=0.27 //l=0.135 //layer=ply \
 //thickness=0.18 //x=41.325 //y=4.97 //x2=41.19 //y2=4.97
r1427 (  325 327 ) resistor r=26.9307 //w=0.15 //l=0.106066 //layer=ply \
 //thickness=0.18 //x=41.525 //y=4.97 //x2=41.6 //y2=5.045
r1428 (  325 326 ) resistor r=102.553 //w=0.094 //l=0.2 //layer=ply \
 //thickness=0.18 //x=41.525 //y=4.97 //x2=41.325 //y2=4.97
r1429 (  324 419 ) resistor r=38.6777 //w=0.284 //l=0.198997 //layer=ply \
 //thickness=0.18 //x=41.28 //y=2.095 //x2=41.205 //y2=2.26
r1430 (  323 417 ) resistor r=21.2976 //w=0.217 //l=0.0928709 //layer=ply \
 //thickness=0.18 //x=41.28 //y=1.63 //x2=41.24 //y2=1.555
r1431 (  323 324 ) resistor r=238.436 //w=0.094 //l=0.465 //layer=ply \
 //thickness=0.18 //x=41.28 //y=1.63 //x2=41.28 //y2=2.095
r1432 (  322 417 ) resistor r=39.0671 //w=0.217 //l=0.173853 //layer=ply \
 //thickness=0.18 //x=41.28 //y=1.4 //x2=41.24 //y2=1.555
r1433 (  321 416 ) resistor r=45.1352 //w=0.168 //l=0.173853 //layer=ply \
 //thickness=0.18 //x=41.28 //y=1.09 //x2=41.24 //y2=0.935
r1434 (  321 322 ) resistor r=158.957 //w=0.094 //l=0.31 //layer=ply \
 //thickness=0.18 //x=41.28 //y=1.09 //x2=41.28 //y2=1.4
r1435 (  316 410 ) resistor r=5.52526 //w=0.168 //l=0.115 //layer=ply \
 //thickness=0.18 //x=40.91 //y=1.555 //x2=40.795 //y2=1.555
r1436 (  315 417 ) resistor r=11.4558 //w=0.217 //l=0.115 //layer=ply \
 //thickness=0.18 //x=41.125 //y=1.555 //x2=41.24 //y2=1.555
r1437 (  314 409 ) resistor r=5.52526 //w=0.168 //l=0.115 //layer=ply \
 //thickness=0.18 //x=40.91 //y=0.935 //x2=40.795 //y2=0.935
r1438 (  313 416 ) resistor r=5.52526 //w=0.168 //l=0.115 //layer=ply \
 //thickness=0.18 //x=41.125 //y=0.935 //x2=41.24 //y2=0.935
r1439 (  313 314 ) resistor r=110.245 //w=0.094 //l=0.215 //layer=ply \
 //thickness=0.18 //x=41.125 //y=0.935 //x2=40.91 //y2=0.935
r1440 (  312 410 ) resistor r=45.1352 //w=0.168 //l=0.173853 //layer=ply \
 //thickness=0.18 //x=40.755 //y=1.4 //x2=40.795 //y2=1.555
r1441 (  311 409 ) resistor r=45.1352 //w=0.168 //l=0.173853 //layer=ply \
 //thickness=0.18 //x=40.755 //y=1.09 //x2=40.795 //y2=0.935
r1442 (  311 312 ) resistor r=158.957 //w=0.094 //l=0.31 //layer=ply \
 //thickness=0.18 //x=40.755 //y=1.09 //x2=40.755 //y2=1.4
r1443 (  307 403 ) resistor r=16.5046 //w=0.27 //l=0.135 //layer=ply \
 //thickness=0.18 //x=26.895 //y=4.97 //x2=26.76 //y2=4.97
r1444 (  306 308 ) resistor r=26.9307 //w=0.15 //l=0.106066 //layer=ply \
 //thickness=0.18 //x=27.095 //y=4.97 //x2=27.17 //y2=5.045
r1445 (  306 307 ) resistor r=102.553 //w=0.094 //l=0.2 //layer=ply \
 //thickness=0.18 //x=27.095 //y=4.97 //x2=26.895 //y2=4.97
r1446 (  305 408 ) resistor r=38.6777 //w=0.284 //l=0.198997 //layer=ply \
 //thickness=0.18 //x=26.85 //y=2.095 //x2=26.775 //y2=2.26
r1447 (  304 406 ) resistor r=21.2976 //w=0.217 //l=0.0928709 //layer=ply \
 //thickness=0.18 //x=26.85 //y=1.63 //x2=26.81 //y2=1.555
r1448 (  304 305 ) resistor r=238.436 //w=0.094 //l=0.465 //layer=ply \
 //thickness=0.18 //x=26.85 //y=1.63 //x2=26.85 //y2=2.095
r1449 (  303 406 ) resistor r=39.0671 //w=0.217 //l=0.173853 //layer=ply \
 //thickness=0.18 //x=26.85 //y=1.4 //x2=26.81 //y2=1.555
r1450 (  302 405 ) resistor r=45.1352 //w=0.168 //l=0.173853 //layer=ply \
 //thickness=0.18 //x=26.85 //y=1.09 //x2=26.81 //y2=0.935
r1451 (  302 303 ) resistor r=158.957 //w=0.094 //l=0.31 //layer=ply \
 //thickness=0.18 //x=26.85 //y=1.09 //x2=26.85 //y2=1.4
r1452 (  297 399 ) resistor r=5.52526 //w=0.168 //l=0.115 //layer=ply \
 //thickness=0.18 //x=26.48 //y=1.555 //x2=26.365 //y2=1.555
r1453 (  296 406 ) resistor r=11.4558 //w=0.217 //l=0.115 //layer=ply \
 //thickness=0.18 //x=26.695 //y=1.555 //x2=26.81 //y2=1.555
r1454 (  295 398 ) resistor r=5.52526 //w=0.168 //l=0.115 //layer=ply \
 //thickness=0.18 //x=26.48 //y=0.935 //x2=26.365 //y2=0.935
r1455 (  294 405 ) resistor r=5.52526 //w=0.168 //l=0.115 //layer=ply \
 //thickness=0.18 //x=26.695 //y=0.935 //x2=26.81 //y2=0.935
r1456 (  294 295 ) resistor r=110.245 //w=0.094 //l=0.215 //layer=ply \
 //thickness=0.18 //x=26.695 //y=0.935 //x2=26.48 //y2=0.935
r1457 (  293 399 ) resistor r=45.1352 //w=0.168 //l=0.173853 //layer=ply \
 //thickness=0.18 //x=26.325 //y=1.4 //x2=26.365 //y2=1.555
r1458 (  292 398 ) resistor r=45.1352 //w=0.168 //l=0.173853 //layer=ply \
 //thickness=0.18 //x=26.325 //y=1.09 //x2=26.365 //y2=0.935
r1459 (  292 293 ) resistor r=158.957 //w=0.094 //l=0.31 //layer=ply \
 //thickness=0.18 //x=26.325 //y=1.09 //x2=26.325 //y2=1.4
r1460 (  288 392 ) resistor r=16.5046 //w=0.27 //l=0.135 //layer=ply \
 //thickness=0.18 //x=12.465 //y=4.97 //x2=12.33 //y2=4.97
r1461 (  287 289 ) resistor r=26.9307 //w=0.15 //l=0.106066 //layer=ply \
 //thickness=0.18 //x=12.665 //y=4.97 //x2=12.74 //y2=5.045
r1462 (  287 288 ) resistor r=102.553 //w=0.094 //l=0.2 //layer=ply \
 //thickness=0.18 //x=12.665 //y=4.97 //x2=12.465 //y2=4.97
r1463 (  286 397 ) resistor r=38.6777 //w=0.284 //l=0.198997 //layer=ply \
 //thickness=0.18 //x=12.42 //y=2.095 //x2=12.345 //y2=2.26
r1464 (  285 395 ) resistor r=21.2976 //w=0.217 //l=0.0928709 //layer=ply \
 //thickness=0.18 //x=12.42 //y=1.63 //x2=12.38 //y2=1.555
r1465 (  285 286 ) resistor r=238.436 //w=0.094 //l=0.465 //layer=ply \
 //thickness=0.18 //x=12.42 //y=1.63 //x2=12.42 //y2=2.095
r1466 (  284 395 ) resistor r=39.0671 //w=0.217 //l=0.173853 //layer=ply \
 //thickness=0.18 //x=12.42 //y=1.4 //x2=12.38 //y2=1.555
r1467 (  283 394 ) resistor r=45.1352 //w=0.168 //l=0.173853 //layer=ply \
 //thickness=0.18 //x=12.42 //y=1.09 //x2=12.38 //y2=0.935
r1468 (  283 284 ) resistor r=158.957 //w=0.094 //l=0.31 //layer=ply \
 //thickness=0.18 //x=12.42 //y=1.09 //x2=12.42 //y2=1.4
r1469 (  278 388 ) resistor r=5.52526 //w=0.168 //l=0.115 //layer=ply \
 //thickness=0.18 //x=12.05 //y=1.555 //x2=11.935 //y2=1.555
r1470 (  277 395 ) resistor r=11.4558 //w=0.217 //l=0.115 //layer=ply \
 //thickness=0.18 //x=12.265 //y=1.555 //x2=12.38 //y2=1.555
r1471 (  276 387 ) resistor r=5.52526 //w=0.168 //l=0.115 //layer=ply \
 //thickness=0.18 //x=12.05 //y=0.935 //x2=11.935 //y2=0.935
r1472 (  275 394 ) resistor r=5.52526 //w=0.168 //l=0.115 //layer=ply \
 //thickness=0.18 //x=12.265 //y=0.935 //x2=12.38 //y2=0.935
r1473 (  275 276 ) resistor r=110.245 //w=0.094 //l=0.215 //layer=ply \
 //thickness=0.18 //x=12.265 //y=0.935 //x2=12.05 //y2=0.935
r1474 (  274 388 ) resistor r=45.1352 //w=0.168 //l=0.173853 //layer=ply \
 //thickness=0.18 //x=11.895 //y=1.4 //x2=11.935 //y2=1.555
r1475 (  273 387 ) resistor r=45.1352 //w=0.168 //l=0.173853 //layer=ply \
 //thickness=0.18 //x=11.895 //y=1.09 //x2=11.935 //y2=0.935
r1476 (  273 274 ) resistor r=158.957 //w=0.094 //l=0.31 //layer=ply \
 //thickness=0.18 //x=11.895 //y=1.09 //x2=11.895 //y2=1.4
r1477 (  272 384 ) resistor r=592.245 //w=0.094 //l=1.155 //layer=ply \
 //thickness=0.18 //x=84.89 //y=6.2 //x2=84.89 //y2=5.045
r1478 (  271 448 ) resistor r=592.245 //w=0.094 //l=1.155 //layer=ply \
 //thickness=0.18 //x=84.45 //y=6.2 //x2=84.45 //y2=5.045
r1479 (  270 365 ) resistor r=592.245 //w=0.094 //l=1.155 //layer=ply \
 //thickness=0.18 //x=70.46 //y=6.2 //x2=70.46 //y2=5.045
r1480 (  269 437 ) resistor r=592.245 //w=0.094 //l=1.155 //layer=ply \
 //thickness=0.18 //x=70.02 //y=6.2 //x2=70.02 //y2=5.045
r1481 (  268 346 ) resistor r=592.245 //w=0.094 //l=1.155 //layer=ply \
 //thickness=0.18 //x=56.03 //y=6.2 //x2=56.03 //y2=5.045
r1482 (  267 426 ) resistor r=592.245 //w=0.094 //l=1.155 //layer=ply \
 //thickness=0.18 //x=55.59 //y=6.2 //x2=55.59 //y2=5.045
r1483 (  266 327 ) resistor r=592.245 //w=0.094 //l=1.155 //layer=ply \
 //thickness=0.18 //x=41.6 //y=6.2 //x2=41.6 //y2=5.045
r1484 (  265 415 ) resistor r=592.245 //w=0.094 //l=1.155 //layer=ply \
 //thickness=0.18 //x=41.16 //y=6.2 //x2=41.16 //y2=5.045
r1485 (  264 308 ) resistor r=592.245 //w=0.094 //l=1.155 //layer=ply \
 //thickness=0.18 //x=27.17 //y=6.2 //x2=27.17 //y2=5.045
r1486 (  263 404 ) resistor r=592.245 //w=0.094 //l=1.155 //layer=ply \
 //thickness=0.18 //x=26.73 //y=6.2 //x2=26.73 //y2=5.045
r1487 (  262 289 ) resistor r=592.245 //w=0.094 //l=1.155 //layer=ply \
 //thickness=0.18 //x=12.74 //y=6.2 //x2=12.74 //y2=5.045
r1488 (  261 393 ) resistor r=592.245 //w=0.094 //l=1.155 //layer=ply \
 //thickness=0.18 //x=12.3 //y=6.2 //x2=12.3 //y2=5.045
r1489 (  260 372 ) resistor r=55.3787 //w=0.094 //l=0.108 //layer=ply \
 //thickness=0.18 //x=84.307 //y=1.555 //x2=84.415 //y2=1.555
r1490 (  260 373 ) resistor r=54.866 //w=0.094 //l=0.107 //layer=ply \
 //thickness=0.18 //x=84.307 //y=1.555 //x2=84.2 //y2=1.555
r1491 (  259 353 ) resistor r=55.3787 //w=0.094 //l=0.108 //layer=ply \
 //thickness=0.18 //x=69.877 //y=1.555 //x2=69.985 //y2=1.555
r1492 (  259 354 ) resistor r=54.866 //w=0.094 //l=0.107 //layer=ply \
 //thickness=0.18 //x=69.877 //y=1.555 //x2=69.77 //y2=1.555
r1493 (  258 334 ) resistor r=55.3787 //w=0.094 //l=0.108 //layer=ply \
 //thickness=0.18 //x=55.447 //y=1.555 //x2=55.555 //y2=1.555
r1494 (  258 335 ) resistor r=54.866 //w=0.094 //l=0.107 //layer=ply \
 //thickness=0.18 //x=55.447 //y=1.555 //x2=55.34 //y2=1.555
r1495 (  257 315 ) resistor r=55.3787 //w=0.094 //l=0.108 //layer=ply \
 //thickness=0.18 //x=41.017 //y=1.555 //x2=41.125 //y2=1.555
r1496 (  257 316 ) resistor r=54.866 //w=0.094 //l=0.107 //layer=ply \
 //thickness=0.18 //x=41.017 //y=1.555 //x2=40.91 //y2=1.555
r1497 (  256 296 ) resistor r=55.3787 //w=0.094 //l=0.108 //layer=ply \
 //thickness=0.18 //x=26.587 //y=1.555 //x2=26.695 //y2=1.555
r1498 (  256 297 ) resistor r=54.866 //w=0.094 //l=0.107 //layer=ply \
 //thickness=0.18 //x=26.587 //y=1.555 //x2=26.48 //y2=1.555
r1499 (  255 277 ) resistor r=55.3787 //w=0.094 //l=0.108 //layer=ply \
 //thickness=0.18 //x=12.157 //y=1.555 //x2=12.265 //y2=1.555
r1500 (  255 278 ) resistor r=54.866 //w=0.094 //l=0.107 //layer=ply \
 //thickness=0.18 //x=12.157 //y=1.555 //x2=12.05 //y2=1.555
r1501 (  251 445 ) resistor r=152 //w=0.17 //l=0.17 //layer=licon //count=1 \
 //x=84.48 //y=4.88 //x2=84.48 //y2=4.88
r1502 (  242 452 ) resistor r=152 //w=0.17 //l=0.17 //layer=licon //count=1 \
 //x=84.48 //y=2.26 //x2=84.48 //y2=2.26
r1503 (  237 434 ) resistor r=152 //w=0.17 //l=0.17 //layer=licon //count=1 \
 //x=70.05 //y=4.88 //x2=70.05 //y2=4.88
r1504 (  228 441 ) resistor r=152 //w=0.17 //l=0.17 //layer=licon //count=1 \
 //x=70.05 //y=2.26 //x2=70.05 //y2=2.26
r1505 (  223 423 ) resistor r=152 //w=0.17 //l=0.17 //layer=licon //count=1 \
 //x=55.62 //y=4.88 //x2=55.62 //y2=4.88
r1506 (  214 430 ) resistor r=152 //w=0.17 //l=0.17 //layer=licon //count=1 \
 //x=55.62 //y=2.26 //x2=55.62 //y2=2.26
r1507 (  209 412 ) resistor r=152 //w=0.17 //l=0.17 //layer=licon //count=1 \
 //x=41.19 //y=4.88 //x2=41.19 //y2=4.88
r1508 (  200 419 ) resistor r=152 //w=0.17 //l=0.17 //layer=licon //count=1 \
 //x=41.19 //y=2.26 //x2=41.19 //y2=2.26
r1509 (  195 401 ) resistor r=152 //w=0.17 //l=0.17 //layer=licon //count=1 \
 //x=26.76 //y=4.88 //x2=26.76 //y2=4.88
r1510 (  186 408 ) resistor r=152 //w=0.17 //l=0.17 //layer=licon //count=1 \
 //x=26.76 //y=2.26 //x2=26.76 //y2=2.26
r1511 (  181 390 ) resistor r=152 //w=0.17 //l=0.17 //layer=licon //count=1 \
 //x=12.33 //y=4.88 //x2=12.33 //y2=4.88
r1512 (  172 397 ) resistor r=152 //w=0.17 //l=0.17 //layer=licon //count=1 \
 //x=12.33 //y=2.26 //x2=12.33 //y2=2.26
r1513 (  157 159 ) resistor r=0.10734 //w=0.281 //l=0.16 //layer=m2 \
 //thickness=0.36 //x=12.33 //y=3.125 //x2=12.49 //y2=3.125
r1514 (  154 170 ) resistor r=3.98787 //w=0.179 //l=5.71999 //layer=m2 \
 //thickness=0.36 //x=78.77 //y=3.125 //x2=84.48 //y2=3.145
r1515 (  154 155 ) resistor r=0.410305 //w=0.131 //l=0.43 //layer=m2 \
 //thickness=0.36 //x=78.77 //y=3.125 //x2=78.34 //y2=3.125
r1516 (  152 155 ) resistor r=0.125 //w=0.17 //l=0.177341 //layer=m2 \
 //thickness=0.36 //x=78.17 //y=3.14 //x2=78.34 //y2=3.125
r1517 (  152 153 ) resistor r=3.84065 //w=0.131 //l=4.025 //layer=m2 \
 //thickness=0.36 //x=78.17 //y=3.14 //x2=74.145 //y2=3.14
r1518 (  150 153 ) resistor r=0.125 //w=0.17 //l=0.177341 //layer=m2 \
 //thickness=0.36 //x=73.975 //y=3.155 //x2=74.145 //y2=3.14
r1519 (  150 151 ) resistor r=0.329198 //w=0.131 //l=0.345 //layer=m2 \
 //thickness=0.36 //x=73.975 //y=3.155 //x2=73.63 //y2=3.155
r1520 (  148 151 ) resistor r=0.1875 //w=0.17 //l=0.262393 //layer=m2 \
 //thickness=0.36 //x=73.375 //y=3.14 //x2=73.63 //y2=3.155
r1521 (  148 149 ) resistor r=1.04008 //w=0.131 //l=1.09 //layer=m2 \
 //thickness=0.36 //x=73.375 //y=3.14 //x2=72.285 //y2=3.14
r1522 (  147 168 ) resistor r=1.1391 //w=0.189 //l=1.73494 //layer=m2 \
 //thickness=0.36 //x=71.77 //y=3.155 //x2=70.05 //y2=3.125
r1523 (  146 149 ) resistor r=0.125 //w=0.17 //l=0.177341 //layer=m2 \
 //thickness=0.36 //x=72.115 //y=3.155 //x2=72.285 //y2=3.14
r1524 (  146 147 ) resistor r=0.329198 //w=0.131 //l=0.345 //layer=m2 \
 //thickness=0.36 //x=72.115 //y=3.155 //x2=71.77 //y2=3.155
r1525 (  144 168 ) resistor r=0.593468 //w=0.189 //l=0.917224 //layer=m2 \
 //thickness=0.36 //x=69.155 //y=3.17 //x2=70.05 //y2=3.125
r1526 (  144 145 ) resistor r=0.329198 //w=0.131 //l=0.345 //layer=m2 \
 //thickness=0.36 //x=69.155 //y=3.17 //x2=68.81 //y2=3.17
r1527 (  142 145 ) resistor r=0.1875 //w=0.17 //l=0.269583 //layer=m2 \
 //thickness=0.36 //x=68.555 //y=3.14 //x2=68.81 //y2=3.17
r1528 (  142 143 ) resistor r=0.949427 //w=0.131 //l=0.995 //layer=m2 \
 //thickness=0.36 //x=68.555 //y=3.14 //x2=67.56 //y2=3.14
r1529 (  140 143 ) resistor r=0.1875 //w=0.17 //l=0.269583 //layer=m2 \
 //thickness=0.36 //x=67.305 //y=3.11 //x2=67.56 //y2=3.14
r1530 (  140 141 ) resistor r=0.410305 //w=0.131 //l=0.43 //layer=m2 \
 //thickness=0.36 //x=67.305 //y=3.11 //x2=66.875 //y2=3.11
r1531 (  138 141 ) resistor r=0.125 //w=0.17 //l=0.184391 //layer=m2 \
 //thickness=0.36 //x=66.705 //y=3.14 //x2=66.875 //y2=3.11
r1532 (  138 139 ) resistor r=2.08492 //w=0.131 //l=2.185 //layer=m2 \
 //thickness=0.36 //x=66.705 //y=3.14 //x2=64.52 //y2=3.14
r1533 (  136 139 ) resistor r=0.125 //w=0.17 //l=0.184391 //layer=m2 \
 //thickness=0.36 //x=64.35 //y=3.17 //x2=64.52 //y2=3.14
r1534 (  136 137 ) resistor r=0.329198 //w=0.131 //l=0.345 //layer=m2 \
 //thickness=0.36 //x=64.35 //y=3.17 //x2=64.005 //y2=3.17
r1535 (  134 137 ) resistor r=0.1875 //w=0.17 //l=0.269583 //layer=m2 \
 //thickness=0.36 //x=63.75 //y=3.14 //x2=64.005 //y2=3.17
r1536 (  134 135 ) resistor r=1.03053 //w=0.131 //l=1.08 //layer=m2 \
 //thickness=0.36 //x=63.75 //y=3.14 //x2=62.67 //y2=3.14
r1537 (  132 135 ) resistor r=0.125 //w=0.17 //l=0.184391 //layer=m2 \
 //thickness=0.36 //x=62.5 //y=3.17 //x2=62.67 //y2=3.14
r1538 (  132 133 ) resistor r=0.329198 //w=0.131 //l=0.345 //layer=m2 \
 //thickness=0.36 //x=62.5 //y=3.17 //x2=62.155 //y2=3.17
r1539 (  131 166 ) resistor r=3.99136 //w=0.179 //l=5.7225 //layer=m2 \
 //thickness=0.36 //x=61.335 //y=3.13 //x2=55.62 //y2=3.145
r1540 (  130 133 ) resistor r=0.286765 //w=0.17 //l=0.409512 //layer=m2 \
 //thickness=0.36 //x=61.765 //y=3.13 //x2=62.155 //y2=3.17
r1541 (  130 131 ) resistor r=0.410305 //w=0.131 //l=0.43 //layer=m2 \
 //thickness=0.36 //x=61.765 //y=3.13 //x2=61.335 //y2=3.13
r1542 (  128 166 ) resistor r=0.112172 //w=0.179 //l=0.162481 //layer=m2 \
 //thickness=0.36 //x=55.46 //y=3.14 //x2=55.62 //y2=3.145
r1543 (  128 164 ) resistor r=3.0916 //w=0.131 //l=3.24 //layer=m2 \
 //thickness=0.36 //x=55.46 //y=3.14 //x2=52.22 //y2=3.14
r1544 (  126 164 ) resistor r=0.0824018 //w=0.161 //l=0.1 //layer=m2 \
 //thickness=0.36 //x=52.12 //y=3.125 //x2=52.22 //y2=3.125
r1545 (  126 127 ) resistor r=0.310559 //w=0.161 //l=0.4 //layer=m2 \
 //thickness=0.36 //x=52.12 //y=3.125 //x2=51.72 //y2=3.125
r1546 (  124 127 ) resistor r=1.31541 //w=0.172 //l=1.81 //layer=m2 \
 //thickness=0.36 //x=49.91 //y=3.125 //x2=51.72 //y2=3.125
r1547 (  124 125 ) resistor r=0.410305 //w=0.131 //l=0.43 //layer=m2 \
 //thickness=0.36 //x=49.91 //y=3.125 //x2=49.48 //y2=3.125
r1548 (  122 125 ) resistor r=0.125 //w=0.17 //l=0.177341 //layer=m2 \
 //thickness=0.36 //x=49.31 //y=3.14 //x2=49.48 //y2=3.125
r1549 (  122 123 ) resistor r=3.84065 //w=0.131 //l=4.025 //layer=m2 \
 //thickness=0.36 //x=49.31 //y=3.14 //x2=45.285 //y2=3.14
r1550 (  120 123 ) resistor r=0.125 //w=0.17 //l=0.177341 //layer=m2 \
 //thickness=0.36 //x=45.115 //y=3.155 //x2=45.285 //y2=3.14
r1551 (  120 121 ) resistor r=0.329198 //w=0.131 //l=0.345 //layer=m2 \
 //thickness=0.36 //x=45.115 //y=3.155 //x2=44.77 //y2=3.155
r1552 (  118 121 ) resistor r=0.1875 //w=0.17 //l=0.262393 //layer=m2 \
 //thickness=0.36 //x=44.515 //y=3.14 //x2=44.77 //y2=3.155
r1553 (  118 119 ) resistor r=1.04008 //w=0.131 //l=1.09 //layer=m2 \
 //thickness=0.36 //x=44.515 //y=3.14 //x2=43.425 //y2=3.14
r1554 (  117 163 ) resistor r=1.1391 //w=0.189 //l=1.73494 //layer=m2 \
 //thickness=0.36 //x=42.91 //y=3.155 //x2=41.19 //y2=3.125
r1555 (  116 119 ) resistor r=0.125 //w=0.17 //l=0.177341 //layer=m2 \
 //thickness=0.36 //x=43.255 //y=3.155 //x2=43.425 //y2=3.14
r1556 (  116 117 ) resistor r=0.329198 //w=0.131 //l=0.345 //layer=m2 \
 //thickness=0.36 //x=43.255 //y=3.155 //x2=42.91 //y2=3.155
r1557 (  114 163 ) resistor r=0.593468 //w=0.189 //l=0.917224 //layer=m2 \
 //thickness=0.36 //x=40.295 //y=3.17 //x2=41.19 //y2=3.125
r1558 (  114 115 ) resistor r=0.329198 //w=0.131 //l=0.345 //layer=m2 \
 //thickness=0.36 //x=40.295 //y=3.17 //x2=39.95 //y2=3.17
r1559 (  112 115 ) resistor r=0.1875 //w=0.17 //l=0.269583 //layer=m2 \
 //thickness=0.36 //x=39.695 //y=3.14 //x2=39.95 //y2=3.17
r1560 (  112 113 ) resistor r=0.949427 //w=0.131 //l=0.995 //layer=m2 \
 //thickness=0.36 //x=39.695 //y=3.14 //x2=38.7 //y2=3.14
r1561 (  110 113 ) resistor r=0.1875 //w=0.17 //l=0.269583 //layer=m2 \
 //thickness=0.36 //x=38.445 //y=3.11 //x2=38.7 //y2=3.14
r1562 (  110 111 ) resistor r=0.410305 //w=0.131 //l=0.43 //layer=m2 \
 //thickness=0.36 //x=38.445 //y=3.11 //x2=38.015 //y2=3.11
r1563 (  108 111 ) resistor r=0.125 //w=0.17 //l=0.184391 //layer=m2 \
 //thickness=0.36 //x=37.845 //y=3.14 //x2=38.015 //y2=3.11
r1564 (  108 109 ) resistor r=2.08492 //w=0.131 //l=2.185 //layer=m2 \
 //thickness=0.36 //x=37.845 //y=3.14 //x2=35.66 //y2=3.14
r1565 (  106 109 ) resistor r=0.125 //w=0.17 //l=0.184391 //layer=m2 \
 //thickness=0.36 //x=35.49 //y=3.17 //x2=35.66 //y2=3.14
r1566 (  106 107 ) resistor r=0.329198 //w=0.131 //l=0.345 //layer=m2 \
 //thickness=0.36 //x=35.49 //y=3.17 //x2=35.145 //y2=3.17
r1567 (  104 107 ) resistor r=0.1875 //w=0.17 //l=0.269583 //layer=m2 \
 //thickness=0.36 //x=34.89 //y=3.14 //x2=35.145 //y2=3.17
r1568 (  104 105 ) resistor r=1.03053 //w=0.131 //l=1.08 //layer=m2 \
 //thickness=0.36 //x=34.89 //y=3.14 //x2=33.81 //y2=3.14
r1569 (  102 105 ) resistor r=0.125 //w=0.17 //l=0.184391 //layer=m2 \
 //thickness=0.36 //x=33.64 //y=3.17 //x2=33.81 //y2=3.14
r1570 (  102 103 ) resistor r=0.329198 //w=0.131 //l=0.345 //layer=m2 \
 //thickness=0.36 //x=33.64 //y=3.17 //x2=33.295 //y2=3.17
r1571 (  101 161 ) resistor r=4.08214 //w=0.175 //l=5.7225 //layer=m2 \
 //thickness=0.36 //x=32.475 //y=3.13 //x2=26.76 //y2=3.145
r1572 (  100 103 ) resistor r=0.286765 //w=0.17 //l=0.409512 //layer=m2 \
 //thickness=0.36 //x=32.905 //y=3.13 //x2=33.295 //y2=3.17
r1573 (  100 101 ) resistor r=0.410305 //w=0.131 //l=0.43 //layer=m2 \
 //thickness=0.36 //x=32.905 //y=3.13 //x2=32.475 //y2=3.13
r1574 (  98 161 ) resistor r=4.07857 //w=0.175 //l=5.71999 //layer=m2 \
 //thickness=0.36 //x=21.05 //y=3.125 //x2=26.76 //y2=3.145
r1575 (  98 99 ) resistor r=0.410305 //w=0.131 //l=0.43 //layer=m2 \
 //thickness=0.36 //x=21.05 //y=3.125 //x2=20.62 //y2=3.125
r1576 (  96 99 ) resistor r=0.125 //w=0.17 //l=0.177341 //layer=m2 \
 //thickness=0.36 //x=20.45 //y=3.14 //x2=20.62 //y2=3.125
r1577 (  96 97 ) resistor r=3.84065 //w=0.131 //l=4.025 //layer=m2 \
 //thickness=0.36 //x=20.45 //y=3.14 //x2=16.425 //y2=3.14
r1578 (  94 97 ) resistor r=0.125 //w=0.17 //l=0.177341 //layer=m2 \
 //thickness=0.36 //x=16.255 //y=3.155 //x2=16.425 //y2=3.14
r1579 (  94 95 ) resistor r=0.329198 //w=0.131 //l=0.345 //layer=m2 \
 //thickness=0.36 //x=16.255 //y=3.155 //x2=15.91 //y2=3.155
r1580 (  92 95 ) resistor r=0.1875 //w=0.17 //l=0.262393 //layer=m2 \
 //thickness=0.36 //x=15.655 //y=3.14 //x2=15.91 //y2=3.155
r1581 (  92 93 ) resistor r=1.04008 //w=0.131 //l=1.09 //layer=m2 \
 //thickness=0.36 //x=15.655 //y=3.14 //x2=14.565 //y2=3.14
r1582 (  90 93 ) resistor r=0.125 //w=0.17 //l=0.177341 //layer=m2 \
 //thickness=0.36 //x=14.395 //y=3.155 //x2=14.565 //y2=3.14
r1583 (  90 91 ) resistor r=0.329198 //w=0.131 //l=0.345 //layer=m2 \
 //thickness=0.36 //x=14.395 //y=3.155 //x2=14.05 //y2=3.155
r1584 (  88 91 ) resistor r=0.1875 //w=0.17 //l=0.262393 //layer=m2 \
 //thickness=0.36 //x=13.795 //y=3.14 //x2=14.05 //y2=3.155
r1585 (  88 159 ) resistor r=1.24523 //w=0.131 //l=1.305 //layer=m2 \
 //thickness=0.36 //x=13.795 //y=3.14 //x2=12.49 //y2=3.14
r1586 (  87 251 ) resistor r=9.3 //w=0.17 //l=0.17 //layer=mcon //count=1 \
 //x=84.48 //y=4.88 //x2=84.48 //y2=4.88
r1587 (  85 242 ) resistor r=9.3 //w=0.17 //l=0.17 //layer=mcon //count=1 \
 //x=84.48 //y=2.26 //x2=84.48 //y2=2.26
r1588 (  83 170 ) resistor r=4.5 //w=0.15 //l=0.15 //layer=via1 //count=1 \
 //x=84.48 //y=3.145 //x2=84.48 //y2=3.145
r1589 (  81 83 ) resistor r=0.00166223 //w=0.376 //l=0.005 //layer=m1 \
 //thickness=0.36 //x=84.427 //y=3.14 //x2=84.427 //y2=3.145
r1590 (  77 168 ) resistor r=4.5 //w=0.15 //l=0.15 //layer=via1 //count=1 \
 //x=70.05 //y=3.125 //x2=70.05 //y2=3.125
r1591 (  75 237 ) resistor r=9.3 //w=0.17 //l=0.17 //layer=mcon //count=1 \
 //x=70.05 //y=4.88 //x2=70.05 //y2=4.88
r1592 (  73 228 ) resistor r=9.3 //w=0.17 //l=0.17 //layer=mcon //count=1 \
 //x=70.05 //y=2.26 //x2=70.05 //y2=2.26
r1593 (  71 223 ) resistor r=9.3 //w=0.17 //l=0.17 //layer=mcon //count=1 \
 //x=55.62 //y=4.88 //x2=55.62 //y2=4.88
r1594 (  69 214 ) resistor r=9.3 //w=0.17 //l=0.17 //layer=mcon //count=1 \
 //x=55.62 //y=2.26 //x2=55.62 //y2=2.26
r1595 (  67 166 ) resistor r=4.5 //w=0.15 //l=0.15 //layer=via1 //count=1 \
 //x=55.62 //y=3.145 //x2=55.62 //y2=3.145
r1596 (  61 163 ) resistor r=4.5 //w=0.15 //l=0.15 //layer=via1 //count=1 \
 //x=41.19 //y=3.125 //x2=41.19 //y2=3.125
r1597 (  59 209 ) resistor r=9.3 //w=0.17 //l=0.17 //layer=mcon //count=1 \
 //x=41.19 //y=4.88 //x2=41.19 //y2=4.88
r1598 (  57 200 ) resistor r=9.3 //w=0.17 //l=0.17 //layer=mcon //count=1 \
 //x=41.19 //y=2.26 //x2=41.19 //y2=2.26
r1599 (  55 195 ) resistor r=9.3 //w=0.17 //l=0.17 //layer=mcon //count=1 \
 //x=26.76 //y=4.88 //x2=26.76 //y2=4.88
r1600 (  53 186 ) resistor r=9.3 //w=0.17 //l=0.17 //layer=mcon //count=1 \
 //x=26.76 //y=2.26 //x2=26.76 //y2=2.26
r1601 (  51 161 ) resistor r=4.5 //w=0.15 //l=0.15 //layer=via1 //count=1 \
 //x=26.76 //y=3.145 //x2=26.76 //y2=3.145
r1602 (  45 157 ) resistor r=4.5 //w=0.15 //l=0.15 //layer=via1 //count=1 \
 //x=12.33 //y=3.125 //x2=12.33 //y2=3.125
r1603 (  43 181 ) resistor r=9.3 //w=0.17 //l=0.17 //layer=mcon //count=1 \
 //x=12.33 //y=4.88 //x2=12.33 //y2=4.88
r1604 (  41 172 ) resistor r=9.3 //w=0.17 //l=0.17 //layer=mcon //count=1 \
 //x=12.33 //y=2.26 //x2=12.33 //y2=2.26
r1605 (  39 87 ) resistor r=0.0717383 //w=0.224 //l=0.115 //layer=m1 \
 //thickness=0.36 //x=84.48 //y=4.765 //x2=84.48 //y2=4.88
r1606 (  38 83 ) resistor r=0.0911593 //w=0.376 //l=0.184608 //layer=m1 \
 //thickness=0.36 //x=84.48 //y=3.305 //x2=84.427 //y2=3.145
r1607 (  38 39 ) resistor r=1.39313 //w=0.131 //l=1.46 //layer=m1 \
 //thickness=0.36 //x=84.48 //y=3.305 //x2=84.48 //y2=4.765
r1608 (  37 81 ) resistor r=0.0894971 //w=0.376 //l=0.179555 //layer=m1 \
 //thickness=0.36 //x=84.48 //y=2.985 //x2=84.427 //y2=3.14
r1609 (  36 85 ) resistor r=0.0715665 //w=0.226 //l=0.115996 //layer=m1 \
 //thickness=0.36 //x=84.48 //y=2.375 //x2=84.482 //y2=2.26
r1610 (  36 37 ) resistor r=0.582061 //w=0.131 //l=0.61 //layer=m1 \
 //thickness=0.36 //x=84.48 //y=2.375 //x2=84.48 //y2=2.985
r1611 (  35 75 ) resistor r=0.0717383 //w=0.224 //l=0.115 //layer=m1 \
 //thickness=0.36 //x=70.05 //y=4.765 //x2=70.05 //y2=4.88
r1612 (  34 35 ) resistor r=1.41221 //w=0.131 //l=1.48 //layer=m1 \
 //thickness=0.36 //x=70.05 //y=3.285 //x2=70.05 //y2=4.765
r1613 (  32 77 ) resistor r=0.0911593 //w=0.376 //l=0.184174 //layer=m1 \
 //thickness=0.36 //x=70.05 //y=2.965 //x2=70.102 //y2=3.125
r1614 (  31 73 ) resistor r=0.0715665 //w=0.226 //l=0.115996 //layer=m1 \
 //thickness=0.36 //x=70.05 //y=2.375 //x2=70.052 //y2=2.26
r1615 (  30 71 ) resistor r=0.0717383 //w=0.224 //l=0.115 //layer=m1 \
 //thickness=0.36 //x=55.62 //y=4.765 //x2=55.62 //y2=4.88
r1616 (  29 67 ) resistor r=0.0911593 //w=0.376 //l=0.184608 //layer=m1 \
 //thickness=0.36 //x=55.62 //y=3.305 //x2=55.567 //y2=3.145
r1617 (  29 30 ) resistor r=1.39313 //w=0.131 //l=1.46 //layer=m1 \
 //thickness=0.36 //x=55.62 //y=3.305 //x2=55.62 //y2=4.765
r1618 (  26 69 ) resistor r=0.0715665 //w=0.226 //l=0.115996 //layer=m1 \
 //thickness=0.36 //x=55.62 //y=2.375 //x2=55.622 //y2=2.26
r1619 (  25 59 ) resistor r=0.0717383 //w=0.224 //l=0.115 //layer=m1 \
 //thickness=0.36 //x=41.19 //y=4.765 //x2=41.19 //y2=4.88
r1620 (  24 25 ) resistor r=1.41221 //w=0.131 //l=1.48 //layer=m1 \
 //thickness=0.36 //x=41.19 //y=3.285 //x2=41.19 //y2=4.765
r1621 (  22 61 ) resistor r=0.0911593 //w=0.376 //l=0.184174 //layer=m1 \
 //thickness=0.36 //x=41.19 //y=2.965 //x2=41.242 //y2=3.125
r1622 (  21 57 ) resistor r=0.0715665 //w=0.226 //l=0.115996 //layer=m1 \
 //thickness=0.36 //x=41.19 //y=2.375 //x2=41.192 //y2=2.26
r1623 (  20 55 ) resistor r=0.0717383 //w=0.224 //l=0.115 //layer=m1 \
 //thickness=0.36 //x=26.76 //y=4.765 //x2=26.76 //y2=4.88
r1624 (  19 51 ) resistor r=0.0911593 //w=0.376 //l=0.184608 //layer=m1 \
 //thickness=0.36 //x=26.76 //y=3.305 //x2=26.707 //y2=3.145
r1625 (  19 20 ) resistor r=1.39313 //w=0.131 //l=1.46 //layer=m1 \
 //thickness=0.36 //x=26.76 //y=3.305 //x2=26.76 //y2=4.765
r1626 (  16 53 ) resistor r=0.0715665 //w=0.226 //l=0.115996 //layer=m1 \
 //thickness=0.36 //x=26.76 //y=2.375 //x2=26.762 //y2=2.26
r1627 (  15 43 ) resistor r=0.0717383 //w=0.224 //l=0.115 //layer=m1 \
 //thickness=0.36 //x=12.33 //y=4.765 //x2=12.33 //y2=4.88
r1628 (  14 15 ) resistor r=1.41221 //w=0.131 //l=1.48 //layer=m1 \
 //thickness=0.36 //x=12.33 //y=3.285 //x2=12.33 //y2=4.765
r1629 (  12 45 ) resistor r=0.0911593 //w=0.376 //l=0.184174 //layer=m1 \
 //thickness=0.36 //x=12.33 //y=2.965 //x2=12.382 //y2=3.125
r1630 (  11 41 ) resistor r=0.0715665 //w=0.226 //l=0.115996 //layer=m1 \
 //thickness=0.36 //x=12.33 //y=2.375 //x2=12.332 //y2=2.26
r1631 (  10 34 ) resistor r=0.0861726 //w=0.376 //l=0.169012 //layer=m1 \
 //thickness=0.36 //x=70.102 //y=3.14 //x2=70.05 //y2=3.285
r1632 (  10 77 ) resistor r=0.0049867 //w=0.376 //l=0.015 //layer=m1 \
 //thickness=0.36 //x=70.102 //y=3.14 //x2=70.102 //y2=3.125
r1633 (  9 67 ) resistor r=0.00166223 //w=0.376 //l=0.005 //layer=m1 \
 //thickness=0.36 //x=55.567 //y=3.14 //x2=55.567 //y2=3.145
r1634 (  9 27 ) resistor r=0.0894971 //w=0.376 //l=0.179555 //layer=m1 \
 //thickness=0.36 //x=55.567 //y=3.14 //x2=55.62 //y2=2.985
r1635 (  8 24 ) resistor r=0.0861726 //w=0.376 //l=0.169012 //layer=m1 \
 //thickness=0.36 //x=41.242 //y=3.14 //x2=41.19 //y2=3.285
r1636 (  8 61 ) resistor r=0.0049867 //w=0.376 //l=0.015 //layer=m1 \
 //thickness=0.36 //x=41.242 //y=3.14 //x2=41.242 //y2=3.125
r1637 (  7 51 ) resistor r=0.00166223 //w=0.376 //l=0.005 //layer=m1 \
 //thickness=0.36 //x=26.707 //y=3.14 //x2=26.707 //y2=3.145
r1638 (  7 17 ) resistor r=0.0894971 //w=0.376 //l=0.179555 //layer=m1 \
 //thickness=0.36 //x=26.707 //y=3.14 //x2=26.76 //y2=2.985
r1639 (  6 14 ) resistor r=0.0861726 //w=0.376 //l=0.169012 //layer=m1 \
 //thickness=0.36 //x=12.382 //y=3.14 //x2=12.33 //y2=3.285
r1640 (  6 45 ) resistor r=0.0049867 //w=0.376 //l=0.015 //layer=m1 \
 //thickness=0.36 //x=12.382 //y=3.14 //x2=12.382 //y2=3.125
r1641 (  5 32 ) resistor r=0.186069 //w=0.131 //l=0.195 //layer=m1 \
 //thickness=0.36 //x=70.05 //y=2.77 //x2=70.05 //y2=2.965
r1642 (  5 31 ) resistor r=0.376908 //w=0.131 //l=0.395 //layer=m1 \
 //thickness=0.36 //x=70.05 //y=2.77 //x2=70.05 //y2=2.375
r1643 (  4 27 ) resistor r=0.205153 //w=0.131 //l=0.215 //layer=m1 \
 //thickness=0.36 //x=55.62 //y=2.77 //x2=55.62 //y2=2.985
r1644 (  4 26 ) resistor r=0.376908 //w=0.131 //l=0.395 //layer=m1 \
 //thickness=0.36 //x=55.62 //y=2.77 //x2=55.62 //y2=2.375
r1645 (  3 22 ) resistor r=0.186069 //w=0.131 //l=0.195 //layer=m1 \
 //thickness=0.36 //x=41.19 //y=2.77 //x2=41.19 //y2=2.965
r1646 (  3 21 ) resistor r=0.376908 //w=0.131 //l=0.395 //layer=m1 \
 //thickness=0.36 //x=41.19 //y=2.77 //x2=41.19 //y2=2.375
r1647 (  2 17 ) resistor r=0.205153 //w=0.131 //l=0.215 //layer=m1 \
 //thickness=0.36 //x=26.76 //y=2.77 //x2=26.76 //y2=2.985
r1648 (  2 16 ) resistor r=0.376908 //w=0.131 //l=0.395 //layer=m1 \
 //thickness=0.36 //x=26.76 //y=2.77 //x2=26.76 //y2=2.375
r1649 (  1 12 ) resistor r=0.186069 //w=0.131 //l=0.195 //layer=m1 \
 //thickness=0.36 //x=12.33 //y=2.77 //x2=12.33 //y2=2.965
r1650 (  1 11 ) resistor r=0.376908 //w=0.131 //l=0.395 //layer=m1 \
 //thickness=0.36 //x=12.33 //y=2.77 //x2=12.33 //y2=2.375
ends PM_TMRDFFSNRNQX1\%SN

subckt PM_TMRDFFSNRNQX1\%noxref_20 ( 1 2 3 4 5 6 7 8 9 11 14 15 17 18 19 20 22 \
 23 24 25 26 27 28 34 38 45 48 51 57 61 70 72 73 77 80 81 87 96 101 110 115 \
 123 131 148 157 161 162 163 164 165 166 167 168 169 173 174 175 180 182 185 \
 186 190 191 192 197 199 202 203 207 208 209 214 216 219 220 222 223 228 232 \
 233 238 242 243 248 251 253 254 255 )
c609 ( 251 0 ) capacitor c=0.00885916f //x=76.035 //y=1.095
c610 ( 248 0 ) capacitor c=0.0651477f //x=85.59 //y=4.88
c611 ( 243 0 ) capacitor c=0.0278202f //x=85.59 //y=2.095
c612 ( 242 0 ) capacitor c=0.0487297f //x=85.59 //y=2.26
c613 ( 238 0 ) capacitor c=0.0651406f //x=71.16 //y=4.88
c614 ( 233 0 ) capacitor c=0.0278202f //x=71.16 //y=2.095
c615 ( 232 0 ) capacitor c=0.0503043f //x=71.16 //y=2.26
c616 ( 228 0 ) capacitor c=0.0653609f //x=66.35 //y=4.88
c617 ( 223 0 ) capacitor c=0.0278202f //x=66.35 //y=2.095
c618 ( 222 0 ) capacitor c=0.0503043f //x=66.35 //y=2.26
c619 ( 220 0 ) capacitor c=0.0443175f //x=86.11 //y=1.44
c620 ( 219 0 ) capacitor c=0.0199703f //x=86.11 //y=1.095
c621 ( 216 0 ) capacitor c=0.0162526f //x=85.955 //y=1.595
c622 ( 214 0 ) capacitor c=0.0157807f //x=85.955 //y=0.94
c623 ( 209 0 ) capacitor c=0.0220935f //x=85.58 //y=1.75
c624 ( 208 0 ) capacitor c=0.0207489f //x=85.58 //y=1.44
c625 ( 207 0 ) capacitor c=0.0194091f //x=85.58 //y=1.095
c626 ( 203 0 ) capacitor c=0.0443175f //x=71.68 //y=1.44
c627 ( 202 0 ) capacitor c=0.0199703f //x=71.68 //y=1.095
c628 ( 199 0 ) capacitor c=0.0162526f //x=71.525 //y=1.595
c629 ( 197 0 ) capacitor c=0.0157807f //x=71.525 //y=0.94
c630 ( 192 0 ) capacitor c=0.0220935f //x=71.15 //y=1.75
c631 ( 191 0 ) capacitor c=0.0207489f //x=71.15 //y=1.44
c632 ( 190 0 ) capacitor c=0.0194091f //x=71.15 //y=1.095
c633 ( 186 0 ) capacitor c=0.0443175f //x=66.87 //y=1.44
c634 ( 185 0 ) capacitor c=0.0199703f //x=66.87 //y=1.095
c635 ( 182 0 ) capacitor c=0.0162526f //x=66.715 //y=1.595
c636 ( 180 0 ) capacitor c=0.0157807f //x=66.715 //y=0.94
c637 ( 175 0 ) capacitor c=0.0220935f //x=66.34 //y=1.75
c638 ( 174 0 ) capacitor c=0.0207489f //x=66.34 //y=1.44
c639 ( 173 0 ) capacitor c=0.0194091f //x=66.34 //y=1.095
c640 ( 169 0 ) capacitor c=0.159671f //x=85.77 //y=6.2
c641 ( 168 0 ) capacitor c=0.110208f //x=85.33 //y=6.2
c642 ( 167 0 ) capacitor c=0.159671f //x=71.34 //y=6.2
c643 ( 166 0 ) capacitor c=0.110208f //x=70.9 //y=6.2
c644 ( 165 0 ) capacitor c=0.159671f //x=66.53 //y=6.2
c645 ( 164 0 ) capacitor c=0.110219f //x=66.09 //y=6.2
c646 ( 157 0 ) capacitor c=7.7417e-19 //x=85.59 //y=4.88
c647 ( 148 0 ) capacitor c=0.00101179f //x=85.59 //y=2.26
c648 ( 131 0 ) capacitor c=0.0293124f //x=75.93 //y=5.56
c649 ( 123 0 ) capacitor c=0.029137f //x=75.05 //y=5.56
c650 ( 115 0 ) capacitor c=0.0278099f //x=74.17 //y=5.56
c651 ( 110 0 ) capacitor c=9.5006e-19 //x=71.16 //y=4.88
c652 ( 101 0 ) capacitor c=0.00101179f //x=71.16 //y=2.26
c653 ( 96 0 ) capacitor c=9.08283e-19 //x=66.35 //y=4.88
c654 ( 87 0 ) capacitor c=0.00101179f //x=66.35 //y=2.26
c655 ( 81 0 ) capacitor c=3.98458e-19 //x=71.32 //y=3.895
c656 ( 80 0 ) capacitor c=0.0441954f //x=71 //y=3.895
c657 ( 77 0 ) capacitor c=3.98458e-19 //x=66.51 //y=3.895
c658 ( 73 0 ) capacitor c=0.0212158f //x=78.425 //y=3.895
c659 ( 72 0 ) capacitor c=0.0867333f //x=78.77 //y=3.895
c660 ( 70 0 ) capacitor c=0.0533559f //x=76.54 //y=3.88
c661 ( 61 0 ) capacitor c=0.0149589f //x=85.59 //y=3.88
c662 ( 57 0 ) capacitor c=0.0158949f //x=76.71 //y=3.88
c663 ( 51 0 ) capacitor c=0.00111241f //x=75.93 //y=5.335
c664 ( 48 0 ) capacitor c=0.00737416f //x=75.05 //y=5.335
c665 ( 45 0 ) capacitor c=0.0119166f //x=74.172 //y=5.335
c666 ( 38 0 ) capacitor c=0.0149589f //x=71.16 //y=3.88
c667 ( 34 0 ) capacitor c=0.0149589f //x=66.35 //y=3.88
c668 ( 28 0 ) capacitor c=0.0197432f //x=85.59 //y=4.75
c669 ( 27 0 ) capacitor c=0.0115215f //x=85.59 //y=4.045
c670 ( 26 0 ) capacitor c=0.0333977f //x=85.59 //y=3.725
c671 ( 25 0 ) capacitor c=0.00553505f //x=85.59 //y=2.375
c672 ( 24 0 ) capacitor c=0.030326f //x=76.71 //y=5.25
c673 ( 23 0 ) capacitor c=0.0138897f //x=76.71 //y=4.055
c674 ( 22 0 ) capacitor c=0.0490588f //x=76.71 //y=3.735
c675 ( 20 0 ) capacitor c=0.00493487f //x=76.31 //y=1.845
c676 ( 19 0 ) capacitor c=0.0133342f //x=76.625 //y=1.845
c677 ( 18 0 ) capacitor c=0.0167992f //x=76.225 //y=1.76
c678 ( 17 0 ) capacitor c=0.0111491f //x=76.225 //y=1.305
c679 ( 15 0 ) capacitor c=0.0238276f //x=76.625 //y=5.335
c680 ( 14 0 ) capacitor c=0.00933983f //x=75.93 //y=5.56
c681 ( 11 0 ) capacitor c=0.0173034f //x=75.815 //y=5.335
c682 ( 9 0 ) capacitor c=0.0153223f //x=74.93 //y=5.335
c683 ( 8 0 ) capacitor c=0.0180102f //x=71.16 //y=4.75
c684 ( 7 0 ) capacitor c=0.011494f //x=71.16 //y=4.055
c685 ( 6 0 ) capacitor c=0.029293f //x=71.16 //y=3.735
c686 ( 5 0 ) capacitor c=0.00556102f //x=71.16 //y=2.375
c687 ( 4 0 ) capacitor c=0.0173396f //x=66.35 //y=4.75
c688 ( 3 0 ) capacitor c=0.0132847f //x=66.35 //y=4.055
c689 ( 2 0 ) capacitor c=0.0302473f //x=66.35 //y=3.735
c690 ( 1 0 ) capacitor c=0.00556102f //x=66.35 //y=2.375
r691 (  242 243 ) resistor r=52.7279 //w=0.214 //l=0.165 //layer=ply \
 //thickness=0.18 //x=85.59 //y=2.26 //x2=85.59 //y2=2.095
r692 (  232 233 ) resistor r=52.7279 //w=0.214 //l=0.165 //layer=ply \
 //thickness=0.18 //x=71.16 //y=2.26 //x2=71.16 //y2=2.095
r693 (  222 223 ) resistor r=52.7279 //w=0.214 //l=0.165 //layer=ply \
 //thickness=0.18 //x=66.35 //y=2.26 //x2=66.35 //y2=2.095
r694 (  220 250 ) resistor r=45.1352 //w=0.168 //l=0.173853 //layer=ply \
 //thickness=0.18 //x=86.11 //y=1.44 //x2=86.07 //y2=1.595
r695 (  219 249 ) resistor r=45.1352 //w=0.168 //l=0.173853 //layer=ply \
 //thickness=0.18 //x=86.11 //y=1.095 //x2=86.07 //y2=0.94
r696 (  219 220 ) resistor r=176.904 //w=0.094 //l=0.345 //layer=ply \
 //thickness=0.18 //x=86.11 //y=1.095 //x2=86.11 //y2=1.44
r697 (  217 246 ) resistor r=10.701 //w=0.21 //l=0.115 //layer=ply \
 //thickness=0.18 //x=85.735 //y=1.595 //x2=85.62 //y2=1.595
r698 (  216 250 ) resistor r=5.52526 //w=0.168 //l=0.115 //layer=ply \
 //thickness=0.18 //x=85.955 //y=1.595 //x2=86.07 //y2=1.595
r699 (  215 245 ) resistor r=5.52526 //w=0.168 //l=0.115 //layer=ply \
 //thickness=0.18 //x=85.735 //y=0.94 //x2=85.62 //y2=0.94
r700 (  214 249 ) resistor r=5.52526 //w=0.168 //l=0.115 //layer=ply \
 //thickness=0.18 //x=85.955 //y=0.94 //x2=86.07 //y2=0.94
r701 (  214 215 ) resistor r=112.809 //w=0.094 //l=0.22 //layer=ply \
 //thickness=0.18 //x=85.955 //y=0.94 //x2=85.735 //y2=0.94
r702 (  211 248 ) resistor r=37.236 //w=0.233 //l=0.249199 //layer=ply \
 //thickness=0.18 //x=85.77 //y=5.045 //x2=85.59 //y2=4.88
r703 (  209 246 ) resistor r=39.5823 //w=0.21 //l=0.173853 //layer=ply \
 //thickness=0.18 //x=85.58 //y=1.75 //x2=85.62 //y2=1.595
r704 (  209 243 ) resistor r=176.904 //w=0.094 //l=0.345 //layer=ply \
 //thickness=0.18 //x=85.58 //y=1.75 //x2=85.58 //y2=2.095
r705 (  208 246 ) resistor r=39.5823 //w=0.21 //l=0.173853 //layer=ply \
 //thickness=0.18 //x=85.58 //y=1.44 //x2=85.62 //y2=1.595
r706 (  207 245 ) resistor r=45.1352 //w=0.168 //l=0.173853 //layer=ply \
 //thickness=0.18 //x=85.58 //y=1.095 //x2=85.62 //y2=0.94
r707 (  207 208 ) resistor r=176.904 //w=0.094 //l=0.345 //layer=ply \
 //thickness=0.18 //x=85.58 //y=1.095 //x2=85.58 //y2=1.44
r708 (  204 248 ) resistor r=53.7854 //w=0.233 //l=0.332415 //layer=ply \
 //thickness=0.18 //x=85.33 //y=5.045 //x2=85.59 //y2=4.88
r709 (  203 240 ) resistor r=45.1352 //w=0.168 //l=0.173853 //layer=ply \
 //thickness=0.18 //x=71.68 //y=1.44 //x2=71.64 //y2=1.595
r710 (  202 239 ) resistor r=45.1352 //w=0.168 //l=0.173853 //layer=ply \
 //thickness=0.18 //x=71.68 //y=1.095 //x2=71.64 //y2=0.94
r711 (  202 203 ) resistor r=176.904 //w=0.094 //l=0.345 //layer=ply \
 //thickness=0.18 //x=71.68 //y=1.095 //x2=71.68 //y2=1.44
r712 (  200 236 ) resistor r=10.701 //w=0.21 //l=0.115 //layer=ply \
 //thickness=0.18 //x=71.305 //y=1.595 //x2=71.19 //y2=1.595
r713 (  199 240 ) resistor r=5.52526 //w=0.168 //l=0.115 //layer=ply \
 //thickness=0.18 //x=71.525 //y=1.595 //x2=71.64 //y2=1.595
r714 (  198 235 ) resistor r=5.52526 //w=0.168 //l=0.115 //layer=ply \
 //thickness=0.18 //x=71.305 //y=0.94 //x2=71.19 //y2=0.94
r715 (  197 239 ) resistor r=5.52526 //w=0.168 //l=0.115 //layer=ply \
 //thickness=0.18 //x=71.525 //y=0.94 //x2=71.64 //y2=0.94
r716 (  197 198 ) resistor r=112.809 //w=0.094 //l=0.22 //layer=ply \
 //thickness=0.18 //x=71.525 //y=0.94 //x2=71.305 //y2=0.94
r717 (  194 238 ) resistor r=37.236 //w=0.233 //l=0.249199 //layer=ply \
 //thickness=0.18 //x=71.34 //y=5.045 //x2=71.16 //y2=4.88
r718 (  192 236 ) resistor r=39.5823 //w=0.21 //l=0.173853 //layer=ply \
 //thickness=0.18 //x=71.15 //y=1.75 //x2=71.19 //y2=1.595
r719 (  192 233 ) resistor r=176.904 //w=0.094 //l=0.345 //layer=ply \
 //thickness=0.18 //x=71.15 //y=1.75 //x2=71.15 //y2=2.095
r720 (  191 236 ) resistor r=39.5823 //w=0.21 //l=0.173853 //layer=ply \
 //thickness=0.18 //x=71.15 //y=1.44 //x2=71.19 //y2=1.595
r721 (  190 235 ) resistor r=45.1352 //w=0.168 //l=0.173853 //layer=ply \
 //thickness=0.18 //x=71.15 //y=1.095 //x2=71.19 //y2=0.94
r722 (  190 191 ) resistor r=176.904 //w=0.094 //l=0.345 //layer=ply \
 //thickness=0.18 //x=71.15 //y=1.095 //x2=71.15 //y2=1.44
r723 (  187 238 ) resistor r=53.7854 //w=0.233 //l=0.332415 //layer=ply \
 //thickness=0.18 //x=70.9 //y=5.045 //x2=71.16 //y2=4.88
r724 (  186 230 ) resistor r=45.1352 //w=0.168 //l=0.173853 //layer=ply \
 //thickness=0.18 //x=66.87 //y=1.44 //x2=66.83 //y2=1.595
r725 (  185 229 ) resistor r=45.1352 //w=0.168 //l=0.173853 //layer=ply \
 //thickness=0.18 //x=66.87 //y=1.095 //x2=66.83 //y2=0.94
r726 (  185 186 ) resistor r=176.904 //w=0.094 //l=0.345 //layer=ply \
 //thickness=0.18 //x=66.87 //y=1.095 //x2=66.87 //y2=1.44
r727 (  183 226 ) resistor r=10.701 //w=0.21 //l=0.115 //layer=ply \
 //thickness=0.18 //x=66.495 //y=1.595 //x2=66.38 //y2=1.595
r728 (  182 230 ) resistor r=5.52526 //w=0.168 //l=0.115 //layer=ply \
 //thickness=0.18 //x=66.715 //y=1.595 //x2=66.83 //y2=1.595
r729 (  181 225 ) resistor r=5.52526 //w=0.168 //l=0.115 //layer=ply \
 //thickness=0.18 //x=66.495 //y=0.94 //x2=66.38 //y2=0.94
r730 (  180 229 ) resistor r=5.52526 //w=0.168 //l=0.115 //layer=ply \
 //thickness=0.18 //x=66.715 //y=0.94 //x2=66.83 //y2=0.94
r731 (  180 181 ) resistor r=112.809 //w=0.094 //l=0.22 //layer=ply \
 //thickness=0.18 //x=66.715 //y=0.94 //x2=66.495 //y2=0.94
r732 (  177 228 ) resistor r=37.236 //w=0.233 //l=0.249199 //layer=ply \
 //thickness=0.18 //x=66.53 //y=5.045 //x2=66.35 //y2=4.88
r733 (  175 226 ) resistor r=39.5823 //w=0.21 //l=0.173853 //layer=ply \
 //thickness=0.18 //x=66.34 //y=1.75 //x2=66.38 //y2=1.595
r734 (  175 223 ) resistor r=176.904 //w=0.094 //l=0.345 //layer=ply \
 //thickness=0.18 //x=66.34 //y=1.75 //x2=66.34 //y2=2.095
r735 (  174 226 ) resistor r=39.5823 //w=0.21 //l=0.173853 //layer=ply \
 //thickness=0.18 //x=66.34 //y=1.44 //x2=66.38 //y2=1.595
r736 (  173 225 ) resistor r=45.1352 //w=0.168 //l=0.173853 //layer=ply \
 //thickness=0.18 //x=66.34 //y=1.095 //x2=66.38 //y2=0.94
r737 (  173 174 ) resistor r=176.904 //w=0.094 //l=0.345 //layer=ply \
 //thickness=0.18 //x=66.34 //y=1.095 //x2=66.34 //y2=1.44
r738 (  170 228 ) resistor r=53.7854 //w=0.233 //l=0.332415 //layer=ply \
 //thickness=0.18 //x=66.09 //y=5.045 //x2=66.35 //y2=4.88
r739 (  169 211 ) resistor r=592.245 //w=0.094 //l=1.155 //layer=ply \
 //thickness=0.18 //x=85.77 //y=6.2 //x2=85.77 //y2=5.045
r740 (  168 204 ) resistor r=592.245 //w=0.094 //l=1.155 //layer=ply \
 //thickness=0.18 //x=85.33 //y=6.2 //x2=85.33 //y2=5.045
r741 (  167 194 ) resistor r=592.245 //w=0.094 //l=1.155 //layer=ply \
 //thickness=0.18 //x=71.34 //y=6.2 //x2=71.34 //y2=5.045
r742 (  166 187 ) resistor r=592.245 //w=0.094 //l=1.155 //layer=ply \
 //thickness=0.18 //x=70.9 //y=6.2 //x2=70.9 //y2=5.045
r743 (  165 177 ) resistor r=592.245 //w=0.094 //l=1.155 //layer=ply \
 //thickness=0.18 //x=66.53 //y=6.2 //x2=66.53 //y2=5.045
r744 (  164 170 ) resistor r=592.245 //w=0.094 //l=1.155 //layer=ply \
 //thickness=0.18 //x=66.09 //y=6.2 //x2=66.09 //y2=5.045
r745 (  163 216 ) resistor r=56.4043 //w=0.094 //l=0.11 //layer=ply \
 //thickness=0.18 //x=85.845 //y=1.595 //x2=85.955 //y2=1.595
r746 (  163 217 ) resistor r=56.4043 //w=0.094 //l=0.11 //layer=ply \
 //thickness=0.18 //x=85.845 //y=1.595 //x2=85.735 //y2=1.595
r747 (  162 199 ) resistor r=56.4043 //w=0.094 //l=0.11 //layer=ply \
 //thickness=0.18 //x=71.415 //y=1.595 //x2=71.525 //y2=1.595
r748 (  162 200 ) resistor r=56.4043 //w=0.094 //l=0.11 //layer=ply \
 //thickness=0.18 //x=71.415 //y=1.595 //x2=71.305 //y2=1.595
r749 (  161 182 ) resistor r=56.4043 //w=0.094 //l=0.11 //layer=ply \
 //thickness=0.18 //x=66.605 //y=1.595 //x2=66.715 //y2=1.595
r750 (  161 183 ) resistor r=56.4043 //w=0.094 //l=0.11 //layer=ply \
 //thickness=0.18 //x=66.605 //y=1.595 //x2=66.495 //y2=1.595
r751 (  157 248 ) resistor r=152 //w=0.17 //l=0.17 //layer=licon //count=1 \
 //x=85.59 //y=4.88 //x2=85.59 //y2=4.88
r752 (  148 242 ) resistor r=152 //w=0.17 //l=0.17 //layer=licon //count=1 \
 //x=85.59 //y=2.26 //x2=85.59 //y2=2.26
r753 (  131 255 ) resistor r=23.615 //w=0.187 //l=0.345 //layer=li \
 //thickness=0.1 //x=75.93 //y=5.56 //x2=75.93 //y2=5.905
r754 (  123 254 ) resistor r=23.615 //w=0.187 //l=0.345 //layer=li \
 //thickness=0.1 //x=75.05 //y=5.56 //x2=75.05 //y2=5.905
r755 (  115 253 ) resistor r=23.615 //w=0.187 //l=0.345 //layer=li \
 //thickness=0.1 //x=74.17 //y=5.56 //x2=74.17 //y2=5.905
r756 (  110 238 ) resistor r=152 //w=0.17 //l=0.17 //layer=licon //count=1 \
 //x=71.16 //y=4.88 //x2=71.16 //y2=4.88
r757 (  101 232 ) resistor r=152 //w=0.17 //l=0.17 //layer=licon //count=1 \
 //x=71.16 //y=2.26 //x2=71.16 //y2=2.26
r758 (  96 228 ) resistor r=152 //w=0.17 //l=0.17 //layer=licon //count=1 \
 //x=66.35 //y=4.88 //x2=66.35 //y2=4.88
r759 (  87 222 ) resistor r=152 //w=0.17 //l=0.17 //layer=licon //count=1 \
 //x=66.35 //y=2.26 //x2=66.35 //y2=2.26
r760 (  79 81 ) resistor r=0.10734 //w=0.281 //l=0.16 //layer=m2 \
 //thickness=0.36 //x=71.16 //y=3.895 //x2=71.32 //y2=3.895
r761 (  79 80 ) resistor r=0.10734 //w=0.281 //l=0.16 //layer=m2 \
 //thickness=0.36 //x=71.16 //y=3.895 //x2=71 //y2=3.895
r762 (  77 80 ) resistor r=4.28435 //w=0.131 //l=4.49 //layer=m2 \
 //thickness=0.36 //x=66.51 //y=3.88 //x2=71 //y2=3.88
r763 (  75 77 ) resistor r=0.10734 //w=0.281 //l=0.16 //layer=m2 \
 //thickness=0.36 //x=66.35 //y=3.895 //x2=66.51 //y2=3.895
r764 (  73 83 ) resistor r=1.10266 //w=0.196 //l=1.725 //layer=m2 \
 //thickness=0.36 //x=78.425 //y=3.895 //x2=76.7 //y2=3.895
r765 (  72 85 ) resistor r=4.81638 //w=0.177 //l=6.825 //layer=m2 \
 //thickness=0.36 //x=78.77 //y=3.895 //x2=85.59 //y2=3.885
r766 (  72 73 ) resistor r=0.329198 //w=0.131 //l=0.345 //layer=m2 \
 //thickness=0.36 //x=78.77 //y=3.895 //x2=78.425 //y2=3.895
r767 (  70 83 ) resistor r=0.104578 //w=0.196 //l=0.167332 //layer=m2 \
 //thickness=0.36 //x=76.54 //y=3.88 //x2=76.7 //y2=3.895
r768 (  70 81 ) resistor r=4.98092 //w=0.131 //l=5.22 //layer=m2 \
 //thickness=0.36 //x=76.54 //y=3.88 //x2=71.32 //y2=3.88
r769 (  67 157 ) resistor r=9.3 //w=0.17 //l=0.17 //layer=mcon //count=1 \
 //x=85.59 //y=4.88 //x2=85.59 //y2=4.88
r770 (  65 148 ) resistor r=9.3 //w=0.17 //l=0.17 //layer=mcon //count=1 \
 //x=85.59 //y=2.26 //x2=85.59 //y2=2.26
r771 (  63 85 ) resistor r=4.5 //w=0.15 //l=0.15 //layer=via1 //count=1 \
 //x=85.59 //y=3.885 //x2=85.59 //y2=3.885
r772 (  61 63 ) resistor r=0.00166223 //w=0.376 //l=0.005 //layer=m1 \
 //thickness=0.36 //x=85.537 //y=3.88 //x2=85.537 //y2=3.885
r773 (  59 83 ) resistor r=4.5 //w=0.15 //l=0.15 //layer=via1 //count=1 \
 //x=76.7 //y=3.895 //x2=76.7 //y2=3.895
r774 (  57 59 ) resistor r=0.00490838 //w=0.382 //l=0.015 //layer=m1 \
 //thickness=0.36 //x=76.757 //y=3.88 //x2=76.757 //y2=3.895
r775 (  55 251 ) resistor r=9.3 //w=0.17 //l=0.17 //layer=mcon //count=1 \
 //x=76.225 //y=1.19 //x2=76.225 //y2=1.19
r776 (  53 131 ) resistor r=9.3 //w=0.17 //l=0.17 //layer=mcon //count=1 \
 //x=75.93 //y=5.56 //x2=75.93 //y2=5.56
r777 (  50 123 ) resistor r=9.3 //w=0.17 //l=0.17 //layer=mcon //count=1 \
 //x=75.05 //y=5.56 //x2=75.05 //y2=5.56
r778 (  48 50 ) resistor r=0.121228 //w=0.232 //l=0.225 //layer=m1 \
 //thickness=0.36 //x=75.05 //y=5.335 //x2=75.05 //y2=5.56
r779 (  47 115 ) resistor r=9.3 //w=0.17 //l=0.17 //layer=mcon //count=1 \
 //x=74.17 //y=5.56 //x2=74.17 //y2=5.56
r780 (  45 47 ) resistor r=0.129608 //w=0.217 //l=0.225 //layer=m1 \
 //thickness=0.36 //x=74.172 //y=5.335 //x2=74.172 //y2=5.56
r781 (  44 110 ) resistor r=9.3 //w=0.17 //l=0.17 //layer=mcon //count=1 \
 //x=71.16 //y=4.88 //x2=71.16 //y2=4.88
r782 (  42 101 ) resistor r=9.3 //w=0.17 //l=0.17 //layer=mcon //count=1 \
 //x=71.16 //y=2.26 //x2=71.16 //y2=2.26
r783 (  40 79 ) resistor r=4.5 //w=0.15 //l=0.15 //layer=via1 //count=1 \
 //x=71.16 //y=3.895 //x2=71.16 //y2=3.895
r784 (  38 40 ) resistor r=0.0049867 //w=0.376 //l=0.015 //layer=m1 \
 //thickness=0.36 //x=71.107 //y=3.88 //x2=71.107 //y2=3.895
r785 (  36 75 ) resistor r=4.5 //w=0.15 //l=0.15 //layer=via1 //count=1 \
 //x=66.35 //y=3.895 //x2=66.35 //y2=3.895
r786 (  34 36 ) resistor r=0.0049867 //w=0.376 //l=0.015 //layer=m1 \
 //thickness=0.36 //x=66.402 //y=3.88 //x2=66.402 //y2=3.895
r787 (  32 96 ) resistor r=9.3 //w=0.17 //l=0.17 //layer=mcon //count=1 \
 //x=66.35 //y=4.88 //x2=66.35 //y2=4.88
r788 (  30 87 ) resistor r=9.3 //w=0.17 //l=0.17 //layer=mcon //count=1 \
 //x=66.35 //y=2.26 //x2=66.35 //y2=2.26
r789 (  28 67 ) resistor r=0.0801089 //w=0.224 //l=0.13 //layer=m1 \
 //thickness=0.36 //x=85.59 //y=4.75 //x2=85.59 //y2=4.88
r790 (  27 63 ) resistor r=0.0911593 //w=0.376 //l=0.184608 //layer=m1 \
 //thickness=0.36 //x=85.59 //y=4.045 //x2=85.537 //y2=3.885
r791 (  27 28 ) resistor r=0.67271 //w=0.131 //l=0.705 //layer=m1 \
 //thickness=0.36 //x=85.59 //y=4.045 //x2=85.59 //y2=4.75
r792 (  26 61 ) resistor r=0.0894971 //w=0.376 //l=0.179555 //layer=m1 \
 //thickness=0.36 //x=85.59 //y=3.725 //x2=85.537 //y2=3.88
r793 (  25 65 ) resistor r=0.0719237 //w=0.222 //l=0.115 //layer=m1 \
 //thickness=0.36 //x=85.59 //y=2.375 //x2=85.59 //y2=2.26
r794 (  25 26 ) resistor r=1.28817 //w=0.131 //l=1.35 //layer=m1 \
 //thickness=0.36 //x=85.59 //y=2.375 //x2=85.59 //y2=3.725
r795 (  23 59 ) resistor r=0.0914072 //w=0.382 //l=0.181989 //layer=m1 \
 //thickness=0.36 //x=76.71 //y=4.055 //x2=76.757 //y2=3.895
r796 (  23 24 ) resistor r=1.14027 //w=0.131 //l=1.195 //layer=m1 \
 //thickness=0.36 //x=76.71 //y=4.055 //x2=76.71 //y2=5.25
r797 (  22 57 ) resistor r=0.0864989 //w=0.382 //l=0.166853 //layer=m1 \
 //thickness=0.36 //x=76.71 //y=3.735 //x2=76.757 //y2=3.88
r798 (  21 22 ) resistor r=1.72233 //w=0.131 //l=1.805 //layer=m1 \
 //thickness=0.36 //x=76.71 //y=1.93 //x2=76.71 //y2=3.735
r799 (  19 21 ) resistor r=0.0698411 //w=0.17 //l=0.120208 //layer=m1 \
 //thickness=0.36 //x=76.625 //y=1.845 //x2=76.71 //y2=1.93
r800 (  19 20 ) resistor r=0.300573 //w=0.131 //l=0.315 //layer=m1 \
 //thickness=0.36 //x=76.625 //y=1.845 //x2=76.31 //y2=1.845
r801 (  18 20 ) resistor r=0.0698411 //w=0.17 //l=0.120208 //layer=m1 \
 //thickness=0.36 //x=76.225 //y=1.76 //x2=76.31 //y2=1.845
r802 (  17 55 ) resistor r=0.0717383 //w=0.224 //l=0.115 //layer=m1 \
 //thickness=0.36 //x=76.225 //y=1.305 //x2=76.225 //y2=1.19
r803 (  17 18 ) resistor r=0.43416 //w=0.131 //l=0.455 //layer=m1 \
 //thickness=0.36 //x=76.225 //y=1.305 //x2=76.225 //y2=1.76
r804 (  16 51 ) resistor r=0.0675342 //w=0.23 //l=0.115 //layer=m1 \
 //thickness=0.36 //x=76.045 //y=5.335 //x2=75.93 //y2=5.335
r805 (  15 24 ) resistor r=0.0698411 //w=0.17 //l=0.120208 //layer=m1 \
 //thickness=0.36 //x=76.625 //y=5.335 //x2=76.71 //y2=5.25
r806 (  15 16 ) resistor r=0.553435 //w=0.131 //l=0.58 //layer=m1 \
 //thickness=0.36 //x=76.625 //y=5.335 //x2=76.045 //y2=5.335
r807 (  14 53 ) resistor r=0.00118313 //w=0.23 //layer=m1 //thickness=0.36 \
 //x=75.93 //y=5.56 //x2=75.93 //y2=5.56
r808 (  13 51 ) resistor r=0.002872 //w=0.34 //l=0.085 //layer=m1 \
 //thickness=0.36 //x=75.93 //y=5.42 //x2=75.93 //y2=5.335
r809 (  13 14 ) resistor r=0.091623 //w=0.191 //l=0.14 //layer=m1 \
 //thickness=0.36 //x=75.93 //y=5.42 //x2=75.93 //y2=5.56
r810 (  12 48 ) resistor r=0.0262263 //w=0.232 //l=0.12 //layer=m1 \
 //thickness=0.36 //x=75.17 //y=5.335 //x2=75.05 //y2=5.335
r811 (  11 51 ) resistor r=0.0675342 //w=0.23 //l=0.115 //layer=m1 \
 //thickness=0.36 //x=75.815 //y=5.335 //x2=75.93 //y2=5.335
r812 (  11 12 ) resistor r=0.615458 //w=0.131 //l=0.645 //layer=m1 \
 //thickness=0.36 //x=75.815 //y=5.335 //x2=75.17 //y2=5.335
r813 (  10 45 ) resistor r=0.0222262 //w=0.217 //l=0.118 //layer=m1 \
 //thickness=0.36 //x=74.29 //y=5.335 //x2=74.172 //y2=5.335
r814 (  9 48 ) resistor r=0.0262263 //w=0.232 //l=0.12 //layer=m1 \
 //thickness=0.36 //x=74.93 //y=5.335 //x2=75.05 //y2=5.335
r815 (  9 10 ) resistor r=0.610687 //w=0.131 //l=0.64 //layer=m1 \
 //thickness=0.36 //x=74.93 //y=5.335 //x2=74.29 //y2=5.335
r816 (  8 44 ) resistor r=0.0801089 //w=0.224 //l=0.13 //layer=m1 \
 //thickness=0.36 //x=71.16 //y=4.75 //x2=71.16 //y2=4.88
r817 (  7 40 ) resistor r=0.0911593 //w=0.376 //l=0.184608 //layer=m1 \
 //thickness=0.36 //x=71.16 //y=4.055 //x2=71.107 //y2=3.895
r818 (  7 8 ) resistor r=0.663168 //w=0.131 //l=0.695 //layer=m1 \
 //thickness=0.36 //x=71.16 //y=4.055 //x2=71.16 //y2=4.75
r819 (  6 38 ) resistor r=0.0861726 //w=0.376 //l=0.16944 //layer=m1 \
 //thickness=0.36 //x=71.16 //y=3.735 //x2=71.107 //y2=3.88
r820 (  5 42 ) resistor r=0.0719237 //w=0.222 //l=0.115 //layer=m1 \
 //thickness=0.36 //x=71.16 //y=2.375 //x2=71.16 //y2=2.26
r821 (  5 6 ) resistor r=1.29771 //w=0.131 //l=1.36 //layer=m1 \
 //thickness=0.36 //x=71.16 //y=2.375 //x2=71.16 //y2=3.735
r822 (  4 32 ) resistor r=0.0801089 //w=0.224 //l=0.13 //layer=m1 \
 //thickness=0.36 //x=66.35 //y=4.75 //x2=66.35 //y2=4.88
r823 (  3 36 ) resistor r=0.0911593 //w=0.376 //l=0.184174 //layer=m1 \
 //thickness=0.36 //x=66.35 //y=4.055 //x2=66.402 //y2=3.895
r824 (  3 4 ) resistor r=0.663168 //w=0.131 //l=0.695 //layer=m1 \
 //thickness=0.36 //x=66.35 //y=4.055 //x2=66.35 //y2=4.75
r825 (  2 34 ) resistor r=0.0861726 //w=0.376 //l=0.169012 //layer=m1 \
 //thickness=0.36 //x=66.35 //y=3.735 //x2=66.402 //y2=3.88
r826 (  1 30 ) resistor r=0.0719237 //w=0.222 //l=0.115 //layer=m1 \
 //thickness=0.36 //x=66.35 //y=2.375 //x2=66.35 //y2=2.26
r827 (  1 2 ) resistor r=1.29771 //w=0.131 //l=1.36 //layer=m1 \
 //thickness=0.36 //x=66.35 //y=2.375 //x2=66.35 //y2=3.735
ends PM_TMRDFFSNRNQX1\%noxref_20

subckt PM_TMRDFFSNRNQX1\%noxref_21 ( 1 2 3 5 8 9 11 12 13 14 16 17 18 19 20 21 \
 22 29 32 35 41 56 58 60 62 64 65 67 69 78 79 82 87 92 100 108 125 130 135 140 \
 144 145 146 147 148 149 150 151 152 156 157 158 163 165 168 169 173 174 175 \
 176 177 179 182 185 186 187 188 189 190 191 192 196 198 201 202 203 204 209 \
 210 215 227 234 236 237 238 )
c595 ( 234 0 ) capacitor c=0.00885916f //x=85.655 //y=1.095
c596 ( 227 0 ) capacitor c=0.0586737f //x=94.47 //y=2.26
c597 ( 215 0 ) capacitor c=0.0710579f //x=80.78 //y=4.88
c598 ( 210 0 ) capacitor c=0.0278202f //x=80.78 //y=2.095
c599 ( 209 0 ) capacitor c=0.0493352f //x=80.78 //y=2.26
c600 ( 204 0 ) capacitor c=0.0318956f //x=95.175 //y=1.39
c601 ( 203 0 ) capacitor c=0.0186809f //x=95.175 //y=1.045
c602 ( 202 0 ) capacitor c=0.0659968f //x=94.815 //y=4.975
c603 ( 201 0 ) capacitor c=0.0373387f //x=95.105 //y=4.975
c604 ( 198 0 ) capacitor c=0.0157936f //x=95.02 //y=1.545
c605 ( 196 0 ) capacitor c=0.0158553f //x=95.02 //y=0.89
c606 ( 192 0 ) capacitor c=0.0302441f //x=94.645 //y=2.095
c607 ( 191 0 ) capacitor c=0.0238107f //x=94.645 //y=1.7
c608 ( 190 0 ) capacitor c=0.0234359f //x=94.645 //y=1.39
c609 ( 189 0 ) capacitor c=0.0199332f //x=94.645 //y=1.045
c610 ( 188 0 ) capacitor c=0.0972519f //x=92.815 //y=2.095
c611 ( 187 0 ) capacitor c=0.0251353f //x=92.815 //y=1.74
c612 ( 186 0 ) capacitor c=0.0234318f //x=92.815 //y=1.43
c613 ( 185 0 ) capacitor c=0.019155f //x=92.815 //y=1.085
c614 ( 182 0 ) capacitor c=0.0714656f //x=92.72 //y=5.05
c615 ( 179 0 ) capacitor c=0.0186579f //x=92.66 //y=1.585
c616 ( 177 0 ) capacitor c=0.0157803f //x=92.66 //y=0.93
c617 ( 176 0 ) capacitor c=0.0134011f //x=92.355 //y=4.975
c618 ( 175 0 ) capacitor c=0.0243282f //x=92.645 //y=4.975
c619 ( 174 0 ) capacitor c=0.0364928f //x=92.285 //y=1.43
c620 ( 173 0 ) capacitor c=0.0174823f //x=92.285 //y=1.085
c621 ( 169 0 ) capacitor c=0.0443175f //x=81.3 //y=1.44
c622 ( 168 0 ) capacitor c=0.0199703f //x=81.3 //y=1.095
c623 ( 165 0 ) capacitor c=0.0159602f //x=81.145 //y=1.595
c624 ( 163 0 ) capacitor c=0.0157807f //x=81.145 //y=0.94
c625 ( 158 0 ) capacitor c=0.0220935f //x=80.77 //y=1.75
c626 ( 157 0 ) capacitor c=0.0207489f //x=80.77 //y=1.44
c627 ( 156 0 ) capacitor c=0.0194091f //x=80.77 //y=1.095
c628 ( 152 0 ) capacitor c=0.11081f //x=95.18 //y=6.205
c629 ( 151 0 ) capacitor c=0.154997f //x=94.74 //y=6.205
c630 ( 150 0 ) capacitor c=0.155934f //x=92.72 //y=6.205
c631 ( 149 0 ) capacitor c=0.110593f //x=92.28 //y=6.205
c632 ( 148 0 ) capacitor c=0.159671f //x=80.96 //y=6.2
c633 ( 147 0 ) capacitor c=0.110208f //x=80.52 //y=6.2
c634 ( 140 0 ) capacitor c=7.7962e-19 //x=94.47 //y=4.885
c635 ( 135 0 ) capacitor c=7.43216e-19 //x=94.47 //y=2.26
c636 ( 130 0 ) capacitor c=7.79163e-19 //x=92.99 //y=4.885
c637 ( 125 0 ) capacitor c=7.43216e-19 //x=92.99 //y=2.26
c638 ( 108 0 ) capacitor c=0.0292914f //x=85.55 //y=5.56
c639 ( 100 0 ) capacitor c=0.0292489f //x=84.67 //y=5.56
c640 ( 92 0 ) capacitor c=0.0278099f //x=83.79 //y=5.56
c641 ( 87 0 ) capacitor c=7.7417e-19 //x=80.78 //y=4.88
c642 ( 82 0 ) capacitor c=0.00101179f //x=80.78 //y=2.26
c643 ( 79 0 ) capacitor c=0.0208859f //x=94.305 //y=2.27
c644 ( 78 0 ) capacitor c=0.00246433f //x=94.465 //y=2.27
c645 ( 69 0 ) capacitor c=0.00668954f //x=80.77 //y=2.325
c646 ( 67 0 ) capacitor c=0.00638151f //x=93.155 //y=2.26
c647 ( 65 0 ) capacitor c=0.075492f //x=86.485 //y=2.4
c648 ( 64 0 ) capacitor c=0.168148f //x=92.825 //y=2.4
c649 ( 62 0 ) capacitor c=0.00882412f //x=83.58 //y=2.37
c650 ( 60 0 ) capacitor c=0.0265244f //x=82.98 //y=2.4
c651 ( 58 0 ) capacitor c=0.014689f //x=81.735 //y=2.37
c652 ( 56 0 ) capacitor c=0.00958882f //x=81.135 //y=2.4
c653 ( 41 0 ) capacitor c=0.0141963f //x=86.33 //y=2.4
c654 ( 35 0 ) capacitor c=8.84507e-19 //x=85.55 //y=5.335
c655 ( 32 0 ) capacitor c=0.00788343f //x=84.67 //y=5.335
c656 ( 29 0 ) capacitor c=0.0111234f //x=83.792 //y=5.335
c657 ( 22 0 ) capacitor c=0.0783117f //x=94.47 //y=4.755
c658 ( 21 0 ) capacitor c=0.00995077f //x=94.47 //y=2.43
c659 ( 20 0 ) capacitor c=0.0863594f //x=92.99 //y=4.76
c660 ( 19 0 ) capacitor c=0.0102822f //x=92.99 //y=2.43
c661 ( 18 0 ) capacitor c=0.0754415f //x=86.33 //y=5.25
c662 ( 17 0 ) capacitor c=0.0118637f //x=86.33 //y=2.565
c663 ( 16 0 ) capacitor c=0.0098449f //x=86.33 //y=2.245
c664 ( 14 0 ) capacitor c=0.00493487f //x=85.93 //y=1.845
c665 ( 13 0 ) capacitor c=0.0127191f //x=86.245 //y=1.845
c666 ( 12 0 ) capacitor c=0.0150416f //x=85.845 //y=1.76
c667 ( 11 0 ) capacitor c=0.0113205f //x=85.845 //y=1.305
c668 ( 9 0 ) capacitor c=0.0237317f //x=86.245 //y=5.335
c669 ( 8 0 ) capacitor c=0.00906283f //x=85.55 //y=5.56
c670 ( 5 0 ) capacitor c=0.0180822f //x=85.435 //y=5.335
c671 ( 3 0 ) capacitor c=0.0146396f //x=84.55 //y=5.335
c672 ( 2 0 ) capacitor c=0.0615417f //x=80.78 //y=4.75
c673 ( 1 0 ) capacitor c=0.011862f //x=80.78 //y=2.485
r674 (  209 210 ) resistor r=52.7279 //w=0.214 //l=0.165 //layer=ply \
 //thickness=0.18 //x=80.78 //y=2.26 //x2=80.78 //y2=2.095
r675 (  204 233 ) resistor r=45.1352 //w=0.168 //l=0.173853 //layer=ply \
 //thickness=0.18 //x=95.175 //y=1.39 //x2=95.135 //y2=1.545
r676 (  203 232 ) resistor r=45.1352 //w=0.168 //l=0.173853 //layer=ply \
 //thickness=0.18 //x=95.175 //y=1.045 //x2=95.135 //y2=0.89
r677 (  203 204 ) resistor r=176.904 //w=0.094 //l=0.345 //layer=ply \
 //thickness=0.18 //x=95.175 //y=1.045 //x2=95.175 //y2=1.39
r678 (  201 205 ) resistor r=26.9307 //w=0.15 //l=0.106066 //layer=ply \
 //thickness=0.18 //x=95.105 //y=4.975 //x2=95.18 //y2=5.05
r679 (  201 202 ) resistor r=148.702 //w=0.094 //l=0.29 //layer=ply \
 //thickness=0.18 //x=95.105 //y=4.975 //x2=94.815 //y2=4.975
r680 (  199 231 ) resistor r=10.701 //w=0.21 //l=0.115 //layer=ply \
 //thickness=0.18 //x=94.8 //y=1.545 //x2=94.685 //y2=1.545
r681 (  198 233 ) resistor r=5.52526 //w=0.168 //l=0.115 //layer=ply \
 //thickness=0.18 //x=95.02 //y=1.545 //x2=95.135 //y2=1.545
r682 (  197 230 ) resistor r=5.52526 //w=0.168 //l=0.115 //layer=ply \
 //thickness=0.18 //x=94.8 //y=0.89 //x2=94.685 //y2=0.89
r683 (  196 232 ) resistor r=5.52526 //w=0.168 //l=0.115 //layer=ply \
 //thickness=0.18 //x=95.02 //y=0.89 //x2=95.135 //y2=0.89
r684 (  196 197 ) resistor r=112.809 //w=0.094 //l=0.22 //layer=ply \
 //thickness=0.18 //x=95.02 //y=0.89 //x2=94.8 //y2=0.89
r685 (  193 202 ) resistor r=22.1787 //w=0.252 //l=0.106066 //layer=ply \
 //thickness=0.18 //x=94.74 //y=5.05 //x2=94.815 //y2=4.975
r686 (  193 229 ) resistor r=51.6429 //w=0.252 //l=0.34271 //layer=ply \
 //thickness=0.18 //x=94.74 //y=5.05 //x2=94.47 //y2=4.885
r687 (  192 227 ) resistor r=30.4513 //w=0.277 //l=0.243926 //layer=ply \
 //thickness=0.18 //x=94.645 //y=2.095 //x2=94.47 //y2=2.26
r688 (  191 231 ) resistor r=39.5823 //w=0.21 //l=0.173853 //layer=ply \
 //thickness=0.18 //x=94.645 //y=1.7 //x2=94.685 //y2=1.545
r689 (  191 192 ) resistor r=202.543 //w=0.094 //l=0.395 //layer=ply \
 //thickness=0.18 //x=94.645 //y=1.7 //x2=94.645 //y2=2.095
r690 (  190 231 ) resistor r=39.5823 //w=0.21 //l=0.173853 //layer=ply \
 //thickness=0.18 //x=94.645 //y=1.39 //x2=94.685 //y2=1.545
r691 (  189 230 ) resistor r=45.1352 //w=0.168 //l=0.173853 //layer=ply \
 //thickness=0.18 //x=94.645 //y=1.045 //x2=94.685 //y2=0.89
r692 (  189 190 ) resistor r=176.904 //w=0.094 //l=0.345 //layer=ply \
 //thickness=0.18 //x=94.645 //y=1.045 //x2=94.645 //y2=1.39
r693 (  188 223 ) resistor r=30.4513 //w=0.277 //l=0.243926 //layer=ply \
 //thickness=0.18 //x=92.815 //y=2.095 //x2=92.99 //y2=2.26
r694 (  187 221 ) resistor r=39.5823 //w=0.21 //l=0.173853 //layer=ply \
 //thickness=0.18 //x=92.815 //y=1.74 //x2=92.775 //y2=1.585
r695 (  187 188 ) resistor r=182.032 //w=0.094 //l=0.355 //layer=ply \
 //thickness=0.18 //x=92.815 //y=1.74 //x2=92.815 //y2=2.095
r696 (  186 221 ) resistor r=39.5823 //w=0.21 //l=0.173853 //layer=ply \
 //thickness=0.18 //x=92.815 //y=1.43 //x2=92.775 //y2=1.585
r697 (  185 220 ) resistor r=45.1352 //w=0.168 //l=0.173853 //layer=ply \
 //thickness=0.18 //x=92.815 //y=1.085 //x2=92.775 //y2=0.93
r698 (  185 186 ) resistor r=176.904 //w=0.094 //l=0.345 //layer=ply \
 //thickness=0.18 //x=92.815 //y=1.085 //x2=92.815 //y2=1.43
r699 (  182 225 ) resistor r=51.6429 //w=0.252 //l=0.34271 //layer=ply \
 //thickness=0.18 //x=92.72 //y=5.05 //x2=92.99 //y2=4.885
r700 (  180 219 ) resistor r=5.52526 //w=0.168 //l=0.115 //layer=ply \
 //thickness=0.18 //x=92.44 //y=1.585 //x2=92.325 //y2=1.585
r701 (  179 221 ) resistor r=10.701 //w=0.21 //l=0.115 //layer=ply \
 //thickness=0.18 //x=92.66 //y=1.585 //x2=92.775 //y2=1.585
r702 (  178 218 ) resistor r=5.52526 //w=0.168 //l=0.115 //layer=ply \
 //thickness=0.18 //x=92.44 //y=0.93 //x2=92.325 //y2=0.93
r703 (  177 220 ) resistor r=5.52526 //w=0.168 //l=0.115 //layer=ply \
 //thickness=0.18 //x=92.66 //y=0.93 //x2=92.775 //y2=0.93
r704 (  177 178 ) resistor r=112.809 //w=0.094 //l=0.22 //layer=ply \
 //thickness=0.18 //x=92.66 //y=0.93 //x2=92.44 //y2=0.93
r705 (  175 182 ) resistor r=22.1787 //w=0.252 //l=0.106066 //layer=ply \
 //thickness=0.18 //x=92.645 //y=4.975 //x2=92.72 //y2=5.05
r706 (  175 176 ) resistor r=148.702 //w=0.094 //l=0.29 //layer=ply \
 //thickness=0.18 //x=92.645 //y=4.975 //x2=92.355 //y2=4.975
r707 (  174 219 ) resistor r=45.1352 //w=0.168 //l=0.173853 //layer=ply \
 //thickness=0.18 //x=92.285 //y=1.43 //x2=92.325 //y2=1.585
r708 (  173 218 ) resistor r=45.1352 //w=0.168 //l=0.173853 //layer=ply \
 //thickness=0.18 //x=92.285 //y=1.085 //x2=92.325 //y2=0.93
r709 (  173 174 ) resistor r=176.904 //w=0.094 //l=0.345 //layer=ply \
 //thickness=0.18 //x=92.285 //y=1.085 //x2=92.285 //y2=1.43
r710 (  170 176 ) resistor r=26.9307 //w=0.15 //l=0.106066 //layer=ply \
 //thickness=0.18 //x=92.28 //y=5.05 //x2=92.355 //y2=4.975
r711 (  169 217 ) resistor r=45.1352 //w=0.168 //l=0.173853 //layer=ply \
 //thickness=0.18 //x=81.3 //y=1.44 //x2=81.26 //y2=1.595
r712 (  168 216 ) resistor r=45.1352 //w=0.168 //l=0.173853 //layer=ply \
 //thickness=0.18 //x=81.3 //y=1.095 //x2=81.26 //y2=0.94
r713 (  168 169 ) resistor r=176.904 //w=0.094 //l=0.345 //layer=ply \
 //thickness=0.18 //x=81.3 //y=1.095 //x2=81.3 //y2=1.44
r714 (  166 213 ) resistor r=10.701 //w=0.21 //l=0.115 //layer=ply \
 //thickness=0.18 //x=80.925 //y=1.595 //x2=80.81 //y2=1.595
r715 (  165 217 ) resistor r=5.52526 //w=0.168 //l=0.115 //layer=ply \
 //thickness=0.18 //x=81.145 //y=1.595 //x2=81.26 //y2=1.595
r716 (  164 212 ) resistor r=5.52526 //w=0.168 //l=0.115 //layer=ply \
 //thickness=0.18 //x=80.925 //y=0.94 //x2=80.81 //y2=0.94
r717 (  163 216 ) resistor r=5.52526 //w=0.168 //l=0.115 //layer=ply \
 //thickness=0.18 //x=81.145 //y=0.94 //x2=81.26 //y2=0.94
r718 (  163 164 ) resistor r=112.809 //w=0.094 //l=0.22 //layer=ply \
 //thickness=0.18 //x=81.145 //y=0.94 //x2=80.925 //y2=0.94
r719 (  160 215 ) resistor r=37.236 //w=0.233 //l=0.249199 //layer=ply \
 //thickness=0.18 //x=80.96 //y=5.045 //x2=80.78 //y2=4.88
r720 (  158 213 ) resistor r=39.5823 //w=0.21 //l=0.173853 //layer=ply \
 //thickness=0.18 //x=80.77 //y=1.75 //x2=80.81 //y2=1.595
r721 (  158 210 ) resistor r=176.904 //w=0.094 //l=0.345 //layer=ply \
 //thickness=0.18 //x=80.77 //y=1.75 //x2=80.77 //y2=2.095
r722 (  157 213 ) resistor r=39.5823 //w=0.21 //l=0.173853 //layer=ply \
 //thickness=0.18 //x=80.77 //y=1.44 //x2=80.81 //y2=1.595
r723 (  156 212 ) resistor r=45.1352 //w=0.168 //l=0.173853 //layer=ply \
 //thickness=0.18 //x=80.77 //y=1.095 //x2=80.81 //y2=0.94
r724 (  156 157 ) resistor r=176.904 //w=0.094 //l=0.345 //layer=ply \
 //thickness=0.18 //x=80.77 //y=1.095 //x2=80.77 //y2=1.44
r725 (  153 215 ) resistor r=53.7854 //w=0.233 //l=0.332415 //layer=ply \
 //thickness=0.18 //x=80.52 //y=5.045 //x2=80.78 //y2=4.88
r726 (  152 205 ) resistor r=592.245 //w=0.094 //l=1.155 //layer=ply \
 //thickness=0.18 //x=95.18 //y=6.205 //x2=95.18 //y2=5.05
r727 (  151 193 ) resistor r=592.245 //w=0.094 //l=1.155 //layer=ply \
 //thickness=0.18 //x=94.74 //y=6.205 //x2=94.74 //y2=5.05
r728 (  150 182 ) resistor r=592.245 //w=0.094 //l=1.155 //layer=ply \
 //thickness=0.18 //x=92.72 //y=6.205 //x2=92.72 //y2=5.05
r729 (  149 170 ) resistor r=592.245 //w=0.094 //l=1.155 //layer=ply \
 //thickness=0.18 //x=92.28 //y=6.205 //x2=92.28 //y2=5.05
r730 (  148 160 ) resistor r=592.245 //w=0.094 //l=1.155 //layer=ply \
 //thickness=0.18 //x=80.96 //y=6.2 //x2=80.96 //y2=5.045
r731 (  147 153 ) resistor r=592.245 //w=0.094 //l=1.155 //layer=ply \
 //thickness=0.18 //x=80.52 //y=6.2 //x2=80.52 //y2=5.045
r732 (  146 198 ) resistor r=56.4043 //w=0.094 //l=0.11 //layer=ply \
 //thickness=0.18 //x=94.91 //y=1.545 //x2=95.02 //y2=1.545
r733 (  146 199 ) resistor r=56.4043 //w=0.094 //l=0.11 //layer=ply \
 //thickness=0.18 //x=94.91 //y=1.545 //x2=94.8 //y2=1.545
r734 (  145 179 ) resistor r=56.4043 //w=0.094 //l=0.11 //layer=ply \
 //thickness=0.18 //x=92.55 //y=1.585 //x2=92.66 //y2=1.585
r735 (  145 180 ) resistor r=56.4043 //w=0.094 //l=0.11 //layer=ply \
 //thickness=0.18 //x=92.55 //y=1.585 //x2=92.44 //y2=1.585
r736 (  144 165 ) resistor r=56.4043 //w=0.094 //l=0.11 //layer=ply \
 //thickness=0.18 //x=81.035 //y=1.595 //x2=81.145 //y2=1.595
r737 (  144 166 ) resistor r=56.4043 //w=0.094 //l=0.11 //layer=ply \
 //thickness=0.18 //x=81.035 //y=1.595 //x2=80.925 //y2=1.595
r738 (  140 229 ) resistor r=152 //w=0.17 //l=0.17 //layer=licon //count=1 \
 //x=94.47 //y=4.885 //x2=94.47 //y2=4.885
r739 (  135 227 ) resistor r=152 //w=0.17 //l=0.17 //layer=licon //count=1 \
 //x=94.47 //y=2.26 //x2=94.47 //y2=2.26
r740 (  130 225 ) resistor r=152 //w=0.17 //l=0.17 //layer=licon //count=1 \
 //x=92.99 //y=4.885 //x2=92.99 //y2=4.885
r741 (  125 223 ) resistor r=152 //w=0.17 //l=0.17 //layer=licon //count=1 \
 //x=92.99 //y=2.26 //x2=92.99 //y2=2.26
r742 (  108 238 ) resistor r=23.615 //w=0.187 //l=0.345 //layer=li \
 //thickness=0.1 //x=85.55 //y=5.56 //x2=85.55 //y2=5.905
r743 (  100 237 ) resistor r=23.615 //w=0.187 //l=0.345 //layer=li \
 //thickness=0.1 //x=84.67 //y=5.56 //x2=84.67 //y2=5.905
r744 (  92 236 ) resistor r=23.615 //w=0.187 //l=0.345 //layer=li \
 //thickness=0.1 //x=83.79 //y=5.56 //x2=83.79 //y2=5.905
r745 (  87 215 ) resistor r=152 //w=0.17 //l=0.17 //layer=licon //count=1 \
 //x=80.78 //y=4.88 //x2=80.78 //y2=4.88
r746 (  82 209 ) resistor r=152 //w=0.17 //l=0.17 //layer=licon //count=1 \
 //x=80.78 //y=2.26 //x2=80.78 //y2=2.26
r747 (  78 79 ) resistor r=0.10734 //w=0.281 //l=0.16 //layer=m2 \
 //thickness=0.36 //x=94.465 //y=2.27 //x2=94.305 //y2=2.27
r748 (  69 71 ) resistor r=0.033363 //w=0.281 //l=0.075 //layer=m2 \
 //thickness=0.36 //x=80.77 //y=2.325 //x2=80.77 //y2=2.4
r749 (  67 76 ) resistor r=0.0906114 //w=0.361 //l=0.177539 //layer=m2 \
 //thickness=0.36 //x=93.155 //y=2.26 //x2=92.995 //y2=2.297
r750 (  67 79 ) resistor r=1.09733 //w=0.131 //l=1.15 //layer=m2 \
 //thickness=0.36 //x=93.155 //y=2.26 //x2=94.305 //y2=2.26
r751 (  65 74 ) resistor r=0.108234 //w=0.187 //l=0.162481 //layer=m2 \
 //thickness=0.36 //x=86.485 //y=2.4 //x2=86.325 //y2=2.405
r752 (  64 76 ) resistor r=0.094074 //w=0.361 //l=0.21543 //layer=m2 \
 //thickness=0.36 //x=92.825 //y=2.4 //x2=92.995 //y2=2.297
r753 (  64 65 ) resistor r=6.04962 //w=0.131 //l=6.34 //layer=m2 \
 //thickness=0.36 //x=92.825 //y=2.4 //x2=86.485 //y2=2.4
r754 (  62 74 ) resistor r=1.83617 //w=0.187 //l=2.76244 //layer=m2 \
 //thickness=0.36 //x=83.58 //y=2.37 //x2=86.325 //y2=2.405
r755 (  62 63 ) resistor r=0.410305 //w=0.131 //l=0.43 //layer=m2 \
 //thickness=0.36 //x=83.58 //y=2.37 //x2=83.15 //y2=2.37
r756 (  60 63 ) resistor r=0.125 //w=0.17 //l=0.184391 //layer=m2 \
 //thickness=0.36 //x=82.98 //y=2.4 //x2=83.15 //y2=2.37
r757 (  60 61 ) resistor r=0.944656 //w=0.131 //l=0.99 //layer=m2 \
 //thickness=0.36 //x=82.98 //y=2.4 //x2=81.99 //y2=2.4
r758 (  58 61 ) resistor r=0.1875 //w=0.17 //l=0.269583 //layer=m2 \
 //thickness=0.36 //x=81.735 //y=2.37 //x2=81.99 //y2=2.4
r759 (  58 59 ) resistor r=0.410305 //w=0.131 //l=0.43 //layer=m2 \
 //thickness=0.36 //x=81.735 //y=2.37 //x2=81.305 //y2=2.37
r760 (  57 71 ) resistor r=0.0455071 //w=0.32 //l=0.16 //layer=m2 \
 //thickness=0.36 //x=80.93 //y=2.4 //x2=80.77 //y2=2.4
r761 (  56 59 ) resistor r=0.125 //w=0.17 //l=0.184391 //layer=m2 \
 //thickness=0.36 //x=81.135 //y=2.4 //x2=81.305 //y2=2.37
r762 (  56 57 ) resistor r=0.195611 //w=0.131 //l=0.205 //layer=m2 \
 //thickness=0.36 //x=81.135 //y=2.4 //x2=80.93 //y2=2.4
r763 (  55 140 ) resistor r=9.3 //w=0.17 //l=0.17 //layer=mcon //count=1 \
 //x=94.47 //y=4.885 //x2=94.47 //y2=4.885
r764 (  53 78 ) resistor r=4.5 //w=0.15 //l=0.15 //layer=via1 //count=1 \
 //x=94.465 //y=2.27 //x2=94.465 //y2=2.27
r765 (  51 135 ) resistor r=9.3 //w=0.17 //l=0.17 //layer=mcon //count=1 \
 //x=94.47 //y=2.26 //x2=94.47 //y2=2.26
r766 (  51 53 ) resistor r=0.00334225 //w=0.374 //l=0.01 //layer=m1 \
 //thickness=0.36 //x=94.415 //y=2.26 //x2=94.415 //y2=2.27
r767 (  49 76 ) resistor r=4.5 //w=0.15 //l=0.15 //layer=via1 //count=1 \
 //x=92.995 //y=2.27 //x2=92.995 //y2=2.27
r768 (  47 125 ) resistor r=9.3 //w=0.17 //l=0.17 //layer=mcon //count=1 \
 //x=92.99 //y=2.26 //x2=92.99 //y2=2.26
r769 (  47 49 ) resistor r=0.00334225 //w=0.374 //l=0.01 //layer=m1 \
 //thickness=0.36 //x=93.045 //y=2.26 //x2=93.045 //y2=2.27
r770 (  45 130 ) resistor r=9.3 //w=0.17 //l=0.17 //layer=mcon //count=1 \
 //x=92.99 //y=4.885 //x2=92.99 //y2=4.885
r771 (  43 74 ) resistor r=4.5 //w=0.15 //l=0.15 //layer=via1 //count=1 \
 //x=86.325 //y=2.405 //x2=86.325 //y2=2.405
r772 (  41 43 ) resistor r=0.00167112 //w=0.374 //l=0.005 //layer=m1 \
 //thickness=0.36 //x=86.275 //y=2.4 //x2=86.275 //y2=2.405
r773 (  39 234 ) resistor r=9.3 //w=0.17 //l=0.17 //layer=mcon //count=1 \
 //x=85.845 //y=1.19 //x2=85.845 //y2=1.19
r774 (  37 108 ) resistor r=9.3 //w=0.17 //l=0.17 //layer=mcon //count=1 \
 //x=85.55 //y=5.56 //x2=85.55 //y2=5.56
r775 (  34 100 ) resistor r=9.3 //w=0.17 //l=0.17 //layer=mcon //count=1 \
 //x=84.67 //y=5.56 //x2=84.67 //y2=5.56
r776 (  32 34 ) resistor r=0.121228 //w=0.232 //l=0.225 //layer=m1 \
 //thickness=0.36 //x=84.67 //y=5.335 //x2=84.67 //y2=5.56
r777 (  31 92 ) resistor r=9.3 //w=0.17 //l=0.17 //layer=mcon //count=1 \
 //x=83.79 //y=5.56 //x2=83.79 //y2=5.56
r778 (  29 31 ) resistor r=0.129608 //w=0.217 //l=0.225 //layer=m1 \
 //thickness=0.36 //x=83.792 //y=5.335 //x2=83.792 //y2=5.56
r779 (  28 69 ) resistor r=4.5 //w=0.15 //l=0.15 //layer=via1 //count=1 \
 //x=80.77 //y=2.325 //x2=80.77 //y2=2.325
r780 (  26 82 ) resistor r=9.3 //w=0.17 //l=0.17 //layer=mcon //count=1 \
 //x=80.78 //y=2.26 //x2=80.78 //y2=2.26
r781 (  26 28 ) resistor r=0.0272651 //w=0.298 //l=0.065 //layer=m1 \
 //thickness=0.36 //x=80.77 //y=2.26 //x2=80.77 //y2=2.325
r782 (  24 87 ) resistor r=9.3 //w=0.17 //l=0.17 //layer=mcon //count=1 \
 //x=80.78 //y=4.88 //x2=80.78 //y2=4.88
r783 (  22 55 ) resistor r=0.0777782 //w=0.252 //l=0.131491 //layer=m1 \
 //thickness=0.36 //x=94.47 //y=4.755 //x2=94.467 //y2=4.885
r784 (  21 53 ) resistor r=0.0910802 //w=0.374 //l=0.185472 //layer=m1 \
 //thickness=0.36 //x=94.47 //y=2.43 //x2=94.415 //y2=2.27
r785 (  21 22 ) resistor r=2.21851 //w=0.131 //l=2.325 //layer=m1 \
 //thickness=0.36 //x=94.47 //y=2.43 //x2=94.47 //y2=4.755
r786 (  20 45 ) resistor r=0.075298 //w=0.252 //l=0.125 //layer=m1 \
 //thickness=0.36 //x=92.99 //y=4.76 //x2=92.99 //y2=4.885
r787 (  19 49 ) resistor r=0.0910802 //w=0.374 //l=0.185472 //layer=m1 \
 //thickness=0.36 //x=92.99 //y=2.43 //x2=93.045 //y2=2.27
r788 (  19 20 ) resistor r=2.22328 //w=0.131 //l=2.33 //layer=m1 \
 //thickness=0.36 //x=92.99 //y=2.43 //x2=92.99 //y2=4.76
r789 (  17 43 ) resistor r=0.0910802 //w=0.374 //l=0.185472 //layer=m1 \
 //thickness=0.36 //x=86.33 //y=2.565 //x2=86.275 //y2=2.405
r790 (  17 18 ) resistor r=2.56202 //w=0.131 //l=2.685 //layer=m1 \
 //thickness=0.36 //x=86.33 //y=2.565 //x2=86.33 //y2=5.25
r791 (  16 41 ) resistor r=0.089409 //w=0.374 //l=0.180416 //layer=m1 \
 //thickness=0.36 //x=86.33 //y=2.245 //x2=86.275 //y2=2.4
r792 (  15 16 ) resistor r=0.300573 //w=0.131 //l=0.315 //layer=m1 \
 //thickness=0.36 //x=86.33 //y=1.93 //x2=86.33 //y2=2.245
r793 (  13 15 ) resistor r=0.0698411 //w=0.17 //l=0.120208 //layer=m1 \
 //thickness=0.36 //x=86.245 //y=1.845 //x2=86.33 //y2=1.93
r794 (  13 14 ) resistor r=0.300573 //w=0.131 //l=0.315 //layer=m1 \
 //thickness=0.36 //x=86.245 //y=1.845 //x2=85.93 //y2=1.845
r795 (  12 14 ) resistor r=0.0698411 //w=0.17 //l=0.120208 //layer=m1 \
 //thickness=0.36 //x=85.845 //y=1.76 //x2=85.93 //y2=1.845
r796 (  11 39 ) resistor r=0.0717383 //w=0.224 //l=0.115 //layer=m1 \
 //thickness=0.36 //x=85.845 //y=1.305 //x2=85.845 //y2=1.19
r797 (  11 12 ) resistor r=0.43416 //w=0.131 //l=0.455 //layer=m1 \
 //thickness=0.36 //x=85.845 //y=1.305 //x2=85.845 //y2=1.76
r798 (  10 35 ) resistor r=0.0675342 //w=0.23 //l=0.115 //layer=m1 \
 //thickness=0.36 //x=85.665 //y=5.335 //x2=85.55 //y2=5.335
r799 (  9 18 ) resistor r=0.0698411 //w=0.17 //l=0.120208 //layer=m1 \
 //thickness=0.36 //x=86.245 //y=5.335 //x2=86.33 //y2=5.25
r800 (  9 10 ) resistor r=0.553435 //w=0.131 //l=0.58 //layer=m1 \
 //thickness=0.36 //x=86.245 //y=5.335 //x2=85.665 //y2=5.335
r801 (  8 37 ) resistor r=0.00118313 //w=0.23 //layer=m1 //thickness=0.36 \
 //x=85.55 //y=5.56 //x2=85.55 //y2=5.56
r802 (  7 35 ) resistor r=0.002872 //w=0.34 //l=0.085 //layer=m1 \
 //thickness=0.36 //x=85.55 //y=5.42 //x2=85.55 //y2=5.335
r803 (  7 8 ) resistor r=0.091623 //w=0.191 //l=0.14 //layer=m1 \
 //thickness=0.36 //x=85.55 //y=5.42 //x2=85.55 //y2=5.56
r804 (  6 32 ) resistor r=0.0262263 //w=0.232 //l=0.12 //layer=m1 \
 //thickness=0.36 //x=84.79 //y=5.335 //x2=84.67 //y2=5.335
r805 (  5 35 ) resistor r=0.0675342 //w=0.23 //l=0.115 //layer=m1 \
 //thickness=0.36 //x=85.435 //y=5.335 //x2=85.55 //y2=5.335
r806 (  5 6 ) resistor r=0.615458 //w=0.131 //l=0.645 //layer=m1 \
 //thickness=0.36 //x=85.435 //y=5.335 //x2=84.79 //y2=5.335
r807 (  4 29 ) resistor r=0.0222262 //w=0.217 //l=0.118 //layer=m1 \
 //thickness=0.36 //x=83.91 //y=5.335 //x2=83.792 //y2=5.335
r808 (  3 32 ) resistor r=0.0262263 //w=0.232 //l=0.12 //layer=m1 \
 //thickness=0.36 //x=84.55 //y=5.335 //x2=84.67 //y2=5.335
r809 (  3 4 ) resistor r=0.610687 //w=0.131 //l=0.64 //layer=m1 \
 //thickness=0.36 //x=84.55 //y=5.335 //x2=83.91 //y2=5.335
r810 (  2 24 ) resistor r=0.0801089 //w=0.224 //l=0.13 //layer=m1 \
 //thickness=0.36 //x=80.78 //y=4.75 //x2=80.78 //y2=4.88
r811 (  1 28 ) resistor r=0.089984 //w=0.298 //l=0.164924 //layer=m1 \
 //thickness=0.36 //x=80.78 //y=2.485 //x2=80.77 //y2=2.325
r812 (  1 2 ) resistor r=2.16126 //w=0.131 //l=2.265 //layer=m1 \
 //thickness=0.36 //x=80.78 //y=2.485 //x2=80.78 //y2=4.75
ends PM_TMRDFFSNRNQX1\%noxref_21

subckt PM_TMRDFFSNRNQX1\%noxref_22 ( 1 2 3 4 5 7 10 11 13 14 15 16 18 19 20 21 \
 22 23 24 25 26 27 28 36 37 40 43 49 59 63 68 69 70 72 74 76 77 78 80 82 85 86 \
 87 88 90 92 94 96 98 100 102 105 115 116 119 128 133 141 149 166 175 180 189 \
 193 194 195 196 197 198 199 200 201 205 206 207 212 214 217 218 219 220 221 \
 226 228 230 236 237 238 239 240 245 247 249 255 256 258 259 264 268 269 272 \
 280 281 284 292 294 295 296 )
c743 ( 292 0 ) capacitor c=0.00885916f //x=56.795 //y=1.095
c744 ( 284 0 ) capacitor c=0.0370698f //x=95.6 //y=4.885
c745 ( 281 0 ) capacitor c=0.028421f //x=95.58 //y=2.095
c746 ( 280 0 ) capacitor c=0.0512002f //x=95.58 //y=2.26
c747 ( 272 0 ) capacitor c=0.0387879f //x=88.96 //y=4.885
c748 ( 269 0 ) capacitor c=0.0300885f //x=88.92 //y=2.095
c749 ( 268 0 ) capacitor c=0.0554483f //x=88.92 //y=2.26
c750 ( 264 0 ) capacitor c=0.0710579f //x=51.92 //y=4.88
c751 ( 259 0 ) capacitor c=0.0278202f //x=51.92 //y=2.095
c752 ( 258 0 ) capacitor c=0.0479397f //x=51.92 //y=2.26
c753 ( 256 0 ) capacitor c=0.0237734f //x=96.145 //y=1.435
c754 ( 255 0 ) capacitor c=0.0191782f //x=96.145 //y=1.085
c755 ( 249 0 ) capacitor c=0.0361171f //x=95.99 //y=1.585
c756 ( 247 0 ) capacitor c=0.0157803f //x=95.99 //y=0.93
c757 ( 245 0 ) capacitor c=0.0377178f //x=95.985 //y=4.975
c758 ( 240 0 ) capacitor c=0.020493f //x=95.615 //y=1.74
c759 ( 239 0 ) capacitor c=0.0167049f //x=95.615 //y=1.435
c760 ( 238 0 ) capacitor c=0.0174993f //x=95.615 //y=1.085
c761 ( 237 0 ) capacitor c=0.0443648f //x=89.485 //y=1.43
c762 ( 236 0 ) capacitor c=0.0192211f //x=89.485 //y=1.085
c763 ( 230 0 ) capacitor c=0.0186579f //x=89.33 //y=1.585
c764 ( 228 0 ) capacitor c=0.0157795f //x=89.33 //y=0.93
c765 ( 226 0 ) capacitor c=0.0351351f //x=89.325 //y=4.975
c766 ( 221 0 ) capacitor c=0.0209124f //x=88.955 //y=1.74
c767 ( 220 0 ) capacitor c=0.016848f //x=88.955 //y=1.43
c768 ( 219 0 ) capacitor c=0.0174777f //x=88.955 //y=1.085
c769 ( 218 0 ) capacitor c=0.0443175f //x=52.44 //y=1.44
c770 ( 217 0 ) capacitor c=0.0199703f //x=52.44 //y=1.095
c771 ( 214 0 ) capacitor c=0.0162526f //x=52.285 //y=1.595
c772 ( 212 0 ) capacitor c=0.0157807f //x=52.285 //y=0.94
c773 ( 207 0 ) capacitor c=0.0220935f //x=51.91 //y=1.75
c774 ( 206 0 ) capacitor c=0.0207489f //x=51.91 //y=1.44
c775 ( 205 0 ) capacitor c=0.0194091f //x=51.91 //y=1.095
c776 ( 201 0 ) capacitor c=0.155887f //x=96.06 //y=6.205
c777 ( 200 0 ) capacitor c=0.1106f //x=95.62 //y=6.205
c778 ( 199 0 ) capacitor c=0.154859f //x=89.4 //y=6.205
c779 ( 198 0 ) capacitor c=0.110573f //x=88.96 //y=6.205
c780 ( 197 0 ) capacitor c=0.159671f //x=52.1 //y=6.2
c781 ( 196 0 ) capacitor c=0.110208f //x=51.66 //y=6.2
c782 ( 189 0 ) capacitor c=8.10734e-19 //x=95.6 //y=4.885
c783 ( 180 0 ) capacitor c=0.00105273f //x=95.58 //y=2.26
c784 ( 175 0 ) capacitor c=0.00173056f //x=88.96 //y=4.885
c785 ( 166 0 ) capacitor c=0.00152737f //x=88.92 //y=2.26
c786 ( 149 0 ) capacitor c=0.0293719f //x=56.69 //y=5.56
c787 ( 141 0 ) capacitor c=0.0292879f //x=55.81 //y=5.56
c788 ( 133 0 ) capacitor c=0.0278099f //x=54.93 //y=5.56
c789 ( 128 0 ) capacitor c=9.5006e-19 //x=51.92 //y=4.88
c790 ( 119 0 ) capacitor c=0.00101179f //x=51.92 //y=2.26
c791 ( 116 0 ) capacitor c=0.162165f //x=95.435 //y=4.21
c792 ( 115 0 ) capacitor c=0.00479868f //x=95.595 //y=4.21
c793 ( 105 0 ) capacitor c=0.0165817f //x=89.08 //y=4.252
c794 ( 102 0 ) capacitor c=0.00498823f //x=88.03 //y=4.235
c795 ( 100 0 ) capacitor c=0.0296711f //x=87.43 //y=4.25
c796 ( 98 0 ) capacitor c=0.0049231f //x=85.805 //y=4.27
c797 ( 96 0 ) capacitor c=0.0827755f //x=85.205 //y=4.25
c798 ( 94 0 ) capacitor c=0.00430603f //x=76.915 //y=4.28
c799 ( 92 0 ) capacitor c=0.0493847f //x=76.315 //y=4.25
c800 ( 90 0 ) capacitor c=0.00404489f //x=71.375 //y=4.31
c801 ( 88 0 ) capacitor c=0.0450008f //x=66.565 //y=4.28
c802 ( 87 0 ) capacitor c=0.00292689f //x=65.695 //y=4.25
c803 ( 86 0 ) capacitor c=0.00782061f //x=65.965 //y=4.25
c804 ( 85 0 ) capacitor c=0.00460873f //x=65.61 //y=4.165
c805 ( 82 0 ) capacitor c=0.0514445f //x=61.765 //y=3.9
c806 ( 80 0 ) capacitor c=0.0218422f //x=61.165 //y=3.88
c807 ( 78 0 ) capacitor c=0.007152f //x=59.535 //y=3.865
c808 ( 77 0 ) capacitor c=0.0073781f //x=57.63 //y=3.88
c809 ( 76 0 ) capacitor c=0.0250417f //x=58.935 //y=3.88
c810 ( 74 0 ) capacitor c=0.00222613f //x=56.945 //y=3.5
c811 ( 72 0 ) capacitor c=0.00520791f //x=56.345 //y=3.51
c812 ( 70 0 ) capacitor c=0.0031901f //x=55.835 //y=3.53
c813 ( 69 0 ) capacitor c=3.99286e-19 //x=52.08 //y=3.51
c814 ( 68 0 ) capacitor c=0.0358962f //x=55.235 //y=3.51
c815 ( 63 0 ) capacitor c=0.0138506f //x=95.58 //y=4.25
c816 ( 59 0 ) capacitor c=0.0153807f //x=88.92 //y=4.25
c817 ( 49 0 ) capacitor c=0.0158263f //x=57.47 //y=3.51
c818 ( 43 0 ) capacitor c=8.42472e-19 //x=56.69 //y=5.335
c819 ( 40 0 ) capacitor c=0.00753514f //x=55.81 //y=5.335
c820 ( 37 0 ) capacitor c=0.0109203f //x=54.932 //y=5.335
c821 ( 36 0 ) capacitor c=0.0166445f //x=51.92 //y=3.51
c822 ( 28 0 ) capacitor c=0.0124358f //x=95.58 //y=4.74
c823 ( 27 0 ) capacitor c=0.0108569f //x=95.58 //y=4.37
c824 ( 26 0 ) capacitor c=0.0498276f //x=95.58 //y=4.05
c825 ( 25 0 ) capacitor c=0.00651439f //x=95.58 //y=2.38
c826 ( 24 0 ) capacitor c=0.0169891f //x=88.92 //y=4.71
c827 ( 23 0 ) capacitor c=0.0132636f //x=88.92 //y=4.365
c828 ( 22 0 ) capacitor c=0.0659761f //x=88.92 //y=4.045
c829 ( 21 0 ) capacitor c=0.00716889f //x=88.92 //y=2.375
c830 ( 20 0 ) capacitor c=0.0403689f //x=57.47 //y=5.25
c831 ( 19 0 ) capacitor c=0.0135238f //x=57.47 //y=3.685
c832 ( 18 0 ) capacitor c=0.0389407f //x=57.47 //y=3.365
c833 ( 16 0 ) capacitor c=0.00493487f //x=57.07 //y=1.845
c834 ( 15 0 ) capacitor c=0.013289f //x=57.385 //y=1.845
c835 ( 14 0 ) capacitor c=0.0167992f //x=56.985 //y=1.76
c836 ( 13 0 ) capacitor c=0.0112869f //x=56.985 //y=1.305
c837 ( 11 0 ) capacitor c=0.0213474f //x=57.385 //y=5.335
c838 ( 10 0 ) capacitor c=0.00933983f //x=56.69 //y=5.56
c839 ( 7 0 ) capacitor c=0.0177111f //x=56.575 //y=5.335
c840 ( 5 0 ) capacitor c=0.0143796f //x=55.69 //y=5.335
c841 ( 4 0 ) capacitor c=0.0292201f //x=51.92 //y=4.75
c842 ( 3 0 ) capacitor c=0.0121604f //x=51.92 //y=3.655
c843 ( 2 0 ) capacitor c=0.0218282f //x=51.92 //y=3.365
c844 ( 1 0 ) capacitor c=0.00554887f //x=51.92 //y=2.375
r845 (  286 287 ) resistor r=32.4568 //w=0.214 //l=0.075 //layer=ply \
 //thickness=0.18 //x=95.6 //y=4.975 //x2=95.6 //y2=5.05
r846 (  284 286 ) resistor r=20.271 //w=0.214 //l=0.09 //layer=ply \
 //thickness=0.18 //x=95.6 //y=4.885 //x2=95.6 //y2=4.975
r847 (  280 281 ) resistor r=52.7279 //w=0.214 //l=0.165 //layer=ply \
 //thickness=0.18 //x=95.58 //y=2.26 //x2=95.58 //y2=2.095
r848 (  272 274 ) resistor r=20.271 //w=0.214 //l=0.09 //layer=ply \
 //thickness=0.18 //x=88.96 //y=4.885 //x2=88.96 //y2=4.975
r849 (  268 269 ) resistor r=52.7279 //w=0.214 //l=0.165 //layer=ply \
 //thickness=0.18 //x=88.92 //y=2.26 //x2=88.92 //y2=2.095
r850 (  258 259 ) resistor r=52.7279 //w=0.214 //l=0.165 //layer=ply \
 //thickness=0.18 //x=51.92 //y=2.26 //x2=51.92 //y2=2.095
r851 (  256 291 ) resistor r=4.95774 //w=0.164 //l=0.112 //layer=ply \
 //thickness=0.18 //x=96.145 //y=1.435 //x2=96.145 //y2=1.547
r852 (  255 290 ) resistor r=45.1352 //w=0.168 //l=0.173853 //layer=ply \
 //thickness=0.18 //x=96.145 //y=1.085 //x2=96.105 //y2=0.93
r853 (  255 256 ) resistor r=179.468 //w=0.094 //l=0.35 //layer=ply \
 //thickness=0.18 //x=96.145 //y=1.085 //x2=96.145 //y2=1.435
r854 (  250 289 ) resistor r=10.8103 //w=0.211 //l=0.115 //layer=ply \
 //thickness=0.18 //x=95.77 //y=1.585 //x2=95.655 //y2=1.585
r855 (  249 291 ) resistor r=45.9962 //w=0.164 //l=0.17296 //layer=ply \
 //thickness=0.18 //x=95.99 //y=1.585 //x2=96.145 //y2=1.547
r856 (  248 288 ) resistor r=5.52526 //w=0.168 //l=0.115 //layer=ply \
 //thickness=0.18 //x=95.77 //y=0.93 //x2=95.655 //y2=0.93
r857 (  247 290 ) resistor r=5.52526 //w=0.168 //l=0.115 //layer=ply \
 //thickness=0.18 //x=95.99 //y=0.93 //x2=96.105 //y2=0.93
r858 (  247 248 ) resistor r=112.809 //w=0.094 //l=0.22 //layer=ply \
 //thickness=0.18 //x=95.99 //y=0.93 //x2=95.77 //y2=0.93
r859 (  246 286 ) resistor r=16.5046 //w=0.27 //l=0.135 //layer=ply \
 //thickness=0.18 //x=95.735 //y=4.975 //x2=95.6 //y2=4.975
r860 (  245 252 ) resistor r=26.9307 //w=0.15 //l=0.106066 //layer=ply \
 //thickness=0.18 //x=95.985 //y=4.975 //x2=96.06 //y2=5.05
r861 (  245 246 ) resistor r=128.191 //w=0.094 //l=0.25 //layer=ply \
 //thickness=0.18 //x=95.985 //y=4.975 //x2=95.735 //y2=4.975
r862 (  240 289 ) resistor r=39.5036 //w=0.211 //l=0.173853 //layer=ply \
 //thickness=0.18 //x=95.615 //y=1.74 //x2=95.655 //y2=1.585
r863 (  240 281 ) resistor r=182.032 //w=0.094 //l=0.355 //layer=ply \
 //thickness=0.18 //x=95.615 //y=1.74 //x2=95.615 //y2=2.095
r864 (  239 289 ) resistor r=38.3614 //w=0.211 //l=0.168819 //layer=ply \
 //thickness=0.18 //x=95.615 //y=1.435 //x2=95.655 //y2=1.585
r865 (  238 288 ) resistor r=45.1352 //w=0.168 //l=0.173853 //layer=ply \
 //thickness=0.18 //x=95.615 //y=1.085 //x2=95.655 //y2=0.93
r866 (  238 239 ) resistor r=179.468 //w=0.094 //l=0.35 //layer=ply \
 //thickness=0.18 //x=95.615 //y=1.085 //x2=95.615 //y2=1.435
r867 (  237 278 ) resistor r=45.1352 //w=0.168 //l=0.173853 //layer=ply \
 //thickness=0.18 //x=89.485 //y=1.43 //x2=89.445 //y2=1.585
r868 (  236 277 ) resistor r=45.1352 //w=0.168 //l=0.173853 //layer=ply \
 //thickness=0.18 //x=89.485 //y=1.085 //x2=89.445 //y2=0.93
r869 (  236 237 ) resistor r=176.904 //w=0.094 //l=0.345 //layer=ply \
 //thickness=0.18 //x=89.485 //y=1.085 //x2=89.485 //y2=1.43
r870 (  231 276 ) resistor r=10.701 //w=0.21 //l=0.115 //layer=ply \
 //thickness=0.18 //x=89.11 //y=1.585 //x2=88.995 //y2=1.585
r871 (  230 278 ) resistor r=5.52526 //w=0.168 //l=0.115 //layer=ply \
 //thickness=0.18 //x=89.33 //y=1.585 //x2=89.445 //y2=1.585
r872 (  229 275 ) resistor r=5.52526 //w=0.168 //l=0.115 //layer=ply \
 //thickness=0.18 //x=89.11 //y=0.93 //x2=88.995 //y2=0.93
r873 (  228 277 ) resistor r=5.52526 //w=0.168 //l=0.115 //layer=ply \
 //thickness=0.18 //x=89.33 //y=0.93 //x2=89.445 //y2=0.93
r874 (  228 229 ) resistor r=112.809 //w=0.094 //l=0.22 //layer=ply \
 //thickness=0.18 //x=89.33 //y=0.93 //x2=89.11 //y2=0.93
r875 (  227 274 ) resistor r=16.5046 //w=0.27 //l=0.135 //layer=ply \
 //thickness=0.18 //x=89.095 //y=4.975 //x2=88.96 //y2=4.975
r876 (  226 233 ) resistor r=26.9307 //w=0.15 //l=0.106066 //layer=ply \
 //thickness=0.18 //x=89.325 //y=4.975 //x2=89.4 //y2=5.05
r877 (  226 227 ) resistor r=117.936 //w=0.094 //l=0.23 //layer=ply \
 //thickness=0.18 //x=89.325 //y=4.975 //x2=89.095 //y2=4.975
r878 (  223 274 ) resistor r=32.4568 //w=0.214 //l=0.075 //layer=ply \
 //thickness=0.18 //x=88.96 //y=5.05 //x2=88.96 //y2=4.975
r879 (  221 276 ) resistor r=39.5823 //w=0.21 //l=0.173853 //layer=ply \
 //thickness=0.18 //x=88.955 //y=1.74 //x2=88.995 //y2=1.585
r880 (  221 269 ) resistor r=182.032 //w=0.094 //l=0.355 //layer=ply \
 //thickness=0.18 //x=88.955 //y=1.74 //x2=88.955 //y2=2.095
r881 (  220 276 ) resistor r=39.5823 //w=0.21 //l=0.173853 //layer=ply \
 //thickness=0.18 //x=88.955 //y=1.43 //x2=88.995 //y2=1.585
r882 (  219 275 ) resistor r=45.1352 //w=0.168 //l=0.173853 //layer=ply \
 //thickness=0.18 //x=88.955 //y=1.085 //x2=88.995 //y2=0.93
r883 (  219 220 ) resistor r=176.904 //w=0.094 //l=0.345 //layer=ply \
 //thickness=0.18 //x=88.955 //y=1.085 //x2=88.955 //y2=1.43
r884 (  218 266 ) resistor r=45.1352 //w=0.168 //l=0.173853 //layer=ply \
 //thickness=0.18 //x=52.44 //y=1.44 //x2=52.4 //y2=1.595
r885 (  217 265 ) resistor r=45.1352 //w=0.168 //l=0.173853 //layer=ply \
 //thickness=0.18 //x=52.44 //y=1.095 //x2=52.4 //y2=0.94
r886 (  217 218 ) resistor r=176.904 //w=0.094 //l=0.345 //layer=ply \
 //thickness=0.18 //x=52.44 //y=1.095 //x2=52.44 //y2=1.44
r887 (  215 262 ) resistor r=10.701 //w=0.21 //l=0.115 //layer=ply \
 //thickness=0.18 //x=52.065 //y=1.595 //x2=51.95 //y2=1.595
r888 (  214 266 ) resistor r=5.52526 //w=0.168 //l=0.115 //layer=ply \
 //thickness=0.18 //x=52.285 //y=1.595 //x2=52.4 //y2=1.595
r889 (  213 261 ) resistor r=5.52526 //w=0.168 //l=0.115 //layer=ply \
 //thickness=0.18 //x=52.065 //y=0.94 //x2=51.95 //y2=0.94
r890 (  212 265 ) resistor r=5.52526 //w=0.168 //l=0.115 //layer=ply \
 //thickness=0.18 //x=52.285 //y=0.94 //x2=52.4 //y2=0.94
r891 (  212 213 ) resistor r=112.809 //w=0.094 //l=0.22 //layer=ply \
 //thickness=0.18 //x=52.285 //y=0.94 //x2=52.065 //y2=0.94
r892 (  209 264 ) resistor r=37.236 //w=0.233 //l=0.249199 //layer=ply \
 //thickness=0.18 //x=52.1 //y=5.045 //x2=51.92 //y2=4.88
r893 (  207 262 ) resistor r=39.5823 //w=0.21 //l=0.173853 //layer=ply \
 //thickness=0.18 //x=51.91 //y=1.75 //x2=51.95 //y2=1.595
r894 (  207 259 ) resistor r=176.904 //w=0.094 //l=0.345 //layer=ply \
 //thickness=0.18 //x=51.91 //y=1.75 //x2=51.91 //y2=2.095
r895 (  206 262 ) resistor r=39.5823 //w=0.21 //l=0.173853 //layer=ply \
 //thickness=0.18 //x=51.91 //y=1.44 //x2=51.95 //y2=1.595
r896 (  205 261 ) resistor r=45.1352 //w=0.168 //l=0.173853 //layer=ply \
 //thickness=0.18 //x=51.91 //y=1.095 //x2=51.95 //y2=0.94
r897 (  205 206 ) resistor r=176.904 //w=0.094 //l=0.345 //layer=ply \
 //thickness=0.18 //x=51.91 //y=1.095 //x2=51.91 //y2=1.44
r898 (  202 264 ) resistor r=53.7854 //w=0.233 //l=0.332415 //layer=ply \
 //thickness=0.18 //x=51.66 //y=5.045 //x2=51.92 //y2=4.88
r899 (  201 252 ) resistor r=592.245 //w=0.094 //l=1.155 //layer=ply \
 //thickness=0.18 //x=96.06 //y=6.205 //x2=96.06 //y2=5.05
r900 (  200 287 ) resistor r=592.245 //w=0.094 //l=1.155 //layer=ply \
 //thickness=0.18 //x=95.62 //y=6.205 //x2=95.62 //y2=5.05
r901 (  199 233 ) resistor r=592.245 //w=0.094 //l=1.155 //layer=ply \
 //thickness=0.18 //x=89.4 //y=6.205 //x2=89.4 //y2=5.05
r902 (  198 223 ) resistor r=592.245 //w=0.094 //l=1.155 //layer=ply \
 //thickness=0.18 //x=88.96 //y=6.205 //x2=88.96 //y2=5.05
r903 (  197 209 ) resistor r=592.245 //w=0.094 //l=1.155 //layer=ply \
 //thickness=0.18 //x=52.1 //y=6.2 //x2=52.1 //y2=5.045
r904 (  196 202 ) resistor r=592.245 //w=0.094 //l=1.155 //layer=ply \
 //thickness=0.18 //x=51.66 //y=6.2 //x2=51.66 //y2=5.045
r905 (  195 249 ) resistor r=56.4043 //w=0.094 //l=0.11 //layer=ply \
 //thickness=0.18 //x=95.88 //y=1.585 //x2=95.99 //y2=1.585
r906 (  195 250 ) resistor r=56.4043 //w=0.094 //l=0.11 //layer=ply \
 //thickness=0.18 //x=95.88 //y=1.585 //x2=95.77 //y2=1.585
r907 (  194 230 ) resistor r=56.4043 //w=0.094 //l=0.11 //layer=ply \
 //thickness=0.18 //x=89.22 //y=1.585 //x2=89.33 //y2=1.585
r908 (  194 231 ) resistor r=56.4043 //w=0.094 //l=0.11 //layer=ply \
 //thickness=0.18 //x=89.22 //y=1.585 //x2=89.11 //y2=1.585
r909 (  193 214 ) resistor r=56.4043 //w=0.094 //l=0.11 //layer=ply \
 //thickness=0.18 //x=52.175 //y=1.595 //x2=52.285 //y2=1.595
r910 (  193 215 ) resistor r=56.4043 //w=0.094 //l=0.11 //layer=ply \
 //thickness=0.18 //x=52.175 //y=1.595 //x2=52.065 //y2=1.595
r911 (  189 284 ) resistor r=152 //w=0.17 //l=0.17 //layer=licon //count=1 \
 //x=95.6 //y=4.885 //x2=95.6 //y2=4.885
r912 (  180 280 ) resistor r=152 //w=0.17 //l=0.17 //layer=licon //count=1 \
 //x=95.58 //y=2.26 //x2=95.58 //y2=2.26
r913 (  175 272 ) resistor r=152 //w=0.17 //l=0.17 //layer=licon //count=1 \
 //x=88.96 //y=4.885 //x2=88.96 //y2=4.885
r914 (  166 268 ) resistor r=152 //w=0.17 //l=0.17 //layer=licon //count=1 \
 //x=88.92 //y=2.26 //x2=88.92 //y2=2.26
r915 (  149 296 ) resistor r=23.615 //w=0.187 //l=0.345 //layer=li \
 //thickness=0.1 //x=56.69 //y=5.56 //x2=56.69 //y2=5.905
r916 (  141 295 ) resistor r=23.615 //w=0.187 //l=0.345 //layer=li \
 //thickness=0.1 //x=55.81 //y=5.56 //x2=55.81 //y2=5.905
r917 (  133 294 ) resistor r=23.615 //w=0.187 //l=0.345 //layer=li \
 //thickness=0.1 //x=54.93 //y=5.56 //x2=54.93 //y2=5.905
r918 (  128 264 ) resistor r=152 //w=0.17 //l=0.17 //layer=licon //count=1 \
 //x=51.92 //y=4.88 //x2=51.92 //y2=4.88
r919 (  119 258 ) resistor r=152 //w=0.17 //l=0.17 //layer=licon //count=1 \
 //x=51.92 //y=2.26 //x2=51.92 //y2=2.26
r920 (  115 116 ) resistor r=0.104807 //w=0.281 //l=0.16 //layer=m2 \
 //thickness=0.36 //x=95.595 //y=4.21 //x2=95.435 //y2=4.21
r921 (  105 113 ) resistor r=0.0974628 //w=0.216 //l=0.181989 //layer=m2 \
 //thickness=0.36 //x=89.08 //y=4.252 //x2=88.92 //y2=4.205
r922 (  105 116 ) resistor r=5.84099 //w=0.136 //l=6.355 //layer=m2 \
 //thickness=0.36 //x=89.08 //y=4.252 //x2=95.435 //y2=4.252
r923 (  102 113 ) resistor r=0.521062 //w=0.216 //l=0.904876 //layer=m2 \
 //thickness=0.36 //x=88.03 //y=4.235 //x2=88.92 //y2=4.205
r924 (  102 103 ) resistor r=0.410305 //w=0.131 //l=0.43 //layer=m2 \
 //thickness=0.36 //x=88.03 //y=4.235 //x2=87.6 //y2=4.235
r925 (  100 103 ) resistor r=0.125 //w=0.17 //l=0.177341 //layer=m2 \
 //thickness=0.36 //x=87.43 //y=4.25 //x2=87.6 //y2=4.235
r926 (  100 101 ) resistor r=1.38836 //w=0.131 //l=1.455 //layer=m2 \
 //thickness=0.36 //x=87.43 //y=4.25 //x2=85.975 //y2=4.25
r927 (  98 101 ) resistor r=0.125 //w=0.17 //l=0.179722 //layer=m2 \
 //thickness=0.36 //x=85.805 //y=4.27 //x2=85.975 //y2=4.25
r928 (  98 99 ) resistor r=0.329198 //w=0.131 //l=0.345 //layer=m2 \
 //thickness=0.36 //x=85.805 //y=4.27 //x2=85.46 //y2=4.27
r929 (  96 99 ) resistor r=0.1875 //w=0.17 //l=0.264811 //layer=m2 \
 //thickness=0.36 //x=85.205 //y=4.25 //x2=85.46 //y2=4.27
r930 (  96 97 ) resistor r=7.74809 //w=0.131 //l=8.12 //layer=m2 \
 //thickness=0.36 //x=85.205 //y=4.25 //x2=77.085 //y2=4.25
r931 (  94 97 ) resistor r=0.125 //w=0.17 //l=0.184391 //layer=m2 \
 //thickness=0.36 //x=76.915 //y=4.28 //x2=77.085 //y2=4.25
r932 (  94 95 ) resistor r=0.329198 //w=0.131 //l=0.345 //layer=m2 \
 //thickness=0.36 //x=76.915 //y=4.28 //x2=76.57 //y2=4.28
r933 (  92 95 ) resistor r=0.1875 //w=0.17 //l=0.269583 //layer=m2 \
 //thickness=0.36 //x=76.315 //y=4.25 //x2=76.57 //y2=4.28
r934 (  92 93 ) resistor r=4.49905 //w=0.131 //l=4.715 //layer=m2 \
 //thickness=0.36 //x=76.315 //y=4.25 //x2=71.6 //y2=4.25
r935 (  90 93 ) resistor r=0.14881 //w=0.189 //l=0.253229 //layer=m2 \
 //thickness=0.36 //x=71.375 //y=4.31 //x2=71.6 //y2=4.25
r936 (  90 91 ) resistor r=0.329198 //w=0.131 //l=0.345 //layer=m2 \
 //thickness=0.36 //x=71.375 //y=4.31 //x2=71.03 //y2=4.31
r937 (  88 91 ) resistor r=3.26389 //w=0.171 //l=4.47998 //layer=m2 \
 //thickness=0.36 //x=66.565 //y=4.28 //x2=71.03 //y2=4.31
r938 (  88 89 ) resistor r=0.329198 //w=0.131 //l=0.345 //layer=m2 \
 //thickness=0.36 //x=66.565 //y=4.28 //x2=66.22 //y2=4.28
r939 (  86 89 ) resistor r=0.1875 //w=0.17 //l=0.269583 //layer=m2 \
 //thickness=0.36 //x=65.965 //y=4.25 //x2=66.22 //y2=4.28
r940 (  86 87 ) resistor r=0.257634 //w=0.131 //l=0.27 //layer=m2 \
 //thickness=0.36 //x=65.965 //y=4.25 //x2=65.695 //y2=4.25
r941 (  85 87 ) resistor r=0.0698411 //w=0.17 //l=0.120208 //layer=m2 \
 //thickness=0.36 //x=65.61 //y=4.165 //x2=65.695 //y2=4.25
r942 (  84 85 ) resistor r=0.19084 //w=0.131 //l=0.2 //layer=m2 \
 //thickness=0.36 //x=65.61 //y=3.965 //x2=65.61 //y2=4.165
r943 (  82 84 ) resistor r=2.82721 //w=0.17 //l=3.85 //layer=m2 \
 //thickness=0.36 //x=61.765 //y=3.9 //x2=65.61 //y2=3.89
r944 (  82 83 ) resistor r=0.329198 //w=0.131 //l=0.345 //layer=m2 \
 //thickness=0.36 //x=61.765 //y=3.9 //x2=61.42 //y2=3.9
r945 (  80 83 ) resistor r=0.1875 //w=0.17 //l=0.264811 //layer=m2 \
 //thickness=0.36 //x=61.165 //y=3.88 //x2=61.42 //y2=3.9
r946 (  80 81 ) resistor r=1.31202 //w=0.131 //l=1.375 //layer=m2 \
 //thickness=0.36 //x=61.165 //y=3.88 //x2=59.79 //y2=3.88
r947 (  78 81 ) resistor r=0.1875 //w=0.17 //l=0.262393 //layer=m2 \
 //thickness=0.36 //x=59.535 //y=3.865 //x2=59.79 //y2=3.88
r948 (  78 79 ) resistor r=0.410305 //w=0.131 //l=0.43 //layer=m2 \
 //thickness=0.36 //x=59.535 //y=3.865 //x2=59.105 //y2=3.865
r949 (  77 110 ) resistor r=0.0900728 //w=0.341 //l=0.309839 //layer=m2 \
 //thickness=0.36 //x=57.63 //y=3.88 //x2=57.47 //y2=3.64
r950 (  76 79 ) resistor r=0.125 //w=0.17 //l=0.177341 //layer=m2 \
 //thickness=0.36 //x=58.935 //y=3.88 //x2=59.105 //y2=3.865
r951 (  76 77 ) resistor r=1.24523 //w=0.131 //l=1.305 //layer=m2 \
 //thickness=0.36 //x=58.935 //y=3.88 //x2=57.63 //y2=3.88
r952 (  74 110 ) resistor r=0.22387 //w=0.341 //l=0.590868 //layer=m2 \
 //thickness=0.36 //x=56.945 //y=3.5 //x2=57.47 //y2=3.64
r953 (  74 75 ) resistor r=0.410305 //w=0.131 //l=0.43 //layer=m2 \
 //thickness=0.36 //x=56.945 //y=3.5 //x2=56.515 //y2=3.5
r954 (  72 75 ) resistor r=0.125 //w=0.17 //l=0.174929 //layer=m2 \
 //thickness=0.36 //x=56.345 //y=3.51 //x2=56.515 //y2=3.5
r955 (  72 73 ) resistor r=0.324427 //w=0.131 //l=0.34 //layer=m2 \
 //thickness=0.36 //x=56.345 //y=3.51 //x2=56.005 //y2=3.51
r956 (  70 73 ) resistor r=0.125 //w=0.17 //l=0.179722 //layer=m2 \
 //thickness=0.36 //x=55.835 //y=3.53 //x2=56.005 //y2=3.51
r957 (  70 71 ) resistor r=0.329198 //w=0.131 //l=0.345 //layer=m2 \
 //thickness=0.36 //x=55.835 //y=3.53 //x2=55.49 //y2=3.53
r958 (  69 107 ) resistor r=0.108362 //w=0.251 //l=0.16 //layer=m2 \
 //thickness=0.36 //x=52.08 //y=3.51 //x2=51.92 //y2=3.51
r959 (  68 71 ) resistor r=0.1875 //w=0.17 //l=0.264811 //layer=m2 \
 //thickness=0.36 //x=55.235 //y=3.51 //x2=55.49 //y2=3.53
r960 (  68 69 ) resistor r=3.0105 //w=0.131 //l=3.155 //layer=m2 \
 //thickness=0.36 //x=55.235 //y=3.51 //x2=52.08 //y2=3.51
r961 (  67 189 ) resistor r=9.3 //w=0.17 //l=0.17 //layer=mcon //count=1 \
 //x=95.6 //y=4.885 //x2=95.6 //y2=4.885
r962 (  65 180 ) resistor r=9.3 //w=0.17 //l=0.17 //layer=mcon //count=1 \
 //x=95.58 //y=2.26 //x2=95.58 //y2=2.26
r963 (  61 115 ) resistor r=4.5 //w=0.15 //l=0.15 //layer=via1 //count=1 \
 //x=95.595 //y=4.21 //x2=95.595 //y2=4.21
r964 (  61 63 ) resistor r=0.0130208 //w=0.384 //l=0.04 //layer=m1 \
 //thickness=0.36 //x=95.535 //y=4.21 //x2=95.535 //y2=4.25
r965 (  57 113 ) resistor r=4.5 //w=0.15 //l=0.15 //layer=via1 //count=1 \
 //x=88.92 //y=4.205 //x2=88.92 //y2=4.205
r966 (  57 59 ) resistor r=0.0149601 //w=0.376 //l=0.045 //layer=m1 \
 //thickness=0.36 //x=88.972 //y=4.205 //x2=88.972 //y2=4.25
r967 (  55 175 ) resistor r=9.3 //w=0.17 //l=0.17 //layer=mcon //count=1 \
 //x=88.96 //y=4.885 //x2=88.96 //y2=4.885
r968 (  53 166 ) resistor r=9.3 //w=0.17 //l=0.17 //layer=mcon //count=1 \
 //x=88.92 //y=2.26 //x2=88.92 //y2=2.26
r969 (  51 110 ) resistor r=4.5 //w=0.15 //l=0.15 //layer=via1 //count=1 \
 //x=57.47 //y=3.525 //x2=57.47 //y2=3.525
r970 (  49 51 ) resistor r=0.0049867 //w=0.376 //l=0.015 //layer=m1 \
 //thickness=0.36 //x=57.417 //y=3.51 //x2=57.417 //y2=3.525
r971 (  47 292 ) resistor r=9.3 //w=0.17 //l=0.17 //layer=mcon //count=1 \
 //x=56.985 //y=1.19 //x2=56.985 //y2=1.19
r972 (  45 149 ) resistor r=9.3 //w=0.17 //l=0.17 //layer=mcon //count=1 \
 //x=56.69 //y=5.56 //x2=56.69 //y2=5.56
r973 (  42 141 ) resistor r=9.3 //w=0.17 //l=0.17 //layer=mcon //count=1 \
 //x=55.81 //y=5.56 //x2=55.81 //y2=5.56
r974 (  40 42 ) resistor r=0.121228 //w=0.232 //l=0.225 //layer=m1 \
 //thickness=0.36 //x=55.81 //y=5.335 //x2=55.81 //y2=5.56
r975 (  39 133 ) resistor r=9.3 //w=0.17 //l=0.17 //layer=mcon //count=1 \
 //x=54.93 //y=5.56 //x2=54.93 //y2=5.56
r976 (  37 39 ) resistor r=0.129608 //w=0.217 //l=0.225 //layer=m1 \
 //thickness=0.36 //x=54.932 //y=5.335 //x2=54.932 //y2=5.56
r977 (  34 107 ) resistor r=4.5 //w=0.15 //l=0.15 //layer=via1 //count=1 \
 //x=51.92 //y=3.495 //x2=51.92 //y2=3.495
r978 (  34 36 ) resistor r=0.00490838 //w=0.382 //l=0.015 //layer=m1 \
 //thickness=0.36 //x=51.972 //y=3.495 //x2=51.972 //y2=3.51
r979 (  32 128 ) resistor r=9.3 //w=0.17 //l=0.17 //layer=mcon //count=1 \
 //x=51.92 //y=4.88 //x2=51.92 //y2=4.88
r980 (  30 119 ) resistor r=9.3 //w=0.17 //l=0.17 //layer=mcon //count=1 \
 //x=51.92 //y=2.26 //x2=51.92 //y2=2.26
r981 (  28 67 ) resistor r=0.0893515 //w=0.219 //l=0.154677 //layer=m1 \
 //thickness=0.36 //x=95.58 //y=4.74 //x2=95.6 //y2=4.885
r982 (  27 63 ) resistor r=0.0784723 //w=0.384 //l=0.140712 //layer=m1 \
 //thickness=0.36 //x=95.58 //y=4.37 //x2=95.535 //y2=4.25
r983 (  27 28 ) resistor r=0.353053 //w=0.131 //l=0.37 //layer=m1 \
 //thickness=0.36 //x=95.58 //y=4.37 //x2=95.58 //y2=4.74
r984 (  26 61 ) resistor r=0.0914932 //w=0.384 //l=0.181108 //layer=m1 \
 //thickness=0.36 //x=95.58 //y=4.05 //x2=95.535 //y2=4.21
r985 (  25 65 ) resistor r=0.0744285 //w=0.225 //l=0.12 //layer=m1 \
 //thickness=0.36 //x=95.58 //y=2.38 //x2=95.58 //y2=2.26
r986 (  25 26 ) resistor r=1.59351 //w=0.131 //l=1.67 //layer=m1 \
 //thickness=0.36 //x=95.58 //y=2.38 //x2=95.58 //y2=4.05
r987 (  24 55 ) resistor r=0.100665 //w=0.248 //l=0.193972 //layer=m1 \
 //thickness=0.36 //x=88.92 //y=4.71 //x2=88.96 //y2=4.885
r988 (  23 59 ) resistor r=0.0761992 //w=0.376 //l=0.138582 //layer=m1 \
 //thickness=0.36 //x=88.92 //y=4.365 //x2=88.972 //y2=4.25
r989 (  23 24 ) resistor r=0.329198 //w=0.131 //l=0.345 //layer=m1 \
 //thickness=0.36 //x=88.92 //y=4.365 //x2=88.92 //y2=4.71
r990 (  22 57 ) resistor r=0.0911593 //w=0.376 //l=0.184174 //layer=m1 \
 //thickness=0.36 //x=88.92 //y=4.045 //x2=88.972 //y2=4.205
r991 (  21 53 ) resistor r=0.0717383 //w=0.224 //l=0.115 //layer=m1 \
 //thickness=0.36 //x=88.92 //y=2.375 //x2=88.92 //y2=2.26
r992 (  21 22 ) resistor r=1.59351 //w=0.131 //l=1.67 //layer=m1 \
 //thickness=0.36 //x=88.92 //y=2.375 //x2=88.92 //y2=4.045
r993 (  19 51 ) resistor r=0.0911593 //w=0.376 //l=0.184608 //layer=m1 \
 //thickness=0.36 //x=57.47 //y=3.685 //x2=57.417 //y2=3.525
r994 (  19 20 ) resistor r=1.49332 //w=0.131 //l=1.565 //layer=m1 \
 //thickness=0.36 //x=57.47 //y=3.685 //x2=57.47 //y2=5.25
r995 (  18 49 ) resistor r=0.0861726 //w=0.376 //l=0.16944 //layer=m1 \
 //thickness=0.36 //x=57.47 //y=3.365 //x2=57.417 //y2=3.51
r996 (  17 18 ) resistor r=1.36927 //w=0.131 //l=1.435 //layer=m1 \
 //thickness=0.36 //x=57.47 //y=1.93 //x2=57.47 //y2=3.365
r997 (  15 17 ) resistor r=0.0698411 //w=0.17 //l=0.120208 //layer=m1 \
 //thickness=0.36 //x=57.385 //y=1.845 //x2=57.47 //y2=1.93
r998 (  15 16 ) resistor r=0.300573 //w=0.131 //l=0.315 //layer=m1 \
 //thickness=0.36 //x=57.385 //y=1.845 //x2=57.07 //y2=1.845
r999 (  14 16 ) resistor r=0.0698411 //w=0.17 //l=0.120208 //layer=m1 \
 //thickness=0.36 //x=56.985 //y=1.76 //x2=57.07 //y2=1.845
r1000 (  13 47 ) resistor r=0.0717383 //w=0.224 //l=0.115 //layer=m1 \
 //thickness=0.36 //x=56.985 //y=1.305 //x2=56.985 //y2=1.19
r1001 (  13 14 ) resistor r=0.43416 //w=0.131 //l=0.455 //layer=m1 \
 //thickness=0.36 //x=56.985 //y=1.305 //x2=56.985 //y2=1.76
r1002 (  12 43 ) resistor r=0.0675342 //w=0.23 //l=0.115 //layer=m1 \
 //thickness=0.36 //x=56.805 //y=5.335 //x2=56.69 //y2=5.335
r1003 (  11 20 ) resistor r=0.0698411 //w=0.17 //l=0.120208 //layer=m1 \
 //thickness=0.36 //x=57.385 //y=5.335 //x2=57.47 //y2=5.25
r1004 (  11 12 ) resistor r=0.553435 //w=0.131 //l=0.58 //layer=m1 \
 //thickness=0.36 //x=57.385 //y=5.335 //x2=56.805 //y2=5.335
r1005 (  10 45 ) resistor r=0.00118313 //w=0.23 //layer=m1 //thickness=0.36 \
 //x=56.69 //y=5.56 //x2=56.69 //y2=5.56
r1006 (  9 43 ) resistor r=0.002872 //w=0.34 //l=0.085 //layer=m1 \
 //thickness=0.36 //x=56.69 //y=5.42 //x2=56.69 //y2=5.335
r1007 (  9 10 ) resistor r=0.091623 //w=0.191 //l=0.14 //layer=m1 \
 //thickness=0.36 //x=56.69 //y=5.42 //x2=56.69 //y2=5.56
r1008 (  8 40 ) resistor r=0.0262263 //w=0.232 //l=0.12 //layer=m1 \
 //thickness=0.36 //x=55.93 //y=5.335 //x2=55.81 //y2=5.335
r1009 (  7 43 ) resistor r=0.0675342 //w=0.23 //l=0.115 //layer=m1 \
 //thickness=0.36 //x=56.575 //y=5.335 //x2=56.69 //y2=5.335
r1010 (  7 8 ) resistor r=0.615458 //w=0.131 //l=0.645 //layer=m1 \
 //thickness=0.36 //x=56.575 //y=5.335 //x2=55.93 //y2=5.335
r1011 (  6 37 ) resistor r=0.0222262 //w=0.217 //l=0.118 //layer=m1 \
 //thickness=0.36 //x=55.05 //y=5.335 //x2=54.932 //y2=5.335
r1012 (  5 40 ) resistor r=0.0262263 //w=0.232 //l=0.12 //layer=m1 \
 //thickness=0.36 //x=55.69 //y=5.335 //x2=55.81 //y2=5.335
r1013 (  5 6 ) resistor r=0.610687 //w=0.131 //l=0.64 //layer=m1 \
 //thickness=0.36 //x=55.69 //y=5.335 //x2=55.05 //y2=5.335
r1014 (  4 32 ) resistor r=0.0801089 //w=0.224 //l=0.13 //layer=m1 \
 //thickness=0.36 //x=51.92 //y=4.75 //x2=51.92 //y2=4.88
r1015 (  3 36 ) resistor r=0.0864989 //w=0.382 //l=0.169012 //layer=m1 \
 //thickness=0.36 //x=51.92 //y=3.655 //x2=51.972 //y2=3.51
r1016 (  3 4 ) resistor r=1.04485 //w=0.131 //l=1.095 //layer=m1 \
 //thickness=0.36 //x=51.92 //y=3.655 //x2=51.92 //y2=4.75
r1017 (  2 34 ) resistor r=0.0815905 //w=0.382 //l=0.153818 //layer=m1 \
 //thickness=0.36 //x=51.92 //y=3.365 //x2=51.972 //y2=3.495
r1018 (  1 30 ) resistor r=0.0719237 //w=0.222 //l=0.115 //layer=m1 \
 //thickness=0.36 //x=51.92 //y=2.375 //x2=51.92 //y2=2.26
r1019 (  1 2 ) resistor r=0.944656 //w=0.131 //l=0.99 //layer=m1 \
 //thickness=0.36 //x=51.92 //y=2.375 //x2=51.92 //y2=3.365
ends PM_TMRDFFSNRNQX1\%noxref_22

subckt PM_TMRDFFSNRNQX1\%noxref_23 ( 1 3 4 5 7 8 10 11 12 14 15 16 18 22 25 28 \
 36 40 44 57 60 61 63 64 69 71 72 81 89 107 116 124 125 126 127 128 129 130 \
 134 135 136 138 144 145 147 155 156 157 161 162 )
c344 ( 157 0 ) capacitor c=0.00985497f //x=95.69 //y=1.085
c345 ( 156 0 ) capacitor c=0.0108921f //x=92.36 //y=1.085
c346 ( 155 0 ) capacitor c=0.0110394f //x=89.03 //y=1.085
c347 ( 147 0 ) capacitor c=0.0564228f //x=97.8 //y=2.265
c348 ( 145 0 ) capacitor c=0.0439576f //x=98.44 //y=1.435
c349 ( 144 0 ) capacitor c=0.0201087f //x=98.44 //y=1.09
c350 ( 138 0 ) capacitor c=0.0161986f //x=98.285 //y=1.59
c351 ( 136 0 ) capacitor c=0.0157807f //x=98.285 //y=0.935
c352 ( 135 0 ) capacitor c=0.051108f //x=98.03 //y=4.97
c353 ( 134 0 ) capacitor c=0.0390974f //x=98.32 //y=4.97
c354 ( 130 0 ) capacitor c=0.0301471f //x=97.91 //y=2.1
c355 ( 129 0 ) capacitor c=0.0255349f //x=97.91 //y=1.745
c356 ( 128 0 ) capacitor c=0.0234346f //x=97.91 //y=1.435
c357 ( 127 0 ) capacitor c=0.02013f //x=97.91 //y=1.09
c358 ( 126 0 ) capacitor c=0.153927f //x=98.395 //y=6.2
c359 ( 125 0 ) capacitor c=0.154397f //x=97.955 //y=6.2
c360 ( 116 0 ) capacitor c=6.76693e-19 //x=97.8 //y=4.88
c361 ( 107 0 ) capacitor c=9.11699e-19 //x=97.8 //y=2.265
c362 ( 89 0 ) capacitor c=0.0265472f //x=95.84 //y=5.56
c363 ( 81 0 ) capacitor c=0.0232072f //x=94.96 //y=5.56
c364 ( 72 0 ) capacitor c=0.0554023f //x=97.64 //y=4.255
c365 ( 71 0 ) capacitor c=0.00519588f //x=97.8 //y=4.255
c366 ( 69 0 ) capacitor c=0.00713729f //x=96.48 //y=4.255
c367 ( 64 0 ) capacitor c=0.0842751f //x=95.715 //y=1.405
c368 ( 63 0 ) capacitor c=0.0257508f //x=95.875 //y=1.405
c369 ( 61 0 ) capacitor c=0.00655817f //x=92.68 //y=1.405
c370 ( 60 0 ) capacitor c=0.0744064f //x=92.42 //y=1.405
c371 ( 57 0 ) capacitor c=0.00222181f //x=89.385 //y=1.405
c372 ( 44 0 ) capacitor c=0.00786008f //x=97.8 //y=2.265
c373 ( 40 0 ) capacitor c=0.012406f //x=97.8 //y=4.25
c374 ( 36 0 ) capacitor c=0.0138558f //x=96.32 //y=4.25
c375 ( 28 0 ) capacitor c=0.0126021f //x=95.837 //y=5.39
c376 ( 25 0 ) capacitor c=0.0156957f //x=94.96 //y=5.39
c377 ( 22 0 ) capacitor c=0.00902843f //x=92.55 //y=1.36
c378 ( 18 0 ) capacitor c=0.00590002f //x=89.22 //y=1.36
c379 ( 16 0 ) capacitor c=0.00997505f //x=97.8 //y=4.76
c380 ( 15 0 ) capacitor c=0.0109955f //x=97.8 //y=4.415
c381 ( 14 0 ) capacitor c=0.0499339f //x=97.8 //y=4.095
c382 ( 12 0 ) capacitor c=0.0201925f //x=96.32 //y=5.305
c383 ( 11 0 ) capacitor c=0.0114995f //x=96.32 //y=4.415
c384 ( 10 0 ) capacitor c=0.0634551f //x=96.32 //y=4.095
c385 ( 8 0 ) capacitor c=0.00834076f //x=95.965 //y=1.825
c386 ( 7 0 ) capacitor c=0.014154f //x=96.235 //y=1.825
c387 ( 5 0 ) capacitor c=0.00996583f //x=96.235 //y=5.39
c388 ( 4 0 ) capacitor c=0.00638645f //x=95.88 //y=1.74
c389 ( 3 0 ) capacitor c=0.00623208f //x=95.88 //y=1.535
c390 ( 1 0 ) capacitor c=0.0116295f //x=95.715 //y=5.39
r391 (  147 148 ) resistor r=17.5563 //w=0.302 //l=0.11 //layer=ply \
 //thickness=0.18 //x=97.8 //y=2.265 //x2=97.91 //y2=2.265
r392 (  145 154 ) resistor r=45.1352 //w=0.168 //l=0.173853 //layer=ply \
 //thickness=0.18 //x=98.44 //y=1.435 //x2=98.4 //y2=1.59
r393 (  144 153 ) resistor r=45.1352 //w=0.168 //l=0.173853 //layer=ply \
 //thickness=0.18 //x=98.44 //y=1.09 //x2=98.4 //y2=0.935
r394 (  144 145 ) resistor r=176.904 //w=0.094 //l=0.345 //layer=ply \
 //thickness=0.18 //x=98.44 //y=1.09 //x2=98.44 //y2=1.435
r395 (  139 152 ) resistor r=10.701 //w=0.21 //l=0.115 //layer=ply \
 //thickness=0.18 //x=98.065 //y=1.59 //x2=97.95 //y2=1.59
r396 (  138 154 ) resistor r=5.52526 //w=0.168 //l=0.115 //layer=ply \
 //thickness=0.18 //x=98.285 //y=1.59 //x2=98.4 //y2=1.59
r397 (  137 151 ) resistor r=5.52526 //w=0.168 //l=0.115 //layer=ply \
 //thickness=0.18 //x=98.065 //y=0.935 //x2=97.95 //y2=0.935
r398 (  136 153 ) resistor r=5.52526 //w=0.168 //l=0.115 //layer=ply \
 //thickness=0.18 //x=98.285 //y=0.935 //x2=98.4 //y2=0.935
r399 (  136 137 ) resistor r=112.809 //w=0.094 //l=0.22 //layer=ply \
 //thickness=0.18 //x=98.285 //y=0.935 //x2=98.065 //y2=0.935
r400 (  134 141 ) resistor r=26.9307 //w=0.15 //l=0.106066 //layer=ply \
 //thickness=0.18 //x=98.32 //y=4.97 //x2=98.395 //y2=5.045
r401 (  134 135 ) resistor r=148.702 //w=0.094 //l=0.29 //layer=ply \
 //thickness=0.18 //x=98.32 //y=4.97 //x2=98.03 //y2=4.97
r402 (  131 135 ) resistor r=23.403 //w=0.284 //l=0.106066 //layer=ply \
 //thickness=0.18 //x=97.955 //y=5.045 //x2=98.03 //y2=4.97
r403 (  131 150 ) resistor r=26.3063 //w=0.284 //l=0.229783 //layer=ply \
 //thickness=0.18 //x=97.955 //y=5.045 //x2=97.8 //y2=4.88
r404 (  130 148 ) resistor r=19.1248 //w=0.302 //l=0.165 //layer=ply \
 //thickness=0.18 //x=97.91 //y=2.1 //x2=97.91 //y2=2.265
r405 (  129 152 ) resistor r=39.5823 //w=0.21 //l=0.173853 //layer=ply \
 //thickness=0.18 //x=97.91 //y=1.745 //x2=97.95 //y2=1.59
r406 (  129 130 ) resistor r=182.032 //w=0.094 //l=0.355 //layer=ply \
 //thickness=0.18 //x=97.91 //y=1.745 //x2=97.91 //y2=2.1
r407 (  128 152 ) resistor r=39.5823 //w=0.21 //l=0.173853 //layer=ply \
 //thickness=0.18 //x=97.91 //y=1.435 //x2=97.95 //y2=1.59
r408 (  127 151 ) resistor r=45.1352 //w=0.168 //l=0.173853 //layer=ply \
 //thickness=0.18 //x=97.91 //y=1.09 //x2=97.95 //y2=0.935
r409 (  127 128 ) resistor r=176.904 //w=0.094 //l=0.345 //layer=ply \
 //thickness=0.18 //x=97.91 //y=1.09 //x2=97.91 //y2=1.435
r410 (  126 141 ) resistor r=592.245 //w=0.094 //l=1.155 //layer=ply \
 //thickness=0.18 //x=98.395 //y=6.2 //x2=98.395 //y2=5.045
r411 (  125 131 ) resistor r=592.245 //w=0.094 //l=1.155 //layer=ply \
 //thickness=0.18 //x=97.955 //y=6.2 //x2=97.955 //y2=5.045
r412 (  124 138 ) resistor r=56.4043 //w=0.094 //l=0.11 //layer=ply \
 //thickness=0.18 //x=98.175 //y=1.59 //x2=98.285 //y2=1.59
r413 (  124 139 ) resistor r=56.4043 //w=0.094 //l=0.11 //layer=ply \
 //thickness=0.18 //x=98.175 //y=1.59 //x2=98.065 //y2=1.59
r414 (  123 155 ) resistor r=13.3953 //w=0.172 //l=0.18 //layer=li \
 //thickness=0.1 //x=89.217 //y=1.36 //x2=89.217 //y2=1.18
r415 (  116 150 ) resistor r=152 //w=0.17 //l=0.17 //layer=licon //count=1 \
 //x=97.8 //y=4.88 //x2=97.8 //y2=4.88
r416 (  107 147 ) resistor r=152 //w=0.17 //l=0.17 //layer=licon //count=1 \
 //x=97.8 //y=2.265 //x2=97.8 //y2=2.265
r417 (  100 157 ) resistor r=12.3209 //w=0.187 //l=0.18 //layer=li \
 //thickness=0.1 //x=95.88 //y=1.36 //x2=95.88 //y2=1.18
r418 (  89 162 ) resistor r=23.2727 //w=0.187 //l=0.34 //layer=li \
 //thickness=0.1 //x=95.84 //y=5.56 //x2=95.84 //y2=5.9
r419 (  81 161 ) resistor r=23.2727 //w=0.187 //l=0.34 //layer=li \
 //thickness=0.1 //x=94.96 //y=5.56 //x2=94.96 //y2=5.9
r420 (  78 156 ) resistor r=12.3209 //w=0.187 //l=0.18 //layer=li \
 //thickness=0.1 //x=92.55 //y=1.36 //x2=92.55 //y2=1.18
r421 (  71 72 ) resistor r=0.10734 //w=0.281 //l=0.16 //layer=m2 \
 //thickness=0.36 //x=97.8 //y=4.255 //x2=97.64 //y2=4.255
r422 (  69 72 ) resistor r=1.10687 //w=0.131 //l=1.16 //layer=m2 \
 //thickness=0.36 //x=96.48 //y=4.25 //x2=97.64 //y2=4.25
r423 (  67 69 ) resistor r=0.10734 //w=0.281 //l=0.16 //layer=m2 \
 //thickness=0.36 //x=96.32 //y=4.255 //x2=96.48 //y2=4.255
r424 (  63 64 ) resistor r=0.10734 //w=0.281 //l=0.16 //layer=m2 \
 //thickness=0.36 //x=95.875 //y=1.405 //x2=95.715 //y2=1.405
r425 (  61 64 ) resistor r=2.89599 //w=0.131 //l=3.035 //layer=m2 \
 //thickness=0.36 //x=92.68 //y=1.36 //x2=95.715 //y2=1.36
r426 (  59 61 ) resistor r=0.0942778 //w=0.221 //l=0.13 //layer=m2 \
 //thickness=0.36 //x=92.55 //y=1.405 //x2=92.68 //y2=1.405
r427 (  59 60 ) resistor r=0.0942778 //w=0.221 //l=0.13 //layer=m2 \
 //thickness=0.36 //x=92.55 //y=1.405 //x2=92.42 //y2=1.405
r428 (  57 60 ) resistor r=2.89599 //w=0.131 //l=3.035 //layer=m2 \
 //thickness=0.36 //x=89.385 //y=1.36 //x2=92.42 //y2=1.36
r429 (  55 57 ) resistor r=0.10734 //w=0.281 //l=0.16 //layer=m2 \
 //thickness=0.36 //x=89.225 //y=1.405 //x2=89.385 //y2=1.405
r430 (  47 116 ) resistor r=9.3 //w=0.17 //l=0.17 //layer=mcon //count=1 \
 //x=97.8 //y=4.88 //x2=97.8 //y2=4.88
r431 (  44 107 ) resistor r=9.3 //w=0.17 //l=0.17 //layer=mcon //count=1 \
 //x=97.8 //y=2.265 //x2=97.8 //y2=2.265
r432 (  42 71 ) resistor r=4.5 //w=0.15 //l=0.15 //layer=via1 //count=1 \
 //x=97.8 //y=4.255 //x2=97.8 //y2=4.255
r433 (  40 42 ) resistor r=0.00166223 //w=0.376 //l=0.005 //layer=m1 \
 //thickness=0.36 //x=97.747 //y=4.25 //x2=97.747 //y2=4.255
r434 (  38 67 ) resistor r=4.5 //w=0.15 //l=0.15 //layer=via1 //count=1 \
 //x=96.32 //y=4.255 //x2=96.32 //y2=4.255
r435 (  36 38 ) resistor r=0.00166223 //w=0.376 //l=0.005 //layer=m1 \
 //thickness=0.36 //x=96.372 //y=4.25 //x2=96.372 //y2=4.255
r436 (  34 63 ) resistor r=4.5 //w=0.15 //l=0.15 //layer=via1 //count=1 \
 //x=95.875 //y=1.405 //x2=95.875 //y2=1.405
r437 (  32 100 ) resistor r=9.3 //w=0.17 //l=0.17 //layer=mcon //count=1 \
 //x=95.88 //y=1.36 //x2=95.88 //y2=1.36
r438 (  32 34 ) resistor r=0.0163043 //w=0.345 //l=0.045 //layer=m1 \
 //thickness=0.36 //x=95.82 //y=1.36 //x2=95.82 //y2=1.405
r439 (  30 89 ) resistor r=9.3 //w=0.17 //l=0.17 //layer=mcon //count=1 \
 //x=95.84 //y=5.56 //x2=95.84 //y2=5.56
r440 (  28 30 ) resistor r=0.0944444 //w=0.225 //l=0.17 //layer=m1 \
 //thickness=0.36 //x=95.837 //y=5.39 //x2=95.837 //y2=5.56
r441 (  27 81 ) resistor r=9.3 //w=0.17 //l=0.17 //layer=mcon //count=1 \
 //x=94.96 //y=5.56 //x2=94.96 //y2=5.56
r442 (  25 27 ) resistor r=0.0936123 //w=0.227 //l=0.17 //layer=m1 \
 //thickness=0.36 //x=94.96 //y=5.39 //x2=94.96 //y2=5.56
r443 (  24 59 ) resistor r=4.5 //w=0.15 //l=0.15 //layer=via1 //count=1 \
 //x=92.55 //y=1.405 //x2=92.55 //y2=1.405
r444 (  22 78 ) resistor r=9.3 //w=0.17 //l=0.17 //layer=mcon //count=1 \
 //x=92.55 //y=1.36 //x2=92.55 //y2=1.36
r445 (  22 24 ) resistor r=0.0163043 //w=0.345 //l=0.045 //layer=m1 \
 //thickness=0.36 //x=92.49 //y=1.36 //x2=92.49 //y2=1.405
r446 (  20 55 ) resistor r=4.5 //w=0.15 //l=0.15 //layer=via1 //count=1 \
 //x=89.225 //y=1.405 //x2=89.225 //y2=1.405
r447 (  18 123 ) resistor r=9.3 //w=0.17 //l=0.17 //layer=mcon //count=1 \
 //x=89.22 //y=1.36 //x2=89.22 //y2=1.36
r448 (  18 20 ) resistor r=0.0150401 //w=0.374 //l=0.045 //layer=m1 \
 //thickness=0.36 //x=89.275 //y=1.36 //x2=89.275 //y2=1.405
r449 (  16 47 ) resistor r=0.0732479 //w=0.241 //l=0.122474 //layer=m1 \
 //thickness=0.36 //x=97.8 //y=4.76 //x2=97.805 //y2=4.88
r450 (  15 42 ) resistor r=0.0911593 //w=0.376 //l=0.184608 //layer=m1 \
 //thickness=0.36 //x=97.8 //y=4.415 //x2=97.747 //y2=4.255
r451 (  15 16 ) resistor r=0.329198 //w=0.131 //l=0.345 //layer=m1 \
 //thickness=0.36 //x=97.8 //y=4.415 //x2=97.8 //y2=4.76
r452 (  14 40 ) resistor r=0.0894971 //w=0.376 //l=0.179555 //layer=m1 \
 //thickness=0.36 //x=97.8 //y=4.095 //x2=97.747 //y2=4.25
r453 (  13 44 ) resistor r=0.116051 //w=0.211 //l=0.165 //layer=m1 \
 //thickness=0.36 //x=97.8 //y=2.43 //x2=97.8 //y2=2.265
r454 (  13 14 ) resistor r=1.58874 //w=0.131 //l=1.665 //layer=m1 \
 //thickness=0.36 //x=97.8 //y=2.43 //x2=97.8 //y2=4.095
r455 (  11 38 ) resistor r=0.0911593 //w=0.376 //l=0.184174 //layer=m1 \
 //thickness=0.36 //x=96.32 //y=4.415 //x2=96.372 //y2=4.255
r456 (  11 12 ) resistor r=0.849237 //w=0.131 //l=0.89 //layer=m1 \
 //thickness=0.36 //x=96.32 //y=4.415 //x2=96.32 //y2=5.305
r457 (  10 36 ) resistor r=0.0894971 //w=0.376 //l=0.179123 //layer=m1 \
 //thickness=0.36 //x=96.32 //y=4.095 //x2=96.372 //y2=4.25
r458 (  9 10 ) resistor r=2.08492 //w=0.131 //l=2.185 //layer=m1 \
 //thickness=0.36 //x=96.32 //y=1.91 //x2=96.32 //y2=4.095
r459 (  7 9 ) resistor r=0.0698411 //w=0.17 //l=0.120208 //layer=m1 \
 //thickness=0.36 //x=96.235 //y=1.825 //x2=96.32 //y2=1.91
r460 (  7 8 ) resistor r=0.257634 //w=0.131 //l=0.27 //layer=m1 \
 //thickness=0.36 //x=96.235 //y=1.825 //x2=95.965 //y2=1.825
r461 (  6 28 ) resistor r=0.0243946 //w=0.225 //l=0.123 //layer=m1 \
 //thickness=0.36 //x=95.96 //y=5.39 //x2=95.837 //y2=5.39
r462 (  5 12 ) resistor r=0.0698411 //w=0.17 //l=0.120208 //layer=m1 \
 //thickness=0.36 //x=96.235 //y=5.39 //x2=96.32 //y2=5.305
r463 (  5 6 ) resistor r=0.262405 //w=0.131 //l=0.275 //layer=m1 \
 //thickness=0.36 //x=96.235 //y=5.39 //x2=95.96 //y2=5.39
r464 (  4 8 ) resistor r=0.0698411 //w=0.17 //l=0.120208 //layer=m1 \
 //thickness=0.36 //x=95.88 //y=1.74 //x2=95.965 //y2=1.825
r465 (  3 34 ) resistor r=0.0792909 //w=0.345 //l=0.157162 //layer=m1 \
 //thickness=0.36 //x=95.88 //y=1.535 //x2=95.82 //y2=1.405
r466 (  3 4 ) resistor r=0.195611 //w=0.131 //l=0.205 //layer=m1 \
 //thickness=0.36 //x=95.88 //y=1.535 //x2=95.88 //y2=1.74
r467 (  2 25 ) resistor r=0.0249239 //w=0.227 //l=0.125 //layer=m1 \
 //thickness=0.36 //x=95.085 //y=5.39 //x2=94.96 //y2=5.39
r468 (  1 28 ) resistor r=0.0243946 //w=0.225 //l=0.122 //layer=m1 \
 //thickness=0.36 //x=95.715 //y=5.39 //x2=95.837 //y2=5.39
r469 (  1 2 ) resistor r=0.601145 //w=0.131 //l=0.63 //layer=m1 \
 //thickness=0.36 //x=95.715 //y=5.39 //x2=95.085 //y2=5.39
ends PM_TMRDFFSNRNQX1\%noxref_23

subckt PM_TMRDFFSNRNQX1\%Q ( 2 4 5 6 7 8 10 11 12 14 19 22 34 45 47 )
c100 ( 45 0 ) capacitor c=0.00875839f //x=97.985 //y=1.09
c101 ( 34 0 ) capacitor c=0.0261871f //x=98.175 //y=5.56
c102 ( 22 0 ) capacitor c=0.0106115f //x=98.54 //y=4.25
c103 ( 19 0 ) capacitor c=0.0151874f //x=98.54 //y=4.25
c104 ( 14 0 ) capacitor c=0.0196817f //x=98.17 //y=1.185
c105 ( 12 0 ) capacitor c=0.0169669f //x=98.54 //y=5.055
c106 ( 11 0 ) capacitor c=0.0193464f //x=98.54 //y=4.42
c107 ( 10 0 ) capacitor c=0.0879883f //x=98.54 //y=4.1
c108 ( 8 0 ) capacitor c=0.00557311f //x=98.26 //y=5.14
c109 ( 7 0 ) capacitor c=0.00866828f //x=98.455 //y=5.14
c110 ( 6 0 ) capacitor c=0.00724565f //x=98.255 //y=2.02
c111 ( 5 0 ) capacitor c=0.0141809f //x=98.455 //y=2.02
c112 ( 4 0 ) capacitor c=0.0117946f //x=98.175 //y=5.42
c113 ( 2 0 ) capacitor c=0.0166561f //x=98.17 //y=1.935
r114 (  34 47 ) resistor r=23.615 //w=0.187 //l=0.345 //layer=li \
 //thickness=0.1 //x=98.175 //y=5.56 //x2=98.175 //y2=5.905
r115 (  22 26 ) resistor r=0.0044484 //w=0.281 //l=0.01 //layer=m2 \
 //thickness=0.36 //x=98.535 //y=4.25 //x2=98.535 //y2=4.26
r116 (  21 26 ) resistor r=4.5 //w=0.15 //l=0.15 //layer=via1 //count=1 \
 //x=98.535 //y=4.26 //x2=98.535 //y2=4.26
r117 (  19 21 ) resistor r=0.00329815 //w=0.379 //l=0.01 //layer=m1 \
 //thickness=0.36 //x=98.59 //y=4.25 //x2=98.59 //y2=4.26
r118 (  17 34 ) resistor r=9.3 //w=0.17 //l=0.17 //layer=mcon //count=1 \
 //x=98.175 //y=5.56 //x2=98.175 //y2=5.56
r119 (  14 45 ) resistor r=9.3 //w=0.17 //l=0.17 //layer=mcon //count=1 \
 //x=98.17 //y=1.185 //x2=98.17 //y2=1.185
r120 (  11 21 ) resistor r=0.0912814 //w=0.379 //l=0.183303 //layer=m1 \
 //thickness=0.36 //x=98.54 //y=4.42 //x2=98.59 //y2=4.26
r121 (  11 12 ) resistor r=0.605916 //w=0.131 //l=0.635 //layer=m1 \
 //thickness=0.36 //x=98.54 //y=4.42 //x2=98.54 //y2=5.055
r122 (  10 19 ) resistor r=0.0879833 //w=0.379 //l=0.173205 //layer=m1 \
 //thickness=0.36 //x=98.54 //y=4.1 //x2=98.59 //y2=4.25
r123 (  9 10 ) resistor r=1.90363 //w=0.131 //l=1.995 //layer=m1 \
 //thickness=0.36 //x=98.54 //y=2.105 //x2=98.54 //y2=4.1
r124 (  7 12 ) resistor r=0.0698411 //w=0.17 //l=0.120208 //layer=m1 \
 //thickness=0.36 //x=98.455 //y=5.14 //x2=98.54 //y2=5.055
r125 (  7 8 ) resistor r=0.186069 //w=0.131 //l=0.195 //layer=m1 \
 //thickness=0.36 //x=98.455 //y=5.14 //x2=98.26 //y2=5.14
r126 (  5 9 ) resistor r=0.0698411 //w=0.17 //l=0.120208 //layer=m1 \
 //thickness=0.36 //x=98.455 //y=2.02 //x2=98.54 //y2=2.105
r127 (  5 6 ) resistor r=0.19084 //w=0.131 //l=0.2 //layer=m1 //thickness=0.36 \
 //x=98.455 //y=2.02 //x2=98.255 //y2=2.02
r128 (  4 17 ) resistor r=0.086672 //w=0.218 //l=0.14 //layer=m1 \
 //thickness=0.36 //x=98.175 //y=5.42 //x2=98.175 //y2=5.56
r129 (  3 8 ) resistor r=0.0698411 //w=0.17 //l=0.120208 //layer=m1 \
 //thickness=0.36 //x=98.175 //y=5.225 //x2=98.26 //y2=5.14
r130 (  3 4 ) resistor r=0.186069 //w=0.131 //l=0.195 //layer=m1 \
 //thickness=0.36 //x=98.175 //y=5.225 //x2=98.175 //y2=5.42
r131 (  2 6 ) resistor r=0.0698411 //w=0.17 //l=0.120208 //layer=m1 \
 //thickness=0.36 //x=98.17 //y=1.935 //x2=98.255 //y2=2.02
r132 (  1 14 ) resistor r=0.105739 //w=0.201 //l=0.145 //layer=m1 \
 //thickness=0.36 //x=98.17 //y=1.33 //x2=98.17 //y2=1.185
r133 (  1 2 ) resistor r=0.57729 //w=0.131 //l=0.605 //layer=m1 \
 //thickness=0.36 //x=98.17 //y=1.33 //x2=98.17 //y2=1.935
ends PM_TMRDFFSNRNQX1\%Q

subckt PM_TMRDFFSNRNQX1\%VDD ( 1 2 149 150 151 153 154 155 159 160 177 233 236 \
 245 255 263 273 291 301 309 319 337 347 355 365 383 393 401 411 429 439 447 \
 457 475 485 493 503 521 531 539 549 567 577 585 595 613 623 631 641 659 669 \
 677 687 705 715 723 733 751 761 769 779 785 797 807 815 825 843 853 861 871 \
 889 899 907 917 935 945 953 963 981 991 999 1009 1027 1037 1045 1055 1061 \
 1096 1104 1124 1142 1147 1152 1157 1162 1167 1172 1177 1182 1187 1192 1197 \
 1202 1207 1212 1217 1222 1227 1228 1229 1230 1234 1235 1236 1237 1238 1239 \
 1240 1241 1242 1243 1244 1245 1246 1247 1248 1249 1250 1251 1252 1253 1254 \
 1255 1256 1257 1258 1259 1260 1261 1262 1263 1264 1265 1266 1267 1268 1269 \
 1270 1271 1272 1273 1274 1275 1276 1277 1278 1279 1280 1281 1282 1283 1284 \
 1285 1286 1287 1288 1289 1290 1291 1292 1293 1294 1295 1296 1297 1298 1299 \
 1300 1301 1302 1303 1304 1305 1306 1307 1308 1309 1310 1311 )
c1447 ( 1311 0 ) capacitor c=0.0606818f //x=98.47 //y=5.2
c1448 ( 1310 0 ) capacitor c=0.0575062f //x=97.6 //y=5.2
c1449 ( 1309 0 ) capacitor c=0.0424825f //x=89.475 //y=5.205
c1450 ( 1308 0 ) capacitor c=0.0224071f //x=88.595 //y=5.205
c1451 ( 1307 0 ) capacitor c=0.0513776f //x=87.725 //y=5.205
c1452 ( 1306 0 ) capacitor c=0.046689f //x=85.845 //y=5.2
c1453 ( 1305 0 ) capacitor c=0.0255621f //x=84.965 //y=5.2
c1454 ( 1304 0 ) capacitor c=0.0256114f //x=84.085 //y=5.2
c1455 ( 1303 0 ) capacitor c=0.0676549f //x=83.215 //y=5.2
c1456 ( 1302 0 ) capacitor c=0.0466891f //x=81.035 //y=5.2
c1457 ( 1301 0 ) capacitor c=0.025617f //x=80.155 //y=5.2
c1458 ( 1300 0 ) capacitor c=0.0256114f //x=79.275 //y=5.2
c1459 ( 1299 0 ) capacitor c=0.0676623f //x=78.405 //y=5.2
c1460 ( 1298 0 ) capacitor c=0.0466891f //x=76.225 //y=5.2
c1461 ( 1297 0 ) capacitor c=0.025617f //x=75.345 //y=5.2
c1462 ( 1296 0 ) capacitor c=0.0256114f //x=74.465 //y=5.2
c1463 ( 1295 0 ) capacitor c=0.0676871f //x=73.595 //y=5.2
c1464 ( 1294 0 ) capacitor c=0.0466891f //x=71.415 //y=5.2
c1465 ( 1293 0 ) capacitor c=0.025617f //x=70.535 //y=5.2
c1466 ( 1292 0 ) capacitor c=0.0256114f //x=69.655 //y=5.2
c1467 ( 1291 0 ) capacitor c=0.0676862f //x=68.785 //y=5.2
c1468 ( 1290 0 ) capacitor c=0.0466891f //x=66.605 //y=5.2
c1469 ( 1289 0 ) capacitor c=0.0256238f //x=65.725 //y=5.2
c1470 ( 1288 0 ) capacitor c=0.025619f //x=64.845 //y=5.2
c1471 ( 1287 0 ) capacitor c=0.0676862f //x=63.975 //y=5.2
c1472 ( 1286 0 ) capacitor c=0.0466891f //x=61.795 //y=5.2
c1473 ( 1285 0 ) capacitor c=0.025617f //x=60.915 //y=5.2
c1474 ( 1284 0 ) capacitor c=0.0256114f //x=60.035 //y=5.2
c1475 ( 1283 0 ) capacitor c=0.0675515f //x=59.165 //y=5.2
c1476 ( 1282 0 ) capacitor c=0.0466891f //x=56.985 //y=5.2
c1477 ( 1281 0 ) capacitor c=0.025617f //x=56.105 //y=5.2
c1478 ( 1280 0 ) capacitor c=0.0256114f //x=55.225 //y=5.2
c1479 ( 1279 0 ) capacitor c=0.0676881f //x=54.355 //y=5.2
c1480 ( 1278 0 ) capacitor c=0.0466891f //x=52.175 //y=5.2
c1481 ( 1277 0 ) capacitor c=0.025617f //x=51.295 //y=5.2
c1482 ( 1276 0 ) capacitor c=0.0256114f //x=50.415 //y=5.2
c1483 ( 1275 0 ) capacitor c=0.0676378f //x=49.545 //y=5.2
c1484 ( 1274 0 ) capacitor c=0.0466891f //x=47.365 //y=5.2
c1485 ( 1273 0 ) capacitor c=0.025617f //x=46.485 //y=5.2
c1486 ( 1272 0 ) capacitor c=0.0256114f //x=45.605 //y=5.2
c1487 ( 1271 0 ) capacitor c=0.0676871f //x=44.735 //y=5.2
c1488 ( 1270 0 ) capacitor c=0.0466891f //x=42.555 //y=5.2
c1489 ( 1269 0 ) capacitor c=0.025617f //x=41.675 //y=5.2
c1490 ( 1268 0 ) capacitor c=0.0256114f //x=40.795 //y=5.2
c1491 ( 1267 0 ) capacitor c=0.0676862f //x=39.925 //y=5.2
c1492 ( 1266 0 ) capacitor c=0.0466891f //x=37.745 //y=5.2
c1493 ( 1265 0 ) capacitor c=0.025617f //x=36.865 //y=5.2
c1494 ( 1264 0 ) capacitor c=0.0256114f //x=35.985 //y=5.2
c1495 ( 1263 0 ) capacitor c=0.0676862f //x=35.115 //y=5.2
c1496 ( 1262 0 ) capacitor c=0.0466891f //x=32.935 //y=5.2
c1497 ( 1261 0 ) capacitor c=0.025617f //x=32.055 //y=5.2
c1498 ( 1260 0 ) capacitor c=0.0256114f //x=31.175 //y=5.2
c1499 ( 1259 0 ) capacitor c=0.0675526f //x=30.305 //y=5.2
c1500 ( 1258 0 ) capacitor c=0.0466891f //x=28.125 //y=5.2
c1501 ( 1257 0 ) capacitor c=0.025617f //x=27.245 //y=5.2
c1502 ( 1256 0 ) capacitor c=0.0256114f //x=26.365 //y=5.2
c1503 ( 1255 0 ) capacitor c=0.0677148f //x=25.495 //y=5.2
c1504 ( 1254 0 ) capacitor c=0.0466891f //x=23.315 //y=5.2
c1505 ( 1253 0 ) capacitor c=0.025617f //x=22.435 //y=5.2
c1506 ( 1252 0 ) capacitor c=0.0256114f //x=21.555 //y=5.2
c1507 ( 1251 0 ) capacitor c=0.0676623f //x=20.685 //y=5.2
c1508 ( 1250 0 ) capacitor c=0.0466891f //x=18.505 //y=5.2
c1509 ( 1249 0 ) capacitor c=0.025617f //x=17.625 //y=5.2
c1510 ( 1248 0 ) capacitor c=0.0256114f //x=16.745 //y=5.2
c1511 ( 1247 0 ) capacitor c=0.0677138f //x=15.875 //y=5.2
c1512 ( 1246 0 ) capacitor c=0.0466891f //x=13.695 //y=5.2
c1513 ( 1245 0 ) capacitor c=0.025617f //x=12.815 //y=5.2
c1514 ( 1244 0 ) capacitor c=0.0256114f //x=11.935 //y=5.2
c1515 ( 1243 0 ) capacitor c=0.0676529f //x=11.065 //y=5.2
c1516 ( 1242 0 ) capacitor c=0.0466891f //x=8.885 //y=5.2
c1517 ( 1241 0 ) capacitor c=0.025617f //x=8.005 //y=5.2
c1518 ( 1240 0 ) capacitor c=0.0256114f //x=7.125 //y=5.2
c1519 ( 1239 0 ) capacitor c=0.0677384f //x=6.255 //y=5.2
c1520 ( 1238 0 ) capacitor c=0.0466891f //x=4.075 //y=5.2
c1521 ( 1237 0 ) capacitor c=0.025617f //x=3.195 //y=5.2
c1522 ( 1236 0 ) capacitor c=0.0256114f //x=2.315 //y=5.2
c1523 ( 1235 0 ) capacitor c=0.0693233f //x=1.445 //y=5.2
c1524 ( 1234 0 ) capacitor c=0.25757f //x=98.54 //y=7.58
c1525 ( 1232 0 ) capacitor c=0.00597439f //x=97.8 //y=7.58
c1526 ( 1230 0 ) capacitor c=0.117819f //x=97.06 //y=7.585
c1527 ( 1229 0 ) capacitor c=0.120784f //x=93.73 //y=7.585
c1528 ( 1228 0 ) capacitor c=0.125977f //x=90.4 //y=7.585
c1529 ( 1227 0 ) capacitor c=0.140972f //x=87.07 //y=7.585
c1530 ( 1226 0 ) capacitor c=0.00597439f //x=85.99 //y=7.585
c1531 ( 1225 0 ) capacitor c=0.00597439f //x=85.11 //y=7.585
c1532 ( 1224 0 ) capacitor c=0.00597439f //x=84.23 //y=7.585
c1533 ( 1223 0 ) capacitor c=0.00597439f //x=83.35 //y=7.585
c1534 ( 1222 0 ) capacitor c=0.163341f //x=82.26 //y=7.585
c1535 ( 1221 0 ) capacitor c=0.00597439f //x=81.18 //y=7.585
c1536 ( 1220 0 ) capacitor c=0.00597439f //x=80.3 //y=7.585
c1537 ( 1219 0 ) capacitor c=0.00597439f //x=79.42 //y=7.585
c1538 ( 1218 0 ) capacitor c=0.00597439f //x=78.54 //y=7.585
c1539 ( 1217 0 ) capacitor c=0.163341f //x=77.45 //y=7.585
c1540 ( 1216 0 ) capacitor c=0.00597439f //x=76.37 //y=7.585
c1541 ( 1215 0 ) capacitor c=0.00597439f //x=75.49 //y=7.585
c1542 ( 1214 0 ) capacitor c=0.00597439f //x=74.61 //y=7.585
c1543 ( 1213 0 ) capacitor c=0.00597439f //x=73.73 //y=7.585
c1544 ( 1212 0 ) capacitor c=0.161191f //x=72.64 //y=7.585
c1545 ( 1211 0 ) capacitor c=0.00597439f //x=71.56 //y=7.585
c1546 ( 1210 0 ) capacitor c=0.00597439f //x=70.68 //y=7.585
c1547 ( 1209 0 ) capacitor c=0.00597439f //x=69.8 //y=7.585
c1548 ( 1208 0 ) capacitor c=0.00597439f //x=68.92 //y=7.585
c1549 ( 1207 0 ) capacitor c=0.163472f //x=67.83 //y=7.585
c1550 ( 1206 0 ) capacitor c=0.00597439f //x=66.75 //y=7.585
c1551 ( 1205 0 ) capacitor c=0.00597439f //x=65.87 //y=7.585
c1552 ( 1204 0 ) capacitor c=0.00597439f //x=64.99 //y=7.585
c1553 ( 1203 0 ) capacitor c=0.00597439f //x=64.11 //y=7.585
c1554 ( 1202 0 ) capacitor c=0.162645f //x=63.02 //y=7.585
c1555 ( 1201 0 ) capacitor c=0.00597439f //x=61.94 //y=7.585
c1556 ( 1200 0 ) capacitor c=0.00597439f //x=61.06 //y=7.585
c1557 ( 1199 0 ) capacitor c=0.00597439f //x=60.18 //y=7.585
c1558 ( 1198 0 ) capacitor c=0.00597439f //x=59.3 //y=7.585
c1559 ( 1197 0 ) capacitor c=0.162703f //x=58.21 //y=7.585
c1560 ( 1196 0 ) capacitor c=0.00597439f //x=57.13 //y=7.585
c1561 ( 1195 0 ) capacitor c=0.00597439f //x=56.25 //y=7.585
c1562 ( 1194 0 ) capacitor c=0.00597439f //x=55.37 //y=7.585
c1563 ( 1193 0 ) capacitor c=0.00597439f //x=54.49 //y=7.585
c1564 ( 1192 0 ) capacitor c=0.163472f //x=53.4 //y=7.585
c1565 ( 1191 0 ) capacitor c=0.00597439f //x=52.32 //y=7.585
c1566 ( 1190 0 ) capacitor c=0.00597439f //x=51.44 //y=7.585
c1567 ( 1189 0 ) capacitor c=0.00597439f //x=50.56 //y=7.585
c1568 ( 1188 0 ) capacitor c=0.00597439f //x=49.68 //y=7.585
c1569 ( 1187 0 ) capacitor c=0.163472f //x=48.59 //y=7.585
c1570 ( 1186 0 ) capacitor c=0.00597439f //x=47.51 //y=7.585
c1571 ( 1185 0 ) capacitor c=0.00597439f //x=46.63 //y=7.585
c1572 ( 1184 0 ) capacitor c=0.00597439f //x=45.75 //y=7.585
c1573 ( 1183 0 ) capacitor c=0.00597439f //x=44.87 //y=7.585
c1574 ( 1182 0 ) capacitor c=0.161147f //x=43.78 //y=7.585
c1575 ( 1181 0 ) capacitor c=0.00597439f //x=42.7 //y=7.585
c1576 ( 1180 0 ) capacitor c=0.00597439f //x=41.82 //y=7.585
c1577 ( 1179 0 ) capacitor c=0.00597439f //x=40.94 //y=7.585
c1578 ( 1178 0 ) capacitor c=0.00597439f //x=40.06 //y=7.585
c1579 ( 1177 0 ) capacitor c=0.163472f //x=38.97 //y=7.585
c1580 ( 1176 0 ) capacitor c=0.00597439f //x=37.89 //y=7.585
c1581 ( 1175 0 ) capacitor c=0.00597439f //x=37.01 //y=7.585
c1582 ( 1174 0 ) capacitor c=0.00597439f //x=36.13 //y=7.585
c1583 ( 1173 0 ) capacitor c=0.00597439f //x=35.25 //y=7.585
c1584 ( 1172 0 ) capacitor c=0.161264f //x=34.16 //y=7.585
c1585 ( 1171 0 ) capacitor c=0.00597439f //x=33.08 //y=7.585
c1586 ( 1170 0 ) capacitor c=0.00597439f //x=32.2 //y=7.585
c1587 ( 1169 0 ) capacitor c=0.00597439f //x=31.32 //y=7.585
c1588 ( 1168 0 ) capacitor c=0.00597439f //x=30.44 //y=7.585
c1589 ( 1167 0 ) capacitor c=0.160349f //x=29.35 //y=7.585
c1590 ( 1166 0 ) capacitor c=0.00597439f //x=28.27 //y=7.585
c1591 ( 1165 0 ) capacitor c=0.00597439f //x=27.39 //y=7.585
c1592 ( 1164 0 ) capacitor c=0.00597439f //x=26.51 //y=7.585
c1593 ( 1163 0 ) capacitor c=0.00597439f //x=25.63 //y=7.585
c1594 ( 1162 0 ) capacitor c=0.163341f //x=24.54 //y=7.585
c1595 ( 1161 0 ) capacitor c=0.00597439f //x=23.46 //y=7.585
c1596 ( 1160 0 ) capacitor c=0.00597439f //x=22.58 //y=7.585
c1597 ( 1159 0 ) capacitor c=0.00597439f //x=21.7 //y=7.585
c1598 ( 1158 0 ) capacitor c=0.00597439f //x=20.82 //y=7.585
c1599 ( 1157 0 ) capacitor c=0.163341f //x=19.73 //y=7.585
c1600 ( 1156 0 ) capacitor c=0.00597439f //x=18.65 //y=7.585
c1601 ( 1155 0 ) capacitor c=0.00597439f //x=17.77 //y=7.585
c1602 ( 1154 0 ) capacitor c=0.00597439f //x=16.89 //y=7.585
c1603 ( 1153 0 ) capacitor c=0.00597439f //x=16.01 //y=7.585
c1604 ( 1152 0 ) capacitor c=0.163341f //x=14.92 //y=7.585
c1605 ( 1151 0 ) capacitor c=0.00597439f //x=13.84 //y=7.585
c1606 ( 1150 0 ) capacitor c=0.00597439f //x=12.96 //y=7.585
c1607 ( 1149 0 ) capacitor c=0.00597439f //x=12.08 //y=7.585
c1608 ( 1148 0 ) capacitor c=0.00597439f //x=11.2 //y=7.585
c1609 ( 1147 0 ) capacitor c=0.163341f //x=10.11 //y=7.585
c1610 ( 1146 0 ) capacitor c=0.00597439f //x=9.03 //y=7.585
c1611 ( 1145 0 ) capacitor c=0.00597439f //x=8.15 //y=7.585
c1612 ( 1144 0 ) capacitor c=0.00597439f //x=7.27 //y=7.585
c1613 ( 1143 0 ) capacitor c=0.00597439f //x=6.39 //y=7.585
c1614 ( 1142 0 ) capacitor c=0.163259f //x=5.3 //y=7.585
c1615 ( 1141 0 ) capacitor c=0.00597439f //x=4.22 //y=7.585
c1616 ( 1140 0 ) capacitor c=0.00597439f //x=3.34 //y=7.585
c1617 ( 1139 0 ) capacitor c=0.00597439f //x=2.46 //y=7.585
c1618 ( 1138 0 ) capacitor c=0.00597439f //x=1.58 //y=7.585
c1619 ( 1124 0 ) capacitor c=0.0291371f //x=98.53 //y=7.585
c1620 ( 1114 0 ) capacitor c=0.021306f //x=97.65 //y=7.585
c1621 ( 1104 0 ) capacitor c=0.134506f //x=96.89 //y=7.585
c1622 ( 1096 0 ) capacitor c=0.131873f //x=93.56 //y=7.585
c1623 ( 1061 0 ) capacitor c=0.133054f //x=90.23 //y=7.585
c1624 ( 1055 0 ) capacitor c=0.042257f //x=86.9 //y=7.585
c1625 ( 1045 0 ) capacitor c=0.0288858f //x=85.905 //y=7.585
c1626 ( 1037 0 ) capacitor c=0.0289326f //x=85.025 //y=7.585
c1627 ( 1027 0 ) capacitor c=0.0290299f //x=84.145 //y=7.585
c1628 ( 1015 0 ) capacitor c=0.0455283f //x=83.265 //y=7.585
c1629 ( 1009 0 ) capacitor c=0.042257f //x=82.09 //y=7.585
c1630 ( 999 0 ) capacitor c=0.0288858f //x=81.095 //y=7.585
c1631 ( 991 0 ) capacitor c=0.0289326f //x=80.215 //y=7.585
c1632 ( 981 0 ) capacitor c=0.0290299f //x=79.335 //y=7.585
c1633 ( 969 0 ) capacitor c=0.0455283f //x=78.455 //y=7.585
c1634 ( 963 0 ) capacitor c=0.042257f //x=77.28 //y=7.585
c1635 ( 953 0 ) capacitor c=0.0288858f //x=76.285 //y=7.585
c1636 ( 945 0 ) capacitor c=0.0289326f //x=75.405 //y=7.585
c1637 ( 935 0 ) capacitor c=0.0286631f //x=74.525 //y=7.585
c1638 ( 923 0 ) capacitor c=0.0386886f //x=73.645 //y=7.585
c1639 ( 917 0 ) capacitor c=0.038209f //x=72.47 //y=7.585
c1640 ( 907 0 ) capacitor c=0.0288858f //x=71.475 //y=7.585
c1641 ( 899 0 ) capacitor c=0.0289326f //x=70.595 //y=7.585
c1642 ( 889 0 ) capacitor c=0.0286631f //x=69.715 //y=7.585
c1643 ( 877 0 ) capacitor c=0.0386886f //x=68.835 //y=7.585
c1644 ( 871 0 ) capacitor c=0.038209f //x=67.66 //y=7.585
c1645 ( 861 0 ) capacitor c=0.0288858f //x=66.665 //y=7.585
c1646 ( 853 0 ) capacitor c=0.0288627f //x=65.785 //y=7.585
c1647 ( 843 0 ) capacitor c=0.0286631f //x=64.905 //y=7.585
c1648 ( 831 0 ) capacitor c=0.0386886f //x=64.025 //y=7.585
c1649 ( 825 0 ) capacitor c=0.038209f //x=62.85 //y=7.585
c1650 ( 815 0 ) capacitor c=0.0288858f //x=61.855 //y=7.585
c1651 ( 807 0 ) capacitor c=0.0289326f //x=60.975 //y=7.585
c1652 ( 797 0 ) capacitor c=0.0287535f //x=60.095 //y=7.585
c1653 ( 785 0 ) capacitor c=0.0386886f //x=59.215 //y=7.585
c1654 ( 779 0 ) capacitor c=0.038209f //x=58.04 //y=7.585
c1655 ( 769 0 ) capacitor c=0.0288858f //x=57.045 //y=7.585
c1656 ( 761 0 ) capacitor c=0.0289326f //x=56.165 //y=7.585
c1657 ( 751 0 ) capacitor c=0.0286631f //x=55.285 //y=7.585
c1658 ( 739 0 ) capacitor c=0.0386886f //x=54.405 //y=7.585
c1659 ( 733 0 ) capacitor c=0.038209f //x=53.23 //y=7.585
c1660 ( 723 0 ) capacitor c=0.0288858f //x=52.235 //y=7.585
c1661 ( 715 0 ) capacitor c=0.0289326f //x=51.355 //y=7.585
c1662 ( 705 0 ) capacitor c=0.0286631f //x=50.475 //y=7.585
c1663 ( 693 0 ) capacitor c=0.0386886f //x=49.595 //y=7.585
c1664 ( 687 0 ) capacitor c=0.038209f //x=48.42 //y=7.585
c1665 ( 677 0 ) capacitor c=0.0288858f //x=47.425 //y=7.585
c1666 ( 669 0 ) capacitor c=0.0289326f //x=46.545 //y=7.585
c1667 ( 659 0 ) capacitor c=0.0286631f //x=45.665 //y=7.585
c1668 ( 647 0 ) capacitor c=0.0386886f //x=44.785 //y=7.585
c1669 ( 641 0 ) capacitor c=0.038209f //x=43.61 //y=7.585
c1670 ( 631 0 ) capacitor c=0.0288858f //x=42.615 //y=7.585
c1671 ( 623 0 ) capacitor c=0.0289326f //x=41.735 //y=7.585
c1672 ( 613 0 ) capacitor c=0.0286631f //x=40.855 //y=7.585
c1673 ( 601 0 ) capacitor c=0.0386886f //x=39.975 //y=7.585
c1674 ( 595 0 ) capacitor c=0.038209f //x=38.8 //y=7.585
c1675 ( 585 0 ) capacitor c=0.0288858f //x=37.805 //y=7.585
c1676 ( 577 0 ) capacitor c=0.0289326f //x=36.925 //y=7.585
c1677 ( 567 0 ) capacitor c=0.0286631f //x=36.045 //y=7.585
c1678 ( 555 0 ) capacitor c=0.0386886f //x=35.165 //y=7.585
c1679 ( 549 0 ) capacitor c=0.038209f //x=33.99 //y=7.585
c1680 ( 539 0 ) capacitor c=0.0288858f //x=32.995 //y=7.585
c1681 ( 531 0 ) capacitor c=0.0289326f //x=32.115 //y=7.585
c1682 ( 521 0 ) capacitor c=0.0286631f //x=31.235 //y=7.585
c1683 ( 509 0 ) capacitor c=0.0386886f //x=30.355 //y=7.585
c1684 ( 503 0 ) capacitor c=0.0390964f //x=29.18 //y=7.585
c1685 ( 493 0 ) capacitor c=0.0288858f //x=28.185 //y=7.585
c1686 ( 485 0 ) capacitor c=0.0289326f //x=27.305 //y=7.585
c1687 ( 475 0 ) capacitor c=0.0290299f //x=26.425 //y=7.585
c1688 ( 463 0 ) capacitor c=0.0455283f //x=25.545 //y=7.585
c1689 ( 457 0 ) capacitor c=0.042257f //x=24.37 //y=7.585
c1690 ( 447 0 ) capacitor c=0.0288858f //x=23.375 //y=7.585
c1691 ( 439 0 ) capacitor c=0.0289326f //x=22.495 //y=7.585
c1692 ( 429 0 ) capacitor c=0.0290299f //x=21.615 //y=7.585
c1693 ( 417 0 ) capacitor c=0.0455283f //x=20.735 //y=7.585
c1694 ( 411 0 ) capacitor c=0.042257f //x=19.56 //y=7.585
c1695 ( 401 0 ) capacitor c=0.0288858f //x=18.565 //y=7.585
c1696 ( 393 0 ) capacitor c=0.0289326f //x=17.685 //y=7.585
c1697 ( 383 0 ) capacitor c=0.0290299f //x=16.805 //y=7.585
c1698 ( 371 0 ) capacitor c=0.0455283f //x=15.925 //y=7.585
c1699 ( 365 0 ) capacitor c=0.042257f //x=14.75 //y=7.585
c1700 ( 355 0 ) capacitor c=0.0288858f //x=13.755 //y=7.585
c1701 ( 347 0 ) capacitor c=0.0289326f //x=12.875 //y=7.585
c1702 ( 337 0 ) capacitor c=0.0290299f //x=11.995 //y=7.585
c1703 ( 325 0 ) capacitor c=0.0455283f //x=11.115 //y=7.585
c1704 ( 319 0 ) capacitor c=0.042257f //x=9.94 //y=7.585
c1705 ( 309 0 ) capacitor c=0.0288858f //x=8.945 //y=7.585
c1706 ( 301 0 ) capacitor c=0.0289326f //x=8.065 //y=7.585
c1707 ( 291 0 ) capacitor c=0.0290299f //x=7.185 //y=7.585
c1708 ( 279 0 ) capacitor c=0.0455283f //x=6.305 //y=7.585
c1709 ( 273 0 ) capacitor c=0.042257f //x=5.13 //y=7.585
c1710 ( 263 0 ) capacitor c=0.0288858f //x=4.135 //y=7.585
c1711 ( 255 0 ) capacitor c=0.0289326f //x=3.255 //y=7.585
c1712 ( 245 0 ) capacitor c=0.0290743f //x=2.375 //y=7.585
c1713 ( 236 0 ) capacitor c=0.253518f //x=1.23 //y=7.58
c1714 ( 233 0 ) capacitor c=0.0445047f //x=1.495 //y=7.585
c1715 ( 224 0 ) capacitor c=0.00499323f //x=89.62 //y=7.585
c1716 ( 221 0 ) capacitor c=0.00499323f //x=88.74 //y=7.585
c1717 ( 216 0 ) capacitor c=0.00499323f //x=87.81 //y=7.58
c1718 ( 177 0 ) capacitor c=0.347627f //x=98.54 //y=7.58
c1719 ( 160 0 ) capacitor c=0.00657976f //x=89.62 //y=7.41
c1720 ( 159 0 ) capacitor c=0.00827249f //x=89.62 //y=7.035
c1721 ( 155 0 ) capacitor c=0.0220779f //x=89.535 //y=7.585
c1722 ( 154 0 ) capacitor c=0.00369726f //x=88.74 //y=7.41
c1723 ( 153 0 ) capacitor c=0.00650208f //x=88.74 //y=7.035
c1724 ( 151 0 ) capacitor c=0.02242f //x=88.655 //y=7.585
c1725 ( 150 0 ) capacitor c=0.0090067f //x=87.86 //y=7.41
c1726 ( 149 0 ) capacitor c=0.0125184f //x=87.86 //y=7.035
c1727 ( 2 0 ) capacitor c=3.14539f //x=87.775 //y=7.585
r1728 (  1126 1234 ) resistor r=4.23183 //w=0.7 //l=0.175 //layer=li \
 //thickness=0.1 //x=98.615 //y=7.41 //x2=98.615 //y2=7.585
r1729 (  1126 1311 ) resistor r=56.4706 //w=0.187 //l=0.825 //layer=li \
 //thickness=0.1 //x=98.615 //y=7.41 //x2=98.615 //y2=6.585
r1730 (  1125 1232 ) resistor r=2.87058 //w=0.35 //l=0.085 //layer=li \
 //thickness=0.1 //x=97.82 //y=7.585 //x2=97.735 //y2=7.585
r1731 (  1124 1234 ) resistor r=2.87058 //w=0.35 //l=0.085 //layer=li \
 //thickness=0.1 //x=98.53 //y=7.585 //x2=98.615 //y2=7.585
r1732 (  1124 1125 ) resistor r=24.7629 //w=0.367 //l=0.71 //layer=li \
 //thickness=0.1 //x=98.53 //y=7.585 //x2=97.82 //y2=7.585
r1733 (  1116 1232 ) resistor r=4.23183 //w=0.7 //l=0.175 //layer=li \
 //thickness=0.1 //x=97.735 //y=7.41 //x2=97.735 //y2=7.585
r1734 (  1116 1310 ) resistor r=56.4706 //w=0.187 //l=0.825 //layer=li \
 //thickness=0.1 //x=97.735 //y=7.41 //x2=97.735 //y2=6.585
r1735 (  1115 1230 ) resistor r=5.29055 //w=0.35 //l=0.17 //layer=li \
 //thickness=0.1 //x=97.23 //y=7.585 //x2=97.06 //y2=7.585
r1736 (  1114 1232 ) resistor r=2.87058 //w=0.35 //l=0.085 //layer=li \
 //thickness=0.1 //x=97.65 //y=7.585 //x2=97.735 //y2=7.585
r1737 (  1114 1115 ) resistor r=14.6485 //w=0.367 //l=0.42 //layer=li \
 //thickness=0.1 //x=97.65 //y=7.585 //x2=97.23 //y2=7.585
r1738 (  1109 1111 ) resistor r=38.7139 //w=0.367 //l=1.11 //layer=li \
 //thickness=0.1 //x=95.21 //y=7.585 //x2=96.32 //y2=7.585
r1739 (  1107 1109 ) resistor r=38.7139 //w=0.367 //l=1.11 //layer=li \
 //thickness=0.1 //x=94.1 //y=7.585 //x2=95.21 //y2=7.585
r1740 (  1105 1229 ) resistor r=5.29055 //w=0.35 //l=0.17 //layer=li \
 //thickness=0.1 //x=93.9 //y=7.585 //x2=93.73 //y2=7.585
r1741 (  1105 1107 ) resistor r=6.97548 //w=0.367 //l=0.2 //layer=li \
 //thickness=0.1 //x=93.9 //y=7.585 //x2=94.1 //y2=7.585
r1742 (  1104 1230 ) resistor r=5.29055 //w=0.35 //l=0.17 //layer=li \
 //thickness=0.1 //x=96.89 //y=7.585 //x2=97.06 //y2=7.585
r1743 (  1104 1111 ) resistor r=19.8801 //w=0.367 //l=0.57 //layer=li \
 //thickness=0.1 //x=96.89 //y=7.585 //x2=96.32 //y2=7.585
r1744 (  1099 1101 ) resistor r=38.7139 //w=0.367 //l=1.11 //layer=li \
 //thickness=0.1 //x=91.51 //y=7.585 //x2=92.62 //y2=7.585
r1745 (  1097 1228 ) resistor r=5.29055 //w=0.35 //l=0.17 //layer=li \
 //thickness=0.1 //x=90.57 //y=7.585 //x2=90.4 //y2=7.585
r1746 (  1097 1099 ) resistor r=32.7847 //w=0.367 //l=0.94 //layer=li \
 //thickness=0.1 //x=90.57 //y=7.585 //x2=91.51 //y2=7.585
r1747 (  1096 1229 ) resistor r=5.29055 //w=0.35 //l=0.17 //layer=li \
 //thickness=0.1 //x=93.56 //y=7.585 //x2=93.73 //y2=7.585
r1748 (  1096 1101 ) resistor r=32.7847 //w=0.367 //l=0.94 //layer=li \
 //thickness=0.1 //x=93.56 //y=7.585 //x2=92.62 //y2=7.585
r1749 (  1092 1309 ) resistor r=23.2727 //w=0.187 //l=0.34 //layer=li \
 //thickness=0.1 //x=89.62 //y=6.92 //x2=89.62 //y2=6.58
r1750 (  1077 1307 ) resistor r=23.2727 //w=0.187 //l=0.34 //layer=li \
 //thickness=0.1 //x=87.86 //y=6.92 //x2=87.86 //y2=6.58
r1751 (  1066 1068 ) resistor r=38.7139 //w=0.367 //l=1.11 //layer=li \
 //thickness=0.1 //x=88.92 //y=7.585 //x2=90.03 //y2=7.585
r1752 (  1064 1066 ) resistor r=38.7139 //w=0.367 //l=1.11 //layer=li \
 //thickness=0.1 //x=87.81 //y=7.585 //x2=88.92 //y2=7.585
r1753 (  1062 1227 ) resistor r=5.29055 //w=0.35 //l=0.17 //layer=li \
 //thickness=0.1 //x=87.24 //y=7.585 //x2=87.07 //y2=7.585
r1754 (  1062 1064 ) resistor r=19.8801 //w=0.367 //l=0.57 //layer=li \
 //thickness=0.1 //x=87.24 //y=7.585 //x2=87.81 //y2=7.585
r1755 (  1061 1228 ) resistor r=5.29055 //w=0.35 //l=0.17 //layer=li \
 //thickness=0.1 //x=90.23 //y=7.585 //x2=90.4 //y2=7.585
r1756 (  1061 1068 ) resistor r=6.97548 //w=0.367 //l=0.2 //layer=li \
 //thickness=0.1 //x=90.23 //y=7.585 //x2=90.03 //y2=7.585
r1757 (  1056 1226 ) resistor r=2.87058 //w=0.35 //l=0.085 //layer=li \
 //thickness=0.1 //x=86.075 //y=7.585 //x2=85.99 //y2=7.585
r1758 (  1056 1058 ) resistor r=8.89373 //w=0.367 //l=0.255 //layer=li \
 //thickness=0.1 //x=86.075 //y=7.585 //x2=86.33 //y2=7.585
r1759 (  1055 1227 ) resistor r=5.29055 //w=0.35 //l=0.17 //layer=li \
 //thickness=0.1 //x=86.9 //y=7.585 //x2=87.07 //y2=7.585
r1760 (  1055 1058 ) resistor r=19.8801 //w=0.367 //l=0.57 //layer=li \
 //thickness=0.1 //x=86.9 //y=7.585 //x2=86.33 //y2=7.585
r1761 (  1049 1226 ) resistor r=4.23183 //w=0.7 //l=0.175 //layer=li \
 //thickness=0.1 //x=85.99 //y=7.41 //x2=85.99 //y2=7.585
r1762 (  1049 1306 ) resistor r=33.1979 //w=0.187 //l=0.485 //layer=li \
 //thickness=0.1 //x=85.99 //y=7.41 //x2=85.99 //y2=6.925
r1763 (  1046 1225 ) resistor r=2.87058 //w=0.35 //l=0.085 //layer=li \
 //thickness=0.1 //x=85.195 //y=7.585 //x2=85.11 //y2=7.585
r1764 (  1046 1048 ) resistor r=0.871935 //w=0.367 //l=0.025 //layer=li \
 //thickness=0.1 //x=85.195 //y=7.585 //x2=85.22 //y2=7.585
r1765 (  1045 1226 ) resistor r=2.87058 //w=0.35 //l=0.085 //layer=li \
 //thickness=0.1 //x=85.905 //y=7.585 //x2=85.99 //y2=7.585
r1766 (  1045 1048 ) resistor r=23.891 //w=0.367 //l=0.685 //layer=li \
 //thickness=0.1 //x=85.905 //y=7.585 //x2=85.22 //y2=7.585
r1767 (  1039 1225 ) resistor r=4.23183 //w=0.7 //l=0.175 //layer=li \
 //thickness=0.1 //x=85.11 //y=7.41 //x2=85.11 //y2=7.585
r1768 (  1039 1305 ) resistor r=33.1979 //w=0.187 //l=0.485 //layer=li \
 //thickness=0.1 //x=85.11 //y=7.41 //x2=85.11 //y2=6.925
r1769 (  1038 1224 ) resistor r=2.87058 //w=0.35 //l=0.085 //layer=li \
 //thickness=0.1 //x=84.315 //y=7.585 //x2=84.23 //y2=7.585
r1770 (  1037 1225 ) resistor r=2.87058 //w=0.35 //l=0.085 //layer=li \
 //thickness=0.1 //x=85.025 //y=7.585 //x2=85.11 //y2=7.585
r1771 (  1037 1038 ) resistor r=24.7629 //w=0.367 //l=0.71 //layer=li \
 //thickness=0.1 //x=85.025 //y=7.585 //x2=84.315 //y2=7.585
r1772 (  1031 1224 ) resistor r=4.23183 //w=0.7 //l=0.175 //layer=li \
 //thickness=0.1 //x=84.23 //y=7.41 //x2=84.23 //y2=7.585
r1773 (  1031 1304 ) resistor r=33.1979 //w=0.187 //l=0.485 //layer=li \
 //thickness=0.1 //x=84.23 //y=7.41 //x2=84.23 //y2=6.925
r1774 (  1028 1223 ) resistor r=2.87058 //w=0.35 //l=0.085 //layer=li \
 //thickness=0.1 //x=83.435 //y=7.585 //x2=83.35 //y2=7.585
r1775 (  1028 1030 ) resistor r=23.5422 //w=0.367 //l=0.675 //layer=li \
 //thickness=0.1 //x=83.435 //y=7.585 //x2=84.11 //y2=7.585
r1776 (  1027 1224 ) resistor r=2.87058 //w=0.35 //l=0.085 //layer=li \
 //thickness=0.1 //x=84.145 //y=7.585 //x2=84.23 //y2=7.585
r1777 (  1027 1030 ) resistor r=1.22071 //w=0.367 //l=0.035 //layer=li \
 //thickness=0.1 //x=84.145 //y=7.585 //x2=84.11 //y2=7.585
r1778 (  1019 1223 ) resistor r=4.23183 //w=0.7 //l=0.175 //layer=li \
 //thickness=0.1 //x=83.35 //y=7.41 //x2=83.35 //y2=7.585
r1779 (  1019 1303 ) resistor r=56.4706 //w=0.187 //l=0.825 //layer=li \
 //thickness=0.1 //x=83.35 //y=7.41 //x2=83.35 //y2=6.585
r1780 (  1016 1222 ) resistor r=5.29055 //w=0.35 //l=0.17 //layer=li \
 //thickness=0.1 //x=82.43 //y=7.585 //x2=82.26 //y2=7.585
r1781 (  1016 1018 ) resistor r=19.8801 //w=0.367 //l=0.57 //layer=li \
 //thickness=0.1 //x=82.43 //y=7.585 //x2=83 //y2=7.585
r1782 (  1015 1223 ) resistor r=2.87058 //w=0.35 //l=0.085 //layer=li \
 //thickness=0.1 //x=83.265 //y=7.585 //x2=83.35 //y2=7.585
r1783 (  1015 1018 ) resistor r=9.24251 //w=0.367 //l=0.265 //layer=li \
 //thickness=0.1 //x=83.265 //y=7.585 //x2=83 //y2=7.585
r1784 (  1010 1221 ) resistor r=2.87058 //w=0.35 //l=0.085 //layer=li \
 //thickness=0.1 //x=81.265 //y=7.585 //x2=81.18 //y2=7.585
r1785 (  1010 1012 ) resistor r=8.89373 //w=0.367 //l=0.255 //layer=li \
 //thickness=0.1 //x=81.265 //y=7.585 //x2=81.52 //y2=7.585
r1786 (  1009 1222 ) resistor r=5.29055 //w=0.35 //l=0.17 //layer=li \
 //thickness=0.1 //x=82.09 //y=7.585 //x2=82.26 //y2=7.585
r1787 (  1009 1012 ) resistor r=19.8801 //w=0.367 //l=0.57 //layer=li \
 //thickness=0.1 //x=82.09 //y=7.585 //x2=81.52 //y2=7.585
r1788 (  1003 1221 ) resistor r=4.23183 //w=0.7 //l=0.175 //layer=li \
 //thickness=0.1 //x=81.18 //y=7.41 //x2=81.18 //y2=7.585
r1789 (  1003 1302 ) resistor r=33.1979 //w=0.187 //l=0.485 //layer=li \
 //thickness=0.1 //x=81.18 //y=7.41 //x2=81.18 //y2=6.925
r1790 (  1000 1220 ) resistor r=2.87058 //w=0.35 //l=0.085 //layer=li \
 //thickness=0.1 //x=80.385 //y=7.585 //x2=80.3 //y2=7.585
r1791 (  1000 1002 ) resistor r=0.871935 //w=0.367 //l=0.025 //layer=li \
 //thickness=0.1 //x=80.385 //y=7.585 //x2=80.41 //y2=7.585
r1792 (  999 1221 ) resistor r=2.87058 //w=0.35 //l=0.085 //layer=li \
 //thickness=0.1 //x=81.095 //y=7.585 //x2=81.18 //y2=7.585
r1793 (  999 1002 ) resistor r=23.891 //w=0.367 //l=0.685 //layer=li \
 //thickness=0.1 //x=81.095 //y=7.585 //x2=80.41 //y2=7.585
r1794 (  993 1220 ) resistor r=4.23183 //w=0.7 //l=0.175 //layer=li \
 //thickness=0.1 //x=80.3 //y=7.41 //x2=80.3 //y2=7.585
r1795 (  993 1301 ) resistor r=33.1979 //w=0.187 //l=0.485 //layer=li \
 //thickness=0.1 //x=80.3 //y=7.41 //x2=80.3 //y2=6.925
r1796 (  992 1219 ) resistor r=2.87058 //w=0.35 //l=0.085 //layer=li \
 //thickness=0.1 //x=79.505 //y=7.585 //x2=79.42 //y2=7.585
r1797 (  991 1220 ) resistor r=2.87058 //w=0.35 //l=0.085 //layer=li \
 //thickness=0.1 //x=80.215 //y=7.585 //x2=80.3 //y2=7.585
r1798 (  991 992 ) resistor r=24.7629 //w=0.367 //l=0.71 //layer=li \
 //thickness=0.1 //x=80.215 //y=7.585 //x2=79.505 //y2=7.585
r1799 (  985 1219 ) resistor r=4.23183 //w=0.7 //l=0.175 //layer=li \
 //thickness=0.1 //x=79.42 //y=7.41 //x2=79.42 //y2=7.585
r1800 (  985 1300 ) resistor r=33.1979 //w=0.187 //l=0.485 //layer=li \
 //thickness=0.1 //x=79.42 //y=7.41 //x2=79.42 //y2=6.925
r1801 (  982 1218 ) resistor r=2.87058 //w=0.35 //l=0.085 //layer=li \
 //thickness=0.1 //x=78.625 //y=7.585 //x2=78.54 //y2=7.585
r1802 (  982 984 ) resistor r=23.5422 //w=0.367 //l=0.675 //layer=li \
 //thickness=0.1 //x=78.625 //y=7.585 //x2=79.3 //y2=7.585
r1803 (  981 1219 ) resistor r=2.87058 //w=0.35 //l=0.085 //layer=li \
 //thickness=0.1 //x=79.335 //y=7.585 //x2=79.42 //y2=7.585
r1804 (  981 984 ) resistor r=1.22071 //w=0.367 //l=0.035 //layer=li \
 //thickness=0.1 //x=79.335 //y=7.585 //x2=79.3 //y2=7.585
r1805 (  973 1218 ) resistor r=4.23183 //w=0.7 //l=0.175 //layer=li \
 //thickness=0.1 //x=78.54 //y=7.41 //x2=78.54 //y2=7.585
r1806 (  973 1299 ) resistor r=56.4706 //w=0.187 //l=0.825 //layer=li \
 //thickness=0.1 //x=78.54 //y=7.41 //x2=78.54 //y2=6.585
r1807 (  970 1217 ) resistor r=5.29055 //w=0.35 //l=0.17 //layer=li \
 //thickness=0.1 //x=77.62 //y=7.585 //x2=77.45 //y2=7.585
r1808 (  970 972 ) resistor r=19.8801 //w=0.367 //l=0.57 //layer=li \
 //thickness=0.1 //x=77.62 //y=7.585 //x2=78.19 //y2=7.585
r1809 (  969 1218 ) resistor r=2.87058 //w=0.35 //l=0.085 //layer=li \
 //thickness=0.1 //x=78.455 //y=7.585 //x2=78.54 //y2=7.585
r1810 (  969 972 ) resistor r=9.24251 //w=0.367 //l=0.265 //layer=li \
 //thickness=0.1 //x=78.455 //y=7.585 //x2=78.19 //y2=7.585
r1811 (  964 1216 ) resistor r=2.87058 //w=0.35 //l=0.085 //layer=li \
 //thickness=0.1 //x=76.455 //y=7.585 //x2=76.37 //y2=7.585
r1812 (  964 966 ) resistor r=8.89373 //w=0.367 //l=0.255 //layer=li \
 //thickness=0.1 //x=76.455 //y=7.585 //x2=76.71 //y2=7.585
r1813 (  963 1217 ) resistor r=5.29055 //w=0.35 //l=0.17 //layer=li \
 //thickness=0.1 //x=77.28 //y=7.585 //x2=77.45 //y2=7.585
r1814 (  963 966 ) resistor r=19.8801 //w=0.367 //l=0.57 //layer=li \
 //thickness=0.1 //x=77.28 //y=7.585 //x2=76.71 //y2=7.585
r1815 (  957 1216 ) resistor r=4.23183 //w=0.7 //l=0.175 //layer=li \
 //thickness=0.1 //x=76.37 //y=7.41 //x2=76.37 //y2=7.585
r1816 (  957 1298 ) resistor r=33.1979 //w=0.187 //l=0.485 //layer=li \
 //thickness=0.1 //x=76.37 //y=7.41 //x2=76.37 //y2=6.925
r1817 (  954 1215 ) resistor r=2.87058 //w=0.35 //l=0.085 //layer=li \
 //thickness=0.1 //x=75.575 //y=7.585 //x2=75.49 //y2=7.585
r1818 (  954 956 ) resistor r=0.871935 //w=0.367 //l=0.025 //layer=li \
 //thickness=0.1 //x=75.575 //y=7.585 //x2=75.6 //y2=7.585
r1819 (  953 1216 ) resistor r=2.87058 //w=0.35 //l=0.085 //layer=li \
 //thickness=0.1 //x=76.285 //y=7.585 //x2=76.37 //y2=7.585
r1820 (  953 956 ) resistor r=23.891 //w=0.367 //l=0.685 //layer=li \
 //thickness=0.1 //x=76.285 //y=7.585 //x2=75.6 //y2=7.585
r1821 (  947 1215 ) resistor r=4.23183 //w=0.7 //l=0.175 //layer=li \
 //thickness=0.1 //x=75.49 //y=7.41 //x2=75.49 //y2=7.585
r1822 (  947 1297 ) resistor r=33.1979 //w=0.187 //l=0.485 //layer=li \
 //thickness=0.1 //x=75.49 //y=7.41 //x2=75.49 //y2=6.925
r1823 (  946 1214 ) resistor r=2.87058 //w=0.35 //l=0.085 //layer=li \
 //thickness=0.1 //x=74.695 //y=7.585 //x2=74.61 //y2=7.585
r1824 (  945 1215 ) resistor r=2.87058 //w=0.35 //l=0.085 //layer=li \
 //thickness=0.1 //x=75.405 //y=7.585 //x2=75.49 //y2=7.585
r1825 (  945 946 ) resistor r=24.7629 //w=0.367 //l=0.71 //layer=li \
 //thickness=0.1 //x=75.405 //y=7.585 //x2=74.695 //y2=7.585
r1826 (  939 1214 ) resistor r=4.23183 //w=0.7 //l=0.175 //layer=li \
 //thickness=0.1 //x=74.61 //y=7.41 //x2=74.61 //y2=7.585
r1827 (  939 1296 ) resistor r=33.1979 //w=0.187 //l=0.485 //layer=li \
 //thickness=0.1 //x=74.61 //y=7.41 //x2=74.61 //y2=6.925
r1828 (  936 1213 ) resistor r=2.87058 //w=0.35 //l=0.085 //layer=li \
 //thickness=0.1 //x=73.815 //y=7.585 //x2=73.73 //y2=7.585
r1829 (  936 938 ) resistor r=23.5422 //w=0.367 //l=0.675 //layer=li \
 //thickness=0.1 //x=73.815 //y=7.585 //x2=74.49 //y2=7.585
r1830 (  935 1214 ) resistor r=2.87058 //w=0.35 //l=0.085 //layer=li \
 //thickness=0.1 //x=74.525 //y=7.585 //x2=74.61 //y2=7.585
r1831 (  935 938 ) resistor r=1.22071 //w=0.367 //l=0.035 //layer=li \
 //thickness=0.1 //x=74.525 //y=7.585 //x2=74.49 //y2=7.585
r1832 (  927 1213 ) resistor r=4.23183 //w=0.7 //l=0.175 //layer=li \
 //thickness=0.1 //x=73.73 //y=7.41 //x2=73.73 //y2=7.585
r1833 (  927 1295 ) resistor r=56.4706 //w=0.187 //l=0.825 //layer=li \
 //thickness=0.1 //x=73.73 //y=7.41 //x2=73.73 //y2=6.585
r1834 (  924 1212 ) resistor r=5.29055 //w=0.35 //l=0.17 //layer=li \
 //thickness=0.1 //x=72.81 //y=7.585 //x2=72.64 //y2=7.585
r1835 (  924 926 ) resistor r=19.8801 //w=0.367 //l=0.57 //layer=li \
 //thickness=0.1 //x=72.81 //y=7.585 //x2=73.38 //y2=7.585
r1836 (  923 1213 ) resistor r=2.87058 //w=0.35 //l=0.085 //layer=li \
 //thickness=0.1 //x=73.645 //y=7.585 //x2=73.73 //y2=7.585
r1837 (  923 926 ) resistor r=9.24251 //w=0.367 //l=0.265 //layer=li \
 //thickness=0.1 //x=73.645 //y=7.585 //x2=73.38 //y2=7.585
r1838 (  918 1211 ) resistor r=2.87058 //w=0.35 //l=0.085 //layer=li \
 //thickness=0.1 //x=71.645 //y=7.585 //x2=71.56 //y2=7.585
r1839 (  918 920 ) resistor r=8.89373 //w=0.367 //l=0.255 //layer=li \
 //thickness=0.1 //x=71.645 //y=7.585 //x2=71.9 //y2=7.585
r1840 (  917 1212 ) resistor r=5.29055 //w=0.35 //l=0.17 //layer=li \
 //thickness=0.1 //x=72.47 //y=7.585 //x2=72.64 //y2=7.585
r1841 (  917 920 ) resistor r=19.8801 //w=0.367 //l=0.57 //layer=li \
 //thickness=0.1 //x=72.47 //y=7.585 //x2=71.9 //y2=7.585
r1842 (  911 1211 ) resistor r=4.23183 //w=0.7 //l=0.175 //layer=li \
 //thickness=0.1 //x=71.56 //y=7.41 //x2=71.56 //y2=7.585
r1843 (  911 1294 ) resistor r=33.1979 //w=0.187 //l=0.485 //layer=li \
 //thickness=0.1 //x=71.56 //y=7.41 //x2=71.56 //y2=6.925
r1844 (  908 1210 ) resistor r=2.87058 //w=0.35 //l=0.085 //layer=li \
 //thickness=0.1 //x=70.765 //y=7.585 //x2=70.68 //y2=7.585
r1845 (  908 910 ) resistor r=0.871935 //w=0.367 //l=0.025 //layer=li \
 //thickness=0.1 //x=70.765 //y=7.585 //x2=70.79 //y2=7.585
r1846 (  907 1211 ) resistor r=2.87058 //w=0.35 //l=0.085 //layer=li \
 //thickness=0.1 //x=71.475 //y=7.585 //x2=71.56 //y2=7.585
r1847 (  907 910 ) resistor r=23.891 //w=0.367 //l=0.685 //layer=li \
 //thickness=0.1 //x=71.475 //y=7.585 //x2=70.79 //y2=7.585
r1848 (  901 1210 ) resistor r=4.23183 //w=0.7 //l=0.175 //layer=li \
 //thickness=0.1 //x=70.68 //y=7.41 //x2=70.68 //y2=7.585
r1849 (  901 1293 ) resistor r=33.1979 //w=0.187 //l=0.485 //layer=li \
 //thickness=0.1 //x=70.68 //y=7.41 //x2=70.68 //y2=6.925
r1850 (  900 1209 ) resistor r=2.87058 //w=0.35 //l=0.085 //layer=li \
 //thickness=0.1 //x=69.885 //y=7.585 //x2=69.8 //y2=7.585
r1851 (  899 1210 ) resistor r=2.87058 //w=0.35 //l=0.085 //layer=li \
 //thickness=0.1 //x=70.595 //y=7.585 //x2=70.68 //y2=7.585
r1852 (  899 900 ) resistor r=24.7629 //w=0.367 //l=0.71 //layer=li \
 //thickness=0.1 //x=70.595 //y=7.585 //x2=69.885 //y2=7.585
r1853 (  893 1209 ) resistor r=4.23183 //w=0.7 //l=0.175 //layer=li \
 //thickness=0.1 //x=69.8 //y=7.41 //x2=69.8 //y2=7.585
r1854 (  893 1292 ) resistor r=33.1979 //w=0.187 //l=0.485 //layer=li \
 //thickness=0.1 //x=69.8 //y=7.41 //x2=69.8 //y2=6.925
r1855 (  890 1208 ) resistor r=2.87058 //w=0.35 //l=0.085 //layer=li \
 //thickness=0.1 //x=69.005 //y=7.585 //x2=68.92 //y2=7.585
r1856 (  890 892 ) resistor r=23.5422 //w=0.367 //l=0.675 //layer=li \
 //thickness=0.1 //x=69.005 //y=7.585 //x2=69.68 //y2=7.585
r1857 (  889 1209 ) resistor r=2.87058 //w=0.35 //l=0.085 //layer=li \
 //thickness=0.1 //x=69.715 //y=7.585 //x2=69.8 //y2=7.585
r1858 (  889 892 ) resistor r=1.22071 //w=0.367 //l=0.035 //layer=li \
 //thickness=0.1 //x=69.715 //y=7.585 //x2=69.68 //y2=7.585
r1859 (  881 1208 ) resistor r=4.23183 //w=0.7 //l=0.175 //layer=li \
 //thickness=0.1 //x=68.92 //y=7.41 //x2=68.92 //y2=7.585
r1860 (  881 1291 ) resistor r=56.4706 //w=0.187 //l=0.825 //layer=li \
 //thickness=0.1 //x=68.92 //y=7.41 //x2=68.92 //y2=6.585
r1861 (  878 1207 ) resistor r=5.29055 //w=0.35 //l=0.17 //layer=li \
 //thickness=0.1 //x=68 //y=7.585 //x2=67.83 //y2=7.585
r1862 (  878 880 ) resistor r=19.8801 //w=0.367 //l=0.57 //layer=li \
 //thickness=0.1 //x=68 //y=7.585 //x2=68.57 //y2=7.585
r1863 (  877 1208 ) resistor r=2.87058 //w=0.35 //l=0.085 //layer=li \
 //thickness=0.1 //x=68.835 //y=7.585 //x2=68.92 //y2=7.585
r1864 (  877 880 ) resistor r=9.24251 //w=0.367 //l=0.265 //layer=li \
 //thickness=0.1 //x=68.835 //y=7.585 //x2=68.57 //y2=7.585
r1865 (  872 1206 ) resistor r=2.87058 //w=0.35 //l=0.085 //layer=li \
 //thickness=0.1 //x=66.835 //y=7.585 //x2=66.75 //y2=7.585
r1866 (  872 874 ) resistor r=8.89373 //w=0.367 //l=0.255 //layer=li \
 //thickness=0.1 //x=66.835 //y=7.585 //x2=67.09 //y2=7.585
r1867 (  871 1207 ) resistor r=5.29055 //w=0.35 //l=0.17 //layer=li \
 //thickness=0.1 //x=67.66 //y=7.585 //x2=67.83 //y2=7.585
r1868 (  871 874 ) resistor r=19.8801 //w=0.367 //l=0.57 //layer=li \
 //thickness=0.1 //x=67.66 //y=7.585 //x2=67.09 //y2=7.585
r1869 (  865 1206 ) resistor r=4.23183 //w=0.7 //l=0.175 //layer=li \
 //thickness=0.1 //x=66.75 //y=7.41 //x2=66.75 //y2=7.585
r1870 (  865 1290 ) resistor r=33.1979 //w=0.187 //l=0.485 //layer=li \
 //thickness=0.1 //x=66.75 //y=7.41 //x2=66.75 //y2=6.925
r1871 (  862 1205 ) resistor r=2.87058 //w=0.35 //l=0.085 //layer=li \
 //thickness=0.1 //x=65.955 //y=7.585 //x2=65.87 //y2=7.585
r1872 (  862 864 ) resistor r=0.871935 //w=0.367 //l=0.025 //layer=li \
 //thickness=0.1 //x=65.955 //y=7.585 //x2=65.98 //y2=7.585
r1873 (  861 1206 ) resistor r=2.87058 //w=0.35 //l=0.085 //layer=li \
 //thickness=0.1 //x=66.665 //y=7.585 //x2=66.75 //y2=7.585
r1874 (  861 864 ) resistor r=23.891 //w=0.367 //l=0.685 //layer=li \
 //thickness=0.1 //x=66.665 //y=7.585 //x2=65.98 //y2=7.585
r1875 (  855 1205 ) resistor r=4.23183 //w=0.7 //l=0.175 //layer=li \
 //thickness=0.1 //x=65.87 //y=7.41 //x2=65.87 //y2=7.585
r1876 (  855 1289 ) resistor r=33.1979 //w=0.187 //l=0.485 //layer=li \
 //thickness=0.1 //x=65.87 //y=7.41 //x2=65.87 //y2=6.925
r1877 (  854 1204 ) resistor r=2.87058 //w=0.35 //l=0.085 //layer=li \
 //thickness=0.1 //x=65.075 //y=7.585 //x2=64.99 //y2=7.585
r1878 (  853 1205 ) resistor r=2.87058 //w=0.35 //l=0.085 //layer=li \
 //thickness=0.1 //x=65.785 //y=7.585 //x2=65.87 //y2=7.585
r1879 (  853 854 ) resistor r=24.7629 //w=0.367 //l=0.71 //layer=li \
 //thickness=0.1 //x=65.785 //y=7.585 //x2=65.075 //y2=7.585
r1880 (  847 1204 ) resistor r=4.23183 //w=0.7 //l=0.175 //layer=li \
 //thickness=0.1 //x=64.99 //y=7.41 //x2=64.99 //y2=7.585
r1881 (  847 1288 ) resistor r=33.1979 //w=0.187 //l=0.485 //layer=li \
 //thickness=0.1 //x=64.99 //y=7.41 //x2=64.99 //y2=6.925
r1882 (  844 1203 ) resistor r=2.87058 //w=0.35 //l=0.085 //layer=li \
 //thickness=0.1 //x=64.195 //y=7.585 //x2=64.11 //y2=7.585
r1883 (  844 846 ) resistor r=23.5422 //w=0.367 //l=0.675 //layer=li \
 //thickness=0.1 //x=64.195 //y=7.585 //x2=64.87 //y2=7.585
r1884 (  843 1204 ) resistor r=2.87058 //w=0.35 //l=0.085 //layer=li \
 //thickness=0.1 //x=64.905 //y=7.585 //x2=64.99 //y2=7.585
r1885 (  843 846 ) resistor r=1.22071 //w=0.367 //l=0.035 //layer=li \
 //thickness=0.1 //x=64.905 //y=7.585 //x2=64.87 //y2=7.585
r1886 (  835 1203 ) resistor r=4.23183 //w=0.7 //l=0.175 //layer=li \
 //thickness=0.1 //x=64.11 //y=7.41 //x2=64.11 //y2=7.585
r1887 (  835 1287 ) resistor r=56.4706 //w=0.187 //l=0.825 //layer=li \
 //thickness=0.1 //x=64.11 //y=7.41 //x2=64.11 //y2=6.585
r1888 (  832 1202 ) resistor r=5.29055 //w=0.35 //l=0.17 //layer=li \
 //thickness=0.1 //x=63.19 //y=7.585 //x2=63.02 //y2=7.585
r1889 (  832 834 ) resistor r=19.8801 //w=0.367 //l=0.57 //layer=li \
 //thickness=0.1 //x=63.19 //y=7.585 //x2=63.76 //y2=7.585
r1890 (  831 1203 ) resistor r=2.87058 //w=0.35 //l=0.085 //layer=li \
 //thickness=0.1 //x=64.025 //y=7.585 //x2=64.11 //y2=7.585
r1891 (  831 834 ) resistor r=9.24251 //w=0.367 //l=0.265 //layer=li \
 //thickness=0.1 //x=64.025 //y=7.585 //x2=63.76 //y2=7.585
r1892 (  826 1201 ) resistor r=2.87058 //w=0.35 //l=0.085 //layer=li \
 //thickness=0.1 //x=62.025 //y=7.585 //x2=61.94 //y2=7.585
r1893 (  826 828 ) resistor r=8.89373 //w=0.367 //l=0.255 //layer=li \
 //thickness=0.1 //x=62.025 //y=7.585 //x2=62.28 //y2=7.585
r1894 (  825 1202 ) resistor r=5.29055 //w=0.35 //l=0.17 //layer=li \
 //thickness=0.1 //x=62.85 //y=7.585 //x2=63.02 //y2=7.585
r1895 (  825 828 ) resistor r=19.8801 //w=0.367 //l=0.57 //layer=li \
 //thickness=0.1 //x=62.85 //y=7.585 //x2=62.28 //y2=7.585
r1896 (  819 1201 ) resistor r=4.23183 //w=0.7 //l=0.175 //layer=li \
 //thickness=0.1 //x=61.94 //y=7.41 //x2=61.94 //y2=7.585
r1897 (  819 1286 ) resistor r=33.1979 //w=0.187 //l=0.485 //layer=li \
 //thickness=0.1 //x=61.94 //y=7.41 //x2=61.94 //y2=6.925
r1898 (  816 1200 ) resistor r=2.87058 //w=0.35 //l=0.085 //layer=li \
 //thickness=0.1 //x=61.145 //y=7.585 //x2=61.06 //y2=7.585
r1899 (  816 818 ) resistor r=0.871935 //w=0.367 //l=0.025 //layer=li \
 //thickness=0.1 //x=61.145 //y=7.585 //x2=61.17 //y2=7.585
r1900 (  815 1201 ) resistor r=2.87058 //w=0.35 //l=0.085 //layer=li \
 //thickness=0.1 //x=61.855 //y=7.585 //x2=61.94 //y2=7.585
r1901 (  815 818 ) resistor r=23.891 //w=0.367 //l=0.685 //layer=li \
 //thickness=0.1 //x=61.855 //y=7.585 //x2=61.17 //y2=7.585
r1902 (  809 1200 ) resistor r=4.23183 //w=0.7 //l=0.175 //layer=li \
 //thickness=0.1 //x=61.06 //y=7.41 //x2=61.06 //y2=7.585
r1903 (  809 1285 ) resistor r=33.1979 //w=0.187 //l=0.485 //layer=li \
 //thickness=0.1 //x=61.06 //y=7.41 //x2=61.06 //y2=6.925
r1904 (  808 1199 ) resistor r=2.87058 //w=0.35 //l=0.085 //layer=li \
 //thickness=0.1 //x=60.265 //y=7.585 //x2=60.18 //y2=7.585
r1905 (  807 1200 ) resistor r=2.87058 //w=0.35 //l=0.085 //layer=li \
 //thickness=0.1 //x=60.975 //y=7.585 //x2=61.06 //y2=7.585
r1906 (  807 808 ) resistor r=24.7629 //w=0.367 //l=0.71 //layer=li \
 //thickness=0.1 //x=60.975 //y=7.585 //x2=60.265 //y2=7.585
r1907 (  801 1199 ) resistor r=4.23183 //w=0.7 //l=0.175 //layer=li \
 //thickness=0.1 //x=60.18 //y=7.41 //x2=60.18 //y2=7.585
r1908 (  801 1284 ) resistor r=33.1979 //w=0.187 //l=0.485 //layer=li \
 //thickness=0.1 //x=60.18 //y=7.41 //x2=60.18 //y2=6.925
r1909 (  798 1198 ) resistor r=2.87058 //w=0.35 //l=0.085 //layer=li \
 //thickness=0.1 //x=59.385 //y=7.585 //x2=59.3 //y2=7.585
r1910 (  798 800 ) resistor r=23.5422 //w=0.367 //l=0.675 //layer=li \
 //thickness=0.1 //x=59.385 //y=7.585 //x2=60.06 //y2=7.585
r1911 (  797 1199 ) resistor r=2.87058 //w=0.35 //l=0.085 //layer=li \
 //thickness=0.1 //x=60.095 //y=7.585 //x2=60.18 //y2=7.585
r1912 (  797 800 ) resistor r=1.22071 //w=0.367 //l=0.035 //layer=li \
 //thickness=0.1 //x=60.095 //y=7.585 //x2=60.06 //y2=7.585
r1913 (  789 1198 ) resistor r=4.23183 //w=0.7 //l=0.175 //layer=li \
 //thickness=0.1 //x=59.3 //y=7.41 //x2=59.3 //y2=7.585
r1914 (  789 1283 ) resistor r=56.4706 //w=0.187 //l=0.825 //layer=li \
 //thickness=0.1 //x=59.3 //y=7.41 //x2=59.3 //y2=6.585
r1915 (  786 1197 ) resistor r=5.29055 //w=0.35 //l=0.17 //layer=li \
 //thickness=0.1 //x=58.38 //y=7.585 //x2=58.21 //y2=7.585
r1916 (  786 788 ) resistor r=19.8801 //w=0.367 //l=0.57 //layer=li \
 //thickness=0.1 //x=58.38 //y=7.585 //x2=58.95 //y2=7.585
r1917 (  785 1198 ) resistor r=2.87058 //w=0.35 //l=0.085 //layer=li \
 //thickness=0.1 //x=59.215 //y=7.585 //x2=59.3 //y2=7.585
r1918 (  785 788 ) resistor r=9.24251 //w=0.367 //l=0.265 //layer=li \
 //thickness=0.1 //x=59.215 //y=7.585 //x2=58.95 //y2=7.585
r1919 (  780 1196 ) resistor r=2.87058 //w=0.35 //l=0.085 //layer=li \
 //thickness=0.1 //x=57.215 //y=7.585 //x2=57.13 //y2=7.585
r1920 (  780 782 ) resistor r=8.89373 //w=0.367 //l=0.255 //layer=li \
 //thickness=0.1 //x=57.215 //y=7.585 //x2=57.47 //y2=7.585
r1921 (  779 1197 ) resistor r=5.29055 //w=0.35 //l=0.17 //layer=li \
 //thickness=0.1 //x=58.04 //y=7.585 //x2=58.21 //y2=7.585
r1922 (  779 782 ) resistor r=19.8801 //w=0.367 //l=0.57 //layer=li \
 //thickness=0.1 //x=58.04 //y=7.585 //x2=57.47 //y2=7.585
r1923 (  773 1196 ) resistor r=4.23183 //w=0.7 //l=0.175 //layer=li \
 //thickness=0.1 //x=57.13 //y=7.41 //x2=57.13 //y2=7.585
r1924 (  773 1282 ) resistor r=33.1979 //w=0.187 //l=0.485 //layer=li \
 //thickness=0.1 //x=57.13 //y=7.41 //x2=57.13 //y2=6.925
r1925 (  770 1195 ) resistor r=2.87058 //w=0.35 //l=0.085 //layer=li \
 //thickness=0.1 //x=56.335 //y=7.585 //x2=56.25 //y2=7.585
r1926 (  770 772 ) resistor r=0.871935 //w=0.367 //l=0.025 //layer=li \
 //thickness=0.1 //x=56.335 //y=7.585 //x2=56.36 //y2=7.585
r1927 (  769 1196 ) resistor r=2.87058 //w=0.35 //l=0.085 //layer=li \
 //thickness=0.1 //x=57.045 //y=7.585 //x2=57.13 //y2=7.585
r1928 (  769 772 ) resistor r=23.891 //w=0.367 //l=0.685 //layer=li \
 //thickness=0.1 //x=57.045 //y=7.585 //x2=56.36 //y2=7.585
r1929 (  763 1195 ) resistor r=4.23183 //w=0.7 //l=0.175 //layer=li \
 //thickness=0.1 //x=56.25 //y=7.41 //x2=56.25 //y2=7.585
r1930 (  763 1281 ) resistor r=33.1979 //w=0.187 //l=0.485 //layer=li \
 //thickness=0.1 //x=56.25 //y=7.41 //x2=56.25 //y2=6.925
r1931 (  762 1194 ) resistor r=2.87058 //w=0.35 //l=0.085 //layer=li \
 //thickness=0.1 //x=55.455 //y=7.585 //x2=55.37 //y2=7.585
r1932 (  761 1195 ) resistor r=2.87058 //w=0.35 //l=0.085 //layer=li \
 //thickness=0.1 //x=56.165 //y=7.585 //x2=56.25 //y2=7.585
r1933 (  761 762 ) resistor r=24.7629 //w=0.367 //l=0.71 //layer=li \
 //thickness=0.1 //x=56.165 //y=7.585 //x2=55.455 //y2=7.585
r1934 (  755 1194 ) resistor r=4.23183 //w=0.7 //l=0.175 //layer=li \
 //thickness=0.1 //x=55.37 //y=7.41 //x2=55.37 //y2=7.585
r1935 (  755 1280 ) resistor r=33.1979 //w=0.187 //l=0.485 //layer=li \
 //thickness=0.1 //x=55.37 //y=7.41 //x2=55.37 //y2=6.925
r1936 (  752 1193 ) resistor r=2.87058 //w=0.35 //l=0.085 //layer=li \
 //thickness=0.1 //x=54.575 //y=7.585 //x2=54.49 //y2=7.585
r1937 (  752 754 ) resistor r=23.5422 //w=0.367 //l=0.675 //layer=li \
 //thickness=0.1 //x=54.575 //y=7.585 //x2=55.25 //y2=7.585
r1938 (  751 1194 ) resistor r=2.87058 //w=0.35 //l=0.085 //layer=li \
 //thickness=0.1 //x=55.285 //y=7.585 //x2=55.37 //y2=7.585
r1939 (  751 754 ) resistor r=1.22071 //w=0.367 //l=0.035 //layer=li \
 //thickness=0.1 //x=55.285 //y=7.585 //x2=55.25 //y2=7.585
r1940 (  743 1193 ) resistor r=4.23183 //w=0.7 //l=0.175 //layer=li \
 //thickness=0.1 //x=54.49 //y=7.41 //x2=54.49 //y2=7.585
r1941 (  743 1279 ) resistor r=56.4706 //w=0.187 //l=0.825 //layer=li \
 //thickness=0.1 //x=54.49 //y=7.41 //x2=54.49 //y2=6.585
r1942 (  740 1192 ) resistor r=5.29055 //w=0.35 //l=0.17 //layer=li \
 //thickness=0.1 //x=53.57 //y=7.585 //x2=53.4 //y2=7.585
r1943 (  740 742 ) resistor r=19.8801 //w=0.367 //l=0.57 //layer=li \
 //thickness=0.1 //x=53.57 //y=7.585 //x2=54.14 //y2=7.585
r1944 (  739 1193 ) resistor r=2.87058 //w=0.35 //l=0.085 //layer=li \
 //thickness=0.1 //x=54.405 //y=7.585 //x2=54.49 //y2=7.585
r1945 (  739 742 ) resistor r=9.24251 //w=0.367 //l=0.265 //layer=li \
 //thickness=0.1 //x=54.405 //y=7.585 //x2=54.14 //y2=7.585
r1946 (  734 1191 ) resistor r=2.87058 //w=0.35 //l=0.085 //layer=li \
 //thickness=0.1 //x=52.405 //y=7.585 //x2=52.32 //y2=7.585
r1947 (  734 736 ) resistor r=8.89373 //w=0.367 //l=0.255 //layer=li \
 //thickness=0.1 //x=52.405 //y=7.585 //x2=52.66 //y2=7.585
r1948 (  733 1192 ) resistor r=5.29055 //w=0.35 //l=0.17 //layer=li \
 //thickness=0.1 //x=53.23 //y=7.585 //x2=53.4 //y2=7.585
r1949 (  733 736 ) resistor r=19.8801 //w=0.367 //l=0.57 //layer=li \
 //thickness=0.1 //x=53.23 //y=7.585 //x2=52.66 //y2=7.585
r1950 (  727 1191 ) resistor r=4.23183 //w=0.7 //l=0.175 //layer=li \
 //thickness=0.1 //x=52.32 //y=7.41 //x2=52.32 //y2=7.585
r1951 (  727 1278 ) resistor r=33.1979 //w=0.187 //l=0.485 //layer=li \
 //thickness=0.1 //x=52.32 //y=7.41 //x2=52.32 //y2=6.925
r1952 (  724 1190 ) resistor r=2.87058 //w=0.35 //l=0.085 //layer=li \
 //thickness=0.1 //x=51.525 //y=7.585 //x2=51.44 //y2=7.585
r1953 (  724 726 ) resistor r=0.871935 //w=0.367 //l=0.025 //layer=li \
 //thickness=0.1 //x=51.525 //y=7.585 //x2=51.55 //y2=7.585
r1954 (  723 1191 ) resistor r=2.87058 //w=0.35 //l=0.085 //layer=li \
 //thickness=0.1 //x=52.235 //y=7.585 //x2=52.32 //y2=7.585
r1955 (  723 726 ) resistor r=23.891 //w=0.367 //l=0.685 //layer=li \
 //thickness=0.1 //x=52.235 //y=7.585 //x2=51.55 //y2=7.585
r1956 (  717 1190 ) resistor r=4.23183 //w=0.7 //l=0.175 //layer=li \
 //thickness=0.1 //x=51.44 //y=7.41 //x2=51.44 //y2=7.585
r1957 (  717 1277 ) resistor r=33.1979 //w=0.187 //l=0.485 //layer=li \
 //thickness=0.1 //x=51.44 //y=7.41 //x2=51.44 //y2=6.925
r1958 (  716 1189 ) resistor r=2.87058 //w=0.35 //l=0.085 //layer=li \
 //thickness=0.1 //x=50.645 //y=7.585 //x2=50.56 //y2=7.585
r1959 (  715 1190 ) resistor r=2.87058 //w=0.35 //l=0.085 //layer=li \
 //thickness=0.1 //x=51.355 //y=7.585 //x2=51.44 //y2=7.585
r1960 (  715 716 ) resistor r=24.7629 //w=0.367 //l=0.71 //layer=li \
 //thickness=0.1 //x=51.355 //y=7.585 //x2=50.645 //y2=7.585
r1961 (  709 1189 ) resistor r=4.23183 //w=0.7 //l=0.175 //layer=li \
 //thickness=0.1 //x=50.56 //y=7.41 //x2=50.56 //y2=7.585
r1962 (  709 1276 ) resistor r=33.1979 //w=0.187 //l=0.485 //layer=li \
 //thickness=0.1 //x=50.56 //y=7.41 //x2=50.56 //y2=6.925
r1963 (  706 1188 ) resistor r=2.87058 //w=0.35 //l=0.085 //layer=li \
 //thickness=0.1 //x=49.765 //y=7.585 //x2=49.68 //y2=7.585
r1964 (  706 708 ) resistor r=23.5422 //w=0.367 //l=0.675 //layer=li \
 //thickness=0.1 //x=49.765 //y=7.585 //x2=50.44 //y2=7.585
r1965 (  705 1189 ) resistor r=2.87058 //w=0.35 //l=0.085 //layer=li \
 //thickness=0.1 //x=50.475 //y=7.585 //x2=50.56 //y2=7.585
r1966 (  705 708 ) resistor r=1.22071 //w=0.367 //l=0.035 //layer=li \
 //thickness=0.1 //x=50.475 //y=7.585 //x2=50.44 //y2=7.585
r1967 (  697 1188 ) resistor r=4.23183 //w=0.7 //l=0.175 //layer=li \
 //thickness=0.1 //x=49.68 //y=7.41 //x2=49.68 //y2=7.585
r1968 (  697 1275 ) resistor r=56.4706 //w=0.187 //l=0.825 //layer=li \
 //thickness=0.1 //x=49.68 //y=7.41 //x2=49.68 //y2=6.585
r1969 (  694 1187 ) resistor r=5.29055 //w=0.35 //l=0.17 //layer=li \
 //thickness=0.1 //x=48.76 //y=7.585 //x2=48.59 //y2=7.585
r1970 (  694 696 ) resistor r=19.8801 //w=0.367 //l=0.57 //layer=li \
 //thickness=0.1 //x=48.76 //y=7.585 //x2=49.33 //y2=7.585
r1971 (  693 1188 ) resistor r=2.87058 //w=0.35 //l=0.085 //layer=li \
 //thickness=0.1 //x=49.595 //y=7.585 //x2=49.68 //y2=7.585
r1972 (  693 696 ) resistor r=9.24251 //w=0.367 //l=0.265 //layer=li \
 //thickness=0.1 //x=49.595 //y=7.585 //x2=49.33 //y2=7.585
r1973 (  688 1186 ) resistor r=2.87058 //w=0.35 //l=0.085 //layer=li \
 //thickness=0.1 //x=47.595 //y=7.585 //x2=47.51 //y2=7.585
r1974 (  688 690 ) resistor r=8.89373 //w=0.367 //l=0.255 //layer=li \
 //thickness=0.1 //x=47.595 //y=7.585 //x2=47.85 //y2=7.585
r1975 (  687 1187 ) resistor r=5.29055 //w=0.35 //l=0.17 //layer=li \
 //thickness=0.1 //x=48.42 //y=7.585 //x2=48.59 //y2=7.585
r1976 (  687 690 ) resistor r=19.8801 //w=0.367 //l=0.57 //layer=li \
 //thickness=0.1 //x=48.42 //y=7.585 //x2=47.85 //y2=7.585
r1977 (  681 1186 ) resistor r=4.23183 //w=0.7 //l=0.175 //layer=li \
 //thickness=0.1 //x=47.51 //y=7.41 //x2=47.51 //y2=7.585
r1978 (  681 1274 ) resistor r=33.1979 //w=0.187 //l=0.485 //layer=li \
 //thickness=0.1 //x=47.51 //y=7.41 //x2=47.51 //y2=6.925
r1979 (  678 1185 ) resistor r=2.87058 //w=0.35 //l=0.085 //layer=li \
 //thickness=0.1 //x=46.715 //y=7.585 //x2=46.63 //y2=7.585
r1980 (  678 680 ) resistor r=0.871935 //w=0.367 //l=0.025 //layer=li \
 //thickness=0.1 //x=46.715 //y=7.585 //x2=46.74 //y2=7.585
r1981 (  677 1186 ) resistor r=2.87058 //w=0.35 //l=0.085 //layer=li \
 //thickness=0.1 //x=47.425 //y=7.585 //x2=47.51 //y2=7.585
r1982 (  677 680 ) resistor r=23.891 //w=0.367 //l=0.685 //layer=li \
 //thickness=0.1 //x=47.425 //y=7.585 //x2=46.74 //y2=7.585
r1983 (  671 1185 ) resistor r=4.23183 //w=0.7 //l=0.175 //layer=li \
 //thickness=0.1 //x=46.63 //y=7.41 //x2=46.63 //y2=7.585
r1984 (  671 1273 ) resistor r=33.1979 //w=0.187 //l=0.485 //layer=li \
 //thickness=0.1 //x=46.63 //y=7.41 //x2=46.63 //y2=6.925
r1985 (  670 1184 ) resistor r=2.87058 //w=0.35 //l=0.085 //layer=li \
 //thickness=0.1 //x=45.835 //y=7.585 //x2=45.75 //y2=7.585
r1986 (  669 1185 ) resistor r=2.87058 //w=0.35 //l=0.085 //layer=li \
 //thickness=0.1 //x=46.545 //y=7.585 //x2=46.63 //y2=7.585
r1987 (  669 670 ) resistor r=24.7629 //w=0.367 //l=0.71 //layer=li \
 //thickness=0.1 //x=46.545 //y=7.585 //x2=45.835 //y2=7.585
r1988 (  663 1184 ) resistor r=4.23183 //w=0.7 //l=0.175 //layer=li \
 //thickness=0.1 //x=45.75 //y=7.41 //x2=45.75 //y2=7.585
r1989 (  663 1272 ) resistor r=33.1979 //w=0.187 //l=0.485 //layer=li \
 //thickness=0.1 //x=45.75 //y=7.41 //x2=45.75 //y2=6.925
r1990 (  660 1183 ) resistor r=2.87058 //w=0.35 //l=0.085 //layer=li \
 //thickness=0.1 //x=44.955 //y=7.585 //x2=44.87 //y2=7.585
r1991 (  660 662 ) resistor r=23.5422 //w=0.367 //l=0.675 //layer=li \
 //thickness=0.1 //x=44.955 //y=7.585 //x2=45.63 //y2=7.585
r1992 (  659 1184 ) resistor r=2.87058 //w=0.35 //l=0.085 //layer=li \
 //thickness=0.1 //x=45.665 //y=7.585 //x2=45.75 //y2=7.585
r1993 (  659 662 ) resistor r=1.22071 //w=0.367 //l=0.035 //layer=li \
 //thickness=0.1 //x=45.665 //y=7.585 //x2=45.63 //y2=7.585
r1994 (  651 1183 ) resistor r=4.23183 //w=0.7 //l=0.175 //layer=li \
 //thickness=0.1 //x=44.87 //y=7.41 //x2=44.87 //y2=7.585
r1995 (  651 1271 ) resistor r=56.4706 //w=0.187 //l=0.825 //layer=li \
 //thickness=0.1 //x=44.87 //y=7.41 //x2=44.87 //y2=6.585
r1996 (  648 1182 ) resistor r=5.29055 //w=0.35 //l=0.17 //layer=li \
 //thickness=0.1 //x=43.95 //y=7.585 //x2=43.78 //y2=7.585
r1997 (  648 650 ) resistor r=19.8801 //w=0.367 //l=0.57 //layer=li \
 //thickness=0.1 //x=43.95 //y=7.585 //x2=44.52 //y2=7.585
r1998 (  647 1183 ) resistor r=2.87058 //w=0.35 //l=0.085 //layer=li \
 //thickness=0.1 //x=44.785 //y=7.585 //x2=44.87 //y2=7.585
r1999 (  647 650 ) resistor r=9.24251 //w=0.367 //l=0.265 //layer=li \
 //thickness=0.1 //x=44.785 //y=7.585 //x2=44.52 //y2=7.585
r2000 (  642 1181 ) resistor r=2.87058 //w=0.35 //l=0.085 //layer=li \
 //thickness=0.1 //x=42.785 //y=7.585 //x2=42.7 //y2=7.585
r2001 (  642 644 ) resistor r=8.89373 //w=0.367 //l=0.255 //layer=li \
 //thickness=0.1 //x=42.785 //y=7.585 //x2=43.04 //y2=7.585
r2002 (  641 1182 ) resistor r=5.29055 //w=0.35 //l=0.17 //layer=li \
 //thickness=0.1 //x=43.61 //y=7.585 //x2=43.78 //y2=7.585
r2003 (  641 644 ) resistor r=19.8801 //w=0.367 //l=0.57 //layer=li \
 //thickness=0.1 //x=43.61 //y=7.585 //x2=43.04 //y2=7.585
r2004 (  635 1181 ) resistor r=4.23183 //w=0.7 //l=0.175 //layer=li \
 //thickness=0.1 //x=42.7 //y=7.41 //x2=42.7 //y2=7.585
r2005 (  635 1270 ) resistor r=33.1979 //w=0.187 //l=0.485 //layer=li \
 //thickness=0.1 //x=42.7 //y=7.41 //x2=42.7 //y2=6.925
r2006 (  632 1180 ) resistor r=2.87058 //w=0.35 //l=0.085 //layer=li \
 //thickness=0.1 //x=41.905 //y=7.585 //x2=41.82 //y2=7.585
r2007 (  632 634 ) resistor r=0.871935 //w=0.367 //l=0.025 //layer=li \
 //thickness=0.1 //x=41.905 //y=7.585 //x2=41.93 //y2=7.585
r2008 (  631 1181 ) resistor r=2.87058 //w=0.35 //l=0.085 //layer=li \
 //thickness=0.1 //x=42.615 //y=7.585 //x2=42.7 //y2=7.585
r2009 (  631 634 ) resistor r=23.891 //w=0.367 //l=0.685 //layer=li \
 //thickness=0.1 //x=42.615 //y=7.585 //x2=41.93 //y2=7.585
r2010 (  625 1180 ) resistor r=4.23183 //w=0.7 //l=0.175 //layer=li \
 //thickness=0.1 //x=41.82 //y=7.41 //x2=41.82 //y2=7.585
r2011 (  625 1269 ) resistor r=33.1979 //w=0.187 //l=0.485 //layer=li \
 //thickness=0.1 //x=41.82 //y=7.41 //x2=41.82 //y2=6.925
r2012 (  624 1179 ) resistor r=2.87058 //w=0.35 //l=0.085 //layer=li \
 //thickness=0.1 //x=41.025 //y=7.585 //x2=40.94 //y2=7.585
r2013 (  623 1180 ) resistor r=2.87058 //w=0.35 //l=0.085 //layer=li \
 //thickness=0.1 //x=41.735 //y=7.585 //x2=41.82 //y2=7.585
r2014 (  623 624 ) resistor r=24.7629 //w=0.367 //l=0.71 //layer=li \
 //thickness=0.1 //x=41.735 //y=7.585 //x2=41.025 //y2=7.585
r2015 (  617 1179 ) resistor r=4.23183 //w=0.7 //l=0.175 //layer=li \
 //thickness=0.1 //x=40.94 //y=7.41 //x2=40.94 //y2=7.585
r2016 (  617 1268 ) resistor r=33.1979 //w=0.187 //l=0.485 //layer=li \
 //thickness=0.1 //x=40.94 //y=7.41 //x2=40.94 //y2=6.925
r2017 (  614 1178 ) resistor r=2.87058 //w=0.35 //l=0.085 //layer=li \
 //thickness=0.1 //x=40.145 //y=7.585 //x2=40.06 //y2=7.585
r2018 (  614 616 ) resistor r=23.5422 //w=0.367 //l=0.675 //layer=li \
 //thickness=0.1 //x=40.145 //y=7.585 //x2=40.82 //y2=7.585
r2019 (  613 1179 ) resistor r=2.87058 //w=0.35 //l=0.085 //layer=li \
 //thickness=0.1 //x=40.855 //y=7.585 //x2=40.94 //y2=7.585
r2020 (  613 616 ) resistor r=1.22071 //w=0.367 //l=0.035 //layer=li \
 //thickness=0.1 //x=40.855 //y=7.585 //x2=40.82 //y2=7.585
r2021 (  605 1178 ) resistor r=4.23183 //w=0.7 //l=0.175 //layer=li \
 //thickness=0.1 //x=40.06 //y=7.41 //x2=40.06 //y2=7.585
r2022 (  605 1267 ) resistor r=56.4706 //w=0.187 //l=0.825 //layer=li \
 //thickness=0.1 //x=40.06 //y=7.41 //x2=40.06 //y2=6.585
r2023 (  602 1177 ) resistor r=5.29055 //w=0.35 //l=0.17 //layer=li \
 //thickness=0.1 //x=39.14 //y=7.585 //x2=38.97 //y2=7.585
r2024 (  602 604 ) resistor r=19.8801 //w=0.367 //l=0.57 //layer=li \
 //thickness=0.1 //x=39.14 //y=7.585 //x2=39.71 //y2=7.585
r2025 (  601 1178 ) resistor r=2.87058 //w=0.35 //l=0.085 //layer=li \
 //thickness=0.1 //x=39.975 //y=7.585 //x2=40.06 //y2=7.585
r2026 (  601 604 ) resistor r=9.24251 //w=0.367 //l=0.265 //layer=li \
 //thickness=0.1 //x=39.975 //y=7.585 //x2=39.71 //y2=7.585
r2027 (  596 1176 ) resistor r=2.87058 //w=0.35 //l=0.085 //layer=li \
 //thickness=0.1 //x=37.975 //y=7.585 //x2=37.89 //y2=7.585
r2028 (  596 598 ) resistor r=8.89373 //w=0.367 //l=0.255 //layer=li \
 //thickness=0.1 //x=37.975 //y=7.585 //x2=38.23 //y2=7.585
r2029 (  595 1177 ) resistor r=5.29055 //w=0.35 //l=0.17 //layer=li \
 //thickness=0.1 //x=38.8 //y=7.585 //x2=38.97 //y2=7.585
r2030 (  595 598 ) resistor r=19.8801 //w=0.367 //l=0.57 //layer=li \
 //thickness=0.1 //x=38.8 //y=7.585 //x2=38.23 //y2=7.585
r2031 (  589 1176 ) resistor r=4.23183 //w=0.7 //l=0.175 //layer=li \
 //thickness=0.1 //x=37.89 //y=7.41 //x2=37.89 //y2=7.585
r2032 (  589 1266 ) resistor r=33.1979 //w=0.187 //l=0.485 //layer=li \
 //thickness=0.1 //x=37.89 //y=7.41 //x2=37.89 //y2=6.925
r2033 (  586 1175 ) resistor r=2.87058 //w=0.35 //l=0.085 //layer=li \
 //thickness=0.1 //x=37.095 //y=7.585 //x2=37.01 //y2=7.585
r2034 (  586 588 ) resistor r=0.871935 //w=0.367 //l=0.025 //layer=li \
 //thickness=0.1 //x=37.095 //y=7.585 //x2=37.12 //y2=7.585
r2035 (  585 1176 ) resistor r=2.87058 //w=0.35 //l=0.085 //layer=li \
 //thickness=0.1 //x=37.805 //y=7.585 //x2=37.89 //y2=7.585
r2036 (  585 588 ) resistor r=23.891 //w=0.367 //l=0.685 //layer=li \
 //thickness=0.1 //x=37.805 //y=7.585 //x2=37.12 //y2=7.585
r2037 (  579 1175 ) resistor r=4.23183 //w=0.7 //l=0.175 //layer=li \
 //thickness=0.1 //x=37.01 //y=7.41 //x2=37.01 //y2=7.585
r2038 (  579 1265 ) resistor r=33.1979 //w=0.187 //l=0.485 //layer=li \
 //thickness=0.1 //x=37.01 //y=7.41 //x2=37.01 //y2=6.925
r2039 (  578 1174 ) resistor r=2.87058 //w=0.35 //l=0.085 //layer=li \
 //thickness=0.1 //x=36.215 //y=7.585 //x2=36.13 //y2=7.585
r2040 (  577 1175 ) resistor r=2.87058 //w=0.35 //l=0.085 //layer=li \
 //thickness=0.1 //x=36.925 //y=7.585 //x2=37.01 //y2=7.585
r2041 (  577 578 ) resistor r=24.7629 //w=0.367 //l=0.71 //layer=li \
 //thickness=0.1 //x=36.925 //y=7.585 //x2=36.215 //y2=7.585
r2042 (  571 1174 ) resistor r=4.23183 //w=0.7 //l=0.175 //layer=li \
 //thickness=0.1 //x=36.13 //y=7.41 //x2=36.13 //y2=7.585
r2043 (  571 1264 ) resistor r=33.1979 //w=0.187 //l=0.485 //layer=li \
 //thickness=0.1 //x=36.13 //y=7.41 //x2=36.13 //y2=6.925
r2044 (  568 1173 ) resistor r=2.87058 //w=0.35 //l=0.085 //layer=li \
 //thickness=0.1 //x=35.335 //y=7.585 //x2=35.25 //y2=7.585
r2045 (  568 570 ) resistor r=23.5422 //w=0.367 //l=0.675 //layer=li \
 //thickness=0.1 //x=35.335 //y=7.585 //x2=36.01 //y2=7.585
r2046 (  567 1174 ) resistor r=2.87058 //w=0.35 //l=0.085 //layer=li \
 //thickness=0.1 //x=36.045 //y=7.585 //x2=36.13 //y2=7.585
r2047 (  567 570 ) resistor r=1.22071 //w=0.367 //l=0.035 //layer=li \
 //thickness=0.1 //x=36.045 //y=7.585 //x2=36.01 //y2=7.585
r2048 (  559 1173 ) resistor r=4.23183 //w=0.7 //l=0.175 //layer=li \
 //thickness=0.1 //x=35.25 //y=7.41 //x2=35.25 //y2=7.585
r2049 (  559 1263 ) resistor r=56.4706 //w=0.187 //l=0.825 //layer=li \
 //thickness=0.1 //x=35.25 //y=7.41 //x2=35.25 //y2=6.585
r2050 (  556 1172 ) resistor r=5.29055 //w=0.35 //l=0.17 //layer=li \
 //thickness=0.1 //x=34.33 //y=7.585 //x2=34.16 //y2=7.585
r2051 (  556 558 ) resistor r=19.8801 //w=0.367 //l=0.57 //layer=li \
 //thickness=0.1 //x=34.33 //y=7.585 //x2=34.9 //y2=7.585
r2052 (  555 1173 ) resistor r=2.87058 //w=0.35 //l=0.085 //layer=li \
 //thickness=0.1 //x=35.165 //y=7.585 //x2=35.25 //y2=7.585
r2053 (  555 558 ) resistor r=9.24251 //w=0.367 //l=0.265 //layer=li \
 //thickness=0.1 //x=35.165 //y=7.585 //x2=34.9 //y2=7.585
r2054 (  550 1171 ) resistor r=2.87058 //w=0.35 //l=0.085 //layer=li \
 //thickness=0.1 //x=33.165 //y=7.585 //x2=33.08 //y2=7.585
r2055 (  550 552 ) resistor r=8.89373 //w=0.367 //l=0.255 //layer=li \
 //thickness=0.1 //x=33.165 //y=7.585 //x2=33.42 //y2=7.585
r2056 (  549 1172 ) resistor r=5.29055 //w=0.35 //l=0.17 //layer=li \
 //thickness=0.1 //x=33.99 //y=7.585 //x2=34.16 //y2=7.585
r2057 (  549 552 ) resistor r=19.8801 //w=0.367 //l=0.57 //layer=li \
 //thickness=0.1 //x=33.99 //y=7.585 //x2=33.42 //y2=7.585
r2058 (  543 1171 ) resistor r=4.23183 //w=0.7 //l=0.175 //layer=li \
 //thickness=0.1 //x=33.08 //y=7.41 //x2=33.08 //y2=7.585
r2059 (  543 1262 ) resistor r=33.1979 //w=0.187 //l=0.485 //layer=li \
 //thickness=0.1 //x=33.08 //y=7.41 //x2=33.08 //y2=6.925
r2060 (  540 1170 ) resistor r=2.87058 //w=0.35 //l=0.085 //layer=li \
 //thickness=0.1 //x=32.285 //y=7.585 //x2=32.2 //y2=7.585
r2061 (  540 542 ) resistor r=0.871935 //w=0.367 //l=0.025 //layer=li \
 //thickness=0.1 //x=32.285 //y=7.585 //x2=32.31 //y2=7.585
r2062 (  539 1171 ) resistor r=2.87058 //w=0.35 //l=0.085 //layer=li \
 //thickness=0.1 //x=32.995 //y=7.585 //x2=33.08 //y2=7.585
r2063 (  539 542 ) resistor r=23.891 //w=0.367 //l=0.685 //layer=li \
 //thickness=0.1 //x=32.995 //y=7.585 //x2=32.31 //y2=7.585
r2064 (  533 1170 ) resistor r=4.23183 //w=0.7 //l=0.175 //layer=li \
 //thickness=0.1 //x=32.2 //y=7.41 //x2=32.2 //y2=7.585
r2065 (  533 1261 ) resistor r=33.1979 //w=0.187 //l=0.485 //layer=li \
 //thickness=0.1 //x=32.2 //y=7.41 //x2=32.2 //y2=6.925
r2066 (  532 1169 ) resistor r=2.87058 //w=0.35 //l=0.085 //layer=li \
 //thickness=0.1 //x=31.405 //y=7.585 //x2=31.32 //y2=7.585
r2067 (  531 1170 ) resistor r=2.87058 //w=0.35 //l=0.085 //layer=li \
 //thickness=0.1 //x=32.115 //y=7.585 //x2=32.2 //y2=7.585
r2068 (  531 532 ) resistor r=24.7629 //w=0.367 //l=0.71 //layer=li \
 //thickness=0.1 //x=32.115 //y=7.585 //x2=31.405 //y2=7.585
r2069 (  525 1169 ) resistor r=4.23183 //w=0.7 //l=0.175 //layer=li \
 //thickness=0.1 //x=31.32 //y=7.41 //x2=31.32 //y2=7.585
r2070 (  525 1260 ) resistor r=33.1979 //w=0.187 //l=0.485 //layer=li \
 //thickness=0.1 //x=31.32 //y=7.41 //x2=31.32 //y2=6.925
r2071 (  522 1168 ) resistor r=2.87058 //w=0.35 //l=0.085 //layer=li \
 //thickness=0.1 //x=30.525 //y=7.585 //x2=30.44 //y2=7.585
r2072 (  522 524 ) resistor r=23.5422 //w=0.367 //l=0.675 //layer=li \
 //thickness=0.1 //x=30.525 //y=7.585 //x2=31.2 //y2=7.585
r2073 (  521 1169 ) resistor r=2.87058 //w=0.35 //l=0.085 //layer=li \
 //thickness=0.1 //x=31.235 //y=7.585 //x2=31.32 //y2=7.585
r2074 (  521 524 ) resistor r=1.22071 //w=0.367 //l=0.035 //layer=li \
 //thickness=0.1 //x=31.235 //y=7.585 //x2=31.2 //y2=7.585
r2075 (  513 1168 ) resistor r=4.23183 //w=0.7 //l=0.175 //layer=li \
 //thickness=0.1 //x=30.44 //y=7.41 //x2=30.44 //y2=7.585
r2076 (  513 1259 ) resistor r=56.4706 //w=0.187 //l=0.825 //layer=li \
 //thickness=0.1 //x=30.44 //y=7.41 //x2=30.44 //y2=6.585
r2077 (  510 1167 ) resistor r=5.29055 //w=0.35 //l=0.17 //layer=li \
 //thickness=0.1 //x=29.52 //y=7.585 //x2=29.35 //y2=7.585
r2078 (  510 512 ) resistor r=19.8801 //w=0.367 //l=0.57 //layer=li \
 //thickness=0.1 //x=29.52 //y=7.585 //x2=30.09 //y2=7.585
r2079 (  509 1168 ) resistor r=2.87058 //w=0.35 //l=0.085 //layer=li \
 //thickness=0.1 //x=30.355 //y=7.585 //x2=30.44 //y2=7.585
r2080 (  509 512 ) resistor r=9.24251 //w=0.367 //l=0.265 //layer=li \
 //thickness=0.1 //x=30.355 //y=7.585 //x2=30.09 //y2=7.585
r2081 (  504 1166 ) resistor r=2.87058 //w=0.35 //l=0.085 //layer=li \
 //thickness=0.1 //x=28.355 //y=7.585 //x2=28.27 //y2=7.585
r2082 (  504 506 ) resistor r=8.89373 //w=0.367 //l=0.255 //layer=li \
 //thickness=0.1 //x=28.355 //y=7.585 //x2=28.61 //y2=7.585
r2083 (  503 1167 ) resistor r=5.29055 //w=0.35 //l=0.17 //layer=li \
 //thickness=0.1 //x=29.18 //y=7.585 //x2=29.35 //y2=7.585
r2084 (  503 506 ) resistor r=19.8801 //w=0.367 //l=0.57 //layer=li \
 //thickness=0.1 //x=29.18 //y=7.585 //x2=28.61 //y2=7.585
r2085 (  497 1166 ) resistor r=4.23183 //w=0.7 //l=0.175 //layer=li \
 //thickness=0.1 //x=28.27 //y=7.41 //x2=28.27 //y2=7.585
r2086 (  497 1258 ) resistor r=33.1979 //w=0.187 //l=0.485 //layer=li \
 //thickness=0.1 //x=28.27 //y=7.41 //x2=28.27 //y2=6.925
r2087 (  494 1165 ) resistor r=2.87058 //w=0.35 //l=0.085 //layer=li \
 //thickness=0.1 //x=27.475 //y=7.585 //x2=27.39 //y2=7.585
r2088 (  494 496 ) resistor r=0.871935 //w=0.367 //l=0.025 //layer=li \
 //thickness=0.1 //x=27.475 //y=7.585 //x2=27.5 //y2=7.585
r2089 (  493 1166 ) resistor r=2.87058 //w=0.35 //l=0.085 //layer=li \
 //thickness=0.1 //x=28.185 //y=7.585 //x2=28.27 //y2=7.585
r2090 (  493 496 ) resistor r=23.891 //w=0.367 //l=0.685 //layer=li \
 //thickness=0.1 //x=28.185 //y=7.585 //x2=27.5 //y2=7.585
r2091 (  487 1165 ) resistor r=4.23183 //w=0.7 //l=0.175 //layer=li \
 //thickness=0.1 //x=27.39 //y=7.41 //x2=27.39 //y2=7.585
r2092 (  487 1257 ) resistor r=33.1979 //w=0.187 //l=0.485 //layer=li \
 //thickness=0.1 //x=27.39 //y=7.41 //x2=27.39 //y2=6.925
r2093 (  486 1164 ) resistor r=2.87058 //w=0.35 //l=0.085 //layer=li \
 //thickness=0.1 //x=26.595 //y=7.585 //x2=26.51 //y2=7.585
r2094 (  485 1165 ) resistor r=2.87058 //w=0.35 //l=0.085 //layer=li \
 //thickness=0.1 //x=27.305 //y=7.585 //x2=27.39 //y2=7.585
r2095 (  485 486 ) resistor r=24.7629 //w=0.367 //l=0.71 //layer=li \
 //thickness=0.1 //x=27.305 //y=7.585 //x2=26.595 //y2=7.585
r2096 (  479 1164 ) resistor r=4.23183 //w=0.7 //l=0.175 //layer=li \
 //thickness=0.1 //x=26.51 //y=7.41 //x2=26.51 //y2=7.585
r2097 (  479 1256 ) resistor r=33.1979 //w=0.187 //l=0.485 //layer=li \
 //thickness=0.1 //x=26.51 //y=7.41 //x2=26.51 //y2=6.925
r2098 (  476 1163 ) resistor r=2.87058 //w=0.35 //l=0.085 //layer=li \
 //thickness=0.1 //x=25.715 //y=7.585 //x2=25.63 //y2=7.585
r2099 (  476 478 ) resistor r=23.5422 //w=0.367 //l=0.675 //layer=li \
 //thickness=0.1 //x=25.715 //y=7.585 //x2=26.39 //y2=7.585
r2100 (  475 1164 ) resistor r=2.87058 //w=0.35 //l=0.085 //layer=li \
 //thickness=0.1 //x=26.425 //y=7.585 //x2=26.51 //y2=7.585
r2101 (  475 478 ) resistor r=1.22071 //w=0.367 //l=0.035 //layer=li \
 //thickness=0.1 //x=26.425 //y=7.585 //x2=26.39 //y2=7.585
r2102 (  467 1163 ) resistor r=4.23183 //w=0.7 //l=0.175 //layer=li \
 //thickness=0.1 //x=25.63 //y=7.41 //x2=25.63 //y2=7.585
r2103 (  467 1255 ) resistor r=56.4706 //w=0.187 //l=0.825 //layer=li \
 //thickness=0.1 //x=25.63 //y=7.41 //x2=25.63 //y2=6.585
r2104 (  464 1162 ) resistor r=5.29055 //w=0.35 //l=0.17 //layer=li \
 //thickness=0.1 //x=24.71 //y=7.585 //x2=24.54 //y2=7.585
r2105 (  464 466 ) resistor r=19.8801 //w=0.367 //l=0.57 //layer=li \
 //thickness=0.1 //x=24.71 //y=7.585 //x2=25.28 //y2=7.585
r2106 (  463 1163 ) resistor r=2.87058 //w=0.35 //l=0.085 //layer=li \
 //thickness=0.1 //x=25.545 //y=7.585 //x2=25.63 //y2=7.585
r2107 (  463 466 ) resistor r=9.24251 //w=0.367 //l=0.265 //layer=li \
 //thickness=0.1 //x=25.545 //y=7.585 //x2=25.28 //y2=7.585
r2108 (  458 1161 ) resistor r=2.87058 //w=0.35 //l=0.085 //layer=li \
 //thickness=0.1 //x=23.545 //y=7.585 //x2=23.46 //y2=7.585
r2109 (  458 460 ) resistor r=8.89373 //w=0.367 //l=0.255 //layer=li \
 //thickness=0.1 //x=23.545 //y=7.585 //x2=23.8 //y2=7.585
r2110 (  457 1162 ) resistor r=5.29055 //w=0.35 //l=0.17 //layer=li \
 //thickness=0.1 //x=24.37 //y=7.585 //x2=24.54 //y2=7.585
r2111 (  457 460 ) resistor r=19.8801 //w=0.367 //l=0.57 //layer=li \
 //thickness=0.1 //x=24.37 //y=7.585 //x2=23.8 //y2=7.585
r2112 (  451 1161 ) resistor r=4.23183 //w=0.7 //l=0.175 //layer=li \
 //thickness=0.1 //x=23.46 //y=7.41 //x2=23.46 //y2=7.585
r2113 (  451 1254 ) resistor r=33.1979 //w=0.187 //l=0.485 //layer=li \
 //thickness=0.1 //x=23.46 //y=7.41 //x2=23.46 //y2=6.925
r2114 (  448 1160 ) resistor r=2.87058 //w=0.35 //l=0.085 //layer=li \
 //thickness=0.1 //x=22.665 //y=7.585 //x2=22.58 //y2=7.585
r2115 (  448 450 ) resistor r=0.871935 //w=0.367 //l=0.025 //layer=li \
 //thickness=0.1 //x=22.665 //y=7.585 //x2=22.69 //y2=7.585
r2116 (  447 1161 ) resistor r=2.87058 //w=0.35 //l=0.085 //layer=li \
 //thickness=0.1 //x=23.375 //y=7.585 //x2=23.46 //y2=7.585
r2117 (  447 450 ) resistor r=23.891 //w=0.367 //l=0.685 //layer=li \
 //thickness=0.1 //x=23.375 //y=7.585 //x2=22.69 //y2=7.585
r2118 (  441 1160 ) resistor r=4.23183 //w=0.7 //l=0.175 //layer=li \
 //thickness=0.1 //x=22.58 //y=7.41 //x2=22.58 //y2=7.585
r2119 (  441 1253 ) resistor r=33.1979 //w=0.187 //l=0.485 //layer=li \
 //thickness=0.1 //x=22.58 //y=7.41 //x2=22.58 //y2=6.925
r2120 (  440 1159 ) resistor r=2.87058 //w=0.35 //l=0.085 //layer=li \
 //thickness=0.1 //x=21.785 //y=7.585 //x2=21.7 //y2=7.585
r2121 (  439 1160 ) resistor r=2.87058 //w=0.35 //l=0.085 //layer=li \
 //thickness=0.1 //x=22.495 //y=7.585 //x2=22.58 //y2=7.585
r2122 (  439 440 ) resistor r=24.7629 //w=0.367 //l=0.71 //layer=li \
 //thickness=0.1 //x=22.495 //y=7.585 //x2=21.785 //y2=7.585
r2123 (  433 1159 ) resistor r=4.23183 //w=0.7 //l=0.175 //layer=li \
 //thickness=0.1 //x=21.7 //y=7.41 //x2=21.7 //y2=7.585
r2124 (  433 1252 ) resistor r=33.1979 //w=0.187 //l=0.485 //layer=li \
 //thickness=0.1 //x=21.7 //y=7.41 //x2=21.7 //y2=6.925
r2125 (  430 1158 ) resistor r=2.87058 //w=0.35 //l=0.085 //layer=li \
 //thickness=0.1 //x=20.905 //y=7.585 //x2=20.82 //y2=7.585
r2126 (  430 432 ) resistor r=23.5422 //w=0.367 //l=0.675 //layer=li \
 //thickness=0.1 //x=20.905 //y=7.585 //x2=21.58 //y2=7.585
r2127 (  429 1159 ) resistor r=2.87058 //w=0.35 //l=0.085 //layer=li \
 //thickness=0.1 //x=21.615 //y=7.585 //x2=21.7 //y2=7.585
r2128 (  429 432 ) resistor r=1.22071 //w=0.367 //l=0.035 //layer=li \
 //thickness=0.1 //x=21.615 //y=7.585 //x2=21.58 //y2=7.585
r2129 (  421 1158 ) resistor r=4.23183 //w=0.7 //l=0.175 //layer=li \
 //thickness=0.1 //x=20.82 //y=7.41 //x2=20.82 //y2=7.585
r2130 (  421 1251 ) resistor r=56.4706 //w=0.187 //l=0.825 //layer=li \
 //thickness=0.1 //x=20.82 //y=7.41 //x2=20.82 //y2=6.585
r2131 (  418 1157 ) resistor r=5.29055 //w=0.35 //l=0.17 //layer=li \
 //thickness=0.1 //x=19.9 //y=7.585 //x2=19.73 //y2=7.585
r2132 (  418 420 ) resistor r=19.8801 //w=0.367 //l=0.57 //layer=li \
 //thickness=0.1 //x=19.9 //y=7.585 //x2=20.47 //y2=7.585
r2133 (  417 1158 ) resistor r=2.87058 //w=0.35 //l=0.085 //layer=li \
 //thickness=0.1 //x=20.735 //y=7.585 //x2=20.82 //y2=7.585
r2134 (  417 420 ) resistor r=9.24251 //w=0.367 //l=0.265 //layer=li \
 //thickness=0.1 //x=20.735 //y=7.585 //x2=20.47 //y2=7.585
r2135 (  412 1156 ) resistor r=2.87058 //w=0.35 //l=0.085 //layer=li \
 //thickness=0.1 //x=18.735 //y=7.585 //x2=18.65 //y2=7.585
r2136 (  412 414 ) resistor r=8.89373 //w=0.367 //l=0.255 //layer=li \
 //thickness=0.1 //x=18.735 //y=7.585 //x2=18.99 //y2=7.585
r2137 (  411 1157 ) resistor r=5.29055 //w=0.35 //l=0.17 //layer=li \
 //thickness=0.1 //x=19.56 //y=7.585 //x2=19.73 //y2=7.585
r2138 (  411 414 ) resistor r=19.8801 //w=0.367 //l=0.57 //layer=li \
 //thickness=0.1 //x=19.56 //y=7.585 //x2=18.99 //y2=7.585
r2139 (  405 1156 ) resistor r=4.23183 //w=0.7 //l=0.175 //layer=li \
 //thickness=0.1 //x=18.65 //y=7.41 //x2=18.65 //y2=7.585
r2140 (  405 1250 ) resistor r=33.1979 //w=0.187 //l=0.485 //layer=li \
 //thickness=0.1 //x=18.65 //y=7.41 //x2=18.65 //y2=6.925
r2141 (  402 1155 ) resistor r=2.87058 //w=0.35 //l=0.085 //layer=li \
 //thickness=0.1 //x=17.855 //y=7.585 //x2=17.77 //y2=7.585
r2142 (  402 404 ) resistor r=0.871935 //w=0.367 //l=0.025 //layer=li \
 //thickness=0.1 //x=17.855 //y=7.585 //x2=17.88 //y2=7.585
r2143 (  401 1156 ) resistor r=2.87058 //w=0.35 //l=0.085 //layer=li \
 //thickness=0.1 //x=18.565 //y=7.585 //x2=18.65 //y2=7.585
r2144 (  401 404 ) resistor r=23.891 //w=0.367 //l=0.685 //layer=li \
 //thickness=0.1 //x=18.565 //y=7.585 //x2=17.88 //y2=7.585
r2145 (  395 1155 ) resistor r=4.23183 //w=0.7 //l=0.175 //layer=li \
 //thickness=0.1 //x=17.77 //y=7.41 //x2=17.77 //y2=7.585
r2146 (  395 1249 ) resistor r=33.1979 //w=0.187 //l=0.485 //layer=li \
 //thickness=0.1 //x=17.77 //y=7.41 //x2=17.77 //y2=6.925
r2147 (  394 1154 ) resistor r=2.87058 //w=0.35 //l=0.085 //layer=li \
 //thickness=0.1 //x=16.975 //y=7.585 //x2=16.89 //y2=7.585
r2148 (  393 1155 ) resistor r=2.87058 //w=0.35 //l=0.085 //layer=li \
 //thickness=0.1 //x=17.685 //y=7.585 //x2=17.77 //y2=7.585
r2149 (  393 394 ) resistor r=24.7629 //w=0.367 //l=0.71 //layer=li \
 //thickness=0.1 //x=17.685 //y=7.585 //x2=16.975 //y2=7.585
r2150 (  387 1154 ) resistor r=4.23183 //w=0.7 //l=0.175 //layer=li \
 //thickness=0.1 //x=16.89 //y=7.41 //x2=16.89 //y2=7.585
r2151 (  387 1248 ) resistor r=33.1979 //w=0.187 //l=0.485 //layer=li \
 //thickness=0.1 //x=16.89 //y=7.41 //x2=16.89 //y2=6.925
r2152 (  384 1153 ) resistor r=2.87058 //w=0.35 //l=0.085 //layer=li \
 //thickness=0.1 //x=16.095 //y=7.585 //x2=16.01 //y2=7.585
r2153 (  384 386 ) resistor r=23.5422 //w=0.367 //l=0.675 //layer=li \
 //thickness=0.1 //x=16.095 //y=7.585 //x2=16.77 //y2=7.585
r2154 (  383 1154 ) resistor r=2.87058 //w=0.35 //l=0.085 //layer=li \
 //thickness=0.1 //x=16.805 //y=7.585 //x2=16.89 //y2=7.585
r2155 (  383 386 ) resistor r=1.22071 //w=0.367 //l=0.035 //layer=li \
 //thickness=0.1 //x=16.805 //y=7.585 //x2=16.77 //y2=7.585
r2156 (  375 1153 ) resistor r=4.23183 //w=0.7 //l=0.175 //layer=li \
 //thickness=0.1 //x=16.01 //y=7.41 //x2=16.01 //y2=7.585
r2157 (  375 1247 ) resistor r=56.4706 //w=0.187 //l=0.825 //layer=li \
 //thickness=0.1 //x=16.01 //y=7.41 //x2=16.01 //y2=6.585
r2158 (  372 1152 ) resistor r=5.29055 //w=0.35 //l=0.17 //layer=li \
 //thickness=0.1 //x=15.09 //y=7.585 //x2=14.92 //y2=7.585
r2159 (  372 374 ) resistor r=19.8801 //w=0.367 //l=0.57 //layer=li \
 //thickness=0.1 //x=15.09 //y=7.585 //x2=15.66 //y2=7.585
r2160 (  371 1153 ) resistor r=2.87058 //w=0.35 //l=0.085 //layer=li \
 //thickness=0.1 //x=15.925 //y=7.585 //x2=16.01 //y2=7.585
r2161 (  371 374 ) resistor r=9.24251 //w=0.367 //l=0.265 //layer=li \
 //thickness=0.1 //x=15.925 //y=7.585 //x2=15.66 //y2=7.585
r2162 (  366 1151 ) resistor r=2.87058 //w=0.35 //l=0.085 //layer=li \
 //thickness=0.1 //x=13.925 //y=7.585 //x2=13.84 //y2=7.585
r2163 (  366 368 ) resistor r=8.89373 //w=0.367 //l=0.255 //layer=li \
 //thickness=0.1 //x=13.925 //y=7.585 //x2=14.18 //y2=7.585
r2164 (  365 1152 ) resistor r=5.29055 //w=0.35 //l=0.17 //layer=li \
 //thickness=0.1 //x=14.75 //y=7.585 //x2=14.92 //y2=7.585
r2165 (  365 368 ) resistor r=19.8801 //w=0.367 //l=0.57 //layer=li \
 //thickness=0.1 //x=14.75 //y=7.585 //x2=14.18 //y2=7.585
r2166 (  359 1151 ) resistor r=4.23183 //w=0.7 //l=0.175 //layer=li \
 //thickness=0.1 //x=13.84 //y=7.41 //x2=13.84 //y2=7.585
r2167 (  359 1246 ) resistor r=33.1979 //w=0.187 //l=0.485 //layer=li \
 //thickness=0.1 //x=13.84 //y=7.41 //x2=13.84 //y2=6.925
r2168 (  356 1150 ) resistor r=2.87058 //w=0.35 //l=0.085 //layer=li \
 //thickness=0.1 //x=13.045 //y=7.585 //x2=12.96 //y2=7.585
r2169 (  356 358 ) resistor r=0.871935 //w=0.367 //l=0.025 //layer=li \
 //thickness=0.1 //x=13.045 //y=7.585 //x2=13.07 //y2=7.585
r2170 (  355 1151 ) resistor r=2.87058 //w=0.35 //l=0.085 //layer=li \
 //thickness=0.1 //x=13.755 //y=7.585 //x2=13.84 //y2=7.585
r2171 (  355 358 ) resistor r=23.891 //w=0.367 //l=0.685 //layer=li \
 //thickness=0.1 //x=13.755 //y=7.585 //x2=13.07 //y2=7.585
r2172 (  349 1150 ) resistor r=4.23183 //w=0.7 //l=0.175 //layer=li \
 //thickness=0.1 //x=12.96 //y=7.41 //x2=12.96 //y2=7.585
r2173 (  349 1245 ) resistor r=33.1979 //w=0.187 //l=0.485 //layer=li \
 //thickness=0.1 //x=12.96 //y=7.41 //x2=12.96 //y2=6.925
r2174 (  348 1149 ) resistor r=2.87058 //w=0.35 //l=0.085 //layer=li \
 //thickness=0.1 //x=12.165 //y=7.585 //x2=12.08 //y2=7.585
r2175 (  347 1150 ) resistor r=2.87058 //w=0.35 //l=0.085 //layer=li \
 //thickness=0.1 //x=12.875 //y=7.585 //x2=12.96 //y2=7.585
r2176 (  347 348 ) resistor r=24.7629 //w=0.367 //l=0.71 //layer=li \
 //thickness=0.1 //x=12.875 //y=7.585 //x2=12.165 //y2=7.585
r2177 (  341 1149 ) resistor r=4.23183 //w=0.7 //l=0.175 //layer=li \
 //thickness=0.1 //x=12.08 //y=7.41 //x2=12.08 //y2=7.585
r2178 (  341 1244 ) resistor r=33.1979 //w=0.187 //l=0.485 //layer=li \
 //thickness=0.1 //x=12.08 //y=7.41 //x2=12.08 //y2=6.925
r2179 (  338 1148 ) resistor r=2.87058 //w=0.35 //l=0.085 //layer=li \
 //thickness=0.1 //x=11.285 //y=7.585 //x2=11.2 //y2=7.585
r2180 (  338 340 ) resistor r=23.5422 //w=0.367 //l=0.675 //layer=li \
 //thickness=0.1 //x=11.285 //y=7.585 //x2=11.96 //y2=7.585
r2181 (  337 1149 ) resistor r=2.87058 //w=0.35 //l=0.085 //layer=li \
 //thickness=0.1 //x=11.995 //y=7.585 //x2=12.08 //y2=7.585
r2182 (  337 340 ) resistor r=1.22071 //w=0.367 //l=0.035 //layer=li \
 //thickness=0.1 //x=11.995 //y=7.585 //x2=11.96 //y2=7.585
r2183 (  329 1148 ) resistor r=4.23183 //w=0.7 //l=0.175 //layer=li \
 //thickness=0.1 //x=11.2 //y=7.41 //x2=11.2 //y2=7.585
r2184 (  329 1243 ) resistor r=56.4706 //w=0.187 //l=0.825 //layer=li \
 //thickness=0.1 //x=11.2 //y=7.41 //x2=11.2 //y2=6.585
r2185 (  326 1147 ) resistor r=5.29055 //w=0.35 //l=0.17 //layer=li \
 //thickness=0.1 //x=10.28 //y=7.585 //x2=10.11 //y2=7.585
r2186 (  326 328 ) resistor r=19.8801 //w=0.367 //l=0.57 //layer=li \
 //thickness=0.1 //x=10.28 //y=7.585 //x2=10.85 //y2=7.585
r2187 (  325 1148 ) resistor r=2.87058 //w=0.35 //l=0.085 //layer=li \
 //thickness=0.1 //x=11.115 //y=7.585 //x2=11.2 //y2=7.585
r2188 (  325 328 ) resistor r=9.24251 //w=0.367 //l=0.265 //layer=li \
 //thickness=0.1 //x=11.115 //y=7.585 //x2=10.85 //y2=7.585
r2189 (  320 1146 ) resistor r=2.87058 //w=0.35 //l=0.085 //layer=li \
 //thickness=0.1 //x=9.115 //y=7.585 //x2=9.03 //y2=7.585
r2190 (  320 322 ) resistor r=8.89373 //w=0.367 //l=0.255 //layer=li \
 //thickness=0.1 //x=9.115 //y=7.585 //x2=9.37 //y2=7.585
r2191 (  319 1147 ) resistor r=5.29055 //w=0.35 //l=0.17 //layer=li \
 //thickness=0.1 //x=9.94 //y=7.585 //x2=10.11 //y2=7.585
r2192 (  319 322 ) resistor r=19.8801 //w=0.367 //l=0.57 //layer=li \
 //thickness=0.1 //x=9.94 //y=7.585 //x2=9.37 //y2=7.585
r2193 (  313 1146 ) resistor r=4.23183 //w=0.7 //l=0.175 //layer=li \
 //thickness=0.1 //x=9.03 //y=7.41 //x2=9.03 //y2=7.585
r2194 (  313 1242 ) resistor r=33.1979 //w=0.187 //l=0.485 //layer=li \
 //thickness=0.1 //x=9.03 //y=7.41 //x2=9.03 //y2=6.925
r2195 (  310 1145 ) resistor r=2.87058 //w=0.35 //l=0.085 //layer=li \
 //thickness=0.1 //x=8.235 //y=7.585 //x2=8.15 //y2=7.585
r2196 (  310 312 ) resistor r=0.871935 //w=0.367 //l=0.025 //layer=li \
 //thickness=0.1 //x=8.235 //y=7.585 //x2=8.26 //y2=7.585
r2197 (  309 1146 ) resistor r=2.87058 //w=0.35 //l=0.085 //layer=li \
 //thickness=0.1 //x=8.945 //y=7.585 //x2=9.03 //y2=7.585
r2198 (  309 312 ) resistor r=23.891 //w=0.367 //l=0.685 //layer=li \
 //thickness=0.1 //x=8.945 //y=7.585 //x2=8.26 //y2=7.585
r2199 (  303 1145 ) resistor r=4.23183 //w=0.7 //l=0.175 //layer=li \
 //thickness=0.1 //x=8.15 //y=7.41 //x2=8.15 //y2=7.585
r2200 (  303 1241 ) resistor r=33.1979 //w=0.187 //l=0.485 //layer=li \
 //thickness=0.1 //x=8.15 //y=7.41 //x2=8.15 //y2=6.925
r2201 (  302 1144 ) resistor r=2.87058 //w=0.35 //l=0.085 //layer=li \
 //thickness=0.1 //x=7.355 //y=7.585 //x2=7.27 //y2=7.585
r2202 (  301 1145 ) resistor r=2.87058 //w=0.35 //l=0.085 //layer=li \
 //thickness=0.1 //x=8.065 //y=7.585 //x2=8.15 //y2=7.585
r2203 (  301 302 ) resistor r=24.7629 //w=0.367 //l=0.71 //layer=li \
 //thickness=0.1 //x=8.065 //y=7.585 //x2=7.355 //y2=7.585
r2204 (  295 1144 ) resistor r=4.23183 //w=0.7 //l=0.175 //layer=li \
 //thickness=0.1 //x=7.27 //y=7.41 //x2=7.27 //y2=7.585
r2205 (  295 1240 ) resistor r=33.1979 //w=0.187 //l=0.485 //layer=li \
 //thickness=0.1 //x=7.27 //y=7.41 //x2=7.27 //y2=6.925
r2206 (  292 1143 ) resistor r=2.87058 //w=0.35 //l=0.085 //layer=li \
 //thickness=0.1 //x=6.475 //y=7.585 //x2=6.39 //y2=7.585
r2207 (  292 294 ) resistor r=23.5422 //w=0.367 //l=0.675 //layer=li \
 //thickness=0.1 //x=6.475 //y=7.585 //x2=7.15 //y2=7.585
r2208 (  291 1144 ) resistor r=2.87058 //w=0.35 //l=0.085 //layer=li \
 //thickness=0.1 //x=7.185 //y=7.585 //x2=7.27 //y2=7.585
r2209 (  291 294 ) resistor r=1.22071 //w=0.367 //l=0.035 //layer=li \
 //thickness=0.1 //x=7.185 //y=7.585 //x2=7.15 //y2=7.585
r2210 (  283 1143 ) resistor r=4.23183 //w=0.7 //l=0.175 //layer=li \
 //thickness=0.1 //x=6.39 //y=7.41 //x2=6.39 //y2=7.585
r2211 (  283 1239 ) resistor r=56.4706 //w=0.187 //l=0.825 //layer=li \
 //thickness=0.1 //x=6.39 //y=7.41 //x2=6.39 //y2=6.585
r2212 (  280 1142 ) resistor r=5.29055 //w=0.35 //l=0.17 //layer=li \
 //thickness=0.1 //x=5.47 //y=7.585 //x2=5.3 //y2=7.585
r2213 (  280 282 ) resistor r=19.8801 //w=0.367 //l=0.57 //layer=li \
 //thickness=0.1 //x=5.47 //y=7.585 //x2=6.04 //y2=7.585
r2214 (  279 1143 ) resistor r=2.87058 //w=0.35 //l=0.085 //layer=li \
 //thickness=0.1 //x=6.305 //y=7.585 //x2=6.39 //y2=7.585
r2215 (  279 282 ) resistor r=9.24251 //w=0.367 //l=0.265 //layer=li \
 //thickness=0.1 //x=6.305 //y=7.585 //x2=6.04 //y2=7.585
r2216 (  274 1141 ) resistor r=2.87058 //w=0.35 //l=0.085 //layer=li \
 //thickness=0.1 //x=4.305 //y=7.585 //x2=4.22 //y2=7.585
r2217 (  274 276 ) resistor r=8.89373 //w=0.367 //l=0.255 //layer=li \
 //thickness=0.1 //x=4.305 //y=7.585 //x2=4.56 //y2=7.585
r2218 (  273 1142 ) resistor r=5.29055 //w=0.35 //l=0.17 //layer=li \
 //thickness=0.1 //x=5.13 //y=7.585 //x2=5.3 //y2=7.585
r2219 (  273 276 ) resistor r=19.8801 //w=0.367 //l=0.57 //layer=li \
 //thickness=0.1 //x=5.13 //y=7.585 //x2=4.56 //y2=7.585
r2220 (  267 1141 ) resistor r=4.23183 //w=0.7 //l=0.175 //layer=li \
 //thickness=0.1 //x=4.22 //y=7.41 //x2=4.22 //y2=7.585
r2221 (  267 1238 ) resistor r=33.1979 //w=0.187 //l=0.485 //layer=li \
 //thickness=0.1 //x=4.22 //y=7.41 //x2=4.22 //y2=6.925
r2222 (  264 1140 ) resistor r=2.87058 //w=0.35 //l=0.085 //layer=li \
 //thickness=0.1 //x=3.425 //y=7.585 //x2=3.34 //y2=7.585
r2223 (  264 266 ) resistor r=0.871935 //w=0.367 //l=0.025 //layer=li \
 //thickness=0.1 //x=3.425 //y=7.585 //x2=3.45 //y2=7.585
r2224 (  263 1141 ) resistor r=2.87058 //w=0.35 //l=0.085 //layer=li \
 //thickness=0.1 //x=4.135 //y=7.585 //x2=4.22 //y2=7.585
r2225 (  263 266 ) resistor r=23.891 //w=0.367 //l=0.685 //layer=li \
 //thickness=0.1 //x=4.135 //y=7.585 //x2=3.45 //y2=7.585
r2226 (  257 1140 ) resistor r=4.23183 //w=0.7 //l=0.175 //layer=li \
 //thickness=0.1 //x=3.34 //y=7.41 //x2=3.34 //y2=7.585
r2227 (  257 1237 ) resistor r=33.1979 //w=0.187 //l=0.485 //layer=li \
 //thickness=0.1 //x=3.34 //y=7.41 //x2=3.34 //y2=6.925
r2228 (  256 1139 ) resistor r=2.87058 //w=0.35 //l=0.085 //layer=li \
 //thickness=0.1 //x=2.545 //y=7.585 //x2=2.46 //y2=7.585
r2229 (  255 1140 ) resistor r=2.87058 //w=0.35 //l=0.085 //layer=li \
 //thickness=0.1 //x=3.255 //y=7.585 //x2=3.34 //y2=7.585
r2230 (  255 256 ) resistor r=24.7629 //w=0.367 //l=0.71 //layer=li \
 //thickness=0.1 //x=3.255 //y=7.585 //x2=2.545 //y2=7.585
r2231 (  249 1139 ) resistor r=4.23183 //w=0.7 //l=0.175 //layer=li \
 //thickness=0.1 //x=2.46 //y=7.41 //x2=2.46 //y2=7.585
r2232 (  249 1236 ) resistor r=33.1979 //w=0.187 //l=0.485 //layer=li \
 //thickness=0.1 //x=2.46 //y=7.41 //x2=2.46 //y2=6.925
r2233 (  246 1138 ) resistor r=2.87058 //w=0.35 //l=0.085 //layer=li \
 //thickness=0.1 //x=1.665 //y=7.585 //x2=1.58 //y2=7.585
r2234 (  246 248 ) resistor r=23.5422 //w=0.367 //l=0.675 //layer=li \
 //thickness=0.1 //x=1.665 //y=7.585 //x2=2.34 //y2=7.585
r2235 (  245 1139 ) resistor r=2.87058 //w=0.35 //l=0.085 //layer=li \
 //thickness=0.1 //x=2.375 //y=7.585 //x2=2.46 //y2=7.585
r2236 (  245 248 ) resistor r=1.22071 //w=0.367 //l=0.035 //layer=li \
 //thickness=0.1 //x=2.375 //y=7.585 //x2=2.34 //y2=7.585
r2237 (  237 1138 ) resistor r=4.23183 //w=0.7 //l=0.175 //layer=li \
 //thickness=0.1 //x=1.58 //y=7.41 //x2=1.58 //y2=7.585
r2238 (  237 1235 ) resistor r=56.4706 //w=0.187 //l=0.825 //layer=li \
 //thickness=0.1 //x=1.58 //y=7.41 //x2=1.58 //y2=6.585
r2239 (  233 1138 ) resistor r=2.87058 //w=0.35 //l=0.085 //layer=li \
 //thickness=0.1 //x=1.495 //y=7.585 //x2=1.58 //y2=7.585
r2240 (  233 236 ) resistor r=9.24251 //w=0.367 //l=0.265 //layer=li \
 //thickness=0.1 //x=1.495 //y=7.585 //x2=1.23 //y2=7.585
r2241 (  226 1092 ) resistor r=9.3 //w=0.17 //l=0.17 //layer=mcon //count=1 \
 //x=89.62 //y=6.92 //x2=89.62 //y2=6.92
r2242 (  223 1308 ) resistor r=9.3 //w=0.17 //l=0.17 //layer=mcon //count=1 \
 //x=88.74 //y=6.92 //x2=88.74 //y2=6.92
r2243 (  220 1077 ) resistor r=9.3 //w=0.17 //l=0.17 //layer=mcon //count=1 \
 //x=87.86 //y=6.92 //x2=87.86 //y2=6.92
r2244 (  216 1064 ) resistor r=3.1 //w=0.17 //l=0.51 //layer=mcon //count=3 \
 //x=87.81 //y=7.58 //x2=87.81 //y2=7.58
r2245 (  177 1234 ) resistor r=4.65 //w=0.17 //l=0.34 //layer=mcon //count=2 \
 //x=98.54 //y=7.58 //x2=98.54 //y2=7.58
r2246 (  175 1232 ) resistor r=3.1 //w=0.17 //l=0.51 //layer=mcon //count=3 \
 //x=97.8 //y=7.58 //x2=97.8 //y2=7.58
r2247 (  175 177 ) resistor r=0.297428 //w=0.311 //l=0.74 //layer=m1 \
 //thickness=0.36 //x=97.8 //y=7.585 //x2=98.54 //y2=7.585
r2248 (  173 1111 ) resistor r=3.1 //w=0.17 //l=0.51 //layer=mcon //count=3 \
 //x=96.32 //y=7.58 //x2=96.32 //y2=7.58
r2249 (  173 175 ) resistor r=0.594855 //w=0.311 //l=1.48 //layer=m1 \
 //thickness=0.36 //x=96.32 //y=7.585 //x2=97.8 //y2=7.585
r2250 (  171 1109 ) resistor r=3.1 //w=0.17 //l=0.51 //layer=mcon //count=3 \
 //x=95.21 //y=7.58 //x2=95.21 //y2=7.58
r2251 (  171 173 ) resistor r=0.446141 //w=0.311 //l=1.11 //layer=m1 \
 //thickness=0.36 //x=95.21 //y=7.585 //x2=96.32 //y2=7.585
r2252 (  169 1107 ) resistor r=3.1 //w=0.17 //l=0.51 //layer=mcon //count=3 \
 //x=94.1 //y=7.58 //x2=94.1 //y2=7.58
r2253 (  169 171 ) resistor r=0.446141 //w=0.311 //l=1.11 //layer=m1 \
 //thickness=0.36 //x=94.1 //y=7.585 //x2=95.21 //y2=7.585
r2254 (  167 1101 ) resistor r=3.1 //w=0.17 //l=0.51 //layer=mcon //count=3 \
 //x=92.62 //y=7.58 //x2=92.62 //y2=7.58
r2255 (  167 169 ) resistor r=0.594855 //w=0.311 //l=1.48 //layer=m1 \
 //thickness=0.36 //x=92.62 //y=7.585 //x2=94.1 //y2=7.585
r2256 (  165 1099 ) resistor r=3.1 //w=0.17 //l=0.51 //layer=mcon //count=3 \
 //x=91.51 //y=7.58 //x2=91.51 //y2=7.58
r2257 (  165 167 ) resistor r=0.446141 //w=0.311 //l=1.11 //layer=m1 \
 //thickness=0.36 //x=91.51 //y=7.585 //x2=92.62 //y2=7.585
r2258 (  163 1068 ) resistor r=3.1 //w=0.17 //l=0.51 //layer=mcon //count=3 \
 //x=90.03 //y=7.58 //x2=90.03 //y2=7.58
r2259 (  163 165 ) resistor r=0.594855 //w=0.311 //l=1.48 //layer=m1 \
 //thickness=0.36 //x=90.03 //y=7.585 //x2=91.51 //y2=7.585
r2260 (  161 224 ) resistor r=0.028033 //w=0.35 //l=0.085 //layer=m1 \
 //thickness=0.36 //x=89.705 //y=7.585 //x2=89.62 //y2=7.585
r2261 (  161 163 ) resistor r=0.130627 //w=0.311 //l=0.325 //layer=m1 \
 //thickness=0.36 //x=89.705 //y=7.585 //x2=90.03 //y2=7.585
r2262 (  160 224 ) resistor r=0.0413265 //w=0.7 //l=0.175 //layer=m1 \
 //thickness=0.36 //x=89.62 //y=7.41 //x2=89.62 //y2=7.585
r2263 (  159 226 ) resistor r=0.0715665 //w=0.226 //l=0.115 //layer=m1 \
 //thickness=0.36 //x=89.62 //y=7.035 //x2=89.62 //y2=6.92
r2264 (  159 160 ) resistor r=0.357824 //w=0.131 //l=0.375 //layer=m1 \
 //thickness=0.36 //x=89.62 //y=7.035 //x2=89.62 //y2=7.41
r2265 (  158 1066 ) resistor r=3.1 //w=0.17 //l=0.51 //layer=mcon //count=3 \
 //x=88.92 //y=7.58 //x2=88.92 //y2=7.58
r2266 (  156 221 ) resistor r=0.028033 //w=0.35 //l=0.085 //layer=m1 \
 //thickness=0.36 //x=88.825 //y=7.585 //x2=88.74 //y2=7.585
r2267 (  156 158 ) resistor r=0.0381833 //w=0.311 //l=0.095 //layer=m1 \
 //thickness=0.36 //x=88.825 //y=7.585 //x2=88.92 //y2=7.585
r2268 (  155 224 ) resistor r=0.028033 //w=0.35 //l=0.085 //layer=m1 \
 //thickness=0.36 //x=89.535 //y=7.585 //x2=89.62 //y2=7.585
r2269 (  155 158 ) resistor r=0.247186 //w=0.311 //l=0.615 //layer=m1 \
 //thickness=0.36 //x=89.535 //y=7.585 //x2=88.92 //y2=7.585
r2270 (  154 221 ) resistor r=0.0413265 //w=0.7 //l=0.175 //layer=m1 \
 //thickness=0.36 //x=88.74 //y=7.41 //x2=88.74 //y2=7.585
r2271 (  153 223 ) resistor r=0.0715665 //w=0.226 //l=0.117473 //layer=m1 \
 //thickness=0.36 //x=88.74 //y=7.035 //x2=88.745 //y2=6.92
r2272 (  153 154 ) resistor r=0.357824 //w=0.131 //l=0.375 //layer=m1 \
 //thickness=0.36 //x=88.74 //y=7.035 //x2=88.74 //y2=7.41
r2273 (  152 216 ) resistor r=0.028033 //w=0.35 //l=0.085 //layer=m1 \
 //thickness=0.36 //x=87.945 //y=7.585 //x2=87.86 //y2=7.585
r2274 (  151 221 ) resistor r=0.028033 //w=0.35 //l=0.085 //layer=m1 \
 //thickness=0.36 //x=88.655 //y=7.585 //x2=88.74 //y2=7.585
r2275 (  151 152 ) resistor r=0.28537 //w=0.311 //l=0.71 //layer=m1 \
 //thickness=0.36 //x=88.655 //y=7.585 //x2=87.945 //y2=7.585
r2276 (  150 216 ) resistor r=0.0413265 //w=0.7 //l=0.175 //layer=m1 \
 //thickness=0.36 //x=87.86 //y=7.41 //x2=87.86 //y2=7.585
r2277 (  149 220 ) resistor r=0.0712609 //w=0.23 //l=0.11649 //layer=m1 \
 //thickness=0.36 //x=87.86 //y=7.035 //x2=87.857 //y2=6.92
r2278 (  149 150 ) resistor r=0.357824 //w=0.131 //l=0.375 //layer=m1 \
 //thickness=0.36 //x=87.86 //y=7.035 //x2=87.86 //y2=7.41
r2279 (  148 1058 ) resistor r=3.1 //w=0.17 //l=0.51 //layer=mcon //count=3 \
 //x=86.33 //y=7.58 //x2=86.33 //y2=7.58
r2280 (  146 1048 ) resistor r=3.1 //w=0.17 //l=0.51 //layer=mcon //count=3 \
 //x=85.22 //y=7.58 //x2=85.22 //y2=7.58
r2281 (  146 148 ) resistor r=0.446141 //w=0.311 //l=1.11 //layer=m1 \
 //thickness=0.36 //x=85.22 //y=7.585 //x2=86.33 //y2=7.585
r2282 (  144 1030 ) resistor r=3.1 //w=0.17 //l=0.51 //layer=mcon //count=3 \
 //x=84.11 //y=7.58 //x2=84.11 //y2=7.58
r2283 (  144 146 ) resistor r=0.446141 //w=0.311 //l=1.11 //layer=m1 \
 //thickness=0.36 //x=84.11 //y=7.585 //x2=85.22 //y2=7.585
r2284 (  142 1018 ) resistor r=3.1 //w=0.17 //l=0.51 //layer=mcon //count=3 \
 //x=83 //y=7.58 //x2=83 //y2=7.58
r2285 (  142 144 ) resistor r=0.446141 //w=0.311 //l=1.11 //layer=m1 \
 //thickness=0.36 //x=83 //y=7.585 //x2=84.11 //y2=7.585
r2286 (  140 1012 ) resistor r=3.1 //w=0.17 //l=0.51 //layer=mcon //count=3 \
 //x=81.52 //y=7.58 //x2=81.52 //y2=7.58
r2287 (  140 142 ) resistor r=0.594855 //w=0.311 //l=1.48 //layer=m1 \
 //thickness=0.36 //x=81.52 //y=7.585 //x2=83 //y2=7.585
r2288 (  138 1002 ) resistor r=3.1 //w=0.17 //l=0.51 //layer=mcon //count=3 \
 //x=80.41 //y=7.58 //x2=80.41 //y2=7.58
r2289 (  138 140 ) resistor r=0.446141 //w=0.311 //l=1.11 //layer=m1 \
 //thickness=0.36 //x=80.41 //y=7.585 //x2=81.52 //y2=7.585
r2290 (  136 984 ) resistor r=3.1 //w=0.17 //l=0.51 //layer=mcon //count=3 \
 //x=79.3 //y=7.58 //x2=79.3 //y2=7.58
r2291 (  136 138 ) resistor r=0.446141 //w=0.311 //l=1.11 //layer=m1 \
 //thickness=0.36 //x=79.3 //y=7.585 //x2=80.41 //y2=7.585
r2292 (  134 972 ) resistor r=3.1 //w=0.17 //l=0.51 //layer=mcon //count=3 \
 //x=78.19 //y=7.58 //x2=78.19 //y2=7.58
r2293 (  134 136 ) resistor r=0.446141 //w=0.311 //l=1.11 //layer=m1 \
 //thickness=0.36 //x=78.19 //y=7.585 //x2=79.3 //y2=7.585
r2294 (  132 966 ) resistor r=3.1 //w=0.17 //l=0.51 //layer=mcon //count=3 \
 //x=76.71 //y=7.58 //x2=76.71 //y2=7.58
r2295 (  132 134 ) resistor r=0.594855 //w=0.311 //l=1.48 //layer=m1 \
 //thickness=0.36 //x=76.71 //y=7.585 //x2=78.19 //y2=7.585
r2296 (  130 956 ) resistor r=3.1 //w=0.17 //l=0.51 //layer=mcon //count=3 \
 //x=75.6 //y=7.58 //x2=75.6 //y2=7.58
r2297 (  130 132 ) resistor r=0.446141 //w=0.311 //l=1.11 //layer=m1 \
 //thickness=0.36 //x=75.6 //y=7.585 //x2=76.71 //y2=7.585
r2298 (  128 938 ) resistor r=3.1 //w=0.17 //l=0.51 //layer=mcon //count=3 \
 //x=74.49 //y=7.58 //x2=74.49 //y2=7.58
r2299 (  128 130 ) resistor r=0.446141 //w=0.311 //l=1.11 //layer=m1 \
 //thickness=0.36 //x=74.49 //y=7.585 //x2=75.6 //y2=7.585
r2300 (  126 926 ) resistor r=3.1 //w=0.17 //l=0.51 //layer=mcon //count=3 \
 //x=73.38 //y=7.58 //x2=73.38 //y2=7.58
r2301 (  126 128 ) resistor r=0.446141 //w=0.311 //l=1.11 //layer=m1 \
 //thickness=0.36 //x=73.38 //y=7.585 //x2=74.49 //y2=7.585
r2302 (  124 920 ) resistor r=3.1 //w=0.17 //l=0.51 //layer=mcon //count=3 \
 //x=71.9 //y=7.58 //x2=71.9 //y2=7.58
r2303 (  124 126 ) resistor r=0.594855 //w=0.311 //l=1.48 //layer=m1 \
 //thickness=0.36 //x=71.9 //y=7.585 //x2=73.38 //y2=7.585
r2304 (  122 910 ) resistor r=3.1 //w=0.17 //l=0.51 //layer=mcon //count=3 \
 //x=70.79 //y=7.58 //x2=70.79 //y2=7.58
r2305 (  122 124 ) resistor r=0.446141 //w=0.311 //l=1.11 //layer=m1 \
 //thickness=0.36 //x=70.79 //y=7.585 //x2=71.9 //y2=7.585
r2306 (  120 892 ) resistor r=3.1 //w=0.17 //l=0.51 //layer=mcon //count=3 \
 //x=69.68 //y=7.58 //x2=69.68 //y2=7.58
r2307 (  120 122 ) resistor r=0.446141 //w=0.311 //l=1.11 //layer=m1 \
 //thickness=0.36 //x=69.68 //y=7.585 //x2=70.79 //y2=7.585
r2308 (  118 880 ) resistor r=3.1 //w=0.17 //l=0.51 //layer=mcon //count=3 \
 //x=68.57 //y=7.58 //x2=68.57 //y2=7.58
r2309 (  118 120 ) resistor r=0.446141 //w=0.311 //l=1.11 //layer=m1 \
 //thickness=0.36 //x=68.57 //y=7.585 //x2=69.68 //y2=7.585
r2310 (  116 874 ) resistor r=3.1 //w=0.17 //l=0.51 //layer=mcon //count=3 \
 //x=67.09 //y=7.58 //x2=67.09 //y2=7.58
r2311 (  116 118 ) resistor r=0.594855 //w=0.311 //l=1.48 //layer=m1 \
 //thickness=0.36 //x=67.09 //y=7.585 //x2=68.57 //y2=7.585
r2312 (  114 864 ) resistor r=3.1 //w=0.17 //l=0.51 //layer=mcon //count=3 \
 //x=65.98 //y=7.58 //x2=65.98 //y2=7.58
r2313 (  114 116 ) resistor r=0.446141 //w=0.311 //l=1.11 //layer=m1 \
 //thickness=0.36 //x=65.98 //y=7.585 //x2=67.09 //y2=7.585
r2314 (  112 846 ) resistor r=3.1 //w=0.17 //l=0.51 //layer=mcon //count=3 \
 //x=64.87 //y=7.58 //x2=64.87 //y2=7.58
r2315 (  112 114 ) resistor r=0.446141 //w=0.311 //l=1.11 //layer=m1 \
 //thickness=0.36 //x=64.87 //y=7.585 //x2=65.98 //y2=7.585
r2316 (  110 834 ) resistor r=3.1 //w=0.17 //l=0.51 //layer=mcon //count=3 \
 //x=63.76 //y=7.58 //x2=63.76 //y2=7.58
r2317 (  110 112 ) resistor r=0.446141 //w=0.311 //l=1.11 //layer=m1 \
 //thickness=0.36 //x=63.76 //y=7.585 //x2=64.87 //y2=7.585
r2318 (  108 828 ) resistor r=3.1 //w=0.17 //l=0.51 //layer=mcon //count=3 \
 //x=62.28 //y=7.58 //x2=62.28 //y2=7.58
r2319 (  108 110 ) resistor r=0.594855 //w=0.311 //l=1.48 //layer=m1 \
 //thickness=0.36 //x=62.28 //y=7.585 //x2=63.76 //y2=7.585
r2320 (  106 818 ) resistor r=3.1 //w=0.17 //l=0.51 //layer=mcon //count=3 \
 //x=61.17 //y=7.58 //x2=61.17 //y2=7.58
r2321 (  106 108 ) resistor r=0.446141 //w=0.311 //l=1.11 //layer=m1 \
 //thickness=0.36 //x=61.17 //y=7.585 //x2=62.28 //y2=7.585
r2322 (  104 800 ) resistor r=3.1 //w=0.17 //l=0.51 //layer=mcon //count=3 \
 //x=60.06 //y=7.58 //x2=60.06 //y2=7.58
r2323 (  104 106 ) resistor r=0.446141 //w=0.311 //l=1.11 //layer=m1 \
 //thickness=0.36 //x=60.06 //y=7.585 //x2=61.17 //y2=7.585
r2324 (  102 788 ) resistor r=3.1 //w=0.17 //l=0.51 //layer=mcon //count=3 \
 //x=58.95 //y=7.58 //x2=58.95 //y2=7.58
r2325 (  102 104 ) resistor r=0.446141 //w=0.311 //l=1.11 //layer=m1 \
 //thickness=0.36 //x=58.95 //y=7.585 //x2=60.06 //y2=7.585
r2326 (  100 782 ) resistor r=3.1 //w=0.17 //l=0.51 //layer=mcon //count=3 \
 //x=57.47 //y=7.58 //x2=57.47 //y2=7.58
r2327 (  100 102 ) resistor r=0.594855 //w=0.311 //l=1.48 //layer=m1 \
 //thickness=0.36 //x=57.47 //y=7.585 //x2=58.95 //y2=7.585
r2328 (  98 772 ) resistor r=3.1 //w=0.17 //l=0.51 //layer=mcon //count=3 \
 //x=56.36 //y=7.58 //x2=56.36 //y2=7.58
r2329 (  98 100 ) resistor r=0.446141 //w=0.311 //l=1.11 //layer=m1 \
 //thickness=0.36 //x=56.36 //y=7.585 //x2=57.47 //y2=7.585
r2330 (  96 754 ) resistor r=3.1 //w=0.17 //l=0.51 //layer=mcon //count=3 \
 //x=55.25 //y=7.58 //x2=55.25 //y2=7.58
r2331 (  96 98 ) resistor r=0.446141 //w=0.311 //l=1.11 //layer=m1 \
 //thickness=0.36 //x=55.25 //y=7.585 //x2=56.36 //y2=7.585
r2332 (  94 742 ) resistor r=3.1 //w=0.17 //l=0.51 //layer=mcon //count=3 \
 //x=54.14 //y=7.58 //x2=54.14 //y2=7.58
r2333 (  94 96 ) resistor r=0.446141 //w=0.311 //l=1.11 //layer=m1 \
 //thickness=0.36 //x=54.14 //y=7.585 //x2=55.25 //y2=7.585
r2334 (  92 736 ) resistor r=3.1 //w=0.17 //l=0.51 //layer=mcon //count=3 \
 //x=52.66 //y=7.58 //x2=52.66 //y2=7.58
r2335 (  92 94 ) resistor r=0.594855 //w=0.311 //l=1.48 //layer=m1 \
 //thickness=0.36 //x=52.66 //y=7.585 //x2=54.14 //y2=7.585
r2336 (  90 726 ) resistor r=3.1 //w=0.17 //l=0.51 //layer=mcon //count=3 \
 //x=51.55 //y=7.58 //x2=51.55 //y2=7.58
r2337 (  90 92 ) resistor r=0.446141 //w=0.311 //l=1.11 //layer=m1 \
 //thickness=0.36 //x=51.55 //y=7.585 //x2=52.66 //y2=7.585
r2338 (  88 708 ) resistor r=3.1 //w=0.17 //l=0.51 //layer=mcon //count=3 \
 //x=50.44 //y=7.58 //x2=50.44 //y2=7.58
r2339 (  88 90 ) resistor r=0.446141 //w=0.311 //l=1.11 //layer=m1 \
 //thickness=0.36 //x=50.44 //y=7.585 //x2=51.55 //y2=7.585
r2340 (  85 696 ) resistor r=3.1 //w=0.17 //l=0.51 //layer=mcon //count=3 \
 //x=49.33 //y=7.58 //x2=49.33 //y2=7.58
r2341 (  83 690 ) resistor r=3.1 //w=0.17 //l=0.51 //layer=mcon //count=3 \
 //x=47.85 //y=7.58 //x2=47.85 //y2=7.58
r2342 (  83 85 ) resistor r=0.594855 //w=0.311 //l=1.48 //layer=m1 \
 //thickness=0.36 //x=47.85 //y=7.585 //x2=49.33 //y2=7.585
r2343 (  81 680 ) resistor r=3.1 //w=0.17 //l=0.51 //layer=mcon //count=3 \
 //x=46.74 //y=7.58 //x2=46.74 //y2=7.58
r2344 (  81 83 ) resistor r=0.446141 //w=0.311 //l=1.11 //layer=m1 \
 //thickness=0.36 //x=46.74 //y=7.585 //x2=47.85 //y2=7.585
r2345 (  79 662 ) resistor r=3.1 //w=0.17 //l=0.51 //layer=mcon //count=3 \
 //x=45.63 //y=7.58 //x2=45.63 //y2=7.58
r2346 (  79 81 ) resistor r=0.446141 //w=0.311 //l=1.11 //layer=m1 \
 //thickness=0.36 //x=45.63 //y=7.585 //x2=46.74 //y2=7.585
r2347 (  77 650 ) resistor r=3.1 //w=0.17 //l=0.51 //layer=mcon //count=3 \
 //x=44.52 //y=7.58 //x2=44.52 //y2=7.58
r2348 (  77 79 ) resistor r=0.446141 //w=0.311 //l=1.11 //layer=m1 \
 //thickness=0.36 //x=44.52 //y=7.585 //x2=45.63 //y2=7.585
r2349 (  75 644 ) resistor r=3.1 //w=0.17 //l=0.51 //layer=mcon //count=3 \
 //x=43.04 //y=7.58 //x2=43.04 //y2=7.58
r2350 (  75 77 ) resistor r=0.594855 //w=0.311 //l=1.48 //layer=m1 \
 //thickness=0.36 //x=43.04 //y=7.585 //x2=44.52 //y2=7.585
r2351 (  73 634 ) resistor r=3.1 //w=0.17 //l=0.51 //layer=mcon //count=3 \
 //x=41.93 //y=7.58 //x2=41.93 //y2=7.58
r2352 (  73 75 ) resistor r=0.446141 //w=0.311 //l=1.11 //layer=m1 \
 //thickness=0.36 //x=41.93 //y=7.585 //x2=43.04 //y2=7.585
r2353 (  71 616 ) resistor r=3.1 //w=0.17 //l=0.51 //layer=mcon //count=3 \
 //x=40.82 //y=7.58 //x2=40.82 //y2=7.58
r2354 (  71 73 ) resistor r=0.446141 //w=0.311 //l=1.11 //layer=m1 \
 //thickness=0.36 //x=40.82 //y=7.585 //x2=41.93 //y2=7.585
r2355 (  69 604 ) resistor r=3.1 //w=0.17 //l=0.51 //layer=mcon //count=3 \
 //x=39.71 //y=7.58 //x2=39.71 //y2=7.58
r2356 (  69 71 ) resistor r=0.446141 //w=0.311 //l=1.11 //layer=m1 \
 //thickness=0.36 //x=39.71 //y=7.585 //x2=40.82 //y2=7.585
r2357 (  67 598 ) resistor r=3.1 //w=0.17 //l=0.51 //layer=mcon //count=3 \
 //x=38.23 //y=7.58 //x2=38.23 //y2=7.58
r2358 (  67 69 ) resistor r=0.594855 //w=0.311 //l=1.48 //layer=m1 \
 //thickness=0.36 //x=38.23 //y=7.585 //x2=39.71 //y2=7.585
r2359 (  65 588 ) resistor r=3.1 //w=0.17 //l=0.51 //layer=mcon //count=3 \
 //x=37.12 //y=7.58 //x2=37.12 //y2=7.58
r2360 (  65 67 ) resistor r=0.446141 //w=0.311 //l=1.11 //layer=m1 \
 //thickness=0.36 //x=37.12 //y=7.585 //x2=38.23 //y2=7.585
r2361 (  63 570 ) resistor r=3.1 //w=0.17 //l=0.51 //layer=mcon //count=3 \
 //x=36.01 //y=7.58 //x2=36.01 //y2=7.58
r2362 (  63 65 ) resistor r=0.446141 //w=0.311 //l=1.11 //layer=m1 \
 //thickness=0.36 //x=36.01 //y=7.585 //x2=37.12 //y2=7.585
r2363 (  61 558 ) resistor r=3.1 //w=0.17 //l=0.51 //layer=mcon //count=3 \
 //x=34.9 //y=7.58 //x2=34.9 //y2=7.58
r2364 (  61 63 ) resistor r=0.446141 //w=0.311 //l=1.11 //layer=m1 \
 //thickness=0.36 //x=34.9 //y=7.585 //x2=36.01 //y2=7.585
r2365 (  59 552 ) resistor r=3.1 //w=0.17 //l=0.51 //layer=mcon //count=3 \
 //x=33.42 //y=7.58 //x2=33.42 //y2=7.58
r2366 (  59 61 ) resistor r=0.594855 //w=0.311 //l=1.48 //layer=m1 \
 //thickness=0.36 //x=33.42 //y=7.585 //x2=34.9 //y2=7.585
r2367 (  57 542 ) resistor r=3.1 //w=0.17 //l=0.51 //layer=mcon //count=3 \
 //x=32.31 //y=7.58 //x2=32.31 //y2=7.58
r2368 (  57 59 ) resistor r=0.446141 //w=0.311 //l=1.11 //layer=m1 \
 //thickness=0.36 //x=32.31 //y=7.585 //x2=33.42 //y2=7.585
r2369 (  55 524 ) resistor r=3.1 //w=0.17 //l=0.51 //layer=mcon //count=3 \
 //x=31.2 //y=7.58 //x2=31.2 //y2=7.58
r2370 (  55 57 ) resistor r=0.446141 //w=0.311 //l=1.11 //layer=m1 \
 //thickness=0.36 //x=31.2 //y=7.585 //x2=32.31 //y2=7.585
r2371 (  53 512 ) resistor r=3.1 //w=0.17 //l=0.51 //layer=mcon //count=3 \
 //x=30.09 //y=7.58 //x2=30.09 //y2=7.58
r2372 (  53 55 ) resistor r=0.446141 //w=0.311 //l=1.11 //layer=m1 \
 //thickness=0.36 //x=30.09 //y=7.585 //x2=31.2 //y2=7.585
r2373 (  51 506 ) resistor r=3.1 //w=0.17 //l=0.51 //layer=mcon //count=3 \
 //x=28.61 //y=7.58 //x2=28.61 //y2=7.58
r2374 (  51 53 ) resistor r=0.594855 //w=0.311 //l=1.48 //layer=m1 \
 //thickness=0.36 //x=28.61 //y=7.585 //x2=30.09 //y2=7.585
r2375 (  49 496 ) resistor r=3.1 //w=0.17 //l=0.51 //layer=mcon //count=3 \
 //x=27.5 //y=7.58 //x2=27.5 //y2=7.58
r2376 (  49 51 ) resistor r=0.446141 //w=0.311 //l=1.11 //layer=m1 \
 //thickness=0.36 //x=27.5 //y=7.585 //x2=28.61 //y2=7.585
r2377 (  47 478 ) resistor r=3.1 //w=0.17 //l=0.51 //layer=mcon //count=3 \
 //x=26.39 //y=7.58 //x2=26.39 //y2=7.58
r2378 (  47 49 ) resistor r=0.446141 //w=0.311 //l=1.11 //layer=m1 \
 //thickness=0.36 //x=26.39 //y=7.585 //x2=27.5 //y2=7.585
r2379 (  45 466 ) resistor r=3.1 //w=0.17 //l=0.51 //layer=mcon //count=3 \
 //x=25.28 //y=7.58 //x2=25.28 //y2=7.58
r2380 (  45 47 ) resistor r=0.446141 //w=0.311 //l=1.11 //layer=m1 \
 //thickness=0.36 //x=25.28 //y=7.585 //x2=26.39 //y2=7.585
r2381 (  43 460 ) resistor r=3.1 //w=0.17 //l=0.51 //layer=mcon //count=3 \
 //x=23.8 //y=7.58 //x2=23.8 //y2=7.58
r2382 (  43 45 ) resistor r=0.594855 //w=0.311 //l=1.48 //layer=m1 \
 //thickness=0.36 //x=23.8 //y=7.585 //x2=25.28 //y2=7.585
r2383 (  41 450 ) resistor r=3.1 //w=0.17 //l=0.51 //layer=mcon //count=3 \
 //x=22.69 //y=7.58 //x2=22.69 //y2=7.58
r2384 (  41 43 ) resistor r=0.446141 //w=0.311 //l=1.11 //layer=m1 \
 //thickness=0.36 //x=22.69 //y=7.585 //x2=23.8 //y2=7.585
r2385 (  39 432 ) resistor r=3.1 //w=0.17 //l=0.51 //layer=mcon //count=3 \
 //x=21.58 //y=7.58 //x2=21.58 //y2=7.58
r2386 (  39 41 ) resistor r=0.446141 //w=0.311 //l=1.11 //layer=m1 \
 //thickness=0.36 //x=21.58 //y=7.585 //x2=22.69 //y2=7.585
r2387 (  37 420 ) resistor r=3.1 //w=0.17 //l=0.51 //layer=mcon //count=3 \
 //x=20.47 //y=7.58 //x2=20.47 //y2=7.58
r2388 (  37 39 ) resistor r=0.446141 //w=0.311 //l=1.11 //layer=m1 \
 //thickness=0.36 //x=20.47 //y=7.585 //x2=21.58 //y2=7.585
r2389 (  35 414 ) resistor r=3.1 //w=0.17 //l=0.51 //layer=mcon //count=3 \
 //x=18.99 //y=7.58 //x2=18.99 //y2=7.58
r2390 (  35 37 ) resistor r=0.594855 //w=0.311 //l=1.48 //layer=m1 \
 //thickness=0.36 //x=18.99 //y=7.585 //x2=20.47 //y2=7.585
r2391 (  33 404 ) resistor r=3.1 //w=0.17 //l=0.51 //layer=mcon //count=3 \
 //x=17.88 //y=7.58 //x2=17.88 //y2=7.58
r2392 (  33 35 ) resistor r=0.446141 //w=0.311 //l=1.11 //layer=m1 \
 //thickness=0.36 //x=17.88 //y=7.585 //x2=18.99 //y2=7.585
r2393 (  31 386 ) resistor r=3.1 //w=0.17 //l=0.51 //layer=mcon //count=3 \
 //x=16.77 //y=7.58 //x2=16.77 //y2=7.58
r2394 (  31 33 ) resistor r=0.446141 //w=0.311 //l=1.11 //layer=m1 \
 //thickness=0.36 //x=16.77 //y=7.585 //x2=17.88 //y2=7.585
r2395 (  29 374 ) resistor r=3.1 //w=0.17 //l=0.51 //layer=mcon //count=3 \
 //x=15.66 //y=7.58 //x2=15.66 //y2=7.58
r2396 (  29 31 ) resistor r=0.446141 //w=0.311 //l=1.11 //layer=m1 \
 //thickness=0.36 //x=15.66 //y=7.585 //x2=16.77 //y2=7.585
r2397 (  27 368 ) resistor r=3.1 //w=0.17 //l=0.51 //layer=mcon //count=3 \
 //x=14.18 //y=7.58 //x2=14.18 //y2=7.58
r2398 (  27 29 ) resistor r=0.594855 //w=0.311 //l=1.48 //layer=m1 \
 //thickness=0.36 //x=14.18 //y=7.585 //x2=15.66 //y2=7.585
r2399 (  25 358 ) resistor r=3.1 //w=0.17 //l=0.51 //layer=mcon //count=3 \
 //x=13.07 //y=7.58 //x2=13.07 //y2=7.58
r2400 (  25 27 ) resistor r=0.446141 //w=0.311 //l=1.11 //layer=m1 \
 //thickness=0.36 //x=13.07 //y=7.585 //x2=14.18 //y2=7.585
r2401 (  23 340 ) resistor r=3.1 //w=0.17 //l=0.51 //layer=mcon //count=3 \
 //x=11.96 //y=7.58 //x2=11.96 //y2=7.58
r2402 (  23 25 ) resistor r=0.446141 //w=0.311 //l=1.11 //layer=m1 \
 //thickness=0.36 //x=11.96 //y=7.585 //x2=13.07 //y2=7.585
r2403 (  21 328 ) resistor r=3.1 //w=0.17 //l=0.51 //layer=mcon //count=3 \
 //x=10.85 //y=7.58 //x2=10.85 //y2=7.58
r2404 (  21 23 ) resistor r=0.446141 //w=0.311 //l=1.11 //layer=m1 \
 //thickness=0.36 //x=10.85 //y=7.585 //x2=11.96 //y2=7.585
r2405 (  19 322 ) resistor r=3.1 //w=0.17 //l=0.51 //layer=mcon //count=3 \
 //x=9.37 //y=7.58 //x2=9.37 //y2=7.58
r2406 (  19 21 ) resistor r=0.594855 //w=0.311 //l=1.48 //layer=m1 \
 //thickness=0.36 //x=9.37 //y=7.585 //x2=10.85 //y2=7.585
r2407 (  17 312 ) resistor r=3.1 //w=0.17 //l=0.51 //layer=mcon //count=3 \
 //x=8.26 //y=7.58 //x2=8.26 //y2=7.58
r2408 (  17 19 ) resistor r=0.446141 //w=0.311 //l=1.11 //layer=m1 \
 //thickness=0.36 //x=8.26 //y=7.585 //x2=9.37 //y2=7.585
r2409 (  15 294 ) resistor r=3.1 //w=0.17 //l=0.51 //layer=mcon //count=3 \
 //x=7.15 //y=7.58 //x2=7.15 //y2=7.58
r2410 (  15 17 ) resistor r=0.446141 //w=0.311 //l=1.11 //layer=m1 \
 //thickness=0.36 //x=7.15 //y=7.585 //x2=8.26 //y2=7.585
r2411 (  13 282 ) resistor r=3.1 //w=0.17 //l=0.51 //layer=mcon //count=3 \
 //x=6.04 //y=7.58 //x2=6.04 //y2=7.58
r2412 (  13 15 ) resistor r=0.446141 //w=0.311 //l=1.11 //layer=m1 \
 //thickness=0.36 //x=6.04 //y=7.585 //x2=7.15 //y2=7.585
r2413 (  11 276 ) resistor r=3.1 //w=0.17 //l=0.51 //layer=mcon //count=3 \
 //x=4.56 //y=7.58 //x2=4.56 //y2=7.58
r2414 (  11 13 ) resistor r=0.594855 //w=0.311 //l=1.48 //layer=m1 \
 //thickness=0.36 //x=4.56 //y=7.585 //x2=6.04 //y2=7.585
r2415 (  9 266 ) resistor r=3.1 //w=0.17 //l=0.51 //layer=mcon //count=3 \
 //x=3.45 //y=7.58 //x2=3.45 //y2=7.58
r2416 (  9 11 ) resistor r=0.446141 //w=0.311 //l=1.11 //layer=m1 \
 //thickness=0.36 //x=3.45 //y=7.585 //x2=4.56 //y2=7.585
r2417 (  7 248 ) resistor r=3.1 //w=0.17 //l=0.51 //layer=mcon //count=3 \
 //x=2.34 //y=7.58 //x2=2.34 //y2=7.58
r2418 (  7 9 ) resistor r=0.446141 //w=0.311 //l=1.11 //layer=m1 \
 //thickness=0.36 //x=2.34 //y=7.585 //x2=3.45 //y2=7.585
r2419 (  4 236 ) resistor r=3.1 //w=0.17 //l=0.51 //layer=mcon //count=3 \
 //x=1.23 //y=7.58 //x2=1.23 //y2=7.58
r2420 (  4 7 ) resistor r=0.446141 //w=0.311 //l=1.11 //layer=m1 \
 //thickness=0.36 //x=1.23 //y=7.585 //x2=2.34 //y2=7.585
r2421 (  2 216 ) resistor r=0.028033 //w=0.35 //l=0.085 //layer=m1 \
 //thickness=0.36 //x=87.775 //y=7.585 //x2=87.86 //y2=7.585
r2422 (  2 148 ) resistor r=0.580788 //w=0.311 //l=1.445 //layer=m1 \
 //thickness=0.36 //x=87.775 //y=7.585 //x2=86.33 //y2=7.585
r2423 (  1 88 ) resistor r=0.223071 //w=0.311 //l=0.555 //layer=m1 \
 //thickness=0.36 //x=49.885 //y=7.585 //x2=50.44 //y2=7.585
r2424 (  1 85 ) resistor r=0.223071 //w=0.311 //l=0.555 //layer=m1 \
 //thickness=0.36 //x=49.885 //y=7.585 //x2=49.33 //y2=7.585
ends PM_TMRDFFSNRNQX1\%VDD

subckt PM_TMRDFFSNRNQX1\%noxref_26 ( 5 7 15 19 30 33 34 )
c66 ( 34 0 ) capacitor c=0.0443556f //x=3.455 //y=0.555
c67 ( 33 0 ) capacitor c=0.0194217f //x=2.35 //y=1.09
c68 ( 30 0 ) capacitor c=0.00141302f //x=3.59 //y=1.175
c69 ( 19 0 ) capacitor c=0.00692795f //x=4.56 //y=0.805
c70 ( 15 0 ) capacitor c=0.0155078f //x=4.475 //y=0.72
c71 ( 7 0 ) capacitor c=0.00689459f //x=3.59 //y=0.805
c72 ( 5 0 ) capacitor c=0.0235962f //x=3.505 //y=1.175
r73 (  19 34 ) resistor r=3.57586 //w=0.17 //l=0.125 //layer=li \
 //thickness=0.1 //x=4.56 //y=0.805 //x2=4.56 //y2=0.68
r74 (  19 34 ) resistor r=18.139 //w=0.187 //l=0.265 //layer=li \
 //thickness=0.1 //x=4.56 //y=0.805 //x2=4.56 //y2=1.07
r75 (  16 34 ) resistor r=3.57586 //w=0.17 //l=0.103078 //layer=li \
 //thickness=0.1 //x=3.675 //y=0.72 //x2=3.59 //y2=0.68
r76 (  16 34 ) resistor r=27.3797 //w=0.187 //l=0.4 //layer=li //thickness=0.1 \
 //x=3.675 //y=0.72 //x2=4.075 //y2=0.72
r77 (  15 34 ) resistor r=3.57586 //w=0.17 //l=0.103078 //layer=li \
 //thickness=0.1 //x=4.475 //y=0.72 //x2=4.56 //y2=0.68
r78 (  15 34 ) resistor r=27.3797 //w=0.187 //l=0.4 //layer=li //thickness=0.1 \
 //x=4.475 //y=0.72 //x2=4.075 //y2=0.72
r79 (  11 30 ) resistor r=5.4201 //w=0.17 //l=0.085 //layer=li //thickness=0.1 \
 //x=3.59 //y=1.26 //x2=3.59 //y2=1.175
r80 (  11 34 ) resistor r=10.2674 //w=0.187 //l=0.15 //layer=li \
 //thickness=0.1 //x=3.59 //y=1.26 //x2=3.59 //y2=1.41
r81 (  8 30 ) resistor r=5.4201 //w=0.17 //l=0.085 //layer=li //thickness=0.1 \
 //x=3.59 //y=1.09 //x2=3.59 //y2=1.175
r82 (  8 34 ) resistor r=1.36898 //w=0.187 //l=0.02 //layer=li //thickness=0.1 \
 //x=3.59 //y=1.09 //x2=3.59 //y2=1.07
r83 (  7 34 ) resistor r=3.57586 //w=0.17 //l=0.125 //layer=li //thickness=0.1 \
 //x=3.59 //y=0.805 //x2=3.59 //y2=0.68
r84 (  7 34 ) resistor r=18.139 //w=0.187 //l=0.265 //layer=li //thickness=0.1 \
 //x=3.59 //y=0.805 //x2=3.59 //y2=1.07
r85 (  6 33 ) resistor r=0.751729 //w=0.17 //l=0.085 //layer=li \
 //thickness=0.1 //x=2.625 //y=1.175 //x2=2.54 //y2=1.175
r86 (  5 30 ) resistor r=1.40859 //w=0.34 //l=0.085 //layer=li //thickness=0.1 \
 //x=3.505 //y=1.175 //x2=3.59 //y2=1.175
r87 (  5 6 ) resistor r=60.2353 //w=0.187 //l=0.88 //layer=li //thickness=0.1 \
 //x=3.505 //y=1.175 //x2=2.625 //y2=1.175
ends PM_TMRDFFSNRNQX1\%noxref_26

subckt PM_TMRDFFSNRNQX1\%noxref_27 ( 5 7 15 19 30 33 34 )
c67 ( 34 0 ) capacitor c=0.0451719f //x=8.265 //y=0.555
c68 ( 33 0 ) capacitor c=0.0194945f //x=7.16 //y=1.09
c69 ( 30 0 ) capacitor c=0.00141302f //x=8.4 //y=1.175
c70 ( 19 0 ) capacitor c=0.00692795f //x=9.37 //y=0.805
c71 ( 15 0 ) capacitor c=0.0154868f //x=9.285 //y=0.72
c72 ( 7 0 ) capacitor c=0.00689459f //x=8.4 //y=0.805
c73 ( 5 0 ) capacitor c=0.0235962f //x=8.315 //y=1.175
r74 (  19 34 ) resistor r=3.57586 //w=0.17 //l=0.125 //layer=li \
 //thickness=0.1 //x=9.37 //y=0.805 //x2=9.37 //y2=0.68
r75 (  19 34 ) resistor r=18.139 //w=0.187 //l=0.265 //layer=li \
 //thickness=0.1 //x=9.37 //y=0.805 //x2=9.37 //y2=1.07
r76 (  16 34 ) resistor r=3.57586 //w=0.17 //l=0.103078 //layer=li \
 //thickness=0.1 //x=8.485 //y=0.72 //x2=8.4 //y2=0.68
r77 (  16 34 ) resistor r=27.3797 //w=0.187 //l=0.4 //layer=li //thickness=0.1 \
 //x=8.485 //y=0.72 //x2=8.885 //y2=0.72
r78 (  15 34 ) resistor r=3.57586 //w=0.17 //l=0.103078 //layer=li \
 //thickness=0.1 //x=9.285 //y=0.72 //x2=9.37 //y2=0.68
r79 (  15 34 ) resistor r=27.3797 //w=0.187 //l=0.4 //layer=li //thickness=0.1 \
 //x=9.285 //y=0.72 //x2=8.885 //y2=0.72
r80 (  11 30 ) resistor r=5.4201 //w=0.17 //l=0.085 //layer=li //thickness=0.1 \
 //x=8.4 //y=1.26 //x2=8.4 //y2=1.175
r81 (  11 34 ) resistor r=10.2674 //w=0.187 //l=0.15 //layer=li \
 //thickness=0.1 //x=8.4 //y=1.26 //x2=8.4 //y2=1.41
r82 (  8 30 ) resistor r=5.4201 //w=0.17 //l=0.085 //layer=li //thickness=0.1 \
 //x=8.4 //y=1.09 //x2=8.4 //y2=1.175
r83 (  8 34 ) resistor r=1.36898 //w=0.187 //l=0.02 //layer=li //thickness=0.1 \
 //x=8.4 //y=1.09 //x2=8.4 //y2=1.07
r84 (  7 34 ) resistor r=3.57586 //w=0.17 //l=0.125 //layer=li //thickness=0.1 \
 //x=8.4 //y=0.805 //x2=8.4 //y2=0.68
r85 (  7 34 ) resistor r=18.139 //w=0.187 //l=0.265 //layer=li //thickness=0.1 \
 //x=8.4 //y=0.805 //x2=8.4 //y2=1.07
r86 (  6 33 ) resistor r=0.751729 //w=0.17 //l=0.085 //layer=li \
 //thickness=0.1 //x=7.435 //y=1.175 //x2=7.35 //y2=1.175
r87 (  5 30 ) resistor r=1.40859 //w=0.34 //l=0.085 //layer=li //thickness=0.1 \
 //x=8.315 //y=1.175 //x2=8.4 //y2=1.175
r88 (  5 6 ) resistor r=60.2353 //w=0.187 //l=0.88 //layer=li //thickness=0.1 \
 //x=8.315 //y=1.175 //x2=7.435 //y2=1.175
ends PM_TMRDFFSNRNQX1\%noxref_27

subckt PM_TMRDFFSNRNQX1\%noxref_28 ( 5 7 15 19 30 33 34 )
c68 ( 34 0 ) capacitor c=0.0442917f //x=13.075 //y=0.555
c69 ( 33 0 ) capacitor c=0.0193551f //x=11.97 //y=1.09
c70 ( 30 0 ) capacitor c=0.00141302f //x=13.21 //y=1.175
c71 ( 19 0 ) capacitor c=0.00692795f //x=14.18 //y=0.805
c72 ( 15 0 ) capacitor c=0.0154868f //x=14.095 //y=0.72
c73 ( 7 0 ) capacitor c=0.00689459f //x=13.21 //y=0.805
c74 ( 5 0 ) capacitor c=0.0235962f //x=13.125 //y=1.175
r75 (  19 34 ) resistor r=3.57586 //w=0.17 //l=0.125 //layer=li \
 //thickness=0.1 //x=14.18 //y=0.805 //x2=14.18 //y2=0.68
r76 (  19 34 ) resistor r=18.139 //w=0.187 //l=0.265 //layer=li \
 //thickness=0.1 //x=14.18 //y=0.805 //x2=14.18 //y2=1.07
r77 (  16 34 ) resistor r=3.57586 //w=0.17 //l=0.103078 //layer=li \
 //thickness=0.1 //x=13.295 //y=0.72 //x2=13.21 //y2=0.68
r78 (  16 34 ) resistor r=27.3797 //w=0.187 //l=0.4 //layer=li //thickness=0.1 \
 //x=13.295 //y=0.72 //x2=13.695 //y2=0.72
r79 (  15 34 ) resistor r=3.57586 //w=0.17 //l=0.103078 //layer=li \
 //thickness=0.1 //x=14.095 //y=0.72 //x2=14.18 //y2=0.68
r80 (  15 34 ) resistor r=27.3797 //w=0.187 //l=0.4 //layer=li //thickness=0.1 \
 //x=14.095 //y=0.72 //x2=13.695 //y2=0.72
r81 (  11 30 ) resistor r=5.4201 //w=0.17 //l=0.085 //layer=li //thickness=0.1 \
 //x=13.21 //y=1.26 //x2=13.21 //y2=1.175
r82 (  11 34 ) resistor r=10.2674 //w=0.187 //l=0.15 //layer=li \
 //thickness=0.1 //x=13.21 //y=1.26 //x2=13.21 //y2=1.41
r83 (  8 30 ) resistor r=5.4201 //w=0.17 //l=0.085 //layer=li //thickness=0.1 \
 //x=13.21 //y=1.09 //x2=13.21 //y2=1.175
r84 (  8 34 ) resistor r=1.36898 //w=0.187 //l=0.02 //layer=li //thickness=0.1 \
 //x=13.21 //y=1.09 //x2=13.21 //y2=1.07
r85 (  7 34 ) resistor r=3.57586 //w=0.17 //l=0.125 //layer=li //thickness=0.1 \
 //x=13.21 //y=0.805 //x2=13.21 //y2=0.68
r86 (  7 34 ) resistor r=18.139 //w=0.187 //l=0.265 //layer=li //thickness=0.1 \
 //x=13.21 //y=0.805 //x2=13.21 //y2=1.07
r87 (  6 33 ) resistor r=0.751729 //w=0.17 //l=0.085 //layer=li \
 //thickness=0.1 //x=12.245 //y=1.175 //x2=12.16 //y2=1.175
r88 (  5 30 ) resistor r=1.40859 //w=0.34 //l=0.085 //layer=li //thickness=0.1 \
 //x=13.125 //y=1.175 //x2=13.21 //y2=1.175
r89 (  5 6 ) resistor r=60.2353 //w=0.187 //l=0.88 //layer=li //thickness=0.1 \
 //x=13.125 //y=1.175 //x2=12.245 //y2=1.175
ends PM_TMRDFFSNRNQX1\%noxref_28

subckt PM_TMRDFFSNRNQX1\%noxref_29 ( 5 7 15 19 30 33 34 )
c67 ( 34 0 ) capacitor c=0.0452753f //x=17.885 //y=0.555
c68 ( 33 0 ) capacitor c=0.0194988f //x=16.78 //y=1.09
c69 ( 30 0 ) capacitor c=0.00141302f //x=18.02 //y=1.175
c70 ( 19 0 ) capacitor c=0.00692795f //x=18.99 //y=0.805
c71 ( 15 0 ) capacitor c=0.0153812f //x=18.905 //y=0.72
c72 ( 7 0 ) capacitor c=0.00689459f //x=18.02 //y=0.805
c73 ( 5 0 ) capacitor c=0.0235962f //x=17.935 //y=1.175
r74 (  19 34 ) resistor r=3.57586 //w=0.17 //l=0.125 //layer=li \
 //thickness=0.1 //x=18.99 //y=0.805 //x2=18.99 //y2=0.68
r75 (  19 34 ) resistor r=18.139 //w=0.187 //l=0.265 //layer=li \
 //thickness=0.1 //x=18.99 //y=0.805 //x2=18.99 //y2=1.07
r76 (  16 34 ) resistor r=3.57586 //w=0.17 //l=0.103078 //layer=li \
 //thickness=0.1 //x=18.105 //y=0.72 //x2=18.02 //y2=0.68
r77 (  16 34 ) resistor r=27.3797 //w=0.187 //l=0.4 //layer=li //thickness=0.1 \
 //x=18.105 //y=0.72 //x2=18.505 //y2=0.72
r78 (  15 34 ) resistor r=3.57586 //w=0.17 //l=0.103078 //layer=li \
 //thickness=0.1 //x=18.905 //y=0.72 //x2=18.99 //y2=0.68
r79 (  15 34 ) resistor r=27.3797 //w=0.187 //l=0.4 //layer=li //thickness=0.1 \
 //x=18.905 //y=0.72 //x2=18.505 //y2=0.72
r80 (  11 30 ) resistor r=5.4201 //w=0.17 //l=0.085 //layer=li //thickness=0.1 \
 //x=18.02 //y=1.26 //x2=18.02 //y2=1.175
r81 (  11 34 ) resistor r=10.2674 //w=0.187 //l=0.15 //layer=li \
 //thickness=0.1 //x=18.02 //y=1.26 //x2=18.02 //y2=1.41
r82 (  8 30 ) resistor r=5.4201 //w=0.17 //l=0.085 //layer=li //thickness=0.1 \
 //x=18.02 //y=1.09 //x2=18.02 //y2=1.175
r83 (  8 34 ) resistor r=1.36898 //w=0.187 //l=0.02 //layer=li //thickness=0.1 \
 //x=18.02 //y=1.09 //x2=18.02 //y2=1.07
r84 (  7 34 ) resistor r=3.57586 //w=0.17 //l=0.125 //layer=li //thickness=0.1 \
 //x=18.02 //y=0.805 //x2=18.02 //y2=0.68
r85 (  7 34 ) resistor r=18.139 //w=0.187 //l=0.265 //layer=li //thickness=0.1 \
 //x=18.02 //y=0.805 //x2=18.02 //y2=1.07
r86 (  6 33 ) resistor r=0.751729 //w=0.17 //l=0.085 //layer=li \
 //thickness=0.1 //x=17.055 //y=1.175 //x2=16.97 //y2=1.175
r87 (  5 30 ) resistor r=1.40859 //w=0.34 //l=0.085 //layer=li //thickness=0.1 \
 //x=17.935 //y=1.175 //x2=18.02 //y2=1.175
r88 (  5 6 ) resistor r=60.2353 //w=0.187 //l=0.88 //layer=li //thickness=0.1 \
 //x=17.935 //y=1.175 //x2=17.055 //y2=1.175
ends PM_TMRDFFSNRNQX1\%noxref_29

subckt PM_TMRDFFSNRNQX1\%noxref_30 ( 5 7 15 19 30 33 34 )
c68 ( 34 0 ) capacitor c=0.0444783f //x=22.695 //y=0.555
c69 ( 33 0 ) capacitor c=0.0190261f //x=21.59 //y=1.09
c70 ( 30 0 ) capacitor c=0.00141302f //x=22.83 //y=1.175
c71 ( 19 0 ) capacitor c=0.00692795f //x=23.8 //y=0.805
c72 ( 15 0 ) capacitor c=0.0155062f //x=23.715 //y=0.72
c73 ( 7 0 ) capacitor c=0.00689459f //x=22.83 //y=0.805
c74 ( 5 0 ) capacitor c=0.0235962f //x=22.745 //y=1.175
r75 (  19 34 ) resistor r=3.57586 //w=0.17 //l=0.125 //layer=li \
 //thickness=0.1 //x=23.8 //y=0.805 //x2=23.8 //y2=0.68
r76 (  19 34 ) resistor r=18.139 //w=0.187 //l=0.265 //layer=li \
 //thickness=0.1 //x=23.8 //y=0.805 //x2=23.8 //y2=1.07
r77 (  16 34 ) resistor r=3.57586 //w=0.17 //l=0.103078 //layer=li \
 //thickness=0.1 //x=22.915 //y=0.72 //x2=22.83 //y2=0.68
r78 (  16 34 ) resistor r=27.3797 //w=0.187 //l=0.4 //layer=li //thickness=0.1 \
 //x=22.915 //y=0.72 //x2=23.315 //y2=0.72
r79 (  15 34 ) resistor r=3.57586 //w=0.17 //l=0.103078 //layer=li \
 //thickness=0.1 //x=23.715 //y=0.72 //x2=23.8 //y2=0.68
r80 (  15 34 ) resistor r=27.3797 //w=0.187 //l=0.4 //layer=li //thickness=0.1 \
 //x=23.715 //y=0.72 //x2=23.315 //y2=0.72
r81 (  11 30 ) resistor r=5.4201 //w=0.17 //l=0.085 //layer=li //thickness=0.1 \
 //x=22.83 //y=1.26 //x2=22.83 //y2=1.175
r82 (  11 34 ) resistor r=10.2674 //w=0.187 //l=0.15 //layer=li \
 //thickness=0.1 //x=22.83 //y=1.26 //x2=22.83 //y2=1.41
r83 (  8 30 ) resistor r=5.4201 //w=0.17 //l=0.085 //layer=li //thickness=0.1 \
 //x=22.83 //y=1.09 //x2=22.83 //y2=1.175
r84 (  8 34 ) resistor r=1.36898 //w=0.187 //l=0.02 //layer=li //thickness=0.1 \
 //x=22.83 //y=1.09 //x2=22.83 //y2=1.07
r85 (  7 34 ) resistor r=3.57586 //w=0.17 //l=0.125 //layer=li //thickness=0.1 \
 //x=22.83 //y=0.805 //x2=22.83 //y2=0.68
r86 (  7 34 ) resistor r=18.139 //w=0.187 //l=0.265 //layer=li //thickness=0.1 \
 //x=22.83 //y=0.805 //x2=22.83 //y2=1.07
r87 (  6 33 ) resistor r=0.751729 //w=0.17 //l=0.085 //layer=li \
 //thickness=0.1 //x=21.865 //y=1.175 //x2=21.78 //y2=1.175
r88 (  5 30 ) resistor r=1.40859 //w=0.34 //l=0.085 //layer=li //thickness=0.1 \
 //x=22.745 //y=1.175 //x2=22.83 //y2=1.175
r89 (  5 6 ) resistor r=60.2353 //w=0.187 //l=0.88 //layer=li //thickness=0.1 \
 //x=22.745 //y=1.175 //x2=21.865 //y2=1.175
ends PM_TMRDFFSNRNQX1\%noxref_30

subckt PM_TMRDFFSNRNQX1\%noxref_31 ( 5 7 15 19 30 33 34 )
c69 ( 34 0 ) capacitor c=0.0450311f //x=27.505 //y=0.555
c70 ( 33 0 ) capacitor c=0.018587f //x=26.4 //y=1.09
c71 ( 30 0 ) capacitor c=0.00141302f //x=27.64 //y=1.175
c72 ( 19 0 ) capacitor c=0.00692795f //x=28.61 //y=0.805
c73 ( 15 0 ) capacitor c=0.0154873f //x=28.525 //y=0.72
c74 ( 7 0 ) capacitor c=0.00689459f //x=27.64 //y=0.805
c75 ( 5 0 ) capacitor c=0.0235962f //x=27.555 //y=1.175
r76 (  19 34 ) resistor r=3.57586 //w=0.17 //l=0.125 //layer=li \
 //thickness=0.1 //x=28.61 //y=0.805 //x2=28.61 //y2=0.68
r77 (  19 34 ) resistor r=18.139 //w=0.187 //l=0.265 //layer=li \
 //thickness=0.1 //x=28.61 //y=0.805 //x2=28.61 //y2=1.07
r78 (  16 34 ) resistor r=3.57586 //w=0.17 //l=0.103078 //layer=li \
 //thickness=0.1 //x=27.725 //y=0.72 //x2=27.64 //y2=0.68
r79 (  16 34 ) resistor r=27.3797 //w=0.187 //l=0.4 //layer=li //thickness=0.1 \
 //x=27.725 //y=0.72 //x2=28.125 //y2=0.72
r80 (  15 34 ) resistor r=3.57586 //w=0.17 //l=0.103078 //layer=li \
 //thickness=0.1 //x=28.525 //y=0.72 //x2=28.61 //y2=0.68
r81 (  15 34 ) resistor r=27.3797 //w=0.187 //l=0.4 //layer=li //thickness=0.1 \
 //x=28.525 //y=0.72 //x2=28.125 //y2=0.72
r82 (  11 30 ) resistor r=5.4201 //w=0.17 //l=0.085 //layer=li //thickness=0.1 \
 //x=27.64 //y=1.26 //x2=27.64 //y2=1.175
r83 (  11 34 ) resistor r=10.2674 //w=0.187 //l=0.15 //layer=li \
 //thickness=0.1 //x=27.64 //y=1.26 //x2=27.64 //y2=1.41
r84 (  8 30 ) resistor r=5.4201 //w=0.17 //l=0.085 //layer=li //thickness=0.1 \
 //x=27.64 //y=1.09 //x2=27.64 //y2=1.175
r85 (  8 34 ) resistor r=1.36898 //w=0.187 //l=0.02 //layer=li //thickness=0.1 \
 //x=27.64 //y=1.09 //x2=27.64 //y2=1.07
r86 (  7 34 ) resistor r=3.57586 //w=0.17 //l=0.125 //layer=li //thickness=0.1 \
 //x=27.64 //y=0.805 //x2=27.64 //y2=0.68
r87 (  7 34 ) resistor r=18.139 //w=0.187 //l=0.265 //layer=li //thickness=0.1 \
 //x=27.64 //y=0.805 //x2=27.64 //y2=1.07
r88 (  6 33 ) resistor r=0.751729 //w=0.17 //l=0.085 //layer=li \
 //thickness=0.1 //x=26.675 //y=1.175 //x2=26.59 //y2=1.175
r89 (  5 30 ) resistor r=1.40859 //w=0.34 //l=0.085 //layer=li //thickness=0.1 \
 //x=27.555 //y=1.175 //x2=27.64 //y2=1.175
r90 (  5 6 ) resistor r=60.2353 //w=0.187 //l=0.88 //layer=li //thickness=0.1 \
 //x=27.555 //y=1.175 //x2=26.675 //y2=1.175
ends PM_TMRDFFSNRNQX1\%noxref_31

subckt PM_TMRDFFSNRNQX1\%noxref_32 ( 5 7 15 19 30 33 34 )
c67 ( 34 0 ) capacitor c=0.0443556f //x=32.315 //y=0.555
c68 ( 33 0 ) capacitor c=0.019073f //x=31.21 //y=1.09
c69 ( 30 0 ) capacitor c=0.00141302f //x=32.45 //y=1.175
c70 ( 19 0 ) capacitor c=0.00692795f //x=33.42 //y=0.805
c71 ( 15 0 ) capacitor c=0.0155078f //x=33.335 //y=0.72
c72 ( 7 0 ) capacitor c=0.00689459f //x=32.45 //y=0.805
c73 ( 5 0 ) capacitor c=0.0235962f //x=32.365 //y=1.175
r74 (  19 34 ) resistor r=3.57586 //w=0.17 //l=0.125 //layer=li \
 //thickness=0.1 //x=33.42 //y=0.805 //x2=33.42 //y2=0.68
r75 (  19 34 ) resistor r=18.139 //w=0.187 //l=0.265 //layer=li \
 //thickness=0.1 //x=33.42 //y=0.805 //x2=33.42 //y2=1.07
r76 (  16 34 ) resistor r=3.57586 //w=0.17 //l=0.103078 //layer=li \
 //thickness=0.1 //x=32.535 //y=0.72 //x2=32.45 //y2=0.68
r77 (  16 34 ) resistor r=27.3797 //w=0.187 //l=0.4 //layer=li //thickness=0.1 \
 //x=32.535 //y=0.72 //x2=32.935 //y2=0.72
r78 (  15 34 ) resistor r=3.57586 //w=0.17 //l=0.103078 //layer=li \
 //thickness=0.1 //x=33.335 //y=0.72 //x2=33.42 //y2=0.68
r79 (  15 34 ) resistor r=27.3797 //w=0.187 //l=0.4 //layer=li //thickness=0.1 \
 //x=33.335 //y=0.72 //x2=32.935 //y2=0.72
r80 (  11 30 ) resistor r=5.4201 //w=0.17 //l=0.085 //layer=li //thickness=0.1 \
 //x=32.45 //y=1.26 //x2=32.45 //y2=1.175
r81 (  11 34 ) resistor r=10.2674 //w=0.187 //l=0.15 //layer=li \
 //thickness=0.1 //x=32.45 //y=1.26 //x2=32.45 //y2=1.41
r82 (  8 30 ) resistor r=5.4201 //w=0.17 //l=0.085 //layer=li //thickness=0.1 \
 //x=32.45 //y=1.09 //x2=32.45 //y2=1.175
r83 (  8 34 ) resistor r=1.36898 //w=0.187 //l=0.02 //layer=li //thickness=0.1 \
 //x=32.45 //y=1.09 //x2=32.45 //y2=1.07
r84 (  7 34 ) resistor r=3.57586 //w=0.17 //l=0.125 //layer=li //thickness=0.1 \
 //x=32.45 //y=0.805 //x2=32.45 //y2=0.68
r85 (  7 34 ) resistor r=18.139 //w=0.187 //l=0.265 //layer=li //thickness=0.1 \
 //x=32.45 //y=0.805 //x2=32.45 //y2=1.07
r86 (  6 33 ) resistor r=0.751729 //w=0.17 //l=0.085 //layer=li \
 //thickness=0.1 //x=31.485 //y=1.175 //x2=31.4 //y2=1.175
r87 (  5 30 ) resistor r=1.40859 //w=0.34 //l=0.085 //layer=li //thickness=0.1 \
 //x=32.365 //y=1.175 //x2=32.45 //y2=1.175
r88 (  5 6 ) resistor r=60.2353 //w=0.187 //l=0.88 //layer=li //thickness=0.1 \
 //x=32.365 //y=1.175 //x2=31.485 //y2=1.175
ends PM_TMRDFFSNRNQX1\%noxref_32

subckt PM_TMRDFFSNRNQX1\%noxref_33 ( 5 7 15 19 30 33 34 )
c67 ( 34 0 ) capacitor c=0.0451719f //x=37.125 //y=0.555
c68 ( 33 0 ) capacitor c=0.0194945f //x=36.02 //y=1.09
c69 ( 30 0 ) capacitor c=0.00141302f //x=37.26 //y=1.175
c70 ( 19 0 ) capacitor c=0.00692795f //x=38.23 //y=0.805
c71 ( 15 0 ) capacitor c=0.0154868f //x=38.145 //y=0.72
c72 ( 7 0 ) capacitor c=0.00689459f //x=37.26 //y=0.805
c73 ( 5 0 ) capacitor c=0.0235962f //x=37.175 //y=1.175
r74 (  19 34 ) resistor r=3.57586 //w=0.17 //l=0.125 //layer=li \
 //thickness=0.1 //x=38.23 //y=0.805 //x2=38.23 //y2=0.68
r75 (  19 34 ) resistor r=18.139 //w=0.187 //l=0.265 //layer=li \
 //thickness=0.1 //x=38.23 //y=0.805 //x2=38.23 //y2=1.07
r76 (  16 34 ) resistor r=3.57586 //w=0.17 //l=0.103078 //layer=li \
 //thickness=0.1 //x=37.345 //y=0.72 //x2=37.26 //y2=0.68
r77 (  16 34 ) resistor r=27.3797 //w=0.187 //l=0.4 //layer=li //thickness=0.1 \
 //x=37.345 //y=0.72 //x2=37.745 //y2=0.72
r78 (  15 34 ) resistor r=3.57586 //w=0.17 //l=0.103078 //layer=li \
 //thickness=0.1 //x=38.145 //y=0.72 //x2=38.23 //y2=0.68
r79 (  15 34 ) resistor r=27.3797 //w=0.187 //l=0.4 //layer=li //thickness=0.1 \
 //x=38.145 //y=0.72 //x2=37.745 //y2=0.72
r80 (  11 30 ) resistor r=5.4201 //w=0.17 //l=0.085 //layer=li //thickness=0.1 \
 //x=37.26 //y=1.26 //x2=37.26 //y2=1.175
r81 (  11 34 ) resistor r=10.2674 //w=0.187 //l=0.15 //layer=li \
 //thickness=0.1 //x=37.26 //y=1.26 //x2=37.26 //y2=1.41
r82 (  8 30 ) resistor r=5.4201 //w=0.17 //l=0.085 //layer=li //thickness=0.1 \
 //x=37.26 //y=1.09 //x2=37.26 //y2=1.175
r83 (  8 34 ) resistor r=1.36898 //w=0.187 //l=0.02 //layer=li //thickness=0.1 \
 //x=37.26 //y=1.09 //x2=37.26 //y2=1.07
r84 (  7 34 ) resistor r=3.57586 //w=0.17 //l=0.125 //layer=li //thickness=0.1 \
 //x=37.26 //y=0.805 //x2=37.26 //y2=0.68
r85 (  7 34 ) resistor r=18.139 //w=0.187 //l=0.265 //layer=li //thickness=0.1 \
 //x=37.26 //y=0.805 //x2=37.26 //y2=1.07
r86 (  6 33 ) resistor r=0.751729 //w=0.17 //l=0.085 //layer=li \
 //thickness=0.1 //x=36.295 //y=1.175 //x2=36.21 //y2=1.175
r87 (  5 30 ) resistor r=1.40859 //w=0.34 //l=0.085 //layer=li //thickness=0.1 \
 //x=37.175 //y=1.175 //x2=37.26 //y2=1.175
r88 (  5 6 ) resistor r=60.2353 //w=0.187 //l=0.88 //layer=li //thickness=0.1 \
 //x=37.175 //y=1.175 //x2=36.295 //y2=1.175
ends PM_TMRDFFSNRNQX1\%noxref_33

subckt PM_TMRDFFSNRNQX1\%noxref_34 ( 5 7 15 19 30 33 34 )
c68 ( 34 0 ) capacitor c=0.0442917f //x=41.935 //y=0.555
c69 ( 33 0 ) capacitor c=0.0193551f //x=40.83 //y=1.09
c70 ( 30 0 ) capacitor c=0.00141302f //x=42.07 //y=1.175
c71 ( 19 0 ) capacitor c=0.00692795f //x=43.04 //y=0.805
c72 ( 15 0 ) capacitor c=0.0154868f //x=42.955 //y=0.72
c73 ( 7 0 ) capacitor c=0.00689459f //x=42.07 //y=0.805
c74 ( 5 0 ) capacitor c=0.0235962f //x=41.985 //y=1.175
r75 (  19 34 ) resistor r=3.57586 //w=0.17 //l=0.125 //layer=li \
 //thickness=0.1 //x=43.04 //y=0.805 //x2=43.04 //y2=0.68
r76 (  19 34 ) resistor r=18.139 //w=0.187 //l=0.265 //layer=li \
 //thickness=0.1 //x=43.04 //y=0.805 //x2=43.04 //y2=1.07
r77 (  16 34 ) resistor r=3.57586 //w=0.17 //l=0.103078 //layer=li \
 //thickness=0.1 //x=42.155 //y=0.72 //x2=42.07 //y2=0.68
r78 (  16 34 ) resistor r=27.3797 //w=0.187 //l=0.4 //layer=li //thickness=0.1 \
 //x=42.155 //y=0.72 //x2=42.555 //y2=0.72
r79 (  15 34 ) resistor r=3.57586 //w=0.17 //l=0.103078 //layer=li \
 //thickness=0.1 //x=42.955 //y=0.72 //x2=43.04 //y2=0.68
r80 (  15 34 ) resistor r=27.3797 //w=0.187 //l=0.4 //layer=li //thickness=0.1 \
 //x=42.955 //y=0.72 //x2=42.555 //y2=0.72
r81 (  11 30 ) resistor r=5.4201 //w=0.17 //l=0.085 //layer=li //thickness=0.1 \
 //x=42.07 //y=1.26 //x2=42.07 //y2=1.175
r82 (  11 34 ) resistor r=10.2674 //w=0.187 //l=0.15 //layer=li \
 //thickness=0.1 //x=42.07 //y=1.26 //x2=42.07 //y2=1.41
r83 (  8 30 ) resistor r=5.4201 //w=0.17 //l=0.085 //layer=li //thickness=0.1 \
 //x=42.07 //y=1.09 //x2=42.07 //y2=1.175
r84 (  8 34 ) resistor r=1.36898 //w=0.187 //l=0.02 //layer=li //thickness=0.1 \
 //x=42.07 //y=1.09 //x2=42.07 //y2=1.07
r85 (  7 34 ) resistor r=3.57586 //w=0.17 //l=0.125 //layer=li //thickness=0.1 \
 //x=42.07 //y=0.805 //x2=42.07 //y2=0.68
r86 (  7 34 ) resistor r=18.139 //w=0.187 //l=0.265 //layer=li //thickness=0.1 \
 //x=42.07 //y=0.805 //x2=42.07 //y2=1.07
r87 (  6 33 ) resistor r=0.751729 //w=0.17 //l=0.085 //layer=li \
 //thickness=0.1 //x=41.105 //y=1.175 //x2=41.02 //y2=1.175
r88 (  5 30 ) resistor r=1.40859 //w=0.34 //l=0.085 //layer=li //thickness=0.1 \
 //x=41.985 //y=1.175 //x2=42.07 //y2=1.175
r89 (  5 6 ) resistor r=60.2353 //w=0.187 //l=0.88 //layer=li //thickness=0.1 \
 //x=41.985 //y=1.175 //x2=41.105 //y2=1.175
ends PM_TMRDFFSNRNQX1\%noxref_34

subckt PM_TMRDFFSNRNQX1\%noxref_35 ( 5 7 15 19 30 33 34 )
c67 ( 34 0 ) capacitor c=0.0452753f //x=46.745 //y=0.555
c68 ( 33 0 ) capacitor c=0.0194988f //x=45.64 //y=1.09
c69 ( 30 0 ) capacitor c=0.00141302f //x=46.88 //y=1.175
c70 ( 19 0 ) capacitor c=0.00692795f //x=47.85 //y=0.805
c71 ( 15 0 ) capacitor c=0.0153812f //x=47.765 //y=0.72
c72 ( 7 0 ) capacitor c=0.00689459f //x=46.88 //y=0.805
c73 ( 5 0 ) capacitor c=0.0235962f //x=46.795 //y=1.175
r74 (  19 34 ) resistor r=3.57586 //w=0.17 //l=0.125 //layer=li \
 //thickness=0.1 //x=47.85 //y=0.805 //x2=47.85 //y2=0.68
r75 (  19 34 ) resistor r=18.139 //w=0.187 //l=0.265 //layer=li \
 //thickness=0.1 //x=47.85 //y=0.805 //x2=47.85 //y2=1.07
r76 (  16 34 ) resistor r=3.57586 //w=0.17 //l=0.103078 //layer=li \
 //thickness=0.1 //x=46.965 //y=0.72 //x2=46.88 //y2=0.68
r77 (  16 34 ) resistor r=27.3797 //w=0.187 //l=0.4 //layer=li //thickness=0.1 \
 //x=46.965 //y=0.72 //x2=47.365 //y2=0.72
r78 (  15 34 ) resistor r=3.57586 //w=0.17 //l=0.103078 //layer=li \
 //thickness=0.1 //x=47.765 //y=0.72 //x2=47.85 //y2=0.68
r79 (  15 34 ) resistor r=27.3797 //w=0.187 //l=0.4 //layer=li //thickness=0.1 \
 //x=47.765 //y=0.72 //x2=47.365 //y2=0.72
r80 (  11 30 ) resistor r=5.4201 //w=0.17 //l=0.085 //layer=li //thickness=0.1 \
 //x=46.88 //y=1.26 //x2=46.88 //y2=1.175
r81 (  11 34 ) resistor r=10.2674 //w=0.187 //l=0.15 //layer=li \
 //thickness=0.1 //x=46.88 //y=1.26 //x2=46.88 //y2=1.41
r82 (  8 30 ) resistor r=5.4201 //w=0.17 //l=0.085 //layer=li //thickness=0.1 \
 //x=46.88 //y=1.09 //x2=46.88 //y2=1.175
r83 (  8 34 ) resistor r=1.36898 //w=0.187 //l=0.02 //layer=li //thickness=0.1 \
 //x=46.88 //y=1.09 //x2=46.88 //y2=1.07
r84 (  7 34 ) resistor r=3.57586 //w=0.17 //l=0.125 //layer=li //thickness=0.1 \
 //x=46.88 //y=0.805 //x2=46.88 //y2=0.68
r85 (  7 34 ) resistor r=18.139 //w=0.187 //l=0.265 //layer=li //thickness=0.1 \
 //x=46.88 //y=0.805 //x2=46.88 //y2=1.07
r86 (  6 33 ) resistor r=0.751729 //w=0.17 //l=0.085 //layer=li \
 //thickness=0.1 //x=45.915 //y=1.175 //x2=45.83 //y2=1.175
r87 (  5 30 ) resistor r=1.40859 //w=0.34 //l=0.085 //layer=li //thickness=0.1 \
 //x=46.795 //y=1.175 //x2=46.88 //y2=1.175
r88 (  5 6 ) resistor r=60.2353 //w=0.187 //l=0.88 //layer=li //thickness=0.1 \
 //x=46.795 //y=1.175 //x2=45.915 //y2=1.175
ends PM_TMRDFFSNRNQX1\%noxref_35

subckt PM_TMRDFFSNRNQX1\%noxref_36 ( 5 7 15 19 30 33 34 )
c68 ( 34 0 ) capacitor c=0.0444783f //x=51.555 //y=0.555
c69 ( 33 0 ) capacitor c=0.0190261f //x=50.45 //y=1.09
c70 ( 30 0 ) capacitor c=0.00141302f //x=51.69 //y=1.175
c71 ( 19 0 ) capacitor c=0.00692795f //x=52.66 //y=0.805
c72 ( 15 0 ) capacitor c=0.0155062f //x=52.575 //y=0.72
c73 ( 7 0 ) capacitor c=0.00689459f //x=51.69 //y=0.805
c74 ( 5 0 ) capacitor c=0.0235962f //x=51.605 //y=1.175
r75 (  19 34 ) resistor r=3.57586 //w=0.17 //l=0.125 //layer=li \
 //thickness=0.1 //x=52.66 //y=0.805 //x2=52.66 //y2=0.68
r76 (  19 34 ) resistor r=18.139 //w=0.187 //l=0.265 //layer=li \
 //thickness=0.1 //x=52.66 //y=0.805 //x2=52.66 //y2=1.07
r77 (  16 34 ) resistor r=3.57586 //w=0.17 //l=0.103078 //layer=li \
 //thickness=0.1 //x=51.775 //y=0.72 //x2=51.69 //y2=0.68
r78 (  16 34 ) resistor r=27.3797 //w=0.187 //l=0.4 //layer=li //thickness=0.1 \
 //x=51.775 //y=0.72 //x2=52.175 //y2=0.72
r79 (  15 34 ) resistor r=3.57586 //w=0.17 //l=0.103078 //layer=li \
 //thickness=0.1 //x=52.575 //y=0.72 //x2=52.66 //y2=0.68
r80 (  15 34 ) resistor r=27.3797 //w=0.187 //l=0.4 //layer=li //thickness=0.1 \
 //x=52.575 //y=0.72 //x2=52.175 //y2=0.72
r81 (  11 30 ) resistor r=5.4201 //w=0.17 //l=0.085 //layer=li //thickness=0.1 \
 //x=51.69 //y=1.26 //x2=51.69 //y2=1.175
r82 (  11 34 ) resistor r=10.2674 //w=0.187 //l=0.15 //layer=li \
 //thickness=0.1 //x=51.69 //y=1.26 //x2=51.69 //y2=1.41
r83 (  8 30 ) resistor r=5.4201 //w=0.17 //l=0.085 //layer=li //thickness=0.1 \
 //x=51.69 //y=1.09 //x2=51.69 //y2=1.175
r84 (  8 34 ) resistor r=1.36898 //w=0.187 //l=0.02 //layer=li //thickness=0.1 \
 //x=51.69 //y=1.09 //x2=51.69 //y2=1.07
r85 (  7 34 ) resistor r=3.57586 //w=0.17 //l=0.125 //layer=li //thickness=0.1 \
 //x=51.69 //y=0.805 //x2=51.69 //y2=0.68
r86 (  7 34 ) resistor r=18.139 //w=0.187 //l=0.265 //layer=li //thickness=0.1 \
 //x=51.69 //y=0.805 //x2=51.69 //y2=1.07
r87 (  6 33 ) resistor r=0.751729 //w=0.17 //l=0.085 //layer=li \
 //thickness=0.1 //x=50.725 //y=1.175 //x2=50.64 //y2=1.175
r88 (  5 30 ) resistor r=1.40859 //w=0.34 //l=0.085 //layer=li //thickness=0.1 \
 //x=51.605 //y=1.175 //x2=51.69 //y2=1.175
r89 (  5 6 ) resistor r=60.2353 //w=0.187 //l=0.88 //layer=li //thickness=0.1 \
 //x=51.605 //y=1.175 //x2=50.725 //y2=1.175
ends PM_TMRDFFSNRNQX1\%noxref_36

subckt PM_TMRDFFSNRNQX1\%noxref_37 ( 5 7 15 19 30 33 34 )
c69 ( 34 0 ) capacitor c=0.0450311f //x=56.365 //y=0.555
c70 ( 33 0 ) capacitor c=0.018587f //x=55.26 //y=1.09
c71 ( 30 0 ) capacitor c=0.00141302f //x=56.5 //y=1.175
c72 ( 19 0 ) capacitor c=0.00692795f //x=57.47 //y=0.805
c73 ( 15 0 ) capacitor c=0.0154873f //x=57.385 //y=0.72
c74 ( 7 0 ) capacitor c=0.00689459f //x=56.5 //y=0.805
c75 ( 5 0 ) capacitor c=0.0235962f //x=56.415 //y=1.175
r76 (  19 34 ) resistor r=3.57586 //w=0.17 //l=0.125 //layer=li \
 //thickness=0.1 //x=57.47 //y=0.805 //x2=57.47 //y2=0.68
r77 (  19 34 ) resistor r=18.139 //w=0.187 //l=0.265 //layer=li \
 //thickness=0.1 //x=57.47 //y=0.805 //x2=57.47 //y2=1.07
r78 (  16 34 ) resistor r=3.57586 //w=0.17 //l=0.103078 //layer=li \
 //thickness=0.1 //x=56.585 //y=0.72 //x2=56.5 //y2=0.68
r79 (  16 34 ) resistor r=27.3797 //w=0.187 //l=0.4 //layer=li //thickness=0.1 \
 //x=56.585 //y=0.72 //x2=56.985 //y2=0.72
r80 (  15 34 ) resistor r=3.57586 //w=0.17 //l=0.103078 //layer=li \
 //thickness=0.1 //x=57.385 //y=0.72 //x2=57.47 //y2=0.68
r81 (  15 34 ) resistor r=27.3797 //w=0.187 //l=0.4 //layer=li //thickness=0.1 \
 //x=57.385 //y=0.72 //x2=56.985 //y2=0.72
r82 (  11 30 ) resistor r=5.4201 //w=0.17 //l=0.085 //layer=li //thickness=0.1 \
 //x=56.5 //y=1.26 //x2=56.5 //y2=1.175
r83 (  11 34 ) resistor r=10.2674 //w=0.187 //l=0.15 //layer=li \
 //thickness=0.1 //x=56.5 //y=1.26 //x2=56.5 //y2=1.41
r84 (  8 30 ) resistor r=5.4201 //w=0.17 //l=0.085 //layer=li //thickness=0.1 \
 //x=56.5 //y=1.09 //x2=56.5 //y2=1.175
r85 (  8 34 ) resistor r=1.36898 //w=0.187 //l=0.02 //layer=li //thickness=0.1 \
 //x=56.5 //y=1.09 //x2=56.5 //y2=1.07
r86 (  7 34 ) resistor r=3.57586 //w=0.17 //l=0.125 //layer=li //thickness=0.1 \
 //x=56.5 //y=0.805 //x2=56.5 //y2=0.68
r87 (  7 34 ) resistor r=18.139 //w=0.187 //l=0.265 //layer=li //thickness=0.1 \
 //x=56.5 //y=0.805 //x2=56.5 //y2=1.07
r88 (  6 33 ) resistor r=0.751729 //w=0.17 //l=0.085 //layer=li \
 //thickness=0.1 //x=55.535 //y=1.175 //x2=55.45 //y2=1.175
r89 (  5 30 ) resistor r=1.40859 //w=0.34 //l=0.085 //layer=li //thickness=0.1 \
 //x=56.415 //y=1.175 //x2=56.5 //y2=1.175
r90 (  5 6 ) resistor r=60.2353 //w=0.187 //l=0.88 //layer=li //thickness=0.1 \
 //x=56.415 //y=1.175 //x2=55.535 //y2=1.175
ends PM_TMRDFFSNRNQX1\%noxref_37

subckt PM_TMRDFFSNRNQX1\%noxref_38 ( 5 7 15 19 30 33 34 )
c67 ( 34 0 ) capacitor c=0.0443556f //x=61.175 //y=0.555
c68 ( 33 0 ) capacitor c=0.019073f //x=60.07 //y=1.09
c69 ( 30 0 ) capacitor c=0.00141302f //x=61.31 //y=1.175
c70 ( 19 0 ) capacitor c=0.00692795f //x=62.28 //y=0.805
c71 ( 15 0 ) capacitor c=0.0155078f //x=62.195 //y=0.72
c72 ( 7 0 ) capacitor c=0.00689459f //x=61.31 //y=0.805
c73 ( 5 0 ) capacitor c=0.0235962f //x=61.225 //y=1.175
r74 (  19 34 ) resistor r=3.57586 //w=0.17 //l=0.125 //layer=li \
 //thickness=0.1 //x=62.28 //y=0.805 //x2=62.28 //y2=0.68
r75 (  19 34 ) resistor r=18.139 //w=0.187 //l=0.265 //layer=li \
 //thickness=0.1 //x=62.28 //y=0.805 //x2=62.28 //y2=1.07
r76 (  16 34 ) resistor r=3.57586 //w=0.17 //l=0.103078 //layer=li \
 //thickness=0.1 //x=61.395 //y=0.72 //x2=61.31 //y2=0.68
r77 (  16 34 ) resistor r=27.3797 //w=0.187 //l=0.4 //layer=li //thickness=0.1 \
 //x=61.395 //y=0.72 //x2=61.795 //y2=0.72
r78 (  15 34 ) resistor r=3.57586 //w=0.17 //l=0.103078 //layer=li \
 //thickness=0.1 //x=62.195 //y=0.72 //x2=62.28 //y2=0.68
r79 (  15 34 ) resistor r=27.3797 //w=0.187 //l=0.4 //layer=li //thickness=0.1 \
 //x=62.195 //y=0.72 //x2=61.795 //y2=0.72
r80 (  11 30 ) resistor r=5.4201 //w=0.17 //l=0.085 //layer=li //thickness=0.1 \
 //x=61.31 //y=1.26 //x2=61.31 //y2=1.175
r81 (  11 34 ) resistor r=10.2674 //w=0.187 //l=0.15 //layer=li \
 //thickness=0.1 //x=61.31 //y=1.26 //x2=61.31 //y2=1.41
r82 (  8 30 ) resistor r=5.4201 //w=0.17 //l=0.085 //layer=li //thickness=0.1 \
 //x=61.31 //y=1.09 //x2=61.31 //y2=1.175
r83 (  8 34 ) resistor r=1.36898 //w=0.187 //l=0.02 //layer=li //thickness=0.1 \
 //x=61.31 //y=1.09 //x2=61.31 //y2=1.07
r84 (  7 34 ) resistor r=3.57586 //w=0.17 //l=0.125 //layer=li //thickness=0.1 \
 //x=61.31 //y=0.805 //x2=61.31 //y2=0.68
r85 (  7 34 ) resistor r=18.139 //w=0.187 //l=0.265 //layer=li //thickness=0.1 \
 //x=61.31 //y=0.805 //x2=61.31 //y2=1.07
r86 (  6 33 ) resistor r=0.751729 //w=0.17 //l=0.085 //layer=li \
 //thickness=0.1 //x=60.345 //y=1.175 //x2=60.26 //y2=1.175
r87 (  5 30 ) resistor r=1.40859 //w=0.34 //l=0.085 //layer=li //thickness=0.1 \
 //x=61.225 //y=1.175 //x2=61.31 //y2=1.175
r88 (  5 6 ) resistor r=60.2353 //w=0.187 //l=0.88 //layer=li //thickness=0.1 \
 //x=61.225 //y=1.175 //x2=60.345 //y2=1.175
ends PM_TMRDFFSNRNQX1\%noxref_38

subckt PM_TMRDFFSNRNQX1\%noxref_39 ( 5 7 15 19 30 33 34 )
c67 ( 34 0 ) capacitor c=0.0451719f //x=65.985 //y=0.555
c68 ( 33 0 ) capacitor c=0.0194945f //x=64.88 //y=1.09
c69 ( 30 0 ) capacitor c=0.00141302f //x=66.12 //y=1.175
c70 ( 19 0 ) capacitor c=0.00692795f //x=67.09 //y=0.805
c71 ( 15 0 ) capacitor c=0.0154868f //x=67.005 //y=0.72
c72 ( 7 0 ) capacitor c=0.00689459f //x=66.12 //y=0.805
c73 ( 5 0 ) capacitor c=0.0235962f //x=66.035 //y=1.175
r74 (  19 34 ) resistor r=3.57586 //w=0.17 //l=0.125 //layer=li \
 //thickness=0.1 //x=67.09 //y=0.805 //x2=67.09 //y2=0.68
r75 (  19 34 ) resistor r=18.139 //w=0.187 //l=0.265 //layer=li \
 //thickness=0.1 //x=67.09 //y=0.805 //x2=67.09 //y2=1.07
r76 (  16 34 ) resistor r=3.57586 //w=0.17 //l=0.103078 //layer=li \
 //thickness=0.1 //x=66.205 //y=0.72 //x2=66.12 //y2=0.68
r77 (  16 34 ) resistor r=27.3797 //w=0.187 //l=0.4 //layer=li //thickness=0.1 \
 //x=66.205 //y=0.72 //x2=66.605 //y2=0.72
r78 (  15 34 ) resistor r=3.57586 //w=0.17 //l=0.103078 //layer=li \
 //thickness=0.1 //x=67.005 //y=0.72 //x2=67.09 //y2=0.68
r79 (  15 34 ) resistor r=27.3797 //w=0.187 //l=0.4 //layer=li //thickness=0.1 \
 //x=67.005 //y=0.72 //x2=66.605 //y2=0.72
r80 (  11 30 ) resistor r=5.4201 //w=0.17 //l=0.085 //layer=li //thickness=0.1 \
 //x=66.12 //y=1.26 //x2=66.12 //y2=1.175
r81 (  11 34 ) resistor r=10.2674 //w=0.187 //l=0.15 //layer=li \
 //thickness=0.1 //x=66.12 //y=1.26 //x2=66.12 //y2=1.41
r82 (  8 30 ) resistor r=5.4201 //w=0.17 //l=0.085 //layer=li //thickness=0.1 \
 //x=66.12 //y=1.09 //x2=66.12 //y2=1.175
r83 (  8 34 ) resistor r=1.36898 //w=0.187 //l=0.02 //layer=li //thickness=0.1 \
 //x=66.12 //y=1.09 //x2=66.12 //y2=1.07
r84 (  7 34 ) resistor r=3.57586 //w=0.17 //l=0.125 //layer=li //thickness=0.1 \
 //x=66.12 //y=0.805 //x2=66.12 //y2=0.68
r85 (  7 34 ) resistor r=18.139 //w=0.187 //l=0.265 //layer=li //thickness=0.1 \
 //x=66.12 //y=0.805 //x2=66.12 //y2=1.07
r86 (  6 33 ) resistor r=0.751729 //w=0.17 //l=0.085 //layer=li \
 //thickness=0.1 //x=65.155 //y=1.175 //x2=65.07 //y2=1.175
r87 (  5 30 ) resistor r=1.40859 //w=0.34 //l=0.085 //layer=li //thickness=0.1 \
 //x=66.035 //y=1.175 //x2=66.12 //y2=1.175
r88 (  5 6 ) resistor r=60.2353 //w=0.187 //l=0.88 //layer=li //thickness=0.1 \
 //x=66.035 //y=1.175 //x2=65.155 //y2=1.175
ends PM_TMRDFFSNRNQX1\%noxref_39

subckt PM_TMRDFFSNRNQX1\%noxref_40 ( 5 7 15 19 30 33 34 )
c68 ( 34 0 ) capacitor c=0.0442917f //x=70.795 //y=0.555
c69 ( 33 0 ) capacitor c=0.0193551f //x=69.69 //y=1.09
c70 ( 30 0 ) capacitor c=0.00141302f //x=70.93 //y=1.175
c71 ( 19 0 ) capacitor c=0.00692795f //x=71.9 //y=0.805
c72 ( 15 0 ) capacitor c=0.0154868f //x=71.815 //y=0.72
c73 ( 7 0 ) capacitor c=0.00689459f //x=70.93 //y=0.805
c74 ( 5 0 ) capacitor c=0.0235962f //x=70.845 //y=1.175
r75 (  19 34 ) resistor r=3.57586 //w=0.17 //l=0.125 //layer=li \
 //thickness=0.1 //x=71.9 //y=0.805 //x2=71.9 //y2=0.68
r76 (  19 34 ) resistor r=18.139 //w=0.187 //l=0.265 //layer=li \
 //thickness=0.1 //x=71.9 //y=0.805 //x2=71.9 //y2=1.07
r77 (  16 34 ) resistor r=3.57586 //w=0.17 //l=0.103078 //layer=li \
 //thickness=0.1 //x=71.015 //y=0.72 //x2=70.93 //y2=0.68
r78 (  16 34 ) resistor r=27.3797 //w=0.187 //l=0.4 //layer=li //thickness=0.1 \
 //x=71.015 //y=0.72 //x2=71.415 //y2=0.72
r79 (  15 34 ) resistor r=3.57586 //w=0.17 //l=0.103078 //layer=li \
 //thickness=0.1 //x=71.815 //y=0.72 //x2=71.9 //y2=0.68
r80 (  15 34 ) resistor r=27.3797 //w=0.187 //l=0.4 //layer=li //thickness=0.1 \
 //x=71.815 //y=0.72 //x2=71.415 //y2=0.72
r81 (  11 30 ) resistor r=5.4201 //w=0.17 //l=0.085 //layer=li //thickness=0.1 \
 //x=70.93 //y=1.26 //x2=70.93 //y2=1.175
r82 (  11 34 ) resistor r=10.2674 //w=0.187 //l=0.15 //layer=li \
 //thickness=0.1 //x=70.93 //y=1.26 //x2=70.93 //y2=1.41
r83 (  8 30 ) resistor r=5.4201 //w=0.17 //l=0.085 //layer=li //thickness=0.1 \
 //x=70.93 //y=1.09 //x2=70.93 //y2=1.175
r84 (  8 34 ) resistor r=1.36898 //w=0.187 //l=0.02 //layer=li //thickness=0.1 \
 //x=70.93 //y=1.09 //x2=70.93 //y2=1.07
r85 (  7 34 ) resistor r=3.57586 //w=0.17 //l=0.125 //layer=li //thickness=0.1 \
 //x=70.93 //y=0.805 //x2=70.93 //y2=0.68
r86 (  7 34 ) resistor r=18.139 //w=0.187 //l=0.265 //layer=li //thickness=0.1 \
 //x=70.93 //y=0.805 //x2=70.93 //y2=1.07
r87 (  6 33 ) resistor r=0.751729 //w=0.17 //l=0.085 //layer=li \
 //thickness=0.1 //x=69.965 //y=1.175 //x2=69.88 //y2=1.175
r88 (  5 30 ) resistor r=1.40859 //w=0.34 //l=0.085 //layer=li //thickness=0.1 \
 //x=70.845 //y=1.175 //x2=70.93 //y2=1.175
r89 (  5 6 ) resistor r=60.2353 //w=0.187 //l=0.88 //layer=li //thickness=0.1 \
 //x=70.845 //y=1.175 //x2=69.965 //y2=1.175
ends PM_TMRDFFSNRNQX1\%noxref_40

subckt PM_TMRDFFSNRNQX1\%noxref_41 ( 5 7 15 19 30 33 34 )
c67 ( 34 0 ) capacitor c=0.0452753f //x=75.605 //y=0.555
c68 ( 33 0 ) capacitor c=0.0194988f //x=74.5 //y=1.09
c69 ( 30 0 ) capacitor c=0.00141302f //x=75.74 //y=1.175
c70 ( 19 0 ) capacitor c=0.00692795f //x=76.71 //y=0.805
c71 ( 15 0 ) capacitor c=0.0153812f //x=76.625 //y=0.72
c72 ( 7 0 ) capacitor c=0.00689459f //x=75.74 //y=0.805
c73 ( 5 0 ) capacitor c=0.0235962f //x=75.655 //y=1.175
r74 (  19 34 ) resistor r=3.57586 //w=0.17 //l=0.125 //layer=li \
 //thickness=0.1 //x=76.71 //y=0.805 //x2=76.71 //y2=0.68
r75 (  19 34 ) resistor r=18.139 //w=0.187 //l=0.265 //layer=li \
 //thickness=0.1 //x=76.71 //y=0.805 //x2=76.71 //y2=1.07
r76 (  16 34 ) resistor r=3.57586 //w=0.17 //l=0.103078 //layer=li \
 //thickness=0.1 //x=75.825 //y=0.72 //x2=75.74 //y2=0.68
r77 (  16 34 ) resistor r=27.3797 //w=0.187 //l=0.4 //layer=li //thickness=0.1 \
 //x=75.825 //y=0.72 //x2=76.225 //y2=0.72
r78 (  15 34 ) resistor r=3.57586 //w=0.17 //l=0.103078 //layer=li \
 //thickness=0.1 //x=76.625 //y=0.72 //x2=76.71 //y2=0.68
r79 (  15 34 ) resistor r=27.3797 //w=0.187 //l=0.4 //layer=li //thickness=0.1 \
 //x=76.625 //y=0.72 //x2=76.225 //y2=0.72
r80 (  11 30 ) resistor r=5.4201 //w=0.17 //l=0.085 //layer=li //thickness=0.1 \
 //x=75.74 //y=1.26 //x2=75.74 //y2=1.175
r81 (  11 34 ) resistor r=10.2674 //w=0.187 //l=0.15 //layer=li \
 //thickness=0.1 //x=75.74 //y=1.26 //x2=75.74 //y2=1.41
r82 (  8 30 ) resistor r=5.4201 //w=0.17 //l=0.085 //layer=li //thickness=0.1 \
 //x=75.74 //y=1.09 //x2=75.74 //y2=1.175
r83 (  8 34 ) resistor r=1.36898 //w=0.187 //l=0.02 //layer=li //thickness=0.1 \
 //x=75.74 //y=1.09 //x2=75.74 //y2=1.07
r84 (  7 34 ) resistor r=3.57586 //w=0.17 //l=0.125 //layer=li //thickness=0.1 \
 //x=75.74 //y=0.805 //x2=75.74 //y2=0.68
r85 (  7 34 ) resistor r=18.139 //w=0.187 //l=0.265 //layer=li //thickness=0.1 \
 //x=75.74 //y=0.805 //x2=75.74 //y2=1.07
r86 (  6 33 ) resistor r=0.751729 //w=0.17 //l=0.085 //layer=li \
 //thickness=0.1 //x=74.775 //y=1.175 //x2=74.69 //y2=1.175
r87 (  5 30 ) resistor r=1.40859 //w=0.34 //l=0.085 //layer=li //thickness=0.1 \
 //x=75.655 //y=1.175 //x2=75.74 //y2=1.175
r88 (  5 6 ) resistor r=60.2353 //w=0.187 //l=0.88 //layer=li //thickness=0.1 \
 //x=75.655 //y=1.175 //x2=74.775 //y2=1.175
ends PM_TMRDFFSNRNQX1\%noxref_41

subckt PM_TMRDFFSNRNQX1\%noxref_42 ( 5 7 15 19 30 33 34 )
c68 ( 34 0 ) capacitor c=0.0445231f //x=80.415 //y=0.555
c69 ( 33 0 ) capacitor c=0.0190261f //x=79.31 //y=1.09
c70 ( 30 0 ) capacitor c=0.00141302f //x=80.55 //y=1.175
c71 ( 19 0 ) capacitor c=0.00692795f //x=81.52 //y=0.805
c72 ( 15 0 ) capacitor c=0.0153783f //x=81.435 //y=0.72
c73 ( 7 0 ) capacitor c=0.00689459f //x=80.55 //y=0.805
c74 ( 5 0 ) capacitor c=0.0247635f //x=80.465 //y=1.175
r75 (  19 34 ) resistor r=3.57586 //w=0.17 //l=0.125 //layer=li \
 //thickness=0.1 //x=81.52 //y=0.805 //x2=81.52 //y2=0.68
r76 (  19 34 ) resistor r=18.139 //w=0.187 //l=0.265 //layer=li \
 //thickness=0.1 //x=81.52 //y=0.805 //x2=81.52 //y2=1.07
r77 (  16 34 ) resistor r=3.57586 //w=0.17 //l=0.103078 //layer=li \
 //thickness=0.1 //x=80.635 //y=0.72 //x2=80.55 //y2=0.68
r78 (  16 34 ) resistor r=27.3797 //w=0.187 //l=0.4 //layer=li //thickness=0.1 \
 //x=80.635 //y=0.72 //x2=81.035 //y2=0.72
r79 (  15 34 ) resistor r=3.57586 //w=0.17 //l=0.103078 //layer=li \
 //thickness=0.1 //x=81.435 //y=0.72 //x2=81.52 //y2=0.68
r80 (  15 34 ) resistor r=27.3797 //w=0.187 //l=0.4 //layer=li //thickness=0.1 \
 //x=81.435 //y=0.72 //x2=81.035 //y2=0.72
r81 (  11 30 ) resistor r=5.4201 //w=0.17 //l=0.085 //layer=li //thickness=0.1 \
 //x=80.55 //y=1.26 //x2=80.55 //y2=1.175
r82 (  11 34 ) resistor r=10.2674 //w=0.187 //l=0.15 //layer=li \
 //thickness=0.1 //x=80.55 //y=1.26 //x2=80.55 //y2=1.41
r83 (  8 30 ) resistor r=5.4201 //w=0.17 //l=0.085 //layer=li //thickness=0.1 \
 //x=80.55 //y=1.09 //x2=80.55 //y2=1.175
r84 (  8 34 ) resistor r=1.36898 //w=0.187 //l=0.02 //layer=li //thickness=0.1 \
 //x=80.55 //y=1.09 //x2=80.55 //y2=1.07
r85 (  7 34 ) resistor r=3.57586 //w=0.17 //l=0.125 //layer=li //thickness=0.1 \
 //x=80.55 //y=0.805 //x2=80.55 //y2=0.68
r86 (  7 34 ) resistor r=18.139 //w=0.187 //l=0.265 //layer=li //thickness=0.1 \
 //x=80.55 //y=0.805 //x2=80.55 //y2=1.07
r87 (  6 33 ) resistor r=0.751729 //w=0.17 //l=0.085 //layer=li \
 //thickness=0.1 //x=79.585 //y=1.175 //x2=79.5 //y2=1.175
r88 (  5 30 ) resistor r=1.40859 //w=0.34 //l=0.085 //layer=li //thickness=0.1 \
 //x=80.465 //y=1.175 //x2=80.55 //y2=1.175
r89 (  5 6 ) resistor r=60.2353 //w=0.187 //l=0.88 //layer=li //thickness=0.1 \
 //x=80.465 //y=1.175 //x2=79.585 //y2=1.175
ends PM_TMRDFFSNRNQX1\%noxref_42

subckt PM_TMRDFFSNRNQX1\%noxref_43 ( 5 7 15 19 30 33 34 )
c69 ( 34 0 ) capacitor c=0.0437205f //x=85.225 //y=0.555
c70 ( 33 0 ) capacitor c=0.0185765f //x=84.12 //y=1.09
c71 ( 30 0 ) capacitor c=0.00141302f //x=85.36 //y=1.175
c72 ( 19 0 ) capacitor c=0.00695768f //x=86.33 //y=0.805
c73 ( 15 0 ) capacitor c=0.0154873f //x=86.245 //y=0.72
c74 ( 7 0 ) capacitor c=0.00689476f //x=85.36 //y=0.805
c75 ( 5 0 ) capacitor c=0.0235962f //x=85.275 //y=1.175
r76 (  19 34 ) resistor r=3.57586 //w=0.17 //l=0.125 //layer=li \
 //thickness=0.1 //x=86.33 //y=0.805 //x2=86.33 //y2=0.68
r77 (  19 34 ) resistor r=18.139 //w=0.187 //l=0.265 //layer=li \
 //thickness=0.1 //x=86.33 //y=0.805 //x2=86.33 //y2=1.07
r78 (  16 34 ) resistor r=3.57586 //w=0.17 //l=0.103078 //layer=li \
 //thickness=0.1 //x=85.445 //y=0.72 //x2=85.36 //y2=0.68
r79 (  16 34 ) resistor r=27.3797 //w=0.187 //l=0.4 //layer=li //thickness=0.1 \
 //x=85.445 //y=0.72 //x2=85.845 //y2=0.72
r80 (  15 34 ) resistor r=3.57586 //w=0.17 //l=0.103078 //layer=li \
 //thickness=0.1 //x=86.245 //y=0.72 //x2=86.33 //y2=0.68
r81 (  15 34 ) resistor r=27.3797 //w=0.187 //l=0.4 //layer=li //thickness=0.1 \
 //x=86.245 //y=0.72 //x2=85.845 //y2=0.72
r82 (  11 30 ) resistor r=5.4201 //w=0.17 //l=0.085 //layer=li //thickness=0.1 \
 //x=85.36 //y=1.26 //x2=85.36 //y2=1.175
r83 (  11 34 ) resistor r=10.2674 //w=0.187 //l=0.15 //layer=li \
 //thickness=0.1 //x=85.36 //y=1.26 //x2=85.36 //y2=1.41
r84 (  8 30 ) resistor r=5.4201 //w=0.17 //l=0.085 //layer=li //thickness=0.1 \
 //x=85.36 //y=1.09 //x2=85.36 //y2=1.175
r85 (  8 34 ) resistor r=1.36898 //w=0.187 //l=0.02 //layer=li //thickness=0.1 \
 //x=85.36 //y=1.09 //x2=85.36 //y2=1.07
r86 (  7 34 ) resistor r=3.57586 //w=0.17 //l=0.125 //layer=li //thickness=0.1 \
 //x=85.36 //y=0.805 //x2=85.36 //y2=0.68
r87 (  7 34 ) resistor r=18.139 //w=0.187 //l=0.265 //layer=li //thickness=0.1 \
 //x=85.36 //y=0.805 //x2=85.36 //y2=1.07
r88 (  6 33 ) resistor r=0.751729 //w=0.17 //l=0.085 //layer=li \
 //thickness=0.1 //x=84.395 //y=1.175 //x2=84.31 //y2=1.175
r89 (  5 30 ) resistor r=1.40859 //w=0.34 //l=0.085 //layer=li //thickness=0.1 \
 //x=85.275 //y=1.175 //x2=85.36 //y2=1.175
r90 (  5 6 ) resistor r=60.2353 //w=0.187 //l=0.88 //layer=li //thickness=0.1 \
 //x=85.275 //y=1.175 //x2=84.395 //y2=1.175
ends PM_TMRDFFSNRNQX1\%noxref_43

subckt PM_TMRDFFSNRNQX1\%noxref_44 ( 1 3 4 5 7 9 19 25 27 30 40 49 71 72 73 74 \
 75 )
c160 ( 75 0 ) capacitor c=0.0354016f //x=92.795 //y=5.205
c161 ( 74 0 ) capacitor c=0.0241107f //x=91.915 //y=5.205
c162 ( 72 0 ) capacitor c=0.00544792f //x=89.035 //y=5.205
c163 ( 71 0 ) capacitor c=0.00516996f //x=88.155 //y=5.205
c164 ( 49 0 ) capacitor c=0.0509795f //x=91.18 //y=5.39
c165 ( 40 0 ) capacitor c=0.0363228f //x=89.18 //y=5.39
c166 ( 30 0 ) capacitor c=0.0294643f //x=88.3 //y=5.56
c167 ( 27 0 ) capacitor c=0.00984489f //x=92.94 //y=6.92
c168 ( 25 0 ) capacitor c=0.0059844f //x=92.057 //y=7.09
c169 ( 19 0 ) capacitor c=0.00975753f //x=91.18 //y=6.92
c170 ( 9 0 ) capacitor c=0.014892f //x=88.302 //y=5.39
c171 ( 7 0 ) capacitor c=0.00787288f //x=92.825 //y=7.09
c172 ( 5 0 ) capacitor c=0.00659042f //x=91.94 //y=7.09
c173 ( 4 0 ) capacitor c=0.0054878f //x=89.295 //y=5.39
c174 ( 3 0 ) capacitor c=0.0636102f //x=91.065 //y=5.39
c175 ( 1 0 ) capacitor c=0.0145996f //x=89.065 //y=5.39
r176 (  49 73 ) resistor r=58.1818 //w=0.187 //l=0.85 //layer=li \
 //thickness=0.1 //x=91.18 //y=5.39 //x2=91.18 //y2=6.24
r177 (  40 72 ) resistor r=58.1818 //w=0.187 //l=0.85 //layer=li \
 //thickness=0.1 //x=89.18 //y=5.39 //x2=89.18 //y2=6.24
r178 (  30 71 ) resistor r=23.2727 //w=0.187 //l=0.34 //layer=li \
 //thickness=0.1 //x=88.3 //y=5.56 //x2=88.3 //y2=5.9
r179 (  27 75 ) resistor r=9.3 //w=0.17 //l=0.17 //layer=mcon //count=1 \
 //x=92.94 //y=6.92 //x2=92.94 //y2=6.92
r180 (  27 28 ) resistor r=0.0988372 //w=0.215 //l=0.17 //layer=m1 \
 //thickness=0.36 //x=92.942 //y=6.92 //x2=92.942 //y2=7.09
r181 (  24 74 ) resistor r=9.3 //w=0.17 //l=0.17 //layer=mcon //count=1 \
 //x=92.06 //y=6.92 //x2=92.06 //y2=6.92
r182 (  24 25 ) resistor r=0.0940266 //w=0.226 //l=0.17 //layer=m1 \
 //thickness=0.36 //x=92.057 //y=6.92 //x2=92.057 //y2=7.09
r183 (  22 49 ) resistor r=9.3 //w=0.17 //l=0.17 //layer=mcon //count=1 \
 //x=91.18 //y=5.39 //x2=91.18 //y2=5.39
r184 (  19 73 ) resistor r=9.3 //w=0.17 //l=0.17 //layer=mcon //count=1 \
 //x=91.18 //y=6.92 //x2=91.18 //y2=6.92
r185 (  19 20 ) resistor r=0.0979263 //w=0.217 //l=0.17 //layer=m1 \
 //thickness=0.36 //x=91.182 //y=6.92 //x2=91.182 //y2=7.09
r186 (  15 40 ) resistor r=9.3 //w=0.17 //l=0.17 //layer=mcon //count=1 \
 //x=89.18 //y=5.39 //x2=89.18 //y2=5.39
r187 (  11 30 ) resistor r=9.3 //w=0.17 //l=0.17 //layer=mcon //count=1 \
 //x=88.3 //y=5.56 //x2=88.3 //y2=5.56
r188 (  9 11 ) resistor r=0.0944444 //w=0.225 //l=0.17 //layer=m1 \
 //thickness=0.36 //x=88.302 //y=5.39 //x2=88.302 //y2=5.56
r189 (  8 25 ) resistor r=0.0246599 //w=0.226 //l=0.118 //layer=m1 \
 //thickness=0.36 //x=92.175 //y=7.09 //x2=92.057 //y2=7.09
r190 (  7 28 ) resistor r=0.0216707 //w=0.215 //l=0.117 //layer=m1 \
 //thickness=0.36 //x=92.825 //y=7.09 //x2=92.942 //y2=7.09
r191 (  7 8 ) resistor r=0.620229 //w=0.131 //l=0.65 //layer=m1 \
 //thickness=0.36 //x=92.825 //y=7.09 //x2=92.175 //y2=7.09
r192 (  6 20 ) resistor r=0.0222262 //w=0.217 //l=0.118 //layer=m1 \
 //thickness=0.36 //x=91.3 //y=7.09 //x2=91.182 //y2=7.09
r193 (  5 25 ) resistor r=0.0246599 //w=0.226 //l=0.117 //layer=m1 \
 //thickness=0.36 //x=91.94 //y=7.09 //x2=92.057 //y2=7.09
r194 (  5 6 ) resistor r=0.610687 //w=0.131 //l=0.64 //layer=m1 \
 //thickness=0.36 //x=91.94 //y=7.09 //x2=91.3 //y2=7.09
r195 (  4 15 ) resistor r=0.0880901 //w=0.191 //l=0.115 //layer=m1 \
 //thickness=0.36 //x=89.295 //y=5.39 //x2=89.18 //y2=5.39
r196 (  3 22 ) resistor r=0.0717383 //w=0.224 //l=0.115 //layer=m1 \
 //thickness=0.36 //x=91.065 //y=5.39 //x2=91.18 //y2=5.39
r197 (  3 4 ) resistor r=1.68893 //w=0.131 //l=1.77 //layer=m1 \
 //thickness=0.36 //x=91.065 //y=5.39 //x2=89.295 //y2=5.39
r198 (  2 9 ) resistor r=0.0243946 //w=0.225 //l=0.123 //layer=m1 \
 //thickness=0.36 //x=88.425 //y=5.39 //x2=88.302 //y2=5.39
r199 (  1 15 ) resistor r=0.0880901 //w=0.191 //l=0.115 //layer=m1 \
 //thickness=0.36 //x=89.065 //y=5.39 //x2=89.18 //y2=5.39
r200 (  1 2 ) resistor r=0.610687 //w=0.131 //l=0.64 //layer=m1 \
 //thickness=0.36 //x=89.065 //y=5.39 //x2=88.425 //y2=5.39
ends PM_TMRDFFSNRNQX1\%noxref_44

subckt PM_TMRDFFSNRNQX1\%noxref_45 ( 1 3 4 5 7 9 15 21 23 26 34 40 62 63 64 65 \
 66 )
c132 ( 66 0 ) capacitor c=0.0343252f //x=96.135 //y=5.205
c133 ( 65 0 ) capacitor c=0.0239063f //x=95.255 //y=5.205
c134 ( 40 0 ) capacitor c=0.0496553f //x=94.52 //y=5.39
c135 ( 34 0 ) capacitor c=0.0324071f //x=92.5 //y=5.39
c136 ( 26 0 ) capacitor c=0.0224248f //x=91.62 //y=5.56
c137 ( 23 0 ) capacitor c=0.0155899f //x=96.28 //y=6.92
c138 ( 21 0 ) capacitor c=0.00566376f //x=95.4 //y=7.09
c139 ( 15 0 ) capacitor c=0.00945187f //x=94.52 //y=6.92
c140 ( 9 0 ) capacitor c=0.015341f //x=91.62 //y=5.39
c141 ( 7 0 ) capacitor c=0.0068287f //x=96.15 //y=7.09
c142 ( 5 0 ) capacitor c=0.00878908f //x=95.285 //y=7.09
c143 ( 4 0 ) capacitor c=0.00713333f //x=92.615 //y=5.39
c144 ( 3 0 ) capacitor c=0.0571674f //x=94.405 //y=5.39
c145 ( 1 0 ) capacitor c=0.0183133f //x=92.385 //y=5.39
r146 (  40 64 ) resistor r=58.1818 //w=0.187 //l=0.85 //layer=li \
 //thickness=0.1 //x=94.52 //y=5.39 //x2=94.52 //y2=6.24
r147 (  34 63 ) resistor r=58.1818 //w=0.187 //l=0.85 //layer=li \
 //thickness=0.1 //x=92.5 //y=5.39 //x2=92.5 //y2=6.24
r148 (  26 62 ) resistor r=23.2727 //w=0.187 //l=0.34 //layer=li \
 //thickness=0.1 //x=91.62 //y=5.56 //x2=91.62 //y2=5.9
r149 (  23 66 ) resistor r=9.3 //w=0.17 //l=0.17 //layer=mcon //count=1 \
 //x=96.28 //y=6.92 //x2=96.28 //y2=6.92
r150 (  23 24 ) resistor r=0.0923913 //w=0.23 //l=0.17 //layer=m1 \
 //thickness=0.36 //x=96.275 //y=6.92 //x2=96.275 //y2=7.09
r151 (  20 65 ) resistor r=9.3 //w=0.17 //l=0.17 //layer=mcon //count=1 \
 //x=95.4 //y=6.92 //x2=95.4 //y2=6.92
r152 (  20 21 ) resistor r=0.0957207 //w=0.222 //l=0.17 //layer=m1 \
 //thickness=0.36 //x=95.4 //y=6.92 //x2=95.4 //y2=7.09
r153 (  18 40 ) resistor r=9.3 //w=0.17 //l=0.17 //layer=mcon //count=1 \
 //x=94.52 //y=5.39 //x2=94.52 //y2=5.39
r154 (  15 64 ) resistor r=9.3 //w=0.17 //l=0.17 //layer=mcon //count=1 \
 //x=94.52 //y=6.92 //x2=94.52 //y2=6.92
r155 (  15 16 ) resistor r=0.100236 //w=0.212 //l=0.17 //layer=m1 \
 //thickness=0.36 //x=94.52 //y=6.92 //x2=94.52 //y2=7.09
r156 (  13 34 ) resistor r=9.3 //w=0.17 //l=0.17 //layer=mcon //count=1 \
 //x=92.5 //y=5.39 //x2=92.5 //y2=5.39
r157 (  11 26 ) resistor r=9.3 //w=0.17 //l=0.17 //layer=mcon //count=1 \
 //x=91.62 //y=5.56 //x2=91.62 //y2=5.56
r158 (  9 11 ) resistor r=0.100236 //w=0.212 //l=0.17 //layer=m1 \
 //thickness=0.36 //x=91.62 //y=5.39 //x2=91.62 //y2=5.56
r159 (  8 21 ) resistor r=0.0235912 //w=0.222 //l=0.115 //layer=m1 \
 //thickness=0.36 //x=95.515 //y=7.09 //x2=95.4 //y2=7.09
r160 (  7 24 ) resistor r=0.0257089 //w=0.23 //l=0.125 //layer=m1 \
 //thickness=0.36 //x=96.15 //y=7.09 //x2=96.275 //y2=7.09
r161 (  7 8 ) resistor r=0.605916 //w=0.131 //l=0.635 //layer=m1 \
 //thickness=0.36 //x=96.15 //y=7.09 //x2=95.515 //y2=7.09
r162 (  6 16 ) resistor r=0.0208269 //w=0.212 //l=0.115 //layer=m1 \
 //thickness=0.36 //x=94.635 //y=7.09 //x2=94.52 //y2=7.09
r163 (  5 21 ) resistor r=0.0235912 //w=0.222 //l=0.115 //layer=m1 \
 //thickness=0.36 //x=95.285 //y=7.09 //x2=95.4 //y2=7.09
r164 (  5 6 ) resistor r=0.620229 //w=0.131 //l=0.65 //layer=m1 \
 //thickness=0.36 //x=95.285 //y=7.09 //x2=94.635 //y2=7.09
r165 (  4 13 ) resistor r=0.0880901 //w=0.191 //l=0.115 //layer=m1 \
 //thickness=0.36 //x=92.615 //y=5.39 //x2=92.5 //y2=5.39
r166 (  3 18 ) resistor r=0.0717383 //w=0.224 //l=0.115 //layer=m1 \
 //thickness=0.36 //x=94.405 //y=5.39 //x2=94.52 //y2=5.39
r167 (  3 4 ) resistor r=1.70802 //w=0.131 //l=1.79 //layer=m1 \
 //thickness=0.36 //x=94.405 //y=5.39 //x2=92.615 //y2=5.39
r168 (  2 9 ) resistor r=0.0208269 //w=0.212 //l=0.115 //layer=m1 \
 //thickness=0.36 //x=91.735 //y=5.39 //x2=91.62 //y2=5.39
r169 (  1 13 ) resistor r=0.0880901 //w=0.191 //l=0.115 //layer=m1 \
 //thickness=0.36 //x=92.385 //y=5.39 //x2=92.5 //y2=5.39
r170 (  1 2 ) resistor r=0.620229 //w=0.131 //l=0.65 //layer=m1 \
 //thickness=0.36 //x=92.385 //y=5.39 //x2=91.735 //y2=5.39
ends PM_TMRDFFSNRNQX1\%noxref_45

subckt PM_TMRDFFSNRNQX1\%GND ( 1 2 6 7 18 19 30 31 42 43 54 55 66 67 78 79 90 \
 91 102 103 114 115 126 127 139 140 151 152 163 164 175 176 187 188 199 200 \
 211 212 223 224 231 232 239 248 251 255 259 263 267 271 275 279 283 287 291 \
 295 299 303 307 311 315 319 334 337 351 368 385 402 419 436 453 470 487 504 \
 521 538 555 572 589 606 623 640 655 668 686 691 695 707 708 709 710 711 712 \
 713 714 715 716 717 718 719 720 721 722 723 724 725 726 727 734 741 742 743 \
 744 745 746 747 748 749 750 751 752 753 754 755 756 757 758 759 760 761 762 )
c1745 ( 762 0 ) capacitor c=0.0636259f //x=97.555 //y=0.55
c1746 ( 761 0 ) capacitor c=0.00828027f //x=94.72 //y=1.045
c1747 ( 760 0 ) capacitor c=0.00867576f //x=91.39 //y=1.045
c1748 ( 759 0 ) capacitor c=0.0083251f //x=88.06 //y=1.045
c1749 ( 758 0 ) capacitor c=0.00840423f //x=83.145 //y=1.055
c1750 ( 757 0 ) capacitor c=0.00840423f //x=78.335 //y=1.055
c1751 ( 756 0 ) capacitor c=0.00840423f //x=73.525 //y=1.055
c1752 ( 755 0 ) capacitor c=0.00840423f //x=68.715 //y=1.055
c1753 ( 754 0 ) capacitor c=0.00840423f //x=63.905 //y=1.055
c1754 ( 753 0 ) capacitor c=0.00840423f //x=59.095 //y=1.055
c1755 ( 752 0 ) capacitor c=0.00840423f //x=54.285 //y=1.055
c1756 ( 751 0 ) capacitor c=0.00840423f //x=49.475 //y=1.055
c1757 ( 750 0 ) capacitor c=0.00840423f //x=44.665 //y=1.055
c1758 ( 749 0 ) capacitor c=0.00840423f //x=39.855 //y=1.055
c1759 ( 748 0 ) capacitor c=0.00840423f //x=35.045 //y=1.055
c1760 ( 747 0 ) capacitor c=0.00840423f //x=30.235 //y=1.055
c1761 ( 746 0 ) capacitor c=0.00840423f //x=25.425 //y=1.055
c1762 ( 745 0 ) capacitor c=0.00840423f //x=20.615 //y=1.055
c1763 ( 744 0 ) capacitor c=0.00840423f //x=15.805 //y=1.055
c1764 ( 743 0 ) capacitor c=0.00840423f //x=10.995 //y=1.055
c1765 ( 742 0 ) capacitor c=0.00840423f //x=6.185 //y=1.055
c1766 ( 741 0 ) capacitor c=0.00840423f //x=1.375 //y=1.055
c1767 ( 734 0 ) capacitor c=0.260862f //x=98.66 //y=0.175
c1768 ( 727 0 ) capacitor c=0.113464f //x=97.06 //y=0.175
c1769 ( 726 0 ) capacitor c=0.11024f //x=93.73 //y=0.175
c1770 ( 725 0 ) capacitor c=0.1237f //x=90.4 //y=0.175
c1771 ( 724 0 ) capacitor c=0.11441f //x=87.07 //y=0.175
c1772 ( 723 0 ) capacitor c=0.109567f //x=82.26 //y=0.175
c1773 ( 722 0 ) capacitor c=0.114177f //x=77.45 //y=0.175
c1774 ( 721 0 ) capacitor c=0.109628f //x=72.64 //y=0.175
c1775 ( 720 0 ) capacitor c=0.112438f //x=67.83 //y=0.175
c1776 ( 719 0 ) capacitor c=0.109586f //x=63.02 //y=0.175
c1777 ( 718 0 ) capacitor c=0.114177f //x=58.21 //y=0.175
c1778 ( 717 0 ) capacitor c=0.109534f //x=53.4 //y=0.175
c1779 ( 716 0 ) capacitor c=0.114177f //x=48.59 //y=0.175
c1780 ( 715 0 ) capacitor c=0.109628f //x=43.78 //y=0.175
c1781 ( 714 0 ) capacitor c=0.112438f //x=38.97 //y=0.175
c1782 ( 713 0 ) capacitor c=0.109586f //x=34.16 //y=0.175
c1783 ( 712 0 ) capacitor c=0.114177f //x=29.35 //y=0.175
c1784 ( 711 0 ) capacitor c=0.109575f //x=24.54 //y=0.175
c1785 ( 710 0 ) capacitor c=0.114177f //x=19.73 //y=0.175
c1786 ( 709 0 ) capacitor c=0.109628f //x=14.92 //y=0.175
c1787 ( 708 0 ) capacitor c=0.112592f //x=10.11 //y=0.175
c1788 ( 707 0 ) capacitor c=0.10974f //x=5.3 //y=0.175
c1789 ( 698 0 ) capacitor c=0.00585268f //x=98.66 //y=0.63
c1790 ( 695 0 ) capacitor c=0.0061991f //x=98.575 //y=0.715
c1791 ( 694 0 ) capacitor c=0.00479851f //x=98.17 //y=0.63
c1792 ( 691 0 ) capacitor c=0.00645299f //x=98.085 //y=0.715
c1793 ( 686 0 ) capacitor c=0.00586769f //x=97.69 //y=0.63
c1794 ( 683 0 ) capacitor c=0.0191899f //x=97.605 //y=0.175
c1795 ( 668 0 ) capacitor c=0.122563f //x=96.89 //y=0.175
c1796 ( 655 0 ) capacitor c=0.118812f //x=93.56 //y=0.175
c1797 ( 640 0 ) capacitor c=0.119089f //x=90.23 //y=0.175
c1798 ( 623 0 ) capacitor c=0.176388f //x=86.9 //y=0.175
c1799 ( 606 0 ) capacitor c=0.174554f //x=82.09 //y=0.175
c1800 ( 589 0 ) capacitor c=0.176385f //x=77.28 //y=0.175
c1801 ( 572 0 ) capacitor c=0.176388f //x=72.47 //y=0.175
c1802 ( 555 0 ) capacitor c=0.176388f //x=67.66 //y=0.175
c1803 ( 538 0 ) capacitor c=0.17641f //x=62.85 //y=0.175
c1804 ( 521 0 ) capacitor c=0.176556f //x=58.04 //y=0.175
c1805 ( 504 0 ) capacitor c=0.176414f //x=53.23 //y=0.175
c1806 ( 487 0 ) capacitor c=0.176385f //x=48.42 //y=0.175
c1807 ( 470 0 ) capacitor c=0.176388f //x=43.61 //y=0.175
c1808 ( 453 0 ) capacitor c=0.176388f //x=38.8 //y=0.175
c1809 ( 436 0 ) capacitor c=0.17641f //x=33.99 //y=0.175
c1810 ( 419 0 ) capacitor c=0.176363f //x=29.18 //y=0.175
c1811 ( 402 0 ) capacitor c=0.176414f //x=24.37 //y=0.175
c1812 ( 385 0 ) capacitor c=0.176385f //x=19.56 //y=0.175
c1813 ( 368 0 ) capacitor c=0.176388f //x=14.75 //y=0.175
c1814 ( 351 0 ) capacitor c=0.176388f //x=9.94 //y=0.175
c1815 ( 337 0 ) capacitor c=0.197064f //x=1.23 //y=0.18
c1816 ( 334 0 ) capacitor c=0.17924f //x=5.13 //y=0.175
c1817 ( 329 0 ) capacitor c=0.00509083f //x=94.91 //y=0.175
c1818 ( 326 0 ) capacitor c=0.00510068f //x=91.51 //y=0.18
c1819 ( 322 0 ) capacitor c=0.00509083f //x=88.25 //y=0.175
c1820 ( 321 0 ) capacitor c=0.00509414f //x=83.335 //y=0.175
c1821 ( 319 0 ) capacitor c=0.0139528f //x=83.335 //y=1.145
c1822 ( 317 0 ) capacitor c=0.00509414f //x=78.525 //y=0.175
c1823 ( 315 0 ) capacitor c=0.0140686f //x=78.525 //y=1.145
c1824 ( 313 0 ) capacitor c=0.00509414f //x=73.715 //y=0.175
c1825 ( 311 0 ) capacitor c=0.0140128f //x=73.715 //y=1.145
c1826 ( 309 0 ) capacitor c=0.00509414f //x=68.905 //y=0.175
c1827 ( 307 0 ) capacitor c=0.0140132f //x=68.905 //y=1.145
c1828 ( 305 0 ) capacitor c=0.00509414f //x=64.095 //y=0.175
c1829 ( 303 0 ) capacitor c=0.0140783f //x=64.095 //y=1.145
c1830 ( 301 0 ) capacitor c=0.00509414f //x=59.285 //y=0.175
c1831 ( 299 0 ) capacitor c=0.0140577f //x=59.285 //y=1.145
c1832 ( 297 0 ) capacitor c=0.00509414f //x=54.475 //y=0.175
c1833 ( 295 0 ) capacitor c=0.0140088f //x=54.475 //y=1.145
c1834 ( 293 0 ) capacitor c=0.00509414f //x=49.665 //y=0.175
c1835 ( 291 0 ) capacitor c=0.0140644f //x=49.665 //y=1.145
c1836 ( 289 0 ) capacitor c=0.00509414f //x=44.855 //y=0.175
c1837 ( 287 0 ) capacitor c=0.0140128f //x=44.855 //y=1.145
c1838 ( 285 0 ) capacitor c=0.00509414f //x=40.045 //y=0.175
c1839 ( 283 0 ) capacitor c=0.0140132f //x=40.045 //y=1.145
c1840 ( 281 0 ) capacitor c=0.00509414f //x=35.235 //y=0.175
c1841 ( 279 0 ) capacitor c=0.0140783f //x=35.235 //y=1.145
c1842 ( 277 0 ) capacitor c=0.00509414f //x=30.425 //y=0.175
c1843 ( 275 0 ) capacitor c=0.0141231f //x=30.425 //y=1.145
c1844 ( 273 0 ) capacitor c=0.00509414f //x=25.615 //y=0.175
c1845 ( 271 0 ) capacitor c=0.0140136f //x=25.615 //y=1.145
c1846 ( 269 0 ) capacitor c=0.00509414f //x=20.805 //y=0.175
c1847 ( 267 0 ) capacitor c=0.0140686f //x=20.805 //y=1.145
c1848 ( 265 0 ) capacitor c=0.00509414f //x=15.995 //y=0.175
c1849 ( 263 0 ) capacitor c=0.0140168f //x=15.995 //y=1.145
c1850 ( 261 0 ) capacitor c=0.00509414f //x=11.185 //y=0.175
c1851 ( 259 0 ) capacitor c=0.0139572f //x=11.185 //y=1.145
c1852 ( 257 0 ) capacitor c=0.00509414f //x=6.375 //y=0.175
c1853 ( 255 0 ) capacitor c=0.0140851f //x=6.375 //y=1.145
c1854 ( 253 0 ) capacitor c=0.00509414f //x=1.565 //y=0.175
c1855 ( 251 0 ) capacitor c=0.017f //x=1.565 //y=1.145
c1856 ( 248 0 ) capacitor c=0.178677f //x=98.54 //y=0.18
c1857 ( 239 0 ) capacitor c=0.035089f //x=94.91 //y=1.02
c1858 ( 232 0 ) capacitor c=0.107294f //x=94.825 //y=0.175
c1859 ( 231 0 ) capacitor c=0.0283986f //x=91.58 //y=1.015
c1860 ( 224 0 ) capacitor c=0.112366f //x=91.495 //y=0.175
c1861 ( 223 0 ) capacitor c=0.0347805f //x=88.25 //y=1.015
c1862 ( 212 0 ) capacitor c=0.154656f //x=88.165 //y=0.175
c1863 ( 211 0 ) capacitor c=0.0302305f //x=83.335 //y=1.015
c1864 ( 200 0 ) capacitor c=0.148696f //x=83.25 //y=0.175
c1865 ( 199 0 ) capacitor c=0.0302305f //x=78.525 //y=1.015
c1866 ( 188 0 ) capacitor c=0.14916f //x=78.44 //y=0.175
c1867 ( 187 0 ) capacitor c=0.0302305f //x=73.715 //y=1.015
c1868 ( 176 0 ) capacitor c=0.148704f //x=73.63 //y=0.175
c1869 ( 175 0 ) capacitor c=0.0302305f //x=68.905 //y=1.015
c1870 ( 164 0 ) capacitor c=0.149124f //x=68.82 //y=0.175
c1871 ( 163 0 ) capacitor c=0.0302305f //x=64.095 //y=1.015
c1872 ( 152 0 ) capacitor c=0.148598f //x=64.01 //y=0.175
c1873 ( 151 0 ) capacitor c=0.0302305f //x=59.285 //y=1.015
c1874 ( 140 0 ) capacitor c=0.150478f //x=59.2 //y=0.175
c1875 ( 139 0 ) capacitor c=0.0302305f //x=54.475 //y=1.015
c1876 ( 127 0 ) capacitor c=0.148588f //x=54.39 //y=0.175
c1877 ( 126 0 ) capacitor c=0.0302305f //x=49.665 //y=1.015
c1878 ( 115 0 ) capacitor c=0.14916f //x=49.58 //y=0.175
c1879 ( 114 0 ) capacitor c=0.0302305f //x=44.855 //y=1.015
c1880 ( 103 0 ) capacitor c=0.148704f //x=44.77 //y=0.175
c1881 ( 102 0 ) capacitor c=0.0302305f //x=40.045 //y=1.015
c1882 ( 91 0 ) capacitor c=0.149124f //x=39.96 //y=0.175
c1883 ( 90 0 ) capacitor c=0.0302305f //x=35.235 //y=1.015
c1884 ( 79 0 ) capacitor c=0.148636f //x=35.15 //y=0.175
c1885 ( 78 0 ) capacitor c=0.0302305f //x=30.425 //y=1.015
c1886 ( 67 0 ) capacitor c=0.150281f //x=30.34 //y=0.175
c1887 ( 66 0 ) capacitor c=0.0302305f //x=25.615 //y=1.015
c1888 ( 55 0 ) capacitor c=0.148607f //x=25.53 //y=0.175
c1889 ( 54 0 ) capacitor c=0.0302305f //x=20.805 //y=1.015
c1890 ( 43 0 ) capacitor c=0.14916f //x=20.72 //y=0.175
c1891 ( 42 0 ) capacitor c=0.0302305f //x=15.995 //y=1.015
c1892 ( 31 0 ) capacitor c=0.148704f //x=15.91 //y=0.175
c1893 ( 30 0 ) capacitor c=0.0302305f //x=11.185 //y=1.015
c1894 ( 19 0 ) capacitor c=0.149124f //x=11.1 //y=0.175
c1895 ( 18 0 ) capacitor c=0.0302305f //x=6.375 //y=1.015
c1896 ( 7 0 ) capacitor c=0.148598f //x=6.29 //y=0.175
c1897 ( 6 0 ) capacitor c=0.0302305f //x=1.565 //y=1.015
c1898 ( 2 0 ) capacitor c=0.0710427f //x=1.48 //y=0.175
r1899 (  733 734 ) resistor r=4.18529 //w=0.367 //l=0.12 //layer=li \
 //thickness=0.1 //x=98.54 //y=0.175 //x2=98.66 //y2=0.175
r1900 (  731 733 ) resistor r=12.9046 //w=0.367 //l=0.37 //layer=li \
 //thickness=0.1 //x=98.17 //y=0.175 //x2=98.54 //y2=0.175
r1901 (  730 731 ) resistor r=12.9046 //w=0.367 //l=0.37 //layer=li \
 //thickness=0.1 //x=97.8 //y=0.175 //x2=98.17 //y2=0.175
r1902 (  728 730 ) resistor r=3.83651 //w=0.367 //l=0.11 //layer=li \
 //thickness=0.1 //x=97.69 //y=0.175 //x2=97.8 //y2=0.175
r1903 (  699 762 ) resistor r=5.4201 //w=0.17 //l=0.085 //layer=li \
 //thickness=0.1 //x=98.66 //y=0.8 //x2=98.66 //y2=0.715
r1904 (  699 762 ) resistor r=41.4118 //w=0.187 //l=0.605 //layer=li \
 //thickness=0.1 //x=98.66 //y=0.8 //x2=98.66 //y2=1.405
r1905 (  698 762 ) resistor r=5.4201 //w=0.17 //l=0.085 //layer=li \
 //thickness=0.1 //x=98.66 //y=0.63 //x2=98.66 //y2=0.715
r1906 (  697 734 ) resistor r=5.21862 //w=0.35 //l=0.175 //layer=li \
 //thickness=0.1 //x=98.66 //y=0.35 //x2=98.66 //y2=0.175
r1907 (  697 698 ) resistor r=19.1658 //w=0.187 //l=0.28 //layer=li \
 //thickness=0.1 //x=98.66 //y=0.35 //x2=98.66 //y2=0.63
r1908 (  696 762 ) resistor r=5.4201 //w=0.17 //l=0.085 //layer=li \
 //thickness=0.1 //x=98.255 //y=0.715 //x2=98.17 //y2=0.715
r1909 (  695 762 ) resistor r=1.40859 //w=0.34 //l=0.085 //layer=li \
 //thickness=0.1 //x=98.575 //y=0.715 //x2=98.66 //y2=0.715
r1910 (  695 696 ) resistor r=21.9037 //w=0.187 //l=0.32 //layer=li \
 //thickness=0.1 //x=98.575 //y=0.715 //x2=98.255 //y2=0.715
r1911 (  694 762 ) resistor r=1.40859 //w=0.34 //l=0.085 //layer=li \
 //thickness=0.1 //x=98.17 //y=0.63 //x2=98.17 //y2=0.715
r1912 (  693 731 ) resistor r=5.21862 //w=0.35 //l=0.175 //layer=li \
 //thickness=0.1 //x=98.17 //y=0.35 //x2=98.17 //y2=0.175
r1913 (  693 694 ) resistor r=19.1658 //w=0.187 //l=0.28 //layer=li \
 //thickness=0.1 //x=98.17 //y=0.35 //x2=98.17 //y2=0.63
r1914 (  692 762 ) resistor r=1.40859 //w=0.34 //l=0.085 //layer=li \
 //thickness=0.1 //x=97.775 //y=0.715 //x2=97.69 //y2=0.715
r1915 (  691 762 ) resistor r=5.4201 //w=0.17 //l=0.085 //layer=li \
 //thickness=0.1 //x=98.085 //y=0.715 //x2=98.17 //y2=0.715
r1916 (  691 692 ) resistor r=21.2193 //w=0.187 //l=0.31 //layer=li \
 //thickness=0.1 //x=98.085 //y=0.715 //x2=97.775 //y2=0.715
r1917 (  687 762 ) resistor r=5.4201 //w=0.17 //l=0.085 //layer=li \
 //thickness=0.1 //x=97.69 //y=0.8 //x2=97.69 //y2=0.715
r1918 (  687 762 ) resistor r=41.4118 //w=0.187 //l=0.605 //layer=li \
 //thickness=0.1 //x=97.69 //y=0.8 //x2=97.69 //y2=1.405
r1919 (  686 762 ) resistor r=5.4201 //w=0.17 //l=0.085 //layer=li \
 //thickness=0.1 //x=97.69 //y=0.63 //x2=97.69 //y2=0.715
r1920 (  685 728 ) resistor r=5.21862 //w=0.35 //l=0.175 //layer=li \
 //thickness=0.1 //x=97.69 //y=0.35 //x2=97.69 //y2=0.175
r1921 (  685 686 ) resistor r=19.1658 //w=0.187 //l=0.28 //layer=li \
 //thickness=0.1 //x=97.69 //y=0.35 //x2=97.69 //y2=0.63
r1922 (  684 727 ) resistor r=5.29055 //w=0.35 //l=0.17 //layer=li \
 //thickness=0.1 //x=97.23 //y=0.175 //x2=97.06 //y2=0.175
r1923 (  683 728 ) resistor r=2.96458 //w=0.367 //l=0.085 //layer=li \
 //thickness=0.1 //x=97.605 //y=0.175 //x2=97.69 //y2=0.175
r1924 (  683 684 ) resistor r=13.079 //w=0.367 //l=0.375 //layer=li \
 //thickness=0.1 //x=97.605 //y=0.175 //x2=97.23 //y2=0.175
r1925 (  673 675 ) resistor r=38.7139 //w=0.367 //l=1.11 //layer=li \
 //thickness=0.1 //x=95.21 //y=0.175 //x2=96.32 //y2=0.175
r1926 (  671 673 ) resistor r=38.7139 //w=0.367 //l=1.11 //layer=li \
 //thickness=0.1 //x=94.1 //y=0.175 //x2=95.21 //y2=0.175
r1927 (  669 726 ) resistor r=5.29055 //w=0.35 //l=0.17 //layer=li \
 //thickness=0.1 //x=93.9 //y=0.175 //x2=93.73 //y2=0.175
r1928 (  669 671 ) resistor r=6.97548 //w=0.367 //l=0.2 //layer=li \
 //thickness=0.1 //x=93.9 //y=0.175 //x2=94.1 //y2=0.175
r1929 (  668 727 ) resistor r=5.29055 //w=0.35 //l=0.17 //layer=li \
 //thickness=0.1 //x=96.89 //y=0.175 //x2=97.06 //y2=0.175
r1930 (  668 675 ) resistor r=19.8801 //w=0.367 //l=0.57 //layer=li \
 //thickness=0.1 //x=96.89 //y=0.175 //x2=96.32 //y2=0.175
r1931 (  658 660 ) resistor r=38.7139 //w=0.367 //l=1.11 //layer=li \
 //thickness=0.1 //x=91.51 //y=0.175 //x2=92.62 //y2=0.175
r1932 (  656 725 ) resistor r=5.29055 //w=0.35 //l=0.17 //layer=li \
 //thickness=0.1 //x=90.57 //y=0.175 //x2=90.4 //y2=0.175
r1933 (  656 658 ) resistor r=32.7847 //w=0.367 //l=0.94 //layer=li \
 //thickness=0.1 //x=90.57 //y=0.175 //x2=91.51 //y2=0.175
r1934 (  655 726 ) resistor r=5.29055 //w=0.35 //l=0.17 //layer=li \
 //thickness=0.1 //x=93.56 //y=0.175 //x2=93.73 //y2=0.175
r1935 (  655 660 ) resistor r=32.7847 //w=0.367 //l=0.94 //layer=li \
 //thickness=0.1 //x=93.56 //y=0.175 //x2=92.62 //y2=0.175
r1936 (  645 647 ) resistor r=38.7139 //w=0.367 //l=1.11 //layer=li \
 //thickness=0.1 //x=88.92 //y=0.175 //x2=90.03 //y2=0.175
r1937 (  643 645 ) resistor r=38.7139 //w=0.367 //l=1.11 //layer=li \
 //thickness=0.1 //x=87.81 //y=0.175 //x2=88.92 //y2=0.175
r1938 (  641 724 ) resistor r=5.29055 //w=0.35 //l=0.17 //layer=li \
 //thickness=0.1 //x=87.24 //y=0.175 //x2=87.07 //y2=0.175
r1939 (  641 643 ) resistor r=19.8801 //w=0.367 //l=0.57 //layer=li \
 //thickness=0.1 //x=87.24 //y=0.175 //x2=87.81 //y2=0.175
r1940 (  640 725 ) resistor r=5.29055 //w=0.35 //l=0.17 //layer=li \
 //thickness=0.1 //x=90.23 //y=0.175 //x2=90.4 //y2=0.175
r1941 (  640 647 ) resistor r=6.97548 //w=0.367 //l=0.2 //layer=li \
 //thickness=0.1 //x=90.23 //y=0.175 //x2=90.03 //y2=0.175
r1942 (  630 632 ) resistor r=38.7139 //w=0.367 //l=1.11 //layer=li \
 //thickness=0.1 //x=85.22 //y=0.175 //x2=86.33 //y2=0.175
r1943 (  628 630 ) resistor r=38.7139 //w=0.367 //l=1.11 //layer=li \
 //thickness=0.1 //x=84.11 //y=0.175 //x2=85.22 //y2=0.175
r1944 (  626 628 ) resistor r=38.7139 //w=0.367 //l=1.11 //layer=li \
 //thickness=0.1 //x=83 //y=0.175 //x2=84.11 //y2=0.175
r1945 (  624 723 ) resistor r=5.29055 //w=0.35 //l=0.17 //layer=li \
 //thickness=0.1 //x=82.43 //y=0.175 //x2=82.26 //y2=0.175
r1946 (  624 626 ) resistor r=19.8801 //w=0.367 //l=0.57 //layer=li \
 //thickness=0.1 //x=82.43 //y=0.175 //x2=83 //y2=0.175
r1947 (  623 724 ) resistor r=5.29055 //w=0.35 //l=0.17 //layer=li \
 //thickness=0.1 //x=86.9 //y=0.175 //x2=87.07 //y2=0.175
r1948 (  623 632 ) resistor r=19.8801 //w=0.367 //l=0.57 //layer=li \
 //thickness=0.1 //x=86.9 //y=0.175 //x2=86.33 //y2=0.175
r1949 (  613 615 ) resistor r=38.7139 //w=0.367 //l=1.11 //layer=li \
 //thickness=0.1 //x=80.41 //y=0.175 //x2=81.52 //y2=0.175
r1950 (  611 613 ) resistor r=38.7139 //w=0.367 //l=1.11 //layer=li \
 //thickness=0.1 //x=79.3 //y=0.175 //x2=80.41 //y2=0.175
r1951 (  609 611 ) resistor r=38.7139 //w=0.367 //l=1.11 //layer=li \
 //thickness=0.1 //x=78.19 //y=0.175 //x2=79.3 //y2=0.175
r1952 (  607 722 ) resistor r=5.29055 //w=0.35 //l=0.17 //layer=li \
 //thickness=0.1 //x=77.62 //y=0.175 //x2=77.45 //y2=0.175
r1953 (  607 609 ) resistor r=19.8801 //w=0.367 //l=0.57 //layer=li \
 //thickness=0.1 //x=77.62 //y=0.175 //x2=78.19 //y2=0.175
r1954 (  606 723 ) resistor r=5.29055 //w=0.35 //l=0.17 //layer=li \
 //thickness=0.1 //x=82.09 //y=0.175 //x2=82.26 //y2=0.175
r1955 (  606 615 ) resistor r=19.8801 //w=0.367 //l=0.57 //layer=li \
 //thickness=0.1 //x=82.09 //y=0.175 //x2=81.52 //y2=0.175
r1956 (  596 598 ) resistor r=38.7139 //w=0.367 //l=1.11 //layer=li \
 //thickness=0.1 //x=75.6 //y=0.175 //x2=76.71 //y2=0.175
r1957 (  594 596 ) resistor r=38.7139 //w=0.367 //l=1.11 //layer=li \
 //thickness=0.1 //x=74.49 //y=0.175 //x2=75.6 //y2=0.175
r1958 (  592 594 ) resistor r=38.7139 //w=0.367 //l=1.11 //layer=li \
 //thickness=0.1 //x=73.38 //y=0.175 //x2=74.49 //y2=0.175
r1959 (  590 721 ) resistor r=5.29055 //w=0.35 //l=0.17 //layer=li \
 //thickness=0.1 //x=72.81 //y=0.175 //x2=72.64 //y2=0.175
r1960 (  590 592 ) resistor r=19.8801 //w=0.367 //l=0.57 //layer=li \
 //thickness=0.1 //x=72.81 //y=0.175 //x2=73.38 //y2=0.175
r1961 (  589 722 ) resistor r=5.29055 //w=0.35 //l=0.17 //layer=li \
 //thickness=0.1 //x=77.28 //y=0.175 //x2=77.45 //y2=0.175
r1962 (  589 598 ) resistor r=19.8801 //w=0.367 //l=0.57 //layer=li \
 //thickness=0.1 //x=77.28 //y=0.175 //x2=76.71 //y2=0.175
r1963 (  579 581 ) resistor r=38.7139 //w=0.367 //l=1.11 //layer=li \
 //thickness=0.1 //x=70.79 //y=0.175 //x2=71.9 //y2=0.175
r1964 (  577 579 ) resistor r=38.7139 //w=0.367 //l=1.11 //layer=li \
 //thickness=0.1 //x=69.68 //y=0.175 //x2=70.79 //y2=0.175
r1965 (  575 577 ) resistor r=38.7139 //w=0.367 //l=1.11 //layer=li \
 //thickness=0.1 //x=68.57 //y=0.175 //x2=69.68 //y2=0.175
r1966 (  573 720 ) resistor r=5.29055 //w=0.35 //l=0.17 //layer=li \
 //thickness=0.1 //x=68 //y=0.175 //x2=67.83 //y2=0.175
r1967 (  573 575 ) resistor r=19.8801 //w=0.367 //l=0.57 //layer=li \
 //thickness=0.1 //x=68 //y=0.175 //x2=68.57 //y2=0.175
r1968 (  572 721 ) resistor r=5.29055 //w=0.35 //l=0.17 //layer=li \
 //thickness=0.1 //x=72.47 //y=0.175 //x2=72.64 //y2=0.175
r1969 (  572 581 ) resistor r=19.8801 //w=0.367 //l=0.57 //layer=li \
 //thickness=0.1 //x=72.47 //y=0.175 //x2=71.9 //y2=0.175
r1970 (  562 564 ) resistor r=38.7139 //w=0.367 //l=1.11 //layer=li \
 //thickness=0.1 //x=65.98 //y=0.175 //x2=67.09 //y2=0.175
r1971 (  560 562 ) resistor r=38.7139 //w=0.367 //l=1.11 //layer=li \
 //thickness=0.1 //x=64.87 //y=0.175 //x2=65.98 //y2=0.175
r1972 (  558 560 ) resistor r=38.7139 //w=0.367 //l=1.11 //layer=li \
 //thickness=0.1 //x=63.76 //y=0.175 //x2=64.87 //y2=0.175
r1973 (  556 719 ) resistor r=5.29055 //w=0.35 //l=0.17 //layer=li \
 //thickness=0.1 //x=63.19 //y=0.175 //x2=63.02 //y2=0.175
r1974 (  556 558 ) resistor r=19.8801 //w=0.367 //l=0.57 //layer=li \
 //thickness=0.1 //x=63.19 //y=0.175 //x2=63.76 //y2=0.175
r1975 (  555 720 ) resistor r=5.29055 //w=0.35 //l=0.17 //layer=li \
 //thickness=0.1 //x=67.66 //y=0.175 //x2=67.83 //y2=0.175
r1976 (  555 564 ) resistor r=19.8801 //w=0.367 //l=0.57 //layer=li \
 //thickness=0.1 //x=67.66 //y=0.175 //x2=67.09 //y2=0.175
r1977 (  545 547 ) resistor r=38.7139 //w=0.367 //l=1.11 //layer=li \
 //thickness=0.1 //x=61.17 //y=0.175 //x2=62.28 //y2=0.175
r1978 (  543 545 ) resistor r=38.7139 //w=0.367 //l=1.11 //layer=li \
 //thickness=0.1 //x=60.06 //y=0.175 //x2=61.17 //y2=0.175
r1979 (  541 543 ) resistor r=38.7139 //w=0.367 //l=1.11 //layer=li \
 //thickness=0.1 //x=58.95 //y=0.175 //x2=60.06 //y2=0.175
r1980 (  539 718 ) resistor r=5.29055 //w=0.35 //l=0.17 //layer=li \
 //thickness=0.1 //x=58.38 //y=0.175 //x2=58.21 //y2=0.175
r1981 (  539 541 ) resistor r=19.8801 //w=0.367 //l=0.57 //layer=li \
 //thickness=0.1 //x=58.38 //y=0.175 //x2=58.95 //y2=0.175
r1982 (  538 719 ) resistor r=5.29055 //w=0.35 //l=0.17 //layer=li \
 //thickness=0.1 //x=62.85 //y=0.175 //x2=63.02 //y2=0.175
r1983 (  538 547 ) resistor r=19.8801 //w=0.367 //l=0.57 //layer=li \
 //thickness=0.1 //x=62.85 //y=0.175 //x2=62.28 //y2=0.175
r1984 (  528 530 ) resistor r=38.7139 //w=0.367 //l=1.11 //layer=li \
 //thickness=0.1 //x=56.36 //y=0.175 //x2=57.47 //y2=0.175
r1985 (  526 528 ) resistor r=38.7139 //w=0.367 //l=1.11 //layer=li \
 //thickness=0.1 //x=55.25 //y=0.175 //x2=56.36 //y2=0.175
r1986 (  524 526 ) resistor r=38.7139 //w=0.367 //l=1.11 //layer=li \
 //thickness=0.1 //x=54.14 //y=0.175 //x2=55.25 //y2=0.175
r1987 (  522 717 ) resistor r=5.29055 //w=0.35 //l=0.17 //layer=li \
 //thickness=0.1 //x=53.57 //y=0.175 //x2=53.4 //y2=0.175
r1988 (  522 524 ) resistor r=19.8801 //w=0.367 //l=0.57 //layer=li \
 //thickness=0.1 //x=53.57 //y=0.175 //x2=54.14 //y2=0.175
r1989 (  521 718 ) resistor r=5.29055 //w=0.35 //l=0.17 //layer=li \
 //thickness=0.1 //x=58.04 //y=0.175 //x2=58.21 //y2=0.175
r1990 (  521 530 ) resistor r=19.8801 //w=0.367 //l=0.57 //layer=li \
 //thickness=0.1 //x=58.04 //y=0.175 //x2=57.47 //y2=0.175
r1991 (  511 513 ) resistor r=38.7139 //w=0.367 //l=1.11 //layer=li \
 //thickness=0.1 //x=51.55 //y=0.175 //x2=52.66 //y2=0.175
r1992 (  509 511 ) resistor r=38.7139 //w=0.367 //l=1.11 //layer=li \
 //thickness=0.1 //x=50.44 //y=0.175 //x2=51.55 //y2=0.175
r1993 (  507 509 ) resistor r=38.7139 //w=0.367 //l=1.11 //layer=li \
 //thickness=0.1 //x=49.33 //y=0.175 //x2=50.44 //y2=0.175
r1994 (  505 716 ) resistor r=5.29055 //w=0.35 //l=0.17 //layer=li \
 //thickness=0.1 //x=48.76 //y=0.175 //x2=48.59 //y2=0.175
r1995 (  505 507 ) resistor r=19.8801 //w=0.367 //l=0.57 //layer=li \
 //thickness=0.1 //x=48.76 //y=0.175 //x2=49.33 //y2=0.175
r1996 (  504 717 ) resistor r=5.29055 //w=0.35 //l=0.17 //layer=li \
 //thickness=0.1 //x=53.23 //y=0.175 //x2=53.4 //y2=0.175
r1997 (  504 513 ) resistor r=19.8801 //w=0.367 //l=0.57 //layer=li \
 //thickness=0.1 //x=53.23 //y=0.175 //x2=52.66 //y2=0.175
r1998 (  494 496 ) resistor r=38.7139 //w=0.367 //l=1.11 //layer=li \
 //thickness=0.1 //x=46.74 //y=0.175 //x2=47.85 //y2=0.175
r1999 (  492 494 ) resistor r=38.7139 //w=0.367 //l=1.11 //layer=li \
 //thickness=0.1 //x=45.63 //y=0.175 //x2=46.74 //y2=0.175
r2000 (  490 492 ) resistor r=38.7139 //w=0.367 //l=1.11 //layer=li \
 //thickness=0.1 //x=44.52 //y=0.175 //x2=45.63 //y2=0.175
r2001 (  488 715 ) resistor r=5.29055 //w=0.35 //l=0.17 //layer=li \
 //thickness=0.1 //x=43.95 //y=0.175 //x2=43.78 //y2=0.175
r2002 (  488 490 ) resistor r=19.8801 //w=0.367 //l=0.57 //layer=li \
 //thickness=0.1 //x=43.95 //y=0.175 //x2=44.52 //y2=0.175
r2003 (  487 716 ) resistor r=5.29055 //w=0.35 //l=0.17 //layer=li \
 //thickness=0.1 //x=48.42 //y=0.175 //x2=48.59 //y2=0.175
r2004 (  487 496 ) resistor r=19.8801 //w=0.367 //l=0.57 //layer=li \
 //thickness=0.1 //x=48.42 //y=0.175 //x2=47.85 //y2=0.175
r2005 (  477 479 ) resistor r=38.7139 //w=0.367 //l=1.11 //layer=li \
 //thickness=0.1 //x=41.93 //y=0.175 //x2=43.04 //y2=0.175
r2006 (  475 477 ) resistor r=38.7139 //w=0.367 //l=1.11 //layer=li \
 //thickness=0.1 //x=40.82 //y=0.175 //x2=41.93 //y2=0.175
r2007 (  473 475 ) resistor r=38.7139 //w=0.367 //l=1.11 //layer=li \
 //thickness=0.1 //x=39.71 //y=0.175 //x2=40.82 //y2=0.175
r2008 (  471 714 ) resistor r=5.29055 //w=0.35 //l=0.17 //layer=li \
 //thickness=0.1 //x=39.14 //y=0.175 //x2=38.97 //y2=0.175
r2009 (  471 473 ) resistor r=19.8801 //w=0.367 //l=0.57 //layer=li \
 //thickness=0.1 //x=39.14 //y=0.175 //x2=39.71 //y2=0.175
r2010 (  470 715 ) resistor r=5.29055 //w=0.35 //l=0.17 //layer=li \
 //thickness=0.1 //x=43.61 //y=0.175 //x2=43.78 //y2=0.175
r2011 (  470 479 ) resistor r=19.8801 //w=0.367 //l=0.57 //layer=li \
 //thickness=0.1 //x=43.61 //y=0.175 //x2=43.04 //y2=0.175
r2012 (  460 462 ) resistor r=38.7139 //w=0.367 //l=1.11 //layer=li \
 //thickness=0.1 //x=37.12 //y=0.175 //x2=38.23 //y2=0.175
r2013 (  458 460 ) resistor r=38.7139 //w=0.367 //l=1.11 //layer=li \
 //thickness=0.1 //x=36.01 //y=0.175 //x2=37.12 //y2=0.175
r2014 (  456 458 ) resistor r=38.7139 //w=0.367 //l=1.11 //layer=li \
 //thickness=0.1 //x=34.9 //y=0.175 //x2=36.01 //y2=0.175
r2015 (  454 713 ) resistor r=5.29055 //w=0.35 //l=0.17 //layer=li \
 //thickness=0.1 //x=34.33 //y=0.175 //x2=34.16 //y2=0.175
r2016 (  454 456 ) resistor r=19.8801 //w=0.367 //l=0.57 //layer=li \
 //thickness=0.1 //x=34.33 //y=0.175 //x2=34.9 //y2=0.175
r2017 (  453 714 ) resistor r=5.29055 //w=0.35 //l=0.17 //layer=li \
 //thickness=0.1 //x=38.8 //y=0.175 //x2=38.97 //y2=0.175
r2018 (  453 462 ) resistor r=19.8801 //w=0.367 //l=0.57 //layer=li \
 //thickness=0.1 //x=38.8 //y=0.175 //x2=38.23 //y2=0.175
r2019 (  443 445 ) resistor r=38.7139 //w=0.367 //l=1.11 //layer=li \
 //thickness=0.1 //x=32.31 //y=0.175 //x2=33.42 //y2=0.175
r2020 (  441 443 ) resistor r=38.7139 //w=0.367 //l=1.11 //layer=li \
 //thickness=0.1 //x=31.2 //y=0.175 //x2=32.31 //y2=0.175
r2021 (  439 441 ) resistor r=38.7139 //w=0.367 //l=1.11 //layer=li \
 //thickness=0.1 //x=30.09 //y=0.175 //x2=31.2 //y2=0.175
r2022 (  437 712 ) resistor r=5.29055 //w=0.35 //l=0.17 //layer=li \
 //thickness=0.1 //x=29.52 //y=0.175 //x2=29.35 //y2=0.175
r2023 (  437 439 ) resistor r=19.8801 //w=0.367 //l=0.57 //layer=li \
 //thickness=0.1 //x=29.52 //y=0.175 //x2=30.09 //y2=0.175
r2024 (  436 713 ) resistor r=5.29055 //w=0.35 //l=0.17 //layer=li \
 //thickness=0.1 //x=33.99 //y=0.175 //x2=34.16 //y2=0.175
r2025 (  436 445 ) resistor r=19.8801 //w=0.367 //l=0.57 //layer=li \
 //thickness=0.1 //x=33.99 //y=0.175 //x2=33.42 //y2=0.175
r2026 (  426 428 ) resistor r=38.7139 //w=0.367 //l=1.11 //layer=li \
 //thickness=0.1 //x=27.5 //y=0.175 //x2=28.61 //y2=0.175
r2027 (  424 426 ) resistor r=38.7139 //w=0.367 //l=1.11 //layer=li \
 //thickness=0.1 //x=26.39 //y=0.175 //x2=27.5 //y2=0.175
r2028 (  422 424 ) resistor r=38.7139 //w=0.367 //l=1.11 //layer=li \
 //thickness=0.1 //x=25.28 //y=0.175 //x2=26.39 //y2=0.175
r2029 (  420 711 ) resistor r=5.29055 //w=0.35 //l=0.17 //layer=li \
 //thickness=0.1 //x=24.71 //y=0.175 //x2=24.54 //y2=0.175
r2030 (  420 422 ) resistor r=19.8801 //w=0.367 //l=0.57 //layer=li \
 //thickness=0.1 //x=24.71 //y=0.175 //x2=25.28 //y2=0.175
r2031 (  419 712 ) resistor r=5.29055 //w=0.35 //l=0.17 //layer=li \
 //thickness=0.1 //x=29.18 //y=0.175 //x2=29.35 //y2=0.175
r2032 (  419 428 ) resistor r=19.8801 //w=0.367 //l=0.57 //layer=li \
 //thickness=0.1 //x=29.18 //y=0.175 //x2=28.61 //y2=0.175
r2033 (  409 411 ) resistor r=38.7139 //w=0.367 //l=1.11 //layer=li \
 //thickness=0.1 //x=22.69 //y=0.175 //x2=23.8 //y2=0.175
r2034 (  407 409 ) resistor r=38.7139 //w=0.367 //l=1.11 //layer=li \
 //thickness=0.1 //x=21.58 //y=0.175 //x2=22.69 //y2=0.175
r2035 (  405 407 ) resistor r=38.7139 //w=0.367 //l=1.11 //layer=li \
 //thickness=0.1 //x=20.47 //y=0.175 //x2=21.58 //y2=0.175
r2036 (  403 710 ) resistor r=5.29055 //w=0.35 //l=0.17 //layer=li \
 //thickness=0.1 //x=19.9 //y=0.175 //x2=19.73 //y2=0.175
r2037 (  403 405 ) resistor r=19.8801 //w=0.367 //l=0.57 //layer=li \
 //thickness=0.1 //x=19.9 //y=0.175 //x2=20.47 //y2=0.175
r2038 (  402 711 ) resistor r=5.29055 //w=0.35 //l=0.17 //layer=li \
 //thickness=0.1 //x=24.37 //y=0.175 //x2=24.54 //y2=0.175
r2039 (  402 411 ) resistor r=19.8801 //w=0.367 //l=0.57 //layer=li \
 //thickness=0.1 //x=24.37 //y=0.175 //x2=23.8 //y2=0.175
r2040 (  392 394 ) resistor r=38.7139 //w=0.367 //l=1.11 //layer=li \
 //thickness=0.1 //x=17.88 //y=0.175 //x2=18.99 //y2=0.175
r2041 (  390 392 ) resistor r=38.7139 //w=0.367 //l=1.11 //layer=li \
 //thickness=0.1 //x=16.77 //y=0.175 //x2=17.88 //y2=0.175
r2042 (  388 390 ) resistor r=38.7139 //w=0.367 //l=1.11 //layer=li \
 //thickness=0.1 //x=15.66 //y=0.175 //x2=16.77 //y2=0.175
r2043 (  386 709 ) resistor r=5.29055 //w=0.35 //l=0.17 //layer=li \
 //thickness=0.1 //x=15.09 //y=0.175 //x2=14.92 //y2=0.175
r2044 (  386 388 ) resistor r=19.8801 //w=0.367 //l=0.57 //layer=li \
 //thickness=0.1 //x=15.09 //y=0.175 //x2=15.66 //y2=0.175
r2045 (  385 710 ) resistor r=5.29055 //w=0.35 //l=0.17 //layer=li \
 //thickness=0.1 //x=19.56 //y=0.175 //x2=19.73 //y2=0.175
r2046 (  385 394 ) resistor r=19.8801 //w=0.367 //l=0.57 //layer=li \
 //thickness=0.1 //x=19.56 //y=0.175 //x2=18.99 //y2=0.175
r2047 (  375 377 ) resistor r=38.7139 //w=0.367 //l=1.11 //layer=li \
 //thickness=0.1 //x=13.07 //y=0.175 //x2=14.18 //y2=0.175
r2048 (  373 375 ) resistor r=38.7139 //w=0.367 //l=1.11 //layer=li \
 //thickness=0.1 //x=11.96 //y=0.175 //x2=13.07 //y2=0.175
r2049 (  371 373 ) resistor r=38.7139 //w=0.367 //l=1.11 //layer=li \
 //thickness=0.1 //x=10.85 //y=0.175 //x2=11.96 //y2=0.175
r2050 (  369 708 ) resistor r=5.29055 //w=0.35 //l=0.17 //layer=li \
 //thickness=0.1 //x=10.28 //y=0.175 //x2=10.11 //y2=0.175
r2051 (  369 371 ) resistor r=19.8801 //w=0.367 //l=0.57 //layer=li \
 //thickness=0.1 //x=10.28 //y=0.175 //x2=10.85 //y2=0.175
r2052 (  368 709 ) resistor r=5.29055 //w=0.35 //l=0.17 //layer=li \
 //thickness=0.1 //x=14.75 //y=0.175 //x2=14.92 //y2=0.175
r2053 (  368 377 ) resistor r=19.8801 //w=0.367 //l=0.57 //layer=li \
 //thickness=0.1 //x=14.75 //y=0.175 //x2=14.18 //y2=0.175
r2054 (  358 360 ) resistor r=38.7139 //w=0.367 //l=1.11 //layer=li \
 //thickness=0.1 //x=8.26 //y=0.175 //x2=9.37 //y2=0.175
r2055 (  356 358 ) resistor r=38.7139 //w=0.367 //l=1.11 //layer=li \
 //thickness=0.1 //x=7.15 //y=0.175 //x2=8.26 //y2=0.175
r2056 (  354 356 ) resistor r=38.7139 //w=0.367 //l=1.11 //layer=li \
 //thickness=0.1 //x=6.04 //y=0.175 //x2=7.15 //y2=0.175
r2057 (  352 707 ) resistor r=5.29055 //w=0.35 //l=0.17 //layer=li \
 //thickness=0.1 //x=5.47 //y=0.175 //x2=5.3 //y2=0.175
r2058 (  352 354 ) resistor r=19.8801 //w=0.367 //l=0.57 //layer=li \
 //thickness=0.1 //x=5.47 //y=0.175 //x2=6.04 //y2=0.175
r2059 (  351 708 ) resistor r=5.29055 //w=0.35 //l=0.17 //layer=li \
 //thickness=0.1 //x=9.94 //y=0.175 //x2=10.11 //y2=0.175
r2060 (  351 360 ) resistor r=19.8801 //w=0.367 //l=0.57 //layer=li \
 //thickness=0.1 //x=9.94 //y=0.175 //x2=9.37 //y2=0.175
r2061 (  341 343 ) resistor r=38.7139 //w=0.367 //l=1.11 //layer=li \
 //thickness=0.1 //x=3.45 //y=0.175 //x2=4.56 //y2=0.175
r2062 (  339 341 ) resistor r=38.7139 //w=0.367 //l=1.11 //layer=li \
 //thickness=0.1 //x=2.34 //y=0.175 //x2=3.45 //y2=0.175
r2063 (  337 339 ) resistor r=38.7139 //w=0.367 //l=1.11 //layer=li \
 //thickness=0.1 //x=1.23 //y=0.175 //x2=2.34 //y2=0.175
r2064 (  334 707 ) resistor r=5.29055 //w=0.35 //l=0.17 //layer=li \
 //thickness=0.1 //x=5.13 //y=0.175 //x2=5.3 //y2=0.175
r2065 (  334 343 ) resistor r=19.8801 //w=0.367 //l=0.57 //layer=li \
 //thickness=0.1 //x=5.13 //y=0.175 //x2=4.56 //y2=0.175
r2066 (  331 761 ) resistor r=9.3 //w=0.17 //l=0.17 //layer=mcon //count=1 \
 //x=94.91 //y=1.135 //x2=94.91 //y2=1.135
r2067 (  328 760 ) resistor r=9.3 //w=0.17 //l=0.17 //layer=mcon //count=1 \
 //x=91.58 //y=1.135 //x2=91.58 //y2=1.135
r2068 (  326 658 ) resistor r=3.1 //w=0.17 //l=0.51 //layer=mcon //count=3 \
 //x=91.51 //y=0.18 //x2=91.51 //y2=0.18
r2069 (  324 759 ) resistor r=9.3 //w=0.17 //l=0.17 //layer=mcon //count=1 \
 //x=88.25 //y=1.135 //x2=88.25 //y2=1.135
r2070 (  319 758 ) resistor r=9.3 //w=0.17 //l=0.17 //layer=mcon //count=1 \
 //x=83.335 //y=1.145 //x2=83.335 //y2=1.145
r2071 (  315 757 ) resistor r=9.3 //w=0.17 //l=0.17 //layer=mcon //count=1 \
 //x=78.525 //y=1.145 //x2=78.525 //y2=1.145
r2072 (  311 756 ) resistor r=9.3 //w=0.17 //l=0.17 //layer=mcon //count=1 \
 //x=73.715 //y=1.145 //x2=73.715 //y2=1.145
r2073 (  307 755 ) resistor r=9.3 //w=0.17 //l=0.17 //layer=mcon //count=1 \
 //x=68.905 //y=1.145 //x2=68.905 //y2=1.145
r2074 (  303 754 ) resistor r=9.3 //w=0.17 //l=0.17 //layer=mcon //count=1 \
 //x=64.095 //y=1.145 //x2=64.095 //y2=1.145
r2075 (  299 753 ) resistor r=9.3 //w=0.17 //l=0.17 //layer=mcon //count=1 \
 //x=59.285 //y=1.145 //x2=59.285 //y2=1.145
r2076 (  295 752 ) resistor r=9.3 //w=0.17 //l=0.17 //layer=mcon //count=1 \
 //x=54.475 //y=1.145 //x2=54.475 //y2=1.145
r2077 (  291 751 ) resistor r=9.3 //w=0.17 //l=0.17 //layer=mcon //count=1 \
 //x=49.665 //y=1.145 //x2=49.665 //y2=1.145
r2078 (  287 750 ) resistor r=9.3 //w=0.17 //l=0.17 //layer=mcon //count=1 \
 //x=44.855 //y=1.145 //x2=44.855 //y2=1.145
r2079 (  283 749 ) resistor r=9.3 //w=0.17 //l=0.17 //layer=mcon //count=1 \
 //x=40.045 //y=1.145 //x2=40.045 //y2=1.145
r2080 (  279 748 ) resistor r=9.3 //w=0.17 //l=0.17 //layer=mcon //count=1 \
 //x=35.235 //y=1.145 //x2=35.235 //y2=1.145
r2081 (  275 747 ) resistor r=9.3 //w=0.17 //l=0.17 //layer=mcon //count=1 \
 //x=30.425 //y=1.145 //x2=30.425 //y2=1.145
r2082 (  271 746 ) resistor r=9.3 //w=0.17 //l=0.17 //layer=mcon //count=1 \
 //x=25.615 //y=1.145 //x2=25.615 //y2=1.145
r2083 (  267 745 ) resistor r=9.3 //w=0.17 //l=0.17 //layer=mcon //count=1 \
 //x=20.805 //y=1.145 //x2=20.805 //y2=1.145
r2084 (  263 744 ) resistor r=9.3 //w=0.17 //l=0.17 //layer=mcon //count=1 \
 //x=15.995 //y=1.145 //x2=15.995 //y2=1.145
r2085 (  259 743 ) resistor r=9.3 //w=0.17 //l=0.17 //layer=mcon //count=1 \
 //x=11.185 //y=1.145 //x2=11.185 //y2=1.145
r2086 (  255 742 ) resistor r=9.3 //w=0.17 //l=0.17 //layer=mcon //count=1 \
 //x=6.375 //y=1.145 //x2=6.375 //y2=1.145
r2087 (  251 741 ) resistor r=9.3 //w=0.17 //l=0.17 //layer=mcon //count=1 \
 //x=1.565 //y=1.145 //x2=1.565 //y2=1.145
r2088 (  248 733 ) resistor r=4.65 //w=0.17 //l=0.34 //layer=mcon //count=2 \
 //x=98.54 //y=0.18 //x2=98.54 //y2=0.18
r2089 (  246 730 ) resistor r=3.1 //w=0.17 //l=0.51 //layer=mcon //count=3 \
 //x=97.8 //y=0.18 //x2=97.8 //y2=0.18
r2090 (  246 248 ) resistor r=0.297428 //w=0.311 //l=0.74 //layer=m1 \
 //thickness=0.36 //x=97.8 //y=0.175 //x2=98.54 //y2=0.175
r2091 (  244 675 ) resistor r=3.1 //w=0.17 //l=0.51 //layer=mcon //count=3 \
 //x=96.32 //y=0.18 //x2=96.32 //y2=0.18
r2092 (  244 246 ) resistor r=0.594855 //w=0.311 //l=1.48 //layer=m1 \
 //thickness=0.36 //x=96.32 //y=0.175 //x2=97.8 //y2=0.175
r2093 (  242 673 ) resistor r=3.1 //w=0.17 //l=0.51 //layer=mcon //count=3 \
 //x=95.21 //y=0.18 //x2=95.21 //y2=0.18
r2094 (  242 244 ) resistor r=0.446141 //w=0.311 //l=1.11 //layer=m1 \
 //thickness=0.36 //x=95.21 //y=0.175 //x2=96.32 //y2=0.175
r2095 (  240 329 ) resistor r=0.028033 //w=0.35 //l=0.085 //layer=m1 \
 //thickness=0.36 //x=94.995 //y=0.175 //x2=94.91 //y2=0.175
r2096 (  240 242 ) resistor r=0.0864148 //w=0.311 //l=0.215 //layer=m1 \
 //thickness=0.36 //x=94.995 //y=0.175 //x2=95.21 //y2=0.175
r2097 (  239 331 ) resistor r=0.0703067 //w=0.254 //l=0.11649 //layer=m1 \
 //thickness=0.36 //x=94.91 //y=1.02 //x2=94.907 //y2=1.135
r2098 (  238 329 ) resistor r=0.0413265 //w=0.7 //l=0.175 //layer=m1 \
 //thickness=0.36 //x=94.91 //y=0.35 //x2=94.91 //y2=0.175
r2099 (  238 239 ) resistor r=0.639313 //w=0.131 //l=0.67 //layer=m1 \
 //thickness=0.36 //x=94.91 //y=0.35 //x2=94.91 //y2=1.02
r2100 (  237 671 ) resistor r=3.1 //w=0.17 //l=0.51 //layer=mcon //count=3 \
 //x=94.1 //y=0.18 //x2=94.1 //y2=0.18
r2101 (  235 660 ) resistor r=3.1 //w=0.17 //l=0.51 //layer=mcon //count=3 \
 //x=92.62 //y=0.18 //x2=92.62 //y2=0.18
r2102 (  235 237 ) resistor r=0.594855 //w=0.311 //l=1.48 //layer=m1 \
 //thickness=0.36 //x=92.62 //y=0.175 //x2=94.1 //y2=0.175
r2103 (  233 326 ) resistor r=0.028033 //w=0.35 //l=0.085 //layer=m1 \
 //thickness=0.36 //x=91.665 //y=0.175 //x2=91.58 //y2=0.175
r2104 (  233 235 ) resistor r=0.383842 //w=0.311 //l=0.955 //layer=m1 \
 //thickness=0.36 //x=91.665 //y=0.175 //x2=92.62 //y2=0.175
r2105 (  232 329 ) resistor r=0.028033 //w=0.35 //l=0.085 //layer=m1 \
 //thickness=0.36 //x=94.825 //y=0.175 //x2=94.91 //y2=0.175
r2106 (  232 237 ) resistor r=0.291399 //w=0.311 //l=0.725 //layer=m1 \
 //thickness=0.36 //x=94.825 //y=0.175 //x2=94.1 //y2=0.175
r2107 (  231 328 ) resistor r=0.072745 //w=0.255 //l=0.122474 //layer=m1 \
 //thickness=0.36 //x=91.58 //y=1.015 //x2=91.585 //y2=1.135
r2108 (  230 326 ) resistor r=0.0413265 //w=0.7 //l=0.175 //layer=m1 \
 //thickness=0.36 //x=91.58 //y=0.35 //x2=91.58 //y2=0.175
r2109 (  230 231 ) resistor r=0.634542 //w=0.131 //l=0.665 //layer=m1 \
 //thickness=0.36 //x=91.58 //y=0.35 //x2=91.58 //y2=1.015
r2110 (  229 647 ) resistor r=3.1 //w=0.17 //l=0.51 //layer=mcon //count=3 \
 //x=90.03 //y=0.18 //x2=90.03 //y2=0.18
r2111 (  227 645 ) resistor r=3.1 //w=0.17 //l=0.51 //layer=mcon //count=3 \
 //x=88.92 //y=0.18 //x2=88.92 //y2=0.18
r2112 (  227 229 ) resistor r=0.446141 //w=0.311 //l=1.11 //layer=m1 \
 //thickness=0.36 //x=88.92 //y=0.175 //x2=90.03 //y2=0.175
r2113 (  225 322 ) resistor r=0.028033 //w=0.35 //l=0.085 //layer=m1 \
 //thickness=0.36 //x=88.335 //y=0.175 //x2=88.25 //y2=0.175
r2114 (  225 227 ) resistor r=0.235129 //w=0.311 //l=0.585 //layer=m1 \
 //thickness=0.36 //x=88.335 //y=0.175 //x2=88.92 //y2=0.175
r2115 (  224 326 ) resistor r=0.028033 //w=0.35 //l=0.085 //layer=m1 \
 //thickness=0.36 //x=91.495 //y=0.175 //x2=91.58 //y2=0.175
r2116 (  224 229 ) resistor r=0.588826 //w=0.311 //l=1.465 //layer=m1 \
 //thickness=0.36 //x=91.495 //y=0.175 //x2=90.03 //y2=0.175
r2117 (  223 324 ) resistor r=0.0729089 //w=0.249 //l=0.120996 //layer=m1 \
 //thickness=0.36 //x=88.25 //y=1.015 //x2=88.252 //y2=1.135
r2118 (  222 322 ) resistor r=0.0413265 //w=0.7 //l=0.175 //layer=m1 \
 //thickness=0.36 //x=88.25 //y=0.35 //x2=88.25 //y2=0.175
r2119 (  222 223 ) resistor r=0.634542 //w=0.131 //l=0.665 //layer=m1 \
 //thickness=0.36 //x=88.25 //y=0.35 //x2=88.25 //y2=1.015
r2120 (  221 643 ) resistor r=3.1 //w=0.17 //l=0.51 //layer=mcon //count=3 \
 //x=87.81 //y=0.18 //x2=87.81 //y2=0.18
r2121 (  219 632 ) resistor r=3.1 //w=0.17 //l=0.51 //layer=mcon //count=3 \
 //x=86.33 //y=0.18 //x2=86.33 //y2=0.18
r2122 (  219 221 ) resistor r=0.594855 //w=0.311 //l=1.48 //layer=m1 \
 //thickness=0.36 //x=86.33 //y=0.175 //x2=87.81 //y2=0.175
r2123 (  217 630 ) resistor r=3.1 //w=0.17 //l=0.51 //layer=mcon //count=3 \
 //x=85.22 //y=0.18 //x2=85.22 //y2=0.18
r2124 (  217 219 ) resistor r=0.446141 //w=0.311 //l=1.11 //layer=m1 \
 //thickness=0.36 //x=85.22 //y=0.175 //x2=86.33 //y2=0.175
r2125 (  215 628 ) resistor r=3.1 //w=0.17 //l=0.51 //layer=mcon //count=3 \
 //x=84.11 //y=0.18 //x2=84.11 //y2=0.18
r2126 (  215 217 ) resistor r=0.446141 //w=0.311 //l=1.11 //layer=m1 \
 //thickness=0.36 //x=84.11 //y=0.175 //x2=85.22 //y2=0.175
r2127 (  213 321 ) resistor r=0.028033 //w=0.35 //l=0.085 //layer=m1 \
 //thickness=0.36 //x=83.42 //y=0.175 //x2=83.335 //y2=0.175
r2128 (  213 215 ) resistor r=0.277331 //w=0.311 //l=0.69 //layer=m1 \
 //thickness=0.36 //x=83.42 //y=0.175 //x2=84.11 //y2=0.175
r2129 (  212 322 ) resistor r=0.028033 //w=0.35 //l=0.085 //layer=m1 \
 //thickness=0.36 //x=88.165 //y=0.175 //x2=88.25 //y2=0.175
r2130 (  212 221 ) resistor r=0.142685 //w=0.311 //l=0.355 //layer=m1 \
 //thickness=0.36 //x=88.165 //y=0.175 //x2=87.81 //y2=0.175
r2131 (  211 319 ) resistor r=0.0942778 //w=0.221 //l=0.13 //layer=m1 \
 //thickness=0.36 //x=83.335 //y=1.015 //x2=83.335 //y2=1.145
r2132 (  210 321 ) resistor r=0.0413265 //w=0.7 //l=0.175 //layer=m1 \
 //thickness=0.36 //x=83.335 //y=0.35 //x2=83.335 //y2=0.175
r2133 (  210 211 ) resistor r=0.634542 //w=0.131 //l=0.665 //layer=m1 \
 //thickness=0.36 //x=83.335 //y=0.35 //x2=83.335 //y2=1.015
r2134 (  209 626 ) resistor r=3.1 //w=0.17 //l=0.51 //layer=mcon //count=3 \
 //x=83 //y=0.18 //x2=83 //y2=0.18
r2135 (  207 615 ) resistor r=3.1 //w=0.17 //l=0.51 //layer=mcon //count=3 \
 //x=81.52 //y=0.18 //x2=81.52 //y2=0.18
r2136 (  207 209 ) resistor r=0.594855 //w=0.311 //l=1.48 //layer=m1 \
 //thickness=0.36 //x=81.52 //y=0.175 //x2=83 //y2=0.175
r2137 (  205 613 ) resistor r=3.1 //w=0.17 //l=0.51 //layer=mcon //count=3 \
 //x=80.41 //y=0.18 //x2=80.41 //y2=0.18
r2138 (  205 207 ) resistor r=0.446141 //w=0.311 //l=1.11 //layer=m1 \
 //thickness=0.36 //x=80.41 //y=0.175 //x2=81.52 //y2=0.175
r2139 (  203 611 ) resistor r=3.1 //w=0.17 //l=0.51 //layer=mcon //count=3 \
 //x=79.3 //y=0.18 //x2=79.3 //y2=0.18
r2140 (  203 205 ) resistor r=0.446141 //w=0.311 //l=1.11 //layer=m1 \
 //thickness=0.36 //x=79.3 //y=0.175 //x2=80.41 //y2=0.175
r2141 (  201 317 ) resistor r=0.028033 //w=0.35 //l=0.085 //layer=m1 \
 //thickness=0.36 //x=78.61 //y=0.175 //x2=78.525 //y2=0.175
r2142 (  201 203 ) resistor r=0.277331 //w=0.311 //l=0.69 //layer=m1 \
 //thickness=0.36 //x=78.61 //y=0.175 //x2=79.3 //y2=0.175
r2143 (  200 321 ) resistor r=0.028033 //w=0.35 //l=0.085 //layer=m1 \
 //thickness=0.36 //x=83.25 //y=0.175 //x2=83.335 //y2=0.175
r2144 (  200 209 ) resistor r=0.100482 //w=0.311 //l=0.25 //layer=m1 \
 //thickness=0.36 //x=83.25 //y=0.175 //x2=83 //y2=0.175
r2145 (  199 315 ) resistor r=0.0942778 //w=0.221 //l=0.13 //layer=m1 \
 //thickness=0.36 //x=78.525 //y=1.015 //x2=78.525 //y2=1.145
r2146 (  198 317 ) resistor r=0.0413265 //w=0.7 //l=0.175 //layer=m1 \
 //thickness=0.36 //x=78.525 //y=0.35 //x2=78.525 //y2=0.175
r2147 (  198 199 ) resistor r=0.634542 //w=0.131 //l=0.665 //layer=m1 \
 //thickness=0.36 //x=78.525 //y=0.35 //x2=78.525 //y2=1.015
r2148 (  197 609 ) resistor r=3.1 //w=0.17 //l=0.51 //layer=mcon //count=3 \
 //x=78.19 //y=0.18 //x2=78.19 //y2=0.18
r2149 (  195 598 ) resistor r=3.1 //w=0.17 //l=0.51 //layer=mcon //count=3 \
 //x=76.71 //y=0.18 //x2=76.71 //y2=0.18
r2150 (  195 197 ) resistor r=0.594855 //w=0.311 //l=1.48 //layer=m1 \
 //thickness=0.36 //x=76.71 //y=0.175 //x2=78.19 //y2=0.175
r2151 (  193 596 ) resistor r=3.1 //w=0.17 //l=0.51 //layer=mcon //count=3 \
 //x=75.6 //y=0.18 //x2=75.6 //y2=0.18
r2152 (  193 195 ) resistor r=0.446141 //w=0.311 //l=1.11 //layer=m1 \
 //thickness=0.36 //x=75.6 //y=0.175 //x2=76.71 //y2=0.175
r2153 (  191 594 ) resistor r=3.1 //w=0.17 //l=0.51 //layer=mcon //count=3 \
 //x=74.49 //y=0.18 //x2=74.49 //y2=0.18
r2154 (  191 193 ) resistor r=0.446141 //w=0.311 //l=1.11 //layer=m1 \
 //thickness=0.36 //x=74.49 //y=0.175 //x2=75.6 //y2=0.175
r2155 (  189 313 ) resistor r=0.028033 //w=0.35 //l=0.085 //layer=m1 \
 //thickness=0.36 //x=73.8 //y=0.175 //x2=73.715 //y2=0.175
r2156 (  189 191 ) resistor r=0.277331 //w=0.311 //l=0.69 //layer=m1 \
 //thickness=0.36 //x=73.8 //y=0.175 //x2=74.49 //y2=0.175
r2157 (  188 317 ) resistor r=0.028033 //w=0.35 //l=0.085 //layer=m1 \
 //thickness=0.36 //x=78.44 //y=0.175 //x2=78.525 //y2=0.175
r2158 (  188 197 ) resistor r=0.100482 //w=0.311 //l=0.25 //layer=m1 \
 //thickness=0.36 //x=78.44 //y=0.175 //x2=78.19 //y2=0.175
r2159 (  187 311 ) resistor r=0.0942778 //w=0.221 //l=0.13 //layer=m1 \
 //thickness=0.36 //x=73.715 //y=1.015 //x2=73.715 //y2=1.145
r2160 (  186 313 ) resistor r=0.0413265 //w=0.7 //l=0.175 //layer=m1 \
 //thickness=0.36 //x=73.715 //y=0.35 //x2=73.715 //y2=0.175
r2161 (  186 187 ) resistor r=0.634542 //w=0.131 //l=0.665 //layer=m1 \
 //thickness=0.36 //x=73.715 //y=0.35 //x2=73.715 //y2=1.015
r2162 (  185 592 ) resistor r=3.1 //w=0.17 //l=0.51 //layer=mcon //count=3 \
 //x=73.38 //y=0.18 //x2=73.38 //y2=0.18
r2163 (  183 581 ) resistor r=3.1 //w=0.17 //l=0.51 //layer=mcon //count=3 \
 //x=71.9 //y=0.18 //x2=71.9 //y2=0.18
r2164 (  183 185 ) resistor r=0.594855 //w=0.311 //l=1.48 //layer=m1 \
 //thickness=0.36 //x=71.9 //y=0.175 //x2=73.38 //y2=0.175
r2165 (  181 579 ) resistor r=3.1 //w=0.17 //l=0.51 //layer=mcon //count=3 \
 //x=70.79 //y=0.18 //x2=70.79 //y2=0.18
r2166 (  181 183 ) resistor r=0.446141 //w=0.311 //l=1.11 //layer=m1 \
 //thickness=0.36 //x=70.79 //y=0.175 //x2=71.9 //y2=0.175
r2167 (  179 577 ) resistor r=3.1 //w=0.17 //l=0.51 //layer=mcon //count=3 \
 //x=69.68 //y=0.18 //x2=69.68 //y2=0.18
r2168 (  179 181 ) resistor r=0.446141 //w=0.311 //l=1.11 //layer=m1 \
 //thickness=0.36 //x=69.68 //y=0.175 //x2=70.79 //y2=0.175
r2169 (  177 309 ) resistor r=0.028033 //w=0.35 //l=0.085 //layer=m1 \
 //thickness=0.36 //x=68.99 //y=0.175 //x2=68.905 //y2=0.175
r2170 (  177 179 ) resistor r=0.277331 //w=0.311 //l=0.69 //layer=m1 \
 //thickness=0.36 //x=68.99 //y=0.175 //x2=69.68 //y2=0.175
r2171 (  176 313 ) resistor r=0.028033 //w=0.35 //l=0.085 //layer=m1 \
 //thickness=0.36 //x=73.63 //y=0.175 //x2=73.715 //y2=0.175
r2172 (  176 185 ) resistor r=0.100482 //w=0.311 //l=0.25 //layer=m1 \
 //thickness=0.36 //x=73.63 //y=0.175 //x2=73.38 //y2=0.175
r2173 (  175 307 ) resistor r=0.0942778 //w=0.221 //l=0.13 //layer=m1 \
 //thickness=0.36 //x=68.905 //y=1.015 //x2=68.905 //y2=1.145
r2174 (  174 309 ) resistor r=0.0413265 //w=0.7 //l=0.175 //layer=m1 \
 //thickness=0.36 //x=68.905 //y=0.35 //x2=68.905 //y2=0.175
r2175 (  174 175 ) resistor r=0.634542 //w=0.131 //l=0.665 //layer=m1 \
 //thickness=0.36 //x=68.905 //y=0.35 //x2=68.905 //y2=1.015
r2176 (  173 575 ) resistor r=3.1 //w=0.17 //l=0.51 //layer=mcon //count=3 \
 //x=68.57 //y=0.18 //x2=68.57 //y2=0.18
r2177 (  171 564 ) resistor r=3.1 //w=0.17 //l=0.51 //layer=mcon //count=3 \
 //x=67.09 //y=0.18 //x2=67.09 //y2=0.18
r2178 (  171 173 ) resistor r=0.594855 //w=0.311 //l=1.48 //layer=m1 \
 //thickness=0.36 //x=67.09 //y=0.175 //x2=68.57 //y2=0.175
r2179 (  169 562 ) resistor r=3.1 //w=0.17 //l=0.51 //layer=mcon //count=3 \
 //x=65.98 //y=0.18 //x2=65.98 //y2=0.18
r2180 (  169 171 ) resistor r=0.446141 //w=0.311 //l=1.11 //layer=m1 \
 //thickness=0.36 //x=65.98 //y=0.175 //x2=67.09 //y2=0.175
r2181 (  167 560 ) resistor r=3.1 //w=0.17 //l=0.51 //layer=mcon //count=3 \
 //x=64.87 //y=0.18 //x2=64.87 //y2=0.18
r2182 (  167 169 ) resistor r=0.446141 //w=0.311 //l=1.11 //layer=m1 \
 //thickness=0.36 //x=64.87 //y=0.175 //x2=65.98 //y2=0.175
r2183 (  165 305 ) resistor r=0.028033 //w=0.35 //l=0.085 //layer=m1 \
 //thickness=0.36 //x=64.18 //y=0.175 //x2=64.095 //y2=0.175
r2184 (  165 167 ) resistor r=0.277331 //w=0.311 //l=0.69 //layer=m1 \
 //thickness=0.36 //x=64.18 //y=0.175 //x2=64.87 //y2=0.175
r2185 (  164 309 ) resistor r=0.028033 //w=0.35 //l=0.085 //layer=m1 \
 //thickness=0.36 //x=68.82 //y=0.175 //x2=68.905 //y2=0.175
r2186 (  164 173 ) resistor r=0.100482 //w=0.311 //l=0.25 //layer=m1 \
 //thickness=0.36 //x=68.82 //y=0.175 //x2=68.57 //y2=0.175
r2187 (  163 303 ) resistor r=0.0942778 //w=0.221 //l=0.13 //layer=m1 \
 //thickness=0.36 //x=64.095 //y=1.015 //x2=64.095 //y2=1.145
r2188 (  162 305 ) resistor r=0.0413265 //w=0.7 //l=0.175 //layer=m1 \
 //thickness=0.36 //x=64.095 //y=0.35 //x2=64.095 //y2=0.175
r2189 (  162 163 ) resistor r=0.634542 //w=0.131 //l=0.665 //layer=m1 \
 //thickness=0.36 //x=64.095 //y=0.35 //x2=64.095 //y2=1.015
r2190 (  161 558 ) resistor r=3.1 //w=0.17 //l=0.51 //layer=mcon //count=3 \
 //x=63.76 //y=0.18 //x2=63.76 //y2=0.18
r2191 (  159 547 ) resistor r=3.1 //w=0.17 //l=0.51 //layer=mcon //count=3 \
 //x=62.28 //y=0.18 //x2=62.28 //y2=0.18
r2192 (  159 161 ) resistor r=0.594855 //w=0.311 //l=1.48 //layer=m1 \
 //thickness=0.36 //x=62.28 //y=0.175 //x2=63.76 //y2=0.175
r2193 (  157 545 ) resistor r=3.1 //w=0.17 //l=0.51 //layer=mcon //count=3 \
 //x=61.17 //y=0.18 //x2=61.17 //y2=0.18
r2194 (  157 159 ) resistor r=0.446141 //w=0.311 //l=1.11 //layer=m1 \
 //thickness=0.36 //x=61.17 //y=0.175 //x2=62.28 //y2=0.175
r2195 (  155 543 ) resistor r=3.1 //w=0.17 //l=0.51 //layer=mcon //count=3 \
 //x=60.06 //y=0.18 //x2=60.06 //y2=0.18
r2196 (  155 157 ) resistor r=0.446141 //w=0.311 //l=1.11 //layer=m1 \
 //thickness=0.36 //x=60.06 //y=0.175 //x2=61.17 //y2=0.175
r2197 (  153 301 ) resistor r=0.028033 //w=0.35 //l=0.085 //layer=m1 \
 //thickness=0.36 //x=59.37 //y=0.175 //x2=59.285 //y2=0.175
r2198 (  153 155 ) resistor r=0.277331 //w=0.311 //l=0.69 //layer=m1 \
 //thickness=0.36 //x=59.37 //y=0.175 //x2=60.06 //y2=0.175
r2199 (  152 305 ) resistor r=0.028033 //w=0.35 //l=0.085 //layer=m1 \
 //thickness=0.36 //x=64.01 //y=0.175 //x2=64.095 //y2=0.175
r2200 (  152 161 ) resistor r=0.100482 //w=0.311 //l=0.25 //layer=m1 \
 //thickness=0.36 //x=64.01 //y=0.175 //x2=63.76 //y2=0.175
r2201 (  151 299 ) resistor r=0.0942778 //w=0.221 //l=0.13 //layer=m1 \
 //thickness=0.36 //x=59.285 //y=1.015 //x2=59.285 //y2=1.145
r2202 (  150 301 ) resistor r=0.0413265 //w=0.7 //l=0.175 //layer=m1 \
 //thickness=0.36 //x=59.285 //y=0.35 //x2=59.285 //y2=0.175
r2203 (  150 151 ) resistor r=0.634542 //w=0.131 //l=0.665 //layer=m1 \
 //thickness=0.36 //x=59.285 //y=0.35 //x2=59.285 //y2=1.015
r2204 (  149 541 ) resistor r=3.1 //w=0.17 //l=0.51 //layer=mcon //count=3 \
 //x=58.95 //y=0.18 //x2=58.95 //y2=0.18
r2205 (  147 530 ) resistor r=3.1 //w=0.17 //l=0.51 //layer=mcon //count=3 \
 //x=57.47 //y=0.18 //x2=57.47 //y2=0.18
r2206 (  147 149 ) resistor r=0.594855 //w=0.311 //l=1.48 //layer=m1 \
 //thickness=0.36 //x=57.47 //y=0.175 //x2=58.95 //y2=0.175
r2207 (  145 528 ) resistor r=3.1 //w=0.17 //l=0.51 //layer=mcon //count=3 \
 //x=56.36 //y=0.18 //x2=56.36 //y2=0.18
r2208 (  145 147 ) resistor r=0.446141 //w=0.311 //l=1.11 //layer=m1 \
 //thickness=0.36 //x=56.36 //y=0.175 //x2=57.47 //y2=0.175
r2209 (  143 526 ) resistor r=3.1 //w=0.17 //l=0.51 //layer=mcon //count=3 \
 //x=55.25 //y=0.18 //x2=55.25 //y2=0.18
r2210 (  143 145 ) resistor r=0.446141 //w=0.311 //l=1.11 //layer=m1 \
 //thickness=0.36 //x=55.25 //y=0.175 //x2=56.36 //y2=0.175
r2211 (  141 297 ) resistor r=0.028033 //w=0.35 //l=0.085 //layer=m1 \
 //thickness=0.36 //x=54.56 //y=0.175 //x2=54.475 //y2=0.175
r2212 (  141 143 ) resistor r=0.277331 //w=0.311 //l=0.69 //layer=m1 \
 //thickness=0.36 //x=54.56 //y=0.175 //x2=55.25 //y2=0.175
r2213 (  140 301 ) resistor r=0.028033 //w=0.35 //l=0.085 //layer=m1 \
 //thickness=0.36 //x=59.2 //y=0.175 //x2=59.285 //y2=0.175
r2214 (  140 149 ) resistor r=0.100482 //w=0.311 //l=0.25 //layer=m1 \
 //thickness=0.36 //x=59.2 //y=0.175 //x2=58.95 //y2=0.175
r2215 (  139 295 ) resistor r=0.0942778 //w=0.221 //l=0.13 //layer=m1 \
 //thickness=0.36 //x=54.475 //y=1.015 //x2=54.475 //y2=1.145
r2216 (  138 297 ) resistor r=0.0413265 //w=0.7 //l=0.175 //layer=m1 \
 //thickness=0.36 //x=54.475 //y=0.35 //x2=54.475 //y2=0.175
r2217 (  138 139 ) resistor r=0.634542 //w=0.131 //l=0.665 //layer=m1 \
 //thickness=0.36 //x=54.475 //y=0.35 //x2=54.475 //y2=1.015
r2218 (  137 524 ) resistor r=3.1 //w=0.17 //l=0.51 //layer=mcon //count=3 \
 //x=54.14 //y=0.18 //x2=54.14 //y2=0.18
r2219 (  135 513 ) resistor r=3.1 //w=0.17 //l=0.51 //layer=mcon //count=3 \
 //x=52.66 //y=0.18 //x2=52.66 //y2=0.18
r2220 (  135 137 ) resistor r=0.594855 //w=0.311 //l=1.48 //layer=m1 \
 //thickness=0.36 //x=52.66 //y=0.175 //x2=54.14 //y2=0.175
r2221 (  133 511 ) resistor r=3.1 //w=0.17 //l=0.51 //layer=mcon //count=3 \
 //x=51.55 //y=0.18 //x2=51.55 //y2=0.18
r2222 (  133 135 ) resistor r=0.446141 //w=0.311 //l=1.11 //layer=m1 \
 //thickness=0.36 //x=51.55 //y=0.175 //x2=52.66 //y2=0.175
r2223 (  131 509 ) resistor r=3.1 //w=0.17 //l=0.51 //layer=mcon //count=3 \
 //x=50.44 //y=0.18 //x2=50.44 //y2=0.18
r2224 (  131 133 ) resistor r=0.446141 //w=0.311 //l=1.11 //layer=m1 \
 //thickness=0.36 //x=50.44 //y=0.175 //x2=51.55 //y2=0.175
r2225 (  128 293 ) resistor r=0.028033 //w=0.35 //l=0.085 //layer=m1 \
 //thickness=0.36 //x=49.75 //y=0.175 //x2=49.665 //y2=0.175
r2226 (  127 297 ) resistor r=0.028033 //w=0.35 //l=0.085 //layer=m1 \
 //thickness=0.36 //x=54.39 //y=0.175 //x2=54.475 //y2=0.175
r2227 (  127 137 ) resistor r=0.100482 //w=0.311 //l=0.25 //layer=m1 \
 //thickness=0.36 //x=54.39 //y=0.175 //x2=54.14 //y2=0.175
r2228 (  126 291 ) resistor r=0.0942778 //w=0.221 //l=0.13 //layer=m1 \
 //thickness=0.36 //x=49.665 //y=1.015 //x2=49.665 //y2=1.145
r2229 (  125 293 ) resistor r=0.0413265 //w=0.7 //l=0.175 //layer=m1 \
 //thickness=0.36 //x=49.665 //y=0.35 //x2=49.665 //y2=0.175
r2230 (  125 126 ) resistor r=0.634542 //w=0.131 //l=0.665 //layer=m1 \
 //thickness=0.36 //x=49.665 //y=0.35 //x2=49.665 //y2=1.015
r2231 (  124 507 ) resistor r=3.1 //w=0.17 //l=0.51 //layer=mcon //count=3 \
 //x=49.33 //y=0.18 //x2=49.33 //y2=0.18
r2232 (  122 496 ) resistor r=3.1 //w=0.17 //l=0.51 //layer=mcon //count=3 \
 //x=47.85 //y=0.18 //x2=47.85 //y2=0.18
r2233 (  122 124 ) resistor r=0.594855 //w=0.311 //l=1.48 //layer=m1 \
 //thickness=0.36 //x=47.85 //y=0.175 //x2=49.33 //y2=0.175
r2234 (  120 494 ) resistor r=3.1 //w=0.17 //l=0.51 //layer=mcon //count=3 \
 //x=46.74 //y=0.18 //x2=46.74 //y2=0.18
r2235 (  120 122 ) resistor r=0.446141 //w=0.311 //l=1.11 //layer=m1 \
 //thickness=0.36 //x=46.74 //y=0.175 //x2=47.85 //y2=0.175
r2236 (  118 492 ) resistor r=3.1 //w=0.17 //l=0.51 //layer=mcon //count=3 \
 //x=45.63 //y=0.18 //x2=45.63 //y2=0.18
r2237 (  118 120 ) resistor r=0.446141 //w=0.311 //l=1.11 //layer=m1 \
 //thickness=0.36 //x=45.63 //y=0.175 //x2=46.74 //y2=0.175
r2238 (  116 289 ) resistor r=0.028033 //w=0.35 //l=0.085 //layer=m1 \
 //thickness=0.36 //x=44.94 //y=0.175 //x2=44.855 //y2=0.175
r2239 (  116 118 ) resistor r=0.277331 //w=0.311 //l=0.69 //layer=m1 \
 //thickness=0.36 //x=44.94 //y=0.175 //x2=45.63 //y2=0.175
r2240 (  115 293 ) resistor r=0.028033 //w=0.35 //l=0.085 //layer=m1 \
 //thickness=0.36 //x=49.58 //y=0.175 //x2=49.665 //y2=0.175
r2241 (  115 124 ) resistor r=0.100482 //w=0.311 //l=0.25 //layer=m1 \
 //thickness=0.36 //x=49.58 //y=0.175 //x2=49.33 //y2=0.175
r2242 (  114 287 ) resistor r=0.0942778 //w=0.221 //l=0.13 //layer=m1 \
 //thickness=0.36 //x=44.855 //y=1.015 //x2=44.855 //y2=1.145
r2243 (  113 289 ) resistor r=0.0413265 //w=0.7 //l=0.175 //layer=m1 \
 //thickness=0.36 //x=44.855 //y=0.35 //x2=44.855 //y2=0.175
r2244 (  113 114 ) resistor r=0.634542 //w=0.131 //l=0.665 //layer=m1 \
 //thickness=0.36 //x=44.855 //y=0.35 //x2=44.855 //y2=1.015
r2245 (  112 490 ) resistor r=3.1 //w=0.17 //l=0.51 //layer=mcon //count=3 \
 //x=44.52 //y=0.18 //x2=44.52 //y2=0.18
r2246 (  110 479 ) resistor r=3.1 //w=0.17 //l=0.51 //layer=mcon //count=3 \
 //x=43.04 //y=0.18 //x2=43.04 //y2=0.18
r2247 (  110 112 ) resistor r=0.594855 //w=0.311 //l=1.48 //layer=m1 \
 //thickness=0.36 //x=43.04 //y=0.175 //x2=44.52 //y2=0.175
r2248 (  108 477 ) resistor r=3.1 //w=0.17 //l=0.51 //layer=mcon //count=3 \
 //x=41.93 //y=0.18 //x2=41.93 //y2=0.18
r2249 (  108 110 ) resistor r=0.446141 //w=0.311 //l=1.11 //layer=m1 \
 //thickness=0.36 //x=41.93 //y=0.175 //x2=43.04 //y2=0.175
r2250 (  106 475 ) resistor r=3.1 //w=0.17 //l=0.51 //layer=mcon //count=3 \
 //x=40.82 //y=0.18 //x2=40.82 //y2=0.18
r2251 (  106 108 ) resistor r=0.446141 //w=0.311 //l=1.11 //layer=m1 \
 //thickness=0.36 //x=40.82 //y=0.175 //x2=41.93 //y2=0.175
r2252 (  104 285 ) resistor r=0.028033 //w=0.35 //l=0.085 //layer=m1 \
 //thickness=0.36 //x=40.13 //y=0.175 //x2=40.045 //y2=0.175
r2253 (  104 106 ) resistor r=0.277331 //w=0.311 //l=0.69 //layer=m1 \
 //thickness=0.36 //x=40.13 //y=0.175 //x2=40.82 //y2=0.175
r2254 (  103 289 ) resistor r=0.028033 //w=0.35 //l=0.085 //layer=m1 \
 //thickness=0.36 //x=44.77 //y=0.175 //x2=44.855 //y2=0.175
r2255 (  103 112 ) resistor r=0.100482 //w=0.311 //l=0.25 //layer=m1 \
 //thickness=0.36 //x=44.77 //y=0.175 //x2=44.52 //y2=0.175
r2256 (  102 283 ) resistor r=0.0942778 //w=0.221 //l=0.13 //layer=m1 \
 //thickness=0.36 //x=40.045 //y=1.015 //x2=40.045 //y2=1.145
r2257 (  101 285 ) resistor r=0.0413265 //w=0.7 //l=0.175 //layer=m1 \
 //thickness=0.36 //x=40.045 //y=0.35 //x2=40.045 //y2=0.175
r2258 (  101 102 ) resistor r=0.634542 //w=0.131 //l=0.665 //layer=m1 \
 //thickness=0.36 //x=40.045 //y=0.35 //x2=40.045 //y2=1.015
r2259 (  100 473 ) resistor r=3.1 //w=0.17 //l=0.51 //layer=mcon //count=3 \
 //x=39.71 //y=0.18 //x2=39.71 //y2=0.18
r2260 (  98 462 ) resistor r=3.1 //w=0.17 //l=0.51 //layer=mcon //count=3 \
 //x=38.23 //y=0.18 //x2=38.23 //y2=0.18
r2261 (  98 100 ) resistor r=0.594855 //w=0.311 //l=1.48 //layer=m1 \
 //thickness=0.36 //x=38.23 //y=0.175 //x2=39.71 //y2=0.175
r2262 (  96 460 ) resistor r=3.1 //w=0.17 //l=0.51 //layer=mcon //count=3 \
 //x=37.12 //y=0.18 //x2=37.12 //y2=0.18
r2263 (  96 98 ) resistor r=0.446141 //w=0.311 //l=1.11 //layer=m1 \
 //thickness=0.36 //x=37.12 //y=0.175 //x2=38.23 //y2=0.175
r2264 (  94 458 ) resistor r=3.1 //w=0.17 //l=0.51 //layer=mcon //count=3 \
 //x=36.01 //y=0.18 //x2=36.01 //y2=0.18
r2265 (  94 96 ) resistor r=0.446141 //w=0.311 //l=1.11 //layer=m1 \
 //thickness=0.36 //x=36.01 //y=0.175 //x2=37.12 //y2=0.175
r2266 (  92 281 ) resistor r=0.028033 //w=0.35 //l=0.085 //layer=m1 \
 //thickness=0.36 //x=35.32 //y=0.175 //x2=35.235 //y2=0.175
r2267 (  92 94 ) resistor r=0.277331 //w=0.311 //l=0.69 //layer=m1 \
 //thickness=0.36 //x=35.32 //y=0.175 //x2=36.01 //y2=0.175
r2268 (  91 285 ) resistor r=0.028033 //w=0.35 //l=0.085 //layer=m1 \
 //thickness=0.36 //x=39.96 //y=0.175 //x2=40.045 //y2=0.175
r2269 (  91 100 ) resistor r=0.100482 //w=0.311 //l=0.25 //layer=m1 \
 //thickness=0.36 //x=39.96 //y=0.175 //x2=39.71 //y2=0.175
r2270 (  90 279 ) resistor r=0.0942778 //w=0.221 //l=0.13 //layer=m1 \
 //thickness=0.36 //x=35.235 //y=1.015 //x2=35.235 //y2=1.145
r2271 (  89 281 ) resistor r=0.0413265 //w=0.7 //l=0.175 //layer=m1 \
 //thickness=0.36 //x=35.235 //y=0.35 //x2=35.235 //y2=0.175
r2272 (  89 90 ) resistor r=0.634542 //w=0.131 //l=0.665 //layer=m1 \
 //thickness=0.36 //x=35.235 //y=0.35 //x2=35.235 //y2=1.015
r2273 (  88 456 ) resistor r=3.1 //w=0.17 //l=0.51 //layer=mcon //count=3 \
 //x=34.9 //y=0.18 //x2=34.9 //y2=0.18
r2274 (  86 445 ) resistor r=3.1 //w=0.17 //l=0.51 //layer=mcon //count=3 \
 //x=33.42 //y=0.18 //x2=33.42 //y2=0.18
r2275 (  86 88 ) resistor r=0.594855 //w=0.311 //l=1.48 //layer=m1 \
 //thickness=0.36 //x=33.42 //y=0.175 //x2=34.9 //y2=0.175
r2276 (  84 443 ) resistor r=3.1 //w=0.17 //l=0.51 //layer=mcon //count=3 \
 //x=32.31 //y=0.18 //x2=32.31 //y2=0.18
r2277 (  84 86 ) resistor r=0.446141 //w=0.311 //l=1.11 //layer=m1 \
 //thickness=0.36 //x=32.31 //y=0.175 //x2=33.42 //y2=0.175
r2278 (  82 441 ) resistor r=3.1 //w=0.17 //l=0.51 //layer=mcon //count=3 \
 //x=31.2 //y=0.18 //x2=31.2 //y2=0.18
r2279 (  82 84 ) resistor r=0.446141 //w=0.311 //l=1.11 //layer=m1 \
 //thickness=0.36 //x=31.2 //y=0.175 //x2=32.31 //y2=0.175
r2280 (  80 277 ) resistor r=0.028033 //w=0.35 //l=0.085 //layer=m1 \
 //thickness=0.36 //x=30.51 //y=0.175 //x2=30.425 //y2=0.175
r2281 (  80 82 ) resistor r=0.277331 //w=0.311 //l=0.69 //layer=m1 \
 //thickness=0.36 //x=30.51 //y=0.175 //x2=31.2 //y2=0.175
r2282 (  79 281 ) resistor r=0.028033 //w=0.35 //l=0.085 //layer=m1 \
 //thickness=0.36 //x=35.15 //y=0.175 //x2=35.235 //y2=0.175
r2283 (  79 88 ) resistor r=0.100482 //w=0.311 //l=0.25 //layer=m1 \
 //thickness=0.36 //x=35.15 //y=0.175 //x2=34.9 //y2=0.175
r2284 (  78 275 ) resistor r=0.0942778 //w=0.221 //l=0.13 //layer=m1 \
 //thickness=0.36 //x=30.425 //y=1.015 //x2=30.425 //y2=1.145
r2285 (  77 277 ) resistor r=0.0413265 //w=0.7 //l=0.175 //layer=m1 \
 //thickness=0.36 //x=30.425 //y=0.35 //x2=30.425 //y2=0.175
r2286 (  77 78 ) resistor r=0.634542 //w=0.131 //l=0.665 //layer=m1 \
 //thickness=0.36 //x=30.425 //y=0.35 //x2=30.425 //y2=1.015
r2287 (  76 439 ) resistor r=3.1 //w=0.17 //l=0.51 //layer=mcon //count=3 \
 //x=30.09 //y=0.18 //x2=30.09 //y2=0.18
r2288 (  74 428 ) resistor r=3.1 //w=0.17 //l=0.51 //layer=mcon //count=3 \
 //x=28.61 //y=0.18 //x2=28.61 //y2=0.18
r2289 (  74 76 ) resistor r=0.594855 //w=0.311 //l=1.48 //layer=m1 \
 //thickness=0.36 //x=28.61 //y=0.175 //x2=30.09 //y2=0.175
r2290 (  72 426 ) resistor r=3.1 //w=0.17 //l=0.51 //layer=mcon //count=3 \
 //x=27.5 //y=0.18 //x2=27.5 //y2=0.18
r2291 (  72 74 ) resistor r=0.446141 //w=0.311 //l=1.11 //layer=m1 \
 //thickness=0.36 //x=27.5 //y=0.175 //x2=28.61 //y2=0.175
r2292 (  70 424 ) resistor r=3.1 //w=0.17 //l=0.51 //layer=mcon //count=3 \
 //x=26.39 //y=0.18 //x2=26.39 //y2=0.18
r2293 (  70 72 ) resistor r=0.446141 //w=0.311 //l=1.11 //layer=m1 \
 //thickness=0.36 //x=26.39 //y=0.175 //x2=27.5 //y2=0.175
r2294 (  68 273 ) resistor r=0.028033 //w=0.35 //l=0.085 //layer=m1 \
 //thickness=0.36 //x=25.7 //y=0.175 //x2=25.615 //y2=0.175
r2295 (  68 70 ) resistor r=0.277331 //w=0.311 //l=0.69 //layer=m1 \
 //thickness=0.36 //x=25.7 //y=0.175 //x2=26.39 //y2=0.175
r2296 (  67 277 ) resistor r=0.028033 //w=0.35 //l=0.085 //layer=m1 \
 //thickness=0.36 //x=30.34 //y=0.175 //x2=30.425 //y2=0.175
r2297 (  67 76 ) resistor r=0.100482 //w=0.311 //l=0.25 //layer=m1 \
 //thickness=0.36 //x=30.34 //y=0.175 //x2=30.09 //y2=0.175
r2298 (  66 271 ) resistor r=0.0942778 //w=0.221 //l=0.13 //layer=m1 \
 //thickness=0.36 //x=25.615 //y=1.015 //x2=25.615 //y2=1.145
r2299 (  65 273 ) resistor r=0.0413265 //w=0.7 //l=0.175 //layer=m1 \
 //thickness=0.36 //x=25.615 //y=0.35 //x2=25.615 //y2=0.175
r2300 (  65 66 ) resistor r=0.634542 //w=0.131 //l=0.665 //layer=m1 \
 //thickness=0.36 //x=25.615 //y=0.35 //x2=25.615 //y2=1.015
r2301 (  64 422 ) resistor r=3.1 //w=0.17 //l=0.51 //layer=mcon //count=3 \
 //x=25.28 //y=0.18 //x2=25.28 //y2=0.18
r2302 (  62 411 ) resistor r=3.1 //w=0.17 //l=0.51 //layer=mcon //count=3 \
 //x=23.8 //y=0.18 //x2=23.8 //y2=0.18
r2303 (  62 64 ) resistor r=0.594855 //w=0.311 //l=1.48 //layer=m1 \
 //thickness=0.36 //x=23.8 //y=0.175 //x2=25.28 //y2=0.175
r2304 (  60 409 ) resistor r=3.1 //w=0.17 //l=0.51 //layer=mcon //count=3 \
 //x=22.69 //y=0.18 //x2=22.69 //y2=0.18
r2305 (  60 62 ) resistor r=0.446141 //w=0.311 //l=1.11 //layer=m1 \
 //thickness=0.36 //x=22.69 //y=0.175 //x2=23.8 //y2=0.175
r2306 (  58 407 ) resistor r=3.1 //w=0.17 //l=0.51 //layer=mcon //count=3 \
 //x=21.58 //y=0.18 //x2=21.58 //y2=0.18
r2307 (  58 60 ) resistor r=0.446141 //w=0.311 //l=1.11 //layer=m1 \
 //thickness=0.36 //x=21.58 //y=0.175 //x2=22.69 //y2=0.175
r2308 (  56 269 ) resistor r=0.028033 //w=0.35 //l=0.085 //layer=m1 \
 //thickness=0.36 //x=20.89 //y=0.175 //x2=20.805 //y2=0.175
r2309 (  56 58 ) resistor r=0.277331 //w=0.311 //l=0.69 //layer=m1 \
 //thickness=0.36 //x=20.89 //y=0.175 //x2=21.58 //y2=0.175
r2310 (  55 273 ) resistor r=0.028033 //w=0.35 //l=0.085 //layer=m1 \
 //thickness=0.36 //x=25.53 //y=0.175 //x2=25.615 //y2=0.175
r2311 (  55 64 ) resistor r=0.100482 //w=0.311 //l=0.25 //layer=m1 \
 //thickness=0.36 //x=25.53 //y=0.175 //x2=25.28 //y2=0.175
r2312 (  54 267 ) resistor r=0.0942778 //w=0.221 //l=0.13 //layer=m1 \
 //thickness=0.36 //x=20.805 //y=1.015 //x2=20.805 //y2=1.145
r2313 (  53 269 ) resistor r=0.0413265 //w=0.7 //l=0.175 //layer=m1 \
 //thickness=0.36 //x=20.805 //y=0.35 //x2=20.805 //y2=0.175
r2314 (  53 54 ) resistor r=0.634542 //w=0.131 //l=0.665 //layer=m1 \
 //thickness=0.36 //x=20.805 //y=0.35 //x2=20.805 //y2=1.015
r2315 (  52 405 ) resistor r=3.1 //w=0.17 //l=0.51 //layer=mcon //count=3 \
 //x=20.47 //y=0.18 //x2=20.47 //y2=0.18
r2316 (  50 394 ) resistor r=3.1 //w=0.17 //l=0.51 //layer=mcon //count=3 \
 //x=18.99 //y=0.18 //x2=18.99 //y2=0.18
r2317 (  50 52 ) resistor r=0.594855 //w=0.311 //l=1.48 //layer=m1 \
 //thickness=0.36 //x=18.99 //y=0.175 //x2=20.47 //y2=0.175
r2318 (  48 392 ) resistor r=3.1 //w=0.17 //l=0.51 //layer=mcon //count=3 \
 //x=17.88 //y=0.18 //x2=17.88 //y2=0.18
r2319 (  48 50 ) resistor r=0.446141 //w=0.311 //l=1.11 //layer=m1 \
 //thickness=0.36 //x=17.88 //y=0.175 //x2=18.99 //y2=0.175
r2320 (  46 390 ) resistor r=3.1 //w=0.17 //l=0.51 //layer=mcon //count=3 \
 //x=16.77 //y=0.18 //x2=16.77 //y2=0.18
r2321 (  46 48 ) resistor r=0.446141 //w=0.311 //l=1.11 //layer=m1 \
 //thickness=0.36 //x=16.77 //y=0.175 //x2=17.88 //y2=0.175
r2322 (  44 265 ) resistor r=0.028033 //w=0.35 //l=0.085 //layer=m1 \
 //thickness=0.36 //x=16.08 //y=0.175 //x2=15.995 //y2=0.175
r2323 (  44 46 ) resistor r=0.277331 //w=0.311 //l=0.69 //layer=m1 \
 //thickness=0.36 //x=16.08 //y=0.175 //x2=16.77 //y2=0.175
r2324 (  43 269 ) resistor r=0.028033 //w=0.35 //l=0.085 //layer=m1 \
 //thickness=0.36 //x=20.72 //y=0.175 //x2=20.805 //y2=0.175
r2325 (  43 52 ) resistor r=0.100482 //w=0.311 //l=0.25 //layer=m1 \
 //thickness=0.36 //x=20.72 //y=0.175 //x2=20.47 //y2=0.175
r2326 (  42 263 ) resistor r=0.0942778 //w=0.221 //l=0.13 //layer=m1 \
 //thickness=0.36 //x=15.995 //y=1.015 //x2=15.995 //y2=1.145
r2327 (  41 265 ) resistor r=0.0413265 //w=0.7 //l=0.175 //layer=m1 \
 //thickness=0.36 //x=15.995 //y=0.35 //x2=15.995 //y2=0.175
r2328 (  41 42 ) resistor r=0.634542 //w=0.131 //l=0.665 //layer=m1 \
 //thickness=0.36 //x=15.995 //y=0.35 //x2=15.995 //y2=1.015
r2329 (  40 388 ) resistor r=3.1 //w=0.17 //l=0.51 //layer=mcon //count=3 \
 //x=15.66 //y=0.18 //x2=15.66 //y2=0.18
r2330 (  38 377 ) resistor r=3.1 //w=0.17 //l=0.51 //layer=mcon //count=3 \
 //x=14.18 //y=0.18 //x2=14.18 //y2=0.18
r2331 (  38 40 ) resistor r=0.594855 //w=0.311 //l=1.48 //layer=m1 \
 //thickness=0.36 //x=14.18 //y=0.175 //x2=15.66 //y2=0.175
r2332 (  36 375 ) resistor r=3.1 //w=0.17 //l=0.51 //layer=mcon //count=3 \
 //x=13.07 //y=0.18 //x2=13.07 //y2=0.18
r2333 (  36 38 ) resistor r=0.446141 //w=0.311 //l=1.11 //layer=m1 \
 //thickness=0.36 //x=13.07 //y=0.175 //x2=14.18 //y2=0.175
r2334 (  34 373 ) resistor r=3.1 //w=0.17 //l=0.51 //layer=mcon //count=3 \
 //x=11.96 //y=0.18 //x2=11.96 //y2=0.18
r2335 (  34 36 ) resistor r=0.446141 //w=0.311 //l=1.11 //layer=m1 \
 //thickness=0.36 //x=11.96 //y=0.175 //x2=13.07 //y2=0.175
r2336 (  32 261 ) resistor r=0.028033 //w=0.35 //l=0.085 //layer=m1 \
 //thickness=0.36 //x=11.27 //y=0.175 //x2=11.185 //y2=0.175
r2337 (  32 34 ) resistor r=0.277331 //w=0.311 //l=0.69 //layer=m1 \
 //thickness=0.36 //x=11.27 //y=0.175 //x2=11.96 //y2=0.175
r2338 (  31 265 ) resistor r=0.028033 //w=0.35 //l=0.085 //layer=m1 \
 //thickness=0.36 //x=15.91 //y=0.175 //x2=15.995 //y2=0.175
r2339 (  31 40 ) resistor r=0.100482 //w=0.311 //l=0.25 //layer=m1 \
 //thickness=0.36 //x=15.91 //y=0.175 //x2=15.66 //y2=0.175
r2340 (  30 259 ) resistor r=0.0942778 //w=0.221 //l=0.13 //layer=m1 \
 //thickness=0.36 //x=11.185 //y=1.015 //x2=11.185 //y2=1.145
r2341 (  29 261 ) resistor r=0.0413265 //w=0.7 //l=0.175 //layer=m1 \
 //thickness=0.36 //x=11.185 //y=0.35 //x2=11.185 //y2=0.175
r2342 (  29 30 ) resistor r=0.634542 //w=0.131 //l=0.665 //layer=m1 \
 //thickness=0.36 //x=11.185 //y=0.35 //x2=11.185 //y2=1.015
r2343 (  28 371 ) resistor r=3.1 //w=0.17 //l=0.51 //layer=mcon //count=3 \
 //x=10.85 //y=0.18 //x2=10.85 //y2=0.18
r2344 (  26 360 ) resistor r=3.1 //w=0.17 //l=0.51 //layer=mcon //count=3 \
 //x=9.37 //y=0.18 //x2=9.37 //y2=0.18
r2345 (  26 28 ) resistor r=0.594855 //w=0.311 //l=1.48 //layer=m1 \
 //thickness=0.36 //x=9.37 //y=0.175 //x2=10.85 //y2=0.175
r2346 (  24 358 ) resistor r=3.1 //w=0.17 //l=0.51 //layer=mcon //count=3 \
 //x=8.26 //y=0.18 //x2=8.26 //y2=0.18
r2347 (  24 26 ) resistor r=0.446141 //w=0.311 //l=1.11 //layer=m1 \
 //thickness=0.36 //x=8.26 //y=0.175 //x2=9.37 //y2=0.175
r2348 (  22 356 ) resistor r=3.1 //w=0.17 //l=0.51 //layer=mcon //count=3 \
 //x=7.15 //y=0.18 //x2=7.15 //y2=0.18
r2349 (  22 24 ) resistor r=0.446141 //w=0.311 //l=1.11 //layer=m1 \
 //thickness=0.36 //x=7.15 //y=0.175 //x2=8.26 //y2=0.175
r2350 (  20 257 ) resistor r=0.028033 //w=0.35 //l=0.085 //layer=m1 \
 //thickness=0.36 //x=6.46 //y=0.175 //x2=6.375 //y2=0.175
r2351 (  20 22 ) resistor r=0.277331 //w=0.311 //l=0.69 //layer=m1 \
 //thickness=0.36 //x=6.46 //y=0.175 //x2=7.15 //y2=0.175
r2352 (  19 261 ) resistor r=0.028033 //w=0.35 //l=0.085 //layer=m1 \
 //thickness=0.36 //x=11.1 //y=0.175 //x2=11.185 //y2=0.175
r2353 (  19 28 ) resistor r=0.100482 //w=0.311 //l=0.25 //layer=m1 \
 //thickness=0.36 //x=11.1 //y=0.175 //x2=10.85 //y2=0.175
r2354 (  18 255 ) resistor r=0.0942778 //w=0.221 //l=0.13 //layer=m1 \
 //thickness=0.36 //x=6.375 //y=1.015 //x2=6.375 //y2=1.145
r2355 (  17 257 ) resistor r=0.0413265 //w=0.7 //l=0.175 //layer=m1 \
 //thickness=0.36 //x=6.375 //y=0.35 //x2=6.375 //y2=0.175
r2356 (  17 18 ) resistor r=0.634542 //w=0.131 //l=0.665 //layer=m1 \
 //thickness=0.36 //x=6.375 //y=0.35 //x2=6.375 //y2=1.015
r2357 (  16 354 ) resistor r=3.1 //w=0.17 //l=0.51 //layer=mcon //count=3 \
 //x=6.04 //y=0.18 //x2=6.04 //y2=0.18
r2358 (  14 343 ) resistor r=3.1 //w=0.17 //l=0.51 //layer=mcon //count=3 \
 //x=4.56 //y=0.18 //x2=4.56 //y2=0.18
r2359 (  14 16 ) resistor r=0.594855 //w=0.311 //l=1.48 //layer=m1 \
 //thickness=0.36 //x=4.56 //y=0.175 //x2=6.04 //y2=0.175
r2360 (  12 341 ) resistor r=3.1 //w=0.17 //l=0.51 //layer=mcon //count=3 \
 //x=3.45 //y=0.18 //x2=3.45 //y2=0.18
r2361 (  12 14 ) resistor r=0.446141 //w=0.311 //l=1.11 //layer=m1 \
 //thickness=0.36 //x=3.45 //y=0.175 //x2=4.56 //y2=0.175
r2362 (  10 339 ) resistor r=3.1 //w=0.17 //l=0.51 //layer=mcon //count=3 \
 //x=2.34 //y=0.18 //x2=2.34 //y2=0.18
r2363 (  10 12 ) resistor r=0.446141 //w=0.311 //l=1.11 //layer=m1 \
 //thickness=0.36 //x=2.34 //y=0.175 //x2=3.45 //y2=0.175
r2364 (  8 253 ) resistor r=0.028033 //w=0.35 //l=0.085 //layer=m1 \
 //thickness=0.36 //x=1.65 //y=0.175 //x2=1.565 //y2=0.175
r2365 (  8 10 ) resistor r=0.277331 //w=0.311 //l=0.69 //layer=m1 \
 //thickness=0.36 //x=1.65 //y=0.175 //x2=2.34 //y2=0.175
r2366 (  7 257 ) resistor r=0.028033 //w=0.35 //l=0.085 //layer=m1 \
 //thickness=0.36 //x=6.29 //y=0.175 //x2=6.375 //y2=0.175
r2367 (  7 16 ) resistor r=0.100482 //w=0.311 //l=0.25 //layer=m1 \
 //thickness=0.36 //x=6.29 //y=0.175 //x2=6.04 //y2=0.175
r2368 (  6 251 ) resistor r=0.0942778 //w=0.221 //l=0.13 //layer=m1 \
 //thickness=0.36 //x=1.565 //y=1.015 //x2=1.565 //y2=1.145
r2369 (  5 253 ) resistor r=0.0413265 //w=0.7 //l=0.175 //layer=m1 \
 //thickness=0.36 //x=1.565 //y=0.35 //x2=1.565 //y2=0.175
r2370 (  5 6 ) resistor r=0.634542 //w=0.131 //l=0.665 //layer=m1 \
 //thickness=0.36 //x=1.565 //y=0.35 //x2=1.565 //y2=1.015
r2371 (  4 337 ) resistor r=3.1 //w=0.17 //l=0.51 //layer=mcon //count=3 \
 //x=1.23 //y=0.18 //x2=1.23 //y2=0.18
r2372 (  2 253 ) resistor r=0.028033 //w=0.35 //l=0.085 //layer=m1 \
 //thickness=0.36 //x=1.48 //y=0.175 //x2=1.565 //y2=0.175
r2373 (  2 4 ) resistor r=0.0892857 //w=0.35 //l=0.25 //layer=m1 \
 //thickness=0.36 //x=1.48 //y=0.175 //x2=1.23 //y2=0.175
r2374 (  1 131 ) resistor r=0.223071 //w=0.311 //l=0.555 //layer=m1 \
 //thickness=0.36 //x=49.885 //y=0.175 //x2=50.44 //y2=0.175
r2375 (  1 128 ) resistor r=0.0542605 //w=0.311 //l=0.135 //layer=m1 \
 //thickness=0.36 //x=49.885 //y=0.175 //x2=49.75 //y2=0.175
ends PM_TMRDFFSNRNQX1\%GND

subckt PM_TMRDFFSNRNQX1\%noxref_47 ( 1 5 9 13 17 35 )
c55 ( 35 0 ) capacitor c=0.0709164f //x=0.945 //y=0.555
c56 ( 17 0 ) capacitor c=0.0214613f //x=2.935 //y=1.77
c57 ( 13 0 ) capacitor c=0.0153216f //x=2.935 //y=0.72
c58 ( 9 0 ) capacitor c=0.00772076f //x=2.05 //y=0.805
c59 ( 5 0 ) capacitor c=0.0197381f //x=1.965 //y=1.77
c60 ( 1 0 ) capacitor c=0.0109947f //x=1.08 //y=1.685
r61 (  18 35 ) resistor r=5.4201 //w=0.17 //l=0.103078 //layer=li \
 //thickness=0.1 //x=2.135 //y=1.77 //x2=2.05 //y2=1.81
r62 (  18 35 ) resistor r=27.3797 //w=0.187 //l=0.4 //layer=li //thickness=0.1 \
 //x=2.135 //y=1.77 //x2=2.535 //y2=1.77
r63 (  17 35 ) resistor r=0.751729 //w=0.17 //l=0.085 //layer=li \
 //thickness=0.1 //x=2.935 //y=1.77 //x2=3.02 //y2=1.77
r64 (  17 35 ) resistor r=27.3797 //w=0.187 //l=0.4 //layer=li //thickness=0.1 \
 //x=2.935 //y=1.77 //x2=2.535 //y2=1.77
r65 (  14 35 ) resistor r=3.57586 //w=0.17 //l=0.103078 //layer=li \
 //thickness=0.1 //x=2.135 //y=0.72 //x2=2.05 //y2=0.68
r66 (  14 35 ) resistor r=27.3797 //w=0.187 //l=0.4 //layer=li //thickness=0.1 \
 //x=2.135 //y=0.72 //x2=2.535 //y2=0.72
r67 (  13 35 ) resistor r=0.751729 //w=0.17 //l=0.085 //layer=li \
 //thickness=0.1 //x=2.935 //y=0.72 //x2=3.02 //y2=0.72
r68 (  13 35 ) resistor r=27.3797 //w=0.187 //l=0.4 //layer=li //thickness=0.1 \
 //x=2.935 //y=0.72 //x2=2.535 //y2=0.72
r69 (  10 35 ) resistor r=1.40859 //w=0.34 //l=0.125 //layer=li \
 //thickness=0.1 //x=2.05 //y=1.685 //x2=2.05 //y2=1.81
r70 (  10 35 ) resistor r=42.0963 //w=0.187 //l=0.615 //layer=li \
 //thickness=0.1 //x=2.05 //y=1.685 //x2=2.05 //y2=1.07
r71 (  9 35 ) resistor r=3.57586 //w=0.17 //l=0.125 //layer=li //thickness=0.1 \
 //x=2.05 //y=0.805 //x2=2.05 //y2=0.68
r72 (  9 35 ) resistor r=18.139 //w=0.187 //l=0.265 //layer=li //thickness=0.1 \
 //x=2.05 //y=0.805 //x2=2.05 //y2=1.07
r73 (  6 35 ) resistor r=3.57586 //w=0.17 //l=0.103078 //layer=li \
 //thickness=0.1 //x=1.165 //y=1.77 //x2=1.08 //y2=1.81
r74 (  6 35 ) resistor r=27.3797 //w=0.187 //l=0.4 //layer=li //thickness=0.1 \
 //x=1.165 //y=1.77 //x2=1.565 //y2=1.77
r75 (  5 35 ) resistor r=5.4201 //w=0.17 //l=0.103078 //layer=li \
 //thickness=0.1 //x=1.965 //y=1.77 //x2=2.05 //y2=1.81
r76 (  5 35 ) resistor r=27.3797 //w=0.187 //l=0.4 //layer=li //thickness=0.1 \
 //x=1.965 //y=1.77 //x2=1.565 //y2=1.77
r77 (  1 35 ) resistor r=3.57586 //w=0.17 //l=0.125 //layer=li //thickness=0.1 \
 //x=1.08 //y=1.685 //x2=1.08 //y2=1.81
r78 (  1 35 ) resistor r=42.0963 //w=0.187 //l=0.615 //layer=li \
 //thickness=0.1 //x=1.08 //y=1.685 //x2=1.08 //y2=1.07
ends PM_TMRDFFSNRNQX1\%noxref_47

subckt PM_TMRDFFSNRNQX1\%noxref_48 ( 1 5 9 13 17 35 )
c57 ( 35 0 ) capacitor c=0.0691212f //x=5.755 //y=0.555
c58 ( 17 0 ) capacitor c=0.0190725f //x=7.745 //y=1.77
c59 ( 13 0 ) capacitor c=0.015325f //x=7.745 //y=0.72
c60 ( 9 0 ) capacitor c=0.00772076f //x=6.86 //y=0.805
c61 ( 5 0 ) capacitor c=0.0166941f //x=6.775 //y=1.77
c62 ( 1 0 ) capacitor c=0.00710458f //x=5.89 //y=1.685
r63 (  18 35 ) resistor r=5.4201 //w=0.17 //l=0.103078 //layer=li \
 //thickness=0.1 //x=6.945 //y=1.77 //x2=6.86 //y2=1.81
r64 (  18 35 ) resistor r=27.3797 //w=0.187 //l=0.4 //layer=li //thickness=0.1 \
 //x=6.945 //y=1.77 //x2=7.345 //y2=1.77
r65 (  17 35 ) resistor r=0.751729 //w=0.17 //l=0.085 //layer=li \
 //thickness=0.1 //x=7.745 //y=1.77 //x2=7.83 //y2=1.77
r66 (  17 35 ) resistor r=27.3797 //w=0.187 //l=0.4 //layer=li //thickness=0.1 \
 //x=7.745 //y=1.77 //x2=7.345 //y2=1.77
r67 (  14 35 ) resistor r=3.57586 //w=0.17 //l=0.103078 //layer=li \
 //thickness=0.1 //x=6.945 //y=0.72 //x2=6.86 //y2=0.68
r68 (  14 35 ) resistor r=27.3797 //w=0.187 //l=0.4 //layer=li //thickness=0.1 \
 //x=6.945 //y=0.72 //x2=7.345 //y2=0.72
r69 (  13 35 ) resistor r=0.751729 //w=0.17 //l=0.085 //layer=li \
 //thickness=0.1 //x=7.745 //y=0.72 //x2=7.83 //y2=0.72
r70 (  13 35 ) resistor r=27.3797 //w=0.187 //l=0.4 //layer=li //thickness=0.1 \
 //x=7.745 //y=0.72 //x2=7.345 //y2=0.72
r71 (  10 35 ) resistor r=1.40859 //w=0.34 //l=0.125 //layer=li \
 //thickness=0.1 //x=6.86 //y=1.685 //x2=6.86 //y2=1.81
r72 (  10 35 ) resistor r=42.0963 //w=0.187 //l=0.615 //layer=li \
 //thickness=0.1 //x=6.86 //y=1.685 //x2=6.86 //y2=1.07
r73 (  9 35 ) resistor r=3.57586 //w=0.17 //l=0.125 //layer=li //thickness=0.1 \
 //x=6.86 //y=0.805 //x2=6.86 //y2=0.68
r74 (  9 35 ) resistor r=18.139 //w=0.187 //l=0.265 //layer=li //thickness=0.1 \
 //x=6.86 //y=0.805 //x2=6.86 //y2=1.07
r75 (  6 35 ) resistor r=3.57586 //w=0.17 //l=0.103078 //layer=li \
 //thickness=0.1 //x=5.975 //y=1.77 //x2=5.89 //y2=1.81
r76 (  6 35 ) resistor r=27.3797 //w=0.187 //l=0.4 //layer=li //thickness=0.1 \
 //x=5.975 //y=1.77 //x2=6.375 //y2=1.77
r77 (  5 35 ) resistor r=5.4201 //w=0.17 //l=0.103078 //layer=li \
 //thickness=0.1 //x=6.775 //y=1.77 //x2=6.86 //y2=1.81
r78 (  5 35 ) resistor r=27.3797 //w=0.187 //l=0.4 //layer=li //thickness=0.1 \
 //x=6.775 //y=1.77 //x2=6.375 //y2=1.77
r79 (  1 35 ) resistor r=3.57586 //w=0.17 //l=0.125 //layer=li //thickness=0.1 \
 //x=5.89 //y=1.685 //x2=5.89 //y2=1.81
r80 (  1 35 ) resistor r=42.0963 //w=0.187 //l=0.615 //layer=li \
 //thickness=0.1 //x=5.89 //y=1.685 //x2=5.89 //y2=1.07
ends PM_TMRDFFSNRNQX1\%noxref_48

subckt PM_TMRDFFSNRNQX1\%noxref_49 ( 1 5 9 13 17 35 )
c58 ( 35 0 ) capacitor c=0.0691212f //x=10.565 //y=0.555
c59 ( 17 0 ) capacitor c=0.0190725f //x=12.555 //y=1.77
c60 ( 13 0 ) capacitor c=0.015325f //x=12.555 //y=0.72
c61 ( 9 0 ) capacitor c=0.00772076f //x=11.67 //y=0.805
c62 ( 5 0 ) capacitor c=0.0167789f //x=11.585 //y=1.77
c63 ( 1 0 ) capacitor c=0.00710458f //x=10.7 //y=1.685
r64 (  18 35 ) resistor r=5.4201 //w=0.17 //l=0.103078 //layer=li \
 //thickness=0.1 //x=11.755 //y=1.77 //x2=11.67 //y2=1.81
r65 (  18 35 ) resistor r=27.3797 //w=0.187 //l=0.4 //layer=li //thickness=0.1 \
 //x=11.755 //y=1.77 //x2=12.155 //y2=1.77
r66 (  17 35 ) resistor r=0.751729 //w=0.17 //l=0.085 //layer=li \
 //thickness=0.1 //x=12.555 //y=1.77 //x2=12.64 //y2=1.77
r67 (  17 35 ) resistor r=27.3797 //w=0.187 //l=0.4 //layer=li //thickness=0.1 \
 //x=12.555 //y=1.77 //x2=12.155 //y2=1.77
r68 (  14 35 ) resistor r=3.57586 //w=0.17 //l=0.103078 //layer=li \
 //thickness=0.1 //x=11.755 //y=0.72 //x2=11.67 //y2=0.68
r69 (  14 35 ) resistor r=27.3797 //w=0.187 //l=0.4 //layer=li //thickness=0.1 \
 //x=11.755 //y=0.72 //x2=12.155 //y2=0.72
r70 (  13 35 ) resistor r=0.751729 //w=0.17 //l=0.085 //layer=li \
 //thickness=0.1 //x=12.555 //y=0.72 //x2=12.64 //y2=0.72
r71 (  13 35 ) resistor r=27.3797 //w=0.187 //l=0.4 //layer=li //thickness=0.1 \
 //x=12.555 //y=0.72 //x2=12.155 //y2=0.72
r72 (  10 35 ) resistor r=1.40859 //w=0.34 //l=0.125 //layer=li \
 //thickness=0.1 //x=11.67 //y=1.685 //x2=11.67 //y2=1.81
r73 (  10 35 ) resistor r=42.0963 //w=0.187 //l=0.615 //layer=li \
 //thickness=0.1 //x=11.67 //y=1.685 //x2=11.67 //y2=1.07
r74 (  9 35 ) resistor r=3.57586 //w=0.17 //l=0.125 //layer=li //thickness=0.1 \
 //x=11.67 //y=0.805 //x2=11.67 //y2=0.68
r75 (  9 35 ) resistor r=18.139 //w=0.187 //l=0.265 //layer=li //thickness=0.1 \
 //x=11.67 //y=0.805 //x2=11.67 //y2=1.07
r76 (  6 35 ) resistor r=3.57586 //w=0.17 //l=0.103078 //layer=li \
 //thickness=0.1 //x=10.785 //y=1.77 //x2=10.7 //y2=1.81
r77 (  6 35 ) resistor r=27.3797 //w=0.187 //l=0.4 //layer=li //thickness=0.1 \
 //x=10.785 //y=1.77 //x2=11.185 //y2=1.77
r78 (  5 35 ) resistor r=5.4201 //w=0.17 //l=0.103078 //layer=li \
 //thickness=0.1 //x=11.585 //y=1.77 //x2=11.67 //y2=1.81
r79 (  5 35 ) resistor r=27.3797 //w=0.187 //l=0.4 //layer=li //thickness=0.1 \
 //x=11.585 //y=1.77 //x2=11.185 //y2=1.77
r80 (  1 35 ) resistor r=3.57586 //w=0.17 //l=0.125 //layer=li //thickness=0.1 \
 //x=10.7 //y=1.685 //x2=10.7 //y2=1.81
r81 (  1 35 ) resistor r=42.0963 //w=0.187 //l=0.615 //layer=li \
 //thickness=0.1 //x=10.7 //y=1.685 //x2=10.7 //y2=1.07
ends PM_TMRDFFSNRNQX1\%noxref_49

subckt PM_TMRDFFSNRNQX1\%noxref_50 ( 1 5 9 13 17 35 )
c59 ( 35 0 ) capacitor c=0.0691212f //x=15.375 //y=0.555
c60 ( 17 0 ) capacitor c=0.0190725f //x=17.365 //y=1.77
c61 ( 13 0 ) capacitor c=0.015325f //x=17.365 //y=0.72
c62 ( 9 0 ) capacitor c=0.00772076f //x=16.48 //y=0.805
c63 ( 5 0 ) capacitor c=0.0167589f //x=16.395 //y=1.77
c64 ( 1 0 ) capacitor c=0.00710458f //x=15.51 //y=1.685
r65 (  18 35 ) resistor r=5.4201 //w=0.17 //l=0.103078 //layer=li \
 //thickness=0.1 //x=16.565 //y=1.77 //x2=16.48 //y2=1.81
r66 (  18 35 ) resistor r=27.3797 //w=0.187 //l=0.4 //layer=li //thickness=0.1 \
 //x=16.565 //y=1.77 //x2=16.965 //y2=1.77
r67 (  17 35 ) resistor r=0.751729 //w=0.17 //l=0.085 //layer=li \
 //thickness=0.1 //x=17.365 //y=1.77 //x2=17.45 //y2=1.77
r68 (  17 35 ) resistor r=27.3797 //w=0.187 //l=0.4 //layer=li //thickness=0.1 \
 //x=17.365 //y=1.77 //x2=16.965 //y2=1.77
r69 (  14 35 ) resistor r=3.57586 //w=0.17 //l=0.103078 //layer=li \
 //thickness=0.1 //x=16.565 //y=0.72 //x2=16.48 //y2=0.68
r70 (  14 35 ) resistor r=27.3797 //w=0.187 //l=0.4 //layer=li //thickness=0.1 \
 //x=16.565 //y=0.72 //x2=16.965 //y2=0.72
r71 (  13 35 ) resistor r=0.751729 //w=0.17 //l=0.085 //layer=li \
 //thickness=0.1 //x=17.365 //y=0.72 //x2=17.45 //y2=0.72
r72 (  13 35 ) resistor r=27.3797 //w=0.187 //l=0.4 //layer=li //thickness=0.1 \
 //x=17.365 //y=0.72 //x2=16.965 //y2=0.72
r73 (  10 35 ) resistor r=1.40859 //w=0.34 //l=0.125 //layer=li \
 //thickness=0.1 //x=16.48 //y=1.685 //x2=16.48 //y2=1.81
r74 (  10 35 ) resistor r=42.0963 //w=0.187 //l=0.615 //layer=li \
 //thickness=0.1 //x=16.48 //y=1.685 //x2=16.48 //y2=1.07
r75 (  9 35 ) resistor r=3.57586 //w=0.17 //l=0.125 //layer=li //thickness=0.1 \
 //x=16.48 //y=0.805 //x2=16.48 //y2=0.68
r76 (  9 35 ) resistor r=18.139 //w=0.187 //l=0.265 //layer=li //thickness=0.1 \
 //x=16.48 //y=0.805 //x2=16.48 //y2=1.07
r77 (  6 35 ) resistor r=3.57586 //w=0.17 //l=0.103078 //layer=li \
 //thickness=0.1 //x=15.595 //y=1.77 //x2=15.51 //y2=1.81
r78 (  6 35 ) resistor r=27.3797 //w=0.187 //l=0.4 //layer=li //thickness=0.1 \
 //x=15.595 //y=1.77 //x2=15.995 //y2=1.77
r79 (  5 35 ) resistor r=5.4201 //w=0.17 //l=0.103078 //layer=li \
 //thickness=0.1 //x=16.395 //y=1.77 //x2=16.48 //y2=1.81
r80 (  5 35 ) resistor r=27.3797 //w=0.187 //l=0.4 //layer=li //thickness=0.1 \
 //x=16.395 //y=1.77 //x2=15.995 //y2=1.77
r81 (  1 35 ) resistor r=3.57586 //w=0.17 //l=0.125 //layer=li //thickness=0.1 \
 //x=15.51 //y=1.685 //x2=15.51 //y2=1.81
r82 (  1 35 ) resistor r=42.0963 //w=0.187 //l=0.615 //layer=li \
 //thickness=0.1 //x=15.51 //y=1.685 //x2=15.51 //y2=1.07
ends PM_TMRDFFSNRNQX1\%noxref_50

subckt PM_TMRDFFSNRNQX1\%noxref_51 ( 1 5 9 13 17 35 )
c58 ( 35 0 ) capacitor c=0.0691212f //x=20.185 //y=0.555
c59 ( 17 0 ) capacitor c=0.0189585f //x=22.175 //y=1.77
c60 ( 13 0 ) capacitor c=0.0153221f //x=22.175 //y=0.72
c61 ( 9 0 ) capacitor c=0.00772076f //x=21.29 //y=0.805
c62 ( 5 0 ) capacitor c=0.0168501f //x=21.205 //y=1.77
c63 ( 1 0 ) capacitor c=0.00710458f //x=20.32 //y=1.685
r64 (  18 35 ) resistor r=5.4201 //w=0.17 //l=0.103078 //layer=li \
 //thickness=0.1 //x=21.375 //y=1.77 //x2=21.29 //y2=1.81
r65 (  18 35 ) resistor r=27.3797 //w=0.187 //l=0.4 //layer=li //thickness=0.1 \
 //x=21.375 //y=1.77 //x2=21.775 //y2=1.77
r66 (  17 35 ) resistor r=0.751729 //w=0.17 //l=0.085 //layer=li \
 //thickness=0.1 //x=22.175 //y=1.77 //x2=22.26 //y2=1.77
r67 (  17 35 ) resistor r=27.3797 //w=0.187 //l=0.4 //layer=li //thickness=0.1 \
 //x=22.175 //y=1.77 //x2=21.775 //y2=1.77
r68 (  14 35 ) resistor r=3.57586 //w=0.17 //l=0.103078 //layer=li \
 //thickness=0.1 //x=21.375 //y=0.72 //x2=21.29 //y2=0.68
r69 (  14 35 ) resistor r=27.3797 //w=0.187 //l=0.4 //layer=li //thickness=0.1 \
 //x=21.375 //y=0.72 //x2=21.775 //y2=0.72
r70 (  13 35 ) resistor r=0.751729 //w=0.17 //l=0.085 //layer=li \
 //thickness=0.1 //x=22.175 //y=0.72 //x2=22.26 //y2=0.72
r71 (  13 35 ) resistor r=27.3797 //w=0.187 //l=0.4 //layer=li //thickness=0.1 \
 //x=22.175 //y=0.72 //x2=21.775 //y2=0.72
r72 (  10 35 ) resistor r=1.40859 //w=0.34 //l=0.125 //layer=li \
 //thickness=0.1 //x=21.29 //y=1.685 //x2=21.29 //y2=1.81
r73 (  10 35 ) resistor r=42.0963 //w=0.187 //l=0.615 //layer=li \
 //thickness=0.1 //x=21.29 //y=1.685 //x2=21.29 //y2=1.07
r74 (  9 35 ) resistor r=3.57586 //w=0.17 //l=0.125 //layer=li //thickness=0.1 \
 //x=21.29 //y=0.805 //x2=21.29 //y2=0.68
r75 (  9 35 ) resistor r=18.139 //w=0.187 //l=0.265 //layer=li //thickness=0.1 \
 //x=21.29 //y=0.805 //x2=21.29 //y2=1.07
r76 (  6 35 ) resistor r=3.57586 //w=0.17 //l=0.103078 //layer=li \
 //thickness=0.1 //x=20.405 //y=1.77 //x2=20.32 //y2=1.81
r77 (  6 35 ) resistor r=27.3797 //w=0.187 //l=0.4 //layer=li //thickness=0.1 \
 //x=20.405 //y=1.77 //x2=20.805 //y2=1.77
r78 (  5 35 ) resistor r=5.4201 //w=0.17 //l=0.103078 //layer=li \
 //thickness=0.1 //x=21.205 //y=1.77 //x2=21.29 //y2=1.81
r79 (  5 35 ) resistor r=27.3797 //w=0.187 //l=0.4 //layer=li //thickness=0.1 \
 //x=21.205 //y=1.77 //x2=20.805 //y2=1.77
r80 (  1 35 ) resistor r=3.57586 //w=0.17 //l=0.125 //layer=li //thickness=0.1 \
 //x=20.32 //y=1.685 //x2=20.32 //y2=1.81
r81 (  1 35 ) resistor r=42.0963 //w=0.187 //l=0.615 //layer=li \
 //thickness=0.1 //x=20.32 //y=1.685 //x2=20.32 //y2=1.07
ends PM_TMRDFFSNRNQX1\%noxref_51

subckt PM_TMRDFFSNRNQX1\%noxref_52 ( 1 5 9 13 17 35 )
c59 ( 35 0 ) capacitor c=0.0691212f //x=24.995 //y=0.555
c60 ( 17 0 ) capacitor c=0.0190725f //x=26.985 //y=1.77
c61 ( 13 0 ) capacitor c=0.015325f //x=26.985 //y=0.72
c62 ( 9 0 ) capacitor c=0.00772076f //x=26.1 //y=0.805
c63 ( 5 0 ) capacitor c=0.0167627f //x=26.015 //y=1.77
c64 ( 1 0 ) capacitor c=0.00710458f //x=25.13 //y=1.685
r65 (  18 35 ) resistor r=5.4201 //w=0.17 //l=0.103078 //layer=li \
 //thickness=0.1 //x=26.185 //y=1.77 //x2=26.1 //y2=1.81
r66 (  18 35 ) resistor r=27.3797 //w=0.187 //l=0.4 //layer=li //thickness=0.1 \
 //x=26.185 //y=1.77 //x2=26.585 //y2=1.77
r67 (  17 35 ) resistor r=0.751729 //w=0.17 //l=0.085 //layer=li \
 //thickness=0.1 //x=26.985 //y=1.77 //x2=27.07 //y2=1.77
r68 (  17 35 ) resistor r=27.3797 //w=0.187 //l=0.4 //layer=li //thickness=0.1 \
 //x=26.985 //y=1.77 //x2=26.585 //y2=1.77
r69 (  14 35 ) resistor r=3.57586 //w=0.17 //l=0.103078 //layer=li \
 //thickness=0.1 //x=26.185 //y=0.72 //x2=26.1 //y2=0.68
r70 (  14 35 ) resistor r=27.3797 //w=0.187 //l=0.4 //layer=li //thickness=0.1 \
 //x=26.185 //y=0.72 //x2=26.585 //y2=0.72
r71 (  13 35 ) resistor r=0.751729 //w=0.17 //l=0.085 //layer=li \
 //thickness=0.1 //x=26.985 //y=0.72 //x2=27.07 //y2=0.72
r72 (  13 35 ) resistor r=27.3797 //w=0.187 //l=0.4 //layer=li //thickness=0.1 \
 //x=26.985 //y=0.72 //x2=26.585 //y2=0.72
r73 (  10 35 ) resistor r=1.40859 //w=0.34 //l=0.125 //layer=li \
 //thickness=0.1 //x=26.1 //y=1.685 //x2=26.1 //y2=1.81
r74 (  10 35 ) resistor r=42.0963 //w=0.187 //l=0.615 //layer=li \
 //thickness=0.1 //x=26.1 //y=1.685 //x2=26.1 //y2=1.07
r75 (  9 35 ) resistor r=3.57586 //w=0.17 //l=0.125 //layer=li //thickness=0.1 \
 //x=26.1 //y=0.805 //x2=26.1 //y2=0.68
r76 (  9 35 ) resistor r=18.139 //w=0.187 //l=0.265 //layer=li //thickness=0.1 \
 //x=26.1 //y=0.805 //x2=26.1 //y2=1.07
r77 (  6 35 ) resistor r=3.57586 //w=0.17 //l=0.103078 //layer=li \
 //thickness=0.1 //x=25.215 //y=1.77 //x2=25.13 //y2=1.81
r78 (  6 35 ) resistor r=27.3797 //w=0.187 //l=0.4 //layer=li //thickness=0.1 \
 //x=25.215 //y=1.77 //x2=25.615 //y2=1.77
r79 (  5 35 ) resistor r=5.4201 //w=0.17 //l=0.103078 //layer=li \
 //thickness=0.1 //x=26.015 //y=1.77 //x2=26.1 //y2=1.81
r80 (  5 35 ) resistor r=27.3797 //w=0.187 //l=0.4 //layer=li //thickness=0.1 \
 //x=26.015 //y=1.77 //x2=25.615 //y2=1.77
r81 (  1 35 ) resistor r=3.57586 //w=0.17 //l=0.125 //layer=li //thickness=0.1 \
 //x=25.13 //y=1.685 //x2=25.13 //y2=1.81
r82 (  1 35 ) resistor r=42.0963 //w=0.187 //l=0.615 //layer=li \
 //thickness=0.1 //x=25.13 //y=1.685 //x2=25.13 //y2=1.07
ends PM_TMRDFFSNRNQX1\%noxref_52

subckt PM_TMRDFFSNRNQX1\%noxref_53 ( 1 5 9 13 17 35 )
c56 ( 35 0 ) capacitor c=0.0691212f //x=29.805 //y=0.555
c57 ( 17 0 ) capacitor c=0.0189725f //x=31.795 //y=1.77
c58 ( 13 0 ) capacitor c=0.0153216f //x=31.795 //y=0.72
c59 ( 9 0 ) capacitor c=0.00772076f //x=30.91 //y=0.805
c60 ( 5 0 ) capacitor c=0.0168501f //x=30.825 //y=1.77
c61 ( 1 0 ) capacitor c=0.00710458f //x=29.94 //y=1.685
r62 (  18 35 ) resistor r=5.4201 //w=0.17 //l=0.103078 //layer=li \
 //thickness=0.1 //x=30.995 //y=1.77 //x2=30.91 //y2=1.81
r63 (  18 35 ) resistor r=27.3797 //w=0.187 //l=0.4 //layer=li //thickness=0.1 \
 //x=30.995 //y=1.77 //x2=31.395 //y2=1.77
r64 (  17 35 ) resistor r=0.751729 //w=0.17 //l=0.085 //layer=li \
 //thickness=0.1 //x=31.795 //y=1.77 //x2=31.88 //y2=1.77
r65 (  17 35 ) resistor r=27.3797 //w=0.187 //l=0.4 //layer=li //thickness=0.1 \
 //x=31.795 //y=1.77 //x2=31.395 //y2=1.77
r66 (  14 35 ) resistor r=3.57586 //w=0.17 //l=0.103078 //layer=li \
 //thickness=0.1 //x=30.995 //y=0.72 //x2=30.91 //y2=0.68
r67 (  14 35 ) resistor r=27.3797 //w=0.187 //l=0.4 //layer=li //thickness=0.1 \
 //x=30.995 //y=0.72 //x2=31.395 //y2=0.72
r68 (  13 35 ) resistor r=0.751729 //w=0.17 //l=0.085 //layer=li \
 //thickness=0.1 //x=31.795 //y=0.72 //x2=31.88 //y2=0.72
r69 (  13 35 ) resistor r=27.3797 //w=0.187 //l=0.4 //layer=li //thickness=0.1 \
 //x=31.795 //y=0.72 //x2=31.395 //y2=0.72
r70 (  10 35 ) resistor r=1.40859 //w=0.34 //l=0.125 //layer=li \
 //thickness=0.1 //x=30.91 //y=1.685 //x2=30.91 //y2=1.81
r71 (  10 35 ) resistor r=42.0963 //w=0.187 //l=0.615 //layer=li \
 //thickness=0.1 //x=30.91 //y=1.685 //x2=30.91 //y2=1.07
r72 (  9 35 ) resistor r=3.57586 //w=0.17 //l=0.125 //layer=li //thickness=0.1 \
 //x=30.91 //y=0.805 //x2=30.91 //y2=0.68
r73 (  9 35 ) resistor r=18.139 //w=0.187 //l=0.265 //layer=li //thickness=0.1 \
 //x=30.91 //y=0.805 //x2=30.91 //y2=1.07
r74 (  6 35 ) resistor r=3.57586 //w=0.17 //l=0.103078 //layer=li \
 //thickness=0.1 //x=30.025 //y=1.77 //x2=29.94 //y2=1.81
r75 (  6 35 ) resistor r=27.3797 //w=0.187 //l=0.4 //layer=li //thickness=0.1 \
 //x=30.025 //y=1.77 //x2=30.425 //y2=1.77
r76 (  5 35 ) resistor r=5.4201 //w=0.17 //l=0.103078 //layer=li \
 //thickness=0.1 //x=30.825 //y=1.77 //x2=30.91 //y2=1.81
r77 (  5 35 ) resistor r=27.3797 //w=0.187 //l=0.4 //layer=li //thickness=0.1 \
 //x=30.825 //y=1.77 //x2=30.425 //y2=1.77
r78 (  1 35 ) resistor r=3.57586 //w=0.17 //l=0.125 //layer=li //thickness=0.1 \
 //x=29.94 //y=1.685 //x2=29.94 //y2=1.81
r79 (  1 35 ) resistor r=42.0963 //w=0.187 //l=0.615 //layer=li \
 //thickness=0.1 //x=29.94 //y=1.685 //x2=29.94 //y2=1.07
ends PM_TMRDFFSNRNQX1\%noxref_53

subckt PM_TMRDFFSNRNQX1\%noxref_54 ( 1 5 9 13 17 35 )
c57 ( 35 0 ) capacitor c=0.0691212f //x=34.615 //y=0.555
c58 ( 17 0 ) capacitor c=0.0190725f //x=36.605 //y=1.77
c59 ( 13 0 ) capacitor c=0.015325f //x=36.605 //y=0.72
c60 ( 9 0 ) capacitor c=0.00772076f //x=35.72 //y=0.805
c61 ( 5 0 ) capacitor c=0.0166941f //x=35.635 //y=1.77
c62 ( 1 0 ) capacitor c=0.00710458f //x=34.75 //y=1.685
r63 (  18 35 ) resistor r=5.4201 //w=0.17 //l=0.103078 //layer=li \
 //thickness=0.1 //x=35.805 //y=1.77 //x2=35.72 //y2=1.81
r64 (  18 35 ) resistor r=27.3797 //w=0.187 //l=0.4 //layer=li //thickness=0.1 \
 //x=35.805 //y=1.77 //x2=36.205 //y2=1.77
r65 (  17 35 ) resistor r=0.751729 //w=0.17 //l=0.085 //layer=li \
 //thickness=0.1 //x=36.605 //y=1.77 //x2=36.69 //y2=1.77
r66 (  17 35 ) resistor r=27.3797 //w=0.187 //l=0.4 //layer=li //thickness=0.1 \
 //x=36.605 //y=1.77 //x2=36.205 //y2=1.77
r67 (  14 35 ) resistor r=3.57586 //w=0.17 //l=0.103078 //layer=li \
 //thickness=0.1 //x=35.805 //y=0.72 //x2=35.72 //y2=0.68
r68 (  14 35 ) resistor r=27.3797 //w=0.187 //l=0.4 //layer=li //thickness=0.1 \
 //x=35.805 //y=0.72 //x2=36.205 //y2=0.72
r69 (  13 35 ) resistor r=0.751729 //w=0.17 //l=0.085 //layer=li \
 //thickness=0.1 //x=36.605 //y=0.72 //x2=36.69 //y2=0.72
r70 (  13 35 ) resistor r=27.3797 //w=0.187 //l=0.4 //layer=li //thickness=0.1 \
 //x=36.605 //y=0.72 //x2=36.205 //y2=0.72
r71 (  10 35 ) resistor r=1.40859 //w=0.34 //l=0.125 //layer=li \
 //thickness=0.1 //x=35.72 //y=1.685 //x2=35.72 //y2=1.81
r72 (  10 35 ) resistor r=42.0963 //w=0.187 //l=0.615 //layer=li \
 //thickness=0.1 //x=35.72 //y=1.685 //x2=35.72 //y2=1.07
r73 (  9 35 ) resistor r=3.57586 //w=0.17 //l=0.125 //layer=li //thickness=0.1 \
 //x=35.72 //y=0.805 //x2=35.72 //y2=0.68
r74 (  9 35 ) resistor r=18.139 //w=0.187 //l=0.265 //layer=li //thickness=0.1 \
 //x=35.72 //y=0.805 //x2=35.72 //y2=1.07
r75 (  6 35 ) resistor r=3.57586 //w=0.17 //l=0.103078 //layer=li \
 //thickness=0.1 //x=34.835 //y=1.77 //x2=34.75 //y2=1.81
r76 (  6 35 ) resistor r=27.3797 //w=0.187 //l=0.4 //layer=li //thickness=0.1 \
 //x=34.835 //y=1.77 //x2=35.235 //y2=1.77
r77 (  5 35 ) resistor r=5.4201 //w=0.17 //l=0.103078 //layer=li \
 //thickness=0.1 //x=35.635 //y=1.77 //x2=35.72 //y2=1.81
r78 (  5 35 ) resistor r=27.3797 //w=0.187 //l=0.4 //layer=li //thickness=0.1 \
 //x=35.635 //y=1.77 //x2=35.235 //y2=1.77
r79 (  1 35 ) resistor r=3.57586 //w=0.17 //l=0.125 //layer=li //thickness=0.1 \
 //x=34.75 //y=1.685 //x2=34.75 //y2=1.81
r80 (  1 35 ) resistor r=42.0963 //w=0.187 //l=0.615 //layer=li \
 //thickness=0.1 //x=34.75 //y=1.685 //x2=34.75 //y2=1.07
ends PM_TMRDFFSNRNQX1\%noxref_54

subckt PM_TMRDFFSNRNQX1\%noxref_55 ( 1 5 9 13 17 35 )
c58 ( 35 0 ) capacitor c=0.0691212f //x=39.425 //y=0.555
c59 ( 17 0 ) capacitor c=0.0190725f //x=41.415 //y=1.77
c60 ( 13 0 ) capacitor c=0.015325f //x=41.415 //y=0.72
c61 ( 9 0 ) capacitor c=0.00772076f //x=40.53 //y=0.805
c62 ( 5 0 ) capacitor c=0.0167789f //x=40.445 //y=1.77
c63 ( 1 0 ) capacitor c=0.00710458f //x=39.56 //y=1.685
r64 (  18 35 ) resistor r=5.4201 //w=0.17 //l=0.103078 //layer=li \
 //thickness=0.1 //x=40.615 //y=1.77 //x2=40.53 //y2=1.81
r65 (  18 35 ) resistor r=27.3797 //w=0.187 //l=0.4 //layer=li //thickness=0.1 \
 //x=40.615 //y=1.77 //x2=41.015 //y2=1.77
r66 (  17 35 ) resistor r=0.751729 //w=0.17 //l=0.085 //layer=li \
 //thickness=0.1 //x=41.415 //y=1.77 //x2=41.5 //y2=1.77
r67 (  17 35 ) resistor r=27.3797 //w=0.187 //l=0.4 //layer=li //thickness=0.1 \
 //x=41.415 //y=1.77 //x2=41.015 //y2=1.77
r68 (  14 35 ) resistor r=3.57586 //w=0.17 //l=0.103078 //layer=li \
 //thickness=0.1 //x=40.615 //y=0.72 //x2=40.53 //y2=0.68
r69 (  14 35 ) resistor r=27.3797 //w=0.187 //l=0.4 //layer=li //thickness=0.1 \
 //x=40.615 //y=0.72 //x2=41.015 //y2=0.72
r70 (  13 35 ) resistor r=0.751729 //w=0.17 //l=0.085 //layer=li \
 //thickness=0.1 //x=41.415 //y=0.72 //x2=41.5 //y2=0.72
r71 (  13 35 ) resistor r=27.3797 //w=0.187 //l=0.4 //layer=li //thickness=0.1 \
 //x=41.415 //y=0.72 //x2=41.015 //y2=0.72
r72 (  10 35 ) resistor r=1.40859 //w=0.34 //l=0.125 //layer=li \
 //thickness=0.1 //x=40.53 //y=1.685 //x2=40.53 //y2=1.81
r73 (  10 35 ) resistor r=42.0963 //w=0.187 //l=0.615 //layer=li \
 //thickness=0.1 //x=40.53 //y=1.685 //x2=40.53 //y2=1.07
r74 (  9 35 ) resistor r=3.57586 //w=0.17 //l=0.125 //layer=li //thickness=0.1 \
 //x=40.53 //y=0.805 //x2=40.53 //y2=0.68
r75 (  9 35 ) resistor r=18.139 //w=0.187 //l=0.265 //layer=li //thickness=0.1 \
 //x=40.53 //y=0.805 //x2=40.53 //y2=1.07
r76 (  6 35 ) resistor r=3.57586 //w=0.17 //l=0.103078 //layer=li \
 //thickness=0.1 //x=39.645 //y=1.77 //x2=39.56 //y2=1.81
r77 (  6 35 ) resistor r=27.3797 //w=0.187 //l=0.4 //layer=li //thickness=0.1 \
 //x=39.645 //y=1.77 //x2=40.045 //y2=1.77
r78 (  5 35 ) resistor r=5.4201 //w=0.17 //l=0.103078 //layer=li \
 //thickness=0.1 //x=40.445 //y=1.77 //x2=40.53 //y2=1.81
r79 (  5 35 ) resistor r=27.3797 //w=0.187 //l=0.4 //layer=li //thickness=0.1 \
 //x=40.445 //y=1.77 //x2=40.045 //y2=1.77
r80 (  1 35 ) resistor r=3.57586 //w=0.17 //l=0.125 //layer=li //thickness=0.1 \
 //x=39.56 //y=1.685 //x2=39.56 //y2=1.81
r81 (  1 35 ) resistor r=42.0963 //w=0.187 //l=0.615 //layer=li \
 //thickness=0.1 //x=39.56 //y=1.685 //x2=39.56 //y2=1.07
ends PM_TMRDFFSNRNQX1\%noxref_55

subckt PM_TMRDFFSNRNQX1\%noxref_56 ( 1 5 9 13 17 35 )
c59 ( 35 0 ) capacitor c=0.0691212f //x=44.235 //y=0.555
c60 ( 17 0 ) capacitor c=0.0190725f //x=46.225 //y=1.77
c61 ( 13 0 ) capacitor c=0.015325f //x=46.225 //y=0.72
c62 ( 9 0 ) capacitor c=0.00772076f //x=45.34 //y=0.805
c63 ( 5 0 ) capacitor c=0.0167589f //x=45.255 //y=1.77
c64 ( 1 0 ) capacitor c=0.00710458f //x=44.37 //y=1.685
r65 (  18 35 ) resistor r=5.4201 //w=0.17 //l=0.103078 //layer=li \
 //thickness=0.1 //x=45.425 //y=1.77 //x2=45.34 //y2=1.81
r66 (  18 35 ) resistor r=27.3797 //w=0.187 //l=0.4 //layer=li //thickness=0.1 \
 //x=45.425 //y=1.77 //x2=45.825 //y2=1.77
r67 (  17 35 ) resistor r=0.751729 //w=0.17 //l=0.085 //layer=li \
 //thickness=0.1 //x=46.225 //y=1.77 //x2=46.31 //y2=1.77
r68 (  17 35 ) resistor r=27.3797 //w=0.187 //l=0.4 //layer=li //thickness=0.1 \
 //x=46.225 //y=1.77 //x2=45.825 //y2=1.77
r69 (  14 35 ) resistor r=3.57586 //w=0.17 //l=0.103078 //layer=li \
 //thickness=0.1 //x=45.425 //y=0.72 //x2=45.34 //y2=0.68
r70 (  14 35 ) resistor r=27.3797 //w=0.187 //l=0.4 //layer=li //thickness=0.1 \
 //x=45.425 //y=0.72 //x2=45.825 //y2=0.72
r71 (  13 35 ) resistor r=0.751729 //w=0.17 //l=0.085 //layer=li \
 //thickness=0.1 //x=46.225 //y=0.72 //x2=46.31 //y2=0.72
r72 (  13 35 ) resistor r=27.3797 //w=0.187 //l=0.4 //layer=li //thickness=0.1 \
 //x=46.225 //y=0.72 //x2=45.825 //y2=0.72
r73 (  10 35 ) resistor r=1.40859 //w=0.34 //l=0.125 //layer=li \
 //thickness=0.1 //x=45.34 //y=1.685 //x2=45.34 //y2=1.81
r74 (  10 35 ) resistor r=42.0963 //w=0.187 //l=0.615 //layer=li \
 //thickness=0.1 //x=45.34 //y=1.685 //x2=45.34 //y2=1.07
r75 (  9 35 ) resistor r=3.57586 //w=0.17 //l=0.125 //layer=li //thickness=0.1 \
 //x=45.34 //y=0.805 //x2=45.34 //y2=0.68
r76 (  9 35 ) resistor r=18.139 //w=0.187 //l=0.265 //layer=li //thickness=0.1 \
 //x=45.34 //y=0.805 //x2=45.34 //y2=1.07
r77 (  6 35 ) resistor r=3.57586 //w=0.17 //l=0.103078 //layer=li \
 //thickness=0.1 //x=44.455 //y=1.77 //x2=44.37 //y2=1.81
r78 (  6 35 ) resistor r=27.3797 //w=0.187 //l=0.4 //layer=li //thickness=0.1 \
 //x=44.455 //y=1.77 //x2=44.855 //y2=1.77
r79 (  5 35 ) resistor r=5.4201 //w=0.17 //l=0.103078 //layer=li \
 //thickness=0.1 //x=45.255 //y=1.77 //x2=45.34 //y2=1.81
r80 (  5 35 ) resistor r=27.3797 //w=0.187 //l=0.4 //layer=li //thickness=0.1 \
 //x=45.255 //y=1.77 //x2=44.855 //y2=1.77
r81 (  1 35 ) resistor r=3.57586 //w=0.17 //l=0.125 //layer=li //thickness=0.1 \
 //x=44.37 //y=1.685 //x2=44.37 //y2=1.81
r82 (  1 35 ) resistor r=42.0963 //w=0.187 //l=0.615 //layer=li \
 //thickness=0.1 //x=44.37 //y=1.685 //x2=44.37 //y2=1.07
ends PM_TMRDFFSNRNQX1\%noxref_56

subckt PM_TMRDFFSNRNQX1\%noxref_57 ( 1 5 9 13 17 35 )
c58 ( 35 0 ) capacitor c=0.0691212f //x=49.045 //y=0.555
c59 ( 17 0 ) capacitor c=0.0189585f //x=51.035 //y=1.77
c60 ( 13 0 ) capacitor c=0.0153221f //x=51.035 //y=0.72
c61 ( 9 0 ) capacitor c=0.00772076f //x=50.15 //y=0.805
c62 ( 5 0 ) capacitor c=0.0168501f //x=50.065 //y=1.77
c63 ( 1 0 ) capacitor c=0.00710458f //x=49.18 //y=1.685
r64 (  18 35 ) resistor r=5.4201 //w=0.17 //l=0.103078 //layer=li \
 //thickness=0.1 //x=50.235 //y=1.77 //x2=50.15 //y2=1.81
r65 (  18 35 ) resistor r=27.3797 //w=0.187 //l=0.4 //layer=li //thickness=0.1 \
 //x=50.235 //y=1.77 //x2=50.635 //y2=1.77
r66 (  17 35 ) resistor r=0.751729 //w=0.17 //l=0.085 //layer=li \
 //thickness=0.1 //x=51.035 //y=1.77 //x2=51.12 //y2=1.77
r67 (  17 35 ) resistor r=27.3797 //w=0.187 //l=0.4 //layer=li //thickness=0.1 \
 //x=51.035 //y=1.77 //x2=50.635 //y2=1.77
r68 (  14 35 ) resistor r=3.57586 //w=0.17 //l=0.103078 //layer=li \
 //thickness=0.1 //x=50.235 //y=0.72 //x2=50.15 //y2=0.68
r69 (  14 35 ) resistor r=27.3797 //w=0.187 //l=0.4 //layer=li //thickness=0.1 \
 //x=50.235 //y=0.72 //x2=50.635 //y2=0.72
r70 (  13 35 ) resistor r=0.751729 //w=0.17 //l=0.085 //layer=li \
 //thickness=0.1 //x=51.035 //y=0.72 //x2=51.12 //y2=0.72
r71 (  13 35 ) resistor r=27.3797 //w=0.187 //l=0.4 //layer=li //thickness=0.1 \
 //x=51.035 //y=0.72 //x2=50.635 //y2=0.72
r72 (  10 35 ) resistor r=1.40859 //w=0.34 //l=0.125 //layer=li \
 //thickness=0.1 //x=50.15 //y=1.685 //x2=50.15 //y2=1.81
r73 (  10 35 ) resistor r=42.0963 //w=0.187 //l=0.615 //layer=li \
 //thickness=0.1 //x=50.15 //y=1.685 //x2=50.15 //y2=1.07
r74 (  9 35 ) resistor r=3.57586 //w=0.17 //l=0.125 //layer=li //thickness=0.1 \
 //x=50.15 //y=0.805 //x2=50.15 //y2=0.68
r75 (  9 35 ) resistor r=18.139 //w=0.187 //l=0.265 //layer=li //thickness=0.1 \
 //x=50.15 //y=0.805 //x2=50.15 //y2=1.07
r76 (  6 35 ) resistor r=3.57586 //w=0.17 //l=0.103078 //layer=li \
 //thickness=0.1 //x=49.265 //y=1.77 //x2=49.18 //y2=1.81
r77 (  6 35 ) resistor r=27.3797 //w=0.187 //l=0.4 //layer=li //thickness=0.1 \
 //x=49.265 //y=1.77 //x2=49.665 //y2=1.77
r78 (  5 35 ) resistor r=5.4201 //w=0.17 //l=0.103078 //layer=li \
 //thickness=0.1 //x=50.065 //y=1.77 //x2=50.15 //y2=1.81
r79 (  5 35 ) resistor r=27.3797 //w=0.187 //l=0.4 //layer=li //thickness=0.1 \
 //x=50.065 //y=1.77 //x2=49.665 //y2=1.77
r80 (  1 35 ) resistor r=3.57586 //w=0.17 //l=0.125 //layer=li //thickness=0.1 \
 //x=49.18 //y=1.685 //x2=49.18 //y2=1.81
r81 (  1 35 ) resistor r=42.0963 //w=0.187 //l=0.615 //layer=li \
 //thickness=0.1 //x=49.18 //y=1.685 //x2=49.18 //y2=1.07
ends PM_TMRDFFSNRNQX1\%noxref_57

subckt PM_TMRDFFSNRNQX1\%noxref_58 ( 1 5 9 13 17 35 )
c59 ( 35 0 ) capacitor c=0.0691212f //x=53.855 //y=0.555
c60 ( 17 0 ) capacitor c=0.0190725f //x=55.845 //y=1.77
c61 ( 13 0 ) capacitor c=0.015325f //x=55.845 //y=0.72
c62 ( 9 0 ) capacitor c=0.00772076f //x=54.96 //y=0.805
c63 ( 5 0 ) capacitor c=0.0167869f //x=54.875 //y=1.77
c64 ( 1 0 ) capacitor c=0.00710458f //x=53.99 //y=1.685
r65 (  18 35 ) resistor r=5.4201 //w=0.17 //l=0.103078 //layer=li \
 //thickness=0.1 //x=55.045 //y=1.77 //x2=54.96 //y2=1.81
r66 (  18 35 ) resistor r=27.3797 //w=0.187 //l=0.4 //layer=li //thickness=0.1 \
 //x=55.045 //y=1.77 //x2=55.445 //y2=1.77
r67 (  17 35 ) resistor r=0.751729 //w=0.17 //l=0.085 //layer=li \
 //thickness=0.1 //x=55.845 //y=1.77 //x2=55.93 //y2=1.77
r68 (  17 35 ) resistor r=27.3797 //w=0.187 //l=0.4 //layer=li //thickness=0.1 \
 //x=55.845 //y=1.77 //x2=55.445 //y2=1.77
r69 (  14 35 ) resistor r=3.57586 //w=0.17 //l=0.103078 //layer=li \
 //thickness=0.1 //x=55.045 //y=0.72 //x2=54.96 //y2=0.68
r70 (  14 35 ) resistor r=27.3797 //w=0.187 //l=0.4 //layer=li //thickness=0.1 \
 //x=55.045 //y=0.72 //x2=55.445 //y2=0.72
r71 (  13 35 ) resistor r=0.751729 //w=0.17 //l=0.085 //layer=li \
 //thickness=0.1 //x=55.845 //y=0.72 //x2=55.93 //y2=0.72
r72 (  13 35 ) resistor r=27.3797 //w=0.187 //l=0.4 //layer=li //thickness=0.1 \
 //x=55.845 //y=0.72 //x2=55.445 //y2=0.72
r73 (  10 35 ) resistor r=1.40859 //w=0.34 //l=0.125 //layer=li \
 //thickness=0.1 //x=54.96 //y=1.685 //x2=54.96 //y2=1.81
r74 (  10 35 ) resistor r=42.0963 //w=0.187 //l=0.615 //layer=li \
 //thickness=0.1 //x=54.96 //y=1.685 //x2=54.96 //y2=1.07
r75 (  9 35 ) resistor r=3.57586 //w=0.17 //l=0.125 //layer=li //thickness=0.1 \
 //x=54.96 //y=0.805 //x2=54.96 //y2=0.68
r76 (  9 35 ) resistor r=18.139 //w=0.187 //l=0.265 //layer=li //thickness=0.1 \
 //x=54.96 //y=0.805 //x2=54.96 //y2=1.07
r77 (  6 35 ) resistor r=3.57586 //w=0.17 //l=0.103078 //layer=li \
 //thickness=0.1 //x=54.075 //y=1.77 //x2=53.99 //y2=1.81
r78 (  6 35 ) resistor r=27.3797 //w=0.187 //l=0.4 //layer=li //thickness=0.1 \
 //x=54.075 //y=1.77 //x2=54.475 //y2=1.77
r79 (  5 35 ) resistor r=5.4201 //w=0.17 //l=0.103078 //layer=li \
 //thickness=0.1 //x=54.875 //y=1.77 //x2=54.96 //y2=1.81
r80 (  5 35 ) resistor r=27.3797 //w=0.187 //l=0.4 //layer=li //thickness=0.1 \
 //x=54.875 //y=1.77 //x2=54.475 //y2=1.77
r81 (  1 35 ) resistor r=3.57586 //w=0.17 //l=0.125 //layer=li //thickness=0.1 \
 //x=53.99 //y=1.685 //x2=53.99 //y2=1.81
r82 (  1 35 ) resistor r=42.0963 //w=0.187 //l=0.615 //layer=li \
 //thickness=0.1 //x=53.99 //y=1.685 //x2=53.99 //y2=1.07
ends PM_TMRDFFSNRNQX1\%noxref_58

subckt PM_TMRDFFSNRNQX1\%noxref_59 ( 1 5 9 13 17 35 )
c56 ( 35 0 ) capacitor c=0.0691212f //x=58.665 //y=0.555
c57 ( 17 0 ) capacitor c=0.0189725f //x=60.655 //y=1.77
c58 ( 13 0 ) capacitor c=0.0153216f //x=60.655 //y=0.72
c59 ( 9 0 ) capacitor c=0.00772076f //x=59.77 //y=0.805
c60 ( 5 0 ) capacitor c=0.0168501f //x=59.685 //y=1.77
c61 ( 1 0 ) capacitor c=0.00710458f //x=58.8 //y=1.685
r62 (  18 35 ) resistor r=5.4201 //w=0.17 //l=0.103078 //layer=li \
 //thickness=0.1 //x=59.855 //y=1.77 //x2=59.77 //y2=1.81
r63 (  18 35 ) resistor r=27.3797 //w=0.187 //l=0.4 //layer=li //thickness=0.1 \
 //x=59.855 //y=1.77 //x2=60.255 //y2=1.77
r64 (  17 35 ) resistor r=0.751729 //w=0.17 //l=0.085 //layer=li \
 //thickness=0.1 //x=60.655 //y=1.77 //x2=60.74 //y2=1.77
r65 (  17 35 ) resistor r=27.3797 //w=0.187 //l=0.4 //layer=li //thickness=0.1 \
 //x=60.655 //y=1.77 //x2=60.255 //y2=1.77
r66 (  14 35 ) resistor r=3.57586 //w=0.17 //l=0.103078 //layer=li \
 //thickness=0.1 //x=59.855 //y=0.72 //x2=59.77 //y2=0.68
r67 (  14 35 ) resistor r=27.3797 //w=0.187 //l=0.4 //layer=li //thickness=0.1 \
 //x=59.855 //y=0.72 //x2=60.255 //y2=0.72
r68 (  13 35 ) resistor r=0.751729 //w=0.17 //l=0.085 //layer=li \
 //thickness=0.1 //x=60.655 //y=0.72 //x2=60.74 //y2=0.72
r69 (  13 35 ) resistor r=27.3797 //w=0.187 //l=0.4 //layer=li //thickness=0.1 \
 //x=60.655 //y=0.72 //x2=60.255 //y2=0.72
r70 (  10 35 ) resistor r=1.40859 //w=0.34 //l=0.125 //layer=li \
 //thickness=0.1 //x=59.77 //y=1.685 //x2=59.77 //y2=1.81
r71 (  10 35 ) resistor r=42.0963 //w=0.187 //l=0.615 //layer=li \
 //thickness=0.1 //x=59.77 //y=1.685 //x2=59.77 //y2=1.07
r72 (  9 35 ) resistor r=3.57586 //w=0.17 //l=0.125 //layer=li //thickness=0.1 \
 //x=59.77 //y=0.805 //x2=59.77 //y2=0.68
r73 (  9 35 ) resistor r=18.139 //w=0.187 //l=0.265 //layer=li //thickness=0.1 \
 //x=59.77 //y=0.805 //x2=59.77 //y2=1.07
r74 (  6 35 ) resistor r=3.57586 //w=0.17 //l=0.103078 //layer=li \
 //thickness=0.1 //x=58.885 //y=1.77 //x2=58.8 //y2=1.81
r75 (  6 35 ) resistor r=27.3797 //w=0.187 //l=0.4 //layer=li //thickness=0.1 \
 //x=58.885 //y=1.77 //x2=59.285 //y2=1.77
r76 (  5 35 ) resistor r=5.4201 //w=0.17 //l=0.103078 //layer=li \
 //thickness=0.1 //x=59.685 //y=1.77 //x2=59.77 //y2=1.81
r77 (  5 35 ) resistor r=27.3797 //w=0.187 //l=0.4 //layer=li //thickness=0.1 \
 //x=59.685 //y=1.77 //x2=59.285 //y2=1.77
r78 (  1 35 ) resistor r=3.57586 //w=0.17 //l=0.125 //layer=li //thickness=0.1 \
 //x=58.8 //y=1.685 //x2=58.8 //y2=1.81
r79 (  1 35 ) resistor r=42.0963 //w=0.187 //l=0.615 //layer=li \
 //thickness=0.1 //x=58.8 //y=1.685 //x2=58.8 //y2=1.07
ends PM_TMRDFFSNRNQX1\%noxref_59

subckt PM_TMRDFFSNRNQX1\%noxref_60 ( 1 5 9 13 17 35 )
c57 ( 35 0 ) capacitor c=0.0691212f //x=63.475 //y=0.555
c58 ( 17 0 ) capacitor c=0.0190725f //x=65.465 //y=1.77
c59 ( 13 0 ) capacitor c=0.015325f //x=65.465 //y=0.72
c60 ( 9 0 ) capacitor c=0.00772076f //x=64.58 //y=0.805
c61 ( 5 0 ) capacitor c=0.0166941f //x=64.495 //y=1.77
c62 ( 1 0 ) capacitor c=0.00710458f //x=63.61 //y=1.685
r63 (  18 35 ) resistor r=5.4201 //w=0.17 //l=0.103078 //layer=li \
 //thickness=0.1 //x=64.665 //y=1.77 //x2=64.58 //y2=1.81
r64 (  18 35 ) resistor r=27.3797 //w=0.187 //l=0.4 //layer=li //thickness=0.1 \
 //x=64.665 //y=1.77 //x2=65.065 //y2=1.77
r65 (  17 35 ) resistor r=0.751729 //w=0.17 //l=0.085 //layer=li \
 //thickness=0.1 //x=65.465 //y=1.77 //x2=65.55 //y2=1.77
r66 (  17 35 ) resistor r=27.3797 //w=0.187 //l=0.4 //layer=li //thickness=0.1 \
 //x=65.465 //y=1.77 //x2=65.065 //y2=1.77
r67 (  14 35 ) resistor r=3.57586 //w=0.17 //l=0.103078 //layer=li \
 //thickness=0.1 //x=64.665 //y=0.72 //x2=64.58 //y2=0.68
r68 (  14 35 ) resistor r=27.3797 //w=0.187 //l=0.4 //layer=li //thickness=0.1 \
 //x=64.665 //y=0.72 //x2=65.065 //y2=0.72
r69 (  13 35 ) resistor r=0.751729 //w=0.17 //l=0.085 //layer=li \
 //thickness=0.1 //x=65.465 //y=0.72 //x2=65.55 //y2=0.72
r70 (  13 35 ) resistor r=27.3797 //w=0.187 //l=0.4 //layer=li //thickness=0.1 \
 //x=65.465 //y=0.72 //x2=65.065 //y2=0.72
r71 (  10 35 ) resistor r=1.40859 //w=0.34 //l=0.125 //layer=li \
 //thickness=0.1 //x=64.58 //y=1.685 //x2=64.58 //y2=1.81
r72 (  10 35 ) resistor r=42.0963 //w=0.187 //l=0.615 //layer=li \
 //thickness=0.1 //x=64.58 //y=1.685 //x2=64.58 //y2=1.07
r73 (  9 35 ) resistor r=3.57586 //w=0.17 //l=0.125 //layer=li //thickness=0.1 \
 //x=64.58 //y=0.805 //x2=64.58 //y2=0.68
r74 (  9 35 ) resistor r=18.139 //w=0.187 //l=0.265 //layer=li //thickness=0.1 \
 //x=64.58 //y=0.805 //x2=64.58 //y2=1.07
r75 (  6 35 ) resistor r=3.57586 //w=0.17 //l=0.103078 //layer=li \
 //thickness=0.1 //x=63.695 //y=1.77 //x2=63.61 //y2=1.81
r76 (  6 35 ) resistor r=27.3797 //w=0.187 //l=0.4 //layer=li //thickness=0.1 \
 //x=63.695 //y=1.77 //x2=64.095 //y2=1.77
r77 (  5 35 ) resistor r=5.4201 //w=0.17 //l=0.103078 //layer=li \
 //thickness=0.1 //x=64.495 //y=1.77 //x2=64.58 //y2=1.81
r78 (  5 35 ) resistor r=27.3797 //w=0.187 //l=0.4 //layer=li //thickness=0.1 \
 //x=64.495 //y=1.77 //x2=64.095 //y2=1.77
r79 (  1 35 ) resistor r=3.57586 //w=0.17 //l=0.125 //layer=li //thickness=0.1 \
 //x=63.61 //y=1.685 //x2=63.61 //y2=1.81
r80 (  1 35 ) resistor r=42.0963 //w=0.187 //l=0.615 //layer=li \
 //thickness=0.1 //x=63.61 //y=1.685 //x2=63.61 //y2=1.07
ends PM_TMRDFFSNRNQX1\%noxref_60

subckt PM_TMRDFFSNRNQX1\%noxref_61 ( 1 5 9 13 17 35 )
c58 ( 35 0 ) capacitor c=0.0691212f //x=68.285 //y=0.555
c59 ( 17 0 ) capacitor c=0.0190725f //x=70.275 //y=1.77
c60 ( 13 0 ) capacitor c=0.015325f //x=70.275 //y=0.72
c61 ( 9 0 ) capacitor c=0.00772076f //x=69.39 //y=0.805
c62 ( 5 0 ) capacitor c=0.0167789f //x=69.305 //y=1.77
c63 ( 1 0 ) capacitor c=0.00710458f //x=68.42 //y=1.685
r64 (  18 35 ) resistor r=5.4201 //w=0.17 //l=0.103078 //layer=li \
 //thickness=0.1 //x=69.475 //y=1.77 //x2=69.39 //y2=1.81
r65 (  18 35 ) resistor r=27.3797 //w=0.187 //l=0.4 //layer=li //thickness=0.1 \
 //x=69.475 //y=1.77 //x2=69.875 //y2=1.77
r66 (  17 35 ) resistor r=0.751729 //w=0.17 //l=0.085 //layer=li \
 //thickness=0.1 //x=70.275 //y=1.77 //x2=70.36 //y2=1.77
r67 (  17 35 ) resistor r=27.3797 //w=0.187 //l=0.4 //layer=li //thickness=0.1 \
 //x=70.275 //y=1.77 //x2=69.875 //y2=1.77
r68 (  14 35 ) resistor r=3.57586 //w=0.17 //l=0.103078 //layer=li \
 //thickness=0.1 //x=69.475 //y=0.72 //x2=69.39 //y2=0.68
r69 (  14 35 ) resistor r=27.3797 //w=0.187 //l=0.4 //layer=li //thickness=0.1 \
 //x=69.475 //y=0.72 //x2=69.875 //y2=0.72
r70 (  13 35 ) resistor r=0.751729 //w=0.17 //l=0.085 //layer=li \
 //thickness=0.1 //x=70.275 //y=0.72 //x2=70.36 //y2=0.72
r71 (  13 35 ) resistor r=27.3797 //w=0.187 //l=0.4 //layer=li //thickness=0.1 \
 //x=70.275 //y=0.72 //x2=69.875 //y2=0.72
r72 (  10 35 ) resistor r=1.40859 //w=0.34 //l=0.125 //layer=li \
 //thickness=0.1 //x=69.39 //y=1.685 //x2=69.39 //y2=1.81
r73 (  10 35 ) resistor r=42.0963 //w=0.187 //l=0.615 //layer=li \
 //thickness=0.1 //x=69.39 //y=1.685 //x2=69.39 //y2=1.07
r74 (  9 35 ) resistor r=3.57586 //w=0.17 //l=0.125 //layer=li //thickness=0.1 \
 //x=69.39 //y=0.805 //x2=69.39 //y2=0.68
r75 (  9 35 ) resistor r=18.139 //w=0.187 //l=0.265 //layer=li //thickness=0.1 \
 //x=69.39 //y=0.805 //x2=69.39 //y2=1.07
r76 (  6 35 ) resistor r=3.57586 //w=0.17 //l=0.103078 //layer=li \
 //thickness=0.1 //x=68.505 //y=1.77 //x2=68.42 //y2=1.81
r77 (  6 35 ) resistor r=27.3797 //w=0.187 //l=0.4 //layer=li //thickness=0.1 \
 //x=68.505 //y=1.77 //x2=68.905 //y2=1.77
r78 (  5 35 ) resistor r=5.4201 //w=0.17 //l=0.103078 //layer=li \
 //thickness=0.1 //x=69.305 //y=1.77 //x2=69.39 //y2=1.81
r79 (  5 35 ) resistor r=27.3797 //w=0.187 //l=0.4 //layer=li //thickness=0.1 \
 //x=69.305 //y=1.77 //x2=68.905 //y2=1.77
r80 (  1 35 ) resistor r=3.57586 //w=0.17 //l=0.125 //layer=li //thickness=0.1 \
 //x=68.42 //y=1.685 //x2=68.42 //y2=1.81
r81 (  1 35 ) resistor r=42.0963 //w=0.187 //l=0.615 //layer=li \
 //thickness=0.1 //x=68.42 //y=1.685 //x2=68.42 //y2=1.07
ends PM_TMRDFFSNRNQX1\%noxref_61

subckt PM_TMRDFFSNRNQX1\%noxref_62 ( 1 5 9 13 17 35 )
c59 ( 35 0 ) capacitor c=0.0691212f //x=73.095 //y=0.555
c60 ( 17 0 ) capacitor c=0.0190725f //x=75.085 //y=1.77
c61 ( 13 0 ) capacitor c=0.015325f //x=75.085 //y=0.72
c62 ( 9 0 ) capacitor c=0.00772076f //x=74.2 //y=0.805
c63 ( 5 0 ) capacitor c=0.0167589f //x=74.115 //y=1.77
c64 ( 1 0 ) capacitor c=0.00710458f //x=73.23 //y=1.685
r65 (  18 35 ) resistor r=5.4201 //w=0.17 //l=0.103078 //layer=li \
 //thickness=0.1 //x=74.285 //y=1.77 //x2=74.2 //y2=1.81
r66 (  18 35 ) resistor r=27.3797 //w=0.187 //l=0.4 //layer=li //thickness=0.1 \
 //x=74.285 //y=1.77 //x2=74.685 //y2=1.77
r67 (  17 35 ) resistor r=0.751729 //w=0.17 //l=0.085 //layer=li \
 //thickness=0.1 //x=75.085 //y=1.77 //x2=75.17 //y2=1.77
r68 (  17 35 ) resistor r=27.3797 //w=0.187 //l=0.4 //layer=li //thickness=0.1 \
 //x=75.085 //y=1.77 //x2=74.685 //y2=1.77
r69 (  14 35 ) resistor r=3.57586 //w=0.17 //l=0.103078 //layer=li \
 //thickness=0.1 //x=74.285 //y=0.72 //x2=74.2 //y2=0.68
r70 (  14 35 ) resistor r=27.3797 //w=0.187 //l=0.4 //layer=li //thickness=0.1 \
 //x=74.285 //y=0.72 //x2=74.685 //y2=0.72
r71 (  13 35 ) resistor r=0.751729 //w=0.17 //l=0.085 //layer=li \
 //thickness=0.1 //x=75.085 //y=0.72 //x2=75.17 //y2=0.72
r72 (  13 35 ) resistor r=27.3797 //w=0.187 //l=0.4 //layer=li //thickness=0.1 \
 //x=75.085 //y=0.72 //x2=74.685 //y2=0.72
r73 (  10 35 ) resistor r=1.40859 //w=0.34 //l=0.125 //layer=li \
 //thickness=0.1 //x=74.2 //y=1.685 //x2=74.2 //y2=1.81
r74 (  10 35 ) resistor r=42.0963 //w=0.187 //l=0.615 //layer=li \
 //thickness=0.1 //x=74.2 //y=1.685 //x2=74.2 //y2=1.07
r75 (  9 35 ) resistor r=3.57586 //w=0.17 //l=0.125 //layer=li //thickness=0.1 \
 //x=74.2 //y=0.805 //x2=74.2 //y2=0.68
r76 (  9 35 ) resistor r=18.139 //w=0.187 //l=0.265 //layer=li //thickness=0.1 \
 //x=74.2 //y=0.805 //x2=74.2 //y2=1.07
r77 (  6 35 ) resistor r=3.57586 //w=0.17 //l=0.103078 //layer=li \
 //thickness=0.1 //x=73.315 //y=1.77 //x2=73.23 //y2=1.81
r78 (  6 35 ) resistor r=27.3797 //w=0.187 //l=0.4 //layer=li //thickness=0.1 \
 //x=73.315 //y=1.77 //x2=73.715 //y2=1.77
r79 (  5 35 ) resistor r=5.4201 //w=0.17 //l=0.103078 //layer=li \
 //thickness=0.1 //x=74.115 //y=1.77 //x2=74.2 //y2=1.81
r80 (  5 35 ) resistor r=27.3797 //w=0.187 //l=0.4 //layer=li //thickness=0.1 \
 //x=74.115 //y=1.77 //x2=73.715 //y2=1.77
r81 (  1 35 ) resistor r=3.57586 //w=0.17 //l=0.125 //layer=li //thickness=0.1 \
 //x=73.23 //y=1.685 //x2=73.23 //y2=1.81
r82 (  1 35 ) resistor r=42.0963 //w=0.187 //l=0.615 //layer=li \
 //thickness=0.1 //x=73.23 //y=1.685 //x2=73.23 //y2=1.07
ends PM_TMRDFFSNRNQX1\%noxref_62

subckt PM_TMRDFFSNRNQX1\%noxref_63 ( 1 5 9 13 17 35 )
c58 ( 35 0 ) capacitor c=0.069559f //x=77.905 //y=0.555
c59 ( 17 0 ) capacitor c=0.0190918f //x=79.895 //y=1.77
c60 ( 13 0 ) capacitor c=0.0153483f //x=79.895 //y=0.72
c61 ( 9 0 ) capacitor c=0.00772076f //x=79.01 //y=0.805
c62 ( 5 0 ) capacitor c=0.0168501f //x=78.925 //y=1.77
c63 ( 1 0 ) capacitor c=0.00710458f //x=78.04 //y=1.685
r64 (  18 35 ) resistor r=5.4201 //w=0.17 //l=0.103078 //layer=li \
 //thickness=0.1 //x=79.095 //y=1.77 //x2=79.01 //y2=1.81
r65 (  18 35 ) resistor r=27.3797 //w=0.187 //l=0.4 //layer=li //thickness=0.1 \
 //x=79.095 //y=1.77 //x2=79.495 //y2=1.77
r66 (  17 35 ) resistor r=0.751729 //w=0.17 //l=0.085 //layer=li \
 //thickness=0.1 //x=79.895 //y=1.77 //x2=79.98 //y2=1.77
r67 (  17 35 ) resistor r=27.3797 //w=0.187 //l=0.4 //layer=li //thickness=0.1 \
 //x=79.895 //y=1.77 //x2=79.495 //y2=1.77
r68 (  14 35 ) resistor r=3.57586 //w=0.17 //l=0.103078 //layer=li \
 //thickness=0.1 //x=79.095 //y=0.72 //x2=79.01 //y2=0.68
r69 (  14 35 ) resistor r=27.3797 //w=0.187 //l=0.4 //layer=li //thickness=0.1 \
 //x=79.095 //y=0.72 //x2=79.495 //y2=0.72
r70 (  13 35 ) resistor r=0.751729 //w=0.17 //l=0.085 //layer=li \
 //thickness=0.1 //x=79.895 //y=0.72 //x2=79.98 //y2=0.72
r71 (  13 35 ) resistor r=27.3797 //w=0.187 //l=0.4 //layer=li //thickness=0.1 \
 //x=79.895 //y=0.72 //x2=79.495 //y2=0.72
r72 (  10 35 ) resistor r=1.40859 //w=0.34 //l=0.125 //layer=li \
 //thickness=0.1 //x=79.01 //y=1.685 //x2=79.01 //y2=1.81
r73 (  10 35 ) resistor r=42.0963 //w=0.187 //l=0.615 //layer=li \
 //thickness=0.1 //x=79.01 //y=1.685 //x2=79.01 //y2=1.07
r74 (  9 35 ) resistor r=3.57586 //w=0.17 //l=0.125 //layer=li //thickness=0.1 \
 //x=79.01 //y=0.805 //x2=79.01 //y2=0.68
r75 (  9 35 ) resistor r=18.139 //w=0.187 //l=0.265 //layer=li //thickness=0.1 \
 //x=79.01 //y=0.805 //x2=79.01 //y2=1.07
r76 (  6 35 ) resistor r=3.57586 //w=0.17 //l=0.103078 //layer=li \
 //thickness=0.1 //x=78.125 //y=1.77 //x2=78.04 //y2=1.81
r77 (  6 35 ) resistor r=27.3797 //w=0.187 //l=0.4 //layer=li //thickness=0.1 \
 //x=78.125 //y=1.77 //x2=78.525 //y2=1.77
r78 (  5 35 ) resistor r=5.4201 //w=0.17 //l=0.103078 //layer=li \
 //thickness=0.1 //x=78.925 //y=1.77 //x2=79.01 //y2=1.81
r79 (  5 35 ) resistor r=27.3797 //w=0.187 //l=0.4 //layer=li //thickness=0.1 \
 //x=78.925 //y=1.77 //x2=78.525 //y2=1.77
r80 (  1 35 ) resistor r=3.57586 //w=0.17 //l=0.125 //layer=li //thickness=0.1 \
 //x=78.04 //y=1.685 //x2=78.04 //y2=1.81
r81 (  1 35 ) resistor r=42.0963 //w=0.187 //l=0.615 //layer=li \
 //thickness=0.1 //x=78.04 //y=1.685 //x2=78.04 //y2=1.07
ends PM_TMRDFFSNRNQX1\%noxref_63

subckt PM_TMRDFFSNRNQX1\%noxref_64 ( 1 5 9 13 17 35 )
c59 ( 35 0 ) capacitor c=0.0691304f //x=82.715 //y=0.555
c60 ( 17 0 ) capacitor c=0.0190725f //x=84.705 //y=1.77
c61 ( 13 0 ) capacitor c=0.015325f //x=84.705 //y=0.72
c62 ( 9 0 ) capacitor c=0.00772076f //x=83.82 //y=0.805
c63 ( 5 0 ) capacitor c=0.0167688f //x=83.735 //y=1.77
c64 ( 1 0 ) capacitor c=0.00710458f //x=82.85 //y=1.685
r65 (  18 35 ) resistor r=5.4201 //w=0.17 //l=0.103078 //layer=li \
 //thickness=0.1 //x=83.905 //y=1.77 //x2=83.82 //y2=1.81
r66 (  18 35 ) resistor r=27.3797 //w=0.187 //l=0.4 //layer=li //thickness=0.1 \
 //x=83.905 //y=1.77 //x2=84.305 //y2=1.77
r67 (  17 35 ) resistor r=0.751729 //w=0.17 //l=0.085 //layer=li \
 //thickness=0.1 //x=84.705 //y=1.77 //x2=84.79 //y2=1.77
r68 (  17 35 ) resistor r=27.3797 //w=0.187 //l=0.4 //layer=li //thickness=0.1 \
 //x=84.705 //y=1.77 //x2=84.305 //y2=1.77
r69 (  14 35 ) resistor r=3.57586 //w=0.17 //l=0.103078 //layer=li \
 //thickness=0.1 //x=83.905 //y=0.72 //x2=83.82 //y2=0.68
r70 (  14 35 ) resistor r=27.3797 //w=0.187 //l=0.4 //layer=li //thickness=0.1 \
 //x=83.905 //y=0.72 //x2=84.305 //y2=0.72
r71 (  13 35 ) resistor r=0.751729 //w=0.17 //l=0.085 //layer=li \
 //thickness=0.1 //x=84.705 //y=0.72 //x2=84.79 //y2=0.72
r72 (  13 35 ) resistor r=27.3797 //w=0.187 //l=0.4 //layer=li //thickness=0.1 \
 //x=84.705 //y=0.72 //x2=84.305 //y2=0.72
r73 (  10 35 ) resistor r=1.40859 //w=0.34 //l=0.125 //layer=li \
 //thickness=0.1 //x=83.82 //y=1.685 //x2=83.82 //y2=1.81
r74 (  10 35 ) resistor r=42.0963 //w=0.187 //l=0.615 //layer=li \
 //thickness=0.1 //x=83.82 //y=1.685 //x2=83.82 //y2=1.07
r75 (  9 35 ) resistor r=3.57586 //w=0.17 //l=0.125 //layer=li //thickness=0.1 \
 //x=83.82 //y=0.805 //x2=83.82 //y2=0.68
r76 (  9 35 ) resistor r=18.139 //w=0.187 //l=0.265 //layer=li //thickness=0.1 \
 //x=83.82 //y=0.805 //x2=83.82 //y2=1.07
r77 (  6 35 ) resistor r=3.57586 //w=0.17 //l=0.103078 //layer=li \
 //thickness=0.1 //x=82.935 //y=1.77 //x2=82.85 //y2=1.81
r78 (  6 35 ) resistor r=27.3797 //w=0.187 //l=0.4 //layer=li //thickness=0.1 \
 //x=82.935 //y=1.77 //x2=83.335 //y2=1.77
r79 (  5 35 ) resistor r=5.4201 //w=0.17 //l=0.103078 //layer=li \
 //thickness=0.1 //x=83.735 //y=1.77 //x2=83.82 //y2=1.81
r80 (  5 35 ) resistor r=27.3797 //w=0.187 //l=0.4 //layer=li //thickness=0.1 \
 //x=83.735 //y=1.77 //x2=83.335 //y2=1.77
r81 (  1 35 ) resistor r=3.57586 //w=0.17 //l=0.125 //layer=li //thickness=0.1 \
 //x=82.85 //y=1.685 //x2=82.85 //y2=1.81
r82 (  1 35 ) resistor r=42.0963 //w=0.187 //l=0.615 //layer=li \
 //thickness=0.1 //x=82.85 //y=1.685 //x2=82.85 //y2=1.07
ends PM_TMRDFFSNRNQX1\%noxref_64

subckt PM_TMRDFFSNRNQX1\%noxref_65 ( 1 5 9 10 13 17 29 )
c67 ( 29 0 ) capacitor c=0.0764215f //x=87.63 //y=0.545
c68 ( 17 0 ) capacitor c=0.00678917f //x=89.705 //y=0.795
c69 ( 13 0 ) capacitor c=0.0154047f //x=89.62 //y=0.71
c70 ( 10 0 ) capacitor c=0.00748068f //x=88.735 //y=1.675
c71 ( 9 0 ) capacitor c=0.00770028f //x=88.735 //y=0.795
c72 ( 5 0 ) capacitor c=0.0203276f //x=88.65 //y=1.76
c73 ( 1 0 ) capacitor c=0.00454619f //x=87.765 //y=1.675
r74 (  17 29 ) resistor r=3.57586 //w=0.17 //l=0.125 //layer=li \
 //thickness=0.1 //x=89.705 //y=0.795 //x2=89.705 //y2=0.67
r75 (  17 29 ) resistor r=41.4118 //w=0.187 //l=0.605 //layer=li \
 //thickness=0.1 //x=89.705 //y=0.795 //x2=89.705 //y2=1.4
r76 (  14 29 ) resistor r=3.57586 //w=0.17 //l=0.103078 //layer=li \
 //thickness=0.1 //x=88.82 //y=0.71 //x2=88.735 //y2=0.67
r77 (  14 29 ) resistor r=27.0374 //w=0.187 //l=0.395 //layer=li \
 //thickness=0.1 //x=88.82 //y=0.71 //x2=89.215 //y2=0.71
r78 (  13 29 ) resistor r=3.57586 //w=0.17 //l=0.103078 //layer=li \
 //thickness=0.1 //x=89.62 //y=0.71 //x2=89.705 //y2=0.67
r79 (  13 29 ) resistor r=27.7219 //w=0.187 //l=0.405 //layer=li \
 //thickness=0.1 //x=89.62 //y=0.71 //x2=89.215 //y2=0.71
r80 (  10 29 ) resistor r=3.57586 //w=0.17 //l=0.125 //layer=li \
 //thickness=0.1 //x=88.735 //y=1.675 //x2=88.735 //y2=1.8
r81 (  10 29 ) resistor r=42.0963 //w=0.187 //l=0.615 //layer=li \
 //thickness=0.1 //x=88.735 //y=1.675 //x2=88.735 //y2=1.06
r82 (  9 29 ) resistor r=3.57586 //w=0.17 //l=0.125 //layer=li //thickness=0.1 \
 //x=88.735 //y=0.795 //x2=88.735 //y2=0.67
r83 (  9 29 ) resistor r=18.139 //w=0.187 //l=0.265 //layer=li //thickness=0.1 \
 //x=88.735 //y=0.795 //x2=88.735 //y2=1.06
r84 (  6 29 ) resistor r=3.57586 //w=0.17 //l=0.103078 //layer=li \
 //thickness=0.1 //x=87.85 //y=1.76 //x2=87.765 //y2=1.8
r85 (  6 29 ) resistor r=27.3797 //w=0.187 //l=0.4 //layer=li //thickness=0.1 \
 //x=87.85 //y=1.76 //x2=88.25 //y2=1.76
r86 (  5 29 ) resistor r=3.57586 //w=0.17 //l=0.103078 //layer=li \
 //thickness=0.1 //x=88.65 //y=1.76 //x2=88.735 //y2=1.8
r87 (  5 29 ) resistor r=27.3797 //w=0.187 //l=0.4 //layer=li //thickness=0.1 \
 //x=88.65 //y=1.76 //x2=88.25 //y2=1.76
r88 (  1 29 ) resistor r=3.57586 //w=0.17 //l=0.125 //layer=li //thickness=0.1 \
 //x=87.765 //y=1.675 //x2=87.765 //y2=1.8
r89 (  1 29 ) resistor r=42.0963 //w=0.187 //l=0.615 //layer=li \
 //thickness=0.1 //x=87.765 //y=1.675 //x2=87.765 //y2=1.06
ends PM_TMRDFFSNRNQX1\%noxref_65

subckt PM_TMRDFFSNRNQX1\%noxref_66 ( 1 5 9 10 13 17 29 )
c62 ( 29 0 ) capacitor c=0.0738181f //x=90.96 //y=0.545
c63 ( 17 0 ) capacitor c=0.00678917f //x=93.035 //y=0.795
c64 ( 13 0 ) capacitor c=0.0158009f //x=92.95 //y=0.71
c65 ( 10 0 ) capacitor c=0.00864691f //x=92.065 //y=1.675
c66 ( 9 0 ) capacitor c=0.00770028f //x=92.065 //y=0.795
c67 ( 5 0 ) capacitor c=0.0176916f //x=91.98 //y=1.76
c68 ( 1 0 ) capacitor c=0.00845775f //x=91.095 //y=1.675
r69 (  17 29 ) resistor r=3.57586 //w=0.17 //l=0.125 //layer=li \
 //thickness=0.1 //x=93.035 //y=0.795 //x2=93.035 //y2=0.67
r70 (  17 29 ) resistor r=41.4118 //w=0.187 //l=0.605 //layer=li \
 //thickness=0.1 //x=93.035 //y=0.795 //x2=93.035 //y2=1.4
r71 (  14 29 ) resistor r=3.57586 //w=0.17 //l=0.103078 //layer=li \
 //thickness=0.1 //x=92.15 //y=0.71 //x2=92.065 //y2=0.67
r72 (  14 29 ) resistor r=27.3797 //w=0.187 //l=0.4 //layer=li //thickness=0.1 \
 //x=92.15 //y=0.71 //x2=92.55 //y2=0.71
r73 (  13 29 ) resistor r=3.57586 //w=0.17 //l=0.103078 //layer=li \
 //thickness=0.1 //x=92.95 //y=0.71 //x2=93.035 //y2=0.67
r74 (  13 29 ) resistor r=27.3797 //w=0.187 //l=0.4 //layer=li //thickness=0.1 \
 //x=92.95 //y=0.71 //x2=92.55 //y2=0.71
r75 (  10 29 ) resistor r=3.57586 //w=0.17 //l=0.125 //layer=li \
 //thickness=0.1 //x=92.065 //y=1.675 //x2=92.065 //y2=1.8
r76 (  10 29 ) resistor r=42.0963 //w=0.187 //l=0.615 //layer=li \
 //thickness=0.1 //x=92.065 //y=1.675 //x2=92.065 //y2=1.06
r77 (  9 29 ) resistor r=3.57586 //w=0.17 //l=0.125 //layer=li //thickness=0.1 \
 //x=92.065 //y=0.795 //x2=92.065 //y2=0.67
r78 (  9 29 ) resistor r=18.139 //w=0.187 //l=0.265 //layer=li //thickness=0.1 \
 //x=92.065 //y=0.795 //x2=92.065 //y2=1.06
r79 (  6 29 ) resistor r=3.57586 //w=0.17 //l=0.103078 //layer=li \
 //thickness=0.1 //x=91.18 //y=1.76 //x2=91.095 //y2=1.8
r80 (  6 29 ) resistor r=27.3797 //w=0.187 //l=0.4 //layer=li //thickness=0.1 \
 //x=91.18 //y=1.76 //x2=91.58 //y2=1.76
r81 (  5 29 ) resistor r=3.57586 //w=0.17 //l=0.103078 //layer=li \
 //thickness=0.1 //x=91.98 //y=1.76 //x2=92.065 //y2=1.8
r82 (  5 29 ) resistor r=27.3797 //w=0.187 //l=0.4 //layer=li //thickness=0.1 \
 //x=91.98 //y=1.76 //x2=91.58 //y2=1.76
r83 (  1 29 ) resistor r=3.57586 //w=0.17 //l=0.125 //layer=li //thickness=0.1 \
 //x=91.095 //y=1.675 //x2=91.095 //y2=1.8
r84 (  1 29 ) resistor r=42.0963 //w=0.187 //l=0.615 //layer=li \
 //thickness=0.1 //x=91.095 //y=1.675 //x2=91.095 //y2=1.06
ends PM_TMRDFFSNRNQX1\%noxref_66

subckt PM_TMRDFFSNRNQX1\%noxref_67 ( 1 5 9 10 13 17 29 )
c69 ( 29 0 ) capacitor c=0.0677164f //x=94.29 //y=0.545
c70 ( 17 0 ) capacitor c=0.00709795f //x=96.365 //y=0.795
c71 ( 13 0 ) capacitor c=0.0152565f //x=96.28 //y=0.71
c72 ( 10 0 ) capacitor c=0.00749806f //x=95.395 //y=1.675
c73 ( 9 0 ) capacitor c=0.00770028f //x=95.395 //y=0.795
c74 ( 5 0 ) capacitor c=0.0236235f //x=95.31 //y=1.76
c75 ( 1 0 ) capacitor c=0.00498238f //x=94.425 //y=1.675
r76 (  17 29 ) resistor r=3.57586 //w=0.17 //l=0.125 //layer=li \
 //thickness=0.1 //x=96.365 //y=0.795 //x2=96.365 //y2=0.67
r77 (  17 29 ) resistor r=18.139 //w=0.187 //l=0.265 //layer=li \
 //thickness=0.1 //x=96.365 //y=0.795 //x2=96.365 //y2=1.06
r78 (  14 29 ) resistor r=3.57586 //w=0.17 //l=0.103078 //layer=li \
 //thickness=0.1 //x=95.48 //y=0.71 //x2=95.395 //y2=0.67
r79 (  14 29 ) resistor r=27.3797 //w=0.187 //l=0.4 //layer=li //thickness=0.1 \
 //x=95.48 //y=0.71 //x2=95.88 //y2=0.71
r80 (  13 29 ) resistor r=3.57586 //w=0.17 //l=0.103078 //layer=li \
 //thickness=0.1 //x=96.28 //y=0.71 //x2=96.365 //y2=0.67
r81 (  13 29 ) resistor r=27.3797 //w=0.187 //l=0.4 //layer=li //thickness=0.1 \
 //x=96.28 //y=0.71 //x2=95.88 //y2=0.71
r82 (  10 29 ) resistor r=3.57586 //w=0.17 //l=0.125 //layer=li \
 //thickness=0.1 //x=95.395 //y=1.675 //x2=95.395 //y2=1.8
r83 (  10 29 ) resistor r=42.0963 //w=0.187 //l=0.615 //layer=li \
 //thickness=0.1 //x=95.395 //y=1.675 //x2=95.395 //y2=1.06
r84 (  9 29 ) resistor r=3.57586 //w=0.17 //l=0.125 //layer=li //thickness=0.1 \
 //x=95.395 //y=0.795 //x2=95.395 //y2=0.67
r85 (  9 29 ) resistor r=18.139 //w=0.187 //l=0.265 //layer=li //thickness=0.1 \
 //x=95.395 //y=0.795 //x2=95.395 //y2=1.06
r86 (  6 29 ) resistor r=3.57586 //w=0.17 //l=0.103078 //layer=li \
 //thickness=0.1 //x=94.51 //y=1.76 //x2=94.425 //y2=1.8
r87 (  6 29 ) resistor r=27.3797 //w=0.187 //l=0.4 //layer=li //thickness=0.1 \
 //x=94.51 //y=1.76 //x2=94.91 //y2=1.76
r88 (  5 29 ) resistor r=3.57586 //w=0.17 //l=0.103078 //layer=li \
 //thickness=0.1 //x=95.31 //y=1.76 //x2=95.395 //y2=1.8
r89 (  5 29 ) resistor r=27.3797 //w=0.187 //l=0.4 //layer=li //thickness=0.1 \
 //x=95.31 //y=1.76 //x2=94.91 //y2=1.76
r90 (  1 29 ) resistor r=3.57586 //w=0.17 //l=0.125 //layer=li //thickness=0.1 \
 //x=94.425 //y=1.675 //x2=94.425 //y2=1.8
r91 (  1 29 ) resistor r=42.0963 //w=0.187 //l=0.615 //layer=li \
 //thickness=0.1 //x=94.425 //y=1.675 //x2=94.425 //y2=1.06
ends PM_TMRDFFSNRNQX1\%noxref_67
