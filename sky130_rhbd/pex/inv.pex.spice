// File: inv.spi.pex
// Created: Tue Apr 29 10:49:49 2025
// Program "Calibre xRC"
// Version "v2023.2_27.15"
// Nominal Temperature: 30C
// Circuit Temperature: 30C
//
simulator lang=spectre
subckt PM_INV\%A ( 1 3 7 8 16 )
c9 ( 16 0 ) capacitor c=0.0718082f //x=-0.119 //y=0.56
c10 ( 8 0 ) capacitor c=0.0833265f //x=0.075 //y=1.195
c11 ( 7 0 ) capacitor c=0.0709645f //x=0.075 //y=0.005
c12 ( 3 0 ) capacitor c=0.012557f //x=-0.119 //y=0.56
r13 (  16 18 ) resistor r=56.5354 //w=0.414 //l=0.19 //layer=ply \
 //thickness=0.18 //x=-0.085 //y=0.56 //x2=-0.085 //y2=0.75
r14 (  16 17 ) resistor r=55.9533 //w=0.414 //l=0.185 //layer=ply \
 //thickness=0.18 //x=-0.085 //y=0.56 //x2=-0.085 //y2=0.375
r15 (  8 18 ) resistor r=228.181 //w=0.094 //l=0.445 //layer=ply \
 //thickness=0.18 //x=0.075 //y=1.195 //x2=0.075 //y2=0.75
r16 (  7 17 ) resistor r=189.723 //w=0.094 //l=0.37 //layer=ply \
 //thickness=0.18 //x=0.075 //y=0.005 //x2=0.075 //y2=0.375
r17 (  3 16 ) resistor r=152 //w=0.17 //l=0.17 //layer=licon //count=1 \
 //x=-0.119 //y=0.56 //x2=-0.119 //y2=0.56
r18 (  1 3 ) resistor r=0.249027 //w=0.257 //l=0.005 //layer=li \
 //thickness=0.1 //x=-0.12 //y=0.565 //x2=-0.12 //y2=0.56
ends PM_INV\%A

subckt PM_INV\%Y ( 1 9 11 )
c5 ( 9 0 ) capacitor c=0.0848727f //x=0.15 //y=-0.205
r6 (  1 11 ) resistor r=41.0695 //w=0.187 //l=0.6 //layer=li //thickness=0.1 \
 //x=0.29 //y=0.675 //x2=0.29 //y2=1.275
r7 (  1 9 ) resistor r=51.2684 //w=0.187 //l=0.749 //layer=li //thickness=0.1 \
 //x=0.29 //y=0.675 //x2=0.29 //y2=-0.074
ends PM_INV\%Y
