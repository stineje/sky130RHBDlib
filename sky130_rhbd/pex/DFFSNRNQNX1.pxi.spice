// File: DFFSNRNQNX1.spi.DFFSNRNQNX1.pxi
// Created: Tue Apr 29 10:40:51 2025
//
simulator lang=spectre
x_PM_DFFSNRNQNX1\%GND ( GND N_GND_c_8_p N_GND_c_117_p N_GND_c_1_p N_GND_c_9_p \
 N_GND_c_10_p N_GND_c_14_p N_GND_c_15_p N_GND_c_38_p N_GND_c_45_p N_GND_c_52_p \
 N_GND_c_65_p N_GND_c_72_p N_GND_c_84_p N_GND_c_2_p N_GND_c_3_p N_GND_c_4_p \
 N_GND_c_5_p N_GND_c_6_p N_GND_c_7_p N_GND_M0_noxref_d N_GND_M3_noxref_d \
 N_GND_M6_noxref_d N_GND_M9_noxref_d N_GND_M12_noxref_d N_GND_M15_noxref_d )  \
 PM_DFFSNRNQNX1\%GND
x_PM_DFFSNRNQNX1\%VDD ( VDD N_VDD_c_315_p N_VDD_c_308_n N_VDD_c_316_p \
 N_VDD_c_317_p N_VDD_c_323_p N_VDD_c_327_p N_VDD_c_461_p N_VDD_c_336_p \
 N_VDD_c_406_p N_VDD_c_424_p N_VDD_c_428_p N_VDD_c_464_p N_VDD_c_340_p \
 N_VDD_c_365_p N_VDD_c_371_p N_VDD_c_375_p N_VDD_c_467_p N_VDD_c_381_p \
 N_VDD_c_410_p N_VDD_c_492_p N_VDD_c_477_p N_VDD_c_478_p N_VDD_c_438_p \
 N_VDD_c_496_p N_VDD_c_509_p N_VDD_c_513_p N_VDD_c_555_p N_VDD_c_518_p \
 N_VDD_c_547_p N_VDD_c_587_p N_VDD_c_309_n N_VDD_c_310_n N_VDD_c_311_n \
 N_VDD_c_312_n N_VDD_c_313_n N_VDD_c_314_n N_VDD_M18_noxref_s \
 N_VDD_M19_noxref_d N_VDD_M21_noxref_d N_VDD_M23_noxref_d N_VDD_M24_noxref_s \
 N_VDD_M25_noxref_d N_VDD_M27_noxref_d N_VDD_M29_noxref_d N_VDD_M30_noxref_s \
 N_VDD_M31_noxref_d N_VDD_M33_noxref_d N_VDD_M35_noxref_d N_VDD_M36_noxref_s \
 N_VDD_M37_noxref_d N_VDD_M39_noxref_d N_VDD_M41_noxref_d N_VDD_M42_noxref_s \
 N_VDD_M43_noxref_d N_VDD_M45_noxref_d N_VDD_M47_noxref_d N_VDD_M48_noxref_s \
 N_VDD_M49_noxref_d N_VDD_M51_noxref_d N_VDD_M53_noxref_d )  PM_DFFSNRNQNX1\%VDD
x_PM_DFFSNRNQNX1\%noxref_3 ( N_noxref_3_c_650_n N_noxref_3_c_654_n \
 N_noxref_3_c_655_n N_noxref_3_c_659_n N_noxref_3_c_684_n N_noxref_3_c_688_n \
 N_noxref_3_c_690_n N_noxref_3_c_694_n N_noxref_3_c_660_n N_noxref_3_c_769_p \
 N_noxref_3_c_698_n N_noxref_3_c_661_n N_noxref_3_c_662_n N_noxref_3_c_816_p \
 N_noxref_3_c_780_p N_noxref_3_M3_noxref_g N_noxref_3_M6_noxref_g \
 N_noxref_3_M24_noxref_g N_noxref_3_M25_noxref_g N_noxref_3_M30_noxref_g \
 N_noxref_3_M31_noxref_g N_noxref_3_c_663_n N_noxref_3_c_665_n \
 N_noxref_3_c_666_n N_noxref_3_c_667_n N_noxref_3_c_668_n N_noxref_3_c_669_n \
 N_noxref_3_c_670_n N_noxref_3_c_672_n N_noxref_3_c_746_p N_noxref_3_c_713_n \
 N_noxref_3_c_673_n N_noxref_3_c_675_n N_noxref_3_c_676_n N_noxref_3_c_677_n \
 N_noxref_3_c_678_n N_noxref_3_c_679_n N_noxref_3_c_680_n N_noxref_3_c_682_n \
 N_noxref_3_c_735_p N_noxref_3_c_715_n N_noxref_3_M2_noxref_d \
 N_noxref_3_M18_noxref_d N_noxref_3_M20_noxref_d N_noxref_3_M22_noxref_d )  \
 PM_DFFSNRNQNX1\%noxref_3
x_PM_DFFSNRNQNX1\%noxref_4 ( N_noxref_4_c_901_n N_noxref_4_c_954_n \
 N_noxref_4_c_915_n N_noxref_4_c_919_n N_noxref_4_c_921_n N_noxref_4_c_925_n \
 N_noxref_4_c_902_n N_noxref_4_c_999_p N_noxref_4_c_929_n N_noxref_4_c_903_n \
 N_noxref_4_c_1009_p N_noxref_4_c_1017_p N_noxref_4_M9_noxref_g \
 N_noxref_4_M36_noxref_g N_noxref_4_M37_noxref_g N_noxref_4_c_904_n \
 N_noxref_4_c_906_n N_noxref_4_c_907_n N_noxref_4_c_908_n N_noxref_4_c_909_n \
 N_noxref_4_c_910_n N_noxref_4_c_911_n N_noxref_4_c_913_n N_noxref_4_c_967_p \
 N_noxref_4_c_937_n N_noxref_4_M8_noxref_d N_noxref_4_M30_noxref_d \
 N_noxref_4_M32_noxref_d N_noxref_4_M34_noxref_d )  PM_DFFSNRNQNX1\%noxref_4
x_PM_DFFSNRNQNX1\%CLK ( N_CLK_c_1061_n N_CLK_c_1078_n CLK CLK CLK CLK CLK \
 N_CLK_c_1062_n N_CLK_c_1063_n N_CLK_M4_noxref_g N_CLK_M10_noxref_g \
 N_CLK_M26_noxref_g N_CLK_M27_noxref_g N_CLK_M38_noxref_g N_CLK_M39_noxref_g \
 N_CLK_c_1090_n N_CLK_c_1093_n N_CLK_c_1216_p N_CLK_c_1223_p N_CLK_c_1095_n \
 N_CLK_c_1096_n N_CLK_c_1097_n N_CLK_c_1098_n N_CLK_c_1142_p N_CLK_c_1117_n \
 N_CLK_c_1120_n N_CLK_c_1239_p N_CLK_c_1246_p N_CLK_c_1122_n N_CLK_c_1123_n \
 N_CLK_c_1124_n N_CLK_c_1125_n N_CLK_c_1150_p N_CLK_c_1101_n N_CLK_c_1127_n )  \
 PM_DFFSNRNQNX1\%CLK
x_PM_DFFSNRNQNX1\%noxref_6 ( N_noxref_6_c_1251_n N_noxref_6_c_1252_n \
 N_noxref_6_c_1253_n N_noxref_6_c_1323_n N_noxref_6_c_1254_n \
 N_noxref_6_c_1270_n N_noxref_6_c_1274_n N_noxref_6_c_1276_n \
 N_noxref_6_c_1280_n N_noxref_6_c_1255_n N_noxref_6_c_1333_n \
 N_noxref_6_c_1284_n N_noxref_6_c_1256_n N_noxref_6_c_1373_n \
 N_noxref_6_c_1454_p N_noxref_6_M2_noxref_g N_noxref_6_M12_noxref_g \
 N_noxref_6_M22_noxref_g N_noxref_6_M23_noxref_g N_noxref_6_M42_noxref_g \
 N_noxref_6_M43_noxref_g N_noxref_6_c_1340_n N_noxref_6_c_1341_n \
 N_noxref_6_c_1342_n N_noxref_6_c_1343_n N_noxref_6_c_1344_n \
 N_noxref_6_c_1346_n N_noxref_6_c_1347_n N_noxref_6_c_1257_n \
 N_noxref_6_c_1259_n N_noxref_6_c_1260_n N_noxref_6_c_1261_n \
 N_noxref_6_c_1262_n N_noxref_6_c_1263_n N_noxref_6_c_1264_n \
 N_noxref_6_c_1266_n N_noxref_6_c_1400_p N_noxref_6_c_1296_n \
 N_noxref_6_c_1349_n N_noxref_6_c_1350_n N_noxref_6_c_1352_n \
 N_noxref_6_M5_noxref_d N_noxref_6_M24_noxref_d N_noxref_6_M26_noxref_d \
 N_noxref_6_M28_noxref_d )  PM_DFFSNRNQNX1\%noxref_6
x_PM_DFFSNRNQNX1\%RN ( N_RN_c_1511_n N_RN_c_1512_n N_RN_c_1533_n N_RN_c_1539_n \
 RN RN RN RN RN RN RN RN RN RN RN RN RN N_RN_c_1513_n N_RN_c_1514_n \
 N_RN_c_1515_n N_RN_M1_noxref_g N_RN_M11_noxref_g N_RN_M13_noxref_g \
 N_RN_M20_noxref_g N_RN_M21_noxref_g N_RN_M40_noxref_g N_RN_M41_noxref_g \
 N_RN_M44_noxref_g N_RN_M45_noxref_g N_RN_c_1752_p N_RN_c_1754_p N_RN_c_1778_p \
 N_RN_c_1785_p N_RN_c_1641_n N_RN_c_1642_n N_RN_c_1643_n N_RN_c_1644_n \
 N_RN_c_1575_n N_RN_c_1600_n N_RN_c_1601_n N_RN_c_1602_n N_RN_c_1721_p \
 N_RN_c_1703_p N_RN_c_1723_p N_RN_c_1704_p N_RN_c_1648_n N_RN_c_1651_n \
 N_RN_c_1808_p N_RN_c_1815_p N_RN_c_1653_n N_RN_c_1654_n N_RN_c_1655_n \
 N_RN_c_1656_n N_RN_c_1671_p N_RN_c_1576_n N_RN_c_1603_n N_RN_c_1605_n \
 N_RN_c_1606_n N_RN_c_1660_n )  PM_DFFSNRNQNX1\%RN
x_PM_DFFSNRNQNX1\%QN ( N_QN_c_1820_n N_QN_c_1889_p QN QN QN QN QN QN QN QN QN \
 N_QN_c_1835_n N_QN_c_1839_n N_QN_c_1841_n N_QN_c_1845_n N_QN_c_1821_n \
 N_QN_c_1891_p N_QN_c_1822_n N_QN_c_1884_n N_QN_c_1933_p N_QN_M15_noxref_g \
 N_QN_M48_noxref_g N_QN_M49_noxref_g N_QN_c_1823_n N_QN_c_1825_n N_QN_c_1826_n \
 N_QN_c_1827_n N_QN_c_1828_n N_QN_c_1829_n N_QN_c_1830_n N_QN_c_1832_n \
 N_QN_c_1898_p N_QN_c_1856_n N_QN_M14_noxref_d N_QN_M42_noxref_d \
 N_QN_M44_noxref_d N_QN_M46_noxref_d )  PM_DFFSNRNQNX1\%QN
x_PM_DFFSNRNQNX1\%SN ( N_SN_c_1977_n SN N_SN_c_1987_n N_SN_c_1988_n \
 N_SN_M7_noxref_g N_SN_M16_noxref_g N_SN_M32_noxref_g N_SN_M33_noxref_g \
 N_SN_M50_noxref_g N_SN_M51_noxref_g N_SN_c_2010_n N_SN_c_2013_n N_SN_c_2149_p \
 N_SN_c_2157_p N_SN_c_2015_n N_SN_c_2016_n N_SN_c_2017_n N_SN_c_2018_n \
 N_SN_c_2035_n N_SN_c_2069_n N_SN_c_2072_n N_SN_c_2189_p N_SN_c_2196_p \
 N_SN_c_2074_n N_SN_c_2075_n N_SN_c_2076_n N_SN_c_2077_n N_SN_c_2087_p \
 N_SN_c_2020_n N_SN_c_2079_n )  PM_DFFSNRNQNX1\%SN
x_PM_DFFSNRNQNX1\%noxref_10 ( N_noxref_10_c_2206_n N_noxref_10_c_2300_n \
 N_noxref_10_c_2207_n N_noxref_10_c_2270_n N_noxref_10_c_2208_n \
 N_noxref_10_c_2215_n N_noxref_10_c_2201_n N_noxref_10_c_2309_n \
 N_noxref_10_c_2202_n N_noxref_10_c_2217_n N_noxref_10_c_2221_n \
 N_noxref_10_c_2223_n N_noxref_10_c_2227_n N_noxref_10_c_2203_n \
 N_noxref_10_c_2441_n N_noxref_10_c_2231_n N_noxref_10_c_2204_n \
 N_noxref_10_c_2233_n N_noxref_10_c_2318_n N_noxref_10_c_2405_n \
 N_noxref_10_M5_noxref_g N_noxref_10_M8_noxref_g N_noxref_10_M17_noxref_g \
 N_noxref_10_M28_noxref_g N_noxref_10_M29_noxref_g N_noxref_10_M34_noxref_g \
 N_noxref_10_M35_noxref_g N_noxref_10_M52_noxref_g N_noxref_10_M53_noxref_g \
 N_noxref_10_c_2322_n N_noxref_10_c_2323_n N_noxref_10_c_2324_n \
 N_noxref_10_c_2362_n N_noxref_10_c_2363_n N_noxref_10_c_2365_n \
 N_noxref_10_c_2366_n N_noxref_10_c_2283_n N_noxref_10_c_2284_n \
 N_noxref_10_c_2285_n N_noxref_10_c_2286_n N_noxref_10_c_2287_n \
 N_noxref_10_c_2289_n N_noxref_10_c_2290_n N_noxref_10_c_2456_n \
 N_noxref_10_c_2457_n N_noxref_10_c_2458_n N_noxref_10_c_2497_p \
 N_noxref_10_c_2483_p N_noxref_10_c_2499_p N_noxref_10_c_2484_p \
 N_noxref_10_c_2267_n N_noxref_10_c_2327_n N_noxref_10_c_2328_n \
 N_noxref_10_c_2292_n N_noxref_10_c_2293_n N_noxref_10_c_2295_n \
 N_noxref_10_c_2466_n N_noxref_10_c_2468_n N_noxref_10_c_2469_n \
 N_noxref_10_M11_noxref_d N_noxref_10_M36_noxref_d N_noxref_10_M38_noxref_d \
 N_noxref_10_M40_noxref_d )  PM_DFFSNRNQNX1\%noxref_10
x_PM_DFFSNRNQNX1\%noxref_11 ( N_noxref_11_c_2540_n N_noxref_11_c_2579_n \
 N_noxref_11_c_2541_n N_noxref_11_c_2546_n N_noxref_11_c_2550_n \
 N_noxref_11_c_2552_n N_noxref_11_c_2556_n N_noxref_11_c_2542_n \
 N_noxref_11_c_2692_p N_noxref_11_c_2560_n N_noxref_11_c_2640_n \
 N_noxref_11_c_2662_n N_noxref_11_M14_noxref_g N_noxref_11_M46_noxref_g \
 N_noxref_11_M47_noxref_g N_noxref_11_c_2589_n N_noxref_11_c_2590_n \
 N_noxref_11_c_2591_n N_noxref_11_c_2618_n N_noxref_11_c_2619_n \
 N_noxref_11_c_2621_n N_noxref_11_c_2622_n N_noxref_11_c_2592_n \
 N_noxref_11_c_2594_n N_noxref_11_c_2595_n N_noxref_11_M17_noxref_d \
 N_noxref_11_M48_noxref_d N_noxref_11_M50_noxref_d N_noxref_11_M52_noxref_d )  \
 PM_DFFSNRNQNX1\%noxref_11
x_PM_DFFSNRNQNX1\%D ( D D D D D D N_D_c_2697_n N_D_M0_noxref_g \
 N_D_M18_noxref_g N_D_M19_noxref_g N_D_c_2698_n N_D_c_2700_n N_D_c_2701_n \
 N_D_c_2702_n N_D_c_2703_n N_D_c_2704_n N_D_c_2705_n N_D_c_2707_n N_D_c_2720_n \
 N_D_c_2715_n )  PM_DFFSNRNQNX1\%D
x_PM_DFFSNRNQNX1\%noxref_13 ( N_noxref_13_c_2781_n N_noxref_13_c_2753_n \
 N_noxref_13_c_2757_n N_noxref_13_c_2760_n N_noxref_13_c_2772_n \
 N_noxref_13_M0_noxref_s )  PM_DFFSNRNQNX1\%noxref_13
x_PM_DFFSNRNQNX1\%noxref_14 ( N_noxref_14_c_2799_n N_noxref_14_c_2802_n \
 N_noxref_14_c_2805_n N_noxref_14_c_2808_n N_noxref_14_c_2816_n \
 N_noxref_14_M1_noxref_d N_noxref_14_M2_noxref_s )  PM_DFFSNRNQNX1\%noxref_14
x_PM_DFFSNRNQNX1\%noxref_15 ( N_noxref_15_c_2868_n N_noxref_15_c_2852_n \
 N_noxref_15_c_2856_n N_noxref_15_c_2859_n N_noxref_15_c_2879_n \
 N_noxref_15_M3_noxref_s )  PM_DFFSNRNQNX1\%noxref_15
x_PM_DFFSNRNQNX1\%noxref_16 ( N_noxref_16_c_2904_n N_noxref_16_c_2907_n \
 N_noxref_16_c_2910_n N_noxref_16_c_2913_n N_noxref_16_c_2936_n \
 N_noxref_16_M4_noxref_d N_noxref_16_M5_noxref_s )  PM_DFFSNRNQNX1\%noxref_16
x_PM_DFFSNRNQNX1\%noxref_17 ( N_noxref_17_c_2974_n N_noxref_17_c_2958_n \
 N_noxref_17_c_2962_n N_noxref_17_c_2965_n N_noxref_17_c_2988_n \
 N_noxref_17_M6_noxref_s )  PM_DFFSNRNQNX1\%noxref_17
x_PM_DFFSNRNQNX1\%noxref_18 ( N_noxref_18_c_3011_n N_noxref_18_c_3014_n \
 N_noxref_18_c_3017_n N_noxref_18_c_3020_n N_noxref_18_c_3028_n \
 N_noxref_18_M7_noxref_d N_noxref_18_M8_noxref_s )  PM_DFFSNRNQNX1\%noxref_18
x_PM_DFFSNRNQNX1\%noxref_19 ( N_noxref_19_c_3081_n N_noxref_19_c_3065_n \
 N_noxref_19_c_3069_n N_noxref_19_c_3072_n N_noxref_19_c_3095_n \
 N_noxref_19_M9_noxref_s )  PM_DFFSNRNQNX1\%noxref_19
x_PM_DFFSNRNQNX1\%noxref_20 ( N_noxref_20_c_3115_n N_noxref_20_c_3118_n \
 N_noxref_20_c_3121_n N_noxref_20_c_3124_n N_noxref_20_c_3146_n \
 N_noxref_20_M10_noxref_d N_noxref_20_M11_noxref_s )  PM_DFFSNRNQNX1\%noxref_20
x_PM_DFFSNRNQNX1\%noxref_21 ( N_noxref_21_c_3185_n N_noxref_21_c_3169_n \
 N_noxref_21_c_3173_n N_noxref_21_c_3176_n N_noxref_21_c_3197_n \
 N_noxref_21_M12_noxref_s )  PM_DFFSNRNQNX1\%noxref_21
x_PM_DFFSNRNQNX1\%noxref_22 ( N_noxref_22_c_3219_n N_noxref_22_c_3222_n \
 N_noxref_22_c_3225_n N_noxref_22_c_3228_n N_noxref_22_c_3248_n \
 N_noxref_22_M13_noxref_d N_noxref_22_M14_noxref_s )  PM_DFFSNRNQNX1\%noxref_22
x_PM_DFFSNRNQNX1\%noxref_23 ( N_noxref_23_c_3287_n N_noxref_23_c_3273_n \
 N_noxref_23_c_3277_n N_noxref_23_c_3280_n N_noxref_23_c_3303_n \
 N_noxref_23_M15_noxref_s )  PM_DFFSNRNQNX1\%noxref_23
x_PM_DFFSNRNQNX1\%noxref_24 ( N_noxref_24_c_3323_n N_noxref_24_c_3325_n \
 N_noxref_24_c_3328_n N_noxref_24_c_3330_n N_noxref_24_c_3351_n \
 N_noxref_24_M16_noxref_d N_noxref_24_M17_noxref_s )  PM_DFFSNRNQNX1\%noxref_24
cc_1 ( N_GND_c_1_p N_VDD_c_308_n ) capacitor c=0.00989514f //x=1.23 //y=0.18 \
 //x2=1.23 //y2=7.58
cc_2 ( N_GND_c_2_p N_VDD_c_309_n ) capacitor c=0.00989514f //x=28.61 //y=0.18 \
 //x2=28.61 //y2=7.58
cc_3 ( N_GND_c_3_p N_VDD_c_310_n ) capacitor c=0.0089209f //x=5.3 //y=0.175 \
 //x2=5.3 //y2=7.585
cc_4 ( N_GND_c_4_p N_VDD_c_311_n ) capacitor c=0.00475168f //x=10.11 //y=0.175 \
 //x2=10.11 //y2=7.585
cc_5 ( N_GND_c_5_p N_VDD_c_312_n ) capacitor c=0.00572592f //x=14.92 //y=0.175 \
 //x2=14.92 //y2=7.585
cc_6 ( N_GND_c_6_p N_VDD_c_313_n ) capacitor c=0.00572592f //x=19.73 //y=0.175 \
 //x2=19.73 //y2=7.585
cc_7 ( N_GND_c_7_p N_VDD_c_314_n ) capacitor c=0.00572592f //x=24.54 //y=0.175 \
 //x2=24.54 //y2=7.585
cc_8 ( N_GND_c_8_p N_noxref_3_c_650_n ) capacitor c=0.0138093f //x=28.61 \
 //y=0.18 //x2=6.295 //y2=3.145
cc_9 ( N_GND_c_9_p N_noxref_3_c_650_n ) capacitor c=0.00197527f //x=5.13 \
 //y=0.175 //x2=6.295 //y2=3.145
cc_10 ( N_GND_c_10_p N_noxref_3_c_650_n ) capacitor c=0.00184133f //x=6.29 \
 //y=0.175 //x2=6.295 //y2=3.145
cc_11 ( N_GND_c_3_p N_noxref_3_c_650_n ) capacitor c=0.0143866f //x=5.3 \
 //y=0.175 //x2=6.295 //y2=3.145
cc_12 ( N_GND_c_8_p N_noxref_3_c_654_n ) capacitor c=0.00197784f //x=28.61 \
 //y=0.18 //x2=4.675 //y2=3.145
cc_13 ( N_GND_c_8_p N_noxref_3_c_655_n ) capacitor c=0.0371812f //x=28.61 \
 //y=0.18 //x2=11.105 //y2=3.145
cc_14 ( N_GND_c_14_p N_noxref_3_c_655_n ) capacitor c=0.00285846f //x=9.94 \
 //y=0.175 //x2=11.105 //y2=3.145
cc_15 ( N_GND_c_15_p N_noxref_3_c_655_n ) capacitor c=0.00184133f //x=11.1 \
 //y=0.175 //x2=11.105 //y2=3.145
cc_16 ( N_GND_c_4_p N_noxref_3_c_655_n ) capacitor c=0.0143866f //x=10.11 \
 //y=0.175 //x2=11.105 //y2=3.145
cc_17 ( N_GND_c_8_p N_noxref_3_c_659_n ) capacitor c=0.00182666f //x=28.61 \
 //y=0.18 //x2=6.525 //y2=3.145
cc_18 ( N_GND_c_3_p N_noxref_3_c_660_n ) capacitor c=0.0459494f //x=5.3 \
 //y=0.175 //x2=4.475 //y2=1.845
cc_19 ( N_GND_c_3_p N_noxref_3_c_661_n ) capacitor c=0.0179249f //x=5.3 \
 //y=0.175 //x2=6.41 //y2=2.26
cc_20 ( N_GND_c_4_p N_noxref_3_c_662_n ) capacitor c=0.0176137f //x=10.11 \
 //y=0.175 //x2=11.22 //y2=2.26
cc_21 ( N_GND_c_10_p N_noxref_3_c_663_n ) capacitor c=0.00133465f //x=6.29 \
 //y=0.175 //x2=6.11 //y2=1.055
cc_22 ( N_GND_M3_noxref_d N_noxref_3_c_663_n ) capacitor c=0.00211996f \
 //x=6.185 //y=1.055 //x2=6.11 //y2=1.055
cc_23 ( N_GND_M3_noxref_d N_noxref_3_c_665_n ) capacitor c=0.00255985f \
 //x=6.185 //y=1.055 //x2=6.11 //y2=1.4
cc_24 ( N_GND_c_3_p N_noxref_3_c_666_n ) capacitor c=0.00204716f //x=5.3 \
 //y=0.175 //x2=6.11 //y2=1.71
cc_25 ( N_GND_c_3_p N_noxref_3_c_667_n ) capacitor c=0.0126573f //x=5.3 \
 //y=0.175 //x2=6.11 //y2=2.095
cc_26 ( N_GND_M3_noxref_d N_noxref_3_c_668_n ) capacitor c=0.0131387f \
 //x=6.185 //y=1.055 //x2=6.485 //y2=0.9
cc_27 ( N_GND_M3_noxref_d N_noxref_3_c_669_n ) capacitor c=0.00193165f \
 //x=6.185 //y=1.055 //x2=6.485 //y2=1.555
cc_28 ( N_GND_c_14_p N_noxref_3_c_670_n ) capacitor c=0.00129623f //x=9.94 \
 //y=0.175 //x2=6.64 //y2=1.055
cc_29 ( N_GND_M3_noxref_d N_noxref_3_c_670_n ) capacitor c=0.00257848f \
 //x=6.185 //y=1.055 //x2=6.64 //y2=1.055
cc_30 ( N_GND_M3_noxref_d N_noxref_3_c_672_n ) capacitor c=0.00255985f \
 //x=6.185 //y=1.055 //x2=6.64 //y2=1.4
cc_31 ( N_GND_c_15_p N_noxref_3_c_673_n ) capacitor c=0.00133465f //x=11.1 \
 //y=0.175 //x2=10.92 //y2=1.055
cc_32 ( N_GND_M6_noxref_d N_noxref_3_c_673_n ) capacitor c=0.00211996f \
 //x=10.995 //y=1.055 //x2=10.92 //y2=1.055
cc_33 ( N_GND_M6_noxref_d N_noxref_3_c_675_n ) capacitor c=0.00255985f \
 //x=10.995 //y=1.055 //x2=10.92 //y2=1.4
cc_34 ( N_GND_c_4_p N_noxref_3_c_676_n ) capacitor c=0.00204716f //x=10.11 \
 //y=0.175 //x2=10.92 //y2=1.71
cc_35 ( N_GND_c_4_p N_noxref_3_c_677_n ) capacitor c=0.0126573f //x=10.11 \
 //y=0.175 //x2=10.92 //y2=2.095
cc_36 ( N_GND_M6_noxref_d N_noxref_3_c_678_n ) capacitor c=0.0131387f \
 //x=10.995 //y=1.055 //x2=11.295 //y2=0.9
cc_37 ( N_GND_M6_noxref_d N_noxref_3_c_679_n ) capacitor c=0.00193165f \
 //x=10.995 //y=1.055 //x2=11.295 //y2=1.555
cc_38 ( N_GND_c_38_p N_noxref_3_c_680_n ) capacitor c=0.00129623f //x=14.75 \
 //y=0.175 //x2=11.45 //y2=1.055
cc_39 ( N_GND_M6_noxref_d N_noxref_3_c_680_n ) capacitor c=0.00257848f \
 //x=10.995 //y=1.055 //x2=11.45 //y2=1.055
cc_40 ( N_GND_M6_noxref_d N_noxref_3_c_682_n ) capacitor c=0.00255985f \
 //x=10.995 //y=1.055 //x2=11.45 //y2=1.4
cc_41 ( N_GND_c_3_p N_noxref_3_M2_noxref_d ) capacitor c=0.00591582f //x=5.3 \
 //y=0.175 //x2=3.885 //y2=1.095
cc_42 ( N_GND_c_5_p N_noxref_4_c_901_n ) capacitor c=0.0075089f //x=14.92 \
 //y=0.175 //x2=15.915 //y2=3.14
cc_43 ( N_GND_c_5_p N_noxref_4_c_902_n ) capacitor c=0.0432342f //x=14.92 \
 //y=0.175 //x2=14.095 //y2=1.845
cc_44 ( N_GND_c_5_p N_noxref_4_c_903_n ) capacitor c=0.0153336f //x=14.92 \
 //y=0.175 //x2=16.03 //y2=2.26
cc_45 ( N_GND_c_45_p N_noxref_4_c_904_n ) capacitor c=0.00133465f //x=15.91 \
 //y=0.175 //x2=15.73 //y2=1.055
cc_46 ( N_GND_M9_noxref_d N_noxref_4_c_904_n ) capacitor c=0.00211996f \
 //x=15.805 //y=1.055 //x2=15.73 //y2=1.055
cc_47 ( N_GND_M9_noxref_d N_noxref_4_c_906_n ) capacitor c=0.00255985f \
 //x=15.805 //y=1.055 //x2=15.73 //y2=1.4
cc_48 ( N_GND_c_5_p N_noxref_4_c_907_n ) capacitor c=0.00204716f //x=14.92 \
 //y=0.175 //x2=15.73 //y2=1.71
cc_49 ( N_GND_c_5_p N_noxref_4_c_908_n ) capacitor c=0.0126573f //x=14.92 \
 //y=0.175 //x2=15.73 //y2=2.095
cc_50 ( N_GND_M9_noxref_d N_noxref_4_c_909_n ) capacitor c=0.0131387f \
 //x=15.805 //y=1.055 //x2=16.105 //y2=0.9
cc_51 ( N_GND_M9_noxref_d N_noxref_4_c_910_n ) capacitor c=0.00193165f \
 //x=15.805 //y=1.055 //x2=16.105 //y2=1.555
cc_52 ( N_GND_c_52_p N_noxref_4_c_911_n ) capacitor c=0.00129623f //x=19.56 \
 //y=0.175 //x2=16.26 //y2=1.055
cc_53 ( N_GND_M9_noxref_d N_noxref_4_c_911_n ) capacitor c=0.00257848f \
 //x=15.805 //y=1.055 //x2=16.26 //y2=1.055
cc_54 ( N_GND_M9_noxref_d N_noxref_4_c_913_n ) capacitor c=0.00255985f \
 //x=15.805 //y=1.055 //x2=16.26 //y2=1.4
cc_55 ( N_GND_c_5_p N_noxref_4_M8_noxref_d ) capacitor c=0.00591582f //x=14.92 \
 //y=0.175 //x2=13.505 //y2=1.095
cc_56 ( N_GND_c_8_p N_CLK_c_1061_n ) capacitor c=0.0284424f //x=28.61 //y=0.18 \
 //x2=17.025 //y2=3.51
cc_57 ( N_GND_c_3_p N_CLK_c_1062_n ) capacitor c=7.64246e-19 //x=5.3 //y=0.175 \
 //x2=7.52 //y2=2.26
cc_58 ( N_GND_c_5_p N_CLK_c_1063_n ) capacitor c=6.4925e-19 //x=14.92 \
 //y=0.175 //x2=17.14 //y2=2.26
cc_59 ( N_GND_c_8_p N_noxref_6_c_1251_n ) capacitor c=0.008256f //x=28.61 \
 //y=0.18 //x2=9.255 //y2=3.88
cc_60 ( N_GND_c_8_p N_noxref_6_c_1252_n ) capacitor c=0.00154868f //x=28.61 \
 //y=0.18 //x2=3.935 //y2=3.88
cc_61 ( N_GND_c_6_p N_noxref_6_c_1253_n ) capacitor c=0.003498f //x=19.73 \
 //y=0.175 //x2=20.725 //y2=3.88
cc_62 ( N_GND_c_3_p N_noxref_6_c_1254_n ) capacitor c=9.53263e-19 //x=5.3 \
 //y=0.175 //x2=3.82 //y2=2.26
cc_63 ( N_GND_c_4_p N_noxref_6_c_1255_n ) capacitor c=0.0455868f //x=10.11 \
 //y=0.175 //x2=9.285 //y2=1.845
cc_64 ( N_GND_c_6_p N_noxref_6_c_1256_n ) capacitor c=0.0153336f //x=19.73 \
 //y=0.175 //x2=20.84 //y2=2.26
cc_65 ( N_GND_c_65_p N_noxref_6_c_1257_n ) capacitor c=0.00133465f //x=20.72 \
 //y=0.175 //x2=20.54 //y2=1.055
cc_66 ( N_GND_M12_noxref_d N_noxref_6_c_1257_n ) capacitor c=0.00211996f \
 //x=20.615 //y=1.055 //x2=20.54 //y2=1.055
cc_67 ( N_GND_M12_noxref_d N_noxref_6_c_1259_n ) capacitor c=0.00255985f \
 //x=20.615 //y=1.055 //x2=20.54 //y2=1.4
cc_68 ( N_GND_c_6_p N_noxref_6_c_1260_n ) capacitor c=0.00204716f //x=19.73 \
 //y=0.175 //x2=20.54 //y2=1.71
cc_69 ( N_GND_c_6_p N_noxref_6_c_1261_n ) capacitor c=0.0126573f //x=19.73 \
 //y=0.175 //x2=20.54 //y2=2.095
cc_70 ( N_GND_M12_noxref_d N_noxref_6_c_1262_n ) capacitor c=0.0131387f \
 //x=20.615 //y=1.055 //x2=20.915 //y2=0.9
cc_71 ( N_GND_M12_noxref_d N_noxref_6_c_1263_n ) capacitor c=0.00193165f \
 //x=20.615 //y=1.055 //x2=20.915 //y2=1.555
cc_72 ( N_GND_c_72_p N_noxref_6_c_1264_n ) capacitor c=0.00129623f //x=24.37 \
 //y=0.175 //x2=21.07 //y2=1.055
cc_73 ( N_GND_M12_noxref_d N_noxref_6_c_1264_n ) capacitor c=0.00257848f \
 //x=20.615 //y=1.055 //x2=21.07 //y2=1.055
cc_74 ( N_GND_M12_noxref_d N_noxref_6_c_1266_n ) capacitor c=0.00255985f \
 //x=20.615 //y=1.055 //x2=21.07 //y2=1.4
cc_75 ( N_GND_c_4_p N_noxref_6_M5_noxref_d ) capacitor c=0.00591582f //x=10.11 \
 //y=0.175 //x2=8.695 //y2=1.095
cc_76 ( N_GND_c_8_p N_RN_c_1511_n ) capacitor c=0.00571529f //x=28.61 //y=0.18 \
 //x2=18.135 //y2=4.62
cc_77 ( N_GND_c_8_p N_RN_c_1512_n ) capacitor c=0.00132681f //x=28.61 //y=0.18 \
 //x2=2.825 //y2=4.62
cc_78 ( N_GND_c_1_p N_RN_c_1513_n ) capacitor c=7.64246e-19 //x=1.23 //y=0.18 \
 //x2=2.71 //y2=2.26
cc_79 ( N_GND_c_6_p N_RN_c_1514_n ) capacitor c=7.09207e-19 //x=19.73 \
 //y=0.175 //x2=18.25 //y2=2.26
cc_80 ( N_GND_c_6_p N_RN_c_1515_n ) capacitor c=6.4925e-19 //x=19.73 //y=0.175 \
 //x2=21.95 //y2=2.26
cc_81 ( N_GND_c_7_p N_QN_c_1820_n ) capacitor c=0.00505543f //x=24.54 \
 //y=0.175 //x2=25.535 //y2=3.51
cc_82 ( N_GND_c_7_p N_QN_c_1821_n ) capacitor c=0.0432429f //x=24.54 //y=0.175 \
 //x2=23.715 //y2=1.845
cc_83 ( N_GND_c_7_p N_QN_c_1822_n ) capacitor c=0.0152529f //x=24.54 //y=0.175 \
 //x2=25.65 //y2=2.26
cc_84 ( N_GND_c_84_p N_QN_c_1823_n ) capacitor c=0.00133465f //x=25.53 \
 //y=0.175 //x2=25.35 //y2=1.055
cc_85 ( N_GND_M15_noxref_d N_QN_c_1823_n ) capacitor c=0.00211996f //x=25.425 \
 //y=1.055 //x2=25.35 //y2=1.055
cc_86 ( N_GND_M15_noxref_d N_QN_c_1825_n ) capacitor c=0.00255985f //x=25.425 \
 //y=1.055 //x2=25.35 //y2=1.4
cc_87 ( N_GND_c_7_p N_QN_c_1826_n ) capacitor c=0.00204716f //x=24.54 \
 //y=0.175 //x2=25.35 //y2=1.71
cc_88 ( N_GND_c_7_p N_QN_c_1827_n ) capacitor c=0.0126573f //x=24.54 //y=0.175 \
 //x2=25.35 //y2=2.095
cc_89 ( N_GND_M15_noxref_d N_QN_c_1828_n ) capacitor c=0.0131387f //x=25.425 \
 //y=1.055 //x2=25.725 //y2=0.9
cc_90 ( N_GND_M15_noxref_d N_QN_c_1829_n ) capacitor c=0.00193165f //x=25.425 \
 //y=1.055 //x2=25.725 //y2=1.555
cc_91 ( N_GND_c_2_p N_QN_c_1830_n ) capacitor c=0.00129623f //x=28.61 //y=0.18 \
 //x2=25.88 //y2=1.055
cc_92 ( N_GND_M15_noxref_d N_QN_c_1830_n ) capacitor c=0.00257848f //x=25.425 \
 //y=1.055 //x2=25.88 //y2=1.055
cc_93 ( N_GND_M15_noxref_d N_QN_c_1832_n ) capacitor c=0.00255985f //x=25.425 \
 //y=1.055 //x2=25.88 //y2=1.4
cc_94 ( N_GND_c_7_p N_QN_M14_noxref_d ) capacitor c=0.00591582f //x=24.54 \
 //y=0.175 //x2=23.125 //y2=1.095
cc_95 ( N_GND_c_8_p N_SN_c_1977_n ) capacitor c=0.122947f //x=28.61 //y=0.18 \
 //x2=12.33 //y2=2.775
cc_96 ( N_GND_c_38_p N_SN_c_1977_n ) capacitor c=0.00331661f //x=14.75 \
 //y=0.175 //x2=12.33 //y2=2.775
cc_97 ( N_GND_c_45_p N_SN_c_1977_n ) capacitor c=0.00222056f //x=15.91 \
 //y=0.175 //x2=12.33 //y2=2.775
cc_98 ( N_GND_c_52_p N_SN_c_1977_n ) capacitor c=0.00344532f //x=19.56 \
 //y=0.175 //x2=12.33 //y2=2.775
cc_99 ( N_GND_c_65_p N_SN_c_1977_n ) capacitor c=0.00222056f //x=20.72 \
 //y=0.175 //x2=12.33 //y2=2.775
cc_100 ( N_GND_c_72_p N_SN_c_1977_n ) capacitor c=0.00344532f //x=24.37 \
 //y=0.175 //x2=12.33 //y2=2.775
cc_101 ( N_GND_c_84_p N_SN_c_1977_n ) capacitor c=0.00222056f //x=25.53 \
 //y=0.175 //x2=12.33 //y2=2.775
cc_102 ( N_GND_c_5_p N_SN_c_1977_n ) capacitor c=0.0338055f //x=14.92 \
 //y=0.175 //x2=12.33 //y2=2.775
cc_103 ( N_GND_c_6_p N_SN_c_1977_n ) capacitor c=0.0377057f //x=19.73 \
 //y=0.175 //x2=12.33 //y2=2.775
cc_104 ( N_GND_c_7_p N_SN_c_1977_n ) capacitor c=0.0360747f //x=24.54 \
 //y=0.175 //x2=12.33 //y2=2.775
cc_105 ( N_GND_c_4_p N_SN_c_1987_n ) capacitor c=9.22578e-19 //x=10.11 \
 //y=0.175 //x2=12.33 //y2=2.26
cc_106 ( N_GND_c_7_p N_SN_c_1988_n ) capacitor c=6.9062e-19 //x=24.54 \
 //y=0.175 //x2=26.76 //y2=2.26
cc_107 ( N_GND_c_4_p N_noxref_10_c_2201_n ) capacitor c=9.53263e-19 //x=10.11 \
 //y=0.175 //x2=8.63 //y2=2.26
cc_108 ( N_GND_c_5_p N_noxref_10_c_2202_n ) capacitor c=7.95166e-19 //x=14.92 \
 //y=0.175 //x2=13.44 //y2=2.26
cc_109 ( N_GND_c_6_p N_noxref_10_c_2203_n ) capacitor c=0.0433371f //x=19.73 \
 //y=0.175 //x2=18.905 //y2=1.845
cc_110 ( N_GND_c_2_p N_noxref_10_c_2204_n ) capacitor c=0.00128267f //x=28.61 \
 //y=0.18 //x2=27.87 //y2=2.26
cc_111 ( N_GND_c_6_p N_noxref_10_M11_noxref_d ) capacitor c=0.00591582f \
 //x=19.73 //y=0.175 //x2=18.315 //y2=1.095
cc_112 ( N_GND_c_8_p N_noxref_11_c_2540_n ) capacitor c=0.0135222f //x=28.61 \
 //y=0.18 //x2=28.495 //y2=3.88
cc_113 ( N_GND_c_7_p N_noxref_11_c_2541_n ) capacitor c=7.09207e-19 //x=24.54 \
 //y=0.175 //x2=23.06 //y2=2.26
cc_114 ( N_GND_c_2_p N_noxref_11_c_2542_n ) capacitor c=0.0461865f //x=28.61 \
 //y=0.18 //x2=28.525 //y2=1.845
cc_115 ( N_GND_c_2_p N_noxref_11_M17_noxref_d ) capacitor c=0.00593061f \
 //x=28.61 //y=0.18 //x2=27.935 //y2=1.095
cc_116 ( N_GND_c_1_p N_D_c_2697_n ) capacitor c=0.0180363f //x=1.23 //y=0.18 \
 //x2=1.6 //y2=2.26
cc_117 ( N_GND_c_117_p N_D_c_2698_n ) capacitor c=0.00133465f //x=1.48 \
 //y=0.175 //x2=1.3 //y2=1.055
cc_118 ( N_GND_M0_noxref_d N_D_c_2698_n ) capacitor c=0.00211996f //x=1.375 \
 //y=1.055 //x2=1.3 //y2=1.055
cc_119 ( N_GND_M0_noxref_d N_D_c_2700_n ) capacitor c=0.00255985f //x=1.375 \
 //y=1.055 //x2=1.3 //y2=1.4
cc_120 ( N_GND_c_1_p N_D_c_2701_n ) capacitor c=0.00295461f //x=1.23 //y=0.18 \
 //x2=1.3 //y2=1.71
cc_121 ( N_GND_c_1_p N_D_c_2702_n ) capacitor c=0.0134214f //x=1.23 //y=0.18 \
 //x2=1.3 //y2=2.095
cc_122 ( N_GND_M0_noxref_d N_D_c_2703_n ) capacitor c=0.0131387f //x=1.375 \
 //y=1.055 //x2=1.675 //y2=0.9
cc_123 ( N_GND_M0_noxref_d N_D_c_2704_n ) capacitor c=0.00193165f //x=1.375 \
 //y=1.055 //x2=1.675 //y2=1.555
cc_124 ( N_GND_c_9_p N_D_c_2705_n ) capacitor c=0.00129623f //x=5.13 //y=0.175 \
 //x2=1.83 //y2=1.055
cc_125 ( N_GND_M0_noxref_d N_D_c_2705_n ) capacitor c=0.00257848f //x=1.375 \
 //y=1.055 //x2=1.83 //y2=1.055
cc_126 ( N_GND_M0_noxref_d N_D_c_2707_n ) capacitor c=0.00255985f //x=1.375 \
 //y=1.055 //x2=1.83 //y2=1.4
cc_127 ( N_GND_c_8_p N_noxref_13_c_2753_n ) capacitor c=0.00710601f //x=28.61 \
 //y=0.18 //x2=1.965 //y2=1.77
cc_128 ( N_GND_c_117_p N_noxref_13_c_2753_n ) capacitor c=0.00110148f //x=1.48 \
 //y=0.175 //x2=1.965 //y2=1.77
cc_129 ( N_GND_c_9_p N_noxref_13_c_2753_n ) capacitor c=0.0017942f //x=5.13 \
 //y=0.175 //x2=1.965 //y2=1.77
cc_130 ( N_GND_M0_noxref_d N_noxref_13_c_2753_n ) capacitor c=0.00900213f \
 //x=1.375 //y=1.055 //x2=1.965 //y2=1.77
cc_131 ( N_GND_c_8_p N_noxref_13_c_2757_n ) capacitor c=0.00710913f //x=28.61 \
 //y=0.18 //x2=2.05 //y2=0.805
cc_132 ( N_GND_c_9_p N_noxref_13_c_2757_n ) capacitor c=0.0140604f //x=5.13 \
 //y=0.175 //x2=2.05 //y2=0.805
cc_133 ( N_GND_M0_noxref_d N_noxref_13_c_2757_n ) capacitor c=0.033954f \
 //x=1.375 //y=1.055 //x2=2.05 //y2=0.805
cc_134 ( N_GND_c_8_p N_noxref_13_c_2760_n ) capacitor c=0.0169168f //x=28.61 \
 //y=0.18 //x2=2.935 //y2=0.72
cc_135 ( N_GND_c_9_p N_noxref_13_c_2760_n ) capacitor c=0.0356451f //x=5.13 \
 //y=0.175 //x2=2.935 //y2=0.72
cc_136 ( N_GND_c_2_p N_noxref_13_c_2760_n ) capacitor c=0.00265129f //x=28.61 \
 //y=0.18 //x2=2.935 //y2=0.72
cc_137 ( N_GND_c_8_p N_noxref_13_M0_noxref_s ) capacitor c=0.0126406f \
 //x=28.61 //y=0.18 //x2=0.945 //y2=0.555
cc_138 ( N_GND_c_117_p N_noxref_13_M0_noxref_s ) capacitor c=0.0140604f \
 //x=1.48 //y=0.175 //x2=0.945 //y2=0.555
cc_139 ( N_GND_c_1_p N_noxref_13_M0_noxref_s ) capacitor c=0.0712607f //x=1.23 \
 //y=0.18 //x2=0.945 //y2=0.555
cc_140 ( N_GND_c_9_p N_noxref_13_M0_noxref_s ) capacitor c=0.0131642f //x=5.13 \
 //y=0.175 //x2=0.945 //y2=0.555
cc_141 ( N_GND_c_3_p N_noxref_13_M0_noxref_s ) capacitor c=3.31601e-19 //x=5.3 \
 //y=0.175 //x2=0.945 //y2=0.555
cc_142 ( N_GND_M0_noxref_d N_noxref_13_M0_noxref_s ) capacitor c=0.033718f \
 //x=1.375 //y=1.055 //x2=0.945 //y2=0.555
cc_143 ( N_GND_c_8_p N_noxref_14_c_2799_n ) capacitor c=0.00667941f //x=28.61 \
 //y=0.18 //x2=3.505 //y2=1.175
cc_144 ( N_GND_c_9_p N_noxref_14_c_2799_n ) capacitor c=0.00830851f //x=5.13 \
 //y=0.175 //x2=3.505 //y2=1.175
cc_145 ( N_GND_c_2_p N_noxref_14_c_2799_n ) capacitor c=3.54249e-19 //x=28.61 \
 //y=0.18 //x2=3.505 //y2=1.175
cc_146 ( N_GND_c_8_p N_noxref_14_c_2802_n ) capacitor c=0.00584981f //x=28.61 \
 //y=0.18 //x2=3.59 //y2=0.805
cc_147 ( N_GND_c_9_p N_noxref_14_c_2802_n ) capacitor c=0.0140604f //x=5.13 \
 //y=0.175 //x2=3.59 //y2=0.805
cc_148 ( N_GND_M0_noxref_d N_noxref_14_c_2802_n ) capacitor c=6.21394e-19 \
 //x=1.375 //y=1.055 //x2=3.59 //y2=0.805
cc_149 ( N_GND_c_8_p N_noxref_14_c_2805_n ) capacitor c=0.0121522f //x=28.61 \
 //y=0.18 //x2=4.475 //y2=0.72
cc_150 ( N_GND_c_9_p N_noxref_14_c_2805_n ) capacitor c=0.0363007f //x=5.13 \
 //y=0.175 //x2=4.475 //y2=0.72
cc_151 ( N_GND_c_2_p N_noxref_14_c_2805_n ) capacitor c=0.00283214f //x=28.61 \
 //y=0.18 //x2=4.475 //y2=0.72
cc_152 ( N_GND_c_8_p N_noxref_14_c_2808_n ) capacitor c=0.00276771f //x=28.61 \
 //y=0.18 //x2=4.56 //y2=0.805
cc_153 ( N_GND_c_9_p N_noxref_14_c_2808_n ) capacitor c=0.0142117f //x=5.13 \
 //y=0.175 //x2=4.56 //y2=0.805
cc_154 ( N_GND_c_3_p N_noxref_14_c_2808_n ) capacitor c=0.0404137f //x=5.3 \
 //y=0.175 //x2=4.56 //y2=0.805
cc_155 ( N_GND_M0_noxref_d N_noxref_14_M1_noxref_d ) capacitor c=0.00162435f \
 //x=1.375 //y=1.055 //x2=2.35 //y2=1.09
cc_156 ( N_GND_c_1_p N_noxref_14_M2_noxref_s ) capacitor c=8.16352e-19 \
 //x=1.23 //y=0.18 //x2=3.455 //y2=0.555
cc_157 ( N_GND_c_3_p N_noxref_14_M2_noxref_s ) capacitor c=0.00183204f //x=5.3 \
 //y=0.175 //x2=3.455 //y2=0.555
cc_158 ( N_GND_c_8_p N_noxref_15_c_2852_n ) capacitor c=0.00540974f //x=28.61 \
 //y=0.18 //x2=6.775 //y2=1.77
cc_159 ( N_GND_c_10_p N_noxref_15_c_2852_n ) capacitor c=0.00111663f //x=6.29 \
 //y=0.175 //x2=6.775 //y2=1.77
cc_160 ( N_GND_c_14_p N_noxref_15_c_2852_n ) capacitor c=0.00180935f //x=9.94 \
 //y=0.175 //x2=6.775 //y2=1.77
cc_161 ( N_GND_M3_noxref_d N_noxref_15_c_2852_n ) capacitor c=0.00880068f \
 //x=6.185 //y=1.055 //x2=6.775 //y2=1.77
cc_162 ( N_GND_c_8_p N_noxref_15_c_2856_n ) capacitor c=0.00277773f //x=28.61 \
 //y=0.18 //x2=6.86 //y2=0.805
cc_163 ( N_GND_c_14_p N_noxref_15_c_2856_n ) capacitor c=0.014281f //x=9.94 \
 //y=0.175 //x2=6.86 //y2=0.805
cc_164 ( N_GND_M3_noxref_d N_noxref_15_c_2856_n ) capacitor c=0.033954f \
 //x=6.185 //y=1.055 //x2=6.86 //y2=0.805
cc_165 ( N_GND_c_8_p N_noxref_15_c_2859_n ) capacitor c=0.0113759f //x=28.61 \
 //y=0.18 //x2=7.745 //y2=0.72
cc_166 ( N_GND_c_14_p N_noxref_15_c_2859_n ) capacitor c=0.036202f //x=9.94 \
 //y=0.175 //x2=7.745 //y2=0.72
cc_167 ( N_GND_c_2_p N_noxref_15_c_2859_n ) capacitor c=0.00265129f //x=28.61 \
 //y=0.18 //x2=7.745 //y2=0.72
cc_168 ( N_GND_c_8_p N_noxref_15_M3_noxref_s ) capacitor c=0.00554983f \
 //x=28.61 //y=0.18 //x2=5.755 //y2=0.555
cc_169 ( N_GND_c_10_p N_noxref_15_M3_noxref_s ) capacitor c=0.014281f //x=6.29 \
 //y=0.175 //x2=5.755 //y2=0.555
cc_170 ( N_GND_c_14_p N_noxref_15_M3_noxref_s ) capacitor c=0.0138494f \
 //x=9.94 //y=0.175 //x2=5.755 //y2=0.555
cc_171 ( N_GND_c_3_p N_noxref_15_M3_noxref_s ) capacitor c=0.0696963f //x=5.3 \
 //y=0.175 //x2=5.755 //y2=0.555
cc_172 ( N_GND_c_4_p N_noxref_15_M3_noxref_s ) capacitor c=3.31601e-19 \
 //x=10.11 //y=0.175 //x2=5.755 //y2=0.555
cc_173 ( N_GND_M3_noxref_d N_noxref_15_M3_noxref_s ) capacitor c=0.033718f \
 //x=6.185 //y=1.055 //x2=5.755 //y2=0.555
cc_174 ( N_GND_c_8_p N_noxref_16_c_2904_n ) capacitor c=0.00375835f //x=28.61 \
 //y=0.18 //x2=8.315 //y2=1.175
cc_175 ( N_GND_c_14_p N_noxref_16_c_2904_n ) capacitor c=0.0094541f //x=9.94 \
 //y=0.175 //x2=8.315 //y2=1.175
cc_176 ( N_GND_c_2_p N_noxref_16_c_2904_n ) capacitor c=3.54249e-19 //x=28.61 \
 //y=0.18 //x2=8.315 //y2=1.175
cc_177 ( N_GND_c_8_p N_noxref_16_c_2907_n ) capacitor c=0.00277773f //x=28.61 \
 //y=0.18 //x2=8.4 //y2=0.805
cc_178 ( N_GND_c_14_p N_noxref_16_c_2907_n ) capacitor c=0.014281f //x=9.94 \
 //y=0.175 //x2=8.4 //y2=0.805
cc_179 ( N_GND_M3_noxref_d N_noxref_16_c_2907_n ) capacitor c=6.21394e-19 \
 //x=6.185 //y=1.055 //x2=8.4 //y2=0.805
cc_180 ( N_GND_c_8_p N_noxref_16_c_2910_n ) capacitor c=0.0114572f //x=28.61 \
 //y=0.18 //x2=9.285 //y2=0.72
cc_181 ( N_GND_c_14_p N_noxref_16_c_2910_n ) capacitor c=0.0366009f //x=9.94 \
 //y=0.175 //x2=9.285 //y2=0.72
cc_182 ( N_GND_c_2_p N_noxref_16_c_2910_n ) capacitor c=0.00283214f //x=28.61 \
 //y=0.18 //x2=9.285 //y2=0.72
cc_183 ( N_GND_c_8_p N_noxref_16_c_2913_n ) capacitor c=0.00277626f //x=28.61 \
 //y=0.18 //x2=9.37 //y2=0.805
cc_184 ( N_GND_c_14_p N_noxref_16_c_2913_n ) capacitor c=0.0142177f //x=9.94 \
 //y=0.175 //x2=9.37 //y2=0.805
cc_185 ( N_GND_c_4_p N_noxref_16_c_2913_n ) capacitor c=0.0404137f //x=10.11 \
 //y=0.175 //x2=9.37 //y2=0.805
cc_186 ( N_GND_M3_noxref_d N_noxref_16_M4_noxref_d ) capacitor c=0.00162435f \
 //x=6.185 //y=1.055 //x2=7.16 //y2=1.09
cc_187 ( N_GND_c_3_p N_noxref_16_M5_noxref_s ) capacitor c=8.16352e-19 //x=5.3 \
 //y=0.175 //x2=8.265 //y2=0.555
cc_188 ( N_GND_c_4_p N_noxref_16_M5_noxref_s ) capacitor c=0.00183204f \
 //x=10.11 //y=0.175 //x2=8.265 //y2=0.555
cc_189 ( N_GND_c_8_p N_noxref_17_c_2958_n ) capacitor c=0.00543428f //x=28.61 \
 //y=0.18 //x2=11.585 //y2=1.77
cc_190 ( N_GND_c_15_p N_noxref_17_c_2958_n ) capacitor c=0.00111663f //x=11.1 \
 //y=0.175 //x2=11.585 //y2=1.77
cc_191 ( N_GND_c_38_p N_noxref_17_c_2958_n ) capacitor c=0.00180972f //x=14.75 \
 //y=0.175 //x2=11.585 //y2=1.77
cc_192 ( N_GND_M6_noxref_d N_noxref_17_c_2958_n ) capacitor c=0.00880068f \
 //x=10.995 //y=1.055 //x2=11.585 //y2=1.77
cc_193 ( N_GND_c_8_p N_noxref_17_c_2962_n ) capacitor c=0.00287676f //x=28.61 \
 //y=0.18 //x2=11.67 //y2=0.805
cc_194 ( N_GND_c_38_p N_noxref_17_c_2962_n ) capacitor c=0.0143483f //x=14.75 \
 //y=0.175 //x2=11.67 //y2=0.805
cc_195 ( N_GND_M6_noxref_d N_noxref_17_c_2962_n ) capacitor c=0.033954f \
 //x=10.995 //y=1.055 //x2=11.67 //y2=0.805
cc_196 ( N_GND_c_8_p N_noxref_17_c_2965_n ) capacitor c=0.0113757f //x=28.61 \
 //y=0.18 //x2=12.555 //y2=0.72
cc_197 ( N_GND_c_38_p N_noxref_17_c_2965_n ) capacitor c=0.0362009f //x=14.75 \
 //y=0.175 //x2=12.555 //y2=0.72
cc_198 ( N_GND_c_2_p N_noxref_17_c_2965_n ) capacitor c=0.00265129f //x=28.61 \
 //y=0.18 //x2=12.555 //y2=0.72
cc_199 ( N_GND_c_8_p N_noxref_17_M6_noxref_s ) capacitor c=0.00543544f \
 //x=28.61 //y=0.18 //x2=10.565 //y2=0.555
cc_200 ( N_GND_c_15_p N_noxref_17_M6_noxref_s ) capacitor c=0.014281f //x=11.1 \
 //y=0.175 //x2=10.565 //y2=0.555
cc_201 ( N_GND_c_38_p N_noxref_17_M6_noxref_s ) capacitor c=0.0132462f \
 //x=14.75 //y=0.175 //x2=10.565 //y2=0.555
cc_202 ( N_GND_c_4_p N_noxref_17_M6_noxref_s ) capacitor c=0.0696963f \
 //x=10.11 //y=0.175 //x2=10.565 //y2=0.555
cc_203 ( N_GND_c_5_p N_noxref_17_M6_noxref_s ) capacitor c=3.31601e-19 \
 //x=14.92 //y=0.175 //x2=10.565 //y2=0.555
cc_204 ( N_GND_M6_noxref_d N_noxref_17_M6_noxref_s ) capacitor c=0.033718f \
 //x=10.995 //y=1.055 //x2=10.565 //y2=0.555
cc_205 ( N_GND_c_8_p N_noxref_18_c_3011_n ) capacitor c=0.00365025f //x=28.61 \
 //y=0.18 //x2=13.125 //y2=1.175
cc_206 ( N_GND_c_38_p N_noxref_18_c_3011_n ) capacitor c=0.00940539f //x=14.75 \
 //y=0.175 //x2=13.125 //y2=1.175
cc_207 ( N_GND_c_2_p N_noxref_18_c_3011_n ) capacitor c=3.54249e-19 //x=28.61 \
 //y=0.18 //x2=13.125 //y2=1.175
cc_208 ( N_GND_c_8_p N_noxref_18_c_3014_n ) capacitor c=0.00266677f //x=28.61 \
 //y=0.18 //x2=13.21 //y2=0.805
cc_209 ( N_GND_c_38_p N_noxref_18_c_3014_n ) capacitor c=0.0142029f //x=14.75 \
 //y=0.175 //x2=13.21 //y2=0.805
cc_210 ( N_GND_M6_noxref_d N_noxref_18_c_3014_n ) capacitor c=6.21394e-19 \
 //x=10.995 //y=1.055 //x2=13.21 //y2=0.805
cc_211 ( N_GND_c_8_p N_noxref_18_c_3017_n ) capacitor c=0.0110158f //x=28.61 \
 //y=0.18 //x2=14.095 //y2=0.72
cc_212 ( N_GND_c_38_p N_noxref_18_c_3017_n ) capacitor c=0.0365105f //x=14.75 \
 //y=0.175 //x2=14.095 //y2=0.72
cc_213 ( N_GND_c_2_p N_noxref_18_c_3017_n ) capacitor c=0.00283214f //x=28.61 \
 //y=0.18 //x2=14.095 //y2=0.72
cc_214 ( N_GND_c_8_p N_noxref_18_c_3020_n ) capacitor c=0.00266478f //x=28.61 \
 //y=0.18 //x2=14.18 //y2=0.805
cc_215 ( N_GND_c_38_p N_noxref_18_c_3020_n ) capacitor c=0.0141392f //x=14.75 \
 //y=0.175 //x2=14.18 //y2=0.805
cc_216 ( N_GND_c_5_p N_noxref_18_c_3020_n ) capacitor c=0.0404137f //x=14.92 \
 //y=0.175 //x2=14.18 //y2=0.805
cc_217 ( N_GND_M6_noxref_d N_noxref_18_M7_noxref_d ) capacitor c=0.00162435f \
 //x=10.995 //y=1.055 //x2=11.97 //y2=1.09
cc_218 ( N_GND_c_4_p N_noxref_18_M8_noxref_s ) capacitor c=8.16352e-19 \
 //x=10.11 //y=0.175 //x2=13.075 //y2=0.555
cc_219 ( N_GND_c_5_p N_noxref_18_M8_noxref_s ) capacitor c=0.00183204f \
 //x=14.92 //y=0.175 //x2=13.075 //y2=0.555
cc_220 ( N_GND_c_8_p N_noxref_19_c_3065_n ) capacitor c=0.00530041f //x=28.61 \
 //y=0.18 //x2=16.395 //y2=1.77
cc_221 ( N_GND_c_45_p N_noxref_19_c_3065_n ) capacitor c=0.0011162f //x=15.91 \
 //y=0.175 //x2=16.395 //y2=1.77
cc_222 ( N_GND_c_52_p N_noxref_19_c_3065_n ) capacitor c=0.00180892f //x=19.56 \
 //y=0.175 //x2=16.395 //y2=1.77
cc_223 ( N_GND_M9_noxref_d N_noxref_19_c_3065_n ) capacitor c=0.00869761f \
 //x=15.805 //y=1.055 //x2=16.395 //y2=1.77
cc_224 ( N_GND_c_8_p N_noxref_19_c_3069_n ) capacitor c=0.00266677f //x=28.61 \
 //y=0.18 //x2=16.48 //y2=0.805
cc_225 ( N_GND_c_52_p N_noxref_19_c_3069_n ) capacitor c=0.0142029f //x=19.56 \
 //y=0.175 //x2=16.48 //y2=0.805
cc_226 ( N_GND_M9_noxref_d N_noxref_19_c_3069_n ) capacitor c=0.033954f \
 //x=15.805 //y=1.055 //x2=16.48 //y2=0.805
cc_227 ( N_GND_c_8_p N_noxref_19_c_3072_n ) capacitor c=0.0109346f //x=28.61 \
 //y=0.18 //x2=17.365 //y2=0.72
cc_228 ( N_GND_c_52_p N_noxref_19_c_3072_n ) capacitor c=0.0361571f //x=19.56 \
 //y=0.175 //x2=17.365 //y2=0.72
cc_229 ( N_GND_c_2_p N_noxref_19_c_3072_n ) capacitor c=0.00265129f //x=28.61 \
 //y=0.18 //x2=17.365 //y2=0.72
cc_230 ( N_GND_c_8_p N_noxref_19_M9_noxref_s ) capacitor c=0.0053241f \
 //x=28.61 //y=0.18 //x2=15.375 //y2=0.555
cc_231 ( N_GND_c_45_p N_noxref_19_M9_noxref_s ) capacitor c=0.0142029f \
 //x=15.91 //y=0.175 //x2=15.375 //y2=0.555
cc_232 ( N_GND_c_52_p N_noxref_19_M9_noxref_s ) capacitor c=0.0132459f \
 //x=19.56 //y=0.175 //x2=15.375 //y2=0.555
cc_233 ( N_GND_c_5_p N_noxref_19_M9_noxref_s ) capacitor c=0.0696963f \
 //x=14.92 //y=0.175 //x2=15.375 //y2=0.555
cc_234 ( N_GND_c_6_p N_noxref_19_M9_noxref_s ) capacitor c=3.31601e-19 \
 //x=19.73 //y=0.175 //x2=15.375 //y2=0.555
cc_235 ( N_GND_M9_noxref_d N_noxref_19_M9_noxref_s ) capacitor c=0.033718f \
 //x=15.805 //y=1.055 //x2=15.375 //y2=0.555
cc_236 ( N_GND_c_8_p N_noxref_20_c_3115_n ) capacitor c=0.00365025f //x=28.61 \
 //y=0.18 //x2=17.935 //y2=1.175
cc_237 ( N_GND_c_52_p N_noxref_20_c_3115_n ) capacitor c=0.00940539f //x=19.56 \
 //y=0.175 //x2=17.935 //y2=1.175
cc_238 ( N_GND_c_2_p N_noxref_20_c_3115_n ) capacitor c=3.54249e-19 //x=28.61 \
 //y=0.18 //x2=17.935 //y2=1.175
cc_239 ( N_GND_c_8_p N_noxref_20_c_3118_n ) capacitor c=0.00266677f //x=28.61 \
 //y=0.18 //x2=18.02 //y2=0.805
cc_240 ( N_GND_c_52_p N_noxref_20_c_3118_n ) capacitor c=0.0142029f //x=19.56 \
 //y=0.175 //x2=18.02 //y2=0.805
cc_241 ( N_GND_M9_noxref_d N_noxref_20_c_3118_n ) capacitor c=6.21394e-19 \
 //x=15.805 //y=1.055 //x2=18.02 //y2=0.805
cc_242 ( N_GND_c_8_p N_noxref_20_c_3121_n ) capacitor c=0.0110158f //x=28.61 \
 //y=0.18 //x2=18.905 //y2=0.72
cc_243 ( N_GND_c_52_p N_noxref_20_c_3121_n ) capacitor c=0.0365578f //x=19.56 \
 //y=0.175 //x2=18.905 //y2=0.72
cc_244 ( N_GND_c_2_p N_noxref_20_c_3121_n ) capacitor c=0.00283214f //x=28.61 \
 //y=0.18 //x2=18.905 //y2=0.72
cc_245 ( N_GND_c_8_p N_noxref_20_c_3124_n ) capacitor c=0.00266478f //x=28.61 \
 //y=0.18 //x2=18.99 //y2=0.805
cc_246 ( N_GND_c_52_p N_noxref_20_c_3124_n ) capacitor c=0.0141392f //x=19.56 \
 //y=0.175 //x2=18.99 //y2=0.805
cc_247 ( N_GND_c_6_p N_noxref_20_c_3124_n ) capacitor c=0.0404137f //x=19.73 \
 //y=0.175 //x2=18.99 //y2=0.805
cc_248 ( N_GND_M9_noxref_d N_noxref_20_M10_noxref_d ) capacitor c=0.00162435f \
 //x=15.805 //y=1.055 //x2=16.78 //y2=1.09
cc_249 ( N_GND_c_5_p N_noxref_20_M11_noxref_s ) capacitor c=8.16352e-19 \
 //x=14.92 //y=0.175 //x2=17.885 //y2=0.555
cc_250 ( N_GND_c_6_p N_noxref_20_M11_noxref_s ) capacitor c=0.00183204f \
 //x=19.73 //y=0.175 //x2=17.885 //y2=0.555
cc_251 ( N_GND_c_8_p N_noxref_21_c_3169_n ) capacitor c=0.00530041f //x=28.61 \
 //y=0.18 //x2=21.205 //y2=1.77
cc_252 ( N_GND_c_65_p N_noxref_21_c_3169_n ) capacitor c=0.0011162f //x=20.72 \
 //y=0.175 //x2=21.205 //y2=1.77
cc_253 ( N_GND_c_72_p N_noxref_21_c_3169_n ) capacitor c=0.00180892f //x=24.37 \
 //y=0.175 //x2=21.205 //y2=1.77
cc_254 ( N_GND_M12_noxref_d N_noxref_21_c_3169_n ) capacitor c=0.00869761f \
 //x=20.615 //y=1.055 //x2=21.205 //y2=1.77
cc_255 ( N_GND_c_8_p N_noxref_21_c_3173_n ) capacitor c=0.00266677f //x=28.61 \
 //y=0.18 //x2=21.29 //y2=0.805
cc_256 ( N_GND_c_72_p N_noxref_21_c_3173_n ) capacitor c=0.0142029f //x=24.37 \
 //y=0.175 //x2=21.29 //y2=0.805
cc_257 ( N_GND_M12_noxref_d N_noxref_21_c_3173_n ) capacitor c=0.033954f \
 //x=20.615 //y=1.055 //x2=21.29 //y2=0.805
cc_258 ( N_GND_c_8_p N_noxref_21_c_3176_n ) capacitor c=0.0109346f //x=28.61 \
 //y=0.18 //x2=22.175 //y2=0.72
cc_259 ( N_GND_c_72_p N_noxref_21_c_3176_n ) capacitor c=0.0361571f //x=24.37 \
 //y=0.175 //x2=22.175 //y2=0.72
cc_260 ( N_GND_c_2_p N_noxref_21_c_3176_n ) capacitor c=0.00265129f //x=28.61 \
 //y=0.18 //x2=22.175 //y2=0.72
cc_261 ( N_GND_c_8_p N_noxref_21_M12_noxref_s ) capacitor c=0.0053241f \
 //x=28.61 //y=0.18 //x2=20.185 //y2=0.555
cc_262 ( N_GND_c_65_p N_noxref_21_M12_noxref_s ) capacitor c=0.0142029f \
 //x=20.72 //y=0.175 //x2=20.185 //y2=0.555
cc_263 ( N_GND_c_72_p N_noxref_21_M12_noxref_s ) capacitor c=0.0132459f \
 //x=24.37 //y=0.175 //x2=20.185 //y2=0.555
cc_264 ( N_GND_c_6_p N_noxref_21_M12_noxref_s ) capacitor c=0.0696963f \
 //x=19.73 //y=0.175 //x2=20.185 //y2=0.555
cc_265 ( N_GND_c_7_p N_noxref_21_M12_noxref_s ) capacitor c=3.31601e-19 \
 //x=24.54 //y=0.175 //x2=20.185 //y2=0.555
cc_266 ( N_GND_M12_noxref_d N_noxref_21_M12_noxref_s ) capacitor c=0.033718f \
 //x=20.615 //y=1.055 //x2=20.185 //y2=0.555
cc_267 ( N_GND_c_8_p N_noxref_22_c_3219_n ) capacitor c=0.00365025f //x=28.61 \
 //y=0.18 //x2=22.745 //y2=1.175
cc_268 ( N_GND_c_72_p N_noxref_22_c_3219_n ) capacitor c=0.00940539f //x=24.37 \
 //y=0.175 //x2=22.745 //y2=1.175
cc_269 ( N_GND_c_2_p N_noxref_22_c_3219_n ) capacitor c=3.54249e-19 //x=28.61 \
 //y=0.18 //x2=22.745 //y2=1.175
cc_270 ( N_GND_c_8_p N_noxref_22_c_3222_n ) capacitor c=0.00266677f //x=28.61 \
 //y=0.18 //x2=22.83 //y2=0.805
cc_271 ( N_GND_c_72_p N_noxref_22_c_3222_n ) capacitor c=0.0142029f //x=24.37 \
 //y=0.175 //x2=22.83 //y2=0.805
cc_272 ( N_GND_M12_noxref_d N_noxref_22_c_3222_n ) capacitor c=6.21394e-19 \
 //x=20.615 //y=1.055 //x2=22.83 //y2=0.805
cc_273 ( N_GND_c_8_p N_noxref_22_c_3225_n ) capacitor c=0.0110158f //x=28.61 \
 //y=0.18 //x2=23.715 //y2=0.72
cc_274 ( N_GND_c_72_p N_noxref_22_c_3225_n ) capacitor c=0.0365105f //x=24.37 \
 //y=0.175 //x2=23.715 //y2=0.72
cc_275 ( N_GND_c_2_p N_noxref_22_c_3225_n ) capacitor c=0.00283214f //x=28.61 \
 //y=0.18 //x2=23.715 //y2=0.72
cc_276 ( N_GND_c_8_p N_noxref_22_c_3228_n ) capacitor c=0.00266478f //x=28.61 \
 //y=0.18 //x2=23.8 //y2=0.805
cc_277 ( N_GND_c_72_p N_noxref_22_c_3228_n ) capacitor c=0.0141392f //x=24.37 \
 //y=0.175 //x2=23.8 //y2=0.805
cc_278 ( N_GND_c_7_p N_noxref_22_c_3228_n ) capacitor c=0.0404137f //x=24.54 \
 //y=0.175 //x2=23.8 //y2=0.805
cc_279 ( N_GND_M12_noxref_d N_noxref_22_M13_noxref_d ) capacitor c=0.00162435f \
 //x=20.615 //y=1.055 //x2=21.59 //y2=1.09
cc_280 ( N_GND_c_6_p N_noxref_22_M14_noxref_s ) capacitor c=8.16352e-19 \
 //x=19.73 //y=0.175 //x2=22.695 //y2=0.555
cc_281 ( N_GND_c_7_p N_noxref_22_M14_noxref_s ) capacitor c=0.00183204f \
 //x=24.54 //y=0.175 //x2=22.695 //y2=0.555
cc_282 ( N_GND_c_8_p N_noxref_23_c_3273_n ) capacitor c=0.00530041f //x=28.61 \
 //y=0.18 //x2=26.015 //y2=1.77
cc_283 ( N_GND_c_84_p N_noxref_23_c_3273_n ) capacitor c=0.0011162f //x=25.53 \
 //y=0.175 //x2=26.015 //y2=1.77
cc_284 ( N_GND_c_2_p N_noxref_23_c_3273_n ) capacitor c=0.00180892f //x=28.61 \
 //y=0.18 //x2=26.015 //y2=1.77
cc_285 ( N_GND_M15_noxref_d N_noxref_23_c_3273_n ) capacitor c=0.00869761f \
 //x=25.425 //y=1.055 //x2=26.015 //y2=1.77
cc_286 ( N_GND_c_8_p N_noxref_23_c_3277_n ) capacitor c=0.00266677f //x=28.61 \
 //y=0.18 //x2=26.1 //y2=0.805
cc_287 ( N_GND_c_2_p N_noxref_23_c_3277_n ) capacitor c=0.0142029f //x=28.61 \
 //y=0.18 //x2=26.1 //y2=0.805
cc_288 ( N_GND_M15_noxref_d N_noxref_23_c_3277_n ) capacitor c=0.033954f \
 //x=25.425 //y=1.055 //x2=26.1 //y2=0.805
cc_289 ( N_GND_c_8_p N_noxref_23_c_3280_n ) capacitor c=0.0110444f //x=28.61 \
 //y=0.18 //x2=26.985 //y2=0.72
cc_290 ( N_GND_c_2_p N_noxref_23_c_3280_n ) capacitor c=0.0385626f //x=28.61 \
 //y=0.18 //x2=26.985 //y2=0.72
cc_291 ( N_GND_c_8_p N_noxref_23_M15_noxref_s ) capacitor c=0.00563757f \
 //x=28.61 //y=0.18 //x2=24.995 //y2=0.555
cc_292 ( N_GND_c_84_p N_noxref_23_M15_noxref_s ) capacitor c=0.0142029f \
 //x=25.53 //y=0.175 //x2=24.995 //y2=0.555
cc_293 ( N_GND_c_2_p N_noxref_23_M15_noxref_s ) capacitor c=0.0129733f \
 //x=28.61 //y=0.18 //x2=24.995 //y2=0.555
cc_294 ( N_GND_c_7_p N_noxref_23_M15_noxref_s ) capacitor c=0.0696963f \
 //x=24.54 //y=0.175 //x2=24.995 //y2=0.555
cc_295 ( N_GND_M15_noxref_d N_noxref_23_M15_noxref_s ) capacitor c=0.033718f \
 //x=25.425 //y=1.055 //x2=24.995 //y2=0.555
cc_296 ( N_GND_c_8_p N_noxref_24_c_3323_n ) capacitor c=0.0039455f //x=28.61 \
 //y=0.18 //x2=27.555 //y2=1.175
cc_297 ( N_GND_c_2_p N_noxref_24_c_3323_n ) capacitor c=0.00866275f //x=28.61 \
 //y=0.18 //x2=27.555 //y2=1.175
cc_298 ( N_GND_c_8_p N_noxref_24_c_3325_n ) capacitor c=0.00296983f //x=28.61 \
 //y=0.18 //x2=27.64 //y2=0.805
cc_299 ( N_GND_c_2_p N_noxref_24_c_3325_n ) capacitor c=0.0140604f //x=28.61 \
 //y=0.18 //x2=27.64 //y2=0.805
cc_300 ( N_GND_M15_noxref_d N_noxref_24_c_3325_n ) capacitor c=6.21394e-19 \
 //x=25.425 //y=1.055 //x2=27.64 //y2=0.805
cc_301 ( N_GND_c_8_p N_noxref_24_c_3328_n ) capacitor c=0.0122164f //x=28.61 \
 //y=0.18 //x2=28.525 //y2=0.72
cc_302 ( N_GND_c_2_p N_noxref_24_c_3328_n ) capacitor c=0.0389144f //x=28.61 \
 //y=0.18 //x2=28.525 //y2=0.72
cc_303 ( N_GND_c_8_p N_noxref_24_c_3330_n ) capacitor c=0.00296193f //x=28.61 \
 //y=0.18 //x2=28.61 //y2=0.805
cc_304 ( N_GND_c_2_p N_noxref_24_c_3330_n ) capacitor c=0.0549457f //x=28.61 \
 //y=0.18 //x2=28.61 //y2=0.805
cc_305 ( N_GND_M15_noxref_d N_noxref_24_M16_noxref_d ) capacitor c=0.00162435f \
 //x=25.425 //y=1.055 //x2=26.4 //y2=1.09
cc_306 ( N_GND_c_2_p N_noxref_24_M17_noxref_s ) capacitor c=0.00183576f \
 //x=28.61 //y=0.18 //x2=27.505 //y2=0.555
cc_307 ( N_GND_c_7_p N_noxref_24_M17_noxref_s ) capacitor c=8.16352e-19 \
 //x=24.54 //y=0.175 //x2=27.505 //y2=0.555
cc_308 ( N_VDD_c_315_p N_noxref_3_c_684_n ) capacitor c=0.00557828f //x=28.61 \
 //y=7.58 //x2=2.815 //y2=5.335
cc_309 ( N_VDD_c_316_p N_noxref_3_c_684_n ) capacitor c=4.18731e-19 //x=2.375 \
 //y=7.585 //x2=2.815 //y2=5.335
cc_310 ( N_VDD_c_317_p N_noxref_3_c_684_n ) capacitor c=4.3239e-19 //x=3.255 \
 //y=7.585 //x2=2.815 //y2=5.335
cc_311 ( N_VDD_M19_noxref_d N_noxref_3_c_684_n ) capacitor c=0.0119121f \
 //x=2.315 //y=5.2 //x2=2.815 //y2=5.335
cc_312 ( N_VDD_c_308_n N_noxref_3_c_688_n ) capacitor c=0.00880189f //x=1.23 \
 //y=7.58 //x2=2.105 //y2=5.335
cc_313 ( N_VDD_M18_noxref_s N_noxref_3_c_688_n ) capacitor c=0.0831083f \
 //x=1.445 //y=5.2 //x2=2.105 //y2=5.335
cc_314 ( N_VDD_c_315_p N_noxref_3_c_690_n ) capacitor c=0.00442256f //x=28.61 \
 //y=7.58 //x2=3.695 //y2=5.335
cc_315 ( N_VDD_c_317_p N_noxref_3_c_690_n ) capacitor c=4.32416e-19 //x=3.255 \
 //y=7.585 //x2=3.695 //y2=5.335
cc_316 ( N_VDD_c_323_p N_noxref_3_c_690_n ) capacitor c=4.32416e-19 //x=4.135 \
 //y=7.585 //x2=3.695 //y2=5.335
cc_317 ( N_VDD_M21_noxref_d N_noxref_3_c_690_n ) capacitor c=0.0112992f \
 //x=3.195 //y=5.2 //x2=3.695 //y2=5.335
cc_318 ( N_VDD_c_315_p N_noxref_3_c_694_n ) capacitor c=0.00434594f //x=28.61 \
 //y=7.58 //x2=4.475 //y2=5.335
cc_319 ( N_VDD_c_323_p N_noxref_3_c_694_n ) capacitor c=7.47443e-19 //x=4.135 \
 //y=7.585 //x2=4.475 //y2=5.335
cc_320 ( N_VDD_c_327_p N_noxref_3_c_694_n ) capacitor c=0.00199034f //x=5.13 \
 //y=7.585 //x2=4.475 //y2=5.335
cc_321 ( N_VDD_M23_noxref_d N_noxref_3_c_694_n ) capacitor c=0.0112992f \
 //x=4.075 //y=5.2 //x2=4.475 //y2=5.335
cc_322 ( N_VDD_c_310_n N_noxref_3_c_698_n ) capacitor c=0.043403f //x=5.3 \
 //y=7.585 //x2=4.56 //y2=3.145
cc_323 ( N_VDD_c_315_p N_noxref_3_c_661_n ) capacitor c=9.09811e-19 //x=28.61 \
 //y=7.58 //x2=6.41 //y2=2.26
cc_324 ( N_VDD_c_310_n N_noxref_3_c_661_n ) capacitor c=0.0140736f //x=5.3 \
 //y=7.585 //x2=6.41 //y2=2.26
cc_325 ( N_VDD_M24_noxref_s N_noxref_3_c_661_n ) capacitor c=0.0120369f \
 //x=6.255 //y=5.2 //x2=6.41 //y2=2.26
cc_326 ( N_VDD_c_315_p N_noxref_3_c_662_n ) capacitor c=9.09811e-19 //x=28.61 \
 //y=7.58 //x2=11.22 //y2=2.26
cc_327 ( N_VDD_c_311_n N_noxref_3_c_662_n ) capacitor c=0.0134015f //x=10.11 \
 //y=7.585 //x2=11.22 //y2=2.26
cc_328 ( N_VDD_M30_noxref_s N_noxref_3_c_662_n ) capacitor c=0.0125365f \
 //x=11.065 //y=5.2 //x2=11.22 //y2=2.26
cc_329 ( N_VDD_c_336_p N_noxref_3_M24_noxref_g ) capacitor c=0.00755614f \
 //x=7.185 //y=7.585 //x2=6.61 //y2=6.2
cc_330 ( N_VDD_M24_noxref_s N_noxref_3_M24_noxref_g ) capacitor c=0.0477201f \
 //x=6.255 //y=5.2 //x2=6.61 //y2=6.2
cc_331 ( N_VDD_c_336_p N_noxref_3_M25_noxref_g ) capacitor c=0.00679791f \
 //x=7.185 //y=7.585 //x2=7.05 //y2=6.2
cc_332 ( N_VDD_M25_noxref_d N_noxref_3_M25_noxref_g ) capacitor c=0.015318f \
 //x=7.125 //y=5.2 //x2=7.05 //y2=6.2
cc_333 ( N_VDD_c_340_p N_noxref_3_M30_noxref_g ) capacitor c=0.00755614f \
 //x=11.995 //y=7.585 //x2=11.42 //y2=6.2
cc_334 ( N_VDD_M30_noxref_s N_noxref_3_M30_noxref_g ) capacitor c=0.0477201f \
 //x=11.065 //y=5.2 //x2=11.42 //y2=6.2
cc_335 ( N_VDD_c_340_p N_noxref_3_M31_noxref_g ) capacitor c=0.00679791f \
 //x=11.995 //y=7.585 //x2=11.86 //y2=6.2
cc_336 ( N_VDD_M31_noxref_d N_noxref_3_M31_noxref_g ) capacitor c=0.015318f \
 //x=11.935 //y=5.2 //x2=11.86 //y2=6.2
cc_337 ( N_VDD_c_310_n N_noxref_3_c_713_n ) capacitor c=0.00757682f //x=5.3 \
 //y=7.585 //x2=6.685 //y2=4.97
cc_338 ( N_VDD_M24_noxref_s N_noxref_3_c_713_n ) capacitor c=0.00444941f \
 //x=6.255 //y=5.2 //x2=6.685 //y2=4.97
cc_339 ( N_VDD_c_311_n N_noxref_3_c_715_n ) capacitor c=0.0076931f //x=10.11 \
 //y=7.585 //x2=11.495 //y2=4.97
cc_340 ( N_VDD_M30_noxref_s N_noxref_3_c_715_n ) capacitor c=0.00444941f \
 //x=11.065 //y=5.2 //x2=11.495 //y2=4.97
cc_341 ( N_VDD_c_315_p N_noxref_3_M18_noxref_d ) capacitor c=0.00707991f \
 //x=28.61 //y=7.58 //x2=1.875 //y2=5.2
cc_342 ( N_VDD_c_316_p N_noxref_3_M18_noxref_d ) capacitor c=0.0138842f \
 //x=2.375 //y=7.585 //x2=1.875 //y2=5.2
cc_343 ( N_VDD_M19_noxref_d N_noxref_3_M18_noxref_d ) capacitor c=0.0664752f \
 //x=2.315 //y=5.2 //x2=1.875 //y2=5.2
cc_344 ( N_VDD_c_315_p N_noxref_3_M20_noxref_d ) capacitor c=0.0027526f \
 //x=28.61 //y=7.58 //x2=2.755 //y2=5.2
cc_345 ( N_VDD_c_317_p N_noxref_3_M20_noxref_d ) capacitor c=0.0140573f \
 //x=3.255 //y=7.585 //x2=2.755 //y2=5.2
cc_346 ( N_VDD_c_310_n N_noxref_3_M20_noxref_d ) capacitor c=4.9285e-19 \
 //x=5.3 //y=7.585 //x2=2.755 //y2=5.2
cc_347 ( N_VDD_M18_noxref_s N_noxref_3_M20_noxref_d ) capacitor c=0.00130656f \
 //x=1.445 //y=5.2 //x2=2.755 //y2=5.2
cc_348 ( N_VDD_M19_noxref_d N_noxref_3_M20_noxref_d ) capacitor c=0.0664752f \
 //x=2.315 //y=5.2 //x2=2.755 //y2=5.2
cc_349 ( N_VDD_M21_noxref_d N_noxref_3_M20_noxref_d ) capacitor c=0.0664752f \
 //x=3.195 //y=5.2 //x2=2.755 //y2=5.2
cc_350 ( N_VDD_c_315_p N_noxref_3_M22_noxref_d ) capacitor c=0.00275309f \
 //x=28.61 //y=7.58 //x2=3.635 //y2=5.2
cc_351 ( N_VDD_c_323_p N_noxref_3_M22_noxref_d ) capacitor c=0.01376f \
 //x=4.135 //y=7.585 //x2=3.635 //y2=5.2
cc_352 ( N_VDD_c_310_n N_noxref_3_M22_noxref_d ) capacitor c=0.00939849f \
 //x=5.3 //y=7.585 //x2=3.635 //y2=5.2
cc_353 ( N_VDD_M21_noxref_d N_noxref_3_M22_noxref_d ) capacitor c=0.0664752f \
 //x=3.195 //y=5.2 //x2=3.635 //y2=5.2
cc_354 ( N_VDD_M23_noxref_d N_noxref_3_M22_noxref_d ) capacitor c=0.0664752f \
 //x=4.075 //y=5.2 //x2=3.635 //y2=5.2
cc_355 ( N_VDD_M24_noxref_s N_noxref_3_M22_noxref_d ) capacitor c=3.57641e-19 \
 //x=6.255 //y=5.2 //x2=3.635 //y2=5.2
cc_356 ( N_VDD_c_315_p N_noxref_4_c_915_n ) capacitor c=0.00444939f //x=28.61 \
 //y=7.58 //x2=12.435 //y2=5.335
cc_357 ( N_VDD_c_340_p N_noxref_4_c_915_n ) capacitor c=4.32416e-19 //x=11.995 \
 //y=7.585 //x2=12.435 //y2=5.335
cc_358 ( N_VDD_c_365_p N_noxref_4_c_915_n ) capacitor c=4.32416e-19 //x=12.875 \
 //y=7.585 //x2=12.435 //y2=5.335
cc_359 ( N_VDD_M31_noxref_d N_noxref_4_c_915_n ) capacitor c=0.0112992f \
 //x=11.935 //y=5.2 //x2=12.435 //y2=5.335
cc_360 ( N_VDD_c_311_n N_noxref_4_c_919_n ) capacitor c=0.00863585f //x=10.11 \
 //y=7.585 //x2=11.725 //y2=5.335
cc_361 ( N_VDD_M30_noxref_s N_noxref_4_c_919_n ) capacitor c=0.0831083f \
 //x=11.065 //y=5.2 //x2=11.725 //y2=5.335
cc_362 ( N_VDD_c_315_p N_noxref_4_c_921_n ) capacitor c=0.00442256f //x=28.61 \
 //y=7.58 //x2=13.315 //y2=5.335
cc_363 ( N_VDD_c_365_p N_noxref_4_c_921_n ) capacitor c=4.32416e-19 //x=12.875 \
 //y=7.585 //x2=13.315 //y2=5.335
cc_364 ( N_VDD_c_371_p N_noxref_4_c_921_n ) capacitor c=4.32416e-19 //x=13.755 \
 //y=7.585 //x2=13.315 //y2=5.335
cc_365 ( N_VDD_M33_noxref_d N_noxref_4_c_921_n ) capacitor c=0.0112992f \
 //x=12.815 //y=5.2 //x2=13.315 //y2=5.335
cc_366 ( N_VDD_c_315_p N_noxref_4_c_925_n ) capacitor c=0.00434594f //x=28.61 \
 //y=7.58 //x2=14.095 //y2=5.335
cc_367 ( N_VDD_c_371_p N_noxref_4_c_925_n ) capacitor c=7.47443e-19 //x=13.755 \
 //y=7.585 //x2=14.095 //y2=5.335
cc_368 ( N_VDD_c_375_p N_noxref_4_c_925_n ) capacitor c=0.00199034f //x=14.75 \
 //y=7.585 //x2=14.095 //y2=5.335
cc_369 ( N_VDD_M35_noxref_d N_noxref_4_c_925_n ) capacitor c=0.0112992f \
 //x=13.695 //y=5.2 //x2=14.095 //y2=5.335
cc_370 ( N_VDD_c_312_n N_noxref_4_c_929_n ) capacitor c=0.0427356f //x=14.92 \
 //y=7.585 //x2=14.18 //y2=3.14
cc_371 ( N_VDD_c_315_p N_noxref_4_c_903_n ) capacitor c=9.09811e-19 //x=28.61 \
 //y=7.58 //x2=16.03 //y2=2.26
cc_372 ( N_VDD_c_312_n N_noxref_4_c_903_n ) capacitor c=0.0133888f //x=14.92 \
 //y=7.585 //x2=16.03 //y2=2.26
cc_373 ( N_VDD_M36_noxref_s N_noxref_4_c_903_n ) capacitor c=0.0125365f \
 //x=15.875 //y=5.2 //x2=16.03 //y2=2.26
cc_374 ( N_VDD_c_381_p N_noxref_4_M36_noxref_g ) capacitor c=0.00755614f \
 //x=16.805 //y=7.585 //x2=16.23 //y2=6.2
cc_375 ( N_VDD_M36_noxref_s N_noxref_4_M36_noxref_g ) capacitor c=0.0477201f \
 //x=15.875 //y=5.2 //x2=16.23 //y2=6.2
cc_376 ( N_VDD_c_381_p N_noxref_4_M37_noxref_g ) capacitor c=0.00679791f \
 //x=16.805 //y=7.585 //x2=16.67 //y2=6.2
cc_377 ( N_VDD_M37_noxref_d N_noxref_4_M37_noxref_g ) capacitor c=0.015318f \
 //x=16.745 //y=5.2 //x2=16.67 //y2=6.2
cc_378 ( N_VDD_c_312_n N_noxref_4_c_937_n ) capacitor c=0.00757682f //x=14.92 \
 //y=7.585 //x2=16.305 //y2=4.97
cc_379 ( N_VDD_M36_noxref_s N_noxref_4_c_937_n ) capacitor c=0.00444941f \
 //x=15.875 //y=5.2 //x2=16.305 //y2=4.97
cc_380 ( N_VDD_c_315_p N_noxref_4_M30_noxref_d ) capacitor c=0.00275309f \
 //x=28.61 //y=7.58 //x2=11.495 //y2=5.2
cc_381 ( N_VDD_c_340_p N_noxref_4_M30_noxref_d ) capacitor c=0.0140577f \
 //x=11.995 //y=7.585 //x2=11.495 //y2=5.2
cc_382 ( N_VDD_M31_noxref_d N_noxref_4_M30_noxref_d ) capacitor c=0.0664752f \
 //x=11.935 //y=5.2 //x2=11.495 //y2=5.2
cc_383 ( N_VDD_c_315_p N_noxref_4_M32_noxref_d ) capacitor c=0.00275309f \
 //x=28.61 //y=7.58 //x2=12.375 //y2=5.2
cc_384 ( N_VDD_c_365_p N_noxref_4_M32_noxref_d ) capacitor c=0.0140577f \
 //x=12.875 //y=7.585 //x2=12.375 //y2=5.2
cc_385 ( N_VDD_c_312_n N_noxref_4_M32_noxref_d ) capacitor c=4.9285e-19 \
 //x=14.92 //y=7.585 //x2=12.375 //y2=5.2
cc_386 ( N_VDD_M30_noxref_s N_noxref_4_M32_noxref_d ) capacitor c=0.00130656f \
 //x=11.065 //y=5.2 //x2=12.375 //y2=5.2
cc_387 ( N_VDD_M31_noxref_d N_noxref_4_M32_noxref_d ) capacitor c=0.0664752f \
 //x=11.935 //y=5.2 //x2=12.375 //y2=5.2
cc_388 ( N_VDD_M33_noxref_d N_noxref_4_M32_noxref_d ) capacitor c=0.0664752f \
 //x=12.815 //y=5.2 //x2=12.375 //y2=5.2
cc_389 ( N_VDD_c_315_p N_noxref_4_M34_noxref_d ) capacitor c=0.00275309f \
 //x=28.61 //y=7.58 //x2=13.255 //y2=5.2
cc_390 ( N_VDD_c_371_p N_noxref_4_M34_noxref_d ) capacitor c=0.0140577f \
 //x=13.755 //y=7.585 //x2=13.255 //y2=5.2
cc_391 ( N_VDD_c_312_n N_noxref_4_M34_noxref_d ) capacitor c=0.00939849f \
 //x=14.92 //y=7.585 //x2=13.255 //y2=5.2
cc_392 ( N_VDD_M33_noxref_d N_noxref_4_M34_noxref_d ) capacitor c=0.0664752f \
 //x=12.815 //y=5.2 //x2=13.255 //y2=5.2
cc_393 ( N_VDD_M35_noxref_d N_noxref_4_M34_noxref_d ) capacitor c=0.0664752f \
 //x=13.695 //y=5.2 //x2=13.255 //y2=5.2
cc_394 ( N_VDD_M36_noxref_s N_noxref_4_M34_noxref_d ) capacitor c=3.57641e-19 \
 //x=15.875 //y=5.2 //x2=13.255 //y2=5.2
cc_395 ( N_VDD_c_315_p N_CLK_c_1062_n ) capacitor c=2.03391e-19 //x=28.61 \
 //y=7.58 //x2=7.52 //y2=2.26
cc_396 ( N_VDD_c_310_n N_CLK_c_1062_n ) capacitor c=6.95672e-19 //x=5.3 \
 //y=7.585 //x2=7.52 //y2=2.26
cc_397 ( N_VDD_c_315_p N_CLK_c_1063_n ) capacitor c=2.03391e-19 //x=28.61 \
 //y=7.58 //x2=17.14 //y2=2.26
cc_398 ( N_VDD_c_312_n N_CLK_c_1063_n ) capacitor c=6.29521e-19 //x=14.92 \
 //y=7.585 //x2=17.14 //y2=2.26
cc_399 ( N_VDD_c_406_p N_CLK_M26_noxref_g ) capacitor c=0.00680845f //x=8.065 \
 //y=7.585 //x2=7.49 //y2=6.2
cc_400 ( N_VDD_M25_noxref_d N_CLK_M26_noxref_g ) capacitor c=0.015318f \
 //x=7.125 //y=5.2 //x2=7.49 //y2=6.2
cc_401 ( N_VDD_c_406_p N_CLK_M27_noxref_g ) capacitor c=0.00679791f //x=8.065 \
 //y=7.585 //x2=7.93 //y2=6.2
cc_402 ( N_VDD_M27_noxref_d N_CLK_M27_noxref_g ) capacitor c=0.015318f \
 //x=8.005 //y=5.2 //x2=7.93 //y2=6.2
cc_403 ( N_VDD_c_410_p N_CLK_M38_noxref_g ) capacitor c=0.00680845f //x=17.685 \
 //y=7.585 //x2=17.11 //y2=6.2
cc_404 ( N_VDD_M37_noxref_d N_CLK_M38_noxref_g ) capacitor c=0.015318f \
 //x=16.745 //y=5.2 //x2=17.11 //y2=6.2
cc_405 ( N_VDD_c_410_p N_CLK_M39_noxref_g ) capacitor c=0.00679791f //x=17.685 \
 //y=7.585 //x2=17.55 //y2=6.2
cc_406 ( N_VDD_M39_noxref_d N_CLK_M39_noxref_g ) capacitor c=0.015318f \
 //x=17.625 //y=5.2 //x2=17.55 //y2=6.2
cc_407 ( N_VDD_c_310_n N_noxref_6_c_1251_n ) capacitor c=0.00686858f //x=5.3 \
 //y=7.585 //x2=9.255 //y2=3.88
cc_408 ( N_VDD_c_310_n N_noxref_6_c_1254_n ) capacitor c=7.23426e-19 //x=5.3 \
 //y=7.585 //x2=3.82 //y2=2.26
cc_409 ( N_VDD_c_315_p N_noxref_6_c_1270_n ) capacitor c=0.00444939f //x=28.61 \
 //y=7.58 //x2=7.625 //y2=5.335
cc_410 ( N_VDD_c_336_p N_noxref_6_c_1270_n ) capacitor c=4.32416e-19 //x=7.185 \
 //y=7.585 //x2=7.625 //y2=5.335
cc_411 ( N_VDD_c_406_p N_noxref_6_c_1270_n ) capacitor c=4.32416e-19 //x=8.065 \
 //y=7.585 //x2=7.625 //y2=5.335
cc_412 ( N_VDD_M25_noxref_d N_noxref_6_c_1270_n ) capacitor c=0.0112992f \
 //x=7.125 //y=5.2 //x2=7.625 //y2=5.335
cc_413 ( N_VDD_c_310_n N_noxref_6_c_1274_n ) capacitor c=0.00863585f //x=5.3 \
 //y=7.585 //x2=6.915 //y2=5.335
cc_414 ( N_VDD_M24_noxref_s N_noxref_6_c_1274_n ) capacitor c=0.0831083f \
 //x=6.255 //y=5.2 //x2=6.915 //y2=5.335
cc_415 ( N_VDD_c_315_p N_noxref_6_c_1276_n ) capacitor c=0.00442256f //x=28.61 \
 //y=7.58 //x2=8.505 //y2=5.335
cc_416 ( N_VDD_c_406_p N_noxref_6_c_1276_n ) capacitor c=4.32416e-19 //x=8.065 \
 //y=7.585 //x2=8.505 //y2=5.335
cc_417 ( N_VDD_c_424_p N_noxref_6_c_1276_n ) capacitor c=4.32416e-19 //x=8.945 \
 //y=7.585 //x2=8.505 //y2=5.335
cc_418 ( N_VDD_M27_noxref_d N_noxref_6_c_1276_n ) capacitor c=0.0112992f \
 //x=8.005 //y=5.2 //x2=8.505 //y2=5.335
cc_419 ( N_VDD_c_315_p N_noxref_6_c_1280_n ) capacitor c=0.00434594f //x=28.61 \
 //y=7.58 //x2=9.285 //y2=5.335
cc_420 ( N_VDD_c_424_p N_noxref_6_c_1280_n ) capacitor c=7.47443e-19 //x=8.945 \
 //y=7.585 //x2=9.285 //y2=5.335
cc_421 ( N_VDD_c_428_p N_noxref_6_c_1280_n ) capacitor c=0.00199034f //x=9.94 \
 //y=7.585 //x2=9.285 //y2=5.335
cc_422 ( N_VDD_M29_noxref_d N_noxref_6_c_1280_n ) capacitor c=0.0112992f \
 //x=8.885 //y=5.2 //x2=9.285 //y2=5.335
cc_423 ( N_VDD_c_311_n N_noxref_6_c_1284_n ) capacitor c=0.0427358f //x=10.11 \
 //y=7.585 //x2=9.37 //y2=3.88
cc_424 ( N_VDD_c_315_p N_noxref_6_c_1256_n ) capacitor c=9.09811e-19 //x=28.61 \
 //y=7.58 //x2=20.84 //y2=2.26
cc_425 ( N_VDD_c_313_n N_noxref_6_c_1256_n ) capacitor c=0.013309f //x=19.73 \
 //y=7.585 //x2=20.84 //y2=2.26
cc_426 ( N_VDD_M42_noxref_s N_noxref_6_c_1256_n ) capacitor c=0.0120369f \
 //x=20.685 //y=5.2 //x2=20.84 //y2=2.26
cc_427 ( N_VDD_c_323_p N_noxref_6_M22_noxref_g ) capacitor c=0.00679791f \
 //x=4.135 //y=7.585 //x2=3.56 //y2=6.2
cc_428 ( N_VDD_M21_noxref_d N_noxref_6_M22_noxref_g ) capacitor c=0.015318f \
 //x=3.195 //y=5.2 //x2=3.56 //y2=6.2
cc_429 ( N_VDD_c_323_p N_noxref_6_M23_noxref_g ) capacitor c=0.00680002f \
 //x=4.135 //y=7.585 //x2=4 //y2=6.2
cc_430 ( N_VDD_M23_noxref_d N_noxref_6_M23_noxref_g ) capacitor c=0.0394719f \
 //x=4.075 //y=5.2 //x2=4 //y2=6.2
cc_431 ( N_VDD_c_438_p N_noxref_6_M42_noxref_g ) capacitor c=0.00755614f \
 //x=21.615 //y=7.585 //x2=21.04 //y2=6.2
cc_432 ( N_VDD_M42_noxref_s N_noxref_6_M42_noxref_g ) capacitor c=0.0477201f \
 //x=20.685 //y=5.2 //x2=21.04 //y2=6.2
cc_433 ( N_VDD_c_438_p N_noxref_6_M43_noxref_g ) capacitor c=0.00679791f \
 //x=21.615 //y=7.585 //x2=21.48 //y2=6.2
cc_434 ( N_VDD_M43_noxref_d N_noxref_6_M43_noxref_g ) capacitor c=0.015318f \
 //x=21.555 //y=5.2 //x2=21.48 //y2=6.2
cc_435 ( N_VDD_c_313_n N_noxref_6_c_1296_n ) capacitor c=0.00757682f //x=19.73 \
 //y=7.585 //x2=21.115 //y2=4.97
cc_436 ( N_VDD_M42_noxref_s N_noxref_6_c_1296_n ) capacitor c=0.00444941f \
 //x=20.685 //y=5.2 //x2=21.115 //y2=4.97
cc_437 ( N_VDD_c_315_p N_noxref_6_M24_noxref_d ) capacitor c=0.00275309f \
 //x=28.61 //y=7.58 //x2=6.685 //y2=5.2
cc_438 ( N_VDD_c_336_p N_noxref_6_M24_noxref_d ) capacitor c=0.0140577f \
 //x=7.185 //y=7.585 //x2=6.685 //y2=5.2
cc_439 ( N_VDD_M25_noxref_d N_noxref_6_M24_noxref_d ) capacitor c=0.0664752f \
 //x=7.125 //y=5.2 //x2=6.685 //y2=5.2
cc_440 ( N_VDD_c_315_p N_noxref_6_M26_noxref_d ) capacitor c=0.00275309f \
 //x=28.61 //y=7.58 //x2=7.565 //y2=5.2
cc_441 ( N_VDD_c_406_p N_noxref_6_M26_noxref_d ) capacitor c=0.0140577f \
 //x=8.065 //y=7.585 //x2=7.565 //y2=5.2
cc_442 ( N_VDD_c_311_n N_noxref_6_M26_noxref_d ) capacitor c=4.9285e-19 \
 //x=10.11 //y=7.585 //x2=7.565 //y2=5.2
cc_443 ( N_VDD_M24_noxref_s N_noxref_6_M26_noxref_d ) capacitor c=0.00130656f \
 //x=6.255 //y=5.2 //x2=7.565 //y2=5.2
cc_444 ( N_VDD_M25_noxref_d N_noxref_6_M26_noxref_d ) capacitor c=0.0664752f \
 //x=7.125 //y=5.2 //x2=7.565 //y2=5.2
cc_445 ( N_VDD_M27_noxref_d N_noxref_6_M26_noxref_d ) capacitor c=0.0664752f \
 //x=8.005 //y=5.2 //x2=7.565 //y2=5.2
cc_446 ( N_VDD_c_315_p N_noxref_6_M28_noxref_d ) capacitor c=0.00275309f \
 //x=28.61 //y=7.58 //x2=8.445 //y2=5.2
cc_447 ( N_VDD_c_424_p N_noxref_6_M28_noxref_d ) capacitor c=0.0140577f \
 //x=8.945 //y=7.585 //x2=8.445 //y2=5.2
cc_448 ( N_VDD_c_311_n N_noxref_6_M28_noxref_d ) capacitor c=0.00939849f \
 //x=10.11 //y=7.585 //x2=8.445 //y2=5.2
cc_449 ( N_VDD_M27_noxref_d N_noxref_6_M28_noxref_d ) capacitor c=0.0664752f \
 //x=8.005 //y=5.2 //x2=8.445 //y2=5.2
cc_450 ( N_VDD_M29_noxref_d N_noxref_6_M28_noxref_d ) capacitor c=0.0664752f \
 //x=8.885 //y=5.2 //x2=8.445 //y2=5.2
cc_451 ( N_VDD_M30_noxref_s N_noxref_6_M28_noxref_d ) capacitor c=3.57641e-19 \
 //x=11.065 //y=5.2 //x2=8.445 //y2=5.2
cc_452 ( N_VDD_c_315_p N_RN_c_1511_n ) capacitor c=0.115622f //x=28.61 \
 //y=7.58 //x2=18.135 //y2=4.62
cc_453 ( N_VDD_c_327_p N_RN_c_1511_n ) capacitor c=0.00258661f //x=5.13 \
 //y=7.585 //x2=18.135 //y2=4.62
cc_454 ( N_VDD_c_461_p N_RN_c_1511_n ) capacitor c=0.00329211f //x=6.305 \
 //y=7.585 //x2=18.135 //y2=4.62
cc_455 ( N_VDD_c_336_p N_RN_c_1511_n ) capacitor c=0.00135946f //x=7.185 \
 //y=7.585 //x2=18.135 //y2=4.62
cc_456 ( N_VDD_c_428_p N_RN_c_1511_n ) capacitor c=0.00258661f //x=9.94 \
 //y=7.585 //x2=18.135 //y2=4.62
cc_457 ( N_VDD_c_464_p N_RN_c_1511_n ) capacitor c=0.00329211f //x=11.115 \
 //y=7.585 //x2=18.135 //y2=4.62
cc_458 ( N_VDD_c_340_p N_RN_c_1511_n ) capacitor c=0.00135946f //x=11.995 \
 //y=7.585 //x2=18.135 //y2=4.62
cc_459 ( N_VDD_c_375_p N_RN_c_1511_n ) capacitor c=0.00258661f //x=14.75 \
 //y=7.585 //x2=18.135 //y2=4.62
cc_460 ( N_VDD_c_467_p N_RN_c_1511_n ) capacitor c=0.00329211f //x=15.925 \
 //y=7.585 //x2=18.135 //y2=4.62
cc_461 ( N_VDD_c_381_p N_RN_c_1511_n ) capacitor c=0.00135946f //x=16.805 \
 //y=7.585 //x2=18.135 //y2=4.62
cc_462 ( N_VDD_c_310_n N_RN_c_1511_n ) capacitor c=0.0375613f //x=5.3 \
 //y=7.585 //x2=18.135 //y2=4.62
cc_463 ( N_VDD_c_311_n N_RN_c_1511_n ) capacitor c=0.0389825f //x=10.11 \
 //y=7.585 //x2=18.135 //y2=4.62
cc_464 ( N_VDD_c_312_n N_RN_c_1511_n ) capacitor c=0.0389825f //x=14.92 \
 //y=7.585 //x2=18.135 //y2=4.62
cc_465 ( N_VDD_M24_noxref_s N_RN_c_1511_n ) capacitor c=0.00179503f //x=6.255 \
 //y=5.2 //x2=18.135 //y2=4.62
cc_466 ( N_VDD_M30_noxref_s N_RN_c_1511_n ) capacitor c=0.00179503f //x=11.065 \
 //y=5.2 //x2=18.135 //y2=4.62
cc_467 ( N_VDD_M36_noxref_s N_RN_c_1511_n ) capacitor c=0.00179503f //x=15.875 \
 //y=5.2 //x2=18.135 //y2=4.62
cc_468 ( N_VDD_c_315_p N_RN_c_1512_n ) capacitor c=0.00146234f //x=28.61 \
 //y=7.58 //x2=2.825 //y2=4.62
cc_469 ( N_VDD_c_315_p N_RN_c_1533_n ) capacitor c=0.0282968f //x=28.61 \
 //y=7.58 //x2=21.835 //y2=4.62
cc_470 ( N_VDD_c_477_p N_RN_c_1533_n ) capacitor c=0.00258661f //x=19.56 \
 //y=7.585 //x2=21.835 //y2=4.62
cc_471 ( N_VDD_c_478_p N_RN_c_1533_n ) capacitor c=0.00329211f //x=20.735 \
 //y=7.585 //x2=21.835 //y2=4.62
cc_472 ( N_VDD_c_438_p N_RN_c_1533_n ) capacitor c=0.00135946f //x=21.615 \
 //y=7.585 //x2=21.835 //y2=4.62
cc_473 ( N_VDD_c_313_n N_RN_c_1533_n ) capacitor c=0.0389825f //x=19.73 \
 //y=7.585 //x2=21.835 //y2=4.62
cc_474 ( N_VDD_M42_noxref_s N_RN_c_1533_n ) capacitor c=0.00179503f //x=20.685 \
 //y=5.2 //x2=21.835 //y2=4.62
cc_475 ( N_VDD_c_315_p N_RN_c_1539_n ) capacitor c=0.00110884f //x=28.61 \
 //y=7.58 //x2=18.365 //y2=4.62
cc_476 ( N_VDD_c_315_p N_RN_c_1513_n ) capacitor c=2.03193e-19 //x=28.61 \
 //y=7.58 //x2=2.71 //y2=2.26
cc_477 ( N_VDD_c_308_n N_RN_c_1513_n ) capacitor c=8.7832e-19 //x=1.23 \
 //y=7.58 //x2=2.71 //y2=2.26
cc_478 ( N_VDD_c_313_n N_RN_c_1514_n ) capacitor c=6.89593e-19 //x=19.73 \
 //y=7.585 //x2=18.25 //y2=2.26
cc_479 ( N_VDD_c_315_p N_RN_c_1515_n ) capacitor c=2.03193e-19 //x=28.61 \
 //y=7.58 //x2=21.95 //y2=2.26
cc_480 ( N_VDD_c_313_n N_RN_c_1515_n ) capacitor c=6.41871e-19 //x=19.73 \
 //y=7.585 //x2=21.95 //y2=2.26
cc_481 ( N_VDD_c_317_p N_RN_M20_noxref_g ) capacitor c=0.00680845f //x=3.255 \
 //y=7.585 //x2=2.68 //y2=6.2
cc_482 ( N_VDD_M19_noxref_d N_RN_M20_noxref_g ) capacitor c=0.015318f \
 //x=2.315 //y=5.2 //x2=2.68 //y2=6.2
cc_483 ( N_VDD_c_317_p N_RN_M21_noxref_g ) capacitor c=0.00679791f //x=3.255 \
 //y=7.585 //x2=3.12 //y2=6.2
cc_484 ( N_VDD_M21_noxref_d N_RN_M21_noxref_g ) capacitor c=0.015318f \
 //x=3.195 //y=5.2 //x2=3.12 //y2=6.2
cc_485 ( N_VDD_c_492_p N_RN_M40_noxref_g ) capacitor c=0.00679791f //x=18.565 \
 //y=7.585 //x2=17.99 //y2=6.2
cc_486 ( N_VDD_M39_noxref_d N_RN_M40_noxref_g ) capacitor c=0.015318f \
 //x=17.625 //y=5.2 //x2=17.99 //y2=6.2
cc_487 ( N_VDD_c_492_p N_RN_M41_noxref_g ) capacitor c=0.00680002f //x=18.565 \
 //y=7.585 //x2=18.43 //y2=6.2
cc_488 ( N_VDD_M41_noxref_d N_RN_M41_noxref_g ) capacitor c=0.0394719f \
 //x=18.505 //y=5.2 //x2=18.43 //y2=6.2
cc_489 ( N_VDD_c_496_p N_RN_M44_noxref_g ) capacitor c=0.00680845f //x=22.495 \
 //y=7.585 //x2=21.92 //y2=6.2
cc_490 ( N_VDD_M43_noxref_d N_RN_M44_noxref_g ) capacitor c=0.015318f \
 //x=21.555 //y=5.2 //x2=21.92 //y2=6.2
cc_491 ( N_VDD_c_496_p N_RN_M45_noxref_g ) capacitor c=0.00679791f //x=22.495 \
 //y=7.585 //x2=22.36 //y2=6.2
cc_492 ( N_VDD_M45_noxref_d N_RN_M45_noxref_g ) capacitor c=0.015318f \
 //x=22.435 //y=5.2 //x2=22.36 //y2=6.2
cc_493 ( N_VDD_c_314_n QN ) capacitor c=0.045031f //x=24.54 //y=7.585 \
 //x2=23.8 //y2=2.4
cc_494 ( N_VDD_c_315_p N_QN_c_1835_n ) capacitor c=0.00444798f //x=28.61 \
 //y=7.58 //x2=22.055 //y2=5.335
cc_495 ( N_VDD_c_438_p N_QN_c_1835_n ) capacitor c=4.32416e-19 //x=21.615 \
 //y=7.585 //x2=22.055 //y2=5.335
cc_496 ( N_VDD_c_496_p N_QN_c_1835_n ) capacitor c=4.3239e-19 //x=22.495 \
 //y=7.585 //x2=22.055 //y2=5.335
cc_497 ( N_VDD_M43_noxref_d N_QN_c_1835_n ) capacitor c=0.0112992f //x=21.555 \
 //y=5.2 //x2=22.055 //y2=5.335
cc_498 ( N_VDD_c_313_n N_QN_c_1839_n ) capacitor c=0.00863585f //x=19.73 \
 //y=7.585 //x2=21.345 //y2=5.335
cc_499 ( N_VDD_M42_noxref_s N_QN_c_1839_n ) capacitor c=0.0831083f //x=20.685 \
 //y=5.2 //x2=21.345 //y2=5.335
cc_500 ( N_VDD_c_315_p N_QN_c_1841_n ) capacitor c=0.00449039f //x=28.61 \
 //y=7.58 //x2=22.935 //y2=5.335
cc_501 ( N_VDD_c_496_p N_QN_c_1841_n ) capacitor c=4.32713e-19 //x=22.495 \
 //y=7.585 //x2=22.935 //y2=5.335
cc_502 ( N_VDD_c_509_p N_QN_c_1841_n ) capacitor c=4.32713e-19 //x=23.375 \
 //y=7.585 //x2=22.935 //y2=5.335
cc_503 ( N_VDD_M45_noxref_d N_QN_c_1841_n ) capacitor c=0.0115154f //x=22.435 \
 //y=5.2 //x2=22.935 //y2=5.335
cc_504 ( N_VDD_c_315_p N_QN_c_1845_n ) capacitor c=0.00443036f //x=28.61 \
 //y=7.58 //x2=23.715 //y2=5.335
cc_505 ( N_VDD_c_509_p N_QN_c_1845_n ) capacitor c=7.48482e-19 //x=23.375 \
 //y=7.585 //x2=23.715 //y2=5.335
cc_506 ( N_VDD_c_513_p N_QN_c_1845_n ) capacitor c=0.00199449f //x=24.37 \
 //y=7.585 //x2=23.715 //y2=5.335
cc_507 ( N_VDD_M47_noxref_d N_QN_c_1845_n ) capacitor c=0.0115154f //x=23.315 \
 //y=5.2 //x2=23.715 //y2=5.335
cc_508 ( N_VDD_c_315_p N_QN_c_1822_n ) capacitor c=9.22979e-19 //x=28.61 \
 //y=7.58 //x2=25.65 //y2=2.26
cc_509 ( N_VDD_c_314_n N_QN_c_1822_n ) capacitor c=0.0160291f //x=24.54 \
 //y=7.585 //x2=25.65 //y2=2.26
cc_510 ( N_VDD_M48_noxref_s N_QN_c_1822_n ) capacitor c=0.0123185f //x=25.495 \
 //y=5.2 //x2=25.65 //y2=2.26
cc_511 ( N_VDD_c_518_p N_QN_M48_noxref_g ) capacitor c=0.00755614f //x=26.425 \
 //y=7.585 //x2=25.85 //y2=6.2
cc_512 ( N_VDD_M48_noxref_s N_QN_M48_noxref_g ) capacitor c=0.0477201f \
 //x=25.495 //y=5.2 //x2=25.85 //y2=6.2
cc_513 ( N_VDD_c_518_p N_QN_M49_noxref_g ) capacitor c=0.00679791f //x=26.425 \
 //y=7.585 //x2=26.29 //y2=6.2
cc_514 ( N_VDD_M49_noxref_d N_QN_M49_noxref_g ) capacitor c=0.015318f \
 //x=26.365 //y=5.2 //x2=26.29 //y2=6.2
cc_515 ( N_VDD_c_314_n N_QN_c_1856_n ) capacitor c=0.00757682f //x=24.54 \
 //y=7.585 //x2=25.925 //y2=4.97
cc_516 ( N_VDD_M48_noxref_s N_QN_c_1856_n ) capacitor c=0.0044516f //x=25.495 \
 //y=5.2 //x2=25.925 //y2=4.97
cc_517 ( N_VDD_c_315_p N_QN_M42_noxref_d ) capacitor c=0.00275309f //x=28.61 \
 //y=7.58 //x2=21.115 //y2=5.2
cc_518 ( N_VDD_c_438_p N_QN_M42_noxref_d ) capacitor c=0.0140577f //x=21.615 \
 //y=7.585 //x2=21.115 //y2=5.2
cc_519 ( N_VDD_M43_noxref_d N_QN_M42_noxref_d ) capacitor c=0.0664752f \
 //x=21.555 //y=5.2 //x2=21.115 //y2=5.2
cc_520 ( N_VDD_c_315_p N_QN_M44_noxref_d ) capacitor c=0.00282784f //x=28.61 \
 //y=7.58 //x2=21.995 //y2=5.2
cc_521 ( N_VDD_c_496_p N_QN_M44_noxref_d ) capacitor c=0.0141082f //x=22.495 \
 //y=7.585 //x2=21.995 //y2=5.2
cc_522 ( N_VDD_c_314_n N_QN_M44_noxref_d ) capacitor c=4.9285e-19 //x=24.54 \
 //y=7.585 //x2=21.995 //y2=5.2
cc_523 ( N_VDD_M42_noxref_s N_QN_M44_noxref_d ) capacitor c=0.00130656f \
 //x=20.685 //y=5.2 //x2=21.995 //y2=5.2
cc_524 ( N_VDD_M43_noxref_d N_QN_M44_noxref_d ) capacitor c=0.0664752f \
 //x=21.555 //y=5.2 //x2=21.995 //y2=5.2
cc_525 ( N_VDD_M45_noxref_d N_QN_M44_noxref_d ) capacitor c=0.0664752f \
 //x=22.435 //y=5.2 //x2=21.995 //y2=5.2
cc_526 ( N_VDD_c_315_p N_QN_M46_noxref_d ) capacitor c=0.00285148f //x=28.61 \
 //y=7.58 //x2=22.875 //y2=5.2
cc_527 ( N_VDD_c_509_p N_QN_M46_noxref_d ) capacitor c=0.0138265f //x=23.375 \
 //y=7.585 //x2=22.875 //y2=5.2
cc_528 ( N_VDD_c_314_n N_QN_M46_noxref_d ) capacitor c=0.00939849f //x=24.54 \
 //y=7.585 //x2=22.875 //y2=5.2
cc_529 ( N_VDD_M45_noxref_d N_QN_M46_noxref_d ) capacitor c=0.0664752f \
 //x=22.435 //y=5.2 //x2=22.875 //y2=5.2
cc_530 ( N_VDD_M47_noxref_d N_QN_M46_noxref_d ) capacitor c=0.0664752f \
 //x=23.315 //y=5.2 //x2=22.875 //y2=5.2
cc_531 ( N_VDD_M48_noxref_s N_QN_M46_noxref_d ) capacitor c=3.57641e-19 \
 //x=25.495 //y=5.2 //x2=22.875 //y2=5.2
cc_532 ( N_VDD_c_315_p N_SN_c_1987_n ) capacitor c=2.03391e-19 //x=28.61 \
 //y=7.58 //x2=12.33 //y2=2.26
cc_533 ( N_VDD_c_311_n N_SN_c_1987_n ) capacitor c=6.19572e-19 //x=10.11 \
 //y=7.585 //x2=12.33 //y2=2.26
cc_534 ( N_VDD_c_315_p N_SN_c_1988_n ) capacitor c=2.05728e-19 //x=28.61 \
 //y=7.58 //x2=26.76 //y2=2.26
cc_535 ( N_VDD_c_314_n N_SN_c_1988_n ) capacitor c=7.34568e-19 //x=24.54 \
 //y=7.585 //x2=26.76 //y2=2.26
cc_536 ( N_VDD_c_365_p N_SN_M32_noxref_g ) capacitor c=0.00680845f //x=12.875 \
 //y=7.585 //x2=12.3 //y2=6.2
cc_537 ( N_VDD_M31_noxref_d N_SN_M32_noxref_g ) capacitor c=0.015318f \
 //x=11.935 //y=5.2 //x2=12.3 //y2=6.2
cc_538 ( N_VDD_c_365_p N_SN_M33_noxref_g ) capacitor c=0.00679791f //x=12.875 \
 //y=7.585 //x2=12.74 //y2=6.2
cc_539 ( N_VDD_M33_noxref_d N_SN_M33_noxref_g ) capacitor c=0.015318f \
 //x=12.815 //y=5.2 //x2=12.74 //y2=6.2
cc_540 ( N_VDD_c_547_p N_SN_M50_noxref_g ) capacitor c=0.00680845f //x=27.305 \
 //y=7.585 //x2=26.73 //y2=6.2
cc_541 ( N_VDD_M49_noxref_d N_SN_M50_noxref_g ) capacitor c=0.015318f \
 //x=26.365 //y=5.2 //x2=26.73 //y2=6.2
cc_542 ( N_VDD_c_547_p N_SN_M51_noxref_g ) capacitor c=0.00679791f //x=27.305 \
 //y=7.585 //x2=27.17 //y2=6.2
cc_543 ( N_VDD_M51_noxref_d N_SN_M51_noxref_g ) capacitor c=0.015318f \
 //x=27.245 //y=5.2 //x2=27.17 //y2=6.2
cc_544 ( N_VDD_c_311_n N_noxref_10_c_2206_n ) capacitor c=0.0140577f //x=10.11 \
 //y=7.585 //x2=13.325 //y2=4.25
cc_545 ( N_VDD_c_312_n N_noxref_10_c_2207_n ) capacitor c=0.0140577f //x=14.92 \
 //y=7.585 //x2=18.875 //y2=4.25
cc_546 ( N_VDD_c_315_p N_noxref_10_c_2208_n ) capacitor c=0.0525081f //x=28.61 \
 //y=7.58 //x2=27.755 //y2=4.25
cc_547 ( N_VDD_c_513_p N_noxref_10_c_2208_n ) capacitor c=0.00214169f \
 //x=24.37 //y=7.585 //x2=27.755 //y2=4.25
cc_548 ( N_VDD_c_555_p N_noxref_10_c_2208_n ) capacitor c=0.00271488f \
 //x=25.545 //y=7.585 //x2=27.755 //y2=4.25
cc_549 ( N_VDD_c_518_p N_noxref_10_c_2208_n ) capacitor c=0.00113405f \
 //x=26.425 //y=7.585 //x2=27.755 //y2=4.25
cc_550 ( N_VDD_c_313_n N_noxref_10_c_2208_n ) capacitor c=0.0140577f //x=19.73 \
 //y=7.585 //x2=27.755 //y2=4.25
cc_551 ( N_VDD_c_314_n N_noxref_10_c_2208_n ) capacitor c=0.0269493f //x=24.54 \
 //y=7.585 //x2=27.755 //y2=4.25
cc_552 ( N_VDD_M48_noxref_s N_noxref_10_c_2208_n ) capacitor c=0.00122829f \
 //x=25.495 //y=5.2 //x2=27.755 //y2=4.25
cc_553 ( N_VDD_c_313_n N_noxref_10_c_2215_n ) capacitor c=0.00104972f \
 //x=19.73 //y=7.585 //x2=19.105 //y2=4.25
cc_554 ( N_VDD_c_312_n N_noxref_10_c_2202_n ) capacitor c=5.93913e-19 \
 //x=14.92 //y=7.585 //x2=13.44 //y2=2.26
cc_555 ( N_VDD_c_315_p N_noxref_10_c_2217_n ) capacitor c=0.00444939f \
 //x=28.61 //y=7.58 //x2=17.245 //y2=5.335
cc_556 ( N_VDD_c_381_p N_noxref_10_c_2217_n ) capacitor c=4.32416e-19 \
 //x=16.805 //y=7.585 //x2=17.245 //y2=5.335
cc_557 ( N_VDD_c_410_p N_noxref_10_c_2217_n ) capacitor c=4.32416e-19 \
 //x=17.685 //y=7.585 //x2=17.245 //y2=5.335
cc_558 ( N_VDD_M37_noxref_d N_noxref_10_c_2217_n ) capacitor c=0.0112992f \
 //x=16.745 //y=5.2 //x2=17.245 //y2=5.335
cc_559 ( N_VDD_c_312_n N_noxref_10_c_2221_n ) capacitor c=0.00863585f \
 //x=14.92 //y=7.585 //x2=16.535 //y2=5.335
cc_560 ( N_VDD_M36_noxref_s N_noxref_10_c_2221_n ) capacitor c=0.0831083f \
 //x=15.875 //y=5.2 //x2=16.535 //y2=5.335
cc_561 ( N_VDD_c_315_p N_noxref_10_c_2223_n ) capacitor c=0.00442256f \
 //x=28.61 //y=7.58 //x2=18.125 //y2=5.335
cc_562 ( N_VDD_c_410_p N_noxref_10_c_2223_n ) capacitor c=4.32416e-19 \
 //x=17.685 //y=7.585 //x2=18.125 //y2=5.335
cc_563 ( N_VDD_c_492_p N_noxref_10_c_2223_n ) capacitor c=4.32416e-19 \
 //x=18.565 //y=7.585 //x2=18.125 //y2=5.335
cc_564 ( N_VDD_M39_noxref_d N_noxref_10_c_2223_n ) capacitor c=0.0112992f \
 //x=17.625 //y=5.2 //x2=18.125 //y2=5.335
cc_565 ( N_VDD_c_315_p N_noxref_10_c_2227_n ) capacitor c=0.00434536f \
 //x=28.61 //y=7.58 //x2=18.905 //y2=5.335
cc_566 ( N_VDD_c_492_p N_noxref_10_c_2227_n ) capacitor c=7.47366e-19 \
 //x=18.565 //y=7.585 //x2=18.905 //y2=5.335
cc_567 ( N_VDD_c_477_p N_noxref_10_c_2227_n ) capacitor c=0.00199034f \
 //x=19.56 //y=7.585 //x2=18.905 //y2=5.335
cc_568 ( N_VDD_M41_noxref_d N_noxref_10_c_2227_n ) capacitor c=0.0112992f \
 //x=18.505 //y=5.2 //x2=18.905 //y2=5.335
cc_569 ( N_VDD_c_313_n N_noxref_10_c_2231_n ) capacitor c=0.042763f //x=19.73 \
 //y=7.585 //x2=18.99 //y2=4.25
cc_570 ( N_VDD_c_309_n N_noxref_10_c_2204_n ) capacitor c=9.3395e-19 //x=28.61 \
 //y=7.58 //x2=27.87 //y2=2.26
cc_571 ( N_VDD_c_311_n N_noxref_10_c_2233_n ) capacitor c=5.93454e-19 \
 //x=10.11 //y=7.585 //x2=8.625 //y2=4.25
cc_572 ( N_VDD_c_424_p N_noxref_10_M28_noxref_g ) capacitor c=0.00679791f \
 //x=8.945 //y=7.585 //x2=8.37 //y2=6.2
cc_573 ( N_VDD_M27_noxref_d N_noxref_10_M28_noxref_g ) capacitor c=0.015318f \
 //x=8.005 //y=5.2 //x2=8.37 //y2=6.2
cc_574 ( N_VDD_c_424_p N_noxref_10_M29_noxref_g ) capacitor c=0.00680002f \
 //x=8.945 //y=7.585 //x2=8.81 //y2=6.2
cc_575 ( N_VDD_M29_noxref_d N_noxref_10_M29_noxref_g ) capacitor c=0.0394719f \
 //x=8.885 //y=5.2 //x2=8.81 //y2=6.2
cc_576 ( N_VDD_c_371_p N_noxref_10_M34_noxref_g ) capacitor c=0.00679791f \
 //x=13.755 //y=7.585 //x2=13.18 //y2=6.2
cc_577 ( N_VDD_M33_noxref_d N_noxref_10_M34_noxref_g ) capacitor c=0.015318f \
 //x=12.815 //y=5.2 //x2=13.18 //y2=6.2
cc_578 ( N_VDD_c_371_p N_noxref_10_M35_noxref_g ) capacitor c=0.00680002f \
 //x=13.755 //y=7.585 //x2=13.62 //y2=6.2
cc_579 ( N_VDD_M35_noxref_d N_noxref_10_M35_noxref_g ) capacitor c=0.0394719f \
 //x=13.695 //y=5.2 //x2=13.62 //y2=6.2
cc_580 ( N_VDD_c_587_p N_noxref_10_M52_noxref_g ) capacitor c=0.00679791f \
 //x=28.185 //y=7.585 //x2=27.61 //y2=6.2
cc_581 ( N_VDD_M51_noxref_d N_noxref_10_M52_noxref_g ) capacitor c=0.015318f \
 //x=27.245 //y=5.2 //x2=27.61 //y2=6.2
cc_582 ( N_VDD_c_587_p N_noxref_10_M53_noxref_g ) capacitor c=0.00680002f \
 //x=28.185 //y=7.585 //x2=28.05 //y2=6.2
cc_583 ( N_VDD_M53_noxref_d N_noxref_10_M53_noxref_g ) capacitor c=0.0394719f \
 //x=28.125 //y=5.2 //x2=28.05 //y2=6.2
cc_584 ( N_VDD_c_315_p N_noxref_10_M36_noxref_d ) capacitor c=0.00275309f \
 //x=28.61 //y=7.58 //x2=16.305 //y2=5.2
cc_585 ( N_VDD_c_381_p N_noxref_10_M36_noxref_d ) capacitor c=0.0140577f \
 //x=16.805 //y=7.585 //x2=16.305 //y2=5.2
cc_586 ( N_VDD_M37_noxref_d N_noxref_10_M36_noxref_d ) capacitor c=0.0664752f \
 //x=16.745 //y=5.2 //x2=16.305 //y2=5.2
cc_587 ( N_VDD_c_315_p N_noxref_10_M38_noxref_d ) capacitor c=0.00275309f \
 //x=28.61 //y=7.58 //x2=17.185 //y2=5.2
cc_588 ( N_VDD_c_410_p N_noxref_10_M38_noxref_d ) capacitor c=0.0140577f \
 //x=17.685 //y=7.585 //x2=17.185 //y2=5.2
cc_589 ( N_VDD_c_313_n N_noxref_10_M38_noxref_d ) capacitor c=4.9285e-19 \
 //x=19.73 //y=7.585 //x2=17.185 //y2=5.2
cc_590 ( N_VDD_M36_noxref_s N_noxref_10_M38_noxref_d ) capacitor c=0.00130656f \
 //x=15.875 //y=5.2 //x2=17.185 //y2=5.2
cc_591 ( N_VDD_M37_noxref_d N_noxref_10_M38_noxref_d ) capacitor c=0.0664752f \
 //x=16.745 //y=5.2 //x2=17.185 //y2=5.2
cc_592 ( N_VDD_M39_noxref_d N_noxref_10_M38_noxref_d ) capacitor c=0.0664752f \
 //x=17.625 //y=5.2 //x2=17.185 //y2=5.2
cc_593 ( N_VDD_c_315_p N_noxref_10_M40_noxref_d ) capacitor c=0.00274524f \
 //x=28.61 //y=7.58 //x2=18.065 //y2=5.2
cc_594 ( N_VDD_c_492_p N_noxref_10_M40_noxref_d ) capacitor c=0.0140523f \
 //x=18.565 //y=7.585 //x2=18.065 //y2=5.2
cc_595 ( N_VDD_c_313_n N_noxref_10_M40_noxref_d ) capacitor c=0.00939849f \
 //x=19.73 //y=7.585 //x2=18.065 //y2=5.2
cc_596 ( N_VDD_M39_noxref_d N_noxref_10_M40_noxref_d ) capacitor c=0.0664752f \
 //x=17.625 //y=5.2 //x2=18.065 //y2=5.2
cc_597 ( N_VDD_M41_noxref_d N_noxref_10_M40_noxref_d ) capacitor c=0.0664752f \
 //x=18.505 //y=5.2 //x2=18.065 //y2=5.2
cc_598 ( N_VDD_M42_noxref_s N_noxref_10_M40_noxref_d ) capacitor c=3.57641e-19 \
 //x=20.685 //y=5.2 //x2=18.065 //y2=5.2
cc_599 ( N_VDD_c_315_p N_noxref_11_c_2540_n ) capacitor c=0.0226734f //x=28.61 \
 //y=7.58 //x2=28.495 //y2=3.88
cc_600 ( N_VDD_c_314_n N_noxref_11_c_2541_n ) capacitor c=0.00114628f \
 //x=24.54 //y=7.585 //x2=23.06 //y2=2.26
cc_601 ( N_VDD_c_315_p N_noxref_11_c_2546_n ) capacitor c=0.00451543f \
 //x=28.61 //y=7.58 //x2=26.865 //y2=5.335
cc_602 ( N_VDD_c_518_p N_noxref_11_c_2546_n ) capacitor c=4.32713e-19 \
 //x=26.425 //y=7.585 //x2=26.865 //y2=5.335
cc_603 ( N_VDD_c_547_p N_noxref_11_c_2546_n ) capacitor c=4.32713e-19 \
 //x=27.305 //y=7.585 //x2=26.865 //y2=5.335
cc_604 ( N_VDD_M49_noxref_d N_noxref_11_c_2546_n ) capacitor c=0.0115154f \
 //x=26.365 //y=5.2 //x2=26.865 //y2=5.335
cc_605 ( N_VDD_c_314_n N_noxref_11_c_2550_n ) capacitor c=0.00863585f \
 //x=24.54 //y=7.585 //x2=26.155 //y2=5.335
cc_606 ( N_VDD_M48_noxref_s N_noxref_11_c_2550_n ) capacitor c=0.0831083f \
 //x=25.495 //y=5.2 //x2=26.155 //y2=5.335
cc_607 ( N_VDD_c_315_p N_noxref_11_c_2552_n ) capacitor c=0.00449039f \
 //x=28.61 //y=7.58 //x2=27.745 //y2=5.335
cc_608 ( N_VDD_c_547_p N_noxref_11_c_2552_n ) capacitor c=4.32713e-19 \
 //x=27.305 //y=7.585 //x2=27.745 //y2=5.335
cc_609 ( N_VDD_c_587_p N_noxref_11_c_2552_n ) capacitor c=4.32713e-19 \
 //x=28.185 //y=7.585 //x2=27.745 //y2=5.335
cc_610 ( N_VDD_M51_noxref_d N_noxref_11_c_2552_n ) capacitor c=0.0115154f \
 //x=27.245 //y=5.2 //x2=27.745 //y2=5.335
cc_611 ( N_VDD_c_315_p N_noxref_11_c_2556_n ) capacitor c=0.00449388f \
 //x=28.61 //y=7.58 //x2=28.525 //y2=5.335
cc_612 ( N_VDD_c_587_p N_noxref_11_c_2556_n ) capacitor c=7.41422e-19 \
 //x=28.185 //y=7.585 //x2=28.525 //y2=5.335
cc_613 ( N_VDD_c_309_n N_noxref_11_c_2556_n ) capacitor c=0.00180478f \
 //x=28.61 //y=7.58 //x2=28.525 //y2=5.335
cc_614 ( N_VDD_M53_noxref_d N_noxref_11_c_2556_n ) capacitor c=0.0116571f \
 //x=28.125 //y=5.2 //x2=28.525 //y2=5.335
cc_615 ( N_VDD_c_309_n N_noxref_11_c_2560_n ) capacitor c=0.0459745f //x=28.61 \
 //y=7.58 //x2=28.61 //y2=3.88
cc_616 ( N_VDD_c_509_p N_noxref_11_M46_noxref_g ) capacitor c=0.00679791f \
 //x=23.375 //y=7.585 //x2=22.8 //y2=6.2
cc_617 ( N_VDD_M45_noxref_d N_noxref_11_M46_noxref_g ) capacitor c=0.015318f \
 //x=22.435 //y=5.2 //x2=22.8 //y2=6.2
cc_618 ( N_VDD_c_509_p N_noxref_11_M47_noxref_g ) capacitor c=0.00680002f \
 //x=23.375 //y=7.585 //x2=23.24 //y2=6.2
cc_619 ( N_VDD_M47_noxref_d N_noxref_11_M47_noxref_g ) capacitor c=0.0394719f \
 //x=23.315 //y=5.2 //x2=23.24 //y2=6.2
cc_620 ( N_VDD_c_315_p N_noxref_11_M48_noxref_d ) capacitor c=0.00285148f \
 //x=28.61 //y=7.58 //x2=25.925 //y2=5.2
cc_621 ( N_VDD_c_518_p N_noxref_11_M48_noxref_d ) capacitor c=0.0141242f \
 //x=26.425 //y=7.585 //x2=25.925 //y2=5.2
cc_622 ( N_VDD_M49_noxref_d N_noxref_11_M48_noxref_d ) capacitor c=0.0664752f \
 //x=26.365 //y=5.2 //x2=25.925 //y2=5.2
cc_623 ( N_VDD_c_315_p N_noxref_11_M50_noxref_d ) capacitor c=0.00285148f \
 //x=28.61 //y=7.58 //x2=26.805 //y2=5.2
cc_624 ( N_VDD_c_547_p N_noxref_11_M50_noxref_d ) capacitor c=0.0141242f \
 //x=27.305 //y=7.585 //x2=26.805 //y2=5.2
cc_625 ( N_VDD_c_309_n N_noxref_11_M50_noxref_d ) capacitor c=4.9285e-19 \
 //x=28.61 //y=7.58 //x2=26.805 //y2=5.2
cc_626 ( N_VDD_M48_noxref_s N_noxref_11_M50_noxref_d ) capacitor c=0.00130656f \
 //x=25.495 //y=5.2 //x2=26.805 //y2=5.2
cc_627 ( N_VDD_M49_noxref_d N_noxref_11_M50_noxref_d ) capacitor c=0.0664752f \
 //x=26.365 //y=5.2 //x2=26.805 //y2=5.2
cc_628 ( N_VDD_M51_noxref_d N_noxref_11_M50_noxref_d ) capacitor c=0.0664752f \
 //x=27.245 //y=5.2 //x2=26.805 //y2=5.2
cc_629 ( N_VDD_c_315_p N_noxref_11_M52_noxref_d ) capacitor c=0.00284424f \
 //x=28.61 //y=7.58 //x2=27.685 //y2=5.2
cc_630 ( N_VDD_c_587_p N_noxref_11_M52_noxref_d ) capacitor c=0.0138217f \
 //x=28.185 //y=7.585 //x2=27.685 //y2=5.2
cc_631 ( N_VDD_c_309_n N_noxref_11_M52_noxref_d ) capacitor c=0.00963505f \
 //x=28.61 //y=7.58 //x2=27.685 //y2=5.2
cc_632 ( N_VDD_M51_noxref_d N_noxref_11_M52_noxref_d ) capacitor c=0.0664752f \
 //x=27.245 //y=5.2 //x2=27.685 //y2=5.2
cc_633 ( N_VDD_M53_noxref_d N_noxref_11_M52_noxref_d ) capacitor c=0.0664752f \
 //x=28.125 //y=5.2 //x2=27.685 //y2=5.2
cc_634 ( N_VDD_c_315_p N_D_c_2697_n ) capacitor c=0.0011224f //x=28.61 \
 //y=7.58 //x2=1.6 //y2=2.26
cc_635 ( N_VDD_c_308_n N_D_c_2697_n ) capacitor c=0.0165592f //x=1.23 //y=7.58 \
 //x2=1.6 //y2=2.26
cc_636 ( N_VDD_M18_noxref_s N_D_c_2697_n ) capacitor c=0.0130258f //x=1.445 \
 //y=5.2 //x2=1.6 //y2=2.26
cc_637 ( N_VDD_c_316_p N_D_M18_noxref_g ) capacitor c=0.00755614f //x=2.375 \
 //y=7.585 //x2=1.8 //y2=6.2
cc_638 ( N_VDD_M18_noxref_s N_D_M18_noxref_g ) capacitor c=0.0477201f \
 //x=1.445 //y=5.2 //x2=1.8 //y2=6.2
cc_639 ( N_VDD_c_316_p N_D_M19_noxref_g ) capacitor c=0.00679791f //x=2.375 \
 //y=7.585 //x2=2.24 //y2=6.2
cc_640 ( N_VDD_M19_noxref_d N_D_M19_noxref_g ) capacitor c=0.015318f //x=2.315 \
 //y=5.2 //x2=2.24 //y2=6.2
cc_641 ( N_VDD_c_308_n N_D_c_2715_n ) capacitor c=0.00757682f //x=1.23 \
 //y=7.58 //x2=1.875 //y2=4.97
cc_642 ( N_VDD_M18_noxref_s N_D_c_2715_n ) capacitor c=0.00442985f //x=1.445 \
 //y=5.2 //x2=1.875 //y2=4.97
cc_643 ( N_noxref_3_c_655_n N_noxref_4_c_954_n ) capacitor c=0.00556843f \
 //x=11.105 //y=3.145 //x2=14.295 //y2=3.14
cc_644 ( N_noxref_3_M31_noxref_g N_noxref_4_c_915_n ) capacitor c=0.0168349f \
 //x=11.86 //y=6.2 //x2=12.435 //y2=5.335
cc_645 ( N_noxref_3_M30_noxref_g N_noxref_4_c_919_n ) capacitor c=0.0213876f \
 //x=11.42 //y=6.2 //x2=11.725 //y2=5.335
cc_646 ( N_noxref_3_c_735_p N_noxref_4_c_919_n ) capacitor c=0.00428486f \
 //x=11.785 //y=4.97 //x2=11.725 //y2=5.335
cc_647 ( N_noxref_3_M31_noxref_g N_noxref_4_M30_noxref_d ) capacitor \
 c=0.0180032f //x=11.86 //y=6.2 //x2=11.495 //y2=5.2
cc_648 ( N_noxref_3_c_655_n N_CLK_c_1061_n ) capacitor c=0.33849f //x=11.105 \
 //y=3.145 //x2=17.025 //y2=3.51
cc_649 ( N_noxref_3_c_662_n N_CLK_c_1061_n ) capacitor c=0.0216421f //x=11.22 \
 //y=2.26 //x2=17.025 //y2=3.51
cc_650 ( N_noxref_3_c_655_n N_CLK_c_1078_n ) capacitor c=0.0294585f //x=11.105 \
 //y=3.145 //x2=7.635 //y2=3.51
cc_651 ( N_noxref_3_c_661_n N_CLK_c_1078_n ) capacitor c=0.00526349f //x=6.41 \
 //y=2.26 //x2=7.635 //y2=3.51
cc_652 ( N_noxref_3_c_655_n N_CLK_c_1062_n ) capacitor c=0.0253594f //x=11.105 \
 //y=3.145 //x2=7.52 //y2=2.26
cc_653 ( N_noxref_3_c_659_n N_CLK_c_1062_n ) capacitor c=9.95819e-19 //x=6.525 \
 //y=3.145 //x2=7.52 //y2=2.26
cc_654 ( N_noxref_3_c_698_n N_CLK_c_1062_n ) capacitor c=5.06912e-19 //x=4.56 \
 //y=3.145 //x2=7.52 //y2=2.26
cc_655 ( N_noxref_3_c_661_n N_CLK_c_1062_n ) capacitor c=0.0487554f //x=6.41 \
 //y=2.26 //x2=7.52 //y2=2.26
cc_656 ( N_noxref_3_c_667_n N_CLK_c_1062_n ) capacitor c=0.00238338f //x=6.11 \
 //y=2.095 //x2=7.52 //y2=2.26
cc_657 ( N_noxref_3_c_746_p N_CLK_c_1062_n ) capacitor c=0.00147352f //x=6.975 \
 //y=4.97 //x2=7.52 //y2=2.26
cc_658 ( N_noxref_3_c_713_n N_CLK_c_1062_n ) capacitor c=0.00142741f //x=6.685 \
 //y=4.97 //x2=7.52 //y2=2.26
cc_659 ( N_noxref_3_M24_noxref_g N_CLK_M26_noxref_g ) capacitor c=0.0105869f \
 //x=6.61 //y=6.2 //x2=7.49 //y2=6.2
cc_660 ( N_noxref_3_M25_noxref_g N_CLK_M26_noxref_g ) capacitor c=0.10632f \
 //x=7.05 //y=6.2 //x2=7.49 //y2=6.2
cc_661 ( N_noxref_3_M25_noxref_g N_CLK_M27_noxref_g ) capacitor c=0.0101598f \
 //x=7.05 //y=6.2 //x2=7.93 //y2=6.2
cc_662 ( N_noxref_3_c_663_n N_CLK_c_1090_n ) capacitor c=5.72482e-19 //x=6.11 \
 //y=1.055 //x2=7.085 //y2=1.09
cc_663 ( N_noxref_3_c_665_n N_CLK_c_1090_n ) capacitor c=0.00149976f //x=6.11 \
 //y=1.4 //x2=7.085 //y2=1.09
cc_664 ( N_noxref_3_c_670_n N_CLK_c_1090_n ) capacitor c=0.0160123f //x=6.64 \
 //y=1.055 //x2=7.085 //y2=1.09
cc_665 ( N_noxref_3_c_666_n N_CLK_c_1093_n ) capacitor c=0.00111227f //x=6.11 \
 //y=1.71 //x2=7.085 //y2=1.4
cc_666 ( N_noxref_3_c_672_n N_CLK_c_1093_n ) capacitor c=0.0124075f //x=6.64 \
 //y=1.4 //x2=7.085 //y2=1.4
cc_667 ( N_noxref_3_c_670_n N_CLK_c_1095_n ) capacitor c=0.00103227f //x=6.64 \
 //y=1.055 //x2=7.61 //y2=1.09
cc_668 ( N_noxref_3_c_672_n N_CLK_c_1096_n ) capacitor c=0.0010154f //x=6.64 \
 //y=1.4 //x2=7.61 //y2=1.4
cc_669 ( N_noxref_3_c_672_n N_CLK_c_1097_n ) capacitor c=9.23422e-19 //x=6.64 \
 //y=1.4 //x2=7.61 //y2=1.63
cc_670 ( N_noxref_3_c_655_n N_CLK_c_1098_n ) capacitor c=0.00231387f \
 //x=11.105 //y=3.145 //x2=7.61 //y2=2.095
cc_671 ( N_noxref_3_c_661_n N_CLK_c_1098_n ) capacitor c=0.00231304f //x=6.41 \
 //y=2.26 //x2=7.61 //y2=2.095
cc_672 ( N_noxref_3_c_667_n N_CLK_c_1098_n ) capacitor c=0.00964411f //x=6.11 \
 //y=2.095 //x2=7.61 //y2=2.095
cc_673 ( N_noxref_3_c_661_n N_CLK_c_1101_n ) capacitor c=0.00183762f //x=6.41 \
 //y=2.26 //x2=7.52 //y2=4.88
cc_674 ( N_noxref_3_c_746_p N_CLK_c_1101_n ) capacitor c=0.0168581f //x=6.975 \
 //y=4.97 //x2=7.52 //y2=4.88
cc_675 ( N_noxref_3_c_713_n N_CLK_c_1101_n ) capacitor c=0.00484466f //x=6.685 \
 //y=4.97 //x2=7.52 //y2=4.88
cc_676 ( N_noxref_3_c_650_n N_noxref_6_c_1251_n ) capacitor c=0.0743044f \
 //x=6.295 //y=3.145 //x2=9.255 //y2=3.88
cc_677 ( N_noxref_3_c_654_n N_noxref_6_c_1251_n ) capacitor c=0.0136944f \
 //x=4.675 //y=3.145 //x2=9.255 //y2=3.88
cc_678 ( N_noxref_3_c_655_n N_noxref_6_c_1251_n ) capacitor c=0.053052f \
 //x=11.105 //y=3.145 //x2=9.255 //y2=3.88
cc_679 ( N_noxref_3_c_659_n N_noxref_6_c_1251_n ) capacitor c=0.0123989f \
 //x=6.525 //y=3.145 //x2=9.255 //y2=3.88
cc_680 ( N_noxref_3_c_769_p N_noxref_6_c_1251_n ) capacitor c=0.0042996f \
 //x=4.16 //y=1.845 //x2=9.255 //y2=3.88
cc_681 ( N_noxref_3_c_698_n N_noxref_6_c_1251_n ) capacitor c=0.0237485f \
 //x=4.56 //y=3.145 //x2=9.255 //y2=3.88
cc_682 ( N_noxref_3_c_661_n N_noxref_6_c_1251_n ) capacitor c=0.024705f \
 //x=6.41 //y=2.26 //x2=9.255 //y2=3.88
cc_683 ( N_noxref_3_c_698_n N_noxref_6_c_1252_n ) capacitor c=0.00179385f \
 //x=4.56 //y=3.145 //x2=3.935 //y2=3.88
cc_684 ( N_noxref_3_c_655_n N_noxref_6_c_1253_n ) capacitor c=0.0117239f \
 //x=11.105 //y=3.145 //x2=20.725 //y2=3.88
cc_685 ( N_noxref_3_c_662_n N_noxref_6_c_1253_n ) capacitor c=0.0197627f \
 //x=11.22 //y=2.26 //x2=20.725 //y2=3.88
cc_686 ( N_noxref_3_c_655_n N_noxref_6_c_1323_n ) capacitor c=4.83387e-19 \
 //x=11.105 //y=3.145 //x2=9.485 //y2=3.88
cc_687 ( N_noxref_3_c_662_n N_noxref_6_c_1323_n ) capacitor c=7.01366e-19 \
 //x=11.22 //y=2.26 //x2=9.485 //y2=3.88
cc_688 ( N_noxref_3_c_654_n N_noxref_6_c_1254_n ) capacitor c=0.00687545f \
 //x=4.675 //y=3.145 //x2=3.82 //y2=2.26
cc_689 ( N_noxref_3_c_698_n N_noxref_6_c_1254_n ) capacitor c=0.0857427f \
 //x=4.56 //y=3.145 //x2=3.82 //y2=2.26
cc_690 ( N_noxref_3_c_661_n N_noxref_6_c_1254_n ) capacitor c=0.00105582f \
 //x=6.41 //y=2.26 //x2=3.82 //y2=2.26
cc_691 ( N_noxref_3_c_780_p N_noxref_6_c_1254_n ) capacitor c=0.016476f \
 //x=3.78 //y=5.335 //x2=3.82 //y2=2.26
cc_692 ( N_noxref_3_M25_noxref_g N_noxref_6_c_1270_n ) capacitor c=0.0168349f \
 //x=7.05 //y=6.2 //x2=7.625 //y2=5.335
cc_693 ( N_noxref_3_c_694_n N_noxref_6_c_1274_n ) capacitor c=3.10026e-19 \
 //x=4.475 //y=5.335 //x2=6.915 //y2=5.335
cc_694 ( N_noxref_3_M24_noxref_g N_noxref_6_c_1274_n ) capacitor c=0.0213876f \
 //x=6.61 //y=6.2 //x2=6.915 //y2=5.335
cc_695 ( N_noxref_3_c_746_p N_noxref_6_c_1274_n ) capacitor c=0.00428486f \
 //x=6.975 //y=4.97 //x2=6.915 //y2=5.335
cc_696 ( N_noxref_3_c_655_n N_noxref_6_c_1333_n ) capacitor c=0.00835258f \
 //x=11.105 //y=3.145 //x2=8.97 //y2=1.845
cc_697 ( N_noxref_3_c_655_n N_noxref_6_c_1284_n ) capacitor c=0.024355f \
 //x=11.105 //y=3.145 //x2=9.37 //y2=3.88
cc_698 ( N_noxref_3_c_662_n N_noxref_6_c_1284_n ) capacitor c=0.0109419f \
 //x=11.22 //y=2.26 //x2=9.37 //y2=3.88
cc_699 ( N_noxref_3_c_690_n N_noxref_6_M22_noxref_g ) capacitor c=0.01736f \
 //x=3.695 //y=5.335 //x2=3.56 //y2=6.2
cc_700 ( N_noxref_3_M22_noxref_d N_noxref_6_M22_noxref_g ) capacitor \
 c=0.0180032f //x=3.635 //y=5.2 //x2=3.56 //y2=6.2
cc_701 ( N_noxref_3_c_694_n N_noxref_6_M23_noxref_g ) capacitor c=0.0194981f \
 //x=4.475 //y=5.335 //x2=4 //y2=6.2
cc_702 ( N_noxref_3_M22_noxref_d N_noxref_6_M23_noxref_g ) capacitor \
 c=0.0194246f //x=3.635 //y=5.2 //x2=4 //y2=6.2
cc_703 ( N_noxref_3_M2_noxref_d N_noxref_6_c_1340_n ) capacitor c=0.00217566f \
 //x=3.885 //y=1.095 //x2=3.81 //y2=1.095
cc_704 ( N_noxref_3_M2_noxref_d N_noxref_6_c_1341_n ) capacitor c=0.0034598f \
 //x=3.885 //y=1.095 //x2=3.81 //y2=1.44
cc_705 ( N_noxref_3_M2_noxref_d N_noxref_6_c_1342_n ) capacitor c=0.00544291f \
 //x=3.885 //y=1.095 //x2=3.81 //y2=1.75
cc_706 ( N_noxref_3_M2_noxref_d N_noxref_6_c_1343_n ) capacitor c=0.00241102f \
 //x=3.885 //y=1.095 //x2=4.185 //y2=0.94
cc_707 ( N_noxref_3_c_660_n N_noxref_6_c_1344_n ) capacitor c=0.00359704f \
 //x=4.475 //y=1.845 //x2=4.185 //y2=1.595
cc_708 ( N_noxref_3_M2_noxref_d N_noxref_6_c_1344_n ) capacitor c=0.0140297f \
 //x=3.885 //y=1.095 //x2=4.185 //y2=1.595
cc_709 ( N_noxref_3_M2_noxref_d N_noxref_6_c_1346_n ) capacitor c=0.00219619f \
 //x=3.885 //y=1.095 //x2=4.34 //y2=1.095
cc_710 ( N_noxref_3_c_660_n N_noxref_6_c_1347_n ) capacitor c=0.00457401f \
 //x=4.475 //y=1.845 //x2=4.34 //y2=1.44
cc_711 ( N_noxref_3_M2_noxref_d N_noxref_6_c_1347_n ) capacitor c=0.00603828f \
 //x=3.885 //y=1.095 //x2=4.34 //y2=1.44
cc_712 ( N_noxref_3_c_698_n N_noxref_6_c_1349_n ) capacitor c=0.00877984f \
 //x=4.56 //y=3.145 //x2=3.82 //y2=2.26
cc_713 ( N_noxref_3_c_698_n N_noxref_6_c_1350_n ) capacitor c=0.00283672f \
 //x=4.56 //y=3.145 //x2=3.82 //y2=2.095
cc_714 ( N_noxref_3_M2_noxref_d N_noxref_6_c_1350_n ) capacitor c=0.00661782f \
 //x=3.885 //y=1.095 //x2=3.82 //y2=2.095
cc_715 ( N_noxref_3_c_694_n N_noxref_6_c_1352_n ) capacitor c=0.00201851f \
 //x=4.475 //y=5.335 //x2=3.82 //y2=4.88
cc_716 ( N_noxref_3_c_698_n N_noxref_6_c_1352_n ) capacitor c=0.013693f \
 //x=4.56 //y=3.145 //x2=3.82 //y2=4.88
cc_717 ( N_noxref_3_c_780_p N_noxref_6_c_1352_n ) capacitor c=0.00475601f \
 //x=3.78 //y=5.335 //x2=3.82 //y2=4.88
cc_718 ( N_noxref_3_M25_noxref_g N_noxref_6_M24_noxref_d ) capacitor \
 c=0.0180032f //x=7.05 //y=6.2 //x2=6.685 //y2=5.2
cc_719 ( N_noxref_3_c_650_n N_RN_c_1511_n ) capacitor c=0.00385587f //x=6.295 \
 //y=3.145 //x2=18.135 //y2=4.62
cc_720 ( N_noxref_3_c_654_n N_RN_c_1511_n ) capacitor c=3.67454e-19 //x=4.675 \
 //y=3.145 //x2=18.135 //y2=4.62
cc_721 ( N_noxref_3_c_655_n N_RN_c_1511_n ) capacitor c=0.00397392f //x=11.105 \
 //y=3.145 //x2=18.135 //y2=4.62
cc_722 ( N_noxref_3_c_659_n N_RN_c_1511_n ) capacitor c=2.47225e-19 //x=6.525 \
 //y=3.145 //x2=18.135 //y2=4.62
cc_723 ( N_noxref_3_c_694_n N_RN_c_1511_n ) capacitor c=0.0183122f //x=4.475 \
 //y=5.335 //x2=18.135 //y2=4.62
cc_724 ( N_noxref_3_c_698_n N_RN_c_1511_n ) capacitor c=0.023368f //x=4.56 \
 //y=3.145 //x2=18.135 //y2=4.62
cc_725 ( N_noxref_3_c_661_n N_RN_c_1511_n ) capacitor c=0.0232115f //x=6.41 \
 //y=2.26 //x2=18.135 //y2=4.62
cc_726 ( N_noxref_3_c_662_n N_RN_c_1511_n ) capacitor c=0.0208709f //x=11.22 \
 //y=2.26 //x2=18.135 //y2=4.62
cc_727 ( N_noxref_3_c_816_p N_RN_c_1511_n ) capacitor c=0.0306894f //x=2.9 \
 //y=5.335 //x2=18.135 //y2=4.62
cc_728 ( N_noxref_3_c_713_n N_RN_c_1511_n ) capacitor c=0.0169569f //x=6.685 \
 //y=4.97 //x2=18.135 //y2=4.62
cc_729 ( N_noxref_3_c_715_n N_RN_c_1511_n ) capacitor c=0.0166984f //x=11.495 \
 //y=4.97 //x2=18.135 //y2=4.62
cc_730 ( N_noxref_3_c_684_n N_RN_c_1512_n ) capacitor c=0.00325717f //x=2.815 \
 //y=5.335 //x2=2.825 //y2=4.62
cc_731 ( N_noxref_3_c_684_n N_RN_c_1513_n ) capacitor c=0.0143918f //x=2.815 \
 //y=5.335 //x2=2.71 //y2=2.26
cc_732 ( N_noxref_3_c_698_n N_RN_c_1513_n ) capacitor c=0.0032755f //x=4.56 \
 //y=3.145 //x2=2.71 //y2=2.26
cc_733 ( N_noxref_3_c_684_n N_RN_M20_noxref_g ) capacitor c=0.016514f \
 //x=2.815 //y=5.335 //x2=2.68 //y2=6.2
cc_734 ( N_noxref_3_M20_noxref_d N_RN_M20_noxref_g ) capacitor c=0.0180032f \
 //x=2.755 //y=5.2 //x2=2.68 //y2=6.2
cc_735 ( N_noxref_3_c_690_n N_RN_M21_noxref_g ) capacitor c=0.01736f //x=3.695 \
 //y=5.335 //x2=3.12 //y2=6.2
cc_736 ( N_noxref_3_M20_noxref_d N_RN_M21_noxref_g ) capacitor c=0.0180032f \
 //x=2.755 //y=5.2 //x2=3.12 //y2=6.2
cc_737 ( N_noxref_3_c_816_p N_RN_c_1575_n ) capacitor c=0.00426767f //x=2.9 \
 //y=5.335 //x2=3.045 //y2=4.97
cc_738 ( N_noxref_3_c_684_n N_RN_c_1576_n ) capacitor c=0.00322046f //x=2.815 \
 //y=5.335 //x2=2.71 //y2=4.88
cc_739 ( N_noxref_3_c_662_n N_SN_c_1977_n ) capacitor c=0.0053718f //x=11.22 \
 //y=2.26 //x2=12.33 //y2=2.775
cc_740 ( N_noxref_3_c_655_n N_SN_c_1987_n ) capacitor c=0.00316035f //x=11.105 \
 //y=3.145 //x2=12.33 //y2=2.26
cc_741 ( N_noxref_3_c_662_n N_SN_c_1987_n ) capacitor c=0.0456411f //x=11.22 \
 //y=2.26 //x2=12.33 //y2=2.26
cc_742 ( N_noxref_3_c_677_n N_SN_c_1987_n ) capacitor c=0.00238338f //x=10.92 \
 //y=2.095 //x2=12.33 //y2=2.26
cc_743 ( N_noxref_3_c_735_p N_SN_c_1987_n ) capacitor c=0.00147352f //x=11.785 \
 //y=4.97 //x2=12.33 //y2=2.26
cc_744 ( N_noxref_3_c_715_n N_SN_c_1987_n ) capacitor c=0.00142741f //x=11.495 \
 //y=4.97 //x2=12.33 //y2=2.26
cc_745 ( N_noxref_3_M30_noxref_g N_SN_M32_noxref_g ) capacitor c=0.0105869f \
 //x=11.42 //y=6.2 //x2=12.3 //y2=6.2
cc_746 ( N_noxref_3_M31_noxref_g N_SN_M32_noxref_g ) capacitor c=0.10632f \
 //x=11.86 //y=6.2 //x2=12.3 //y2=6.2
cc_747 ( N_noxref_3_M31_noxref_g N_SN_M33_noxref_g ) capacitor c=0.0101598f \
 //x=11.86 //y=6.2 //x2=12.74 //y2=6.2
cc_748 ( N_noxref_3_c_673_n N_SN_c_2010_n ) capacitor c=5.72482e-19 //x=10.92 \
 //y=1.055 //x2=11.895 //y2=1.09
cc_749 ( N_noxref_3_c_675_n N_SN_c_2010_n ) capacitor c=0.00149976f //x=10.92 \
 //y=1.4 //x2=11.895 //y2=1.09
cc_750 ( N_noxref_3_c_680_n N_SN_c_2010_n ) capacitor c=0.0160123f //x=11.45 \
 //y=1.055 //x2=11.895 //y2=1.09
cc_751 ( N_noxref_3_c_676_n N_SN_c_2013_n ) capacitor c=0.00111227f //x=10.92 \
 //y=1.71 //x2=11.895 //y2=1.4
cc_752 ( N_noxref_3_c_682_n N_SN_c_2013_n ) capacitor c=0.0124075f //x=11.45 \
 //y=1.4 //x2=11.895 //y2=1.4
cc_753 ( N_noxref_3_c_680_n N_SN_c_2015_n ) capacitor c=0.00103227f //x=11.45 \
 //y=1.055 //x2=12.42 //y2=1.09
cc_754 ( N_noxref_3_c_682_n N_SN_c_2016_n ) capacitor c=0.0010154f //x=11.45 \
 //y=1.4 //x2=12.42 //y2=1.4
cc_755 ( N_noxref_3_c_682_n N_SN_c_2017_n ) capacitor c=9.23422e-19 //x=11.45 \
 //y=1.4 //x2=12.42 //y2=1.63
cc_756 ( N_noxref_3_c_662_n N_SN_c_2018_n ) capacitor c=0.00231304f //x=11.22 \
 //y=2.26 //x2=12.42 //y2=2.095
cc_757 ( N_noxref_3_c_677_n N_SN_c_2018_n ) capacitor c=0.00964411f //x=10.92 \
 //y=2.095 //x2=12.42 //y2=2.095
cc_758 ( N_noxref_3_c_662_n N_SN_c_2020_n ) capacitor c=0.00183762f //x=11.22 \
 //y=2.26 //x2=12.33 //y2=4.88
cc_759 ( N_noxref_3_c_735_p N_SN_c_2020_n ) capacitor c=0.0168581f //x=11.785 \
 //y=4.97 //x2=12.33 //y2=4.88
cc_760 ( N_noxref_3_c_715_n N_SN_c_2020_n ) capacitor c=0.00484466f //x=11.495 \
 //y=4.97 //x2=12.33 //y2=4.88
cc_761 ( N_noxref_3_c_662_n N_noxref_10_c_2206_n ) capacitor c=0.0194977f \
 //x=11.22 //y=2.26 //x2=13.325 //y2=4.25
cc_762 ( N_noxref_3_c_655_n N_noxref_10_c_2201_n ) capacitor c=0.0224183f \
 //x=11.105 //y=3.145 //x2=8.63 //y2=2.26
cc_763 ( N_noxref_3_c_661_n N_noxref_10_c_2201_n ) capacitor c=0.0010353f \
 //x=6.41 //y=2.26 //x2=8.63 //y2=2.26
cc_764 ( N_noxref_3_c_662_n N_noxref_10_c_2201_n ) capacitor c=6.87018e-19 \
 //x=11.22 //y=2.26 //x2=8.63 //y2=2.26
cc_765 ( N_noxref_3_c_662_n N_noxref_10_c_2202_n ) capacitor c=0.00128582f \
 //x=11.22 //y=2.26 //x2=13.44 //y2=2.26
cc_766 ( N_noxref_3_c_661_n N_noxref_10_c_2233_n ) capacitor c=3.2187e-19 \
 //x=6.41 //y=2.26 //x2=8.625 //y2=4.25
cc_767 ( N_noxref_3_c_655_n N_noxref_10_c_2267_n ) capacitor c=0.0018253f \
 //x=11.105 //y=3.145 //x2=8.63 //y2=2.26
cc_768 ( N_noxref_3_c_688_n N_D_M18_noxref_g ) capacitor c=0.0213876f \
 //x=2.105 //y=5.335 //x2=1.8 //y2=6.2
cc_769 ( N_noxref_3_c_684_n N_D_M19_noxref_g ) capacitor c=0.0204065f \
 //x=2.815 //y=5.335 //x2=2.24 //y2=6.2
cc_770 ( N_noxref_3_M18_noxref_d N_D_M19_noxref_g ) capacitor c=0.0180032f \
 //x=1.875 //y=5.2 //x2=2.24 //y2=6.2
cc_771 ( N_noxref_3_c_688_n N_D_c_2720_n ) capacitor c=0.00437952f //x=2.105 \
 //y=5.335 //x2=2.165 //y2=4.97
cc_772 ( N_noxref_3_M2_noxref_d N_noxref_13_M0_noxref_s ) capacitor \
 c=0.00309936f //x=3.885 //y=1.095 //x2=0.945 //y2=0.555
cc_773 ( N_noxref_3_c_660_n N_noxref_14_c_2805_n ) capacitor c=0.00467111f \
 //x=4.475 //y=1.845 //x2=4.475 //y2=0.72
cc_774 ( N_noxref_3_M2_noxref_d N_noxref_14_c_2805_n ) capacitor c=0.0118029f \
 //x=3.885 //y=1.095 //x2=4.475 //y2=0.72
cc_775 ( N_noxref_3_c_769_p N_noxref_14_c_2816_n ) capacitor c=0.0200405f \
 //x=4.16 //y=1.845 //x2=3.59 //y2=1.175
cc_776 ( N_noxref_3_M2_noxref_d N_noxref_14_M1_noxref_d ) capacitor \
 c=5.27807e-19 //x=3.885 //y=1.095 //x2=2.35 //y2=1.09
cc_777 ( N_noxref_3_c_660_n N_noxref_14_M2_noxref_s ) capacitor c=0.0205066f \
 //x=4.475 //y=1.845 //x2=3.455 //y2=0.555
cc_778 ( N_noxref_3_M2_noxref_d N_noxref_14_M2_noxref_s ) capacitor \
 c=0.0426368f //x=3.885 //y=1.095 //x2=3.455 //y2=0.555
cc_779 ( N_noxref_3_c_650_n N_noxref_15_c_2868_n ) capacitor c=0.00323545f \
 //x=6.295 //y=3.145 //x2=5.89 //y2=1.685
cc_780 ( N_noxref_3_c_660_n N_noxref_15_c_2868_n ) capacitor c=3.84569e-19 \
 //x=4.475 //y=1.845 //x2=5.89 //y2=1.685
cc_781 ( N_noxref_3_c_667_n N_noxref_15_c_2868_n ) capacitor c=0.0034165f \
 //x=6.11 //y=2.095 //x2=5.89 //y2=1.685
cc_782 ( N_noxref_3_c_650_n N_noxref_15_c_2852_n ) capacitor c=0.00724023f \
 //x=6.295 //y=3.145 //x2=6.775 //y2=1.77
cc_783 ( N_noxref_3_c_655_n N_noxref_15_c_2852_n ) capacitor c=0.0039595f \
 //x=11.105 //y=3.145 //x2=6.775 //y2=1.77
cc_784 ( N_noxref_3_c_659_n N_noxref_15_c_2852_n ) capacitor c=0.00158887f \
 //x=6.525 //y=3.145 //x2=6.775 //y2=1.77
cc_785 ( N_noxref_3_c_661_n N_noxref_15_c_2852_n ) capacitor c=0.0119604f \
 //x=6.41 //y=2.26 //x2=6.775 //y2=1.77
cc_786 ( N_noxref_3_c_666_n N_noxref_15_c_2852_n ) capacitor c=0.00703864f \
 //x=6.11 //y=1.71 //x2=6.775 //y2=1.77
cc_787 ( N_noxref_3_c_667_n N_noxref_15_c_2852_n ) capacitor c=0.0224281f \
 //x=6.11 //y=2.095 //x2=6.775 //y2=1.77
cc_788 ( N_noxref_3_c_669_n N_noxref_15_c_2852_n ) capacitor c=0.00708583f \
 //x=6.485 //y=1.555 //x2=6.775 //y2=1.77
cc_789 ( N_noxref_3_c_672_n N_noxref_15_c_2852_n ) capacitor c=0.00698822f \
 //x=6.64 //y=1.4 //x2=6.775 //y2=1.77
cc_790 ( N_noxref_3_c_655_n N_noxref_15_c_2879_n ) capacitor c=0.0109188f \
 //x=11.105 //y=3.145 //x2=7.745 //y2=1.77
cc_791 ( N_noxref_3_c_655_n N_noxref_15_M3_noxref_s ) capacitor c=0.00625215f \
 //x=11.105 //y=3.145 //x2=5.755 //y2=0.555
cc_792 ( N_noxref_3_c_663_n N_noxref_15_M3_noxref_s ) capacitor c=0.0327271f \
 //x=6.11 //y=1.055 //x2=5.755 //y2=0.555
cc_793 ( N_noxref_3_c_666_n N_noxref_15_M3_noxref_s ) capacitor c=7.99997e-19 \
 //x=6.11 //y=1.71 //x2=5.755 //y2=0.555
cc_794 ( N_noxref_3_c_667_n N_noxref_15_M3_noxref_s ) capacitor c=0.00122123f \
 //x=6.11 //y=2.095 //x2=5.755 //y2=0.555
cc_795 ( N_noxref_3_c_670_n N_noxref_15_M3_noxref_s ) capacitor c=0.0121427f \
 //x=6.64 //y=1.055 //x2=5.755 //y2=0.555
cc_796 ( N_noxref_3_M2_noxref_d N_noxref_15_M3_noxref_s ) capacitor \
 c=2.55333e-19 //x=3.885 //y=1.095 //x2=5.755 //y2=0.555
cc_797 ( N_noxref_3_c_655_n N_noxref_16_c_2904_n ) capacitor c=0.00382437f \
 //x=11.105 //y=3.145 //x2=8.315 //y2=1.175
cc_798 ( N_noxref_3_c_655_n N_noxref_16_c_2910_n ) capacitor c=6.56577e-19 \
 //x=11.105 //y=3.145 //x2=9.285 //y2=0.72
cc_799 ( N_noxref_3_c_655_n N_noxref_16_M5_noxref_s ) capacitor c=0.00323545f \
 //x=11.105 //y=3.145 //x2=8.265 //y2=0.555
cc_800 ( N_noxref_3_c_655_n N_noxref_17_c_2974_n ) capacitor c=0.00323545f \
 //x=11.105 //y=3.145 //x2=10.7 //y2=1.685
cc_801 ( N_noxref_3_c_677_n N_noxref_17_c_2974_n ) capacitor c=0.0034165f \
 //x=10.92 //y=2.095 //x2=10.7 //y2=1.685
cc_802 ( N_noxref_3_c_655_n N_noxref_17_c_2958_n ) capacitor c=0.00929348f \
 //x=11.105 //y=3.145 //x2=11.585 //y2=1.77
cc_803 ( N_noxref_3_c_662_n N_noxref_17_c_2958_n ) capacitor c=0.0119604f \
 //x=11.22 //y=2.26 //x2=11.585 //y2=1.77
cc_804 ( N_noxref_3_c_676_n N_noxref_17_c_2958_n ) capacitor c=0.00703864f \
 //x=10.92 //y=1.71 //x2=11.585 //y2=1.77
cc_805 ( N_noxref_3_c_677_n N_noxref_17_c_2958_n ) capacitor c=0.0224281f \
 //x=10.92 //y=2.095 //x2=11.585 //y2=1.77
cc_806 ( N_noxref_3_c_679_n N_noxref_17_c_2958_n ) capacitor c=0.00708583f \
 //x=11.295 //y=1.555 //x2=11.585 //y2=1.77
cc_807 ( N_noxref_3_c_682_n N_noxref_17_c_2958_n ) capacitor c=0.00698822f \
 //x=11.45 //y=1.4 //x2=11.585 //y2=1.77
cc_808 ( N_noxref_3_c_673_n N_noxref_17_M6_noxref_s ) capacitor c=0.0327271f \
 //x=10.92 //y=1.055 //x2=10.565 //y2=0.555
cc_809 ( N_noxref_3_c_676_n N_noxref_17_M6_noxref_s ) capacitor c=7.99997e-19 \
 //x=10.92 //y=1.71 //x2=10.565 //y2=0.555
cc_810 ( N_noxref_3_c_677_n N_noxref_17_M6_noxref_s ) capacitor c=0.00122123f \
 //x=10.92 //y=2.095 //x2=10.565 //y2=0.555
cc_811 ( N_noxref_3_c_680_n N_noxref_17_M6_noxref_s ) capacitor c=0.0121427f \
 //x=11.45 //y=1.055 //x2=10.565 //y2=0.555
cc_812 ( N_noxref_4_c_901_n N_CLK_c_1061_n ) capacitor c=0.174212f //x=15.915 \
 //y=3.14 //x2=17.025 //y2=3.51
cc_813 ( N_noxref_4_c_954_n N_CLK_c_1061_n ) capacitor c=0.0294052f //x=14.295 \
 //y=3.14 //x2=17.025 //y2=3.51
cc_814 ( N_noxref_4_c_929_n N_CLK_c_1061_n ) capacitor c=0.0205776f //x=14.18 \
 //y=3.14 //x2=17.025 //y2=3.51
cc_815 ( N_noxref_4_c_903_n N_CLK_c_1061_n ) capacitor c=0.0229269f //x=16.03 \
 //y=2.26 //x2=17.025 //y2=3.51
cc_816 ( N_noxref_4_c_901_n N_CLK_c_1063_n ) capacitor c=0.00520283f \
 //x=15.915 //y=3.14 //x2=17.14 //y2=2.26
cc_817 ( N_noxref_4_c_929_n N_CLK_c_1063_n ) capacitor c=5.24823e-19 //x=14.18 \
 //y=3.14 //x2=17.14 //y2=2.26
cc_818 ( N_noxref_4_c_903_n N_CLK_c_1063_n ) capacitor c=0.0442053f //x=16.03 \
 //y=2.26 //x2=17.14 //y2=2.26
cc_819 ( N_noxref_4_c_908_n N_CLK_c_1063_n ) capacitor c=0.00238338f //x=15.73 \
 //y=2.095 //x2=17.14 //y2=2.26
cc_820 ( N_noxref_4_c_967_p N_CLK_c_1063_n ) capacitor c=0.00147352f \
 //x=16.595 //y=4.97 //x2=17.14 //y2=2.26
cc_821 ( N_noxref_4_c_937_n N_CLK_c_1063_n ) capacitor c=0.00142741f \
 //x=16.305 //y=4.97 //x2=17.14 //y2=2.26
cc_822 ( N_noxref_4_M36_noxref_g N_CLK_M38_noxref_g ) capacitor c=0.0105869f \
 //x=16.23 //y=6.2 //x2=17.11 //y2=6.2
cc_823 ( N_noxref_4_M37_noxref_g N_CLK_M38_noxref_g ) capacitor c=0.10632f \
 //x=16.67 //y=6.2 //x2=17.11 //y2=6.2
cc_824 ( N_noxref_4_M37_noxref_g N_CLK_M39_noxref_g ) capacitor c=0.0101598f \
 //x=16.67 //y=6.2 //x2=17.55 //y2=6.2
cc_825 ( N_noxref_4_c_904_n N_CLK_c_1117_n ) capacitor c=5.72482e-19 //x=15.73 \
 //y=1.055 //x2=16.705 //y2=1.09
cc_826 ( N_noxref_4_c_906_n N_CLK_c_1117_n ) capacitor c=0.00149976f //x=15.73 \
 //y=1.4 //x2=16.705 //y2=1.09
cc_827 ( N_noxref_4_c_911_n N_CLK_c_1117_n ) capacitor c=0.0160123f //x=16.26 \
 //y=1.055 //x2=16.705 //y2=1.09
cc_828 ( N_noxref_4_c_907_n N_CLK_c_1120_n ) capacitor c=0.00111227f //x=15.73 \
 //y=1.71 //x2=16.705 //y2=1.4
cc_829 ( N_noxref_4_c_913_n N_CLK_c_1120_n ) capacitor c=0.0124075f //x=16.26 \
 //y=1.4 //x2=16.705 //y2=1.4
cc_830 ( N_noxref_4_c_911_n N_CLK_c_1122_n ) capacitor c=0.00103227f //x=16.26 \
 //y=1.055 //x2=17.23 //y2=1.09
cc_831 ( N_noxref_4_c_913_n N_CLK_c_1123_n ) capacitor c=0.0010154f //x=16.26 \
 //y=1.4 //x2=17.23 //y2=1.4
cc_832 ( N_noxref_4_c_913_n N_CLK_c_1124_n ) capacitor c=9.23422e-19 //x=16.26 \
 //y=1.4 //x2=17.23 //y2=1.63
cc_833 ( N_noxref_4_c_903_n N_CLK_c_1125_n ) capacitor c=0.00231304f //x=16.03 \
 //y=2.26 //x2=17.23 //y2=2.095
cc_834 ( N_noxref_4_c_908_n N_CLK_c_1125_n ) capacitor c=0.00964411f //x=15.73 \
 //y=2.095 //x2=17.23 //y2=2.095
cc_835 ( N_noxref_4_c_903_n N_CLK_c_1127_n ) capacitor c=0.00183762f //x=16.03 \
 //y=2.26 //x2=17.14 //y2=4.88
cc_836 ( N_noxref_4_c_967_p N_CLK_c_1127_n ) capacitor c=0.0168581f //x=16.595 \
 //y=4.97 //x2=17.14 //y2=4.88
cc_837 ( N_noxref_4_c_937_n N_CLK_c_1127_n ) capacitor c=0.00484466f \
 //x=16.305 //y=4.97 //x2=17.14 //y2=4.88
cc_838 ( N_noxref_4_c_901_n N_noxref_6_c_1253_n ) capacitor c=0.0116525f \
 //x=15.915 //y=3.14 //x2=20.725 //y2=3.88
cc_839 ( N_noxref_4_c_954_n N_noxref_6_c_1253_n ) capacitor c=7.98461e-19 \
 //x=14.295 //y=3.14 //x2=20.725 //y2=3.88
cc_840 ( N_noxref_4_c_929_n N_noxref_6_c_1253_n ) capacitor c=0.0187698f \
 //x=14.18 //y=3.14 //x2=20.725 //y2=3.88
cc_841 ( N_noxref_4_c_903_n N_noxref_6_c_1253_n ) capacitor c=0.0197889f \
 //x=16.03 //y=2.26 //x2=20.725 //y2=3.88
cc_842 ( N_noxref_4_c_919_n N_noxref_6_c_1280_n ) capacitor c=3.10026e-19 \
 //x=11.725 //y=5.335 //x2=9.285 //y2=5.335
cc_843 ( N_noxref_4_c_915_n N_RN_c_1511_n ) capacitor c=0.032219f //x=12.435 \
 //y=5.335 //x2=18.135 //y2=4.62
cc_844 ( N_noxref_4_c_919_n N_RN_c_1511_n ) capacitor c=0.0230136f //x=11.725 \
 //y=5.335 //x2=18.135 //y2=4.62
cc_845 ( N_noxref_4_c_925_n N_RN_c_1511_n ) capacitor c=0.0183122f //x=14.095 \
 //y=5.335 //x2=18.135 //y2=4.62
cc_846 ( N_noxref_4_c_929_n N_RN_c_1511_n ) capacitor c=0.0210274f //x=14.18 \
 //y=3.14 //x2=18.135 //y2=4.62
cc_847 ( N_noxref_4_c_903_n N_RN_c_1511_n ) capacitor c=0.0208709f //x=16.03 \
 //y=2.26 //x2=18.135 //y2=4.62
cc_848 ( N_noxref_4_c_937_n N_RN_c_1511_n ) capacitor c=0.0166984f //x=16.305 \
 //y=4.97 //x2=18.135 //y2=4.62
cc_849 ( N_noxref_4_c_903_n N_RN_c_1514_n ) capacitor c=0.00132243f //x=16.03 \
 //y=2.26 //x2=18.25 //y2=2.26
cc_850 ( N_noxref_4_c_901_n N_SN_c_1977_n ) capacitor c=0.172536f //x=15.915 \
 //y=3.14 //x2=12.33 //y2=2.775
cc_851 ( N_noxref_4_c_954_n N_SN_c_1977_n ) capacitor c=0.0292376f //x=14.295 \
 //y=3.14 //x2=12.33 //y2=2.775
cc_852 ( N_noxref_4_c_999_p N_SN_c_1977_n ) capacitor c=0.0115788f //x=13.78 \
 //y=1.845 //x2=12.33 //y2=2.775
cc_853 ( N_noxref_4_c_929_n N_SN_c_1977_n ) capacitor c=0.0228083f //x=14.18 \
 //y=3.14 //x2=12.33 //y2=2.775
cc_854 ( N_noxref_4_c_903_n N_SN_c_1977_n ) capacitor c=0.024186f //x=16.03 \
 //y=2.26 //x2=12.33 //y2=2.775
cc_855 ( N_noxref_4_c_908_n N_SN_c_1977_n ) capacitor c=0.00712164f //x=15.73 \
 //y=2.095 //x2=12.33 //y2=2.775
cc_856 ( N_noxref_4_c_915_n N_SN_c_1987_n ) capacitor c=0.0144268f //x=12.435 \
 //y=5.335 //x2=12.33 //y2=2.26
cc_857 ( N_noxref_4_c_929_n N_SN_c_1987_n ) capacitor c=0.00265671f //x=14.18 \
 //y=3.14 //x2=12.33 //y2=2.26
cc_858 ( N_noxref_4_c_915_n N_SN_M32_noxref_g ) capacitor c=0.0165266f \
 //x=12.435 //y=5.335 //x2=12.3 //y2=6.2
cc_859 ( N_noxref_4_M32_noxref_d N_SN_M32_noxref_g ) capacitor c=0.0180032f \
 //x=12.375 //y=5.2 //x2=12.3 //y2=6.2
cc_860 ( N_noxref_4_c_921_n N_SN_M33_noxref_g ) capacitor c=0.01736f \
 //x=13.315 //y=5.335 //x2=12.74 //y2=6.2
cc_861 ( N_noxref_4_M32_noxref_d N_SN_M33_noxref_g ) capacitor c=0.0180032f \
 //x=12.375 //y=5.2 //x2=12.74 //y2=6.2
cc_862 ( N_noxref_4_c_1009_p N_SN_c_2035_n ) capacitor c=0.00426767f //x=12.52 \
 //y=5.335 //x2=12.665 //y2=4.97
cc_863 ( N_noxref_4_c_915_n N_SN_c_2020_n ) capacitor c=0.00322054f //x=12.435 \
 //y=5.335 //x2=12.33 //y2=4.88
cc_864 ( N_noxref_4_c_929_n N_noxref_10_c_2207_n ) capacitor c=0.0181982f \
 //x=14.18 //y=3.14 //x2=18.875 //y2=4.25
cc_865 ( N_noxref_4_c_903_n N_noxref_10_c_2207_n ) capacitor c=0.019517f \
 //x=16.03 //y=2.26 //x2=18.875 //y2=4.25
cc_866 ( N_noxref_4_c_929_n N_noxref_10_c_2270_n ) capacitor c=0.00179385f \
 //x=14.18 //y=3.14 //x2=13.555 //y2=4.25
cc_867 ( N_noxref_4_c_954_n N_noxref_10_c_2202_n ) capacitor c=0.00458487f \
 //x=14.295 //y=3.14 //x2=13.44 //y2=2.26
cc_868 ( N_noxref_4_c_929_n N_noxref_10_c_2202_n ) capacitor c=0.0790601f \
 //x=14.18 //y=3.14 //x2=13.44 //y2=2.26
cc_869 ( N_noxref_4_c_903_n N_noxref_10_c_2202_n ) capacitor c=8.48165e-19 \
 //x=16.03 //y=2.26 //x2=13.44 //y2=2.26
cc_870 ( N_noxref_4_c_1017_p N_noxref_10_c_2202_n ) capacitor c=0.0171303f \
 //x=13.4 //y=5.335 //x2=13.44 //y2=2.26
cc_871 ( N_noxref_4_M37_noxref_g N_noxref_10_c_2217_n ) capacitor c=0.0168349f \
 //x=16.67 //y=6.2 //x2=17.245 //y2=5.335
cc_872 ( N_noxref_4_c_925_n N_noxref_10_c_2221_n ) capacitor c=3.10026e-19 \
 //x=14.095 //y=5.335 //x2=16.535 //y2=5.335
cc_873 ( N_noxref_4_M36_noxref_g N_noxref_10_c_2221_n ) capacitor c=0.0213876f \
 //x=16.23 //y=6.2 //x2=16.535 //y2=5.335
cc_874 ( N_noxref_4_c_967_p N_noxref_10_c_2221_n ) capacitor c=0.00428486f \
 //x=16.595 //y=4.97 //x2=16.535 //y2=5.335
cc_875 ( N_noxref_4_c_921_n N_noxref_10_M34_noxref_g ) capacitor c=0.01736f \
 //x=13.315 //y=5.335 //x2=13.18 //y2=6.2
cc_876 ( N_noxref_4_M34_noxref_d N_noxref_10_M34_noxref_g ) capacitor \
 c=0.0180032f //x=13.255 //y=5.2 //x2=13.18 //y2=6.2
cc_877 ( N_noxref_4_c_925_n N_noxref_10_M35_noxref_g ) capacitor c=0.0194981f \
 //x=14.095 //y=5.335 //x2=13.62 //y2=6.2
cc_878 ( N_noxref_4_M34_noxref_d N_noxref_10_M35_noxref_g ) capacitor \
 c=0.0194246f //x=13.255 //y=5.2 //x2=13.62 //y2=6.2
cc_879 ( N_noxref_4_M8_noxref_d N_noxref_10_c_2283_n ) capacitor c=0.00217566f \
 //x=13.505 //y=1.095 //x2=13.43 //y2=1.095
cc_880 ( N_noxref_4_M8_noxref_d N_noxref_10_c_2284_n ) capacitor c=0.0034598f \
 //x=13.505 //y=1.095 //x2=13.43 //y2=1.44
cc_881 ( N_noxref_4_M8_noxref_d N_noxref_10_c_2285_n ) capacitor c=0.00544291f \
 //x=13.505 //y=1.095 //x2=13.43 //y2=1.75
cc_882 ( N_noxref_4_M8_noxref_d N_noxref_10_c_2286_n ) capacitor c=0.00241102f \
 //x=13.505 //y=1.095 //x2=13.805 //y2=0.94
cc_883 ( N_noxref_4_c_902_n N_noxref_10_c_2287_n ) capacitor c=0.00359704f \
 //x=14.095 //y=1.845 //x2=13.805 //y2=1.595
cc_884 ( N_noxref_4_M8_noxref_d N_noxref_10_c_2287_n ) capacitor c=0.0140297f \
 //x=13.505 //y=1.095 //x2=13.805 //y2=1.595
cc_885 ( N_noxref_4_M8_noxref_d N_noxref_10_c_2289_n ) capacitor c=0.00219619f \
 //x=13.505 //y=1.095 //x2=13.96 //y2=1.095
cc_886 ( N_noxref_4_c_902_n N_noxref_10_c_2290_n ) capacitor c=0.00457401f \
 //x=14.095 //y=1.845 //x2=13.96 //y2=1.44
cc_887 ( N_noxref_4_M8_noxref_d N_noxref_10_c_2290_n ) capacitor c=0.00603828f \
 //x=13.505 //y=1.095 //x2=13.96 //y2=1.44
cc_888 ( N_noxref_4_c_929_n N_noxref_10_c_2292_n ) capacitor c=0.00877984f \
 //x=14.18 //y=3.14 //x2=13.44 //y2=2.26
cc_889 ( N_noxref_4_c_929_n N_noxref_10_c_2293_n ) capacitor c=0.00283672f \
 //x=14.18 //y=3.14 //x2=13.44 //y2=2.095
cc_890 ( N_noxref_4_M8_noxref_d N_noxref_10_c_2293_n ) capacitor c=0.00661782f \
 //x=13.505 //y=1.095 //x2=13.44 //y2=2.095
cc_891 ( N_noxref_4_c_925_n N_noxref_10_c_2295_n ) capacitor c=0.00201851f \
 //x=14.095 //y=5.335 //x2=13.44 //y2=4.88
cc_892 ( N_noxref_4_c_929_n N_noxref_10_c_2295_n ) capacitor c=0.013844f \
 //x=14.18 //y=3.14 //x2=13.44 //y2=4.88
cc_893 ( N_noxref_4_c_1017_p N_noxref_10_c_2295_n ) capacitor c=0.00475601f \
 //x=13.4 //y=5.335 //x2=13.44 //y2=4.88
cc_894 ( N_noxref_4_M37_noxref_g N_noxref_10_M36_noxref_d ) capacitor \
 c=0.0180032f //x=16.67 //y=6.2 //x2=16.305 //y2=5.2
cc_895 ( N_noxref_4_M8_noxref_d N_noxref_17_M6_noxref_s ) capacitor \
 c=0.00309936f //x=13.505 //y=1.095 //x2=10.565 //y2=0.555
cc_896 ( N_noxref_4_c_902_n N_noxref_18_c_3017_n ) capacitor c=0.00461497f \
 //x=14.095 //y=1.845 //x2=14.095 //y2=0.72
cc_897 ( N_noxref_4_M8_noxref_d N_noxref_18_c_3017_n ) capacitor c=0.0116817f \
 //x=13.505 //y=1.095 //x2=14.095 //y2=0.72
cc_898 ( N_noxref_4_c_999_p N_noxref_18_c_3028_n ) capacitor c=0.0200405f \
 //x=13.78 //y=1.845 //x2=13.21 //y2=1.175
cc_899 ( N_noxref_4_M8_noxref_d N_noxref_18_M7_noxref_d ) capacitor \
 c=5.27807e-19 //x=13.505 //y=1.095 //x2=11.97 //y2=1.09
cc_900 ( N_noxref_4_c_902_n N_noxref_18_M8_noxref_s ) capacitor c=0.0201579f \
 //x=14.095 //y=1.845 //x2=13.075 //y2=0.555
cc_901 ( N_noxref_4_M8_noxref_d N_noxref_18_M8_noxref_s ) capacitor \
 c=0.0426368f //x=13.505 //y=1.095 //x2=13.075 //y2=0.555
cc_902 ( N_noxref_4_c_902_n N_noxref_19_c_3081_n ) capacitor c=3.84569e-19 \
 //x=14.095 //y=1.845 //x2=15.51 //y2=1.685
cc_903 ( N_noxref_4_c_908_n N_noxref_19_c_3081_n ) capacitor c=0.0034165f \
 //x=15.73 //y=2.095 //x2=15.51 //y2=1.685
cc_904 ( N_noxref_4_c_903_n N_noxref_19_c_3065_n ) capacitor c=0.0117982f \
 //x=16.03 //y=2.26 //x2=16.395 //y2=1.77
cc_905 ( N_noxref_4_c_907_n N_noxref_19_c_3065_n ) capacitor c=0.00703864f \
 //x=15.73 //y=1.71 //x2=16.395 //y2=1.77
cc_906 ( N_noxref_4_c_908_n N_noxref_19_c_3065_n ) capacitor c=0.0215834f \
 //x=15.73 //y=2.095 //x2=16.395 //y2=1.77
cc_907 ( N_noxref_4_c_910_n N_noxref_19_c_3065_n ) capacitor c=0.00708583f \
 //x=16.105 //y=1.555 //x2=16.395 //y2=1.77
cc_908 ( N_noxref_4_c_913_n N_noxref_19_c_3065_n ) capacitor c=0.00698822f \
 //x=16.26 //y=1.4 //x2=16.395 //y2=1.77
cc_909 ( N_noxref_4_c_904_n N_noxref_19_M9_noxref_s ) capacitor c=0.0327271f \
 //x=15.73 //y=1.055 //x2=15.375 //y2=0.555
cc_910 ( N_noxref_4_c_907_n N_noxref_19_M9_noxref_s ) capacitor c=7.99997e-19 \
 //x=15.73 //y=1.71 //x2=15.375 //y2=0.555
cc_911 ( N_noxref_4_c_908_n N_noxref_19_M9_noxref_s ) capacitor c=0.00122123f \
 //x=15.73 //y=2.095 //x2=15.375 //y2=0.555
cc_912 ( N_noxref_4_c_911_n N_noxref_19_M9_noxref_s ) capacitor c=0.0121427f \
 //x=16.26 //y=1.055 //x2=15.375 //y2=0.555
cc_913 ( N_noxref_4_M8_noxref_d N_noxref_19_M9_noxref_s ) capacitor \
 c=2.55333e-19 //x=13.505 //y=1.095 //x2=15.375 //y2=0.555
cc_914 ( N_CLK_c_1061_n N_noxref_6_c_1251_n ) capacitor c=0.14131f //x=17.025 \
 //y=3.51 //x2=9.255 //y2=3.88
cc_915 ( N_CLK_c_1078_n N_noxref_6_c_1251_n ) capacitor c=0.029189f //x=7.635 \
 //y=3.51 //x2=9.255 //y2=3.88
cc_916 ( N_CLK_c_1062_n N_noxref_6_c_1251_n ) capacitor c=0.0231796f //x=7.52 \
 //y=2.26 //x2=9.255 //y2=3.88
cc_917 ( N_CLK_c_1061_n N_noxref_6_c_1253_n ) capacitor c=0.697076f //x=17.025 \
 //y=3.51 //x2=20.725 //y2=3.88
cc_918 ( N_CLK_c_1063_n N_noxref_6_c_1253_n ) capacitor c=0.0208745f //x=17.14 \
 //y=2.26 //x2=20.725 //y2=3.88
cc_919 ( N_CLK_c_1061_n N_noxref_6_c_1323_n ) capacitor c=0.0268461f \
 //x=17.025 //y=3.51 //x2=9.485 //y2=3.88
cc_920 ( N_CLK_c_1062_n N_noxref_6_c_1270_n ) capacitor c=0.0144268f //x=7.52 \
 //y=2.26 //x2=7.625 //y2=5.335
cc_921 ( N_CLK_M26_noxref_g N_noxref_6_c_1270_n ) capacitor c=0.0165266f \
 //x=7.49 //y=6.2 //x2=7.625 //y2=5.335
cc_922 ( N_CLK_c_1101_n N_noxref_6_c_1270_n ) capacitor c=0.00322054f //x=7.52 \
 //y=4.88 //x2=7.625 //y2=5.335
cc_923 ( N_CLK_M27_noxref_g N_noxref_6_c_1276_n ) capacitor c=0.01736f \
 //x=7.93 //y=6.2 //x2=8.505 //y2=5.335
cc_924 ( N_CLK_c_1061_n N_noxref_6_c_1284_n ) capacitor c=0.0205384f \
 //x=17.025 //y=3.51 //x2=9.37 //y2=3.88
cc_925 ( N_CLK_c_1062_n N_noxref_6_c_1284_n ) capacitor c=0.00286753f //x=7.52 \
 //y=2.26 //x2=9.37 //y2=3.88
cc_926 ( N_CLK_c_1142_p N_noxref_6_c_1373_n ) capacitor c=0.00426767f \
 //x=7.855 //y=4.97 //x2=7.71 //y2=5.335
cc_927 ( N_CLK_M26_noxref_g N_noxref_6_M26_noxref_d ) capacitor c=0.0180032f \
 //x=7.49 //y=6.2 //x2=7.565 //y2=5.2
cc_928 ( N_CLK_M27_noxref_g N_noxref_6_M26_noxref_d ) capacitor c=0.0180032f \
 //x=7.93 //y=6.2 //x2=7.565 //y2=5.2
cc_929 ( N_CLK_c_1061_n N_RN_c_1511_n ) capacitor c=0.00660904f //x=17.025 \
 //y=3.51 //x2=18.135 //y2=4.62
cc_930 ( N_CLK_c_1078_n N_RN_c_1511_n ) capacitor c=7.33995e-19 //x=7.635 \
 //y=3.51 //x2=18.135 //y2=4.62
cc_931 ( N_CLK_c_1062_n N_RN_c_1511_n ) capacitor c=0.0233868f //x=7.52 \
 //y=2.26 //x2=18.135 //y2=4.62
cc_932 ( N_CLK_c_1063_n N_RN_c_1511_n ) capacitor c=0.0210462f //x=17.14 \
 //y=2.26 //x2=18.135 //y2=4.62
cc_933 ( N_CLK_c_1142_p N_RN_c_1511_n ) capacitor c=0.0085986f //x=7.855 \
 //y=4.97 //x2=18.135 //y2=4.62
cc_934 ( N_CLK_c_1150_p N_RN_c_1511_n ) capacitor c=0.0085986f //x=17.475 \
 //y=4.97 //x2=18.135 //y2=4.62
cc_935 ( N_CLK_c_1101_n N_RN_c_1511_n ) capacitor c=0.00293313f //x=7.52 \
 //y=4.88 //x2=18.135 //y2=4.62
cc_936 ( N_CLK_c_1127_n N_RN_c_1511_n ) capacitor c=0.00293313f //x=17.14 \
 //y=4.88 //x2=18.135 //y2=4.62
cc_937 ( N_CLK_c_1063_n N_RN_c_1539_n ) capacitor c=0.00153281f //x=17.14 \
 //y=2.26 //x2=18.365 //y2=4.62
cc_938 ( N_CLK_c_1061_n N_RN_c_1514_n ) capacitor c=0.00526349f //x=17.025 \
 //y=3.51 //x2=18.25 //y2=2.26
cc_939 ( N_CLK_c_1063_n N_RN_c_1514_n ) capacitor c=0.0464118f //x=17.14 \
 //y=2.26 //x2=18.25 //y2=2.26
cc_940 ( N_CLK_c_1125_n N_RN_c_1514_n ) capacitor c=0.0023343f //x=17.23 \
 //y=2.095 //x2=18.25 //y2=2.26
cc_941 ( N_CLK_c_1127_n N_RN_c_1514_n ) capacitor c=0.00141297f //x=17.14 \
 //y=4.88 //x2=18.25 //y2=2.26
cc_942 ( N_CLK_M38_noxref_g N_RN_M40_noxref_g ) capacitor c=0.0101598f \
 //x=17.11 //y=6.2 //x2=17.99 //y2=6.2
cc_943 ( N_CLK_M39_noxref_g N_RN_M40_noxref_g ) capacitor c=0.0602553f \
 //x=17.55 //y=6.2 //x2=17.99 //y2=6.2
cc_944 ( N_CLK_M39_noxref_g N_RN_M41_noxref_g ) capacitor c=0.0101598f \
 //x=17.55 //y=6.2 //x2=18.43 //y2=6.2
cc_945 ( N_CLK_c_1122_n N_RN_c_1600_n ) capacitor c=0.00456962f //x=17.23 \
 //y=1.09 //x2=18.24 //y2=1.095
cc_946 ( N_CLK_c_1123_n N_RN_c_1601_n ) capacitor c=0.00438372f //x=17.23 \
 //y=1.4 //x2=18.24 //y2=1.44
cc_947 ( N_CLK_c_1124_n N_RN_c_1602_n ) capacitor c=0.00438372f //x=17.23 \
 //y=1.63 //x2=18.24 //y2=1.75
cc_948 ( N_CLK_c_1063_n N_RN_c_1603_n ) capacitor c=0.00228632f //x=17.14 \
 //y=2.26 //x2=18.25 //y2=2.26
cc_949 ( N_CLK_c_1125_n N_RN_c_1603_n ) capacitor c=0.00933826f //x=17.23 \
 //y=2.095 //x2=18.25 //y2=2.26
cc_950 ( N_CLK_c_1125_n N_RN_c_1605_n ) capacitor c=0.00438372f //x=17.23 \
 //y=2.095 //x2=18.25 //y2=2.095
cc_951 ( N_CLK_c_1063_n N_RN_c_1606_n ) capacitor c=0.00219458f //x=17.14 \
 //y=2.26 //x2=18.25 //y2=4.88
cc_952 ( N_CLK_c_1150_p N_RN_c_1606_n ) capacitor c=0.0611812f //x=17.475 \
 //y=4.97 //x2=18.25 //y2=4.88
cc_953 ( N_CLK_c_1127_n N_RN_c_1606_n ) capacitor c=0.00487508f //x=17.14 \
 //y=4.88 //x2=18.25 //y2=4.88
cc_954 ( N_CLK_c_1061_n N_SN_c_1977_n ) capacitor c=0.142136f //x=17.025 \
 //y=3.51 //x2=12.33 //y2=2.775
cc_955 ( N_CLK_c_1063_n N_SN_c_1977_n ) capacitor c=0.0251844f //x=17.14 \
 //y=2.26 //x2=12.33 //y2=2.775
cc_956 ( N_CLK_c_1125_n N_SN_c_1977_n ) capacitor c=0.00263139f //x=17.23 \
 //y=2.095 //x2=12.33 //y2=2.775
cc_957 ( N_CLK_c_1061_n N_SN_c_1987_n ) capacitor c=0.0216891f //x=17.025 \
 //y=3.51 //x2=12.33 //y2=2.26
cc_958 ( N_CLK_c_1061_n N_noxref_10_c_2206_n ) capacitor c=0.0347141f \
 //x=17.025 //y=3.51 //x2=13.325 //y2=4.25
cc_959 ( N_CLK_c_1061_n N_noxref_10_c_2300_n ) capacitor c=7.00757e-19 \
 //x=17.025 //y=3.51 //x2=8.74 //y2=4.25
cc_960 ( N_CLK_c_1062_n N_noxref_10_c_2300_n ) capacitor c=0.00528706f \
 //x=7.52 //y=2.26 //x2=8.74 //y2=4.25
cc_961 ( N_CLK_c_1061_n N_noxref_10_c_2207_n ) capacitor c=0.0257572f \
 //x=17.025 //y=3.51 //x2=18.875 //y2=4.25
cc_962 ( N_CLK_c_1063_n N_noxref_10_c_2207_n ) capacitor c=0.0190126f \
 //x=17.14 //y=2.26 //x2=18.875 //y2=4.25
cc_963 ( N_CLK_c_1061_n N_noxref_10_c_2270_n ) capacitor c=4.7279e-19 \
 //x=17.025 //y=3.51 //x2=13.555 //y2=4.25
cc_964 ( N_CLK_c_1061_n N_noxref_10_c_2201_n ) capacitor c=0.0179796f \
 //x=17.025 //y=3.51 //x2=8.63 //y2=2.26
cc_965 ( N_CLK_c_1078_n N_noxref_10_c_2201_n ) capacitor c=0.00128547f \
 //x=7.635 //y=3.51 //x2=8.63 //y2=2.26
cc_966 ( N_CLK_c_1062_n N_noxref_10_c_2201_n ) capacitor c=0.0322045f //x=7.52 \
 //y=2.26 //x2=8.63 //y2=2.26
cc_967 ( N_CLK_c_1098_n N_noxref_10_c_2201_n ) capacitor c=0.0023343f //x=7.61 \
 //y=2.095 //x2=8.63 //y2=2.26
cc_968 ( N_CLK_c_1062_n N_noxref_10_c_2309_n ) capacitor c=0.00867715f \
 //x=7.52 //y=2.26 //x2=8.63 //y2=4.88
cc_969 ( N_CLK_c_1101_n N_noxref_10_c_2309_n ) capacitor c=0.00142741f \
 //x=7.52 //y=4.88 //x2=8.63 //y2=4.88
cc_970 ( N_CLK_c_1061_n N_noxref_10_c_2202_n ) capacitor c=0.0203592f \
 //x=17.025 //y=3.51 //x2=13.44 //y2=2.26
cc_971 ( N_CLK_c_1063_n N_noxref_10_c_2217_n ) capacitor c=0.0144268f \
 //x=17.14 //y=2.26 //x2=17.245 //y2=5.335
cc_972 ( N_CLK_M38_noxref_g N_noxref_10_c_2217_n ) capacitor c=0.0165266f \
 //x=17.11 //y=6.2 //x2=17.245 //y2=5.335
cc_973 ( N_CLK_c_1127_n N_noxref_10_c_2217_n ) capacitor c=0.00322054f \
 //x=17.14 //y=4.88 //x2=17.245 //y2=5.335
cc_974 ( N_CLK_M39_noxref_g N_noxref_10_c_2223_n ) capacitor c=0.01736f \
 //x=17.55 //y=6.2 //x2=18.125 //y2=5.335
cc_975 ( N_CLK_c_1063_n N_noxref_10_c_2231_n ) capacitor c=0.00315138f \
 //x=17.14 //y=2.26 //x2=18.99 //y2=4.25
cc_976 ( N_CLK_c_1062_n N_noxref_10_c_2233_n ) capacitor c=0.00609925f \
 //x=7.52 //y=2.26 //x2=8.625 //y2=4.25
cc_977 ( N_CLK_c_1150_p N_noxref_10_c_2318_n ) capacitor c=0.00426767f \
 //x=17.475 //y=4.97 //x2=17.33 //y2=5.335
cc_978 ( N_CLK_M26_noxref_g N_noxref_10_M28_noxref_g ) capacitor c=0.0101598f \
 //x=7.49 //y=6.2 //x2=8.37 //y2=6.2
cc_979 ( N_CLK_M27_noxref_g N_noxref_10_M28_noxref_g ) capacitor c=0.0602553f \
 //x=7.93 //y=6.2 //x2=8.37 //y2=6.2
cc_980 ( N_CLK_M27_noxref_g N_noxref_10_M29_noxref_g ) capacitor c=0.0101598f \
 //x=7.93 //y=6.2 //x2=8.81 //y2=6.2
cc_981 ( N_CLK_c_1095_n N_noxref_10_c_2322_n ) capacitor c=0.00456962f \
 //x=7.61 //y=1.09 //x2=8.62 //y2=1.095
cc_982 ( N_CLK_c_1096_n N_noxref_10_c_2323_n ) capacitor c=0.00438372f \
 //x=7.61 //y=1.4 //x2=8.62 //y2=1.44
cc_983 ( N_CLK_c_1097_n N_noxref_10_c_2324_n ) capacitor c=0.00438372f \
 //x=7.61 //y=1.63 //x2=8.62 //y2=1.75
cc_984 ( N_CLK_c_1062_n N_noxref_10_c_2267_n ) capacitor c=0.00228632f \
 //x=7.52 //y=2.26 //x2=8.63 //y2=2.26
cc_985 ( N_CLK_c_1098_n N_noxref_10_c_2267_n ) capacitor c=0.00933826f \
 //x=7.61 //y=2.095 //x2=8.63 //y2=2.26
cc_986 ( N_CLK_c_1098_n N_noxref_10_c_2327_n ) capacitor c=0.00438372f \
 //x=7.61 //y=2.095 //x2=8.63 //y2=2.095
cc_987 ( N_CLK_c_1062_n N_noxref_10_c_2328_n ) capacitor c=0.00219458f \
 //x=7.52 //y=2.26 //x2=8.63 //y2=4.88
cc_988 ( N_CLK_c_1142_p N_noxref_10_c_2328_n ) capacitor c=0.0611812f \
 //x=7.855 //y=4.97 //x2=8.63 //y2=4.88
cc_989 ( N_CLK_c_1101_n N_noxref_10_c_2328_n ) capacitor c=0.00487508f \
 //x=7.52 //y=4.88 //x2=8.63 //y2=4.88
cc_990 ( N_CLK_M38_noxref_g N_noxref_10_M38_noxref_d ) capacitor c=0.0180032f \
 //x=17.11 //y=6.2 //x2=17.185 //y2=5.2
cc_991 ( N_CLK_M39_noxref_g N_noxref_10_M38_noxref_d ) capacitor c=0.0180032f \
 //x=17.55 //y=6.2 //x2=17.185 //y2=5.2
cc_992 ( N_CLK_c_1090_n N_noxref_15_c_2859_n ) capacitor c=0.0167228f \
 //x=7.085 //y=1.09 //x2=7.745 //y2=0.72
cc_993 ( N_CLK_c_1095_n N_noxref_15_c_2859_n ) capacitor c=0.00534519f \
 //x=7.61 //y=1.09 //x2=7.745 //y2=0.72
cc_994 ( N_CLK_c_1062_n N_noxref_15_c_2879_n ) capacitor c=0.0124901f //x=7.52 \
 //y=2.26 //x2=7.745 //y2=1.77
cc_995 ( N_CLK_c_1093_n N_noxref_15_c_2879_n ) capacitor c=0.0153476f \
 //x=7.085 //y=1.4 //x2=7.745 //y2=1.77
cc_996 ( N_CLK_c_1098_n N_noxref_15_c_2879_n ) capacitor c=0.0223834f //x=7.61 \
 //y=2.095 //x2=7.745 //y2=1.77
cc_997 ( N_CLK_c_1090_n N_noxref_15_M3_noxref_s ) capacitor c=0.00798959f \
 //x=7.085 //y=1.09 //x2=5.755 //y2=0.555
cc_998 ( N_CLK_c_1097_n N_noxref_15_M3_noxref_s ) capacitor c=0.00212176f \
 //x=7.61 //y=1.63 //x2=5.755 //y2=0.555
cc_999 ( N_CLK_c_1098_n N_noxref_15_M3_noxref_s ) capacitor c=0.00298115f \
 //x=7.61 //y=2.095 //x2=5.755 //y2=0.555
cc_1000 ( N_CLK_c_1216_p N_noxref_16_c_2904_n ) capacitor c=2.14837e-19 \
 //x=7.455 //y=0.935 //x2=8.315 //y2=1.175
cc_1001 ( N_CLK_c_1095_n N_noxref_16_c_2904_n ) capacitor c=0.00123426f \
 //x=7.61 //y=1.09 //x2=8.315 //y2=1.175
cc_1002 ( N_CLK_c_1096_n N_noxref_16_c_2904_n ) capacitor c=0.0129288f \
 //x=7.61 //y=1.4 //x2=8.315 //y2=1.175
cc_1003 ( N_CLK_c_1097_n N_noxref_16_c_2904_n ) capacitor c=0.00142359f \
 //x=7.61 //y=1.63 //x2=8.315 //y2=1.175
cc_1004 ( N_CLK_c_1090_n N_noxref_16_M4_noxref_d ) capacitor c=0.00223875f \
 //x=7.085 //y=1.09 //x2=7.16 //y2=1.09
cc_1005 ( N_CLK_c_1093_n N_noxref_16_M4_noxref_d ) capacitor c=0.00262485f \
 //x=7.085 //y=1.4 //x2=7.16 //y2=1.09
cc_1006 ( N_CLK_c_1216_p N_noxref_16_M4_noxref_d ) capacitor c=0.00220746f \
 //x=7.455 //y=0.935 //x2=7.16 //y2=1.09
cc_1007 ( N_CLK_c_1223_p N_noxref_16_M4_noxref_d ) capacitor c=0.00194798f \
 //x=7.455 //y=1.555 //x2=7.16 //y2=1.09
cc_1008 ( N_CLK_c_1095_n N_noxref_16_M4_noxref_d ) capacitor c=0.00198465f \
 //x=7.61 //y=1.09 //x2=7.16 //y2=1.09
cc_1009 ( N_CLK_c_1096_n N_noxref_16_M4_noxref_d ) capacitor c=0.00128384f \
 //x=7.61 //y=1.4 //x2=7.16 //y2=1.09
cc_1010 ( N_CLK_c_1095_n N_noxref_16_M5_noxref_s ) capacitor c=7.21316e-19 \
 //x=7.61 //y=1.09 //x2=8.265 //y2=0.555
cc_1011 ( N_CLK_c_1096_n N_noxref_16_M5_noxref_s ) capacitor c=0.00348171f \
 //x=7.61 //y=1.4 //x2=8.265 //y2=0.555
cc_1012 ( N_CLK_c_1061_n N_noxref_17_c_2958_n ) capacitor c=0.00263604f \
 //x=17.025 //y=3.51 //x2=11.585 //y2=1.77
cc_1013 ( N_CLK_c_1061_n N_noxref_17_c_2988_n ) capacitor c=0.00504206f \
 //x=17.025 //y=3.51 //x2=12.555 //y2=1.77
cc_1014 ( N_CLK_c_1061_n N_noxref_17_M6_noxref_s ) capacitor c=0.00243521f \
 //x=17.025 //y=3.51 //x2=10.565 //y2=0.555
cc_1015 ( N_CLK_c_1117_n N_noxref_19_c_3072_n ) capacitor c=0.0167228f \
 //x=16.705 //y=1.09 //x2=17.365 //y2=0.72
cc_1016 ( N_CLK_c_1122_n N_noxref_19_c_3072_n ) capacitor c=0.00534519f \
 //x=17.23 //y=1.09 //x2=17.365 //y2=0.72
cc_1017 ( N_CLK_c_1063_n N_noxref_19_c_3095_n ) capacitor c=0.012061f \
 //x=17.14 //y=2.26 //x2=17.365 //y2=1.77
cc_1018 ( N_CLK_c_1120_n N_noxref_19_c_3095_n ) capacitor c=0.0153476f \
 //x=16.705 //y=1.4 //x2=17.365 //y2=1.77
cc_1019 ( N_CLK_c_1125_n N_noxref_19_c_3095_n ) capacitor c=0.0219329f \
 //x=17.23 //y=2.095 //x2=17.365 //y2=1.77
cc_1020 ( N_CLK_c_1117_n N_noxref_19_M9_noxref_s ) capacitor c=0.00798959f \
 //x=16.705 //y=1.09 //x2=15.375 //y2=0.555
cc_1021 ( N_CLK_c_1124_n N_noxref_19_M9_noxref_s ) capacitor c=0.00212176f \
 //x=17.23 //y=1.63 //x2=15.375 //y2=0.555
cc_1022 ( N_CLK_c_1125_n N_noxref_19_M9_noxref_s ) capacitor c=0.00298115f \
 //x=17.23 //y=2.095 //x2=15.375 //y2=0.555
cc_1023 ( N_CLK_c_1239_p N_noxref_20_c_3115_n ) capacitor c=2.14837e-19 \
 //x=17.075 //y=0.935 //x2=17.935 //y2=1.175
cc_1024 ( N_CLK_c_1122_n N_noxref_20_c_3115_n ) capacitor c=0.00123426f \
 //x=17.23 //y=1.09 //x2=17.935 //y2=1.175
cc_1025 ( N_CLK_c_1123_n N_noxref_20_c_3115_n ) capacitor c=0.0129288f \
 //x=17.23 //y=1.4 //x2=17.935 //y2=1.175
cc_1026 ( N_CLK_c_1124_n N_noxref_20_c_3115_n ) capacitor c=0.00142359f \
 //x=17.23 //y=1.63 //x2=17.935 //y2=1.175
cc_1027 ( N_CLK_c_1117_n N_noxref_20_M10_noxref_d ) capacitor c=0.00223875f \
 //x=16.705 //y=1.09 //x2=16.78 //y2=1.09
cc_1028 ( N_CLK_c_1120_n N_noxref_20_M10_noxref_d ) capacitor c=0.00262485f \
 //x=16.705 //y=1.4 //x2=16.78 //y2=1.09
cc_1029 ( N_CLK_c_1239_p N_noxref_20_M10_noxref_d ) capacitor c=0.00220746f \
 //x=17.075 //y=0.935 //x2=16.78 //y2=1.09
cc_1030 ( N_CLK_c_1246_p N_noxref_20_M10_noxref_d ) capacitor c=0.00194798f \
 //x=17.075 //y=1.555 //x2=16.78 //y2=1.09
cc_1031 ( N_CLK_c_1122_n N_noxref_20_M10_noxref_d ) capacitor c=0.00198465f \
 //x=17.23 //y=1.09 //x2=16.78 //y2=1.09
cc_1032 ( N_CLK_c_1123_n N_noxref_20_M10_noxref_d ) capacitor c=0.00128384f \
 //x=17.23 //y=1.4 //x2=16.78 //y2=1.09
cc_1033 ( N_CLK_c_1122_n N_noxref_20_M11_noxref_s ) capacitor c=7.21316e-19 \
 //x=17.23 //y=1.09 //x2=17.885 //y2=0.555
cc_1034 ( N_CLK_c_1123_n N_noxref_20_M11_noxref_s ) capacitor c=0.00348171f \
 //x=17.23 //y=1.4 //x2=17.885 //y2=0.555
cc_1035 ( N_noxref_6_c_1251_n N_RN_c_1511_n ) capacitor c=0.199363f //x=9.255 \
 //y=3.88 //x2=18.135 //y2=4.62
cc_1036 ( N_noxref_6_c_1252_n N_RN_c_1511_n ) capacitor c=0.0134983f //x=3.935 \
 //y=3.88 //x2=18.135 //y2=4.62
cc_1037 ( N_noxref_6_c_1253_n N_RN_c_1511_n ) capacitor c=0.0638008f \
 //x=20.725 //y=3.88 //x2=18.135 //y2=4.62
cc_1038 ( N_noxref_6_c_1323_n N_RN_c_1511_n ) capacitor c=4.78746e-19 \
 //x=9.485 //y=3.88 //x2=18.135 //y2=4.62
cc_1039 ( N_noxref_6_c_1254_n N_RN_c_1511_n ) capacitor c=0.0226638f //x=3.82 \
 //y=2.26 //x2=18.135 //y2=4.62
cc_1040 ( N_noxref_6_c_1270_n N_RN_c_1511_n ) capacitor c=0.032089f //x=7.625 \
 //y=5.335 //x2=18.135 //y2=4.62
cc_1041 ( N_noxref_6_c_1274_n N_RN_c_1511_n ) capacitor c=0.0230136f //x=6.915 \
 //y=5.335 //x2=18.135 //y2=4.62
cc_1042 ( N_noxref_6_c_1280_n N_RN_c_1511_n ) capacitor c=0.0183122f //x=9.285 \
 //y=5.335 //x2=18.135 //y2=4.62
cc_1043 ( N_noxref_6_c_1284_n N_RN_c_1511_n ) capacitor c=0.0210274f //x=9.37 \
 //y=3.88 //x2=18.135 //y2=4.62
cc_1044 ( N_noxref_6_c_1352_n N_RN_c_1511_n ) capacitor c=0.00988777f //x=3.82 \
 //y=4.88 //x2=18.135 //y2=4.62
cc_1045 ( N_noxref_6_c_1254_n N_RN_c_1512_n ) capacitor c=0.00153281f //x=3.82 \
 //y=2.26 //x2=2.825 //y2=4.62
cc_1046 ( N_noxref_6_c_1253_n N_RN_c_1533_n ) capacitor c=0.0157795f \
 //x=20.725 //y=3.88 //x2=21.835 //y2=4.62
cc_1047 ( N_noxref_6_c_1256_n N_RN_c_1533_n ) capacitor c=0.0218124f //x=20.84 \
 //y=2.26 //x2=21.835 //y2=4.62
cc_1048 ( N_noxref_6_c_1296_n N_RN_c_1533_n ) capacitor c=0.0168397f \
 //x=21.115 //y=4.97 //x2=21.835 //y2=4.62
cc_1049 ( N_noxref_6_c_1253_n N_RN_c_1539_n ) capacitor c=4.66937e-19 \
 //x=20.725 //y=3.88 //x2=18.365 //y2=4.62
cc_1050 ( N_noxref_6_c_1252_n N_RN_c_1513_n ) capacitor c=0.00526349f \
 //x=3.935 //y=3.88 //x2=2.71 //y2=2.26
cc_1051 ( N_noxref_6_c_1254_n N_RN_c_1513_n ) capacitor c=0.0535967f //x=3.82 \
 //y=2.26 //x2=2.71 //y2=2.26
cc_1052 ( N_noxref_6_c_1349_n N_RN_c_1513_n ) capacitor c=0.00228632f //x=3.82 \
 //y=2.26 //x2=2.71 //y2=2.26
cc_1053 ( N_noxref_6_c_1352_n N_RN_c_1513_n ) capacitor c=0.00218014f //x=3.82 \
 //y=4.88 //x2=2.71 //y2=2.26
cc_1054 ( N_noxref_6_c_1253_n N_RN_c_1514_n ) capacitor c=0.0218601f \
 //x=20.725 //y=3.88 //x2=18.25 //y2=2.26
cc_1055 ( N_noxref_6_c_1256_n N_RN_c_1514_n ) capacitor c=8.87185e-19 \
 //x=20.84 //y=2.26 //x2=18.25 //y2=2.26
cc_1056 ( N_noxref_6_c_1253_n N_RN_c_1515_n ) capacitor c=0.0027353f \
 //x=20.725 //y=3.88 //x2=21.95 //y2=2.26
cc_1057 ( N_noxref_6_c_1256_n N_RN_c_1515_n ) capacitor c=0.049364f //x=20.84 \
 //y=2.26 //x2=21.95 //y2=2.26
cc_1058 ( N_noxref_6_c_1261_n N_RN_c_1515_n ) capacitor c=0.00238338f \
 //x=20.54 //y=2.095 //x2=21.95 //y2=2.26
cc_1059 ( N_noxref_6_c_1400_p N_RN_c_1515_n ) capacitor c=0.00147352f \
 //x=21.405 //y=4.97 //x2=21.95 //y2=2.26
cc_1060 ( N_noxref_6_c_1296_n N_RN_c_1515_n ) capacitor c=0.00141297f \
 //x=21.115 //y=4.97 //x2=21.95 //y2=2.26
cc_1061 ( N_noxref_6_M22_noxref_g N_RN_M20_noxref_g ) capacitor c=0.0101598f \
 //x=3.56 //y=6.2 //x2=2.68 //y2=6.2
cc_1062 ( N_noxref_6_M22_noxref_g N_RN_M21_noxref_g ) capacitor c=0.0602553f \
 //x=3.56 //y=6.2 //x2=3.12 //y2=6.2
cc_1063 ( N_noxref_6_M23_noxref_g N_RN_M21_noxref_g ) capacitor c=0.0101598f \
 //x=4 //y=6.2 //x2=3.12 //y2=6.2
cc_1064 ( N_noxref_6_M42_noxref_g N_RN_M44_noxref_g ) capacitor c=0.0105869f \
 //x=21.04 //y=6.2 //x2=21.92 //y2=6.2
cc_1065 ( N_noxref_6_M43_noxref_g N_RN_M44_noxref_g ) capacitor c=0.10632f \
 //x=21.48 //y=6.2 //x2=21.92 //y2=6.2
cc_1066 ( N_noxref_6_M43_noxref_g N_RN_M45_noxref_g ) capacitor c=0.0101598f \
 //x=21.48 //y=6.2 //x2=22.36 //y2=6.2
cc_1067 ( N_noxref_6_c_1340_n N_RN_c_1641_n ) capacitor c=0.00456962f //x=3.81 \
 //y=1.095 //x2=2.8 //y2=1.09
cc_1068 ( N_noxref_6_c_1341_n N_RN_c_1642_n ) capacitor c=0.00438372f //x=3.81 \
 //y=1.44 //x2=2.8 //y2=1.4
cc_1069 ( N_noxref_6_c_1342_n N_RN_c_1643_n ) capacitor c=0.00438372f //x=3.81 \
 //y=1.75 //x2=2.8 //y2=1.63
cc_1070 ( N_noxref_6_c_1254_n N_RN_c_1644_n ) capacitor c=0.0023343f //x=3.82 \
 //y=2.26 //x2=2.8 //y2=2.095
cc_1071 ( N_noxref_6_c_1349_n N_RN_c_1644_n ) capacitor c=0.00933826f //x=3.82 \
 //y=2.26 //x2=2.8 //y2=2.095
cc_1072 ( N_noxref_6_c_1350_n N_RN_c_1644_n ) capacitor c=0.00438372f //x=3.82 \
 //y=2.095 //x2=2.8 //y2=2.095
cc_1073 ( N_noxref_6_c_1352_n N_RN_c_1575_n ) capacitor c=0.0611812f //x=3.82 \
 //y=4.88 //x2=3.045 //y2=4.97
cc_1074 ( N_noxref_6_c_1257_n N_RN_c_1648_n ) capacitor c=5.72482e-19 \
 //x=20.54 //y=1.055 //x2=21.515 //y2=1.09
cc_1075 ( N_noxref_6_c_1259_n N_RN_c_1648_n ) capacitor c=0.00149976f \
 //x=20.54 //y=1.4 //x2=21.515 //y2=1.09
cc_1076 ( N_noxref_6_c_1264_n N_RN_c_1648_n ) capacitor c=0.0160123f //x=21.07 \
 //y=1.055 //x2=21.515 //y2=1.09
cc_1077 ( N_noxref_6_c_1260_n N_RN_c_1651_n ) capacitor c=0.00111227f \
 //x=20.54 //y=1.71 //x2=21.515 //y2=1.4
cc_1078 ( N_noxref_6_c_1266_n N_RN_c_1651_n ) capacitor c=0.0124075f //x=21.07 \
 //y=1.4 //x2=21.515 //y2=1.4
cc_1079 ( N_noxref_6_c_1264_n N_RN_c_1653_n ) capacitor c=0.00103227f \
 //x=21.07 //y=1.055 //x2=22.04 //y2=1.09
cc_1080 ( N_noxref_6_c_1266_n N_RN_c_1654_n ) capacitor c=0.0010154f //x=21.07 \
 //y=1.4 //x2=22.04 //y2=1.4
cc_1081 ( N_noxref_6_c_1266_n N_RN_c_1655_n ) capacitor c=9.23422e-19 \
 //x=21.07 //y=1.4 //x2=22.04 //y2=1.63
cc_1082 ( N_noxref_6_c_1256_n N_RN_c_1656_n ) capacitor c=0.00231304f \
 //x=20.84 //y=2.26 //x2=22.04 //y2=2.095
cc_1083 ( N_noxref_6_c_1261_n N_RN_c_1656_n ) capacitor c=0.00964411f \
 //x=20.54 //y=2.095 //x2=22.04 //y2=2.095
cc_1084 ( N_noxref_6_c_1254_n N_RN_c_1576_n ) capacitor c=0.00142741f //x=3.82 \
 //y=2.26 //x2=2.71 //y2=4.88
cc_1085 ( N_noxref_6_c_1352_n N_RN_c_1576_n ) capacitor c=0.00487508f //x=3.82 \
 //y=4.88 //x2=2.71 //y2=4.88
cc_1086 ( N_noxref_6_c_1256_n N_RN_c_1660_n ) capacitor c=0.00183762f \
 //x=20.84 //y=2.26 //x2=21.95 //y2=4.88
cc_1087 ( N_noxref_6_c_1400_p N_RN_c_1660_n ) capacitor c=0.0168581f \
 //x=21.405 //y=4.97 //x2=21.95 //y2=4.88
cc_1088 ( N_noxref_6_c_1296_n N_RN_c_1660_n ) capacitor c=0.00484466f \
 //x=21.115 //y=4.97 //x2=21.95 //y2=4.88
cc_1089 ( N_noxref_6_M43_noxref_g N_QN_c_1835_n ) capacitor c=0.0168349f \
 //x=21.48 //y=6.2 //x2=22.055 //y2=5.335
cc_1090 ( N_noxref_6_M42_noxref_g N_QN_c_1839_n ) capacitor c=0.0213876f \
 //x=21.04 //y=6.2 //x2=21.345 //y2=5.335
cc_1091 ( N_noxref_6_c_1400_p N_QN_c_1839_n ) capacitor c=0.00428486f \
 //x=21.405 //y=4.97 //x2=21.345 //y2=5.335
cc_1092 ( N_noxref_6_M43_noxref_g N_QN_M42_noxref_d ) capacitor c=0.0180032f \
 //x=21.48 //y=6.2 //x2=21.115 //y2=5.2
cc_1093 ( N_noxref_6_c_1253_n N_SN_c_1977_n ) capacitor c=0.123442f //x=20.725 \
 //y=3.88 //x2=12.33 //y2=2.775
cc_1094 ( N_noxref_6_c_1256_n N_SN_c_1977_n ) capacitor c=0.0263038f //x=20.84 \
 //y=2.26 //x2=12.33 //y2=2.775
cc_1095 ( N_noxref_6_c_1261_n N_SN_c_1977_n ) capacitor c=0.00537379f \
 //x=20.54 //y=2.095 //x2=12.33 //y2=2.775
cc_1096 ( N_noxref_6_c_1253_n N_SN_c_1987_n ) capacitor c=0.0190398f \
 //x=20.725 //y=3.88 //x2=12.33 //y2=2.26
cc_1097 ( N_noxref_6_c_1284_n N_SN_c_1987_n ) capacitor c=5.91559e-19 //x=9.37 \
 //y=3.88 //x2=12.33 //y2=2.26
cc_1098 ( N_noxref_6_c_1251_n N_noxref_10_c_2206_n ) capacitor c=0.0450244f \
 //x=9.255 //y=3.88 //x2=13.325 //y2=4.25
cc_1099 ( N_noxref_6_c_1253_n N_noxref_10_c_2206_n ) capacitor c=0.339801f \
 //x=20.725 //y=3.88 //x2=13.325 //y2=4.25
cc_1100 ( N_noxref_6_c_1323_n N_noxref_10_c_2206_n ) capacitor c=0.026809f \
 //x=9.485 //y=3.88 //x2=13.325 //y2=4.25
cc_1101 ( N_noxref_6_c_1284_n N_noxref_10_c_2206_n ) capacitor c=0.0200135f \
 //x=9.37 //y=3.88 //x2=13.325 //y2=4.25
cc_1102 ( N_noxref_6_c_1251_n N_noxref_10_c_2300_n ) capacitor c=0.0295035f \
 //x=9.255 //y=3.88 //x2=8.74 //y2=4.25
cc_1103 ( N_noxref_6_c_1284_n N_noxref_10_c_2300_n ) capacitor c=0.00178442f \
 //x=9.37 //y=3.88 //x2=8.74 //y2=4.25
cc_1104 ( N_noxref_6_c_1253_n N_noxref_10_c_2207_n ) capacitor c=0.468089f \
 //x=20.725 //y=3.88 //x2=18.875 //y2=4.25
cc_1105 ( N_noxref_6_c_1253_n N_noxref_10_c_2270_n ) capacitor c=0.0268959f \
 //x=20.725 //y=3.88 //x2=13.555 //y2=4.25
cc_1106 ( N_noxref_6_c_1253_n N_noxref_10_c_2208_n ) capacitor c=0.176507f \
 //x=20.725 //y=3.88 //x2=27.755 //y2=4.25
cc_1107 ( N_noxref_6_c_1256_n N_noxref_10_c_2208_n ) capacitor c=0.0213324f \
 //x=20.84 //y=2.26 //x2=27.755 //y2=4.25
cc_1108 ( N_noxref_6_c_1253_n N_noxref_10_c_2215_n ) capacitor c=0.0268461f \
 //x=20.725 //y=3.88 //x2=19.105 //y2=4.25
cc_1109 ( N_noxref_6_c_1256_n N_noxref_10_c_2215_n ) capacitor c=3.50683e-19 \
 //x=20.84 //y=2.26 //x2=19.105 //y2=4.25
cc_1110 ( N_noxref_6_c_1251_n N_noxref_10_c_2201_n ) capacitor c=0.0177645f \
 //x=9.255 //y=3.88 //x2=8.63 //y2=2.26
cc_1111 ( N_noxref_6_c_1323_n N_noxref_10_c_2201_n ) capacitor c=0.00179385f \
 //x=9.485 //y=3.88 //x2=8.63 //y2=2.26
cc_1112 ( N_noxref_6_c_1284_n N_noxref_10_c_2201_n ) capacitor c=0.0794709f \
 //x=9.37 //y=3.88 //x2=8.63 //y2=2.26
cc_1113 ( N_noxref_6_c_1454_p N_noxref_10_c_2309_n ) capacitor c=0.0166016f \
 //x=8.59 //y=5.335 //x2=8.63 //y2=4.88
cc_1114 ( N_noxref_6_c_1253_n N_noxref_10_c_2202_n ) capacitor c=0.019837f \
 //x=20.725 //y=3.88 //x2=13.44 //y2=2.26
cc_1115 ( N_noxref_6_c_1253_n N_noxref_10_c_2231_n ) capacitor c=0.0251381f \
 //x=20.725 //y=3.88 //x2=18.99 //y2=4.25
cc_1116 ( N_noxref_6_c_1256_n N_noxref_10_c_2231_n ) capacitor c=0.0142589f \
 //x=20.84 //y=2.26 //x2=18.99 //y2=4.25
cc_1117 ( N_noxref_6_c_1251_n N_noxref_10_c_2233_n ) capacitor c=0.00221254f \
 //x=9.255 //y=3.88 //x2=8.625 //y2=4.25
cc_1118 ( N_noxref_6_c_1284_n N_noxref_10_c_2233_n ) capacitor c=3.94811e-19 \
 //x=9.37 //y=3.88 //x2=8.625 //y2=4.25
cc_1119 ( N_noxref_6_c_1454_p N_noxref_10_c_2233_n ) capacitor c=2.67208e-19 \
 //x=8.59 //y=5.335 //x2=8.625 //y2=4.25
cc_1120 ( N_noxref_6_c_1276_n N_noxref_10_M28_noxref_g ) capacitor c=0.01736f \
 //x=8.505 //y=5.335 //x2=8.37 //y2=6.2
cc_1121 ( N_noxref_6_M28_noxref_d N_noxref_10_M28_noxref_g ) capacitor \
 c=0.0180032f //x=8.445 //y=5.2 //x2=8.37 //y2=6.2
cc_1122 ( N_noxref_6_c_1280_n N_noxref_10_M29_noxref_g ) capacitor \
 c=0.0194981f //x=9.285 //y=5.335 //x2=8.81 //y2=6.2
cc_1123 ( N_noxref_6_M28_noxref_d N_noxref_10_M29_noxref_g ) capacitor \
 c=0.0194246f //x=8.445 //y=5.2 //x2=8.81 //y2=6.2
cc_1124 ( N_noxref_6_M5_noxref_d N_noxref_10_c_2322_n ) capacitor \
 c=0.00217566f //x=8.695 //y=1.095 //x2=8.62 //y2=1.095
cc_1125 ( N_noxref_6_M5_noxref_d N_noxref_10_c_2323_n ) capacitor c=0.0034598f \
 //x=8.695 //y=1.095 //x2=8.62 //y2=1.44
cc_1126 ( N_noxref_6_M5_noxref_d N_noxref_10_c_2324_n ) capacitor \
 c=0.00544291f //x=8.695 //y=1.095 //x2=8.62 //y2=1.75
cc_1127 ( N_noxref_6_M5_noxref_d N_noxref_10_c_2362_n ) capacitor \
 c=0.00241102f //x=8.695 //y=1.095 //x2=8.995 //y2=0.94
cc_1128 ( N_noxref_6_c_1255_n N_noxref_10_c_2363_n ) capacitor c=0.00359704f \
 //x=9.285 //y=1.845 //x2=8.995 //y2=1.595
cc_1129 ( N_noxref_6_M5_noxref_d N_noxref_10_c_2363_n ) capacitor c=0.0140297f \
 //x=8.695 //y=1.095 //x2=8.995 //y2=1.595
cc_1130 ( N_noxref_6_M5_noxref_d N_noxref_10_c_2365_n ) capacitor \
 c=0.00219619f //x=8.695 //y=1.095 //x2=9.15 //y2=1.095
cc_1131 ( N_noxref_6_c_1255_n N_noxref_10_c_2366_n ) capacitor c=0.00457401f \
 //x=9.285 //y=1.845 //x2=9.15 //y2=1.44
cc_1132 ( N_noxref_6_M5_noxref_d N_noxref_10_c_2366_n ) capacitor \
 c=0.00603828f //x=8.695 //y=1.095 //x2=9.15 //y2=1.44
cc_1133 ( N_noxref_6_c_1284_n N_noxref_10_c_2267_n ) capacitor c=0.00877984f \
 //x=9.37 //y=3.88 //x2=8.63 //y2=2.26
cc_1134 ( N_noxref_6_c_1284_n N_noxref_10_c_2327_n ) capacitor c=0.00283672f \
 //x=9.37 //y=3.88 //x2=8.63 //y2=2.095
cc_1135 ( N_noxref_6_M5_noxref_d N_noxref_10_c_2327_n ) capacitor \
 c=0.00661782f //x=8.695 //y=1.095 //x2=8.63 //y2=2.095
cc_1136 ( N_noxref_6_c_1280_n N_noxref_10_c_2328_n ) capacitor c=0.00201851f \
 //x=9.285 //y=5.335 //x2=8.63 //y2=4.88
cc_1137 ( N_noxref_6_c_1284_n N_noxref_10_c_2328_n ) capacitor c=0.013844f \
 //x=9.37 //y=3.88 //x2=8.63 //y2=4.88
cc_1138 ( N_noxref_6_c_1454_p N_noxref_10_c_2328_n ) capacitor c=0.0046827f \
 //x=8.59 //y=5.335 //x2=8.63 //y2=4.88
cc_1139 ( N_noxref_6_c_1253_n N_noxref_11_c_2579_n ) capacitor c=0.00740361f \
 //x=20.725 //y=3.88 //x2=23.175 //y2=3.88
cc_1140 ( N_noxref_6_c_1256_n N_noxref_11_c_2541_n ) capacitor c=0.00135527f \
 //x=20.84 //y=2.26 //x2=23.06 //y2=2.26
cc_1141 ( N_noxref_6_c_1254_n N_D_c_2697_n ) capacitor c=0.00181863f //x=3.82 \
 //y=2.26 //x2=1.6 //y2=2.26
cc_1142 ( N_noxref_6_c_1254_n N_noxref_14_c_2805_n ) capacitor c=0.00209081f \
 //x=3.82 //y=2.26 //x2=4.475 //y2=0.72
cc_1143 ( N_noxref_6_c_1340_n N_noxref_14_c_2805_n ) capacitor c=0.0194423f \
 //x=3.81 //y=1.095 //x2=4.475 //y2=0.72
cc_1144 ( N_noxref_6_c_1346_n N_noxref_14_c_2805_n ) capacitor c=0.00656458f \
 //x=4.34 //y=1.095 //x2=4.475 //y2=0.72
cc_1145 ( N_noxref_6_c_1349_n N_noxref_14_c_2805_n ) capacitor c=2.20712e-19 \
 //x=3.82 //y=2.26 //x2=4.475 //y2=0.72
cc_1146 ( N_noxref_6_c_1341_n N_noxref_14_c_2816_n ) capacitor c=0.00538829f \
 //x=3.81 //y=1.44 //x2=3.59 //y2=1.175
cc_1147 ( N_noxref_6_c_1340_n N_noxref_14_M2_noxref_s ) capacitor \
 c=0.00538829f //x=3.81 //y=1.095 //x2=3.455 //y2=0.555
cc_1148 ( N_noxref_6_c_1342_n N_noxref_14_M2_noxref_s ) capacitor \
 c=0.00538829f //x=3.81 //y=1.75 //x2=3.455 //y2=0.555
cc_1149 ( N_noxref_6_c_1346_n N_noxref_14_M2_noxref_s ) capacitor c=0.0143002f \
 //x=4.34 //y=1.095 //x2=3.455 //y2=0.555
cc_1150 ( N_noxref_6_c_1347_n N_noxref_14_M2_noxref_s ) capacitor \
 c=0.00290153f //x=4.34 //y=1.44 //x2=3.455 //y2=0.555
cc_1151 ( N_noxref_6_M5_noxref_d N_noxref_15_M3_noxref_s ) capacitor \
 c=0.00309936f //x=8.695 //y=1.095 //x2=5.755 //y2=0.555
cc_1152 ( N_noxref_6_c_1255_n N_noxref_16_c_2910_n ) capacitor c=0.00464321f \
 //x=9.285 //y=1.845 //x2=9.285 //y2=0.72
cc_1153 ( N_noxref_6_M5_noxref_d N_noxref_16_c_2910_n ) capacitor c=0.0117414f \
 //x=8.695 //y=1.095 //x2=9.285 //y2=0.72
cc_1154 ( N_noxref_6_c_1333_n N_noxref_16_c_2936_n ) capacitor c=0.0200405f \
 //x=8.97 //y=1.845 //x2=8.4 //y2=1.175
cc_1155 ( N_noxref_6_M5_noxref_d N_noxref_16_M4_noxref_d ) capacitor \
 c=5.27807e-19 //x=8.695 //y=1.095 //x2=7.16 //y2=1.09
cc_1156 ( N_noxref_6_c_1255_n N_noxref_16_M5_noxref_s ) capacitor c=0.0205309f \
 //x=9.285 //y=1.845 //x2=8.265 //y2=0.555
cc_1157 ( N_noxref_6_M5_noxref_d N_noxref_16_M5_noxref_s ) capacitor \
 c=0.0426368f //x=8.695 //y=1.095 //x2=8.265 //y2=0.555
cc_1158 ( N_noxref_6_c_1255_n N_noxref_17_c_2974_n ) capacitor c=3.84569e-19 \
 //x=9.285 //y=1.845 //x2=10.7 //y2=1.685
cc_1159 ( N_noxref_6_M5_noxref_d N_noxref_17_M6_noxref_s ) capacitor \
 c=2.55333e-19 //x=8.695 //y=1.095 //x2=10.565 //y2=0.555
cc_1160 ( N_noxref_6_c_1261_n N_noxref_21_c_3185_n ) capacitor c=0.0034165f \
 //x=20.54 //y=2.095 //x2=20.32 //y2=1.685
cc_1161 ( N_noxref_6_c_1256_n N_noxref_21_c_3169_n ) capacitor c=0.0122624f \
 //x=20.84 //y=2.26 //x2=21.205 //y2=1.77
cc_1162 ( N_noxref_6_c_1260_n N_noxref_21_c_3169_n ) capacitor c=0.00703864f \
 //x=20.54 //y=1.71 //x2=21.205 //y2=1.77
cc_1163 ( N_noxref_6_c_1261_n N_noxref_21_c_3169_n ) capacitor c=0.0215834f \
 //x=20.54 //y=2.095 //x2=21.205 //y2=1.77
cc_1164 ( N_noxref_6_c_1263_n N_noxref_21_c_3169_n ) capacitor c=0.00708583f \
 //x=20.915 //y=1.555 //x2=21.205 //y2=1.77
cc_1165 ( N_noxref_6_c_1266_n N_noxref_21_c_3169_n ) capacitor c=0.00698822f \
 //x=21.07 //y=1.4 //x2=21.205 //y2=1.77
cc_1166 ( N_noxref_6_c_1257_n N_noxref_21_M12_noxref_s ) capacitor \
 c=0.0327271f //x=20.54 //y=1.055 //x2=20.185 //y2=0.555
cc_1167 ( N_noxref_6_c_1260_n N_noxref_21_M12_noxref_s ) capacitor \
 c=7.99997e-19 //x=20.54 //y=1.71 //x2=20.185 //y2=0.555
cc_1168 ( N_noxref_6_c_1261_n N_noxref_21_M12_noxref_s ) capacitor \
 c=0.00122123f //x=20.54 //y=2.095 //x2=20.185 //y2=0.555
cc_1169 ( N_noxref_6_c_1264_n N_noxref_21_M12_noxref_s ) capacitor \
 c=0.0121427f //x=21.07 //y=1.055 //x2=20.185 //y2=0.555
cc_1170 ( N_RN_c_1515_n QN ) capacitor c=0.00326636f //x=21.95 //y=2.26 \
 //x2=23.8 //y2=2.4
cc_1171 ( N_RN_c_1533_n N_QN_c_1835_n ) capacitor c=0.00241768f //x=21.835 \
 //y=4.62 //x2=22.055 //y2=5.335
cc_1172 ( N_RN_c_1515_n N_QN_c_1835_n ) capacitor c=0.014564f //x=21.95 \
 //y=2.26 //x2=22.055 //y2=5.335
cc_1173 ( N_RN_M44_noxref_g N_QN_c_1835_n ) capacitor c=0.016514f //x=21.92 \
 //y=6.2 //x2=22.055 //y2=5.335
cc_1174 ( N_RN_c_1660_n N_QN_c_1835_n ) capacitor c=0.00322046f //x=21.95 \
 //y=4.88 //x2=22.055 //y2=5.335
cc_1175 ( N_RN_c_1533_n N_QN_c_1839_n ) capacitor c=0.0219114f //x=21.835 \
 //y=4.62 //x2=21.345 //y2=5.335
cc_1176 ( N_RN_M45_noxref_g N_QN_c_1841_n ) capacitor c=0.0184045f //x=22.36 \
 //y=6.2 //x2=22.935 //y2=5.335
cc_1177 ( N_RN_c_1533_n N_QN_c_1884_n ) capacitor c=0.00101864f //x=21.835 \
 //y=4.62 //x2=22.14 //y2=5.335
cc_1178 ( N_RN_c_1671_p N_QN_c_1884_n ) capacitor c=0.00427771f //x=22.285 \
 //y=4.97 //x2=22.14 //y2=5.335
cc_1179 ( N_RN_M44_noxref_g N_QN_M44_noxref_d ) capacitor c=0.0180032f \
 //x=21.92 //y=6.2 //x2=21.995 //y2=5.2
cc_1180 ( N_RN_M45_noxref_g N_QN_M44_noxref_d ) capacitor c=0.0180032f \
 //x=22.36 //y=6.2 //x2=21.995 //y2=5.2
cc_1181 ( N_RN_c_1533_n N_SN_c_1977_n ) capacitor c=0.00602392f //x=21.835 \
 //y=4.62 //x2=12.33 //y2=2.775
cc_1182 ( N_RN_c_1514_n N_SN_c_1977_n ) capacitor c=0.0253613f //x=18.25 \
 //y=2.26 //x2=12.33 //y2=2.775
cc_1183 ( N_RN_c_1515_n N_SN_c_1977_n ) capacitor c=0.0273718f //x=21.95 \
 //y=2.26 //x2=12.33 //y2=2.775
cc_1184 ( N_RN_c_1656_n N_SN_c_1977_n ) capacitor c=0.00233308f //x=22.04 \
 //y=2.095 //x2=12.33 //y2=2.775
cc_1185 ( N_RN_c_1603_n N_SN_c_1977_n ) capacitor c=0.00232725f //x=18.25 \
 //y=2.26 //x2=12.33 //y2=2.775
cc_1186 ( N_RN_c_1511_n N_SN_c_1987_n ) capacitor c=0.0210462f //x=18.135 \
 //y=4.62 //x2=12.33 //y2=2.26
cc_1187 ( N_RN_c_1511_n N_SN_c_2035_n ) capacitor c=0.00862724f //x=18.135 \
 //y=4.62 //x2=12.665 //y2=4.97
cc_1188 ( N_RN_c_1511_n N_SN_c_2020_n ) capacitor c=0.00293313f //x=18.135 \
 //y=4.62 //x2=12.33 //y2=4.88
cc_1189 ( N_RN_c_1511_n N_noxref_10_c_2206_n ) capacitor c=0.398867f \
 //x=18.135 //y=4.62 //x2=13.325 //y2=4.25
cc_1190 ( N_RN_c_1511_n N_noxref_10_c_2300_n ) capacitor c=0.0291412f \
 //x=18.135 //y=4.62 //x2=8.74 //y2=4.25
cc_1191 ( N_RN_c_1511_n N_noxref_10_c_2207_n ) capacitor c=0.398418f \
 //x=18.135 //y=4.62 //x2=18.875 //y2=4.25
cc_1192 ( N_RN_c_1533_n N_noxref_10_c_2207_n ) capacitor c=0.0442407f \
 //x=21.835 //y=4.62 //x2=18.875 //y2=4.25
cc_1193 ( N_RN_c_1539_n N_noxref_10_c_2207_n ) capacitor c=0.0268623f \
 //x=18.365 //y=4.62 //x2=18.875 //y2=4.25
cc_1194 ( N_RN_c_1514_n N_noxref_10_c_2207_n ) capacitor c=0.0198123f \
 //x=18.25 //y=2.26 //x2=18.875 //y2=4.25
cc_1195 ( N_RN_c_1511_n N_noxref_10_c_2270_n ) capacitor c=0.0265199f \
 //x=18.135 //y=4.62 //x2=13.555 //y2=4.25
cc_1196 ( N_RN_c_1533_n N_noxref_10_c_2208_n ) capacitor c=0.268165f \
 //x=21.835 //y=4.62 //x2=27.755 //y2=4.25
cc_1197 ( N_RN_c_1515_n N_noxref_10_c_2208_n ) capacitor c=0.0256971f \
 //x=21.95 //y=2.26 //x2=27.755 //y2=4.25
cc_1198 ( N_RN_c_1671_p N_noxref_10_c_2208_n ) capacitor c=0.00483006f \
 //x=22.285 //y=4.97 //x2=27.755 //y2=4.25
cc_1199 ( N_RN_c_1533_n N_noxref_10_c_2215_n ) capacitor c=0.0265915f \
 //x=21.835 //y=4.62 //x2=19.105 //y2=4.25
cc_1200 ( N_RN_c_1514_n N_noxref_10_c_2215_n ) capacitor c=0.00179385f \
 //x=18.25 //y=2.26 //x2=19.105 //y2=4.25
cc_1201 ( N_RN_c_1511_n N_noxref_10_c_2309_n ) capacitor c=0.0197679f \
 //x=18.135 //y=4.62 //x2=8.63 //y2=4.88
cc_1202 ( N_RN_c_1511_n N_noxref_10_c_2202_n ) capacitor c=0.0218403f \
 //x=18.135 //y=4.62 //x2=13.44 //y2=2.26
cc_1203 ( N_RN_c_1511_n N_noxref_10_c_2217_n ) capacitor c=0.0311077f \
 //x=18.135 //y=4.62 //x2=17.245 //y2=5.335
cc_1204 ( N_RN_c_1511_n N_noxref_10_c_2221_n ) capacitor c=0.0230136f \
 //x=18.135 //y=4.62 //x2=16.535 //y2=5.335
cc_1205 ( N_RN_M40_noxref_g N_noxref_10_c_2223_n ) capacitor c=0.01736f \
 //x=17.99 //y=6.2 //x2=18.125 //y2=5.335
cc_1206 ( N_RN_c_1533_n N_noxref_10_c_2227_n ) capacitor c=0.0173131f \
 //x=21.835 //y=4.62 //x2=18.905 //y2=5.335
cc_1207 ( N_RN_c_1539_n N_noxref_10_c_2227_n ) capacitor c=0.00124956f \
 //x=18.365 //y=4.62 //x2=18.905 //y2=5.335
cc_1208 ( N_RN_M41_noxref_g N_noxref_10_c_2227_n ) capacitor c=0.0194918f \
 //x=18.43 //y=6.2 //x2=18.905 //y2=5.335
cc_1209 ( N_RN_c_1606_n N_noxref_10_c_2227_n ) capacitor c=0.00201851f \
 //x=18.25 //y=4.88 //x2=18.905 //y2=5.335
cc_1210 ( N_RN_c_1703_p N_noxref_10_c_2203_n ) capacitor c=0.00359704f \
 //x=18.615 //y=1.595 //x2=18.905 //y2=1.845
cc_1211 ( N_RN_c_1704_p N_noxref_10_c_2203_n ) capacitor c=0.00457401f \
 //x=18.77 //y=1.44 //x2=18.905 //y2=1.845
cc_1212 ( N_RN_c_1533_n N_noxref_10_c_2231_n ) capacitor c=0.022862f \
 //x=21.835 //y=4.62 //x2=18.99 //y2=4.25
cc_1213 ( N_RN_c_1539_n N_noxref_10_c_2231_n ) capacitor c=0.00118555f \
 //x=18.365 //y=4.62 //x2=18.99 //y2=4.25
cc_1214 ( N_RN_c_1514_n N_noxref_10_c_2231_n ) capacitor c=0.081883f //x=18.25 \
 //y=2.26 //x2=18.99 //y2=4.25
cc_1215 ( N_RN_c_1515_n N_noxref_10_c_2231_n ) capacitor c=7.03136e-19 \
 //x=21.95 //y=2.26 //x2=18.99 //y2=4.25
cc_1216 ( N_RN_c_1603_n N_noxref_10_c_2231_n ) capacitor c=0.00877984f \
 //x=18.25 //y=2.26 //x2=18.99 //y2=4.25
cc_1217 ( N_RN_c_1605_n N_noxref_10_c_2231_n ) capacitor c=0.00283672f \
 //x=18.25 //y=2.095 //x2=18.99 //y2=4.25
cc_1218 ( N_RN_c_1606_n N_noxref_10_c_2231_n ) capacitor c=0.013693f //x=18.25 \
 //y=4.88 //x2=18.99 //y2=4.25
cc_1219 ( N_RN_c_1511_n N_noxref_10_c_2233_n ) capacitor c=0.00215288f \
 //x=18.135 //y=4.62 //x2=8.625 //y2=4.25
cc_1220 ( N_RN_c_1539_n N_noxref_10_c_2405_n ) capacitor c=0.00125695f \
 //x=18.365 //y=4.62 //x2=18.21 //y2=5.335
cc_1221 ( N_RN_c_1514_n N_noxref_10_c_2405_n ) capacitor c=0.0165698f \
 //x=18.25 //y=2.26 //x2=18.21 //y2=5.335
cc_1222 ( N_RN_c_1606_n N_noxref_10_c_2405_n ) capacitor c=0.00475592f \
 //x=18.25 //y=4.88 //x2=18.21 //y2=5.335
cc_1223 ( N_RN_c_1511_n N_noxref_10_c_2328_n ) capacitor c=0.011194f \
 //x=18.135 //y=4.62 //x2=8.63 //y2=4.88
cc_1224 ( N_RN_c_1511_n N_noxref_10_c_2295_n ) capacitor c=0.0111881f \
 //x=18.135 //y=4.62 //x2=13.44 //y2=4.88
cc_1225 ( N_RN_c_1600_n N_noxref_10_M11_noxref_d ) capacitor c=0.00217566f \
 //x=18.24 //y=1.095 //x2=18.315 //y2=1.095
cc_1226 ( N_RN_c_1601_n N_noxref_10_M11_noxref_d ) capacitor c=0.0034598f \
 //x=18.24 //y=1.44 //x2=18.315 //y2=1.095
cc_1227 ( N_RN_c_1602_n N_noxref_10_M11_noxref_d ) capacitor c=0.00544291f \
 //x=18.24 //y=1.75 //x2=18.315 //y2=1.095
cc_1228 ( N_RN_c_1721_p N_noxref_10_M11_noxref_d ) capacitor c=0.00241102f \
 //x=18.615 //y=0.94 //x2=18.315 //y2=1.095
cc_1229 ( N_RN_c_1703_p N_noxref_10_M11_noxref_d ) capacitor c=0.0140297f \
 //x=18.615 //y=1.595 //x2=18.315 //y2=1.095
cc_1230 ( N_RN_c_1723_p N_noxref_10_M11_noxref_d ) capacitor c=0.00219619f \
 //x=18.77 //y=1.095 //x2=18.315 //y2=1.095
cc_1231 ( N_RN_c_1704_p N_noxref_10_M11_noxref_d ) capacitor c=0.00603828f \
 //x=18.77 //y=1.44 //x2=18.315 //y2=1.095
cc_1232 ( N_RN_c_1605_n N_noxref_10_M11_noxref_d ) capacitor c=0.00661782f \
 //x=18.25 //y=2.095 //x2=18.315 //y2=1.095
cc_1233 ( N_RN_M40_noxref_g N_noxref_10_M40_noxref_d ) capacitor c=0.0180032f \
 //x=17.99 //y=6.2 //x2=18.065 //y2=5.2
cc_1234 ( N_RN_M41_noxref_g N_noxref_10_M40_noxref_d ) capacitor c=0.0194246f \
 //x=18.43 //y=6.2 //x2=18.065 //y2=5.2
cc_1235 ( N_RN_c_1515_n N_noxref_11_c_2579_n ) capacitor c=0.0027353f \
 //x=21.95 //y=2.26 //x2=23.175 //y2=3.88
cc_1236 ( N_RN_c_1533_n N_noxref_11_c_2541_n ) capacitor c=0.00551083f \
 //x=21.835 //y=4.62 //x2=23.06 //y2=2.26
cc_1237 ( N_RN_c_1515_n N_noxref_11_c_2541_n ) capacitor c=0.0502572f \
 //x=21.95 //y=2.26 //x2=23.06 //y2=2.26
cc_1238 ( N_RN_c_1656_n N_noxref_11_c_2541_n ) capacitor c=0.0023343f \
 //x=22.04 //y=2.095 //x2=23.06 //y2=2.26
cc_1239 ( N_RN_c_1660_n N_noxref_11_c_2541_n ) capacitor c=0.00142741f \
 //x=21.95 //y=4.88 //x2=23.06 //y2=2.26
cc_1240 ( N_RN_M44_noxref_g N_noxref_11_M46_noxref_g ) capacitor c=0.0101598f \
 //x=21.92 //y=6.2 //x2=22.8 //y2=6.2
cc_1241 ( N_RN_M45_noxref_g N_noxref_11_M46_noxref_g ) capacitor c=0.0602553f \
 //x=22.36 //y=6.2 //x2=22.8 //y2=6.2
cc_1242 ( N_RN_M45_noxref_g N_noxref_11_M47_noxref_g ) capacitor c=0.0101598f \
 //x=22.36 //y=6.2 //x2=23.24 //y2=6.2
cc_1243 ( N_RN_c_1653_n N_noxref_11_c_2589_n ) capacitor c=0.00456962f \
 //x=22.04 //y=1.09 //x2=23.05 //y2=1.095
cc_1244 ( N_RN_c_1654_n N_noxref_11_c_2590_n ) capacitor c=0.00438372f \
 //x=22.04 //y=1.4 //x2=23.05 //y2=1.44
cc_1245 ( N_RN_c_1655_n N_noxref_11_c_2591_n ) capacitor c=0.00438372f \
 //x=22.04 //y=1.63 //x2=23.05 //y2=1.75
cc_1246 ( N_RN_c_1515_n N_noxref_11_c_2592_n ) capacitor c=0.00228632f \
 //x=21.95 //y=2.26 //x2=23.06 //y2=2.26
cc_1247 ( N_RN_c_1656_n N_noxref_11_c_2592_n ) capacitor c=0.00933826f \
 //x=22.04 //y=2.095 //x2=23.06 //y2=2.26
cc_1248 ( N_RN_c_1656_n N_noxref_11_c_2594_n ) capacitor c=0.00438372f \
 //x=22.04 //y=2.095 //x2=23.06 //y2=2.095
cc_1249 ( N_RN_c_1515_n N_noxref_11_c_2595_n ) capacitor c=0.00218014f \
 //x=21.95 //y=2.26 //x2=23.06 //y2=4.88
cc_1250 ( N_RN_c_1671_p N_noxref_11_c_2595_n ) capacitor c=0.0611812f \
 //x=22.285 //y=4.97 //x2=23.06 //y2=4.88
cc_1251 ( N_RN_c_1660_n N_noxref_11_c_2595_n ) capacitor c=0.00487508f \
 //x=21.95 //y=4.88 //x2=23.06 //y2=4.88
cc_1252 ( N_RN_c_1512_n N_D_c_2697_n ) capacitor c=0.00551083f //x=2.825 \
 //y=4.62 //x2=1.6 //y2=2.26
cc_1253 ( N_RN_c_1513_n N_D_c_2697_n ) capacitor c=0.0563464f //x=2.71 \
 //y=2.26 //x2=1.6 //y2=2.26
cc_1254 ( N_RN_c_1644_n N_D_c_2697_n ) capacitor c=0.00231304f //x=2.8 \
 //y=2.095 //x2=1.6 //y2=2.26
cc_1255 ( N_RN_c_1576_n N_D_c_2697_n ) capacitor c=0.00183762f //x=2.71 \
 //y=4.88 //x2=1.6 //y2=2.26
cc_1256 ( N_RN_M20_noxref_g N_D_M18_noxref_g ) capacitor c=0.0105869f //x=2.68 \
 //y=6.2 //x2=1.8 //y2=6.2
cc_1257 ( N_RN_M20_noxref_g N_D_M19_noxref_g ) capacitor c=0.10632f //x=2.68 \
 //y=6.2 //x2=2.24 //y2=6.2
cc_1258 ( N_RN_M21_noxref_g N_D_M19_noxref_g ) capacitor c=0.0101598f //x=3.12 \
 //y=6.2 //x2=2.24 //y2=6.2
cc_1259 ( N_RN_c_1752_p N_D_c_2698_n ) capacitor c=5.72482e-19 //x=2.275 \
 //y=1.09 //x2=1.3 //y2=1.055
cc_1260 ( N_RN_c_1752_p N_D_c_2700_n ) capacitor c=0.00149976f //x=2.275 \
 //y=1.09 //x2=1.3 //y2=1.4
cc_1261 ( N_RN_c_1754_p N_D_c_2701_n ) capacitor c=0.00111227f //x=2.275 \
 //y=1.4 //x2=1.3 //y2=1.71
cc_1262 ( N_RN_c_1513_n N_D_c_2702_n ) capacitor c=0.00238338f //x=2.71 \
 //y=2.26 //x2=1.3 //y2=2.095
cc_1263 ( N_RN_c_1644_n N_D_c_2702_n ) capacitor c=0.00964411f //x=2.8 \
 //y=2.095 //x2=1.3 //y2=2.095
cc_1264 ( N_RN_c_1752_p N_D_c_2705_n ) capacitor c=0.0160123f //x=2.275 \
 //y=1.09 //x2=1.83 //y2=1.055
cc_1265 ( N_RN_c_1641_n N_D_c_2705_n ) capacitor c=0.00103227f //x=2.8 \
 //y=1.09 //x2=1.83 //y2=1.055
cc_1266 ( N_RN_c_1754_p N_D_c_2707_n ) capacitor c=0.0124075f //x=2.275 \
 //y=1.4 //x2=1.83 //y2=1.4
cc_1267 ( N_RN_c_1642_n N_D_c_2707_n ) capacitor c=0.0010154f //x=2.8 //y=1.4 \
 //x2=1.83 //y2=1.4
cc_1268 ( N_RN_c_1643_n N_D_c_2707_n ) capacitor c=9.23422e-19 //x=2.8 \
 //y=1.63 //x2=1.83 //y2=1.4
cc_1269 ( N_RN_c_1513_n N_D_c_2720_n ) capacitor c=0.00147352f //x=2.71 \
 //y=2.26 //x2=2.165 //y2=4.97
cc_1270 ( N_RN_c_1576_n N_D_c_2720_n ) capacitor c=0.0168581f //x=2.71 \
 //y=4.88 //x2=2.165 //y2=4.97
cc_1271 ( N_RN_c_1513_n N_D_c_2715_n ) capacitor c=0.00141297f //x=2.71 \
 //y=2.26 //x2=1.875 //y2=4.97
cc_1272 ( N_RN_c_1576_n N_D_c_2715_n ) capacitor c=0.00484466f //x=2.71 \
 //y=4.88 //x2=1.875 //y2=4.97
cc_1273 ( N_RN_c_1752_p N_noxref_13_c_2760_n ) capacitor c=0.0167228f \
 //x=2.275 //y=1.09 //x2=2.935 //y2=0.72
cc_1274 ( N_RN_c_1641_n N_noxref_13_c_2760_n ) capacitor c=0.00534519f //x=2.8 \
 //y=1.09 //x2=2.935 //y2=0.72
cc_1275 ( N_RN_c_1511_n N_noxref_13_c_2772_n ) capacitor c=0.00136783f \
 //x=18.135 //y=4.62 //x2=2.935 //y2=1.77
cc_1276 ( N_RN_c_1512_n N_noxref_13_c_2772_n ) capacitor c=0.00102601f \
 //x=2.825 //y=4.62 //x2=2.935 //y2=1.77
cc_1277 ( N_RN_c_1513_n N_noxref_13_c_2772_n ) capacitor c=0.012374f //x=2.71 \
 //y=2.26 //x2=2.935 //y2=1.77
cc_1278 ( N_RN_c_1754_p N_noxref_13_c_2772_n ) capacitor c=0.0153476f \
 //x=2.275 //y=1.4 //x2=2.935 //y2=1.77
cc_1279 ( N_RN_c_1644_n N_noxref_13_c_2772_n ) capacitor c=0.0231679f //x=2.8 \
 //y=2.095 //x2=2.935 //y2=1.77
cc_1280 ( N_RN_c_1511_n N_noxref_13_M0_noxref_s ) capacitor c=9.40017e-19 \
 //x=18.135 //y=4.62 //x2=0.945 //y2=0.555
cc_1281 ( N_RN_c_1752_p N_noxref_13_M0_noxref_s ) capacitor c=0.00798959f \
 //x=2.275 //y=1.09 //x2=0.945 //y2=0.555
cc_1282 ( N_RN_c_1643_n N_noxref_13_M0_noxref_s ) capacitor c=0.00212176f \
 //x=2.8 //y=1.63 //x2=0.945 //y2=0.555
cc_1283 ( N_RN_c_1644_n N_noxref_13_M0_noxref_s ) capacitor c=0.00298115f \
 //x=2.8 //y=2.095 //x2=0.945 //y2=0.555
cc_1284 ( N_RN_c_1511_n N_noxref_14_c_2799_n ) capacitor c=0.00133627f \
 //x=18.135 //y=4.62 //x2=3.505 //y2=1.175
cc_1285 ( N_RN_c_1778_p N_noxref_14_c_2799_n ) capacitor c=2.14837e-19 \
 //x=2.645 //y=0.935 //x2=3.505 //y2=1.175
cc_1286 ( N_RN_c_1641_n N_noxref_14_c_2799_n ) capacitor c=0.00123426f //x=2.8 \
 //y=1.09 //x2=3.505 //y2=1.175
cc_1287 ( N_RN_c_1642_n N_noxref_14_c_2799_n ) capacitor c=0.0129288f //x=2.8 \
 //y=1.4 //x2=3.505 //y2=1.175
cc_1288 ( N_RN_c_1643_n N_noxref_14_c_2799_n ) capacitor c=0.00142359f //x=2.8 \
 //y=1.63 //x2=3.505 //y2=1.175
cc_1289 ( N_RN_c_1752_p N_noxref_14_M1_noxref_d ) capacitor c=0.00223875f \
 //x=2.275 //y=1.09 //x2=2.35 //y2=1.09
cc_1290 ( N_RN_c_1754_p N_noxref_14_M1_noxref_d ) capacitor c=0.00262485f \
 //x=2.275 //y=1.4 //x2=2.35 //y2=1.09
cc_1291 ( N_RN_c_1778_p N_noxref_14_M1_noxref_d ) capacitor c=0.00220746f \
 //x=2.645 //y=0.935 //x2=2.35 //y2=1.09
cc_1292 ( N_RN_c_1785_p N_noxref_14_M1_noxref_d ) capacitor c=0.00194798f \
 //x=2.645 //y=1.555 //x2=2.35 //y2=1.09
cc_1293 ( N_RN_c_1641_n N_noxref_14_M1_noxref_d ) capacitor c=0.00198465f \
 //x=2.8 //y=1.09 //x2=2.35 //y2=1.09
cc_1294 ( N_RN_c_1642_n N_noxref_14_M1_noxref_d ) capacitor c=0.00128384f \
 //x=2.8 //y=1.4 //x2=2.35 //y2=1.09
cc_1295 ( N_RN_c_1511_n N_noxref_14_M2_noxref_s ) capacitor c=9.61379e-19 \
 //x=18.135 //y=4.62 //x2=3.455 //y2=0.555
cc_1296 ( N_RN_c_1641_n N_noxref_14_M2_noxref_s ) capacitor c=7.21316e-19 \
 //x=2.8 //y=1.09 //x2=3.455 //y2=0.555
cc_1297 ( N_RN_c_1642_n N_noxref_14_M2_noxref_s ) capacitor c=0.00348171f \
 //x=2.8 //y=1.4 //x2=3.455 //y2=0.555
cc_1298 ( N_RN_c_1514_n N_noxref_20_c_3121_n ) capacitor c=0.0020642f \
 //x=18.25 //y=2.26 //x2=18.905 //y2=0.72
cc_1299 ( N_RN_c_1600_n N_noxref_20_c_3121_n ) capacitor c=0.0194423f \
 //x=18.24 //y=1.095 //x2=18.905 //y2=0.72
cc_1300 ( N_RN_c_1723_p N_noxref_20_c_3121_n ) capacitor c=0.00656458f \
 //x=18.77 //y=1.095 //x2=18.905 //y2=0.72
cc_1301 ( N_RN_c_1603_n N_noxref_20_c_3121_n ) capacitor c=2.20712e-19 \
 //x=18.25 //y=2.26 //x2=18.905 //y2=0.72
cc_1302 ( N_RN_c_1601_n N_noxref_20_c_3146_n ) capacitor c=0.00538829f \
 //x=18.24 //y=1.44 //x2=18.02 //y2=1.175
cc_1303 ( N_RN_c_1600_n N_noxref_20_M11_noxref_s ) capacitor c=0.00538829f \
 //x=18.24 //y=1.095 //x2=17.885 //y2=0.555
cc_1304 ( N_RN_c_1602_n N_noxref_20_M11_noxref_s ) capacitor c=0.00538829f \
 //x=18.24 //y=1.75 //x2=17.885 //y2=0.555
cc_1305 ( N_RN_c_1723_p N_noxref_20_M11_noxref_s ) capacitor c=0.0143002f \
 //x=18.77 //y=1.095 //x2=17.885 //y2=0.555
cc_1306 ( N_RN_c_1704_p N_noxref_20_M11_noxref_s ) capacitor c=0.00290153f \
 //x=18.77 //y=1.44 //x2=17.885 //y2=0.555
cc_1307 ( N_RN_c_1648_n N_noxref_21_c_3176_n ) capacitor c=0.0167228f \
 //x=21.515 //y=1.09 //x2=22.175 //y2=0.72
cc_1308 ( N_RN_c_1653_n N_noxref_21_c_3176_n ) capacitor c=0.00534519f \
 //x=22.04 //y=1.09 //x2=22.175 //y2=0.72
cc_1309 ( N_RN_c_1515_n N_noxref_21_c_3197_n ) capacitor c=0.012334f //x=21.95 \
 //y=2.26 //x2=22.175 //y2=1.77
cc_1310 ( N_RN_c_1651_n N_noxref_21_c_3197_n ) capacitor c=0.0153476f \
 //x=21.515 //y=1.4 //x2=22.175 //y2=1.77
cc_1311 ( N_RN_c_1656_n N_noxref_21_c_3197_n ) capacitor c=0.0219329f \
 //x=22.04 //y=2.095 //x2=22.175 //y2=1.77
cc_1312 ( N_RN_c_1648_n N_noxref_21_M12_noxref_s ) capacitor c=0.00798959f \
 //x=21.515 //y=1.09 //x2=20.185 //y2=0.555
cc_1313 ( N_RN_c_1655_n N_noxref_21_M12_noxref_s ) capacitor c=0.00212176f \
 //x=22.04 //y=1.63 //x2=20.185 //y2=0.555
cc_1314 ( N_RN_c_1656_n N_noxref_21_M12_noxref_s ) capacitor c=0.00298115f \
 //x=22.04 //y=2.095 //x2=20.185 //y2=0.555
cc_1315 ( N_RN_c_1808_p N_noxref_22_c_3219_n ) capacitor c=2.14837e-19 \
 //x=21.885 //y=0.935 //x2=22.745 //y2=1.175
cc_1316 ( N_RN_c_1653_n N_noxref_22_c_3219_n ) capacitor c=0.00123426f \
 //x=22.04 //y=1.09 //x2=22.745 //y2=1.175
cc_1317 ( N_RN_c_1654_n N_noxref_22_c_3219_n ) capacitor c=0.0129288f \
 //x=22.04 //y=1.4 //x2=22.745 //y2=1.175
cc_1318 ( N_RN_c_1655_n N_noxref_22_c_3219_n ) capacitor c=0.00142359f \
 //x=22.04 //y=1.63 //x2=22.745 //y2=1.175
cc_1319 ( N_RN_c_1648_n N_noxref_22_M13_noxref_d ) capacitor c=0.00223875f \
 //x=21.515 //y=1.09 //x2=21.59 //y2=1.09
cc_1320 ( N_RN_c_1651_n N_noxref_22_M13_noxref_d ) capacitor c=0.00262485f \
 //x=21.515 //y=1.4 //x2=21.59 //y2=1.09
cc_1321 ( N_RN_c_1808_p N_noxref_22_M13_noxref_d ) capacitor c=0.00220746f \
 //x=21.885 //y=0.935 //x2=21.59 //y2=1.09
cc_1322 ( N_RN_c_1815_p N_noxref_22_M13_noxref_d ) capacitor c=0.00194798f \
 //x=21.885 //y=1.555 //x2=21.59 //y2=1.09
cc_1323 ( N_RN_c_1653_n N_noxref_22_M13_noxref_d ) capacitor c=0.00198465f \
 //x=22.04 //y=1.09 //x2=21.59 //y2=1.09
cc_1324 ( N_RN_c_1654_n N_noxref_22_M13_noxref_d ) capacitor c=0.00128384f \
 //x=22.04 //y=1.4 //x2=21.59 //y2=1.09
cc_1325 ( N_RN_c_1653_n N_noxref_22_M14_noxref_s ) capacitor c=7.21316e-19 \
 //x=22.04 //y=1.09 //x2=22.695 //y2=0.555
cc_1326 ( N_RN_c_1654_n N_noxref_22_M14_noxref_s ) capacitor c=0.00348171f \
 //x=22.04 //y=1.4 //x2=22.695 //y2=0.555
cc_1327 ( N_QN_c_1820_n N_SN_c_1977_n ) capacitor c=0.0844361f //x=25.535 \
 //y=3.51 //x2=12.33 //y2=2.775
cc_1328 ( N_QN_c_1889_p N_SN_c_1977_n ) capacitor c=0.0133526f //x=23.915 \
 //y=3.51 //x2=12.33 //y2=2.775
cc_1329 ( QN N_SN_c_1977_n ) capacitor c=0.0236318f //x=23.8 //y=2.4 \
 //x2=12.33 //y2=2.775
cc_1330 ( N_QN_c_1891_p N_SN_c_1977_n ) capacitor c=0.0115788f //x=23.4 \
 //y=1.845 //x2=12.33 //y2=2.775
cc_1331 ( N_QN_c_1822_n N_SN_c_1977_n ) capacitor c=0.0262948f //x=25.65 \
 //y=2.26 //x2=12.33 //y2=2.775
cc_1332 ( N_QN_c_1827_n N_SN_c_1977_n ) capacitor c=0.00565297f //x=25.35 \
 //y=2.095 //x2=12.33 //y2=2.775
cc_1333 ( N_QN_c_1820_n N_SN_c_1988_n ) capacitor c=0.00520283f //x=25.535 \
 //y=3.51 //x2=26.76 //y2=2.26
cc_1334 ( QN N_SN_c_1988_n ) capacitor c=5.77178e-19 //x=23.8 //y=2.4 \
 //x2=26.76 //y2=2.26
cc_1335 ( N_QN_c_1822_n N_SN_c_1988_n ) capacitor c=0.0489575f //x=25.65 \
 //y=2.26 //x2=26.76 //y2=2.26
cc_1336 ( N_QN_c_1827_n N_SN_c_1988_n ) capacitor c=0.00238338f //x=25.35 \
 //y=2.095 //x2=26.76 //y2=2.26
cc_1337 ( N_QN_c_1898_p N_SN_c_1988_n ) capacitor c=0.00147352f //x=26.215 \
 //y=4.97 //x2=26.76 //y2=2.26
cc_1338 ( N_QN_c_1856_n N_SN_c_1988_n ) capacitor c=0.00142741f //x=25.925 \
 //y=4.97 //x2=26.76 //y2=2.26
cc_1339 ( N_QN_M48_noxref_g N_SN_M50_noxref_g ) capacitor c=0.0105869f \
 //x=25.85 //y=6.2 //x2=26.73 //y2=6.2
cc_1340 ( N_QN_M49_noxref_g N_SN_M50_noxref_g ) capacitor c=0.10632f //x=26.29 \
 //y=6.2 //x2=26.73 //y2=6.2
cc_1341 ( N_QN_M49_noxref_g N_SN_M51_noxref_g ) capacitor c=0.0101598f \
 //x=26.29 //y=6.2 //x2=27.17 //y2=6.2
cc_1342 ( N_QN_c_1823_n N_SN_c_2069_n ) capacitor c=5.72482e-19 //x=25.35 \
 //y=1.055 //x2=26.325 //y2=1.09
cc_1343 ( N_QN_c_1825_n N_SN_c_2069_n ) capacitor c=0.00149976f //x=25.35 \
 //y=1.4 //x2=26.325 //y2=1.09
cc_1344 ( N_QN_c_1830_n N_SN_c_2069_n ) capacitor c=0.0160123f //x=25.88 \
 //y=1.055 //x2=26.325 //y2=1.09
cc_1345 ( N_QN_c_1826_n N_SN_c_2072_n ) capacitor c=0.00111227f //x=25.35 \
 //y=1.71 //x2=26.325 //y2=1.4
cc_1346 ( N_QN_c_1832_n N_SN_c_2072_n ) capacitor c=0.0124075f //x=25.88 \
 //y=1.4 //x2=26.325 //y2=1.4
cc_1347 ( N_QN_c_1830_n N_SN_c_2074_n ) capacitor c=0.00103227f //x=25.88 \
 //y=1.055 //x2=26.85 //y2=1.09
cc_1348 ( N_QN_c_1832_n N_SN_c_2075_n ) capacitor c=0.0010154f //x=25.88 \
 //y=1.4 //x2=26.85 //y2=1.4
cc_1349 ( N_QN_c_1832_n N_SN_c_2076_n ) capacitor c=9.23422e-19 //x=25.88 \
 //y=1.4 //x2=26.85 //y2=1.63
cc_1350 ( N_QN_c_1822_n N_SN_c_2077_n ) capacitor c=0.00231304f //x=25.65 \
 //y=2.26 //x2=26.85 //y2=2.095
cc_1351 ( N_QN_c_1827_n N_SN_c_2077_n ) capacitor c=0.00964411f //x=25.35 \
 //y=2.095 //x2=26.85 //y2=2.095
cc_1352 ( N_QN_c_1822_n N_SN_c_2079_n ) capacitor c=0.00183762f //x=25.65 \
 //y=2.26 //x2=26.76 //y2=4.88
cc_1353 ( N_QN_c_1898_p N_SN_c_2079_n ) capacitor c=0.0168581f //x=26.215 \
 //y=4.97 //x2=26.76 //y2=4.88
cc_1354 ( N_QN_c_1856_n N_SN_c_2079_n ) capacitor c=0.00484466f //x=25.925 \
 //y=4.97 //x2=26.76 //y2=4.88
cc_1355 ( N_QN_c_1820_n N_noxref_10_c_2208_n ) capacitor c=0.0106705f \
 //x=25.535 //y=3.51 //x2=27.755 //y2=4.25
cc_1356 ( N_QN_c_1889_p N_noxref_10_c_2208_n ) capacitor c=7.97799e-19 \
 //x=23.915 //y=3.51 //x2=27.755 //y2=4.25
cc_1357 ( QN N_noxref_10_c_2208_n ) capacitor c=0.0232919f //x=23.8 //y=2.4 \
 //x2=27.755 //y2=4.25
cc_1358 ( N_QN_c_1845_n N_noxref_10_c_2208_n ) capacitor c=0.0138556f \
 //x=23.715 //y=5.335 //x2=27.755 //y2=4.25
cc_1359 ( N_QN_c_1822_n N_noxref_10_c_2208_n ) capacitor c=0.0234593f \
 //x=25.65 //y=2.26 //x2=27.755 //y2=4.25
cc_1360 ( N_QN_c_1884_n N_noxref_10_c_2208_n ) capacitor c=0.0229907f \
 //x=22.14 //y=5.335 //x2=27.755 //y2=4.25
cc_1361 ( N_QN_c_1856_n N_noxref_10_c_2208_n ) capacitor c=0.0131995f \
 //x=25.925 //y=4.97 //x2=27.755 //y2=4.25
cc_1362 ( N_QN_c_1839_n N_noxref_10_c_2227_n ) capacitor c=3.10026e-19 \
 //x=21.345 //y=5.335 //x2=18.905 //y2=5.335
cc_1363 ( N_QN_c_1822_n N_noxref_10_c_2204_n ) capacitor c=0.00153442f \
 //x=25.65 //y=2.26 //x2=27.87 //y2=2.26
cc_1364 ( N_QN_c_1820_n N_noxref_11_c_2540_n ) capacitor c=0.176086f \
 //x=25.535 //y=3.51 //x2=28.495 //y2=3.88
cc_1365 ( N_QN_c_1889_p N_noxref_11_c_2540_n ) capacitor c=0.029467f \
 //x=23.915 //y=3.51 //x2=28.495 //y2=3.88
cc_1366 ( QN N_noxref_11_c_2540_n ) capacitor c=0.0206044f //x=23.8 //y=2.4 \
 //x2=28.495 //y2=3.88
cc_1367 ( N_QN_c_1822_n N_noxref_11_c_2540_n ) capacitor c=0.0215974f \
 //x=25.65 //y=2.26 //x2=28.495 //y2=3.88
cc_1368 ( QN N_noxref_11_c_2579_n ) capacitor c=0.00131333f //x=23.8 //y=2.4 \
 //x2=23.175 //y2=3.88
cc_1369 ( N_QN_c_1889_p N_noxref_11_c_2541_n ) capacitor c=0.00720056f \
 //x=23.915 //y=3.51 //x2=23.06 //y2=2.26
cc_1370 ( QN N_noxref_11_c_2541_n ) capacitor c=0.082926f //x=23.8 //y=2.4 \
 //x2=23.06 //y2=2.26
cc_1371 ( N_QN_c_1822_n N_noxref_11_c_2541_n ) capacitor c=9.66956e-19 \
 //x=25.65 //y=2.26 //x2=23.06 //y2=2.26
cc_1372 ( N_QN_c_1933_p N_noxref_11_c_2541_n ) capacitor c=0.0168082f \
 //x=23.02 //y=5.335 //x2=23.06 //y2=2.26
cc_1373 ( N_QN_M49_noxref_g N_noxref_11_c_2546_n ) capacitor c=0.0178794f \
 //x=26.29 //y=6.2 //x2=26.865 //y2=5.335
cc_1374 ( N_QN_c_1845_n N_noxref_11_c_2550_n ) capacitor c=3.10026e-19 \
 //x=23.715 //y=5.335 //x2=26.155 //y2=5.335
cc_1375 ( N_QN_M48_noxref_g N_noxref_11_c_2550_n ) capacitor c=0.0213876f \
 //x=25.85 //y=6.2 //x2=26.155 //y2=5.335
cc_1376 ( N_QN_c_1898_p N_noxref_11_c_2550_n ) capacitor c=0.00429591f \
 //x=26.215 //y=4.97 //x2=26.155 //y2=5.335
cc_1377 ( N_QN_c_1841_n N_noxref_11_M46_noxref_g ) capacitor c=0.0184045f \
 //x=22.935 //y=5.335 //x2=22.8 //y2=6.2
cc_1378 ( N_QN_M46_noxref_d N_noxref_11_M46_noxref_g ) capacitor c=0.0180032f \
 //x=22.875 //y=5.2 //x2=22.8 //y2=6.2
cc_1379 ( N_QN_c_1845_n N_noxref_11_M47_noxref_g ) capacitor c=0.0205426f \
 //x=23.715 //y=5.335 //x2=23.24 //y2=6.2
cc_1380 ( N_QN_M46_noxref_d N_noxref_11_M47_noxref_g ) capacitor c=0.0194246f \
 //x=22.875 //y=5.2 //x2=23.24 //y2=6.2
cc_1381 ( N_QN_M14_noxref_d N_noxref_11_c_2589_n ) capacitor c=0.00217566f \
 //x=23.125 //y=1.095 //x2=23.05 //y2=1.095
cc_1382 ( N_QN_M14_noxref_d N_noxref_11_c_2590_n ) capacitor c=0.0034598f \
 //x=23.125 //y=1.095 //x2=23.05 //y2=1.44
cc_1383 ( N_QN_M14_noxref_d N_noxref_11_c_2591_n ) capacitor c=0.00544291f \
 //x=23.125 //y=1.095 //x2=23.05 //y2=1.75
cc_1384 ( N_QN_M14_noxref_d N_noxref_11_c_2618_n ) capacitor c=0.00241102f \
 //x=23.125 //y=1.095 //x2=23.425 //y2=0.94
cc_1385 ( N_QN_c_1821_n N_noxref_11_c_2619_n ) capacitor c=0.00359704f \
 //x=23.715 //y=1.845 //x2=23.425 //y2=1.595
cc_1386 ( N_QN_M14_noxref_d N_noxref_11_c_2619_n ) capacitor c=0.0140297f \
 //x=23.125 //y=1.095 //x2=23.425 //y2=1.595
cc_1387 ( N_QN_M14_noxref_d N_noxref_11_c_2621_n ) capacitor c=0.00219619f \
 //x=23.125 //y=1.095 //x2=23.58 //y2=1.095
cc_1388 ( N_QN_c_1821_n N_noxref_11_c_2622_n ) capacitor c=0.00457401f \
 //x=23.715 //y=1.845 //x2=23.58 //y2=1.44
cc_1389 ( N_QN_M14_noxref_d N_noxref_11_c_2622_n ) capacitor c=0.00603828f \
 //x=23.125 //y=1.095 //x2=23.58 //y2=1.44
cc_1390 ( QN N_noxref_11_c_2592_n ) capacitor c=0.00877984f //x=23.8 //y=2.4 \
 //x2=23.06 //y2=2.26
cc_1391 ( QN N_noxref_11_c_2594_n ) capacitor c=0.00283672f //x=23.8 //y=2.4 \
 //x2=23.06 //y2=2.095
cc_1392 ( N_QN_M14_noxref_d N_noxref_11_c_2594_n ) capacitor c=0.00661782f \
 //x=23.125 //y=1.095 //x2=23.06 //y2=2.095
cc_1393 ( QN N_noxref_11_c_2595_n ) capacitor c=0.013693f //x=23.8 //y=2.4 \
 //x2=23.06 //y2=4.88
cc_1394 ( N_QN_c_1845_n N_noxref_11_c_2595_n ) capacitor c=0.00201851f \
 //x=23.715 //y=5.335 //x2=23.06 //y2=4.88
cc_1395 ( N_QN_c_1933_p N_noxref_11_c_2595_n ) capacitor c=0.00475729f \
 //x=23.02 //y=5.335 //x2=23.06 //y2=4.88
cc_1396 ( N_QN_M49_noxref_g N_noxref_11_M48_noxref_d ) capacitor c=0.0180032f \
 //x=26.29 //y=6.2 //x2=25.925 //y2=5.2
cc_1397 ( N_QN_M14_noxref_d N_noxref_21_M12_noxref_s ) capacitor c=0.00309936f \
 //x=23.125 //y=1.095 //x2=20.185 //y2=0.555
cc_1398 ( N_QN_c_1821_n N_noxref_22_c_3225_n ) capacitor c=0.00461497f \
 //x=23.715 //y=1.845 //x2=23.715 //y2=0.72
cc_1399 ( N_QN_M14_noxref_d N_noxref_22_c_3225_n ) capacitor c=0.0116817f \
 //x=23.125 //y=1.095 //x2=23.715 //y2=0.72
cc_1400 ( N_QN_c_1891_p N_noxref_22_c_3248_n ) capacitor c=0.0200405f //x=23.4 \
 //y=1.845 //x2=22.83 //y2=1.175
cc_1401 ( N_QN_M14_noxref_d N_noxref_22_M13_noxref_d ) capacitor c=5.27807e-19 \
 //x=23.125 //y=1.095 //x2=21.59 //y2=1.09
cc_1402 ( N_QN_c_1821_n N_noxref_22_M14_noxref_s ) capacitor c=0.0201579f \
 //x=23.715 //y=1.845 //x2=22.695 //y2=0.555
cc_1403 ( N_QN_M14_noxref_d N_noxref_22_M14_noxref_s ) capacitor c=0.0426368f \
 //x=23.125 //y=1.095 //x2=22.695 //y2=0.555
cc_1404 ( N_QN_c_1821_n N_noxref_23_c_3287_n ) capacitor c=3.84569e-19 \
 //x=23.715 //y=1.845 //x2=25.13 //y2=1.685
cc_1405 ( N_QN_c_1827_n N_noxref_23_c_3287_n ) capacitor c=0.0034165f \
 //x=25.35 //y=2.095 //x2=25.13 //y2=1.685
cc_1406 ( N_QN_c_1822_n N_noxref_23_c_3273_n ) capacitor c=0.0122624f \
 //x=25.65 //y=2.26 //x2=26.015 //y2=1.77
cc_1407 ( N_QN_c_1826_n N_noxref_23_c_3273_n ) capacitor c=0.00703864f \
 //x=25.35 //y=1.71 //x2=26.015 //y2=1.77
cc_1408 ( N_QN_c_1827_n N_noxref_23_c_3273_n ) capacitor c=0.0215834f \
 //x=25.35 //y=2.095 //x2=26.015 //y2=1.77
cc_1409 ( N_QN_c_1829_n N_noxref_23_c_3273_n ) capacitor c=0.00708583f \
 //x=25.725 //y=1.555 //x2=26.015 //y2=1.77
cc_1410 ( N_QN_c_1832_n N_noxref_23_c_3273_n ) capacitor c=0.00698822f \
 //x=25.88 //y=1.4 //x2=26.015 //y2=1.77
cc_1411 ( N_QN_c_1823_n N_noxref_23_M15_noxref_s ) capacitor c=0.0327271f \
 //x=25.35 //y=1.055 //x2=24.995 //y2=0.555
cc_1412 ( N_QN_c_1826_n N_noxref_23_M15_noxref_s ) capacitor c=7.99997e-19 \
 //x=25.35 //y=1.71 //x2=24.995 //y2=0.555
cc_1413 ( N_QN_c_1827_n N_noxref_23_M15_noxref_s ) capacitor c=0.00122123f \
 //x=25.35 //y=2.095 //x2=24.995 //y2=0.555
cc_1414 ( N_QN_c_1830_n N_noxref_23_M15_noxref_s ) capacitor c=0.0121427f \
 //x=25.88 //y=1.055 //x2=24.995 //y2=0.555
cc_1415 ( N_QN_M14_noxref_d N_noxref_23_M15_noxref_s ) capacitor c=2.55333e-19 \
 //x=23.125 //y=1.095 //x2=24.995 //y2=0.555
cc_1416 ( N_SN_c_1987_n N_noxref_10_c_2206_n ) capacitor c=0.0190126f \
 //x=12.33 //y=2.26 //x2=13.325 //y2=4.25
cc_1417 ( N_SN_c_1977_n N_noxref_10_c_2207_n ) capacitor c=0.00948333f \
 //x=12.33 //y=2.775 //x2=18.875 //y2=4.25
cc_1418 ( N_SN_c_1987_n N_noxref_10_c_2270_n ) capacitor c=0.00128547f \
 //x=12.33 //y=2.26 //x2=13.555 //y2=4.25
cc_1419 ( N_SN_c_1977_n N_noxref_10_c_2208_n ) capacitor c=0.0565388f \
 //x=12.33 //y=2.775 //x2=27.755 //y2=4.25
cc_1420 ( N_SN_c_1988_n N_noxref_10_c_2208_n ) capacitor c=0.0242403f \
 //x=26.76 //y=2.26 //x2=27.755 //y2=4.25
cc_1421 ( N_SN_c_2087_p N_noxref_10_c_2208_n ) capacitor c=0.0067704f \
 //x=27.095 //y=4.97 //x2=27.755 //y2=4.25
cc_1422 ( N_SN_c_2079_n N_noxref_10_c_2208_n ) capacitor c=0.00230259f \
 //x=26.76 //y=4.88 //x2=27.755 //y2=4.25
cc_1423 ( N_SN_c_1977_n N_noxref_10_c_2215_n ) capacitor c=3.16222e-19 \
 //x=12.33 //y=2.775 //x2=19.105 //y2=4.25
cc_1424 ( N_SN_c_1977_n N_noxref_10_c_2202_n ) capacitor c=0.0251694f \
 //x=12.33 //y=2.775 //x2=13.44 //y2=2.26
cc_1425 ( N_SN_c_1987_n N_noxref_10_c_2202_n ) capacitor c=0.0453023f \
 //x=12.33 //y=2.26 //x2=13.44 //y2=2.26
cc_1426 ( N_SN_c_2018_n N_noxref_10_c_2202_n ) capacitor c=0.0023343f \
 //x=12.42 //y=2.095 //x2=13.44 //y2=2.26
cc_1427 ( N_SN_c_2020_n N_noxref_10_c_2202_n ) capacitor c=0.00142741f \
 //x=12.33 //y=4.88 //x2=13.44 //y2=2.26
cc_1428 ( N_SN_c_1977_n N_noxref_10_c_2441_n ) capacitor c=0.0115788f \
 //x=12.33 //y=2.775 //x2=18.59 //y2=1.845
cc_1429 ( N_SN_c_1977_n N_noxref_10_c_2231_n ) capacitor c=0.024834f //x=12.33 \
 //y=2.775 //x2=18.99 //y2=4.25
cc_1430 ( N_SN_c_1977_n N_noxref_10_c_2204_n ) capacitor c=0.00526349f \
 //x=12.33 //y=2.775 //x2=27.87 //y2=2.26
cc_1431 ( N_SN_c_1988_n N_noxref_10_c_2204_n ) capacitor c=0.0511494f \
 //x=26.76 //y=2.26 //x2=27.87 //y2=2.26
cc_1432 ( N_SN_c_2077_n N_noxref_10_c_2204_n ) capacitor c=0.0023343f \
 //x=26.85 //y=2.095 //x2=27.87 //y2=2.26
cc_1433 ( N_SN_c_2079_n N_noxref_10_c_2204_n ) capacitor c=0.00142741f \
 //x=26.76 //y=4.88 //x2=27.87 //y2=2.26
cc_1434 ( N_SN_M32_noxref_g N_noxref_10_M34_noxref_g ) capacitor c=0.0101598f \
 //x=12.3 //y=6.2 //x2=13.18 //y2=6.2
cc_1435 ( N_SN_M33_noxref_g N_noxref_10_M34_noxref_g ) capacitor c=0.0602553f \
 //x=12.74 //y=6.2 //x2=13.18 //y2=6.2
cc_1436 ( N_SN_M33_noxref_g N_noxref_10_M35_noxref_g ) capacitor c=0.0101598f \
 //x=12.74 //y=6.2 //x2=13.62 //y2=6.2
cc_1437 ( N_SN_M50_noxref_g N_noxref_10_M52_noxref_g ) capacitor c=0.0101598f \
 //x=26.73 //y=6.2 //x2=27.61 //y2=6.2
cc_1438 ( N_SN_M51_noxref_g N_noxref_10_M52_noxref_g ) capacitor c=0.0602553f \
 //x=27.17 //y=6.2 //x2=27.61 //y2=6.2
cc_1439 ( N_SN_M51_noxref_g N_noxref_10_M53_noxref_g ) capacitor c=0.0101598f \
 //x=27.17 //y=6.2 //x2=28.05 //y2=6.2
cc_1440 ( N_SN_c_2015_n N_noxref_10_c_2283_n ) capacitor c=0.00456962f \
 //x=12.42 //y=1.09 //x2=13.43 //y2=1.095
cc_1441 ( N_SN_c_2016_n N_noxref_10_c_2284_n ) capacitor c=0.00438372f \
 //x=12.42 //y=1.4 //x2=13.43 //y2=1.44
cc_1442 ( N_SN_c_2017_n N_noxref_10_c_2285_n ) capacitor c=0.00438372f \
 //x=12.42 //y=1.63 //x2=13.43 //y2=1.75
cc_1443 ( N_SN_c_2074_n N_noxref_10_c_2456_n ) capacitor c=0.00456962f \
 //x=26.85 //y=1.09 //x2=27.86 //y2=1.095
cc_1444 ( N_SN_c_2075_n N_noxref_10_c_2457_n ) capacitor c=0.00438372f \
 //x=26.85 //y=1.4 //x2=27.86 //y2=1.44
cc_1445 ( N_SN_c_2076_n N_noxref_10_c_2458_n ) capacitor c=0.00438372f \
 //x=26.85 //y=1.63 //x2=27.86 //y2=1.75
cc_1446 ( N_SN_c_1977_n N_noxref_10_c_2292_n ) capacitor c=0.00232725f \
 //x=12.33 //y=2.775 //x2=13.44 //y2=2.26
cc_1447 ( N_SN_c_1987_n N_noxref_10_c_2292_n ) capacitor c=0.00228632f \
 //x=12.33 //y=2.26 //x2=13.44 //y2=2.26
cc_1448 ( N_SN_c_2018_n N_noxref_10_c_2292_n ) capacitor c=0.00933826f \
 //x=12.42 //y=2.095 //x2=13.44 //y2=2.26
cc_1449 ( N_SN_c_2018_n N_noxref_10_c_2293_n ) capacitor c=0.00438372f \
 //x=12.42 //y=2.095 //x2=13.44 //y2=2.095
cc_1450 ( N_SN_c_1987_n N_noxref_10_c_2295_n ) capacitor c=0.00219458f \
 //x=12.33 //y=2.26 //x2=13.44 //y2=4.88
cc_1451 ( N_SN_c_2035_n N_noxref_10_c_2295_n ) capacitor c=0.0611812f \
 //x=12.665 //y=4.97 //x2=13.44 //y2=4.88
cc_1452 ( N_SN_c_2020_n N_noxref_10_c_2295_n ) capacitor c=0.00487508f \
 //x=12.33 //y=4.88 //x2=13.44 //y2=4.88
cc_1453 ( N_SN_c_1988_n N_noxref_10_c_2466_n ) capacitor c=0.00228632f \
 //x=26.76 //y=2.26 //x2=27.87 //y2=2.26
cc_1454 ( N_SN_c_2077_n N_noxref_10_c_2466_n ) capacitor c=0.00933826f \
 //x=26.85 //y=2.095 //x2=27.87 //y2=2.26
cc_1455 ( N_SN_c_2077_n N_noxref_10_c_2468_n ) capacitor c=0.00438372f \
 //x=26.85 //y=2.095 //x2=27.87 //y2=2.095
cc_1456 ( N_SN_c_1988_n N_noxref_10_c_2469_n ) capacitor c=0.00219458f \
 //x=26.76 //y=2.26 //x2=27.87 //y2=4.88
cc_1457 ( N_SN_c_2087_p N_noxref_10_c_2469_n ) capacitor c=0.0611812f \
 //x=27.095 //y=4.97 //x2=27.87 //y2=4.88
cc_1458 ( N_SN_c_2079_n N_noxref_10_c_2469_n ) capacitor c=0.00487508f \
 //x=26.76 //y=4.88 //x2=27.87 //y2=4.88
cc_1459 ( N_SN_c_1977_n N_noxref_11_c_2540_n ) capacitor c=0.0534219f \
 //x=12.33 //y=2.775 //x2=28.495 //y2=3.88
cc_1460 ( N_SN_c_1988_n N_noxref_11_c_2540_n ) capacitor c=0.0229885f \
 //x=26.76 //y=2.26 //x2=28.495 //y2=3.88
cc_1461 ( N_SN_c_1977_n N_noxref_11_c_2579_n ) capacitor c=0.00777466f \
 //x=12.33 //y=2.775 //x2=23.175 //y2=3.88
cc_1462 ( N_SN_c_1977_n N_noxref_11_c_2541_n ) capacitor c=0.025454f //x=12.33 \
 //y=2.775 //x2=23.06 //y2=2.26
cc_1463 ( N_SN_c_1988_n N_noxref_11_c_2546_n ) capacitor c=0.0148665f \
 //x=26.76 //y=2.26 //x2=26.865 //y2=5.335
cc_1464 ( N_SN_M50_noxref_g N_noxref_11_c_2546_n ) capacitor c=0.0166659f \
 //x=26.73 //y=6.2 //x2=26.865 //y2=5.335
cc_1465 ( N_SN_c_2079_n N_noxref_11_c_2546_n ) capacitor c=0.00322396f \
 //x=26.76 //y=4.88 //x2=26.865 //y2=5.335
cc_1466 ( N_SN_M51_noxref_g N_noxref_11_c_2552_n ) capacitor c=0.0184045f \
 //x=27.17 //y=6.2 //x2=27.745 //y2=5.335
cc_1467 ( N_SN_c_1988_n N_noxref_11_c_2560_n ) capacitor c=0.00376573f \
 //x=26.76 //y=2.26 //x2=28.61 //y2=3.88
cc_1468 ( N_SN_c_2087_p N_noxref_11_c_2640_n ) capacitor c=0.00427862f \
 //x=27.095 //y=4.97 //x2=26.95 //y2=5.335
cc_1469 ( N_SN_c_1977_n N_noxref_11_c_2592_n ) capacitor c=0.00232725f \
 //x=12.33 //y=2.775 //x2=23.06 //y2=2.26
cc_1470 ( N_SN_M50_noxref_g N_noxref_11_M50_noxref_d ) capacitor c=0.0180032f \
 //x=26.73 //y=6.2 //x2=26.805 //y2=5.2
cc_1471 ( N_SN_M51_noxref_g N_noxref_11_M50_noxref_d ) capacitor c=0.0180032f \
 //x=27.17 //y=6.2 //x2=26.805 //y2=5.2
cc_1472 ( N_SN_c_2010_n N_noxref_17_c_2965_n ) capacitor c=0.0167228f \
 //x=11.895 //y=1.09 //x2=12.555 //y2=0.72
cc_1473 ( N_SN_c_2015_n N_noxref_17_c_2965_n ) capacitor c=0.00534519f \
 //x=12.42 //y=1.09 //x2=12.555 //y2=0.72
cc_1474 ( N_SN_c_1977_n N_noxref_17_c_2988_n ) capacitor c=0.00531578f \
 //x=12.33 //y=2.775 //x2=12.555 //y2=1.77
cc_1475 ( N_SN_c_1987_n N_noxref_17_c_2988_n ) capacitor c=0.0120472f \
 //x=12.33 //y=2.26 //x2=12.555 //y2=1.77
cc_1476 ( N_SN_c_2013_n N_noxref_17_c_2988_n ) capacitor c=0.0153476f \
 //x=11.895 //y=1.4 //x2=12.555 //y2=1.77
cc_1477 ( N_SN_c_2018_n N_noxref_17_c_2988_n ) capacitor c=0.021924f //x=12.42 \
 //y=2.095 //x2=12.555 //y2=1.77
cc_1478 ( N_SN_c_1977_n N_noxref_17_M6_noxref_s ) capacitor c=0.00417977f \
 //x=12.33 //y=2.775 //x2=10.565 //y2=0.555
cc_1479 ( N_SN_c_2010_n N_noxref_17_M6_noxref_s ) capacitor c=0.00798959f \
 //x=11.895 //y=1.09 //x2=10.565 //y2=0.555
cc_1480 ( N_SN_c_2017_n N_noxref_17_M6_noxref_s ) capacitor c=0.00212176f \
 //x=12.42 //y=1.63 //x2=10.565 //y2=0.555
cc_1481 ( N_SN_c_2018_n N_noxref_17_M6_noxref_s ) capacitor c=0.00298115f \
 //x=12.42 //y=2.095 //x2=10.565 //y2=0.555
cc_1482 ( N_SN_c_1977_n N_noxref_18_c_3011_n ) capacitor c=0.00494691f \
 //x=12.33 //y=2.775 //x2=13.125 //y2=1.175
cc_1483 ( N_SN_c_2149_p N_noxref_18_c_3011_n ) capacitor c=2.14837e-19 \
 //x=12.265 //y=0.935 //x2=13.125 //y2=1.175
cc_1484 ( N_SN_c_2015_n N_noxref_18_c_3011_n ) capacitor c=0.00123426f \
 //x=12.42 //y=1.09 //x2=13.125 //y2=1.175
cc_1485 ( N_SN_c_2016_n N_noxref_18_c_3011_n ) capacitor c=0.0129288f \
 //x=12.42 //y=1.4 //x2=13.125 //y2=1.175
cc_1486 ( N_SN_c_2017_n N_noxref_18_c_3011_n ) capacitor c=0.00142359f \
 //x=12.42 //y=1.63 //x2=13.125 //y2=1.175
cc_1487 ( N_SN_c_1977_n N_noxref_18_c_3017_n ) capacitor c=8.29806e-19 \
 //x=12.33 //y=2.775 //x2=14.095 //y2=0.72
cc_1488 ( N_SN_c_2010_n N_noxref_18_M7_noxref_d ) capacitor c=0.00223875f \
 //x=11.895 //y=1.09 //x2=11.97 //y2=1.09
cc_1489 ( N_SN_c_2013_n N_noxref_18_M7_noxref_d ) capacitor c=0.00262485f \
 //x=11.895 //y=1.4 //x2=11.97 //y2=1.09
cc_1490 ( N_SN_c_2149_p N_noxref_18_M7_noxref_d ) capacitor c=0.00220746f \
 //x=12.265 //y=0.935 //x2=11.97 //y2=1.09
cc_1491 ( N_SN_c_2157_p N_noxref_18_M7_noxref_d ) capacitor c=0.00194798f \
 //x=12.265 //y=1.555 //x2=11.97 //y2=1.09
cc_1492 ( N_SN_c_2015_n N_noxref_18_M7_noxref_d ) capacitor c=0.00198465f \
 //x=12.42 //y=1.09 //x2=11.97 //y2=1.09
cc_1493 ( N_SN_c_2016_n N_noxref_18_M7_noxref_d ) capacitor c=0.00128384f \
 //x=12.42 //y=1.4 //x2=11.97 //y2=1.09
cc_1494 ( N_SN_c_1977_n N_noxref_18_M8_noxref_s ) capacitor c=0.00448771f \
 //x=12.33 //y=2.775 //x2=13.075 //y2=0.555
cc_1495 ( N_SN_c_2015_n N_noxref_18_M8_noxref_s ) capacitor c=7.21316e-19 \
 //x=12.42 //y=1.09 //x2=13.075 //y2=0.555
cc_1496 ( N_SN_c_2016_n N_noxref_18_M8_noxref_s ) capacitor c=0.00348171f \
 //x=12.42 //y=1.4 //x2=13.075 //y2=0.555
cc_1497 ( N_SN_c_1977_n N_noxref_19_c_3081_n ) capacitor c=0.00448771f \
 //x=12.33 //y=2.775 //x2=15.51 //y2=1.685
cc_1498 ( N_SN_c_1977_n N_noxref_19_c_3065_n ) capacitor c=0.0163649f \
 //x=12.33 //y=2.775 //x2=16.395 //y2=1.77
cc_1499 ( N_SN_c_1977_n N_noxref_19_c_3095_n ) capacitor c=0.0144126f \
 //x=12.33 //y=2.775 //x2=17.365 //y2=1.77
cc_1500 ( N_SN_c_1977_n N_noxref_19_M9_noxref_s ) capacitor c=0.00867201f \
 //x=12.33 //y=2.775 //x2=15.375 //y2=0.555
cc_1501 ( N_SN_c_1977_n N_noxref_20_c_3115_n ) capacitor c=0.00494691f \
 //x=12.33 //y=2.775 //x2=17.935 //y2=1.175
cc_1502 ( N_SN_c_1977_n N_noxref_20_c_3121_n ) capacitor c=8.29806e-19 \
 //x=12.33 //y=2.775 //x2=18.905 //y2=0.72
cc_1503 ( N_SN_c_1977_n N_noxref_20_M11_noxref_s ) capacitor c=0.00448771f \
 //x=12.33 //y=2.775 //x2=17.885 //y2=0.555
cc_1504 ( N_SN_c_1977_n N_noxref_21_c_3185_n ) capacitor c=0.00448771f \
 //x=12.33 //y=2.775 //x2=20.32 //y2=1.685
cc_1505 ( N_SN_c_1977_n N_noxref_21_c_3169_n ) capacitor c=0.0163649f \
 //x=12.33 //y=2.775 //x2=21.205 //y2=1.77
cc_1506 ( N_SN_c_1977_n N_noxref_21_c_3197_n ) capacitor c=0.0144126f \
 //x=12.33 //y=2.775 //x2=22.175 //y2=1.77
cc_1507 ( N_SN_c_1977_n N_noxref_21_M12_noxref_s ) capacitor c=0.00867201f \
 //x=12.33 //y=2.775 //x2=20.185 //y2=0.555
cc_1508 ( N_SN_c_1977_n N_noxref_22_c_3219_n ) capacitor c=0.00494691f \
 //x=12.33 //y=2.775 //x2=22.745 //y2=1.175
cc_1509 ( N_SN_c_1977_n N_noxref_22_c_3225_n ) capacitor c=8.29806e-19 \
 //x=12.33 //y=2.775 //x2=23.715 //y2=0.72
cc_1510 ( N_SN_c_1977_n N_noxref_22_M14_noxref_s ) capacitor c=0.00448771f \
 //x=12.33 //y=2.775 //x2=22.695 //y2=0.555
cc_1511 ( N_SN_c_1977_n N_noxref_23_c_3287_n ) capacitor c=0.00448771f \
 //x=12.33 //y=2.775 //x2=25.13 //y2=1.685
cc_1512 ( N_SN_c_1977_n N_noxref_23_c_3273_n ) capacitor c=0.0163649f \
 //x=12.33 //y=2.775 //x2=26.015 //y2=1.77
cc_1513 ( N_SN_c_2069_n N_noxref_23_c_3280_n ) capacitor c=0.0167228f \
 //x=26.325 //y=1.09 //x2=26.985 //y2=0.72
cc_1514 ( N_SN_c_2074_n N_noxref_23_c_3280_n ) capacitor c=0.00534519f \
 //x=26.85 //y=1.09 //x2=26.985 //y2=0.72
cc_1515 ( N_SN_c_1977_n N_noxref_23_c_3303_n ) capacitor c=0.0125242f \
 //x=12.33 //y=2.775 //x2=26.985 //y2=1.77
cc_1516 ( N_SN_c_1988_n N_noxref_23_c_3303_n ) capacitor c=0.0123163f \
 //x=26.76 //y=2.26 //x2=26.985 //y2=1.77
cc_1517 ( N_SN_c_2072_n N_noxref_23_c_3303_n ) capacitor c=0.0153476f \
 //x=26.325 //y=1.4 //x2=26.985 //y2=1.77
cc_1518 ( N_SN_c_2077_n N_noxref_23_c_3303_n ) capacitor c=0.0221623f \
 //x=26.85 //y=2.095 //x2=26.985 //y2=1.77
cc_1519 ( N_SN_c_1977_n N_noxref_23_M15_noxref_s ) capacitor c=0.00448771f \
 //x=12.33 //y=2.775 //x2=24.995 //y2=0.555
cc_1520 ( N_SN_c_2069_n N_noxref_23_M15_noxref_s ) capacitor c=0.00798959f \
 //x=26.325 //y=1.09 //x2=24.995 //y2=0.555
cc_1521 ( N_SN_c_2076_n N_noxref_23_M15_noxref_s ) capacitor c=0.00212176f \
 //x=26.85 //y=1.63 //x2=24.995 //y2=0.555
cc_1522 ( N_SN_c_2077_n N_noxref_23_M15_noxref_s ) capacitor c=0.00298115f \
 //x=26.85 //y=2.095 //x2=24.995 //y2=0.555
cc_1523 ( N_SN_c_2189_p N_noxref_24_c_3323_n ) capacitor c=2.14837e-19 \
 //x=26.695 //y=0.935 //x2=27.555 //y2=1.175
cc_1524 ( N_SN_c_2074_n N_noxref_24_c_3323_n ) capacitor c=0.00123426f \
 //x=26.85 //y=1.09 //x2=27.555 //y2=1.175
cc_1525 ( N_SN_c_2075_n N_noxref_24_c_3323_n ) capacitor c=0.0129288f \
 //x=26.85 //y=1.4 //x2=27.555 //y2=1.175
cc_1526 ( N_SN_c_2076_n N_noxref_24_c_3323_n ) capacitor c=0.00142359f \
 //x=26.85 //y=1.63 //x2=27.555 //y2=1.175
cc_1527 ( N_SN_c_2069_n N_noxref_24_M16_noxref_d ) capacitor c=0.00223875f \
 //x=26.325 //y=1.09 //x2=26.4 //y2=1.09
cc_1528 ( N_SN_c_2072_n N_noxref_24_M16_noxref_d ) capacitor c=0.00262485f \
 //x=26.325 //y=1.4 //x2=26.4 //y2=1.09
cc_1529 ( N_SN_c_2189_p N_noxref_24_M16_noxref_d ) capacitor c=0.00220746f \
 //x=26.695 //y=0.935 //x2=26.4 //y2=1.09
cc_1530 ( N_SN_c_2196_p N_noxref_24_M16_noxref_d ) capacitor c=0.00194798f \
 //x=26.695 //y=1.555 //x2=26.4 //y2=1.09
cc_1531 ( N_SN_c_2074_n N_noxref_24_M16_noxref_d ) capacitor c=0.00198465f \
 //x=26.85 //y=1.09 //x2=26.4 //y2=1.09
cc_1532 ( N_SN_c_2075_n N_noxref_24_M16_noxref_d ) capacitor c=0.00128384f \
 //x=26.85 //y=1.4 //x2=26.4 //y2=1.09
cc_1533 ( N_SN_c_2074_n N_noxref_24_M17_noxref_s ) capacitor c=7.21316e-19 \
 //x=26.85 //y=1.09 //x2=27.505 //y2=0.555
cc_1534 ( N_SN_c_2075_n N_noxref_24_M17_noxref_s ) capacitor c=0.00348171f \
 //x=26.85 //y=1.4 //x2=27.505 //y2=0.555
cc_1535 ( N_noxref_10_c_2208_n N_noxref_11_c_2540_n ) capacitor c=0.433554f \
 //x=27.755 //y=4.25 //x2=28.495 //y2=3.88
cc_1536 ( N_noxref_10_c_2204_n N_noxref_11_c_2540_n ) capacitor c=0.027223f \
 //x=27.87 //y=2.26 //x2=28.495 //y2=3.88
cc_1537 ( N_noxref_10_c_2469_n N_noxref_11_c_2540_n ) capacitor c=0.0018324f \
 //x=27.87 //y=4.88 //x2=28.495 //y2=3.88
cc_1538 ( N_noxref_10_c_2208_n N_noxref_11_c_2579_n ) capacitor c=0.0292842f \
 //x=27.755 //y=4.25 //x2=23.175 //y2=3.88
cc_1539 ( N_noxref_10_c_2208_n N_noxref_11_c_2541_n ) capacitor c=0.0237491f \
 //x=27.755 //y=4.25 //x2=23.06 //y2=2.26
cc_1540 ( N_noxref_10_c_2208_n N_noxref_11_c_2546_n ) capacitor c=0.0236892f \
 //x=27.755 //y=4.25 //x2=26.865 //y2=5.335
cc_1541 ( N_noxref_10_c_2208_n N_noxref_11_c_2550_n ) capacitor c=0.0173f \
 //x=27.755 //y=4.25 //x2=26.155 //y2=5.335
cc_1542 ( N_noxref_10_M52_noxref_g N_noxref_11_c_2552_n ) capacitor \
 c=0.0184045f //x=27.61 //y=6.2 //x2=27.745 //y2=5.335
cc_1543 ( N_noxref_10_c_2208_n N_noxref_11_c_2556_n ) capacitor c=0.00181724f \
 //x=27.755 //y=4.25 //x2=28.525 //y2=5.335
cc_1544 ( N_noxref_10_M53_noxref_g N_noxref_11_c_2556_n ) capacitor \
 c=0.0211056f //x=28.05 //y=6.2 //x2=28.525 //y2=5.335
cc_1545 ( N_noxref_10_c_2469_n N_noxref_11_c_2556_n ) capacitor c=0.00201851f \
 //x=27.87 //y=4.88 //x2=28.525 //y2=5.335
cc_1546 ( N_noxref_10_c_2483_p N_noxref_11_c_2542_n ) capacitor c=0.00359704f \
 //x=28.235 //y=1.595 //x2=28.525 //y2=1.845
cc_1547 ( N_noxref_10_c_2484_p N_noxref_11_c_2542_n ) capacitor c=0.00457401f \
 //x=28.39 //y=1.44 //x2=28.525 //y2=1.845
cc_1548 ( N_noxref_10_c_2208_n N_noxref_11_c_2560_n ) capacitor c=0.00642908f \
 //x=27.755 //y=4.25 //x2=28.61 //y2=3.88
cc_1549 ( N_noxref_10_c_2204_n N_noxref_11_c_2560_n ) capacitor c=0.0880964f \
 //x=27.87 //y=2.26 //x2=28.61 //y2=3.88
cc_1550 ( N_noxref_10_c_2466_n N_noxref_11_c_2560_n ) capacitor c=0.00877984f \
 //x=27.87 //y=2.26 //x2=28.61 //y2=3.88
cc_1551 ( N_noxref_10_c_2468_n N_noxref_11_c_2560_n ) capacitor c=0.00283672f \
 //x=27.87 //y=2.095 //x2=28.61 //y2=3.88
cc_1552 ( N_noxref_10_c_2469_n N_noxref_11_c_2560_n ) capacitor c=0.013844f \
 //x=27.87 //y=4.88 //x2=28.61 //y2=3.88
cc_1553 ( N_noxref_10_c_2208_n N_noxref_11_c_2662_n ) capacitor c=7.87932e-19 \
 //x=27.755 //y=4.25 //x2=27.83 //y2=5.335
cc_1554 ( N_noxref_10_c_2204_n N_noxref_11_c_2662_n ) capacitor c=0.0169174f \
 //x=27.87 //y=2.26 //x2=27.83 //y2=5.335
cc_1555 ( N_noxref_10_c_2469_n N_noxref_11_c_2662_n ) capacitor c=0.0047572f \
 //x=27.87 //y=4.88 //x2=27.83 //y2=5.335
cc_1556 ( N_noxref_10_c_2208_n N_noxref_11_c_2595_n ) capacitor c=0.00775263f \
 //x=27.755 //y=4.25 //x2=23.06 //y2=4.88
cc_1557 ( N_noxref_10_c_2456_n N_noxref_11_M17_noxref_d ) capacitor \
 c=0.00217566f //x=27.86 //y=1.095 //x2=27.935 //y2=1.095
cc_1558 ( N_noxref_10_c_2457_n N_noxref_11_M17_noxref_d ) capacitor \
 c=0.0034598f //x=27.86 //y=1.44 //x2=27.935 //y2=1.095
cc_1559 ( N_noxref_10_c_2458_n N_noxref_11_M17_noxref_d ) capacitor \
 c=0.00544291f //x=27.86 //y=1.75 //x2=27.935 //y2=1.095
cc_1560 ( N_noxref_10_c_2497_p N_noxref_11_M17_noxref_d ) capacitor \
 c=0.00241102f //x=28.235 //y=0.94 //x2=27.935 //y2=1.095
cc_1561 ( N_noxref_10_c_2483_p N_noxref_11_M17_noxref_d ) capacitor \
 c=0.0140297f //x=28.235 //y=1.595 //x2=27.935 //y2=1.095
cc_1562 ( N_noxref_10_c_2499_p N_noxref_11_M17_noxref_d ) capacitor \
 c=0.00219619f //x=28.39 //y=1.095 //x2=27.935 //y2=1.095
cc_1563 ( N_noxref_10_c_2484_p N_noxref_11_M17_noxref_d ) capacitor \
 c=0.00603828f //x=28.39 //y=1.44 //x2=27.935 //y2=1.095
cc_1564 ( N_noxref_10_c_2468_n N_noxref_11_M17_noxref_d ) capacitor \
 c=0.00661782f //x=27.87 //y=2.095 //x2=27.935 //y2=1.095
cc_1565 ( N_noxref_10_M52_noxref_g N_noxref_11_M52_noxref_d ) capacitor \
 c=0.0180032f //x=27.61 //y=6.2 //x2=27.685 //y2=5.2
cc_1566 ( N_noxref_10_M53_noxref_g N_noxref_11_M52_noxref_d ) capacitor \
 c=0.0194246f //x=28.05 //y=6.2 //x2=27.685 //y2=5.2
cc_1567 ( N_noxref_10_c_2201_n N_noxref_16_c_2910_n ) capacitor c=0.00207747f \
 //x=8.63 //y=2.26 //x2=9.285 //y2=0.72
cc_1568 ( N_noxref_10_c_2322_n N_noxref_16_c_2910_n ) capacitor c=0.0194423f \
 //x=8.62 //y=1.095 //x2=9.285 //y2=0.72
cc_1569 ( N_noxref_10_c_2365_n N_noxref_16_c_2910_n ) capacitor c=0.00656458f \
 //x=9.15 //y=1.095 //x2=9.285 //y2=0.72
cc_1570 ( N_noxref_10_c_2267_n N_noxref_16_c_2910_n ) capacitor c=2.20712e-19 \
 //x=8.63 //y=2.26 //x2=9.285 //y2=0.72
cc_1571 ( N_noxref_10_c_2323_n N_noxref_16_c_2936_n ) capacitor c=0.00538829f \
 //x=8.62 //y=1.44 //x2=8.4 //y2=1.175
cc_1572 ( N_noxref_10_c_2322_n N_noxref_16_M5_noxref_s ) capacitor \
 c=0.00538829f //x=8.62 //y=1.095 //x2=8.265 //y2=0.555
cc_1573 ( N_noxref_10_c_2324_n N_noxref_16_M5_noxref_s ) capacitor \
 c=0.00538829f //x=8.62 //y=1.75 //x2=8.265 //y2=0.555
cc_1574 ( N_noxref_10_c_2365_n N_noxref_16_M5_noxref_s ) capacitor \
 c=0.0143002f //x=9.15 //y=1.095 //x2=8.265 //y2=0.555
cc_1575 ( N_noxref_10_c_2366_n N_noxref_16_M5_noxref_s ) capacitor \
 c=0.00290153f //x=9.15 //y=1.44 //x2=8.265 //y2=0.555
cc_1576 ( N_noxref_10_c_2202_n N_noxref_18_c_3017_n ) capacitor c=0.0020642f \
 //x=13.44 //y=2.26 //x2=14.095 //y2=0.72
cc_1577 ( N_noxref_10_c_2283_n N_noxref_18_c_3017_n ) capacitor c=0.0194423f \
 //x=13.43 //y=1.095 //x2=14.095 //y2=0.72
cc_1578 ( N_noxref_10_c_2289_n N_noxref_18_c_3017_n ) capacitor c=0.00656458f \
 //x=13.96 //y=1.095 //x2=14.095 //y2=0.72
cc_1579 ( N_noxref_10_c_2292_n N_noxref_18_c_3017_n ) capacitor c=2.20712e-19 \
 //x=13.44 //y=2.26 //x2=14.095 //y2=0.72
cc_1580 ( N_noxref_10_c_2284_n N_noxref_18_c_3028_n ) capacitor c=0.00538829f \
 //x=13.43 //y=1.44 //x2=13.21 //y2=1.175
cc_1581 ( N_noxref_10_c_2283_n N_noxref_18_M8_noxref_s ) capacitor \
 c=0.00538829f //x=13.43 //y=1.095 //x2=13.075 //y2=0.555
cc_1582 ( N_noxref_10_c_2285_n N_noxref_18_M8_noxref_s ) capacitor \
 c=0.00538829f //x=13.43 //y=1.75 //x2=13.075 //y2=0.555
cc_1583 ( N_noxref_10_c_2289_n N_noxref_18_M8_noxref_s ) capacitor \
 c=0.0143002f //x=13.96 //y=1.095 //x2=13.075 //y2=0.555
cc_1584 ( N_noxref_10_c_2290_n N_noxref_18_M8_noxref_s ) capacitor \
 c=0.00290153f //x=13.96 //y=1.44 //x2=13.075 //y2=0.555
cc_1585 ( N_noxref_10_M11_noxref_d N_noxref_19_M9_noxref_s ) capacitor \
 c=0.00309936f //x=18.315 //y=1.095 //x2=15.375 //y2=0.555
cc_1586 ( N_noxref_10_c_2203_n N_noxref_20_c_3121_n ) capacitor c=0.00461497f \
 //x=18.905 //y=1.845 //x2=18.905 //y2=0.72
cc_1587 ( N_noxref_10_M11_noxref_d N_noxref_20_c_3121_n ) capacitor \
 c=0.0116817f //x=18.315 //y=1.095 //x2=18.905 //y2=0.72
cc_1588 ( N_noxref_10_c_2441_n N_noxref_20_c_3146_n ) capacitor c=0.0200405f \
 //x=18.59 //y=1.845 //x2=18.02 //y2=1.175
cc_1589 ( N_noxref_10_M11_noxref_d N_noxref_20_M10_noxref_d ) capacitor \
 c=5.27807e-19 //x=18.315 //y=1.095 //x2=16.78 //y2=1.09
cc_1590 ( N_noxref_10_c_2203_n N_noxref_20_M11_noxref_s ) capacitor \
 c=0.0201579f //x=18.905 //y=1.845 //x2=17.885 //y2=0.555
cc_1591 ( N_noxref_10_M11_noxref_d N_noxref_20_M11_noxref_s ) capacitor \
 c=0.0426368f //x=18.315 //y=1.095 //x2=17.885 //y2=0.555
cc_1592 ( N_noxref_10_c_2203_n N_noxref_21_c_3185_n ) capacitor c=3.84569e-19 \
 //x=18.905 //y=1.845 //x2=20.32 //y2=1.685
cc_1593 ( N_noxref_10_M11_noxref_d N_noxref_21_M12_noxref_s ) capacitor \
 c=2.55333e-19 //x=18.315 //y=1.095 //x2=20.185 //y2=0.555
cc_1594 ( N_noxref_10_c_2204_n N_noxref_24_c_3328_n ) capacitor c=0.00209116f \
 //x=27.87 //y=2.26 //x2=28.525 //y2=0.72
cc_1595 ( N_noxref_10_c_2456_n N_noxref_24_c_3328_n ) capacitor c=0.0194423f \
 //x=27.86 //y=1.095 //x2=28.525 //y2=0.72
cc_1596 ( N_noxref_10_c_2499_p N_noxref_24_c_3328_n ) capacitor c=0.00656458f \
 //x=28.39 //y=1.095 //x2=28.525 //y2=0.72
cc_1597 ( N_noxref_10_c_2466_n N_noxref_24_c_3328_n ) capacitor c=2.20712e-19 \
 //x=27.87 //y=2.26 //x2=28.525 //y2=0.72
cc_1598 ( N_noxref_10_c_2457_n N_noxref_24_c_3351_n ) capacitor c=0.00538829f \
 //x=27.86 //y=1.44 //x2=27.64 //y2=1.175
cc_1599 ( N_noxref_10_c_2456_n N_noxref_24_M17_noxref_s ) capacitor \
 c=0.00538829f //x=27.86 //y=1.095 //x2=27.505 //y2=0.555
cc_1600 ( N_noxref_10_c_2458_n N_noxref_24_M17_noxref_s ) capacitor \
 c=0.00538829f //x=27.86 //y=1.75 //x2=27.505 //y2=0.555
cc_1601 ( N_noxref_10_c_2499_p N_noxref_24_M17_noxref_s ) capacitor \
 c=0.0143002f //x=28.39 //y=1.095 //x2=27.505 //y2=0.555
cc_1602 ( N_noxref_10_c_2484_p N_noxref_24_M17_noxref_s ) capacitor \
 c=0.00290153f //x=28.39 //y=1.44 //x2=27.505 //y2=0.555
cc_1603 ( N_noxref_11_c_2541_n N_noxref_22_c_3225_n ) capacitor c=0.0020642f \
 //x=23.06 //y=2.26 //x2=23.715 //y2=0.72
cc_1604 ( N_noxref_11_c_2589_n N_noxref_22_c_3225_n ) capacitor c=0.0194423f \
 //x=23.05 //y=1.095 //x2=23.715 //y2=0.72
cc_1605 ( N_noxref_11_c_2621_n N_noxref_22_c_3225_n ) capacitor c=0.00656458f \
 //x=23.58 //y=1.095 //x2=23.715 //y2=0.72
cc_1606 ( N_noxref_11_c_2592_n N_noxref_22_c_3225_n ) capacitor c=2.20712e-19 \
 //x=23.06 //y=2.26 //x2=23.715 //y2=0.72
cc_1607 ( N_noxref_11_c_2590_n N_noxref_22_c_3248_n ) capacitor c=0.00538829f \
 //x=23.05 //y=1.44 //x2=22.83 //y2=1.175
cc_1608 ( N_noxref_11_c_2589_n N_noxref_22_M14_noxref_s ) capacitor \
 c=0.00538829f //x=23.05 //y=1.095 //x2=22.695 //y2=0.555
cc_1609 ( N_noxref_11_c_2591_n N_noxref_22_M14_noxref_s ) capacitor \
 c=0.00538829f //x=23.05 //y=1.75 //x2=22.695 //y2=0.555
cc_1610 ( N_noxref_11_c_2621_n N_noxref_22_M14_noxref_s ) capacitor \
 c=0.0143002f //x=23.58 //y=1.095 //x2=22.695 //y2=0.555
cc_1611 ( N_noxref_11_c_2622_n N_noxref_22_M14_noxref_s ) capacitor \
 c=0.00290153f //x=23.58 //y=1.44 //x2=22.695 //y2=0.555
cc_1612 ( N_noxref_11_c_2540_n N_noxref_23_c_3303_n ) capacitor c=0.00104728f \
 //x=28.495 //y=3.88 //x2=26.985 //y2=1.77
cc_1613 ( N_noxref_11_c_2540_n N_noxref_23_M15_noxref_s ) capacitor \
 c=0.00175826f //x=28.495 //y=3.88 //x2=24.995 //y2=0.555
cc_1614 ( N_noxref_11_M17_noxref_d N_noxref_23_M15_noxref_s ) capacitor \
 c=0.00309936f //x=27.935 //y=1.095 //x2=24.995 //y2=0.555
cc_1615 ( N_noxref_11_c_2540_n N_noxref_24_c_3323_n ) capacitor c=0.00250466f \
 //x=28.495 //y=3.88 //x2=27.555 //y2=1.175
cc_1616 ( N_noxref_11_c_2540_n N_noxref_24_c_3328_n ) capacitor c=3.47229e-19 \
 //x=28.495 //y=3.88 //x2=28.525 //y2=0.72
cc_1617 ( N_noxref_11_c_2542_n N_noxref_24_c_3328_n ) capacitor c=0.00467233f \
 //x=28.525 //y=1.845 //x2=28.525 //y2=0.72
cc_1618 ( N_noxref_11_M17_noxref_d N_noxref_24_c_3328_n ) capacitor \
 c=0.0118029f //x=27.935 //y=1.095 //x2=28.525 //y2=0.72
cc_1619 ( N_noxref_11_c_2692_p N_noxref_24_c_3351_n ) capacitor c=0.0200405f \
 //x=28.21 //y=1.845 //x2=27.64 //y2=1.175
cc_1620 ( N_noxref_11_M17_noxref_d N_noxref_24_M16_noxref_d ) capacitor \
 c=5.27807e-19 //x=27.935 //y=1.095 //x2=26.4 //y2=1.09
cc_1621 ( N_noxref_11_c_2540_n N_noxref_24_M17_noxref_s ) capacitor \
 c=0.00188576f //x=28.495 //y=3.88 //x2=27.505 //y2=0.555
cc_1622 ( N_noxref_11_c_2542_n N_noxref_24_M17_noxref_s ) capacitor \
 c=0.0209131f //x=28.525 //y=1.845 //x2=27.505 //y2=0.555
cc_1623 ( N_noxref_11_M17_noxref_d N_noxref_24_M17_noxref_s ) capacitor \
 c=0.0426368f //x=27.935 //y=1.095 //x2=27.505 //y2=0.555
cc_1624 ( N_D_c_2702_n N_noxref_13_c_2781_n ) capacitor c=0.0034165f //x=1.3 \
 //y=2.095 //x2=1.08 //y2=1.685
cc_1625 ( N_D_c_2697_n N_noxref_13_c_2753_n ) capacitor c=0.0122915f //x=1.6 \
 //y=2.26 //x2=1.965 //y2=1.77
cc_1626 ( N_D_c_2701_n N_noxref_13_c_2753_n ) capacitor c=0.00703864f //x=1.3 \
 //y=1.71 //x2=1.965 //y2=1.77
cc_1627 ( N_D_c_2702_n N_noxref_13_c_2753_n ) capacitor c=0.0259045f //x=1.3 \
 //y=2.095 //x2=1.965 //y2=1.77
cc_1628 ( N_D_c_2704_n N_noxref_13_c_2753_n ) capacitor c=0.00708583f \
 //x=1.675 //y=1.555 //x2=1.965 //y2=1.77
cc_1629 ( N_D_c_2707_n N_noxref_13_c_2753_n ) capacitor c=0.00698822f //x=1.83 \
 //y=1.4 //x2=1.965 //y2=1.77
cc_1630 ( N_D_c_2698_n N_noxref_13_M0_noxref_s ) capacitor c=0.0327271f \
 //x=1.3 //y=1.055 //x2=0.945 //y2=0.555
cc_1631 ( N_D_c_2701_n N_noxref_13_M0_noxref_s ) capacitor c=7.99997e-19 \
 //x=1.3 //y=1.71 //x2=0.945 //y2=0.555
cc_1632 ( N_D_c_2702_n N_noxref_13_M0_noxref_s ) capacitor c=0.00122123f \
 //x=1.3 //y=2.095 //x2=0.945 //y2=0.555
cc_1633 ( N_D_c_2705_n N_noxref_13_M0_noxref_s ) capacitor c=0.0121427f \
 //x=1.83 //y=1.055 //x2=0.945 //y2=0.555
cc_1634 ( N_noxref_13_c_2760_n N_noxref_14_c_2799_n ) capacitor c=0.0136048f \
 //x=2.935 //y=0.72 //x2=3.505 //y2=1.175
cc_1635 ( N_noxref_13_c_2772_n N_noxref_14_c_2799_n ) capacitor c=0.0102333f \
 //x=2.935 //y=1.77 //x2=3.505 //y2=1.175
cc_1636 ( N_noxref_13_M0_noxref_s N_noxref_14_c_2799_n ) capacitor c=0.023344f \
 //x=0.945 //y=0.555 //x2=3.505 //y2=1.175
cc_1637 ( N_noxref_13_M0_noxref_s N_noxref_14_c_2802_n ) capacitor \
 c=0.0180035f //x=0.945 //y=0.555 //x2=3.59 //y2=0.805
cc_1638 ( N_noxref_13_c_2760_n N_noxref_14_M1_noxref_d ) capacitor \
 c=0.0129526f //x=2.935 //y=0.72 //x2=2.35 //y2=1.09
cc_1639 ( N_noxref_13_c_2772_n N_noxref_14_M1_noxref_d ) capacitor \
 c=0.00912489f //x=2.935 //y=1.77 //x2=2.35 //y2=1.09
cc_1640 ( N_noxref_13_M0_noxref_s N_noxref_14_M1_noxref_d ) capacitor \
 c=0.0159202f //x=0.945 //y=0.555 //x2=2.35 //y2=1.09
cc_1641 ( N_noxref_13_M0_noxref_s N_noxref_14_M2_noxref_s ) capacitor \
 c=0.0213553f //x=0.945 //y=0.555 //x2=3.455 //y2=0.555
cc_1642 ( N_noxref_14_c_2808_n N_noxref_15_M3_noxref_s ) capacitor \
 c=0.00191848f //x=4.56 //y=0.805 //x2=5.755 //y2=0.555
cc_1643 ( N_noxref_15_c_2859_n N_noxref_16_c_2904_n ) capacitor c=0.0133829f \
 //x=7.745 //y=0.72 //x2=8.315 //y2=1.175
cc_1644 ( N_noxref_15_c_2879_n N_noxref_16_c_2904_n ) capacitor c=0.0101148f \
 //x=7.745 //y=1.77 //x2=8.315 //y2=1.175
cc_1645 ( N_noxref_15_M3_noxref_s N_noxref_16_c_2904_n ) capacitor \
 c=0.0226294f //x=5.755 //y=0.555 //x2=8.315 //y2=1.175
cc_1646 ( N_noxref_15_M3_noxref_s N_noxref_16_c_2907_n ) capacitor \
 c=0.0180035f //x=5.755 //y=0.555 //x2=8.4 //y2=0.805
cc_1647 ( N_noxref_15_c_2859_n N_noxref_16_M4_noxref_d ) capacitor \
 c=0.0128573f //x=7.745 //y=0.72 //x2=7.16 //y2=1.09
cc_1648 ( N_noxref_15_c_2879_n N_noxref_16_M4_noxref_d ) capacitor \
 c=0.00892105f //x=7.745 //y=1.77 //x2=7.16 //y2=1.09
cc_1649 ( N_noxref_15_M3_noxref_s N_noxref_16_M4_noxref_d ) capacitor \
 c=0.0159202f //x=5.755 //y=0.555 //x2=7.16 //y2=1.09
cc_1650 ( N_noxref_15_M3_noxref_s N_noxref_16_M5_noxref_s ) capacitor \
 c=0.0213553f //x=5.755 //y=0.555 //x2=8.265 //y2=0.555
cc_1651 ( N_noxref_16_c_2913_n N_noxref_17_M6_noxref_s ) capacitor \
 c=0.00191848f //x=9.37 //y=0.805 //x2=10.565 //y2=0.555
cc_1652 ( N_noxref_17_c_2965_n N_noxref_18_c_3011_n ) capacitor c=0.0133023f \
 //x=12.555 //y=0.72 //x2=13.125 //y2=1.175
cc_1653 ( N_noxref_17_c_2988_n N_noxref_18_c_3011_n ) capacitor c=0.0100045f \
 //x=12.555 //y=1.77 //x2=13.125 //y2=1.175
cc_1654 ( N_noxref_17_M6_noxref_s N_noxref_18_c_3011_n ) capacitor \
 c=0.0224465f //x=10.565 //y=0.555 //x2=13.125 //y2=1.175
cc_1655 ( N_noxref_17_M6_noxref_s N_noxref_18_c_3014_n ) capacitor \
 c=0.0180035f //x=10.565 //y=0.555 //x2=13.21 //y2=0.805
cc_1656 ( N_noxref_17_c_2965_n N_noxref_18_M7_noxref_d ) capacitor \
 c=0.0128594f //x=12.555 //y=0.72 //x2=11.97 //y2=1.09
cc_1657 ( N_noxref_17_c_2988_n N_noxref_18_M7_noxref_d ) capacitor \
 c=0.00891539f //x=12.555 //y=1.77 //x2=11.97 //y2=1.09
cc_1658 ( N_noxref_17_M6_noxref_s N_noxref_18_M7_noxref_d ) capacitor \
 c=0.0159202f //x=10.565 //y=0.555 //x2=11.97 //y2=1.09
cc_1659 ( N_noxref_17_M6_noxref_s N_noxref_18_M8_noxref_s ) capacitor \
 c=0.0213553f //x=10.565 //y=0.555 //x2=13.075 //y2=0.555
cc_1660 ( N_noxref_18_c_3020_n N_noxref_19_M9_noxref_s ) capacitor \
 c=0.00191848f //x=14.18 //y=0.805 //x2=15.375 //y2=0.555
cc_1661 ( N_noxref_19_c_3072_n N_noxref_20_c_3115_n ) capacitor c=0.0133059f \
 //x=17.365 //y=0.72 //x2=17.935 //y2=1.175
cc_1662 ( N_noxref_19_c_3095_n N_noxref_20_c_3115_n ) capacitor c=0.0100097f \
 //x=17.365 //y=1.77 //x2=17.935 //y2=1.175
cc_1663 ( N_noxref_19_M9_noxref_s N_noxref_20_c_3115_n ) capacitor \
 c=0.0224457f //x=15.375 //y=0.555 //x2=17.935 //y2=1.175
cc_1664 ( N_noxref_19_M9_noxref_s N_noxref_20_c_3118_n ) capacitor \
 c=0.0180035f //x=15.375 //y=0.555 //x2=18.02 //y2=0.805
cc_1665 ( N_noxref_19_c_3072_n N_noxref_20_M10_noxref_d ) capacitor \
 c=0.0128027f //x=17.365 //y=0.72 //x2=16.78 //y2=1.09
cc_1666 ( N_noxref_19_c_3095_n N_noxref_20_M10_noxref_d ) capacitor \
 c=0.00879751f //x=17.365 //y=1.77 //x2=16.78 //y2=1.09
cc_1667 ( N_noxref_19_M9_noxref_s N_noxref_20_M10_noxref_d ) capacitor \
 c=0.0159202f //x=15.375 //y=0.555 //x2=16.78 //y2=1.09
cc_1668 ( N_noxref_19_M9_noxref_s N_noxref_20_M11_noxref_s ) capacitor \
 c=0.0213553f //x=15.375 //y=0.555 //x2=17.885 //y2=0.555
cc_1669 ( N_noxref_20_c_3124_n N_noxref_21_M12_noxref_s ) capacitor \
 c=0.00191848f //x=18.99 //y=0.805 //x2=20.185 //y2=0.555
cc_1670 ( N_noxref_21_c_3176_n N_noxref_22_c_3219_n ) capacitor c=0.0133059f \
 //x=22.175 //y=0.72 //x2=22.745 //y2=1.175
cc_1671 ( N_noxref_21_c_3197_n N_noxref_22_c_3219_n ) capacitor c=0.0100097f \
 //x=22.175 //y=1.77 //x2=22.745 //y2=1.175
cc_1672 ( N_noxref_21_M12_noxref_s N_noxref_22_c_3219_n ) capacitor \
 c=0.0224457f //x=20.185 //y=0.555 //x2=22.745 //y2=1.175
cc_1673 ( N_noxref_21_M12_noxref_s N_noxref_22_c_3222_n ) capacitor \
 c=0.0180035f //x=20.185 //y=0.555 //x2=22.83 //y2=0.805
cc_1674 ( N_noxref_21_c_3176_n N_noxref_22_M13_noxref_d ) capacitor \
 c=0.0128027f //x=22.175 //y=0.72 //x2=21.59 //y2=1.09
cc_1675 ( N_noxref_21_c_3197_n N_noxref_22_M13_noxref_d ) capacitor \
 c=0.00879751f //x=22.175 //y=1.77 //x2=21.59 //y2=1.09
cc_1676 ( N_noxref_21_M12_noxref_s N_noxref_22_M13_noxref_d ) capacitor \
 c=0.0159202f //x=20.185 //y=0.555 //x2=21.59 //y2=1.09
cc_1677 ( N_noxref_21_M12_noxref_s N_noxref_22_M14_noxref_s ) capacitor \
 c=0.0213553f //x=20.185 //y=0.555 //x2=22.695 //y2=0.555
cc_1678 ( N_noxref_22_c_3228_n N_noxref_23_M15_noxref_s ) capacitor \
 c=0.00191848f //x=23.8 //y=0.805 //x2=24.995 //y2=0.555
cc_1679 ( N_noxref_23_c_3280_n N_noxref_24_c_3323_n ) capacitor c=0.0133434f \
 //x=26.985 //y=0.72 //x2=27.555 //y2=1.175
cc_1680 ( N_noxref_23_c_3303_n N_noxref_24_c_3323_n ) capacitor c=0.0100618f \
 //x=26.985 //y=1.77 //x2=27.555 //y2=1.175
cc_1681 ( N_noxref_23_M15_noxref_s N_noxref_24_c_3323_n ) capacitor \
 c=0.0228195f //x=24.995 //y=0.555 //x2=27.555 //y2=1.175
cc_1682 ( N_noxref_23_M15_noxref_s N_noxref_24_c_3325_n ) capacitor \
 c=0.0180035f //x=24.995 //y=0.555 //x2=27.64 //y2=0.805
cc_1683 ( N_noxref_23_c_3280_n N_noxref_24_M16_noxref_d ) capacitor \
 c=0.0128018f //x=26.985 //y=0.72 //x2=26.4 //y2=1.09
cc_1684 ( N_noxref_23_c_3303_n N_noxref_24_M16_noxref_d ) capacitor \
 c=0.00879464f //x=26.985 //y=1.77 //x2=26.4 //y2=1.09
cc_1685 ( N_noxref_23_M15_noxref_s N_noxref_24_M16_noxref_d ) capacitor \
 c=0.0159202f //x=24.995 //y=0.555 //x2=26.4 //y2=1.09
cc_1686 ( N_noxref_23_M15_noxref_s N_noxref_24_M17_noxref_s ) capacitor \
 c=0.0213553f //x=24.995 //y=0.555 //x2=27.505 //y2=0.555
