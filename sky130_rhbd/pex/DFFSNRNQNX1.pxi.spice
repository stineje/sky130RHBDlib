// File: DFFSNRNQNX1.spi.DFFSNRNQNX1.pxi
// Created: Fri Feb 20 10:11:09 2026
//
simulator lang=spectre
x_PM_DFFSNRNQNX1\%noxref_1 ( N_noxref_1_c_154_p N_noxref_1_c_74_p \
 N_noxref_1_c_96_p N_noxref_1_c_75_p N_noxref_1_c_76_p N_noxref_1_c_131_p \
 N_noxref_1_c_86_p N_noxref_1_c_77_p N_noxref_1_c_9_p N_noxref_1_c_68_p \
 N_noxref_1_c_17_p N_noxref_1_c_21_p N_noxref_1_c_10_p N_noxref_1_c_11_p \
 N_noxref_1_c_12_p N_noxref_1_c_88_p N_noxref_1_c_89_p N_noxref_1_c_33_p \
 N_noxref_1_c_34_p N_noxref_1_c_235_p N_noxref_1_c_155_p N_noxref_1_c_82_p \
 N_noxref_1_c_72_p N_noxref_1_c_13_p N_noxref_1_c_5_p N_noxref_1_c_106_p \
 N_noxref_1_c_73_p N_noxref_1_c_14_p N_noxref_1_c_15_p N_noxref_1_c_237_p \
 N_noxref_1_c_156_p N_noxref_1_c_83_p N_noxref_1_c_16_p N_noxref_1_c_19_p \
 N_noxref_1_c_178_p N_noxref_1_c_188_p N_noxref_1_M3_noxref_g \
 N_noxref_1_M6_noxref_g N_noxref_1_M24_noxref_g N_noxref_1_M25_noxref_g \
 N_noxref_1_M30_noxref_g N_noxref_1_M31_noxref_g N_noxref_1_c_51_p \
 N_noxref_1_c_52_p N_noxref_1_c_54_p N_noxref_1_c_24_p N_noxref_1_c_323_p \
 N_noxref_1_c_337_p N_noxref_1_c_53_p N_noxref_1_c_55_p N_noxref_1_c_29_p \
 N_noxref_1_c_30_p N_noxref_1_c_204_p N_noxref_1_c_205_p N_noxref_1_c_207_p \
 N_noxref_1_c_179_p N_noxref_1_c_326_p N_noxref_1_c_348_p N_noxref_1_c_206_p \
 N_noxref_1_c_208_p N_noxref_1_c_4_p N_noxref_1_c_190_p N_noxref_1_M2_noxref_d \
 N_noxref_1_M18_noxref_d N_noxref_1_M20_noxref_d N_noxref_1_M22_noxref_d )  \
 PM_DFFSNRNQNX1\%noxref_1
x_PM_DFFSNRNQNX1\%noxref_2 ( N_noxref_2_c_415_n N_noxref_2_c_519_p \
 N_noxref_2_c_527_p N_noxref_2_c_486_p N_noxref_2_c_499_p N_noxref_2_c_597_p \
 N_noxref_2_c_500_p N_noxref_2_c_480_p N_noxref_2_c_423_p N_noxref_2_c_440_p \
 N_noxref_2_c_435_p N_noxref_2_c_431_p N_noxref_2_c_424_p N_noxref_2_c_425_p \
 N_noxref_2_c_426_p N_noxref_2_c_416_n N_noxref_2_c_490_p N_noxref_2_c_616_p \
 N_noxref_2_c_419_n N_noxref_2_c_427_p N_noxref_2_c_445_p N_noxref_2_c_442_p \
 N_noxref_2_c_428_p N_noxref_2_c_420_n N_noxref_2_c_494_p N_noxref_2_c_547_p \
 N_noxref_2_c_429_p N_noxref_2_c_437_p N_noxref_2_M9_noxref_g \
 N_noxref_2_M36_noxref_g N_noxref_2_M37_noxref_g N_noxref_2_c_463_p \
 N_noxref_2_c_464_p N_noxref_2_c_466_p N_noxref_2_c_433_p N_noxref_2_c_660_p \
 N_noxref_2_c_670_p N_noxref_2_c_465_p N_noxref_2_c_467_p N_noxref_2_c_438_p \
 N_noxref_2_c_439_p N_noxref_2_M8_noxref_d N_noxref_2_M30_noxref_d \
 N_noxref_2_M32_noxref_d N_noxref_2_M34_noxref_d )  PM_DFFSNRNQNX1\%noxref_2
x_PM_DFFSNRNQNX1\%CLK ( CLK CLK CLK CLK CLK N_CLK_c_715_n N_CLK_c_719_n \
 N_CLK_c_721_n N_CLK_c_768_n N_CLK_c_771_n N_CLK_c_772_n N_CLK_c_725_n \
 N_CLK_c_726_n N_CLK_c_727_n N_CLK_c_730_n N_CLK_c_777_n N_CLK_c_780_n \
 N_CLK_c_783_n N_CLK_c_787_n N_CLK_c_732_n N_CLK_c_734_n N_CLK_c_738_n \
 N_CLK_c_789_n N_CLK_c_793_n N_CLK_M4_noxref_g N_CLK_M10_noxref_g \
 N_CLK_M26_noxref_g N_CLK_M27_noxref_g N_CLK_M38_noxref_g N_CLK_M39_noxref_g \
 N_CLK_c_745_n N_CLK_c_748_n N_CLK_c_988_p N_CLK_c_989_p N_CLK_c_750_n \
 N_CLK_c_751_n N_CLK_c_752_n N_CLK_c_753_n N_CLK_c_831_p N_CLK_c_800_n \
 N_CLK_c_803_n N_CLK_c_1005_p N_CLK_c_1006_p N_CLK_c_805_n N_CLK_c_806_n \
 N_CLK_c_807_n N_CLK_c_808_n N_CLK_c_892_p N_CLK_c_756_n N_CLK_c_811_n )  \
 PM_DFFSNRNQNX1\%CLK
x_PM_DFFSNRNQNX1\%noxref_4 ( N_noxref_4_c_1040_n N_noxref_4_c_1041_n \
 N_noxref_4_c_1048_n N_noxref_4_c_1053_n N_noxref_4_c_1058_n \
 N_noxref_4_c_1137_n N_noxref_4_c_1126_n N_noxref_4_c_1127_n \
 N_noxref_4_c_1059_n N_noxref_4_c_1350_p N_noxref_4_c_1128_n \
 N_noxref_4_c_1060_n N_noxref_4_c_1062_n N_noxref_4_c_1067_n \
 N_noxref_4_c_1068_n N_noxref_4_c_1193_p N_noxref_4_c_1180_p \
 N_noxref_4_c_1185_p N_noxref_4_c_1181_p N_noxref_4_c_1069_n \
 N_noxref_4_c_1070_n N_noxref_4_c_1143_n N_noxref_4_c_1213_p \
 N_noxref_4_c_1292_p N_noxref_4_c_1187_p N_noxref_4_c_1075_n \
 N_noxref_4_c_1083_n N_noxref_4_c_1084_n N_noxref_4_c_1085_n \
 N_noxref_4_c_1214_p N_noxref_4_c_1157_n N_noxref_4_c_1086_n \
 N_noxref_4_c_1183_p N_noxref_4_c_1188_p N_noxref_4_c_1088_n \
 N_noxref_4_c_1089_n N_noxref_4_c_1093_n N_noxref_4_c_1169_n \
 N_noxref_4_c_1302_p N_noxref_4_c_1189_p N_noxref_4_c_1200_p \
 N_noxref_4_M2_noxref_g N_noxref_4_M12_noxref_g N_noxref_4_M22_noxref_g \
 N_noxref_4_M23_noxref_g N_noxref_4_M42_noxref_g N_noxref_4_M43_noxref_g \
 N_noxref_4_c_1102_n N_noxref_4_c_1104_n N_noxref_4_c_1107_n \
 N_noxref_4_c_1108_n N_noxref_4_c_1110_n N_noxref_4_c_1114_n \
 N_noxref_4_c_1116_n N_noxref_4_c_1252_p N_noxref_4_c_1253_p \
 N_noxref_4_c_1255_p N_noxref_4_c_1195_p N_noxref_4_c_1467_p \
 N_noxref_4_c_1477_p N_noxref_4_c_1254_p N_noxref_4_c_1256_p \
 N_noxref_4_c_1201_p N_noxref_4_c_1202_p N_noxref_4_c_1120_n \
 N_noxref_4_c_1121_n N_noxref_4_c_1123_n N_noxref_4_M5_noxref_d \
 N_noxref_4_M24_noxref_d N_noxref_4_M26_noxref_d N_noxref_4_M28_noxref_d )  \
 PM_DFFSNRNQNX1\%noxref_4
x_PM_DFFSNRNQNX1\%RN ( RN RN RN RN RN RN RN RN RN RN RN RN RN N_RN_c_1598_n \
 N_RN_c_1551_n N_RN_c_1601_n N_RN_c_1515_n N_RN_c_1554_n N_RN_c_1607_n \
 N_RN_c_1518_n N_RN_c_1620_n N_RN_c_1623_n N_RN_c_1524_n N_RN_c_1525_n \
 N_RN_c_1631_n N_RN_c_1527_n N_RN_c_1561_n N_RN_c_1565_n N_RN_c_1638_n \
 N_RN_c_1642_n N_RN_M1_noxref_g N_RN_M11_noxref_g N_RN_M13_noxref_g \
 N_RN_M20_noxref_g N_RN_M21_noxref_g N_RN_M40_noxref_g N_RN_M41_noxref_g \
 N_RN_M44_noxref_g N_RN_M45_noxref_g N_RN_c_1851_p N_RN_c_1853_p N_RN_c_1875_p \
 N_RN_c_1876_p N_RN_c_1652_n N_RN_c_1653_n N_RN_c_1654_n N_RN_c_1655_n \
 N_RN_c_1535_n N_RN_c_1571_n N_RN_c_1572_n N_RN_c_1573_n N_RN_c_1718_p \
 N_RN_c_1719_p N_RN_c_1720_p N_RN_c_1721_p N_RN_c_1660_n N_RN_c_1663_n \
 N_RN_c_1902_p N_RN_c_1903_p N_RN_c_1665_n N_RN_c_1666_n N_RN_c_1667_n \
 N_RN_c_1668_n N_RN_c_1691_p N_RN_c_1537_n N_RN_c_1574_n N_RN_c_1577_n \
 N_RN_c_1578_n N_RN_c_1674_n )  PM_DFFSNRNQNX1\%RN
x_PM_DFFSNRNQNX1\%QN ( QN QN QN QN QN QN QN QN QN N_QN_c_1936_n N_QN_c_1950_n \
 N_QN_c_2052_p N_QN_c_2028_p N_QN_c_1983_p N_QN_c_2087_p N_QN_c_2050_p \
 N_QN_c_1984_p N_QN_c_1985_p N_QN_c_1962_p N_QN_c_1974_p N_QN_c_1975_p \
 N_QN_c_1937_n N_QN_c_1952_n N_QN_c_2030_p N_QN_c_1988_p N_QN_c_1989_p \
 N_QN_c_1976_p N_QN_c_1940_n N_QN_c_1958_n N_QN_c_2048_p N_QN_c_1963_p \
 N_QN_c_1977_p N_QN_M15_noxref_g N_QN_M48_noxref_g N_QN_M49_noxref_g \
 N_QN_c_2003_p N_QN_c_2004_p N_QN_c_2006_p N_QN_c_1964_p N_QN_c_2178_p \
 N_QN_c_2188_p N_QN_c_2005_p N_QN_c_2007_p N_QN_c_1978_p N_QN_c_1979_p \
 N_QN_M14_noxref_d N_QN_M42_noxref_d N_QN_M44_noxref_d N_QN_M46_noxref_d )  \
 PM_DFFSNRNQNX1\%QN
x_PM_DFFSNRNQNX1\%SN ( SN N_SN_c_2222_n N_SN_c_2225_n N_SN_c_2227_n \
 N_SN_c_2228_n N_SN_c_2327_n N_SN_c_2330_n N_SN_c_2333_n N_SN_c_2334_n \
 N_SN_c_2236_n N_SN_c_2345_n N_SN_c_2272_n N_SN_c_2276_n N_SN_c_2280_n \
 N_SN_c_2283_n N_SN_c_2237_n N_SN_c_2238_n N_SN_c_2242_n N_SN_c_2356_n \
 N_SN_c_2360_n N_SN_M7_noxref_g N_SN_M16_noxref_g N_SN_M32_noxref_g \
 N_SN_M33_noxref_g N_SN_M50_noxref_g N_SN_M51_noxref_g N_SN_c_2249_n \
 N_SN_c_2252_n N_SN_c_2477_p N_SN_c_2478_p N_SN_c_2254_n N_SN_c_2255_n \
 N_SN_c_2256_n N_SN_c_2257_n N_SN_c_2295_n N_SN_c_2368_n N_SN_c_2371_n \
 N_SN_c_2554_p N_SN_c_2555_p N_SN_c_2373_n N_SN_c_2374_n N_SN_c_2375_n \
 N_SN_c_2376_n N_SN_c_2425_p N_SN_c_2260_n N_SN_c_2379_n )  PM_DFFSNRNQNX1\%SN
x_PM_DFFSNRNQNX1\%noxref_8 ( N_noxref_8_c_2597_n N_noxref_8_c_2598_n \
 N_noxref_8_c_2628_n N_noxref_8_c_2603_n N_noxref_8_c_2606_n \
 N_noxref_8_c_2638_n N_noxref_8_c_2777_n N_noxref_8_c_2779_n \
 N_noxref_8_c_2783_n N_noxref_8_c_2789_n N_noxref_8_c_2794_n \
 N_noxref_8_c_2607_n N_noxref_8_c_2639_n N_noxref_8_c_2711_n \
 N_noxref_8_c_2641_n N_noxref_8_c_2858_n N_noxref_8_c_2844_n \
 N_noxref_8_c_2867_n N_noxref_8_c_2846_n N_noxref_8_c_2642_n \
 N_noxref_8_c_2608_n N_noxref_8_c_2643_n N_noxref_8_c_2814_n \
 N_noxref_8_c_2817_n N_noxref_8_c_2871_n N_noxref_8_c_2649_n \
 N_noxref_8_c_2650_n N_noxref_8_c_2723_n N_noxref_8_c_2605_n \
 N_noxref_8_c_2826_n N_noxref_8_c_2849_n N_noxref_8_c_2659_n \
 N_noxref_8_c_2660_n N_noxref_8_c_2664_n N_noxref_8_c_2615_n \
 N_noxref_8_c_2668_n N_noxref_8_c_2830_n N_noxref_8_c_2878_n \
 N_noxref_8_c_2882_n N_noxref_8_M5_noxref_g N_noxref_8_M17_noxref_g \
 N_noxref_8_M28_noxref_g N_noxref_8_M29_noxref_g N_noxref_8_M52_noxref_g \
 N_noxref_8_M53_noxref_g N_noxref_8_c_2675_n N_noxref_8_c_2676_n \
 N_noxref_8_c_2677_n N_noxref_8_c_2751_n N_noxref_8_c_2753_n \
 N_noxref_8_c_2757_n N_noxref_8_c_2759_n N_noxref_8_c_2888_n \
 N_noxref_8_c_2889_n N_noxref_8_c_2890_n N_noxref_8_c_2915_p \
 N_noxref_8_c_2916_p N_noxref_8_c_2917_p N_noxref_8_c_2918_p \
 N_noxref_8_c_2678_n N_noxref_8_c_2681_n N_noxref_8_c_2682_n \
 N_noxref_8_c_2891_n N_noxref_8_c_2894_n N_noxref_8_c_2895_n \
 N_noxref_8_M11_noxref_d N_noxref_8_M36_noxref_d N_noxref_8_M38_noxref_d \
 N_noxref_8_M40_noxref_d )  PM_DFFSNRNQNX1\%noxref_8
x_PM_DFFSNRNQNX1\%noxref_9 ( N_noxref_9_c_3091_n N_noxref_9_c_3087_n \
 N_noxref_9_c_3096_n N_noxref_9_c_3088_n N_noxref_9_c_3141_n \
 N_noxref_9_c_3208_n N_noxref_9_c_3238_n N_noxref_9_c_3240_n \
 N_noxref_9_c_3245_n N_noxref_9_c_3251_n N_noxref_9_c_3256_n \
 N_noxref_9_c_3142_n N_noxref_9_c_3209_n N_noxref_9_c_3263_n \
 N_noxref_9_c_3211_n N_noxref_9_c_3089_n N_noxref_9_c_3144_n \
 N_noxref_9_c_3212_n N_noxref_9_c_3273_n N_noxref_9_c_3276_n \
 N_noxref_9_c_3149_n N_noxref_9_c_3152_n N_noxref_9_c_3155_n \
 N_noxref_9_c_3159_n N_noxref_9_c_3223_n N_noxref_9_c_3284_n \
 N_noxref_9_c_3090_n N_noxref_9_c_3103_n N_noxref_9_c_3107_n \
 N_noxref_9_c_3167_n N_noxref_9_c_3227_n N_noxref_9_c_3289_n \
 N_noxref_9_M14_noxref_g N_noxref_9_M46_noxref_g N_noxref_9_M47_noxref_g \
 N_noxref_9_c_3113_n N_noxref_9_c_3114_n N_noxref_9_c_3115_n \
 N_noxref_9_c_3182_n N_noxref_9_c_3184_n N_noxref_9_c_3188_n \
 N_noxref_9_c_3190_n N_noxref_9_c_3116_n N_noxref_9_c_3119_n \
 N_noxref_9_c_3120_n N_noxref_9_M17_noxref_d N_noxref_9_M48_noxref_d \
 N_noxref_9_M50_noxref_d N_noxref_9_M52_noxref_d )  PM_DFFSNRNQNX1\%noxref_9
x_PM_DFFSNRNQNX1\%VDD ( VDD N_VDD_c_3378_n N_VDD_c_3390_n N_VDD_c_3392_n \
 N_VDD_c_3395_n N_VDD_c_3399_n N_VDD_c_3403_n N_VDD_c_3404_n N_VDD_c_3496_n \
 N_VDD_c_3524_n N_VDD_c_3528_n N_VDD_c_3406_n N_VDD_c_3457_n N_VDD_c_3461_n \
 N_VDD_c_3465_n N_VDD_c_3466_n N_VDD_c_3498_n N_VDD_c_3566_n N_VDD_c_3672_n \
 N_VDD_c_3529_n N_VDD_c_3568_n N_VDD_c_3604_n N_VDD_c_3608_n N_VDD_c_3609_n \
 N_VDD_c_3642_n N_VDD_c_3674_n N_VDD_c_3676_n N_VDD_c_3408_n N_VDD_c_3414_n \
 N_VDD_c_3470_n N_VDD_c_3539_n N_VDD_c_3613_n N_VDD_M18_noxref_s \
 N_VDD_M19_noxref_d N_VDD_M21_noxref_d N_VDD_M23_noxref_d N_VDD_M24_noxref_s \
 N_VDD_M25_noxref_d N_VDD_M27_noxref_d N_VDD_M29_noxref_d N_VDD_M30_noxref_s \
 N_VDD_M31_noxref_d N_VDD_M33_noxref_d N_VDD_M35_noxref_d N_VDD_M36_noxref_s \
 N_VDD_M37_noxref_d N_VDD_M39_noxref_d N_VDD_M41_noxref_d N_VDD_M42_noxref_s \
 N_VDD_M43_noxref_d N_VDD_M45_noxref_d N_VDD_M47_noxref_d N_VDD_M48_noxref_s \
 N_VDD_M49_noxref_d N_VDD_M51_noxref_d N_VDD_M53_noxref_d )  PM_DFFSNRNQNX1\%VDD
x_PM_DFFSNRNQNX1\%D ( D D D D D D N_D_c_3798_n N_D_c_3801_n N_D_c_3805_n \
 N_D_c_3809_n N_D_M0_noxref_g N_D_M18_noxref_g N_D_M19_noxref_g N_D_c_3815_n \
 N_D_c_3816_n N_D_c_3817_n N_D_c_3818_n N_D_c_3844_p N_D_c_3852_p N_D_c_3821_n \
 N_D_c_3823_n N_D_c_3789_n N_D_c_3829_n )  PM_DFFSNRNQNX1\%D
x_PM_DFFSNRNQNX1\%noxref_12 ( N_noxref_12_c_3901_n N_noxref_12_c_3917_p \
 N_noxref_12_c_3880_n N_noxref_12_c_3919_p N_noxref_12_c_3883_n \
 N_noxref_12_M1_noxref_d N_noxref_12_M2_noxref_s )  PM_DFFSNRNQNX1\%noxref_12
x_PM_DFFSNRNQNX1\%noxref_13 ( N_noxref_13_c_3945_n N_noxref_13_c_3986_p \
 N_noxref_13_c_3964_n N_noxref_13_c_3988_p N_noxref_13_c_3967_n \
 N_noxref_13_M4_noxref_d N_noxref_13_M5_noxref_s )  PM_DFFSNRNQNX1\%noxref_13
x_PM_DFFSNRNQNX1\%noxref_14 ( N_noxref_14_c_4026_n N_noxref_14_c_4058_p \
 N_noxref_14_c_4014_n N_noxref_14_c_4060_p N_noxref_14_c_4017_n \
 N_noxref_14_M7_noxref_d N_noxref_14_M8_noxref_s )  PM_DFFSNRNQNX1\%noxref_14
x_PM_DFFSNRNQNX1\%noxref_15 ( N_noxref_15_c_4089_n N_noxref_15_c_4086_n \
 N_noxref_15_c_4097_n N_noxref_15_c_4088_n N_noxref_15_c_4106_n \
 N_noxref_15_c_4107_n N_noxref_15_c_4108_n N_noxref_15_M8_noxref_g \
 N_noxref_15_M34_noxref_g N_noxref_15_M35_noxref_g N_noxref_15_c_4118_n \
 N_noxref_15_c_4120_n N_noxref_15_c_4123_n N_noxref_15_c_4124_n \
 N_noxref_15_c_4126_n N_noxref_15_c_4130_n N_noxref_15_c_4132_n \
 N_noxref_15_c_4136_n N_noxref_15_c_4137_n N_noxref_15_c_4139_n )  \
 PM_DFFSNRNQNX1\%noxref_15
x_PM_DFFSNRNQNX1\%noxref_16 ( N_noxref_16_c_4211_n N_noxref_16_c_4253_p \
 N_noxref_16_c_4227_n N_noxref_16_c_4255_p N_noxref_16_c_4232_n \
 N_noxref_16_M10_noxref_d N_noxref_16_M11_noxref_s )  PM_DFFSNRNQNX1\%noxref_16
x_PM_DFFSNRNQNX1\%noxref_17 ( N_noxref_17_c_4281_n N_noxref_17_c_4323_p \
 N_noxref_17_c_4296_n N_noxref_17_c_4325_p N_noxref_17_c_4299_n \
 N_noxref_17_M13_noxref_d N_noxref_17_M14_noxref_s )  PM_DFFSNRNQNX1\%noxref_17
x_PM_DFFSNRNQNX1\%GND ( GND N_GND_c_4717_p N_GND_c_4587_n N_GND_c_4351_n \
 N_GND_c_4355_n N_GND_c_4452_n N_GND_c_4358_n N_GND_c_4416_n N_GND_c_4420_n \
 N_GND_c_4454_n N_GND_c_4460_n N_GND_c_4497_n N_GND_c_4505_n N_GND_c_4539_n \
 N_GND_c_4579_n N_GND_c_4361_n N_GND_c_4373_n N_GND_c_4423_n N_GND_c_4464_n \
 N_GND_c_4508_n N_GND_c_4384_n N_GND_c_4580_n N_GND_c_4386_n N_GND_c_4387_n \
 N_GND_c_4436_n N_GND_c_4476_n N_GND_c_4521_n N_GND_c_4388_n N_GND_c_4396_n \
 N_GND_c_4437_n N_GND_c_4482_n N_GND_c_4522_n N_GND_M0_noxref_d \
 N_GND_M3_noxref_d N_GND_M6_noxref_d N_GND_M9_noxref_d N_GND_M12_noxref_d \
 N_GND_M15_noxref_d )  PM_DFFSNRNQNX1\%GND
x_PM_DFFSNRNQNX1\%noxref_19 ( N_noxref_19_c_4836_n N_noxref_19_c_4878_n \
 N_noxref_19_c_4853_n N_noxref_19_c_4882_n N_noxref_19_c_4858_n \
 N_noxref_19_M16_noxref_d N_noxref_19_M17_noxref_s )  PM_DFFSNRNQNX1\%noxref_19
x_PM_DFFSNRNQNX1\%noxref_20 ( N_noxref_20_c_4909_n N_noxref_20_c_4910_n \
 N_noxref_20_c_4921_n N_noxref_20_c_4899_n N_noxref_20_c_4901_n \
 N_noxref_20_M0_noxref_s )  PM_DFFSNRNQNX1\%noxref_20
x_PM_DFFSNRNQNX1\%noxref_21 ( N_noxref_21_c_4951_n N_noxref_21_c_4953_n \
 N_noxref_21_c_4982_n N_noxref_21_c_4969_n N_noxref_21_c_4962_n \
 N_noxref_21_M3_noxref_s )  PM_DFFSNRNQNX1\%noxref_21
x_PM_DFFSNRNQNX1\%noxref_22 ( N_noxref_22_c_5012_n N_noxref_22_c_5014_n \
 N_noxref_22_c_5043_n N_noxref_22_c_5029_n N_noxref_22_c_5027_n \
 N_noxref_22_M6_noxref_s )  PM_DFFSNRNQNX1\%noxref_22
x_PM_DFFSNRNQNX1\%noxref_23 ( N_noxref_23_c_5073_n N_noxref_23_c_5074_n \
 N_noxref_23_c_5102_n N_noxref_23_c_5085_n N_noxref_23_c_5087_n \
 N_noxref_23_M9_noxref_s )  PM_DFFSNRNQNX1\%noxref_23
x_PM_DFFSNRNQNX1\%noxref_24 ( N_noxref_24_c_5132_n N_noxref_24_c_5133_n \
 N_noxref_24_c_5160_n N_noxref_24_c_5144_n N_noxref_24_c_5146_n \
 N_noxref_24_M12_noxref_s )  PM_DFFSNRNQNX1\%noxref_24
x_PM_DFFSNRNQNX1\%noxref_25 ( N_noxref_25_c_5190_n N_noxref_25_c_5191_n \
 N_noxref_25_c_5225_n N_noxref_25_c_5204_n N_noxref_25_c_5206_n \
 N_noxref_25_M15_noxref_s )  PM_DFFSNRNQNX1\%noxref_25
cc_1 ( N_noxref_1_M31_noxref_g N_noxref_2_c_415_n ) capacitor c=0.00893512f \
 //x=11.86 //y=6.2 //x2=12.4 //y2=5.335
cc_2 ( N_noxref_1_M30_noxref_g N_noxref_2_c_416_n ) capacitor c=0.00461408f \
 //x=11.42 //y=6.2 //x2=11.642 //y2=5.335
cc_3 ( N_noxref_1_M31_noxref_g N_noxref_2_c_416_n ) capacitor c=0.00229208f \
 //x=11.86 //y=6.2 //x2=11.642 //y2=5.335
cc_4 ( N_noxref_1_c_4_p N_noxref_2_c_416_n ) capacitor c=0.00171885f \
 //x=11.785 //y=4.97 //x2=11.642 //y2=5.335
cc_5 ( N_noxref_1_c_5_p N_noxref_2_c_419_n ) capacitor c=4.16271e-19 //x=11.22 \
 //y=3.145 //x2=14.18 //y2=3.14
cc_6 ( N_noxref_1_M30_noxref_g N_noxref_2_c_420_n ) capacitor c=0.0162284f \
 //x=11.42 //y=6.2 //x2=11.64 //y2=5.56
cc_7 ( N_noxref_1_M31_noxref_g N_noxref_2_c_420_n ) capacitor c=0.0179041f \
 //x=11.86 //y=6.2 //x2=11.64 //y2=5.56
cc_8 ( N_noxref_1_c_4_p N_noxref_2_c_420_n ) capacitor c=0.00291477f \
 //x=11.785 //y=4.97 //x2=11.64 //y2=5.56
cc_9 ( N_noxref_1_c_9_p CLK ) capacitor c=0.00134338f //x=4.56 //y=2.985 \
 //x2=7.52 //y2=2.77
cc_10 ( N_noxref_1_c_10_p CLK ) capacitor c=0.0180599f //x=6.41 //y=2.98 \
 //x2=7.52 //y2=2.77
cc_11 ( N_noxref_1_c_11_p CLK ) capacitor c=0.00775437f //x=6.41 //y=3.3 \
 //x2=7.52 //y2=2.77
cc_12 ( N_noxref_1_c_12_p CLK ) capacitor c=0.00160345f //x=6.41 //y=4.755 \
 //x2=7.52 //y2=2.77
cc_13 ( N_noxref_1_c_13_p CLK ) capacitor c=2.98349e-19 //x=6.41 //y=3.145 \
 //x2=7.52 //y2=2.77
cc_14 ( N_noxref_1_c_14_p CLK ) capacitor c=0.0265923f //x=7.735 //y=3.13 \
 //x2=7.52 //y2=2.77
cc_15 ( N_noxref_1_c_15_p CLK ) capacitor c=0.0025294f //x=7.305 //y=3.13 \
 //x2=7.52 //y2=2.77
cc_16 ( N_noxref_1_c_16_p CLK ) capacitor c=4.16726e-19 //x=6.41 //y=2.26 \
 //x2=7.52 //y2=2.77
cc_17 ( N_noxref_1_c_17_p CLK ) capacitor c=0.0010127f //x=4.56 //y=5.25 \
 //x2=7.52 //y2=4.25
cc_18 ( N_noxref_1_c_12_p CLK ) capacitor c=0.0264194f //x=6.41 //y=4.755 \
 //x2=7.52 //y2=4.25
cc_19 ( N_noxref_1_c_19_p CLK ) capacitor c=3.36194e-19 //x=6.41 //y=4.88 \
 //x2=7.52 //y2=4.25
cc_20 ( N_noxref_1_c_12_p CLK ) capacitor c=3.43503e-19 //x=6.41 //y=4.755 \
 //x2=7.52 //y2=3.51
cc_21 ( N_noxref_1_c_21_p N_CLK_c_715_n ) capacitor c=0.0115546f //x=6.41 \
 //y=2.375 //x2=7.52 //y2=2.375
cc_22 ( N_noxref_1_c_14_p N_CLK_c_715_n ) capacitor c=0.00225123f //x=7.735 \
 //y=3.13 //x2=7.52 //y2=2.375
cc_23 ( N_noxref_1_c_16_p N_CLK_c_715_n ) capacitor c=5.40058e-19 //x=6.41 \
 //y=2.26 //x2=7.52 //y2=2.375
cc_24 ( N_noxref_1_c_24_p N_CLK_c_715_n ) capacitor c=0.00147006f //x=6.11 \
 //y=2.095 //x2=7.52 //y2=2.375
cc_25 ( N_noxref_1_c_12_p N_CLK_c_719_n ) capacitor c=0.00775314f //x=6.41 \
 //y=4.755 //x2=7.52 //y2=3.675
cc_26 ( N_noxref_1_c_14_p N_CLK_c_719_n ) capacitor c=0.00606467f //x=7.735 \
 //y=3.13 //x2=7.52 //y2=3.675
cc_27 ( N_noxref_1_c_12_p N_CLK_c_721_n ) capacitor c=0.0110307f //x=6.41 \
 //y=4.755 //x2=7.52 //y2=4.765
cc_28 ( N_noxref_1_c_19_p N_CLK_c_721_n ) capacitor c=2.89813e-19 //x=6.41 \
 //y=4.88 //x2=7.52 //y2=4.765
cc_29 ( N_noxref_1_c_29_p N_CLK_c_721_n ) capacitor c=7.66769e-19 //x=6.975 \
 //y=4.97 //x2=7.52 //y2=4.765
cc_30 ( N_noxref_1_c_30_p N_CLK_c_721_n ) capacitor c=7.54501e-19 //x=6.685 \
 //y=4.97 //x2=7.52 //y2=4.765
cc_31 ( N_noxref_1_c_14_p N_CLK_c_725_n ) capacitor c=0.18314f //x=7.735 \
 //y=3.13 //x2=8.975 //y2=3.51
cc_32 ( N_noxref_1_c_14_p N_CLK_c_726_n ) capacitor c=0.118648f //x=7.735 \
 //y=3.13 //x2=9.575 //y2=3.5
cc_33 ( N_noxref_1_c_33_p N_CLK_c_727_n ) capacitor c=0.00363542f //x=11.22 \
 //y=3.3 //x2=10.835 //y2=3.51
cc_34 ( N_noxref_1_c_34_p N_CLK_c_727_n ) capacitor c=4.67826e-19 //x=11.22 \
 //y=4.755 //x2=10.835 //y2=3.51
cc_35 ( N_noxref_1_c_14_p N_CLK_c_727_n ) capacitor c=0.0484136f //x=7.735 \
 //y=3.13 //x2=10.835 //y2=3.51
cc_36 ( N_noxref_1_c_33_p N_CLK_c_730_n ) capacitor c=0.00288354f //x=11.22 \
 //y=3.3 //x2=11.435 //y2=3.525
cc_37 ( N_noxref_1_c_34_p N_CLK_c_730_n ) capacitor c=0.0242134f //x=11.22 \
 //y=4.755 //x2=11.435 //y2=3.525
cc_38 ( N_noxref_1_c_12_p N_CLK_c_732_n ) capacitor c=0.0050817f //x=6.41 \
 //y=4.755 //x2=7.68 //y2=3.515
cc_39 ( N_noxref_1_c_14_p N_CLK_c_732_n ) capacitor c=0.0365231f //x=7.735 \
 //y=3.13 //x2=7.68 //y2=3.515
cc_40 ( N_noxref_1_c_21_p N_CLK_c_734_n ) capacitor c=5.39999e-19 //x=6.41 \
 //y=2.375 //x2=7.52 //y2=2.26
cc_41 ( N_noxref_1_c_10_p N_CLK_c_734_n ) capacitor c=4.16726e-19 //x=6.41 \
 //y=2.98 //x2=7.52 //y2=2.26
cc_42 ( N_noxref_1_c_16_p N_CLK_c_734_n ) capacitor c=0.00125213f //x=6.41 \
 //y=2.26 //x2=7.52 //y2=2.26
cc_43 ( N_noxref_1_c_24_p N_CLK_c_734_n ) capacitor c=0.00214573f //x=6.11 \
 //y=2.095 //x2=7.52 //y2=2.26
cc_44 ( N_noxref_1_c_12_p N_CLK_c_738_n ) capacitor c=0.00103399f //x=6.41 \
 //y=4.755 //x2=7.52 //y2=4.88
cc_45 ( N_noxref_1_c_19_p N_CLK_c_738_n ) capacitor c=0.00113984f //x=6.41 \
 //y=4.88 //x2=7.52 //y2=4.88
cc_46 ( N_noxref_1_c_29_p N_CLK_c_738_n ) capacitor c=0.00116563f //x=6.975 \
 //y=4.97 //x2=7.52 //y2=4.88
cc_47 ( N_noxref_1_c_30_p N_CLK_c_738_n ) capacitor c=0.00129812f //x=6.685 \
 //y=4.97 //x2=7.52 //y2=4.88
cc_48 ( N_noxref_1_M24_noxref_g N_CLK_M26_noxref_g ) capacitor c=0.0106276f \
 //x=6.61 //y=6.2 //x2=7.49 //y2=6.2
cc_49 ( N_noxref_1_M25_noxref_g N_CLK_M26_noxref_g ) capacitor c=0.107144f \
 //x=7.05 //y=6.2 //x2=7.49 //y2=6.2
cc_50 ( N_noxref_1_M25_noxref_g N_CLK_M27_noxref_g ) capacitor c=0.0101598f \
 //x=7.05 //y=6.2 //x2=7.93 //y2=6.2
cc_51 ( N_noxref_1_c_51_p N_CLK_c_745_n ) capacitor c=5.72528e-19 //x=6.11 \
 //y=1.055 //x2=7.085 //y2=1.09
cc_52 ( N_noxref_1_c_52_p N_CLK_c_745_n ) capacitor c=0.00150277f //x=6.11 \
 //y=1.4 //x2=7.085 //y2=1.09
cc_53 ( N_noxref_1_c_53_p N_CLK_c_745_n ) capacitor c=0.0160123f //x=6.64 \
 //y=1.055 //x2=7.085 //y2=1.09
cc_54 ( N_noxref_1_c_54_p N_CLK_c_748_n ) capacitor c=0.00111227f //x=6.11 \
 //y=1.71 //x2=7.085 //y2=1.4
cc_55 ( N_noxref_1_c_55_p N_CLK_c_748_n ) capacitor c=0.0124075f //x=6.64 \
 //y=1.4 //x2=7.085 //y2=1.4
cc_56 ( N_noxref_1_c_53_p N_CLK_c_750_n ) capacitor c=9.19165e-19 //x=6.64 \
 //y=1.055 //x2=7.61 //y2=1.09
cc_57 ( N_noxref_1_c_55_p N_CLK_c_751_n ) capacitor c=0.0010154f //x=6.64 \
 //y=1.4 //x2=7.61 //y2=1.4
cc_58 ( N_noxref_1_c_55_p N_CLK_c_752_n ) capacitor c=9.23422e-19 //x=6.64 \
 //y=1.4 //x2=7.61 //y2=1.63
cc_59 ( N_noxref_1_c_21_p N_CLK_c_753_n ) capacitor c=0.00140534f //x=6.41 \
 //y=2.375 //x2=7.61 //y2=2.095
cc_60 ( N_noxref_1_c_16_p N_CLK_c_753_n ) capacitor c=0.0020754f //x=6.41 \
 //y=2.26 //x2=7.61 //y2=2.095
cc_61 ( N_noxref_1_c_24_p N_CLK_c_753_n ) capacitor c=0.00964411f //x=6.11 \
 //y=2.095 //x2=7.61 //y2=2.095
cc_62 ( N_noxref_1_c_12_p N_CLK_c_756_n ) capacitor c=0.00116212f //x=6.41 \
 //y=4.755 //x2=7.52 //y2=4.88
cc_63 ( N_noxref_1_c_19_p N_CLK_c_756_n ) capacitor c=0.00155973f //x=6.41 \
 //y=4.88 //x2=7.52 //y2=4.88
cc_64 ( N_noxref_1_c_29_p N_CLK_c_756_n ) capacitor c=0.0171374f //x=6.975 \
 //y=4.97 //x2=7.52 //y2=4.88
cc_65 ( N_noxref_1_c_30_p N_CLK_c_756_n ) capacitor c=0.00484466f //x=6.685 \
 //y=4.97 //x2=7.52 //y2=4.88
cc_66 ( N_noxref_1_c_9_p N_noxref_4_c_1040_n ) capacitor c=0.0154269f //x=4.56 \
 //y=2.985 //x2=3.82 //y2=2.375
cc_67 ( N_noxref_1_c_9_p N_noxref_4_c_1041_n ) capacitor c=0.027112f //x=4.56 \
 //y=2.985 //x2=3.82 //y2=3.72
cc_68 ( N_noxref_1_c_68_p N_noxref_4_c_1041_n ) capacitor c=0.0148501f \
 //x=4.56 //y=3.305 //x2=3.82 //y2=3.72
cc_69 ( N_noxref_1_c_17_p N_noxref_4_c_1041_n ) capacitor c=0.0197112f \
 //x=4.56 //y=5.25 //x2=3.82 //y2=3.72
cc_70 ( N_noxref_1_c_10_p N_noxref_4_c_1041_n ) capacitor c=0.00172874f \
 //x=6.41 //y=2.98 //x2=3.82 //y2=3.72
cc_71 ( N_noxref_1_c_12_p N_noxref_4_c_1041_n ) capacitor c=4.42636e-19 \
 //x=6.41 //y=4.755 //x2=3.82 //y2=3.72
cc_72 ( N_noxref_1_c_72_p N_noxref_4_c_1041_n ) capacitor c=6.03895e-19 \
 //x=4.56 //y=3.145 //x2=3.82 //y2=3.72
cc_73 ( N_noxref_1_c_73_p N_noxref_4_c_1041_n ) capacitor c=0.00686862f \
 //x=4.72 //y=3.145 //x2=3.82 //y2=3.72
cc_74 ( N_noxref_1_c_74_p N_noxref_4_c_1048_n ) capacitor c=8.38638e-19 \
 //x=3.665 //y=5.335 //x2=3.82 //y2=4.04
cc_75 ( N_noxref_1_c_75_p N_noxref_4_c_1048_n ) capacitor c=0.0011767f \
 //x=4.475 //y=5.335 //x2=3.82 //y2=4.04
cc_76 ( N_noxref_1_c_76_p N_noxref_4_c_1048_n ) capacitor c=2.10199e-19 \
 //x=4.075 //y=1.305 //x2=3.82 //y2=4.04
cc_77 ( N_noxref_1_c_77_p N_noxref_4_c_1048_n ) capacitor c=8.96559e-19 \
 //x=4.16 //y=1.845 //x2=3.82 //y2=4.04
cc_78 ( N_noxref_1_c_17_p N_noxref_4_c_1048_n ) capacitor c=0.0173413f \
 //x=4.56 //y=5.25 //x2=3.82 //y2=4.04
cc_79 ( N_noxref_1_c_75_p N_noxref_4_c_1053_n ) capacitor c=0.00228791f \
 //x=4.475 //y=5.335 //x2=3.82 //y2=4.75
cc_80 ( N_noxref_1_c_17_p N_noxref_4_c_1053_n ) capacitor c=0.0448376f \
 //x=4.56 //y=5.25 //x2=3.82 //y2=4.75
cc_81 ( N_noxref_1_c_12_p N_noxref_4_c_1053_n ) capacitor c=0.00113976f \
 //x=6.41 //y=4.755 //x2=3.82 //y2=4.75
cc_82 ( N_noxref_1_c_82_p N_noxref_4_c_1053_n ) capacitor c=0.0221235f \
 //x=3.78 //y=5.335 //x2=3.82 //y2=4.75
cc_83 ( N_noxref_1_c_83_p N_noxref_4_c_1053_n ) capacitor c=0.00217653f \
 //x=3.78 //y=5.56 //x2=3.82 //y2=4.75
cc_84 ( N_noxref_1_M25_noxref_g N_noxref_4_c_1058_n ) capacitor c=0.00893512f \
 //x=7.05 //y=6.2 //x2=7.59 //y2=5.335
cc_85 ( N_noxref_1_c_14_p N_noxref_4_c_1059_n ) capacitor c=4.32469e-19 \
 //x=7.735 //y=3.13 //x2=8.885 //y2=1.305
cc_86 ( N_noxref_1_c_86_p N_noxref_4_c_1060_n ) capacitor c=0.00163399f \
 //x=4.475 //y=1.845 //x2=8.97 //y2=1.845
cc_87 ( N_noxref_1_c_14_p N_noxref_4_c_1060_n ) capacitor c=0.0104721f \
 //x=7.735 //y=3.13 //x2=8.97 //y2=1.845
cc_88 ( N_noxref_1_c_88_p N_noxref_4_c_1062_n ) capacitor c=0.00458539f \
 //x=11.22 //y=2.375 //x2=9.37 //y2=3.725
cc_89 ( N_noxref_1_c_89_p N_noxref_4_c_1062_n ) capacitor c=0.00975716f \
 //x=11.22 //y=2.98 //x2=9.37 //y2=3.725
cc_90 ( N_noxref_1_c_33_p N_noxref_4_c_1062_n ) capacitor c=0.00254581f \
 //x=11.22 //y=3.3 //x2=9.37 //y2=3.725
cc_91 ( N_noxref_1_c_34_p N_noxref_4_c_1062_n ) capacitor c=0.00539845f \
 //x=11.22 //y=4.755 //x2=9.37 //y2=3.725
cc_92 ( N_noxref_1_c_14_p N_noxref_4_c_1062_n ) capacitor c=0.0301762f \
 //x=7.735 //y=3.13 //x2=9.37 //y2=3.725
cc_93 ( N_noxref_1_c_34_p N_noxref_4_c_1067_n ) capacitor c=0.00253597f \
 //x=11.22 //y=4.755 //x2=9.37 //y2=4.045
cc_94 ( N_noxref_1_c_34_p N_noxref_4_c_1068_n ) capacitor c=0.011715f \
 //x=11.22 //y=4.755 //x2=9.37 //y2=5.25
cc_95 ( N_noxref_1_c_17_p N_noxref_4_c_1069_n ) capacitor c=6.78671e-19 \
 //x=4.56 //y=5.25 //x2=3.82 //y2=3.88
cc_96 ( N_noxref_1_c_96_p N_noxref_4_c_1070_n ) capacitor c=6.09703e-19 \
 //x=3.78 //y=5.56 //x2=6.832 //y2=5.335
cc_97 ( N_noxref_1_c_75_p N_noxref_4_c_1070_n ) capacitor c=0.00306432f \
 //x=4.475 //y=5.335 //x2=6.832 //y2=5.335
cc_98 ( N_noxref_1_M24_noxref_g N_noxref_4_c_1070_n ) capacitor c=0.00461408f \
 //x=6.61 //y=6.2 //x2=6.832 //y2=5.335
cc_99 ( N_noxref_1_M25_noxref_g N_noxref_4_c_1070_n ) capacitor c=0.00229208f \
 //x=7.05 //y=6.2 //x2=6.832 //y2=5.335
cc_100 ( N_noxref_1_c_29_p N_noxref_4_c_1070_n ) capacitor c=0.00171885f \
 //x=6.975 //y=4.97 //x2=6.832 //y2=5.335
cc_101 ( N_noxref_1_c_77_p N_noxref_4_c_1075_n ) capacitor c=0.0052544f \
 //x=4.16 //y=1.845 //x2=7.135 //y2=3.88
cc_102 ( N_noxref_1_c_68_p N_noxref_4_c_1075_n ) capacitor c=0.00530919f \
 //x=4.56 //y=3.305 //x2=7.135 //y2=3.88
cc_103 ( N_noxref_1_c_17_p N_noxref_4_c_1075_n ) capacitor c=0.0271001f \
 //x=4.56 //y=5.25 //x2=7.135 //y2=3.88
cc_104 ( N_noxref_1_c_11_p N_noxref_4_c_1075_n ) capacitor c=0.00367409f \
 //x=6.41 //y=3.3 //x2=7.135 //y2=3.88
cc_105 ( N_noxref_1_c_12_p N_noxref_4_c_1075_n ) capacitor c=0.030107f \
 //x=6.41 //y=4.755 //x2=7.135 //y2=3.88
cc_106 ( N_noxref_1_c_106_p N_noxref_4_c_1075_n ) capacitor c=0.0723731f \
 //x=6.25 //y=3.145 //x2=7.135 //y2=3.88
cc_107 ( N_noxref_1_c_73_p N_noxref_4_c_1075_n ) capacitor c=0.0161618f \
 //x=4.72 //y=3.145 //x2=7.135 //y2=3.88
cc_108 ( N_noxref_1_c_15_p N_noxref_4_c_1075_n ) capacitor c=0.0495265f \
 //x=7.305 //y=3.13 //x2=7.135 //y2=3.88
cc_109 ( N_noxref_1_c_17_p N_noxref_4_c_1083_n ) capacitor c=0.0032735f \
 //x=4.56 //y=5.25 //x2=3.98 //y2=3.88
cc_110 ( N_noxref_1_c_14_p N_noxref_4_c_1084_n ) capacitor c=0.00855023f \
 //x=7.735 //y=3.13 //x2=7.735 //y2=3.9
cc_111 ( N_noxref_1_c_14_p N_noxref_4_c_1085_n ) capacitor c=0.00422731f \
 //x=7.735 //y=3.13 //x2=8.235 //y2=3.88
cc_112 ( N_noxref_1_c_34_p N_noxref_4_c_1086_n ) capacitor c=0.0259917f \
 //x=11.22 //y=4.755 //x2=17.01 //y2=3.89
cc_113 ( N_noxref_1_c_14_p N_noxref_4_c_1086_n ) capacitor c=0.0132995f \
 //x=7.735 //y=3.13 //x2=17.01 //y2=3.89
cc_114 ( N_noxref_1_c_9_p N_noxref_4_c_1088_n ) capacitor c=0.00163444f \
 //x=4.56 //y=2.985 //x2=3.82 //y2=2.26
cc_115 ( N_noxref_1_c_75_p N_noxref_4_c_1089_n ) capacitor c=0.00130631f \
 //x=4.475 //y=5.335 //x2=3.82 //y2=4.88
cc_116 ( N_noxref_1_c_17_p N_noxref_4_c_1089_n ) capacitor c=0.00131258f \
 //x=4.56 //y=5.25 //x2=3.82 //y2=4.88
cc_117 ( N_noxref_1_c_82_p N_noxref_4_c_1089_n ) capacitor c=0.00346456f \
 //x=3.78 //y=5.335 //x2=3.82 //y2=4.88
cc_118 ( N_noxref_1_c_83_p N_noxref_4_c_1089_n ) capacitor c=0.00552343f \
 //x=3.78 //y=5.56 //x2=3.82 //y2=4.88
cc_119 ( N_noxref_1_M24_noxref_g N_noxref_4_c_1093_n ) capacitor c=0.0162284f \
 //x=6.61 //y=6.2 //x2=6.83 //y2=5.56
cc_120 ( N_noxref_1_M25_noxref_g N_noxref_4_c_1093_n ) capacitor c=0.0179041f \
 //x=7.05 //y=6.2 //x2=6.83 //y2=5.56
cc_121 ( N_noxref_1_c_29_p N_noxref_4_c_1093_n ) capacitor c=0.00291477f \
 //x=6.975 //y=4.97 //x2=6.83 //y2=5.56
cc_122 ( N_noxref_1_c_74_p N_noxref_4_M22_noxref_g ) capacitor c=0.00955829f \
 //x=3.665 //y=5.335 //x2=3.56 //y2=6.2
cc_123 ( N_noxref_1_c_96_p N_noxref_4_M22_noxref_g ) capacitor c=0.00226521f \
 //x=3.78 //y=5.56 //x2=3.56 //y2=6.2
cc_124 ( N_noxref_1_c_83_p N_noxref_4_M22_noxref_g ) capacitor c=0.0178885f \
 //x=3.78 //y=5.56 //x2=3.56 //y2=6.2
cc_125 ( N_noxref_1_c_96_p N_noxref_4_M23_noxref_g ) capacitor c=0.00381703f \
 //x=3.78 //y=5.56 //x2=4 //y2=6.2
cc_126 ( N_noxref_1_c_75_p N_noxref_4_M23_noxref_g ) capacitor c=0.0109656f \
 //x=4.475 //y=5.335 //x2=4 //y2=6.2
cc_127 ( N_noxref_1_c_83_p N_noxref_4_M23_noxref_g ) capacitor c=0.0188608f \
 //x=3.78 //y=5.56 //x2=4 //y2=6.2
cc_128 ( N_noxref_1_c_76_p N_noxref_4_c_1102_n ) capacitor c=4.64015e-19 \
 //x=4.075 //y=1.305 //x2=3.81 //y2=1.095
cc_129 ( N_noxref_1_M2_noxref_d N_noxref_4_c_1102_n ) capacitor c=0.00137165f \
 //x=3.885 //y=1.095 //x2=3.81 //y2=1.095
cc_130 ( N_noxref_1_c_76_p N_noxref_4_c_1104_n ) capacitor c=0.0026012f \
 //x=4.075 //y=1.305 //x2=3.81 //y2=1.44
cc_131 ( N_noxref_1_c_131_p N_noxref_4_c_1104_n ) capacitor c=0.00127432f \
 //x=4.075 //y=1.76 //x2=3.81 //y2=1.44
cc_132 ( N_noxref_1_M2_noxref_d N_noxref_4_c_1104_n ) capacitor c=0.00237422f \
 //x=3.885 //y=1.095 //x2=3.81 //y2=1.44
cc_133 ( N_noxref_1_c_131_p N_noxref_4_c_1107_n ) capacitor c=0.00429966f \
 //x=4.075 //y=1.76 //x2=3.81 //y2=1.75
cc_134 ( N_noxref_1_c_76_p N_noxref_4_c_1108_n ) capacitor c=5.29969e-19 \
 //x=4.075 //y=1.305 //x2=4.185 //y2=0.94
cc_135 ( N_noxref_1_M2_noxref_d N_noxref_4_c_1108_n ) capacitor c=0.0020782f \
 //x=3.885 //y=1.095 //x2=4.185 //y2=0.94
cc_136 ( N_noxref_1_c_76_p N_noxref_4_c_1110_n ) capacitor c=5.17996e-19 \
 //x=4.075 //y=1.305 //x2=4.185 //y2=1.595
cc_137 ( N_noxref_1_c_131_p N_noxref_4_c_1110_n ) capacitor c=0.00942306f \
 //x=4.075 //y=1.76 //x2=4.185 //y2=1.595
cc_138 ( N_noxref_1_c_86_p N_noxref_4_c_1110_n ) capacitor c=0.00194716f \
 //x=4.475 //y=1.845 //x2=4.185 //y2=1.595
cc_139 ( N_noxref_1_M2_noxref_d N_noxref_4_c_1110_n ) capacitor c=0.00356097f \
 //x=3.885 //y=1.095 //x2=4.185 //y2=1.595
cc_140 ( N_noxref_1_c_76_p N_noxref_4_c_1114_n ) capacitor c=5.24634e-19 \
 //x=4.075 //y=1.305 //x2=4.34 //y2=1.095
cc_141 ( N_noxref_1_M2_noxref_d N_noxref_4_c_1114_n ) capacitor c=0.00139206f \
 //x=3.885 //y=1.095 //x2=4.34 //y2=1.095
cc_142 ( N_noxref_1_c_76_p N_noxref_4_c_1116_n ) capacitor c=0.00307978f \
 //x=4.075 //y=1.305 //x2=4.34 //y2=1.44
cc_143 ( N_noxref_1_c_131_p N_noxref_4_c_1116_n ) capacitor c=0.00363411f \
 //x=4.075 //y=1.76 //x2=4.34 //y2=1.44
cc_144 ( N_noxref_1_c_86_p N_noxref_4_c_1116_n ) capacitor c=0.00323576f \
 //x=4.475 //y=1.845 //x2=4.34 //y2=1.44
cc_145 ( N_noxref_1_M2_noxref_d N_noxref_4_c_1116_n ) capacitor c=0.00237422f \
 //x=3.885 //y=1.095 //x2=4.34 //y2=1.44
cc_146 ( N_noxref_1_c_9_p N_noxref_4_c_1120_n ) capacitor c=0.0025845f \
 //x=4.56 //y=2.985 //x2=3.82 //y2=2.26
cc_147 ( N_noxref_1_c_131_p N_noxref_4_c_1121_n ) capacitor c=0.00372124f \
 //x=4.075 //y=1.76 //x2=3.82 //y2=2.095
cc_148 ( N_noxref_1_c_9_p N_noxref_4_c_1121_n ) capacitor c=0.00282067f \
 //x=4.56 //y=2.985 //x2=3.82 //y2=2.095
cc_149 ( N_noxref_1_c_17_p N_noxref_4_c_1123_n ) capacitor c=0.00739875f \
 //x=4.56 //y=5.25 //x2=3.82 //y2=4.88
cc_150 ( N_noxref_1_c_82_p N_noxref_4_c_1123_n ) capacitor c=0.00203307f \
 //x=3.78 //y=5.335 //x2=3.82 //y2=4.88
cc_151 ( N_noxref_1_c_83_p N_noxref_4_c_1123_n ) capacitor c=0.00375636f \
 //x=3.78 //y=5.56 //x2=3.82 //y2=4.88
cc_152 ( N_noxref_1_c_9_p RN ) capacitor c=0.0014251f //x=4.56 //y=2.985 \
 //x2=2.71 //y2=2.77
cc_153 ( N_noxref_1_c_17_p RN ) capacitor c=0.00221437f //x=4.56 //y=5.25 \
 //x2=2.71 //y2=2.77
cc_154 ( N_noxref_1_c_154_p N_RN_c_1515_n ) capacitor c=0.0231261f //x=2.78 \
 //y=5.335 //x2=2.71 //y2=4.635
cc_155 ( N_noxref_1_c_155_p N_RN_c_1515_n ) capacitor c=0.00464186f //x=2.9 \
 //y=5.335 //x2=2.71 //y2=4.635
cc_156 ( N_noxref_1_c_156_p N_RN_c_1515_n ) capacitor c=0.00166114f //x=2.9 \
 //y=5.56 //x2=2.71 //y2=4.635
cc_157 ( N_noxref_1_c_75_p N_RN_c_1518_n ) capacitor c=0.0202612f //x=4.475 \
 //y=5.335 //x2=8.235 //y2=4.62
cc_158 ( N_noxref_1_c_17_p N_RN_c_1518_n ) capacitor c=0.0327101f //x=4.56 \
 //y=5.25 //x2=8.235 //y2=4.62
cc_159 ( N_noxref_1_c_12_p N_RN_c_1518_n ) capacitor c=0.0354235f //x=6.41 \
 //y=4.755 //x2=8.235 //y2=4.62
cc_160 ( N_noxref_1_c_155_p N_RN_c_1518_n ) capacitor c=0.040052f //x=2.9 \
 //y=5.335 //x2=8.235 //y2=4.62
cc_161 ( N_noxref_1_c_106_p N_RN_c_1518_n ) capacitor c=0.00310473f //x=6.25 \
 //y=3.145 //x2=8.235 //y2=4.62
cc_162 ( N_noxref_1_c_15_p N_RN_c_1518_n ) capacitor c=0.00251066f //x=7.305 \
 //y=3.13 //x2=8.235 //y2=4.62
cc_163 ( N_noxref_1_c_34_p N_RN_c_1524_n ) capacitor c=0.0327f //x=11.22 \
 //y=4.755 //x2=18.86 //y2=4.63
cc_164 ( N_noxref_1_c_154_p N_RN_c_1525_n ) capacitor c=0.00127271f //x=2.78 \
 //y=5.335 //x2=2.87 //y2=4.635
cc_165 ( N_noxref_1_c_155_p N_RN_c_1525_n ) capacitor c=0.00102868f //x=2.9 \
 //y=5.335 //x2=2.87 //y2=4.635
cc_166 ( N_noxref_1_c_154_p N_RN_c_1527_n ) capacitor c=0.00492634f //x=2.78 \
 //y=5.335 //x2=2.71 //y2=4.88
cc_167 ( N_noxref_1_c_155_p N_RN_c_1527_n ) capacitor c=0.00132214f //x=2.9 \
 //y=5.335 //x2=2.71 //y2=4.88
cc_168 ( N_noxref_1_c_154_p N_RN_M20_noxref_g ) capacitor c=0.0085824f \
 //x=2.78 //y=5.335 //x2=2.68 //y2=6.2
cc_169 ( N_noxref_1_c_155_p N_RN_M20_noxref_g ) capacitor c=0.00229818f \
 //x=2.9 //y=5.335 //x2=2.68 //y2=6.2
cc_170 ( N_noxref_1_c_156_p N_RN_M20_noxref_g ) capacitor c=0.0179041f //x=2.9 \
 //y=5.56 //x2=2.68 //y2=6.2
cc_171 ( N_noxref_1_c_74_p N_RN_M21_noxref_g ) capacitor c=0.00955829f \
 //x=3.665 //y=5.335 //x2=3.12 //y2=6.2
cc_172 ( N_noxref_1_c_155_p N_RN_M21_noxref_g ) capacitor c=0.00230699f \
 //x=2.9 //y=5.335 //x2=3.12 //y2=6.2
cc_173 ( N_noxref_1_c_156_p N_RN_M21_noxref_g ) capacitor c=0.0179041f //x=2.9 \
 //y=5.56 //x2=3.12 //y2=6.2
cc_174 ( N_noxref_1_c_155_p N_RN_c_1535_n ) capacitor c=0.00174502f //x=2.9 \
 //y=5.335 //x2=3.045 //y2=4.97
cc_175 ( N_noxref_1_c_156_p N_RN_c_1535_n ) capacitor c=0.00294585f //x=2.9 \
 //y=5.56 //x2=3.045 //y2=4.97
cc_176 ( N_noxref_1_c_154_p N_RN_c_1537_n ) capacitor c=3.87955e-19 //x=2.78 \
 //y=5.335 //x2=2.71 //y2=4.88
cc_177 ( N_noxref_1_c_88_p N_SN_c_2222_n ) capacitor c=0.0115546f //x=11.22 \
 //y=2.375 //x2=12.33 //y2=2.375
cc_178 ( N_noxref_1_c_178_p N_SN_c_2222_n ) capacitor c=5.40058e-19 //x=11.22 \
 //y=2.26 //x2=12.33 //y2=2.375
cc_179 ( N_noxref_1_c_179_p N_SN_c_2222_n ) capacitor c=0.00147006f //x=10.92 \
 //y=2.095 //x2=12.33 //y2=2.375
cc_180 ( N_noxref_1_c_89_p N_SN_c_2225_n ) capacitor c=0.00667771f //x=11.22 \
 //y=2.98 //x2=12.33 //y2=2.615
cc_181 ( N_noxref_1_c_178_p N_SN_c_2225_n ) capacitor c=4.16726e-19 //x=11.22 \
 //y=2.26 //x2=12.33 //y2=2.615
cc_182 ( N_noxref_1_c_89_p N_SN_c_2227_n ) capacitor c=0.00775137f //x=11.22 \
 //y=2.98 //x2=12.33 //y2=2.935
cc_183 ( N_noxref_1_c_89_p N_SN_c_2228_n ) capacitor c=0.00140843f //x=11.22 \
 //y=2.98 //x2=12.33 //y2=4.765
cc_184 ( N_noxref_1_c_33_p N_SN_c_2228_n ) capacitor c=0.00775314f //x=11.22 \
 //y=3.3 //x2=12.33 //y2=4.765
cc_185 ( N_noxref_1_c_34_p N_SN_c_2228_n ) capacitor c=0.0435569f //x=11.22 \
 //y=4.755 //x2=12.33 //y2=4.765
cc_186 ( N_noxref_1_c_5_p N_SN_c_2228_n ) capacitor c=3.07905e-19 //x=11.22 \
 //y=3.145 //x2=12.33 //y2=4.765
cc_187 ( N_noxref_1_c_14_p N_SN_c_2228_n ) capacitor c=0.00508131f //x=7.735 \
 //y=3.13 //x2=12.33 //y2=4.765
cc_188 ( N_noxref_1_c_188_p N_SN_c_2228_n ) capacitor c=6.26008e-19 //x=11.22 \
 //y=4.88 //x2=12.33 //y2=4.765
cc_189 ( N_noxref_1_c_4_p N_SN_c_2228_n ) capacitor c=7.66769e-19 //x=11.785 \
 //y=4.97 //x2=12.33 //y2=4.765
cc_190 ( N_noxref_1_c_190_p N_SN_c_2228_n ) capacitor c=7.54501e-19 //x=11.495 \
 //y=4.97 //x2=12.33 //y2=4.765
cc_191 ( N_noxref_1_c_89_p N_SN_c_2236_n ) capacitor c=2.98299e-19 //x=11.22 \
 //y=2.98 //x2=12.33 //y2=2.775
cc_192 ( N_noxref_1_c_89_p N_SN_c_2237_n ) capacitor c=0.00508574f //x=11.22 \
 //y=2.98 //x2=12.49 //y2=2.775
cc_193 ( N_noxref_1_c_88_p N_SN_c_2238_n ) capacitor c=5.39999e-19 //x=11.22 \
 //y=2.375 //x2=12.33 //y2=2.26
cc_194 ( N_noxref_1_c_89_p N_SN_c_2238_n ) capacitor c=4.16726e-19 //x=11.22 \
 //y=2.98 //x2=12.33 //y2=2.26
cc_195 ( N_noxref_1_c_178_p N_SN_c_2238_n ) capacitor c=0.00125213f //x=11.22 \
 //y=2.26 //x2=12.33 //y2=2.26
cc_196 ( N_noxref_1_c_179_p N_SN_c_2238_n ) capacitor c=0.00214573f //x=10.92 \
 //y=2.095 //x2=12.33 //y2=2.26
cc_197 ( N_noxref_1_c_34_p N_SN_c_2242_n ) capacitor c=0.00103399f //x=11.22 \
 //y=4.755 //x2=12.33 //y2=4.88
cc_198 ( N_noxref_1_c_188_p N_SN_c_2242_n ) capacitor c=0.00113984f //x=11.22 \
 //y=4.88 //x2=12.33 //y2=4.88
cc_199 ( N_noxref_1_c_4_p N_SN_c_2242_n ) capacitor c=0.00116563f //x=11.785 \
 //y=4.97 //x2=12.33 //y2=4.88
cc_200 ( N_noxref_1_c_190_p N_SN_c_2242_n ) capacitor c=0.00129812f //x=11.495 \
 //y=4.97 //x2=12.33 //y2=4.88
cc_201 ( N_noxref_1_M30_noxref_g N_SN_M32_noxref_g ) capacitor c=0.0106276f \
 //x=11.42 //y=6.2 //x2=12.3 //y2=6.2
cc_202 ( N_noxref_1_M31_noxref_g N_SN_M32_noxref_g ) capacitor c=0.107144f \
 //x=11.86 //y=6.2 //x2=12.3 //y2=6.2
cc_203 ( N_noxref_1_M31_noxref_g N_SN_M33_noxref_g ) capacitor c=0.0101598f \
 //x=11.86 //y=6.2 //x2=12.74 //y2=6.2
cc_204 ( N_noxref_1_c_204_p N_SN_c_2249_n ) capacitor c=5.72528e-19 //x=10.92 \
 //y=1.055 //x2=11.895 //y2=1.09
cc_205 ( N_noxref_1_c_205_p N_SN_c_2249_n ) capacitor c=0.00150277f //x=10.92 \
 //y=1.4 //x2=11.895 //y2=1.09
cc_206 ( N_noxref_1_c_206_p N_SN_c_2249_n ) capacitor c=0.0160123f //x=11.45 \
 //y=1.055 //x2=11.895 //y2=1.09
cc_207 ( N_noxref_1_c_207_p N_SN_c_2252_n ) capacitor c=0.00111227f //x=10.92 \
 //y=1.71 //x2=11.895 //y2=1.4
cc_208 ( N_noxref_1_c_208_p N_SN_c_2252_n ) capacitor c=0.0124075f //x=11.45 \
 //y=1.4 //x2=11.895 //y2=1.4
cc_209 ( N_noxref_1_c_206_p N_SN_c_2254_n ) capacitor c=9.19165e-19 //x=11.45 \
 //y=1.055 //x2=12.42 //y2=1.09
cc_210 ( N_noxref_1_c_208_p N_SN_c_2255_n ) capacitor c=0.0010154f //x=11.45 \
 //y=1.4 //x2=12.42 //y2=1.4
cc_211 ( N_noxref_1_c_208_p N_SN_c_2256_n ) capacitor c=9.23422e-19 //x=11.45 \
 //y=1.4 //x2=12.42 //y2=1.63
cc_212 ( N_noxref_1_c_88_p N_SN_c_2257_n ) capacitor c=0.00140534f //x=11.22 \
 //y=2.375 //x2=12.42 //y2=2.095
cc_213 ( N_noxref_1_c_178_p N_SN_c_2257_n ) capacitor c=0.0020754f //x=11.22 \
 //y=2.26 //x2=12.42 //y2=2.095
cc_214 ( N_noxref_1_c_179_p N_SN_c_2257_n ) capacitor c=0.00964411f //x=10.92 \
 //y=2.095 //x2=12.42 //y2=2.095
cc_215 ( N_noxref_1_c_34_p N_SN_c_2260_n ) capacitor c=0.00116212f //x=11.22 \
 //y=4.755 //x2=12.33 //y2=4.88
cc_216 ( N_noxref_1_c_188_p N_SN_c_2260_n ) capacitor c=0.00155973f //x=11.22 \
 //y=4.88 //x2=12.33 //y2=4.88
cc_217 ( N_noxref_1_c_4_p N_SN_c_2260_n ) capacitor c=0.0171374f //x=11.785 \
 //y=4.97 //x2=12.33 //y2=4.88
cc_218 ( N_noxref_1_c_190_p N_SN_c_2260_n ) capacitor c=0.00484466f //x=11.495 \
 //y=4.97 //x2=12.33 //y2=4.88
cc_219 ( N_noxref_1_c_14_p N_noxref_8_c_2597_n ) capacitor c=0.00254119f \
 //x=7.735 //y=3.13 //x2=8.63 //y2=2.375
cc_220 ( N_noxref_1_c_10_p N_noxref_8_c_2598_n ) capacitor c=0.00108353f \
 //x=6.41 //y=2.98 //x2=8.63 //y2=4.095
cc_221 ( N_noxref_1_c_12_p N_noxref_8_c_2598_n ) capacitor c=0.00128297f \
 //x=6.41 //y=4.755 //x2=8.63 //y2=4.095
cc_222 ( N_noxref_1_c_89_p N_noxref_8_c_2598_n ) capacitor c=0.00172874f \
 //x=11.22 //y=2.98 //x2=8.63 //y2=4.095
cc_223 ( N_noxref_1_c_34_p N_noxref_8_c_2598_n ) capacitor c=8.80534e-19 \
 //x=11.22 //y=4.755 //x2=8.63 //y2=4.095
cc_224 ( N_noxref_1_c_14_p N_noxref_8_c_2598_n ) capacitor c=0.0268282f \
 //x=7.735 //y=3.13 //x2=8.63 //y2=4.095
cc_225 ( N_noxref_1_c_12_p N_noxref_8_c_2603_n ) capacitor c=2.98402e-19 \
 //x=6.41 //y=4.755 //x2=8.63 //y2=4.75
cc_226 ( N_noxref_1_c_34_p N_noxref_8_c_2603_n ) capacitor c=4.65192e-19 \
 //x=11.22 //y=4.755 //x2=8.63 //y2=4.75
cc_227 ( N_noxref_1_c_34_p N_noxref_8_c_2605_n ) capacitor c=0.0250244f \
 //x=11.22 //y=4.755 //x2=20.705 //y2=4.265
cc_228 ( N_noxref_1_c_154_p N_VDD_c_3378_n ) capacitor c=0.00621353f //x=2.78 \
 //y=5.335 //x2=28.61 //y2=7.58
cc_229 ( N_noxref_1_c_74_p N_VDD_c_3378_n ) capacitor c=0.00627191f //x=3.665 \
 //y=5.335 //x2=28.61 //y2=7.58
cc_230 ( N_noxref_1_c_96_p N_VDD_c_3378_n ) capacitor c=0.00256019f //x=3.78 \
 //y=5.56 //x2=28.61 //y2=7.58
cc_231 ( N_noxref_1_c_75_p N_VDD_c_3378_n ) capacitor c=0.00829247f //x=4.475 \
 //y=5.335 //x2=28.61 //y2=7.58
cc_232 ( N_noxref_1_c_68_p N_VDD_c_3378_n ) capacitor c=4.23984e-19 //x=4.56 \
 //y=3.305 //x2=28.61 //y2=7.58
cc_233 ( N_noxref_1_c_11_p N_VDD_c_3378_n ) capacitor c=3.04546e-19 //x=6.41 \
 //y=3.3 //x2=28.61 //y2=7.58
cc_234 ( N_noxref_1_c_33_p N_VDD_c_3378_n ) capacitor c=3.53251e-19 //x=11.22 \
 //y=3.3 //x2=28.61 //y2=7.58
cc_235 ( N_noxref_1_c_235_p N_VDD_c_3378_n ) capacitor c=0.00261804f //x=2.022 \
 //y=5.335 //x2=28.61 //y2=7.58
cc_236 ( N_noxref_1_c_155_p N_VDD_c_3378_n ) capacitor c=0.00270108f //x=2.9 \
 //y=5.335 //x2=28.61 //y2=7.58
cc_237 ( N_noxref_1_c_237_p N_VDD_c_3378_n ) capacitor c=0.0024232f //x=2.02 \
 //y=5.56 //x2=28.61 //y2=7.58
cc_238 ( N_noxref_1_c_156_p N_VDD_c_3378_n ) capacitor c=0.0024232f //x=2.9 \
 //y=5.56 //x2=28.61 //y2=7.58
cc_239 ( N_noxref_1_c_83_p N_VDD_c_3378_n ) capacitor c=0.0024232f //x=3.78 \
 //y=5.56 //x2=28.61 //y2=7.58
cc_240 ( N_noxref_1_c_235_p N_VDD_c_3390_n ) capacitor c=0.00331944f //x=2.022 \
 //y=5.335 //x2=1.23 //y2=7.58
cc_241 ( N_noxref_1_c_237_p N_VDD_c_3390_n ) capacitor c=0.00509469f //x=2.02 \
 //y=5.56 //x2=1.23 //y2=7.58
cc_242 ( N_noxref_1_c_154_p N_VDD_c_3392_n ) capacitor c=0.00207166f //x=2.78 \
 //y=5.335 //x2=2.375 //y2=7.585
cc_243 ( N_noxref_1_c_235_p N_VDD_c_3392_n ) capacitor c=0.00105965f //x=2.022 \
 //y=5.335 //x2=2.375 //y2=7.585
cc_244 ( N_noxref_1_c_237_p N_VDD_c_3392_n ) capacitor c=0.0138074f //x=2.02 \
 //y=5.56 //x2=2.375 //y2=7.585
cc_245 ( N_noxref_1_c_154_p N_VDD_c_3395_n ) capacitor c=0.0017708f //x=2.78 \
 //y=5.335 //x2=3.255 //y2=7.585
cc_246 ( N_noxref_1_c_74_p N_VDD_c_3395_n ) capacitor c=0.00202922f //x=3.665 \
 //y=5.335 //x2=3.255 //y2=7.585
cc_247 ( N_noxref_1_c_155_p N_VDD_c_3395_n ) capacitor c=9.4822e-19 //x=2.9 \
 //y=5.335 //x2=3.255 //y2=7.585
cc_248 ( N_noxref_1_c_156_p N_VDD_c_3395_n ) capacitor c=0.0138074f //x=2.9 \
 //y=5.56 //x2=3.255 //y2=7.585
cc_249 ( N_noxref_1_c_74_p N_VDD_c_3399_n ) capacitor c=0.00205906f //x=3.665 \
 //y=5.335 //x2=4.135 //y2=7.585
cc_250 ( N_noxref_1_c_96_p N_VDD_c_3399_n ) capacitor c=8.49654e-19 //x=3.78 \
 //y=5.56 //x2=4.135 //y2=7.585
cc_251 ( N_noxref_1_c_75_p N_VDD_c_3399_n ) capacitor c=0.00204238f //x=4.475 \
 //y=5.335 //x2=4.135 //y2=7.585
cc_252 ( N_noxref_1_c_83_p N_VDD_c_3399_n ) capacitor c=0.0135103f //x=3.78 \
 //y=5.56 //x2=4.135 //y2=7.585
cc_253 ( N_noxref_1_c_75_p N_VDD_c_3403_n ) capacitor c=0.00183742f //x=4.475 \
 //y=5.335 //x2=5.13 //y2=7.585
cc_254 ( N_noxref_1_M24_noxref_g N_VDD_c_3404_n ) capacitor c=0.00755614f \
 //x=6.61 //y=6.2 //x2=7.185 //y2=7.585
cc_255 ( N_noxref_1_M25_noxref_g N_VDD_c_3404_n ) capacitor c=0.00755544f \
 //x=7.05 //y=6.2 //x2=7.185 //y2=7.585
cc_256 ( N_noxref_1_M30_noxref_g N_VDD_c_3406_n ) capacitor c=0.00755614f \
 //x=11.42 //y=6.2 //x2=11.995 //y2=7.585
cc_257 ( N_noxref_1_M31_noxref_g N_VDD_c_3406_n ) capacitor c=0.00755544f \
 //x=11.86 //y=6.2 //x2=11.995 //y2=7.585
cc_258 ( N_noxref_1_c_96_p N_VDD_c_3408_n ) capacitor c=0.00282782f //x=3.78 \
 //y=5.56 //x2=5.3 //y2=7.585
cc_259 ( N_noxref_1_c_17_p N_VDD_c_3408_n ) capacitor c=0.033414f //x=4.56 \
 //y=5.25 //x2=5.3 //y2=7.585
cc_260 ( N_noxref_1_c_12_p N_VDD_c_3408_n ) capacitor c=0.0116604f //x=6.41 \
 //y=4.755 //x2=5.3 //y2=7.585
cc_261 ( N_noxref_1_c_83_p N_VDD_c_3408_n ) capacitor c=0.00777981f //x=3.78 \
 //y=5.56 //x2=5.3 //y2=7.585
cc_262 ( N_noxref_1_c_19_p N_VDD_c_3408_n ) capacitor c=0.00370784f //x=6.41 \
 //y=4.88 //x2=5.3 //y2=7.585
cc_263 ( N_noxref_1_c_30_p N_VDD_c_3408_n ) capacitor c=0.00590568f //x=6.685 \
 //y=4.97 //x2=5.3 //y2=7.585
cc_264 ( N_noxref_1_c_34_p N_VDD_c_3414_n ) capacitor c=0.0113974f //x=11.22 \
 //y=4.755 //x2=10.11 //y2=7.585
cc_265 ( N_noxref_1_c_188_p N_VDD_c_3414_n ) capacitor c=0.00370784f //x=11.22 \
 //y=4.88 //x2=10.11 //y2=7.585
cc_266 ( N_noxref_1_c_190_p N_VDD_c_3414_n ) capacitor c=0.00590568f \
 //x=11.495 //y=4.97 //x2=10.11 //y2=7.585
cc_267 ( N_noxref_1_c_235_p N_VDD_M18_noxref_s ) capacitor c=0.0453361f \
 //x=2.022 //y=5.335 //x2=1.445 //y2=5.2
cc_268 ( N_noxref_1_c_155_p N_VDD_M18_noxref_s ) capacitor c=7.80122e-19 \
 //x=2.9 //y=5.335 //x2=1.445 //y2=5.2
cc_269 ( N_noxref_1_c_237_p N_VDD_M18_noxref_s ) capacitor c=0.09305f //x=2.02 \
 //y=5.56 //x2=1.445 //y2=5.2
cc_270 ( N_noxref_1_c_154_p N_VDD_M19_noxref_d ) capacitor c=0.0077575f \
 //x=2.78 //y=5.335 //x2=2.315 //y2=5.2
cc_271 ( N_noxref_1_c_237_p N_VDD_M19_noxref_d ) capacitor c=0.0674491f \
 //x=2.02 //y=5.56 //x2=2.315 //y2=5.2
cc_272 ( N_noxref_1_c_156_p N_VDD_M19_noxref_d ) capacitor c=0.0674762f \
 //x=2.9 //y=5.56 //x2=2.315 //y2=5.2
cc_273 ( N_noxref_1_c_74_p N_VDD_M21_noxref_d ) capacitor c=0.00700141f \
 //x=3.665 //y=5.335 //x2=3.195 //y2=5.2
cc_274 ( N_noxref_1_c_156_p N_VDD_M21_noxref_d ) capacitor c=0.067493f //x=2.9 \
 //y=5.56 //x2=3.195 //y2=5.2
cc_275 ( N_noxref_1_c_83_p N_VDD_M21_noxref_d ) capacitor c=0.0674979f \
 //x=3.78 //y=5.56 //x2=3.195 //y2=5.2
cc_276 ( N_noxref_1_c_75_p N_VDD_M23_noxref_d ) capacitor c=0.00700141f \
 //x=4.475 //y=5.335 //x2=4.075 //y2=5.2
cc_277 ( N_noxref_1_c_83_p N_VDD_M23_noxref_d ) capacitor c=0.0675002f \
 //x=3.78 //y=5.56 //x2=4.075 //y2=5.2
cc_278 ( N_noxref_1_c_96_p N_VDD_M24_noxref_s ) capacitor c=0.00492616f \
 //x=3.78 //y=5.56 //x2=6.255 //y2=5.2
cc_279 ( N_noxref_1_c_75_p N_VDD_M24_noxref_s ) capacitor c=9.42705e-19 \
 //x=4.475 //y=5.335 //x2=6.255 //y2=5.2
cc_280 ( N_noxref_1_c_11_p N_VDD_M24_noxref_s ) capacitor c=5.04452e-19 \
 //x=6.41 //y=3.3 //x2=6.255 //y2=5.2
cc_281 ( N_noxref_1_c_12_p N_VDD_M24_noxref_s ) capacitor c=0.0217981f \
 //x=6.41 //y=4.755 //x2=6.255 //y2=5.2
cc_282 ( N_noxref_1_c_155_p N_VDD_M24_noxref_s ) capacitor c=2.11884e-19 \
 //x=2.9 //y=5.335 //x2=6.255 //y2=5.2
cc_283 ( N_noxref_1_c_19_p N_VDD_M24_noxref_s ) capacitor c=0.00983413f \
 //x=6.41 //y=4.88 //x2=6.255 //y2=5.2
cc_284 ( N_noxref_1_M24_noxref_g N_VDD_M24_noxref_s ) capacitor c=0.053419f \
 //x=6.61 //y=6.2 //x2=6.255 //y2=5.2
cc_285 ( N_noxref_1_c_30_p N_VDD_M24_noxref_s ) capacitor c=0.00607743f \
 //x=6.685 //y=4.97 //x2=6.255 //y2=5.2
cc_286 ( N_noxref_1_M25_noxref_g N_VDD_M25_noxref_d ) capacitor c=0.015318f \
 //x=7.05 //y=6.2 //x2=7.125 //y2=5.2
cc_287 ( N_noxref_1_c_33_p N_VDD_M30_noxref_s ) capacitor c=5.01372e-19 \
 //x=11.22 //y=3.3 //x2=11.065 //y2=5.2
cc_288 ( N_noxref_1_c_34_p N_VDD_M30_noxref_s ) capacitor c=0.0217981f \
 //x=11.22 //y=4.755 //x2=11.065 //y2=5.2
cc_289 ( N_noxref_1_c_188_p N_VDD_M30_noxref_s ) capacitor c=0.00983846f \
 //x=11.22 //y=4.88 //x2=11.065 //y2=5.2
cc_290 ( N_noxref_1_M30_noxref_g N_VDD_M30_noxref_s ) capacitor c=0.053419f \
 //x=11.42 //y=6.2 //x2=11.065 //y2=5.2
cc_291 ( N_noxref_1_c_190_p N_VDD_M30_noxref_s ) capacitor c=0.00607743f \
 //x=11.495 //y=4.97 //x2=11.065 //y2=5.2
cc_292 ( N_noxref_1_M31_noxref_g N_VDD_M31_noxref_d ) capacitor c=0.015318f \
 //x=11.86 //y=6.2 //x2=11.935 //y2=5.2
cc_293 ( N_noxref_1_c_235_p N_D_M18_noxref_g ) capacitor c=0.00501342f \
 //x=2.022 //y=5.335 //x2=1.8 //y2=6.2
cc_294 ( N_noxref_1_c_237_p N_D_M18_noxref_g ) capacitor c=0.0162284f //x=2.02 \
 //y=5.56 //x2=1.8 //y2=6.2
cc_295 ( N_noxref_1_c_154_p N_D_M19_noxref_g ) capacitor c=0.0130704f //x=2.78 \
 //y=5.335 //x2=2.24 //y2=6.2
cc_296 ( N_noxref_1_c_235_p N_D_M19_noxref_g ) capacitor c=0.00229208f \
 //x=2.022 //y=5.335 //x2=2.24 //y2=6.2
cc_297 ( N_noxref_1_c_237_p N_D_M19_noxref_g ) capacitor c=0.0179041f //x=2.02 \
 //y=5.56 //x2=2.24 //y2=6.2
cc_298 ( N_noxref_1_c_235_p N_D_c_3789_n ) capacitor c=0.00171885f //x=2.022 \
 //y=5.335 //x2=2.165 //y2=4.97
cc_299 ( N_noxref_1_c_237_p N_D_c_3789_n ) capacitor c=0.00291477f //x=2.02 \
 //y=5.56 //x2=2.165 //y2=4.97
cc_300 ( N_noxref_1_c_76_p N_noxref_12_c_3880_n ) capacitor c=0.0036878f \
 //x=4.075 //y=1.305 //x2=4.475 //y2=0.72
cc_301 ( N_noxref_1_c_86_p N_noxref_12_c_3880_n ) capacitor c=0.00366757f \
 //x=4.475 //y=1.845 //x2=4.475 //y2=0.72
cc_302 ( N_noxref_1_M2_noxref_d N_noxref_12_c_3880_n ) capacitor c=0.00949319f \
 //x=3.885 //y=1.095 //x2=4.475 //y2=0.72
cc_303 ( N_noxref_1_M2_noxref_d N_noxref_12_c_3883_n ) capacitor c=0.00120711f \
 //x=3.885 //y=1.095 //x2=3.59 //y2=1.175
cc_304 ( N_noxref_1_c_154_p N_noxref_12_M1_noxref_d ) capacitor c=0.00147545f \
 //x=2.78 //y=5.335 //x2=2.35 //y2=1.09
cc_305 ( N_noxref_1_c_76_p N_noxref_12_M1_noxref_d ) capacitor c=0.00802417f \
 //x=4.075 //y=1.305 //x2=2.35 //y2=1.09
cc_306 ( N_noxref_1_c_76_p N_noxref_12_M2_noxref_s ) capacitor c=0.0098487f \
 //x=4.075 //y=1.305 //x2=3.455 //y2=0.555
cc_307 ( N_noxref_1_c_131_p N_noxref_12_M2_noxref_s ) capacitor c=0.028602f \
 //x=4.075 //y=1.76 //x2=3.455 //y2=0.555
cc_308 ( N_noxref_1_c_86_p N_noxref_12_M2_noxref_s ) capacitor c=0.00820799f \
 //x=4.475 //y=1.845 //x2=3.455 //y2=0.555
cc_309 ( N_noxref_1_c_72_p N_noxref_12_M2_noxref_s ) capacitor c=0.00216661f \
 //x=4.56 //y=3.145 //x2=3.455 //y2=0.555
cc_310 ( N_noxref_1_M2_noxref_d N_noxref_12_M2_noxref_s ) capacitor \
 c=0.0279003f //x=3.885 //y=1.095 //x2=3.455 //y2=0.555
cc_311 ( N_noxref_1_c_14_p N_noxref_13_c_3945_n ) capacitor c=0.00448494f \
 //x=7.735 //y=3.13 //x2=8.315 //y2=1.175
cc_312 ( N_noxref_1_c_76_p N_noxref_13_M4_noxref_d ) capacitor c=3.20746e-19 \
 //x=4.075 //y=1.305 //x2=7.16 //y2=1.09
cc_313 ( N_noxref_1_c_15_p N_noxref_13_M4_noxref_d ) capacitor c=0.00450327f \
 //x=7.305 //y=3.13 //x2=7.16 //y2=1.09
cc_314 ( N_noxref_1_c_14_p N_noxref_13_M5_noxref_s ) capacitor c=0.00315012f \
 //x=7.735 //y=3.13 //x2=8.265 //y2=0.555
cc_315 ( N_noxref_1_c_89_p N_noxref_15_c_4086_n ) capacitor c=0.00120442f \
 //x=11.22 //y=2.98 //x2=13.44 //y2=4.135
cc_316 ( N_noxref_1_c_34_p N_noxref_15_c_4086_n ) capacitor c=5.26304e-19 \
 //x=11.22 //y=4.755 //x2=13.44 //y2=4.135
cc_317 ( N_noxref_1_c_34_p N_noxref_15_c_4088_n ) capacitor c=3.60145e-19 \
 //x=11.22 //y=4.755 //x2=13.44 //y2=4.75
cc_318 ( N_noxref_1_c_76_p N_GND_c_4351_n ) capacitor c=0.00901861f //x=4.075 \
 //y=1.305 //x2=6.29 //y2=0.175
cc_319 ( N_noxref_1_c_86_p N_GND_c_4351_n ) capacitor c=0.00713708f //x=4.475 \
 //y=1.845 //x2=6.29 //y2=0.175
cc_320 ( N_noxref_1_c_68_p N_GND_c_4351_n ) capacitor c=5.55175e-19 //x=4.56 \
 //y=3.305 //x2=6.29 //y2=0.175
cc_321 ( N_noxref_1_M2_noxref_d N_GND_c_4351_n ) capacitor c=2.9462e-19 \
 //x=3.885 //y=1.095 //x2=6.29 //y2=0.175
cc_322 ( N_noxref_1_c_51_p N_GND_c_4355_n ) capacitor c=3.97665e-19 //x=6.11 \
 //y=1.055 //x2=6.375 //y2=1.015
cc_323 ( N_noxref_1_c_323_p N_GND_c_4355_n ) capacitor c=0.00864776f //x=6.485 \
 //y=0.9 //x2=6.375 //y2=1.015
cc_324 ( N_noxref_1_c_53_p N_GND_c_4355_n ) capacitor c=4.45447e-19 //x=6.64 \
 //y=1.055 //x2=6.375 //y2=1.015
cc_325 ( N_noxref_1_c_204_p N_GND_c_4358_n ) capacitor c=3.97665e-19 //x=10.92 \
 //y=1.055 //x2=11.185 //y2=1.015
cc_326 ( N_noxref_1_c_326_p N_GND_c_4358_n ) capacitor c=0.00864776f \
 //x=11.295 //y=0.9 //x2=11.185 //y2=1.015
cc_327 ( N_noxref_1_c_206_p N_GND_c_4358_n ) capacitor c=4.45447e-19 //x=11.45 \
 //y=1.055 //x2=11.185 //y2=1.015
cc_328 ( N_noxref_1_c_76_p N_GND_c_4361_n ) capacitor c=0.00543195f //x=4.075 \
 //y=1.305 //x2=6.375 //y2=1.145
cc_329 ( N_noxref_1_c_21_p N_GND_c_4361_n ) capacitor c=0.00814035f //x=6.41 \
 //y=2.375 //x2=6.375 //y2=1.145
cc_330 ( N_noxref_1_c_11_p N_GND_c_4361_n ) capacitor c=8.59136e-19 //x=6.41 \
 //y=3.3 //x2=6.375 //y2=1.145
cc_331 ( N_noxref_1_c_15_p N_GND_c_4361_n ) capacitor c=0.00273958f //x=7.305 \
 //y=3.13 //x2=6.375 //y2=1.145
cc_332 ( N_noxref_1_c_16_p N_GND_c_4361_n ) capacitor c=2.22883e-19 //x=6.41 \
 //y=2.26 //x2=6.375 //y2=1.145
cc_333 ( N_noxref_1_c_51_p N_GND_c_4361_n ) capacitor c=0.00156339f //x=6.11 \
 //y=1.055 //x2=6.375 //y2=1.145
cc_334 ( N_noxref_1_c_52_p N_GND_c_4361_n ) capacitor c=0.00352472f //x=6.11 \
 //y=1.4 //x2=6.375 //y2=1.145
cc_335 ( N_noxref_1_c_54_p N_GND_c_4361_n ) capacitor c=4.27698e-19 //x=6.11 \
 //y=1.71 //x2=6.375 //y2=1.145
cc_336 ( N_noxref_1_c_323_p N_GND_c_4361_n ) capacitor c=9.36995e-19 //x=6.485 \
 //y=0.9 //x2=6.375 //y2=1.145
cc_337 ( N_noxref_1_c_337_p N_GND_c_4361_n ) capacitor c=5.56938e-19 //x=6.485 \
 //y=1.555 //x2=6.375 //y2=1.145
cc_338 ( N_noxref_1_c_53_p N_GND_c_4361_n ) capacitor c=0.0017438f //x=6.64 \
 //y=1.055 //x2=6.375 //y2=1.145
cc_339 ( N_noxref_1_c_55_p N_GND_c_4361_n ) capacitor c=0.00276804f //x=6.64 \
 //y=1.4 //x2=6.375 //y2=1.145
cc_340 ( N_noxref_1_c_88_p N_GND_c_4373_n ) capacitor c=0.00814035f //x=11.22 \
 //y=2.375 //x2=11.185 //y2=1.145
cc_341 ( N_noxref_1_c_33_p N_GND_c_4373_n ) capacitor c=9.6179e-19 //x=11.22 \
 //y=3.3 //x2=11.185 //y2=1.145
cc_342 ( N_noxref_1_c_14_p N_GND_c_4373_n ) capacitor c=0.00278823f //x=7.735 \
 //y=3.13 //x2=11.185 //y2=1.145
cc_343 ( N_noxref_1_c_178_p N_GND_c_4373_n ) capacitor c=2.22883e-19 //x=11.22 \
 //y=2.26 //x2=11.185 //y2=1.145
cc_344 ( N_noxref_1_c_204_p N_GND_c_4373_n ) capacitor c=0.00156339f //x=10.92 \
 //y=1.055 //x2=11.185 //y2=1.145
cc_345 ( N_noxref_1_c_205_p N_GND_c_4373_n ) capacitor c=0.00352472f //x=10.92 \
 //y=1.4 //x2=11.185 //y2=1.145
cc_346 ( N_noxref_1_c_207_p N_GND_c_4373_n ) capacitor c=4.09316e-19 //x=10.92 \
 //y=1.71 //x2=11.185 //y2=1.145
cc_347 ( N_noxref_1_c_326_p N_GND_c_4373_n ) capacitor c=9.36995e-19 \
 //x=11.295 //y=0.9 //x2=11.185 //y2=1.145
cc_348 ( N_noxref_1_c_348_p N_GND_c_4373_n ) capacitor c=5.56938e-19 \
 //x=11.295 //y=1.555 //x2=11.185 //y2=1.145
cc_349 ( N_noxref_1_c_206_p N_GND_c_4373_n ) capacitor c=0.0017438f //x=11.45 \
 //y=1.055 //x2=11.185 //y2=1.145
cc_350 ( N_noxref_1_c_208_p N_GND_c_4373_n ) capacitor c=0.00276804f //x=11.45 \
 //y=1.4 //x2=11.185 //y2=1.145
cc_351 ( N_noxref_1_c_86_p N_GND_c_4384_n ) capacitor c=6.86343e-19 //x=4.475 \
 //y=1.845 //x2=5.13 //y2=0.175
cc_352 ( N_noxref_1_c_68_p N_GND_c_4384_n ) capacitor c=4.87199e-19 //x=4.56 \
 //y=3.305 //x2=5.13 //y2=0.175
cc_353 ( N_noxref_1_c_51_p N_GND_c_4386_n ) capacitor c=0.00677849f //x=6.11 \
 //y=1.055 //x2=9.94 //y2=0.175
cc_354 ( N_noxref_1_c_204_p N_GND_c_4387_n ) capacitor c=0.00677849f //x=10.92 \
 //y=1.055 //x2=14.75 //y2=0.175
cc_355 ( N_noxref_1_c_131_p N_GND_c_4388_n ) capacitor c=0.0045138f //x=4.075 \
 //y=1.76 //x2=5.3 //y2=0.175
cc_356 ( N_noxref_1_c_86_p N_GND_c_4388_n ) capacitor c=0.0349977f //x=4.475 \
 //y=1.845 //x2=5.3 //y2=0.175
cc_357 ( N_noxref_1_c_21_p N_GND_c_4388_n ) capacitor c=0.00407472f //x=6.41 \
 //y=2.375 //x2=5.3 //y2=0.175
cc_358 ( N_noxref_1_c_10_p N_GND_c_4388_n ) capacitor c=0.0118341f //x=6.41 \
 //y=2.98 //x2=5.3 //y2=0.175
cc_359 ( N_noxref_1_c_106_p N_GND_c_4388_n ) capacitor c=0.00722808f //x=6.25 \
 //y=3.145 //x2=5.3 //y2=0.175
cc_360 ( N_noxref_1_c_16_p N_GND_c_4388_n ) capacitor c=0.00394651f //x=6.41 \
 //y=2.26 //x2=5.3 //y2=0.175
cc_361 ( N_noxref_1_c_54_p N_GND_c_4388_n ) capacitor c=0.00170145f //x=6.11 \
 //y=1.71 //x2=5.3 //y2=0.175
cc_362 ( N_noxref_1_c_24_p N_GND_c_4388_n ) capacitor c=0.0103608f //x=6.11 \
 //y=2.095 //x2=5.3 //y2=0.175
cc_363 ( N_noxref_1_c_88_p N_GND_c_4396_n ) capacitor c=0.00407472f //x=11.22 \
 //y=2.375 //x2=10.11 //y2=0.175
cc_364 ( N_noxref_1_c_89_p N_GND_c_4396_n ) capacitor c=0.00911902f //x=11.22 \
 //y=2.98 //x2=10.11 //y2=0.175
cc_365 ( N_noxref_1_c_14_p N_GND_c_4396_n ) capacitor c=0.00722808f //x=7.735 \
 //y=3.13 //x2=10.11 //y2=0.175
cc_366 ( N_noxref_1_c_178_p N_GND_c_4396_n ) capacitor c=0.00394651f //x=11.22 \
 //y=2.26 //x2=10.11 //y2=0.175
cc_367 ( N_noxref_1_c_207_p N_GND_c_4396_n ) capacitor c=0.00170145f //x=10.92 \
 //y=1.71 //x2=10.11 //y2=0.175
cc_368 ( N_noxref_1_c_179_p N_GND_c_4396_n ) capacitor c=0.0103608f //x=10.92 \
 //y=2.095 //x2=10.11 //y2=0.175
cc_369 ( N_noxref_1_c_21_p N_GND_M3_noxref_d ) capacitor c=4.4417e-19 //x=6.41 \
 //y=2.375 //x2=6.185 //y2=1.055
cc_370 ( N_noxref_1_c_51_p N_GND_M3_noxref_d ) capacitor c=0.00184354f \
 //x=6.11 //y=1.055 //x2=6.185 //y2=1.055
cc_371 ( N_noxref_1_c_52_p N_GND_M3_noxref_d ) capacitor c=0.00210798f \
 //x=6.11 //y=1.4 //x2=6.185 //y2=1.055
cc_372 ( N_noxref_1_c_323_p N_GND_M3_noxref_d ) capacitor c=0.00474029f \
 //x=6.485 //y=0.9 //x2=6.185 //y2=1.055
cc_373 ( N_noxref_1_c_337_p N_GND_M3_noxref_d ) capacitor c=0.00166857f \
 //x=6.485 //y=1.555 //x2=6.185 //y2=1.055
cc_374 ( N_noxref_1_c_53_p N_GND_M3_noxref_d ) capacitor c=0.00230174f \
 //x=6.64 //y=1.055 //x2=6.185 //y2=1.055
cc_375 ( N_noxref_1_c_55_p N_GND_M3_noxref_d ) capacitor c=0.00210798f \
 //x=6.64 //y=1.4 //x2=6.185 //y2=1.055
cc_376 ( N_noxref_1_c_88_p N_GND_M6_noxref_d ) capacitor c=4.4417e-19 \
 //x=11.22 //y=2.375 //x2=10.995 //y2=1.055
cc_377 ( N_noxref_1_c_204_p N_GND_M6_noxref_d ) capacitor c=0.00184354f \
 //x=10.92 //y=1.055 //x2=10.995 //y2=1.055
cc_378 ( N_noxref_1_c_205_p N_GND_M6_noxref_d ) capacitor c=0.00210798f \
 //x=10.92 //y=1.4 //x2=10.995 //y2=1.055
cc_379 ( N_noxref_1_c_326_p N_GND_M6_noxref_d ) capacitor c=0.00474029f \
 //x=11.295 //y=0.9 //x2=10.995 //y2=1.055
cc_380 ( N_noxref_1_c_348_p N_GND_M6_noxref_d ) capacitor c=0.00166857f \
 //x=11.295 //y=1.555 //x2=10.995 //y2=1.055
cc_381 ( N_noxref_1_c_206_p N_GND_M6_noxref_d ) capacitor c=0.00230174f \
 //x=11.45 //y=1.055 //x2=10.995 //y2=1.055
cc_382 ( N_noxref_1_c_208_p N_GND_M6_noxref_d ) capacitor c=0.00210798f \
 //x=11.45 //y=1.4 //x2=10.995 //y2=1.055
cc_383 ( N_noxref_1_c_106_p N_noxref_21_c_4951_n ) capacitor c=0.00318305f \
 //x=6.25 //y=3.145 //x2=5.89 //y2=1.685
cc_384 ( N_noxref_1_c_24_p N_noxref_21_c_4951_n ) capacitor c=0.00262672f \
 //x=6.11 //y=2.095 //x2=5.89 //y2=1.685
cc_385 ( N_noxref_1_c_21_p N_noxref_21_c_4953_n ) capacitor c=0.00428451f \
 //x=6.41 //y=2.375 //x2=6.775 //y2=1.77
cc_386 ( N_noxref_1_c_11_p N_noxref_21_c_4953_n ) capacitor c=0.00259355f \
 //x=6.41 //y=3.3 //x2=6.775 //y2=1.77
cc_387 ( N_noxref_1_c_106_p N_noxref_21_c_4953_n ) capacitor c=0.0056247f \
 //x=6.25 //y=3.145 //x2=6.775 //y2=1.77
cc_388 ( N_noxref_1_c_15_p N_noxref_21_c_4953_n ) capacitor c=0.00172959f \
 //x=7.305 //y=3.13 //x2=6.775 //y2=1.77
cc_389 ( N_noxref_1_c_16_p N_noxref_21_c_4953_n ) capacitor c=0.0104666f \
 //x=6.41 //y=2.26 //x2=6.775 //y2=1.77
cc_390 ( N_noxref_1_c_54_p N_noxref_21_c_4953_n ) capacitor c=0.00705077f \
 //x=6.11 //y=1.71 //x2=6.775 //y2=1.77
cc_391 ( N_noxref_1_c_24_p N_noxref_21_c_4953_n ) capacitor c=0.0213793f \
 //x=6.11 //y=2.095 //x2=6.775 //y2=1.77
cc_392 ( N_noxref_1_c_337_p N_noxref_21_c_4953_n ) capacitor c=0.00588627f \
 //x=6.485 //y=1.555 //x2=6.775 //y2=1.77
cc_393 ( N_noxref_1_c_55_p N_noxref_21_c_4953_n ) capacitor c=0.00698822f \
 //x=6.64 //y=1.4 //x2=6.775 //y2=1.77
cc_394 ( N_noxref_1_c_15_p N_noxref_21_c_4962_n ) capacitor c=0.00913468f \
 //x=7.305 //y=3.13 //x2=7.745 //y2=1.77
cc_395 ( N_noxref_1_c_14_p N_noxref_21_M3_noxref_s ) capacitor c=0.0028111f \
 //x=7.735 //y=3.13 //x2=5.755 //y2=0.555
cc_396 ( N_noxref_1_c_15_p N_noxref_21_M3_noxref_s ) capacitor c=0.00318305f \
 //x=7.305 //y=3.13 //x2=5.755 //y2=0.555
cc_397 ( N_noxref_1_c_51_p N_noxref_21_M3_noxref_s ) capacitor c=0.0295256f \
 //x=6.11 //y=1.055 //x2=5.755 //y2=0.555
cc_398 ( N_noxref_1_c_54_p N_noxref_21_M3_noxref_s ) capacitor c=7.99997e-19 \
 //x=6.11 //y=1.71 //x2=5.755 //y2=0.555
cc_399 ( N_noxref_1_c_24_p N_noxref_21_M3_noxref_s ) capacitor c=0.00122123f \
 //x=6.11 //y=2.095 //x2=5.755 //y2=0.555
cc_400 ( N_noxref_1_c_53_p N_noxref_21_M3_noxref_s ) capacitor c=0.0125924f \
 //x=6.64 //y=1.055 //x2=5.755 //y2=0.555
cc_401 ( N_noxref_1_c_14_p N_noxref_22_c_5012_n ) capacitor c=0.00318305f \
 //x=7.735 //y=3.13 //x2=10.7 //y2=1.685
cc_402 ( N_noxref_1_c_179_p N_noxref_22_c_5012_n ) capacitor c=0.00262672f \
 //x=10.92 //y=2.095 //x2=10.7 //y2=1.685
cc_403 ( N_noxref_1_c_88_p N_noxref_22_c_5014_n ) capacitor c=0.00428451f \
 //x=11.22 //y=2.375 //x2=11.585 //y2=1.77
cc_404 ( N_noxref_1_c_33_p N_noxref_22_c_5014_n ) capacitor c=0.00331471f \
 //x=11.22 //y=3.3 //x2=11.585 //y2=1.77
cc_405 ( N_noxref_1_c_14_p N_noxref_22_c_5014_n ) capacitor c=0.00363969f \
 //x=7.735 //y=3.13 //x2=11.585 //y2=1.77
cc_406 ( N_noxref_1_c_178_p N_noxref_22_c_5014_n ) capacitor c=0.0104666f \
 //x=11.22 //y=2.26 //x2=11.585 //y2=1.77
cc_407 ( N_noxref_1_c_207_p N_noxref_22_c_5014_n ) capacitor c=0.00705077f \
 //x=10.92 //y=1.71 //x2=11.585 //y2=1.77
cc_408 ( N_noxref_1_c_179_p N_noxref_22_c_5014_n ) capacitor c=0.0206583f \
 //x=10.92 //y=2.095 //x2=11.585 //y2=1.77
cc_409 ( N_noxref_1_c_348_p N_noxref_22_c_5014_n ) capacitor c=0.00588627f \
 //x=11.295 //y=1.555 //x2=11.585 //y2=1.77
cc_410 ( N_noxref_1_c_208_p N_noxref_22_c_5014_n ) capacitor c=0.00698822f \
 //x=11.45 //y=1.4 //x2=11.585 //y2=1.77
cc_411 ( N_noxref_1_c_204_p N_noxref_22_M6_noxref_s ) capacitor c=0.0295256f \
 //x=10.92 //y=1.055 //x2=10.565 //y2=0.555
cc_412 ( N_noxref_1_c_207_p N_noxref_22_M6_noxref_s ) capacitor c=7.99997e-19 \
 //x=10.92 //y=1.71 //x2=10.565 //y2=0.555
cc_413 ( N_noxref_1_c_179_p N_noxref_22_M6_noxref_s ) capacitor c=0.00122123f \
 //x=10.92 //y=2.095 //x2=10.565 //y2=0.555
cc_414 ( N_noxref_1_c_206_p N_noxref_22_M6_noxref_s ) capacitor c=0.0125924f \
 //x=11.45 //y=1.055 //x2=10.565 //y2=0.555
cc_415 ( N_noxref_2_c_423_p CLK ) capacitor c=9.01273e-19 //x=14.18 //y=2.985 \
 //x2=17.14 //y2=3.14
cc_416 ( N_noxref_2_c_424_p CLK ) capacitor c=0.014889f //x=16.03 //y=2.98 \
 //x2=17.14 //y2=3.14
cc_417 ( N_noxref_2_c_425_p CLK ) capacitor c=0.00775314f //x=16.03 //y=3.3 \
 //x2=17.14 //y2=3.14
cc_418 ( N_noxref_2_c_426_p CLK ) capacitor c=0.00141922f //x=16.03 //y=4.755 \
 //x2=17.14 //y2=3.14
cc_419 ( N_noxref_2_c_427_p CLK ) capacitor c=2.90818e-19 //x=16.03 //y=3.14 \
 //x2=17.14 //y2=3.14
cc_420 ( N_noxref_2_c_428_p CLK ) capacitor c=0.00508569f //x=16.03 //y=3.14 \
 //x2=17.14 //y2=3.14
cc_421 ( N_noxref_2_c_429_p CLK ) capacitor c=4.16726e-19 //x=16.03 //y=2.26 \
 //x2=17.14 //y2=3.14
cc_422 ( N_noxref_2_c_426_p CLK ) capacitor c=3.43503e-19 //x=16.03 //y=4.755 \
 //x2=17.14 //y2=3.51
cc_423 ( N_noxref_2_c_431_p N_CLK_c_768_n ) capacitor c=0.0115546f //x=16.03 \
 //y=2.375 //x2=17.14 //y2=2.375
cc_424 ( N_noxref_2_c_429_p N_CLK_c_768_n ) capacitor c=5.40058e-19 //x=16.03 \
 //y=2.26 //x2=17.14 //y2=2.375
cc_425 ( N_noxref_2_c_433_p N_CLK_c_768_n ) capacitor c=0.00147006f //x=15.73 \
 //y=2.095 //x2=17.14 //y2=2.375
cc_426 ( N_noxref_2_c_426_p N_CLK_c_771_n ) capacitor c=0.00775437f //x=16.03 \
 //y=4.755 //x2=17.14 //y2=3.665
cc_427 ( N_noxref_2_c_435_p N_CLK_c_772_n ) capacitor c=8.17316e-19 //x=14.18 \
 //y=5.25 //x2=17.14 //y2=4.765
cc_428 ( N_noxref_2_c_426_p N_CLK_c_772_n ) capacitor c=0.0349906f //x=16.03 \
 //y=4.755 //x2=17.14 //y2=4.765
cc_429 ( N_noxref_2_c_437_p N_CLK_c_772_n ) capacitor c=6.26008e-19 //x=16.03 \
 //y=4.88 //x2=17.14 //y2=4.765
cc_430 ( N_noxref_2_c_438_p N_CLK_c_772_n ) capacitor c=7.66769e-19 //x=16.595 \
 //y=4.97 //x2=17.14 //y2=4.765
cc_431 ( N_noxref_2_c_439_p N_CLK_c_772_n ) capacitor c=7.54501e-19 //x=16.305 \
 //y=4.97 //x2=17.14 //y2=4.765
cc_432 ( N_noxref_2_c_440_p N_CLK_c_777_n ) capacitor c=0.00155291f //x=14.18 \
 //y=3.305 //x2=13.79 //y2=3.51
cc_433 ( N_noxref_2_c_435_p N_CLK_c_777_n ) capacitor c=4.11092e-19 //x=14.18 \
 //y=5.25 //x2=13.79 //y2=3.51
cc_434 ( N_noxref_2_c_442_p N_CLK_c_777_n ) capacitor c=0.0358254f //x=14.335 \
 //y=3.145 //x2=13.79 //y2=3.51
cc_435 ( N_noxref_2_c_440_p N_CLK_c_780_n ) capacitor c=0.00772002f //x=14.18 \
 //y=3.305 //x2=14.39 //y2=3.53
cc_436 ( N_noxref_2_c_435_p N_CLK_c_780_n ) capacitor c=0.0226196f //x=14.18 \
 //y=5.25 //x2=14.39 //y2=3.53
cc_437 ( N_noxref_2_c_445_p N_CLK_c_780_n ) capacitor c=0.127872f //x=15.87 \
 //y=3.14 //x2=14.39 //y2=3.53
cc_438 ( N_noxref_2_c_425_p N_CLK_c_783_n ) capacitor c=0.00359912f //x=16.03 \
 //y=3.3 //x2=15.645 //y2=3.51
cc_439 ( N_noxref_2_c_426_p N_CLK_c_783_n ) capacitor c=5.02854e-19 //x=16.03 \
 //y=4.755 //x2=15.645 //y2=3.51
cc_440 ( N_noxref_2_c_445_p N_CLK_c_783_n ) capacitor c=0.0108538f //x=15.87 \
 //y=3.14 //x2=15.645 //y2=3.51
cc_441 ( N_noxref_2_c_428_p N_CLK_c_783_n ) capacitor c=0.0358254f //x=16.03 \
 //y=3.14 //x2=15.645 //y2=3.51
cc_442 ( N_noxref_2_c_425_p N_CLK_c_787_n ) capacitor c=0.00288354f //x=16.03 \
 //y=3.3 //x2=16.245 //y2=3.525
cc_443 ( N_noxref_2_c_426_p N_CLK_c_787_n ) capacitor c=0.0256465f //x=16.03 \
 //y=4.755 //x2=16.245 //y2=3.525
cc_444 ( N_noxref_2_c_431_p N_CLK_c_789_n ) capacitor c=5.39999e-19 //x=16.03 \
 //y=2.375 //x2=17.14 //y2=2.26
cc_445 ( N_noxref_2_c_424_p N_CLK_c_789_n ) capacitor c=4.16726e-19 //x=16.03 \
 //y=2.98 //x2=17.14 //y2=2.26
cc_446 ( N_noxref_2_c_429_p N_CLK_c_789_n ) capacitor c=0.00125213f //x=16.03 \
 //y=2.26 //x2=17.14 //y2=2.26
cc_447 ( N_noxref_2_c_433_p N_CLK_c_789_n ) capacitor c=0.00214573f //x=15.73 \
 //y=2.095 //x2=17.14 //y2=2.26
cc_448 ( N_noxref_2_c_426_p N_CLK_c_793_n ) capacitor c=0.00103399f //x=16.03 \
 //y=4.755 //x2=17.14 //y2=4.88
cc_449 ( N_noxref_2_c_437_p N_CLK_c_793_n ) capacitor c=0.00113984f //x=16.03 \
 //y=4.88 //x2=17.14 //y2=4.88
cc_450 ( N_noxref_2_c_438_p N_CLK_c_793_n ) capacitor c=0.00116563f //x=16.595 \
 //y=4.97 //x2=17.14 //y2=4.88
cc_451 ( N_noxref_2_c_439_p N_CLK_c_793_n ) capacitor c=0.00129812f //x=16.305 \
 //y=4.97 //x2=17.14 //y2=4.88
cc_452 ( N_noxref_2_M36_noxref_g N_CLK_M38_noxref_g ) capacitor c=0.0106276f \
 //x=16.23 //y=6.2 //x2=17.11 //y2=6.2
cc_453 ( N_noxref_2_M37_noxref_g N_CLK_M38_noxref_g ) capacitor c=0.107144f \
 //x=16.67 //y=6.2 //x2=17.11 //y2=6.2
cc_454 ( N_noxref_2_M37_noxref_g N_CLK_M39_noxref_g ) capacitor c=0.0101598f \
 //x=16.67 //y=6.2 //x2=17.55 //y2=6.2
cc_455 ( N_noxref_2_c_463_p N_CLK_c_800_n ) capacitor c=5.72528e-19 //x=15.73 \
 //y=1.055 //x2=16.705 //y2=1.09
cc_456 ( N_noxref_2_c_464_p N_CLK_c_800_n ) capacitor c=0.00150277f //x=15.73 \
 //y=1.4 //x2=16.705 //y2=1.09
cc_457 ( N_noxref_2_c_465_p N_CLK_c_800_n ) capacitor c=0.0160123f //x=16.26 \
 //y=1.055 //x2=16.705 //y2=1.09
cc_458 ( N_noxref_2_c_466_p N_CLK_c_803_n ) capacitor c=0.00111227f //x=15.73 \
 //y=1.71 //x2=16.705 //y2=1.4
cc_459 ( N_noxref_2_c_467_p N_CLK_c_803_n ) capacitor c=0.0124075f //x=16.26 \
 //y=1.4 //x2=16.705 //y2=1.4
cc_460 ( N_noxref_2_c_465_p N_CLK_c_805_n ) capacitor c=9.19165e-19 //x=16.26 \
 //y=1.055 //x2=17.23 //y2=1.09
cc_461 ( N_noxref_2_c_467_p N_CLK_c_806_n ) capacitor c=0.0010154f //x=16.26 \
 //y=1.4 //x2=17.23 //y2=1.4
cc_462 ( N_noxref_2_c_467_p N_CLK_c_807_n ) capacitor c=9.23422e-19 //x=16.26 \
 //y=1.4 //x2=17.23 //y2=1.63
cc_463 ( N_noxref_2_c_431_p N_CLK_c_808_n ) capacitor c=0.00140534f //x=16.03 \
 //y=2.375 //x2=17.23 //y2=2.095
cc_464 ( N_noxref_2_c_429_p N_CLK_c_808_n ) capacitor c=0.0020754f //x=16.03 \
 //y=2.26 //x2=17.23 //y2=2.095
cc_465 ( N_noxref_2_c_433_p N_CLK_c_808_n ) capacitor c=0.00964411f //x=15.73 \
 //y=2.095 //x2=17.23 //y2=2.095
cc_466 ( N_noxref_2_c_426_p N_CLK_c_811_n ) capacitor c=0.00116212f //x=16.03 \
 //y=4.755 //x2=17.14 //y2=4.88
cc_467 ( N_noxref_2_c_437_p N_CLK_c_811_n ) capacitor c=0.00155973f //x=16.03 \
 //y=4.88 //x2=17.14 //y2=4.88
cc_468 ( N_noxref_2_c_438_p N_CLK_c_811_n ) capacitor c=0.0171374f //x=16.595 \
 //y=4.97 //x2=17.14 //y2=4.88
cc_469 ( N_noxref_2_c_439_p N_CLK_c_811_n ) capacitor c=0.00484466f //x=16.305 \
 //y=4.97 //x2=17.14 //y2=4.88
cc_470 ( N_noxref_2_c_416_n N_noxref_4_c_1126_n ) capacitor c=6.09703e-19 \
 //x=11.642 //y=5.335 //x2=8.59 //y2=5.56
cc_471 ( N_noxref_2_c_416_n N_noxref_4_c_1127_n ) capacitor c=0.00306432f \
 //x=11.642 //y=5.335 //x2=9.285 //y2=5.335
cc_472 ( N_noxref_2_c_480_p N_noxref_4_c_1128_n ) capacitor c=0.00163399f \
 //x=13.78 //y=1.845 //x2=9.285 //y2=1.845
cc_473 ( N_noxref_2_c_435_p N_noxref_4_c_1086_n ) capacitor c=0.0231681f \
 //x=14.18 //y=5.25 //x2=17.01 //y2=3.89
cc_474 ( N_noxref_2_c_426_p N_noxref_4_c_1086_n ) capacitor c=0.0249454f \
 //x=16.03 //y=4.755 //x2=17.01 //y2=3.89
cc_475 ( N_noxref_2_c_445_p N_noxref_4_c_1086_n ) capacitor c=0.0102954f \
 //x=15.87 //y=3.14 //x2=17.01 //y2=3.89
cc_476 ( N_noxref_2_c_424_p RN ) capacitor c=7.39471e-19 //x=16.03 //y=2.98 \
 //x2=18.25 //y2=3.14
cc_477 ( N_noxref_2_c_426_p RN ) capacitor c=0.00175546f //x=16.03 //y=4.755 \
 //x2=18.25 //y2=3.14
cc_478 ( N_noxref_2_c_486_p N_RN_c_1524_n ) capacitor c=0.0217584f //x=14.095 \
 //y=5.335 //x2=18.86 //y2=4.63
cc_479 ( N_noxref_2_c_435_p N_RN_c_1524_n ) capacitor c=0.0300559f //x=14.18 \
 //y=5.25 //x2=18.86 //y2=4.63
cc_480 ( N_noxref_2_c_426_p N_RN_c_1524_n ) capacitor c=0.0327619f //x=16.03 \
 //y=4.755 //x2=18.86 //y2=4.63
cc_481 ( N_noxref_2_c_416_n N_RN_c_1524_n ) capacitor c=0.0297308f //x=11.642 \
 //y=5.335 //x2=18.86 //y2=4.63
cc_482 ( N_noxref_2_c_490_p N_RN_c_1524_n ) capacitor c=0.0366698f //x=12.52 \
 //y=5.335 //x2=18.86 //y2=4.63
cc_483 ( N_noxref_2_c_423_p N_SN_c_2225_n ) capacitor c=5.96949e-19 //x=14.18 \
 //y=2.985 //x2=12.33 //y2=2.615
cc_484 ( N_noxref_2_c_415_n N_SN_c_2227_n ) capacitor c=4.00712e-19 //x=12.4 \
 //y=5.335 //x2=12.33 //y2=2.935
cc_485 ( N_noxref_2_c_490_p N_SN_c_2227_n ) capacitor c=0.00123192f //x=12.52 \
 //y=5.335 //x2=12.33 //y2=2.935
cc_486 ( N_noxref_2_c_494_p N_SN_c_2227_n ) capacitor c=3.89771e-19 //x=12.52 \
 //y=5.56 //x2=12.33 //y2=2.935
cc_487 ( N_noxref_2_c_415_n N_SN_c_2228_n ) capacitor c=0.0213631f //x=12.4 \
 //y=5.335 //x2=12.33 //y2=4.765
cc_488 ( N_noxref_2_c_435_p N_SN_c_2228_n ) capacitor c=0.00172199f //x=14.18 \
 //y=5.25 //x2=12.33 //y2=4.765
cc_489 ( N_noxref_2_c_490_p N_SN_c_2228_n ) capacitor c=0.00239361f //x=12.52 \
 //y=5.335 //x2=12.33 //y2=4.765
cc_490 ( N_noxref_2_c_494_p N_SN_c_2228_n ) capacitor c=6.21282e-19 //x=12.52 \
 //y=5.56 //x2=12.33 //y2=4.765
cc_491 ( N_noxref_2_c_499_p N_SN_c_2272_n ) capacitor c=5.00731e-19 //x=13.695 \
 //y=1.305 //x2=13.79 //y2=2.77
cc_492 ( N_noxref_2_c_500_p N_SN_c_2272_n ) capacitor c=0.00580453f //x=14.095 \
 //y=1.845 //x2=13.79 //y2=2.77
cc_493 ( N_noxref_2_c_480_p N_SN_c_2272_n ) capacitor c=0.00817689f //x=13.78 \
 //y=1.845 //x2=13.79 //y2=2.77
cc_494 ( N_noxref_2_c_423_p N_SN_c_2272_n ) capacitor c=2.17369e-19 //x=14.18 \
 //y=2.985 //x2=13.79 //y2=2.77
cc_495 ( N_noxref_2_c_423_p N_SN_c_2276_n ) capacitor c=0.0278999f //x=14.18 \
 //y=2.985 //x2=14.39 //y2=2.76
cc_496 ( N_noxref_2_c_440_p N_SN_c_2276_n ) capacitor c=0.00863711f //x=14.18 \
 //y=3.305 //x2=14.39 //y2=2.76
cc_497 ( N_noxref_2_c_445_p N_SN_c_2276_n ) capacitor c=0.133801f //x=15.87 \
 //y=3.14 //x2=14.39 //y2=2.76
cc_498 ( N_noxref_2_c_442_p N_SN_c_2276_n ) capacitor c=0.0365231f //x=14.335 \
 //y=3.145 //x2=14.39 //y2=2.76
cc_499 ( N_noxref_2_c_424_p N_SN_c_2280_n ) capacitor c=5.03806e-19 //x=16.03 \
 //y=2.98 //x2=15.645 //y2=2.77
cc_500 ( N_noxref_2_c_425_p N_SN_c_2280_n ) capacitor c=0.00333241f //x=16.03 \
 //y=3.3 //x2=15.645 //y2=2.77
cc_501 ( N_noxref_2_c_445_p N_SN_c_2280_n ) capacitor c=0.011069f //x=15.87 \
 //y=3.14 //x2=15.645 //y2=2.77
cc_502 ( N_noxref_2_c_431_p N_SN_c_2283_n ) capacitor c=0.00248089f //x=16.03 \
 //y=2.375 //x2=16.245 //y2=2.755
cc_503 ( N_noxref_2_c_424_p N_SN_c_2283_n ) capacitor c=0.0279509f //x=16.03 \
 //y=2.98 //x2=16.245 //y2=2.755
cc_504 ( N_noxref_2_c_425_p N_SN_c_2283_n ) capacitor c=0.00478989f //x=16.03 \
 //y=3.3 //x2=16.245 //y2=2.755
cc_505 ( N_noxref_2_c_428_p N_SN_c_2283_n ) capacitor c=0.0365231f //x=16.03 \
 //y=3.14 //x2=16.245 //y2=2.755
cc_506 ( N_noxref_2_c_415_n N_SN_c_2242_n ) capacitor c=0.00492634f //x=12.4 \
 //y=5.335 //x2=12.33 //y2=4.88
cc_507 ( N_noxref_2_c_490_p N_SN_c_2242_n ) capacitor c=0.00132214f //x=12.52 \
 //y=5.335 //x2=12.33 //y2=4.88
cc_508 ( N_noxref_2_c_415_n N_SN_M32_noxref_g ) capacitor c=0.00858241f \
 //x=12.4 //y=5.335 //x2=12.3 //y2=6.2
cc_509 ( N_noxref_2_c_490_p N_SN_M32_noxref_g ) capacitor c=0.00229818f \
 //x=12.52 //y=5.335 //x2=12.3 //y2=6.2
cc_510 ( N_noxref_2_c_494_p N_SN_M32_noxref_g ) capacitor c=0.0179041f \
 //x=12.52 //y=5.56 //x2=12.3 //y2=6.2
cc_511 ( N_noxref_2_c_519_p N_SN_M33_noxref_g ) capacitor c=0.00955829f \
 //x=13.285 //y=5.335 //x2=12.74 //y2=6.2
cc_512 ( N_noxref_2_c_490_p N_SN_M33_noxref_g ) capacitor c=0.00230699f \
 //x=12.52 //y=5.335 //x2=12.74 //y2=6.2
cc_513 ( N_noxref_2_c_494_p N_SN_M33_noxref_g ) capacitor c=0.0179041f \
 //x=12.52 //y=5.56 //x2=12.74 //y2=6.2
cc_514 ( N_noxref_2_c_490_p N_SN_c_2295_n ) capacitor c=0.00209164f //x=12.52 \
 //y=5.335 //x2=12.665 //y2=4.97
cc_515 ( N_noxref_2_c_494_p N_SN_c_2295_n ) capacitor c=0.00290085f //x=12.52 \
 //y=5.56 //x2=12.665 //y2=4.97
cc_516 ( N_noxref_2_c_415_n N_SN_c_2260_n ) capacitor c=6.02332e-19 //x=12.4 \
 //y=5.335 //x2=12.33 //y2=4.88
cc_517 ( N_noxref_2_M37_noxref_g N_noxref_8_c_2606_n ) capacitor c=0.00893512f \
 //x=16.67 //y=6.2 //x2=17.21 //y2=5.335
cc_518 ( N_noxref_2_c_500_p N_noxref_8_c_2607_n ) capacitor c=0.00163399f \
 //x=14.095 //y=1.845 //x2=18.59 //y2=1.845
cc_519 ( N_noxref_2_c_527_p N_noxref_8_c_2608_n ) capacitor c=6.09703e-19 \
 //x=13.4 //y=5.56 //x2=16.452 //y2=5.335
cc_520 ( N_noxref_2_c_486_p N_noxref_8_c_2608_n ) capacitor c=0.00306432f \
 //x=14.095 //y=5.335 //x2=16.452 //y2=5.335
cc_521 ( N_noxref_2_M36_noxref_g N_noxref_8_c_2608_n ) capacitor c=0.00461408f \
 //x=16.23 //y=6.2 //x2=16.452 //y2=5.335
cc_522 ( N_noxref_2_M37_noxref_g N_noxref_8_c_2608_n ) capacitor c=0.00229208f \
 //x=16.67 //y=6.2 //x2=16.452 //y2=5.335
cc_523 ( N_noxref_2_c_438_p N_noxref_8_c_2608_n ) capacitor c=0.00171885f \
 //x=16.595 //y=4.97 //x2=16.452 //y2=5.335
cc_524 ( N_noxref_2_c_435_p N_noxref_8_c_2605_n ) capacitor c=0.0230354f \
 //x=14.18 //y=5.25 //x2=20.705 //y2=4.265
cc_525 ( N_noxref_2_c_426_p N_noxref_8_c_2605_n ) capacitor c=0.024795f \
 //x=16.03 //y=4.755 //x2=20.705 //y2=4.265
cc_526 ( N_noxref_2_M36_noxref_g N_noxref_8_c_2615_n ) capacitor c=0.0162284f \
 //x=16.23 //y=6.2 //x2=16.45 //y2=5.56
cc_527 ( N_noxref_2_M37_noxref_g N_noxref_8_c_2615_n ) capacitor c=0.0179041f \
 //x=16.67 //y=6.2 //x2=16.45 //y2=5.56
cc_528 ( N_noxref_2_c_438_p N_noxref_8_c_2615_n ) capacitor c=0.00291477f \
 //x=16.595 //y=4.97 //x2=16.45 //y2=5.56
cc_529 ( N_noxref_2_c_415_n N_VDD_c_3378_n ) capacitor c=0.00621363f //x=12.4 \
 //y=5.335 //x2=28.61 //y2=7.58
cc_530 ( N_noxref_2_c_519_p N_VDD_c_3378_n ) capacitor c=0.00627186f \
 //x=13.285 //y=5.335 //x2=28.61 //y2=7.58
cc_531 ( N_noxref_2_c_527_p N_VDD_c_3378_n ) capacitor c=0.00256019f //x=13.4 \
 //y=5.56 //x2=28.61 //y2=7.58
cc_532 ( N_noxref_2_c_486_p N_VDD_c_3378_n ) capacitor c=0.00829248f \
 //x=14.095 //y=5.335 //x2=28.61 //y2=7.58
cc_533 ( N_noxref_2_c_440_p N_VDD_c_3378_n ) capacitor c=4.18205e-19 //x=14.18 \
 //y=3.305 //x2=28.61 //y2=7.58
cc_534 ( N_noxref_2_c_425_p N_VDD_c_3378_n ) capacitor c=3.52434e-19 //x=16.03 \
 //y=3.3 //x2=28.61 //y2=7.58
cc_535 ( N_noxref_2_c_416_n N_VDD_c_3378_n ) capacitor c=0.00261804f \
 //x=11.642 //y=5.335 //x2=28.61 //y2=7.58
cc_536 ( N_noxref_2_c_490_p N_VDD_c_3378_n ) capacitor c=0.00270108f //x=12.52 \
 //y=5.335 //x2=28.61 //y2=7.58
cc_537 ( N_noxref_2_c_420_n N_VDD_c_3378_n ) capacitor c=0.0024232f //x=11.64 \
 //y=5.56 //x2=28.61 //y2=7.58
cc_538 ( N_noxref_2_c_494_p N_VDD_c_3378_n ) capacitor c=0.0024232f //x=12.52 \
 //y=5.56 //x2=28.61 //y2=7.58
cc_539 ( N_noxref_2_c_547_p N_VDD_c_3378_n ) capacitor c=0.0024232f //x=13.4 \
 //y=5.56 //x2=28.61 //y2=7.58
cc_540 ( N_noxref_2_c_415_n N_VDD_c_3406_n ) capacitor c=0.00202922f //x=12.4 \
 //y=5.335 //x2=11.995 //y2=7.585
cc_541 ( N_noxref_2_c_416_n N_VDD_c_3406_n ) capacitor c=9.3757e-19 //x=11.642 \
 //y=5.335 //x2=11.995 //y2=7.585
cc_542 ( N_noxref_2_c_420_n N_VDD_c_3406_n ) capacitor c=0.0138074f //x=11.64 \
 //y=5.56 //x2=11.995 //y2=7.585
cc_543 ( N_noxref_2_c_415_n N_VDD_c_3457_n ) capacitor c=0.0017708f //x=12.4 \
 //y=5.335 //x2=12.875 //y2=7.585
cc_544 ( N_noxref_2_c_519_p N_VDD_c_3457_n ) capacitor c=0.00202922f \
 //x=13.285 //y=5.335 //x2=12.875 //y2=7.585
cc_545 ( N_noxref_2_c_490_p N_VDD_c_3457_n ) capacitor c=9.4822e-19 //x=12.52 \
 //y=5.335 //x2=12.875 //y2=7.585
cc_546 ( N_noxref_2_c_494_p N_VDD_c_3457_n ) capacitor c=0.0138074f //x=12.52 \
 //y=5.56 //x2=12.875 //y2=7.585
cc_547 ( N_noxref_2_c_519_p N_VDD_c_3461_n ) capacitor c=0.00205906f \
 //x=13.285 //y=5.335 //x2=13.755 //y2=7.585
cc_548 ( N_noxref_2_c_527_p N_VDD_c_3461_n ) capacitor c=8.49654e-19 //x=13.4 \
 //y=5.56 //x2=13.755 //y2=7.585
cc_549 ( N_noxref_2_c_486_p N_VDD_c_3461_n ) capacitor c=0.00204238f \
 //x=14.095 //y=5.335 //x2=13.755 //y2=7.585
cc_550 ( N_noxref_2_c_547_p N_VDD_c_3461_n ) capacitor c=0.0135103f //x=13.4 \
 //y=5.56 //x2=13.755 //y2=7.585
cc_551 ( N_noxref_2_c_486_p N_VDD_c_3465_n ) capacitor c=0.00183742f \
 //x=14.095 //y=5.335 //x2=14.75 //y2=7.585
cc_552 ( N_noxref_2_M36_noxref_g N_VDD_c_3466_n ) capacitor c=0.00755614f \
 //x=16.23 //y=6.2 //x2=16.805 //y2=7.585
cc_553 ( N_noxref_2_M37_noxref_g N_VDD_c_3466_n ) capacitor c=0.00755544f \
 //x=16.67 //y=6.2 //x2=16.805 //y2=7.585
cc_554 ( N_noxref_2_c_416_n N_VDD_c_3414_n ) capacitor c=0.0022955f //x=11.642 \
 //y=5.335 //x2=10.11 //y2=7.585
cc_555 ( N_noxref_2_c_420_n N_VDD_c_3414_n ) capacitor c=0.00509469f //x=11.64 \
 //y=5.56 //x2=10.11 //y2=7.585
cc_556 ( N_noxref_2_c_527_p N_VDD_c_3470_n ) capacitor c=0.00282782f //x=13.4 \
 //y=5.56 //x2=14.92 //y2=7.585
cc_557 ( N_noxref_2_c_435_p N_VDD_c_3470_n ) capacitor c=0.0318069f //x=14.18 \
 //y=5.25 //x2=14.92 //y2=7.585
cc_558 ( N_noxref_2_c_426_p N_VDD_c_3470_n ) capacitor c=0.0117388f //x=16.03 \
 //y=4.755 //x2=14.92 //y2=7.585
cc_559 ( N_noxref_2_c_547_p N_VDD_c_3470_n ) capacitor c=0.00777981f //x=13.4 \
 //y=5.56 //x2=14.92 //y2=7.585
cc_560 ( N_noxref_2_c_437_p N_VDD_c_3470_n ) capacitor c=0.00370784f //x=16.03 \
 //y=4.88 //x2=14.92 //y2=7.585
cc_561 ( N_noxref_2_c_439_p N_VDD_c_3470_n ) capacitor c=0.00590568f \
 //x=16.305 //y=4.97 //x2=14.92 //y2=7.585
cc_562 ( N_noxref_2_c_416_n N_VDD_M30_noxref_s ) capacitor c=0.0442713f \
 //x=11.642 //y=5.335 //x2=11.065 //y2=5.2
cc_563 ( N_noxref_2_c_490_p N_VDD_M30_noxref_s ) capacitor c=7.80122e-19 \
 //x=12.52 //y=5.335 //x2=11.065 //y2=5.2
cc_564 ( N_noxref_2_c_420_n N_VDD_M30_noxref_s ) capacitor c=0.09305f \
 //x=11.64 //y=5.56 //x2=11.065 //y2=5.2
cc_565 ( N_noxref_2_c_415_n N_VDD_M31_noxref_d ) capacitor c=0.00700141f \
 //x=12.4 //y=5.335 //x2=11.935 //y2=5.2
cc_566 ( N_noxref_2_c_420_n N_VDD_M31_noxref_d ) capacitor c=0.0674491f \
 //x=11.64 //y=5.56 //x2=11.935 //y2=5.2
cc_567 ( N_noxref_2_c_494_p N_VDD_M31_noxref_d ) capacitor c=0.0674762f \
 //x=12.52 //y=5.56 //x2=11.935 //y2=5.2
cc_568 ( N_noxref_2_c_519_p N_VDD_M33_noxref_d ) capacitor c=0.00700141f \
 //x=13.285 //y=5.335 //x2=12.815 //y2=5.2
cc_569 ( N_noxref_2_c_494_p N_VDD_M33_noxref_d ) capacitor c=0.067493f \
 //x=12.52 //y=5.56 //x2=12.815 //y2=5.2
cc_570 ( N_noxref_2_c_547_p N_VDD_M33_noxref_d ) capacitor c=0.0674979f \
 //x=13.4 //y=5.56 //x2=12.815 //y2=5.2
cc_571 ( N_noxref_2_c_486_p N_VDD_M35_noxref_d ) capacitor c=0.00700141f \
 //x=14.095 //y=5.335 //x2=13.695 //y2=5.2
cc_572 ( N_noxref_2_c_547_p N_VDD_M35_noxref_d ) capacitor c=0.0675002f \
 //x=13.4 //y=5.56 //x2=13.695 //y2=5.2
cc_573 ( N_noxref_2_c_527_p N_VDD_M36_noxref_s ) capacitor c=0.00492616f \
 //x=13.4 //y=5.56 //x2=15.875 //y2=5.2
cc_574 ( N_noxref_2_c_486_p N_VDD_M36_noxref_s ) capacitor c=9.42705e-19 \
 //x=14.095 //y=5.335 //x2=15.875 //y2=5.2
cc_575 ( N_noxref_2_c_425_p N_VDD_M36_noxref_s ) capacitor c=5.01372e-19 \
 //x=16.03 //y=3.3 //x2=15.875 //y2=5.2
cc_576 ( N_noxref_2_c_426_p N_VDD_M36_noxref_s ) capacitor c=0.0217981f \
 //x=16.03 //y=4.755 //x2=15.875 //y2=5.2
cc_577 ( N_noxref_2_c_490_p N_VDD_M36_noxref_s ) capacitor c=2.11884e-19 \
 //x=12.52 //y=5.335 //x2=15.875 //y2=5.2
cc_578 ( N_noxref_2_c_437_p N_VDD_M36_noxref_s ) capacitor c=0.00983846f \
 //x=16.03 //y=4.88 //x2=15.875 //y2=5.2
cc_579 ( N_noxref_2_M36_noxref_g N_VDD_M36_noxref_s ) capacitor c=0.053419f \
 //x=16.23 //y=6.2 //x2=15.875 //y2=5.2
cc_580 ( N_noxref_2_c_439_p N_VDD_M36_noxref_s ) capacitor c=0.00607743f \
 //x=16.305 //y=4.97 //x2=15.875 //y2=5.2
cc_581 ( N_noxref_2_M37_noxref_g N_VDD_M37_noxref_d ) capacitor c=0.015318f \
 //x=16.67 //y=6.2 //x2=16.745 //y2=5.2
cc_582 ( N_noxref_2_c_499_p N_noxref_14_c_4014_n ) capacitor c=0.0036878f \
 //x=13.695 //y=1.305 //x2=14.095 //y2=0.72
cc_583 ( N_noxref_2_c_500_p N_noxref_14_c_4014_n ) capacitor c=0.00399931f \
 //x=14.095 //y=1.845 //x2=14.095 //y2=0.72
cc_584 ( N_noxref_2_M8_noxref_d N_noxref_14_c_4014_n ) capacitor c=0.00910163f \
 //x=13.505 //y=1.095 //x2=14.095 //y2=0.72
cc_585 ( N_noxref_2_M8_noxref_d N_noxref_14_c_4017_n ) capacitor c=0.00120711f \
 //x=13.505 //y=1.095 //x2=13.21 //y2=1.175
cc_586 ( N_noxref_2_c_415_n N_noxref_14_M7_noxref_d ) capacitor c=0.00142884f \
 //x=12.4 //y=5.335 //x2=11.97 //y2=1.09
cc_587 ( N_noxref_2_c_499_p N_noxref_14_M7_noxref_d ) capacitor c=0.00802417f \
 //x=13.695 //y=1.305 //x2=11.97 //y2=1.09
cc_588 ( N_noxref_2_c_499_p N_noxref_14_M8_noxref_s ) capacitor c=0.0098487f \
 //x=13.695 //y=1.305 //x2=13.075 //y2=0.555
cc_589 ( N_noxref_2_c_597_p N_noxref_14_M8_noxref_s ) capacitor c=0.0283243f \
 //x=13.695 //y=1.76 //x2=13.075 //y2=0.555
cc_590 ( N_noxref_2_c_500_p N_noxref_14_M8_noxref_s ) capacitor c=0.0082f \
 //x=14.095 //y=1.845 //x2=13.075 //y2=0.555
cc_591 ( N_noxref_2_c_419_n N_noxref_14_M8_noxref_s ) capacitor c=0.00217661f \
 //x=14.18 //y=3.14 //x2=13.075 //y2=0.555
cc_592 ( N_noxref_2_M8_noxref_d N_noxref_14_M8_noxref_s ) capacitor \
 c=0.0279003f //x=13.505 //y=1.095 //x2=13.075 //y2=0.555
cc_593 ( N_noxref_2_c_423_p N_noxref_15_c_4089_n ) capacitor c=0.0154269f \
 //x=14.18 //y=2.985 //x2=13.44 //y2=2.375
cc_594 ( N_noxref_2_c_423_p N_noxref_15_c_4086_n ) capacitor c=0.0241051f \
 //x=14.18 //y=2.985 //x2=13.44 //y2=4.135
cc_595 ( N_noxref_2_c_440_p N_noxref_15_c_4086_n ) capacitor c=0.0150092f \
 //x=14.18 //y=3.305 //x2=13.44 //y2=4.135
cc_596 ( N_noxref_2_c_435_p N_noxref_15_c_4086_n ) capacitor c=0.0331857f \
 //x=14.18 //y=5.25 //x2=13.44 //y2=4.135
cc_597 ( N_noxref_2_c_424_p N_noxref_15_c_4086_n ) capacitor c=0.00114032f \
 //x=16.03 //y=2.98 //x2=13.44 //y2=4.135
cc_598 ( N_noxref_2_c_426_p N_noxref_15_c_4086_n ) capacitor c=5.53888e-19 \
 //x=16.03 //y=4.755 //x2=13.44 //y2=4.135
cc_599 ( N_noxref_2_c_419_n N_noxref_15_c_4086_n ) capacitor c=5.9567e-19 \
 //x=14.18 //y=3.14 //x2=13.44 //y2=4.135
cc_600 ( N_noxref_2_c_442_p N_noxref_15_c_4086_n ) capacitor c=0.00690943f \
 //x=14.335 //y=3.145 //x2=13.44 //y2=4.135
cc_601 ( N_noxref_2_c_519_p N_noxref_15_c_4097_n ) capacitor c=0.00253345f \
 //x=13.285 //y=5.335 //x2=13.44 //y2=4.365
cc_602 ( N_noxref_2_c_486_p N_noxref_15_c_4097_n ) capacitor c=5.23293e-19 \
 //x=14.095 //y=5.335 //x2=13.44 //y2=4.365
cc_603 ( N_noxref_2_c_435_p N_noxref_15_c_4097_n ) capacitor c=0.0112198f \
 //x=14.18 //y=5.25 //x2=13.44 //y2=4.365
cc_604 ( N_noxref_2_c_547_p N_noxref_15_c_4097_n ) capacitor c=2.03126e-19 \
 //x=13.4 //y=5.56 //x2=13.44 //y2=4.365
cc_605 ( N_noxref_2_c_486_p N_noxref_15_c_4088_n ) capacitor c=0.00228791f \
 //x=14.095 //y=5.335 //x2=13.44 //y2=4.75
cc_606 ( N_noxref_2_c_435_p N_noxref_15_c_4088_n ) capacitor c=0.0295719f \
 //x=14.18 //y=5.25 //x2=13.44 //y2=4.75
cc_607 ( N_noxref_2_c_426_p N_noxref_15_c_4088_n ) capacitor c=4.9983e-19 \
 //x=16.03 //y=4.755 //x2=13.44 //y2=4.75
cc_608 ( N_noxref_2_c_616_p N_noxref_15_c_4088_n ) capacitor c=0.0221596f \
 //x=13.4 //y=5.335 //x2=13.44 //y2=4.75
cc_609 ( N_noxref_2_c_547_p N_noxref_15_c_4088_n ) capacitor c=0.00217653f \
 //x=13.4 //y=5.56 //x2=13.44 //y2=4.75
cc_610 ( N_noxref_2_c_435_p N_noxref_15_c_4106_n ) capacitor c=0.00204859f \
 //x=14.18 //y=5.25 //x2=13.44 //y2=4.25
cc_611 ( N_noxref_2_c_423_p N_noxref_15_c_4107_n ) capacitor c=0.00163444f \
 //x=14.18 //y=2.985 //x2=13.44 //y2=2.26
cc_612 ( N_noxref_2_c_486_p N_noxref_15_c_4108_n ) capacitor c=0.00130631f \
 //x=14.095 //y=5.335 //x2=13.44 //y2=4.88
cc_613 ( N_noxref_2_c_435_p N_noxref_15_c_4108_n ) capacitor c=0.00131258f \
 //x=14.18 //y=5.25 //x2=13.44 //y2=4.88
cc_614 ( N_noxref_2_c_616_p N_noxref_15_c_4108_n ) capacitor c=0.00346456f \
 //x=13.4 //y=5.335 //x2=13.44 //y2=4.88
cc_615 ( N_noxref_2_c_547_p N_noxref_15_c_4108_n ) capacitor c=0.00552343f \
 //x=13.4 //y=5.56 //x2=13.44 //y2=4.88
cc_616 ( N_noxref_2_c_519_p N_noxref_15_M34_noxref_g ) capacitor c=0.00940397f \
 //x=13.285 //y=5.335 //x2=13.18 //y2=6.2
cc_617 ( N_noxref_2_c_527_p N_noxref_15_M34_noxref_g ) capacitor c=0.00226521f \
 //x=13.4 //y=5.56 //x2=13.18 //y2=6.2
cc_618 ( N_noxref_2_c_547_p N_noxref_15_M34_noxref_g ) capacitor c=0.0178885f \
 //x=13.4 //y=5.56 //x2=13.18 //y2=6.2
cc_619 ( N_noxref_2_c_527_p N_noxref_15_M35_noxref_g ) capacitor c=0.00381703f \
 //x=13.4 //y=5.56 //x2=13.62 //y2=6.2
cc_620 ( N_noxref_2_c_486_p N_noxref_15_M35_noxref_g ) capacitor c=0.0107965f \
 //x=14.095 //y=5.335 //x2=13.62 //y2=6.2
cc_621 ( N_noxref_2_c_547_p N_noxref_15_M35_noxref_g ) capacitor c=0.0188608f \
 //x=13.4 //y=5.56 //x2=13.62 //y2=6.2
cc_622 ( N_noxref_2_c_499_p N_noxref_15_c_4118_n ) capacitor c=4.64015e-19 \
 //x=13.695 //y=1.305 //x2=13.43 //y2=1.095
cc_623 ( N_noxref_2_M8_noxref_d N_noxref_15_c_4118_n ) capacitor c=0.00137165f \
 //x=13.505 //y=1.095 //x2=13.43 //y2=1.095
cc_624 ( N_noxref_2_c_499_p N_noxref_15_c_4120_n ) capacitor c=0.0026012f \
 //x=13.695 //y=1.305 //x2=13.43 //y2=1.44
cc_625 ( N_noxref_2_c_597_p N_noxref_15_c_4120_n ) capacitor c=0.00127432f \
 //x=13.695 //y=1.76 //x2=13.43 //y2=1.44
cc_626 ( N_noxref_2_M8_noxref_d N_noxref_15_c_4120_n ) capacitor c=0.00237422f \
 //x=13.505 //y=1.095 //x2=13.43 //y2=1.44
cc_627 ( N_noxref_2_c_597_p N_noxref_15_c_4123_n ) capacitor c=0.00429966f \
 //x=13.695 //y=1.76 //x2=13.43 //y2=1.75
cc_628 ( N_noxref_2_c_499_p N_noxref_15_c_4124_n ) capacitor c=5.29969e-19 \
 //x=13.695 //y=1.305 //x2=13.805 //y2=0.94
cc_629 ( N_noxref_2_M8_noxref_d N_noxref_15_c_4124_n ) capacitor c=0.0020782f \
 //x=13.505 //y=1.095 //x2=13.805 //y2=0.94
cc_630 ( N_noxref_2_c_499_p N_noxref_15_c_4126_n ) capacitor c=5.54437e-19 \
 //x=13.695 //y=1.305 //x2=13.805 //y2=1.595
cc_631 ( N_noxref_2_c_597_p N_noxref_15_c_4126_n ) capacitor c=0.00942306f \
 //x=13.695 //y=1.76 //x2=13.805 //y2=1.595
cc_632 ( N_noxref_2_c_500_p N_noxref_15_c_4126_n ) capacitor c=0.00194716f \
 //x=14.095 //y=1.845 //x2=13.805 //y2=1.595
cc_633 ( N_noxref_2_M8_noxref_d N_noxref_15_c_4126_n ) capacitor c=0.00356097f \
 //x=13.505 //y=1.095 //x2=13.805 //y2=1.595
cc_634 ( N_noxref_2_c_499_p N_noxref_15_c_4130_n ) capacitor c=5.24634e-19 \
 //x=13.695 //y=1.305 //x2=13.96 //y2=1.095
cc_635 ( N_noxref_2_M8_noxref_d N_noxref_15_c_4130_n ) capacitor c=0.00139206f \
 //x=13.505 //y=1.095 //x2=13.96 //y2=1.095
cc_636 ( N_noxref_2_c_499_p N_noxref_15_c_4132_n ) capacitor c=0.00307978f \
 //x=13.695 //y=1.305 //x2=13.96 //y2=1.44
cc_637 ( N_noxref_2_c_597_p N_noxref_15_c_4132_n ) capacitor c=0.00363411f \
 //x=13.695 //y=1.76 //x2=13.96 //y2=1.44
cc_638 ( N_noxref_2_c_500_p N_noxref_15_c_4132_n ) capacitor c=0.00323576f \
 //x=14.095 //y=1.845 //x2=13.96 //y2=1.44
cc_639 ( N_noxref_2_M8_noxref_d N_noxref_15_c_4132_n ) capacitor c=0.00237422f \
 //x=13.505 //y=1.095 //x2=13.96 //y2=1.44
cc_640 ( N_noxref_2_c_423_p N_noxref_15_c_4136_n ) capacitor c=0.0025845f \
 //x=14.18 //y=2.985 //x2=13.44 //y2=2.26
cc_641 ( N_noxref_2_c_597_p N_noxref_15_c_4137_n ) capacitor c=0.0036273f \
 //x=13.695 //y=1.76 //x2=13.44 //y2=2.095
cc_642 ( N_noxref_2_c_423_p N_noxref_15_c_4137_n ) capacitor c=0.00282067f \
 //x=14.18 //y=2.985 //x2=13.44 //y2=2.095
cc_643 ( N_noxref_2_c_435_p N_noxref_15_c_4139_n ) capacitor c=0.00739875f \
 //x=14.18 //y=5.25 //x2=13.44 //y2=4.88
cc_644 ( N_noxref_2_c_616_p N_noxref_15_c_4139_n ) capacitor c=0.00203307f \
 //x=13.4 //y=5.335 //x2=13.44 //y2=4.88
cc_645 ( N_noxref_2_c_547_p N_noxref_15_c_4139_n ) capacitor c=0.00375636f \
 //x=13.4 //y=5.56 //x2=13.44 //y2=4.88
cc_646 ( N_noxref_2_c_499_p N_noxref_16_M10_noxref_d ) capacitor c=3.20746e-19 \
 //x=13.695 //y=1.305 //x2=16.78 //y2=1.09
cc_647 ( N_noxref_2_c_499_p N_GND_c_4416_n ) capacitor c=0.00901861f \
 //x=13.695 //y=1.305 //x2=15.91 //y2=0.175
cc_648 ( N_noxref_2_c_500_p N_GND_c_4416_n ) capacitor c=0.00713708f \
 //x=14.095 //y=1.845 //x2=15.91 //y2=0.175
cc_649 ( N_noxref_2_c_440_p N_GND_c_4416_n ) capacitor c=5.54805e-19 //x=14.18 \
 //y=3.305 //x2=15.91 //y2=0.175
cc_650 ( N_noxref_2_M8_noxref_d N_GND_c_4416_n ) capacitor c=2.9462e-19 \
 //x=13.505 //y=1.095 //x2=15.91 //y2=0.175
cc_651 ( N_noxref_2_c_463_p N_GND_c_4420_n ) capacitor c=3.97665e-19 //x=15.73 \
 //y=1.055 //x2=15.995 //y2=1.015
cc_652 ( N_noxref_2_c_660_p N_GND_c_4420_n ) capacitor c=0.00864776f \
 //x=16.105 //y=0.9 //x2=15.995 //y2=1.015
cc_653 ( N_noxref_2_c_465_p N_GND_c_4420_n ) capacitor c=4.45447e-19 //x=16.26 \
 //y=1.055 //x2=15.995 //y2=1.015
cc_654 ( N_noxref_2_c_499_p N_GND_c_4423_n ) capacitor c=0.00543195f \
 //x=13.695 //y=1.305 //x2=15.995 //y2=1.145
cc_655 ( N_noxref_2_c_431_p N_GND_c_4423_n ) capacitor c=0.00798478f //x=16.03 \
 //y=2.375 //x2=15.995 //y2=1.145
cc_656 ( N_noxref_2_c_425_p N_GND_c_4423_n ) capacitor c=9.46717e-19 //x=16.03 \
 //y=3.3 //x2=15.995 //y2=1.145
cc_657 ( N_noxref_2_c_429_p N_GND_c_4423_n ) capacitor c=2.22883e-19 //x=16.03 \
 //y=2.26 //x2=15.995 //y2=1.145
cc_658 ( N_noxref_2_c_463_p N_GND_c_4423_n ) capacitor c=0.00156339f //x=15.73 \
 //y=1.055 //x2=15.995 //y2=1.145
cc_659 ( N_noxref_2_c_464_p N_GND_c_4423_n ) capacitor c=0.00352472f //x=15.73 \
 //y=1.4 //x2=15.995 //y2=1.145
cc_660 ( N_noxref_2_c_466_p N_GND_c_4423_n ) capacitor c=4.0925e-19 //x=15.73 \
 //y=1.71 //x2=15.995 //y2=1.145
cc_661 ( N_noxref_2_c_660_p N_GND_c_4423_n ) capacitor c=9.36995e-19 \
 //x=16.105 //y=0.9 //x2=15.995 //y2=1.145
cc_662 ( N_noxref_2_c_670_p N_GND_c_4423_n ) capacitor c=5.56938e-19 \
 //x=16.105 //y=1.555 //x2=15.995 //y2=1.145
cc_663 ( N_noxref_2_c_465_p N_GND_c_4423_n ) capacitor c=0.0017438f //x=16.26 \
 //y=1.055 //x2=15.995 //y2=1.145
cc_664 ( N_noxref_2_c_467_p N_GND_c_4423_n ) capacitor c=0.00276804f //x=16.26 \
 //y=1.4 //x2=15.995 //y2=1.145
cc_665 ( N_noxref_2_c_500_p N_GND_c_4387_n ) capacitor c=6.86343e-19 \
 //x=14.095 //y=1.845 //x2=14.75 //y2=0.175
cc_666 ( N_noxref_2_c_440_p N_GND_c_4387_n ) capacitor c=4.87676e-19 //x=14.18 \
 //y=3.305 //x2=14.75 //y2=0.175
cc_667 ( N_noxref_2_c_463_p N_GND_c_4436_n ) capacitor c=0.00677849f //x=15.73 \
 //y=1.055 //x2=19.56 //y2=0.175
cc_668 ( N_noxref_2_c_597_p N_GND_c_4437_n ) capacitor c=0.0045138f //x=13.695 \
 //y=1.76 //x2=14.92 //y2=0.175
cc_669 ( N_noxref_2_c_500_p N_GND_c_4437_n ) capacitor c=0.0310234f //x=14.095 \
 //y=1.845 //x2=14.92 //y2=0.175
cc_670 ( N_noxref_2_c_431_p N_GND_c_4437_n ) capacitor c=0.00407472f //x=16.03 \
 //y=2.375 //x2=14.92 //y2=0.175
cc_671 ( N_noxref_2_c_424_p N_GND_c_4437_n ) capacitor c=0.00962615f //x=16.03 \
 //y=2.98 //x2=14.92 //y2=0.175
cc_672 ( N_noxref_2_c_445_p N_GND_c_4437_n ) capacitor c=0.00411812f //x=15.87 \
 //y=3.14 //x2=14.92 //y2=0.175
cc_673 ( N_noxref_2_c_429_p N_GND_c_4437_n ) capacitor c=0.00394651f //x=16.03 \
 //y=2.26 //x2=14.92 //y2=0.175
cc_674 ( N_noxref_2_c_466_p N_GND_c_4437_n ) capacitor c=0.00170145f //x=15.73 \
 //y=1.71 //x2=14.92 //y2=0.175
cc_675 ( N_noxref_2_c_433_p N_GND_c_4437_n ) capacitor c=0.0103608f //x=15.73 \
 //y=2.095 //x2=14.92 //y2=0.175
cc_676 ( N_noxref_2_c_431_p N_GND_M9_noxref_d ) capacitor c=4.4417e-19 \
 //x=16.03 //y=2.375 //x2=15.805 //y2=1.055
cc_677 ( N_noxref_2_c_463_p N_GND_M9_noxref_d ) capacitor c=0.00184354f \
 //x=15.73 //y=1.055 //x2=15.805 //y2=1.055
cc_678 ( N_noxref_2_c_464_p N_GND_M9_noxref_d ) capacitor c=0.00210798f \
 //x=15.73 //y=1.4 //x2=15.805 //y2=1.055
cc_679 ( N_noxref_2_c_660_p N_GND_M9_noxref_d ) capacitor c=0.00474029f \
 //x=16.105 //y=0.9 //x2=15.805 //y2=1.055
cc_680 ( N_noxref_2_c_670_p N_GND_M9_noxref_d ) capacitor c=0.00166857f \
 //x=16.105 //y=1.555 //x2=15.805 //y2=1.055
cc_681 ( N_noxref_2_c_465_p N_GND_M9_noxref_d ) capacitor c=0.00230174f \
 //x=16.26 //y=1.055 //x2=15.805 //y2=1.055
cc_682 ( N_noxref_2_c_467_p N_GND_M9_noxref_d ) capacitor c=0.00210798f \
 //x=16.26 //y=1.4 //x2=15.805 //y2=1.055
cc_683 ( N_noxref_2_c_433_p N_noxref_23_c_5073_n ) capacitor c=0.00262672f \
 //x=15.73 //y=2.095 //x2=15.51 //y2=1.685
cc_684 ( N_noxref_2_c_431_p N_noxref_23_c_5074_n ) capacitor c=0.00428451f \
 //x=16.03 //y=2.375 //x2=16.395 //y2=1.77
cc_685 ( N_noxref_2_c_425_p N_noxref_23_c_5074_n ) capacitor c=0.00331532f \
 //x=16.03 //y=3.3 //x2=16.395 //y2=1.77
cc_686 ( N_noxref_2_c_429_p N_noxref_23_c_5074_n ) capacitor c=0.0104666f \
 //x=16.03 //y=2.26 //x2=16.395 //y2=1.77
cc_687 ( N_noxref_2_c_466_p N_noxref_23_c_5074_n ) capacitor c=0.00705077f \
 //x=15.73 //y=1.71 //x2=16.395 //y2=1.77
cc_688 ( N_noxref_2_c_433_p N_noxref_23_c_5074_n ) capacitor c=0.0203198f \
 //x=15.73 //y=2.095 //x2=16.395 //y2=1.77
cc_689 ( N_noxref_2_c_670_p N_noxref_23_c_5074_n ) capacitor c=0.00588627f \
 //x=16.105 //y=1.555 //x2=16.395 //y2=1.77
cc_690 ( N_noxref_2_c_467_p N_noxref_23_c_5074_n ) capacitor c=0.00698822f \
 //x=16.26 //y=1.4 //x2=16.395 //y2=1.77
cc_691 ( N_noxref_2_c_463_p N_noxref_23_M9_noxref_s ) capacitor c=0.0295256f \
 //x=15.73 //y=1.055 //x2=15.375 //y2=0.555
cc_692 ( N_noxref_2_c_466_p N_noxref_23_M9_noxref_s ) capacitor c=7.99997e-19 \
 //x=15.73 //y=1.71 //x2=15.375 //y2=0.555
cc_693 ( N_noxref_2_c_433_p N_noxref_23_M9_noxref_s ) capacitor c=0.00122123f \
 //x=15.73 //y=2.095 //x2=15.375 //y2=0.555
cc_694 ( N_noxref_2_c_465_p N_noxref_23_M9_noxref_s ) capacitor c=0.0125924f \
 //x=16.26 //y=1.055 //x2=15.375 //y2=0.555
cc_695 ( N_CLK_c_719_n N_noxref_4_c_1058_n ) capacitor c=6.04267e-19 //x=7.52 \
 //y=3.675 //x2=7.59 //y2=5.335
cc_696 ( N_CLK_c_721_n N_noxref_4_c_1058_n ) capacitor c=0.0213631f //x=7.52 \
 //y=4.765 //x2=7.59 //y2=5.335
cc_697 ( N_CLK_c_738_n N_noxref_4_c_1058_n ) capacitor c=0.00492634f //x=7.52 \
 //y=4.88 //x2=7.59 //y2=5.335
cc_698 ( N_CLK_M26_noxref_g N_noxref_4_c_1058_n ) capacitor c=0.00858241f \
 //x=7.49 //y=6.2 //x2=7.59 //y2=5.335
cc_699 ( N_CLK_c_756_n N_noxref_4_c_1058_n ) capacitor c=5.66497e-19 //x=7.52 \
 //y=4.88 //x2=7.59 //y2=5.335
cc_700 ( N_CLK_M27_noxref_g N_noxref_4_c_1137_n ) capacitor c=0.00955829f \
 //x=7.93 //y=6.2 //x2=8.475 //y2=5.335
cc_701 ( CLK N_noxref_4_c_1062_n ) capacitor c=0.00198165f //x=7.52 //y=2.77 \
 //x2=9.37 //y2=3.725
cc_702 ( N_CLK_c_725_n N_noxref_4_c_1062_n ) capacitor c=2.15423e-19 //x=8.975 \
 //y=3.51 //x2=9.37 //y2=3.725
cc_703 ( N_CLK_c_726_n N_noxref_4_c_1062_n ) capacitor c=0.0225563f //x=9.575 \
 //y=3.5 //x2=9.37 //y2=3.725
cc_704 ( N_CLK_c_726_n N_noxref_4_c_1067_n ) capacitor c=0.00917454f //x=9.575 \
 //y=3.5 //x2=9.37 //y2=4.045
cc_705 ( CLK N_noxref_4_c_1068_n ) capacitor c=0.0014155f //x=7.52 //y=4.25 \
 //x2=9.37 //y2=5.25
cc_706 ( N_CLK_c_719_n N_noxref_4_c_1143_n ) capacitor c=0.00172814f //x=7.52 \
 //y=3.675 //x2=7.71 //y2=5.335
cc_707 ( N_CLK_c_721_n N_noxref_4_c_1143_n ) capacitor c=0.00239361f //x=7.52 \
 //y=4.765 //x2=7.71 //y2=5.335
cc_708 ( N_CLK_c_738_n N_noxref_4_c_1143_n ) capacitor c=0.00132214f //x=7.52 \
 //y=4.88 //x2=7.71 //y2=5.335
cc_709 ( N_CLK_M26_noxref_g N_noxref_4_c_1143_n ) capacitor c=0.00229818f \
 //x=7.49 //y=6.2 //x2=7.71 //y2=5.335
cc_710 ( N_CLK_M27_noxref_g N_noxref_4_c_1143_n ) capacitor c=0.00230699f \
 //x=7.93 //y=6.2 //x2=7.71 //y2=5.335
cc_711 ( N_CLK_c_831_p N_noxref_4_c_1143_n ) capacitor c=0.00190165f //x=7.855 \
 //y=4.97 //x2=7.71 //y2=5.335
cc_712 ( CLK N_noxref_4_c_1075_n ) capacitor c=5.03481e-19 //x=7.52 //y=4.25 \
 //x2=7.135 //y2=3.88
cc_713 ( N_CLK_c_719_n N_noxref_4_c_1075_n ) capacitor c=0.00131741f //x=7.52 \
 //y=3.675 //x2=7.135 //y2=3.88
cc_714 ( N_CLK_c_732_n N_noxref_4_c_1075_n ) capacitor c=0.0358254f //x=7.68 \
 //y=3.515 //x2=7.135 //y2=3.88
cc_715 ( CLK N_noxref_4_c_1084_n ) capacitor c=0.02529f //x=7.52 //y=4.25 \
 //x2=7.735 //y2=3.9
cc_716 ( N_CLK_c_719_n N_noxref_4_c_1084_n ) capacitor c=0.0042462f //x=7.52 \
 //y=3.675 //x2=7.735 //y2=3.9
cc_717 ( N_CLK_c_725_n N_noxref_4_c_1084_n ) capacitor c=0.0547297f //x=8.975 \
 //y=3.51 //x2=7.735 //y2=3.9
cc_718 ( CLK N_noxref_4_c_1085_n ) capacitor c=2.70046e-19 //x=7.52 //y=4.25 \
 //x2=8.235 //y2=3.88
cc_719 ( N_CLK_c_725_n N_noxref_4_c_1085_n ) capacitor c=0.0561191f //x=8.975 \
 //y=3.51 //x2=8.235 //y2=3.88
cc_720 ( N_CLK_c_771_n N_noxref_4_c_1157_n ) capacitor c=0.00261235f //x=17.14 \
 //y=3.665 //x2=17.36 //y2=3.89
cc_721 ( N_CLK_c_772_n N_noxref_4_c_1157_n ) capacitor c=0.0230212f //x=17.14 \
 //y=4.765 //x2=17.36 //y2=3.89
cc_722 ( N_CLK_c_771_n N_noxref_4_c_1086_n ) capacitor c=0.00299925f //x=17.14 \
 //y=3.665 //x2=17.01 //y2=3.89
cc_723 ( N_CLK_c_772_n N_noxref_4_c_1086_n ) capacitor c=2.52815e-19 //x=17.14 \
 //y=4.765 //x2=17.01 //y2=3.89
cc_724 ( N_CLK_c_725_n N_noxref_4_c_1086_n ) capacitor c=0.0237734f //x=8.975 \
 //y=3.51 //x2=17.01 //y2=3.89
cc_725 ( N_CLK_c_726_n N_noxref_4_c_1086_n ) capacitor c=0.159291f //x=9.575 \
 //y=3.5 //x2=17.01 //y2=3.89
cc_726 ( N_CLK_c_727_n N_noxref_4_c_1086_n ) capacitor c=0.0585633f //x=10.835 \
 //y=3.51 //x2=17.01 //y2=3.89
cc_727 ( N_CLK_c_730_n N_noxref_4_c_1086_n ) capacitor c=0.203805f //x=11.435 \
 //y=3.525 //x2=17.01 //y2=3.89
cc_728 ( N_CLK_c_777_n N_noxref_4_c_1086_n ) capacitor c=0.0579621f //x=13.79 \
 //y=3.51 //x2=17.01 //y2=3.89
cc_729 ( N_CLK_c_780_n N_noxref_4_c_1086_n ) capacitor c=0.112024f //x=14.39 \
 //y=3.53 //x2=17.01 //y2=3.89
cc_730 ( N_CLK_c_783_n N_noxref_4_c_1086_n ) capacitor c=0.0578695f //x=15.645 \
 //y=3.51 //x2=17.01 //y2=3.89
cc_731 ( N_CLK_c_787_n N_noxref_4_c_1086_n ) capacitor c=0.0908096f //x=16.245 \
 //y=3.525 //x2=17.01 //y2=3.89
cc_732 ( N_CLK_c_719_n N_noxref_4_c_1169_n ) capacitor c=6.1847e-19 //x=7.52 \
 //y=3.675 //x2=7.71 //y2=5.56
cc_733 ( N_CLK_c_721_n N_noxref_4_c_1169_n ) capacitor c=6.21282e-19 //x=7.52 \
 //y=4.765 //x2=7.71 //y2=5.56
cc_734 ( N_CLK_M26_noxref_g N_noxref_4_c_1169_n ) capacitor c=0.0179041f \
 //x=7.49 //y=6.2 //x2=7.71 //y2=5.56
cc_735 ( N_CLK_M27_noxref_g N_noxref_4_c_1169_n ) capacitor c=0.0179041f \
 //x=7.93 //y=6.2 //x2=7.71 //y2=5.56
cc_736 ( N_CLK_c_831_p N_noxref_4_c_1169_n ) capacitor c=0.00290085f //x=7.855 \
 //y=4.97 //x2=7.71 //y2=5.56
cc_737 ( CLK RN ) capacitor c=0.0253489f //x=17.14 //y=3.14 //x2=18.25 //y2=3.14
cc_738 ( CLK RN ) capacitor c=3.43503e-19 //x=17.14 //y=3.51 //x2=18.25 \
 //y2=3.14
cc_739 ( N_CLK_c_771_n RN ) capacitor c=0.00775314f //x=17.14 //y=3.665 \
 //x2=18.25 //y2=3.14
cc_740 ( N_CLK_c_772_n RN ) capacitor c=0.0206492f //x=17.14 //y=4.765 \
 //x2=18.25 //y2=3.14
cc_741 ( N_CLK_c_787_n RN ) capacitor c=0.00517348f //x=16.245 //y=3.525 \
 //x2=18.25 //y2=3.14
cc_742 ( N_CLK_c_789_n RN ) capacitor c=4.16726e-19 //x=17.14 //y=2.26 \
 //x2=18.25 //y2=3.14
cc_743 ( N_CLK_c_768_n N_RN_c_1551_n ) capacitor c=0.0116288f //x=17.14 \
 //y=2.375 //x2=18.25 //y2=2.375
cc_744 ( N_CLK_c_789_n N_RN_c_1551_n ) capacitor c=5.39999e-19 //x=17.14 \
 //y=2.26 //x2=18.25 //y2=2.375
cc_745 ( N_CLK_c_808_n N_RN_c_1551_n ) capacitor c=0.00141236f //x=17.23 \
 //y=2.095 //x2=18.25 //y2=2.375
cc_746 ( N_CLK_c_772_n N_RN_c_1554_n ) capacitor c=0.0118769f //x=17.14 \
 //y=4.765 //x2=18.245 //y2=4.725
cc_747 ( N_CLK_c_793_n N_RN_c_1554_n ) capacitor c=0.0010848f //x=17.14 \
 //y=4.88 //x2=18.245 //y2=4.725
cc_748 ( N_CLK_c_811_n N_RN_c_1554_n ) capacitor c=8.78874e-19 //x=17.14 \
 //y=4.88 //x2=18.245 //y2=4.725
cc_749 ( CLK N_RN_c_1518_n ) capacitor c=0.0299868f //x=7.52 //y=4.25 \
 //x2=8.235 //y2=4.62
cc_750 ( N_CLK_c_721_n N_RN_c_1518_n ) capacitor c=0.0036605f //x=7.52 \
 //y=4.765 //x2=8.235 //y2=4.62
cc_751 ( N_CLK_c_725_n N_RN_c_1518_n ) capacitor c=0.00435025f //x=8.975 \
 //y=3.51 //x2=8.235 //y2=4.62
cc_752 ( N_CLK_c_772_n N_RN_c_1524_n ) capacitor c=0.0343258f //x=17.14 \
 //y=4.765 //x2=18.86 //y2=4.63
cc_753 ( CLK N_RN_c_1561_n ) capacitor c=4.16726e-19 //x=17.14 //y=3.14 \
 //x2=18.25 //y2=2.26
cc_754 ( N_CLK_c_768_n N_RN_c_1561_n ) capacitor c=5.42289e-19 //x=17.14 \
 //y=2.375 //x2=18.25 //y2=2.26
cc_755 ( N_CLK_c_789_n N_RN_c_1561_n ) capacitor c=0.00125213f //x=17.14 \
 //y=2.26 //x2=18.25 //y2=2.26
cc_756 ( N_CLK_c_808_n N_RN_c_1561_n ) capacitor c=0.00209664f //x=17.23 \
 //y=2.095 //x2=18.25 //y2=2.26
cc_757 ( N_CLK_c_772_n N_RN_c_1565_n ) capacitor c=4.56604e-19 //x=17.14 \
 //y=4.765 //x2=18.25 //y2=4.88
cc_758 ( N_CLK_c_793_n N_RN_c_1565_n ) capacitor c=0.00113392f //x=17.14 \
 //y=4.88 //x2=18.25 //y2=4.88
cc_759 ( N_CLK_c_811_n N_RN_c_1565_n ) capacitor c=0.0012974f //x=17.14 \
 //y=4.88 //x2=18.25 //y2=4.88
cc_760 ( N_CLK_M38_noxref_g N_RN_M40_noxref_g ) capacitor c=0.0101598f \
 //x=17.11 //y=6.2 //x2=17.99 //y2=6.2
cc_761 ( N_CLK_M39_noxref_g N_RN_M40_noxref_g ) capacitor c=0.0607518f \
 //x=17.55 //y=6.2 //x2=17.99 //y2=6.2
cc_762 ( N_CLK_M39_noxref_g N_RN_M41_noxref_g ) capacitor c=0.0101598f \
 //x=17.55 //y=6.2 //x2=18.43 //y2=6.2
cc_763 ( N_CLK_c_805_n N_RN_c_1571_n ) capacitor c=0.00456962f //x=17.23 \
 //y=1.09 //x2=18.24 //y2=1.095
cc_764 ( N_CLK_c_806_n N_RN_c_1572_n ) capacitor c=0.00438372f //x=17.23 \
 //y=1.4 //x2=18.24 //y2=1.44
cc_765 ( N_CLK_c_807_n N_RN_c_1573_n ) capacitor c=0.00438372f //x=17.23 \
 //y=1.63 //x2=18.24 //y2=1.75
cc_766 ( N_CLK_c_768_n N_RN_c_1574_n ) capacitor c=0.00139071f //x=17.14 \
 //y=2.375 //x2=18.25 //y2=2.26
cc_767 ( N_CLK_c_789_n N_RN_c_1574_n ) capacitor c=0.00204868f //x=17.14 \
 //y=2.26 //x2=18.25 //y2=2.26
cc_768 ( N_CLK_c_808_n N_RN_c_1574_n ) capacitor c=0.00933826f //x=17.23 \
 //y=2.095 //x2=18.25 //y2=2.26
cc_769 ( N_CLK_c_808_n N_RN_c_1577_n ) capacitor c=0.00438372f //x=17.23 \
 //y=2.095 //x2=18.25 //y2=2.095
cc_770 ( N_CLK_c_772_n N_RN_c_1578_n ) capacitor c=5.4906e-19 //x=17.14 \
 //y=4.765 //x2=18.25 //y2=4.88
cc_771 ( N_CLK_c_793_n N_RN_c_1578_n ) capacitor c=0.00156771f //x=17.14 \
 //y=4.88 //x2=18.25 //y2=4.88
cc_772 ( N_CLK_c_892_p N_RN_c_1578_n ) capacitor c=0.0616777f //x=17.475 \
 //y=4.97 //x2=18.25 //y2=4.88
cc_773 ( N_CLK_c_811_n N_RN_c_1578_n ) capacitor c=0.00430295f //x=17.14 \
 //y=4.88 //x2=18.25 //y2=4.88
cc_774 ( N_CLK_c_777_n N_SN_c_2227_n ) capacitor c=0.00347504f //x=13.79 \
 //y=3.51 //x2=12.33 //y2=2.935
cc_775 ( N_CLK_c_730_n N_SN_c_2228_n ) capacitor c=4.01108e-19 //x=11.435 \
 //y=3.525 //x2=12.33 //y2=4.765
cc_776 ( N_CLK_c_777_n N_SN_c_2228_n ) capacitor c=0.0257097f //x=13.79 \
 //y=3.51 //x2=12.33 //y2=4.765
cc_777 ( N_CLK_c_777_n N_SN_c_2272_n ) capacitor c=0.0683438f //x=13.79 \
 //y=3.51 //x2=13.79 //y2=2.77
cc_778 ( N_CLK_c_780_n N_SN_c_2276_n ) capacitor c=0.00798615f //x=14.39 \
 //y=3.53 //x2=14.39 //y2=2.76
cc_779 ( N_CLK_c_783_n N_SN_c_2280_n ) capacitor c=0.00802984f //x=15.645 \
 //y=3.51 //x2=15.645 //y2=2.77
cc_780 ( CLK N_SN_c_2283_n ) capacitor c=0.0299983f //x=17.14 //y=3.14 \
 //x2=16.245 //y2=2.755
cc_781 ( N_CLK_c_768_n N_SN_c_2283_n ) capacitor c=0.00304195f //x=17.14 \
 //y=2.375 //x2=16.245 //y2=2.755
cc_782 ( N_CLK_c_771_n N_SN_c_2283_n ) capacitor c=0.00337586f //x=17.14 \
 //y=3.665 //x2=16.245 //y2=2.755
cc_783 ( N_CLK_c_787_n N_SN_c_2283_n ) capacitor c=0.0502927f //x=16.245 \
 //y=3.525 //x2=16.245 //y2=2.755
cc_784 ( N_CLK_c_777_n N_SN_c_2237_n ) capacitor c=0.0161618f //x=13.79 \
 //y=3.51 //x2=12.49 //y2=2.775
cc_785 ( N_CLK_c_715_n N_noxref_8_c_2597_n ) capacitor c=0.0116288f //x=7.52 \
 //y=2.375 //x2=8.63 //y2=2.375
cc_786 ( N_CLK_c_734_n N_noxref_8_c_2597_n ) capacitor c=5.39999e-19 //x=7.52 \
 //y=2.26 //x2=8.63 //y2=2.375
cc_787 ( N_CLK_c_753_n N_noxref_8_c_2597_n ) capacitor c=0.00141236f //x=7.61 \
 //y=2.095 //x2=8.63 //y2=2.375
cc_788 ( CLK N_noxref_8_c_2598_n ) capacitor c=0.0251054f //x=7.52 //y=2.77 \
 //x2=8.63 //y2=4.095
cc_789 ( CLK N_noxref_8_c_2598_n ) capacitor c=0.00963799f //x=7.52 //y=4.25 \
 //x2=8.63 //y2=4.095
cc_790 ( CLK N_noxref_8_c_2598_n ) capacitor c=3.43503e-19 //x=7.52 //y=3.51 \
 //x2=8.63 //y2=4.095
cc_791 ( N_CLK_c_719_n N_noxref_8_c_2598_n ) capacitor c=0.00776907f //x=7.52 \
 //y=3.675 //x2=8.63 //y2=4.095
cc_792 ( N_CLK_c_725_n N_noxref_8_c_2598_n ) capacitor c=0.0214318f //x=8.975 \
 //y=3.51 //x2=8.63 //y2=4.095
cc_793 ( N_CLK_c_732_n N_noxref_8_c_2598_n ) capacitor c=0.00235773f //x=7.68 \
 //y=3.515 //x2=8.63 //y2=4.095
cc_794 ( N_CLK_c_734_n N_noxref_8_c_2598_n ) capacitor c=4.16726e-19 //x=7.52 \
 //y=2.26 //x2=8.63 //y2=4.095
cc_795 ( CLK N_noxref_8_c_2628_n ) capacitor c=0.00787182f //x=7.52 //y=4.25 \
 //x2=8.63 //y2=4.415
cc_796 ( CLK N_noxref_8_c_2603_n ) capacitor c=0.00695116f //x=7.52 //y=4.25 \
 //x2=8.63 //y2=4.75
cc_797 ( N_CLK_c_721_n N_noxref_8_c_2603_n ) capacitor c=0.0107551f //x=7.52 \
 //y=4.765 //x2=8.63 //y2=4.75
cc_798 ( N_CLK_c_738_n N_noxref_8_c_2603_n ) capacitor c=9.47246e-19 //x=7.52 \
 //y=4.88 //x2=8.63 //y2=4.75
cc_799 ( N_CLK_c_756_n N_noxref_8_c_2603_n ) capacitor c=8.42568e-19 //x=7.52 \
 //y=4.88 //x2=8.63 //y2=4.75
cc_800 ( N_CLK_c_771_n N_noxref_8_c_2606_n ) capacitor c=0.00158727f //x=17.14 \
 //y=3.665 //x2=17.21 //y2=5.335
cc_801 ( N_CLK_c_772_n N_noxref_8_c_2606_n ) capacitor c=0.0213631f //x=17.14 \
 //y=4.765 //x2=17.21 //y2=5.335
cc_802 ( N_CLK_c_793_n N_noxref_8_c_2606_n ) capacitor c=0.00492634f //x=17.14 \
 //y=4.88 //x2=17.21 //y2=5.335
cc_803 ( N_CLK_M38_noxref_g N_noxref_8_c_2606_n ) capacitor c=0.00858241f \
 //x=17.11 //y=6.2 //x2=17.21 //y2=5.335
cc_804 ( N_CLK_c_811_n N_noxref_8_c_2606_n ) capacitor c=5.67117e-19 //x=17.14 \
 //y=4.88 //x2=17.21 //y2=5.335
cc_805 ( N_CLK_M39_noxref_g N_noxref_8_c_2638_n ) capacitor c=0.00955829f \
 //x=17.55 //y=6.2 //x2=18.095 //y2=5.335
cc_806 ( CLK N_noxref_8_c_2639_n ) capacitor c=0.00202737f //x=17.14 //y=3.14 \
 //x2=18.99 //y2=4.085
cc_807 ( N_CLK_c_772_n N_noxref_8_c_2639_n ) capacitor c=4.10276e-19 //x=17.14 \
 //y=4.765 //x2=18.99 //y2=4.085
cc_808 ( N_CLK_c_772_n N_noxref_8_c_2641_n ) capacitor c=4.7307e-19 //x=17.14 \
 //y=4.765 //x2=18.99 //y2=5.25
cc_809 ( CLK N_noxref_8_c_2642_n ) capacitor c=3.45551e-19 //x=7.52 //y=4.25 \
 //x2=8.625 //y2=4.25
cc_810 ( N_CLK_c_771_n N_noxref_8_c_2643_n ) capacitor c=6.48791e-19 //x=17.14 \
 //y=3.665 //x2=17.33 //y2=5.335
cc_811 ( N_CLK_c_772_n N_noxref_8_c_2643_n ) capacitor c=0.00239361f //x=17.14 \
 //y=4.765 //x2=17.33 //y2=5.335
cc_812 ( N_CLK_c_793_n N_noxref_8_c_2643_n ) capacitor c=0.00132214f //x=17.14 \
 //y=4.88 //x2=17.33 //y2=5.335
cc_813 ( N_CLK_M38_noxref_g N_noxref_8_c_2643_n ) capacitor c=0.00229818f \
 //x=17.11 //y=6.2 //x2=17.33 //y2=5.335
cc_814 ( N_CLK_M39_noxref_g N_noxref_8_c_2643_n ) capacitor c=0.00230699f \
 //x=17.55 //y=6.2 //x2=17.33 //y2=5.335
cc_815 ( N_CLK_c_892_p N_noxref_8_c_2643_n ) capacitor c=0.00175021f \
 //x=17.475 //y=4.97 //x2=17.33 //y2=5.335
cc_816 ( N_CLK_c_725_n N_noxref_8_c_2649_n ) capacitor c=0.00365029f //x=8.975 \
 //y=3.51 //x2=8.975 //y2=4.25
cc_817 ( N_CLK_c_726_n N_noxref_8_c_2650_n ) capacitor c=0.00182396f //x=9.575 \
 //y=3.5 //x2=9.575 //y2=4.27
cc_818 ( N_CLK_c_772_n N_noxref_8_c_2605_n ) capacitor c=0.0234062f //x=17.14 \
 //y=4.765 //x2=20.705 //y2=4.265
cc_819 ( N_CLK_c_726_n N_noxref_8_c_2605_n ) capacitor c=0.00798834f //x=9.575 \
 //y=3.5 //x2=20.705 //y2=4.265
cc_820 ( N_CLK_c_727_n N_noxref_8_c_2605_n ) capacitor c=0.00304963f \
 //x=10.835 //y=3.51 //x2=20.705 //y2=4.265
cc_821 ( N_CLK_c_730_n N_noxref_8_c_2605_n ) capacitor c=0.0153107f //x=11.435 \
 //y=3.525 //x2=20.705 //y2=4.265
cc_822 ( N_CLK_c_777_n N_noxref_8_c_2605_n ) capacitor c=0.00343046f //x=13.79 \
 //y=3.51 //x2=20.705 //y2=4.265
cc_823 ( N_CLK_c_780_n N_noxref_8_c_2605_n ) capacitor c=0.00796373f //x=14.39 \
 //y=3.53 //x2=20.705 //y2=4.265
cc_824 ( N_CLK_c_783_n N_noxref_8_c_2605_n ) capacitor c=0.00304984f \
 //x=15.645 //y=3.51 //x2=20.705 //y2=4.265
cc_825 ( N_CLK_c_787_n N_noxref_8_c_2605_n ) capacitor c=0.0046527f //x=16.245 \
 //y=3.525 //x2=20.705 //y2=4.265
cc_826 ( CLK N_noxref_8_c_2659_n ) capacitor c=0.00512933f //x=7.52 //y=4.25 \
 //x2=8.78 //y2=4.255
cc_827 ( CLK N_noxref_8_c_2660_n ) capacitor c=4.16726e-19 //x=7.52 //y=2.77 \
 //x2=8.63 //y2=2.26
cc_828 ( N_CLK_c_715_n N_noxref_8_c_2660_n ) capacitor c=5.42289e-19 //x=7.52 \
 //y=2.375 //x2=8.63 //y2=2.26
cc_829 ( N_CLK_c_734_n N_noxref_8_c_2660_n ) capacitor c=0.00125213f //x=7.52 \
 //y=2.26 //x2=8.63 //y2=2.26
cc_830 ( N_CLK_c_753_n N_noxref_8_c_2660_n ) capacitor c=0.00209664f //x=7.61 \
 //y=2.095 //x2=8.63 //y2=2.26
cc_831 ( CLK N_noxref_8_c_2664_n ) capacitor c=2.94497e-19 //x=7.52 //y=4.25 \
 //x2=8.63 //y2=4.88
cc_832 ( N_CLK_c_721_n N_noxref_8_c_2664_n ) capacitor c=4.56604e-19 //x=7.52 \
 //y=4.765 //x2=8.63 //y2=4.88
cc_833 ( N_CLK_c_738_n N_noxref_8_c_2664_n ) capacitor c=0.00113985f //x=7.52 \
 //y=4.88 //x2=8.63 //y2=4.88
cc_834 ( N_CLK_c_756_n N_noxref_8_c_2664_n ) capacitor c=0.00129812f //x=7.52 \
 //y=4.88 //x2=8.63 //y2=4.88
cc_835 ( N_CLK_c_772_n N_noxref_8_c_2668_n ) capacitor c=6.21282e-19 //x=17.14 \
 //y=4.765 //x2=17.33 //y2=5.56
cc_836 ( N_CLK_M38_noxref_g N_noxref_8_c_2668_n ) capacitor c=0.0179041f \
 //x=17.11 //y=6.2 //x2=17.33 //y2=5.56
cc_837 ( N_CLK_M39_noxref_g N_noxref_8_c_2668_n ) capacitor c=0.0179041f \
 //x=17.55 //y=6.2 //x2=17.33 //y2=5.56
cc_838 ( N_CLK_c_892_p N_noxref_8_c_2668_n ) capacitor c=0.00290085f \
 //x=17.475 //y=4.97 //x2=17.33 //y2=5.56
cc_839 ( N_CLK_M26_noxref_g N_noxref_8_M28_noxref_g ) capacitor c=0.0101598f \
 //x=7.49 //y=6.2 //x2=8.37 //y2=6.2
cc_840 ( N_CLK_M27_noxref_g N_noxref_8_M28_noxref_g ) capacitor c=0.0607518f \
 //x=7.93 //y=6.2 //x2=8.37 //y2=6.2
cc_841 ( N_CLK_M27_noxref_g N_noxref_8_M29_noxref_g ) capacitor c=0.0101598f \
 //x=7.93 //y=6.2 //x2=8.81 //y2=6.2
cc_842 ( N_CLK_c_750_n N_noxref_8_c_2675_n ) capacitor c=0.00456962f //x=7.61 \
 //y=1.09 //x2=8.62 //y2=1.095
cc_843 ( N_CLK_c_751_n N_noxref_8_c_2676_n ) capacitor c=0.00438372f //x=7.61 \
 //y=1.4 //x2=8.62 //y2=1.44
cc_844 ( N_CLK_c_752_n N_noxref_8_c_2677_n ) capacitor c=0.00438372f //x=7.61 \
 //y=1.63 //x2=8.62 //y2=1.75
cc_845 ( N_CLK_c_715_n N_noxref_8_c_2678_n ) capacitor c=0.00139071f //x=7.52 \
 //y=2.375 //x2=8.63 //y2=2.26
cc_846 ( N_CLK_c_734_n N_noxref_8_c_2678_n ) capacitor c=0.00204868f //x=7.52 \
 //y=2.26 //x2=8.63 //y2=2.26
cc_847 ( N_CLK_c_753_n N_noxref_8_c_2678_n ) capacitor c=0.00933826f //x=7.61 \
 //y=2.095 //x2=8.63 //y2=2.26
cc_848 ( N_CLK_c_753_n N_noxref_8_c_2681_n ) capacitor c=0.00438372f //x=7.61 \
 //y=2.095 //x2=8.63 //y2=2.095
cc_849 ( N_CLK_c_721_n N_noxref_8_c_2682_n ) capacitor c=0.00124604f //x=7.52 \
 //y=4.765 //x2=8.63 //y2=4.88
cc_850 ( N_CLK_c_738_n N_noxref_8_c_2682_n ) capacitor c=0.00187046f //x=7.52 \
 //y=4.88 //x2=8.63 //y2=4.88
cc_851 ( N_CLK_c_831_p N_noxref_8_c_2682_n ) capacitor c=0.0616777f //x=7.855 \
 //y=4.97 //x2=8.63 //y2=4.88
cc_852 ( N_CLK_c_756_n N_noxref_8_c_2682_n ) capacitor c=0.00487508f //x=7.52 \
 //y=4.88 //x2=8.63 //y2=4.88
cc_853 ( N_CLK_M26_noxref_g N_VDD_c_3496_n ) capacitor c=0.00705252f //x=7.49 \
 //y=6.2 //x2=8.065 //y2=7.585
cc_854 ( N_CLK_M27_noxref_g N_VDD_c_3496_n ) capacitor c=0.00755544f //x=7.93 \
 //y=6.2 //x2=8.065 //y2=7.585
cc_855 ( N_CLK_M38_noxref_g N_VDD_c_3498_n ) capacitor c=0.00705252f //x=17.11 \
 //y=6.2 //x2=17.685 //y2=7.585
cc_856 ( N_CLK_M39_noxref_g N_VDD_c_3498_n ) capacitor c=0.00755544f //x=17.55 \
 //y=6.2 //x2=17.685 //y2=7.585
cc_857 ( N_CLK_M26_noxref_g N_VDD_M25_noxref_d ) capacitor c=0.015318f \
 //x=7.49 //y=6.2 //x2=7.125 //y2=5.2
cc_858 ( N_CLK_M27_noxref_g N_VDD_M27_noxref_d ) capacitor c=0.015318f \
 //x=7.93 //y=6.2 //x2=8.005 //y2=5.2
cc_859 ( N_CLK_M38_noxref_g N_VDD_M37_noxref_d ) capacitor c=0.015318f \
 //x=17.11 //y=6.2 //x2=16.745 //y2=5.2
cc_860 ( N_CLK_M39_noxref_g N_VDD_M39_noxref_d ) capacitor c=0.015318f \
 //x=17.55 //y=6.2 //x2=17.625 //y2=5.2
cc_861 ( N_CLK_c_750_n N_noxref_13_c_3945_n ) capacitor c=0.00123426f //x=7.61 \
 //y=1.09 //x2=8.315 //y2=1.175
cc_862 ( N_CLK_c_751_n N_noxref_13_c_3945_n ) capacitor c=0.0129288f //x=7.61 \
 //y=1.4 //x2=8.315 //y2=1.175
cc_863 ( N_CLK_c_752_n N_noxref_13_c_3945_n ) capacitor c=0.00132209f //x=7.61 \
 //y=1.63 //x2=8.315 //y2=1.175
cc_864 ( N_CLK_c_715_n N_noxref_13_M4_noxref_d ) capacitor c=0.00606292f \
 //x=7.52 //y=2.375 //x2=7.16 //y2=1.09
cc_865 ( N_CLK_c_734_n N_noxref_13_M4_noxref_d ) capacitor c=2.2052e-19 \
 //x=7.52 //y=2.26 //x2=7.16 //y2=1.09
cc_866 ( N_CLK_c_745_n N_noxref_13_M4_noxref_d ) capacitor c=0.00253592f \
 //x=7.085 //y=1.09 //x2=7.16 //y2=1.09
cc_867 ( N_CLK_c_748_n N_noxref_13_M4_noxref_d ) capacitor c=0.00604087f \
 //x=7.085 //y=1.4 //x2=7.16 //y2=1.09
cc_868 ( N_CLK_c_988_p N_noxref_13_M4_noxref_d ) capacitor c=0.002686f \
 //x=7.455 //y=0.935 //x2=7.16 //y2=1.09
cc_869 ( N_CLK_c_989_p N_noxref_13_M4_noxref_d ) capacitor c=0.00251995f \
 //x=7.455 //y=1.555 //x2=7.16 //y2=1.09
cc_870 ( N_CLK_c_750_n N_noxref_13_M4_noxref_d ) capacitor c=0.00314523f \
 //x=7.61 //y=1.09 //x2=7.16 //y2=1.09
cc_871 ( N_CLK_c_751_n N_noxref_13_M4_noxref_d ) capacitor c=0.00168289f \
 //x=7.61 //y=1.4 //x2=7.16 //y2=1.09
cc_872 ( N_CLK_c_752_n N_noxref_13_M4_noxref_d ) capacitor c=0.00111165f \
 //x=7.61 //y=1.63 //x2=7.16 //y2=1.09
cc_873 ( N_CLK_c_750_n N_noxref_13_M5_noxref_s ) capacitor c=7.21316e-19 \
 //x=7.61 //y=1.09 //x2=8.265 //y2=0.555
cc_874 ( N_CLK_c_751_n N_noxref_13_M5_noxref_s ) capacitor c=0.00365271f \
 //x=7.61 //y=1.4 //x2=8.265 //y2=0.555
cc_875 ( N_CLK_c_753_n N_noxref_13_M5_noxref_s ) capacitor c=9.86711e-19 \
 //x=7.61 //y=2.095 //x2=8.265 //y2=0.555
cc_876 ( N_CLK_c_777_n N_noxref_15_c_4086_n ) capacitor c=0.0252135f //x=13.79 \
 //y=3.51 //x2=13.44 //y2=4.135
cc_877 ( N_CLK_c_805_n N_noxref_16_c_4211_n ) capacitor c=0.00123426f \
 //x=17.23 //y=1.09 //x2=17.935 //y2=1.175
cc_878 ( N_CLK_c_806_n N_noxref_16_c_4211_n ) capacitor c=0.0129288f //x=17.23 \
 //y=1.4 //x2=17.935 //y2=1.175
cc_879 ( N_CLK_c_807_n N_noxref_16_c_4211_n ) capacitor c=0.00132209f \
 //x=17.23 //y=1.63 //x2=17.935 //y2=1.175
cc_880 ( N_CLK_c_768_n N_noxref_16_M10_noxref_d ) capacitor c=0.00604066f \
 //x=17.14 //y=2.375 //x2=16.78 //y2=1.09
cc_881 ( N_CLK_c_771_n N_noxref_16_M10_noxref_d ) capacitor c=3.60243e-19 \
 //x=17.14 //y=3.665 //x2=16.78 //y2=1.09
cc_882 ( N_CLK_c_789_n N_noxref_16_M10_noxref_d ) capacitor c=2.2052e-19 \
 //x=17.14 //y=2.26 //x2=16.78 //y2=1.09
cc_883 ( N_CLK_c_800_n N_noxref_16_M10_noxref_d ) capacitor c=0.00253592f \
 //x=16.705 //y=1.09 //x2=16.78 //y2=1.09
cc_884 ( N_CLK_c_803_n N_noxref_16_M10_noxref_d ) capacitor c=0.00604087f \
 //x=16.705 //y=1.4 //x2=16.78 //y2=1.09
cc_885 ( N_CLK_c_1005_p N_noxref_16_M10_noxref_d ) capacitor c=0.002686f \
 //x=17.075 //y=0.935 //x2=16.78 //y2=1.09
cc_886 ( N_CLK_c_1006_p N_noxref_16_M10_noxref_d ) capacitor c=0.00249987f \
 //x=17.075 //y=1.555 //x2=16.78 //y2=1.09
cc_887 ( N_CLK_c_805_n N_noxref_16_M10_noxref_d ) capacitor c=0.00314523f \
 //x=17.23 //y=1.09 //x2=16.78 //y2=1.09
cc_888 ( N_CLK_c_806_n N_noxref_16_M10_noxref_d ) capacitor c=0.00168289f \
 //x=17.23 //y=1.4 //x2=16.78 //y2=1.09
cc_889 ( N_CLK_c_807_n N_noxref_16_M10_noxref_d ) capacitor c=0.00111165f \
 //x=17.23 //y=1.63 //x2=16.78 //y2=1.09
cc_890 ( N_CLK_c_805_n N_noxref_16_M11_noxref_s ) capacitor c=7.21316e-19 \
 //x=17.23 //y=1.09 //x2=17.885 //y2=0.555
cc_891 ( N_CLK_c_806_n N_noxref_16_M11_noxref_s ) capacitor c=0.00365271f \
 //x=17.23 //y=1.4 //x2=17.885 //y2=0.555
cc_892 ( N_CLK_c_808_n N_noxref_16_M11_noxref_s ) capacitor c=9.86711e-19 \
 //x=17.23 //y=2.095 //x2=17.885 //y2=0.555
cc_893 ( N_CLK_c_715_n N_GND_c_4452_n ) capacitor c=9.16602e-19 //x=7.52 \
 //y=2.375 //x2=11.1 //y2=0.175
cc_894 ( N_CLK_c_719_n N_GND_c_4452_n ) capacitor c=2.6202e-19 //x=7.52 \
 //y=3.675 //x2=11.1 //y2=0.175
cc_895 ( N_CLK_c_768_n N_GND_c_4454_n ) capacitor c=9.16602e-19 //x=17.14 \
 //y=2.375 //x2=20.72 //y2=0.175
cc_896 ( N_CLK_c_745_n N_noxref_21_c_4969_n ) capacitor c=0.0167228f //x=7.085 \
 //y=1.09 //x2=7.745 //y2=0.72
cc_897 ( N_CLK_c_750_n N_noxref_21_c_4969_n ) capacitor c=0.00534519f //x=7.61 \
 //y=1.09 //x2=7.745 //y2=0.72
cc_898 ( N_CLK_c_715_n N_noxref_21_c_4962_n ) capacitor c=0.0048147f //x=7.52 \
 //y=2.375 //x2=7.745 //y2=1.77
cc_899 ( N_CLK_c_719_n N_noxref_21_c_4962_n ) capacitor c=0.00205547f //x=7.52 \
 //y=3.675 //x2=7.745 //y2=1.77
cc_900 ( N_CLK_c_734_n N_noxref_21_c_4962_n ) capacitor c=0.0105652f //x=7.52 \
 //y=2.26 //x2=7.745 //y2=1.77
cc_901 ( N_CLK_c_748_n N_noxref_21_c_4962_n ) capacitor c=0.0153476f //x=7.085 \
 //y=1.4 //x2=7.745 //y2=1.77
cc_902 ( N_CLK_c_753_n N_noxref_21_c_4962_n ) capacitor c=0.0219438f //x=7.61 \
 //y=2.095 //x2=7.745 //y2=1.77
cc_903 ( N_CLK_c_719_n N_noxref_21_M3_noxref_s ) capacitor c=3.96991e-19 \
 //x=7.52 //y=3.675 //x2=5.755 //y2=0.555
cc_904 ( N_CLK_c_745_n N_noxref_21_M3_noxref_s ) capacitor c=0.00798959f \
 //x=7.085 //y=1.09 //x2=5.755 //y2=0.555
cc_905 ( N_CLK_c_752_n N_noxref_21_M3_noxref_s ) capacitor c=0.00212176f \
 //x=7.61 //y=1.63 //x2=5.755 //y2=0.555
cc_906 ( N_CLK_c_753_n N_noxref_21_M3_noxref_s ) capacitor c=0.00298115f \
 //x=7.61 //y=2.095 //x2=5.755 //y2=0.555
cc_907 ( N_CLK_c_730_n N_noxref_22_c_5014_n ) capacitor c=0.00278359f \
 //x=11.435 //y=3.525 //x2=11.585 //y2=1.77
cc_908 ( N_CLK_c_777_n N_noxref_22_c_5027_n ) capacitor c=0.00561751f \
 //x=13.79 //y=3.51 //x2=12.555 //y2=1.77
cc_909 ( N_CLK_c_730_n N_noxref_22_M6_noxref_s ) capacitor c=0.00261405f \
 //x=11.435 //y=3.525 //x2=10.565 //y2=0.555
cc_910 ( N_CLK_c_800_n N_noxref_23_c_5085_n ) capacitor c=0.0167228f \
 //x=16.705 //y=1.09 //x2=17.365 //y2=0.72
cc_911 ( N_CLK_c_805_n N_noxref_23_c_5085_n ) capacitor c=0.00534519f \
 //x=17.23 //y=1.09 //x2=17.365 //y2=0.72
cc_912 ( N_CLK_c_768_n N_noxref_23_c_5087_n ) capacitor c=0.0048147f //x=17.14 \
 //y=2.375 //x2=17.365 //y2=1.77
cc_913 ( N_CLK_c_771_n N_noxref_23_c_5087_n ) capacitor c=0.00230811f \
 //x=17.14 //y=3.665 //x2=17.365 //y2=1.77
cc_914 ( N_CLK_c_789_n N_noxref_23_c_5087_n ) capacitor c=0.0105652f //x=17.14 \
 //y=2.26 //x2=17.365 //y2=1.77
cc_915 ( N_CLK_c_803_n N_noxref_23_c_5087_n ) capacitor c=0.0153476f \
 //x=16.705 //y=1.4 //x2=17.365 //y2=1.77
cc_916 ( N_CLK_c_808_n N_noxref_23_c_5087_n ) capacitor c=0.0218132f //x=17.23 \
 //y=2.095 //x2=17.365 //y2=1.77
cc_917 ( N_CLK_c_800_n N_noxref_23_M9_noxref_s ) capacitor c=0.00798959f \
 //x=16.705 //y=1.09 //x2=15.375 //y2=0.555
cc_918 ( N_CLK_c_807_n N_noxref_23_M9_noxref_s ) capacitor c=0.00212176f \
 //x=17.23 //y=1.63 //x2=15.375 //y2=0.555
cc_919 ( N_CLK_c_808_n N_noxref_23_M9_noxref_s ) capacitor c=0.00298115f \
 //x=17.23 //y=2.095 //x2=15.375 //y2=0.555
cc_920 ( N_noxref_4_c_1041_n RN ) capacitor c=0.0402918f //x=3.82 //y=3.72 \
 //x2=2.71 //y2=2.77
cc_921 ( N_noxref_4_c_1048_n RN ) capacitor c=0.00775314f //x=3.82 //y=4.04 \
 //x2=2.71 //y2=2.77
cc_922 ( N_noxref_4_c_1053_n RN ) capacitor c=0.0133963f //x=3.82 //y=4.75 \
 //x2=2.71 //y2=2.77
cc_923 ( N_noxref_4_c_1069_n RN ) capacitor c=3.35971e-19 //x=3.82 //y=3.88 \
 //x2=2.71 //y2=2.77
cc_924 ( N_noxref_4_c_1083_n RN ) capacitor c=0.00508137f //x=3.98 //y=3.88 \
 //x2=2.71 //y2=2.77
cc_925 ( N_noxref_4_c_1088_n RN ) capacitor c=4.16726e-19 //x=3.82 //y=2.26 \
 //x2=2.71 //y2=2.77
cc_926 ( N_noxref_4_c_1180_p RN ) capacitor c=0.00190326f //x=20.84 //y=3.72 \
 //x2=18.25 //y2=3.14
cc_927 ( N_noxref_4_c_1181_p RN ) capacitor c=0.00100495f //x=20.84 //y=4.755 \
 //x2=18.25 //y2=3.14
cc_928 ( N_noxref_4_c_1157_n RN ) capacitor c=2.68825e-19 //x=17.36 //y=3.89 \
 //x2=18.25 //y2=3.14
cc_929 ( N_noxref_4_c_1183_p RN ) capacitor c=0.026783f //x=18.605 //y=3.88 \
 //x2=18.25 //y2=3.14
cc_930 ( N_noxref_4_c_1180_p RN ) capacitor c=0.0387138f //x=20.84 //y=3.72 \
 //x2=21.95 //y2=3.14
cc_931 ( N_noxref_4_c_1185_p RN ) capacitor c=0.00769355f //x=20.84 //y=4.04 \
 //x2=21.95 //y2=3.14
cc_932 ( N_noxref_4_c_1181_p RN ) capacitor c=0.012517f //x=20.84 //y=4.755 \
 //x2=21.95 //y2=3.14
cc_933 ( N_noxref_4_c_1187_p RN ) capacitor c=2.61099e-19 //x=20.835 //y=3.88 \
 //x2=21.95 //y2=3.14
cc_934 ( N_noxref_4_c_1188_p RN ) capacitor c=0.00314475f //x=19.205 //y=3.86 \
 //x2=21.95 //y2=3.14
cc_935 ( N_noxref_4_c_1189_p RN ) capacitor c=4.16726e-19 //x=20.84 //y=2.26 \
 //x2=21.95 //y2=3.14
cc_936 ( N_noxref_4_c_1040_n N_RN_c_1598_n ) capacitor c=0.0116288f //x=3.82 \
 //y=2.375 //x2=2.71 //y2=2.375
cc_937 ( N_noxref_4_c_1088_n N_RN_c_1598_n ) capacitor c=5.42289e-19 //x=3.82 \
 //y=2.26 //x2=2.71 //y2=2.375
cc_938 ( N_noxref_4_c_1120_n N_RN_c_1598_n ) capacitor c=0.00139071f //x=3.82 \
 //y=2.26 //x2=2.71 //y2=2.375
cc_939 ( N_noxref_4_c_1193_p N_RN_c_1601_n ) capacitor c=0.0115546f //x=20.84 \
 //y=2.375 //x2=21.95 //y2=2.375
cc_940 ( N_noxref_4_c_1189_p N_RN_c_1601_n ) capacitor c=5.40058e-19 //x=20.84 \
 //y=2.26 //x2=21.95 //y2=2.375
cc_941 ( N_noxref_4_c_1195_p N_RN_c_1601_n ) capacitor c=0.00147006f //x=20.54 \
 //y=2.095 //x2=21.95 //y2=2.375
cc_942 ( N_noxref_4_c_1053_n N_RN_c_1515_n ) capacitor c=0.0145917f //x=3.82 \
 //y=4.75 //x2=2.71 //y2=4.635
cc_943 ( N_noxref_4_c_1089_n N_RN_c_1515_n ) capacitor c=7.34205e-19 //x=3.82 \
 //y=4.88 //x2=2.71 //y2=4.635
cc_944 ( N_noxref_4_c_1123_n N_RN_c_1515_n ) capacitor c=0.00145688f //x=3.82 \
 //y=4.88 //x2=2.71 //y2=4.635
cc_945 ( N_noxref_4_c_1181_p N_RN_c_1607_n ) capacitor c=0.0118156f //x=20.84 \
 //y=4.755 //x2=21.945 //y2=4.735
cc_946 ( N_noxref_4_c_1200_p N_RN_c_1607_n ) capacitor c=8.3916e-19 //x=20.84 \
 //y=4.88 //x2=21.945 //y2=4.735
cc_947 ( N_noxref_4_c_1201_p N_RN_c_1607_n ) capacitor c=7.66769e-19 \
 //x=21.405 //y=4.97 //x2=21.945 //y2=4.735
cc_948 ( N_noxref_4_c_1202_p N_RN_c_1607_n ) capacitor c=8.67242e-19 \
 //x=21.115 //y=4.97 //x2=21.945 //y2=4.735
cc_949 ( N_noxref_4_c_1048_n N_RN_c_1518_n ) capacitor c=0.00307153f //x=3.82 \
 //y=4.04 //x2=8.235 //y2=4.62
cc_950 ( N_noxref_4_c_1053_n N_RN_c_1518_n ) capacitor c=0.030677f //x=3.82 \
 //y=4.75 //x2=8.235 //y2=4.62
cc_951 ( N_noxref_4_c_1137_n N_RN_c_1518_n ) capacitor c=0.0049111f //x=8.475 \
 //y=5.335 //x2=8.235 //y2=4.62
cc_952 ( N_noxref_4_c_1070_n N_RN_c_1518_n ) capacitor c=0.0296854f //x=6.832 \
 //y=5.335 //x2=8.235 //y2=4.62
cc_953 ( N_noxref_4_c_1143_n N_RN_c_1518_n ) capacitor c=0.0291157f //x=7.71 \
 //y=5.335 //x2=8.235 //y2=4.62
cc_954 ( N_noxref_4_c_1075_n N_RN_c_1518_n ) capacitor c=0.177149f //x=7.135 \
 //y=3.88 //x2=8.235 //y2=4.62
cc_955 ( N_noxref_4_c_1083_n N_RN_c_1518_n ) capacitor c=0.0161094f //x=3.98 \
 //y=3.88 //x2=8.235 //y2=4.62
cc_956 ( N_noxref_4_c_1084_n N_RN_c_1518_n ) capacitor c=0.0235907f //x=7.735 \
 //y=3.9 //x2=8.235 //y2=4.62
cc_957 ( N_noxref_4_c_1085_n N_RN_c_1518_n ) capacitor c=0.00299803f //x=8.235 \
 //y=3.88 //x2=8.235 //y2=4.62
cc_958 ( N_noxref_4_c_1127_n N_RN_c_1620_n ) capacitor c=0.00596285f //x=9.285 \
 //y=5.335 //x2=8.835 //y2=4.64
cc_959 ( N_noxref_4_c_1213_p N_RN_c_1620_n ) capacitor c=0.0049111f //x=8.59 \
 //y=5.335 //x2=8.835 //y2=4.64
cc_960 ( N_noxref_4_c_1214_p N_RN_c_1620_n ) capacitor c=0.00299803f //x=8.835 \
 //y=3.87 //x2=8.835 //y2=4.64
cc_961 ( N_noxref_4_c_1181_p N_RN_c_1623_n ) capacitor c=0.0359261f //x=20.84 \
 //y=4.755 //x2=19.205 //y2=4.63
cc_962 ( N_noxref_4_c_1188_p N_RN_c_1623_n ) capacitor c=0.00863756f \
 //x=19.205 //y=3.86 //x2=19.205 //y2=4.63
cc_963 ( N_noxref_4_c_1127_n N_RN_c_1524_n ) capacitor c=0.0128555f //x=9.285 \
 //y=5.335 //x2=18.86 //y2=4.63
cc_964 ( N_noxref_4_c_1068_n N_RN_c_1524_n ) capacitor c=0.0303667f //x=9.37 \
 //y=5.25 //x2=18.86 //y2=4.63
cc_965 ( N_noxref_4_c_1157_n N_RN_c_1524_n ) capacitor c=0.00808488f //x=17.36 \
 //y=3.89 //x2=18.86 //y2=4.63
cc_966 ( N_noxref_4_c_1086_n N_RN_c_1524_n ) capacitor c=0.0516525f //x=17.01 \
 //y=3.89 //x2=18.86 //y2=4.63
cc_967 ( N_noxref_4_c_1183_p N_RN_c_1524_n ) capacitor c=0.00179618f \
 //x=18.605 //y=3.88 //x2=18.86 //y2=4.63
cc_968 ( N_noxref_4_c_1053_n N_RN_c_1525_n ) capacitor c=0.00293777f //x=3.82 \
 //y=4.75 //x2=2.87 //y2=4.635
cc_969 ( N_noxref_4_c_1040_n N_RN_c_1631_n ) capacitor c=5.39999e-19 //x=3.82 \
 //y=2.375 //x2=2.71 //y2=2.26
cc_970 ( N_noxref_4_c_1041_n N_RN_c_1631_n ) capacitor c=4.16726e-19 //x=3.82 \
 //y=3.72 //x2=2.71 //y2=2.26
cc_971 ( N_noxref_4_c_1088_n N_RN_c_1631_n ) capacitor c=0.00125213f //x=3.82 \
 //y=2.26 //x2=2.71 //y2=2.26
cc_972 ( N_noxref_4_c_1120_n N_RN_c_1631_n ) capacitor c=0.00204868f //x=3.82 \
 //y=2.26 //x2=2.71 //y2=2.26
cc_973 ( N_noxref_4_c_1053_n N_RN_c_1527_n ) capacitor c=4.56604e-19 //x=3.82 \
 //y=4.75 //x2=2.71 //y2=4.88
cc_974 ( N_noxref_4_c_1089_n N_RN_c_1527_n ) capacitor c=0.00113668f //x=3.82 \
 //y=4.88 //x2=2.71 //y2=4.88
cc_975 ( N_noxref_4_c_1123_n N_RN_c_1527_n ) capacitor c=0.00186974f //x=3.82 \
 //y=4.88 //x2=2.71 //y2=4.88
cc_976 ( N_noxref_4_c_1193_p N_RN_c_1638_n ) capacitor c=5.39999e-19 //x=20.84 \
 //y=2.375 //x2=21.95 //y2=2.26
cc_977 ( N_noxref_4_c_1180_p N_RN_c_1638_n ) capacitor c=4.16726e-19 //x=20.84 \
 //y=3.72 //x2=21.95 //y2=2.26
cc_978 ( N_noxref_4_c_1189_p N_RN_c_1638_n ) capacitor c=0.00125213f //x=20.84 \
 //y=2.26 //x2=21.95 //y2=2.26
cc_979 ( N_noxref_4_c_1195_p N_RN_c_1638_n ) capacitor c=0.00214573f //x=20.54 \
 //y=2.095 //x2=21.95 //y2=2.26
cc_980 ( N_noxref_4_c_1181_p N_RN_c_1642_n ) capacitor c=5.64453e-19 //x=20.84 \
 //y=4.755 //x2=21.95 //y2=4.88
cc_981 ( N_noxref_4_c_1200_p N_RN_c_1642_n ) capacitor c=0.00113666f //x=20.84 \
 //y=4.88 //x2=21.95 //y2=4.88
cc_982 ( N_noxref_4_c_1201_p N_RN_c_1642_n ) capacitor c=0.00116563f \
 //x=21.405 //y=4.97 //x2=21.95 //y2=4.88
cc_983 ( N_noxref_4_c_1202_p N_RN_c_1642_n ) capacitor c=0.0012974f //x=21.115 \
 //y=4.97 //x2=21.95 //y2=4.88
cc_984 ( N_noxref_4_M22_noxref_g N_RN_M20_noxref_g ) capacitor c=0.0101598f \
 //x=3.56 //y=6.2 //x2=2.68 //y2=6.2
cc_985 ( N_noxref_4_M22_noxref_g N_RN_M21_noxref_g ) capacitor c=0.0607518f \
 //x=3.56 //y=6.2 //x2=3.12 //y2=6.2
cc_986 ( N_noxref_4_M23_noxref_g N_RN_M21_noxref_g ) capacitor c=0.0101598f \
 //x=4 //y=6.2 //x2=3.12 //y2=6.2
cc_987 ( N_noxref_4_M42_noxref_g N_RN_M44_noxref_g ) capacitor c=0.0106276f \
 //x=21.04 //y=6.2 //x2=21.92 //y2=6.2
cc_988 ( N_noxref_4_M43_noxref_g N_RN_M44_noxref_g ) capacitor c=0.107144f \
 //x=21.48 //y=6.2 //x2=21.92 //y2=6.2
cc_989 ( N_noxref_4_M43_noxref_g N_RN_M45_noxref_g ) capacitor c=0.0101598f \
 //x=21.48 //y=6.2 //x2=22.36 //y2=6.2
cc_990 ( N_noxref_4_c_1102_n N_RN_c_1652_n ) capacitor c=0.00456962f //x=3.81 \
 //y=1.095 //x2=2.8 //y2=1.09
cc_991 ( N_noxref_4_c_1104_n N_RN_c_1653_n ) capacitor c=0.00438372f //x=3.81 \
 //y=1.44 //x2=2.8 //y2=1.4
cc_992 ( N_noxref_4_c_1107_n N_RN_c_1654_n ) capacitor c=0.00438372f //x=3.81 \
 //y=1.75 //x2=2.8 //y2=1.63
cc_993 ( N_noxref_4_c_1040_n N_RN_c_1655_n ) capacitor c=0.00141236f //x=3.82 \
 //y=2.375 //x2=2.8 //y2=2.095
cc_994 ( N_noxref_4_c_1088_n N_RN_c_1655_n ) capacitor c=0.00209664f //x=3.82 \
 //y=2.26 //x2=2.8 //y2=2.095
cc_995 ( N_noxref_4_c_1120_n N_RN_c_1655_n ) capacitor c=0.00933826f //x=3.82 \
 //y=2.26 //x2=2.8 //y2=2.095
cc_996 ( N_noxref_4_c_1121_n N_RN_c_1655_n ) capacitor c=0.00438372f //x=3.82 \
 //y=2.095 //x2=2.8 //y2=2.095
cc_997 ( N_noxref_4_c_1123_n N_RN_c_1535_n ) capacitor c=0.0616777f //x=3.82 \
 //y=4.88 //x2=3.045 //y2=4.97
cc_998 ( N_noxref_4_c_1252_p N_RN_c_1660_n ) capacitor c=5.72528e-19 //x=20.54 \
 //y=1.055 //x2=21.515 //y2=1.09
cc_999 ( N_noxref_4_c_1253_p N_RN_c_1660_n ) capacitor c=0.00150277f //x=20.54 \
 //y=1.4 //x2=21.515 //y2=1.09
cc_1000 ( N_noxref_4_c_1254_p N_RN_c_1660_n ) capacitor c=0.0160123f //x=21.07 \
 //y=1.055 //x2=21.515 //y2=1.09
cc_1001 ( N_noxref_4_c_1255_p N_RN_c_1663_n ) capacitor c=0.00111227f \
 //x=20.54 //y=1.71 //x2=21.515 //y2=1.4
cc_1002 ( N_noxref_4_c_1256_p N_RN_c_1663_n ) capacitor c=0.0124075f //x=21.07 \
 //y=1.4 //x2=21.515 //y2=1.4
cc_1003 ( N_noxref_4_c_1254_p N_RN_c_1665_n ) capacitor c=9.19165e-19 \
 //x=21.07 //y=1.055 //x2=22.04 //y2=1.09
cc_1004 ( N_noxref_4_c_1256_p N_RN_c_1666_n ) capacitor c=0.0010154f //x=21.07 \
 //y=1.4 //x2=22.04 //y2=1.4
cc_1005 ( N_noxref_4_c_1256_p N_RN_c_1667_n ) capacitor c=9.23422e-19 \
 //x=21.07 //y=1.4 //x2=22.04 //y2=1.63
cc_1006 ( N_noxref_4_c_1193_p N_RN_c_1668_n ) capacitor c=0.00140534f \
 //x=20.84 //y=2.375 //x2=22.04 //y2=2.095
cc_1007 ( N_noxref_4_c_1189_p N_RN_c_1668_n ) capacitor c=0.0020754f //x=20.84 \
 //y=2.26 //x2=22.04 //y2=2.095
cc_1008 ( N_noxref_4_c_1195_p N_RN_c_1668_n ) capacitor c=0.00964411f \
 //x=20.54 //y=2.095 //x2=22.04 //y2=2.095
cc_1009 ( N_noxref_4_c_1053_n N_RN_c_1537_n ) capacitor c=5.80817e-19 //x=3.82 \
 //y=4.75 //x2=2.71 //y2=4.88
cc_1010 ( N_noxref_4_c_1089_n N_RN_c_1537_n ) capacitor c=0.00115565f //x=3.82 \
 //y=4.88 //x2=2.71 //y2=4.88
cc_1011 ( N_noxref_4_c_1123_n N_RN_c_1537_n ) capacitor c=0.00460584f //x=3.82 \
 //y=4.88 //x2=2.71 //y2=4.88
cc_1012 ( N_noxref_4_c_1200_p N_RN_c_1674_n ) capacitor c=0.00123917f \
 //x=20.84 //y=4.88 //x2=21.95 //y2=4.88
cc_1013 ( N_noxref_4_c_1201_p N_RN_c_1674_n ) capacitor c=0.0171374f \
 //x=21.405 //y=4.97 //x2=21.95 //y2=4.88
cc_1014 ( N_noxref_4_c_1202_p N_RN_c_1674_n ) capacitor c=0.00406071f \
 //x=21.115 //y=4.97 //x2=21.95 //y2=4.88
cc_1015 ( N_noxref_4_M43_noxref_g N_QN_c_1936_n ) capacitor c=0.00893512f \
 //x=21.48 //y=6.2 //x2=22.02 //y2=5.335
cc_1016 ( N_noxref_4_M42_noxref_g N_QN_c_1937_n ) capacitor c=0.00461408f \
 //x=21.04 //y=6.2 //x2=21.262 //y2=5.335
cc_1017 ( N_noxref_4_M43_noxref_g N_QN_c_1937_n ) capacitor c=0.00229208f \
 //x=21.48 //y=6.2 //x2=21.262 //y2=5.335
cc_1018 ( N_noxref_4_c_1201_p N_QN_c_1937_n ) capacitor c=0.00171885f \
 //x=21.405 //y=4.97 //x2=21.262 //y2=5.335
cc_1019 ( N_noxref_4_M42_noxref_g N_QN_c_1940_n ) capacitor c=0.0162284f \
 //x=21.04 //y=6.2 //x2=21.26 //y2=5.56
cc_1020 ( N_noxref_4_M43_noxref_g N_QN_c_1940_n ) capacitor c=0.0179041f \
 //x=21.48 //y=6.2 //x2=21.26 //y2=5.56
cc_1021 ( N_noxref_4_c_1201_p N_QN_c_1940_n ) capacitor c=0.00291477f \
 //x=21.405 //y=4.97 //x2=21.26 //y2=5.56
cc_1022 ( N_noxref_4_c_1062_n N_SN_c_2225_n ) capacitor c=5.34004e-19 //x=9.37 \
 //y=3.725 //x2=12.33 //y2=2.615
cc_1023 ( N_noxref_4_c_1062_n N_SN_c_2228_n ) capacitor c=9.1491e-19 //x=9.37 \
 //y=3.725 //x2=12.33 //y2=4.765
cc_1024 ( N_noxref_4_c_1068_n N_SN_c_2228_n ) capacitor c=6.6877e-19 //x=9.37 \
 //y=5.25 //x2=12.33 //y2=4.765
cc_1025 ( N_noxref_4_c_1086_n N_SN_c_2228_n ) capacitor c=0.0235202f //x=17.01 \
 //y=3.89 //x2=12.33 //y2=4.765
cc_1026 ( N_noxref_4_c_1086_n N_SN_c_2272_n ) capacitor c=0.00721125f \
 //x=17.01 //y=3.89 //x2=13.79 //y2=2.77
cc_1027 ( N_noxref_4_c_1193_p N_SN_c_2283_n ) capacitor c=0.00310147f \
 //x=20.84 //y=2.375 //x2=16.245 //y2=2.755
cc_1028 ( N_noxref_4_c_1180_p N_SN_c_2283_n ) capacitor c=0.0326259f //x=20.84 \
 //y=3.72 //x2=16.245 //y2=2.755
cc_1029 ( N_noxref_4_c_1185_p N_SN_c_2283_n ) capacitor c=0.00332444f \
 //x=20.84 //y=4.04 //x2=16.245 //y2=2.755
cc_1030 ( N_noxref_4_c_1157_n N_SN_c_2283_n ) capacitor c=0.038889f //x=17.36 \
 //y=3.89 //x2=16.245 //y2=2.755
cc_1031 ( N_noxref_4_c_1086_n N_SN_c_2283_n ) capacitor c=0.0108288f //x=17.01 \
 //y=3.89 //x2=16.245 //y2=2.755
cc_1032 ( N_noxref_4_c_1183_p N_SN_c_2283_n ) capacitor c=0.0189673f \
 //x=18.605 //y=3.88 //x2=16.245 //y2=2.755
cc_1033 ( N_noxref_4_c_1188_p N_SN_c_2283_n ) capacitor c=0.0528868f \
 //x=19.205 //y=3.86 //x2=16.245 //y2=2.755
cc_1034 ( N_noxref_4_c_1062_n N_noxref_8_c_2597_n ) capacitor c=0.0154269f \
 //x=9.37 //y=3.725 //x2=8.63 //y2=2.375
cc_1035 ( N_noxref_4_c_1062_n N_noxref_8_c_2598_n ) capacitor c=0.0551789f \
 //x=9.37 //y=3.725 //x2=8.63 //y2=4.095
cc_1036 ( N_noxref_4_c_1067_n N_noxref_8_c_2598_n ) capacitor c=0.0149949f \
 //x=9.37 //y=4.045 //x2=8.63 //y2=4.095
cc_1037 ( N_noxref_4_c_1068_n N_noxref_8_c_2598_n ) capacitor c=0.00225f \
 //x=9.37 //y=5.25 //x2=8.63 //y2=4.095
cc_1038 ( N_noxref_4_c_1292_p N_noxref_8_c_2598_n ) capacitor c=6.89957e-19 \
 //x=9.37 //y=3.88 //x2=8.63 //y2=4.095
cc_1039 ( N_noxref_4_c_1084_n N_noxref_8_c_2598_n ) capacitor c=3.26957e-19 \
 //x=7.735 //y=3.9 //x2=8.63 //y2=4.095
cc_1040 ( N_noxref_4_c_1085_n N_noxref_8_c_2598_n ) capacitor c=2.47672e-19 \
 //x=8.235 //y=3.88 //x2=8.63 //y2=4.095
cc_1041 ( N_noxref_4_c_1214_p N_noxref_8_c_2598_n ) capacitor c=0.0205776f \
 //x=8.835 //y=3.87 //x2=8.63 //y2=4.095
cc_1042 ( N_noxref_4_c_1086_n N_noxref_8_c_2598_n ) capacitor c=0.00316616f \
 //x=17.01 //y=3.89 //x2=8.63 //y2=4.095
cc_1043 ( N_noxref_4_c_1137_n N_noxref_8_c_2628_n ) capacitor c=0.00148488f \
 //x=8.475 //y=5.335 //x2=8.63 //y2=4.415
cc_1044 ( N_noxref_4_c_1127_n N_noxref_8_c_2628_n ) capacitor c=0.00212239f \
 //x=9.285 //y=5.335 //x2=8.63 //y2=4.415
cc_1045 ( N_noxref_4_c_1060_n N_noxref_8_c_2628_n ) capacitor c=6.90338e-19 \
 //x=8.97 //y=1.845 //x2=8.63 //y2=4.415
cc_1046 ( N_noxref_4_c_1068_n N_noxref_8_c_2628_n ) capacitor c=0.0169935f \
 //x=9.37 //y=5.25 //x2=8.63 //y2=4.415
cc_1047 ( N_noxref_4_c_1214_p N_noxref_8_c_2628_n ) capacitor c=0.0064593f \
 //x=8.835 //y=3.87 //x2=8.63 //y2=4.415
cc_1048 ( N_noxref_4_c_1302_p N_noxref_8_c_2628_n ) capacitor c=2.33764e-19 \
 //x=8.59 //y=5.56 //x2=8.63 //y2=4.415
cc_1049 ( N_noxref_4_c_1127_n N_noxref_8_c_2603_n ) capacitor c=0.00228299f \
 //x=9.285 //y=5.335 //x2=8.63 //y2=4.75
cc_1050 ( N_noxref_4_c_1068_n N_noxref_8_c_2603_n ) capacitor c=0.0274522f \
 //x=9.37 //y=5.25 //x2=8.63 //y2=4.75
cc_1051 ( N_noxref_4_c_1213_p N_noxref_8_c_2603_n ) capacitor c=0.0221096f \
 //x=8.59 //y=5.335 //x2=8.63 //y2=4.75
cc_1052 ( N_noxref_4_c_1302_p N_noxref_8_c_2603_n ) capacitor c=0.00217653f \
 //x=8.59 //y=5.56 //x2=8.63 //y2=4.75
cc_1053 ( N_noxref_4_c_1193_p N_noxref_8_c_2639_n ) capacitor c=0.00458539f \
 //x=20.84 //y=2.375 //x2=18.99 //y2=4.085
cc_1054 ( N_noxref_4_c_1180_p N_noxref_8_c_2639_n ) capacitor c=0.0225357f \
 //x=20.84 //y=3.72 //x2=18.99 //y2=4.085
cc_1055 ( N_noxref_4_c_1185_p N_noxref_8_c_2639_n ) capacitor c=0.00259383f \
 //x=20.84 //y=4.04 //x2=18.99 //y2=4.085
cc_1056 ( N_noxref_4_c_1181_p N_noxref_8_c_2639_n ) capacitor c=8.55594e-19 \
 //x=20.84 //y=4.755 //x2=18.99 //y2=4.085
cc_1057 ( N_noxref_4_c_1183_p N_noxref_8_c_2639_n ) capacitor c=4.16089e-19 \
 //x=18.605 //y=3.88 //x2=18.99 //y2=4.085
cc_1058 ( N_noxref_4_c_1188_p N_noxref_8_c_2639_n ) capacitor c=0.0282446f \
 //x=19.205 //y=3.86 //x2=18.99 //y2=4.085
cc_1059 ( N_noxref_4_c_1181_p N_noxref_8_c_2711_n ) capacitor c=0.00251612f \
 //x=20.84 //y=4.755 //x2=18.99 //y2=4.405
cc_1060 ( N_noxref_4_c_1188_p N_noxref_8_c_2711_n ) capacitor c=0.0091686f \
 //x=19.205 //y=3.86 //x2=18.99 //y2=4.405
cc_1061 ( N_noxref_4_c_1181_p N_noxref_8_c_2641_n ) capacitor c=0.00772368f \
 //x=20.84 //y=4.755 //x2=18.99 //y2=5.25
cc_1062 ( N_noxref_4_c_1068_n N_noxref_8_c_2642_n ) capacitor c=6.82125e-19 \
 //x=9.37 //y=5.25 //x2=8.625 //y2=4.25
cc_1063 ( N_noxref_4_c_1302_p N_noxref_8_c_2642_n ) capacitor c=2.89835e-19 \
 //x=8.59 //y=5.56 //x2=8.625 //y2=4.25
cc_1064 ( N_noxref_4_c_1067_n N_noxref_8_c_2649_n ) capacitor c=0.00144195f \
 //x=9.37 //y=4.045 //x2=8.975 //y2=4.25
cc_1065 ( N_noxref_4_c_1068_n N_noxref_8_c_2649_n ) capacitor c=3.62709e-19 \
 //x=9.37 //y=5.25 //x2=8.975 //y2=4.25
cc_1066 ( N_noxref_4_c_1214_p N_noxref_8_c_2649_n ) capacitor c=0.0108613f \
 //x=8.835 //y=3.87 //x2=8.975 //y2=4.25
cc_1067 ( N_noxref_4_c_1086_n N_noxref_8_c_2649_n ) capacitor c=0.0599693f \
 //x=17.01 //y=3.89 //x2=8.975 //y2=4.25
cc_1068 ( N_noxref_4_c_1067_n N_noxref_8_c_2650_n ) capacitor c=0.00749432f \
 //x=9.37 //y=4.045 //x2=9.575 //y2=4.27
cc_1069 ( N_noxref_4_c_1068_n N_noxref_8_c_2650_n ) capacitor c=0.0209317f \
 //x=9.37 //y=5.25 //x2=9.575 //y2=4.27
cc_1070 ( N_noxref_4_c_1086_n N_noxref_8_c_2650_n ) capacitor c=0.0106828f \
 //x=17.01 //y=3.89 //x2=9.575 //y2=4.27
cc_1071 ( N_noxref_4_c_1185_p N_noxref_8_c_2723_n ) capacitor c=0.00315506f \
 //x=20.84 //y=4.04 //x2=21.05 //y2=4.265
cc_1072 ( N_noxref_4_c_1181_p N_noxref_8_c_2723_n ) capacitor c=0.0237313f \
 //x=20.84 //y=4.755 //x2=21.05 //y2=4.265
cc_1073 ( N_noxref_4_c_1068_n N_noxref_8_c_2605_n ) capacitor c=6.34565e-19 \
 //x=9.37 //y=5.25 //x2=20.705 //y2=4.265
cc_1074 ( N_noxref_4_c_1185_p N_noxref_8_c_2605_n ) capacitor c=0.00498237f \
 //x=20.84 //y=4.04 //x2=20.705 //y2=4.265
cc_1075 ( N_noxref_4_c_1181_p N_noxref_8_c_2605_n ) capacitor c=0.00194984f \
 //x=20.84 //y=4.755 //x2=20.705 //y2=4.265
cc_1076 ( N_noxref_4_c_1157_n N_noxref_8_c_2605_n ) capacitor c=0.107825f \
 //x=17.36 //y=3.89 //x2=20.705 //y2=4.265
cc_1077 ( N_noxref_4_c_1086_n N_noxref_8_c_2605_n ) capacitor c=0.682777f \
 //x=17.01 //y=3.89 //x2=20.705 //y2=4.265
cc_1078 ( N_noxref_4_c_1183_p N_noxref_8_c_2605_n ) capacitor c=0.0117903f \
 //x=18.605 //y=3.88 //x2=20.705 //y2=4.265
cc_1079 ( N_noxref_4_c_1188_p N_noxref_8_c_2605_n ) capacitor c=0.205579f \
 //x=19.205 //y=3.86 //x2=20.705 //y2=4.265
cc_1080 ( N_noxref_4_c_1068_n N_noxref_8_c_2659_n ) capacitor c=0.00297113f \
 //x=9.37 //y=5.25 //x2=8.78 //y2=4.255
cc_1081 ( N_noxref_4_c_1214_p N_noxref_8_c_2659_n ) capacitor c=0.0358834f \
 //x=8.835 //y=3.87 //x2=8.78 //y2=4.255
cc_1082 ( N_noxref_4_c_1062_n N_noxref_8_c_2660_n ) capacitor c=0.00163444f \
 //x=9.37 //y=3.725 //x2=8.63 //y2=2.26
cc_1083 ( N_noxref_4_c_1127_n N_noxref_8_c_2664_n ) capacitor c=0.00130631f \
 //x=9.285 //y=5.335 //x2=8.63 //y2=4.88
cc_1084 ( N_noxref_4_c_1068_n N_noxref_8_c_2664_n ) capacitor c=0.00131258f \
 //x=9.37 //y=5.25 //x2=8.63 //y2=4.88
cc_1085 ( N_noxref_4_c_1213_p N_noxref_8_c_2664_n ) capacitor c=0.00346456f \
 //x=8.59 //y=5.335 //x2=8.63 //y2=4.88
cc_1086 ( N_noxref_4_c_1302_p N_noxref_8_c_2664_n ) capacitor c=0.00624059f \
 //x=8.59 //y=5.56 //x2=8.63 //y2=4.88
cc_1087 ( N_noxref_4_c_1137_n N_noxref_8_M28_noxref_g ) capacitor \
 c=0.00952002f //x=8.475 //y=5.335 //x2=8.37 //y2=6.2
cc_1088 ( N_noxref_4_c_1126_n N_noxref_8_M28_noxref_g ) capacitor \
 c=0.00226521f //x=8.59 //y=5.56 //x2=8.37 //y2=6.2
cc_1089 ( N_noxref_4_c_1302_p N_noxref_8_M28_noxref_g ) capacitor c=0.0178885f \
 //x=8.59 //y=5.56 //x2=8.37 //y2=6.2
cc_1090 ( N_noxref_4_c_1126_n N_noxref_8_M29_noxref_g ) capacitor \
 c=0.00381703f //x=8.59 //y=5.56 //x2=8.81 //y2=6.2
cc_1091 ( N_noxref_4_c_1127_n N_noxref_8_M29_noxref_g ) capacitor c=0.0107549f \
 //x=9.285 //y=5.335 //x2=8.81 //y2=6.2
cc_1092 ( N_noxref_4_c_1302_p N_noxref_8_M29_noxref_g ) capacitor c=0.0188608f \
 //x=8.59 //y=5.56 //x2=8.81 //y2=6.2
cc_1093 ( N_noxref_4_c_1059_n N_noxref_8_c_2675_n ) capacitor c=4.64015e-19 \
 //x=8.885 //y=1.305 //x2=8.62 //y2=1.095
cc_1094 ( N_noxref_4_M5_noxref_d N_noxref_8_c_2675_n ) capacitor c=0.00137165f \
 //x=8.695 //y=1.095 //x2=8.62 //y2=1.095
cc_1095 ( N_noxref_4_c_1059_n N_noxref_8_c_2676_n ) capacitor c=0.0026012f \
 //x=8.885 //y=1.305 //x2=8.62 //y2=1.44
cc_1096 ( N_noxref_4_c_1350_p N_noxref_8_c_2676_n ) capacitor c=0.00127432f \
 //x=8.885 //y=1.76 //x2=8.62 //y2=1.44
cc_1097 ( N_noxref_4_M5_noxref_d N_noxref_8_c_2676_n ) capacitor c=0.00237422f \
 //x=8.695 //y=1.095 //x2=8.62 //y2=1.44
cc_1098 ( N_noxref_4_c_1350_p N_noxref_8_c_2677_n ) capacitor c=0.00429966f \
 //x=8.885 //y=1.76 //x2=8.62 //y2=1.75
cc_1099 ( N_noxref_4_c_1059_n N_noxref_8_c_2751_n ) capacitor c=5.29969e-19 \
 //x=8.885 //y=1.305 //x2=8.995 //y2=0.94
cc_1100 ( N_noxref_4_M5_noxref_d N_noxref_8_c_2751_n ) capacitor c=0.0020782f \
 //x=8.695 //y=1.095 //x2=8.995 //y2=0.94
cc_1101 ( N_noxref_4_c_1059_n N_noxref_8_c_2753_n ) capacitor c=5.31727e-19 \
 //x=8.885 //y=1.305 //x2=8.995 //y2=1.595
cc_1102 ( N_noxref_4_c_1350_p N_noxref_8_c_2753_n ) capacitor c=0.00942306f \
 //x=8.885 //y=1.76 //x2=8.995 //y2=1.595
cc_1103 ( N_noxref_4_c_1128_n N_noxref_8_c_2753_n ) capacitor c=0.00194716f \
 //x=9.285 //y=1.845 //x2=8.995 //y2=1.595
cc_1104 ( N_noxref_4_M5_noxref_d N_noxref_8_c_2753_n ) capacitor c=0.00356097f \
 //x=8.695 //y=1.095 //x2=8.995 //y2=1.595
cc_1105 ( N_noxref_4_c_1059_n N_noxref_8_c_2757_n ) capacitor c=5.24634e-19 \
 //x=8.885 //y=1.305 //x2=9.15 //y2=1.095
cc_1106 ( N_noxref_4_M5_noxref_d N_noxref_8_c_2757_n ) capacitor c=0.00139206f \
 //x=8.695 //y=1.095 //x2=9.15 //y2=1.095
cc_1107 ( N_noxref_4_c_1059_n N_noxref_8_c_2759_n ) capacitor c=0.00307978f \
 //x=8.885 //y=1.305 //x2=9.15 //y2=1.44
cc_1108 ( N_noxref_4_c_1350_p N_noxref_8_c_2759_n ) capacitor c=0.00363411f \
 //x=8.885 //y=1.76 //x2=9.15 //y2=1.44
cc_1109 ( N_noxref_4_c_1128_n N_noxref_8_c_2759_n ) capacitor c=0.00323576f \
 //x=9.285 //y=1.845 //x2=9.15 //y2=1.44
cc_1110 ( N_noxref_4_M5_noxref_d N_noxref_8_c_2759_n ) capacitor c=0.00237422f \
 //x=8.695 //y=1.095 //x2=9.15 //y2=1.44
cc_1111 ( N_noxref_4_c_1062_n N_noxref_8_c_2678_n ) capacitor c=0.0025845f \
 //x=9.37 //y=3.725 //x2=8.63 //y2=2.26
cc_1112 ( N_noxref_4_c_1350_p N_noxref_8_c_2681_n ) capacitor c=0.0036273f \
 //x=8.885 //y=1.76 //x2=8.63 //y2=2.095
cc_1113 ( N_noxref_4_c_1062_n N_noxref_8_c_2681_n ) capacitor c=0.00282067f \
 //x=9.37 //y=3.725 //x2=8.63 //y2=2.095
cc_1114 ( N_noxref_4_c_1068_n N_noxref_8_c_2682_n ) capacitor c=0.00739875f \
 //x=9.37 //y=5.25 //x2=8.63 //y2=4.88
cc_1115 ( N_noxref_4_c_1213_p N_noxref_8_c_2682_n ) capacitor c=0.00203307f \
 //x=8.59 //y=5.335 //x2=8.63 //y2=4.88
cc_1116 ( N_noxref_4_c_1302_p N_noxref_8_c_2682_n ) capacitor c=0.00371818f \
 //x=8.59 //y=5.56 //x2=8.63 //y2=4.88
cc_1117 ( N_noxref_4_c_1180_p N_noxref_9_c_3087_n ) capacitor c=0.00179128f \
 //x=20.84 //y=3.72 //x2=23.06 //y2=3.725
cc_1118 ( N_noxref_4_c_1181_p N_noxref_9_c_3088_n ) capacitor c=8.57514e-19 \
 //x=20.84 //y=4.755 //x2=23.06 //y2=4.75
cc_1119 ( N_noxref_4_c_1187_p N_noxref_9_c_3089_n ) capacitor c=8.86295e-19 \
 //x=20.835 //y=3.88 //x2=23.06 //y2=3.88
cc_1120 ( N_noxref_4_c_1188_p N_noxref_9_c_3090_n ) capacitor c=0.00237984f \
 //x=19.205 //y=3.86 //x2=23.22 //y2=3.885
cc_1121 ( N_noxref_4_c_1058_n N_VDD_c_3378_n ) capacitor c=0.00621353f \
 //x=7.59 //y=5.335 //x2=28.61 //y2=7.58
cc_1122 ( N_noxref_4_c_1137_n N_VDD_c_3378_n ) capacitor c=0.00627189f \
 //x=8.475 //y=5.335 //x2=28.61 //y2=7.58
cc_1123 ( N_noxref_4_c_1126_n N_VDD_c_3378_n ) capacitor c=0.00256019f \
 //x=8.59 //y=5.56 //x2=28.61 //y2=7.58
cc_1124 ( N_noxref_4_c_1127_n N_VDD_c_3378_n ) capacitor c=0.00829246f \
 //x=9.285 //y=5.335 //x2=28.61 //y2=7.58
cc_1125 ( N_noxref_4_c_1067_n N_VDD_c_3378_n ) capacitor c=5.12652e-19 \
 //x=9.37 //y=4.045 //x2=28.61 //y2=7.58
cc_1126 ( N_noxref_4_c_1185_p N_VDD_c_3378_n ) capacitor c=4.1681e-19 \
 //x=20.84 //y=4.04 //x2=28.61 //y2=7.58
cc_1127 ( N_noxref_4_c_1070_n N_VDD_c_3378_n ) capacitor c=0.00261804f \
 //x=6.832 //y=5.335 //x2=28.61 //y2=7.58
cc_1128 ( N_noxref_4_c_1143_n N_VDD_c_3378_n ) capacitor c=0.00270108f \
 //x=7.71 //y=5.335 //x2=28.61 //y2=7.58
cc_1129 ( N_noxref_4_c_1093_n N_VDD_c_3378_n ) capacitor c=0.0024232f //x=6.83 \
 //y=5.56 //x2=28.61 //y2=7.58
cc_1130 ( N_noxref_4_c_1169_n N_VDD_c_3378_n ) capacitor c=0.0024232f //x=7.71 \
 //y=5.56 //x2=28.61 //y2=7.58
cc_1131 ( N_noxref_4_c_1302_p N_VDD_c_3378_n ) capacitor c=0.0024232f //x=8.59 \
 //y=5.56 //x2=28.61 //y2=7.58
cc_1132 ( N_noxref_4_M22_noxref_g N_VDD_c_3399_n ) capacitor c=0.00755544f \
 //x=3.56 //y=6.2 //x2=4.135 //y2=7.585
cc_1133 ( N_noxref_4_M23_noxref_g N_VDD_c_3399_n ) capacitor c=0.00755754f \
 //x=4 //y=6.2 //x2=4.135 //y2=7.585
cc_1134 ( N_noxref_4_c_1058_n N_VDD_c_3404_n ) capacitor c=0.00202922f \
 //x=7.59 //y=5.335 //x2=7.185 //y2=7.585
cc_1135 ( N_noxref_4_c_1070_n N_VDD_c_3404_n ) capacitor c=9.3757e-19 \
 //x=6.832 //y=5.335 //x2=7.185 //y2=7.585
cc_1136 ( N_noxref_4_c_1093_n N_VDD_c_3404_n ) capacitor c=0.0138074f //x=6.83 \
 //y=5.56 //x2=7.185 //y2=7.585
cc_1137 ( N_noxref_4_c_1058_n N_VDD_c_3496_n ) capacitor c=0.0017708f //x=7.59 \
 //y=5.335 //x2=8.065 //y2=7.585
cc_1138 ( N_noxref_4_c_1137_n N_VDD_c_3496_n ) capacitor c=0.00202922f \
 //x=8.475 //y=5.335 //x2=8.065 //y2=7.585
cc_1139 ( N_noxref_4_c_1143_n N_VDD_c_3496_n ) capacitor c=9.4822e-19 //x=7.71 \
 //y=5.335 //x2=8.065 //y2=7.585
cc_1140 ( N_noxref_4_c_1169_n N_VDD_c_3496_n ) capacitor c=0.0138074f //x=7.71 \
 //y=5.56 //x2=8.065 //y2=7.585
cc_1141 ( N_noxref_4_c_1137_n N_VDD_c_3524_n ) capacitor c=0.00205906f \
 //x=8.475 //y=5.335 //x2=8.945 //y2=7.585
cc_1142 ( N_noxref_4_c_1126_n N_VDD_c_3524_n ) capacitor c=8.49654e-19 \
 //x=8.59 //y=5.56 //x2=8.945 //y2=7.585
cc_1143 ( N_noxref_4_c_1127_n N_VDD_c_3524_n ) capacitor c=0.00204238f \
 //x=9.285 //y=5.335 //x2=8.945 //y2=7.585
cc_1144 ( N_noxref_4_c_1302_p N_VDD_c_3524_n ) capacitor c=0.0135103f //x=8.59 \
 //y=5.56 //x2=8.945 //y2=7.585
cc_1145 ( N_noxref_4_c_1127_n N_VDD_c_3528_n ) capacitor c=0.00183742f \
 //x=9.285 //y=5.335 //x2=9.94 //y2=7.585
cc_1146 ( N_noxref_4_M42_noxref_g N_VDD_c_3529_n ) capacitor c=0.00755614f \
 //x=21.04 //y=6.2 //x2=21.615 //y2=7.585
cc_1147 ( N_noxref_4_M43_noxref_g N_VDD_c_3529_n ) capacitor c=0.00755544f \
 //x=21.48 //y=6.2 //x2=21.615 //y2=7.585
cc_1148 ( N_noxref_4_c_1070_n N_VDD_c_3408_n ) capacitor c=0.0022955f \
 //x=6.832 //y=5.335 //x2=5.3 //y2=7.585
cc_1149 ( N_noxref_4_c_1075_n N_VDD_c_3408_n ) capacitor c=0.00419973f \
 //x=7.135 //y=3.88 //x2=5.3 //y2=7.585
cc_1150 ( N_noxref_4_c_1089_n N_VDD_c_3408_n ) capacitor c=0.00224736f \
 //x=3.82 //y=4.88 //x2=5.3 //y2=7.585
cc_1151 ( N_noxref_4_c_1093_n N_VDD_c_3408_n ) capacitor c=0.00509469f \
 //x=6.83 //y=5.56 //x2=5.3 //y2=7.585
cc_1152 ( N_noxref_4_c_1123_n N_VDD_c_3408_n ) capacitor c=2.63786e-19 \
 //x=3.82 //y=4.88 //x2=5.3 //y2=7.585
cc_1153 ( N_noxref_4_c_1126_n N_VDD_c_3414_n ) capacitor c=0.00282782f \
 //x=8.59 //y=5.56 //x2=10.11 //y2=7.585
cc_1154 ( N_noxref_4_c_1068_n N_VDD_c_3414_n ) capacitor c=0.0316778f //x=9.37 \
 //y=5.25 //x2=10.11 //y2=7.585
cc_1155 ( N_noxref_4_c_1302_p N_VDD_c_3414_n ) capacitor c=0.00777981f \
 //x=8.59 //y=5.56 //x2=10.11 //y2=7.585
cc_1156 ( N_noxref_4_c_1181_p N_VDD_c_3539_n ) capacitor c=0.0119171f \
 //x=20.84 //y=4.755 //x2=19.73 //y2=7.585
cc_1157 ( N_noxref_4_c_1200_p N_VDD_c_3539_n ) capacitor c=0.00370784f \
 //x=20.84 //y=4.88 //x2=19.73 //y2=7.585
cc_1158 ( N_noxref_4_c_1202_p N_VDD_c_3539_n ) capacitor c=0.00590568f \
 //x=21.115 //y=4.97 //x2=19.73 //y2=7.585
cc_1159 ( N_noxref_4_M22_noxref_g N_VDD_M21_noxref_d ) capacitor c=0.015318f \
 //x=3.56 //y=6.2 //x2=3.195 //y2=5.2
cc_1160 ( N_noxref_4_M23_noxref_g N_VDD_M23_noxref_d ) capacitor c=0.0394719f \
 //x=4 //y=6.2 //x2=4.075 //y2=5.2
cc_1161 ( N_noxref_4_c_1070_n N_VDD_M24_noxref_s ) capacitor c=0.0442713f \
 //x=6.832 //y=5.335 //x2=6.255 //y2=5.2
cc_1162 ( N_noxref_4_c_1143_n N_VDD_M24_noxref_s ) capacitor c=7.80122e-19 \
 //x=7.71 //y=5.335 //x2=6.255 //y2=5.2
cc_1163 ( N_noxref_4_c_1093_n N_VDD_M24_noxref_s ) capacitor c=0.09305f \
 //x=6.83 //y=5.56 //x2=6.255 //y2=5.2
cc_1164 ( N_noxref_4_c_1058_n N_VDD_M25_noxref_d ) capacitor c=0.00700141f \
 //x=7.59 //y=5.335 //x2=7.125 //y2=5.2
cc_1165 ( N_noxref_4_c_1093_n N_VDD_M25_noxref_d ) capacitor c=0.0674491f \
 //x=6.83 //y=5.56 //x2=7.125 //y2=5.2
cc_1166 ( N_noxref_4_c_1169_n N_VDD_M25_noxref_d ) capacitor c=0.0674762f \
 //x=7.71 //y=5.56 //x2=7.125 //y2=5.2
cc_1167 ( N_noxref_4_c_1137_n N_VDD_M27_noxref_d ) capacitor c=0.00700141f \
 //x=8.475 //y=5.335 //x2=8.005 //y2=5.2
cc_1168 ( N_noxref_4_c_1169_n N_VDD_M27_noxref_d ) capacitor c=0.067493f \
 //x=7.71 //y=5.56 //x2=8.005 //y2=5.2
cc_1169 ( N_noxref_4_c_1302_p N_VDD_M27_noxref_d ) capacitor c=0.0674979f \
 //x=8.59 //y=5.56 //x2=8.005 //y2=5.2
cc_1170 ( N_noxref_4_c_1127_n N_VDD_M29_noxref_d ) capacitor c=0.00700141f \
 //x=9.285 //y=5.335 //x2=8.885 //y2=5.2
cc_1171 ( N_noxref_4_c_1302_p N_VDD_M29_noxref_d ) capacitor c=0.0675002f \
 //x=8.59 //y=5.56 //x2=8.885 //y2=5.2
cc_1172 ( N_noxref_4_c_1126_n N_VDD_M30_noxref_s ) capacitor c=0.00492616f \
 //x=8.59 //y=5.56 //x2=11.065 //y2=5.2
cc_1173 ( N_noxref_4_c_1127_n N_VDD_M30_noxref_s ) capacitor c=9.42705e-19 \
 //x=9.285 //y=5.335 //x2=11.065 //y2=5.2
cc_1174 ( N_noxref_4_c_1143_n N_VDD_M30_noxref_s ) capacitor c=2.11884e-19 \
 //x=7.71 //y=5.335 //x2=11.065 //y2=5.2
cc_1175 ( N_noxref_4_c_1185_p N_VDD_M42_noxref_s ) capacitor c=7.08613e-19 \
 //x=20.84 //y=4.04 //x2=20.685 //y2=5.2
cc_1176 ( N_noxref_4_c_1181_p N_VDD_M42_noxref_s ) capacitor c=0.0217981f \
 //x=20.84 //y=4.755 //x2=20.685 //y2=5.2
cc_1177 ( N_noxref_4_c_1200_p N_VDD_M42_noxref_s ) capacitor c=0.00983413f \
 //x=20.84 //y=4.88 //x2=20.685 //y2=5.2
cc_1178 ( N_noxref_4_M42_noxref_g N_VDD_M42_noxref_s ) capacitor c=0.053419f \
 //x=21.04 //y=6.2 //x2=20.685 //y2=5.2
cc_1179 ( N_noxref_4_c_1202_p N_VDD_M42_noxref_s ) capacitor c=0.00604424f \
 //x=21.115 //y=4.97 //x2=20.685 //y2=5.2
cc_1180 ( N_noxref_4_M43_noxref_g N_VDD_M43_noxref_d ) capacitor c=0.015318f \
 //x=21.48 //y=6.2 //x2=21.555 //y2=5.2
cc_1181 ( N_noxref_4_c_1041_n D ) capacitor c=0.00216161f //x=3.82 //y=3.72 \
 //x2=1.6 //y2=2.77
cc_1182 ( N_noxref_4_c_1053_n D ) capacitor c=0.00113648f //x=3.82 //y=4.75 \
 //x2=1.6 //y2=2.77
cc_1183 ( N_noxref_4_c_1040_n N_noxref_12_c_3880_n ) capacitor c=0.00177186f \
 //x=3.82 //y=2.375 //x2=4.475 //y2=0.72
cc_1184 ( N_noxref_4_c_1088_n N_noxref_12_c_3880_n ) capacitor c=0.00117306f \
 //x=3.82 //y=2.26 //x2=4.475 //y2=0.72
cc_1185 ( N_noxref_4_c_1102_n N_noxref_12_c_3880_n ) capacitor c=0.0206349f \
 //x=3.81 //y=1.095 //x2=4.475 //y2=0.72
cc_1186 ( N_noxref_4_c_1114_n N_noxref_12_c_3880_n ) capacitor c=0.00825432f \
 //x=4.34 //y=1.095 //x2=4.475 //y2=0.72
cc_1187 ( N_noxref_4_c_1120_n N_noxref_12_c_3880_n ) capacitor c=2.20712e-19 \
 //x=3.82 //y=2.26 //x2=4.475 //y2=0.72
cc_1188 ( N_noxref_4_c_1104_n N_noxref_12_c_3883_n ) capacitor c=0.0071177f \
 //x=3.81 //y=1.44 //x2=3.59 //y2=1.175
cc_1189 ( N_noxref_4_c_1102_n N_noxref_12_M2_noxref_s ) capacitor c=0.0071177f \
 //x=3.81 //y=1.095 //x2=3.455 //y2=0.555
cc_1190 ( N_noxref_4_c_1107_n N_noxref_12_M2_noxref_s ) capacitor c=0.0071177f \
 //x=3.81 //y=1.75 //x2=3.455 //y2=0.555
cc_1191 ( N_noxref_4_c_1114_n N_noxref_12_M2_noxref_s ) capacitor c=0.015333f \
 //x=4.34 //y=1.095 //x2=3.455 //y2=0.555
cc_1192 ( N_noxref_4_c_1116_n N_noxref_12_M2_noxref_s ) capacitor \
 c=0.00248746f //x=4.34 //y=1.44 //x2=3.455 //y2=0.555
cc_1193 ( N_noxref_4_c_1059_n N_noxref_13_c_3964_n ) capacitor c=0.00364138f \
 //x=8.885 //y=1.305 //x2=9.285 //y2=0.72
cc_1194 ( N_noxref_4_c_1128_n N_noxref_13_c_3964_n ) capacitor c=0.00368336f \
 //x=9.285 //y=1.845 //x2=9.285 //y2=0.72
cc_1195 ( N_noxref_4_M5_noxref_d N_noxref_13_c_3964_n ) capacitor \
 c=0.00910163f //x=8.695 //y=1.095 //x2=9.285 //y2=0.72
cc_1196 ( N_noxref_4_M5_noxref_d N_noxref_13_c_3967_n ) capacitor \
 c=0.00120711f //x=8.695 //y=1.095 //x2=8.4 //y2=1.175
cc_1197 ( N_noxref_4_c_1058_n N_noxref_13_M4_noxref_d ) capacitor \
 c=0.00136664f //x=7.59 //y=5.335 //x2=7.16 //y2=1.09
cc_1198 ( N_noxref_4_c_1059_n N_noxref_13_M4_noxref_d ) capacitor \
 c=0.00802417f //x=8.885 //y=1.305 //x2=7.16 //y2=1.09
cc_1199 ( N_noxref_4_c_1059_n N_noxref_13_M5_noxref_s ) capacitor c=0.0098487f \
 //x=8.885 //y=1.305 //x2=8.265 //y2=0.555
cc_1200 ( N_noxref_4_c_1350_p N_noxref_13_M5_noxref_s ) capacitor c=0.0283243f \
 //x=8.885 //y=1.76 //x2=8.265 //y2=0.555
cc_1201 ( N_noxref_4_c_1128_n N_noxref_13_M5_noxref_s ) capacitor \
 c=0.00911719f //x=9.285 //y=1.845 //x2=8.265 //y2=0.555
cc_1202 ( N_noxref_4_c_1292_p N_noxref_13_M5_noxref_s ) capacitor \
 c=0.00129723f //x=9.37 //y=3.88 //x2=8.265 //y2=0.555
cc_1203 ( N_noxref_4_M5_noxref_d N_noxref_13_M5_noxref_s ) capacitor \
 c=0.0279003f //x=8.695 //y=1.095 //x2=8.265 //y2=0.555
cc_1204 ( N_noxref_4_c_1059_n N_noxref_14_M7_noxref_d ) capacitor \
 c=3.20746e-19 //x=8.885 //y=1.305 //x2=11.97 //y2=1.09
cc_1205 ( N_noxref_4_c_1086_n N_noxref_15_c_4086_n ) capacitor c=0.0220654f \
 //x=17.01 //y=3.89 //x2=13.44 //y2=4.135
cc_1206 ( N_noxref_4_c_1086_n N_noxref_15_c_4097_n ) capacitor c=0.0052618f \
 //x=17.01 //y=3.89 //x2=13.44 //y2=4.365
cc_1207 ( N_noxref_4_c_1040_n N_GND_c_4351_n ) capacitor c=0.0021992f //x=3.82 \
 //y=2.375 //x2=6.29 //y2=0.175
cc_1208 ( N_noxref_4_c_1059_n N_GND_c_4452_n ) capacitor c=0.00901861f \
 //x=8.885 //y=1.305 //x2=11.1 //y2=0.175
cc_1209 ( N_noxref_4_c_1128_n N_GND_c_4452_n ) capacitor c=0.00713708f \
 //x=9.285 //y=1.845 //x2=11.1 //y2=0.175
cc_1210 ( N_noxref_4_c_1067_n N_GND_c_4452_n ) capacitor c=5.11869e-19 \
 //x=9.37 //y=4.045 //x2=11.1 //y2=0.175
cc_1211 ( N_noxref_4_M5_noxref_d N_GND_c_4452_n ) capacitor c=2.9462e-19 \
 //x=8.695 //y=1.095 //x2=11.1 //y2=0.175
cc_1212 ( N_noxref_4_c_1252_p N_GND_c_4460_n ) capacitor c=3.97665e-19 \
 //x=20.54 //y=1.055 //x2=20.805 //y2=1.015
cc_1213 ( N_noxref_4_c_1467_p N_GND_c_4460_n ) capacitor c=0.00864776f \
 //x=20.915 //y=0.9 //x2=20.805 //y2=1.015
cc_1214 ( N_noxref_4_c_1254_p N_GND_c_4460_n ) capacitor c=4.45447e-19 \
 //x=21.07 //y=1.055 //x2=20.805 //y2=1.015
cc_1215 ( N_noxref_4_c_1059_n N_GND_c_4373_n ) capacitor c=0.00543195f \
 //x=8.885 //y=1.305 //x2=11.185 //y2=1.145
cc_1216 ( N_noxref_4_c_1193_p N_GND_c_4464_n ) capacitor c=0.00799365f \
 //x=20.84 //y=2.375 //x2=20.805 //y2=1.145
cc_1217 ( N_noxref_4_c_1185_p N_GND_c_4464_n ) capacitor c=6.84114e-19 \
 //x=20.84 //y=4.04 //x2=20.805 //y2=1.145
cc_1218 ( N_noxref_4_c_1189_p N_GND_c_4464_n ) capacitor c=2.22883e-19 \
 //x=20.84 //y=2.26 //x2=20.805 //y2=1.145
cc_1219 ( N_noxref_4_c_1252_p N_GND_c_4464_n ) capacitor c=0.00156339f \
 //x=20.54 //y=1.055 //x2=20.805 //y2=1.145
cc_1220 ( N_noxref_4_c_1253_p N_GND_c_4464_n ) capacitor c=0.00352472f \
 //x=20.54 //y=1.4 //x2=20.805 //y2=1.145
cc_1221 ( N_noxref_4_c_1255_p N_GND_c_4464_n ) capacitor c=4.40631e-19 \
 //x=20.54 //y=1.71 //x2=20.805 //y2=1.145
cc_1222 ( N_noxref_4_c_1467_p N_GND_c_4464_n ) capacitor c=9.36995e-19 \
 //x=20.915 //y=0.9 //x2=20.805 //y2=1.145
cc_1223 ( N_noxref_4_c_1477_p N_GND_c_4464_n ) capacitor c=5.96388e-19 \
 //x=20.915 //y=1.555 //x2=20.805 //y2=1.145
cc_1224 ( N_noxref_4_c_1254_p N_GND_c_4464_n ) capacitor c=0.0017438f \
 //x=21.07 //y=1.055 //x2=20.805 //y2=1.145
cc_1225 ( N_noxref_4_c_1256_p N_GND_c_4464_n ) capacitor c=0.00276804f \
 //x=21.07 //y=1.4 //x2=20.805 //y2=1.145
cc_1226 ( N_noxref_4_c_1040_n N_GND_c_4384_n ) capacitor c=2.016e-19 //x=3.82 \
 //y=2.375 //x2=5.13 //y2=0.175
cc_1227 ( N_noxref_4_c_1128_n N_GND_c_4386_n ) capacitor c=6.86343e-19 \
 //x=9.285 //y=1.845 //x2=9.94 //y2=0.175
cc_1228 ( N_noxref_4_c_1252_p N_GND_c_4476_n ) capacitor c=0.00677766f \
 //x=20.54 //y=1.055 //x2=24.37 //y2=0.175
cc_1229 ( N_noxref_4_c_1088_n N_GND_c_4388_n ) capacitor c=0.00239899f \
 //x=3.82 //y=2.26 //x2=5.3 //y2=0.175
cc_1230 ( N_noxref_4_c_1116_n N_GND_c_4388_n ) capacitor c=0.00262688f \
 //x=4.34 //y=1.44 //x2=5.3 //y2=0.175
cc_1231 ( N_noxref_4_c_1120_n N_GND_c_4388_n ) capacitor c=2.63786e-19 \
 //x=3.82 //y=2.26 //x2=5.3 //y2=0.175
cc_1232 ( N_noxref_4_c_1350_p N_GND_c_4396_n ) capacitor c=0.0045138f \
 //x=8.885 //y=1.76 //x2=10.11 //y2=0.175
cc_1233 ( N_noxref_4_c_1128_n N_GND_c_4396_n ) capacitor c=0.0335629f \
 //x=9.285 //y=1.845 //x2=10.11 //y2=0.175
cc_1234 ( N_noxref_4_c_1193_p N_GND_c_4482_n ) capacitor c=0.00407472f \
 //x=20.84 //y=2.375 //x2=19.73 //y2=0.175
cc_1235 ( N_noxref_4_c_1180_p N_GND_c_4482_n ) capacitor c=0.00967862f \
 //x=20.84 //y=3.72 //x2=19.73 //y2=0.175
cc_1236 ( N_noxref_4_c_1188_p N_GND_c_4482_n ) capacitor c=0.00276652f \
 //x=19.205 //y=3.86 //x2=19.73 //y2=0.175
cc_1237 ( N_noxref_4_c_1189_p N_GND_c_4482_n ) capacitor c=0.00411295f \
 //x=20.84 //y=2.26 //x2=19.73 //y2=0.175
cc_1238 ( N_noxref_4_c_1255_p N_GND_c_4482_n ) capacitor c=0.00170145f \
 //x=20.54 //y=1.71 //x2=19.73 //y2=0.175
cc_1239 ( N_noxref_4_c_1195_p N_GND_c_4482_n ) capacitor c=0.00991898f \
 //x=20.54 //y=2.095 //x2=19.73 //y2=0.175
cc_1240 ( N_noxref_4_c_1193_p N_GND_M12_noxref_d ) capacitor c=4.4417e-19 \
 //x=20.84 //y=2.375 //x2=20.615 //y2=1.055
cc_1241 ( N_noxref_4_c_1252_p N_GND_M12_noxref_d ) capacitor c=0.00184354f \
 //x=20.54 //y=1.055 //x2=20.615 //y2=1.055
cc_1242 ( N_noxref_4_c_1253_p N_GND_M12_noxref_d ) capacitor c=0.00210798f \
 //x=20.54 //y=1.4 //x2=20.615 //y2=1.055
cc_1243 ( N_noxref_4_c_1467_p N_GND_M12_noxref_d ) capacitor c=0.00474029f \
 //x=20.915 //y=0.9 //x2=20.615 //y2=1.055
cc_1244 ( N_noxref_4_c_1477_p N_GND_M12_noxref_d ) capacitor c=0.00166857f \
 //x=20.915 //y=1.555 //x2=20.615 //y2=1.055
cc_1245 ( N_noxref_4_c_1254_p N_GND_M12_noxref_d ) capacitor c=0.00230174f \
 //x=21.07 //y=1.055 //x2=20.615 //y2=1.055
cc_1246 ( N_noxref_4_c_1256_p N_GND_M12_noxref_d ) capacitor c=0.00210798f \
 //x=21.07 //y=1.4 //x2=20.615 //y2=1.055
cc_1247 ( N_noxref_4_c_1195_p N_noxref_24_c_5132_n ) capacitor c=0.00262672f \
 //x=20.54 //y=2.095 //x2=20.32 //y2=1.685
cc_1248 ( N_noxref_4_c_1193_p N_noxref_24_c_5133_n ) capacitor c=0.00428451f \
 //x=20.84 //y=2.375 //x2=21.205 //y2=1.77
cc_1249 ( N_noxref_4_c_1185_p N_noxref_24_c_5133_n ) capacitor c=0.00209321f \
 //x=20.84 //y=4.04 //x2=21.205 //y2=1.77
cc_1250 ( N_noxref_4_c_1189_p N_noxref_24_c_5133_n ) capacitor c=0.0104666f \
 //x=20.84 //y=2.26 //x2=21.205 //y2=1.77
cc_1251 ( N_noxref_4_c_1255_p N_noxref_24_c_5133_n ) capacitor c=0.00705077f \
 //x=20.54 //y=1.71 //x2=21.205 //y2=1.77
cc_1252 ( N_noxref_4_c_1195_p N_noxref_24_c_5133_n ) capacitor c=0.0211416f \
 //x=20.54 //y=2.095 //x2=21.205 //y2=1.77
cc_1253 ( N_noxref_4_c_1477_p N_noxref_24_c_5133_n ) capacitor c=0.00588627f \
 //x=20.915 //y=1.555 //x2=21.205 //y2=1.77
cc_1254 ( N_noxref_4_c_1256_p N_noxref_24_c_5133_n ) capacitor c=0.00698822f \
 //x=21.07 //y=1.4 //x2=21.205 //y2=1.77
cc_1255 ( N_noxref_4_c_1252_p N_noxref_24_M12_noxref_s ) capacitor \
 c=0.0295256f //x=20.54 //y=1.055 //x2=20.185 //y2=0.555
cc_1256 ( N_noxref_4_c_1255_p N_noxref_24_M12_noxref_s ) capacitor \
 c=7.99997e-19 //x=20.54 //y=1.71 //x2=20.185 //y2=0.555
cc_1257 ( N_noxref_4_c_1195_p N_noxref_24_M12_noxref_s ) capacitor \
 c=0.00122123f //x=20.54 //y=2.095 //x2=20.185 //y2=0.555
cc_1258 ( N_noxref_4_c_1254_p N_noxref_24_M12_noxref_s ) capacitor \
 c=0.0125924f //x=21.07 //y=1.055 //x2=20.185 //y2=0.555
cc_1259 ( RN QN ) capacitor c=0.00147865f //x=21.95 //y=3.14 //x2=23.8 //y2=2.4
cc_1260 ( RN QN ) capacitor c=0.00168609f //x=21.95 //y=3.14 //x2=23.8 //y2=4.62
cc_1261 ( N_RN_c_1607_n N_QN_c_1936_n ) capacitor c=0.0234412f //x=21.945 \
 //y=4.735 //x2=22.02 //y2=5.335
cc_1262 ( N_RN_c_1623_n N_QN_c_1936_n ) capacitor c=0.00127873f //x=19.205 \
 //y=4.63 //x2=22.02 //y2=5.335
cc_1263 ( N_RN_c_1642_n N_QN_c_1936_n ) capacitor c=0.00492634f //x=21.95 \
 //y=4.88 //x2=22.02 //y2=5.335
cc_1264 ( N_RN_M44_noxref_g N_QN_c_1936_n ) capacitor c=0.00858237f //x=21.92 \
 //y=6.2 //x2=22.02 //y2=5.335
cc_1265 ( N_RN_c_1674_n N_QN_c_1936_n ) capacitor c=3.71233e-19 //x=21.95 \
 //y=4.88 //x2=22.02 //y2=5.335
cc_1266 ( N_RN_M45_noxref_g N_QN_c_1950_n ) capacitor c=0.0103546f //x=22.36 \
 //y=6.2 //x2=22.905 //y2=5.335
cc_1267 ( N_RN_c_1623_n N_QN_c_1937_n ) capacitor c=0.0278748f //x=19.205 \
 //y=4.63 //x2=21.262 //y2=5.335
cc_1268 ( N_RN_c_1607_n N_QN_c_1952_n ) capacitor c=0.00478624f //x=21.945 \
 //y=4.735 //x2=22.14 //y2=5.335
cc_1269 ( N_RN_c_1623_n N_QN_c_1952_n ) capacitor c=0.00102235f //x=19.205 \
 //y=4.63 //x2=22.14 //y2=5.335
cc_1270 ( N_RN_c_1642_n N_QN_c_1952_n ) capacitor c=0.00132214f //x=21.95 \
 //y=4.88 //x2=22.14 //y2=5.335
cc_1271 ( N_RN_M44_noxref_g N_QN_c_1952_n ) capacitor c=0.00229818f //x=21.92 \
 //y=6.2 //x2=22.14 //y2=5.335
cc_1272 ( N_RN_M45_noxref_g N_QN_c_1952_n ) capacitor c=0.00230699f //x=22.36 \
 //y=6.2 //x2=22.14 //y2=5.335
cc_1273 ( N_RN_c_1691_p N_QN_c_1952_n ) capacitor c=0.00172273f //x=22.285 \
 //y=4.97 //x2=22.14 //y2=5.335
cc_1274 ( N_RN_c_1607_n N_QN_c_1958_n ) capacitor c=0.00175285f //x=21.945 \
 //y=4.735 //x2=22.14 //y2=5.56
cc_1275 ( N_RN_M44_noxref_g N_QN_c_1958_n ) capacitor c=0.0179041f //x=21.92 \
 //y=6.2 //x2=22.14 //y2=5.56
cc_1276 ( N_RN_M45_noxref_g N_QN_c_1958_n ) capacitor c=0.0179041f //x=22.36 \
 //y=6.2 //x2=22.14 //y2=5.56
cc_1277 ( N_RN_c_1691_p N_QN_c_1958_n ) capacitor c=0.00293647f //x=22.285 \
 //y=4.97 //x2=22.14 //y2=5.56
cc_1278 ( N_RN_c_1524_n N_SN_c_2228_n ) capacitor c=0.0309811f //x=18.86 \
 //y=4.63 //x2=12.33 //y2=4.765
cc_1279 ( RN N_SN_c_2283_n ) capacitor c=0.0302472f //x=18.25 //y=3.14 \
 //x2=16.245 //y2=2.755
cc_1280 ( RN N_SN_c_2283_n ) capacitor c=0.0326692f //x=21.95 //y=3.14 \
 //x2=16.245 //y2=2.755
cc_1281 ( N_RN_c_1551_n N_SN_c_2283_n ) capacitor c=0.00356704f //x=18.25 \
 //y=2.375 //x2=16.245 //y2=2.755
cc_1282 ( N_RN_c_1601_n N_SN_c_2283_n ) capacitor c=0.00385375f //x=21.95 \
 //y=2.375 //x2=16.245 //y2=2.755
cc_1283 ( N_RN_c_1623_n N_SN_c_2283_n ) capacitor c=0.00260648f //x=19.205 \
 //y=4.63 //x2=16.245 //y2=2.755
cc_1284 ( N_RN_c_1518_n N_noxref_8_c_2628_n ) capacitor c=0.00120777f \
 //x=8.235 //y=4.62 //x2=8.63 //y2=4.415
cc_1285 ( N_RN_c_1620_n N_noxref_8_c_2628_n ) capacitor c=0.00367208f \
 //x=8.835 //y=4.64 //x2=8.63 //y2=4.415
cc_1286 ( N_RN_c_1518_n N_noxref_8_c_2603_n ) capacitor c=4.95457e-19 \
 //x=8.235 //y=4.62 //x2=8.63 //y2=4.75
cc_1287 ( N_RN_c_1620_n N_noxref_8_c_2603_n ) capacitor c=0.0270037f //x=8.835 \
 //y=4.64 //x2=8.63 //y2=4.75
cc_1288 ( N_RN_c_1524_n N_noxref_8_c_2603_n ) capacitor c=4.23638e-19 \
 //x=18.86 //y=4.63 //x2=8.63 //y2=4.75
cc_1289 ( N_RN_c_1554_n N_noxref_8_c_2638_n ) capacitor c=0.00287672f \
 //x=18.245 //y=4.725 //x2=18.095 //y2=5.335
cc_1290 ( N_RN_c_1524_n N_noxref_8_c_2638_n ) capacitor c=0.00127537f \
 //x=18.86 //y=4.63 //x2=18.095 //y2=5.335
cc_1291 ( N_RN_M40_noxref_g N_noxref_8_c_2638_n ) capacitor c=0.00955829f \
 //x=17.99 //y=6.2 //x2=18.095 //y2=5.335
cc_1292 ( N_RN_M40_noxref_g N_noxref_8_c_2777_n ) capacitor c=0.00226521f \
 //x=17.99 //y=6.2 //x2=18.21 //y2=5.56
cc_1293 ( N_RN_M41_noxref_g N_noxref_8_c_2777_n ) capacitor c=0.00381703f \
 //x=18.43 //y=6.2 //x2=18.21 //y2=5.56
cc_1294 ( N_RN_c_1554_n N_noxref_8_c_2779_n ) capacitor c=0.00425719f \
 //x=18.245 //y=4.725 //x2=18.905 //y2=5.335
cc_1295 ( N_RN_c_1524_n N_noxref_8_c_2779_n ) capacitor c=0.020568f //x=18.86 \
 //y=4.63 //x2=18.905 //y2=5.335
cc_1296 ( N_RN_c_1565_n N_noxref_8_c_2779_n ) capacitor c=0.00130631f \
 //x=18.25 //y=4.88 //x2=18.905 //y2=5.335
cc_1297 ( N_RN_M41_noxref_g N_noxref_8_c_2779_n ) capacitor c=0.0107259f \
 //x=18.43 //y=6.2 //x2=18.905 //y2=5.335
cc_1298 ( N_RN_c_1571_n N_noxref_8_c_2783_n ) capacitor c=4.64015e-19 \
 //x=18.24 //y=1.095 //x2=18.505 //y2=1.305
cc_1299 ( N_RN_c_1572_n N_noxref_8_c_2783_n ) capacitor c=0.0026012f //x=18.24 \
 //y=1.44 //x2=18.505 //y2=1.305
cc_1300 ( N_RN_c_1718_p N_noxref_8_c_2783_n ) capacitor c=5.29969e-19 \
 //x=18.615 //y=0.94 //x2=18.505 //y2=1.305
cc_1301 ( N_RN_c_1719_p N_noxref_8_c_2783_n ) capacitor c=5.49615e-19 \
 //x=18.615 //y=1.595 //x2=18.505 //y2=1.305
cc_1302 ( N_RN_c_1720_p N_noxref_8_c_2783_n ) capacitor c=5.24634e-19 \
 //x=18.77 //y=1.095 //x2=18.505 //y2=1.305
cc_1303 ( N_RN_c_1721_p N_noxref_8_c_2783_n ) capacitor c=0.00307978f \
 //x=18.77 //y=1.44 //x2=18.505 //y2=1.305
cc_1304 ( N_RN_c_1572_n N_noxref_8_c_2789_n ) capacitor c=0.00127432f \
 //x=18.24 //y=1.44 //x2=18.505 //y2=1.76
cc_1305 ( N_RN_c_1573_n N_noxref_8_c_2789_n ) capacitor c=0.00429966f \
 //x=18.24 //y=1.75 //x2=18.505 //y2=1.76
cc_1306 ( N_RN_c_1719_p N_noxref_8_c_2789_n ) capacitor c=0.00942306f \
 //x=18.615 //y=1.595 //x2=18.505 //y2=1.76
cc_1307 ( N_RN_c_1721_p N_noxref_8_c_2789_n ) capacitor c=0.00363411f \
 //x=18.77 //y=1.44 //x2=18.505 //y2=1.76
cc_1308 ( N_RN_c_1577_n N_noxref_8_c_2789_n ) capacitor c=0.0036273f //x=18.25 \
 //y=2.095 //x2=18.505 //y2=1.76
cc_1309 ( N_RN_c_1719_p N_noxref_8_c_2794_n ) capacitor c=0.00194716f \
 //x=18.615 //y=1.595 //x2=18.905 //y2=1.845
cc_1310 ( N_RN_c_1721_p N_noxref_8_c_2794_n ) capacitor c=0.00323576f \
 //x=18.77 //y=1.44 //x2=18.905 //y2=1.845
cc_1311 ( RN N_noxref_8_c_2639_n ) capacitor c=0.0718314f //x=18.25 //y=3.14 \
 //x2=18.99 //y2=4.085
cc_1312 ( RN N_noxref_8_c_2639_n ) capacitor c=0.00206457f //x=21.95 //y=3.14 \
 //x2=18.99 //y2=4.085
cc_1313 ( N_RN_c_1551_n N_noxref_8_c_2639_n ) capacitor c=0.0154269f //x=18.25 \
 //y=2.375 //x2=18.99 //y2=4.085
cc_1314 ( N_RN_c_1561_n N_noxref_8_c_2639_n ) capacitor c=0.00163444f \
 //x=18.25 //y=2.26 //x2=18.99 //y2=4.085
cc_1315 ( N_RN_c_1574_n N_noxref_8_c_2639_n ) capacitor c=0.0025845f //x=18.25 \
 //y=2.26 //x2=18.99 //y2=4.085
cc_1316 ( N_RN_c_1577_n N_noxref_8_c_2639_n ) capacitor c=0.00282067f \
 //x=18.25 //y=2.095 //x2=18.99 //y2=4.085
cc_1317 ( RN N_noxref_8_c_2711_n ) capacitor c=0.0146245f //x=18.25 //y=3.14 \
 //x2=18.99 //y2=4.405
cc_1318 ( N_RN_c_1623_n N_noxref_8_c_2711_n ) capacitor c=0.00749612f \
 //x=19.205 //y=4.63 //x2=18.99 //y2=4.405
cc_1319 ( N_RN_c_1524_n N_noxref_8_c_2711_n ) capacitor c=0.00115397f \
 //x=18.86 //y=4.63 //x2=18.99 //y2=4.405
cc_1320 ( RN N_noxref_8_c_2641_n ) capacitor c=0.00665851f //x=18.25 //y=3.14 \
 //x2=18.99 //y2=5.25
cc_1321 ( RN N_noxref_8_c_2641_n ) capacitor c=3.37146e-19 //x=21.95 //y=3.14 \
 //x2=18.99 //y2=5.25
cc_1322 ( N_RN_c_1554_n N_noxref_8_c_2641_n ) capacitor c=0.0208869f \
 //x=18.245 //y=4.725 //x2=18.99 //y2=5.25
cc_1323 ( N_RN_c_1623_n N_noxref_8_c_2641_n ) capacitor c=0.0290666f \
 //x=19.205 //y=4.63 //x2=18.99 //y2=5.25
cc_1324 ( N_RN_c_1524_n N_noxref_8_c_2641_n ) capacitor c=0.0039813f //x=18.86 \
 //y=4.63 //x2=18.99 //y2=5.25
cc_1325 ( N_RN_c_1565_n N_noxref_8_c_2641_n ) capacitor c=8.58024e-19 \
 //x=18.25 //y=4.88 //x2=18.99 //y2=5.25
cc_1326 ( N_RN_c_1578_n N_noxref_8_c_2641_n ) capacitor c=0.00606883f \
 //x=18.25 //y=4.88 //x2=18.99 //y2=5.25
cc_1327 ( N_RN_c_1524_n N_noxref_8_c_2608_n ) capacitor c=0.0291914f //x=18.86 \
 //y=4.63 //x2=16.452 //y2=5.335
cc_1328 ( N_RN_c_1524_n N_noxref_8_c_2643_n ) capacitor c=0.0380455f //x=18.86 \
 //y=4.63 //x2=17.33 //y2=5.335
cc_1329 ( N_RN_c_1554_n N_noxref_8_c_2814_n ) capacitor c=0.0227467f \
 //x=18.245 //y=4.725 //x2=18.21 //y2=5.335
cc_1330 ( N_RN_c_1565_n N_noxref_8_c_2814_n ) capacitor c=0.00346456f \
 //x=18.25 //y=4.88 //x2=18.21 //y2=5.335
cc_1331 ( N_RN_c_1578_n N_noxref_8_c_2814_n ) capacitor c=0.00203307f \
 //x=18.25 //y=4.88 //x2=18.21 //y2=5.335
cc_1332 ( RN N_noxref_8_c_2817_n ) capacitor c=6.15181e-19 //x=18.25 //y=3.14 \
 //x2=18.99 //y2=4.25
cc_1333 ( N_RN_c_1620_n N_noxref_8_c_2649_n ) capacitor c=0.0108205f //x=8.835 \
 //y=4.64 //x2=8.975 //y2=4.25
cc_1334 ( N_RN_c_1524_n N_noxref_8_c_2649_n ) capacitor c=0.075831f //x=18.86 \
 //y=4.63 //x2=8.975 //y2=4.25
cc_1335 ( RN N_noxref_8_c_2723_n ) capacitor c=2.60288e-19 //x=21.95 //y=3.14 \
 //x2=21.05 //y2=4.265
cc_1336 ( N_RN_c_1623_n N_noxref_8_c_2723_n ) capacitor c=0.0876123f \
 //x=19.205 //y=4.63 //x2=21.05 //y2=4.265
cc_1337 ( RN N_noxref_8_c_2605_n ) capacitor c=0.0249219f //x=18.25 //y=3.14 \
 //x2=20.705 //y2=4.265
cc_1338 ( N_RN_c_1554_n N_noxref_8_c_2605_n ) capacitor c=7.89077e-19 \
 //x=18.245 //y=4.725 //x2=20.705 //y2=4.265
cc_1339 ( N_RN_c_1623_n N_noxref_8_c_2605_n ) capacitor c=0.191148f //x=19.205 \
 //y=4.63 //x2=20.705 //y2=4.265
cc_1340 ( N_RN_c_1524_n N_noxref_8_c_2605_n ) capacitor c=0.867565f //x=18.86 \
 //y=4.63 //x2=20.705 //y2=4.265
cc_1341 ( RN N_noxref_8_c_2826_n ) capacitor c=0.0291908f //x=21.95 //y=3.14 \
 //x2=22.675 //y2=4.25
cc_1342 ( N_RN_c_1607_n N_noxref_8_c_2826_n ) capacitor c=0.00133521f \
 //x=21.945 //y=4.735 //x2=22.675 //y2=4.25
cc_1343 ( N_RN_c_1623_n N_noxref_8_c_2826_n ) capacitor c=0.00230614f \
 //x=19.205 //y=4.63 //x2=22.675 //y2=4.25
cc_1344 ( N_RN_c_1518_n N_noxref_8_c_2659_n ) capacitor c=0.0364873f //x=8.235 \
 //y=4.62 //x2=8.78 //y2=4.255
cc_1345 ( N_RN_c_1554_n N_noxref_8_c_2830_n ) capacitor c=0.0032463f \
 //x=18.245 //y=4.725 //x2=18.21 //y2=5.56
cc_1346 ( N_RN_c_1565_n N_noxref_8_c_2830_n ) capacitor c=0.00624059f \
 //x=18.25 //y=4.88 //x2=18.21 //y2=5.56
cc_1347 ( N_RN_M40_noxref_g N_noxref_8_c_2830_n ) capacitor c=0.0178885f \
 //x=17.99 //y=6.2 //x2=18.21 //y2=5.56
cc_1348 ( N_RN_M41_noxref_g N_noxref_8_c_2830_n ) capacitor c=0.0188608f \
 //x=18.43 //y=6.2 //x2=18.21 //y2=5.56
cc_1349 ( N_RN_c_1578_n N_noxref_8_c_2830_n ) capacitor c=0.00375636f \
 //x=18.25 //y=4.88 //x2=18.21 //y2=5.56
cc_1350 ( N_RN_c_1571_n N_noxref_8_M11_noxref_d ) capacitor c=0.00137165f \
 //x=18.24 //y=1.095 //x2=18.315 //y2=1.095
cc_1351 ( N_RN_c_1572_n N_noxref_8_M11_noxref_d ) capacitor c=0.00237422f \
 //x=18.24 //y=1.44 //x2=18.315 //y2=1.095
cc_1352 ( N_RN_c_1718_p N_noxref_8_M11_noxref_d ) capacitor c=0.0020782f \
 //x=18.615 //y=0.94 //x2=18.315 //y2=1.095
cc_1353 ( N_RN_c_1719_p N_noxref_8_M11_noxref_d ) capacitor c=0.00356097f \
 //x=18.615 //y=1.595 //x2=18.315 //y2=1.095
cc_1354 ( N_RN_c_1720_p N_noxref_8_M11_noxref_d ) capacitor c=0.00139206f \
 //x=18.77 //y=1.095 //x2=18.315 //y2=1.095
cc_1355 ( N_RN_c_1721_p N_noxref_8_M11_noxref_d ) capacitor c=0.00237422f \
 //x=18.77 //y=1.44 //x2=18.315 //y2=1.095
cc_1356 ( N_RN_c_1601_n N_noxref_9_c_3091_n ) capacitor c=0.0116288f //x=21.95 \
 //y=2.375 //x2=23.06 //y2=2.375
cc_1357 ( N_RN_c_1638_n N_noxref_9_c_3091_n ) capacitor c=5.39999e-19 \
 //x=21.95 //y=2.26 //x2=23.06 //y2=2.375
cc_1358 ( N_RN_c_1668_n N_noxref_9_c_3091_n ) capacitor c=0.00141236f \
 //x=22.04 //y=2.095 //x2=23.06 //y2=2.375
cc_1359 ( RN N_noxref_9_c_3087_n ) capacitor c=0.0378166f //x=21.95 //y=3.14 \
 //x2=23.06 //y2=3.725
cc_1360 ( N_RN_c_1638_n N_noxref_9_c_3087_n ) capacitor c=4.16726e-19 \
 //x=21.95 //y=2.26 //x2=23.06 //y2=3.725
cc_1361 ( RN N_noxref_9_c_3096_n ) capacitor c=0.00775314f //x=21.95 //y=3.14 \
 //x2=23.06 //y2=4.045
cc_1362 ( RN N_noxref_9_c_3088_n ) capacitor c=0.0123879f //x=21.95 //y=3.14 \
 //x2=23.06 //y2=4.75
cc_1363 ( N_RN_c_1607_n N_noxref_9_c_3088_n ) capacitor c=0.0123766f \
 //x=21.945 //y=4.735 //x2=23.06 //y2=4.75
cc_1364 ( N_RN_c_1623_n N_noxref_9_c_3088_n ) capacitor c=0.00721716f \
 //x=19.205 //y=4.63 //x2=23.06 //y2=4.75
cc_1365 ( N_RN_c_1642_n N_noxref_9_c_3088_n ) capacitor c=4.56604e-19 \
 //x=21.95 //y=4.88 //x2=23.06 //y2=4.75
cc_1366 ( RN N_noxref_9_c_3089_n ) capacitor c=2.64916e-19 //x=21.95 //y=3.14 \
 //x2=23.06 //y2=3.88
cc_1367 ( RN N_noxref_9_c_3090_n ) capacitor c=0.00323501f //x=21.95 //y=3.14 \
 //x2=23.22 //y2=3.885
cc_1368 ( RN N_noxref_9_c_3103_n ) capacitor c=4.16726e-19 //x=21.95 //y=3.14 \
 //x2=23.06 //y2=2.26
cc_1369 ( N_RN_c_1601_n N_noxref_9_c_3103_n ) capacitor c=5.42289e-19 \
 //x=21.95 //y=2.375 //x2=23.06 //y2=2.26
cc_1370 ( N_RN_c_1638_n N_noxref_9_c_3103_n ) capacitor c=0.00125213f \
 //x=21.95 //y=2.26 //x2=23.06 //y2=2.26
cc_1371 ( N_RN_c_1668_n N_noxref_9_c_3103_n ) capacitor c=0.00209664f \
 //x=22.04 //y=2.095 //x2=23.06 //y2=2.26
cc_1372 ( N_RN_c_1607_n N_noxref_9_c_3107_n ) capacitor c=9.59226e-19 \
 //x=21.945 //y=4.735 //x2=23.06 //y2=4.88
cc_1373 ( N_RN_c_1642_n N_noxref_9_c_3107_n ) capacitor c=0.00113671f \
 //x=21.95 //y=4.88 //x2=23.06 //y2=4.88
cc_1374 ( N_RN_c_1674_n N_noxref_9_c_3107_n ) capacitor c=9.77556e-19 \
 //x=21.95 //y=4.88 //x2=23.06 //y2=4.88
cc_1375 ( N_RN_M44_noxref_g N_noxref_9_M46_noxref_g ) capacitor c=0.0101598f \
 //x=21.92 //y=6.2 //x2=22.8 //y2=6.2
cc_1376 ( N_RN_M45_noxref_g N_noxref_9_M46_noxref_g ) capacitor c=0.0607518f \
 //x=22.36 //y=6.2 //x2=22.8 //y2=6.2
cc_1377 ( N_RN_M45_noxref_g N_noxref_9_M47_noxref_g ) capacitor c=0.0101598f \
 //x=22.36 //y=6.2 //x2=23.24 //y2=6.2
cc_1378 ( N_RN_c_1665_n N_noxref_9_c_3113_n ) capacitor c=0.00456962f \
 //x=22.04 //y=1.09 //x2=23.05 //y2=1.095
cc_1379 ( N_RN_c_1666_n N_noxref_9_c_3114_n ) capacitor c=0.00438372f \
 //x=22.04 //y=1.4 //x2=23.05 //y2=1.44
cc_1380 ( N_RN_c_1667_n N_noxref_9_c_3115_n ) capacitor c=0.00438372f \
 //x=22.04 //y=1.63 //x2=23.05 //y2=1.75
cc_1381 ( N_RN_c_1601_n N_noxref_9_c_3116_n ) capacitor c=0.00139071f \
 //x=21.95 //y=2.375 //x2=23.06 //y2=2.26
cc_1382 ( N_RN_c_1638_n N_noxref_9_c_3116_n ) capacitor c=0.00204868f \
 //x=21.95 //y=2.26 //x2=23.06 //y2=2.26
cc_1383 ( N_RN_c_1668_n N_noxref_9_c_3116_n ) capacitor c=0.00933826f \
 //x=22.04 //y=2.095 //x2=23.06 //y2=2.26
cc_1384 ( N_RN_c_1668_n N_noxref_9_c_3119_n ) capacitor c=0.00438372f \
 //x=22.04 //y=2.095 //x2=23.06 //y2=2.095
cc_1385 ( N_RN_c_1607_n N_noxref_9_c_3120_n ) capacitor c=0.00135133f \
 //x=21.945 //y=4.735 //x2=23.06 //y2=4.88
cc_1386 ( N_RN_c_1642_n N_noxref_9_c_3120_n ) capacitor c=0.00186974f \
 //x=21.95 //y=4.88 //x2=23.06 //y2=4.88
cc_1387 ( N_RN_c_1691_p N_noxref_9_c_3120_n ) capacitor c=0.0616777f \
 //x=22.285 //y=4.97 //x2=23.06 //y2=4.88
cc_1388 ( N_RN_c_1674_n N_noxref_9_c_3120_n ) capacitor c=0.0042693f //x=21.95 \
 //y=4.88 //x2=23.06 //y2=4.88
cc_1389 ( N_RN_M20_noxref_g N_VDD_c_3395_n ) capacitor c=0.00705252f //x=2.68 \
 //y=6.2 //x2=3.255 //y2=7.585
cc_1390 ( N_RN_M21_noxref_g N_VDD_c_3395_n ) capacitor c=0.00755544f //x=3.12 \
 //y=6.2 //x2=3.255 //y2=7.585
cc_1391 ( N_RN_M40_noxref_g N_VDD_c_3566_n ) capacitor c=0.00755544f //x=17.99 \
 //y=6.2 //x2=18.565 //y2=7.585
cc_1392 ( N_RN_M41_noxref_g N_VDD_c_3566_n ) capacitor c=0.00755754f //x=18.43 \
 //y=6.2 //x2=18.565 //y2=7.585
cc_1393 ( N_RN_M44_noxref_g N_VDD_c_3568_n ) capacitor c=0.00705252f //x=21.92 \
 //y=6.2 //x2=22.495 //y2=7.585
cc_1394 ( N_RN_M45_noxref_g N_VDD_c_3568_n ) capacitor c=0.00755544f //x=22.36 \
 //y=6.2 //x2=22.495 //y2=7.585
cc_1395 ( N_RN_c_1518_n N_VDD_c_3408_n ) capacitor c=0.025353f //x=8.235 \
 //y=4.62 //x2=5.3 //y2=7.585
cc_1396 ( N_RN_c_1524_n N_VDD_c_3414_n ) capacitor c=0.0265657f //x=18.86 \
 //y=4.63 //x2=10.11 //y2=7.585
cc_1397 ( N_RN_c_1524_n N_VDD_c_3470_n ) capacitor c=0.0265917f //x=18.86 \
 //y=4.63 //x2=14.92 //y2=7.585
cc_1398 ( N_RN_c_1623_n N_VDD_c_3539_n ) capacitor c=0.0263134f //x=19.205 \
 //y=4.63 //x2=19.73 //y2=7.585
cc_1399 ( N_RN_c_1565_n N_VDD_c_3539_n ) capacitor c=0.0022444f //x=18.25 \
 //y=4.88 //x2=19.73 //y2=7.585
cc_1400 ( N_RN_c_1578_n N_VDD_c_3539_n ) capacitor c=2.63786e-19 //x=18.25 \
 //y=4.88 //x2=19.73 //y2=7.585
cc_1401 ( N_RN_M20_noxref_g N_VDD_M19_noxref_d ) capacitor c=0.015318f \
 //x=2.68 //y=6.2 //x2=2.315 //y2=5.2
cc_1402 ( N_RN_M21_noxref_g N_VDD_M21_noxref_d ) capacitor c=0.015318f \
 //x=3.12 //y=6.2 //x2=3.195 //y2=5.2
cc_1403 ( N_RN_c_1518_n N_VDD_M24_noxref_s ) capacitor c=8.25867e-19 //x=8.235 \
 //y=4.62 //x2=6.255 //y2=5.2
cc_1404 ( N_RN_c_1524_n N_VDD_M30_noxref_s ) capacitor c=8.25867e-19 //x=18.86 \
 //y=4.63 //x2=11.065 //y2=5.2
cc_1405 ( N_RN_c_1524_n N_VDD_M36_noxref_s ) capacitor c=8.25867e-19 //x=18.86 \
 //y=4.63 //x2=15.875 //y2=5.2
cc_1406 ( N_RN_M40_noxref_g N_VDD_M39_noxref_d ) capacitor c=0.015318f \
 //x=17.99 //y=6.2 //x2=17.625 //y2=5.2
cc_1407 ( N_RN_M41_noxref_g N_VDD_M41_noxref_d ) capacitor c=0.0394719f \
 //x=18.43 //y=6.2 //x2=18.505 //y2=5.2
cc_1408 ( N_RN_c_1623_n N_VDD_M42_noxref_s ) capacitor c=7.08158e-19 \
 //x=19.205 //y=4.63 //x2=20.685 //y2=5.2
cc_1409 ( N_RN_M44_noxref_g N_VDD_M43_noxref_d ) capacitor c=0.015318f \
 //x=21.92 //y=6.2 //x2=21.555 //y2=5.2
cc_1410 ( N_RN_M45_noxref_g N_VDD_M45_noxref_d ) capacitor c=0.015318f \
 //x=22.36 //y=6.2 //x2=22.435 //y2=5.2
cc_1411 ( RN D ) capacitor c=0.0668419f //x=2.71 //y=2.77 //x2=1.6 //y2=2.77
cc_1412 ( N_RN_c_1515_n D ) capacitor c=0.00640843f //x=2.71 //y=4.635 \
 //x2=1.6 //y2=2.77
cc_1413 ( N_RN_c_1525_n D ) capacitor c=0.00471992f //x=2.87 //y=4.635 \
 //x2=1.6 //y2=2.77
cc_1414 ( N_RN_c_1631_n D ) capacitor c=4.16726e-19 //x=2.71 //y=2.26 //x2=1.6 \
 //y2=2.77
cc_1415 ( N_RN_c_1527_n D ) capacitor c=3.27346e-19 //x=2.71 //y=4.88 //x2=1.6 \
 //y2=2.77
cc_1416 ( N_RN_c_1598_n N_D_c_3798_n ) capacitor c=0.0115546f //x=2.71 \
 //y=2.375 //x2=1.6 //y2=2.375
cc_1417 ( N_RN_c_1631_n N_D_c_3798_n ) capacitor c=0.00375644f //x=2.71 \
 //y=2.26 //x2=1.6 //y2=2.375
cc_1418 ( N_RN_c_1655_n N_D_c_3798_n ) capacitor c=0.00140534f //x=2.8 \
 //y=2.095 //x2=1.6 //y2=2.375
cc_1419 ( N_RN_c_1515_n N_D_c_3801_n ) capacitor c=0.00948513f //x=2.71 \
 //y=4.635 //x2=1.6 //y2=4.755
cc_1420 ( N_RN_c_1525_n N_D_c_3801_n ) capacitor c=9.20501e-19 //x=2.87 \
 //y=4.635 //x2=1.6 //y2=4.755
cc_1421 ( N_RN_c_1527_n N_D_c_3801_n ) capacitor c=0.00376946f //x=2.71 \
 //y=4.88 //x2=1.6 //y2=4.755
cc_1422 ( N_RN_c_1537_n N_D_c_3801_n ) capacitor c=0.00115562f //x=2.71 \
 //y=4.88 //x2=1.6 //y2=4.755
cc_1423 ( RN N_D_c_3805_n ) capacitor c=4.16726e-19 //x=2.71 //y=2.77 //x2=1.6 \
 //y2=2.26
cc_1424 ( N_RN_c_1598_n N_D_c_3805_n ) capacitor c=5.40058e-19 //x=2.71 \
 //y=2.375 //x2=1.6 //y2=2.26
cc_1425 ( N_RN_c_1631_n N_D_c_3805_n ) capacitor c=0.00125213f //x=2.71 \
 //y=2.26 //x2=1.6 //y2=2.26
cc_1426 ( N_RN_c_1655_n N_D_c_3805_n ) capacitor c=0.0020754f //x=2.8 \
 //y=2.095 //x2=1.6 //y2=2.26
cc_1427 ( N_RN_c_1515_n N_D_c_3809_n ) capacitor c=6.06681e-19 //x=2.71 \
 //y=4.635 //x2=1.6 //y2=4.88
cc_1428 ( N_RN_c_1527_n N_D_c_3809_n ) capacitor c=0.00113668f //x=2.71 \
 //y=4.88 //x2=1.6 //y2=4.88
cc_1429 ( N_RN_c_1537_n N_D_c_3809_n ) capacitor c=0.00141726f //x=2.71 \
 //y=4.88 //x2=1.6 //y2=4.88
cc_1430 ( N_RN_M20_noxref_g N_D_M18_noxref_g ) capacitor c=0.0106276f //x=2.68 \
 //y=6.2 //x2=1.8 //y2=6.2
cc_1431 ( N_RN_M20_noxref_g N_D_M19_noxref_g ) capacitor c=0.107144f //x=2.68 \
 //y=6.2 //x2=2.24 //y2=6.2
cc_1432 ( N_RN_M21_noxref_g N_D_M19_noxref_g ) capacitor c=0.0101598f //x=3.12 \
 //y=6.2 //x2=2.24 //y2=6.2
cc_1433 ( N_RN_c_1851_p N_D_c_3815_n ) capacitor c=5.72528e-19 //x=2.275 \
 //y=1.09 //x2=1.3 //y2=1.055
cc_1434 ( N_RN_c_1851_p N_D_c_3816_n ) capacitor c=0.00150277f //x=2.275 \
 //y=1.09 //x2=1.3 //y2=1.4
cc_1435 ( N_RN_c_1853_p N_D_c_3817_n ) capacitor c=0.00111227f //x=2.275 \
 //y=1.4 //x2=1.3 //y2=1.71
cc_1436 ( N_RN_c_1598_n N_D_c_3818_n ) capacitor c=0.00147006f //x=2.71 \
 //y=2.375 //x2=1.3 //y2=2.095
cc_1437 ( N_RN_c_1631_n N_D_c_3818_n ) capacitor c=0.00214573f //x=2.71 \
 //y=2.26 //x2=1.3 //y2=2.095
cc_1438 ( N_RN_c_1655_n N_D_c_3818_n ) capacitor c=0.00964411f //x=2.8 \
 //y=2.095 //x2=1.3 //y2=2.095
cc_1439 ( N_RN_c_1851_p N_D_c_3821_n ) capacitor c=0.0160123f //x=2.275 \
 //y=1.09 //x2=1.83 //y2=1.055
cc_1440 ( N_RN_c_1652_n N_D_c_3821_n ) capacitor c=9.19165e-19 //x=2.8 \
 //y=1.09 //x2=1.83 //y2=1.055
cc_1441 ( N_RN_c_1853_p N_D_c_3823_n ) capacitor c=0.0124075f //x=2.275 \
 //y=1.4 //x2=1.83 //y2=1.4
cc_1442 ( N_RN_c_1653_n N_D_c_3823_n ) capacitor c=0.0010154f //x=2.8 //y=1.4 \
 //x2=1.83 //y2=1.4
cc_1443 ( N_RN_c_1654_n N_D_c_3823_n ) capacitor c=9.23422e-19 //x=2.8 \
 //y=1.63 //x2=1.83 //y2=1.4
cc_1444 ( N_RN_c_1515_n N_D_c_3789_n ) capacitor c=7.66769e-19 //x=2.71 \
 //y=4.635 //x2=2.165 //y2=4.97
cc_1445 ( N_RN_c_1527_n N_D_c_3789_n ) capacitor c=0.00116563f //x=2.71 \
 //y=4.88 //x2=2.165 //y2=4.97
cc_1446 ( N_RN_c_1537_n N_D_c_3789_n ) capacitor c=0.0171374f //x=2.71 \
 //y=4.88 //x2=2.165 //y2=4.97
cc_1447 ( N_RN_c_1515_n N_D_c_3829_n ) capacitor c=9.65382e-19 //x=2.71 \
 //y=4.635 //x2=1.875 //y2=4.97
cc_1448 ( N_RN_c_1527_n N_D_c_3829_n ) capacitor c=0.0012974f //x=2.71 \
 //y=4.88 //x2=1.875 //y2=4.97
cc_1449 ( N_RN_c_1537_n N_D_c_3829_n ) capacitor c=0.00439725f //x=2.71 \
 //y=4.88 //x2=1.875 //y2=4.97
cc_1450 ( N_RN_c_1652_n N_noxref_12_c_3901_n ) capacitor c=0.00123426f //x=2.8 \
 //y=1.09 //x2=3.505 //y2=1.175
cc_1451 ( N_RN_c_1653_n N_noxref_12_c_3901_n ) capacitor c=0.0129288f //x=2.8 \
 //y=1.4 //x2=3.505 //y2=1.175
cc_1452 ( N_RN_c_1654_n N_noxref_12_c_3901_n ) capacitor c=0.00132209f //x=2.8 \
 //y=1.63 //x2=3.505 //y2=1.175
cc_1453 ( N_RN_c_1598_n N_noxref_12_M1_noxref_d ) capacitor c=0.00610736f \
 //x=2.71 //y=2.375 //x2=2.35 //y2=1.09
cc_1454 ( N_RN_c_1631_n N_noxref_12_M1_noxref_d ) capacitor c=2.2052e-19 \
 //x=2.71 //y=2.26 //x2=2.35 //y2=1.09
cc_1455 ( N_RN_c_1851_p N_noxref_12_M1_noxref_d ) capacitor c=0.00253592f \
 //x=2.275 //y=1.09 //x2=2.35 //y2=1.09
cc_1456 ( N_RN_c_1853_p N_noxref_12_M1_noxref_d ) capacitor c=0.00604634f \
 //x=2.275 //y=1.4 //x2=2.35 //y2=1.09
cc_1457 ( N_RN_c_1875_p N_noxref_12_M1_noxref_d ) capacitor c=0.002686f \
 //x=2.645 //y=0.935 //x2=2.35 //y2=1.09
cc_1458 ( N_RN_c_1876_p N_noxref_12_M1_noxref_d ) capacitor c=0.00251995f \
 //x=2.645 //y=1.555 //x2=2.35 //y2=1.09
cc_1459 ( N_RN_c_1652_n N_noxref_12_M1_noxref_d ) capacitor c=0.00314523f \
 //x=2.8 //y=1.09 //x2=2.35 //y2=1.09
cc_1460 ( N_RN_c_1653_n N_noxref_12_M1_noxref_d ) capacitor c=0.00168289f \
 //x=2.8 //y=1.4 //x2=2.35 //y2=1.09
cc_1461 ( N_RN_c_1654_n N_noxref_12_M1_noxref_d ) capacitor c=0.00111165f \
 //x=2.8 //y=1.63 //x2=2.35 //y2=1.09
cc_1462 ( N_RN_c_1652_n N_noxref_12_M2_noxref_s ) capacitor c=7.21316e-19 \
 //x=2.8 //y=1.09 //x2=3.455 //y2=0.555
cc_1463 ( N_RN_c_1653_n N_noxref_12_M2_noxref_s ) capacitor c=0.00365271f \
 //x=2.8 //y=1.4 //x2=3.455 //y2=0.555
cc_1464 ( N_RN_c_1655_n N_noxref_12_M2_noxref_s ) capacitor c=9.86711e-19 \
 //x=2.8 //y=2.095 //x2=3.455 //y2=0.555
cc_1465 ( N_RN_c_1524_n N_noxref_15_c_4097_n ) capacitor c=0.00322787f \
 //x=18.86 //y=4.63 //x2=13.44 //y2=4.365
cc_1466 ( N_RN_c_1524_n N_noxref_15_c_4088_n ) capacitor c=0.0282232f \
 //x=18.86 //y=4.63 //x2=13.44 //y2=4.75
cc_1467 ( N_RN_c_1551_n N_noxref_16_c_4227_n ) capacitor c=0.00177186f \
 //x=18.25 //y=2.375 //x2=18.905 //y2=0.72
cc_1468 ( N_RN_c_1561_n N_noxref_16_c_4227_n ) capacitor c=0.00117306f \
 //x=18.25 //y=2.26 //x2=18.905 //y2=0.72
cc_1469 ( N_RN_c_1571_n N_noxref_16_c_4227_n ) capacitor c=0.0206349f \
 //x=18.24 //y=1.095 //x2=18.905 //y2=0.72
cc_1470 ( N_RN_c_1720_p N_noxref_16_c_4227_n ) capacitor c=0.00825432f \
 //x=18.77 //y=1.095 //x2=18.905 //y2=0.72
cc_1471 ( N_RN_c_1574_n N_noxref_16_c_4227_n ) capacitor c=2.20712e-19 \
 //x=18.25 //y=2.26 //x2=18.905 //y2=0.72
cc_1472 ( N_RN_c_1572_n N_noxref_16_c_4232_n ) capacitor c=0.0071177f \
 //x=18.24 //y=1.44 //x2=18.02 //y2=1.175
cc_1473 ( N_RN_c_1571_n N_noxref_16_M11_noxref_s ) capacitor c=0.0071177f \
 //x=18.24 //y=1.095 //x2=17.885 //y2=0.555
cc_1474 ( N_RN_c_1573_n N_noxref_16_M11_noxref_s ) capacitor c=0.0071177f \
 //x=18.24 //y=1.75 //x2=17.885 //y2=0.555
cc_1475 ( N_RN_c_1720_p N_noxref_16_M11_noxref_s ) capacitor c=0.015333f \
 //x=18.77 //y=1.095 //x2=17.885 //y2=0.555
cc_1476 ( N_RN_c_1721_p N_noxref_16_M11_noxref_s ) capacitor c=0.00248746f \
 //x=18.77 //y=1.44 //x2=17.885 //y2=0.555
cc_1477 ( N_RN_c_1665_n N_noxref_17_c_4281_n ) capacitor c=0.00123426f \
 //x=22.04 //y=1.09 //x2=22.745 //y2=1.175
cc_1478 ( N_RN_c_1666_n N_noxref_17_c_4281_n ) capacitor c=0.0129288f \
 //x=22.04 //y=1.4 //x2=22.745 //y2=1.175
cc_1479 ( N_RN_c_1667_n N_noxref_17_c_4281_n ) capacitor c=0.00132209f \
 //x=22.04 //y=1.63 //x2=22.745 //y2=1.175
cc_1480 ( N_RN_c_1601_n N_noxref_17_M13_noxref_d ) capacitor c=0.00604066f \
 //x=21.95 //y=2.375 //x2=21.59 //y2=1.09
cc_1481 ( N_RN_c_1638_n N_noxref_17_M13_noxref_d ) capacitor c=2.2052e-19 \
 //x=21.95 //y=2.26 //x2=21.59 //y2=1.09
cc_1482 ( N_RN_c_1660_n N_noxref_17_M13_noxref_d ) capacitor c=0.00253592f \
 //x=21.515 //y=1.09 //x2=21.59 //y2=1.09
cc_1483 ( N_RN_c_1663_n N_noxref_17_M13_noxref_d ) capacitor c=0.00604087f \
 //x=21.515 //y=1.4 //x2=21.59 //y2=1.09
cc_1484 ( N_RN_c_1902_p N_noxref_17_M13_noxref_d ) capacitor c=0.002686f \
 //x=21.885 //y=0.935 //x2=21.59 //y2=1.09
cc_1485 ( N_RN_c_1903_p N_noxref_17_M13_noxref_d ) capacitor c=0.00251995f \
 //x=21.885 //y=1.555 //x2=21.59 //y2=1.09
cc_1486 ( N_RN_c_1665_n N_noxref_17_M13_noxref_d ) capacitor c=0.00314523f \
 //x=22.04 //y=1.09 //x2=21.59 //y2=1.09
cc_1487 ( N_RN_c_1666_n N_noxref_17_M13_noxref_d ) capacitor c=0.00168289f \
 //x=22.04 //y=1.4 //x2=21.59 //y2=1.09
cc_1488 ( N_RN_c_1667_n N_noxref_17_M13_noxref_d ) capacitor c=0.00111165f \
 //x=22.04 //y=1.63 //x2=21.59 //y2=1.09
cc_1489 ( N_RN_c_1665_n N_noxref_17_M14_noxref_s ) capacitor c=7.21316e-19 \
 //x=22.04 //y=1.09 //x2=22.695 //y2=0.555
cc_1490 ( N_RN_c_1666_n N_noxref_17_M14_noxref_s ) capacitor c=0.00365271f \
 //x=22.04 //y=1.4 //x2=22.695 //y2=0.555
cc_1491 ( N_RN_c_1668_n N_noxref_17_M14_noxref_s ) capacitor c=9.86711e-19 \
 //x=22.04 //y=2.095 //x2=22.695 //y2=0.555
cc_1492 ( N_RN_c_1598_n N_GND_c_4351_n ) capacitor c=9.16602e-19 //x=2.71 \
 //y=2.375 //x2=6.29 //y2=0.175
cc_1493 ( N_RN_c_1551_n N_GND_c_4454_n ) capacitor c=0.0021992f //x=18.25 \
 //y=2.375 //x2=20.72 //y2=0.175
cc_1494 ( N_RN_c_1601_n N_GND_c_4497_n ) capacitor c=9.16602e-19 //x=21.95 \
 //y=2.375 //x2=25.53 //y2=0.175
cc_1495 ( N_RN_c_1551_n N_GND_c_4436_n ) capacitor c=2.016e-19 //x=18.25 \
 //y=2.375 //x2=19.56 //y2=0.175
cc_1496 ( N_RN_c_1561_n N_GND_c_4482_n ) capacitor c=0.00246191f //x=18.25 \
 //y=2.26 //x2=19.73 //y2=0.175
cc_1497 ( N_RN_c_1721_p N_GND_c_4482_n ) capacitor c=0.00262688f //x=18.77 \
 //y=1.44 //x2=19.73 //y2=0.175
cc_1498 ( N_RN_c_1851_p N_noxref_20_c_4899_n ) capacitor c=0.0167228f \
 //x=2.275 //y=1.09 //x2=2.935 //y2=0.72
cc_1499 ( N_RN_c_1652_n N_noxref_20_c_4899_n ) capacitor c=0.00534519f //x=2.8 \
 //y=1.09 //x2=2.935 //y2=0.72
cc_1500 ( N_RN_c_1598_n N_noxref_20_c_4901_n ) capacitor c=0.0048147f //x=2.71 \
 //y=2.375 //x2=2.935 //y2=1.77
cc_1501 ( N_RN_c_1515_n N_noxref_20_c_4901_n ) capacitor c=9.95678e-19 \
 //x=2.71 //y=4.635 //x2=2.935 //y2=1.77
cc_1502 ( N_RN_c_1631_n N_noxref_20_c_4901_n ) capacitor c=0.0105652f //x=2.71 \
 //y=2.26 //x2=2.935 //y2=1.77
cc_1503 ( N_RN_c_1853_p N_noxref_20_c_4901_n ) capacitor c=0.0153476f \
 //x=2.275 //y=1.4 //x2=2.935 //y2=1.77
cc_1504 ( N_RN_c_1655_n N_noxref_20_c_4901_n ) capacitor c=0.0205285f //x=2.8 \
 //y=2.095 //x2=2.935 //y2=1.77
cc_1505 ( N_RN_c_1851_p N_noxref_20_M0_noxref_s ) capacitor c=0.00798959f \
 //x=2.275 //y=1.09 //x2=0.945 //y2=0.555
cc_1506 ( N_RN_c_1654_n N_noxref_20_M0_noxref_s ) capacitor c=0.00212176f \
 //x=2.8 //y=1.63 //x2=0.945 //y2=0.555
cc_1507 ( N_RN_c_1655_n N_noxref_20_M0_noxref_s ) capacitor c=0.00298115f \
 //x=2.8 //y=2.095 //x2=0.945 //y2=0.555
cc_1508 ( N_RN_c_1660_n N_noxref_24_c_5144_n ) capacitor c=0.0167228f \
 //x=21.515 //y=1.09 //x2=22.175 //y2=0.72
cc_1509 ( N_RN_c_1665_n N_noxref_24_c_5144_n ) capacitor c=0.00534519f \
 //x=22.04 //y=1.09 //x2=22.175 //y2=0.72
cc_1510 ( N_RN_c_1601_n N_noxref_24_c_5146_n ) capacitor c=0.0048147f \
 //x=21.95 //y=2.375 //x2=22.175 //y2=1.77
cc_1511 ( N_RN_c_1607_n N_noxref_24_c_5146_n ) capacitor c=8.94838e-19 \
 //x=21.945 //y=4.735 //x2=22.175 //y2=1.77
cc_1512 ( N_RN_c_1638_n N_noxref_24_c_5146_n ) capacitor c=0.0105652f \
 //x=21.95 //y=2.26 //x2=22.175 //y2=1.77
cc_1513 ( N_RN_c_1663_n N_noxref_24_c_5146_n ) capacitor c=0.0153476f \
 //x=21.515 //y=1.4 //x2=22.175 //y2=1.77
cc_1514 ( N_RN_c_1668_n N_noxref_24_c_5146_n ) capacitor c=0.0200931f \
 //x=22.04 //y=2.095 //x2=22.175 //y2=1.77
cc_1515 ( N_RN_c_1660_n N_noxref_24_M12_noxref_s ) capacitor c=0.00798959f \
 //x=21.515 //y=1.09 //x2=20.185 //y2=0.555
cc_1516 ( N_RN_c_1667_n N_noxref_24_M12_noxref_s ) capacitor c=0.00212176f \
 //x=22.04 //y=1.63 //x2=20.185 //y2=0.555
cc_1517 ( N_RN_c_1668_n N_noxref_24_M12_noxref_s ) capacitor c=0.00298115f \
 //x=22.04 //y=2.095 //x2=20.185 //y2=0.555
cc_1518 ( N_QN_c_1962_p N_SN_c_2327_n ) capacitor c=0.0115546f //x=25.65 \
 //y=2.375 //x2=26.76 //y2=2.375
cc_1519 ( N_QN_c_1963_p N_SN_c_2327_n ) capacitor c=5.40058e-19 //x=25.65 \
 //y=2.26 //x2=26.76 //y2=2.375
cc_1520 ( N_QN_c_1964_p N_SN_c_2327_n ) capacitor c=0.00147006f //x=25.35 \
 //y=2.095 //x2=26.76 //y2=2.375
cc_1521 ( QN N_SN_c_2330_n ) capacitor c=5.20978e-19 //x=23.8 //y=2.4 \
 //x2=26.76 //y2=2.61
cc_1522 ( QN N_SN_c_2330_n ) capacitor c=0.00652526f //x=25.65 //y=2.4 \
 //x2=26.76 //y2=2.61
cc_1523 ( N_QN_c_1963_p N_SN_c_2330_n ) capacitor c=4.16726e-19 //x=25.65 \
 //y=2.26 //x2=26.76 //y2=2.61
cc_1524 ( QN N_SN_c_2333_n ) capacitor c=0.00772613f //x=25.65 //y=2.4 \
 //x2=26.76 //y2=2.93
cc_1525 ( QN N_SN_c_2334_n ) capacitor c=2.81102e-19 //x=23.8 //y=2.4 \
 //x2=26.76 //y2=4.765
cc_1526 ( QN N_SN_c_2334_n ) capacitor c=0.00126969f //x=23.8 //y=4.62 \
 //x2=26.76 //y2=4.765
cc_1527 ( QN N_SN_c_2334_n ) capacitor c=0.0138513f //x=25.65 //y=2.4 \
 //x2=26.76 //y2=4.765
cc_1528 ( QN N_SN_c_2334_n ) capacitor c=0.0263686f //x=25.65 //y=4.62 \
 //x2=26.76 //y2=4.765
cc_1529 ( QN N_SN_c_2334_n ) capacitor c=2.90818e-19 //x=25.65 //y=3.51 \
 //x2=26.76 //y2=4.765
cc_1530 ( N_QN_c_1974_p N_SN_c_2334_n ) capacitor c=0.00775314f //x=25.65 \
 //y=3.67 //x2=26.76 //y2=4.765
cc_1531 ( N_QN_c_1975_p N_SN_c_2334_n ) capacitor c=0.0114531f //x=25.65 \
 //y=4.755 //x2=26.76 //y2=4.765
cc_1532 ( N_QN_c_1976_p N_SN_c_2334_n ) capacitor c=0.00508571f //x=25.65 \
 //y=3.51 //x2=26.76 //y2=4.765
cc_1533 ( N_QN_c_1977_p N_SN_c_2334_n ) capacitor c=6.26008e-19 //x=25.65 \
 //y=4.88 //x2=26.76 //y2=4.765
cc_1534 ( N_QN_c_1978_p N_SN_c_2334_n ) capacitor c=7.66769e-19 //x=26.215 \
 //y=4.97 //x2=26.76 //y2=4.765
cc_1535 ( N_QN_c_1979_p N_SN_c_2334_n ) capacitor c=7.54501e-19 //x=25.925 \
 //y=4.97 //x2=26.76 //y2=4.765
cc_1536 ( QN N_SN_c_2345_n ) capacitor c=2.98299e-19 //x=25.65 //y=2.4 \
 //x2=26.76 //y2=2.77
cc_1537 ( QN N_SN_c_2283_n ) capacitor c=0.0307261f //x=23.8 //y=2.4 \
 //x2=16.245 //y2=2.755
cc_1538 ( QN N_SN_c_2283_n ) capacitor c=0.0327263f //x=25.65 //y=2.4 \
 //x2=16.245 //y2=2.755
cc_1539 ( N_QN_c_1983_p N_SN_c_2283_n ) capacitor c=5.3144e-19 //x=23.315 \
 //y=1.305 //x2=16.245 //y2=2.755
cc_1540 ( N_QN_c_1984_p N_SN_c_2283_n ) capacitor c=0.0140973f //x=23.4 \
 //y=1.845 //x2=16.245 //y2=2.755
cc_1541 ( N_QN_c_1985_p N_SN_c_2283_n ) capacitor c=0.00504956f //x=23.8 \
 //y=3.675 //x2=16.245 //y2=2.755
cc_1542 ( N_QN_c_1962_p N_SN_c_2283_n ) capacitor c=0.00281235f //x=25.65 \
 //y=2.375 //x2=16.245 //y2=2.755
cc_1543 ( N_QN_c_1974_p N_SN_c_2283_n ) capacitor c=0.00419712f //x=25.65 \
 //y=3.67 //x2=16.245 //y2=2.755
cc_1544 ( N_QN_c_1988_p N_SN_c_2283_n ) capacitor c=0.0710432f //x=25.49 \
 //y=3.51 //x2=16.245 //y2=2.755
cc_1545 ( N_QN_c_1989_p N_SN_c_2283_n ) capacitor c=0.0155728f //x=23.96 \
 //y=3.515 //x2=16.245 //y2=2.755
cc_1546 ( N_QN_c_1976_p N_SN_c_2283_n ) capacitor c=0.0157335f //x=25.65 \
 //y=3.51 //x2=16.245 //y2=2.755
cc_1547 ( QN N_SN_c_2356_n ) capacitor c=4.16726e-19 //x=25.65 //y=2.4 \
 //x2=26.76 //y2=2.26
cc_1548 ( N_QN_c_1962_p N_SN_c_2356_n ) capacitor c=5.39999e-19 //x=25.65 \
 //y=2.375 //x2=26.76 //y2=2.26
cc_1549 ( N_QN_c_1963_p N_SN_c_2356_n ) capacitor c=0.00125213f //x=25.65 \
 //y=2.26 //x2=26.76 //y2=2.26
cc_1550 ( N_QN_c_1964_p N_SN_c_2356_n ) capacitor c=0.00214573f //x=25.35 \
 //y=2.095 //x2=26.76 //y2=2.26
cc_1551 ( QN N_SN_c_2360_n ) capacitor c=3.30718e-19 //x=25.65 //y=4.62 \
 //x2=26.76 //y2=4.88
cc_1552 ( N_QN_c_1975_p N_SN_c_2360_n ) capacitor c=7.03272e-19 //x=25.65 \
 //y=4.755 //x2=26.76 //y2=4.88
cc_1553 ( N_QN_c_1977_p N_SN_c_2360_n ) capacitor c=0.00113984f //x=25.65 \
 //y=4.88 //x2=26.76 //y2=4.88
cc_1554 ( N_QN_c_1978_p N_SN_c_2360_n ) capacitor c=0.00116563f //x=26.215 \
 //y=4.97 //x2=26.76 //y2=4.88
cc_1555 ( N_QN_c_1979_p N_SN_c_2360_n ) capacitor c=0.00129812f //x=25.925 \
 //y=4.97 //x2=26.76 //y2=4.88
cc_1556 ( N_QN_M48_noxref_g N_SN_M50_noxref_g ) capacitor c=0.0106276f \
 //x=25.85 //y=6.2 //x2=26.73 //y2=6.2
cc_1557 ( N_QN_M49_noxref_g N_SN_M50_noxref_g ) capacitor c=0.107144f \
 //x=26.29 //y=6.2 //x2=26.73 //y2=6.2
cc_1558 ( N_QN_M49_noxref_g N_SN_M51_noxref_g ) capacitor c=0.0101598f \
 //x=26.29 //y=6.2 //x2=27.17 //y2=6.2
cc_1559 ( N_QN_c_2003_p N_SN_c_2368_n ) capacitor c=5.72528e-19 //x=25.35 \
 //y=1.055 //x2=26.325 //y2=1.09
cc_1560 ( N_QN_c_2004_p N_SN_c_2368_n ) capacitor c=0.00150277f //x=25.35 \
 //y=1.4 //x2=26.325 //y2=1.09
cc_1561 ( N_QN_c_2005_p N_SN_c_2368_n ) capacitor c=0.0160123f //x=25.88 \
 //y=1.055 //x2=26.325 //y2=1.09
cc_1562 ( N_QN_c_2006_p N_SN_c_2371_n ) capacitor c=0.00111227f //x=25.35 \
 //y=1.71 //x2=26.325 //y2=1.4
cc_1563 ( N_QN_c_2007_p N_SN_c_2371_n ) capacitor c=0.0124075f //x=25.88 \
 //y=1.4 //x2=26.325 //y2=1.4
cc_1564 ( N_QN_c_2005_p N_SN_c_2373_n ) capacitor c=9.19165e-19 //x=25.88 \
 //y=1.055 //x2=26.85 //y2=1.09
cc_1565 ( N_QN_c_2007_p N_SN_c_2374_n ) capacitor c=0.0010154f //x=25.88 \
 //y=1.4 //x2=26.85 //y2=1.4
cc_1566 ( N_QN_c_2007_p N_SN_c_2375_n ) capacitor c=9.23422e-19 //x=25.88 \
 //y=1.4 //x2=26.85 //y2=1.63
cc_1567 ( N_QN_c_1962_p N_SN_c_2376_n ) capacitor c=0.00140534f //x=25.65 \
 //y=2.375 //x2=26.85 //y2=2.095
cc_1568 ( N_QN_c_1963_p N_SN_c_2376_n ) capacitor c=0.0020754f //x=25.65 \
 //y=2.26 //x2=26.85 //y2=2.095
cc_1569 ( N_QN_c_1964_p N_SN_c_2376_n ) capacitor c=0.00964411f //x=25.35 \
 //y=2.095 //x2=26.85 //y2=2.095
cc_1570 ( N_QN_c_1975_p N_SN_c_2379_n ) capacitor c=0.00116212f //x=25.65 \
 //y=4.755 //x2=26.76 //y2=4.88
cc_1571 ( N_QN_c_1977_p N_SN_c_2379_n ) capacitor c=0.00155973f //x=25.65 \
 //y=4.88 //x2=26.76 //y2=4.88
cc_1572 ( N_QN_c_1978_p N_SN_c_2379_n ) capacitor c=0.0171374f //x=26.215 \
 //y=4.97 //x2=26.76 //y2=4.88
cc_1573 ( N_QN_c_1979_p N_SN_c_2379_n ) capacitor c=0.00484466f //x=25.925 \
 //y=4.97 //x2=26.76 //y2=4.88
cc_1574 ( N_QN_c_1937_n N_noxref_8_c_2777_n ) capacitor c=6.09703e-19 \
 //x=21.262 //y=5.335 //x2=18.21 //y2=5.56
cc_1575 ( N_QN_c_1937_n N_noxref_8_c_2779_n ) capacitor c=0.00306432f \
 //x=21.262 //y=5.335 //x2=18.905 //y2=5.335
cc_1576 ( N_QN_c_1984_p N_noxref_8_c_2794_n ) capacitor c=0.00163399f //x=23.4 \
 //y=1.845 //x2=18.905 //y2=1.845
cc_1577 ( QN N_noxref_8_c_2844_n ) capacitor c=0.00154094f //x=25.65 //y=2.4 \
 //x2=27.87 //y2=4.085
cc_1578 ( QN N_noxref_8_c_2844_n ) capacitor c=4.52824e-19 //x=25.65 //y=4.62 \
 //x2=27.87 //y2=4.085
cc_1579 ( QN N_noxref_8_c_2846_n ) capacitor c=6.55491e-19 //x=25.65 //y=4.62 \
 //x2=27.87 //y2=4.75
cc_1580 ( N_QN_c_1950_n N_noxref_8_c_2826_n ) capacitor c=0.00396008f \
 //x=22.905 //y=5.335 //x2=22.675 //y2=4.25
cc_1581 ( N_QN_c_1952_n N_noxref_8_c_2826_n ) capacitor c=0.0236631f //x=22.14 \
 //y=5.335 //x2=22.675 //y2=4.25
cc_1582 ( QN N_noxref_8_c_2849_n ) capacitor c=0.0302838f //x=23.8 //y=4.62 \
 //x2=23.275 //y2=4.27
cc_1583 ( QN N_noxref_8_c_2849_n ) capacitor c=0.0286699f //x=25.65 //y=4.62 \
 //x2=23.275 //y2=4.27
cc_1584 ( N_QN_c_2028_p N_noxref_8_c_2849_n ) capacitor c=0.013915f //x=23.715 \
 //y=5.335 //x2=23.275 //y2=4.27
cc_1585 ( N_QN_c_1975_p N_noxref_8_c_2849_n ) capacitor c=0.00306028f \
 //x=25.65 //y=4.755 //x2=23.275 //y2=4.27
cc_1586 ( N_QN_c_2030_p N_noxref_8_c_2849_n ) capacitor c=0.00396008f \
 //x=23.02 //y=5.335 //x2=23.275 //y2=4.27
cc_1587 ( N_QN_c_1988_p N_noxref_8_c_2849_n ) capacitor c=0.00933081f \
 //x=25.49 //y=3.51 //x2=23.275 //y2=4.27
cc_1588 ( QN N_noxref_9_c_3091_n ) capacitor c=0.0154269f //x=23.8 //y=2.4 \
 //x2=23.06 //y2=2.375
cc_1589 ( QN N_noxref_9_c_3087_n ) capacitor c=0.0424252f //x=23.8 //y=2.4 \
 //x2=23.06 //y2=3.725
cc_1590 ( QN N_noxref_9_c_3087_n ) capacitor c=0.00225358f //x=23.8 //y=4.62 \
 //x2=23.06 //y2=3.725
cc_1591 ( QN N_noxref_9_c_3087_n ) capacitor c=0.00152432f //x=25.65 //y=2.4 \
 //x2=23.06 //y2=3.725
cc_1592 ( QN N_noxref_9_c_3087_n ) capacitor c=6.15181e-19 //x=23.8 //y=3.51 \
 //x2=23.06 //y2=3.725
cc_1593 ( N_QN_c_1985_p N_noxref_9_c_3087_n ) capacitor c=0.0148501f //x=23.8 \
 //y=3.675 //x2=23.06 //y2=3.725
cc_1594 ( N_QN_c_1989_p N_noxref_9_c_3087_n ) capacitor c=0.006875f //x=23.96 \
 //y=3.515 //x2=23.06 //y2=3.725
cc_1595 ( QN N_noxref_9_c_3096_n ) capacitor c=0.0172483f //x=23.8 //y=4.62 \
 //x2=23.06 //y2=4.045
cc_1596 ( N_QN_c_1950_n N_noxref_9_c_3096_n ) capacitor c=8.70869e-19 \
 //x=22.905 //y=5.335 //x2=23.06 //y2=4.045
cc_1597 ( N_QN_c_2028_p N_noxref_9_c_3096_n ) capacitor c=0.00136617f \
 //x=23.715 //y=5.335 //x2=23.06 //y2=4.045
cc_1598 ( N_QN_c_1983_p N_noxref_9_c_3096_n ) capacitor c=2.01448e-19 \
 //x=23.315 //y=1.305 //x2=23.06 //y2=4.045
cc_1599 ( N_QN_c_1984_p N_noxref_9_c_3096_n ) capacitor c=8.43174e-19 //x=23.4 \
 //y=1.845 //x2=23.06 //y2=4.045
cc_1600 ( QN N_noxref_9_c_3088_n ) capacitor c=0.0436333f //x=23.8 //y=4.62 \
 //x2=23.06 //y2=4.75
cc_1601 ( QN N_noxref_9_c_3088_n ) capacitor c=0.00143272f //x=25.65 //y=4.62 \
 //x2=23.06 //y2=4.75
cc_1602 ( N_QN_c_2028_p N_noxref_9_c_3088_n ) capacitor c=0.00234762f \
 //x=23.715 //y=5.335 //x2=23.06 //y2=4.75
cc_1603 ( N_QN_c_2030_p N_noxref_9_c_3088_n ) capacitor c=0.0224599f //x=23.02 \
 //y=5.335 //x2=23.06 //y2=4.75
cc_1604 ( N_QN_c_2048_p N_noxref_9_c_3088_n ) capacitor c=0.00217653f \
 //x=23.02 //y=5.56 //x2=23.06 //y2=4.75
cc_1605 ( N_QN_M49_noxref_g N_noxref_9_c_3141_n ) capacitor c=0.00973141f \
 //x=26.29 //y=6.2 //x2=26.83 //y2=5.335
cc_1606 ( N_QN_c_2050_p N_noxref_9_c_3142_n ) capacitor c=0.00163399f \
 //x=23.715 //y=1.845 //x2=28.21 //y2=1.845
cc_1607 ( QN N_noxref_9_c_3089_n ) capacitor c=6.15181e-19 //x=23.8 //y=4.62 \
 //x2=23.06 //y2=3.88
cc_1608 ( N_QN_c_2052_p N_noxref_9_c_3144_n ) capacitor c=6.09703e-19 \
 //x=23.02 //y=5.56 //x2=26.072 //y2=5.335
cc_1609 ( N_QN_c_2028_p N_noxref_9_c_3144_n ) capacitor c=0.00306432f \
 //x=23.715 //y=5.335 //x2=26.072 //y2=5.335
cc_1610 ( N_QN_M48_noxref_g N_noxref_9_c_3144_n ) capacitor c=0.00461408f \
 //x=25.85 //y=6.2 //x2=26.072 //y2=5.335
cc_1611 ( N_QN_M49_noxref_g N_noxref_9_c_3144_n ) capacitor c=0.00229208f \
 //x=26.29 //y=6.2 //x2=26.072 //y2=5.335
cc_1612 ( N_QN_c_1978_p N_noxref_9_c_3144_n ) capacitor c=0.00171885f \
 //x=26.215 //y=4.97 //x2=26.072 //y2=5.335
cc_1613 ( QN N_noxref_9_c_3149_n ) capacitor c=3.67658e-19 //x=23.8 //y=4.62 \
 //x2=23.415 //y2=3.88
cc_1614 ( N_QN_c_1985_p N_noxref_9_c_3149_n ) capacitor c=0.00137094f //x=23.8 \
 //y=3.675 //x2=23.415 //y2=3.88
cc_1615 ( N_QN_c_1989_p N_noxref_9_c_3149_n ) capacitor c=0.0358254f //x=23.96 \
 //y=3.515 //x2=23.415 //y2=3.88
cc_1616 ( QN N_noxref_9_c_3152_n ) capacitor c=0.0216171f //x=23.8 //y=4.62 \
 //x2=24.015 //y2=3.9
cc_1617 ( N_QN_c_1985_p N_noxref_9_c_3152_n ) capacitor c=0.00765069f //x=23.8 \
 //y=3.675 //x2=24.015 //y2=3.9
cc_1618 ( N_QN_c_1988_p N_noxref_9_c_3152_n ) capacitor c=0.127595f //x=25.49 \
 //y=3.51 //x2=24.015 //y2=3.9
cc_1619 ( QN N_noxref_9_c_3155_n ) capacitor c=5.02803e-19 //x=25.65 //y=4.62 \
 //x2=25.265 //y2=3.88
cc_1620 ( N_QN_c_1974_p N_noxref_9_c_3155_n ) capacitor c=0.00346032f \
 //x=25.65 //y=3.67 //x2=25.265 //y2=3.88
cc_1621 ( N_QN_c_1988_p N_noxref_9_c_3155_n ) capacitor c=0.010864f //x=25.49 \
 //y=3.51 //x2=25.265 //y2=3.88
cc_1622 ( N_QN_c_1976_p N_noxref_9_c_3155_n ) capacitor c=0.0358254f //x=25.65 \
 //y=3.51 //x2=25.265 //y2=3.88
cc_1623 ( QN N_noxref_9_c_3159_n ) capacitor c=0.0239278f //x=25.65 //y=4.62 \
 //x2=25.865 //y2=3.895
cc_1624 ( N_QN_c_1974_p N_noxref_9_c_3159_n ) capacitor c=0.00280784f \
 //x=25.65 //y=3.67 //x2=25.865 //y2=3.895
cc_1625 ( QN N_noxref_9_c_3090_n ) capacitor c=0.00300049f //x=23.8 //y=4.62 \
 //x2=23.22 //y2=3.885
cc_1626 ( QN N_noxref_9_c_3103_n ) capacitor c=0.00163444f //x=23.8 //y=2.4 \
 //x2=23.06 //y2=2.26
cc_1627 ( QN N_noxref_9_c_3107_n ) capacitor c=0.00131258f //x=23.8 //y=4.62 \
 //x2=23.06 //y2=4.88
cc_1628 ( N_QN_c_2028_p N_noxref_9_c_3107_n ) capacitor c=0.00130631f \
 //x=23.715 //y=5.335 //x2=23.06 //y2=4.88
cc_1629 ( N_QN_c_2030_p N_noxref_9_c_3107_n ) capacitor c=0.00346456f \
 //x=23.02 //y=5.335 //x2=23.06 //y2=4.88
cc_1630 ( N_QN_c_2048_p N_noxref_9_c_3107_n ) capacitor c=0.00552343f \
 //x=23.02 //y=5.56 //x2=23.06 //y2=4.88
cc_1631 ( N_QN_M48_noxref_g N_noxref_9_c_3167_n ) capacitor c=0.0162284f \
 //x=25.85 //y=6.2 //x2=26.07 //y2=5.56
cc_1632 ( N_QN_M49_noxref_g N_noxref_9_c_3167_n ) capacitor c=0.0179041f \
 //x=26.29 //y=6.2 //x2=26.07 //y2=5.56
cc_1633 ( N_QN_c_1978_p N_noxref_9_c_3167_n ) capacitor c=0.00291477f \
 //x=26.215 //y=4.97 //x2=26.07 //y2=5.56
cc_1634 ( N_QN_c_1950_n N_noxref_9_M46_noxref_g ) capacitor c=0.0103241f \
 //x=22.905 //y=5.335 //x2=22.8 //y2=6.2
cc_1635 ( N_QN_c_2052_p N_noxref_9_M46_noxref_g ) capacitor c=0.00226521f \
 //x=23.02 //y=5.56 //x2=22.8 //y2=6.2
cc_1636 ( N_QN_c_2048_p N_noxref_9_M46_noxref_g ) capacitor c=0.0178885f \
 //x=23.02 //y=5.56 //x2=22.8 //y2=6.2
cc_1637 ( N_QN_c_2052_p N_noxref_9_M47_noxref_g ) capacitor c=0.00381703f \
 //x=23.02 //y=5.56 //x2=23.24 //y2=6.2
cc_1638 ( N_QN_c_2028_p N_noxref_9_M47_noxref_g ) capacitor c=0.0110699f \
 //x=23.715 //y=5.335 //x2=23.24 //y2=6.2
cc_1639 ( N_QN_c_2048_p N_noxref_9_M47_noxref_g ) capacitor c=0.0188608f \
 //x=23.02 //y=5.56 //x2=23.24 //y2=6.2
cc_1640 ( N_QN_c_1983_p N_noxref_9_c_3113_n ) capacitor c=4.64015e-19 \
 //x=23.315 //y=1.305 //x2=23.05 //y2=1.095
cc_1641 ( N_QN_M14_noxref_d N_noxref_9_c_3113_n ) capacitor c=0.00137165f \
 //x=23.125 //y=1.095 //x2=23.05 //y2=1.095
cc_1642 ( N_QN_c_1983_p N_noxref_9_c_3114_n ) capacitor c=0.0026012f \
 //x=23.315 //y=1.305 //x2=23.05 //y2=1.44
cc_1643 ( N_QN_c_2087_p N_noxref_9_c_3114_n ) capacitor c=0.00127432f \
 //x=23.315 //y=1.76 //x2=23.05 //y2=1.44
cc_1644 ( N_QN_M14_noxref_d N_noxref_9_c_3114_n ) capacitor c=0.00237422f \
 //x=23.125 //y=1.095 //x2=23.05 //y2=1.44
cc_1645 ( N_QN_c_2087_p N_noxref_9_c_3115_n ) capacitor c=0.00429966f \
 //x=23.315 //y=1.76 //x2=23.05 //y2=1.75
cc_1646 ( N_QN_c_1983_p N_noxref_9_c_3182_n ) capacitor c=5.29969e-19 \
 //x=23.315 //y=1.305 //x2=23.425 //y2=0.94
cc_1647 ( N_QN_M14_noxref_d N_noxref_9_c_3182_n ) capacitor c=0.0020782f \
 //x=23.125 //y=1.095 //x2=23.425 //y2=0.94
cc_1648 ( N_QN_c_1983_p N_noxref_9_c_3184_n ) capacitor c=5.18116e-19 \
 //x=23.315 //y=1.305 //x2=23.425 //y2=1.595
cc_1649 ( N_QN_c_2087_p N_noxref_9_c_3184_n ) capacitor c=0.00942306f \
 //x=23.315 //y=1.76 //x2=23.425 //y2=1.595
cc_1650 ( N_QN_c_2050_p N_noxref_9_c_3184_n ) capacitor c=0.00194716f \
 //x=23.715 //y=1.845 //x2=23.425 //y2=1.595
cc_1651 ( N_QN_M14_noxref_d N_noxref_9_c_3184_n ) capacitor c=0.00356097f \
 //x=23.125 //y=1.095 //x2=23.425 //y2=1.595
cc_1652 ( N_QN_c_1983_p N_noxref_9_c_3188_n ) capacitor c=5.24634e-19 \
 //x=23.315 //y=1.305 //x2=23.58 //y2=1.095
cc_1653 ( N_QN_M14_noxref_d N_noxref_9_c_3188_n ) capacitor c=0.00139206f \
 //x=23.125 //y=1.095 //x2=23.58 //y2=1.095
cc_1654 ( N_QN_c_1983_p N_noxref_9_c_3190_n ) capacitor c=0.00307978f \
 //x=23.315 //y=1.305 //x2=23.58 //y2=1.44
cc_1655 ( N_QN_c_2087_p N_noxref_9_c_3190_n ) capacitor c=0.00363411f \
 //x=23.315 //y=1.76 //x2=23.58 //y2=1.44
cc_1656 ( N_QN_c_2050_p N_noxref_9_c_3190_n ) capacitor c=0.00323576f \
 //x=23.715 //y=1.845 //x2=23.58 //y2=1.44
cc_1657 ( N_QN_M14_noxref_d N_noxref_9_c_3190_n ) capacitor c=0.00237422f \
 //x=23.125 //y=1.095 //x2=23.58 //y2=1.44
cc_1658 ( QN N_noxref_9_c_3116_n ) capacitor c=0.0025845f //x=23.8 //y=2.4 \
 //x2=23.06 //y2=2.26
cc_1659 ( QN N_noxref_9_c_3119_n ) capacitor c=0.00282067f //x=23.8 //y=2.4 \
 //x2=23.06 //y2=2.095
cc_1660 ( N_QN_c_2087_p N_noxref_9_c_3119_n ) capacitor c=0.0036273f \
 //x=23.315 //y=1.76 //x2=23.06 //y2=2.095
cc_1661 ( QN N_noxref_9_c_3120_n ) capacitor c=0.00739875f //x=23.8 //y=4.62 \
 //x2=23.06 //y2=4.88
cc_1662 ( N_QN_c_2030_p N_noxref_9_c_3120_n ) capacitor c=0.00203307f \
 //x=23.02 //y=5.335 //x2=23.06 //y2=4.88
cc_1663 ( N_QN_c_2048_p N_noxref_9_c_3120_n ) capacitor c=0.00375636f \
 //x=23.02 //y=5.56 //x2=23.06 //y2=4.88
cc_1664 ( N_QN_c_1936_n N_VDD_c_3378_n ) capacitor c=0.00621352f //x=22.02 \
 //y=5.335 //x2=28.61 //y2=7.58
cc_1665 ( N_QN_c_1950_n N_VDD_c_3378_n ) capacitor c=0.00627191f //x=22.905 \
 //y=5.335 //x2=28.61 //y2=7.58
cc_1666 ( N_QN_c_2052_p N_VDD_c_3378_n ) capacitor c=0.00256019f //x=23.02 \
 //y=5.56 //x2=28.61 //y2=7.58
cc_1667 ( N_QN_c_2028_p N_VDD_c_3378_n ) capacitor c=0.00829247f //x=23.715 \
 //y=5.335 //x2=28.61 //y2=7.58
cc_1668 ( N_QN_c_1985_p N_VDD_c_3378_n ) capacitor c=4.58709e-19 //x=23.8 \
 //y=3.675 //x2=28.61 //y2=7.58
cc_1669 ( N_QN_c_1974_p N_VDD_c_3378_n ) capacitor c=3.889e-19 //x=25.65 \
 //y=3.67 //x2=28.61 //y2=7.58
cc_1670 ( N_QN_c_1937_n N_VDD_c_3378_n ) capacitor c=0.00261804f //x=21.262 \
 //y=5.335 //x2=28.61 //y2=7.58
cc_1671 ( N_QN_c_1952_n N_VDD_c_3378_n ) capacitor c=0.00270108f //x=22.14 \
 //y=5.335 //x2=28.61 //y2=7.58
cc_1672 ( N_QN_c_1940_n N_VDD_c_3378_n ) capacitor c=0.0024232f //x=21.26 \
 //y=5.56 //x2=28.61 //y2=7.58
cc_1673 ( N_QN_c_1958_n N_VDD_c_3378_n ) capacitor c=0.0024232f //x=22.14 \
 //y=5.56 //x2=28.61 //y2=7.58
cc_1674 ( N_QN_c_2048_p N_VDD_c_3378_n ) capacitor c=0.0024232f //x=23.02 \
 //y=5.56 //x2=28.61 //y2=7.58
cc_1675 ( N_QN_c_1936_n N_VDD_c_3529_n ) capacitor c=0.00202922f //x=22.02 \
 //y=5.335 //x2=21.615 //y2=7.585
cc_1676 ( N_QN_c_1937_n N_VDD_c_3529_n ) capacitor c=9.3757e-19 //x=21.262 \
 //y=5.335 //x2=21.615 //y2=7.585
cc_1677 ( N_QN_c_1940_n N_VDD_c_3529_n ) capacitor c=0.0138074f //x=21.26 \
 //y=5.56 //x2=21.615 //y2=7.585
cc_1678 ( N_QN_c_1936_n N_VDD_c_3568_n ) capacitor c=0.0017708f //x=22.02 \
 //y=5.335 //x2=22.495 //y2=7.585
cc_1679 ( N_QN_c_1950_n N_VDD_c_3568_n ) capacitor c=0.00202922f //x=22.905 \
 //y=5.335 //x2=22.495 //y2=7.585
cc_1680 ( N_QN_c_1952_n N_VDD_c_3568_n ) capacitor c=9.4822e-19 //x=22.14 \
 //y=5.335 //x2=22.495 //y2=7.585
cc_1681 ( N_QN_c_1958_n N_VDD_c_3568_n ) capacitor c=0.0138074f //x=22.14 \
 //y=5.56 //x2=22.495 //y2=7.585
cc_1682 ( N_QN_c_1950_n N_VDD_c_3604_n ) capacitor c=0.00205906f //x=22.905 \
 //y=5.335 //x2=23.375 //y2=7.585
cc_1683 ( N_QN_c_2052_p N_VDD_c_3604_n ) capacitor c=8.49654e-19 //x=23.02 \
 //y=5.56 //x2=23.375 //y2=7.585
cc_1684 ( N_QN_c_2028_p N_VDD_c_3604_n ) capacitor c=0.00204238f //x=23.715 \
 //y=5.335 //x2=23.375 //y2=7.585
cc_1685 ( N_QN_c_2048_p N_VDD_c_3604_n ) capacitor c=0.0135103f //x=23.02 \
 //y=5.56 //x2=23.375 //y2=7.585
cc_1686 ( N_QN_c_2028_p N_VDD_c_3608_n ) capacitor c=0.00183742f //x=23.715 \
 //y=5.335 //x2=24.37 //y2=7.585
cc_1687 ( N_QN_M48_noxref_g N_VDD_c_3609_n ) capacitor c=0.00755614f //x=25.85 \
 //y=6.2 //x2=26.425 //y2=7.585
cc_1688 ( N_QN_M49_noxref_g N_VDD_c_3609_n ) capacitor c=0.00755544f //x=26.29 \
 //y=6.2 //x2=26.425 //y2=7.585
cc_1689 ( N_QN_c_1937_n N_VDD_c_3539_n ) capacitor c=0.0022955f //x=21.262 \
 //y=5.335 //x2=19.73 //y2=7.585
cc_1690 ( N_QN_c_1940_n N_VDD_c_3539_n ) capacitor c=0.00509469f //x=21.26 \
 //y=5.56 //x2=19.73 //y2=7.585
cc_1691 ( QN N_VDD_c_3613_n ) capacitor c=0.0346476f //x=23.8 //y=4.62 \
 //x2=24.54 //y2=7.585
cc_1692 ( QN N_VDD_c_3613_n ) capacitor c=0.00935853f //x=25.65 //y=4.62 \
 //x2=24.54 //y2=7.585
cc_1693 ( N_QN_c_2052_p N_VDD_c_3613_n ) capacitor c=0.00282782f //x=23.02 \
 //y=5.56 //x2=24.54 //y2=7.585
cc_1694 ( N_QN_c_1975_p N_VDD_c_3613_n ) capacitor c=0.00419437f //x=25.65 \
 //y=4.755 //x2=24.54 //y2=7.585
cc_1695 ( N_QN_c_2048_p N_VDD_c_3613_n ) capacitor c=0.00777981f //x=23.02 \
 //y=5.56 //x2=24.54 //y2=7.585
cc_1696 ( N_QN_c_1977_p N_VDD_c_3613_n ) capacitor c=0.00370784f //x=25.65 \
 //y=4.88 //x2=24.54 //y2=7.585
cc_1697 ( N_QN_c_1979_p N_VDD_c_3613_n ) capacitor c=0.00590568f //x=25.925 \
 //y=4.97 //x2=24.54 //y2=7.585
cc_1698 ( N_QN_c_1937_n N_VDD_M42_noxref_s ) capacitor c=0.0442713f //x=21.262 \
 //y=5.335 //x2=20.685 //y2=5.2
cc_1699 ( N_QN_c_1952_n N_VDD_M42_noxref_s ) capacitor c=7.80122e-19 //x=22.14 \
 //y=5.335 //x2=20.685 //y2=5.2
cc_1700 ( N_QN_c_1940_n N_VDD_M42_noxref_s ) capacitor c=0.09305f //x=21.26 \
 //y=5.56 //x2=20.685 //y2=5.2
cc_1701 ( N_QN_c_1936_n N_VDD_M43_noxref_d ) capacitor c=0.00700141f //x=22.02 \
 //y=5.335 //x2=21.555 //y2=5.2
cc_1702 ( N_QN_c_1940_n N_VDD_M43_noxref_d ) capacitor c=0.0674491f //x=21.26 \
 //y=5.56 //x2=21.555 //y2=5.2
cc_1703 ( N_QN_c_1958_n N_VDD_M43_noxref_d ) capacitor c=0.0674762f //x=22.14 \
 //y=5.56 //x2=21.555 //y2=5.2
cc_1704 ( N_QN_c_1950_n N_VDD_M45_noxref_d ) capacitor c=0.00700141f \
 //x=22.905 //y=5.335 //x2=22.435 //y2=5.2
cc_1705 ( N_QN_c_1958_n N_VDD_M45_noxref_d ) capacitor c=0.067493f //x=22.14 \
 //y=5.56 //x2=22.435 //y2=5.2
cc_1706 ( N_QN_c_2048_p N_VDD_M45_noxref_d ) capacitor c=0.0674979f //x=23.02 \
 //y=5.56 //x2=22.435 //y2=5.2
cc_1707 ( N_QN_c_2028_p N_VDD_M47_noxref_d ) capacitor c=0.00700141f \
 //x=23.715 //y=5.335 //x2=23.315 //y2=5.2
cc_1708 ( N_QN_c_2048_p N_VDD_M47_noxref_d ) capacitor c=0.0675002f //x=23.02 \
 //y=5.56 //x2=23.315 //y2=5.2
cc_1709 ( N_QN_c_2052_p N_VDD_M48_noxref_s ) capacitor c=0.00492616f //x=23.02 \
 //y=5.56 //x2=25.495 //y2=5.2
cc_1710 ( N_QN_c_2028_p N_VDD_M48_noxref_s ) capacitor c=9.42705e-19 \
 //x=23.715 //y=5.335 //x2=25.495 //y2=5.2
cc_1711 ( N_QN_c_1974_p N_VDD_M48_noxref_s ) capacitor c=6.19689e-19 //x=25.65 \
 //y=3.67 //x2=25.495 //y2=5.2
cc_1712 ( N_QN_c_1975_p N_VDD_M48_noxref_s ) capacitor c=0.0224586f //x=25.65 \
 //y=4.755 //x2=25.495 //y2=5.2
cc_1713 ( N_QN_c_1952_n N_VDD_M48_noxref_s ) capacitor c=2.11884e-19 //x=22.14 \
 //y=5.335 //x2=25.495 //y2=5.2
cc_1714 ( N_QN_c_1977_p N_VDD_M48_noxref_s ) capacitor c=0.00983413f //x=25.65 \
 //y=4.88 //x2=25.495 //y2=5.2
cc_1715 ( N_QN_M48_noxref_g N_VDD_M48_noxref_s ) capacitor c=0.053419f \
 //x=25.85 //y=6.2 //x2=25.495 //y2=5.2
cc_1716 ( N_QN_c_1979_p N_VDD_M48_noxref_s ) capacitor c=0.00606273f \
 //x=25.925 //y=4.97 //x2=25.495 //y2=5.2
cc_1717 ( N_QN_M49_noxref_g N_VDD_M49_noxref_d ) capacitor c=0.015318f \
 //x=26.29 //y=6.2 //x2=26.365 //y2=5.2
cc_1718 ( N_QN_c_1983_p N_noxref_17_c_4296_n ) capacitor c=0.0036878f \
 //x=23.315 //y=1.305 //x2=23.715 //y2=0.72
cc_1719 ( N_QN_c_2050_p N_noxref_17_c_4296_n ) capacitor c=0.00399931f \
 //x=23.715 //y=1.845 //x2=23.715 //y2=0.72
cc_1720 ( N_QN_M14_noxref_d N_noxref_17_c_4296_n ) capacitor c=0.00910163f \
 //x=23.125 //y=1.095 //x2=23.715 //y2=0.72
cc_1721 ( N_QN_M14_noxref_d N_noxref_17_c_4299_n ) capacitor c=0.00120711f \
 //x=23.125 //y=1.095 //x2=22.83 //y2=1.175
cc_1722 ( N_QN_c_1936_n N_noxref_17_M13_noxref_d ) capacitor c=0.00144281f \
 //x=22.02 //y=5.335 //x2=21.59 //y2=1.09
cc_1723 ( N_QN_c_1983_p N_noxref_17_M13_noxref_d ) capacitor c=0.00802417f \
 //x=23.315 //y=1.305 //x2=21.59 //y2=1.09
cc_1724 ( QN N_noxref_17_M14_noxref_s ) capacitor c=0.0016218f //x=23.8 \
 //y=3.51 //x2=22.695 //y2=0.555
cc_1725 ( N_QN_c_1983_p N_noxref_17_M14_noxref_s ) capacitor c=0.0098487f \
 //x=23.315 //y=1.305 //x2=22.695 //y2=0.555
cc_1726 ( N_QN_c_2087_p N_noxref_17_M14_noxref_s ) capacitor c=0.0283243f \
 //x=23.315 //y=1.76 //x2=22.695 //y2=0.555
cc_1727 ( N_QN_c_2050_p N_noxref_17_M14_noxref_s ) capacitor c=0.00871957f \
 //x=23.715 //y=1.845 //x2=22.695 //y2=0.555
cc_1728 ( N_QN_M14_noxref_d N_noxref_17_M14_noxref_s ) capacitor c=0.0279003f \
 //x=23.125 //y=1.095 //x2=22.695 //y2=0.555
cc_1729 ( N_QN_c_1983_p N_GND_c_4497_n ) capacitor c=0.00901861f //x=23.315 \
 //y=1.305 //x2=25.53 //y2=0.175
cc_1730 ( N_QN_c_2050_p N_GND_c_4497_n ) capacitor c=0.00713708f //x=23.715 \
 //y=1.845 //x2=25.53 //y2=0.175
cc_1731 ( N_QN_c_1985_p N_GND_c_4497_n ) capacitor c=4.99243e-19 //x=23.8 \
 //y=3.675 //x2=25.53 //y2=0.175
cc_1732 ( N_QN_M14_noxref_d N_GND_c_4497_n ) capacitor c=2.9462e-19 //x=23.125 \
 //y=1.095 //x2=25.53 //y2=0.175
cc_1733 ( N_QN_c_2003_p N_GND_c_4505_n ) capacitor c=3.97665e-19 //x=25.35 \
 //y=1.055 //x2=25.615 //y2=1.015
cc_1734 ( N_QN_c_2178_p N_GND_c_4505_n ) capacitor c=0.00864776f //x=25.725 \
 //y=0.9 //x2=25.615 //y2=1.015
cc_1735 ( N_QN_c_2005_p N_GND_c_4505_n ) capacitor c=4.45447e-19 //x=25.88 \
 //y=1.055 //x2=25.615 //y2=1.015
cc_1736 ( N_QN_c_1983_p N_GND_c_4508_n ) capacitor c=0.00543195f //x=23.315 \
 //y=1.305 //x2=25.615 //y2=1.145
cc_1737 ( N_QN_c_1962_p N_GND_c_4508_n ) capacitor c=0.00799365f //x=25.65 \
 //y=2.375 //x2=25.615 //y2=1.145
cc_1738 ( N_QN_c_1974_p N_GND_c_4508_n ) capacitor c=7.85953e-19 //x=25.65 \
 //y=3.67 //x2=25.615 //y2=1.145
cc_1739 ( N_QN_c_1963_p N_GND_c_4508_n ) capacitor c=2.22883e-19 //x=25.65 \
 //y=2.26 //x2=25.615 //y2=1.145
cc_1740 ( N_QN_c_2003_p N_GND_c_4508_n ) capacitor c=0.00156339f //x=25.35 \
 //y=1.055 //x2=25.615 //y2=1.145
cc_1741 ( N_QN_c_2004_p N_GND_c_4508_n ) capacitor c=0.00352472f //x=25.35 \
 //y=1.4 //x2=25.615 //y2=1.145
cc_1742 ( N_QN_c_2006_p N_GND_c_4508_n ) capacitor c=4.27379e-19 //x=25.35 \
 //y=1.71 //x2=25.615 //y2=1.145
cc_1743 ( N_QN_c_2178_p N_GND_c_4508_n ) capacitor c=7.3749e-19 //x=25.725 \
 //y=0.9 //x2=25.615 //y2=1.145
cc_1744 ( N_QN_c_2188_p N_GND_c_4508_n ) capacitor c=5.79272e-19 //x=25.725 \
 //y=1.555 //x2=25.615 //y2=1.145
cc_1745 ( N_QN_c_2005_p N_GND_c_4508_n ) capacitor c=0.00158223f //x=25.88 \
 //y=1.055 //x2=25.615 //y2=1.145
cc_1746 ( N_QN_c_2007_p N_GND_c_4508_n ) capacitor c=0.00276804f //x=25.88 \
 //y=1.4 //x2=25.615 //y2=1.145
cc_1747 ( N_QN_c_2050_p N_GND_c_4476_n ) capacitor c=6.86343e-19 //x=23.715 \
 //y=1.845 //x2=24.37 //y2=0.175
cc_1748 ( N_QN_c_1985_p N_GND_c_4476_n ) capacitor c=4.02106e-19 //x=23.8 \
 //y=3.675 //x2=24.37 //y2=0.175
cc_1749 ( N_QN_c_2003_p N_GND_c_4521_n ) capacitor c=0.00681781f //x=25.35 \
 //y=1.055 //x2=28.61 //y2=0.18
cc_1750 ( QN N_GND_c_4522_n ) capacitor c=0.00821778f //x=25.65 //y=2.4 \
 //x2=24.54 //y2=0.175
cc_1751 ( N_QN_c_2087_p N_GND_c_4522_n ) capacitor c=0.0045138f //x=23.315 \
 //y=1.76 //x2=24.54 //y2=0.175
cc_1752 ( N_QN_c_2050_p N_GND_c_4522_n ) capacitor c=0.0318268f //x=23.715 \
 //y=1.845 //x2=24.54 //y2=0.175
cc_1753 ( N_QN_c_1962_p N_GND_c_4522_n ) capacitor c=0.00407472f //x=25.65 \
 //y=2.375 //x2=24.54 //y2=0.175
cc_1754 ( N_QN_c_1988_p N_GND_c_4522_n ) capacitor c=0.00341388f //x=25.49 \
 //y=3.51 //x2=24.54 //y2=0.175
cc_1755 ( N_QN_c_1963_p N_GND_c_4522_n ) capacitor c=0.00394651f //x=25.65 \
 //y=2.26 //x2=24.54 //y2=0.175
cc_1756 ( N_QN_c_2006_p N_GND_c_4522_n ) capacitor c=0.00170145f //x=25.35 \
 //y=1.71 //x2=24.54 //y2=0.175
cc_1757 ( N_QN_c_1964_p N_GND_c_4522_n ) capacitor c=0.0103608f //x=25.35 \
 //y=2.095 //x2=24.54 //y2=0.175
cc_1758 ( N_QN_c_1962_p N_GND_M15_noxref_d ) capacitor c=4.4417e-19 //x=25.65 \
 //y=2.375 //x2=25.425 //y2=1.055
cc_1759 ( N_QN_c_2003_p N_GND_M15_noxref_d ) capacitor c=0.00184354f //x=25.35 \
 //y=1.055 //x2=25.425 //y2=1.055
cc_1760 ( N_QN_c_2004_p N_GND_M15_noxref_d ) capacitor c=0.00210798f //x=25.35 \
 //y=1.4 //x2=25.425 //y2=1.055
cc_1761 ( N_QN_c_2178_p N_GND_M15_noxref_d ) capacitor c=0.00474029f \
 //x=25.725 //y=0.9 //x2=25.425 //y2=1.055
cc_1762 ( N_QN_c_2188_p N_GND_M15_noxref_d ) capacitor c=0.00166857f \
 //x=25.725 //y=1.555 //x2=25.425 //y2=1.055
cc_1763 ( N_QN_c_2005_p N_GND_M15_noxref_d ) capacitor c=0.00230174f //x=25.88 \
 //y=1.055 //x2=25.425 //y2=1.055
cc_1764 ( N_QN_c_2007_p N_GND_M15_noxref_d ) capacitor c=0.00210798f //x=25.88 \
 //y=1.4 //x2=25.425 //y2=1.055
cc_1765 ( N_QN_c_1983_p N_noxref_19_M16_noxref_d ) capacitor c=3.20746e-19 \
 //x=23.315 //y=1.305 //x2=26.4 //y2=1.09
cc_1766 ( N_QN_c_1964_p N_noxref_25_c_5190_n ) capacitor c=0.00262672f \
 //x=25.35 //y=2.095 //x2=25.13 //y2=1.685
cc_1767 ( N_QN_c_1962_p N_noxref_25_c_5191_n ) capacitor c=0.00411069f \
 //x=25.65 //y=2.375 //x2=26.015 //y2=1.77
cc_1768 ( N_QN_c_1974_p N_noxref_25_c_5191_n ) capacitor c=0.00258412f \
 //x=25.65 //y=3.67 //x2=26.015 //y2=1.77
cc_1769 ( N_QN_c_1963_p N_noxref_25_c_5191_n ) capacitor c=0.0104666f \
 //x=25.65 //y=2.26 //x2=26.015 //y2=1.77
cc_1770 ( N_QN_c_2006_p N_noxref_25_c_5191_n ) capacitor c=0.00705077f \
 //x=25.35 //y=1.71 //x2=26.015 //y2=1.77
cc_1771 ( N_QN_c_1964_p N_noxref_25_c_5191_n ) capacitor c=0.0213095f \
 //x=25.35 //y=2.095 //x2=26.015 //y2=1.77
cc_1772 ( N_QN_c_2188_p N_noxref_25_c_5191_n ) capacitor c=0.00588627f \
 //x=25.725 //y=1.555 //x2=26.015 //y2=1.77
cc_1773 ( N_QN_c_2007_p N_noxref_25_c_5191_n ) capacitor c=0.00698822f \
 //x=25.88 //y=1.4 //x2=26.015 //y2=1.77
cc_1774 ( N_QN_c_2003_p N_noxref_25_M15_noxref_s ) capacitor c=0.0295256f \
 //x=25.35 //y=1.055 //x2=24.995 //y2=0.555
cc_1775 ( N_QN_c_2006_p N_noxref_25_M15_noxref_s ) capacitor c=7.99997e-19 \
 //x=25.35 //y=1.71 //x2=24.995 //y2=0.555
cc_1776 ( N_QN_c_1964_p N_noxref_25_M15_noxref_s ) capacitor c=0.00122123f \
 //x=25.35 //y=2.095 //x2=24.995 //y2=0.555
cc_1777 ( N_QN_c_2005_p N_noxref_25_M15_noxref_s ) capacitor c=0.0125924f \
 //x=25.88 //y=1.055 //x2=24.995 //y2=0.555
cc_1778 ( N_SN_c_2283_n N_noxref_8_c_2783_n ) capacitor c=5.29143e-19 \
 //x=16.245 //y=2.755 //x2=18.505 //y2=1.305
cc_1779 ( N_SN_c_2283_n N_noxref_8_c_2607_n ) capacitor c=0.0145117f \
 //x=16.245 //y=2.755 //x2=18.59 //y2=1.845
cc_1780 ( N_SN_c_2283_n N_noxref_8_c_2639_n ) capacitor c=0.0326371f \
 //x=16.245 //y=2.755 //x2=18.99 //y2=4.085
cc_1781 ( N_SN_c_2327_n N_noxref_8_c_2858_n ) capacitor c=0.0116288f //x=26.76 \
 //y=2.375 //x2=27.87 //y2=2.375
cc_1782 ( N_SN_c_2356_n N_noxref_8_c_2858_n ) capacitor c=5.39999e-19 \
 //x=26.76 //y=2.26 //x2=27.87 //y2=2.375
cc_1783 ( N_SN_c_2376_n N_noxref_8_c_2858_n ) capacitor c=0.00141236f \
 //x=26.85 //y=2.095 //x2=27.87 //y2=2.375
cc_1784 ( N_SN_c_2330_n N_noxref_8_c_2844_n ) capacitor c=0.00605135f \
 //x=26.76 //y=2.61 //x2=27.87 //y2=4.085
cc_1785 ( N_SN_c_2333_n N_noxref_8_c_2844_n ) capacitor c=0.00775314f \
 //x=26.76 //y=2.93 //x2=27.87 //y2=4.085
cc_1786 ( N_SN_c_2334_n N_noxref_8_c_2844_n ) capacitor c=0.0331433f //x=26.76 \
 //y=4.765 //x2=27.87 //y2=4.085
cc_1787 ( N_SN_c_2345_n N_noxref_8_c_2844_n ) capacitor c=2.99286e-19 \
 //x=26.76 //y=2.77 //x2=27.87 //y2=4.085
cc_1788 ( N_SN_c_2283_n N_noxref_8_c_2844_n ) capacitor c=0.00508119f \
 //x=16.245 //y=2.755 //x2=27.87 //y2=4.085
cc_1789 ( N_SN_c_2356_n N_noxref_8_c_2844_n ) capacitor c=4.16726e-19 \
 //x=26.76 //y=2.26 //x2=27.87 //y2=4.085
cc_1790 ( N_SN_c_2334_n N_noxref_8_c_2867_n ) capacitor c=0.00772613f \
 //x=26.76 //y=4.765 //x2=27.87 //y2=4.405
cc_1791 ( N_SN_c_2334_n N_noxref_8_c_2846_n ) capacitor c=0.020621f //x=26.76 \
 //y=4.765 //x2=27.87 //y2=4.75
cc_1792 ( N_SN_c_2360_n N_noxref_8_c_2846_n ) capacitor c=9.52396e-19 \
 //x=26.76 //y=4.88 //x2=27.87 //y2=4.75
cc_1793 ( N_SN_c_2379_n N_noxref_8_c_2846_n ) capacitor c=8.42568e-19 \
 //x=26.76 //y=4.88 //x2=27.87 //y2=4.75
cc_1794 ( N_SN_c_2334_n N_noxref_8_c_2871_n ) capacitor c=2.70456e-19 \
 //x=26.76 //y=4.765 //x2=27.87 //y2=4.25
cc_1795 ( N_SN_c_2283_n N_noxref_8_c_2723_n ) capacitor c=0.0422133f \
 //x=16.245 //y=2.755 //x2=21.05 //y2=4.265
cc_1796 ( N_SN_c_2228_n N_noxref_8_c_2605_n ) capacitor c=0.0229123f //x=12.33 \
 //y=4.765 //x2=20.705 //y2=4.265
cc_1797 ( N_SN_c_2283_n N_noxref_8_c_2605_n ) capacitor c=0.0144525f \
 //x=16.245 //y=2.755 //x2=20.705 //y2=4.265
cc_1798 ( N_SN_c_2283_n N_noxref_8_c_2826_n ) capacitor c=0.00548999f \
 //x=16.245 //y=2.755 //x2=22.675 //y2=4.25
cc_1799 ( N_SN_c_2334_n N_noxref_8_c_2849_n ) capacitor c=0.0321454f //x=26.76 \
 //y=4.765 //x2=23.275 //y2=4.27
cc_1800 ( N_SN_c_2283_n N_noxref_8_c_2849_n ) capacitor c=0.00340497f \
 //x=16.245 //y=2.755 //x2=23.275 //y2=4.27
cc_1801 ( N_SN_c_2327_n N_noxref_8_c_2878_n ) capacitor c=5.42289e-19 \
 //x=26.76 //y=2.375 //x2=27.87 //y2=2.26
cc_1802 ( N_SN_c_2330_n N_noxref_8_c_2878_n ) capacitor c=4.16726e-19 \
 //x=26.76 //y=2.61 //x2=27.87 //y2=2.26
cc_1803 ( N_SN_c_2356_n N_noxref_8_c_2878_n ) capacitor c=0.00125213f \
 //x=26.76 //y=2.26 //x2=27.87 //y2=2.26
cc_1804 ( N_SN_c_2376_n N_noxref_8_c_2878_n ) capacitor c=0.00209664f \
 //x=26.85 //y=2.095 //x2=27.87 //y2=2.26
cc_1805 ( N_SN_c_2334_n N_noxref_8_c_2882_n ) capacitor c=7.51101e-19 \
 //x=26.76 //y=4.765 //x2=27.87 //y2=4.88
cc_1806 ( N_SN_c_2360_n N_noxref_8_c_2882_n ) capacitor c=0.00113985f \
 //x=26.76 //y=4.88 //x2=27.87 //y2=4.88
cc_1807 ( N_SN_c_2379_n N_noxref_8_c_2882_n ) capacitor c=0.00129812f \
 //x=26.76 //y=4.88 //x2=27.87 //y2=4.88
cc_1808 ( N_SN_M50_noxref_g N_noxref_8_M52_noxref_g ) capacitor c=0.0101598f \
 //x=26.73 //y=6.2 //x2=27.61 //y2=6.2
cc_1809 ( N_SN_M51_noxref_g N_noxref_8_M52_noxref_g ) capacitor c=0.0607518f \
 //x=27.17 //y=6.2 //x2=27.61 //y2=6.2
cc_1810 ( N_SN_M51_noxref_g N_noxref_8_M53_noxref_g ) capacitor c=0.0101598f \
 //x=27.17 //y=6.2 //x2=28.05 //y2=6.2
cc_1811 ( N_SN_c_2373_n N_noxref_8_c_2888_n ) capacitor c=0.00456962f \
 //x=26.85 //y=1.09 //x2=27.86 //y2=1.095
cc_1812 ( N_SN_c_2374_n N_noxref_8_c_2889_n ) capacitor c=0.00438372f \
 //x=26.85 //y=1.4 //x2=27.86 //y2=1.44
cc_1813 ( N_SN_c_2375_n N_noxref_8_c_2890_n ) capacitor c=0.00438372f \
 //x=26.85 //y=1.63 //x2=27.86 //y2=1.75
cc_1814 ( N_SN_c_2327_n N_noxref_8_c_2891_n ) capacitor c=0.00139071f \
 //x=26.76 //y=2.375 //x2=27.87 //y2=2.26
cc_1815 ( N_SN_c_2356_n N_noxref_8_c_2891_n ) capacitor c=0.00204868f \
 //x=26.76 //y=2.26 //x2=27.87 //y2=2.26
cc_1816 ( N_SN_c_2376_n N_noxref_8_c_2891_n ) capacitor c=0.00933826f \
 //x=26.85 //y=2.095 //x2=27.87 //y2=2.26
cc_1817 ( N_SN_c_2376_n N_noxref_8_c_2894_n ) capacitor c=0.00438372f \
 //x=26.85 //y=2.095 //x2=27.87 //y2=2.095
cc_1818 ( N_SN_c_2334_n N_noxref_8_c_2895_n ) capacitor c=0.00124604f \
 //x=26.76 //y=4.765 //x2=27.87 //y2=4.88
cc_1819 ( N_SN_c_2360_n N_noxref_8_c_2895_n ) capacitor c=0.00187046f \
 //x=26.76 //y=4.88 //x2=27.87 //y2=4.88
cc_1820 ( N_SN_c_2425_p N_noxref_8_c_2895_n ) capacitor c=0.0616777f \
 //x=27.095 //y=4.97 //x2=27.87 //y2=4.88
cc_1821 ( N_SN_c_2379_n N_noxref_8_c_2895_n ) capacitor c=0.00487508f \
 //x=26.76 //y=4.88 //x2=27.87 //y2=4.88
cc_1822 ( N_SN_c_2283_n N_noxref_9_c_3091_n ) capacitor c=0.00310514f \
 //x=16.245 //y=2.755 //x2=23.06 //y2=2.375
cc_1823 ( N_SN_c_2283_n N_noxref_9_c_3087_n ) capacitor c=0.0299788f \
 //x=16.245 //y=2.755 //x2=23.06 //y2=3.725
cc_1824 ( N_SN_c_2283_n N_noxref_9_c_3096_n ) capacitor c=0.00274091f \
 //x=16.245 //y=2.755 //x2=23.06 //y2=4.045
cc_1825 ( N_SN_c_2333_n N_noxref_9_c_3141_n ) capacitor c=0.00112327f \
 //x=26.76 //y=2.93 //x2=26.83 //y2=5.335
cc_1826 ( N_SN_c_2334_n N_noxref_9_c_3141_n ) capacitor c=0.0218571f //x=26.76 \
 //y=4.765 //x2=26.83 //y2=5.335
cc_1827 ( N_SN_c_2360_n N_noxref_9_c_3141_n ) capacitor c=0.00492634f \
 //x=26.76 //y=4.88 //x2=26.83 //y2=5.335
cc_1828 ( N_SN_M50_noxref_g N_noxref_9_c_3141_n ) capacitor c=0.00858241f \
 //x=26.73 //y=6.2 //x2=26.83 //y2=5.335
cc_1829 ( N_SN_c_2379_n N_noxref_9_c_3141_n ) capacitor c=6.02516e-19 \
 //x=26.76 //y=4.88 //x2=26.83 //y2=5.335
cc_1830 ( N_SN_M51_noxref_g N_noxref_9_c_3208_n ) capacitor c=0.0103546f \
 //x=27.17 //y=6.2 //x2=27.715 //y2=5.335
cc_1831 ( N_SN_c_2330_n N_noxref_9_c_3209_n ) capacitor c=5.84382e-19 \
 //x=26.76 //y=2.61 //x2=28.61 //y2=3.72
cc_1832 ( N_SN_c_2334_n N_noxref_9_c_3209_n ) capacitor c=0.00159653f \
 //x=26.76 //y=4.765 //x2=28.61 //y2=3.72
cc_1833 ( N_SN_c_2334_n N_noxref_9_c_3211_n ) capacitor c=0.00196651f \
 //x=26.76 //y=4.765 //x2=28.61 //y2=5.25
cc_1834 ( N_SN_c_2333_n N_noxref_9_c_3212_n ) capacitor c=5.06e-19 //x=26.76 \
 //y=2.93 //x2=26.95 //y2=5.335
cc_1835 ( N_SN_c_2334_n N_noxref_9_c_3212_n ) capacitor c=0.00244335f \
 //x=26.76 //y=4.765 //x2=26.95 //y2=5.335
cc_1836 ( N_SN_c_2360_n N_noxref_9_c_3212_n ) capacitor c=0.00132214f \
 //x=26.76 //y=4.88 //x2=26.95 //y2=5.335
cc_1837 ( N_SN_M50_noxref_g N_noxref_9_c_3212_n ) capacitor c=0.00229818f \
 //x=26.73 //y=6.2 //x2=26.95 //y2=5.335
cc_1838 ( N_SN_M51_noxref_g N_noxref_9_c_3212_n ) capacitor c=0.00230699f \
 //x=27.17 //y=6.2 //x2=26.95 //y2=5.335
cc_1839 ( N_SN_c_2425_p N_noxref_9_c_3212_n ) capacitor c=0.00179476f \
 //x=27.095 //y=4.97 //x2=26.95 //y2=5.335
cc_1840 ( N_SN_c_2283_n N_noxref_9_c_3149_n ) capacitor c=0.0146349f \
 //x=16.245 //y=2.755 //x2=23.415 //y2=3.88
cc_1841 ( N_SN_c_2283_n N_noxref_9_c_3152_n ) capacitor c=0.00561727f \
 //x=16.245 //y=2.755 //x2=24.015 //y2=3.9
cc_1842 ( N_SN_c_2283_n N_noxref_9_c_3155_n ) capacitor c=0.00664784f \
 //x=16.245 //y=2.755 //x2=25.265 //y2=3.88
cc_1843 ( N_SN_c_2334_n N_noxref_9_c_3159_n ) capacitor c=4.01108e-19 \
 //x=26.76 //y=4.765 //x2=25.865 //y2=3.895
cc_1844 ( N_SN_c_2283_n N_noxref_9_c_3159_n ) capacitor c=0.0206344f \
 //x=16.245 //y=2.755 //x2=25.865 //y2=3.895
cc_1845 ( N_SN_c_2333_n N_noxref_9_c_3223_n ) capacitor c=0.00260859f \
 //x=26.76 //y=2.93 //x2=27.485 //y2=3.88
cc_1846 ( N_SN_c_2334_n N_noxref_9_c_3223_n ) capacitor c=0.0280813f //x=26.76 \
 //y=4.765 //x2=27.485 //y2=3.88
cc_1847 ( N_SN_c_2283_n N_noxref_9_c_3223_n ) capacitor c=0.00837113f \
 //x=16.245 //y=2.755 //x2=27.485 //y2=3.88
cc_1848 ( N_SN_c_2283_n N_noxref_9_c_3090_n ) capacitor c=0.00806722f \
 //x=16.245 //y=2.755 //x2=23.22 //y2=3.885
cc_1849 ( N_SN_c_2334_n N_noxref_9_c_3227_n ) capacitor c=6.21282e-19 \
 //x=26.76 //y=4.765 //x2=26.95 //y2=5.56
cc_1850 ( N_SN_M50_noxref_g N_noxref_9_c_3227_n ) capacitor c=0.0179041f \
 //x=26.73 //y=6.2 //x2=26.95 //y2=5.56
cc_1851 ( N_SN_M51_noxref_g N_noxref_9_c_3227_n ) capacitor c=0.0179041f \
 //x=27.17 //y=6.2 //x2=26.95 //y2=5.56
cc_1852 ( N_SN_c_2425_p N_noxref_9_c_3227_n ) capacitor c=0.00290085f \
 //x=27.095 //y=4.97 //x2=26.95 //y2=5.56
cc_1853 ( N_SN_M32_noxref_g N_VDD_c_3457_n ) capacitor c=0.00705252f //x=12.3 \
 //y=6.2 //x2=12.875 //y2=7.585
cc_1854 ( N_SN_M33_noxref_g N_VDD_c_3457_n ) capacitor c=0.00755544f //x=12.74 \
 //y=6.2 //x2=12.875 //y2=7.585
cc_1855 ( N_SN_M50_noxref_g N_VDD_c_3642_n ) capacitor c=0.00705252f //x=26.73 \
 //y=6.2 //x2=27.305 //y2=7.585
cc_1856 ( N_SN_M51_noxref_g N_VDD_c_3642_n ) capacitor c=0.00755544f //x=27.17 \
 //y=6.2 //x2=27.305 //y2=7.585
cc_1857 ( N_SN_M32_noxref_g N_VDD_M31_noxref_d ) capacitor c=0.015318f \
 //x=12.3 //y=6.2 //x2=11.935 //y2=5.2
cc_1858 ( N_SN_M33_noxref_g N_VDD_M33_noxref_d ) capacitor c=0.015318f \
 //x=12.74 //y=6.2 //x2=12.815 //y2=5.2
cc_1859 ( N_SN_M50_noxref_g N_VDD_M49_noxref_d ) capacitor c=0.015318f \
 //x=26.73 //y=6.2 //x2=26.365 //y2=5.2
cc_1860 ( N_SN_M51_noxref_g N_VDD_M51_noxref_d ) capacitor c=0.015318f \
 //x=27.17 //y=6.2 //x2=27.245 //y2=5.2
cc_1861 ( N_SN_c_2272_n N_noxref_14_c_4026_n ) capacitor c=0.00528251f \
 //x=13.79 //y=2.77 //x2=13.125 //y2=1.175
cc_1862 ( N_SN_c_2254_n N_noxref_14_c_4026_n ) capacitor c=0.00123426f \
 //x=12.42 //y=1.09 //x2=13.125 //y2=1.175
cc_1863 ( N_SN_c_2255_n N_noxref_14_c_4026_n ) capacitor c=0.0129288f \
 //x=12.42 //y=1.4 //x2=13.125 //y2=1.175
cc_1864 ( N_SN_c_2256_n N_noxref_14_c_4026_n ) capacitor c=0.00132209f \
 //x=12.42 //y=1.63 //x2=13.125 //y2=1.175
cc_1865 ( N_SN_c_2272_n N_noxref_14_c_4014_n ) capacitor c=2.32611e-19 \
 //x=13.79 //y=2.77 //x2=14.095 //y2=0.72
cc_1866 ( N_SN_c_2222_n N_noxref_14_M7_noxref_d ) capacitor c=0.00603521f \
 //x=12.33 //y=2.375 //x2=11.97 //y2=1.09
cc_1867 ( N_SN_c_2227_n N_noxref_14_M7_noxref_d ) capacitor c=2.76459e-19 \
 //x=12.33 //y=2.935 //x2=11.97 //y2=1.09
cc_1868 ( N_SN_c_2237_n N_noxref_14_M7_noxref_d ) capacitor c=9.01305e-19 \
 //x=12.49 //y=2.775 //x2=11.97 //y2=1.09
cc_1869 ( N_SN_c_2238_n N_noxref_14_M7_noxref_d ) capacitor c=2.2052e-19 \
 //x=12.33 //y=2.26 //x2=11.97 //y2=1.09
cc_1870 ( N_SN_c_2249_n N_noxref_14_M7_noxref_d ) capacitor c=0.00253592f \
 //x=11.895 //y=1.09 //x2=11.97 //y2=1.09
cc_1871 ( N_SN_c_2252_n N_noxref_14_M7_noxref_d ) capacitor c=0.00604087f \
 //x=11.895 //y=1.4 //x2=11.97 //y2=1.09
cc_1872 ( N_SN_c_2477_p N_noxref_14_M7_noxref_d ) capacitor c=0.002686f \
 //x=12.265 //y=0.935 //x2=11.97 //y2=1.09
cc_1873 ( N_SN_c_2478_p N_noxref_14_M7_noxref_d ) capacitor c=0.00251995f \
 //x=12.265 //y=1.555 //x2=11.97 //y2=1.09
cc_1874 ( N_SN_c_2254_n N_noxref_14_M7_noxref_d ) capacitor c=0.00314523f \
 //x=12.42 //y=1.09 //x2=11.97 //y2=1.09
cc_1875 ( N_SN_c_2255_n N_noxref_14_M7_noxref_d ) capacitor c=0.00168289f \
 //x=12.42 //y=1.4 //x2=11.97 //y2=1.09
cc_1876 ( N_SN_c_2256_n N_noxref_14_M7_noxref_d ) capacitor c=0.00111165f \
 //x=12.42 //y=1.63 //x2=11.97 //y2=1.09
cc_1877 ( N_SN_c_2272_n N_noxref_14_M8_noxref_s ) capacitor c=0.00360031f \
 //x=13.79 //y=2.77 //x2=13.075 //y2=0.555
cc_1878 ( N_SN_c_2254_n N_noxref_14_M8_noxref_s ) capacitor c=7.21316e-19 \
 //x=12.42 //y=1.09 //x2=13.075 //y2=0.555
cc_1879 ( N_SN_c_2255_n N_noxref_14_M8_noxref_s ) capacitor c=0.00365271f \
 //x=12.42 //y=1.4 //x2=13.075 //y2=0.555
cc_1880 ( N_SN_c_2257_n N_noxref_14_M8_noxref_s ) capacitor c=9.86711e-19 \
 //x=12.42 //y=2.095 //x2=13.075 //y2=0.555
cc_1881 ( N_SN_c_2222_n N_noxref_15_c_4089_n ) capacitor c=0.0116288f \
 //x=12.33 //y=2.375 //x2=13.44 //y2=2.375
cc_1882 ( N_SN_c_2272_n N_noxref_15_c_4089_n ) capacitor c=0.00336473f \
 //x=13.79 //y=2.77 //x2=13.44 //y2=2.375
cc_1883 ( N_SN_c_2238_n N_noxref_15_c_4089_n ) capacitor c=5.39999e-19 \
 //x=12.33 //y=2.26 //x2=13.44 //y2=2.375
cc_1884 ( N_SN_c_2257_n N_noxref_15_c_4089_n ) capacitor c=0.00141236f \
 //x=12.42 //y=2.095 //x2=13.44 //y2=2.375
cc_1885 ( N_SN_c_2225_n N_noxref_15_c_4086_n ) capacitor c=0.00619064f \
 //x=12.33 //y=2.615 //x2=13.44 //y2=4.135
cc_1886 ( N_SN_c_2227_n N_noxref_15_c_4086_n ) capacitor c=0.00763921f \
 //x=12.33 //y=2.935 //x2=13.44 //y2=4.135
cc_1887 ( N_SN_c_2228_n N_noxref_15_c_4086_n ) capacitor c=0.0301066f \
 //x=12.33 //y=4.765 //x2=13.44 //y2=4.135
cc_1888 ( N_SN_c_2236_n N_noxref_15_c_4086_n ) capacitor c=2.99286e-19 \
 //x=12.33 //y=2.775 //x2=13.44 //y2=4.135
cc_1889 ( N_SN_c_2272_n N_noxref_15_c_4086_n ) capacitor c=0.0281489f \
 //x=13.79 //y=2.77 //x2=13.44 //y2=4.135
cc_1890 ( N_SN_c_2237_n N_noxref_15_c_4086_n ) capacitor c=0.00235779f \
 //x=12.49 //y=2.775 //x2=13.44 //y2=4.135
cc_1891 ( N_SN_c_2238_n N_noxref_15_c_4086_n ) capacitor c=4.16726e-19 \
 //x=12.33 //y=2.26 //x2=13.44 //y2=4.135
cc_1892 ( N_SN_c_2228_n N_noxref_15_c_4097_n ) capacitor c=0.00641487f \
 //x=12.33 //y=4.765 //x2=13.44 //y2=4.365
cc_1893 ( N_SN_c_2228_n N_noxref_15_c_4088_n ) capacitor c=0.0189517f \
 //x=12.33 //y=4.765 //x2=13.44 //y2=4.75
cc_1894 ( N_SN_c_2242_n N_noxref_15_c_4088_n ) capacitor c=9.52396e-19 \
 //x=12.33 //y=4.88 //x2=13.44 //y2=4.75
cc_1895 ( N_SN_c_2260_n N_noxref_15_c_4088_n ) capacitor c=8.42568e-19 \
 //x=12.33 //y=4.88 //x2=13.44 //y2=4.75
cc_1896 ( N_SN_c_2228_n N_noxref_15_c_4106_n ) capacitor c=0.00138168f \
 //x=12.33 //y=4.765 //x2=13.44 //y2=4.25
cc_1897 ( N_SN_c_2222_n N_noxref_15_c_4107_n ) capacitor c=5.42289e-19 \
 //x=12.33 //y=2.375 //x2=13.44 //y2=2.26
cc_1898 ( N_SN_c_2225_n N_noxref_15_c_4107_n ) capacitor c=4.16726e-19 \
 //x=12.33 //y=2.615 //x2=13.44 //y2=2.26
cc_1899 ( N_SN_c_2238_n N_noxref_15_c_4107_n ) capacitor c=0.00125213f \
 //x=12.33 //y=2.26 //x2=13.44 //y2=2.26
cc_1900 ( N_SN_c_2257_n N_noxref_15_c_4107_n ) capacitor c=0.00209664f \
 //x=12.42 //y=2.095 //x2=13.44 //y2=2.26
cc_1901 ( N_SN_c_2228_n N_noxref_15_c_4108_n ) capacitor c=7.51101e-19 \
 //x=12.33 //y=4.765 //x2=13.44 //y2=4.88
cc_1902 ( N_SN_c_2242_n N_noxref_15_c_4108_n ) capacitor c=0.00113985f \
 //x=12.33 //y=4.88 //x2=13.44 //y2=4.88
cc_1903 ( N_SN_c_2260_n N_noxref_15_c_4108_n ) capacitor c=0.00129812f \
 //x=12.33 //y=4.88 //x2=13.44 //y2=4.88
cc_1904 ( N_SN_M32_noxref_g N_noxref_15_M34_noxref_g ) capacitor c=0.0101598f \
 //x=12.3 //y=6.2 //x2=13.18 //y2=6.2
cc_1905 ( N_SN_M33_noxref_g N_noxref_15_M34_noxref_g ) capacitor c=0.0607518f \
 //x=12.74 //y=6.2 //x2=13.18 //y2=6.2
cc_1906 ( N_SN_M33_noxref_g N_noxref_15_M35_noxref_g ) capacitor c=0.0101598f \
 //x=12.74 //y=6.2 //x2=13.62 //y2=6.2
cc_1907 ( N_SN_c_2254_n N_noxref_15_c_4118_n ) capacitor c=0.00456962f \
 //x=12.42 //y=1.09 //x2=13.43 //y2=1.095
cc_1908 ( N_SN_c_2255_n N_noxref_15_c_4120_n ) capacitor c=0.00438372f \
 //x=12.42 //y=1.4 //x2=13.43 //y2=1.44
cc_1909 ( N_SN_c_2256_n N_noxref_15_c_4123_n ) capacitor c=0.00438372f \
 //x=12.42 //y=1.63 //x2=13.43 //y2=1.75
cc_1910 ( N_SN_c_2222_n N_noxref_15_c_4136_n ) capacitor c=0.00139071f \
 //x=12.33 //y=2.375 //x2=13.44 //y2=2.26
cc_1911 ( N_SN_c_2238_n N_noxref_15_c_4136_n ) capacitor c=0.00204868f \
 //x=12.33 //y=2.26 //x2=13.44 //y2=2.26
cc_1912 ( N_SN_c_2257_n N_noxref_15_c_4136_n ) capacitor c=0.00933826f \
 //x=12.42 //y=2.095 //x2=13.44 //y2=2.26
cc_1913 ( N_SN_c_2257_n N_noxref_15_c_4137_n ) capacitor c=0.00438372f \
 //x=12.42 //y=2.095 //x2=13.44 //y2=2.095
cc_1914 ( N_SN_c_2228_n N_noxref_15_c_4139_n ) capacitor c=0.00124604f \
 //x=12.33 //y=4.765 //x2=13.44 //y2=4.88
cc_1915 ( N_SN_c_2242_n N_noxref_15_c_4139_n ) capacitor c=0.00187046f \
 //x=12.33 //y=4.88 //x2=13.44 //y2=4.88
cc_1916 ( N_SN_c_2295_n N_noxref_15_c_4139_n ) capacitor c=0.0616777f \
 //x=12.665 //y=4.97 //x2=13.44 //y2=4.88
cc_1917 ( N_SN_c_2260_n N_noxref_15_c_4139_n ) capacitor c=0.00487508f \
 //x=12.33 //y=4.88 //x2=13.44 //y2=4.88
cc_1918 ( N_SN_c_2283_n N_noxref_16_c_4211_n ) capacitor c=0.00528251f \
 //x=16.245 //y=2.755 //x2=17.935 //y2=1.175
cc_1919 ( N_SN_c_2283_n N_noxref_16_c_4227_n ) capacitor c=2.35141e-19 \
 //x=16.245 //y=2.755 //x2=18.905 //y2=0.72
cc_1920 ( N_SN_c_2283_n N_noxref_16_M10_noxref_d ) capacitor c=0.00517852f \
 //x=16.245 //y=2.755 //x2=16.78 //y2=1.09
cc_1921 ( N_SN_c_2283_n N_noxref_16_M11_noxref_s ) capacitor c=0.00373481f \
 //x=16.245 //y=2.755 //x2=17.885 //y2=0.555
cc_1922 ( N_SN_c_2283_n N_noxref_17_c_4281_n ) capacitor c=0.00528251f \
 //x=16.245 //y=2.755 //x2=22.745 //y2=1.175
cc_1923 ( N_SN_c_2283_n N_noxref_17_c_4296_n ) capacitor c=2.89281e-19 \
 //x=16.245 //y=2.755 //x2=23.715 //y2=0.72
cc_1924 ( N_SN_c_2283_n N_noxref_17_M13_noxref_d ) capacitor c=0.00581941f \
 //x=16.245 //y=2.755 //x2=21.59 //y2=1.09
cc_1925 ( N_SN_c_2283_n N_noxref_17_M14_noxref_s ) capacitor c=0.00354433f \
 //x=16.245 //y=2.755 //x2=22.695 //y2=0.555
cc_1926 ( N_SN_c_2222_n N_GND_c_4416_n ) capacitor c=9.16602e-19 //x=12.33 \
 //y=2.375 //x2=15.91 //y2=0.175
cc_1927 ( N_SN_c_2227_n N_GND_c_4416_n ) capacitor c=3.77363e-19 //x=12.33 \
 //y=2.935 //x2=15.91 //y2=0.175
cc_1928 ( N_SN_c_2327_n N_GND_c_4539_n ) capacitor c=9.16602e-19 //x=26.76 \
 //y=2.375 //x2=28.61 //y2=0.18
cc_1929 ( N_SN_c_2283_n N_GND_c_4423_n ) capacitor c=0.00357879f //x=16.245 \
 //y=2.755 //x2=15.995 //y2=1.145
cc_1930 ( N_SN_c_2283_n N_GND_c_4464_n ) capacitor c=0.00362944f //x=16.245 \
 //y=2.755 //x2=20.805 //y2=1.145
cc_1931 ( N_SN_c_2283_n N_GND_c_4508_n ) capacitor c=0.00349818f //x=16.245 \
 //y=2.755 //x2=25.615 //y2=1.145
cc_1932 ( N_SN_c_2345_n N_GND_c_4521_n ) capacitor c=0.00139524f //x=26.76 \
 //y=2.77 //x2=28.61 //y2=0.18
cc_1933 ( N_SN_c_2236_n N_GND_c_4396_n ) capacitor c=0.00178992f //x=12.33 \
 //y=2.775 //x2=10.11 //y2=0.175
cc_1934 ( N_SN_c_2236_n N_GND_c_4437_n ) capacitor c=8.62435e-19 //x=12.33 \
 //y=2.775 //x2=14.92 //y2=0.175
cc_1935 ( N_SN_c_2276_n N_GND_c_4437_n ) capacitor c=2.24255e-19 //x=14.39 \
 //y=2.76 //x2=14.92 //y2=0.175
cc_1936 ( N_SN_c_2280_n N_GND_c_4437_n ) capacitor c=0.0233099f //x=15.645 \
 //y=2.77 //x2=14.92 //y2=0.175
cc_1937 ( N_SN_c_2283_n N_GND_c_4482_n ) capacitor c=0.0247529f //x=16.245 \
 //y=2.755 //x2=19.73 //y2=0.175
cc_1938 ( N_SN_c_2345_n N_GND_c_4522_n ) capacitor c=0.00124714f //x=26.76 \
 //y=2.77 //x2=24.54 //y2=0.175
cc_1939 ( N_SN_c_2283_n N_GND_c_4522_n ) capacitor c=0.0238314f //x=16.245 \
 //y=2.755 //x2=24.54 //y2=0.175
cc_1940 ( N_SN_c_2373_n N_noxref_19_c_4836_n ) capacitor c=0.00123426f \
 //x=26.85 //y=1.09 //x2=27.555 //y2=1.175
cc_1941 ( N_SN_c_2374_n N_noxref_19_c_4836_n ) capacitor c=0.0129288f \
 //x=26.85 //y=1.4 //x2=27.555 //y2=1.175
cc_1942 ( N_SN_c_2375_n N_noxref_19_c_4836_n ) capacitor c=0.00132209f \
 //x=26.85 //y=1.63 //x2=27.555 //y2=1.175
cc_1943 ( N_SN_c_2327_n N_noxref_19_M16_noxref_d ) capacitor c=0.00603481f \
 //x=26.76 //y=2.375 //x2=26.4 //y2=1.09
cc_1944 ( N_SN_c_2333_n N_noxref_19_M16_noxref_d ) capacitor c=9.01213e-19 \
 //x=26.76 //y=2.93 //x2=26.4 //y2=1.09
cc_1945 ( N_SN_c_2283_n N_noxref_19_M16_noxref_d ) capacitor c=0.00395987f \
 //x=16.245 //y=2.755 //x2=26.4 //y2=1.09
cc_1946 ( N_SN_c_2356_n N_noxref_19_M16_noxref_d ) capacitor c=2.2052e-19 \
 //x=26.76 //y=2.26 //x2=26.4 //y2=1.09
cc_1947 ( N_SN_c_2368_n N_noxref_19_M16_noxref_d ) capacitor c=0.00253592f \
 //x=26.325 //y=1.09 //x2=26.4 //y2=1.09
cc_1948 ( N_SN_c_2371_n N_noxref_19_M16_noxref_d ) capacitor c=0.00604087f \
 //x=26.325 //y=1.4 //x2=26.4 //y2=1.09
cc_1949 ( N_SN_c_2554_p N_noxref_19_M16_noxref_d ) capacitor c=0.002686f \
 //x=26.695 //y=0.935 //x2=26.4 //y2=1.09
cc_1950 ( N_SN_c_2555_p N_noxref_19_M16_noxref_d ) capacitor c=0.00248048f \
 //x=26.695 //y=1.555 //x2=26.4 //y2=1.09
cc_1951 ( N_SN_c_2373_n N_noxref_19_M16_noxref_d ) capacitor c=0.00314523f \
 //x=26.85 //y=1.09 //x2=26.4 //y2=1.09
cc_1952 ( N_SN_c_2374_n N_noxref_19_M16_noxref_d ) capacitor c=0.00168289f \
 //x=26.85 //y=1.4 //x2=26.4 //y2=1.09
cc_1953 ( N_SN_c_2375_n N_noxref_19_M16_noxref_d ) capacitor c=0.00111165f \
 //x=26.85 //y=1.63 //x2=26.4 //y2=1.09
cc_1954 ( N_SN_c_2373_n N_noxref_19_M17_noxref_s ) capacitor c=7.21316e-19 \
 //x=26.85 //y=1.09 //x2=27.505 //y2=0.555
cc_1955 ( N_SN_c_2374_n N_noxref_19_M17_noxref_s ) capacitor c=0.00365271f \
 //x=26.85 //y=1.4 //x2=27.505 //y2=0.555
cc_1956 ( N_SN_c_2376_n N_noxref_19_M17_noxref_s ) capacitor c=9.86711e-19 \
 //x=26.85 //y=2.095 //x2=27.505 //y2=0.555
cc_1957 ( N_SN_c_2249_n N_noxref_22_c_5029_n ) capacitor c=0.0167228f \
 //x=11.895 //y=1.09 //x2=12.555 //y2=0.72
cc_1958 ( N_SN_c_2254_n N_noxref_22_c_5029_n ) capacitor c=0.00534519f \
 //x=12.42 //y=1.09 //x2=12.555 //y2=0.72
cc_1959 ( N_SN_c_2222_n N_noxref_22_c_5027_n ) capacitor c=0.0048147f \
 //x=12.33 //y=2.375 //x2=12.555 //y2=1.77
cc_1960 ( N_SN_c_2227_n N_noxref_22_c_5027_n ) capacitor c=0.00324661f \
 //x=12.33 //y=2.935 //x2=12.555 //y2=1.77
cc_1961 ( N_SN_c_2238_n N_noxref_22_c_5027_n ) capacitor c=0.0105652f \
 //x=12.33 //y=2.26 //x2=12.555 //y2=1.77
cc_1962 ( N_SN_c_2252_n N_noxref_22_c_5027_n ) capacitor c=0.0153476f \
 //x=11.895 //y=1.4 //x2=12.555 //y2=1.77
cc_1963 ( N_SN_c_2257_n N_noxref_22_c_5027_n ) capacitor c=0.0197754f \
 //x=12.42 //y=2.095 //x2=12.555 //y2=1.77
cc_1964 ( N_SN_c_2227_n N_noxref_22_M6_noxref_s ) capacitor c=7.9975e-19 \
 //x=12.33 //y=2.935 //x2=10.565 //y2=0.555
cc_1965 ( N_SN_c_2272_n N_noxref_22_M6_noxref_s ) capacitor c=0.0024662f \
 //x=13.79 //y=2.77 //x2=10.565 //y2=0.555
cc_1966 ( N_SN_c_2249_n N_noxref_22_M6_noxref_s ) capacitor c=0.00798959f \
 //x=11.895 //y=1.09 //x2=10.565 //y2=0.555
cc_1967 ( N_SN_c_2256_n N_noxref_22_M6_noxref_s ) capacitor c=0.00212176f \
 //x=12.42 //y=1.63 //x2=10.565 //y2=0.555
cc_1968 ( N_SN_c_2257_n N_noxref_22_M6_noxref_s ) capacitor c=0.00298115f \
 //x=12.42 //y=2.095 //x2=10.565 //y2=0.555
cc_1969 ( N_SN_c_2280_n N_noxref_23_c_5073_n ) capacitor c=0.00375801f \
 //x=15.645 //y=2.77 //x2=15.51 //y2=1.685
cc_1970 ( N_SN_c_2280_n N_noxref_23_c_5074_n ) capacitor c=0.010076f \
 //x=15.645 //y=2.77 //x2=16.395 //y2=1.77
cc_1971 ( N_SN_c_2283_n N_noxref_23_c_5074_n ) capacitor c=0.00136156f \
 //x=16.245 //y=2.755 //x2=16.395 //y2=1.77
cc_1972 ( N_SN_c_2283_n N_noxref_23_c_5087_n ) capacitor c=0.0103008f \
 //x=16.245 //y=2.755 //x2=17.365 //y2=1.77
cc_1973 ( N_SN_c_2283_n N_noxref_23_M9_noxref_s ) capacitor c=0.00698304f \
 //x=16.245 //y=2.755 //x2=15.375 //y2=0.555
cc_1974 ( N_SN_c_2283_n N_noxref_24_c_5132_n ) capacitor c=0.00375801f \
 //x=16.245 //y=2.755 //x2=20.32 //y2=1.685
cc_1975 ( N_SN_c_2283_n N_noxref_24_c_5133_n ) capacitor c=0.0118196f \
 //x=16.245 //y=2.755 //x2=21.205 //y2=1.77
cc_1976 ( N_SN_c_2283_n N_noxref_24_c_5146_n ) capacitor c=0.00983165f \
 //x=16.245 //y=2.755 //x2=22.175 //y2=1.77
cc_1977 ( N_SN_c_2283_n N_noxref_24_M12_noxref_s ) capacitor c=0.00659617f \
 //x=16.245 //y=2.755 //x2=20.185 //y2=0.555
cc_1978 ( N_SN_c_2283_n N_noxref_25_c_5190_n ) capacitor c=0.00375801f \
 //x=16.245 //y=2.755 //x2=25.13 //y2=1.685
cc_1979 ( N_SN_c_2283_n N_noxref_25_c_5191_n ) capacitor c=0.011855f \
 //x=16.245 //y=2.755 //x2=26.015 //y2=1.77
cc_1980 ( N_SN_c_2368_n N_noxref_25_c_5204_n ) capacitor c=0.0167228f \
 //x=26.325 //y=1.09 //x2=26.985 //y2=0.72
cc_1981 ( N_SN_c_2373_n N_noxref_25_c_5204_n ) capacitor c=0.00534519f \
 //x=26.85 //y=1.09 //x2=26.985 //y2=0.72
cc_1982 ( N_SN_c_2327_n N_noxref_25_c_5206_n ) capacitor c=0.0048147f \
 //x=26.76 //y=2.375 //x2=26.985 //y2=1.77
cc_1983 ( N_SN_c_2333_n N_noxref_25_c_5206_n ) capacitor c=0.00377345f \
 //x=26.76 //y=2.93 //x2=26.985 //y2=1.77
cc_1984 ( N_SN_c_2283_n N_noxref_25_c_5206_n ) capacitor c=0.00525615f \
 //x=16.245 //y=2.755 //x2=26.985 //y2=1.77
cc_1985 ( N_SN_c_2356_n N_noxref_25_c_5206_n ) capacitor c=0.0105652f \
 //x=26.76 //y=2.26 //x2=26.985 //y2=1.77
cc_1986 ( N_SN_c_2371_n N_noxref_25_c_5206_n ) capacitor c=0.0153476f \
 //x=26.325 //y=1.4 //x2=26.985 //y2=1.77
cc_1987 ( N_SN_c_2376_n N_noxref_25_c_5206_n ) capacitor c=0.0198382f \
 //x=26.85 //y=2.095 //x2=26.985 //y2=1.77
cc_1988 ( N_SN_c_2283_n N_noxref_25_M15_noxref_s ) capacitor c=0.00375801f \
 //x=16.245 //y=2.755 //x2=24.995 //y2=0.555
cc_1989 ( N_SN_c_2368_n N_noxref_25_M15_noxref_s ) capacitor c=0.00798959f \
 //x=26.325 //y=1.09 //x2=24.995 //y2=0.555
cc_1990 ( N_SN_c_2375_n N_noxref_25_M15_noxref_s ) capacitor c=0.00212176f \
 //x=26.85 //y=1.63 //x2=24.995 //y2=0.555
cc_1991 ( N_SN_c_2376_n N_noxref_25_M15_noxref_s ) capacitor c=0.00298115f \
 //x=26.85 //y=2.095 //x2=24.995 //y2=0.555
cc_1992 ( N_noxref_8_c_2826_n N_noxref_9_c_3096_n ) capacitor c=0.00120279f \
 //x=22.675 //y=4.25 //x2=23.06 //y2=4.045
cc_1993 ( N_noxref_8_c_2849_n N_noxref_9_c_3096_n ) capacitor c=0.00403056f \
 //x=23.275 //y=4.27 //x2=23.06 //y2=4.045
cc_1994 ( N_noxref_8_c_2826_n N_noxref_9_c_3088_n ) capacitor c=5.3881e-19 \
 //x=22.675 //y=4.25 //x2=23.06 //y2=4.75
cc_1995 ( N_noxref_8_c_2849_n N_noxref_9_c_3088_n ) capacitor c=0.0272571f \
 //x=23.275 //y=4.27 //x2=23.06 //y2=4.75
cc_1996 ( N_noxref_8_c_2867_n N_noxref_9_c_3208_n ) capacitor c=0.00304419f \
 //x=27.87 //y=4.405 //x2=27.715 //y2=5.335
cc_1997 ( N_noxref_8_c_2849_n N_noxref_9_c_3208_n ) capacitor c=0.00296604f \
 //x=23.275 //y=4.27 //x2=27.715 //y2=5.335
cc_1998 ( N_noxref_8_M52_noxref_g N_noxref_9_c_3208_n ) capacitor \
 c=0.00979706f //x=27.61 //y=6.2 //x2=27.715 //y2=5.335
cc_1999 ( N_noxref_8_M52_noxref_g N_noxref_9_c_3238_n ) capacitor \
 c=0.00226521f //x=27.61 //y=6.2 //x2=27.83 //y2=5.56
cc_2000 ( N_noxref_8_M53_noxref_g N_noxref_9_c_3238_n ) capacitor \
 c=0.00427254f //x=28.05 //y=6.2 //x2=27.83 //y2=5.56
cc_2001 ( N_noxref_8_c_2867_n N_noxref_9_c_3240_n ) capacitor c=9.0201e-19 \
 //x=27.87 //y=4.405 //x2=28.525 //y2=5.335
cc_2002 ( N_noxref_8_c_2846_n N_noxref_9_c_3240_n ) capacitor c=0.0023415f \
 //x=27.87 //y=4.75 //x2=28.525 //y2=5.335
cc_2003 ( N_noxref_8_c_2849_n N_noxref_9_c_3240_n ) capacitor c=0.00103772f \
 //x=23.275 //y=4.27 //x2=28.525 //y2=5.335
cc_2004 ( N_noxref_8_c_2882_n N_noxref_9_c_3240_n ) capacitor c=0.00130631f \
 //x=27.87 //y=4.88 //x2=28.525 //y2=5.335
cc_2005 ( N_noxref_8_M53_noxref_g N_noxref_9_c_3240_n ) capacitor c=0.0112359f \
 //x=28.05 //y=6.2 //x2=28.525 //y2=5.335
cc_2006 ( N_noxref_8_c_2888_n N_noxref_9_c_3245_n ) capacitor c=4.64015e-19 \
 //x=27.86 //y=1.095 //x2=28.125 //y2=1.305
cc_2007 ( N_noxref_8_c_2889_n N_noxref_9_c_3245_n ) capacitor c=0.0026012f \
 //x=27.86 //y=1.44 //x2=28.125 //y2=1.305
cc_2008 ( N_noxref_8_c_2915_p N_noxref_9_c_3245_n ) capacitor c=5.29969e-19 \
 //x=28.235 //y=0.94 //x2=28.125 //y2=1.305
cc_2009 ( N_noxref_8_c_2916_p N_noxref_9_c_3245_n ) capacitor c=5.39615e-19 \
 //x=28.235 //y=1.595 //x2=28.125 //y2=1.305
cc_2010 ( N_noxref_8_c_2917_p N_noxref_9_c_3245_n ) capacitor c=5.7502e-19 \
 //x=28.39 //y=1.095 //x2=28.125 //y2=1.305
cc_2011 ( N_noxref_8_c_2918_p N_noxref_9_c_3245_n ) capacitor c=0.00357756f \
 //x=28.39 //y=1.44 //x2=28.125 //y2=1.305
cc_2012 ( N_noxref_8_c_2889_n N_noxref_9_c_3251_n ) capacitor c=0.00127432f \
 //x=27.86 //y=1.44 //x2=28.125 //y2=1.76
cc_2013 ( N_noxref_8_c_2890_n N_noxref_9_c_3251_n ) capacitor c=0.00429966f \
 //x=27.86 //y=1.75 //x2=28.125 //y2=1.76
cc_2014 ( N_noxref_8_c_2916_p N_noxref_9_c_3251_n ) capacitor c=0.00942306f \
 //x=28.235 //y=1.595 //x2=28.125 //y2=1.76
cc_2015 ( N_noxref_8_c_2918_p N_noxref_9_c_3251_n ) capacitor c=0.00363411f \
 //x=28.39 //y=1.44 //x2=28.125 //y2=1.76
cc_2016 ( N_noxref_8_c_2894_n N_noxref_9_c_3251_n ) capacitor c=0.0036273f \
 //x=27.87 //y=2.095 //x2=28.125 //y2=1.76
cc_2017 ( N_noxref_8_c_2916_p N_noxref_9_c_3256_n ) capacitor c=0.00194716f \
 //x=28.235 //y=1.595 //x2=28.525 //y2=1.845
cc_2018 ( N_noxref_8_c_2918_p N_noxref_9_c_3256_n ) capacitor c=0.00323576f \
 //x=28.39 //y=1.44 //x2=28.525 //y2=1.845
cc_2019 ( N_noxref_8_c_2858_n N_noxref_9_c_3209_n ) capacitor c=0.0154269f \
 //x=27.87 //y=2.375 //x2=28.61 //y2=3.72
cc_2020 ( N_noxref_8_c_2844_n N_noxref_9_c_3209_n ) capacitor c=0.0619035f \
 //x=27.87 //y=4.085 //x2=28.61 //y2=3.72
cc_2021 ( N_noxref_8_c_2878_n N_noxref_9_c_3209_n ) capacitor c=0.00467849f \
 //x=27.87 //y=2.26 //x2=28.61 //y2=3.72
cc_2022 ( N_noxref_8_c_2891_n N_noxref_9_c_3209_n ) capacitor c=0.0025845f \
 //x=27.87 //y=2.26 //x2=28.61 //y2=3.72
cc_2023 ( N_noxref_8_c_2894_n N_noxref_9_c_3209_n ) capacitor c=0.00282067f \
 //x=27.87 //y=2.095 //x2=28.61 //y2=3.72
cc_2024 ( N_noxref_8_c_2844_n N_noxref_9_c_3263_n ) capacitor c=0.0175859f \
 //x=27.87 //y=4.085 //x2=28.61 //y2=4.04
cc_2025 ( N_noxref_8_c_2844_n N_noxref_9_c_3211_n ) capacitor c=0.00210218f \
 //x=27.87 //y=4.085 //x2=28.61 //y2=5.25
cc_2026 ( N_noxref_8_c_2867_n N_noxref_9_c_3211_n ) capacitor c=0.0149195f \
 //x=27.87 //y=4.405 //x2=28.61 //y2=5.25
cc_2027 ( N_noxref_8_c_2846_n N_noxref_9_c_3211_n ) capacitor c=0.0310513f \
 //x=27.87 //y=4.75 //x2=28.61 //y2=5.25
cc_2028 ( N_noxref_8_c_2871_n N_noxref_9_c_3211_n ) capacitor c=0.00459744f \
 //x=27.87 //y=4.25 //x2=28.61 //y2=5.25
cc_2029 ( N_noxref_8_c_2849_n N_noxref_9_c_3211_n ) capacitor c=0.00686831f \
 //x=23.275 //y=4.27 //x2=28.61 //y2=5.25
cc_2030 ( N_noxref_8_c_2882_n N_noxref_9_c_3211_n ) capacitor c=0.00442006f \
 //x=27.87 //y=4.88 //x2=28.61 //y2=5.25
cc_2031 ( N_noxref_8_c_2895_n N_noxref_9_c_3211_n ) capacitor c=0.00739875f \
 //x=27.87 //y=4.88 //x2=28.61 //y2=5.25
cc_2032 ( N_noxref_8_c_2849_n N_noxref_9_c_3144_n ) capacitor c=0.022636f \
 //x=23.275 //y=4.27 //x2=26.072 //y2=5.335
cc_2033 ( N_noxref_8_c_2849_n N_noxref_9_c_3212_n ) capacitor c=0.0255171f \
 //x=23.275 //y=4.27 //x2=26.95 //y2=5.335
cc_2034 ( N_noxref_8_c_2846_n N_noxref_9_c_3273_n ) capacitor c=0.023204f \
 //x=27.87 //y=4.75 //x2=27.83 //y2=5.335
cc_2035 ( N_noxref_8_c_2882_n N_noxref_9_c_3273_n ) capacitor c=0.00346456f \
 //x=27.87 //y=4.88 //x2=27.83 //y2=5.335
cc_2036 ( N_noxref_8_c_2895_n N_noxref_9_c_3273_n ) capacitor c=0.00203307f \
 //x=27.87 //y=4.88 //x2=27.83 //y2=5.335
cc_2037 ( N_noxref_8_c_2844_n N_noxref_9_c_3276_n ) capacitor c=6.78671e-19 \
 //x=27.87 //y=4.085 //x2=28.61 //y2=3.88
cc_2038 ( N_noxref_8_c_2849_n N_noxref_9_c_3149_n ) capacitor c=0.0846414f \
 //x=23.275 //y=4.27 //x2=23.415 //y2=3.88
cc_2039 ( N_noxref_8_c_2849_n N_noxref_9_c_3152_n ) capacitor c=0.116798f \
 //x=23.275 //y=4.27 //x2=24.015 //y2=3.9
cc_2040 ( N_noxref_8_c_2849_n N_noxref_9_c_3155_n ) capacitor c=0.0604253f \
 //x=23.275 //y=4.27 //x2=25.265 //y2=3.88
cc_2041 ( N_noxref_8_c_2849_n N_noxref_9_c_3159_n ) capacitor c=0.149448f \
 //x=23.275 //y=4.27 //x2=25.865 //y2=3.895
cc_2042 ( N_noxref_8_c_2844_n N_noxref_9_c_3223_n ) capacitor c=5.04002e-19 \
 //x=27.87 //y=4.085 //x2=27.485 //y2=3.88
cc_2043 ( N_noxref_8_c_2867_n N_noxref_9_c_3223_n ) capacitor c=0.00205524f \
 //x=27.87 //y=4.405 //x2=27.485 //y2=3.88
cc_2044 ( N_noxref_8_c_2849_n N_noxref_9_c_3223_n ) capacitor c=0.0114848f \
 //x=23.275 //y=4.27 //x2=27.485 //y2=3.88
cc_2045 ( N_noxref_8_c_2858_n N_noxref_9_c_3284_n ) capacitor c=0.00145163f \
 //x=27.87 //y=2.375 //x2=28.085 //y2=3.86
cc_2046 ( N_noxref_8_c_2844_n N_noxref_9_c_3284_n ) capacitor c=0.0286785f \
 //x=27.87 //y=4.085 //x2=28.085 //y2=3.86
cc_2047 ( N_noxref_8_c_2867_n N_noxref_9_c_3284_n ) capacitor c=0.0044911f \
 //x=27.87 //y=4.405 //x2=28.085 //y2=3.86
cc_2048 ( N_noxref_8_c_2849_n N_noxref_9_c_3284_n ) capacitor c=0.0374977f \
 //x=23.275 //y=4.27 //x2=28.085 //y2=3.86
cc_2049 ( N_noxref_8_c_2826_n N_noxref_9_c_3090_n ) capacitor c=0.0364799f \
 //x=22.675 //y=4.25 //x2=23.22 //y2=3.885
cc_2050 ( N_noxref_8_c_2867_n N_noxref_9_c_3289_n ) capacitor c=2.30056e-19 \
 //x=27.87 //y=4.405 //x2=27.83 //y2=5.56
cc_2051 ( N_noxref_8_c_2846_n N_noxref_9_c_3289_n ) capacitor c=0.00217653f \
 //x=27.87 //y=4.75 //x2=27.83 //y2=5.56
cc_2052 ( N_noxref_8_c_2882_n N_noxref_9_c_3289_n ) capacitor c=0.00552343f \
 //x=27.87 //y=4.88 //x2=27.83 //y2=5.56
cc_2053 ( N_noxref_8_M52_noxref_g N_noxref_9_c_3289_n ) capacitor c=0.0178885f \
 //x=27.61 //y=6.2 //x2=27.83 //y2=5.56
cc_2054 ( N_noxref_8_M53_noxref_g N_noxref_9_c_3289_n ) capacitor c=0.0188608f \
 //x=28.05 //y=6.2 //x2=27.83 //y2=5.56
cc_2055 ( N_noxref_8_c_2895_n N_noxref_9_c_3289_n ) capacitor c=0.00375636f \
 //x=27.87 //y=4.88 //x2=27.83 //y2=5.56
cc_2056 ( N_noxref_8_c_2888_n N_noxref_9_M17_noxref_d ) capacitor \
 c=0.00137165f //x=27.86 //y=1.095 //x2=27.935 //y2=1.095
cc_2057 ( N_noxref_8_c_2889_n N_noxref_9_M17_noxref_d ) capacitor \
 c=0.00237422f //x=27.86 //y=1.44 //x2=27.935 //y2=1.095
cc_2058 ( N_noxref_8_c_2915_p N_noxref_9_M17_noxref_d ) capacitor c=0.0020782f \
 //x=28.235 //y=0.94 //x2=27.935 //y2=1.095
cc_2059 ( N_noxref_8_c_2916_p N_noxref_9_M17_noxref_d ) capacitor \
 c=0.00356097f //x=28.235 //y=1.595 //x2=27.935 //y2=1.095
cc_2060 ( N_noxref_8_c_2917_p N_noxref_9_M17_noxref_d ) capacitor \
 c=0.00139206f //x=28.39 //y=1.095 //x2=27.935 //y2=1.095
cc_2061 ( N_noxref_8_c_2918_p N_noxref_9_M17_noxref_d ) capacitor \
 c=0.00237422f //x=28.39 //y=1.44 //x2=27.935 //y2=1.095
cc_2062 ( N_noxref_8_c_2606_n N_VDD_c_3378_n ) capacitor c=0.00621329f \
 //x=17.21 //y=5.335 //x2=28.61 //y2=7.58
cc_2063 ( N_noxref_8_c_2638_n N_VDD_c_3378_n ) capacitor c=0.0062719f \
 //x=18.095 //y=5.335 //x2=28.61 //y2=7.58
cc_2064 ( N_noxref_8_c_2777_n N_VDD_c_3378_n ) capacitor c=0.00256019f \
 //x=18.21 //y=5.56 //x2=28.61 //y2=7.58
cc_2065 ( N_noxref_8_c_2779_n N_VDD_c_3378_n ) capacitor c=0.00829238f \
 //x=18.905 //y=5.335 //x2=28.61 //y2=7.58
cc_2066 ( N_noxref_8_c_2711_n N_VDD_c_3378_n ) capacitor c=4.99876e-19 \
 //x=18.99 //y=4.405 //x2=28.61 //y2=7.58
cc_2067 ( N_noxref_8_c_2608_n N_VDD_c_3378_n ) capacitor c=0.00261804f \
 //x=16.452 //y=5.335 //x2=28.61 //y2=7.58
cc_2068 ( N_noxref_8_c_2643_n N_VDD_c_3378_n ) capacitor c=0.00270108f \
 //x=17.33 //y=5.335 //x2=28.61 //y2=7.58
cc_2069 ( N_noxref_8_c_2817_n N_VDD_c_3378_n ) capacitor c=3.94104e-19 \
 //x=18.99 //y=4.25 //x2=28.61 //y2=7.58
cc_2070 ( N_noxref_8_c_2615_n N_VDD_c_3378_n ) capacitor c=0.0024232f \
 //x=16.45 //y=5.56 //x2=28.61 //y2=7.58
cc_2071 ( N_noxref_8_c_2668_n N_VDD_c_3378_n ) capacitor c=0.0024232f \
 //x=17.33 //y=5.56 //x2=28.61 //y2=7.58
cc_2072 ( N_noxref_8_c_2830_n N_VDD_c_3378_n ) capacitor c=0.0024232f \
 //x=18.21 //y=5.56 //x2=28.61 //y2=7.58
cc_2073 ( N_noxref_8_M28_noxref_g N_VDD_c_3524_n ) capacitor c=0.00755544f \
 //x=8.37 //y=6.2 //x2=8.945 //y2=7.585
cc_2074 ( N_noxref_8_M29_noxref_g N_VDD_c_3524_n ) capacitor c=0.00755754f \
 //x=8.81 //y=6.2 //x2=8.945 //y2=7.585
cc_2075 ( N_noxref_8_c_2606_n N_VDD_c_3466_n ) capacitor c=0.00202922f \
 //x=17.21 //y=5.335 //x2=16.805 //y2=7.585
cc_2076 ( N_noxref_8_c_2608_n N_VDD_c_3466_n ) capacitor c=9.3757e-19 \
 //x=16.452 //y=5.335 //x2=16.805 //y2=7.585
cc_2077 ( N_noxref_8_c_2615_n N_VDD_c_3466_n ) capacitor c=0.0138074f \
 //x=16.45 //y=5.56 //x2=16.805 //y2=7.585
cc_2078 ( N_noxref_8_c_2606_n N_VDD_c_3498_n ) capacitor c=0.0017708f \
 //x=17.21 //y=5.335 //x2=17.685 //y2=7.585
cc_2079 ( N_noxref_8_c_2638_n N_VDD_c_3498_n ) capacitor c=0.00202922f \
 //x=18.095 //y=5.335 //x2=17.685 //y2=7.585
cc_2080 ( N_noxref_8_c_2643_n N_VDD_c_3498_n ) capacitor c=9.4822e-19 \
 //x=17.33 //y=5.335 //x2=17.685 //y2=7.585
cc_2081 ( N_noxref_8_c_2668_n N_VDD_c_3498_n ) capacitor c=0.0138074f \
 //x=17.33 //y=5.56 //x2=17.685 //y2=7.585
cc_2082 ( N_noxref_8_c_2638_n N_VDD_c_3566_n ) capacitor c=0.00205906f \
 //x=18.095 //y=5.335 //x2=18.565 //y2=7.585
cc_2083 ( N_noxref_8_c_2777_n N_VDD_c_3566_n ) capacitor c=8.49654e-19 \
 //x=18.21 //y=5.56 //x2=18.565 //y2=7.585
cc_2084 ( N_noxref_8_c_2779_n N_VDD_c_3566_n ) capacitor c=0.00204238f \
 //x=18.905 //y=5.335 //x2=18.565 //y2=7.585
cc_2085 ( N_noxref_8_c_2830_n N_VDD_c_3566_n ) capacitor c=0.0135103f \
 //x=18.21 //y=5.56 //x2=18.565 //y2=7.585
cc_2086 ( N_noxref_8_c_2779_n N_VDD_c_3672_n ) capacitor c=0.00157252f \
 //x=18.905 //y=5.335 //x2=19.56 //y2=7.585
cc_2087 ( N_noxref_8_c_2711_n N_VDD_c_3672_n ) capacitor c=4.02207e-19 \
 //x=18.99 //y=4.405 //x2=19.56 //y2=7.585
cc_2088 ( N_noxref_8_M52_noxref_g N_VDD_c_3674_n ) capacitor c=0.00755544f \
 //x=27.61 //y=6.2 //x2=28.185 //y2=7.585
cc_2089 ( N_noxref_8_M53_noxref_g N_VDD_c_3674_n ) capacitor c=0.00755754f \
 //x=28.05 //y=6.2 //x2=28.185 //y2=7.585
cc_2090 ( N_noxref_8_c_2871_n N_VDD_c_3676_n ) capacitor c=0.00152232f \
 //x=27.87 //y=4.25 //x2=28.61 //y2=7.58
cc_2091 ( N_noxref_8_c_2882_n N_VDD_c_3676_n ) capacitor c=0.00224736f \
 //x=27.87 //y=4.88 //x2=28.61 //y2=7.58
cc_2092 ( N_noxref_8_c_2895_n N_VDD_c_3676_n ) capacitor c=2.63786e-19 \
 //x=27.87 //y=4.88 //x2=28.61 //y2=7.58
cc_2093 ( N_noxref_8_c_2642_n N_VDD_c_3408_n ) capacitor c=4.57229e-19 \
 //x=8.625 //y=4.25 //x2=5.3 //y2=7.585
cc_2094 ( N_noxref_8_c_2642_n N_VDD_c_3414_n ) capacitor c=0.00138987f \
 //x=8.625 //y=4.25 //x2=10.11 //y2=7.585
cc_2095 ( N_noxref_8_c_2605_n N_VDD_c_3414_n ) capacitor c=0.00909809f \
 //x=20.705 //y=4.265 //x2=10.11 //y2=7.585
cc_2096 ( N_noxref_8_c_2664_n N_VDD_c_3414_n ) capacitor c=0.00224736f \
 //x=8.63 //y=4.88 //x2=10.11 //y2=7.585
cc_2097 ( N_noxref_8_c_2682_n N_VDD_c_3414_n ) capacitor c=2.63786e-19 \
 //x=8.63 //y=4.88 //x2=10.11 //y2=7.585
cc_2098 ( N_noxref_8_c_2608_n N_VDD_c_3470_n ) capacitor c=0.0022955f \
 //x=16.452 //y=5.335 //x2=14.92 //y2=7.585
cc_2099 ( N_noxref_8_c_2605_n N_VDD_c_3470_n ) capacitor c=0.00867114f \
 //x=20.705 //y=4.265 //x2=14.92 //y2=7.585
cc_2100 ( N_noxref_8_c_2615_n N_VDD_c_3470_n ) capacitor c=0.00509469f \
 //x=16.45 //y=5.56 //x2=14.92 //y2=7.585
cc_2101 ( N_noxref_8_c_2777_n N_VDD_c_3539_n ) capacitor c=0.00282782f \
 //x=18.21 //y=5.56 //x2=19.73 //y2=7.585
cc_2102 ( N_noxref_8_c_2711_n N_VDD_c_3539_n ) capacitor c=0.00171572f \
 //x=18.99 //y=4.405 //x2=19.73 //y2=7.585
cc_2103 ( N_noxref_8_c_2641_n N_VDD_c_3539_n ) capacitor c=0.0293964f \
 //x=18.99 //y=5.25 //x2=19.73 //y2=7.585
cc_2104 ( N_noxref_8_c_2817_n N_VDD_c_3539_n ) capacitor c=0.0050542f \
 //x=18.99 //y=4.25 //x2=19.73 //y2=7.585
cc_2105 ( N_noxref_8_c_2605_n N_VDD_c_3539_n ) capacitor c=0.00857183f \
 //x=20.705 //y=4.265 //x2=19.73 //y2=7.585
cc_2106 ( N_noxref_8_c_2830_n N_VDD_c_3539_n ) capacitor c=0.00777981f \
 //x=18.21 //y=5.56 //x2=19.73 //y2=7.585
cc_2107 ( N_noxref_8_c_2871_n N_VDD_c_3613_n ) capacitor c=3.33168e-19 \
 //x=27.87 //y=4.25 //x2=24.54 //y2=7.585
cc_2108 ( N_noxref_8_c_2849_n N_VDD_c_3613_n ) capacitor c=0.0197375f \
 //x=23.275 //y=4.27 //x2=24.54 //y2=7.585
cc_2109 ( N_noxref_8_M28_noxref_g N_VDD_M27_noxref_d ) capacitor c=0.015318f \
 //x=8.37 //y=6.2 //x2=8.005 //y2=5.2
cc_2110 ( N_noxref_8_M29_noxref_g N_VDD_M29_noxref_d ) capacitor c=0.0394719f \
 //x=8.81 //y=6.2 //x2=8.885 //y2=5.2
cc_2111 ( N_noxref_8_c_2608_n N_VDD_M36_noxref_s ) capacitor c=0.0442713f \
 //x=16.452 //y=5.335 //x2=15.875 //y2=5.2
cc_2112 ( N_noxref_8_c_2643_n N_VDD_M36_noxref_s ) capacitor c=7.80122e-19 \
 //x=17.33 //y=5.335 //x2=15.875 //y2=5.2
cc_2113 ( N_noxref_8_c_2615_n N_VDD_M36_noxref_s ) capacitor c=0.09305f \
 //x=16.45 //y=5.56 //x2=15.875 //y2=5.2
cc_2114 ( N_noxref_8_c_2606_n N_VDD_M37_noxref_d ) capacitor c=0.00700141f \
 //x=17.21 //y=5.335 //x2=16.745 //y2=5.2
cc_2115 ( N_noxref_8_c_2615_n N_VDD_M37_noxref_d ) capacitor c=0.0674491f \
 //x=16.45 //y=5.56 //x2=16.745 //y2=5.2
cc_2116 ( N_noxref_8_c_2668_n N_VDD_M37_noxref_d ) capacitor c=0.0674762f \
 //x=17.33 //y=5.56 //x2=16.745 //y2=5.2
cc_2117 ( N_noxref_8_c_2638_n N_VDD_M39_noxref_d ) capacitor c=0.00700141f \
 //x=18.095 //y=5.335 //x2=17.625 //y2=5.2
cc_2118 ( N_noxref_8_c_2668_n N_VDD_M39_noxref_d ) capacitor c=0.067493f \
 //x=17.33 //y=5.56 //x2=17.625 //y2=5.2
cc_2119 ( N_noxref_8_c_2830_n N_VDD_M39_noxref_d ) capacitor c=0.0674979f \
 //x=18.21 //y=5.56 //x2=17.625 //y2=5.2
cc_2120 ( N_noxref_8_c_2779_n N_VDD_M41_noxref_d ) capacitor c=0.00700141f \
 //x=18.905 //y=5.335 //x2=18.505 //y2=5.2
cc_2121 ( N_noxref_8_c_2830_n N_VDD_M41_noxref_d ) capacitor c=0.0675002f \
 //x=18.21 //y=5.56 //x2=18.505 //y2=5.2
cc_2122 ( N_noxref_8_c_2777_n N_VDD_M42_noxref_s ) capacitor c=0.00492616f \
 //x=18.21 //y=5.56 //x2=20.685 //y2=5.2
cc_2123 ( N_noxref_8_c_2779_n N_VDD_M42_noxref_s ) capacitor c=9.42705e-19 \
 //x=18.905 //y=5.335 //x2=20.685 //y2=5.2
cc_2124 ( N_noxref_8_c_2643_n N_VDD_M42_noxref_s ) capacitor c=2.11884e-19 \
 //x=17.33 //y=5.335 //x2=20.685 //y2=5.2
cc_2125 ( N_noxref_8_c_2849_n N_VDD_M48_noxref_s ) capacitor c=5.34117e-19 \
 //x=23.275 //y=4.27 //x2=25.495 //y2=5.2
cc_2126 ( N_noxref_8_M52_noxref_g N_VDD_M51_noxref_d ) capacitor c=0.015318f \
 //x=27.61 //y=6.2 //x2=27.245 //y2=5.2
cc_2127 ( N_noxref_8_M53_noxref_g N_VDD_M53_noxref_d ) capacitor c=0.0394719f \
 //x=28.05 //y=6.2 //x2=28.125 //y2=5.2
cc_2128 ( N_noxref_8_c_2597_n N_noxref_13_c_3964_n ) capacitor c=0.00175918f \
 //x=8.63 //y=2.375 //x2=9.285 //y2=0.72
cc_2129 ( N_noxref_8_c_2660_n N_noxref_13_c_3964_n ) capacitor c=0.00117306f \
 //x=8.63 //y=2.26 //x2=9.285 //y2=0.72
cc_2130 ( N_noxref_8_c_2675_n N_noxref_13_c_3964_n ) capacitor c=0.0206349f \
 //x=8.62 //y=1.095 //x2=9.285 //y2=0.72
cc_2131 ( N_noxref_8_c_2757_n N_noxref_13_c_3964_n ) capacitor c=0.00825432f \
 //x=9.15 //y=1.095 //x2=9.285 //y2=0.72
cc_2132 ( N_noxref_8_c_2678_n N_noxref_13_c_3964_n ) capacitor c=2.20712e-19 \
 //x=8.63 //y=2.26 //x2=9.285 //y2=0.72
cc_2133 ( N_noxref_8_c_2676_n N_noxref_13_c_3967_n ) capacitor c=0.0071177f \
 //x=8.62 //y=1.44 //x2=8.4 //y2=1.175
cc_2134 ( N_noxref_8_c_2675_n N_noxref_13_M5_noxref_s ) capacitor c=0.0071177f \
 //x=8.62 //y=1.095 //x2=8.265 //y2=0.555
cc_2135 ( N_noxref_8_c_2677_n N_noxref_13_M5_noxref_s ) capacitor c=0.0071177f \
 //x=8.62 //y=1.75 //x2=8.265 //y2=0.555
cc_2136 ( N_noxref_8_c_2757_n N_noxref_13_M5_noxref_s ) capacitor c=0.015333f \
 //x=9.15 //y=1.095 //x2=8.265 //y2=0.555
cc_2137 ( N_noxref_8_c_2759_n N_noxref_13_M5_noxref_s ) capacitor \
 c=0.00248746f //x=9.15 //y=1.44 //x2=8.265 //y2=0.555
cc_2138 ( N_noxref_8_c_2605_n N_noxref_15_c_4097_n ) capacitor c=0.031148f \
 //x=20.705 //y=4.265 //x2=13.44 //y2=4.365
cc_2139 ( N_noxref_8_c_2783_n N_noxref_16_c_4227_n ) capacitor c=0.0036878f \
 //x=18.505 //y=1.305 //x2=18.905 //y2=0.72
cc_2140 ( N_noxref_8_c_2794_n N_noxref_16_c_4227_n ) capacitor c=0.00399931f \
 //x=18.905 //y=1.845 //x2=18.905 //y2=0.72
cc_2141 ( N_noxref_8_M11_noxref_d N_noxref_16_c_4227_n ) capacitor \
 c=0.00910163f //x=18.315 //y=1.095 //x2=18.905 //y2=0.72
cc_2142 ( N_noxref_8_M11_noxref_d N_noxref_16_c_4232_n ) capacitor \
 c=0.00120711f //x=18.315 //y=1.095 //x2=18.02 //y2=1.175
cc_2143 ( N_noxref_8_c_2606_n N_noxref_16_M10_noxref_d ) capacitor \
 c=9.48504e-19 //x=17.21 //y=5.335 //x2=16.78 //y2=1.09
cc_2144 ( N_noxref_8_c_2783_n N_noxref_16_M10_noxref_d ) capacitor \
 c=0.00802417f //x=18.505 //y=1.305 //x2=16.78 //y2=1.09
cc_2145 ( N_noxref_8_c_2783_n N_noxref_16_M11_noxref_s ) capacitor \
 c=0.0098487f //x=18.505 //y=1.305 //x2=17.885 //y2=0.555
cc_2146 ( N_noxref_8_c_2789_n N_noxref_16_M11_noxref_s ) capacitor \
 c=0.0283243f //x=18.505 //y=1.76 //x2=17.885 //y2=0.555
cc_2147 ( N_noxref_8_c_2794_n N_noxref_16_M11_noxref_s ) capacitor \
 c=0.00942148f //x=18.905 //y=1.845 //x2=17.885 //y2=0.555
cc_2148 ( N_noxref_8_c_2817_n N_noxref_16_M11_noxref_s ) capacitor \
 c=0.00108527f //x=18.99 //y=4.25 //x2=17.885 //y2=0.555
cc_2149 ( N_noxref_8_M11_noxref_d N_noxref_16_M11_noxref_s ) capacitor \
 c=0.0279003f //x=18.315 //y=1.095 //x2=17.885 //y2=0.555
cc_2150 ( N_noxref_8_c_2783_n N_noxref_17_M13_noxref_d ) capacitor \
 c=3.20746e-19 //x=18.505 //y=1.305 //x2=21.59 //y2=1.09
cc_2151 ( N_noxref_8_c_2597_n N_GND_c_4452_n ) capacitor c=0.00219894f \
 //x=8.63 //y=2.375 //x2=11.1 //y2=0.175
cc_2152 ( N_noxref_8_c_2783_n N_GND_c_4454_n ) capacitor c=0.00901861f \
 //x=18.505 //y=1.305 //x2=20.72 //y2=0.175
cc_2153 ( N_noxref_8_c_2794_n N_GND_c_4454_n ) capacitor c=0.00713708f \
 //x=18.905 //y=1.845 //x2=20.72 //y2=0.175
cc_2154 ( N_noxref_8_c_2711_n N_GND_c_4454_n ) capacitor c=4.5942e-19 \
 //x=18.99 //y=4.405 //x2=20.72 //y2=0.175
cc_2155 ( N_noxref_8_M11_noxref_d N_GND_c_4454_n ) capacitor c=2.9462e-19 \
 //x=18.315 //y=1.095 //x2=20.72 //y2=0.175
cc_2156 ( N_noxref_8_c_2858_n N_GND_c_4539_n ) capacitor c=0.0021992f \
 //x=27.87 //y=2.375 //x2=28.61 //y2=0.18
cc_2157 ( N_noxref_8_c_2867_n N_GND_c_4539_n ) capacitor c=2.50233e-19 \
 //x=27.87 //y=4.405 //x2=28.61 //y2=0.18
cc_2158 ( N_noxref_8_c_2783_n N_GND_c_4464_n ) capacitor c=0.00543195f \
 //x=18.505 //y=1.305 //x2=20.805 //y2=1.145
cc_2159 ( N_noxref_8_c_2597_n N_GND_c_4386_n ) capacitor c=2.016e-19 //x=8.63 \
 //y=2.375 //x2=9.94 //y2=0.175
cc_2160 ( N_noxref_8_c_2794_n N_GND_c_4436_n ) capacitor c=6.86343e-19 \
 //x=18.905 //y=1.845 //x2=19.56 //y2=0.175
cc_2161 ( N_noxref_8_c_2858_n N_GND_c_4521_n ) capacitor c=2.016e-19 //x=27.87 \
 //y=2.375 //x2=28.61 //y2=0.18
cc_2162 ( N_noxref_8_c_2878_n N_GND_c_4521_n ) capacitor c=0.00246191f \
 //x=27.87 //y=2.26 //x2=28.61 //y2=0.18
cc_2163 ( N_noxref_8_c_2918_p N_GND_c_4521_n ) capacitor c=0.00275764f \
 //x=28.39 //y=1.44 //x2=28.61 //y2=0.18
cc_2164 ( N_noxref_8_c_2660_n N_GND_c_4396_n ) capacitor c=0.00239899f \
 //x=8.63 //y=2.26 //x2=10.11 //y2=0.175
cc_2165 ( N_noxref_8_c_2759_n N_GND_c_4396_n ) capacitor c=0.00262688f \
 //x=9.15 //y=1.44 //x2=10.11 //y2=0.175
cc_2166 ( N_noxref_8_c_2678_n N_GND_c_4396_n ) capacitor c=2.63786e-19 \
 //x=8.63 //y=2.26 //x2=10.11 //y2=0.175
cc_2167 ( N_noxref_8_c_2789_n N_GND_c_4482_n ) capacitor c=0.0045138f \
 //x=18.505 //y=1.76 //x2=19.73 //y2=0.175
cc_2168 ( N_noxref_8_c_2794_n N_GND_c_4482_n ) capacitor c=0.0324453f \
 //x=18.905 //y=1.845 //x2=19.73 //y2=0.175
cc_2169 ( N_noxref_8_c_2858_n N_noxref_19_c_4853_n ) capacitor c=0.00177186f \
 //x=27.87 //y=2.375 //x2=28.525 //y2=0.72
cc_2170 ( N_noxref_8_c_2878_n N_noxref_19_c_4853_n ) capacitor c=0.00117306f \
 //x=27.87 //y=2.26 //x2=28.525 //y2=0.72
cc_2171 ( N_noxref_8_c_2888_n N_noxref_19_c_4853_n ) capacitor c=0.0206349f \
 //x=27.86 //y=1.095 //x2=28.525 //y2=0.72
cc_2172 ( N_noxref_8_c_2917_p N_noxref_19_c_4853_n ) capacitor c=0.00825432f \
 //x=28.39 //y=1.095 //x2=28.525 //y2=0.72
cc_2173 ( N_noxref_8_c_2891_n N_noxref_19_c_4853_n ) capacitor c=2.20712e-19 \
 //x=27.87 //y=2.26 //x2=28.525 //y2=0.72
cc_2174 ( N_noxref_8_c_2889_n N_noxref_19_c_4858_n ) capacitor c=0.0071177f \
 //x=27.86 //y=1.44 //x2=27.64 //y2=1.175
cc_2175 ( N_noxref_8_c_2867_n N_noxref_19_M17_noxref_s ) capacitor \
 c=7.44792e-19 //x=27.87 //y=4.405 //x2=27.505 //y2=0.555
cc_2176 ( N_noxref_8_c_2888_n N_noxref_19_M17_noxref_s ) capacitor \
 c=0.0071177f //x=27.86 //y=1.095 //x2=27.505 //y2=0.555
cc_2177 ( N_noxref_8_c_2890_n N_noxref_19_M17_noxref_s ) capacitor \
 c=0.0071177f //x=27.86 //y=1.75 //x2=27.505 //y2=0.555
cc_2178 ( N_noxref_8_c_2917_p N_noxref_19_M17_noxref_s ) capacitor c=0.015333f \
 //x=28.39 //y=1.095 //x2=27.505 //y2=0.555
cc_2179 ( N_noxref_8_c_2918_p N_noxref_19_M17_noxref_s ) capacitor \
 c=0.00248746f //x=28.39 //y=1.44 //x2=27.505 //y2=0.555
cc_2180 ( N_noxref_9_c_3141_n N_VDD_c_3378_n ) capacitor c=0.00621363f \
 //x=26.83 //y=5.335 //x2=28.61 //y2=7.58
cc_2181 ( N_noxref_9_c_3208_n N_VDD_c_3378_n ) capacitor c=0.00627186f \
 //x=27.715 //y=5.335 //x2=28.61 //y2=7.58
cc_2182 ( N_noxref_9_c_3238_n N_VDD_c_3378_n ) capacitor c=0.00256019f \
 //x=27.83 //y=5.56 //x2=28.61 //y2=7.58
cc_2183 ( N_noxref_9_c_3240_n N_VDD_c_3378_n ) capacitor c=0.00829225f \
 //x=28.525 //y=5.335 //x2=28.61 //y2=7.58
cc_2184 ( N_noxref_9_c_3144_n N_VDD_c_3378_n ) capacitor c=0.00261804f \
 //x=26.072 //y=5.335 //x2=28.61 //y2=7.58
cc_2185 ( N_noxref_9_c_3212_n N_VDD_c_3378_n ) capacitor c=0.00270108f \
 //x=26.95 //y=5.335 //x2=28.61 //y2=7.58
cc_2186 ( N_noxref_9_c_3167_n N_VDD_c_3378_n ) capacitor c=0.0024232f \
 //x=26.07 //y=5.56 //x2=28.61 //y2=7.58
cc_2187 ( N_noxref_9_c_3227_n N_VDD_c_3378_n ) capacitor c=0.0024232f \
 //x=26.95 //y=5.56 //x2=28.61 //y2=7.58
cc_2188 ( N_noxref_9_c_3289_n N_VDD_c_3378_n ) capacitor c=0.0024232f \
 //x=27.83 //y=5.56 //x2=28.61 //y2=7.58
cc_2189 ( N_noxref_9_M46_noxref_g N_VDD_c_3604_n ) capacitor c=0.00755544f \
 //x=22.8 //y=6.2 //x2=23.375 //y2=7.585
cc_2190 ( N_noxref_9_M47_noxref_g N_VDD_c_3604_n ) capacitor c=0.00755754f \
 //x=23.24 //y=6.2 //x2=23.375 //y2=7.585
cc_2191 ( N_noxref_9_c_3141_n N_VDD_c_3609_n ) capacitor c=0.00202922f \
 //x=26.83 //y=5.335 //x2=26.425 //y2=7.585
cc_2192 ( N_noxref_9_c_3144_n N_VDD_c_3609_n ) capacitor c=9.3757e-19 \
 //x=26.072 //y=5.335 //x2=26.425 //y2=7.585
cc_2193 ( N_noxref_9_c_3167_n N_VDD_c_3609_n ) capacitor c=0.0138074f \
 //x=26.07 //y=5.56 //x2=26.425 //y2=7.585
cc_2194 ( N_noxref_9_c_3141_n N_VDD_c_3642_n ) capacitor c=0.0017708f \
 //x=26.83 //y=5.335 //x2=27.305 //y2=7.585
cc_2195 ( N_noxref_9_c_3208_n N_VDD_c_3642_n ) capacitor c=0.00202922f \
 //x=27.715 //y=5.335 //x2=27.305 //y2=7.585
cc_2196 ( N_noxref_9_c_3212_n N_VDD_c_3642_n ) capacitor c=9.4822e-19 \
 //x=26.95 //y=5.335 //x2=27.305 //y2=7.585
cc_2197 ( N_noxref_9_c_3227_n N_VDD_c_3642_n ) capacitor c=0.0138074f \
 //x=26.95 //y=5.56 //x2=27.305 //y2=7.585
cc_2198 ( N_noxref_9_c_3208_n N_VDD_c_3674_n ) capacitor c=0.00205906f \
 //x=27.715 //y=5.335 //x2=28.185 //y2=7.585
cc_2199 ( N_noxref_9_c_3238_n N_VDD_c_3674_n ) capacitor c=8.49654e-19 \
 //x=27.83 //y=5.56 //x2=28.185 //y2=7.585
cc_2200 ( N_noxref_9_c_3240_n N_VDD_c_3674_n ) capacitor c=0.00204238f \
 //x=28.525 //y=5.335 //x2=28.185 //y2=7.585
cc_2201 ( N_noxref_9_c_3289_n N_VDD_c_3674_n ) capacitor c=0.0135103f \
 //x=27.83 //y=5.56 //x2=28.185 //y2=7.585
cc_2202 ( N_noxref_9_c_3238_n N_VDD_c_3676_n ) capacitor c=0.00414616f \
 //x=27.83 //y=5.56 //x2=28.61 //y2=7.58
cc_2203 ( N_noxref_9_c_3240_n N_VDD_c_3676_n ) capacitor c=0.00183742f \
 //x=28.525 //y=5.335 //x2=28.61 //y2=7.58
cc_2204 ( N_noxref_9_c_3211_n N_VDD_c_3676_n ) capacitor c=0.0380473f \
 //x=28.61 //y=5.25 //x2=28.61 //y2=7.58
cc_2205 ( N_noxref_9_c_3289_n N_VDD_c_3676_n ) capacitor c=0.00778106f \
 //x=27.83 //y=5.56 //x2=28.61 //y2=7.58
cc_2206 ( N_noxref_9_c_3144_n N_VDD_c_3613_n ) capacitor c=0.0022955f \
 //x=26.072 //y=5.335 //x2=24.54 //y2=7.585
cc_2207 ( N_noxref_9_c_3107_n N_VDD_c_3613_n ) capacitor c=0.00224736f \
 //x=23.06 //y=4.88 //x2=24.54 //y2=7.585
cc_2208 ( N_noxref_9_c_3167_n N_VDD_c_3613_n ) capacitor c=0.00509469f \
 //x=26.07 //y=5.56 //x2=24.54 //y2=7.585
cc_2209 ( N_noxref_9_c_3120_n N_VDD_c_3613_n ) capacitor c=2.63786e-19 \
 //x=23.06 //y=4.88 //x2=24.54 //y2=7.585
cc_2210 ( N_noxref_9_M46_noxref_g N_VDD_M45_noxref_d ) capacitor c=0.015318f \
 //x=22.8 //y=6.2 //x2=22.435 //y2=5.2
cc_2211 ( N_noxref_9_M47_noxref_g N_VDD_M47_noxref_d ) capacitor c=0.0394719f \
 //x=23.24 //y=6.2 //x2=23.315 //y2=5.2
cc_2212 ( N_noxref_9_c_3144_n N_VDD_M48_noxref_s ) capacitor c=0.0442713f \
 //x=26.072 //y=5.335 //x2=25.495 //y2=5.2
cc_2213 ( N_noxref_9_c_3212_n N_VDD_M48_noxref_s ) capacitor c=7.80122e-19 \
 //x=26.95 //y=5.335 //x2=25.495 //y2=5.2
cc_2214 ( N_noxref_9_c_3167_n N_VDD_M48_noxref_s ) capacitor c=0.09305f \
 //x=26.07 //y=5.56 //x2=25.495 //y2=5.2
cc_2215 ( N_noxref_9_c_3141_n N_VDD_M49_noxref_d ) capacitor c=0.00700141f \
 //x=26.83 //y=5.335 //x2=26.365 //y2=5.2
cc_2216 ( N_noxref_9_c_3167_n N_VDD_M49_noxref_d ) capacitor c=0.0674491f \
 //x=26.07 //y=5.56 //x2=26.365 //y2=5.2
cc_2217 ( N_noxref_9_c_3227_n N_VDD_M49_noxref_d ) capacitor c=0.0674762f \
 //x=26.95 //y=5.56 //x2=26.365 //y2=5.2
cc_2218 ( N_noxref_9_c_3208_n N_VDD_M51_noxref_d ) capacitor c=0.00700141f \
 //x=27.715 //y=5.335 //x2=27.245 //y2=5.2
cc_2219 ( N_noxref_9_c_3227_n N_VDD_M51_noxref_d ) capacitor c=0.067493f \
 //x=26.95 //y=5.56 //x2=27.245 //y2=5.2
cc_2220 ( N_noxref_9_c_3289_n N_VDD_M51_noxref_d ) capacitor c=0.0675031f \
 //x=27.83 //y=5.56 //x2=27.245 //y2=5.2
cc_2221 ( N_noxref_9_c_3240_n N_VDD_M53_noxref_d ) capacitor c=0.00700141f \
 //x=28.525 //y=5.335 //x2=28.125 //y2=5.2
cc_2222 ( N_noxref_9_c_3289_n N_VDD_M53_noxref_d ) capacitor c=0.0675091f \
 //x=27.83 //y=5.56 //x2=28.125 //y2=5.2
cc_2223 ( N_noxref_9_c_3091_n N_noxref_17_c_4296_n ) capacitor c=0.00177186f \
 //x=23.06 //y=2.375 //x2=23.715 //y2=0.72
cc_2224 ( N_noxref_9_c_3103_n N_noxref_17_c_4296_n ) capacitor c=0.00117306f \
 //x=23.06 //y=2.26 //x2=23.715 //y2=0.72
cc_2225 ( N_noxref_9_c_3113_n N_noxref_17_c_4296_n ) capacitor c=0.0206349f \
 //x=23.05 //y=1.095 //x2=23.715 //y2=0.72
cc_2226 ( N_noxref_9_c_3188_n N_noxref_17_c_4296_n ) capacitor c=0.00825432f \
 //x=23.58 //y=1.095 //x2=23.715 //y2=0.72
cc_2227 ( N_noxref_9_c_3116_n N_noxref_17_c_4296_n ) capacitor c=2.20712e-19 \
 //x=23.06 //y=2.26 //x2=23.715 //y2=0.72
cc_2228 ( N_noxref_9_c_3114_n N_noxref_17_c_4299_n ) capacitor c=0.0071177f \
 //x=23.05 //y=1.44 //x2=22.83 //y2=1.175
cc_2229 ( N_noxref_9_c_3113_n N_noxref_17_M14_noxref_s ) capacitor \
 c=0.0071177f //x=23.05 //y=1.095 //x2=22.695 //y2=0.555
cc_2230 ( N_noxref_9_c_3115_n N_noxref_17_M14_noxref_s ) capacitor \
 c=0.0071177f //x=23.05 //y=1.75 //x2=22.695 //y2=0.555
cc_2231 ( N_noxref_9_c_3188_n N_noxref_17_M14_noxref_s ) capacitor c=0.015333f \
 //x=23.58 //y=1.095 //x2=22.695 //y2=0.555
cc_2232 ( N_noxref_9_c_3190_n N_noxref_17_M14_noxref_s ) capacitor \
 c=0.00248746f //x=23.58 //y=1.44 //x2=22.695 //y2=0.555
cc_2233 ( N_noxref_9_c_3091_n N_GND_c_4497_n ) capacitor c=0.0021992f \
 //x=23.06 //y=2.375 //x2=25.53 //y2=0.175
cc_2234 ( N_noxref_9_c_3245_n N_GND_c_4539_n ) capacitor c=0.00901861f \
 //x=28.125 //y=1.305 //x2=28.61 //y2=0.18
cc_2235 ( N_noxref_9_c_3256_n N_GND_c_4539_n ) capacitor c=0.00713708f \
 //x=28.525 //y=1.845 //x2=28.61 //y2=0.18
cc_2236 ( N_noxref_9_M17_noxref_d N_GND_c_4539_n ) capacitor c=2.9462e-19 \
 //x=27.935 //y=1.095 //x2=28.61 //y2=0.18
cc_2237 ( N_noxref_9_c_3091_n N_GND_c_4476_n ) capacitor c=2.016e-19 //x=23.06 \
 //y=2.375 //x2=24.37 //y2=0.175
cc_2238 ( N_noxref_9_c_3251_n N_GND_c_4521_n ) capacitor c=0.00518727f \
 //x=28.125 //y=1.76 //x2=28.61 //y2=0.18
cc_2239 ( N_noxref_9_c_3256_n N_GND_c_4521_n ) capacitor c=0.0384971f \
 //x=28.525 //y=1.845 //x2=28.61 //y2=0.18
cc_2240 ( N_noxref_9_c_3103_n N_GND_c_4522_n ) capacitor c=0.00239899f \
 //x=23.06 //y=2.26 //x2=24.54 //y2=0.175
cc_2241 ( N_noxref_9_c_3190_n N_GND_c_4522_n ) capacitor c=0.00262688f \
 //x=23.58 //y=1.44 //x2=24.54 //y2=0.175
cc_2242 ( N_noxref_9_c_3116_n N_GND_c_4522_n ) capacitor c=2.63786e-19 \
 //x=23.06 //y=2.26 //x2=24.54 //y2=0.175
cc_2243 ( N_noxref_9_c_3245_n N_noxref_19_c_4853_n ) capacitor c=0.00366459f \
 //x=28.125 //y=1.305 //x2=28.525 //y2=0.72
cc_2244 ( N_noxref_9_c_3256_n N_noxref_19_c_4853_n ) capacitor c=0.00383344f \
 //x=28.525 //y=1.845 //x2=28.525 //y2=0.72
cc_2245 ( N_noxref_9_M17_noxref_d N_noxref_19_c_4853_n ) capacitor \
 c=0.00910163f //x=27.935 //y=1.095 //x2=28.525 //y2=0.72
cc_2246 ( N_noxref_9_M17_noxref_d N_noxref_19_c_4858_n ) capacitor \
 c=0.00120711f //x=27.935 //y=1.095 //x2=27.64 //y2=1.175
cc_2247 ( N_noxref_9_c_3141_n N_noxref_19_M16_noxref_d ) capacitor \
 c=9.31851e-19 //x=26.83 //y=5.335 //x2=26.4 //y2=1.09
cc_2248 ( N_noxref_9_c_3245_n N_noxref_19_M16_noxref_d ) capacitor \
 c=0.00803465f //x=28.125 //y=1.305 //x2=26.4 //y2=1.09
cc_2249 ( N_noxref_9_c_3245_n N_noxref_19_M17_noxref_s ) capacitor c=0.011355f \
 //x=28.125 //y=1.305 //x2=27.505 //y2=0.555
cc_2250 ( N_noxref_9_c_3251_n N_noxref_19_M17_noxref_s ) capacitor \
 c=0.0283243f //x=28.125 //y=1.76 //x2=27.505 //y2=0.555
cc_2251 ( N_noxref_9_c_3256_n N_noxref_19_M17_noxref_s ) capacitor \
 c=0.00911719f //x=28.525 //y=1.845 //x2=27.505 //y2=0.555
cc_2252 ( N_noxref_9_c_3276_n N_noxref_19_M17_noxref_s ) capacitor \
 c=0.00129723f //x=28.61 //y=3.88 //x2=27.505 //y2=0.555
cc_2253 ( N_noxref_9_c_3223_n N_noxref_19_M17_noxref_s ) capacitor \
 c=0.00200702f //x=27.485 //y=3.88 //x2=27.505 //y2=0.555
cc_2254 ( N_noxref_9_M17_noxref_d N_noxref_19_M17_noxref_s ) capacitor \
 c=0.0279003f //x=27.935 //y=1.095 //x2=27.505 //y2=0.555
cc_2255 ( N_noxref_9_c_3223_n N_noxref_25_c_5206_n ) capacitor c=7.53071e-19 \
 //x=27.485 //y=3.88 //x2=26.985 //y2=1.77
cc_2256 ( N_noxref_9_c_3223_n N_noxref_25_M15_noxref_s ) capacitor \
 c=0.0020282f //x=27.485 //y=3.88 //x2=24.995 //y2=0.555
cc_2257 ( N_VDD_c_3390_n D ) capacitor c=0.0108498f //x=1.23 //y=7.58 //x2=1.6 \
 //y2=2.77
cc_2258 ( N_VDD_c_3390_n N_D_c_3801_n ) capacitor c=0.00805425f //x=1.23 \
 //y=7.58 //x2=1.6 //y2=4.755
cc_2259 ( N_VDD_M18_noxref_s N_D_c_3801_n ) capacitor c=0.0230396f //x=1.445 \
 //y=5.2 //x2=1.6 //y2=4.755
cc_2260 ( N_VDD_c_3390_n N_D_c_3809_n ) capacitor c=0.00371026f //x=1.23 \
 //y=7.58 //x2=1.6 //y2=4.88
cc_2261 ( N_VDD_M18_noxref_s N_D_c_3809_n ) capacitor c=0.00983413f //x=1.445 \
 //y=5.2 //x2=1.6 //y2=4.88
cc_2262 ( N_VDD_c_3392_n N_D_M18_noxref_g ) capacitor c=0.00755614f //x=2.375 \
 //y=7.585 //x2=1.8 //y2=6.2
cc_2263 ( N_VDD_M18_noxref_s N_D_M18_noxref_g ) capacitor c=0.053419f \
 //x=1.445 //y=5.2 //x2=1.8 //y2=6.2
cc_2264 ( N_VDD_c_3392_n N_D_M19_noxref_g ) capacitor c=0.00755544f //x=2.375 \
 //y=7.585 //x2=2.24 //y2=6.2
cc_2265 ( N_VDD_M19_noxref_d N_D_M19_noxref_g ) capacitor c=0.015318f \
 //x=2.315 //y=5.2 //x2=2.24 //y2=6.2
cc_2266 ( N_VDD_c_3390_n N_D_c_3829_n ) capacitor c=0.00594885f //x=1.23 \
 //y=7.58 //x2=1.875 //y2=4.97
cc_2267 ( N_VDD_M18_noxref_s N_D_c_3829_n ) capacitor c=0.00633126f //x=1.445 \
 //y=5.2 //x2=1.875 //y2=4.97
cc_2268 ( N_VDD_c_3414_n N_noxref_15_c_4106_n ) capacitor c=3.33596e-19 \
 //x=10.11 //y=7.585 //x2=13.44 //y2=4.25
cc_2269 ( N_VDD_c_3470_n N_noxref_15_c_4106_n ) capacitor c=0.00139559f \
 //x=14.92 //y=7.585 //x2=13.44 //y2=4.25
cc_2270 ( N_VDD_c_3470_n N_noxref_15_c_4108_n ) capacitor c=0.00224736f \
 //x=14.92 //y=7.585 //x2=13.44 //y2=4.88
cc_2271 ( N_VDD_c_3461_n N_noxref_15_M34_noxref_g ) capacitor c=0.00755544f \
 //x=13.755 //y=7.585 //x2=13.18 //y2=6.2
cc_2272 ( N_VDD_M33_noxref_d N_noxref_15_M34_noxref_g ) capacitor c=0.015318f \
 //x=12.815 //y=5.2 //x2=13.18 //y2=6.2
cc_2273 ( N_VDD_c_3461_n N_noxref_15_M35_noxref_g ) capacitor c=0.00755754f \
 //x=13.755 //y=7.585 //x2=13.62 //y2=6.2
cc_2274 ( N_VDD_M35_noxref_d N_noxref_15_M35_noxref_g ) capacitor c=0.0394719f \
 //x=13.695 //y=5.2 //x2=13.62 //y2=6.2
cc_2275 ( N_VDD_c_3470_n N_noxref_15_c_4139_n ) capacitor c=2.63786e-19 \
 //x=14.92 //y=7.585 //x2=13.44 //y2=4.88
cc_2276 ( N_VDD_M18_noxref_s N_GND_c_4579_n ) capacitor c=5.21561e-19 \
 //x=1.445 //y=5.2 //x2=1.565 //y2=1.145
cc_2277 ( N_VDD_c_3390_n N_GND_c_4580_n ) capacitor c=0.00989514f //x=1.23 \
 //y=7.58 //x2=1.23 //y2=0.18
cc_2278 ( N_VDD_c_3676_n N_GND_c_4521_n ) capacitor c=0.00989514f //x=28.61 \
 //y=7.58 //x2=28.61 //y2=0.18
cc_2279 ( N_VDD_c_3408_n N_GND_c_4388_n ) capacitor c=0.00897722f //x=5.3 \
 //y=7.585 //x2=5.3 //y2=0.175
cc_2280 ( N_VDD_c_3414_n N_GND_c_4396_n ) capacitor c=0.00648134f //x=10.11 \
 //y=7.585 //x2=10.11 //y2=0.175
cc_2281 ( N_VDD_c_3470_n N_GND_c_4437_n ) capacitor c=0.00648088f //x=14.92 \
 //y=7.585 //x2=14.92 //y2=0.175
cc_2282 ( N_VDD_c_3539_n N_GND_c_4482_n ) capacitor c=0.00663779f //x=19.73 \
 //y=7.585 //x2=19.73 //y2=0.175
cc_2283 ( N_VDD_c_3613_n N_GND_c_4522_n ) capacitor c=0.00654453f //x=24.54 \
 //y=7.585 //x2=24.54 //y2=0.175
cc_2284 ( N_D_c_3815_n N_GND_c_4587_n ) capacitor c=3.97665e-19 //x=1.3 \
 //y=1.055 //x2=1.565 //y2=1.015
cc_2285 ( N_D_c_3844_p N_GND_c_4587_n ) capacitor c=0.00864776f //x=1.675 \
 //y=0.9 //x2=1.565 //y2=1.015
cc_2286 ( N_D_c_3821_n N_GND_c_4587_n ) capacitor c=4.45447e-19 //x=1.83 \
 //y=1.055 //x2=1.565 //y2=1.015
cc_2287 ( N_D_c_3798_n N_GND_c_4579_n ) capacitor c=0.00849742f //x=1.6 \
 //y=2.375 //x2=1.565 //y2=1.145
cc_2288 ( N_D_c_3805_n N_GND_c_4579_n ) capacitor c=2.22883e-19 //x=1.6 \
 //y=2.26 //x2=1.565 //y2=1.145
cc_2289 ( N_D_c_3815_n N_GND_c_4579_n ) capacitor c=0.00142616f //x=1.3 \
 //y=1.055 //x2=1.565 //y2=1.145
cc_2290 ( N_D_c_3816_n N_GND_c_4579_n ) capacitor c=0.00411286f //x=1.3 \
 //y=1.4 //x2=1.565 //y2=1.145
cc_2291 ( N_D_c_3817_n N_GND_c_4579_n ) capacitor c=4.86145e-19 //x=1.3 \
 //y=1.71 //x2=1.565 //y2=1.145
cc_2292 ( N_D_c_3844_p N_GND_c_4579_n ) capacitor c=7.3749e-19 //x=1.675 \
 //y=0.9 //x2=1.565 //y2=1.145
cc_2293 ( N_D_c_3852_p N_GND_c_4579_n ) capacitor c=6.35695e-19 //x=1.675 \
 //y=1.555 //x2=1.565 //y2=1.145
cc_2294 ( N_D_c_3821_n N_GND_c_4579_n ) capacitor c=0.0017438f //x=1.83 \
 //y=1.055 //x2=1.565 //y2=1.145
cc_2295 ( N_D_c_3823_n N_GND_c_4579_n ) capacitor c=0.00276804f //x=1.83 \
 //y=1.4 //x2=1.565 //y2=1.145
cc_2296 ( N_D_c_3815_n N_GND_c_4384_n ) capacitor c=0.00680635f //x=1.3 \
 //y=1.055 //x2=5.13 //y2=0.175
cc_2297 ( D N_GND_c_4580_n ) capacitor c=0.0126319f //x=1.6 //y=2.77 //x2=1.23 \
 //y2=0.18
cc_2298 ( N_D_c_3798_n N_GND_c_4580_n ) capacitor c=0.00779049f //x=1.6 \
 //y=2.375 //x2=1.23 //y2=0.18
cc_2299 ( N_D_c_3805_n N_GND_c_4580_n ) capacitor c=0.00394776f //x=1.6 \
 //y=2.26 //x2=1.23 //y2=0.18
cc_2300 ( N_D_c_3817_n N_GND_c_4580_n ) capacitor c=0.00295461f //x=1.3 \
 //y=1.71 //x2=1.23 //y2=0.18
cc_2301 ( N_D_c_3818_n N_GND_c_4580_n ) capacitor c=0.0112432f //x=1.3 \
 //y=2.095 //x2=1.23 //y2=0.18
cc_2302 ( N_D_c_3798_n N_GND_M0_noxref_d ) capacitor c=4.4417e-19 //x=1.6 \
 //y=2.375 //x2=1.375 //y2=1.055
cc_2303 ( N_D_c_3815_n N_GND_M0_noxref_d ) capacitor c=0.00184354f //x=1.3 \
 //y=1.055 //x2=1.375 //y2=1.055
cc_2304 ( N_D_c_3816_n N_GND_M0_noxref_d ) capacitor c=0.00210798f //x=1.3 \
 //y=1.4 //x2=1.375 //y2=1.055
cc_2305 ( N_D_c_3844_p N_GND_M0_noxref_d ) capacitor c=0.00474029f //x=1.675 \
 //y=0.9 //x2=1.375 //y2=1.055
cc_2306 ( N_D_c_3852_p N_GND_M0_noxref_d ) capacitor c=0.00166857f //x=1.675 \
 //y=1.555 //x2=1.375 //y2=1.055
cc_2307 ( N_D_c_3821_n N_GND_M0_noxref_d ) capacitor c=0.00230174f //x=1.83 \
 //y=1.055 //x2=1.375 //y2=1.055
cc_2308 ( N_D_c_3823_n N_GND_M0_noxref_d ) capacitor c=0.00210798f //x=1.83 \
 //y=1.4 //x2=1.375 //y2=1.055
cc_2309 ( N_D_c_3818_n N_noxref_20_c_4909_n ) capacitor c=0.00267608f //x=1.3 \
 //y=2.095 //x2=1.08 //y2=1.685
cc_2310 ( N_D_c_3798_n N_noxref_20_c_4910_n ) capacitor c=0.00428451f //x=1.6 \
 //y=2.375 //x2=1.965 //y2=1.77
cc_2311 ( N_D_c_3801_n N_noxref_20_c_4910_n ) capacitor c=3.1252e-19 //x=1.6 \
 //y=4.755 //x2=1.965 //y2=1.77
cc_2312 ( N_D_c_3805_n N_noxref_20_c_4910_n ) capacitor c=0.0104666f //x=1.6 \
 //y=2.26 //x2=1.965 //y2=1.77
cc_2313 ( N_D_c_3817_n N_noxref_20_c_4910_n ) capacitor c=0.00703864f //x=1.3 \
 //y=1.71 //x2=1.965 //y2=1.77
cc_2314 ( N_D_c_3818_n N_noxref_20_c_4910_n ) capacitor c=0.0232409f //x=1.3 \
 //y=2.095 //x2=1.965 //y2=1.77
cc_2315 ( N_D_c_3852_p N_noxref_20_c_4910_n ) capacitor c=0.00588627f \
 //x=1.675 //y=1.555 //x2=1.965 //y2=1.77
cc_2316 ( N_D_c_3823_n N_noxref_20_c_4910_n ) capacitor c=0.00758305f //x=1.83 \
 //y=1.4 //x2=1.965 //y2=1.77
cc_2317 ( N_D_c_3815_n N_noxref_20_M0_noxref_s ) capacitor c=0.0295256f \
 //x=1.3 //y=1.055 //x2=0.945 //y2=0.555
cc_2318 ( N_D_c_3817_n N_noxref_20_M0_noxref_s ) capacitor c=7.99997e-19 \
 //x=1.3 //y=1.71 //x2=0.945 //y2=0.555
cc_2319 ( N_D_c_3818_n N_noxref_20_M0_noxref_s ) capacitor c=0.00122123f \
 //x=1.3 //y=2.095 //x2=0.945 //y2=0.555
cc_2320 ( N_D_c_3821_n N_noxref_20_M0_noxref_s ) capacitor c=0.0125924f \
 //x=1.83 //y=1.055 //x2=0.945 //y2=0.555
cc_2321 ( N_noxref_12_c_3901_n N_GND_c_4351_n ) capacitor c=0.0079063f \
 //x=3.505 //y=1.175 //x2=6.29 //y2=0.175
cc_2322 ( N_noxref_12_c_3917_p N_GND_c_4351_n ) capacitor c=0.00674228f \
 //x=3.59 //y=0.805 //x2=6.29 //y2=0.175
cc_2323 ( N_noxref_12_c_3880_n N_GND_c_4351_n ) capacitor c=0.00960819f \
 //x=4.475 //y=0.72 //x2=6.29 //y2=0.175
cc_2324 ( N_noxref_12_c_3919_p N_GND_c_4351_n ) capacitor c=0.00232964f \
 //x=4.56 //y=0.805 //x2=6.29 //y2=0.175
cc_2325 ( N_noxref_12_M1_noxref_d N_GND_c_4351_n ) capacitor c=0.0134285f \
 //x=2.35 //y=1.09 //x2=6.29 //y2=0.175
cc_2326 ( N_noxref_12_M1_noxref_d N_GND_c_4579_n ) capacitor c=0.0156367f \
 //x=2.35 //y=1.09 //x2=1.565 //y2=1.145
cc_2327 ( N_noxref_12_c_3901_n N_GND_c_4384_n ) capacitor c=0.0080792f \
 //x=3.505 //y=1.175 //x2=5.13 //y2=0.175
cc_2328 ( N_noxref_12_c_3917_p N_GND_c_4384_n ) capacitor c=0.0140604f \
 //x=3.59 //y=0.805 //x2=5.13 //y2=0.175
cc_2329 ( N_noxref_12_c_3880_n N_GND_c_4384_n ) capacitor c=0.0364637f \
 //x=4.475 //y=0.72 //x2=5.13 //y2=0.175
cc_2330 ( N_noxref_12_c_3919_p N_GND_c_4384_n ) capacitor c=0.013886f //x=4.56 \
 //y=0.805 //x2=5.13 //y2=0.175
cc_2331 ( N_noxref_12_M2_noxref_s N_GND_c_4580_n ) capacitor c=8.16352e-19 \
 //x=3.455 //y=0.555 //x2=1.23 //y2=0.18
cc_2332 ( N_noxref_12_c_3901_n N_GND_c_4521_n ) capacitor c=3.54249e-19 \
 //x=3.505 //y=1.175 //x2=28.61 //y2=0.18
cc_2333 ( N_noxref_12_c_3880_n N_GND_c_4521_n ) capacitor c=0.00283214f \
 //x=4.475 //y=0.72 //x2=28.61 //y2=0.18
cc_2334 ( N_noxref_12_M1_noxref_d N_GND_c_4521_n ) capacitor c=2.7648e-19 \
 //x=2.35 //y=1.09 //x2=28.61 //y2=0.18
cc_2335 ( N_noxref_12_c_3919_p N_GND_c_4388_n ) capacitor c=0.037873f //x=4.56 \
 //y=0.805 //x2=5.3 //y2=0.175
cc_2336 ( N_noxref_12_M2_noxref_s N_GND_c_4388_n ) capacitor c=0.0051897f \
 //x=3.455 //y=0.555 //x2=5.3 //y2=0.175
cc_2337 ( N_noxref_12_M1_noxref_d N_GND_M0_noxref_d ) capacitor c=3.12752e-19 \
 //x=2.35 //y=1.09 //x2=1.375 //y2=1.055
cc_2338 ( N_noxref_12_c_3917_p N_noxref_20_c_4921_n ) capacitor c=2.15937e-19 \
 //x=3.59 //y=0.805 //x2=2.05 //y2=0.805
cc_2339 ( N_noxref_12_c_3901_n N_noxref_20_c_4899_n ) capacitor c=0.0132582f \
 //x=3.505 //y=1.175 //x2=2.935 //y2=0.72
cc_2340 ( N_noxref_12_M1_noxref_d N_noxref_20_c_4899_n ) capacitor c=0.016458f \
 //x=2.35 //y=1.09 //x2=2.935 //y2=0.72
cc_2341 ( N_noxref_12_c_3901_n N_noxref_20_c_4901_n ) capacitor c=0.00954167f \
 //x=3.505 //y=1.175 //x2=2.935 //y2=1.77
cc_2342 ( N_noxref_12_M1_noxref_d N_noxref_20_c_4901_n ) capacitor \
 c=0.0152611f //x=2.35 //y=1.09 //x2=2.935 //y2=1.77
cc_2343 ( N_noxref_12_c_3901_n N_noxref_20_M0_noxref_s ) capacitor c=0.023368f \
 //x=3.505 //y=1.175 //x2=0.945 //y2=0.555
cc_2344 ( N_noxref_12_c_3917_p N_noxref_20_M0_noxref_s ) capacitor \
 c=0.0175461f //x=3.59 //y=0.805 //x2=0.945 //y2=0.555
cc_2345 ( N_noxref_12_c_3919_p N_noxref_20_M0_noxref_s ) capacitor \
 c=2.98576e-19 //x=4.56 //y=0.805 //x2=0.945 //y2=0.555
cc_2346 ( N_noxref_12_M1_noxref_d N_noxref_20_M0_noxref_s ) capacitor \
 c=0.0187969f //x=2.35 //y=1.09 //x2=0.945 //y2=0.555
cc_2347 ( N_noxref_12_M2_noxref_s N_noxref_20_M0_noxref_s ) capacitor \
 c=0.0210819f //x=3.455 //y=0.555 //x2=0.945 //y2=0.555
cc_2348 ( N_noxref_12_c_3919_p N_noxref_21_M3_noxref_s ) capacitor \
 c=0.00368328f //x=4.56 //y=0.805 //x2=5.755 //y2=0.555
cc_2349 ( N_noxref_12_M2_noxref_s N_noxref_21_M3_noxref_s ) capacitor \
 c=0.00125282f //x=3.455 //y=0.555 //x2=5.755 //y2=0.555
cc_2350 ( N_noxref_13_c_3945_n N_GND_c_4452_n ) capacitor c=0.00533679f \
 //x=8.315 //y=1.175 //x2=11.1 //y2=0.175
cc_2351 ( N_noxref_13_c_3986_p N_GND_c_4452_n ) capacitor c=0.00690955f \
 //x=8.4 //y=0.805 //x2=11.1 //y2=0.175
cc_2352 ( N_noxref_13_c_3964_n N_GND_c_4452_n ) capacitor c=0.0100715f \
 //x=9.285 //y=0.72 //x2=11.1 //y2=0.175
cc_2353 ( N_noxref_13_c_3988_p N_GND_c_4452_n ) capacitor c=0.00232964f \
 //x=9.37 //y=0.805 //x2=11.1 //y2=0.175
cc_2354 ( N_noxref_13_M4_noxref_d N_GND_c_4452_n ) capacitor c=0.0134285f \
 //x=7.16 //y=1.09 //x2=11.1 //y2=0.175
cc_2355 ( N_noxref_13_M4_noxref_d N_GND_c_4361_n ) capacitor c=0.0154456f \
 //x=7.16 //y=1.09 //x2=6.375 //y2=1.145
cc_2356 ( N_noxref_13_c_3945_n N_GND_c_4386_n ) capacitor c=0.0080792f \
 //x=8.315 //y=1.175 //x2=9.94 //y2=0.175
cc_2357 ( N_noxref_13_c_3986_p N_GND_c_4386_n ) capacitor c=0.0140604f //x=8.4 \
 //y=0.805 //x2=9.94 //y2=0.175
cc_2358 ( N_noxref_13_c_3964_n N_GND_c_4386_n ) capacitor c=0.0364637f \
 //x=9.285 //y=0.72 //x2=9.94 //y2=0.175
cc_2359 ( N_noxref_13_c_3988_p N_GND_c_4386_n ) capacitor c=0.013886f //x=9.37 \
 //y=0.805 //x2=9.94 //y2=0.175
cc_2360 ( N_noxref_13_c_3945_n N_GND_c_4521_n ) capacitor c=3.54249e-19 \
 //x=8.315 //y=1.175 //x2=28.61 //y2=0.18
cc_2361 ( N_noxref_13_c_3964_n N_GND_c_4521_n ) capacitor c=0.00283214f \
 //x=9.285 //y=0.72 //x2=28.61 //y2=0.18
cc_2362 ( N_noxref_13_M4_noxref_d N_GND_c_4521_n ) capacitor c=2.7648e-19 \
 //x=7.16 //y=1.09 //x2=28.61 //y2=0.18
cc_2363 ( N_noxref_13_M5_noxref_s N_GND_c_4388_n ) capacitor c=8.16352e-19 \
 //x=8.265 //y=0.555 //x2=5.3 //y2=0.175
cc_2364 ( N_noxref_13_c_3988_p N_GND_c_4396_n ) capacitor c=0.037873f //x=9.37 \
 //y=0.805 //x2=10.11 //y2=0.175
cc_2365 ( N_noxref_13_M5_noxref_s N_GND_c_4396_n ) capacitor c=0.0051897f \
 //x=8.265 //y=0.555 //x2=10.11 //y2=0.175
cc_2366 ( N_noxref_13_M4_noxref_d N_GND_M3_noxref_d ) capacitor c=3.12752e-19 \
 //x=7.16 //y=1.09 //x2=6.185 //y2=1.055
cc_2367 ( N_noxref_13_c_3986_p N_noxref_21_c_4982_n ) capacitor c=2.15937e-19 \
 //x=8.4 //y=0.805 //x2=6.86 //y2=0.805
cc_2368 ( N_noxref_13_c_3945_n N_noxref_21_c_4969_n ) capacitor c=0.0131398f \
 //x=8.315 //y=1.175 //x2=7.745 //y2=0.72
cc_2369 ( N_noxref_13_M4_noxref_d N_noxref_21_c_4969_n ) capacitor \
 c=0.0160925f //x=7.16 //y=1.09 //x2=7.745 //y2=0.72
cc_2370 ( N_noxref_13_c_3945_n N_noxref_21_c_4962_n ) capacitor c=0.00950181f \
 //x=8.315 //y=1.175 //x2=7.745 //y2=1.77
cc_2371 ( N_noxref_13_M4_noxref_d N_noxref_21_c_4962_n ) capacitor \
 c=0.0152032f //x=7.16 //y=1.09 //x2=7.745 //y2=1.77
cc_2372 ( N_noxref_13_c_3945_n N_noxref_21_M3_noxref_s ) capacitor \
 c=0.0230929f //x=8.315 //y=1.175 //x2=5.755 //y2=0.555
cc_2373 ( N_noxref_13_c_3986_p N_noxref_21_M3_noxref_s ) capacitor \
 c=0.0175461f //x=8.4 //y=0.805 //x2=5.755 //y2=0.555
cc_2374 ( N_noxref_13_c_3988_p N_noxref_21_M3_noxref_s ) capacitor \
 c=2.98576e-19 //x=9.37 //y=0.805 //x2=5.755 //y2=0.555
cc_2375 ( N_noxref_13_M4_noxref_d N_noxref_21_M3_noxref_s ) capacitor \
 c=0.0187685f //x=7.16 //y=1.09 //x2=5.755 //y2=0.555
cc_2376 ( N_noxref_13_M5_noxref_s N_noxref_21_M3_noxref_s ) capacitor \
 c=0.0210819f //x=8.265 //y=0.555 //x2=5.755 //y2=0.555
cc_2377 ( N_noxref_13_c_3988_p N_noxref_22_M6_noxref_s ) capacitor \
 c=0.00368328f //x=9.37 //y=0.805 //x2=10.565 //y2=0.555
cc_2378 ( N_noxref_13_M5_noxref_s N_noxref_22_M6_noxref_s ) capacitor \
 c=0.00125282f //x=8.265 //y=0.555 //x2=10.565 //y2=0.555
cc_2379 ( N_noxref_14_c_4014_n N_noxref_15_c_4089_n ) capacitor c=0.00177186f \
 //x=14.095 //y=0.72 //x2=13.44 //y2=2.375
cc_2380 ( N_noxref_14_M8_noxref_s N_noxref_15_c_4097_n ) capacitor \
 c=7.26988e-19 //x=13.075 //y=0.555 //x2=13.44 //y2=4.365
cc_2381 ( N_noxref_14_c_4014_n N_noxref_15_c_4107_n ) capacitor c=0.00117306f \
 //x=14.095 //y=0.72 //x2=13.44 //y2=2.26
cc_2382 ( N_noxref_14_c_4014_n N_noxref_15_c_4118_n ) capacitor c=0.0206349f \
 //x=14.095 //y=0.72 //x2=13.43 //y2=1.095
cc_2383 ( N_noxref_14_M8_noxref_s N_noxref_15_c_4118_n ) capacitor \
 c=0.0071177f //x=13.075 //y=0.555 //x2=13.43 //y2=1.095
cc_2384 ( N_noxref_14_c_4017_n N_noxref_15_c_4120_n ) capacitor c=0.0071177f \
 //x=13.21 //y=1.175 //x2=13.43 //y2=1.44
cc_2385 ( N_noxref_14_M8_noxref_s N_noxref_15_c_4123_n ) capacitor \
 c=0.0071177f //x=13.075 //y=0.555 //x2=13.43 //y2=1.75
cc_2386 ( N_noxref_14_c_4014_n N_noxref_15_c_4130_n ) capacitor c=0.00825432f \
 //x=14.095 //y=0.72 //x2=13.96 //y2=1.095
cc_2387 ( N_noxref_14_M8_noxref_s N_noxref_15_c_4130_n ) capacitor c=0.015333f \
 //x=13.075 //y=0.555 //x2=13.96 //y2=1.095
cc_2388 ( N_noxref_14_M8_noxref_s N_noxref_15_c_4132_n ) capacitor \
 c=0.00248746f //x=13.075 //y=0.555 //x2=13.96 //y2=1.44
cc_2389 ( N_noxref_14_c_4014_n N_noxref_15_c_4136_n ) capacitor c=2.20712e-19 \
 //x=14.095 //y=0.72 //x2=13.44 //y2=2.26
cc_2390 ( N_noxref_14_c_4026_n N_GND_c_4416_n ) capacitor c=0.00533679f \
 //x=13.125 //y=1.175 //x2=15.91 //y2=0.175
cc_2391 ( N_noxref_14_c_4058_p N_GND_c_4416_n ) capacitor c=0.00616247f \
 //x=13.21 //y=0.805 //x2=15.91 //y2=0.175
cc_2392 ( N_noxref_14_c_4014_n N_GND_c_4416_n ) capacitor c=0.00963654f \
 //x=14.095 //y=0.72 //x2=15.91 //y2=0.175
cc_2393 ( N_noxref_14_c_4060_p N_GND_c_4416_n ) capacitor c=0.00232964f \
 //x=14.18 //y=0.805 //x2=15.91 //y2=0.175
cc_2394 ( N_noxref_14_M7_noxref_d N_GND_c_4416_n ) capacitor c=0.0134285f \
 //x=11.97 //y=1.09 //x2=15.91 //y2=0.175
cc_2395 ( N_noxref_14_M7_noxref_d N_GND_c_4373_n ) capacitor c=0.0154456f \
 //x=11.97 //y=1.09 //x2=11.185 //y2=1.145
cc_2396 ( N_noxref_14_c_4026_n N_GND_c_4387_n ) capacitor c=0.0080792f \
 //x=13.125 //y=1.175 //x2=14.75 //y2=0.175
cc_2397 ( N_noxref_14_c_4058_p N_GND_c_4387_n ) capacitor c=0.0140604f \
 //x=13.21 //y=0.805 //x2=14.75 //y2=0.175
cc_2398 ( N_noxref_14_c_4014_n N_GND_c_4387_n ) capacitor c=0.0364637f \
 //x=14.095 //y=0.72 //x2=14.75 //y2=0.175
cc_2399 ( N_noxref_14_c_4060_p N_GND_c_4387_n ) capacitor c=0.013886f \
 //x=14.18 //y=0.805 //x2=14.75 //y2=0.175
cc_2400 ( N_noxref_14_c_4026_n N_GND_c_4521_n ) capacitor c=3.54249e-19 \
 //x=13.125 //y=1.175 //x2=28.61 //y2=0.18
cc_2401 ( N_noxref_14_c_4014_n N_GND_c_4521_n ) capacitor c=0.00283214f \
 //x=14.095 //y=0.72 //x2=28.61 //y2=0.18
cc_2402 ( N_noxref_14_M7_noxref_d N_GND_c_4521_n ) capacitor c=2.7648e-19 \
 //x=11.97 //y=1.09 //x2=28.61 //y2=0.18
cc_2403 ( N_noxref_14_M8_noxref_s N_GND_c_4396_n ) capacitor c=8.16352e-19 \
 //x=13.075 //y=0.555 //x2=10.11 //y2=0.175
cc_2404 ( N_noxref_14_c_4060_p N_GND_c_4437_n ) capacitor c=0.037873f \
 //x=14.18 //y=0.805 //x2=14.92 //y2=0.175
cc_2405 ( N_noxref_14_M8_noxref_s N_GND_c_4437_n ) capacitor c=0.0051897f \
 //x=13.075 //y=0.555 //x2=14.92 //y2=0.175
cc_2406 ( N_noxref_14_M7_noxref_d N_GND_M6_noxref_d ) capacitor c=3.12752e-19 \
 //x=11.97 //y=1.09 //x2=10.995 //y2=1.055
cc_2407 ( N_noxref_14_c_4058_p N_noxref_22_c_5043_n ) capacitor c=2.15937e-19 \
 //x=13.21 //y=0.805 //x2=11.67 //y2=0.805
cc_2408 ( N_noxref_14_c_4026_n N_noxref_22_c_5029_n ) capacitor c=0.0130949f \
 //x=13.125 //y=1.175 //x2=12.555 //y2=0.72
cc_2409 ( N_noxref_14_M7_noxref_d N_noxref_22_c_5029_n ) capacitor \
 c=0.0162022f //x=11.97 //y=1.09 //x2=12.555 //y2=0.72
cc_2410 ( N_noxref_14_c_4026_n N_noxref_22_c_5027_n ) capacitor c=0.00944651f \
 //x=13.125 //y=1.175 //x2=12.555 //y2=1.77
cc_2411 ( N_noxref_14_M7_noxref_d N_noxref_22_c_5027_n ) capacitor \
 c=0.0151527f //x=11.97 //y=1.09 //x2=12.555 //y2=1.77
cc_2412 ( N_noxref_14_c_4026_n N_noxref_22_M6_noxref_s ) capacitor \
 c=0.0225377f //x=13.125 //y=1.175 //x2=10.565 //y2=0.555
cc_2413 ( N_noxref_14_c_4058_p N_noxref_22_M6_noxref_s ) capacitor \
 c=0.0175461f //x=13.21 //y=0.805 //x2=10.565 //y2=0.555
cc_2414 ( N_noxref_14_c_4060_p N_noxref_22_M6_noxref_s ) capacitor \
 c=2.98576e-19 //x=14.18 //y=0.805 //x2=10.565 //y2=0.555
cc_2415 ( N_noxref_14_M7_noxref_d N_noxref_22_M6_noxref_s ) capacitor \
 c=0.0187685f //x=11.97 //y=1.09 //x2=10.565 //y2=0.555
cc_2416 ( N_noxref_14_M8_noxref_s N_noxref_22_M6_noxref_s ) capacitor \
 c=0.0210819f //x=13.075 //y=0.555 //x2=10.565 //y2=0.555
cc_2417 ( N_noxref_14_c_4060_p N_noxref_23_M9_noxref_s ) capacitor \
 c=0.00368328f //x=14.18 //y=0.805 //x2=15.375 //y2=0.555
cc_2418 ( N_noxref_14_M8_noxref_s N_noxref_23_M9_noxref_s ) capacitor \
 c=0.00125282f //x=13.075 //y=0.555 //x2=15.375 //y2=0.555
cc_2419 ( N_noxref_15_c_4089_n N_GND_c_4416_n ) capacitor c=0.0021992f \
 //x=13.44 //y=2.375 //x2=15.91 //y2=0.175
cc_2420 ( N_noxref_15_c_4097_n N_GND_c_4416_n ) capacitor c=2.49012e-19 \
 //x=13.44 //y=4.365 //x2=15.91 //y2=0.175
cc_2421 ( N_noxref_15_c_4089_n N_GND_c_4387_n ) capacitor c=2.016e-19 \
 //x=13.44 //y=2.375 //x2=14.75 //y2=0.175
cc_2422 ( N_noxref_15_c_4107_n N_GND_c_4437_n ) capacitor c=0.00239899f \
 //x=13.44 //y=2.26 //x2=14.92 //y2=0.175
cc_2423 ( N_noxref_15_c_4132_n N_GND_c_4437_n ) capacitor c=0.00262688f \
 //x=13.96 //y=1.44 //x2=14.92 //y2=0.175
cc_2424 ( N_noxref_15_c_4136_n N_GND_c_4437_n ) capacitor c=2.63786e-19 \
 //x=13.44 //y=2.26 //x2=14.92 //y2=0.175
cc_2425 ( N_noxref_16_c_4211_n N_GND_c_4454_n ) capacitor c=0.00533679f \
 //x=17.935 //y=1.175 //x2=20.72 //y2=0.175
cc_2426 ( N_noxref_16_c_4253_p N_GND_c_4454_n ) capacitor c=0.00696173f \
 //x=18.02 //y=0.805 //x2=20.72 //y2=0.175
cc_2427 ( N_noxref_16_c_4227_n N_GND_c_4454_n ) capacitor c=0.00966029f \
 //x=18.905 //y=0.72 //x2=20.72 //y2=0.175
cc_2428 ( N_noxref_16_c_4255_p N_GND_c_4454_n ) capacitor c=0.00232964f \
 //x=18.99 //y=0.805 //x2=20.72 //y2=0.175
cc_2429 ( N_noxref_16_M10_noxref_d N_GND_c_4454_n ) capacitor c=0.0134285f \
 //x=16.78 //y=1.09 //x2=20.72 //y2=0.175
cc_2430 ( N_noxref_16_M10_noxref_d N_GND_c_4423_n ) capacitor c=0.0154456f \
 //x=16.78 //y=1.09 //x2=15.995 //y2=1.145
cc_2431 ( N_noxref_16_c_4211_n N_GND_c_4436_n ) capacitor c=0.0080792f \
 //x=17.935 //y=1.175 //x2=19.56 //y2=0.175
cc_2432 ( N_noxref_16_c_4253_p N_GND_c_4436_n ) capacitor c=0.0140604f \
 //x=18.02 //y=0.805 //x2=19.56 //y2=0.175
cc_2433 ( N_noxref_16_c_4227_n N_GND_c_4436_n ) capacitor c=0.0364637f \
 //x=18.905 //y=0.72 //x2=19.56 //y2=0.175
cc_2434 ( N_noxref_16_c_4255_p N_GND_c_4436_n ) capacitor c=0.013886f \
 //x=18.99 //y=0.805 //x2=19.56 //y2=0.175
cc_2435 ( N_noxref_16_c_4211_n N_GND_c_4521_n ) capacitor c=3.54249e-19 \
 //x=17.935 //y=1.175 //x2=28.61 //y2=0.18
cc_2436 ( N_noxref_16_c_4227_n N_GND_c_4521_n ) capacitor c=0.00283214f \
 //x=18.905 //y=0.72 //x2=28.61 //y2=0.18
cc_2437 ( N_noxref_16_M10_noxref_d N_GND_c_4521_n ) capacitor c=2.7648e-19 \
 //x=16.78 //y=1.09 //x2=28.61 //y2=0.18
cc_2438 ( N_noxref_16_M11_noxref_s N_GND_c_4437_n ) capacitor c=8.16352e-19 \
 //x=17.885 //y=0.555 //x2=14.92 //y2=0.175
cc_2439 ( N_noxref_16_c_4255_p N_GND_c_4482_n ) capacitor c=0.037873f \
 //x=18.99 //y=0.805 //x2=19.73 //y2=0.175
cc_2440 ( N_noxref_16_M11_noxref_s N_GND_c_4482_n ) capacitor c=0.0051897f \
 //x=17.885 //y=0.555 //x2=19.73 //y2=0.175
cc_2441 ( N_noxref_16_M10_noxref_d N_GND_M9_noxref_d ) capacitor c=3.12752e-19 \
 //x=16.78 //y=1.09 //x2=15.805 //y2=1.055
cc_2442 ( N_noxref_16_c_4253_p N_noxref_23_c_5102_n ) capacitor c=2.15937e-19 \
 //x=18.02 //y=0.805 //x2=16.48 //y2=0.805
cc_2443 ( N_noxref_16_c_4211_n N_noxref_23_c_5085_n ) capacitor c=0.0131134f \
 //x=17.935 //y=1.175 //x2=17.365 //y2=0.72
cc_2444 ( N_noxref_16_M10_noxref_d N_noxref_23_c_5085_n ) capacitor \
 c=0.0160925f //x=16.78 //y=1.09 //x2=17.365 //y2=0.72
cc_2445 ( N_noxref_16_c_4211_n N_noxref_23_c_5087_n ) capacitor c=0.00947943f \
 //x=17.935 //y=1.175 //x2=17.365 //y2=1.77
cc_2446 ( N_noxref_16_M10_noxref_d N_noxref_23_c_5087_n ) capacitor \
 c=0.0149824f //x=16.78 //y=1.09 //x2=17.365 //y2=1.77
cc_2447 ( N_noxref_16_c_4211_n N_noxref_23_M9_noxref_s ) capacitor \
 c=0.0225712f //x=17.935 //y=1.175 //x2=15.375 //y2=0.555
cc_2448 ( N_noxref_16_c_4253_p N_noxref_23_M9_noxref_s ) capacitor \
 c=0.0175461f //x=18.02 //y=0.805 //x2=15.375 //y2=0.555
cc_2449 ( N_noxref_16_c_4255_p N_noxref_23_M9_noxref_s ) capacitor \
 c=2.98576e-19 //x=18.99 //y=0.805 //x2=15.375 //y2=0.555
cc_2450 ( N_noxref_16_M10_noxref_d N_noxref_23_M9_noxref_s ) capacitor \
 c=0.0187685f //x=16.78 //y=1.09 //x2=15.375 //y2=0.555
cc_2451 ( N_noxref_16_M11_noxref_s N_noxref_23_M9_noxref_s ) capacitor \
 c=0.0210819f //x=17.885 //y=0.555 //x2=15.375 //y2=0.555
cc_2452 ( N_noxref_16_c_4255_p N_noxref_24_M12_noxref_s ) capacitor \
 c=0.00368328f //x=18.99 //y=0.805 //x2=20.185 //y2=0.555
cc_2453 ( N_noxref_16_M11_noxref_s N_noxref_24_M12_noxref_s ) capacitor \
 c=0.00125282f //x=17.885 //y=0.555 //x2=20.185 //y2=0.555
cc_2454 ( N_noxref_17_c_4281_n N_GND_c_4497_n ) capacitor c=0.00533679f \
 //x=22.745 //y=1.175 //x2=25.53 //y2=0.175
cc_2455 ( N_noxref_17_c_4323_p N_GND_c_4497_n ) capacitor c=0.00674239f \
 //x=22.83 //y=0.805 //x2=25.53 //y2=0.175
cc_2456 ( N_noxref_17_c_4296_n N_GND_c_4497_n ) capacitor c=0.00960852f \
 //x=23.715 //y=0.72 //x2=25.53 //y2=0.175
cc_2457 ( N_noxref_17_c_4325_p N_GND_c_4497_n ) capacitor c=0.00232964f \
 //x=23.8 //y=0.805 //x2=25.53 //y2=0.175
cc_2458 ( N_noxref_17_M13_noxref_d N_GND_c_4497_n ) capacitor c=0.0134285f \
 //x=21.59 //y=1.09 //x2=25.53 //y2=0.175
cc_2459 ( N_noxref_17_M13_noxref_d N_GND_c_4464_n ) capacitor c=0.0154456f \
 //x=21.59 //y=1.09 //x2=20.805 //y2=1.145
cc_2460 ( N_noxref_17_c_4281_n N_GND_c_4476_n ) capacitor c=0.0080792f \
 //x=22.745 //y=1.175 //x2=24.37 //y2=0.175
cc_2461 ( N_noxref_17_c_4323_p N_GND_c_4476_n ) capacitor c=0.0140604f \
 //x=22.83 //y=0.805 //x2=24.37 //y2=0.175
cc_2462 ( N_noxref_17_c_4296_n N_GND_c_4476_n ) capacitor c=0.0364637f \
 //x=23.715 //y=0.72 //x2=24.37 //y2=0.175
cc_2463 ( N_noxref_17_c_4325_p N_GND_c_4476_n ) capacitor c=0.013886f //x=23.8 \
 //y=0.805 //x2=24.37 //y2=0.175
cc_2464 ( N_noxref_17_c_4281_n N_GND_c_4521_n ) capacitor c=3.54249e-19 \
 //x=22.745 //y=1.175 //x2=28.61 //y2=0.18
cc_2465 ( N_noxref_17_c_4296_n N_GND_c_4521_n ) capacitor c=0.00283214f \
 //x=23.715 //y=0.72 //x2=28.61 //y2=0.18
cc_2466 ( N_noxref_17_M13_noxref_d N_GND_c_4521_n ) capacitor c=2.7648e-19 \
 //x=21.59 //y=1.09 //x2=28.61 //y2=0.18
cc_2467 ( N_noxref_17_M14_noxref_s N_GND_c_4482_n ) capacitor c=8.16352e-19 \
 //x=22.695 //y=0.555 //x2=19.73 //y2=0.175
cc_2468 ( N_noxref_17_c_4325_p N_GND_c_4522_n ) capacitor c=0.037873f //x=23.8 \
 //y=0.805 //x2=24.54 //y2=0.175
cc_2469 ( N_noxref_17_M14_noxref_s N_GND_c_4522_n ) capacitor c=0.0051897f \
 //x=22.695 //y=0.555 //x2=24.54 //y2=0.175
cc_2470 ( N_noxref_17_M13_noxref_d N_GND_M12_noxref_d ) capacitor \
 c=3.12752e-19 //x=21.59 //y=1.09 //x2=20.615 //y2=1.055
cc_2471 ( N_noxref_17_c_4323_p N_noxref_24_c_5160_n ) capacitor c=2.15937e-19 \
 //x=22.83 //y=0.805 //x2=21.29 //y2=0.805
cc_2472 ( N_noxref_17_c_4281_n N_noxref_24_c_5144_n ) capacitor c=0.0131134f \
 //x=22.745 //y=1.175 //x2=22.175 //y2=0.72
cc_2473 ( N_noxref_17_M13_noxref_d N_noxref_24_c_5144_n ) capacitor \
 c=0.0160925f //x=21.59 //y=1.09 //x2=22.175 //y2=0.72
cc_2474 ( N_noxref_17_c_4281_n N_noxref_24_c_5146_n ) capacitor c=0.00947943f \
 //x=22.745 //y=1.175 //x2=22.175 //y2=1.77
cc_2475 ( N_noxref_17_M13_noxref_d N_noxref_24_c_5146_n ) capacitor \
 c=0.0152625f //x=21.59 //y=1.09 //x2=22.175 //y2=1.77
cc_2476 ( N_noxref_17_c_4281_n N_noxref_24_M12_noxref_s ) capacitor \
 c=0.0225712f //x=22.745 //y=1.175 //x2=20.185 //y2=0.555
cc_2477 ( N_noxref_17_c_4323_p N_noxref_24_M12_noxref_s ) capacitor \
 c=0.0175461f //x=22.83 //y=0.805 //x2=20.185 //y2=0.555
cc_2478 ( N_noxref_17_c_4325_p N_noxref_24_M12_noxref_s ) capacitor \
 c=2.98576e-19 //x=23.8 //y=0.805 //x2=20.185 //y2=0.555
cc_2479 ( N_noxref_17_M13_noxref_d N_noxref_24_M12_noxref_s ) capacitor \
 c=0.0187685f //x=21.59 //y=1.09 //x2=20.185 //y2=0.555
cc_2480 ( N_noxref_17_M14_noxref_s N_noxref_24_M12_noxref_s ) capacitor \
 c=0.0210819f //x=22.695 //y=0.555 //x2=20.185 //y2=0.555
cc_2481 ( N_noxref_17_c_4325_p N_noxref_25_M15_noxref_s ) capacitor \
 c=0.00368328f //x=23.8 //y=0.805 //x2=24.995 //y2=0.555
cc_2482 ( N_noxref_17_M14_noxref_s N_noxref_25_M15_noxref_s ) capacitor \
 c=0.00125282f //x=22.695 //y=0.555 //x2=24.995 //y2=0.555
cc_2483 ( N_GND_c_4539_n N_noxref_19_c_4836_n ) capacitor c=0.0079063f \
 //x=28.61 //y=0.18 //x2=27.555 //y2=1.175
cc_2484 ( N_GND_c_4521_n N_noxref_19_c_4836_n ) capacitor c=0.00843344f \
 //x=28.61 //y=0.18 //x2=27.555 //y2=1.175
cc_2485 ( N_GND_c_4539_n N_noxref_19_c_4878_n ) capacitor c=0.00616085f \
 //x=28.61 //y=0.18 //x2=27.64 //y2=0.805
cc_2486 ( N_GND_c_4521_n N_noxref_19_c_4878_n ) capacitor c=0.0140604f \
 //x=28.61 //y=0.18 //x2=27.64 //y2=0.805
cc_2487 ( N_GND_c_4539_n N_noxref_19_c_4853_n ) capacitor c=0.0100709f \
 //x=28.61 //y=0.18 //x2=28.525 //y2=0.72
cc_2488 ( N_GND_c_4521_n N_noxref_19_c_4853_n ) capacitor c=0.0392958f \
 //x=28.61 //y=0.18 //x2=28.525 //y2=0.72
cc_2489 ( N_GND_c_4539_n N_noxref_19_c_4882_n ) capacitor c=0.00232964f \
 //x=28.61 //y=0.18 //x2=28.61 //y2=0.805
cc_2490 ( N_GND_c_4521_n N_noxref_19_c_4882_n ) capacitor c=0.0541549f \
 //x=28.61 //y=0.18 //x2=28.61 //y2=0.805
cc_2491 ( N_GND_c_4539_n N_noxref_19_M16_noxref_d ) capacitor c=0.0134285f \
 //x=28.61 //y=0.18 //x2=26.4 //y2=1.09
cc_2492 ( N_GND_c_4508_n N_noxref_19_M16_noxref_d ) capacitor c=0.0154456f \
 //x=25.615 //y=1.145 //x2=26.4 //y2=1.09
cc_2493 ( N_GND_c_4521_n N_noxref_19_M16_noxref_d ) capacitor c=2.7648e-19 \
 //x=28.61 //y=0.18 //x2=26.4 //y2=1.09
cc_2494 ( N_GND_M15_noxref_d N_noxref_19_M16_noxref_d ) capacitor \
 c=3.12752e-19 //x=25.425 //y=1.055 //x2=26.4 //y2=1.09
cc_2495 ( N_GND_c_4521_n N_noxref_19_M17_noxref_s ) capacitor c=0.00532909f \
 //x=28.61 //y=0.18 //x2=27.505 //y2=0.555
cc_2496 ( N_GND_c_4522_n N_noxref_19_M17_noxref_s ) capacitor c=8.16352e-19 \
 //x=24.54 //y=0.175 //x2=27.505 //y2=0.555
cc_2497 ( N_GND_c_4717_p N_noxref_20_c_4910_n ) capacitor c=0.00293992f \
 //x=1.48 //y=0.175 //x2=1.965 //y2=1.77
cc_2498 ( N_GND_c_4351_n N_noxref_20_c_4910_n ) capacitor c=7.69197e-19 \
 //x=6.29 //y=0.175 //x2=1.965 //y2=1.77
cc_2499 ( N_GND_c_4579_n N_noxref_20_c_4910_n ) capacitor c=0.00388652f \
 //x=1.565 //y=1.145 //x2=1.965 //y2=1.77
cc_2500 ( N_GND_c_4384_n N_noxref_20_c_4910_n ) capacitor c=0.00402452f \
 //x=5.13 //y=0.175 //x2=1.965 //y2=1.77
cc_2501 ( N_GND_M0_noxref_d N_noxref_20_c_4910_n ) capacitor c=0.00578031f \
 //x=1.375 //y=1.055 //x2=1.965 //y2=1.77
cc_2502 ( N_GND_c_4587_n N_noxref_20_c_4921_n ) capacitor c=0.0169052f \
 //x=1.565 //y=1.015 //x2=2.05 //y2=0.805
cc_2503 ( N_GND_c_4351_n N_noxref_20_c_4921_n ) capacitor c=0.00710913f \
 //x=6.29 //y=0.175 //x2=2.05 //y2=0.805
cc_2504 ( N_GND_c_4384_n N_noxref_20_c_4921_n ) capacitor c=0.0140604f \
 //x=5.13 //y=0.175 //x2=2.05 //y2=0.805
cc_2505 ( N_GND_c_4580_n N_noxref_20_c_4921_n ) capacitor c=0.00323118f \
 //x=1.23 //y=0.18 //x2=2.05 //y2=0.805
cc_2506 ( N_GND_c_4351_n N_noxref_20_c_4899_n ) capacitor c=0.013823f //x=6.29 \
 //y=0.175 //x2=2.935 //y2=0.72
cc_2507 ( N_GND_c_4384_n N_noxref_20_c_4899_n ) capacitor c=0.0356451f \
 //x=5.13 //y=0.175 //x2=2.935 //y2=0.72
cc_2508 ( N_GND_c_4521_n N_noxref_20_c_4899_n ) capacitor c=0.00265129f \
 //x=28.61 //y=0.18 //x2=2.935 //y2=0.72
cc_2509 ( N_GND_c_4717_p N_noxref_20_M0_noxref_s ) capacitor c=0.00710913f \
 //x=1.48 //y=0.175 //x2=0.945 //y2=0.555
cc_2510 ( N_GND_c_4587_n N_noxref_20_M0_noxref_s ) capacitor c=0.0173062f \
 //x=1.565 //y=1.015 //x2=0.945 //y2=0.555
cc_2511 ( N_GND_c_4351_n N_noxref_20_M0_noxref_s ) capacitor c=0.00683407f \
 //x=6.29 //y=0.175 //x2=0.945 //y2=0.555
cc_2512 ( N_GND_c_4579_n N_noxref_20_M0_noxref_s ) capacitor c=0.0113024f \
 //x=1.565 //y=1.145 //x2=0.945 //y2=0.555
cc_2513 ( N_GND_c_4384_n N_noxref_20_M0_noxref_s ) capacitor c=0.0272246f \
 //x=5.13 //y=0.175 //x2=0.945 //y2=0.555
cc_2514 ( N_GND_c_4580_n N_noxref_20_M0_noxref_s ) capacitor c=0.0675506f \
 //x=1.23 //y=0.18 //x2=0.945 //y2=0.555
cc_2515 ( N_GND_c_4388_n N_noxref_20_M0_noxref_s ) capacitor c=0.00166413f \
 //x=5.3 //y=0.175 //x2=0.945 //y2=0.555
cc_2516 ( N_GND_M0_noxref_d N_noxref_20_M0_noxref_s ) capacitor c=0.0271316f \
 //x=1.375 //y=1.055 //x2=0.945 //y2=0.555
cc_2517 ( N_GND_c_4351_n N_noxref_21_c_4953_n ) capacitor c=0.0011329f \
 //x=6.29 //y=0.175 //x2=6.775 //y2=1.77
cc_2518 ( N_GND_c_4452_n N_noxref_21_c_4953_n ) capacitor c=6.58254e-19 \
 //x=11.1 //y=0.175 //x2=6.775 //y2=1.77
cc_2519 ( N_GND_c_4361_n N_noxref_21_c_4953_n ) capacitor c=0.00362438f \
 //x=6.375 //y=1.145 //x2=6.775 //y2=1.77
cc_2520 ( N_GND_c_4386_n N_noxref_21_c_4953_n ) capacitor c=0.0038933f \
 //x=9.94 //y=0.175 //x2=6.775 //y2=1.77
cc_2521 ( N_GND_M3_noxref_d N_noxref_21_c_4953_n ) capacitor c=0.00578031f \
 //x=6.185 //y=1.055 //x2=6.775 //y2=1.77
cc_2522 ( N_GND_c_4355_n N_noxref_21_c_4982_n ) capacitor c=0.0169052f \
 //x=6.375 //y=1.015 //x2=6.86 //y2=0.805
cc_2523 ( N_GND_c_4452_n N_noxref_21_c_4982_n ) capacitor c=0.00710913f \
 //x=11.1 //y=0.175 //x2=6.86 //y2=0.805
cc_2524 ( N_GND_c_4386_n N_noxref_21_c_4982_n ) capacitor c=0.0140604f \
 //x=9.94 //y=0.175 //x2=6.86 //y2=0.805
cc_2525 ( N_GND_c_4388_n N_noxref_21_c_4982_n ) capacitor c=0.00322478f \
 //x=5.3 //y=0.175 //x2=6.86 //y2=0.805
cc_2526 ( N_GND_c_4452_n N_noxref_21_c_4969_n ) capacitor c=0.0125969f \
 //x=11.1 //y=0.175 //x2=7.745 //y2=0.72
cc_2527 ( N_GND_c_4386_n N_noxref_21_c_4969_n ) capacitor c=0.035931f //x=9.94 \
 //y=0.175 //x2=7.745 //y2=0.72
cc_2528 ( N_GND_c_4521_n N_noxref_21_c_4969_n ) capacitor c=0.00265129f \
 //x=28.61 //y=0.18 //x2=7.745 //y2=0.72
cc_2529 ( N_GND_c_4351_n N_noxref_21_M3_noxref_s ) capacitor c=0.00710913f \
 //x=6.29 //y=0.175 //x2=5.755 //y2=0.555
cc_2530 ( N_GND_c_4355_n N_noxref_21_M3_noxref_s ) capacitor c=0.0173062f \
 //x=6.375 //y=1.015 //x2=5.755 //y2=0.555
cc_2531 ( N_GND_c_4452_n N_noxref_21_M3_noxref_s ) capacitor c=0.00590241f \
 //x=11.1 //y=0.175 //x2=5.755 //y2=0.555
cc_2532 ( N_GND_c_4361_n N_noxref_21_M3_noxref_s ) capacitor c=0.00988958f \
 //x=6.375 //y=1.145 //x2=5.755 //y2=0.555
cc_2533 ( N_GND_c_4386_n N_noxref_21_M3_noxref_s ) capacitor c=0.0274023f \
 //x=9.94 //y=0.175 //x2=5.755 //y2=0.555
cc_2534 ( N_GND_c_4388_n N_noxref_21_M3_noxref_s ) capacitor c=0.0634633f \
 //x=5.3 //y=0.175 //x2=5.755 //y2=0.555
cc_2535 ( N_GND_c_4396_n N_noxref_21_M3_noxref_s ) capacitor c=0.00166413f \
 //x=10.11 //y=0.175 //x2=5.755 //y2=0.555
cc_2536 ( N_GND_M3_noxref_d N_noxref_21_M3_noxref_s ) capacitor c=0.0271316f \
 //x=6.185 //y=1.055 //x2=5.755 //y2=0.555
cc_2537 ( N_GND_c_4452_n N_noxref_22_c_5014_n ) capacitor c=0.0011329f \
 //x=11.1 //y=0.175 //x2=11.585 //y2=1.77
cc_2538 ( N_GND_c_4416_n N_noxref_22_c_5014_n ) capacitor c=7.40908e-19 \
 //x=15.91 //y=0.175 //x2=11.585 //y2=1.77
cc_2539 ( N_GND_c_4373_n N_noxref_22_c_5014_n ) capacitor c=0.00358911f \
 //x=11.185 //y=1.145 //x2=11.585 //y2=1.77
cc_2540 ( N_GND_c_4387_n N_noxref_22_c_5014_n ) capacitor c=0.0038933f \
 //x=14.75 //y=0.175 //x2=11.585 //y2=1.77
cc_2541 ( N_GND_M6_noxref_d N_noxref_22_c_5014_n ) capacitor c=0.00578031f \
 //x=10.995 //y=1.055 //x2=11.585 //y2=1.77
cc_2542 ( N_GND_c_4358_n N_noxref_22_c_5043_n ) capacitor c=0.0169052f \
 //x=11.185 //y=1.015 //x2=11.67 //y2=0.805
cc_2543 ( N_GND_c_4416_n N_noxref_22_c_5043_n ) capacitor c=0.00710913f \
 //x=15.91 //y=0.175 //x2=11.67 //y2=0.805
cc_2544 ( N_GND_c_4387_n N_noxref_22_c_5043_n ) capacitor c=0.0140604f \
 //x=14.75 //y=0.175 //x2=11.67 //y2=0.805
cc_2545 ( N_GND_c_4396_n N_noxref_22_c_5043_n ) capacitor c=0.00322478f \
 //x=10.11 //y=0.175 //x2=11.67 //y2=0.805
cc_2546 ( N_GND_c_4416_n N_noxref_22_c_5029_n ) capacitor c=0.012487f \
 //x=15.91 //y=0.175 //x2=12.555 //y2=0.72
cc_2547 ( N_GND_c_4387_n N_noxref_22_c_5029_n ) capacitor c=0.0358912f \
 //x=14.75 //y=0.175 //x2=12.555 //y2=0.72
cc_2548 ( N_GND_c_4521_n N_noxref_22_c_5029_n ) capacitor c=0.00265129f \
 //x=28.61 //y=0.18 //x2=12.555 //y2=0.72
cc_2549 ( N_GND_c_4452_n N_noxref_22_M6_noxref_s ) capacitor c=0.00710913f \
 //x=11.1 //y=0.175 //x2=10.565 //y2=0.555
cc_2550 ( N_GND_c_4358_n N_noxref_22_M6_noxref_s ) capacitor c=0.0173062f \
 //x=11.185 //y=1.015 //x2=10.565 //y2=0.555
cc_2551 ( N_GND_c_4416_n N_noxref_22_M6_noxref_s ) capacitor c=0.00585169f \
 //x=15.91 //y=0.175 //x2=10.565 //y2=0.555
cc_2552 ( N_GND_c_4373_n N_noxref_22_M6_noxref_s ) capacitor c=0.00988958f \
 //x=11.185 //y=1.145 //x2=10.565 //y2=0.555
cc_2553 ( N_GND_c_4387_n N_noxref_22_M6_noxref_s ) capacitor c=0.0273671f \
 //x=14.75 //y=0.175 //x2=10.565 //y2=0.555
cc_2554 ( N_GND_c_4396_n N_noxref_22_M6_noxref_s ) capacitor c=0.0634633f \
 //x=10.11 //y=0.175 //x2=10.565 //y2=0.555
cc_2555 ( N_GND_c_4437_n N_noxref_22_M6_noxref_s ) capacitor c=0.00166413f \
 //x=14.92 //y=0.175 //x2=10.565 //y2=0.555
cc_2556 ( N_GND_M6_noxref_d N_noxref_22_M6_noxref_s ) capacitor c=0.0271316f \
 //x=10.995 //y=1.055 //x2=10.565 //y2=0.555
cc_2557 ( N_GND_c_4416_n N_noxref_23_c_5074_n ) capacitor c=0.0011329f \
 //x=15.91 //y=0.175 //x2=16.395 //y2=1.77
cc_2558 ( N_GND_c_4454_n N_noxref_23_c_5074_n ) capacitor c=7.40908e-19 \
 //x=20.72 //y=0.175 //x2=16.395 //y2=1.77
cc_2559 ( N_GND_c_4423_n N_noxref_23_c_5074_n ) capacitor c=0.00358901f \
 //x=15.995 //y=1.145 //x2=16.395 //y2=1.77
cc_2560 ( N_GND_c_4436_n N_noxref_23_c_5074_n ) capacitor c=0.0038933f \
 //x=19.56 //y=0.175 //x2=16.395 //y2=1.77
cc_2561 ( N_GND_M9_noxref_d N_noxref_23_c_5074_n ) capacitor c=0.00578031f \
 //x=15.805 //y=1.055 //x2=16.395 //y2=1.77
cc_2562 ( N_GND_c_4420_n N_noxref_23_c_5102_n ) capacitor c=0.0169052f \
 //x=15.995 //y=1.015 //x2=16.48 //y2=0.805
cc_2563 ( N_GND_c_4454_n N_noxref_23_c_5102_n ) capacitor c=0.00710913f \
 //x=20.72 //y=0.175 //x2=16.48 //y2=0.805
cc_2564 ( N_GND_c_4436_n N_noxref_23_c_5102_n ) capacitor c=0.0140604f \
 //x=19.56 //y=0.175 //x2=16.48 //y2=0.805
cc_2565 ( N_GND_c_4437_n N_noxref_23_c_5102_n ) capacitor c=0.00322478f \
 //x=14.92 //y=0.175 //x2=16.48 //y2=0.805
cc_2566 ( N_GND_c_4454_n N_noxref_23_c_5085_n ) capacitor c=0.0123489f \
 //x=20.72 //y=0.175 //x2=17.365 //y2=0.72
cc_2567 ( N_GND_c_4436_n N_noxref_23_c_5085_n ) capacitor c=0.0356451f \
 //x=19.56 //y=0.175 //x2=17.365 //y2=0.72
cc_2568 ( N_GND_c_4521_n N_noxref_23_c_5085_n ) capacitor c=0.00265129f \
 //x=28.61 //y=0.18 //x2=17.365 //y2=0.72
cc_2569 ( N_GND_c_4416_n N_noxref_23_M9_noxref_s ) capacitor c=0.00710913f \
 //x=15.91 //y=0.175 //x2=15.375 //y2=0.555
cc_2570 ( N_GND_c_4420_n N_noxref_23_M9_noxref_s ) capacitor c=0.0173062f \
 //x=15.995 //y=1.015 //x2=15.375 //y2=0.555
cc_2571 ( N_GND_c_4454_n N_noxref_23_M9_noxref_s ) capacitor c=0.00683407f \
 //x=20.72 //y=0.175 //x2=15.375 //y2=0.555
cc_2572 ( N_GND_c_4423_n N_noxref_23_M9_noxref_s ) capacitor c=0.00988958f \
 //x=15.995 //y=1.145 //x2=15.375 //y2=0.555
cc_2573 ( N_GND_c_4436_n N_noxref_23_M9_noxref_s ) capacitor c=0.0272246f \
 //x=19.56 //y=0.175 //x2=15.375 //y2=0.555
cc_2574 ( N_GND_c_4437_n N_noxref_23_M9_noxref_s ) capacitor c=0.0634633f \
 //x=14.92 //y=0.175 //x2=15.375 //y2=0.555
cc_2575 ( N_GND_c_4482_n N_noxref_23_M9_noxref_s ) capacitor c=0.00166413f \
 //x=19.73 //y=0.175 //x2=15.375 //y2=0.555
cc_2576 ( N_GND_M9_noxref_d N_noxref_23_M9_noxref_s ) capacitor c=0.0271316f \
 //x=15.805 //y=1.055 //x2=15.375 //y2=0.555
cc_2577 ( N_GND_c_4454_n N_noxref_24_c_5133_n ) capacitor c=0.0011329f \
 //x=20.72 //y=0.175 //x2=21.205 //y2=1.77
cc_2578 ( N_GND_c_4497_n N_noxref_24_c_5133_n ) capacitor c=7.40908e-19 \
 //x=25.53 //y=0.175 //x2=21.205 //y2=1.77
cc_2579 ( N_GND_c_4464_n N_noxref_24_c_5133_n ) capacitor c=0.00371075f \
 //x=20.805 //y=1.145 //x2=21.205 //y2=1.77
cc_2580 ( N_GND_c_4476_n N_noxref_24_c_5133_n ) capacitor c=0.0038933f \
 //x=24.37 //y=0.175 //x2=21.205 //y2=1.77
cc_2581 ( N_GND_M12_noxref_d N_noxref_24_c_5133_n ) capacitor c=0.00578031f \
 //x=20.615 //y=1.055 //x2=21.205 //y2=1.77
cc_2582 ( N_GND_c_4460_n N_noxref_24_c_5160_n ) capacitor c=0.0169052f \
 //x=20.805 //y=1.015 //x2=21.29 //y2=0.805
cc_2583 ( N_GND_c_4497_n N_noxref_24_c_5160_n ) capacitor c=0.00710913f \
 //x=25.53 //y=0.175 //x2=21.29 //y2=0.805
cc_2584 ( N_GND_c_4476_n N_noxref_24_c_5160_n ) capacitor c=0.0140604f \
 //x=24.37 //y=0.175 //x2=21.29 //y2=0.805
cc_2585 ( N_GND_c_4482_n N_noxref_24_c_5160_n ) capacitor c=0.00322478f \
 //x=19.73 //y=0.175 //x2=21.29 //y2=0.805
cc_2586 ( N_GND_c_4497_n N_noxref_24_c_5144_n ) capacitor c=0.0124379f \
 //x=25.53 //y=0.175 //x2=22.175 //y2=0.72
cc_2587 ( N_GND_c_4476_n N_noxref_24_c_5144_n ) capacitor c=0.0356451f \
 //x=24.37 //y=0.175 //x2=22.175 //y2=0.72
cc_2588 ( N_GND_c_4521_n N_noxref_24_c_5144_n ) capacitor c=0.00265129f \
 //x=28.61 //y=0.18 //x2=22.175 //y2=0.72
cc_2589 ( N_GND_c_4454_n N_noxref_24_M12_noxref_s ) capacitor c=0.00710913f \
 //x=20.72 //y=0.175 //x2=20.185 //y2=0.555
cc_2590 ( N_GND_c_4460_n N_noxref_24_M12_noxref_s ) capacitor c=0.0173062f \
 //x=20.805 //y=1.015 //x2=20.185 //y2=0.555
cc_2591 ( N_GND_c_4497_n N_noxref_24_M12_noxref_s ) capacitor c=0.00683407f \
 //x=25.53 //y=0.175 //x2=20.185 //y2=0.555
cc_2592 ( N_GND_c_4464_n N_noxref_24_M12_noxref_s ) capacitor c=0.00988958f \
 //x=20.805 //y=1.145 //x2=20.185 //y2=0.555
cc_2593 ( N_GND_c_4476_n N_noxref_24_M12_noxref_s ) capacitor c=0.0272246f \
 //x=24.37 //y=0.175 //x2=20.185 //y2=0.555
cc_2594 ( N_GND_c_4482_n N_noxref_24_M12_noxref_s ) capacitor c=0.0634633f \
 //x=19.73 //y=0.175 //x2=20.185 //y2=0.555
cc_2595 ( N_GND_c_4522_n N_noxref_24_M12_noxref_s ) capacitor c=0.00166413f \
 //x=24.54 //y=0.175 //x2=20.185 //y2=0.555
cc_2596 ( N_GND_M12_noxref_d N_noxref_24_M12_noxref_s ) capacitor c=0.0271316f \
 //x=20.615 //y=1.055 //x2=20.185 //y2=0.555
cc_2597 ( N_GND_c_4497_n N_noxref_25_c_5191_n ) capacitor c=0.0011329f \
 //x=25.53 //y=0.175 //x2=26.015 //y2=1.77
cc_2598 ( N_GND_c_4539_n N_noxref_25_c_5191_n ) capacitor c=0.00184004f \
 //x=28.61 //y=0.18 //x2=26.015 //y2=1.77
cc_2599 ( N_GND_c_4508_n N_noxref_25_c_5191_n ) capacitor c=0.003657f \
 //x=25.615 //y=1.145 //x2=26.015 //y2=1.77
cc_2600 ( N_GND_c_4521_n N_noxref_25_c_5191_n ) capacitor c=0.00383655f \
 //x=28.61 //y=0.18 //x2=26.015 //y2=1.77
cc_2601 ( N_GND_M15_noxref_d N_noxref_25_c_5191_n ) capacitor c=0.00578031f \
 //x=25.425 //y=1.055 //x2=26.015 //y2=1.77
cc_2602 ( N_GND_c_4505_n N_noxref_25_c_5225_n ) capacitor c=0.0169052f \
 //x=25.615 //y=1.015 //x2=26.1 //y2=0.805
cc_2603 ( N_GND_c_4539_n N_noxref_25_c_5225_n ) capacitor c=0.00710913f \
 //x=28.61 //y=0.18 //x2=26.1 //y2=0.805
cc_2604 ( N_GND_c_4521_n N_noxref_25_c_5225_n ) capacitor c=0.0140604f \
 //x=28.61 //y=0.18 //x2=26.1 //y2=0.805
cc_2605 ( N_GND_c_4522_n N_noxref_25_c_5225_n ) capacitor c=0.00322478f \
 //x=24.54 //y=0.175 //x2=26.1 //y2=0.805
cc_2606 ( N_GND_c_4539_n N_noxref_25_c_5204_n ) capacitor c=0.012988f \
 //x=28.61 //y=0.18 //x2=26.985 //y2=0.72
cc_2607 ( N_GND_c_4521_n N_noxref_25_c_5204_n ) capacitor c=0.0382964f \
 //x=28.61 //y=0.18 //x2=26.985 //y2=0.72
cc_2608 ( N_GND_c_4497_n N_noxref_25_M15_noxref_s ) capacitor c=0.00710913f \
 //x=25.53 //y=0.175 //x2=24.995 //y2=0.555
cc_2609 ( N_GND_c_4505_n N_noxref_25_M15_noxref_s ) capacitor c=0.0173062f \
 //x=25.615 //y=1.015 //x2=24.995 //y2=0.555
cc_2610 ( N_GND_c_4539_n N_noxref_25_M15_noxref_s ) capacitor c=0.00683407f \
 //x=28.61 //y=0.18 //x2=24.995 //y2=0.555
cc_2611 ( N_GND_c_4508_n N_noxref_25_M15_noxref_s ) capacitor c=0.00988958f \
 //x=25.615 //y=1.145 //x2=24.995 //y2=0.555
cc_2612 ( N_GND_c_4521_n N_noxref_25_M15_noxref_s ) capacitor c=0.028586f \
 //x=28.61 //y=0.18 //x2=24.995 //y2=0.555
cc_2613 ( N_GND_c_4522_n N_noxref_25_M15_noxref_s ) capacitor c=0.0634633f \
 //x=24.54 //y=0.175 //x2=24.995 //y2=0.555
cc_2614 ( N_GND_M15_noxref_d N_noxref_25_M15_noxref_s ) capacitor c=0.0271316f \
 //x=25.425 //y=1.055 //x2=24.995 //y2=0.555
cc_2615 ( N_noxref_19_c_4878_n N_noxref_25_c_5225_n ) capacitor c=2.15937e-19 \
 //x=27.64 //y=0.805 //x2=26.1 //y2=0.805
cc_2616 ( N_noxref_19_c_4836_n N_noxref_25_c_5204_n ) capacitor c=0.0132288f \
 //x=27.555 //y=1.175 //x2=26.985 //y2=0.72
cc_2617 ( N_noxref_19_M16_noxref_d N_noxref_25_c_5204_n ) capacitor \
 c=0.0160925f //x=26.4 //y=1.09 //x2=26.985 //y2=0.72
cc_2618 ( N_noxref_19_c_4836_n N_noxref_25_c_5206_n ) capacitor c=0.00951468f \
 //x=27.555 //y=1.175 //x2=26.985 //y2=1.77
cc_2619 ( N_noxref_19_M16_noxref_d N_noxref_25_c_5206_n ) capacitor \
 c=0.014797f //x=26.4 //y=1.09 //x2=26.985 //y2=1.77
cc_2620 ( N_noxref_19_c_4836_n N_noxref_25_M15_noxref_s ) capacitor \
 c=0.023368f //x=27.555 //y=1.175 //x2=24.995 //y2=0.555
cc_2621 ( N_noxref_19_c_4878_n N_noxref_25_M15_noxref_s ) capacitor \
 c=0.0182125f //x=27.64 //y=0.805 //x2=24.995 //y2=0.555
cc_2622 ( N_noxref_19_M16_noxref_d N_noxref_25_M15_noxref_s ) capacitor \
 c=0.0187685f //x=26.4 //y=1.09 //x2=24.995 //y2=0.555
cc_2623 ( N_noxref_19_M17_noxref_s N_noxref_25_M15_noxref_s ) capacitor \
 c=0.0209954f //x=27.505 //y=0.555 //x2=24.995 //y2=0.555
