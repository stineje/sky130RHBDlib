// File: DFFSNQNX1.spi.DFFSNQNX1.pxi
// Created: Tue Apr 29 10:40:26 2025
//
simulator lang=spectre
x_PM_DFFSNQNX1\%GND ( GND N_GND_c_8_p N_GND_c_137_p N_GND_c_2_p N_GND_c_9_p \
 N_GND_c_10_p N_GND_c_15_p N_GND_c_16_p N_GND_c_42_p N_GND_c_53_p N_GND_c_60_p \
 N_GND_c_75_p N_GND_c_82_p N_GND_c_94_p N_GND_c_1_p N_GND_c_3_p N_GND_c_4_p \
 N_GND_c_5_p N_GND_c_6_p N_GND_c_7_p N_GND_M0_noxref_d N_GND_M2_noxref_d \
 N_GND_M5_noxref_d N_GND_M8_noxref_d N_GND_M10_noxref_d N_GND_M12_noxref_d )  \
 PM_DFFSNQNX1\%GND
x_PM_DFFSNQNX1\%VDD ( VDD N_VDD_c_298_p N_VDD_c_299_p N_VDD_c_300_p \
 N_VDD_c_402_p N_VDD_c_403_p N_VDD_c_315_p N_VDD_c_392_p N_VDD_c_429_p \
 N_VDD_c_377_p N_VDD_c_378_p N_VDD_c_319_p N_VDD_c_340_p N_VDD_c_346_p \
 N_VDD_c_350_p N_VDD_c_381_p N_VDD_c_354_p N_VDD_c_396_p N_VDD_c_410_p \
 N_VDD_c_411_p N_VDD_c_412_p N_VDD_c_466_p N_VDD_c_474_p N_VDD_c_493_p \
 N_VDD_c_518_p N_VDD_c_549_p N_VDD_c_290_n N_VDD_c_291_n N_VDD_c_292_n \
 N_VDD_c_293_n N_VDD_c_294_n N_VDD_c_295_n N_VDD_c_296_n N_VDD_M15_noxref_s \
 N_VDD_M16_noxref_d N_VDD_M18_noxref_d N_VDD_M19_noxref_s N_VDD_M20_noxref_d \
 N_VDD_M22_noxref_d N_VDD_M24_noxref_d N_VDD_M25_noxref_s N_VDD_M26_noxref_d \
 N_VDD_M28_noxref_d N_VDD_M30_noxref_d N_VDD_M31_noxref_s N_VDD_M32_noxref_d \
 N_VDD_M34_noxref_d N_VDD_M35_noxref_s N_VDD_M36_noxref_d N_VDD_M38_noxref_d \
 N_VDD_M39_noxref_s N_VDD_M40_noxref_d N_VDD_M42_noxref_d N_VDD_M44_noxref_d ) \
 PM_DFFSNQNX1\%VDD
x_PM_DFFSNQNX1\%noxref_3 ( N_noxref_3_c_602_n N_noxref_3_c_606_n \
 N_noxref_3_c_608_n N_noxref_3_c_612_n N_noxref_3_c_643_n N_noxref_3_c_647_n \
 N_noxref_3_c_649_n N_noxref_3_c_614_n N_noxref_3_c_722_p N_noxref_3_c_615_n \
 N_noxref_3_c_617_n N_noxref_3_c_618_n N_noxref_3_c_752_p \
 N_noxref_3_M2_noxref_g N_noxref_3_M5_noxref_g N_noxref_3_M19_noxref_g \
 N_noxref_3_M20_noxref_g N_noxref_3_M25_noxref_g N_noxref_3_M26_noxref_g \
 N_noxref_3_c_619_n N_noxref_3_c_621_n N_noxref_3_c_622_n N_noxref_3_c_623_n \
 N_noxref_3_c_624_n N_noxref_3_c_625_n N_noxref_3_c_626_n N_noxref_3_c_628_n \
 N_noxref_3_c_699_p N_noxref_3_c_668_n N_noxref_3_c_629_n N_noxref_3_c_631_n \
 N_noxref_3_c_632_n N_noxref_3_c_633_n N_noxref_3_c_634_n N_noxref_3_c_635_n \
 N_noxref_3_c_636_n N_noxref_3_c_638_n N_noxref_3_c_686_p N_noxref_3_c_670_n \
 N_noxref_3_M1_noxref_d N_noxref_3_M15_noxref_d N_noxref_3_M17_noxref_d )  \
 PM_DFFSNQNX1\%noxref_3
x_PM_DFFSNQNX1\%noxref_4 ( N_noxref_4_c_857_n N_noxref_4_c_858_n \
 N_noxref_4_c_873_n N_noxref_4_c_877_n N_noxref_4_c_879_n N_noxref_4_c_883_n \
 N_noxref_4_c_859_n N_noxref_4_c_955_p N_noxref_4_c_860_n N_noxref_4_c_861_n \
 N_noxref_4_c_968_p N_noxref_4_c_978_p N_noxref_4_M8_noxref_g \
 N_noxref_4_M31_noxref_g N_noxref_4_M32_noxref_g N_noxref_4_c_862_n \
 N_noxref_4_c_864_n N_noxref_4_c_865_n N_noxref_4_c_866_n N_noxref_4_c_867_n \
 N_noxref_4_c_868_n N_noxref_4_c_869_n N_noxref_4_c_871_n N_noxref_4_c_895_n \
 N_noxref_4_M7_noxref_d N_noxref_4_M25_noxref_d N_noxref_4_M27_noxref_d \
 N_noxref_4_M29_noxref_d )  PM_DFFSNQNX1\%noxref_4
x_PM_DFFSNQNX1\%CLK ( N_CLK_c_1027_n N_CLK_c_1038_n CLK CLK CLK CLK CLK CLK \
 CLK CLK N_CLK_c_1024_n N_CLK_c_1039_n N_CLK_c_1025_n N_CLK_c_1040_n \
 N_CLK_c_1167_p N_CLK_c_1139_p N_CLK_c_1042_n N_CLK_c_1095_n N_CLK_c_1189_p \
 N_CLK_M3_noxref_g N_CLK_M9_noxref_g N_CLK_M21_noxref_g N_CLK_M22_noxref_g \
 N_CLK_M33_noxref_g N_CLK_M34_noxref_g N_CLK_c_1068_n N_CLK_c_1071_n \
 N_CLK_c_1228_p N_CLK_c_1235_p N_CLK_c_1073_n N_CLK_c_1074_n N_CLK_c_1075_n \
 N_CLK_c_1076_n N_CLK_c_1136_p N_CLK_c_1100_n N_CLK_c_1103_n N_CLK_c_1105_n \
 N_CLK_c_1122_p N_CLK_c_1212_p N_CLK_c_1144_p N_CLK_c_1108_n N_CLK_c_1109_n \
 N_CLK_c_1079_n N_CLK_c_1110_n N_CLK_c_1192_p N_CLK_c_1112_n )  \
 PM_DFFSNQNX1\%CLK
x_PM_DFFSNQNX1\%noxref_6 ( N_noxref_6_c_1250_n N_noxref_6_c_1252_n \
 N_noxref_6_c_1276_n N_noxref_6_c_1285_n N_noxref_6_c_1345_n \
 N_noxref_6_c_1253_n N_noxref_6_c_1288_n N_noxref_6_c_1292_n \
 N_noxref_6_c_1294_n N_noxref_6_c_1298_n N_noxref_6_c_1255_n \
 N_noxref_6_c_1354_n N_noxref_6_c_1401_n N_noxref_6_c_1256_n \
 N_noxref_6_c_1404_n N_noxref_6_c_1465_p N_noxref_6_c_1305_n \
 N_noxref_6_c_1355_n N_noxref_6_M1_noxref_g N_noxref_6_M10_noxref_g \
 N_noxref_6_M17_noxref_g N_noxref_6_M18_noxref_g N_noxref_6_M35_noxref_g \
 N_noxref_6_M36_noxref_g N_noxref_6_c_1361_n N_noxref_6_c_1362_n \
 N_noxref_6_c_1363_n N_noxref_6_c_1364_n N_noxref_6_c_1366_n \
 N_noxref_6_c_1367_n N_noxref_6_c_1369_n N_noxref_6_c_1370_n \
 N_noxref_6_c_1257_n N_noxref_6_c_1259_n N_noxref_6_c_1260_n \
 N_noxref_6_c_1261_n N_noxref_6_c_1262_n N_noxref_6_c_1263_n \
 N_noxref_6_c_1264_n N_noxref_6_c_1266_n N_noxref_6_c_1372_n \
 N_noxref_6_c_1373_n N_noxref_6_c_1375_n N_noxref_6_c_1315_n \
 N_noxref_6_M4_noxref_d N_noxref_6_M19_noxref_d N_noxref_6_M21_noxref_d \
 N_noxref_6_M23_noxref_d )  PM_DFFSNQNX1\%noxref_6
x_PM_DFFSNQNX1\%noxref_7 ( N_noxref_7_c_1566_n N_noxref_7_c_1557_n \
 N_noxref_7_c_1571_n N_noxref_7_M11_noxref_g N_noxref_7_M37_noxref_g \
 N_noxref_7_M38_noxref_g N_noxref_7_c_1575_n N_noxref_7_c_1578_n \
 N_noxref_7_c_1580_n N_noxref_7_c_1598_p N_noxref_7_c_1611_p \
 N_noxref_7_c_1596_p N_noxref_7_c_1583_n N_noxref_7_c_1584_n \
 N_noxref_7_c_1585_n N_noxref_7_c_1601_p N_noxref_7_c_1587_n )  \
 PM_DFFSNQNX1\%noxref_7
x_PM_DFFSNQNX1\%QN ( QN QN QN QN QN QN QN QN QN N_QN_c_1666_n N_QN_c_1670_n \
 N_QN_c_1672_n N_QN_c_1641_n N_QN_c_1737_p N_QN_c_1675_n N_QN_c_1642_n \
 N_QN_c_1676_n N_QN_c_1713_n N_QN_c_1643_n N_QN_c_1644_n N_QN_c_1717_n \
 N_QN_c_1678_n N_QN_c_1679_n N_QN_c_1722_n N_QN_c_1754_p N_QN_c_1755_p \
 N_QN_M12_noxref_g N_QN_M39_noxref_g N_QN_M40_noxref_g N_QN_c_1645_n \
 N_QN_c_1647_n N_QN_c_1648_n N_QN_c_1649_n N_QN_c_1650_n N_QN_c_1651_n \
 N_QN_c_1652_n N_QN_c_1654_n N_QN_c_1748_p N_QN_c_1684_n N_QN_M11_noxref_d \
 N_QN_M35_noxref_d N_QN_M37_noxref_d )  PM_DFFSNQNX1\%QN
x_PM_DFFSNQNX1\%SN ( N_SN_c_1812_n N_SN_c_1822_n SN SN SN SN SN SN SN SN SN \
 N_SN_c_1840_n N_SN_c_1826_n N_SN_c_1909_n N_SN_c_1828_n N_SN_c_1823_n \
 N_SN_c_1845_n N_SN_c_1892_n N_SN_c_1824_n N_SN_c_1914_n N_SN_c_1916_n \
 N_SN_c_1919_n N_SN_M6_noxref_g N_SN_M13_noxref_g N_SN_M27_noxref_g \
 N_SN_M28_noxref_g N_SN_M41_noxref_g N_SN_M42_noxref_g N_SN_c_1849_n \
 N_SN_c_1852_n N_SN_c_2031_p N_SN_c_2039_p N_SN_c_1854_n N_SN_c_1855_n \
 N_SN_c_1856_n N_SN_c_1857_n N_SN_c_1877_n N_SN_c_1923_n N_SN_c_1926_n \
 N_SN_c_2067_p N_SN_c_2074_p N_SN_c_1928_n N_SN_c_1929_n N_SN_c_1930_n \
 N_SN_c_1931_n N_SN_c_1946_p N_SN_c_1859_n N_SN_c_1933_n )  PM_DFFSNQNX1\%SN
x_PM_DFFSNQNX1\%noxref_10 ( N_noxref_10_c_2079_n N_noxref_10_c_2135_n \
 N_noxref_10_c_2081_n N_noxref_10_c_2145_n N_noxref_10_c_2082_n \
 N_noxref_10_c_2185_n N_noxref_10_c_2083_n N_noxref_10_c_2084_n \
 N_noxref_10_c_2097_n N_noxref_10_c_2101_n N_noxref_10_c_2103_n \
 N_noxref_10_c_2085_n N_noxref_10_c_2331_n N_noxref_10_c_2086_n \
 N_noxref_10_c_2087_n N_noxref_10_c_2221_n N_noxref_10_M4_noxref_g \
 N_noxref_10_M7_noxref_g N_noxref_10_M14_noxref_g N_noxref_10_M23_noxref_g \
 N_noxref_10_M24_noxref_g N_noxref_10_M29_noxref_g N_noxref_10_M30_noxref_g \
 N_noxref_10_M43_noxref_g N_noxref_10_M44_noxref_g N_noxref_10_c_2225_n \
 N_noxref_10_c_2226_n N_noxref_10_c_2227_n N_noxref_10_c_2277_n \
 N_noxref_10_c_2278_n N_noxref_10_c_2280_n N_noxref_10_c_2281_n \
 N_noxref_10_c_2160_n N_noxref_10_c_2161_n N_noxref_10_c_2162_n \
 N_noxref_10_c_2163_n N_noxref_10_c_2164_n N_noxref_10_c_2166_n \
 N_noxref_10_c_2167_n N_noxref_10_c_2356_n N_noxref_10_c_2357_n \
 N_noxref_10_c_2358_n N_noxref_10_c_2393_p N_noxref_10_c_2379_p \
 N_noxref_10_c_2395_p N_noxref_10_c_2380_p N_noxref_10_c_2140_n \
 N_noxref_10_c_2230_n N_noxref_10_c_2231_n N_noxref_10_c_2169_n \
 N_noxref_10_c_2170_n N_noxref_10_c_2172_n N_noxref_10_c_2367_n \
 N_noxref_10_c_2370_n N_noxref_10_c_2371_n N_noxref_10_M9_noxref_d \
 N_noxref_10_M31_noxref_d N_noxref_10_M33_noxref_d )  PM_DFFSNQNX1\%noxref_10
x_PM_DFFSNQNX1\%noxref_11 ( N_noxref_11_c_2441_n N_noxref_11_c_2445_n \
 N_noxref_11_c_2447_n N_noxref_11_c_2451_n N_noxref_11_c_2437_n \
 N_noxref_11_c_2530_p N_noxref_11_c_2438_n N_noxref_11_c_2494_n \
 N_noxref_11_c_2510_n N_noxref_11_M14_noxref_d N_noxref_11_M39_noxref_d \
 N_noxref_11_M41_noxref_d N_noxref_11_M43_noxref_d )  PM_DFFSNQNX1\%noxref_11
x_PM_DFFSNQNX1\%D ( D D D D D D D N_D_c_2535_n N_D_c_2547_n N_D_c_2562_n \
 N_D_c_2563_n N_D_c_2564_n N_D_c_2565_n N_D_c_2566_n N_D_c_2567_n \
 N_D_M0_noxref_g N_D_M15_noxref_g N_D_M16_noxref_g N_D_c_2536_n N_D_c_2538_n \
 N_D_c_2539_n N_D_c_2540_n N_D_c_2541_n N_D_c_2542_n N_D_c_2543_n N_D_c_2545_n \
 N_D_c_2553_n )  PM_DFFSNQNX1\%D
x_PM_DFFSNQNX1\%noxref_13 ( N_noxref_13_c_2639_n N_noxref_13_c_2620_n \
 N_noxref_13_c_2624_n N_noxref_13_c_2627_n N_noxref_13_c_2628_n \
 N_noxref_13_c_2631_n N_noxref_13_M0_noxref_s )  PM_DFFSNQNX1\%noxref_13
x_PM_DFFSNQNX1\%noxref_14 ( N_noxref_14_c_2685_n N_noxref_14_c_2669_n \
 N_noxref_14_c_2673_n N_noxref_14_c_2676_n N_noxref_14_c_2696_n \
 N_noxref_14_M2_noxref_s )  PM_DFFSNQNX1\%noxref_14
x_PM_DFFSNQNX1\%noxref_15 ( N_noxref_15_c_2722_n N_noxref_15_c_2724_n \
 N_noxref_15_c_2727_n N_noxref_15_c_2730_n N_noxref_15_c_2753_n \
 N_noxref_15_M3_noxref_d N_noxref_15_M4_noxref_s )  PM_DFFSNQNX1\%noxref_15
x_PM_DFFSNQNX1\%noxref_16 ( N_noxref_16_c_2791_n N_noxref_16_c_2775_n \
 N_noxref_16_c_2779_n N_noxref_16_c_2782_n N_noxref_16_c_2808_n \
 N_noxref_16_M5_noxref_s )  PM_DFFSNQNX1\%noxref_16
x_PM_DFFSNQNX1\%noxref_17 ( N_noxref_17_c_2829_n N_noxref_17_c_2831_n \
 N_noxref_17_c_2834_n N_noxref_17_c_2837_n N_noxref_17_c_2845_n \
 N_noxref_17_M6_noxref_d N_noxref_17_M7_noxref_s )  PM_DFFSNQNX1\%noxref_17
x_PM_DFFSNQNX1\%noxref_18 ( N_noxref_18_c_2901_n N_noxref_18_c_2882_n \
 N_noxref_18_c_2886_n N_noxref_18_c_2889_n N_noxref_18_c_2890_n \
 N_noxref_18_c_2893_n N_noxref_18_M8_noxref_s )  PM_DFFSNQNX1\%noxref_18
x_PM_DFFSNQNX1\%noxref_19 ( N_noxref_19_c_2954_n N_noxref_19_c_2935_n \
 N_noxref_19_c_2939_n N_noxref_19_c_2942_n N_noxref_19_c_2943_n \
 N_noxref_19_c_2946_n N_noxref_19_M10_noxref_s )  PM_DFFSNQNX1\%noxref_19
x_PM_DFFSNQNX1\%noxref_20 ( N_noxref_20_c_3002_n N_noxref_20_c_2988_n \
 N_noxref_20_c_2992_n N_noxref_20_c_2995_n N_noxref_20_c_3019_n \
 N_noxref_20_M12_noxref_s )  PM_DFFSNQNX1\%noxref_20
x_PM_DFFSNQNX1\%noxref_21 ( N_noxref_21_c_3039_n N_noxref_21_c_3041_n \
 N_noxref_21_c_3044_n N_noxref_21_c_3046_n N_noxref_21_c_3067_n \
 N_noxref_21_M13_noxref_d N_noxref_21_M14_noxref_s )  PM_DFFSNQNX1\%noxref_21
cc_1 ( N_GND_c_1_p N_VDD_c_290_n ) capacitor c=0.00989514f //x=24.115 //y=0.18 \
 //x2=24.115 //y2=7.58
cc_2 ( N_GND_c_2_p N_VDD_c_291_n ) capacitor c=0.00989514f //x=1.175 //y=0.18 \
 //x2=1.175 //y2=7.58
cc_3 ( N_GND_c_3_p N_VDD_c_292_n ) capacitor c=0.00582337f //x=3.765 //y=0.175 \
 //x2=3.765 //y2=7.585
cc_4 ( N_GND_c_4_p N_VDD_c_293_n ) capacitor c=0.00572592f //x=8.575 //y=0.175 \
 //x2=8.575 //y2=7.585
cc_5 ( N_GND_c_5_p N_VDD_c_294_n ) capacitor c=0.00572592f //x=13.385 \
 //y=0.175 //x2=13.385 //y2=7.585
cc_6 ( N_GND_c_6_p N_VDD_c_295_n ) capacitor c=0.00524733f //x=16.715 \
 //y=0.175 //x2=16.715 //y2=7.585
cc_7 ( N_GND_c_7_p N_VDD_c_296_n ) capacitor c=0.00802612f //x=20.045 \
 //y=0.175 //x2=20.045 //y2=7.585
cc_8 ( N_GND_c_8_p N_noxref_3_c_602_n ) capacitor c=0.0139992f //x=24.115 \
 //y=0.18 //x2=4.73 //y2=2.77
cc_9 ( N_GND_c_9_p N_noxref_3_c_602_n ) capacitor c=0.00231062f //x=3.595 \
 //y=0.175 //x2=4.73 //y2=2.77
cc_10 ( N_GND_c_10_p N_noxref_3_c_602_n ) capacitor c=0.00222056f //x=4.755 \
 //y=0.175 //x2=4.73 //y2=2.77
cc_11 ( N_GND_c_3_p N_noxref_3_c_602_n ) capacitor c=0.038878f //x=3.765 \
 //y=0.175 //x2=4.73 //y2=2.77
cc_12 ( N_GND_c_8_p N_noxref_3_c_606_n ) capacitor c=0.00222761f //x=24.115 \
 //y=0.18 //x2=3.14 //y2=2.77
cc_13 ( N_GND_c_3_p N_noxref_3_c_606_n ) capacitor c=0.00111411f //x=3.765 \
 //y=0.175 //x2=3.14 //y2=2.77
cc_14 ( N_GND_c_8_p N_noxref_3_c_608_n ) capacitor c=0.0394795f //x=24.115 \
 //y=0.18 //x2=9.57 //y2=2.77
cc_15 ( N_GND_c_15_p N_noxref_3_c_608_n ) capacitor c=0.00344532f //x=8.405 \
 //y=0.175 //x2=9.57 //y2=2.77
cc_16 ( N_GND_c_16_p N_noxref_3_c_608_n ) capacitor c=0.00222056f //x=9.565 \
 //y=0.175 //x2=9.57 //y2=2.77
cc_17 ( N_GND_c_4_p N_noxref_3_c_608_n ) capacitor c=0.0392112f //x=8.575 \
 //y=0.175 //x2=9.57 //y2=2.77
cc_18 ( N_GND_c_8_p N_noxref_3_c_612_n ) capacitor c=0.00381213f //x=24.115 \
 //y=0.18 //x2=5.14 //y2=2.77
cc_19 ( N_GND_c_3_p N_noxref_3_c_612_n ) capacitor c=7.88768e-19 //x=3.765 \
 //y=0.175 //x2=5.14 //y2=2.77
cc_20 ( N_GND_c_3_p N_noxref_3_c_614_n ) capacitor c=0.0430571f //x=3.765 \
 //y=0.175 //x2=2.94 //y2=1.835
cc_21 ( N_GND_c_2_p N_noxref_3_c_615_n ) capacitor c=0.00101801f //x=1.175 \
 //y=0.18 //x2=3.025 //y2=2.77
cc_22 ( N_GND_c_3_p N_noxref_3_c_615_n ) capacitor c=5.56859e-19 //x=3.765 \
 //y=0.175 //x2=3.025 //y2=2.77
cc_23 ( N_GND_c_3_p N_noxref_3_c_617_n ) capacitor c=0.0150282f //x=3.765 \
 //y=0.175 //x2=4.875 //y2=2.26
cc_24 ( N_GND_c_4_p N_noxref_3_c_618_n ) capacitor c=0.0147449f //x=8.575 \
 //y=0.175 //x2=9.685 //y2=2.26
cc_25 ( N_GND_c_10_p N_noxref_3_c_619_n ) capacitor c=0.00133465f //x=4.755 \
 //y=0.175 //x2=4.575 //y2=1.055
cc_26 ( N_GND_M2_noxref_d N_noxref_3_c_619_n ) capacitor c=0.00211996f \
 //x=4.65 //y=1.055 //x2=4.575 //y2=1.055
cc_27 ( N_GND_M2_noxref_d N_noxref_3_c_621_n ) capacitor c=0.00255985f \
 //x=4.65 //y=1.055 //x2=4.575 //y2=1.4
cc_28 ( N_GND_c_3_p N_noxref_3_c_622_n ) capacitor c=0.00195164f //x=3.765 \
 //y=0.175 //x2=4.575 //y2=1.71
cc_29 ( N_GND_c_3_p N_noxref_3_c_623_n ) capacitor c=0.0126573f //x=3.765 \
 //y=0.175 //x2=4.575 //y2=2.095
cc_30 ( N_GND_M2_noxref_d N_noxref_3_c_624_n ) capacitor c=0.0131387f //x=4.65 \
 //y=1.055 //x2=4.95 //y2=0.9
cc_31 ( N_GND_M2_noxref_d N_noxref_3_c_625_n ) capacitor c=0.00193165f \
 //x=4.65 //y=1.055 //x2=4.95 //y2=1.555
cc_32 ( N_GND_c_15_p N_noxref_3_c_626_n ) capacitor c=0.00129623f //x=8.405 \
 //y=0.175 //x2=5.105 //y2=1.055
cc_33 ( N_GND_M2_noxref_d N_noxref_3_c_626_n ) capacitor c=0.00257848f \
 //x=4.65 //y=1.055 //x2=5.105 //y2=1.055
cc_34 ( N_GND_M2_noxref_d N_noxref_3_c_628_n ) capacitor c=0.00255985f \
 //x=4.65 //y=1.055 //x2=5.105 //y2=1.4
cc_35 ( N_GND_c_16_p N_noxref_3_c_629_n ) capacitor c=0.00133465f //x=9.565 \
 //y=0.175 //x2=9.385 //y2=1.055
cc_36 ( N_GND_M5_noxref_d N_noxref_3_c_629_n ) capacitor c=0.00211996f \
 //x=9.46 //y=1.055 //x2=9.385 //y2=1.055
cc_37 ( N_GND_M5_noxref_d N_noxref_3_c_631_n ) capacitor c=0.00255985f \
 //x=9.46 //y=1.055 //x2=9.385 //y2=1.4
cc_38 ( N_GND_c_4_p N_noxref_3_c_632_n ) capacitor c=0.00204716f //x=8.575 \
 //y=0.175 //x2=9.385 //y2=1.71
cc_39 ( N_GND_c_4_p N_noxref_3_c_633_n ) capacitor c=0.0118433f //x=8.575 \
 //y=0.175 //x2=9.385 //y2=2.095
cc_40 ( N_GND_M5_noxref_d N_noxref_3_c_634_n ) capacitor c=0.0131387f //x=9.46 \
 //y=1.055 //x2=9.76 //y2=0.9
cc_41 ( N_GND_M5_noxref_d N_noxref_3_c_635_n ) capacitor c=0.00193165f \
 //x=9.46 //y=1.055 //x2=9.76 //y2=1.555
cc_42 ( N_GND_c_42_p N_noxref_3_c_636_n ) capacitor c=0.00129623f //x=13.215 \
 //y=0.175 //x2=9.915 //y2=1.055
cc_43 ( N_GND_M5_noxref_d N_noxref_3_c_636_n ) capacitor c=0.00257848f \
 //x=9.46 //y=1.055 //x2=9.915 //y2=1.055
cc_44 ( N_GND_M5_noxref_d N_noxref_3_c_638_n ) capacitor c=0.00255985f \
 //x=9.46 //y=1.055 //x2=9.915 //y2=1.4
cc_45 ( N_GND_c_2_p N_noxref_3_M1_noxref_d ) capacitor c=8.58106e-19 //x=1.175 \
 //y=0.18 //x2=2.395 //y2=1.085
cc_46 ( N_GND_c_3_p N_noxref_3_M1_noxref_d ) capacitor c=0.00616547f //x=3.765 \
 //y=0.175 //x2=2.395 //y2=1.085
cc_47 ( N_GND_M0_noxref_d N_noxref_3_M1_noxref_d ) capacitor c=0.00143464f \
 //x=1.425 //y=1.045 //x2=2.395 //y2=1.085
cc_48 ( N_GND_c_5_p N_noxref_4_c_857_n ) capacitor c=0.026175f //x=13.385 \
 //y=0.175 //x2=14.38 //y2=2.77
cc_49 ( N_GND_c_5_p N_noxref_4_c_858_n ) capacitor c=0.00102529f //x=13.385 \
 //y=0.175 //x2=12.76 //y2=2.77
cc_50 ( N_GND_c_5_p N_noxref_4_c_859_n ) capacitor c=0.0401238f //x=13.385 \
 //y=0.175 //x2=12.56 //y2=1.845
cc_51 ( N_GND_c_5_p N_noxref_4_c_860_n ) capacitor c=5.56859e-19 //x=13.385 \
 //y=0.175 //x2=12.645 //y2=2.77
cc_52 ( N_GND_c_5_p N_noxref_4_c_861_n ) capacitor c=0.0128176f //x=13.385 \
 //y=0.175 //x2=14.495 //y2=2.26
cc_53 ( N_GND_c_53_p N_noxref_4_c_862_n ) capacitor c=0.00135783f //x=14.48 \
 //y=0.175 //x2=14.3 //y2=1.045
cc_54 ( N_GND_M8_noxref_d N_noxref_4_c_862_n ) capacitor c=0.00220047f \
 //x=14.375 //y=1.045 //x2=14.3 //y2=1.045
cc_55 ( N_GND_M8_noxref_d N_noxref_4_c_864_n ) capacitor c=0.00255985f \
 //x=14.375 //y=1.045 //x2=14.3 //y2=1.39
cc_56 ( N_GND_c_5_p N_noxref_4_c_865_n ) capacitor c=0.00189421f //x=13.385 \
 //y=0.175 //x2=14.3 //y2=1.7
cc_57 ( N_GND_c_5_p N_noxref_4_c_866_n ) capacitor c=0.00992619f //x=13.385 \
 //y=0.175 //x2=14.3 //y2=2.095
cc_58 ( N_GND_M8_noxref_d N_noxref_4_c_867_n ) capacitor c=0.0131374f \
 //x=14.375 //y=1.045 //x2=14.675 //y2=0.89
cc_59 ( N_GND_M8_noxref_d N_noxref_4_c_868_n ) capacitor c=0.00193146f \
 //x=14.375 //y=1.045 //x2=14.675 //y2=1.545
cc_60 ( N_GND_c_60_p N_noxref_4_c_869_n ) capacitor c=0.00131234f //x=16.545 \
 //y=0.175 //x2=14.83 //y2=1.045
cc_61 ( N_GND_M8_noxref_d N_noxref_4_c_869_n ) capacitor c=0.00257848f \
 //x=14.375 //y=1.045 //x2=14.83 //y2=1.045
cc_62 ( N_GND_M8_noxref_d N_noxref_4_c_871_n ) capacitor c=0.00255985f \
 //x=14.375 //y=1.045 //x2=14.83 //y2=1.39
cc_63 ( N_GND_c_5_p N_noxref_4_M7_noxref_d ) capacitor c=0.00591582f \
 //x=13.385 //y=0.175 //x2=11.97 //y2=1.095
cc_64 ( N_GND_c_6_p CLK ) capacitor c=5.01941e-19 //x=16.715 //y=0.175 \
 //x2=15.29 //y2=2.77
cc_65 ( N_GND_c_3_p N_CLK_c_1024_n ) capacitor c=7.5188e-19 //x=3.765 \
 //y=0.175 //x2=5.985 //y2=2.26
cc_66 ( N_GND_c_5_p N_CLK_c_1025_n ) capacitor c=9.25978e-19 //x=13.385 \
 //y=0.175 //x2=15.235 //y2=2.26
cc_67 ( N_GND_c_6_p N_CLK_c_1025_n ) capacitor c=5.09695e-19 //x=16.715 \
 //y=0.175 //x2=15.235 //y2=2.26
cc_68 ( N_GND_c_8_p N_noxref_6_c_1250_n ) capacitor c=0.00601337f //x=24.115 \
 //y=0.18 //x2=7.715 //y2=4.25
cc_69 ( N_GND_c_3_p N_noxref_6_c_1250_n ) capacitor c=0.00249392f //x=3.765 \
 //y=0.175 //x2=7.715 //y2=4.25
cc_70 ( N_GND_c_8_p N_noxref_6_c_1252_n ) capacitor c=0.00138662f //x=24.115 \
 //y=0.18 //x2=2.4 //y2=4.25
cc_71 ( N_GND_c_2_p N_noxref_6_c_1253_n ) capacitor c=0.00117047f //x=1.175 \
 //y=0.18 //x2=2.285 //y2=2.26
cc_72 ( N_GND_c_3_p N_noxref_6_c_1253_n ) capacitor c=0.00110672f //x=3.765 \
 //y=0.175 //x2=2.285 //y2=2.26
cc_73 ( N_GND_c_4_p N_noxref_6_c_1255_n ) capacitor c=0.0425027f //x=8.575 \
 //y=0.175 //x2=7.75 //y2=1.845
cc_74 ( N_GND_c_6_p N_noxref_6_c_1256_n ) capacitor c=0.0154414f //x=16.715 \
 //y=0.175 //x2=17.825 //y2=2.26
cc_75 ( N_GND_c_75_p N_noxref_6_c_1257_n ) capacitor c=0.00135783f //x=17.81 \
 //y=0.175 //x2=17.63 //y2=1.045
cc_76 ( N_GND_M10_noxref_d N_noxref_6_c_1257_n ) capacitor c=0.00220047f \
 //x=17.705 //y=1.045 //x2=17.63 //y2=1.045
cc_77 ( N_GND_M10_noxref_d N_noxref_6_c_1259_n ) capacitor c=0.00255985f \
 //x=17.705 //y=1.045 //x2=17.63 //y2=1.39
cc_78 ( N_GND_c_6_p N_noxref_6_c_1260_n ) capacitor c=0.0018059f //x=16.715 \
 //y=0.175 //x2=17.63 //y2=1.7
cc_79 ( N_GND_c_6_p N_noxref_6_c_1261_n ) capacitor c=0.0101006f //x=16.715 \
 //y=0.175 //x2=17.63 //y2=2.095
cc_80 ( N_GND_M10_noxref_d N_noxref_6_c_1262_n ) capacitor c=0.0131374f \
 //x=17.705 //y=1.045 //x2=18.005 //y2=0.89
cc_81 ( N_GND_M10_noxref_d N_noxref_6_c_1263_n ) capacitor c=0.00193146f \
 //x=17.705 //y=1.045 //x2=18.005 //y2=1.545
cc_82 ( N_GND_c_82_p N_noxref_6_c_1264_n ) capacitor c=0.00131234f //x=19.875 \
 //y=0.175 //x2=18.16 //y2=1.045
cc_83 ( N_GND_M10_noxref_d N_noxref_6_c_1264_n ) capacitor c=0.00257848f \
 //x=17.705 //y=1.045 //x2=18.16 //y2=1.045
cc_84 ( N_GND_M10_noxref_d N_noxref_6_c_1266_n ) capacitor c=0.00255985f \
 //x=17.705 //y=1.045 //x2=18.16 //y2=1.39
cc_85 ( N_GND_c_4_p N_noxref_6_M4_noxref_d ) capacitor c=0.00591582f //x=8.575 \
 //y=0.175 //x2=7.16 //y2=1.095
cc_86 ( N_GND_c_6_p N_noxref_7_c_1557_n ) capacitor c=7.1088e-19 //x=16.715 \
 //y=0.175 //x2=18.565 //y2=2.26
cc_87 ( N_GND_c_7_p N_noxref_7_c_1557_n ) capacitor c=7.97321e-19 //x=20.045 \
 //y=0.175 //x2=18.565 //y2=2.26
cc_88 ( N_GND_c_7_p QN ) capacitor c=0.00926924f //x=20.045 //y=0.175 \
 //x2=19.36 //y2=2.77
cc_89 ( N_GND_c_7_p QN ) capacitor c=0.00949869f //x=20.045 //y=0.175 \
 //x2=21.21 //y2=3.14
cc_90 ( N_GND_c_7_p N_QN_c_1641_n ) capacitor c=0.0342545f //x=20.045 \
 //y=0.175 //x2=19.22 //y2=1.835
cc_91 ( N_GND_c_7_p N_QN_c_1642_n ) capacitor c=0.0157206f //x=20.045 \
 //y=0.175 //x2=21.155 //y2=2.26
cc_92 ( N_GND_c_6_p N_QN_c_1643_n ) capacitor c=9.64732e-19 //x=16.715 \
 //y=0.175 //x2=19.332 //y2=2.685
cc_93 ( N_GND_c_7_p N_QN_c_1644_n ) capacitor c=0.00171326f //x=20.045 \
 //y=0.175 //x2=19.332 //y2=3.055
cc_94 ( N_GND_c_94_p N_QN_c_1645_n ) capacitor c=0.00133465f //x=21.035 \
 //y=0.175 //x2=20.855 //y2=1.055
cc_95 ( N_GND_M12_noxref_d N_QN_c_1645_n ) capacitor c=0.00211996f //x=20.93 \
 //y=1.055 //x2=20.855 //y2=1.055
cc_96 ( N_GND_M12_noxref_d N_QN_c_1647_n ) capacitor c=0.00255985f //x=20.93 \
 //y=1.055 //x2=20.855 //y2=1.4
cc_97 ( N_GND_c_7_p N_QN_c_1648_n ) capacitor c=0.00195164f //x=20.045 \
 //y=0.175 //x2=20.855 //y2=1.71
cc_98 ( N_GND_c_7_p N_QN_c_1649_n ) capacitor c=0.0110952f //x=20.045 \
 //y=0.175 //x2=20.855 //y2=2.095
cc_99 ( N_GND_M12_noxref_d N_QN_c_1650_n ) capacitor c=0.0131387f //x=20.93 \
 //y=1.055 //x2=21.23 //y2=0.9
cc_100 ( N_GND_M12_noxref_d N_QN_c_1651_n ) capacitor c=0.00193165f //x=20.93 \
 //y=1.055 //x2=21.23 //y2=1.555
cc_101 ( N_GND_c_1_p N_QN_c_1652_n ) capacitor c=0.00129623f //x=24.115 \
 //y=0.18 //x2=21.385 //y2=1.055
cc_102 ( N_GND_M12_noxref_d N_QN_c_1652_n ) capacitor c=0.00257848f //x=20.93 \
 //y=1.055 //x2=21.385 //y2=1.055
cc_103 ( N_GND_M12_noxref_d N_QN_c_1654_n ) capacitor c=0.00255985f //x=20.93 \
 //y=1.055 //x2=21.385 //y2=1.4
cc_104 ( N_GND_c_6_p N_QN_M11_noxref_d ) capacitor c=8.58106e-19 //x=16.715 \
 //y=0.175 //x2=18.675 //y2=1.085
cc_105 ( N_GND_c_7_p N_QN_M11_noxref_d ) capacitor c=0.00616547f //x=20.045 \
 //y=0.175 //x2=18.675 //y2=1.085
cc_106 ( N_GND_M10_noxref_d N_QN_M11_noxref_d ) capacitor c=0.00143464f \
 //x=17.705 //y=1.045 //x2=18.675 //y2=1.085
cc_107 ( N_GND_c_8_p N_SN_c_1812_n ) capacitor c=0.108882f //x=24.115 //y=0.18 \
 //x2=22.15 //y2=2.4
cc_108 ( N_GND_c_42_p N_SN_c_1812_n ) capacitor c=0.00446269f //x=13.215 \
 //y=0.175 //x2=22.15 //y2=2.4
cc_109 ( N_GND_c_53_p N_SN_c_1812_n ) capacitor c=0.00347867f //x=14.48 \
 //y=0.175 //x2=22.15 //y2=2.4
cc_110 ( N_GND_c_60_p N_SN_c_1812_n ) capacitor c=0.00412122f //x=16.545 \
 //y=0.175 //x2=22.15 //y2=2.4
cc_111 ( N_GND_c_75_p N_SN_c_1812_n ) capacitor c=0.00347867f //x=17.81 \
 //y=0.175 //x2=22.15 //y2=2.4
cc_112 ( N_GND_c_82_p N_SN_c_1812_n ) capacitor c=0.00409134f //x=19.875 \
 //y=0.175 //x2=22.15 //y2=2.4
cc_113 ( N_GND_c_94_p N_SN_c_1812_n ) capacitor c=0.00274395f //x=21.035 \
 //y=0.175 //x2=22.15 //y2=2.4
cc_114 ( N_GND_c_5_p N_SN_c_1812_n ) capacitor c=0.0379964f //x=13.385 \
 //y=0.175 //x2=22.15 //y2=2.4
cc_115 ( N_GND_c_6_p N_SN_c_1812_n ) capacitor c=0.0430854f //x=16.715 \
 //y=0.175 //x2=22.15 //y2=2.4
cc_116 ( N_GND_c_7_p N_SN_c_1812_n ) capacitor c=0.0401775f //x=20.045 \
 //y=0.175 //x2=22.15 //y2=2.4
cc_117 ( N_GND_c_8_p N_SN_c_1822_n ) capacitor c=0.00191259f //x=24.115 \
 //y=0.18 //x2=10.91 //y2=2.4
cc_118 ( N_GND_c_4_p N_SN_c_1823_n ) capacitor c=9.88402e-19 //x=8.575 \
 //y=0.175 //x2=10.822 //y2=2.685
cc_119 ( N_GND_c_7_p N_SN_c_1824_n ) capacitor c=6.01229e-19 //x=20.045 \
 //y=0.175 //x2=22.292 //y2=2.685
cc_120 ( N_GND_c_8_p N_noxref_10_c_2079_n ) capacitor c=0.00925903f //x=24.115 \
 //y=0.18 //x2=11.79 //y2=3.88
cc_121 ( N_GND_c_4_p N_noxref_10_c_2079_n ) capacitor c=0.003498f //x=8.575 \
 //y=0.175 //x2=11.79 //y2=3.88
cc_122 ( N_GND_c_5_p N_noxref_10_c_2081_n ) capacitor c=0.003498f //x=13.385 \
 //y=0.175 //x2=15.86 //y2=3.88
cc_123 ( N_GND_c_6_p N_noxref_10_c_2082_n ) capacitor c=0.00390258f //x=16.715 \
 //y=0.175 //x2=23.26 //y2=3.88
cc_124 ( N_GND_c_4_p N_noxref_10_c_2083_n ) capacitor c=7.88616e-19 //x=8.575 \
 //y=0.175 //x2=7.095 //y2=2.26
cc_125 ( N_GND_c_5_p N_noxref_10_c_2084_n ) capacitor c=0.00101012f //x=13.385 \
 //y=0.175 //x2=11.905 //y2=2.26
cc_126 ( N_GND_c_6_p N_noxref_10_c_2085_n ) capacitor c=0.0432305f //x=16.715 \
 //y=0.175 //x2=15.89 //y2=1.835
cc_127 ( N_GND_c_5_p N_noxref_10_c_2086_n ) capacitor c=9.64732e-19 //x=13.385 \
 //y=0.175 //x2=15.975 //y2=3.88
cc_128 ( N_GND_c_1_p N_noxref_10_c_2087_n ) capacitor c=0.00128271f //x=24.115 \
 //y=0.18 //x2=23.375 //y2=2.26
cc_129 ( N_GND_c_5_p N_noxref_10_M9_noxref_d ) capacitor c=8.58106e-19 \
 //x=13.385 //y=0.175 //x2=15.345 //y2=1.085
cc_130 ( N_GND_c_6_p N_noxref_10_M9_noxref_d ) capacitor c=0.00616547f \
 //x=16.715 //y=0.175 //x2=15.345 //y2=1.085
cc_131 ( N_GND_M8_noxref_d N_noxref_10_M9_noxref_d ) capacitor c=0.00143464f \
 //x=14.375 //y=1.045 //x2=15.345 //y2=1.085
cc_132 ( N_GND_c_1_p N_noxref_11_c_2437_n ) capacitor c=0.0461869f //x=24.115 \
 //y=0.18 //x2=24.03 //y2=1.845
cc_133 ( N_GND_c_8_p N_noxref_11_c_2438_n ) capacitor c=0.0145999f //x=24.115 \
 //y=0.18 //x2=24.115 //y2=3.51
cc_134 ( N_GND_c_1_p N_noxref_11_c_2438_n ) capacitor c=8.41294e-19 //x=24.115 \
 //y=0.18 //x2=24.115 //y2=3.51
cc_135 ( N_GND_c_1_p N_noxref_11_M14_noxref_d ) capacitor c=0.00593061f \
 //x=24.115 //y=0.18 //x2=23.44 //y2=1.095
cc_136 ( N_GND_c_2_p N_D_c_2535_n ) capacitor c=0.0179029f //x=1.175 //y=0.18 \
 //x2=1.545 //y2=2.485
cc_137 ( N_GND_c_137_p N_D_c_2536_n ) capacitor c=0.00135783f //x=1.53 \
 //y=0.175 //x2=1.35 //y2=1.045
cc_138 ( N_GND_M0_noxref_d N_D_c_2536_n ) capacitor c=0.00220047f //x=1.425 \
 //y=1.045 //x2=1.35 //y2=1.045
cc_139 ( N_GND_M0_noxref_d N_D_c_2538_n ) capacitor c=0.00255985f //x=1.425 \
 //y=1.045 //x2=1.35 //y2=1.39
cc_140 ( N_GND_c_2_p N_D_c_2539_n ) capacitor c=0.00264481f //x=1.175 //y=0.18 \
 //x2=1.35 //y2=1.7
cc_141 ( N_GND_c_2_p N_D_c_2540_n ) capacitor c=0.0121947f //x=1.175 //y=0.18 \
 //x2=1.35 //y2=2.095
cc_142 ( N_GND_M0_noxref_d N_D_c_2541_n ) capacitor c=0.0131374f //x=1.425 \
 //y=1.045 //x2=1.725 //y2=0.89
cc_143 ( N_GND_M0_noxref_d N_D_c_2542_n ) capacitor c=0.00193146f //x=1.425 \
 //y=1.045 //x2=1.725 //y2=1.545
cc_144 ( N_GND_c_9_p N_D_c_2543_n ) capacitor c=0.00131234f //x=3.595 \
 //y=0.175 //x2=1.88 //y2=1.045
cc_145 ( N_GND_M0_noxref_d N_D_c_2543_n ) capacitor c=0.00257848f //x=1.425 \
 //y=1.045 //x2=1.88 //y2=1.045
cc_146 ( N_GND_M0_noxref_d N_D_c_2545_n ) capacitor c=0.00255985f //x=1.425 \
 //y=1.045 //x2=1.88 //y2=1.39
cc_147 ( N_GND_c_8_p N_noxref_13_c_2620_n ) capacitor c=0.00704945f //x=24.115 \
 //y=0.18 //x2=2.015 //y2=1.76
cc_148 ( N_GND_c_137_p N_noxref_13_c_2620_n ) capacitor c=0.00111556f //x=1.53 \
 //y=0.175 //x2=2.015 //y2=1.76
cc_149 ( N_GND_c_9_p N_noxref_13_c_2620_n ) capacitor c=0.00181083f //x=3.595 \
 //y=0.175 //x2=2.015 //y2=1.76
cc_150 ( N_GND_M0_noxref_d N_noxref_13_c_2620_n ) capacitor c=0.0089077f \
 //x=1.425 //y=1.045 //x2=2.015 //y2=1.76
cc_151 ( N_GND_c_8_p N_noxref_13_c_2624_n ) capacitor c=0.00688193f //x=24.115 \
 //y=0.18 //x2=2.1 //y2=0.795
cc_152 ( N_GND_c_9_p N_noxref_13_c_2624_n ) capacitor c=0.014661f //x=3.595 \
 //y=0.175 //x2=2.1 //y2=0.795
cc_153 ( N_GND_M0_noxref_d N_noxref_13_c_2624_n ) capacitor c=0.033812f \
 //x=1.425 //y=1.045 //x2=2.1 //y2=0.795
cc_154 ( N_GND_c_2_p N_noxref_13_c_2627_n ) capacitor c=2.91423e-19 //x=1.175 \
 //y=0.18 //x2=2.1 //y2=1.675
cc_155 ( N_GND_c_8_p N_noxref_13_c_2628_n ) capacitor c=0.0134277f //x=24.115 \
 //y=0.18 //x2=2.985 //y2=0.71
cc_156 ( N_GND_c_9_p N_noxref_13_c_2628_n ) capacitor c=0.0373158f //x=3.595 \
 //y=0.175 //x2=2.985 //y2=0.71
cc_157 ( N_GND_c_1_p N_noxref_13_c_2628_n ) capacitor c=0.00198522f //x=24.115 \
 //y=0.18 //x2=2.985 //y2=0.71
cc_158 ( N_GND_c_8_p N_noxref_13_c_2631_n ) capacitor c=0.0027061f //x=24.115 \
 //y=0.18 //x2=3.07 //y2=0.795
cc_159 ( N_GND_c_9_p N_noxref_13_c_2631_n ) capacitor c=0.0147329f //x=3.595 \
 //y=0.175 //x2=3.07 //y2=0.795
cc_160 ( N_GND_c_3_p N_noxref_13_c_2631_n ) capacitor c=0.0431718f //x=3.765 \
 //y=0.175 //x2=3.07 //y2=0.795
cc_161 ( N_GND_c_8_p N_noxref_13_M0_noxref_s ) capacitor c=0.00724992f \
 //x=24.115 //y=0.18 //x2=0.995 //y2=0.545
cc_162 ( N_GND_c_137_p N_noxref_13_M0_noxref_s ) capacitor c=0.014661f \
 //x=1.53 //y=0.175 //x2=0.995 //y2=0.545
cc_163 ( N_GND_c_2_p N_noxref_13_M0_noxref_s ) capacitor c=0.0594057f \
 //x=1.175 //y=0.18 //x2=0.995 //y2=0.545
cc_164 ( N_GND_c_3_p N_noxref_13_M0_noxref_s ) capacitor c=0.00198098f \
 //x=3.765 //y=0.175 //x2=0.995 //y2=0.545
cc_165 ( N_GND_M0_noxref_d N_noxref_13_M0_noxref_s ) capacitor c=0.0334197f \
 //x=1.425 //y=1.045 //x2=0.995 //y2=0.545
cc_166 ( N_GND_c_8_p N_noxref_14_c_2669_n ) capacitor c=0.00529644f //x=24.115 \
 //y=0.18 //x2=5.24 //y2=1.77
cc_167 ( N_GND_c_10_p N_noxref_14_c_2669_n ) capacitor c=0.0011162f //x=4.755 \
 //y=0.175 //x2=5.24 //y2=1.77
cc_168 ( N_GND_c_15_p N_noxref_14_c_2669_n ) capacitor c=0.00180892f //x=8.405 \
 //y=0.175 //x2=5.24 //y2=1.77
cc_169 ( N_GND_M2_noxref_d N_noxref_14_c_2669_n ) capacitor c=0.00868518f \
 //x=4.65 //y=1.055 //x2=5.24 //y2=1.77
cc_170 ( N_GND_c_8_p N_noxref_14_c_2673_n ) capacitor c=0.00266677f //x=24.115 \
 //y=0.18 //x2=5.325 //y2=0.805
cc_171 ( N_GND_c_15_p N_noxref_14_c_2673_n ) capacitor c=0.0142029f //x=8.405 \
 //y=0.175 //x2=5.325 //y2=0.805
cc_172 ( N_GND_M2_noxref_d N_noxref_14_c_2673_n ) capacitor c=0.033954f \
 //x=4.65 //y=1.055 //x2=5.325 //y2=0.805
cc_173 ( N_GND_c_8_p N_noxref_14_c_2676_n ) capacitor c=0.0109346f //x=24.115 \
 //y=0.18 //x2=6.21 //y2=0.72
cc_174 ( N_GND_c_15_p N_noxref_14_c_2676_n ) capacitor c=0.0361571f //x=8.405 \
 //y=0.175 //x2=6.21 //y2=0.72
cc_175 ( N_GND_c_1_p N_noxref_14_c_2676_n ) capacitor c=0.00177401f //x=24.115 \
 //y=0.18 //x2=6.21 //y2=0.72
cc_176 ( N_GND_c_8_p N_noxref_14_M2_noxref_s ) capacitor c=0.0053241f \
 //x=24.115 //y=0.18 //x2=4.22 //y2=0.555
cc_177 ( N_GND_c_10_p N_noxref_14_M2_noxref_s ) capacitor c=0.0142029f \
 //x=4.755 //y=0.175 //x2=4.22 //y2=0.555
cc_178 ( N_GND_c_15_p N_noxref_14_M2_noxref_s ) capacitor c=0.0132459f \
 //x=8.405 //y=0.175 //x2=4.22 //y2=0.555
cc_179 ( N_GND_c_3_p N_noxref_14_M2_noxref_s ) capacitor c=0.0696963f \
 //x=3.765 //y=0.175 //x2=4.22 //y2=0.555
cc_180 ( N_GND_c_4_p N_noxref_14_M2_noxref_s ) capacitor c=3.31601e-19 \
 //x=8.575 //y=0.175 //x2=4.22 //y2=0.555
cc_181 ( N_GND_M2_noxref_d N_noxref_14_M2_noxref_s ) capacitor c=0.033718f \
 //x=4.65 //y=1.055 //x2=4.22 //y2=0.555
cc_182 ( N_GND_c_8_p N_noxref_15_c_2722_n ) capacitor c=0.00365025f //x=24.115 \
 //y=0.18 //x2=6.78 //y2=1.175
cc_183 ( N_GND_c_15_p N_noxref_15_c_2722_n ) capacitor c=0.00940539f //x=8.405 \
 //y=0.175 //x2=6.78 //y2=1.175
cc_184 ( N_GND_c_8_p N_noxref_15_c_2724_n ) capacitor c=0.00266677f //x=24.115 \
 //y=0.18 //x2=6.865 //y2=0.805
cc_185 ( N_GND_c_15_p N_noxref_15_c_2724_n ) capacitor c=0.0142029f //x=8.405 \
 //y=0.175 //x2=6.865 //y2=0.805
cc_186 ( N_GND_M2_noxref_d N_noxref_15_c_2724_n ) capacitor c=6.21394e-19 \
 //x=4.65 //y=1.055 //x2=6.865 //y2=0.805
cc_187 ( N_GND_c_8_p N_noxref_15_c_2727_n ) capacitor c=0.011013f //x=24.115 \
 //y=0.18 //x2=7.75 //y2=0.72
cc_188 ( N_GND_c_15_p N_noxref_15_c_2727_n ) capacitor c=0.0365578f //x=8.405 \
 //y=0.175 //x2=7.75 //y2=0.72
cc_189 ( N_GND_c_1_p N_noxref_15_c_2727_n ) capacitor c=0.00189501f //x=24.115 \
 //y=0.18 //x2=7.75 //y2=0.72
cc_190 ( N_GND_c_8_p N_noxref_15_c_2730_n ) capacitor c=0.00266478f //x=24.115 \
 //y=0.18 //x2=7.835 //y2=0.805
cc_191 ( N_GND_c_15_p N_noxref_15_c_2730_n ) capacitor c=0.0141392f //x=8.405 \
 //y=0.175 //x2=7.835 //y2=0.805
cc_192 ( N_GND_c_4_p N_noxref_15_c_2730_n ) capacitor c=0.0404137f //x=8.575 \
 //y=0.175 //x2=7.835 //y2=0.805
cc_193 ( N_GND_M2_noxref_d N_noxref_15_M3_noxref_d ) capacitor c=0.00162435f \
 //x=4.65 //y=1.055 //x2=5.625 //y2=1.09
cc_194 ( N_GND_c_3_p N_noxref_15_M4_noxref_s ) capacitor c=8.16352e-19 \
 //x=3.765 //y=0.175 //x2=6.73 //y2=0.555
cc_195 ( N_GND_c_4_p N_noxref_15_M4_noxref_s ) capacitor c=0.00180469f \
 //x=8.575 //y=0.175 //x2=6.73 //y2=0.555
cc_196 ( N_GND_c_8_p N_noxref_16_c_2775_n ) capacitor c=0.00537245f //x=24.115 \
 //y=0.18 //x2=10.05 //y2=1.77
cc_197 ( N_GND_c_16_p N_noxref_16_c_2775_n ) capacitor c=0.0011162f //x=9.565 \
 //y=0.175 //x2=10.05 //y2=1.77
cc_198 ( N_GND_c_42_p N_noxref_16_c_2775_n ) capacitor c=0.0017942f //x=13.215 \
 //y=0.175 //x2=10.05 //y2=1.77
cc_199 ( N_GND_M5_noxref_d N_noxref_16_c_2775_n ) capacitor c=0.00868705f \
 //x=9.46 //y=1.055 //x2=10.05 //y2=1.77
cc_200 ( N_GND_c_8_p N_noxref_16_c_2779_n ) capacitor c=0.00296983f //x=24.115 \
 //y=0.18 //x2=10.135 //y2=0.805
cc_201 ( N_GND_c_42_p N_noxref_16_c_2779_n ) capacitor c=0.0140604f //x=13.215 \
 //y=0.175 //x2=10.135 //y2=0.805
cc_202 ( N_GND_M5_noxref_d N_noxref_16_c_2779_n ) capacitor c=0.033954f \
 //x=9.46 //y=1.055 //x2=10.135 //y2=0.805
cc_203 ( N_GND_c_8_p N_noxref_16_c_2782_n ) capacitor c=0.0113478f //x=24.115 \
 //y=0.18 //x2=11.02 //y2=0.72
cc_204 ( N_GND_c_42_p N_noxref_16_c_2782_n ) capacitor c=0.0358664f //x=13.215 \
 //y=0.175 //x2=11.02 //y2=0.72
cc_205 ( N_GND_c_1_p N_noxref_16_c_2782_n ) capacitor c=0.00177401f //x=24.115 \
 //y=0.18 //x2=11.02 //y2=0.72
cc_206 ( N_GND_c_8_p N_noxref_16_M5_noxref_s ) capacitor c=0.00519881f \
 //x=24.115 //y=0.18 //x2=9.03 //y2=0.555
cc_207 ( N_GND_c_16_p N_noxref_16_M5_noxref_s ) capacitor c=0.0142029f \
 //x=9.565 //y=0.175 //x2=9.03 //y2=0.555
cc_208 ( N_GND_c_42_p N_noxref_16_M5_noxref_s ) capacitor c=0.0131542f \
 //x=13.215 //y=0.175 //x2=9.03 //y2=0.555
cc_209 ( N_GND_c_4_p N_noxref_16_M5_noxref_s ) capacitor c=0.0696963f \
 //x=8.575 //y=0.175 //x2=9.03 //y2=0.555
cc_210 ( N_GND_c_5_p N_noxref_16_M5_noxref_s ) capacitor c=3.31601e-19 \
 //x=13.385 //y=0.175 //x2=9.03 //y2=0.555
cc_211 ( N_GND_M5_noxref_d N_noxref_16_M5_noxref_s ) capacitor c=0.033718f \
 //x=9.46 //y=1.055 //x2=9.03 //y2=0.555
cc_212 ( N_GND_c_8_p N_noxref_17_c_2829_n ) capacitor c=0.00353223f //x=24.115 \
 //y=0.18 //x2=11.59 //y2=1.175
cc_213 ( N_GND_c_42_p N_noxref_17_c_2829_n ) capacitor c=0.00935019f \
 //x=13.215 //y=0.175 //x2=11.59 //y2=1.175
cc_214 ( N_GND_c_8_p N_noxref_17_c_2831_n ) capacitor c=0.00254564f //x=24.115 \
 //y=0.18 //x2=11.675 //y2=0.805
cc_215 ( N_GND_c_42_p N_noxref_17_c_2831_n ) capacitor c=0.0141145f //x=13.215 \
 //y=0.175 //x2=11.675 //y2=0.805
cc_216 ( N_GND_M5_noxref_d N_noxref_17_c_2831_n ) capacitor c=6.21394e-19 \
 //x=9.46 //y=1.055 //x2=11.675 //y2=0.805
cc_217 ( N_GND_c_8_p N_noxref_17_c_2834_n ) capacitor c=0.0105355f //x=24.115 \
 //y=0.18 //x2=12.56 //y2=0.72
cc_218 ( N_GND_c_42_p N_noxref_17_c_2834_n ) capacitor c=0.0364623f //x=13.215 \
 //y=0.175 //x2=12.56 //y2=0.72
cc_219 ( N_GND_c_1_p N_noxref_17_c_2834_n ) capacitor c=0.00189501f //x=24.115 \
 //y=0.18 //x2=12.56 //y2=0.72
cc_220 ( N_GND_c_8_p N_noxref_17_c_2837_n ) capacitor c=0.00254308f //x=24.115 \
 //y=0.18 //x2=12.645 //y2=0.805
cc_221 ( N_GND_c_42_p N_noxref_17_c_2837_n ) capacitor c=0.0140503f //x=13.215 \
 //y=0.175 //x2=12.645 //y2=0.805
cc_222 ( N_GND_c_5_p N_noxref_17_c_2837_n ) capacitor c=0.0404137f //x=13.385 \
 //y=0.175 //x2=12.645 //y2=0.805
cc_223 ( N_GND_M5_noxref_d N_noxref_17_M6_noxref_d ) capacitor c=0.00162435f \
 //x=9.46 //y=1.055 //x2=10.435 //y2=1.09
cc_224 ( N_GND_c_4_p N_noxref_17_M7_noxref_s ) capacitor c=8.16352e-19 \
 //x=8.575 //y=0.175 //x2=11.54 //y2=0.555
cc_225 ( N_GND_c_5_p N_noxref_17_M7_noxref_s ) capacitor c=0.00183576f \
 //x=13.385 //y=0.175 //x2=11.54 //y2=0.555
cc_226 ( N_GND_c_8_p N_noxref_18_c_2882_n ) capacitor c=0.00517479f //x=24.115 \
 //y=0.18 //x2=14.965 //y2=1.76
cc_227 ( N_GND_c_53_p N_noxref_18_c_2882_n ) capacitor c=0.00112996f //x=14.48 \
 //y=0.175 //x2=14.965 //y2=1.76
cc_228 ( N_GND_c_60_p N_noxref_18_c_2882_n ) capacitor c=0.00182524f \
 //x=16.545 //y=0.175 //x2=14.965 //y2=1.76
cc_229 ( N_GND_M8_noxref_d N_noxref_18_c_2882_n ) capacitor c=0.00862619f \
 //x=14.375 //y=1.045 //x2=14.965 //y2=1.76
cc_230 ( N_GND_c_8_p N_noxref_18_c_2886_n ) capacitor c=0.00259097f //x=24.115 \
 //y=0.18 //x2=15.05 //y2=0.795
cc_231 ( N_GND_c_60_p N_noxref_18_c_2886_n ) capacitor c=0.0147125f //x=16.545 \
 //y=0.175 //x2=15.05 //y2=0.795
cc_232 ( N_GND_M8_noxref_d N_noxref_18_c_2886_n ) capacitor c=0.033812f \
 //x=14.375 //y=1.045 //x2=15.05 //y2=0.795
cc_233 ( N_GND_c_5_p N_noxref_18_c_2889_n ) capacitor c=2.91423e-19 //x=13.385 \
 //y=0.175 //x2=15.05 //y2=1.675
cc_234 ( N_GND_c_8_p N_noxref_18_c_2890_n ) capacitor c=0.0106959f //x=24.115 \
 //y=0.18 //x2=15.935 //y2=0.71
cc_235 ( N_GND_c_60_p N_noxref_18_c_2890_n ) capacitor c=0.0374502f //x=16.545 \
 //y=0.175 //x2=15.935 //y2=0.71
cc_236 ( N_GND_c_1_p N_noxref_18_c_2890_n ) capacitor c=0.00198522f //x=24.115 \
 //y=0.18 //x2=15.935 //y2=0.71
cc_237 ( N_GND_c_8_p N_noxref_18_c_2893_n ) capacitor c=0.00258902f //x=24.115 \
 //y=0.18 //x2=16.02 //y2=0.795
cc_238 ( N_GND_c_60_p N_noxref_18_c_2893_n ) capacitor c=0.0146462f //x=16.545 \
 //y=0.175 //x2=16.02 //y2=0.795
cc_239 ( N_GND_c_6_p N_noxref_18_c_2893_n ) capacitor c=0.0431718f //x=16.715 \
 //y=0.175 //x2=16.02 //y2=0.795
cc_240 ( N_GND_c_8_p N_noxref_18_M8_noxref_s ) capacitor c=0.00259097f \
 //x=24.115 //y=0.18 //x2=13.945 //y2=0.545
cc_241 ( N_GND_c_53_p N_noxref_18_M8_noxref_s ) capacitor c=0.0147125f \
 //x=14.48 //y=0.175 //x2=13.945 //y2=0.545
cc_242 ( N_GND_c_5_p N_noxref_18_M8_noxref_s ) capacitor c=0.0583534f \
 //x=13.385 //y=0.175 //x2=13.945 //y2=0.545
cc_243 ( N_GND_c_6_p N_noxref_18_M8_noxref_s ) capacitor c=0.00198043f \
 //x=16.715 //y=0.175 //x2=13.945 //y2=0.545
cc_244 ( N_GND_M8_noxref_d N_noxref_18_M8_noxref_s ) capacitor c=0.0334197f \
 //x=14.375 //y=1.045 //x2=13.945 //y2=0.545
cc_245 ( N_GND_c_8_p N_noxref_19_c_2935_n ) capacitor c=0.00517479f //x=24.115 \
 //y=0.18 //x2=18.295 //y2=1.76
cc_246 ( N_GND_c_75_p N_noxref_19_c_2935_n ) capacitor c=0.00112996f //x=17.81 \
 //y=0.175 //x2=18.295 //y2=1.76
cc_247 ( N_GND_c_82_p N_noxref_19_c_2935_n ) capacitor c=0.00182524f \
 //x=19.875 //y=0.175 //x2=18.295 //y2=1.76
cc_248 ( N_GND_M10_noxref_d N_noxref_19_c_2935_n ) capacitor c=0.00862619f \
 //x=17.705 //y=1.045 //x2=18.295 //y2=1.76
cc_249 ( N_GND_c_8_p N_noxref_19_c_2939_n ) capacitor c=0.00259097f //x=24.115 \
 //y=0.18 //x2=18.38 //y2=0.795
cc_250 ( N_GND_c_82_p N_noxref_19_c_2939_n ) capacitor c=0.0144008f //x=19.875 \
 //y=0.175 //x2=18.38 //y2=0.795
cc_251 ( N_GND_M10_noxref_d N_noxref_19_c_2939_n ) capacitor c=0.033812f \
 //x=17.705 //y=1.045 //x2=18.38 //y2=0.795
cc_252 ( N_GND_c_6_p N_noxref_19_c_2942_n ) capacitor c=2.91423e-19 //x=16.715 \
 //y=0.175 //x2=18.38 //y2=1.675
cc_253 ( N_GND_c_8_p N_noxref_19_c_2943_n ) capacitor c=0.0106959f //x=24.115 \
 //y=0.18 //x2=19.265 //y2=0.71
cc_254 ( N_GND_c_82_p N_noxref_19_c_2943_n ) capacitor c=0.0374662f //x=19.875 \
 //y=0.175 //x2=19.265 //y2=0.71
cc_255 ( N_GND_c_1_p N_noxref_19_c_2943_n ) capacitor c=0.00198522f //x=24.115 \
 //y=0.18 //x2=19.265 //y2=0.71
cc_256 ( N_GND_c_8_p N_noxref_19_c_2946_n ) capacitor c=0.00258902f //x=24.115 \
 //y=0.18 //x2=19.35 //y2=0.795
cc_257 ( N_GND_c_82_p N_noxref_19_c_2946_n ) capacitor c=0.0146462f //x=19.875 \
 //y=0.175 //x2=19.35 //y2=0.795
cc_258 ( N_GND_c_7_p N_noxref_19_c_2946_n ) capacitor c=0.0431718f //x=20.045 \
 //y=0.175 //x2=19.35 //y2=0.795
cc_259 ( N_GND_c_8_p N_noxref_19_M10_noxref_s ) capacitor c=0.00259097f \
 //x=24.115 //y=0.18 //x2=17.275 //y2=0.545
cc_260 ( N_GND_c_75_p N_noxref_19_M10_noxref_s ) capacitor c=0.0147125f \
 //x=17.81 //y=0.175 //x2=17.275 //y2=0.545
cc_261 ( N_GND_c_6_p N_noxref_19_M10_noxref_s ) capacitor c=0.058339f \
 //x=16.715 //y=0.175 //x2=17.275 //y2=0.545
cc_262 ( N_GND_c_7_p N_noxref_19_M10_noxref_s ) capacitor c=0.00198098f \
 //x=20.045 //y=0.175 //x2=17.275 //y2=0.545
cc_263 ( N_GND_M10_noxref_d N_noxref_19_M10_noxref_s ) capacitor c=0.0334197f \
 //x=17.705 //y=1.045 //x2=17.275 //y2=0.545
cc_264 ( N_GND_c_8_p N_noxref_20_c_2988_n ) capacitor c=0.00517803f //x=24.115 \
 //y=0.18 //x2=21.52 //y2=1.77
cc_265 ( N_GND_c_94_p N_noxref_20_c_2988_n ) capacitor c=0.00111572f \
 //x=21.035 //y=0.175 //x2=21.52 //y2=1.77
cc_266 ( N_GND_c_1_p N_noxref_20_c_2988_n ) capacitor c=0.00180843f //x=24.115 \
 //y=0.18 //x2=21.52 //y2=1.77
cc_267 ( N_GND_M12_noxref_d N_noxref_20_c_2988_n ) capacitor c=0.00853195f \
 //x=20.93 //y=1.055 //x2=21.52 //y2=1.77
cc_268 ( N_GND_c_8_p N_noxref_20_c_2992_n ) capacitor c=0.00254564f //x=24.115 \
 //y=0.18 //x2=21.605 //y2=0.805
cc_269 ( N_GND_c_1_p N_noxref_20_c_2992_n ) capacitor c=0.0141145f //x=24.115 \
 //y=0.18 //x2=21.605 //y2=0.805
cc_270 ( N_GND_M12_noxref_d N_noxref_20_c_2992_n ) capacitor c=0.033954f \
 //x=20.93 //y=1.055 //x2=21.605 //y2=0.805
cc_271 ( N_GND_c_8_p N_noxref_20_c_2995_n ) capacitor c=0.0105808f //x=24.115 \
 //y=0.18 //x2=22.49 //y2=0.72
cc_272 ( N_GND_c_1_p N_noxref_20_c_2995_n ) capacitor c=0.0379448f //x=24.115 \
 //y=0.18 //x2=22.49 //y2=0.72
cc_273 ( N_GND_c_8_p N_noxref_20_M12_noxref_s ) capacitor c=0.00542017f \
 //x=24.115 //y=0.18 //x2=20.5 //y2=0.555
cc_274 ( N_GND_c_94_p N_noxref_20_M12_noxref_s ) capacitor c=0.0141145f \
 //x=21.035 //y=0.175 //x2=20.5 //y2=0.555
cc_275 ( N_GND_c_1_p N_noxref_20_M12_noxref_s ) capacitor c=0.0137283f \
 //x=24.115 //y=0.18 //x2=20.5 //y2=0.555
cc_276 ( N_GND_c_7_p N_noxref_20_M12_noxref_s ) capacitor c=0.0696963f \
 //x=20.045 //y=0.175 //x2=20.5 //y2=0.555
cc_277 ( N_GND_M12_noxref_d N_noxref_20_M12_noxref_s ) capacitor c=0.033718f \
 //x=20.93 //y=1.055 //x2=20.5 //y2=0.555
cc_278 ( N_GND_c_8_p N_noxref_21_c_3039_n ) capacitor c=0.00385483f //x=24.115 \
 //y=0.18 //x2=23.06 //y2=1.175
cc_279 ( N_GND_c_1_p N_noxref_21_c_3039_n ) capacitor c=0.00967515f //x=24.115 \
 //y=0.18 //x2=23.06 //y2=1.175
cc_280 ( N_GND_c_8_p N_noxref_21_c_3041_n ) capacitor c=0.00287676f //x=24.115 \
 //y=0.18 //x2=23.145 //y2=0.805
cc_281 ( N_GND_c_1_p N_noxref_21_c_3041_n ) capacitor c=0.0143483f //x=24.115 \
 //y=0.18 //x2=23.145 //y2=0.805
cc_282 ( N_GND_M12_noxref_d N_noxref_21_c_3041_n ) capacitor c=6.21394e-19 \
 //x=20.93 //y=1.055 //x2=23.145 //y2=0.805
cc_283 ( N_GND_c_8_p N_noxref_21_c_3044_n ) capacitor c=0.0118473f //x=24.115 \
 //y=0.18 //x2=24.03 //y2=0.72
cc_284 ( N_GND_c_1_p N_noxref_21_c_3044_n ) capacitor c=0.0384839f //x=24.115 \
 //y=0.18 //x2=24.03 //y2=0.72
cc_285 ( N_GND_c_8_p N_noxref_21_c_3046_n ) capacitor c=0.00286787f //x=24.115 \
 //y=0.18 //x2=24.115 //y2=0.805
cc_286 ( N_GND_c_1_p N_noxref_21_c_3046_n ) capacitor c=0.0553774f //x=24.115 \
 //y=0.18 //x2=24.115 //y2=0.805
cc_287 ( N_GND_M12_noxref_d N_noxref_21_M13_noxref_d ) capacitor c=0.00162435f \
 //x=20.93 //y=1.055 //x2=21.905 //y2=1.09
cc_288 ( N_GND_c_1_p N_noxref_21_M14_noxref_s ) capacitor c=0.00183576f \
 //x=24.115 //y=0.18 //x2=23.01 //y2=0.555
cc_289 ( N_GND_c_7_p N_noxref_21_M14_noxref_s ) capacitor c=8.16352e-19 \
 //x=20.045 //y=0.175 //x2=23.01 //y2=0.555
cc_290 ( N_VDD_c_292_n N_noxref_3_c_602_n ) capacitor c=0.00137375f //x=3.765 \
 //y=7.585 //x2=4.73 //y2=2.77
cc_291 ( N_VDD_c_298_p N_noxref_3_c_643_n ) capacitor c=0.00546754f //x=24.115 \
 //y=7.58 //x2=2.46 //y2=5.38
cc_292 ( N_VDD_c_299_p N_noxref_3_c_643_n ) capacitor c=4.34465e-19 //x=2.02 \
 //y=7.585 //x2=2.46 //y2=5.38
cc_293 ( N_VDD_c_300_p N_noxref_3_c_643_n ) capacitor c=4.49193e-19 //x=2.9 \
 //y=7.585 //x2=2.46 //y2=5.38
cc_294 ( N_VDD_M16_noxref_d N_noxref_3_c_643_n ) capacitor c=0.0129686f \
 //x=1.96 //y=5.2 //x2=2.46 //y2=5.38
cc_295 ( N_VDD_c_291_n N_noxref_3_c_647_n ) capacitor c=0.00989999f //x=1.175 \
 //y=7.58 //x2=1.75 //y2=5.38
cc_296 ( N_VDD_M15_noxref_s N_noxref_3_c_647_n ) capacitor c=0.087833f \
 //x=1.09 //y=5.2 //x2=1.75 //y2=5.38
cc_297 ( N_VDD_c_298_p N_noxref_3_c_649_n ) capacitor c=0.0030743f //x=24.115 \
 //y=7.58 //x2=2.94 //y2=5.38
cc_298 ( N_VDD_c_300_p N_noxref_3_c_649_n ) capacitor c=7.74005e-19 //x=2.9 \
 //y=7.585 //x2=2.94 //y2=5.38
cc_299 ( N_VDD_M18_noxref_d N_noxref_3_c_649_n ) capacitor c=0.016158f \
 //x=2.84 //y=5.2 //x2=2.94 //y2=5.38
cc_300 ( N_VDD_c_291_n N_noxref_3_c_615_n ) capacitor c=0.00159771f //x=1.175 \
 //y=7.58 //x2=3.025 //y2=2.77
cc_301 ( N_VDD_c_292_n N_noxref_3_c_615_n ) capacitor c=0.0452382f //x=3.765 \
 //y=7.585 //x2=3.025 //y2=2.77
cc_302 ( N_VDD_c_298_p N_noxref_3_c_617_n ) capacitor c=9.22979e-19 //x=24.115 \
 //y=7.58 //x2=4.875 //y2=2.26
cc_303 ( N_VDD_c_292_n N_noxref_3_c_617_n ) capacitor c=0.0157357f //x=3.765 \
 //y=7.585 //x2=4.875 //y2=2.26
cc_304 ( N_VDD_M19_noxref_s N_noxref_3_c_617_n ) capacitor c=0.012997f \
 //x=4.72 //y=5.2 //x2=4.875 //y2=2.26
cc_305 ( N_VDD_c_298_p N_noxref_3_c_618_n ) capacitor c=9.09811e-19 //x=24.115 \
 //y=7.58 //x2=9.685 //y2=2.26
cc_306 ( N_VDD_c_293_n N_noxref_3_c_618_n ) capacitor c=0.013427f //x=8.575 \
 //y=7.585 //x2=9.685 //y2=2.26
cc_307 ( N_VDD_M25_noxref_s N_noxref_3_c_618_n ) capacitor c=0.0120369f \
 //x=9.53 //y=5.2 //x2=9.685 //y2=2.26
cc_308 ( N_VDD_c_315_p N_noxref_3_M19_noxref_g ) capacitor c=0.00755614f \
 //x=5.65 //y=7.585 //x2=5.075 //y2=6.2
cc_309 ( N_VDD_M19_noxref_s N_noxref_3_M19_noxref_g ) capacitor c=0.0477201f \
 //x=4.72 //y=5.2 //x2=5.075 //y2=6.2
cc_310 ( N_VDD_c_315_p N_noxref_3_M20_noxref_g ) capacitor c=0.00679791f \
 //x=5.65 //y=7.585 //x2=5.515 //y2=6.2
cc_311 ( N_VDD_M20_noxref_d N_noxref_3_M20_noxref_g ) capacitor c=0.015318f \
 //x=5.59 //y=5.2 //x2=5.515 //y2=6.2
cc_312 ( N_VDD_c_319_p N_noxref_3_M25_noxref_g ) capacitor c=0.00755614f \
 //x=10.46 //y=7.585 //x2=9.885 //y2=6.2
cc_313 ( N_VDD_M25_noxref_s N_noxref_3_M25_noxref_g ) capacitor c=0.0477201f \
 //x=9.53 //y=5.2 //x2=9.885 //y2=6.2
cc_314 ( N_VDD_c_319_p N_noxref_3_M26_noxref_g ) capacitor c=0.00679791f \
 //x=10.46 //y=7.585 //x2=10.325 //y2=6.2
cc_315 ( N_VDD_M26_noxref_d N_noxref_3_M26_noxref_g ) capacitor c=0.015318f \
 //x=10.4 //y=5.2 //x2=10.325 //y2=6.2
cc_316 ( N_VDD_c_292_n N_noxref_3_c_668_n ) capacitor c=0.00757682f //x=3.765 \
 //y=7.585 //x2=5.15 //y2=4.97
cc_317 ( N_VDD_M19_noxref_s N_noxref_3_c_668_n ) capacitor c=0.0044516f \
 //x=4.72 //y=5.2 //x2=5.15 //y2=4.97
cc_318 ( N_VDD_c_293_n N_noxref_3_c_670_n ) capacitor c=0.00757682f //x=8.575 \
 //y=7.585 //x2=9.96 //y2=4.97
cc_319 ( N_VDD_M25_noxref_s N_noxref_3_c_670_n ) capacitor c=0.00444941f \
 //x=9.53 //y=5.2 //x2=9.96 //y2=4.97
cc_320 ( N_VDD_c_298_p N_noxref_3_M15_noxref_d ) capacitor c=0.00707767f \
 //x=24.115 //y=7.58 //x2=1.52 //y2=5.2
cc_321 ( N_VDD_c_299_p N_noxref_3_M15_noxref_d ) capacitor c=0.0138202f \
 //x=2.02 //y=7.585 //x2=1.52 //y2=5.2
cc_322 ( N_VDD_c_292_n N_noxref_3_M15_noxref_d ) capacitor c=6.94454e-19 \
 //x=3.765 //y=7.585 //x2=1.52 //y2=5.2
cc_323 ( N_VDD_M16_noxref_d N_noxref_3_M15_noxref_d ) capacitor c=0.0664752f \
 //x=1.96 //y=5.2 //x2=1.52 //y2=5.2
cc_324 ( N_VDD_c_298_p N_noxref_3_M17_noxref_d ) capacitor c=0.00285139f \
 //x=24.115 //y=7.58 //x2=2.4 //y2=5.2
cc_325 ( N_VDD_c_300_p N_noxref_3_M17_noxref_d ) capacitor c=0.0141209f \
 //x=2.9 //y=7.585 //x2=2.4 //y2=5.2
cc_326 ( N_VDD_c_292_n N_noxref_3_M17_noxref_d ) capacitor c=0.0120541f \
 //x=3.765 //y=7.585 //x2=2.4 //y2=5.2
cc_327 ( N_VDD_M15_noxref_s N_noxref_3_M17_noxref_d ) capacitor c=0.00111971f \
 //x=1.09 //y=5.2 //x2=2.4 //y2=5.2
cc_328 ( N_VDD_M16_noxref_d N_noxref_3_M17_noxref_d ) capacitor c=0.0664752f \
 //x=1.96 //y=5.2 //x2=2.4 //y2=5.2
cc_329 ( N_VDD_M18_noxref_d N_noxref_3_M17_noxref_d ) capacitor c=0.0664752f \
 //x=2.84 //y=5.2 //x2=2.4 //y2=5.2
cc_330 ( N_VDD_M19_noxref_s N_noxref_3_M17_noxref_d ) capacitor c=3.73257e-19 \
 //x=4.72 //y=5.2 //x2=2.4 //y2=5.2
cc_331 ( N_VDD_c_298_p N_noxref_4_c_873_n ) capacitor c=0.00444939f //x=24.115 \
 //y=7.58 //x2=10.9 //y2=5.335
cc_332 ( N_VDD_c_319_p N_noxref_4_c_873_n ) capacitor c=4.32416e-19 //x=10.46 \
 //y=7.585 //x2=10.9 //y2=5.335
cc_333 ( N_VDD_c_340_p N_noxref_4_c_873_n ) capacitor c=4.32416e-19 //x=11.34 \
 //y=7.585 //x2=10.9 //y2=5.335
cc_334 ( N_VDD_M26_noxref_d N_noxref_4_c_873_n ) capacitor c=0.0112992f \
 //x=10.4 //y=5.2 //x2=10.9 //y2=5.335
cc_335 ( N_VDD_c_293_n N_noxref_4_c_877_n ) capacitor c=0.00863585f //x=8.575 \
 //y=7.585 //x2=10.19 //y2=5.335
cc_336 ( N_VDD_M25_noxref_s N_noxref_4_c_877_n ) capacitor c=0.0831083f \
 //x=9.53 //y=5.2 //x2=10.19 //y2=5.335
cc_337 ( N_VDD_c_298_p N_noxref_4_c_879_n ) capacitor c=0.00442256f //x=24.115 \
 //y=7.58 //x2=11.78 //y2=5.335
cc_338 ( N_VDD_c_340_p N_noxref_4_c_879_n ) capacitor c=4.32416e-19 //x=11.34 \
 //y=7.585 //x2=11.78 //y2=5.335
cc_339 ( N_VDD_c_346_p N_noxref_4_c_879_n ) capacitor c=4.32416e-19 //x=12.22 \
 //y=7.585 //x2=11.78 //y2=5.335
cc_340 ( N_VDD_M28_noxref_d N_noxref_4_c_879_n ) capacitor c=0.0112992f \
 //x=11.28 //y=5.2 //x2=11.78 //y2=5.335
cc_341 ( N_VDD_c_298_p N_noxref_4_c_883_n ) capacitor c=0.00434594f //x=24.115 \
 //y=7.58 //x2=12.56 //y2=5.335
cc_342 ( N_VDD_c_346_p N_noxref_4_c_883_n ) capacitor c=7.47443e-19 //x=12.22 \
 //y=7.585 //x2=12.56 //y2=5.335
cc_343 ( N_VDD_c_350_p N_noxref_4_c_883_n ) capacitor c=0.00199034f //x=13.215 \
 //y=7.585 //x2=12.56 //y2=5.335
cc_344 ( N_VDD_M30_noxref_d N_noxref_4_c_883_n ) capacitor c=0.0112992f \
 //x=12.16 //y=5.2 //x2=12.56 //y2=5.335
cc_345 ( N_VDD_c_294_n N_noxref_4_c_860_n ) capacitor c=0.042636f //x=13.385 \
 //y=7.585 //x2=12.645 //y2=2.77
cc_346 ( N_VDD_c_298_p N_noxref_4_c_861_n ) capacitor c=0.00125241f //x=24.115 \
 //y=7.58 //x2=14.495 //y2=2.26
cc_347 ( N_VDD_c_354_p N_noxref_4_c_861_n ) capacitor c=2.88017e-19 //x=14.97 \
 //y=7.585 //x2=14.495 //y2=2.26
cc_348 ( N_VDD_c_294_n N_noxref_4_c_861_n ) capacitor c=0.0133961f //x=13.385 \
 //y=7.585 //x2=14.495 //y2=2.26
cc_349 ( N_VDD_c_354_p N_noxref_4_M31_noxref_g ) capacitor c=0.00732332f \
 //x=14.97 //y=7.585 //x2=14.395 //y2=6.2
cc_350 ( N_VDD_M31_noxref_s N_noxref_4_M31_noxref_g ) capacitor c=0.054195f \
 //x=14.04 //y=5.2 //x2=14.395 //y2=6.2
cc_351 ( N_VDD_c_354_p N_noxref_4_M32_noxref_g ) capacitor c=0.00677553f \
 //x=14.97 //y=7.585 //x2=14.835 //y2=6.2
cc_352 ( N_VDD_M32_noxref_d N_noxref_4_M32_noxref_g ) capacitor c=0.015318f \
 //x=14.91 //y=5.2 //x2=14.835 //y2=6.2
cc_353 ( N_VDD_c_294_n N_noxref_4_c_895_n ) capacitor c=0.015293f //x=13.385 \
 //y=7.585 //x2=14.495 //y2=4.88
cc_354 ( N_VDD_c_298_p N_noxref_4_M25_noxref_d ) capacitor c=0.00275309f \
 //x=24.115 //y=7.58 //x2=9.96 //y2=5.2
cc_355 ( N_VDD_c_319_p N_noxref_4_M25_noxref_d ) capacitor c=0.0140577f \
 //x=10.46 //y=7.585 //x2=9.96 //y2=5.2
cc_356 ( N_VDD_M26_noxref_d N_noxref_4_M25_noxref_d ) capacitor c=0.0664752f \
 //x=10.4 //y=5.2 //x2=9.96 //y2=5.2
cc_357 ( N_VDD_c_298_p N_noxref_4_M27_noxref_d ) capacitor c=0.00275309f \
 //x=24.115 //y=7.58 //x2=10.84 //y2=5.2
cc_358 ( N_VDD_c_340_p N_noxref_4_M27_noxref_d ) capacitor c=0.0140577f \
 //x=11.34 //y=7.585 //x2=10.84 //y2=5.2
cc_359 ( N_VDD_c_294_n N_noxref_4_M27_noxref_d ) capacitor c=4.9285e-19 \
 //x=13.385 //y=7.585 //x2=10.84 //y2=5.2
cc_360 ( N_VDD_M25_noxref_s N_noxref_4_M27_noxref_d ) capacitor c=0.00130656f \
 //x=9.53 //y=5.2 //x2=10.84 //y2=5.2
cc_361 ( N_VDD_M26_noxref_d N_noxref_4_M27_noxref_d ) capacitor c=0.0664752f \
 //x=10.4 //y=5.2 //x2=10.84 //y2=5.2
cc_362 ( N_VDD_M28_noxref_d N_noxref_4_M27_noxref_d ) capacitor c=0.0664752f \
 //x=11.28 //y=5.2 //x2=10.84 //y2=5.2
cc_363 ( N_VDD_c_298_p N_noxref_4_M29_noxref_d ) capacitor c=0.00275309f \
 //x=24.115 //y=7.58 //x2=11.72 //y2=5.2
cc_364 ( N_VDD_c_346_p N_noxref_4_M29_noxref_d ) capacitor c=0.0140577f \
 //x=12.22 //y=7.585 //x2=11.72 //y2=5.2
cc_365 ( N_VDD_c_294_n N_noxref_4_M29_noxref_d ) capacitor c=0.00939849f \
 //x=13.385 //y=7.585 //x2=11.72 //y2=5.2
cc_366 ( N_VDD_M28_noxref_d N_noxref_4_M29_noxref_d ) capacitor c=0.0664752f \
 //x=11.28 //y=5.2 //x2=11.72 //y2=5.2
cc_367 ( N_VDD_M30_noxref_d N_noxref_4_M29_noxref_d ) capacitor c=0.0664752f \
 //x=12.16 //y=5.2 //x2=11.72 //y2=5.2
cc_368 ( N_VDD_M31_noxref_s N_noxref_4_M29_noxref_d ) capacitor c=4.52683e-19 \
 //x=14.04 //y=5.2 //x2=11.72 //y2=5.2
cc_369 ( N_VDD_c_298_p N_CLK_c_1027_n ) capacitor c=0.0692073f //x=24.115 \
 //y=7.58 //x2=15.12 //y2=4.62
cc_370 ( N_VDD_c_377_p N_CLK_c_1027_n ) capacitor c=0.00258661f //x=8.405 \
 //y=7.585 //x2=15.12 //y2=4.62
cc_371 ( N_VDD_c_378_p N_CLK_c_1027_n ) capacitor c=0.00329211f //x=9.58 \
 //y=7.585 //x2=15.12 //y2=4.62
cc_372 ( N_VDD_c_319_p N_CLK_c_1027_n ) capacitor c=0.00135946f //x=10.46 \
 //y=7.585 //x2=15.12 //y2=4.62
cc_373 ( N_VDD_c_350_p N_CLK_c_1027_n ) capacitor c=0.00258661f //x=13.215 \
 //y=7.585 //x2=15.12 //y2=4.62
cc_374 ( N_VDD_c_381_p N_CLK_c_1027_n ) capacitor c=0.0020986f //x=14.09 \
 //y=7.585 //x2=15.12 //y2=4.62
cc_375 ( N_VDD_c_354_p N_CLK_c_1027_n ) capacitor c=7.81825e-19 //x=14.97 \
 //y=7.585 //x2=15.12 //y2=4.62
cc_376 ( N_VDD_c_293_n N_CLK_c_1027_n ) capacitor c=0.0389825f //x=8.575 \
 //y=7.585 //x2=15.12 //y2=4.62
cc_377 ( N_VDD_c_294_n N_CLK_c_1027_n ) capacitor c=0.0389825f //x=13.385 \
 //y=7.585 //x2=15.12 //y2=4.62
cc_378 ( N_VDD_M25_noxref_s N_CLK_c_1027_n ) capacitor c=0.00179503f //x=9.53 \
 //y=5.2 //x2=15.12 //y2=4.62
cc_379 ( N_VDD_M31_noxref_s N_CLK_c_1027_n ) capacitor c=0.00541087f //x=14.04 \
 //y=5.2 //x2=15.12 //y2=4.62
cc_380 ( N_VDD_c_298_p N_CLK_c_1038_n ) capacitor c=0.00146219f //x=24.115 \
 //y=7.58 //x2=6.1 //y2=4.62
cc_381 ( N_VDD_c_298_p N_CLK_c_1039_n ) capacitor c=2.03193e-19 //x=24.115 \
 //y=7.58 //x2=5.985 //y2=4.88
cc_382 ( N_VDD_c_294_n N_CLK_c_1040_n ) capacitor c=4.60777e-19 //x=13.385 \
 //y=7.585 //x2=15.235 //y2=4.535
cc_383 ( N_VDD_c_295_n N_CLK_c_1040_n ) capacitor c=3.44263e-19 //x=16.715 \
 //y=7.585 //x2=15.235 //y2=4.535
cc_384 ( N_VDD_c_292_n N_CLK_c_1042_n ) capacitor c=8.47879e-19 //x=3.765 \
 //y=7.585 //x2=6.012 //y2=4.535
cc_385 ( N_VDD_c_392_p N_CLK_M21_noxref_g ) capacitor c=0.00680845f //x=6.53 \
 //y=7.585 //x2=5.955 //y2=6.2
cc_386 ( N_VDD_M20_noxref_d N_CLK_M21_noxref_g ) capacitor c=0.015318f \
 //x=5.59 //y=5.2 //x2=5.955 //y2=6.2
cc_387 ( N_VDD_c_392_p N_CLK_M22_noxref_g ) capacitor c=0.00679791f //x=6.53 \
 //y=7.585 //x2=6.395 //y2=6.2
cc_388 ( N_VDD_M22_noxref_d N_CLK_M22_noxref_g ) capacitor c=0.015318f \
 //x=6.47 //y=5.2 //x2=6.395 //y2=6.2
cc_389 ( N_VDD_c_396_p N_CLK_M33_noxref_g ) capacitor c=0.00678607f //x=15.85 \
 //y=7.585 //x2=15.275 //y2=6.2
cc_390 ( N_VDD_M32_noxref_d N_CLK_M33_noxref_g ) capacitor c=0.015318f \
 //x=14.91 //y=5.2 //x2=15.275 //y2=6.2
cc_391 ( N_VDD_c_396_p N_CLK_M34_noxref_g ) capacitor c=0.00677553f //x=15.85 \
 //y=7.585 //x2=15.715 //y2=6.2
cc_392 ( N_VDD_c_295_n N_CLK_M34_noxref_g ) capacitor c=0.00864163f //x=16.715 \
 //y=7.585 //x2=15.715 //y2=6.2
cc_393 ( N_VDD_M34_noxref_d N_CLK_M34_noxref_g ) capacitor c=0.0430452f \
 //x=15.79 //y=5.2 //x2=15.715 //y2=6.2
cc_394 ( N_VDD_c_298_p N_noxref_6_c_1250_n ) capacitor c=0.0316775f //x=24.115 \
 //y=7.58 //x2=7.715 //y2=4.25
cc_395 ( N_VDD_c_402_p N_noxref_6_c_1250_n ) capacitor c=0.00168633f //x=3.595 \
 //y=7.585 //x2=7.715 //y2=4.25
cc_396 ( N_VDD_c_403_p N_noxref_6_c_1250_n ) capacitor c=0.00271488f //x=4.77 \
 //y=7.585 //x2=7.715 //y2=4.25
cc_397 ( N_VDD_c_315_p N_noxref_6_c_1250_n ) capacitor c=0.00113405f //x=5.65 \
 //y=7.585 //x2=7.715 //y2=4.25
cc_398 ( N_VDD_c_292_n N_noxref_6_c_1250_n ) capacitor c=0.0276226f //x=3.765 \
 //y=7.585 //x2=7.715 //y2=4.25
cc_399 ( N_VDD_M18_noxref_d N_noxref_6_c_1250_n ) capacitor c=5.05316e-19 \
 //x=2.84 //y=5.2 //x2=7.715 //y2=4.25
cc_400 ( N_VDD_M19_noxref_s N_noxref_6_c_1250_n ) capacitor c=0.00122829f \
 //x=4.72 //y=5.2 //x2=7.715 //y2=4.25
cc_401 ( N_VDD_c_298_p N_noxref_6_c_1252_n ) capacitor c=0.0018159f //x=24.115 \
 //y=7.58 //x2=2.4 //y2=4.25
cc_402 ( N_VDD_c_298_p N_noxref_6_c_1276_n ) capacitor c=0.0465621f //x=24.115 \
 //y=7.58 //x2=17.71 //y2=4.25
cc_403 ( N_VDD_c_410_p N_noxref_6_c_1276_n ) capacitor c=0.00168633f \
 //x=16.545 //y=7.585 //x2=17.71 //y2=4.25
cc_404 ( N_VDD_c_411_p N_noxref_6_c_1276_n ) capacitor c=0.00172127f //x=17.42 \
 //y=7.585 //x2=17.71 //y2=4.25
cc_405 ( N_VDD_c_412_p N_noxref_6_c_1276_n ) capacitor c=6.61732e-19 //x=18.3 \
 //y=7.585 //x2=17.71 //y2=4.25
cc_406 ( N_VDD_c_293_n N_noxref_6_c_1276_n ) capacitor c=0.0140577f //x=8.575 \
 //y=7.585 //x2=17.71 //y2=4.25
cc_407 ( N_VDD_c_294_n N_noxref_6_c_1276_n ) capacitor c=0.0140577f //x=13.385 \
 //y=7.585 //x2=17.71 //y2=4.25
cc_408 ( N_VDD_c_295_n N_noxref_6_c_1276_n ) capacitor c=0.0277021f //x=16.715 \
 //y=7.585 //x2=17.71 //y2=4.25
cc_409 ( N_VDD_M34_noxref_d N_noxref_6_c_1276_n ) capacitor c=5.05316e-19 \
 //x=15.79 //y=5.2 //x2=17.71 //y2=4.25
cc_410 ( N_VDD_M35_noxref_s N_noxref_6_c_1276_n ) capacitor c=0.00363045f \
 //x=17.37 //y=5.2 //x2=17.71 //y2=4.25
cc_411 ( N_VDD_c_293_n N_noxref_6_c_1285_n ) capacitor c=0.00104411f //x=8.575 \
 //y=7.585 //x2=7.945 //y2=4.25
cc_412 ( N_VDD_c_291_n N_noxref_6_c_1253_n ) capacitor c=7.01341e-19 //x=1.175 \
 //y=7.58 //x2=2.285 //y2=2.26
cc_413 ( N_VDD_c_292_n N_noxref_6_c_1253_n ) capacitor c=5.66013e-19 //x=3.765 \
 //y=7.585 //x2=2.285 //y2=2.26
cc_414 ( N_VDD_c_298_p N_noxref_6_c_1288_n ) capacitor c=0.00449361f \
 //x=24.115 //y=7.58 //x2=6.09 //y2=5.335
cc_415 ( N_VDD_c_315_p N_noxref_6_c_1288_n ) capacitor c=4.32713e-19 //x=5.65 \
 //y=7.585 //x2=6.09 //y2=5.335
cc_416 ( N_VDD_c_392_p N_noxref_6_c_1288_n ) capacitor c=4.3239e-19 //x=6.53 \
 //y=7.585 //x2=6.09 //y2=5.335
cc_417 ( N_VDD_M20_noxref_d N_noxref_6_c_1288_n ) capacitor c=0.0115154f \
 //x=5.59 //y=5.2 //x2=6.09 //y2=5.335
cc_418 ( N_VDD_c_292_n N_noxref_6_c_1292_n ) capacitor c=0.00863585f //x=3.765 \
 //y=7.585 //x2=5.38 //y2=5.335
cc_419 ( N_VDD_M19_noxref_s N_noxref_6_c_1292_n ) capacitor c=0.0831083f \
 //x=4.72 //y=5.2 //x2=5.38 //y2=5.335
cc_420 ( N_VDD_c_298_p N_noxref_6_c_1294_n ) capacitor c=0.00442256f \
 //x=24.115 //y=7.58 //x2=6.97 //y2=5.335
cc_421 ( N_VDD_c_392_p N_noxref_6_c_1294_n ) capacitor c=4.32416e-19 //x=6.53 \
 //y=7.585 //x2=6.97 //y2=5.335
cc_422 ( N_VDD_c_429_p N_noxref_6_c_1294_n ) capacitor c=4.32416e-19 //x=7.41 \
 //y=7.585 //x2=6.97 //y2=5.335
cc_423 ( N_VDD_M22_noxref_d N_noxref_6_c_1294_n ) capacitor c=0.0112992f \
 //x=6.47 //y=5.2 //x2=6.97 //y2=5.335
cc_424 ( N_VDD_c_298_p N_noxref_6_c_1298_n ) capacitor c=0.00433619f \
 //x=24.115 //y=7.58 //x2=7.75 //y2=5.335
cc_425 ( N_VDD_c_429_p N_noxref_6_c_1298_n ) capacitor c=7.47443e-19 //x=7.41 \
 //y=7.585 //x2=7.75 //y2=5.335
cc_426 ( N_VDD_c_377_p N_noxref_6_c_1298_n ) capacitor c=0.00199034f //x=8.405 \
 //y=7.585 //x2=7.75 //y2=5.335
cc_427 ( N_VDD_M24_noxref_d N_noxref_6_c_1298_n ) capacitor c=0.0112992f \
 //x=7.35 //y=5.2 //x2=7.75 //y2=5.335
cc_428 ( N_VDD_c_298_p N_noxref_6_c_1256_n ) capacitor c=0.00126103f \
 //x=24.115 //y=7.58 //x2=17.825 //y2=2.26
cc_429 ( N_VDD_c_412_p N_noxref_6_c_1256_n ) capacitor c=2.8853e-19 //x=18.3 \
 //y=7.585 //x2=17.825 //y2=2.26
cc_430 ( N_VDD_c_295_n N_noxref_6_c_1256_n ) capacitor c=0.0156647f //x=16.715 \
 //y=7.585 //x2=17.825 //y2=2.26
cc_431 ( N_VDD_c_293_n N_noxref_6_c_1305_n ) capacitor c=0.0427201f //x=8.575 \
 //y=7.585 //x2=7.83 //y2=4.25
cc_432 ( N_VDD_c_300_p N_noxref_6_M17_noxref_g ) capacitor c=0.00678607f \
 //x=2.9 //y=7.585 //x2=2.325 //y2=6.2
cc_433 ( N_VDD_M16_noxref_d N_noxref_6_M17_noxref_g ) capacitor c=0.015318f \
 //x=1.96 //y=5.2 //x2=2.325 //y2=6.2
cc_434 ( N_VDD_c_300_p N_noxref_6_M18_noxref_g ) capacitor c=0.00677553f \
 //x=2.9 //y=7.585 //x2=2.765 //y2=6.2
cc_435 ( N_VDD_c_292_n N_noxref_6_M18_noxref_g ) capacitor c=0.00928743f \
 //x=3.765 //y=7.585 //x2=2.765 //y2=6.2
cc_436 ( N_VDD_M18_noxref_d N_noxref_6_M18_noxref_g ) capacitor c=0.0430452f \
 //x=2.84 //y=5.2 //x2=2.765 //y2=6.2
cc_437 ( N_VDD_c_412_p N_noxref_6_M35_noxref_g ) capacitor c=0.00732332f \
 //x=18.3 //y=7.585 //x2=17.725 //y2=6.2
cc_438 ( N_VDD_M35_noxref_s N_noxref_6_M35_noxref_g ) capacitor c=0.054195f \
 //x=17.37 //y=5.2 //x2=17.725 //y2=6.2
cc_439 ( N_VDD_c_412_p N_noxref_6_M36_noxref_g ) capacitor c=0.00677553f \
 //x=18.3 //y=7.585 //x2=18.165 //y2=6.2
cc_440 ( N_VDD_M36_noxref_d N_noxref_6_M36_noxref_g ) capacitor c=0.015318f \
 //x=18.24 //y=5.2 //x2=18.165 //y2=6.2
cc_441 ( N_VDD_c_295_n N_noxref_6_c_1315_n ) capacitor c=0.0149273f //x=16.715 \
 //y=7.585 //x2=17.825 //y2=4.88
cc_442 ( N_VDD_c_298_p N_noxref_6_M19_noxref_d ) capacitor c=0.00285148f \
 //x=24.115 //y=7.58 //x2=5.15 //y2=5.2
cc_443 ( N_VDD_c_315_p N_noxref_6_M19_noxref_d ) capacitor c=0.0141242f \
 //x=5.65 //y=7.585 //x2=5.15 //y2=5.2
cc_444 ( N_VDD_M20_noxref_d N_noxref_6_M19_noxref_d ) capacitor c=0.0664752f \
 //x=5.59 //y=5.2 //x2=5.15 //y2=5.2
cc_445 ( N_VDD_c_298_p N_noxref_6_M21_noxref_d ) capacitor c=0.0027526f \
 //x=24.115 //y=7.58 //x2=6.03 //y2=5.2
cc_446 ( N_VDD_c_392_p N_noxref_6_M21_noxref_d ) capacitor c=0.0140573f \
 //x=6.53 //y=7.585 //x2=6.03 //y2=5.2
cc_447 ( N_VDD_c_293_n N_noxref_6_M21_noxref_d ) capacitor c=4.9285e-19 \
 //x=8.575 //y=7.585 //x2=6.03 //y2=5.2
cc_448 ( N_VDD_M19_noxref_s N_noxref_6_M21_noxref_d ) capacitor c=0.00130656f \
 //x=4.72 //y=5.2 //x2=6.03 //y2=5.2
cc_449 ( N_VDD_M20_noxref_d N_noxref_6_M21_noxref_d ) capacitor c=0.0664752f \
 //x=5.59 //y=5.2 //x2=6.03 //y2=5.2
cc_450 ( N_VDD_M22_noxref_d N_noxref_6_M21_noxref_d ) capacitor c=0.0664752f \
 //x=6.47 //y=5.2 //x2=6.03 //y2=5.2
cc_451 ( N_VDD_c_298_p N_noxref_6_M23_noxref_d ) capacitor c=0.00275309f \
 //x=24.115 //y=7.58 //x2=6.91 //y2=5.2
cc_452 ( N_VDD_c_429_p N_noxref_6_M23_noxref_d ) capacitor c=0.0140577f \
 //x=7.41 //y=7.585 //x2=6.91 //y2=5.2
cc_453 ( N_VDD_c_293_n N_noxref_6_M23_noxref_d ) capacitor c=0.00939849f \
 //x=8.575 //y=7.585 //x2=6.91 //y2=5.2
cc_454 ( N_VDD_M22_noxref_d N_noxref_6_M23_noxref_d ) capacitor c=0.0664752f \
 //x=6.47 //y=5.2 //x2=6.91 //y2=5.2
cc_455 ( N_VDD_M24_noxref_d N_noxref_6_M23_noxref_d ) capacitor c=0.0664752f \
 //x=7.35 //y=5.2 //x2=6.91 //y2=5.2
cc_456 ( N_VDD_M25_noxref_s N_noxref_6_M23_noxref_d ) capacitor c=3.57641e-19 \
 //x=9.53 //y=5.2 //x2=6.91 //y2=5.2
cc_457 ( N_VDD_c_295_n N_noxref_7_c_1557_n ) capacitor c=9.96243e-19 \
 //x=16.715 //y=7.585 //x2=18.565 //y2=2.26
cc_458 ( N_VDD_c_296_n N_noxref_7_c_1557_n ) capacitor c=7.4472e-19 //x=20.045 \
 //y=7.585 //x2=18.565 //y2=2.26
cc_459 ( N_VDD_c_466_p N_noxref_7_M37_noxref_g ) capacitor c=0.00678607f \
 //x=19.18 //y=7.585 //x2=18.605 //y2=6.2
cc_460 ( N_VDD_M36_noxref_d N_noxref_7_M37_noxref_g ) capacitor c=0.015318f \
 //x=18.24 //y=5.2 //x2=18.605 //y2=6.2
cc_461 ( N_VDD_c_466_p N_noxref_7_M38_noxref_g ) capacitor c=0.00677553f \
 //x=19.18 //y=7.585 //x2=19.045 //y2=6.2
cc_462 ( N_VDD_c_296_n N_noxref_7_M38_noxref_g ) capacitor c=0.00928143f \
 //x=20.045 //y=7.585 //x2=19.045 //y2=6.2
cc_463 ( N_VDD_M38_noxref_d N_noxref_7_M38_noxref_g ) capacitor c=0.0430452f \
 //x=19.12 //y=5.2 //x2=19.045 //y2=6.2
cc_464 ( N_VDD_c_296_n QN ) capacitor c=0.00282519f //x=20.045 //y=7.585 \
 //x2=19.36 //y2=4.25
cc_465 ( N_VDD_c_296_n QN ) capacitor c=0.00926924f //x=20.045 //y=7.585 \
 //x2=19.36 //y2=4.62
cc_466 ( N_VDD_c_298_p QN ) capacitor c=2.28312e-19 //x=24.115 //y=7.58 \
 //x2=19.36 //y2=4.99
cc_467 ( N_VDD_c_474_p QN ) capacitor c=2.16857e-19 //x=19.875 //y=7.585 \
 //x2=19.36 //y2=4.99
cc_468 ( N_VDD_c_295_n QN ) capacitor c=0.00151558f //x=16.715 //y=7.585 \
 //x2=19.36 //y2=4.99
cc_469 ( N_VDD_c_296_n QN ) capacitor c=0.00893044f //x=20.045 //y=7.585 \
 //x2=19.36 //y2=4.99
cc_470 ( N_VDD_c_296_n QN ) capacitor c=0.0167737f //x=20.045 //y=7.585 \
 //x2=21.21 //y2=4.25
cc_471 ( N_VDD_c_298_p QN ) capacitor c=2.10725e-19 //x=24.115 //y=7.58 \
 //x2=21.21 //y2=4.62
cc_472 ( N_VDD_c_298_p N_QN_c_1666_n ) capacitor c=0.00465989f //x=24.115 \
 //y=7.58 //x2=18.74 //y2=5.38
cc_473 ( N_VDD_c_412_p N_QN_c_1666_n ) capacitor c=4.34465e-19 //x=18.3 \
 //y=7.585 //x2=18.74 //y2=5.38
cc_474 ( N_VDD_c_466_p N_QN_c_1666_n ) capacitor c=4.34465e-19 //x=19.18 \
 //y=7.585 //x2=18.74 //y2=5.38
cc_475 ( N_VDD_M36_noxref_d N_QN_c_1666_n ) capacitor c=0.0128492f //x=18.24 \
 //y=5.2 //x2=18.74 //y2=5.38
cc_476 ( N_VDD_c_295_n N_QN_c_1670_n ) capacitor c=0.00985474f //x=16.715 \
 //y=7.585 //x2=18.03 //y2=5.38
cc_477 ( N_VDD_M35_noxref_s N_QN_c_1670_n ) capacitor c=0.087833f //x=17.37 \
 //y=5.2 //x2=18.03 //y2=5.38
cc_478 ( N_VDD_c_298_p N_QN_c_1672_n ) capacitor c=0.00312262f //x=24.115 \
 //y=7.58 //x2=19.22 //y2=5.38
cc_479 ( N_VDD_c_466_p N_QN_c_1672_n ) capacitor c=7.22416e-19 //x=19.18 \
 //y=7.585 //x2=19.22 //y2=5.38
cc_480 ( N_VDD_M38_noxref_d N_QN_c_1672_n ) capacitor c=0.0163548f //x=19.12 \
 //y=5.2 //x2=19.22 //y2=5.38
cc_481 ( N_VDD_c_296_n N_QN_c_1675_n ) capacitor c=0.0154723f //x=20.045 \
 //y=7.585 //x2=19.305 //y2=5.295
cc_482 ( N_VDD_c_298_p N_QN_c_1676_n ) capacitor c=9.35182e-19 //x=24.115 \
 //y=7.58 //x2=21.155 //y2=4.88
cc_483 ( N_VDD_M39_noxref_s N_QN_c_1676_n ) capacitor c=0.0125089f //x=21 \
 //y=5.2 //x2=21.155 //y2=4.88
cc_484 ( N_VDD_c_296_n N_QN_c_1678_n ) capacitor c=0.00760472f //x=20.045 \
 //y=7.585 //x2=19.332 //y2=4.535
cc_485 ( N_VDD_c_296_n N_QN_c_1679_n ) capacitor c=0.00764055f //x=20.045 \
 //y=7.585 //x2=19.332 //y2=4.905
cc_486 ( N_VDD_c_493_p N_QN_M39_noxref_g ) capacitor c=0.00750689f //x=21.93 \
 //y=7.585 //x2=21.355 //y2=6.2
cc_487 ( N_VDD_M39_noxref_s N_QN_M39_noxref_g ) capacitor c=0.0477201f //x=21 \
 //y=5.2 //x2=21.355 //y2=6.2
cc_488 ( N_VDD_c_493_p N_QN_M40_noxref_g ) capacitor c=0.00679791f //x=21.93 \
 //y=7.585 //x2=21.795 //y2=6.2
cc_489 ( N_VDD_M40_noxref_d N_QN_M40_noxref_g ) capacitor c=0.015318f \
 //x=21.87 //y=5.2 //x2=21.795 //y2=6.2
cc_490 ( N_VDD_c_296_n N_QN_c_1684_n ) capacitor c=0.0076931f //x=20.045 \
 //y=7.585 //x2=21.43 //y2=4.97
cc_491 ( N_VDD_M39_noxref_s N_QN_c_1684_n ) capacitor c=0.00446202f //x=21 \
 //y=5.2 //x2=21.43 //y2=4.97
cc_492 ( N_VDD_c_298_p N_QN_M35_noxref_d ) capacitor c=0.00287996f //x=24.115 \
 //y=7.58 //x2=17.8 //y2=5.2
cc_493 ( N_VDD_c_412_p N_QN_M35_noxref_d ) capacitor c=0.0140329f //x=18.3 \
 //y=7.585 //x2=17.8 //y2=5.2
cc_494 ( N_VDD_c_296_n N_QN_M35_noxref_d ) capacitor c=6.94454e-19 //x=20.045 \
 //y=7.585 //x2=17.8 //y2=5.2
cc_495 ( N_VDD_M36_noxref_d N_QN_M35_noxref_d ) capacitor c=0.0664752f \
 //x=18.24 //y=5.2 //x2=17.8 //y2=5.2
cc_496 ( N_VDD_c_298_p N_QN_M37_noxref_d ) capacitor c=0.00294258f //x=24.115 \
 //y=7.58 //x2=18.68 //y2=5.2
cc_497 ( N_VDD_c_466_p N_QN_M37_noxref_d ) capacitor c=0.0138783f //x=19.18 \
 //y=7.585 //x2=18.68 //y2=5.2
cc_498 ( N_VDD_c_296_n N_QN_M37_noxref_d ) capacitor c=0.0120541f //x=20.045 \
 //y=7.585 //x2=18.68 //y2=5.2
cc_499 ( N_VDD_M35_noxref_s N_QN_M37_noxref_d ) capacitor c=0.00111971f \
 //x=17.37 //y=5.2 //x2=18.68 //y2=5.2
cc_500 ( N_VDD_M36_noxref_d N_QN_M37_noxref_d ) capacitor c=0.0664752f \
 //x=18.24 //y=5.2 //x2=18.68 //y2=5.2
cc_501 ( N_VDD_M38_noxref_d N_QN_M37_noxref_d ) capacitor c=0.0664752f \
 //x=19.12 //y=5.2 //x2=18.68 //y2=5.2
cc_502 ( N_VDD_M39_noxref_s N_QN_M37_noxref_d ) capacitor c=3.73257e-19 //x=21 \
 //y=5.2 //x2=18.68 //y2=5.2
cc_503 ( N_VDD_c_296_n SN ) capacitor c=7.43355e-19 //x=20.045 //y=7.585 \
 //x2=22.32 //y2=4.25
cc_504 ( N_VDD_c_298_p N_SN_c_1826_n ) capacitor c=2.03391e-19 //x=24.115 \
 //y=7.58 //x2=10.795 //y2=4.88
cc_505 ( N_VDD_c_293_n N_SN_c_1826_n ) capacitor c=6.15069e-19 //x=8.575 \
 //y=7.585 //x2=10.795 //y2=4.88
cc_506 ( N_VDD_c_298_p N_SN_c_1828_n ) capacitor c=2.07894e-19 //x=24.115 \
 //y=7.58 //x2=22.265 //y2=4.88
cc_507 ( N_VDD_c_340_p N_SN_M27_noxref_g ) capacitor c=0.00680845f //x=11.34 \
 //y=7.585 //x2=10.765 //y2=6.2
cc_508 ( N_VDD_M26_noxref_d N_SN_M27_noxref_g ) capacitor c=0.015318f //x=10.4 \
 //y=5.2 //x2=10.765 //y2=6.2
cc_509 ( N_VDD_c_340_p N_SN_M28_noxref_g ) capacitor c=0.00679791f //x=11.34 \
 //y=7.585 //x2=11.205 //y2=6.2
cc_510 ( N_VDD_M28_noxref_d N_SN_M28_noxref_g ) capacitor c=0.015318f \
 //x=11.28 //y=5.2 //x2=11.205 //y2=6.2
cc_511 ( N_VDD_c_518_p N_SN_M41_noxref_g ) capacitor c=0.00680845f //x=22.81 \
 //y=7.585 //x2=22.235 //y2=6.2
cc_512 ( N_VDD_M40_noxref_d N_SN_M41_noxref_g ) capacitor c=0.015318f \
 //x=21.87 //y=5.2 //x2=22.235 //y2=6.2
cc_513 ( N_VDD_c_518_p N_SN_M42_noxref_g ) capacitor c=0.00679791f //x=22.81 \
 //y=7.585 //x2=22.675 //y2=6.2
cc_514 ( N_VDD_M42_noxref_d N_SN_M42_noxref_g ) capacitor c=0.015318f \
 //x=22.75 //y=5.2 //x2=22.675 //y2=6.2
cc_515 ( N_VDD_c_298_p N_noxref_10_c_2082_n ) capacitor c=0.0405325f \
 //x=24.115 //y=7.58 //x2=23.26 //y2=3.88
cc_516 ( N_VDD_c_296_n N_noxref_10_c_2082_n ) capacitor c=0.0109526f \
 //x=20.045 //y=7.585 //x2=23.26 //y2=3.88
cc_517 ( N_VDD_M38_noxref_d N_noxref_10_c_2082_n ) capacitor c=4.00443e-19 \
 //x=19.12 //y=5.2 //x2=23.26 //y2=3.88
cc_518 ( N_VDD_M39_noxref_s N_noxref_10_c_2082_n ) capacitor c=9.16774e-19 \
 //x=21 //y=5.2 //x2=23.26 //y2=3.88
cc_519 ( N_VDD_c_293_n N_noxref_10_c_2083_n ) capacitor c=7.21808e-19 \
 //x=8.575 //y=7.585 //x2=7.095 //y2=2.26
cc_520 ( N_VDD_c_294_n N_noxref_10_c_2084_n ) capacitor c=6.21611e-19 \
 //x=13.385 //y=7.585 //x2=11.905 //y2=2.26
cc_521 ( N_VDD_c_298_p N_noxref_10_c_2097_n ) capacitor c=0.00453519f \
 //x=24.115 //y=7.58 //x2=15.41 //y2=5.38
cc_522 ( N_VDD_c_354_p N_noxref_10_c_2097_n ) capacitor c=4.48891e-19 \
 //x=14.97 //y=7.585 //x2=15.41 //y2=5.38
cc_523 ( N_VDD_c_396_p N_noxref_10_c_2097_n ) capacitor c=4.48878e-19 \
 //x=15.85 //y=7.585 //x2=15.41 //y2=5.38
cc_524 ( N_VDD_M32_noxref_d N_noxref_10_c_2097_n ) capacitor c=0.0124513f \
 //x=14.91 //y=5.2 //x2=15.41 //y2=5.38
cc_525 ( N_VDD_c_294_n N_noxref_10_c_2101_n ) capacitor c=0.00985474f \
 //x=13.385 //y=7.585 //x2=14.7 //y2=5.38
cc_526 ( N_VDD_M31_noxref_s N_noxref_10_c_2101_n ) capacitor c=0.087833f \
 //x=14.04 //y=5.2 //x2=14.7 //y2=5.38
cc_527 ( N_VDD_c_298_p N_noxref_10_c_2103_n ) capacitor c=0.0030743f \
 //x=24.115 //y=7.58 //x2=15.89 //y2=5.38
cc_528 ( N_VDD_c_396_p N_noxref_10_c_2103_n ) capacitor c=7.74005e-19 \
 //x=15.85 //y=7.585 //x2=15.89 //y2=5.38
cc_529 ( N_VDD_M34_noxref_d N_noxref_10_c_2103_n ) capacitor c=0.016158f \
 //x=15.79 //y=5.2 //x2=15.89 //y2=5.38
cc_530 ( N_VDD_M35_noxref_s N_noxref_10_c_2103_n ) capacitor c=2.44532e-19 \
 //x=17.37 //y=5.2 //x2=15.89 //y2=5.38
cc_531 ( N_VDD_c_294_n N_noxref_10_c_2086_n ) capacitor c=0.00151618f \
 //x=13.385 //y=7.585 //x2=15.975 //y2=3.88
cc_532 ( N_VDD_c_295_n N_noxref_10_c_2086_n ) capacitor c=0.0449321f \
 //x=16.715 //y=7.585 //x2=15.975 //y2=3.88
cc_533 ( N_VDD_c_290_n N_noxref_10_c_2087_n ) capacitor c=8.81482e-19 \
 //x=24.115 //y=7.58 //x2=23.375 //y2=2.26
cc_534 ( N_VDD_c_429_p N_noxref_10_M23_noxref_g ) capacitor c=0.00679791f \
 //x=7.41 //y=7.585 //x2=6.835 //y2=6.2
cc_535 ( N_VDD_M22_noxref_d N_noxref_10_M23_noxref_g ) capacitor c=0.015318f \
 //x=6.47 //y=5.2 //x2=6.835 //y2=6.2
cc_536 ( N_VDD_c_429_p N_noxref_10_M24_noxref_g ) capacitor c=0.00680002f \
 //x=7.41 //y=7.585 //x2=7.275 //y2=6.2
cc_537 ( N_VDD_M24_noxref_d N_noxref_10_M24_noxref_g ) capacitor c=0.0394719f \
 //x=7.35 //y=5.2 //x2=7.275 //y2=6.2
cc_538 ( N_VDD_c_346_p N_noxref_10_M29_noxref_g ) capacitor c=0.00679791f \
 //x=12.22 //y=7.585 //x2=11.645 //y2=6.2
cc_539 ( N_VDD_M28_noxref_d N_noxref_10_M29_noxref_g ) capacitor c=0.015318f \
 //x=11.28 //y=5.2 //x2=11.645 //y2=6.2
cc_540 ( N_VDD_c_346_p N_noxref_10_M30_noxref_g ) capacitor c=0.00680002f \
 //x=12.22 //y=7.585 //x2=12.085 //y2=6.2
cc_541 ( N_VDD_M30_noxref_d N_noxref_10_M30_noxref_g ) capacitor c=0.0394719f \
 //x=12.16 //y=5.2 //x2=12.085 //y2=6.2
cc_542 ( N_VDD_c_549_p N_noxref_10_M43_noxref_g ) capacitor c=0.00679791f \
 //x=23.69 //y=7.585 //x2=23.115 //y2=6.2
cc_543 ( N_VDD_M42_noxref_d N_noxref_10_M43_noxref_g ) capacitor c=0.015318f \
 //x=22.75 //y=5.2 //x2=23.115 //y2=6.2
cc_544 ( N_VDD_c_549_p N_noxref_10_M44_noxref_g ) capacitor c=0.00680002f \
 //x=23.69 //y=7.585 //x2=23.555 //y2=6.2
cc_545 ( N_VDD_M44_noxref_d N_noxref_10_M44_noxref_g ) capacitor c=0.0394719f \
 //x=23.63 //y=5.2 //x2=23.555 //y2=6.2
cc_546 ( N_VDD_c_298_p N_noxref_10_M31_noxref_d ) capacitor c=0.00275298f \
 //x=24.115 //y=7.58 //x2=14.47 //y2=5.2
cc_547 ( N_VDD_c_354_p N_noxref_10_M31_noxref_d ) capacitor c=0.0140544f \
 //x=14.97 //y=7.585 //x2=14.47 //y2=5.2
cc_548 ( N_VDD_c_295_n N_noxref_10_M31_noxref_d ) capacitor c=6.94454e-19 \
 //x=16.715 //y=7.585 //x2=14.47 //y2=5.2
cc_549 ( N_VDD_M32_noxref_d N_noxref_10_M31_noxref_d ) capacitor c=0.0664752f \
 //x=14.91 //y=5.2 //x2=14.47 //y2=5.2
cc_550 ( N_VDD_c_298_p N_noxref_10_M33_noxref_d ) capacitor c=0.00285139f \
 //x=24.115 //y=7.58 //x2=15.35 //y2=5.2
cc_551 ( N_VDD_c_396_p N_noxref_10_M33_noxref_d ) capacitor c=0.0141209f \
 //x=15.85 //y=7.585 //x2=15.35 //y2=5.2
cc_552 ( N_VDD_c_295_n N_noxref_10_M33_noxref_d ) capacitor c=0.0120541f \
 //x=16.715 //y=7.585 //x2=15.35 //y2=5.2
cc_553 ( N_VDD_M31_noxref_s N_noxref_10_M33_noxref_d ) capacitor c=0.00111971f \
 //x=14.04 //y=5.2 //x2=15.35 //y2=5.2
cc_554 ( N_VDD_M32_noxref_d N_noxref_10_M33_noxref_d ) capacitor c=0.0664752f \
 //x=14.91 //y=5.2 //x2=15.35 //y2=5.2
cc_555 ( N_VDD_M34_noxref_d N_noxref_10_M33_noxref_d ) capacitor c=0.0664752f \
 //x=15.79 //y=5.2 //x2=15.35 //y2=5.2
cc_556 ( N_VDD_M35_noxref_s N_noxref_10_M33_noxref_d ) capacitor c=4.54516e-19 \
 //x=17.37 //y=5.2 //x2=15.35 //y2=5.2
cc_557 ( N_VDD_c_298_p N_noxref_11_c_2441_n ) capacitor c=0.00457365f \
 //x=24.115 //y=7.58 //x2=22.37 //y2=5.335
cc_558 ( N_VDD_c_493_p N_noxref_11_c_2441_n ) capacitor c=4.18731e-19 \
 //x=21.93 //y=7.585 //x2=22.37 //y2=5.335
cc_559 ( N_VDD_c_518_p N_noxref_11_c_2441_n ) capacitor c=4.18731e-19 \
 //x=22.81 //y=7.585 //x2=22.37 //y2=5.335
cc_560 ( N_VDD_M40_noxref_d N_noxref_11_c_2441_n ) capacitor c=0.0116571f \
 //x=21.87 //y=5.2 //x2=22.37 //y2=5.335
cc_561 ( N_VDD_c_296_n N_noxref_11_c_2445_n ) capacitor c=0.00863585f \
 //x=20.045 //y=7.585 //x2=21.66 //y2=5.335
cc_562 ( N_VDD_M39_noxref_s N_noxref_11_c_2445_n ) capacitor c=0.0831083f \
 //x=21 //y=5.2 //x2=21.66 //y2=5.335
cc_563 ( N_VDD_c_298_p N_noxref_11_c_2447_n ) capacitor c=0.00454954f \
 //x=24.115 //y=7.58 //x2=23.25 //y2=5.335
cc_564 ( N_VDD_c_518_p N_noxref_11_c_2447_n ) capacitor c=4.18731e-19 \
 //x=22.81 //y=7.585 //x2=23.25 //y2=5.335
cc_565 ( N_VDD_c_549_p N_noxref_11_c_2447_n ) capacitor c=4.18731e-19 \
 //x=23.69 //y=7.585 //x2=23.25 //y2=5.335
cc_566 ( N_VDD_M42_noxref_d N_noxref_11_c_2447_n ) capacitor c=0.0116571f \
 //x=22.75 //y=5.2 //x2=23.25 //y2=5.335
cc_567 ( N_VDD_c_298_p N_noxref_11_c_2451_n ) capacitor c=0.0045622f \
 //x=24.115 //y=7.58 //x2=24.03 //y2=5.335
cc_568 ( N_VDD_c_549_p N_noxref_11_c_2451_n ) capacitor c=6.99544e-19 \
 //x=23.69 //y=7.585 //x2=24.03 //y2=5.335
cc_569 ( N_VDD_c_290_n N_noxref_11_c_2451_n ) capacitor c=0.00180478f \
 //x=24.115 //y=7.58 //x2=24.03 //y2=5.335
cc_570 ( N_VDD_M44_noxref_d N_noxref_11_c_2451_n ) capacitor c=0.0117488f \
 //x=23.63 //y=5.2 //x2=24.03 //y2=5.335
cc_571 ( N_VDD_c_298_p N_noxref_11_c_2438_n ) capacitor c=0.0207341f \
 //x=24.115 //y=7.58 //x2=24.115 //y2=3.51
cc_572 ( N_VDD_c_290_n N_noxref_11_c_2438_n ) capacitor c=0.046173f //x=24.115 \
 //y=7.58 //x2=24.115 //y2=3.51
cc_573 ( N_VDD_c_298_p N_noxref_11_M39_noxref_d ) capacitor c=0.00294265f \
 //x=24.115 //y=7.58 //x2=21.43 //y2=5.2
cc_574 ( N_VDD_c_493_p N_noxref_11_M39_noxref_d ) capacitor c=0.0138842f \
 //x=21.93 //y=7.585 //x2=21.43 //y2=5.2
cc_575 ( N_VDD_M40_noxref_d N_noxref_11_M39_noxref_d ) capacitor c=0.0664752f \
 //x=21.87 //y=5.2 //x2=21.43 //y2=5.2
cc_576 ( N_VDD_c_298_p N_noxref_11_M41_noxref_d ) capacitor c=0.00294265f \
 //x=24.115 //y=7.58 //x2=22.31 //y2=5.2
cc_577 ( N_VDD_c_518_p N_noxref_11_M41_noxref_d ) capacitor c=0.0138649f \
 //x=22.81 //y=7.585 //x2=22.31 //y2=5.2
cc_578 ( N_VDD_c_290_n N_noxref_11_M41_noxref_d ) capacitor c=4.9285e-19 \
 //x=24.115 //y=7.58 //x2=22.31 //y2=5.2
cc_579 ( N_VDD_M39_noxref_s N_noxref_11_M41_noxref_d ) capacitor c=0.00130656f \
 //x=21 //y=5.2 //x2=22.31 //y2=5.2
cc_580 ( N_VDD_M40_noxref_d N_noxref_11_M41_noxref_d ) capacitor c=0.0664752f \
 //x=21.87 //y=5.2 //x2=22.31 //y2=5.2
cc_581 ( N_VDD_M42_noxref_d N_noxref_11_M41_noxref_d ) capacitor c=0.0664752f \
 //x=22.75 //y=5.2 //x2=22.31 //y2=5.2
cc_582 ( N_VDD_c_298_p N_noxref_11_M43_noxref_d ) capacitor c=0.00293591f \
 //x=24.115 //y=7.58 //x2=23.19 //y2=5.2
cc_583 ( N_VDD_c_549_p N_noxref_11_M43_noxref_d ) capacitor c=0.0138122f \
 //x=23.69 //y=7.585 //x2=23.19 //y2=5.2
cc_584 ( N_VDD_c_290_n N_noxref_11_M43_noxref_d ) capacitor c=0.00963505f \
 //x=24.115 //y=7.58 //x2=23.19 //y2=5.2
cc_585 ( N_VDD_M42_noxref_d N_noxref_11_M43_noxref_d ) capacitor c=0.0664752f \
 //x=22.75 //y=5.2 //x2=23.19 //y2=5.2
cc_586 ( N_VDD_M44_noxref_d N_noxref_11_M43_noxref_d ) capacitor c=0.0664752f \
 //x=23.63 //y=5.2 //x2=23.19 //y2=5.2
cc_587 ( N_VDD_c_291_n D ) capacitor c=0.0167799f //x=1.175 //y=7.58 //x2=1.6 \
 //y2=4.25
cc_588 ( N_VDD_c_298_p N_D_c_2547_n ) capacitor c=0.00140336f //x=24.115 \
 //y=7.58 //x2=1.545 //y2=4.88
cc_589 ( N_VDD_c_299_p N_D_c_2547_n ) capacitor c=2.64671e-19 //x=2.02 \
 //y=7.585 //x2=1.545 //y2=4.88
cc_590 ( N_VDD_c_299_p N_D_M15_noxref_g ) capacitor c=0.00732332f //x=2.02 \
 //y=7.585 //x2=1.445 //y2=6.2
cc_591 ( N_VDD_M15_noxref_s N_D_M15_noxref_g ) capacitor c=0.054195f //x=1.09 \
 //y=5.2 //x2=1.445 //y2=6.2
cc_592 ( N_VDD_c_299_p N_D_M16_noxref_g ) capacitor c=0.00677553f //x=2.02 \
 //y=7.585 //x2=1.885 //y2=6.2
cc_593 ( N_VDD_M16_noxref_d N_D_M16_noxref_g ) capacitor c=0.015318f //x=1.96 \
 //y=5.2 //x2=1.885 //y2=6.2
cc_594 ( N_VDD_c_291_n N_D_c_2553_n ) capacitor c=0.0292267f //x=1.175 \
 //y=7.58 //x2=1.545 //y2=4.88
cc_595 ( N_noxref_3_c_608_n N_noxref_4_c_858_n ) capacitor c=0.00564994f \
 //x=9.57 //y=2.77 //x2=12.76 //y2=2.77
cc_596 ( N_noxref_3_M26_noxref_g N_noxref_4_c_873_n ) capacitor c=0.0168349f \
 //x=10.325 //y=6.2 //x2=10.9 //y2=5.335
cc_597 ( N_noxref_3_M25_noxref_g N_noxref_4_c_877_n ) capacitor c=0.0213876f \
 //x=9.885 //y=6.2 //x2=10.19 //y2=5.335
cc_598 ( N_noxref_3_c_686_p N_noxref_4_c_877_n ) capacitor c=0.00428486f \
 //x=10.25 //y=4.97 //x2=10.19 //y2=5.335
cc_599 ( N_noxref_3_M26_noxref_g N_noxref_4_M25_noxref_d ) capacitor \
 c=0.0180032f //x=10.325 //y=6.2 //x2=9.96 //y2=5.2
cc_600 ( N_noxref_3_c_608_n N_CLK_c_1027_n ) capacitor c=0.00546165f //x=9.57 \
 //y=2.77 //x2=15.12 //y2=4.62
cc_601 ( N_noxref_3_c_618_n N_CLK_c_1027_n ) capacitor c=0.0208709f //x=9.685 \
 //y=2.26 //x2=15.12 //y2=4.62
cc_602 ( N_noxref_3_c_670_n N_CLK_c_1027_n ) capacitor c=0.0166984f //x=9.96 \
 //y=4.97 //x2=15.12 //y2=4.62
cc_603 ( N_noxref_3_c_608_n N_CLK_c_1038_n ) capacitor c=5.22124e-19 //x=9.57 \
 //y=2.77 //x2=6.1 //y2=4.62
cc_604 ( N_noxref_3_c_617_n N_CLK_c_1038_n ) capacitor c=0.00551083f //x=4.875 \
 //y=2.26 //x2=6.1 //y2=4.62
cc_605 ( N_noxref_3_c_608_n CLK ) capacitor c=0.00150819f //x=9.57 //y=2.77 \
 //x2=6.04 //y2=3.14
cc_606 ( N_noxref_3_c_608_n N_CLK_c_1024_n ) capacitor c=0.0273718f //x=9.57 \
 //y=2.77 //x2=5.985 //y2=2.26
cc_607 ( N_noxref_3_c_612_n N_CLK_c_1024_n ) capacitor c=0.00103784f //x=5.14 \
 //y=2.77 //x2=5.985 //y2=2.26
cc_608 ( N_noxref_3_c_615_n N_CLK_c_1024_n ) capacitor c=5.0046e-19 //x=3.025 \
 //y=2.77 //x2=5.985 //y2=2.26
cc_609 ( N_noxref_3_c_617_n N_CLK_c_1024_n ) capacitor c=0.0512013f //x=4.875 \
 //y=2.26 //x2=5.985 //y2=2.26
cc_610 ( N_noxref_3_c_623_n N_CLK_c_1024_n ) capacitor c=0.00238338f //x=4.575 \
 //y=2.095 //x2=5.985 //y2=2.26
cc_611 ( N_noxref_3_c_699_p N_CLK_c_1039_n ) capacitor c=0.00147352f //x=5.44 \
 //y=4.97 //x2=5.985 //y2=4.88
cc_612 ( N_noxref_3_c_668_n N_CLK_c_1039_n ) capacitor c=0.00141297f //x=5.15 \
 //y=4.97 //x2=5.985 //y2=4.88
cc_613 ( N_noxref_3_M19_noxref_g N_CLK_M21_noxref_g ) capacitor c=0.0105869f \
 //x=5.075 //y=6.2 //x2=5.955 //y2=6.2
cc_614 ( N_noxref_3_M20_noxref_g N_CLK_M21_noxref_g ) capacitor c=0.10632f \
 //x=5.515 //y=6.2 //x2=5.955 //y2=6.2
cc_615 ( N_noxref_3_M20_noxref_g N_CLK_M22_noxref_g ) capacitor c=0.0101598f \
 //x=5.515 //y=6.2 //x2=6.395 //y2=6.2
cc_616 ( N_noxref_3_c_619_n N_CLK_c_1068_n ) capacitor c=5.72482e-19 //x=4.575 \
 //y=1.055 //x2=5.55 //y2=1.09
cc_617 ( N_noxref_3_c_621_n N_CLK_c_1068_n ) capacitor c=0.00149976f //x=4.575 \
 //y=1.4 //x2=5.55 //y2=1.09
cc_618 ( N_noxref_3_c_626_n N_CLK_c_1068_n ) capacitor c=0.0160123f //x=5.105 \
 //y=1.055 //x2=5.55 //y2=1.09
cc_619 ( N_noxref_3_c_622_n N_CLK_c_1071_n ) capacitor c=0.00111227f //x=4.575 \
 //y=1.71 //x2=5.55 //y2=1.4
cc_620 ( N_noxref_3_c_628_n N_CLK_c_1071_n ) capacitor c=0.0124075f //x=5.105 \
 //y=1.4 //x2=5.55 //y2=1.4
cc_621 ( N_noxref_3_c_626_n N_CLK_c_1073_n ) capacitor c=0.00103227f //x=5.105 \
 //y=1.055 //x2=6.075 //y2=1.09
cc_622 ( N_noxref_3_c_628_n N_CLK_c_1074_n ) capacitor c=0.0010154f //x=5.105 \
 //y=1.4 //x2=6.075 //y2=1.4
cc_623 ( N_noxref_3_c_628_n N_CLK_c_1075_n ) capacitor c=9.23422e-19 //x=5.105 \
 //y=1.4 //x2=6.075 //y2=1.63
cc_624 ( N_noxref_3_c_608_n N_CLK_c_1076_n ) capacitor c=0.00262666f //x=9.57 \
 //y=2.77 //x2=6.075 //y2=2.095
cc_625 ( N_noxref_3_c_617_n N_CLK_c_1076_n ) capacitor c=0.00231304f //x=4.875 \
 //y=2.26 //x2=6.075 //y2=2.095
cc_626 ( N_noxref_3_c_623_n N_CLK_c_1076_n ) capacitor c=0.00964411f //x=4.575 \
 //y=2.095 //x2=6.075 //y2=2.095
cc_627 ( N_noxref_3_c_617_n N_CLK_c_1079_n ) capacitor c=0.00183762f //x=4.875 \
 //y=2.26 //x2=5.985 //y2=4.88
cc_628 ( N_noxref_3_c_699_p N_CLK_c_1079_n ) capacitor c=0.0168581f //x=5.44 \
 //y=4.97 //x2=5.985 //y2=4.88
cc_629 ( N_noxref_3_c_668_n N_CLK_c_1079_n ) capacitor c=0.00484466f //x=5.15 \
 //y=4.97 //x2=5.985 //y2=4.88
cc_630 ( N_noxref_3_c_602_n N_noxref_6_c_1250_n ) capacitor c=0.0375273f \
 //x=4.73 //y=2.77 //x2=7.715 //y2=4.25
cc_631 ( N_noxref_3_c_606_n N_noxref_6_c_1250_n ) capacitor c=0.0053071f \
 //x=3.14 //y=2.77 //x2=7.715 //y2=4.25
cc_632 ( N_noxref_3_c_612_n N_noxref_6_c_1250_n ) capacitor c=0.0490326f \
 //x=5.14 //y=2.77 //x2=7.715 //y2=4.25
cc_633 ( N_noxref_3_c_643_n N_noxref_6_c_1250_n ) capacitor c=0.0129784f \
 //x=2.46 //y=5.38 //x2=7.715 //y2=4.25
cc_634 ( N_noxref_3_c_722_p N_noxref_6_c_1250_n ) capacitor c=0.00308569f \
 //x=2.67 //y=1.835 //x2=7.715 //y2=4.25
cc_635 ( N_noxref_3_c_615_n N_noxref_6_c_1250_n ) capacitor c=0.0280719f \
 //x=3.025 //y=2.77 //x2=7.715 //y2=4.25
cc_636 ( N_noxref_3_c_617_n N_noxref_6_c_1250_n ) capacitor c=0.0283241f \
 //x=4.875 //y=2.26 //x2=7.715 //y2=4.25
cc_637 ( N_noxref_3_c_668_n N_noxref_6_c_1250_n ) capacitor c=0.0116469f \
 //x=5.15 //y=4.97 //x2=7.715 //y2=4.25
cc_638 ( N_noxref_3_c_643_n N_noxref_6_c_1252_n ) capacitor c=0.00198571f \
 //x=2.46 //y=5.38 //x2=2.4 //y2=4.25
cc_639 ( N_noxref_3_c_615_n N_noxref_6_c_1252_n ) capacitor c=0.00179385f \
 //x=3.025 //y=2.77 //x2=2.4 //y2=4.25
cc_640 ( N_noxref_3_c_608_n N_noxref_6_c_1276_n ) capacitor c=0.00635883f \
 //x=9.57 //y=2.77 //x2=17.71 //y2=4.25
cc_641 ( N_noxref_3_c_618_n N_noxref_6_c_1276_n ) capacitor c=0.0194977f \
 //x=9.685 //y=2.26 //x2=17.71 //y2=4.25
cc_642 ( N_noxref_3_c_608_n N_noxref_6_c_1285_n ) capacitor c=3.09116e-19 \
 //x=9.57 //y=2.77 //x2=7.945 //y2=4.25
cc_643 ( N_noxref_3_c_618_n N_noxref_6_c_1285_n ) capacitor c=3.49381e-19 \
 //x=9.685 //y=2.26 //x2=7.945 //y2=4.25
cc_644 ( N_noxref_3_c_643_n N_noxref_6_c_1345_n ) capacitor c=0.0129794f \
 //x=2.46 //y=5.38 //x2=2.285 //y2=4.715
cc_645 ( N_noxref_3_c_615_n N_noxref_6_c_1345_n ) capacitor c=0.0101115f \
 //x=3.025 //y=2.77 //x2=2.285 //y2=4.715
cc_646 ( N_noxref_3_c_606_n N_noxref_6_c_1253_n ) capacitor c=0.00691549f \
 //x=3.14 //y=2.77 //x2=2.285 //y2=2.26
cc_647 ( N_noxref_3_c_615_n N_noxref_6_c_1253_n ) capacitor c=0.0786485f \
 //x=3.025 //y=2.77 //x2=2.285 //y2=2.26
cc_648 ( N_noxref_3_c_617_n N_noxref_6_c_1253_n ) capacitor c=8.97258e-19 \
 //x=4.875 //y=2.26 //x2=2.285 //y2=2.26
cc_649 ( N_noxref_3_M20_noxref_g N_noxref_6_c_1288_n ) capacitor c=0.0178794f \
 //x=5.515 //y=6.2 //x2=6.09 //y2=5.335
cc_650 ( N_noxref_3_c_615_n N_noxref_6_c_1292_n ) capacitor c=2.97874e-19 \
 //x=3.025 //y=2.77 //x2=5.38 //y2=5.335
cc_651 ( N_noxref_3_M19_noxref_g N_noxref_6_c_1292_n ) capacitor c=0.0213876f \
 //x=5.075 //y=6.2 //x2=5.38 //y2=5.335
cc_652 ( N_noxref_3_c_699_p N_noxref_6_c_1292_n ) capacitor c=0.00429591f \
 //x=5.44 //y=4.97 //x2=5.38 //y2=5.335
cc_653 ( N_noxref_3_c_608_n N_noxref_6_c_1354_n ) capacitor c=0.011558f \
 //x=9.57 //y=2.77 //x2=7.435 //y2=1.845
cc_654 ( N_noxref_3_c_608_n N_noxref_6_c_1355_n ) capacitor c=0.024834f \
 //x=9.57 //y=2.77 //x2=7.832 //y2=4.085
cc_655 ( N_noxref_3_c_618_n N_noxref_6_c_1355_n ) capacitor c=0.0148121f \
 //x=9.685 //y=2.26 //x2=7.832 //y2=4.085
cc_656 ( N_noxref_3_c_643_n N_noxref_6_M17_noxref_g ) capacitor c=0.0166421f \
 //x=2.46 //y=5.38 //x2=2.325 //y2=6.2
cc_657 ( N_noxref_3_M17_noxref_d N_noxref_6_M17_noxref_g ) capacitor \
 c=0.0173476f //x=2.4 //y=5.2 //x2=2.325 //y2=6.2
cc_658 ( N_noxref_3_c_649_n N_noxref_6_M18_noxref_g ) capacitor c=0.0199348f \
 //x=2.94 //y=5.38 //x2=2.765 //y2=6.2
cc_659 ( N_noxref_3_M17_noxref_d N_noxref_6_M18_noxref_g ) capacitor \
 c=0.0179769f //x=2.4 //y=5.2 //x2=2.765 //y2=6.2
cc_660 ( N_noxref_3_M1_noxref_d N_noxref_6_c_1361_n ) capacitor c=0.00217566f \
 //x=2.395 //y=1.085 //x2=2.32 //y2=1.085
cc_661 ( N_noxref_3_M1_noxref_d N_noxref_6_c_1362_n ) capacitor c=0.0034598f \
 //x=2.395 //y=1.085 //x2=2.32 //y2=1.43
cc_662 ( N_noxref_3_M1_noxref_d N_noxref_6_c_1363_n ) capacitor c=0.0065582f \
 //x=2.395 //y=1.085 //x2=2.32 //y2=1.74
cc_663 ( N_noxref_3_c_615_n N_noxref_6_c_1364_n ) capacitor c=0.0142673f \
 //x=3.025 //y=2.77 //x2=2.69 //y2=4.97
cc_664 ( N_noxref_3_c_752_p N_noxref_6_c_1364_n ) capacitor c=0.00408717f \
 //x=2.545 //y=5.38 //x2=2.69 //y2=4.97
cc_665 ( N_noxref_3_M1_noxref_d N_noxref_6_c_1366_n ) capacitor c=0.00241102f \
 //x=2.395 //y=1.085 //x2=2.695 //y2=0.93
cc_666 ( N_noxref_3_c_614_n N_noxref_6_c_1367_n ) capacitor c=0.00359704f \
 //x=2.94 //y=1.835 //x2=2.695 //y2=1.585
cc_667 ( N_noxref_3_M1_noxref_d N_noxref_6_c_1367_n ) capacitor c=0.0138845f \
 //x=2.395 //y=1.085 //x2=2.695 //y2=1.585
cc_668 ( N_noxref_3_M1_noxref_d N_noxref_6_c_1369_n ) capacitor c=0.00132245f \
 //x=2.395 //y=1.085 //x2=2.85 //y2=1.085
cc_669 ( N_noxref_3_c_614_n N_noxref_6_c_1370_n ) capacitor c=0.00457401f \
 //x=2.94 //y=1.835 //x2=2.85 //y2=1.43
cc_670 ( N_noxref_3_M1_noxref_d N_noxref_6_c_1370_n ) capacitor c=0.00566463f \
 //x=2.395 //y=1.085 //x2=2.85 //y2=1.43
cc_671 ( N_noxref_3_c_615_n N_noxref_6_c_1372_n ) capacitor c=0.00877984f \
 //x=3.025 //y=2.77 //x2=2.285 //y2=2.26
cc_672 ( N_noxref_3_c_615_n N_noxref_6_c_1373_n ) capacitor c=0.00306024f \
 //x=3.025 //y=2.77 //x2=2.285 //y2=2.095
cc_673 ( N_noxref_3_M1_noxref_d N_noxref_6_c_1373_n ) capacitor c=0.00660593f \
 //x=2.395 //y=1.085 //x2=2.285 //y2=2.095
cc_674 ( N_noxref_3_c_643_n N_noxref_6_c_1375_n ) capacitor c=0.00346627f \
 //x=2.46 //y=5.38 //x2=2.315 //y2=4.88
cc_675 ( N_noxref_3_c_615_n N_noxref_6_c_1375_n ) capacitor c=0.00517969f \
 //x=3.025 //y=2.77 //x2=2.315 //y2=4.88
cc_676 ( N_noxref_3_M20_noxref_g N_noxref_6_M19_noxref_d ) capacitor \
 c=0.0180032f //x=5.515 //y=6.2 //x2=5.15 //y2=5.2
cc_677 ( N_noxref_3_c_618_n N_SN_c_1822_n ) capacitor c=0.00558344f //x=9.685 \
 //y=2.26 //x2=10.91 //y2=2.4
cc_678 ( N_noxref_3_c_633_n N_SN_c_1822_n ) capacitor c=0.00341397f //x=9.385 \
 //y=2.095 //x2=10.91 //y2=2.4
cc_679 ( N_noxref_3_c_608_n SN ) capacitor c=0.00251862f //x=9.57 //y=2.77 \
 //x2=10.85 //y2=2.77
cc_680 ( N_noxref_3_c_618_n N_SN_c_1840_n ) capacitor c=0.0481074f //x=9.685 \
 //y=2.26 //x2=10.795 //y2=2.485
cc_681 ( N_noxref_3_c_633_n N_SN_c_1840_n ) capacitor c=0.00228602f //x=9.385 \
 //y=2.095 //x2=10.795 //y2=2.485
cc_682 ( N_noxref_3_c_686_p N_SN_c_1826_n ) capacitor c=0.00147352f //x=10.25 \
 //y=4.97 //x2=10.795 //y2=4.88
cc_683 ( N_noxref_3_c_670_n N_SN_c_1826_n ) capacitor c=0.00142741f //x=9.96 \
 //y=4.97 //x2=10.795 //y2=4.88
cc_684 ( N_noxref_3_c_608_n N_SN_c_1823_n ) capacitor c=3.72448e-19 //x=9.57 \
 //y=2.77 //x2=10.822 //y2=2.685
cc_685 ( N_noxref_3_c_608_n N_SN_c_1845_n ) capacitor c=3.72448e-19 //x=9.57 \
 //y=2.77 //x2=10.822 //y2=3.055
cc_686 ( N_noxref_3_M25_noxref_g N_SN_M27_noxref_g ) capacitor c=0.0105869f \
 //x=9.885 //y=6.2 //x2=10.765 //y2=6.2
cc_687 ( N_noxref_3_M26_noxref_g N_SN_M27_noxref_g ) capacitor c=0.10632f \
 //x=10.325 //y=6.2 //x2=10.765 //y2=6.2
cc_688 ( N_noxref_3_M26_noxref_g N_SN_M28_noxref_g ) capacitor c=0.0101598f \
 //x=10.325 //y=6.2 //x2=11.205 //y2=6.2
cc_689 ( N_noxref_3_c_629_n N_SN_c_1849_n ) capacitor c=5.72482e-19 //x=9.385 \
 //y=1.055 //x2=10.36 //y2=1.09
cc_690 ( N_noxref_3_c_631_n N_SN_c_1849_n ) capacitor c=0.00149976f //x=9.385 \
 //y=1.4 //x2=10.36 //y2=1.09
cc_691 ( N_noxref_3_c_636_n N_SN_c_1849_n ) capacitor c=0.0160123f //x=9.915 \
 //y=1.055 //x2=10.36 //y2=1.09
cc_692 ( N_noxref_3_c_632_n N_SN_c_1852_n ) capacitor c=0.00111227f //x=9.385 \
 //y=1.71 //x2=10.36 //y2=1.4
cc_693 ( N_noxref_3_c_638_n N_SN_c_1852_n ) capacitor c=0.0124075f //x=9.915 \
 //y=1.4 //x2=10.36 //y2=1.4
cc_694 ( N_noxref_3_c_636_n N_SN_c_1854_n ) capacitor c=0.00103227f //x=9.915 \
 //y=1.055 //x2=10.885 //y2=1.09
cc_695 ( N_noxref_3_c_638_n N_SN_c_1855_n ) capacitor c=0.0010154f //x=9.915 \
 //y=1.4 //x2=10.885 //y2=1.4
cc_696 ( N_noxref_3_c_638_n N_SN_c_1856_n ) capacitor c=9.23422e-19 //x=9.915 \
 //y=1.4 //x2=10.885 //y2=1.63
cc_697 ( N_noxref_3_c_618_n N_SN_c_1857_n ) capacitor c=0.00211714f //x=9.685 \
 //y=2.26 //x2=10.885 //y2=2.095
cc_698 ( N_noxref_3_c_633_n N_SN_c_1857_n ) capacitor c=0.00909574f //x=9.385 \
 //y=2.095 //x2=10.885 //y2=2.095
cc_699 ( N_noxref_3_c_618_n N_SN_c_1859_n ) capacitor c=0.00183762f //x=9.685 \
 //y=2.26 //x2=10.795 //y2=4.88
cc_700 ( N_noxref_3_c_686_p N_SN_c_1859_n ) capacitor c=0.0168581f //x=10.25 \
 //y=4.97 //x2=10.795 //y2=4.88
cc_701 ( N_noxref_3_c_670_n N_SN_c_1859_n ) capacitor c=0.00484466f //x=9.96 \
 //y=4.97 //x2=10.795 //y2=4.88
cc_702 ( N_noxref_3_c_608_n N_noxref_10_c_2079_n ) capacitor c=0.0761096f \
 //x=9.57 //y=2.77 //x2=11.79 //y2=3.88
cc_703 ( N_noxref_3_c_618_n N_noxref_10_c_2079_n ) capacitor c=0.0237114f \
 //x=9.685 //y=2.26 //x2=11.79 //y2=3.88
cc_704 ( N_noxref_3_c_608_n N_noxref_10_c_2135_n ) capacitor c=0.00777466f \
 //x=9.57 //y=2.77 //x2=7.21 //y2=3.88
cc_705 ( N_noxref_3_c_608_n N_noxref_10_c_2083_n ) capacitor c=0.025454f \
 //x=9.57 //y=2.77 //x2=7.095 //y2=2.26
cc_706 ( N_noxref_3_c_617_n N_noxref_10_c_2083_n ) capacitor c=0.00151487f \
 //x=4.875 //y=2.26 //x2=7.095 //y2=2.26
cc_707 ( N_noxref_3_c_618_n N_noxref_10_c_2083_n ) capacitor c=8.19041e-19 \
 //x=9.685 //y=2.26 //x2=7.095 //y2=2.26
cc_708 ( N_noxref_3_c_618_n N_noxref_10_c_2084_n ) capacitor c=0.00130783f \
 //x=9.685 //y=2.26 //x2=11.905 //y2=2.26
cc_709 ( N_noxref_3_c_608_n N_noxref_10_c_2140_n ) capacitor c=0.00232725f \
 //x=9.57 //y=2.77 //x2=7.095 //y2=2.26
cc_710 ( N_noxref_3_c_615_n D ) capacitor c=2.26899e-19 //x=3.025 //y=2.77 \
 //x2=1.6 //y2=3.14
cc_711 ( N_noxref_3_c_615_n D ) capacitor c=2.26899e-19 //x=3.025 //y=2.77 \
 //x2=1.6 //y2=3.51
cc_712 ( N_noxref_3_c_615_n D ) capacitor c=2.26899e-19 //x=3.025 //y=2.77 \
 //x2=1.6 //y2=3.88
cc_713 ( N_noxref_3_c_647_n D ) capacitor c=3.14403e-19 //x=1.75 //y=5.38 \
 //x2=1.6 //y2=4.25
cc_714 ( N_noxref_3_c_647_n D ) capacitor c=0.00159847f //x=1.75 //y=5.38 \
 //x2=1.6 //y2=4.62
cc_715 ( N_noxref_3_c_615_n D ) capacitor c=2.26899e-19 //x=3.025 //y=2.77 \
 //x2=1.6 //y2=4.62
cc_716 ( N_noxref_3_c_647_n N_D_c_2547_n ) capacitor c=0.00569255f //x=1.75 \
 //y=5.38 //x2=1.545 //y2=4.88
cc_717 ( N_noxref_3_c_615_n N_D_c_2547_n ) capacitor c=5.9619e-19 //x=3.025 \
 //y=2.77 //x2=1.545 //y2=4.88
cc_718 ( N_noxref_3_c_615_n N_D_c_2562_n ) capacitor c=2.64068e-19 //x=3.025 \
 //y=2.77 //x2=1.572 //y2=2.685
cc_719 ( N_noxref_3_c_615_n N_D_c_2563_n ) capacitor c=2.57973e-19 //x=3.025 \
 //y=2.77 //x2=1.572 //y2=3.055
cc_720 ( N_noxref_3_c_615_n N_D_c_2564_n ) capacitor c=2.44001e-19 //x=3.025 \
 //y=2.77 //x2=1.572 //y2=3.425
cc_721 ( N_noxref_3_c_615_n N_D_c_2565_n ) capacitor c=2.44001e-19 //x=3.025 \
 //y=2.77 //x2=1.572 //y2=3.795
cc_722 ( N_noxref_3_c_615_n N_D_c_2566_n ) capacitor c=3.00891e-19 //x=3.025 \
 //y=2.77 //x2=1.572 //y2=4.165
cc_723 ( N_noxref_3_c_615_n N_D_c_2567_n ) capacitor c=3.00891e-19 //x=3.025 \
 //y=2.77 //x2=1.572 //y2=4.535
cc_724 ( N_noxref_3_c_647_n N_D_M15_noxref_g ) capacitor c=0.0177326f //x=1.75 \
 //y=5.38 //x2=1.445 //y2=6.2
cc_725 ( N_noxref_3_c_643_n N_D_M16_noxref_g ) capacitor c=0.0203837f //x=2.46 \
 //y=5.38 //x2=1.885 //y2=6.2
cc_726 ( N_noxref_3_M15_noxref_d N_D_M16_noxref_g ) capacitor c=0.0173476f \
 //x=1.52 //y=5.2 //x2=1.885 //y2=6.2
cc_727 ( N_noxref_3_c_647_n N_D_c_2553_n ) capacitor c=0.00491499f //x=1.75 \
 //y=5.38 //x2=1.545 //y2=4.88
cc_728 ( N_noxref_3_c_722_p N_noxref_13_c_2639_n ) capacitor c=3.15806e-19 \
 //x=2.67 //y=1.835 //x2=1.13 //y2=1.675
cc_729 ( N_noxref_3_c_722_p N_noxref_13_c_2627_n ) capacitor c=0.0201674f \
 //x=2.67 //y=1.835 //x2=2.1 //y2=1.675
cc_730 ( N_noxref_3_c_614_n N_noxref_13_c_2628_n ) capacitor c=0.00467467f \
 //x=2.94 //y=1.835 //x2=2.985 //y2=0.71
cc_731 ( N_noxref_3_M1_noxref_d N_noxref_13_c_2628_n ) capacitor c=0.0118355f \
 //x=2.395 //y=1.085 //x2=2.985 //y2=0.71
cc_732 ( N_noxref_3_c_602_n N_noxref_13_M0_noxref_s ) capacitor c=2.68031e-19 \
 //x=4.73 //y=2.77 //x2=0.995 //y2=0.545
cc_733 ( N_noxref_3_c_606_n N_noxref_13_M0_noxref_s ) capacitor c=5.97427e-19 \
 //x=3.14 //y=2.77 //x2=0.995 //y2=0.545
cc_734 ( N_noxref_3_c_614_n N_noxref_13_M0_noxref_s ) capacitor c=0.0129465f \
 //x=2.94 //y=1.835 //x2=0.995 //y2=0.545
cc_735 ( N_noxref_3_M1_noxref_d N_noxref_13_M0_noxref_s ) capacitor \
 c=0.0437911f //x=2.395 //y=1.085 //x2=0.995 //y2=0.545
cc_736 ( N_noxref_3_c_602_n N_noxref_14_c_2685_n ) capacitor c=0.00448771f \
 //x=4.73 //y=2.77 //x2=4.355 //y2=1.685
cc_737 ( N_noxref_3_c_614_n N_noxref_14_c_2685_n ) capacitor c=4.08644e-19 \
 //x=2.94 //y=1.835 //x2=4.355 //y2=1.685
cc_738 ( N_noxref_3_c_623_n N_noxref_14_c_2685_n ) capacitor c=0.0034165f \
 //x=4.575 //y=2.095 //x2=4.355 //y2=1.685
cc_739 ( N_noxref_3_c_602_n N_noxref_14_c_2669_n ) capacitor c=0.00818794f \
 //x=4.73 //y=2.77 //x2=5.24 //y2=1.77
cc_740 ( N_noxref_3_c_608_n N_noxref_14_c_2669_n ) capacitor c=0.00225116f \
 //x=9.57 //y=2.77 //x2=5.24 //y2=1.77
cc_741 ( N_noxref_3_c_612_n N_noxref_14_c_2669_n ) capacitor c=0.00603529f \
 //x=5.14 //y=2.77 //x2=5.24 //y2=1.77
cc_742 ( N_noxref_3_c_617_n N_noxref_14_c_2669_n ) capacitor c=0.0117784f \
 //x=4.875 //y=2.26 //x2=5.24 //y2=1.77
cc_743 ( N_noxref_3_c_622_n N_noxref_14_c_2669_n ) capacitor c=0.00703864f \
 //x=4.575 //y=1.71 //x2=5.24 //y2=1.77
cc_744 ( N_noxref_3_c_623_n N_noxref_14_c_2669_n ) capacitor c=0.0215834f \
 //x=4.575 //y=2.095 //x2=5.24 //y2=1.77
cc_745 ( N_noxref_3_c_625_n N_noxref_14_c_2669_n ) capacitor c=0.00708583f \
 //x=4.95 //y=1.555 //x2=5.24 //y2=1.77
cc_746 ( N_noxref_3_c_628_n N_noxref_14_c_2669_n ) capacitor c=0.00698822f \
 //x=5.105 //y=1.4 //x2=5.24 //y2=1.77
cc_747 ( N_noxref_3_c_608_n N_noxref_14_c_2696_n ) capacitor c=0.0135684f \
 //x=9.57 //y=2.77 //x2=6.21 //y2=1.77
cc_748 ( N_noxref_3_c_608_n N_noxref_14_M2_noxref_s ) capacitor c=0.00867201f \
 //x=9.57 //y=2.77 //x2=4.22 //y2=0.555
cc_749 ( N_noxref_3_c_619_n N_noxref_14_M2_noxref_s ) capacitor c=0.0327271f \
 //x=4.575 //y=1.055 //x2=4.22 //y2=0.555
cc_750 ( N_noxref_3_c_622_n N_noxref_14_M2_noxref_s ) capacitor c=7.99997e-19 \
 //x=4.575 //y=1.71 //x2=4.22 //y2=0.555
cc_751 ( N_noxref_3_c_623_n N_noxref_14_M2_noxref_s ) capacitor c=0.00122123f \
 //x=4.575 //y=2.095 //x2=4.22 //y2=0.555
cc_752 ( N_noxref_3_c_626_n N_noxref_14_M2_noxref_s ) capacitor c=0.0121427f \
 //x=5.105 //y=1.055 //x2=4.22 //y2=0.555
cc_753 ( N_noxref_3_M1_noxref_d N_noxref_14_M2_noxref_s ) capacitor \
 c=2.53688e-19 //x=2.395 //y=1.085 //x2=4.22 //y2=0.555
cc_754 ( N_noxref_3_c_608_n N_noxref_15_c_2722_n ) capacitor c=0.00494691f \
 //x=9.57 //y=2.77 //x2=6.78 //y2=1.175
cc_755 ( N_noxref_3_c_608_n N_noxref_15_c_2727_n ) capacitor c=8.29806e-19 \
 //x=9.57 //y=2.77 //x2=7.75 //y2=0.72
cc_756 ( N_noxref_3_c_608_n N_noxref_15_M4_noxref_s ) capacitor c=0.00448771f \
 //x=9.57 //y=2.77 //x2=6.73 //y2=0.555
cc_757 ( N_noxref_3_c_608_n N_noxref_16_c_2791_n ) capacitor c=0.00448771f \
 //x=9.57 //y=2.77 //x2=9.165 //y2=1.685
cc_758 ( N_noxref_3_c_633_n N_noxref_16_c_2791_n ) capacitor c=0.0034165f \
 //x=9.385 //y=2.095 //x2=9.165 //y2=1.685
cc_759 ( N_noxref_3_c_608_n N_noxref_16_c_2775_n ) capacitor c=0.0116291f \
 //x=9.57 //y=2.77 //x2=10.05 //y2=1.77
cc_760 ( N_noxref_3_c_618_n N_noxref_16_c_2775_n ) capacitor c=0.0122435f \
 //x=9.685 //y=2.26 //x2=10.05 //y2=1.77
cc_761 ( N_noxref_3_c_632_n N_noxref_16_c_2775_n ) capacitor c=0.00703864f \
 //x=9.385 //y=1.71 //x2=10.05 //y2=1.77
cc_762 ( N_noxref_3_c_633_n N_noxref_16_c_2775_n ) capacitor c=0.0215834f \
 //x=9.385 //y=2.095 //x2=10.05 //y2=1.77
cc_763 ( N_noxref_3_c_635_n N_noxref_16_c_2775_n ) capacitor c=0.00708583f \
 //x=9.76 //y=1.555 //x2=10.05 //y2=1.77
cc_764 ( N_noxref_3_c_638_n N_noxref_16_c_2775_n ) capacitor c=0.00698822f \
 //x=9.915 //y=1.4 //x2=10.05 //y2=1.77
cc_765 ( N_noxref_3_c_629_n N_noxref_16_M5_noxref_s ) capacitor c=0.0327271f \
 //x=9.385 //y=1.055 //x2=9.03 //y2=0.555
cc_766 ( N_noxref_3_c_632_n N_noxref_16_M5_noxref_s ) capacitor c=7.99997e-19 \
 //x=9.385 //y=1.71 //x2=9.03 //y2=0.555
cc_767 ( N_noxref_3_c_633_n N_noxref_16_M5_noxref_s ) capacitor c=0.00122123f \
 //x=9.385 //y=2.095 //x2=9.03 //y2=0.555
cc_768 ( N_noxref_3_c_636_n N_noxref_16_M5_noxref_s ) capacitor c=0.0121427f \
 //x=9.915 //y=1.055 //x2=9.03 //y2=0.555
cc_769 ( N_noxref_4_c_873_n N_CLK_c_1027_n ) capacitor c=0.0317044f //x=10.9 \
 //y=5.335 //x2=15.12 //y2=4.62
cc_770 ( N_noxref_4_c_877_n N_CLK_c_1027_n ) capacitor c=0.0230136f //x=10.19 \
 //y=5.335 //x2=15.12 //y2=4.62
cc_771 ( N_noxref_4_c_883_n N_CLK_c_1027_n ) capacitor c=0.0183122f //x=12.56 \
 //y=5.335 //x2=15.12 //y2=4.62
cc_772 ( N_noxref_4_c_860_n N_CLK_c_1027_n ) capacitor c=0.0210274f //x=12.645 \
 //y=2.77 //x2=15.12 //y2=4.62
cc_773 ( N_noxref_4_c_861_n N_CLK_c_1027_n ) capacitor c=0.0215143f //x=14.495 \
 //y=2.26 //x2=15.12 //y2=4.62
cc_774 ( N_noxref_4_c_895_n N_CLK_c_1027_n ) capacitor c=0.0109975f //x=14.495 \
 //y=4.88 //x2=15.12 //y2=4.62
cc_775 ( N_noxref_4_c_857_n CLK ) capacitor c=0.0062641f //x=14.38 //y=2.77 \
 //x2=15.29 //y2=2.77
cc_776 ( N_noxref_4_c_861_n CLK ) capacitor c=4.03999e-19 //x=14.495 //y=2.26 \
 //x2=15.29 //y2=2.77
cc_777 ( N_noxref_4_c_861_n CLK ) capacitor c=0.00440428f //x=14.495 //y=2.26 \
 //x2=15.29 //y2=4.62
cc_778 ( N_noxref_4_c_895_n CLK ) capacitor c=0.00415961f //x=14.495 //y=4.88 \
 //x2=15.29 //y2=4.62
cc_779 ( N_noxref_4_c_857_n N_CLK_c_1025_n ) capacitor c=6.52137e-19 //x=14.38 \
 //y=2.77 //x2=15.235 //y2=2.26
cc_780 ( N_noxref_4_c_861_n N_CLK_c_1025_n ) capacitor c=0.0755884f //x=14.495 \
 //y=2.26 //x2=15.235 //y2=2.26
cc_781 ( N_noxref_4_c_866_n N_CLK_c_1025_n ) capacitor c=0.00284029f //x=14.3 \
 //y=2.095 //x2=15.235 //y2=2.26
cc_782 ( N_noxref_4_c_857_n N_CLK_c_1095_n ) capacitor c=6.52137e-19 //x=14.38 \
 //y=2.77 //x2=15.262 //y2=3.055
cc_783 ( N_noxref_4_c_860_n N_CLK_c_1095_n ) capacitor c=8.88043e-19 \
 //x=12.645 //y=2.77 //x2=15.262 //y2=3.055
cc_784 ( N_noxref_4_M31_noxref_g N_CLK_M33_noxref_g ) capacitor c=0.0104611f \
 //x=14.395 //y=6.2 //x2=15.275 //y2=6.2
cc_785 ( N_noxref_4_M32_noxref_g N_CLK_M33_noxref_g ) capacitor c=0.106811f \
 //x=14.835 //y=6.2 //x2=15.275 //y2=6.2
cc_786 ( N_noxref_4_M32_noxref_g N_CLK_M34_noxref_g ) capacitor c=0.0100341f \
 //x=14.835 //y=6.2 //x2=15.715 //y2=6.2
cc_787 ( N_noxref_4_c_862_n N_CLK_c_1100_n ) capacitor c=4.86506e-19 //x=14.3 \
 //y=1.045 //x2=15.27 //y2=1.085
cc_788 ( N_noxref_4_c_864_n N_CLK_c_1100_n ) capacitor c=0.00152104f //x=14.3 \
 //y=1.39 //x2=15.27 //y2=1.085
cc_789 ( N_noxref_4_c_869_n N_CLK_c_1100_n ) capacitor c=0.0151475f //x=14.83 \
 //y=1.045 //x2=15.27 //y2=1.085
cc_790 ( N_noxref_4_c_865_n N_CLK_c_1103_n ) capacitor c=0.00109982f //x=14.3 \
 //y=1.7 //x2=15.27 //y2=1.43
cc_791 ( N_noxref_4_c_871_n N_CLK_c_1103_n ) capacitor c=0.0111064f //x=14.83 \
 //y=1.39 //x2=15.27 //y2=1.43
cc_792 ( N_noxref_4_c_865_n N_CLK_c_1105_n ) capacitor c=9.57794e-19 //x=14.3 \
 //y=1.7 //x2=15.27 //y2=1.74
cc_793 ( N_noxref_4_c_866_n N_CLK_c_1105_n ) capacitor c=0.00662747f //x=14.3 \
 //y=2.095 //x2=15.27 //y2=1.74
cc_794 ( N_noxref_4_c_871_n N_CLK_c_1105_n ) capacitor c=0.00862358f //x=14.83 \
 //y=1.39 //x2=15.27 //y2=1.74
cc_795 ( N_noxref_4_c_869_n N_CLK_c_1108_n ) capacitor c=0.00124821f //x=14.83 \
 //y=1.045 //x2=15.8 //y2=1.085
cc_796 ( N_noxref_4_c_871_n N_CLK_c_1109_n ) capacitor c=0.00200715f //x=14.83 \
 //y=1.39 //x2=15.8 //y2=1.43
cc_797 ( N_noxref_4_c_861_n N_CLK_c_1110_n ) capacitor c=0.00282278f \
 //x=14.495 //y=2.26 //x2=15.235 //y2=2.26
cc_798 ( N_noxref_4_c_866_n N_CLK_c_1110_n ) capacitor c=0.0172771f //x=14.3 \
 //y=2.095 //x2=15.235 //y2=2.26
cc_799 ( N_noxref_4_c_861_n N_CLK_c_1112_n ) capacitor c=0.00342116f \
 //x=14.495 //y=2.26 //x2=15.265 //y2=4.88
cc_800 ( N_noxref_4_c_895_n N_CLK_c_1112_n ) capacitor c=0.0292158f //x=14.495 \
 //y=4.88 //x2=15.265 //y2=4.88
cc_801 ( N_noxref_4_c_857_n N_noxref_6_c_1276_n ) capacitor c=0.00628974f \
 //x=14.38 //y=2.77 //x2=17.71 //y2=4.25
cc_802 ( N_noxref_4_c_858_n N_noxref_6_c_1276_n ) capacitor c=5.0661e-19 \
 //x=12.76 //y=2.77 //x2=17.71 //y2=4.25
cc_803 ( N_noxref_4_c_860_n N_noxref_6_c_1276_n ) capacitor c=0.0181982f \
 //x=12.645 //y=2.77 //x2=17.71 //y2=4.25
cc_804 ( N_noxref_4_c_861_n N_noxref_6_c_1276_n ) capacitor c=0.0184765f \
 //x=14.495 //y=2.26 //x2=17.71 //y2=4.25
cc_805 ( N_noxref_4_c_877_n N_noxref_6_c_1298_n ) capacitor c=3.10026e-19 \
 //x=10.19 //y=5.335 //x2=7.75 //y2=5.335
cc_806 ( N_noxref_4_c_857_n N_SN_c_1812_n ) capacitor c=0.172308f //x=14.38 \
 //y=2.77 //x2=22.15 //y2=2.4
cc_807 ( N_noxref_4_c_858_n N_SN_c_1812_n ) capacitor c=0.0291301f //x=12.76 \
 //y=2.77 //x2=22.15 //y2=2.4
cc_808 ( N_noxref_4_c_955_p N_SN_c_1812_n ) capacitor c=0.016327f //x=12.245 \
 //y=1.845 //x2=22.15 //y2=2.4
cc_809 ( N_noxref_4_c_860_n N_SN_c_1812_n ) capacitor c=0.0215653f //x=12.645 \
 //y=2.77 //x2=22.15 //y2=2.4
cc_810 ( N_noxref_4_c_861_n N_SN_c_1812_n ) capacitor c=0.0203358f //x=14.495 \
 //y=2.26 //x2=22.15 //y2=2.4
cc_811 ( N_noxref_4_c_866_n N_SN_c_1812_n ) capacitor c=0.00894156f //x=14.3 \
 //y=2.095 //x2=22.15 //y2=2.4
cc_812 ( N_noxref_4_c_873_n SN ) capacitor c=2.20396e-19 //x=10.9 //y=5.335 \
 //x2=10.85 //y2=3.14
cc_813 ( N_noxref_4_c_873_n SN ) capacitor c=5.74965e-19 //x=10.9 //y=5.335 \
 //x2=10.85 //y2=3.51
cc_814 ( N_noxref_4_c_873_n N_SN_c_1826_n ) capacitor c=0.0144268f //x=10.9 \
 //y=5.335 //x2=10.795 //y2=4.88
cc_815 ( N_noxref_4_c_860_n N_SN_c_1826_n ) capacitor c=0.00122431f //x=12.645 \
 //y=2.77 //x2=10.795 //y2=4.88
cc_816 ( N_noxref_4_c_860_n N_SN_c_1823_n ) capacitor c=2.12864e-19 //x=12.645 \
 //y=2.77 //x2=10.822 //y2=2.685
cc_817 ( N_noxref_4_c_873_n N_SN_M27_noxref_g ) capacitor c=0.0165266f \
 //x=10.9 //y=5.335 //x2=10.765 //y2=6.2
cc_818 ( N_noxref_4_M27_noxref_d N_SN_M27_noxref_g ) capacitor c=0.0180032f \
 //x=10.84 //y=5.2 //x2=10.765 //y2=6.2
cc_819 ( N_noxref_4_c_879_n N_SN_M28_noxref_g ) capacitor c=0.01736f //x=11.78 \
 //y=5.335 //x2=11.205 //y2=6.2
cc_820 ( N_noxref_4_M27_noxref_d N_SN_M28_noxref_g ) capacitor c=0.0180032f \
 //x=10.84 //y=5.2 //x2=11.205 //y2=6.2
cc_821 ( N_noxref_4_c_968_p N_SN_c_1877_n ) capacitor c=0.00423398f //x=10.985 \
 //y=5.335 //x2=11.13 //y2=4.97
cc_822 ( N_noxref_4_c_873_n N_SN_c_1859_n ) capacitor c=0.00322054f //x=10.9 \
 //y=5.335 //x2=10.795 //y2=4.88
cc_823 ( N_noxref_4_c_857_n N_noxref_10_c_2081_n ) capacitor c=0.0565623f \
 //x=14.38 //y=2.77 //x2=15.86 //y2=3.88
cc_824 ( N_noxref_4_c_858_n N_noxref_10_c_2081_n ) capacitor c=0.00783891f \
 //x=12.76 //y=2.77 //x2=15.86 //y2=3.88
cc_825 ( N_noxref_4_c_860_n N_noxref_10_c_2081_n ) capacitor c=0.0227211f \
 //x=12.645 //y=2.77 //x2=15.86 //y2=3.88
cc_826 ( N_noxref_4_c_861_n N_noxref_10_c_2081_n ) capacitor c=0.0226973f \
 //x=14.495 //y=2.26 //x2=15.86 //y2=3.88
cc_827 ( N_noxref_4_c_860_n N_noxref_10_c_2145_n ) capacitor c=0.00117715f \
 //x=12.645 //y=2.77 //x2=12.02 //y2=3.88
cc_828 ( N_noxref_4_c_858_n N_noxref_10_c_2084_n ) capacitor c=0.00456439f \
 //x=12.76 //y=2.77 //x2=11.905 //y2=2.26
cc_829 ( N_noxref_4_c_860_n N_noxref_10_c_2084_n ) capacitor c=0.081931f \
 //x=12.645 //y=2.77 //x2=11.905 //y2=2.26
cc_830 ( N_noxref_4_c_861_n N_noxref_10_c_2084_n ) capacitor c=7.74334e-19 \
 //x=14.495 //y=2.26 //x2=11.905 //y2=2.26
cc_831 ( N_noxref_4_c_978_p N_noxref_10_c_2084_n ) capacitor c=0.016476f \
 //x=11.865 //y=5.335 //x2=11.905 //y2=2.26
cc_832 ( N_noxref_4_M32_noxref_g N_noxref_10_c_2097_n ) capacitor c=0.0169521f \
 //x=14.835 //y=6.2 //x2=15.41 //y2=5.38
cc_833 ( N_noxref_4_c_861_n N_noxref_10_c_2101_n ) capacitor c=0.00539951f \
 //x=14.495 //y=2.26 //x2=14.7 //y2=5.38
cc_834 ( N_noxref_4_M31_noxref_g N_noxref_10_c_2101_n ) capacitor c=0.0177326f \
 //x=14.395 //y=6.2 //x2=14.7 //y2=5.38
cc_835 ( N_noxref_4_c_895_n N_noxref_10_c_2101_n ) capacitor c=0.00581252f \
 //x=14.495 //y=4.88 //x2=14.7 //y2=5.38
cc_836 ( N_noxref_4_c_860_n N_noxref_10_c_2086_n ) capacitor c=3.52729e-19 \
 //x=12.645 //y=2.77 //x2=15.975 //y2=3.88
cc_837 ( N_noxref_4_c_861_n N_noxref_10_c_2086_n ) capacitor c=0.00341601f \
 //x=14.495 //y=2.26 //x2=15.975 //y2=3.88
cc_838 ( N_noxref_4_c_879_n N_noxref_10_M29_noxref_g ) capacitor c=0.01736f \
 //x=11.78 //y=5.335 //x2=11.645 //y2=6.2
cc_839 ( N_noxref_4_M29_noxref_d N_noxref_10_M29_noxref_g ) capacitor \
 c=0.0180032f //x=11.72 //y=5.2 //x2=11.645 //y2=6.2
cc_840 ( N_noxref_4_c_883_n N_noxref_10_M30_noxref_g ) capacitor c=0.0194981f \
 //x=12.56 //y=5.335 //x2=12.085 //y2=6.2
cc_841 ( N_noxref_4_M29_noxref_d N_noxref_10_M30_noxref_g ) capacitor \
 c=0.0194246f //x=11.72 //y=5.2 //x2=12.085 //y2=6.2
cc_842 ( N_noxref_4_M7_noxref_d N_noxref_10_c_2160_n ) capacitor c=0.00217566f \
 //x=11.97 //y=1.095 //x2=11.895 //y2=1.095
cc_843 ( N_noxref_4_M7_noxref_d N_noxref_10_c_2161_n ) capacitor c=0.0034598f \
 //x=11.97 //y=1.095 //x2=11.895 //y2=1.44
cc_844 ( N_noxref_4_M7_noxref_d N_noxref_10_c_2162_n ) capacitor c=0.00546784f \
 //x=11.97 //y=1.095 //x2=11.895 //y2=1.75
cc_845 ( N_noxref_4_M7_noxref_d N_noxref_10_c_2163_n ) capacitor c=0.00241102f \
 //x=11.97 //y=1.095 //x2=12.27 //y2=0.94
cc_846 ( N_noxref_4_c_859_n N_noxref_10_c_2164_n ) capacitor c=0.00371277f \
 //x=12.56 //y=1.845 //x2=12.27 //y2=1.595
cc_847 ( N_noxref_4_M7_noxref_d N_noxref_10_c_2164_n ) capacitor c=0.0138621f \
 //x=11.97 //y=1.095 //x2=12.27 //y2=1.595
cc_848 ( N_noxref_4_M7_noxref_d N_noxref_10_c_2166_n ) capacitor c=0.00219619f \
 //x=11.97 //y=1.095 //x2=12.425 //y2=1.095
cc_849 ( N_noxref_4_c_859_n N_noxref_10_c_2167_n ) capacitor c=0.00457401f \
 //x=12.56 //y=1.845 //x2=12.425 //y2=1.44
cc_850 ( N_noxref_4_M7_noxref_d N_noxref_10_c_2167_n ) capacitor c=0.00603828f \
 //x=11.97 //y=1.095 //x2=12.425 //y2=1.44
cc_851 ( N_noxref_4_c_860_n N_noxref_10_c_2169_n ) capacitor c=0.00709342f \
 //x=12.645 //y=2.77 //x2=11.905 //y2=2.26
cc_852 ( N_noxref_4_c_860_n N_noxref_10_c_2170_n ) capacitor c=0.00283672f \
 //x=12.645 //y=2.77 //x2=11.905 //y2=2.095
cc_853 ( N_noxref_4_M7_noxref_d N_noxref_10_c_2170_n ) capacitor c=0.00661782f \
 //x=11.97 //y=1.095 //x2=11.905 //y2=2.095
cc_854 ( N_noxref_4_c_883_n N_noxref_10_c_2172_n ) capacitor c=0.00201851f \
 //x=12.56 //y=5.335 //x2=11.905 //y2=4.88
cc_855 ( N_noxref_4_c_860_n N_noxref_10_c_2172_n ) capacitor c=0.013693f \
 //x=12.645 //y=2.77 //x2=11.905 //y2=4.88
cc_856 ( N_noxref_4_c_978_p N_noxref_10_c_2172_n ) capacitor c=0.00475601f \
 //x=11.865 //y=5.335 //x2=11.905 //y2=4.88
cc_857 ( N_noxref_4_M32_noxref_g N_noxref_10_M31_noxref_d ) capacitor \
 c=0.0173476f //x=14.835 //y=6.2 //x2=14.47 //y2=5.2
cc_858 ( N_noxref_4_M7_noxref_d N_noxref_16_M5_noxref_s ) capacitor \
 c=0.00309936f //x=11.97 //y=1.095 //x2=9.03 //y2=0.555
cc_859 ( N_noxref_4_c_859_n N_noxref_17_c_2834_n ) capacitor c=0.00457167f \
 //x=12.56 //y=1.845 //x2=12.56 //y2=0.72
cc_860 ( N_noxref_4_M7_noxref_d N_noxref_17_c_2834_n ) capacitor c=0.0115903f \
 //x=11.97 //y=1.095 //x2=12.56 //y2=0.72
cc_861 ( N_noxref_4_c_955_p N_noxref_17_c_2845_n ) capacitor c=0.020048f \
 //x=12.245 //y=1.845 //x2=11.675 //y2=1.175
cc_862 ( N_noxref_4_M7_noxref_d N_noxref_17_M6_noxref_d ) capacitor \
 c=5.27807e-19 //x=11.97 //y=1.095 //x2=10.435 //y2=1.09
cc_863 ( N_noxref_4_c_859_n N_noxref_17_M7_noxref_s ) capacitor c=0.0184051f \
 //x=12.56 //y=1.845 //x2=11.54 //y2=0.555
cc_864 ( N_noxref_4_M7_noxref_d N_noxref_17_M7_noxref_s ) capacitor \
 c=0.0426444f //x=11.97 //y=1.095 //x2=11.54 //y2=0.555
cc_865 ( N_noxref_4_c_859_n N_noxref_18_c_2901_n ) capacitor c=3.04182e-19 \
 //x=12.56 //y=1.845 //x2=14.08 //y2=1.675
cc_866 ( N_noxref_4_c_866_n N_noxref_18_c_2901_n ) capacitor c=0.0034165f \
 //x=14.3 //y=2.095 //x2=14.08 //y2=1.675
cc_867 ( N_noxref_4_c_861_n N_noxref_18_c_2882_n ) capacitor c=0.011618f \
 //x=14.495 //y=2.26 //x2=14.965 //y2=1.76
cc_868 ( N_noxref_4_c_865_n N_noxref_18_c_2882_n ) capacitor c=0.00696403f \
 //x=14.3 //y=1.7 //x2=14.965 //y2=1.76
cc_869 ( N_noxref_4_c_866_n N_noxref_18_c_2882_n ) capacitor c=0.0174694f \
 //x=14.3 //y=2.095 //x2=14.965 //y2=1.76
cc_870 ( N_noxref_4_c_868_n N_noxref_18_c_2882_n ) capacitor c=0.00776811f \
 //x=14.675 //y=1.545 //x2=14.965 //y2=1.76
cc_871 ( N_noxref_4_c_871_n N_noxref_18_c_2882_n ) capacitor c=0.00339872f \
 //x=14.83 //y=1.39 //x2=14.965 //y2=1.76
cc_872 ( N_noxref_4_c_866_n N_noxref_18_c_2889_n ) capacitor c=6.71402e-19 \
 //x=14.3 //y=2.095 //x2=15.05 //y2=1.675
cc_873 ( N_noxref_4_c_862_n N_noxref_18_M8_noxref_s ) capacitor c=0.0327502f \
 //x=14.3 //y=1.045 //x2=13.945 //y2=0.545
cc_874 ( N_noxref_4_c_865_n N_noxref_18_M8_noxref_s ) capacitor c=3.48408e-19 \
 //x=14.3 //y=1.7 //x2=13.945 //y2=0.545
cc_875 ( N_noxref_4_c_869_n N_noxref_18_M8_noxref_s ) capacitor c=0.0120759f \
 //x=14.83 //y=1.045 //x2=13.945 //y2=0.545
cc_876 ( N_CLK_c_1027_n N_noxref_6_c_1250_n ) capacitor c=0.139498f //x=15.12 \
 //y=4.62 //x2=7.715 //y2=4.25
cc_877 ( N_CLK_c_1038_n N_noxref_6_c_1250_n ) capacitor c=0.02921f //x=6.1 \
 //y=4.62 //x2=7.715 //y2=4.25
cc_878 ( CLK N_noxref_6_c_1250_n ) capacitor c=0.00120057f //x=6.04 //y=3.88 \
 //x2=7.715 //y2=4.25
cc_879 ( CLK N_noxref_6_c_1250_n ) capacitor c=0.00233143f //x=6.04 //y=4.62 \
 //x2=7.715 //y2=4.25
cc_880 ( N_CLK_c_1042_n N_noxref_6_c_1250_n ) capacitor c=0.0236246f //x=6.012 \
 //y=4.535 //x2=7.715 //y2=4.25
cc_881 ( N_CLK_c_1027_n N_noxref_6_c_1276_n ) capacitor c=0.654106f //x=15.12 \
 //y=4.62 //x2=17.71 //y2=4.25
cc_882 ( CLK N_noxref_6_c_1276_n ) capacitor c=0.00237739f //x=15.29 //y=4.62 \
 //x2=17.71 //y2=4.25
cc_883 ( N_CLK_c_1040_n N_noxref_6_c_1276_n ) capacitor c=0.0166993f \
 //x=15.235 //y=4.535 //x2=17.71 //y2=4.25
cc_884 ( N_CLK_c_1122_p N_noxref_6_c_1276_n ) capacitor c=0.00756255f \
 //x=15.64 //y=4.97 //x2=17.71 //y2=4.25
cc_885 ( N_CLK_c_1112_n N_noxref_6_c_1276_n ) capacitor c=5.77313e-19 \
 //x=15.265 //y=4.88 //x2=17.71 //y2=4.25
cc_886 ( N_CLK_c_1027_n N_noxref_6_c_1285_n ) capacitor c=0.0265302f //x=15.12 \
 //y=4.62 //x2=7.945 //y2=4.25
cc_887 ( N_CLK_c_1038_n N_noxref_6_c_1288_n ) capacitor c=0.00283946f //x=6.1 \
 //y=4.62 //x2=6.09 //y2=5.335
cc_888 ( CLK N_noxref_6_c_1288_n ) capacitor c=0.00132827f //x=6.04 //y=4.62 \
 //x2=6.09 //y2=5.335
cc_889 ( N_CLK_c_1039_n N_noxref_6_c_1288_n ) capacitor c=0.014564f //x=5.985 \
 //y=4.88 //x2=6.09 //y2=5.335
cc_890 ( N_CLK_M21_noxref_g N_noxref_6_c_1288_n ) capacitor c=0.016514f \
 //x=5.955 //y=6.2 //x2=6.09 //y2=5.335
cc_891 ( N_CLK_c_1079_n N_noxref_6_c_1288_n ) capacitor c=0.00322046f \
 //x=5.985 //y=4.88 //x2=6.09 //y2=5.335
cc_892 ( N_CLK_M22_noxref_g N_noxref_6_c_1294_n ) capacitor c=0.01736f \
 //x=6.395 //y=6.2 //x2=6.97 //y2=5.335
cc_893 ( N_CLK_c_1027_n N_noxref_6_c_1298_n ) capacitor c=0.0182691f //x=15.12 \
 //y=4.62 //x2=7.75 //y2=5.335
cc_894 ( N_CLK_c_1027_n N_noxref_6_c_1401_n ) capacitor c=0.0207896f //x=15.12 \
 //y=4.62 //x2=7.835 //y2=5.25
cc_895 ( CLK N_noxref_6_c_1256_n ) capacitor c=3.6266e-19 //x=15.29 //y=3.51 \
 //x2=17.825 //y2=2.26
cc_896 ( N_CLK_c_1040_n N_noxref_6_c_1256_n ) capacitor c=4.39124e-19 \
 //x=15.235 //y=4.535 //x2=17.825 //y2=2.26
cc_897 ( N_CLK_c_1027_n N_noxref_6_c_1404_n ) capacitor c=0.03056f //x=15.12 \
 //y=4.62 //x2=6.175 //y2=5.335
cc_898 ( N_CLK_c_1136_p N_noxref_6_c_1404_n ) capacitor c=0.00419184f //x=6.32 \
 //y=4.97 //x2=6.175 //y2=5.335
cc_899 ( N_CLK_c_1027_n N_noxref_6_c_1305_n ) capacitor c=0.00215288f \
 //x=15.12 //y=4.62 //x2=7.83 //y2=4.25
cc_900 ( N_CLK_c_1024_n N_noxref_6_c_1355_n ) capacitor c=0.00106028f \
 //x=5.985 //y=2.26 //x2=7.832 //y2=4.085
cc_901 ( N_CLK_c_1139_p N_noxref_6_c_1355_n ) capacitor c=2.32128e-19 \
 //x=6.012 //y=3.795 //x2=7.832 //y2=4.085
cc_902 ( N_CLK_M21_noxref_g N_noxref_6_M21_noxref_d ) capacitor c=0.0180032f \
 //x=5.955 //y=6.2 //x2=6.03 //y2=5.2
cc_903 ( N_CLK_M22_noxref_g N_noxref_6_M21_noxref_d ) capacitor c=0.0180032f \
 //x=6.395 //y=6.2 //x2=6.03 //y2=5.2
cc_904 ( CLK N_SN_c_1812_n ) capacitor c=0.00171913f //x=15.29 //y=2.77 \
 //x2=22.15 //y2=2.4
cc_905 ( N_CLK_c_1025_n N_SN_c_1812_n ) capacitor c=0.0226984f //x=15.235 \
 //y=2.26 //x2=22.15 //y2=2.4
cc_906 ( N_CLK_c_1144_p N_SN_c_1812_n ) capacitor c=3.11115e-19 //x=15.645 \
 //y=1.585 //x2=22.15 //y2=2.4
cc_907 ( N_CLK_c_1110_n N_SN_c_1812_n ) capacitor c=0.0056795f //x=15.235 \
 //y=2.26 //x2=22.15 //y2=2.4
cc_908 ( N_CLK_c_1027_n N_SN_c_1826_n ) capacitor c=0.0210462f //x=15.12 \
 //y=4.62 //x2=10.795 //y2=4.88
cc_909 ( N_CLK_c_1027_n N_SN_c_1877_n ) capacitor c=0.0085986f //x=15.12 \
 //y=4.62 //x2=11.13 //y2=4.97
cc_910 ( N_CLK_c_1027_n N_SN_c_1859_n ) capacitor c=0.00293313f //x=15.12 \
 //y=4.62 //x2=10.795 //y2=4.88
cc_911 ( N_CLK_c_1027_n N_noxref_10_c_2079_n ) capacitor c=0.0344996f \
 //x=15.12 //y=4.62 //x2=11.79 //y2=3.88
cc_912 ( N_CLK_c_1027_n N_noxref_10_c_2135_n ) capacitor c=7.0371e-19 \
 //x=15.12 //y=4.62 //x2=7.21 //y2=3.88
cc_913 ( CLK N_noxref_10_c_2135_n ) capacitor c=0.00446435f //x=6.04 //y=3.88 \
 //x2=7.21 //y2=3.88
cc_914 ( N_CLK_c_1139_p N_noxref_10_c_2135_n ) capacitor c=6.33859e-19 \
 //x=6.012 //y=3.795 //x2=7.21 //y2=3.88
cc_915 ( N_CLK_c_1042_n N_noxref_10_c_2135_n ) capacitor c=6.33859e-19 \
 //x=6.012 //y=4.535 //x2=7.21 //y2=3.88
cc_916 ( N_CLK_c_1027_n N_noxref_10_c_2081_n ) capacitor c=0.0215799f \
 //x=15.12 //y=4.62 //x2=15.86 //y2=3.88
cc_917 ( CLK N_noxref_10_c_2081_n ) capacitor c=0.00139768f //x=15.29 //y=3.51 \
 //x2=15.86 //y2=3.88
cc_918 ( N_CLK_c_1040_n N_noxref_10_c_2081_n ) capacitor c=0.0218063f \
 //x=15.235 //y=4.535 //x2=15.86 //y2=3.88
cc_919 ( N_CLK_c_1027_n N_noxref_10_c_2145_n ) capacitor c=4.78625e-19 \
 //x=15.12 //y=4.62 //x2=12.02 //y2=3.88
cc_920 ( N_CLK_c_1040_n N_noxref_10_c_2185_n ) capacitor c=0.00117715f \
 //x=15.235 //y=4.535 //x2=16.09 //y2=3.88
cc_921 ( N_CLK_c_1027_n N_noxref_10_c_2083_n ) capacitor c=0.0198958f \
 //x=15.12 //y=4.62 //x2=7.095 //y2=2.26
cc_922 ( N_CLK_c_1038_n N_noxref_10_c_2083_n ) capacitor c=0.00153281f //x=6.1 \
 //y=4.62 //x2=7.095 //y2=2.26
cc_923 ( CLK N_noxref_10_c_2083_n ) capacitor c=0.00493712f //x=6.04 //y=3.14 \
 //x2=7.095 //y2=2.26
cc_924 ( CLK N_noxref_10_c_2083_n ) capacitor c=0.00493712f //x=6.04 //y=3.51 \
 //x2=7.095 //y2=2.26
cc_925 ( CLK N_noxref_10_c_2083_n ) capacitor c=0.00329813f //x=6.04 //y=3.88 \
 //x2=7.095 //y2=2.26
cc_926 ( CLK N_noxref_10_c_2083_n ) capacitor c=0.00190929f //x=6.04 //y=4.62 \
 //x2=7.095 //y2=2.26
cc_927 ( N_CLK_c_1024_n N_noxref_10_c_2083_n ) capacitor c=0.0156234f \
 //x=5.985 //y=2.26 //x2=7.095 //y2=2.26
cc_928 ( N_CLK_c_1039_n N_noxref_10_c_2083_n ) capacitor c=0.00467264f \
 //x=5.985 //y=4.88 //x2=7.095 //y2=2.26
cc_929 ( N_CLK_c_1167_p N_noxref_10_c_2083_n ) capacitor c=0.0042159f \
 //x=6.012 //y=3.425 //x2=7.095 //y2=2.26
cc_930 ( N_CLK_c_1139_p N_noxref_10_c_2083_n ) capacitor c=0.00395201f \
 //x=6.012 //y=3.795 //x2=7.095 //y2=2.26
cc_931 ( N_CLK_c_1042_n N_noxref_10_c_2083_n ) capacitor c=0.00907305f \
 //x=6.012 //y=4.535 //x2=7.095 //y2=2.26
cc_932 ( N_CLK_c_1076_n N_noxref_10_c_2083_n ) capacitor c=0.0023343f \
 //x=6.075 //y=2.095 //x2=7.095 //y2=2.26
cc_933 ( N_CLK_c_1079_n N_noxref_10_c_2083_n ) capacitor c=0.00142741f \
 //x=5.985 //y=4.88 //x2=7.095 //y2=2.26
cc_934 ( N_CLK_c_1027_n N_noxref_10_c_2084_n ) capacitor c=0.0200057f \
 //x=15.12 //y=4.62 //x2=11.905 //y2=2.26
cc_935 ( N_CLK_c_1027_n N_noxref_10_c_2097_n ) capacitor c=0.00262658f \
 //x=15.12 //y=4.62 //x2=15.41 //y2=5.38
cc_936 ( CLK N_noxref_10_c_2097_n ) capacitor c=0.0135487f //x=15.29 //y=4.62 \
 //x2=15.41 //y2=5.38
cc_937 ( N_CLK_M33_noxref_g N_noxref_10_c_2097_n ) capacitor c=0.0166421f \
 //x=15.275 //y=6.2 //x2=15.41 //y2=5.38
cc_938 ( N_CLK_c_1112_n N_noxref_10_c_2097_n ) capacitor c=0.00346519f \
 //x=15.265 //y=4.88 //x2=15.41 //y2=5.38
cc_939 ( N_CLK_c_1027_n N_noxref_10_c_2101_n ) capacitor c=0.0172877f \
 //x=15.12 //y=4.62 //x2=14.7 //y2=5.38
cc_940 ( N_CLK_M34_noxref_g N_noxref_10_c_2103_n ) capacitor c=0.0199348f \
 //x=15.715 //y=6.2 //x2=15.89 //y2=5.38
cc_941 ( N_CLK_c_1144_p N_noxref_10_c_2085_n ) capacitor c=0.00371277f \
 //x=15.645 //y=1.585 //x2=15.89 //y2=1.835
cc_942 ( N_CLK_c_1109_n N_noxref_10_c_2085_n ) capacitor c=0.00457401f \
 //x=15.8 //y=1.43 //x2=15.89 //y2=1.835
cc_943 ( N_CLK_c_1027_n N_noxref_10_c_2086_n ) capacitor c=0.00557234f \
 //x=15.12 //y=4.62 //x2=15.975 //y2=3.88
cc_944 ( CLK N_noxref_10_c_2086_n ) capacitor c=0.00736744f //x=15.29 //y=2.77 \
 //x2=15.975 //y2=3.88
cc_945 ( CLK N_noxref_10_c_2086_n ) capacitor c=0.00777753f //x=15.29 //y=3.14 \
 //x2=15.975 //y2=3.88
cc_946 ( CLK N_noxref_10_c_2086_n ) capacitor c=0.00739658f //x=15.29 //y=3.51 \
 //x2=15.975 //y2=3.88
cc_947 ( CLK N_noxref_10_c_2086_n ) capacitor c=0.014613f //x=15.29 //y=4.62 \
 //x2=15.975 //y2=3.88
cc_948 ( N_CLK_c_1025_n N_noxref_10_c_2086_n ) capacitor c=0.0148804f \
 //x=15.235 //y=2.26 //x2=15.975 //y2=3.88
cc_949 ( N_CLK_c_1040_n N_noxref_10_c_2086_n ) capacitor c=0.0250326f \
 //x=15.235 //y=4.535 //x2=15.975 //y2=3.88
cc_950 ( N_CLK_c_1095_n N_noxref_10_c_2086_n ) capacitor c=0.00644393f \
 //x=15.262 //y=3.055 //x2=15.975 //y2=3.88
cc_951 ( N_CLK_c_1189_p N_noxref_10_c_2086_n ) capacitor c=0.00647061f \
 //x=15.262 //y=3.425 //x2=15.975 //y2=3.88
cc_952 ( N_CLK_c_1122_p N_noxref_10_c_2086_n ) capacitor c=0.0142673f \
 //x=15.64 //y=4.97 //x2=15.975 //y2=3.88
cc_953 ( N_CLK_c_1110_n N_noxref_10_c_2086_n ) capacitor c=0.00731987f \
 //x=15.235 //y=2.26 //x2=15.975 //y2=3.88
cc_954 ( N_CLK_c_1192_p N_noxref_10_c_2086_n ) capacitor c=0.00306024f \
 //x=15.235 //y=2.095 //x2=15.975 //y2=3.88
cc_955 ( N_CLK_c_1112_n N_noxref_10_c_2086_n ) capacitor c=0.00518024f \
 //x=15.265 //y=4.88 //x2=15.975 //y2=3.88
cc_956 ( N_CLK_c_1122_p N_noxref_10_c_2221_n ) capacitor c=0.00408717f \
 //x=15.64 //y=4.97 //x2=15.495 //y2=5.38
cc_957 ( N_CLK_M21_noxref_g N_noxref_10_M23_noxref_g ) capacitor c=0.0101598f \
 //x=5.955 //y=6.2 //x2=6.835 //y2=6.2
cc_958 ( N_CLK_M22_noxref_g N_noxref_10_M23_noxref_g ) capacitor c=0.0602553f \
 //x=6.395 //y=6.2 //x2=6.835 //y2=6.2
cc_959 ( N_CLK_M22_noxref_g N_noxref_10_M24_noxref_g ) capacitor c=0.0101598f \
 //x=6.395 //y=6.2 //x2=7.275 //y2=6.2
cc_960 ( N_CLK_c_1073_n N_noxref_10_c_2225_n ) capacitor c=0.00456962f \
 //x=6.075 //y=1.09 //x2=7.085 //y2=1.095
cc_961 ( N_CLK_c_1074_n N_noxref_10_c_2226_n ) capacitor c=0.00438372f \
 //x=6.075 //y=1.4 //x2=7.085 //y2=1.44
cc_962 ( N_CLK_c_1075_n N_noxref_10_c_2227_n ) capacitor c=0.00438372f \
 //x=6.075 //y=1.63 //x2=7.085 //y2=1.75
cc_963 ( N_CLK_c_1024_n N_noxref_10_c_2140_n ) capacitor c=0.00228632f \
 //x=5.985 //y=2.26 //x2=7.095 //y2=2.26
cc_964 ( N_CLK_c_1076_n N_noxref_10_c_2140_n ) capacitor c=0.00933826f \
 //x=6.075 //y=2.095 //x2=7.095 //y2=2.26
cc_965 ( N_CLK_c_1076_n N_noxref_10_c_2230_n ) capacitor c=0.00438372f \
 //x=6.075 //y=2.095 //x2=7.095 //y2=2.095
cc_966 ( N_CLK_c_1027_n N_noxref_10_c_2231_n ) capacitor c=0.0111881f \
 //x=15.12 //y=4.62 //x2=7.095 //y2=4.88
cc_967 ( N_CLK_c_1039_n N_noxref_10_c_2231_n ) capacitor c=0.00218014f \
 //x=5.985 //y=4.88 //x2=7.095 //y2=4.88
cc_968 ( N_CLK_c_1136_p N_noxref_10_c_2231_n ) capacitor c=0.0611812f //x=6.32 \
 //y=4.97 //x2=7.095 //y2=4.88
cc_969 ( N_CLK_c_1079_n N_noxref_10_c_2231_n ) capacitor c=0.00487508f \
 //x=5.985 //y=4.88 //x2=7.095 //y2=4.88
cc_970 ( N_CLK_c_1027_n N_noxref_10_c_2172_n ) capacitor c=0.0111881f \
 //x=15.12 //y=4.62 //x2=11.905 //y2=4.88
cc_971 ( N_CLK_c_1100_n N_noxref_10_M9_noxref_d ) capacitor c=0.00217566f \
 //x=15.27 //y=1.085 //x2=15.345 //y2=1.085
cc_972 ( N_CLK_c_1103_n N_noxref_10_M9_noxref_d ) capacitor c=0.0034598f \
 //x=15.27 //y=1.43 //x2=15.345 //y2=1.085
cc_973 ( N_CLK_c_1105_n N_noxref_10_M9_noxref_d ) capacitor c=0.0066953f \
 //x=15.27 //y=1.74 //x2=15.345 //y2=1.085
cc_974 ( N_CLK_c_1212_p N_noxref_10_M9_noxref_d ) capacitor c=0.00241102f \
 //x=15.645 //y=0.93 //x2=15.345 //y2=1.085
cc_975 ( N_CLK_c_1144_p N_noxref_10_M9_noxref_d ) capacitor c=0.0137169f \
 //x=15.645 //y=1.585 //x2=15.345 //y2=1.085
cc_976 ( N_CLK_c_1108_n N_noxref_10_M9_noxref_d ) capacitor c=0.00132245f \
 //x=15.8 //y=1.085 //x2=15.345 //y2=1.085
cc_977 ( N_CLK_c_1109_n N_noxref_10_M9_noxref_d ) capacitor c=0.00566463f \
 //x=15.8 //y=1.43 //x2=15.345 //y2=1.085
cc_978 ( N_CLK_c_1192_p N_noxref_10_M9_noxref_d ) capacitor c=0.00660593f \
 //x=15.235 //y=2.095 //x2=15.345 //y2=1.085
cc_979 ( N_CLK_M33_noxref_g N_noxref_10_M33_noxref_d ) capacitor c=0.0173476f \
 //x=15.275 //y=6.2 //x2=15.35 //y2=5.2
cc_980 ( N_CLK_M34_noxref_g N_noxref_10_M33_noxref_d ) capacitor c=0.0179769f \
 //x=15.715 //y=6.2 //x2=15.35 //y2=5.2
cc_981 ( N_CLK_c_1068_n N_noxref_14_c_2676_n ) capacitor c=0.0167228f //x=5.55 \
 //y=1.09 //x2=6.21 //y2=0.72
cc_982 ( N_CLK_c_1073_n N_noxref_14_c_2676_n ) capacitor c=0.00534519f \
 //x=6.075 //y=1.09 //x2=6.21 //y2=0.72
cc_983 ( CLK N_noxref_14_c_2696_n ) capacitor c=4.56979e-19 //x=6.04 //y=3.14 \
 //x2=6.21 //y2=1.77
cc_984 ( N_CLK_c_1024_n N_noxref_14_c_2696_n ) capacitor c=0.012334f //x=5.985 \
 //y=2.26 //x2=6.21 //y2=1.77
cc_985 ( N_CLK_c_1071_n N_noxref_14_c_2696_n ) capacitor c=0.0153476f //x=5.55 \
 //y=1.4 //x2=6.21 //y2=1.77
cc_986 ( N_CLK_c_1076_n N_noxref_14_c_2696_n ) capacitor c=0.0219813f \
 //x=6.075 //y=2.095 //x2=6.21 //y2=1.77
cc_987 ( N_CLK_c_1068_n N_noxref_14_M2_noxref_s ) capacitor c=0.00798959f \
 //x=5.55 //y=1.09 //x2=4.22 //y2=0.555
cc_988 ( N_CLK_c_1075_n N_noxref_14_M2_noxref_s ) capacitor c=0.00212176f \
 //x=6.075 //y=1.63 //x2=4.22 //y2=0.555
cc_989 ( N_CLK_c_1076_n N_noxref_14_M2_noxref_s ) capacitor c=0.00298115f \
 //x=6.075 //y=2.095 //x2=4.22 //y2=0.555
cc_990 ( N_CLK_c_1228_p N_noxref_15_c_2722_n ) capacitor c=2.14837e-19 \
 //x=5.92 //y=0.935 //x2=6.78 //y2=1.175
cc_991 ( N_CLK_c_1073_n N_noxref_15_c_2722_n ) capacitor c=0.00123426f \
 //x=6.075 //y=1.09 //x2=6.78 //y2=1.175
cc_992 ( N_CLK_c_1074_n N_noxref_15_c_2722_n ) capacitor c=0.0129288f \
 //x=6.075 //y=1.4 //x2=6.78 //y2=1.175
cc_993 ( N_CLK_c_1075_n N_noxref_15_c_2722_n ) capacitor c=0.00142359f \
 //x=6.075 //y=1.63 //x2=6.78 //y2=1.175
cc_994 ( N_CLK_c_1068_n N_noxref_15_M3_noxref_d ) capacitor c=0.00223875f \
 //x=5.55 //y=1.09 //x2=5.625 //y2=1.09
cc_995 ( N_CLK_c_1071_n N_noxref_15_M3_noxref_d ) capacitor c=0.00262485f \
 //x=5.55 //y=1.4 //x2=5.625 //y2=1.09
cc_996 ( N_CLK_c_1228_p N_noxref_15_M3_noxref_d ) capacitor c=0.00220746f \
 //x=5.92 //y=0.935 //x2=5.625 //y2=1.09
cc_997 ( N_CLK_c_1235_p N_noxref_15_M3_noxref_d ) capacitor c=0.00194798f \
 //x=5.92 //y=1.555 //x2=5.625 //y2=1.09
cc_998 ( N_CLK_c_1073_n N_noxref_15_M3_noxref_d ) capacitor c=0.00198465f \
 //x=6.075 //y=1.09 //x2=5.625 //y2=1.09
cc_999 ( N_CLK_c_1074_n N_noxref_15_M3_noxref_d ) capacitor c=0.00128384f \
 //x=6.075 //y=1.4 //x2=5.625 //y2=1.09
cc_1000 ( N_CLK_c_1073_n N_noxref_15_M4_noxref_s ) capacitor c=7.21316e-19 \
 //x=6.075 //y=1.09 //x2=6.73 //y2=0.555
cc_1001 ( N_CLK_c_1074_n N_noxref_15_M4_noxref_s ) capacitor c=0.00348171f \
 //x=6.075 //y=1.4 //x2=6.73 //y2=0.555
cc_1002 ( N_CLK_c_1105_n N_noxref_18_c_2889_n ) capacitor c=0.00623646f \
 //x=15.27 //y=1.74 //x2=15.05 //y2=1.675
cc_1003 ( N_CLK_c_1110_n N_noxref_18_c_2889_n ) capacitor c=0.00173579f \
 //x=15.235 //y=2.26 //x2=15.05 //y2=1.675
cc_1004 ( CLK N_noxref_18_c_2890_n ) capacitor c=4.23752e-19 //x=15.29 \
 //y=2.77 //x2=15.935 //y2=0.71
cc_1005 ( N_CLK_c_1025_n N_noxref_18_c_2890_n ) capacitor c=0.00156605f \
 //x=15.235 //y=2.26 //x2=15.935 //y2=0.71
cc_1006 ( N_CLK_c_1100_n N_noxref_18_c_2890_n ) capacitor c=0.0186004f \
 //x=15.27 //y=1.085 //x2=15.935 //y2=0.71
cc_1007 ( N_CLK_c_1108_n N_noxref_18_c_2890_n ) capacitor c=0.00656458f \
 //x=15.8 //y=1.085 //x2=15.935 //y2=0.71
cc_1008 ( N_CLK_c_1110_n N_noxref_18_c_2890_n ) capacitor c=2.1838e-19 \
 //x=15.235 //y=2.26 //x2=15.935 //y2=0.71
cc_1009 ( N_CLK_c_1100_n N_noxref_18_M8_noxref_s ) capacitor c=0.00623646f \
 //x=15.27 //y=1.085 //x2=13.945 //y2=0.545
cc_1010 ( N_CLK_c_1108_n N_noxref_18_M8_noxref_s ) capacitor c=0.0143002f \
 //x=15.8 //y=1.085 //x2=13.945 //y2=0.545
cc_1011 ( N_CLK_c_1109_n N_noxref_18_M8_noxref_s ) capacitor c=0.00290153f \
 //x=15.8 //y=1.43 //x2=13.945 //y2=0.545
cc_1012 ( N_noxref_6_c_1256_n N_noxref_7_c_1566_n ) capacitor c=0.00400249f \
 //x=17.825 //y=2.26 //x2=18.565 //y2=4.715
cc_1013 ( N_noxref_6_c_1315_n N_noxref_7_c_1566_n ) capacitor c=0.00417994f \
 //x=17.825 //y=4.88 //x2=18.565 //y2=4.715
cc_1014 ( N_noxref_6_c_1276_n N_noxref_7_c_1557_n ) capacitor c=0.00735597f \
 //x=17.71 //y=4.25 //x2=18.565 //y2=2.26
cc_1015 ( N_noxref_6_c_1256_n N_noxref_7_c_1557_n ) capacitor c=0.0788113f \
 //x=17.825 //y=2.26 //x2=18.565 //y2=2.26
cc_1016 ( N_noxref_6_c_1261_n N_noxref_7_c_1557_n ) capacitor c=0.00284029f \
 //x=17.63 //y=2.095 //x2=18.565 //y2=2.26
cc_1017 ( N_noxref_6_c_1256_n N_noxref_7_c_1571_n ) capacitor c=0.00582473f \
 //x=17.825 //y=2.26 //x2=18.565 //y2=3.51
cc_1018 ( N_noxref_6_M35_noxref_g N_noxref_7_M37_noxref_g ) capacitor \
 c=0.0104611f //x=17.725 //y=6.2 //x2=18.605 //y2=6.2
cc_1019 ( N_noxref_6_M36_noxref_g N_noxref_7_M37_noxref_g ) capacitor \
 c=0.106811f //x=18.165 //y=6.2 //x2=18.605 //y2=6.2
cc_1020 ( N_noxref_6_M36_noxref_g N_noxref_7_M38_noxref_g ) capacitor \
 c=0.0100341f //x=18.165 //y=6.2 //x2=19.045 //y2=6.2
cc_1021 ( N_noxref_6_c_1257_n N_noxref_7_c_1575_n ) capacitor c=4.86506e-19 \
 //x=17.63 //y=1.045 //x2=18.6 //y2=1.085
cc_1022 ( N_noxref_6_c_1259_n N_noxref_7_c_1575_n ) capacitor c=0.00152104f \
 //x=17.63 //y=1.39 //x2=18.6 //y2=1.085
cc_1023 ( N_noxref_6_c_1264_n N_noxref_7_c_1575_n ) capacitor c=0.0151475f \
 //x=18.16 //y=1.045 //x2=18.6 //y2=1.085
cc_1024 ( N_noxref_6_c_1260_n N_noxref_7_c_1578_n ) capacitor c=0.00109982f \
 //x=17.63 //y=1.7 //x2=18.6 //y2=1.43
cc_1025 ( N_noxref_6_c_1266_n N_noxref_7_c_1578_n ) capacitor c=0.0111064f \
 //x=18.16 //y=1.39 //x2=18.6 //y2=1.43
cc_1026 ( N_noxref_6_c_1260_n N_noxref_7_c_1580_n ) capacitor c=9.57794e-19 \
 //x=17.63 //y=1.7 //x2=18.6 //y2=1.74
cc_1027 ( N_noxref_6_c_1261_n N_noxref_7_c_1580_n ) capacitor c=0.00662747f \
 //x=17.63 //y=2.095 //x2=18.6 //y2=1.74
cc_1028 ( N_noxref_6_c_1266_n N_noxref_7_c_1580_n ) capacitor c=0.00862358f \
 //x=18.16 //y=1.39 //x2=18.6 //y2=1.74
cc_1029 ( N_noxref_6_c_1264_n N_noxref_7_c_1583_n ) capacitor c=0.00124821f \
 //x=18.16 //y=1.045 //x2=19.13 //y2=1.085
cc_1030 ( N_noxref_6_c_1266_n N_noxref_7_c_1584_n ) capacitor c=0.00200715f \
 //x=18.16 //y=1.39 //x2=19.13 //y2=1.43
cc_1031 ( N_noxref_6_c_1256_n N_noxref_7_c_1585_n ) capacitor c=0.00282278f \
 //x=17.825 //y=2.26 //x2=18.565 //y2=2.26
cc_1032 ( N_noxref_6_c_1261_n N_noxref_7_c_1585_n ) capacitor c=0.0172771f \
 //x=17.63 //y=2.095 //x2=18.565 //y2=2.26
cc_1033 ( N_noxref_6_c_1256_n N_noxref_7_c_1587_n ) capacitor c=0.00344981f \
 //x=17.825 //y=2.26 //x2=18.595 //y2=4.88
cc_1034 ( N_noxref_6_c_1315_n N_noxref_7_c_1587_n ) capacitor c=0.0293367f \
 //x=17.825 //y=4.88 //x2=18.595 //y2=4.88
cc_1035 ( N_noxref_6_M36_noxref_g N_QN_c_1666_n ) capacitor c=0.0187084f \
 //x=18.165 //y=6.2 //x2=18.74 //y2=5.38
cc_1036 ( N_noxref_6_c_1276_n N_QN_c_1670_n ) capacitor c=0.00144307f \
 //x=17.71 //y=4.25 //x2=18.03 //y2=5.38
cc_1037 ( N_noxref_6_c_1256_n N_QN_c_1670_n ) capacitor c=0.00529872f \
 //x=17.825 //y=2.26 //x2=18.03 //y2=5.38
cc_1038 ( N_noxref_6_M35_noxref_g N_QN_c_1670_n ) capacitor c=0.0177326f \
 //x=17.725 //y=6.2 //x2=18.03 //y2=5.38
cc_1039 ( N_noxref_6_c_1315_n N_QN_c_1670_n ) capacitor c=0.00585724f \
 //x=17.825 //y=4.88 //x2=18.03 //y2=5.38
cc_1040 ( N_noxref_6_c_1256_n N_QN_c_1643_n ) capacitor c=0.00399094f \
 //x=17.825 //y=2.26 //x2=19.332 //y2=2.685
cc_1041 ( N_noxref_6_M36_noxref_g N_QN_M35_noxref_d ) capacitor c=0.0173476f \
 //x=18.165 //y=6.2 //x2=17.8 //y2=5.2
cc_1042 ( N_noxref_6_c_1276_n N_SN_c_1812_n ) capacitor c=0.0219225f //x=17.71 \
 //y=4.25 //x2=22.15 //y2=2.4
cc_1043 ( N_noxref_6_c_1256_n N_SN_c_1812_n ) capacitor c=0.0233481f \
 //x=17.825 //y=2.26 //x2=22.15 //y2=2.4
cc_1044 ( N_noxref_6_c_1261_n N_SN_c_1812_n ) capacitor c=0.00814985f \
 //x=17.63 //y=2.095 //x2=22.15 //y2=2.4
cc_1045 ( N_noxref_6_c_1276_n N_SN_c_1822_n ) capacitor c=5.54535e-19 \
 //x=17.71 //y=4.25 //x2=10.91 //y2=2.4
cc_1046 ( N_noxref_6_c_1276_n N_SN_c_1826_n ) capacitor c=0.0190126f //x=17.71 \
 //y=4.25 //x2=10.795 //y2=4.88
cc_1047 ( N_noxref_6_c_1355_n N_SN_c_1845_n ) capacitor c=2.27338e-19 \
 //x=7.832 //y=4.085 //x2=10.822 //y2=3.055
cc_1048 ( N_noxref_6_c_1305_n N_SN_c_1892_n ) capacitor c=2.27338e-19 //x=7.83 \
 //y=4.25 //x2=10.822 //y2=3.425
cc_1049 ( N_noxref_6_c_1250_n N_noxref_10_c_2079_n ) capacitor c=0.044143f \
 //x=7.715 //y=4.25 //x2=11.79 //y2=3.88
cc_1050 ( N_noxref_6_c_1276_n N_noxref_10_c_2079_n ) capacitor c=0.340116f \
 //x=17.71 //y=4.25 //x2=11.79 //y2=3.88
cc_1051 ( N_noxref_6_c_1285_n N_noxref_10_c_2079_n ) capacitor c=0.0267581f \
 //x=7.945 //y=4.25 //x2=11.79 //y2=3.88
cc_1052 ( N_noxref_6_c_1305_n N_noxref_10_c_2079_n ) capacitor c=0.00219785f \
 //x=7.83 //y=4.25 //x2=11.79 //y2=3.88
cc_1053 ( N_noxref_6_c_1355_n N_noxref_10_c_2079_n ) capacitor c=0.0223643f \
 //x=7.832 //y=4.085 //x2=11.79 //y2=3.88
cc_1054 ( N_noxref_6_c_1250_n N_noxref_10_c_2135_n ) capacitor c=0.0292842f \
 //x=7.715 //y=4.25 //x2=7.21 //y2=3.88
cc_1055 ( N_noxref_6_c_1355_n N_noxref_10_c_2135_n ) capacitor c=0.00179385f \
 //x=7.832 //y=4.085 //x2=7.21 //y2=3.88
cc_1056 ( N_noxref_6_c_1276_n N_noxref_10_c_2081_n ) capacitor c=0.338821f \
 //x=17.71 //y=4.25 //x2=15.86 //y2=3.88
cc_1057 ( N_noxref_6_c_1276_n N_noxref_10_c_2145_n ) capacitor c=0.026596f \
 //x=17.71 //y=4.25 //x2=12.02 //y2=3.88
cc_1058 ( N_noxref_6_c_1276_n N_noxref_10_c_2082_n ) capacitor c=0.17615f \
 //x=17.71 //y=4.25 //x2=23.26 //y2=3.88
cc_1059 ( N_noxref_6_c_1256_n N_noxref_10_c_2082_n ) capacitor c=0.0253978f \
 //x=17.825 //y=2.26 //x2=23.26 //y2=3.88
cc_1060 ( N_noxref_6_c_1315_n N_noxref_10_c_2082_n ) capacitor c=0.00463981f \
 //x=17.825 //y=4.88 //x2=23.26 //y2=3.88
cc_1061 ( N_noxref_6_c_1276_n N_noxref_10_c_2185_n ) capacitor c=0.026743f \
 //x=17.71 //y=4.25 //x2=16.09 //y2=3.88
cc_1062 ( N_noxref_6_c_1256_n N_noxref_10_c_2185_n ) capacitor c=7.01366e-19 \
 //x=17.825 //y=2.26 //x2=16.09 //y2=3.88
cc_1063 ( N_noxref_6_c_1250_n N_noxref_10_c_2083_n ) capacitor c=0.0197867f \
 //x=7.715 //y=4.25 //x2=7.095 //y2=2.26
cc_1064 ( N_noxref_6_c_1285_n N_noxref_10_c_2083_n ) capacitor c=0.00180189f \
 //x=7.945 //y=4.25 //x2=7.095 //y2=2.26
cc_1065 ( N_noxref_6_c_1401_n N_noxref_10_c_2083_n ) capacitor c=0.0163236f \
 //x=7.835 //y=5.25 //x2=7.095 //y2=2.26
cc_1066 ( N_noxref_6_c_1465_p N_noxref_10_c_2083_n ) capacitor c=0.016476f \
 //x=7.055 //y=5.335 //x2=7.095 //y2=2.26
cc_1067 ( N_noxref_6_c_1305_n N_noxref_10_c_2083_n ) capacitor c=0.00966503f \
 //x=7.83 //y=4.25 //x2=7.095 //y2=2.26
cc_1068 ( N_noxref_6_c_1355_n N_noxref_10_c_2083_n ) capacitor c=0.0580095f \
 //x=7.832 //y=4.085 //x2=7.095 //y2=2.26
cc_1069 ( N_noxref_6_c_1276_n N_noxref_10_c_2084_n ) capacitor c=0.0198068f \
 //x=17.71 //y=4.25 //x2=11.905 //y2=2.26
cc_1070 ( N_noxref_6_c_1276_n N_noxref_10_c_2097_n ) capacitor c=0.0127115f \
 //x=17.71 //y=4.25 //x2=15.41 //y2=5.38
cc_1071 ( N_noxref_6_c_1276_n N_noxref_10_c_2086_n ) capacitor c=0.0253623f \
 //x=17.71 //y=4.25 //x2=15.975 //y2=3.88
cc_1072 ( N_noxref_6_c_1256_n N_noxref_10_c_2086_n ) capacitor c=0.0145047f \
 //x=17.825 //y=2.26 //x2=15.975 //y2=3.88
cc_1073 ( N_noxref_6_c_1294_n N_noxref_10_M23_noxref_g ) capacitor c=0.01736f \
 //x=6.97 //y=5.335 //x2=6.835 //y2=6.2
cc_1074 ( N_noxref_6_M23_noxref_d N_noxref_10_M23_noxref_g ) capacitor \
 c=0.0180032f //x=6.91 //y=5.2 //x2=6.835 //y2=6.2
cc_1075 ( N_noxref_6_c_1298_n N_noxref_10_M24_noxref_g ) capacitor \
 c=0.0194981f //x=7.75 //y=5.335 //x2=7.275 //y2=6.2
cc_1076 ( N_noxref_6_M23_noxref_d N_noxref_10_M24_noxref_g ) capacitor \
 c=0.0194246f //x=6.91 //y=5.2 //x2=7.275 //y2=6.2
cc_1077 ( N_noxref_6_M4_noxref_d N_noxref_10_c_2225_n ) capacitor \
 c=0.00217566f //x=7.16 //y=1.095 //x2=7.085 //y2=1.095
cc_1078 ( N_noxref_6_M4_noxref_d N_noxref_10_c_2226_n ) capacitor c=0.0034598f \
 //x=7.16 //y=1.095 //x2=7.085 //y2=1.44
cc_1079 ( N_noxref_6_M4_noxref_d N_noxref_10_c_2227_n ) capacitor \
 c=0.00544291f //x=7.16 //y=1.095 //x2=7.085 //y2=1.75
cc_1080 ( N_noxref_6_M4_noxref_d N_noxref_10_c_2277_n ) capacitor \
 c=0.00241102f //x=7.16 //y=1.095 //x2=7.46 //y2=0.94
cc_1081 ( N_noxref_6_c_1255_n N_noxref_10_c_2278_n ) capacitor c=0.00359704f \
 //x=7.75 //y=1.845 //x2=7.46 //y2=1.595
cc_1082 ( N_noxref_6_M4_noxref_d N_noxref_10_c_2278_n ) capacitor c=0.0140297f \
 //x=7.16 //y=1.095 //x2=7.46 //y2=1.595
cc_1083 ( N_noxref_6_M4_noxref_d N_noxref_10_c_2280_n ) capacitor \
 c=0.00219619f //x=7.16 //y=1.095 //x2=7.615 //y2=1.095
cc_1084 ( N_noxref_6_c_1255_n N_noxref_10_c_2281_n ) capacitor c=0.00457401f \
 //x=7.75 //y=1.845 //x2=7.615 //y2=1.44
cc_1085 ( N_noxref_6_M4_noxref_d N_noxref_10_c_2281_n ) capacitor \
 c=0.00603828f //x=7.16 //y=1.095 //x2=7.615 //y2=1.44
cc_1086 ( N_noxref_6_c_1355_n N_noxref_10_c_2140_n ) capacitor c=0.00772308f \
 //x=7.832 //y=4.085 //x2=7.095 //y2=2.26
cc_1087 ( N_noxref_6_c_1355_n N_noxref_10_c_2230_n ) capacitor c=0.00404774f \
 //x=7.832 //y=4.085 //x2=7.095 //y2=2.095
cc_1088 ( N_noxref_6_M4_noxref_d N_noxref_10_c_2230_n ) capacitor \
 c=0.00661782f //x=7.16 //y=1.095 //x2=7.095 //y2=2.095
cc_1089 ( N_noxref_6_c_1298_n N_noxref_10_c_2231_n ) capacitor c=0.00201851f \
 //x=7.75 //y=5.335 //x2=7.095 //y2=4.88
cc_1090 ( N_noxref_6_c_1401_n N_noxref_10_c_2231_n ) capacitor c=0.0151148f \
 //x=7.835 //y=5.25 //x2=7.095 //y2=4.88
cc_1091 ( N_noxref_6_c_1465_p N_noxref_10_c_2231_n ) capacitor c=0.00475601f \
 //x=7.055 //y=5.335 //x2=7.095 //y2=4.88
cc_1092 ( N_noxref_6_c_1253_n D ) capacitor c=0.0071268f //x=2.285 //y=2.26 \
 //x2=1.6 //y2=2.77
cc_1093 ( N_noxref_6_c_1253_n D ) capacitor c=0.00786647f //x=2.285 //y=2.26 \
 //x2=1.6 //y2=3.14
cc_1094 ( N_noxref_6_c_1253_n D ) capacitor c=0.00786647f //x=2.285 //y=2.26 \
 //x2=1.6 //y2=3.51
cc_1095 ( N_noxref_6_c_1253_n D ) capacitor c=0.00786647f //x=2.285 //y=2.26 \
 //x2=1.6 //y2=3.88
cc_1096 ( N_noxref_6_c_1252_n D ) capacitor c=0.00538804f //x=2.4 //y=4.25 \
 //x2=1.6 //y2=4.25
cc_1097 ( N_noxref_6_c_1253_n D ) capacitor c=0.00596938f //x=2.285 //y=2.26 \
 //x2=1.6 //y2=4.25
cc_1098 ( N_noxref_6_c_1253_n D ) capacitor c=0.00777753f //x=2.285 //y=2.26 \
 //x2=1.6 //y2=4.62
cc_1099 ( N_noxref_6_c_1253_n N_D_c_2535_n ) capacitor c=0.0117175f //x=2.285 \
 //y=2.26 //x2=1.545 //y2=2.485
cc_1100 ( N_noxref_6_c_1372_n N_D_c_2535_n ) capacitor c=0.00402155f //x=2.285 \
 //y=2.26 //x2=1.545 //y2=2.485
cc_1101 ( N_noxref_6_c_1345_n N_D_c_2547_n ) capacitor c=0.00348308f //x=2.285 \
 //y=4.715 //x2=1.545 //y2=4.88
cc_1102 ( N_noxref_6_c_1253_n N_D_c_2547_n ) capacitor c=0.00507077f //x=2.285 \
 //y=2.26 //x2=1.545 //y2=4.88
cc_1103 ( N_noxref_6_c_1375_n N_D_c_2547_n ) capacitor c=0.00344981f //x=2.315 \
 //y=4.88 //x2=1.545 //y2=4.88
cc_1104 ( N_noxref_6_c_1253_n N_D_c_2562_n ) capacitor c=0.00643937f //x=2.285 \
 //y=2.26 //x2=1.572 //y2=2.685
cc_1105 ( N_noxref_6_c_1253_n N_D_c_2563_n ) capacitor c=0.00651264f //x=2.285 \
 //y=2.26 //x2=1.572 //y2=3.055
cc_1106 ( N_noxref_6_c_1253_n N_D_c_2564_n ) capacitor c=0.00659563f //x=2.285 \
 //y=2.26 //x2=1.572 //y2=3.425
cc_1107 ( N_noxref_6_c_1253_n N_D_c_2565_n ) capacitor c=0.00659563f //x=2.285 \
 //y=2.26 //x2=1.572 //y2=3.795
cc_1108 ( N_noxref_6_c_1252_n N_D_c_2566_n ) capacitor c=7.21907e-19 //x=2.4 \
 //y=4.25 //x2=1.572 //y2=4.165
cc_1109 ( N_noxref_6_c_1253_n N_D_c_2566_n ) capacitor c=0.00626362f //x=2.285 \
 //y=2.26 //x2=1.572 //y2=4.165
cc_1110 ( N_noxref_6_c_1252_n N_D_c_2567_n ) capacitor c=8.84388e-19 //x=2.4 \
 //y=4.25 //x2=1.572 //y2=4.535
cc_1111 ( N_noxref_6_c_1253_n N_D_c_2567_n ) capacitor c=0.00618976f //x=2.285 \
 //y=2.26 //x2=1.572 //y2=4.535
cc_1112 ( N_noxref_6_M17_noxref_g N_D_M15_noxref_g ) capacitor c=0.0104611f \
 //x=2.325 //y=6.2 //x2=1.445 //y2=6.2
cc_1113 ( N_noxref_6_M17_noxref_g N_D_M16_noxref_g ) capacitor c=0.106811f \
 //x=2.325 //y=6.2 //x2=1.885 //y2=6.2
cc_1114 ( N_noxref_6_M18_noxref_g N_D_M16_noxref_g ) capacitor c=0.0100341f \
 //x=2.765 //y=6.2 //x2=1.885 //y2=6.2
cc_1115 ( N_noxref_6_c_1361_n N_D_c_2536_n ) capacitor c=4.86506e-19 //x=2.32 \
 //y=1.085 //x2=1.35 //y2=1.045
cc_1116 ( N_noxref_6_c_1361_n N_D_c_2538_n ) capacitor c=0.00152104f //x=2.32 \
 //y=1.085 //x2=1.35 //y2=1.39
cc_1117 ( N_noxref_6_c_1362_n N_D_c_2539_n ) capacitor c=0.00109982f //x=2.32 \
 //y=1.43 //x2=1.35 //y2=1.7
cc_1118 ( N_noxref_6_c_1363_n N_D_c_2539_n ) capacitor c=9.57794e-19 //x=2.32 \
 //y=1.74 //x2=1.35 //y2=1.7
cc_1119 ( N_noxref_6_c_1253_n N_D_c_2540_n ) capacitor c=0.00388209f //x=2.285 \
 //y=2.26 //x2=1.35 //y2=2.095
cc_1120 ( N_noxref_6_c_1363_n N_D_c_2540_n ) capacitor c=0.00662747f //x=2.32 \
 //y=1.74 //x2=1.35 //y2=2.095
cc_1121 ( N_noxref_6_c_1372_n N_D_c_2540_n ) capacitor c=0.0170731f //x=2.285 \
 //y=2.26 //x2=1.35 //y2=2.095
cc_1122 ( N_noxref_6_c_1361_n N_D_c_2543_n ) capacitor c=0.0151475f //x=2.32 \
 //y=1.085 //x2=1.88 //y2=1.045
cc_1123 ( N_noxref_6_c_1369_n N_D_c_2543_n ) capacitor c=0.00124821f //x=2.85 \
 //y=1.085 //x2=1.88 //y2=1.045
cc_1124 ( N_noxref_6_c_1362_n N_D_c_2545_n ) capacitor c=0.0111064f //x=2.32 \
 //y=1.43 //x2=1.88 //y2=1.39
cc_1125 ( N_noxref_6_c_1363_n N_D_c_2545_n ) capacitor c=0.00862358f //x=2.32 \
 //y=1.74 //x2=1.88 //y2=1.39
cc_1126 ( N_noxref_6_c_1370_n N_D_c_2545_n ) capacitor c=0.00200715f //x=2.85 \
 //y=1.43 //x2=1.88 //y2=1.39
cc_1127 ( N_noxref_6_c_1345_n N_D_c_2553_n ) capacitor c=0.00417994f //x=2.285 \
 //y=4.715 //x2=1.545 //y2=4.88
cc_1128 ( N_noxref_6_c_1375_n N_D_c_2553_n ) capacitor c=0.0293367f //x=2.315 \
 //y=4.88 //x2=1.545 //y2=4.88
cc_1129 ( N_noxref_6_c_1252_n N_noxref_13_c_2627_n ) capacitor c=3.32378e-19 \
 //x=2.4 //y=4.25 //x2=2.1 //y2=1.675
cc_1130 ( N_noxref_6_c_1363_n N_noxref_13_c_2627_n ) capacitor c=0.00623646f \
 //x=2.32 //y=1.74 //x2=2.1 //y2=1.675
cc_1131 ( N_noxref_6_c_1372_n N_noxref_13_c_2627_n ) capacitor c=0.00176439f \
 //x=2.285 //y=2.26 //x2=2.1 //y2=1.675
cc_1132 ( N_noxref_6_c_1253_n N_noxref_13_c_2628_n ) capacitor c=0.00161845f \
 //x=2.285 //y=2.26 //x2=2.985 //y2=0.71
cc_1133 ( N_noxref_6_c_1361_n N_noxref_13_c_2628_n ) capacitor c=0.0186143f \
 //x=2.32 //y=1.085 //x2=2.985 //y2=0.71
cc_1134 ( N_noxref_6_c_1369_n N_noxref_13_c_2628_n ) capacitor c=0.00656458f \
 //x=2.85 //y=1.085 //x2=2.985 //y2=0.71
cc_1135 ( N_noxref_6_c_1372_n N_noxref_13_c_2628_n ) capacitor c=2.1838e-19 \
 //x=2.285 //y=2.26 //x2=2.985 //y2=0.71
cc_1136 ( N_noxref_6_c_1361_n N_noxref_13_M0_noxref_s ) capacitor \
 c=0.00623646f //x=2.32 //y=1.085 //x2=0.995 //y2=0.545
cc_1137 ( N_noxref_6_c_1369_n N_noxref_13_M0_noxref_s ) capacitor c=0.0143002f \
 //x=2.85 //y=1.085 //x2=0.995 //y2=0.545
cc_1138 ( N_noxref_6_c_1370_n N_noxref_13_M0_noxref_s ) capacitor \
 c=0.00290153f //x=2.85 //y=1.43 //x2=0.995 //y2=0.545
cc_1139 ( N_noxref_6_M4_noxref_d N_noxref_14_M2_noxref_s ) capacitor \
 c=0.00309936f //x=7.16 //y=1.095 //x2=4.22 //y2=0.555
cc_1140 ( N_noxref_6_c_1255_n N_noxref_15_c_2727_n ) capacitor c=0.00461497f \
 //x=7.75 //y=1.845 //x2=7.75 //y2=0.72
cc_1141 ( N_noxref_6_M4_noxref_d N_noxref_15_c_2727_n ) capacitor c=0.0116817f \
 //x=7.16 //y=1.095 //x2=7.75 //y2=0.72
cc_1142 ( N_noxref_6_c_1354_n N_noxref_15_c_2753_n ) capacitor c=0.0200405f \
 //x=7.435 //y=1.845 //x2=6.865 //y2=1.175
cc_1143 ( N_noxref_6_M4_noxref_d N_noxref_15_M3_noxref_d ) capacitor \
 c=5.27807e-19 //x=7.16 //y=1.095 //x2=5.625 //y2=1.09
cc_1144 ( N_noxref_6_c_1255_n N_noxref_15_M4_noxref_s ) capacitor c=0.0201579f \
 //x=7.75 //y=1.845 //x2=6.73 //y2=0.555
cc_1145 ( N_noxref_6_M4_noxref_d N_noxref_15_M4_noxref_s ) capacitor \
 c=0.0426368f //x=7.16 //y=1.095 //x2=6.73 //y2=0.555
cc_1146 ( N_noxref_6_c_1255_n N_noxref_16_c_2791_n ) capacitor c=3.83325e-19 \
 //x=7.75 //y=1.845 //x2=9.165 //y2=1.685
cc_1147 ( N_noxref_6_M4_noxref_d N_noxref_16_M5_noxref_s ) capacitor \
 c=2.55333e-19 //x=7.16 //y=1.095 //x2=9.03 //y2=0.555
cc_1148 ( N_noxref_6_c_1261_n N_noxref_19_c_2954_n ) capacitor c=0.0034165f \
 //x=17.63 //y=2.095 //x2=17.41 //y2=1.675
cc_1149 ( N_noxref_6_c_1256_n N_noxref_19_c_2935_n ) capacitor c=0.0111916f \
 //x=17.825 //y=2.26 //x2=18.295 //y2=1.76
cc_1150 ( N_noxref_6_c_1260_n N_noxref_19_c_2935_n ) capacitor c=0.00696403f \
 //x=17.63 //y=1.7 //x2=18.295 //y2=1.76
cc_1151 ( N_noxref_6_c_1261_n N_noxref_19_c_2935_n ) capacitor c=0.0174694f \
 //x=17.63 //y=2.095 //x2=18.295 //y2=1.76
cc_1152 ( N_noxref_6_c_1263_n N_noxref_19_c_2935_n ) capacitor c=0.00776811f \
 //x=18.005 //y=1.545 //x2=18.295 //y2=1.76
cc_1153 ( N_noxref_6_c_1266_n N_noxref_19_c_2935_n ) capacitor c=0.00339872f \
 //x=18.16 //y=1.39 //x2=18.295 //y2=1.76
cc_1154 ( N_noxref_6_c_1261_n N_noxref_19_c_2942_n ) capacitor c=6.71402e-19 \
 //x=17.63 //y=2.095 //x2=18.38 //y2=1.675
cc_1155 ( N_noxref_6_c_1257_n N_noxref_19_M10_noxref_s ) capacitor \
 c=0.0326577f //x=17.63 //y=1.045 //x2=17.275 //y2=0.545
cc_1156 ( N_noxref_6_c_1260_n N_noxref_19_M10_noxref_s ) capacitor \
 c=3.48408e-19 //x=17.63 //y=1.7 //x2=17.275 //y2=0.545
cc_1157 ( N_noxref_6_c_1264_n N_noxref_19_M10_noxref_s ) capacitor \
 c=0.0120759f //x=18.16 //y=1.045 //x2=17.275 //y2=0.545
cc_1158 ( N_noxref_7_c_1557_n QN ) capacitor c=0.005746f //x=18.565 //y=2.26 \
 //x2=19.36 //y2=3.14
cc_1159 ( N_noxref_7_M38_noxref_g QN ) capacitor c=0.00728936f //x=19.045 \
 //y=6.2 //x2=19.36 //y2=4.99
cc_1160 ( N_noxref_7_c_1587_n QN ) capacitor c=8.36577e-19 //x=18.595 //y=4.88 \
 //x2=19.36 //y2=4.99
cc_1161 ( N_noxref_7_c_1566_n N_QN_c_1666_n ) capacitor c=0.0131484f \
 //x=18.565 //y=4.715 //x2=18.74 //y2=5.38
cc_1162 ( N_noxref_7_M37_noxref_g N_QN_c_1666_n ) capacitor c=0.0166421f \
 //x=18.605 //y=6.2 //x2=18.74 //y2=5.38
cc_1163 ( N_noxref_7_c_1587_n N_QN_c_1666_n ) capacitor c=0.00345427f \
 //x=18.595 //y=4.88 //x2=18.74 //y2=5.38
cc_1164 ( N_noxref_7_M38_noxref_g N_QN_c_1672_n ) capacitor c=0.0206783f \
 //x=19.045 //y=6.2 //x2=19.22 //y2=5.38
cc_1165 ( N_noxref_7_c_1596_p N_QN_c_1641_n ) capacitor c=0.00371277f \
 //x=18.975 //y=1.585 //x2=19.22 //y2=1.835
cc_1166 ( N_noxref_7_c_1584_n N_QN_c_1641_n ) capacitor c=0.00457401f \
 //x=19.13 //y=1.43 //x2=19.22 //y2=1.835
cc_1167 ( N_noxref_7_c_1598_p N_QN_c_1713_n ) capacitor c=0.00421574f \
 //x=18.97 //y=4.97 //x2=18.825 //y2=5.38
cc_1168 ( N_noxref_7_c_1557_n N_QN_c_1643_n ) capacitor c=0.0731817f \
 //x=18.565 //y=2.26 //x2=19.332 //y2=2.685
cc_1169 ( N_noxref_7_c_1585_n N_QN_c_1643_n ) capacitor c=0.00709342f \
 //x=18.565 //y=2.26 //x2=19.332 //y2=2.685
cc_1170 ( N_noxref_7_c_1601_p N_QN_c_1643_n ) capacitor c=0.00306024f \
 //x=18.565 //y=2.095 //x2=19.332 //y2=2.685
cc_1171 ( N_noxref_7_c_1557_n N_QN_c_1717_n ) capacitor c=4.01795e-19 \
 //x=18.565 //y=2.26 //x2=19.332 //y2=4.165
cc_1172 ( N_noxref_7_c_1571_n N_QN_c_1717_n ) capacitor c=0.00294326f \
 //x=18.565 //y=3.51 //x2=19.332 //y2=4.165
cc_1173 ( N_noxref_7_c_1566_n N_QN_c_1679_n ) capacitor c=0.0101588f \
 //x=18.565 //y=4.715 //x2=19.332 //y2=4.905
cc_1174 ( N_noxref_7_c_1598_p N_QN_c_1679_n ) capacitor c=0.00728936f \
 //x=18.97 //y=4.97 //x2=19.332 //y2=4.905
cc_1175 ( N_noxref_7_c_1587_n N_QN_c_1679_n ) capacitor c=0.00533692f \
 //x=18.595 //y=4.88 //x2=19.332 //y2=4.905
cc_1176 ( N_noxref_7_c_1557_n N_QN_c_1722_n ) capacitor c=0.00102404f \
 //x=18.565 //y=2.26 //x2=21.182 //y2=3.055
cc_1177 ( N_noxref_7_c_1575_n N_QN_M11_noxref_d ) capacitor c=0.00217566f \
 //x=18.6 //y=1.085 //x2=18.675 //y2=1.085
cc_1178 ( N_noxref_7_c_1578_n N_QN_M11_noxref_d ) capacitor c=0.0034598f \
 //x=18.6 //y=1.43 //x2=18.675 //y2=1.085
cc_1179 ( N_noxref_7_c_1580_n N_QN_M11_noxref_d ) capacitor c=0.00669531f \
 //x=18.6 //y=1.74 //x2=18.675 //y2=1.085
cc_1180 ( N_noxref_7_c_1611_p N_QN_M11_noxref_d ) capacitor c=0.00241102f \
 //x=18.975 //y=0.93 //x2=18.675 //y2=1.085
cc_1181 ( N_noxref_7_c_1596_p N_QN_M11_noxref_d ) capacitor c=0.0137169f \
 //x=18.975 //y=1.585 //x2=18.675 //y2=1.085
cc_1182 ( N_noxref_7_c_1583_n N_QN_M11_noxref_d ) capacitor c=0.00132245f \
 //x=19.13 //y=1.085 //x2=18.675 //y2=1.085
cc_1183 ( N_noxref_7_c_1584_n N_QN_M11_noxref_d ) capacitor c=0.00566463f \
 //x=19.13 //y=1.43 //x2=18.675 //y2=1.085
cc_1184 ( N_noxref_7_c_1601_p N_QN_M11_noxref_d ) capacitor c=0.00660593f \
 //x=18.565 //y=2.095 //x2=18.675 //y2=1.085
cc_1185 ( N_noxref_7_M37_noxref_g N_QN_M37_noxref_d ) capacitor c=0.0173476f \
 //x=18.605 //y=6.2 //x2=18.68 //y2=5.2
cc_1186 ( N_noxref_7_M38_noxref_g N_QN_M37_noxref_d ) capacitor c=0.0179769f \
 //x=19.045 //y=6.2 //x2=18.68 //y2=5.2
cc_1187 ( N_noxref_7_c_1557_n N_SN_c_1812_n ) capacitor c=0.0218045f \
 //x=18.565 //y=2.26 //x2=22.15 //y2=2.4
cc_1188 ( N_noxref_7_c_1571_n N_SN_c_1812_n ) capacitor c=0.0116819f \
 //x=18.565 //y=3.51 //x2=22.15 //y2=2.4
cc_1189 ( N_noxref_7_c_1596_p N_SN_c_1812_n ) capacitor c=3.11115e-19 \
 //x=18.975 //y=1.585 //x2=22.15 //y2=2.4
cc_1190 ( N_noxref_7_c_1585_n N_SN_c_1812_n ) capacitor c=0.00570196f \
 //x=18.565 //y=2.26 //x2=22.15 //y2=2.4
cc_1191 ( N_noxref_7_c_1566_n N_noxref_10_c_2082_n ) capacitor c=0.00113929f \
 //x=18.565 //y=4.715 //x2=23.26 //y2=3.88
cc_1192 ( N_noxref_7_c_1557_n N_noxref_10_c_2082_n ) capacitor c=0.0234812f \
 //x=18.565 //y=2.26 //x2=23.26 //y2=3.88
cc_1193 ( N_noxref_7_c_1571_n N_noxref_10_c_2082_n ) capacitor c=0.0423669f \
 //x=18.565 //y=3.51 //x2=23.26 //y2=3.88
cc_1194 ( N_noxref_7_c_1598_p N_noxref_10_c_2082_n ) capacitor c=0.00624857f \
 //x=18.97 //y=4.97 //x2=23.26 //y2=3.88
cc_1195 ( N_noxref_7_c_1587_n N_noxref_10_c_2082_n ) capacitor c=9.84146e-19 \
 //x=18.595 //y=4.88 //x2=23.26 //y2=3.88
cc_1196 ( N_noxref_7_c_1557_n N_noxref_10_c_2086_n ) capacitor c=0.00118913f \
 //x=18.565 //y=2.26 //x2=15.975 //y2=3.88
cc_1197 ( N_noxref_7_c_1557_n N_noxref_11_c_2438_n ) capacitor c=0.00340659f \
 //x=18.565 //y=2.26 //x2=24.115 //y2=3.51
cc_1198 ( N_noxref_7_c_1571_n N_noxref_11_c_2438_n ) capacitor c=0.0339004f \
 //x=18.565 //y=3.51 //x2=24.115 //y2=3.51
cc_1199 ( N_noxref_7_c_1580_n N_noxref_19_c_2942_n ) capacitor c=0.00623646f \
 //x=18.6 //y=1.74 //x2=18.38 //y2=1.675
cc_1200 ( N_noxref_7_c_1585_n N_noxref_19_c_2942_n ) capacitor c=0.00173579f \
 //x=18.565 //y=2.26 //x2=18.38 //y2=1.675
cc_1201 ( N_noxref_7_c_1557_n N_noxref_19_c_2943_n ) capacitor c=0.00156605f \
 //x=18.565 //y=2.26 //x2=19.265 //y2=0.71
cc_1202 ( N_noxref_7_c_1575_n N_noxref_19_c_2943_n ) capacitor c=0.0188655f \
 //x=18.6 //y=1.085 //x2=19.265 //y2=0.71
cc_1203 ( N_noxref_7_c_1583_n N_noxref_19_c_2943_n ) capacitor c=0.00656458f \
 //x=19.13 //y=1.085 //x2=19.265 //y2=0.71
cc_1204 ( N_noxref_7_c_1585_n N_noxref_19_c_2943_n ) capacitor c=2.1838e-19 \
 //x=18.565 //y=2.26 //x2=19.265 //y2=0.71
cc_1205 ( N_noxref_7_c_1575_n N_noxref_19_M10_noxref_s ) capacitor \
 c=0.00623646f //x=18.6 //y=1.085 //x2=17.275 //y2=0.545
cc_1206 ( N_noxref_7_c_1583_n N_noxref_19_M10_noxref_s ) capacitor \
 c=0.0143002f //x=19.13 //y=1.085 //x2=17.275 //y2=0.545
cc_1207 ( N_noxref_7_c_1584_n N_noxref_19_M10_noxref_s ) capacitor \
 c=0.00290153f //x=19.13 //y=1.43 //x2=17.275 //y2=0.545
cc_1208 ( QN N_SN_c_1812_n ) capacitor c=0.00117832f //x=19.36 //y=2.77 \
 //x2=22.15 //y2=2.4
cc_1209 ( QN N_SN_c_1812_n ) capacitor c=0.0204544f //x=19.36 //y=3.14 \
 //x2=22.15 //y2=2.4
cc_1210 ( QN N_SN_c_1812_n ) capacitor c=9.85823e-19 //x=21.21 //y=2.77 \
 //x2=22.15 //y2=2.4
cc_1211 ( QN N_SN_c_1812_n ) capacitor c=0.0748309f //x=21.21 //y=3.14 \
 //x2=22.15 //y2=2.4
cc_1212 ( N_QN_c_1737_p N_SN_c_1812_n ) capacitor c=0.0148625f //x=18.95 \
 //y=1.835 //x2=22.15 //y2=2.4
cc_1213 ( N_QN_c_1642_n N_SN_c_1812_n ) capacitor c=0.0231121f //x=21.155 \
 //y=2.26 //x2=22.15 //y2=2.4
cc_1214 ( N_QN_c_1643_n N_SN_c_1812_n ) capacitor c=0.0220911f //x=19.332 \
 //y=2.685 //x2=22.15 //y2=2.4
cc_1215 ( N_QN_c_1649_n N_SN_c_1812_n ) capacitor c=0.0122202f //x=20.855 \
 //y=2.095 //x2=22.15 //y2=2.4
cc_1216 ( QN SN ) capacitor c=0.00505269f //x=21.21 //y=2.77 //x2=22.32 \
 //y2=2.77
cc_1217 ( QN SN ) capacitor c=0.00492825f //x=21.21 //y=3.14 //x2=22.32 \
 //y2=3.14
cc_1218 ( QN SN ) capacitor c=0.00505269f //x=21.21 //y=4.25 //x2=22.32 \
 //y2=4.25
cc_1219 ( QN SN ) capacitor c=0.00505269f //x=21.21 //y=4.62 //x2=22.32 \
 //y2=4.62
cc_1220 ( N_QN_c_1642_n N_SN_c_1909_n ) capacitor c=0.00785366f //x=21.155 \
 //y=2.26 //x2=22.265 //y2=2.485
cc_1221 ( N_QN_c_1649_n N_SN_c_1909_n ) capacitor c=0.00209012f //x=20.855 \
 //y=2.095 //x2=22.265 //y2=2.485
cc_1222 ( N_QN_c_1676_n N_SN_c_1828_n ) capacitor c=0.00486492f //x=21.155 \
 //y=4.88 //x2=22.265 //y2=4.88
cc_1223 ( N_QN_c_1748_p N_SN_c_1828_n ) capacitor c=0.00147352f //x=21.72 \
 //y=4.97 //x2=22.265 //y2=4.88
cc_1224 ( N_QN_c_1684_n N_SN_c_1828_n ) capacitor c=0.00142741f //x=21.43 \
 //y=4.97 //x2=22.265 //y2=4.88
cc_1225 ( QN N_SN_c_1914_n ) capacitor c=4.93861e-19 //x=21.21 //y=3.14 \
 //x2=22.292 //y2=3.055
cc_1226 ( N_QN_c_1722_n N_SN_c_1914_n ) capacitor c=0.00393782f //x=21.182 \
 //y=3.055 //x2=22.292 //y2=3.055
cc_1227 ( QN N_SN_c_1916_n ) capacitor c=4.93861e-19 //x=21.21 //y=3.14 \
 //x2=22.292 //y2=4.165
cc_1228 ( N_QN_c_1717_n N_SN_c_1916_n ) capacitor c=2.53746e-19 //x=19.332 \
 //y=4.165 //x2=22.292 //y2=4.165
cc_1229 ( N_QN_c_1754_p N_SN_c_1916_n ) capacitor c=0.0147233f //x=21.182 \
 //y=4.165 //x2=22.292 //y2=4.165
cc_1230 ( N_QN_c_1755_p N_SN_c_1919_n ) capacitor c=0.00419471f //x=21.182 \
 //y=4.535 //x2=22.292 //y2=4.535
cc_1231 ( N_QN_M39_noxref_g N_SN_M41_noxref_g ) capacitor c=0.0105869f \
 //x=21.355 //y=6.2 //x2=22.235 //y2=6.2
cc_1232 ( N_QN_M40_noxref_g N_SN_M41_noxref_g ) capacitor c=0.10632f \
 //x=21.795 //y=6.2 //x2=22.235 //y2=6.2
cc_1233 ( N_QN_M40_noxref_g N_SN_M42_noxref_g ) capacitor c=0.0101598f \
 //x=21.795 //y=6.2 //x2=22.675 //y2=6.2
cc_1234 ( N_QN_c_1645_n N_SN_c_1923_n ) capacitor c=5.72482e-19 //x=20.855 \
 //y=1.055 //x2=21.83 //y2=1.09
cc_1235 ( N_QN_c_1647_n N_SN_c_1923_n ) capacitor c=0.00149976f //x=20.855 \
 //y=1.4 //x2=21.83 //y2=1.09
cc_1236 ( N_QN_c_1652_n N_SN_c_1923_n ) capacitor c=0.0160123f //x=21.385 \
 //y=1.055 //x2=21.83 //y2=1.09
cc_1237 ( N_QN_c_1648_n N_SN_c_1926_n ) capacitor c=0.00111227f //x=20.855 \
 //y=1.71 //x2=21.83 //y2=1.4
cc_1238 ( N_QN_c_1654_n N_SN_c_1926_n ) capacitor c=0.0124075f //x=21.385 \
 //y=1.4 //x2=21.83 //y2=1.4
cc_1239 ( N_QN_c_1652_n N_SN_c_1928_n ) capacitor c=0.00103227f //x=21.385 \
 //y=1.055 //x2=22.355 //y2=1.09
cc_1240 ( N_QN_c_1654_n N_SN_c_1929_n ) capacitor c=0.0010154f //x=21.385 \
 //y=1.4 //x2=22.355 //y2=1.4
cc_1241 ( N_QN_c_1654_n N_SN_c_1930_n ) capacitor c=9.23422e-19 //x=21.385 \
 //y=1.4 //x2=22.355 //y2=1.63
cc_1242 ( N_QN_c_1642_n N_SN_c_1931_n ) capacitor c=0.00203769f //x=21.155 \
 //y=2.26 //x2=22.355 //y2=2.095
cc_1243 ( N_QN_c_1649_n N_SN_c_1931_n ) capacitor c=0.00834532f //x=20.855 \
 //y=2.095 //x2=22.355 //y2=2.095
cc_1244 ( N_QN_c_1676_n N_SN_c_1933_n ) capacitor c=0.00183762f //x=21.155 \
 //y=4.88 //x2=22.265 //y2=4.88
cc_1245 ( N_QN_c_1748_p N_SN_c_1933_n ) capacitor c=0.0168581f //x=21.72 \
 //y=4.97 //x2=22.265 //y2=4.88
cc_1246 ( N_QN_c_1684_n N_SN_c_1933_n ) capacitor c=0.00484466f //x=21.43 \
 //y=4.97 //x2=22.265 //y2=4.88
cc_1247 ( QN N_noxref_10_c_2082_n ) capacitor c=0.00158277f //x=19.36 //y=3.14 \
 //x2=23.26 //y2=3.88
cc_1248 ( QN N_noxref_10_c_2082_n ) capacitor c=0.00179028f //x=19.36 //y=4.25 \
 //x2=23.26 //y2=3.88
cc_1249 ( QN N_noxref_10_c_2082_n ) capacitor c=0.0104658f //x=21.21 //y=3.14 \
 //x2=23.26 //y2=3.88
cc_1250 ( QN N_noxref_10_c_2082_n ) capacitor c=0.00179028f //x=21.21 //y=4.25 \
 //x2=23.26 //y2=3.88
cc_1251 ( N_QN_c_1666_n N_noxref_10_c_2082_n ) capacitor c=0.0112241f \
 //x=18.74 //y=5.38 //x2=23.26 //y2=3.88
cc_1252 ( N_QN_c_1670_n N_noxref_10_c_2082_n ) capacitor c=0.0099085f \
 //x=18.03 //y=5.38 //x2=23.26 //y2=3.88
cc_1253 ( N_QN_c_1717_n N_noxref_10_c_2082_n ) capacitor c=0.024198f \
 //x=19.332 //y=4.165 //x2=23.26 //y2=3.88
cc_1254 ( N_QN_c_1754_p N_noxref_10_c_2082_n ) capacitor c=0.0245091f \
 //x=21.182 //y=4.165 //x2=23.26 //y2=3.88
cc_1255 ( N_QN_c_1684_n N_noxref_10_c_2082_n ) capacitor c=0.0119729f \
 //x=21.43 //y=4.97 //x2=23.26 //y2=3.88
cc_1256 ( N_QN_c_1643_n N_noxref_10_c_2086_n ) capacitor c=3.4995e-19 \
 //x=19.332 //y=2.685 //x2=15.975 //y2=3.88
cc_1257 ( N_QN_c_1754_p N_noxref_10_c_2087_n ) capacitor c=4.55754e-19 \
 //x=21.182 //y=4.165 //x2=23.375 //y2=2.26
cc_1258 ( N_QN_M40_noxref_g N_noxref_11_c_2441_n ) capacitor c=0.0186539f \
 //x=21.795 //y=6.2 //x2=22.37 //y2=5.335
cc_1259 ( N_QN_c_1675_n N_noxref_11_c_2445_n ) capacitor c=2.97874e-19 \
 //x=19.305 //y=5.295 //x2=21.66 //y2=5.335
cc_1260 ( N_QN_M39_noxref_g N_noxref_11_c_2445_n ) capacitor c=0.0213876f \
 //x=21.355 //y=6.2 //x2=21.66 //y2=5.335
cc_1261 ( N_QN_c_1748_p N_noxref_11_c_2445_n ) capacitor c=0.0044314f \
 //x=21.72 //y=4.97 //x2=21.66 //y2=5.335
cc_1262 ( QN N_noxref_11_c_2438_n ) capacitor c=0.0450251f //x=19.36 //y=3.14 \
 //x2=24.115 //y2=3.51
cc_1263 ( QN N_noxref_11_c_2438_n ) capacitor c=0.157202f //x=21.21 //y=3.14 \
 //x2=24.115 //y2=3.51
cc_1264 ( N_QN_c_1717_n N_noxref_11_c_2438_n ) capacitor c=0.0178265f \
 //x=19.332 //y=4.165 //x2=24.115 //y2=3.51
cc_1265 ( N_QN_c_1754_p N_noxref_11_c_2438_n ) capacitor c=0.0195428f \
 //x=21.182 //y=4.165 //x2=24.115 //y2=3.51
cc_1266 ( N_QN_M40_noxref_g N_noxref_11_M39_noxref_d ) capacitor c=0.0180032f \
 //x=21.795 //y=6.2 //x2=21.43 //y2=5.2
cc_1267 ( N_QN_c_1737_p N_noxref_19_c_2954_n ) capacitor c=3.15806e-19 \
 //x=18.95 //y=1.835 //x2=17.41 //y2=1.675
cc_1268 ( N_QN_c_1737_p N_noxref_19_c_2942_n ) capacitor c=0.0203424f \
 //x=18.95 //y=1.835 //x2=18.38 //y2=1.675
cc_1269 ( N_QN_c_1641_n N_noxref_19_c_2943_n ) capacitor c=0.00457164f \
 //x=19.22 //y=1.835 //x2=19.265 //y2=0.71
cc_1270 ( N_QN_M11_noxref_d N_noxref_19_c_2943_n ) capacitor c=0.0115831f \
 //x=18.675 //y=1.085 //x2=19.265 //y2=0.71
cc_1271 ( QN N_noxref_19_M10_noxref_s ) capacitor c=0.00103206f //x=19.36 \
 //y=2.77 //x2=17.275 //y2=0.545
cc_1272 ( N_QN_c_1641_n N_noxref_19_M10_noxref_s ) capacitor c=0.013435f \
 //x=19.22 //y=1.835 //x2=17.275 //y2=0.545
cc_1273 ( N_QN_M11_noxref_d N_noxref_19_M10_noxref_s ) capacitor c=0.043966f \
 //x=18.675 //y=1.085 //x2=17.275 //y2=0.545
cc_1274 ( N_QN_c_1641_n N_noxref_20_c_3002_n ) capacitor c=4.08644e-19 \
 //x=19.22 //y=1.835 //x2=20.635 //y2=1.685
cc_1275 ( N_QN_c_1649_n N_noxref_20_c_3002_n ) capacitor c=0.0034165f \
 //x=20.855 //y=2.095 //x2=20.635 //y2=1.685
cc_1276 ( QN N_noxref_20_c_2988_n ) capacitor c=9.20514e-19 //x=21.21 //y=2.77 \
 //x2=21.52 //y2=1.77
cc_1277 ( N_QN_c_1642_n N_noxref_20_c_2988_n ) capacitor c=0.0115578f \
 //x=21.155 //y=2.26 //x2=21.52 //y2=1.77
cc_1278 ( N_QN_c_1648_n N_noxref_20_c_2988_n ) capacitor c=0.00697148f \
 //x=20.855 //y=1.71 //x2=21.52 //y2=1.77
cc_1279 ( N_QN_c_1649_n N_noxref_20_c_2988_n ) capacitor c=0.0199242f \
 //x=20.855 //y=2.095 //x2=21.52 //y2=1.77
cc_1280 ( N_QN_c_1651_n N_noxref_20_c_2988_n ) capacitor c=0.00610316f \
 //x=21.23 //y=1.555 //x2=21.52 //y2=1.77
cc_1281 ( N_QN_c_1654_n N_noxref_20_c_2988_n ) capacitor c=0.00698822f \
 //x=21.385 //y=1.4 //x2=21.52 //y2=1.77
cc_1282 ( N_QN_c_1645_n N_noxref_20_M12_noxref_s ) capacitor c=0.0327271f \
 //x=20.855 //y=1.055 //x2=20.5 //y2=0.555
cc_1283 ( N_QN_c_1648_n N_noxref_20_M12_noxref_s ) capacitor c=7.99997e-19 \
 //x=20.855 //y=1.71 //x2=20.5 //y2=0.555
cc_1284 ( N_QN_c_1649_n N_noxref_20_M12_noxref_s ) capacitor c=0.00122123f \
 //x=20.855 //y=2.095 //x2=20.5 //y2=0.555
cc_1285 ( N_QN_c_1652_n N_noxref_20_M12_noxref_s ) capacitor c=0.0121427f \
 //x=21.385 //y=1.055 //x2=20.5 //y2=0.555
cc_1286 ( N_QN_M11_noxref_d N_noxref_20_M12_noxref_s ) capacitor c=2.53688e-19 \
 //x=18.675 //y=1.085 //x2=20.5 //y2=0.555
cc_1287 ( N_SN_c_1812_n N_noxref_10_c_2079_n ) capacitor c=0.018375f //x=22.15 \
 //y=2.4 //x2=11.79 //y2=3.88
cc_1288 ( N_SN_c_1822_n N_noxref_10_c_2079_n ) capacitor c=0.00514376f \
 //x=10.91 //y=2.4 //x2=11.79 //y2=3.88
cc_1289 ( SN N_noxref_10_c_2079_n ) capacitor c=0.00165265f //x=10.85 //y=3.51 \
 //x2=11.79 //y2=3.88
cc_1290 ( N_SN_c_1826_n N_noxref_10_c_2079_n ) capacitor c=0.0238134f \
 //x=10.795 //y=4.88 //x2=11.79 //y2=3.88
cc_1291 ( N_SN_c_1812_n N_noxref_10_c_2081_n ) capacitor c=0.0400937f \
 //x=22.15 //y=2.4 //x2=15.86 //y2=3.88
cc_1292 ( N_SN_c_1812_n N_noxref_10_c_2145_n ) capacitor c=0.00450155f \
 //x=22.15 //y=2.4 //x2=12.02 //y2=3.88
cc_1293 ( N_SN_c_1826_n N_noxref_10_c_2145_n ) capacitor c=0.00128547f \
 //x=10.795 //y=4.88 //x2=12.02 //y2=3.88
cc_1294 ( N_SN_c_1812_n N_noxref_10_c_2082_n ) capacitor c=0.0612253f \
 //x=22.15 //y=2.4 //x2=23.26 //y2=3.88
cc_1295 ( SN N_noxref_10_c_2082_n ) capacitor c=0.00179028f //x=22.32 //y=4.25 \
 //x2=23.26 //y2=3.88
cc_1296 ( N_SN_c_1916_n N_noxref_10_c_2082_n ) capacitor c=0.0250454f \
 //x=22.292 //y=4.165 //x2=23.26 //y2=3.88
cc_1297 ( N_SN_c_1946_p N_noxref_10_c_2082_n ) capacitor c=0.00530831f \
 //x=22.6 //y=4.97 //x2=23.26 //y2=3.88
cc_1298 ( N_SN_c_1933_n N_noxref_10_c_2082_n ) capacitor c=6.78848e-19 \
 //x=22.265 //y=4.88 //x2=23.26 //y2=3.88
cc_1299 ( N_SN_c_1812_n N_noxref_10_c_2185_n ) capacitor c=0.00445687f \
 //x=22.15 //y=2.4 //x2=16.09 //y2=3.88
cc_1300 ( N_SN_c_1812_n N_noxref_10_c_2084_n ) capacitor c=0.0234253f \
 //x=22.15 //y=2.4 //x2=11.905 //y2=2.26
cc_1301 ( N_SN_c_1822_n N_noxref_10_c_2084_n ) capacitor c=0.00165648f \
 //x=10.91 //y=2.4 //x2=11.905 //y2=2.26
cc_1302 ( SN N_noxref_10_c_2084_n ) capacitor c=0.00434317f //x=10.85 //y=2.77 \
 //x2=11.905 //y2=2.26
cc_1303 ( SN N_noxref_10_c_2084_n ) capacitor c=0.00493712f //x=10.85 //y=3.14 \
 //x2=11.905 //y2=2.26
cc_1304 ( SN N_noxref_10_c_2084_n ) capacitor c=0.00493712f //x=10.85 //y=3.51 \
 //x2=11.905 //y2=2.26
cc_1305 ( N_SN_c_1840_n N_noxref_10_c_2084_n ) capacitor c=0.00421778f \
 //x=10.795 //y=2.485 //x2=11.905 //y2=2.26
cc_1306 ( N_SN_c_1826_n N_noxref_10_c_2084_n ) capacitor c=0.0208846f \
 //x=10.795 //y=4.88 //x2=11.905 //y2=2.26
cc_1307 ( N_SN_c_1823_n N_noxref_10_c_2084_n ) capacitor c=0.00388363f \
 //x=10.822 //y=2.685 //x2=11.905 //y2=2.26
cc_1308 ( N_SN_c_1845_n N_noxref_10_c_2084_n ) capacitor c=0.00414238f \
 //x=10.822 //y=3.055 //x2=11.905 //y2=2.26
cc_1309 ( N_SN_c_1892_n N_noxref_10_c_2084_n ) capacitor c=0.0042159f \
 //x=10.822 //y=3.425 //x2=11.905 //y2=2.26
cc_1310 ( N_SN_c_1857_n N_noxref_10_c_2084_n ) capacitor c=0.00257803f \
 //x=10.885 //y=2.095 //x2=11.905 //y2=2.26
cc_1311 ( N_SN_c_1859_n N_noxref_10_c_2084_n ) capacitor c=0.00142741f \
 //x=10.795 //y=4.88 //x2=11.905 //y2=2.26
cc_1312 ( N_SN_c_1812_n N_noxref_10_c_2331_n ) capacitor c=0.0146822f \
 //x=22.15 //y=2.4 //x2=15.62 //y2=1.835
cc_1313 ( N_SN_c_1812_n N_noxref_10_c_2086_n ) capacitor c=0.0247812f \
 //x=22.15 //y=2.4 //x2=15.975 //y2=3.88
cc_1314 ( N_SN_c_1812_n N_noxref_10_c_2087_n ) capacitor c=0.00510792f \
 //x=22.15 //y=2.4 //x2=23.375 //y2=2.26
cc_1315 ( SN N_noxref_10_c_2087_n ) capacitor c=0.00493712f //x=22.32 //y=2.77 \
 //x2=23.375 //y2=2.26
cc_1316 ( SN N_noxref_10_c_2087_n ) capacitor c=0.00472283f //x=22.32 //y=3.14 \
 //x2=23.375 //y2=2.26
cc_1317 ( SN N_noxref_10_c_2087_n ) capacitor c=0.00493712f //x=22.32 //y=4.25 \
 //x2=23.375 //y2=2.26
cc_1318 ( SN N_noxref_10_c_2087_n ) capacitor c=0.00493712f //x=22.32 //y=4.62 \
 //x2=23.375 //y2=2.26
cc_1319 ( N_SN_c_1909_n N_noxref_10_c_2087_n ) capacitor c=0.00486306f \
 //x=22.265 //y=2.485 //x2=23.375 //y2=2.26
cc_1320 ( N_SN_c_1828_n N_noxref_10_c_2087_n ) capacitor c=0.0049097f \
 //x=22.265 //y=4.88 //x2=23.375 //y2=2.26
cc_1321 ( N_SN_c_1824_n N_noxref_10_c_2087_n ) capacitor c=0.00395715f \
 //x=22.292 //y=2.685 //x2=23.375 //y2=2.26
cc_1322 ( N_SN_c_1914_n N_noxref_10_c_2087_n ) capacitor c=0.00418058f \
 //x=22.292 //y=3.055 //x2=23.375 //y2=2.26
cc_1323 ( N_SN_c_1916_n N_noxref_10_c_2087_n ) capacitor c=0.0146175f \
 //x=22.292 //y=4.165 //x2=23.375 //y2=2.26
cc_1324 ( N_SN_c_1919_n N_noxref_10_c_2087_n ) capacitor c=0.0042159f \
 //x=22.292 //y=4.535 //x2=23.375 //y2=2.26
cc_1325 ( N_SN_c_1931_n N_noxref_10_c_2087_n ) capacitor c=0.00227777f \
 //x=22.355 //y=2.095 //x2=23.375 //y2=2.26
cc_1326 ( N_SN_c_1933_n N_noxref_10_c_2087_n ) capacitor c=0.00142741f \
 //x=22.265 //y=4.88 //x2=23.375 //y2=2.26
cc_1327 ( N_SN_M27_noxref_g N_noxref_10_M29_noxref_g ) capacitor c=0.0101598f \
 //x=10.765 //y=6.2 //x2=11.645 //y2=6.2
cc_1328 ( N_SN_M28_noxref_g N_noxref_10_M29_noxref_g ) capacitor c=0.0602553f \
 //x=11.205 //y=6.2 //x2=11.645 //y2=6.2
cc_1329 ( N_SN_M28_noxref_g N_noxref_10_M30_noxref_g ) capacitor c=0.0101598f \
 //x=11.205 //y=6.2 //x2=12.085 //y2=6.2
cc_1330 ( N_SN_M41_noxref_g N_noxref_10_M43_noxref_g ) capacitor c=0.0101598f \
 //x=22.235 //y=6.2 //x2=23.115 //y2=6.2
cc_1331 ( N_SN_M42_noxref_g N_noxref_10_M43_noxref_g ) capacitor c=0.0602553f \
 //x=22.675 //y=6.2 //x2=23.115 //y2=6.2
cc_1332 ( N_SN_M42_noxref_g N_noxref_10_M44_noxref_g ) capacitor c=0.0101598f \
 //x=22.675 //y=6.2 //x2=23.555 //y2=6.2
cc_1333 ( N_SN_c_1854_n N_noxref_10_c_2160_n ) capacitor c=0.00456962f \
 //x=10.885 //y=1.09 //x2=11.895 //y2=1.095
cc_1334 ( N_SN_c_1855_n N_noxref_10_c_2161_n ) capacitor c=0.00438372f \
 //x=10.885 //y=1.4 //x2=11.895 //y2=1.44
cc_1335 ( N_SN_c_1856_n N_noxref_10_c_2162_n ) capacitor c=0.00438372f \
 //x=10.885 //y=1.63 //x2=11.895 //y2=1.75
cc_1336 ( N_SN_c_1812_n N_noxref_10_c_2164_n ) capacitor c=3.13485e-19 \
 //x=22.15 //y=2.4 //x2=12.27 //y2=1.595
cc_1337 ( N_SN_c_1928_n N_noxref_10_c_2356_n ) capacitor c=0.00456962f \
 //x=22.355 //y=1.09 //x2=23.365 //y2=1.095
cc_1338 ( N_SN_c_1929_n N_noxref_10_c_2357_n ) capacitor c=0.00438372f \
 //x=22.355 //y=1.4 //x2=23.365 //y2=1.44
cc_1339 ( N_SN_c_1930_n N_noxref_10_c_2358_n ) capacitor c=0.00438372f \
 //x=22.355 //y=1.63 //x2=23.365 //y2=1.75
cc_1340 ( N_SN_c_1812_n N_noxref_10_c_2169_n ) capacitor c=0.00581478f \
 //x=22.15 //y=2.4 //x2=11.905 //y2=2.26
cc_1341 ( N_SN_c_1822_n N_noxref_10_c_2169_n ) capacitor c=2.3323e-19 \
 //x=10.91 //y=2.4 //x2=11.905 //y2=2.26
cc_1342 ( N_SN_c_1840_n N_noxref_10_c_2169_n ) capacitor c=0.00243514f \
 //x=10.795 //y=2.485 //x2=11.905 //y2=2.26
cc_1343 ( N_SN_c_1857_n N_noxref_10_c_2169_n ) capacitor c=0.00811422f \
 //x=10.885 //y=2.095 //x2=11.905 //y2=2.26
cc_1344 ( N_SN_c_1857_n N_noxref_10_c_2170_n ) capacitor c=0.00438372f \
 //x=10.885 //y=2.095 //x2=11.905 //y2=2.095
cc_1345 ( N_SN_c_1826_n N_noxref_10_c_2172_n ) capacitor c=0.00219458f \
 //x=10.795 //y=4.88 //x2=11.905 //y2=4.88
cc_1346 ( N_SN_c_1877_n N_noxref_10_c_2172_n ) capacitor c=0.0611812f \
 //x=11.13 //y=4.97 //x2=11.905 //y2=4.88
cc_1347 ( N_SN_c_1859_n N_noxref_10_c_2172_n ) capacitor c=0.00487508f \
 //x=10.795 //y=4.88 //x2=11.905 //y2=4.88
cc_1348 ( N_SN_c_1812_n N_noxref_10_c_2367_n ) capacitor c=0.0034041f \
 //x=22.15 //y=2.4 //x2=23.375 //y2=2.26
cc_1349 ( N_SN_c_1909_n N_noxref_10_c_2367_n ) capacitor c=0.00264042f \
 //x=22.265 //y=2.485 //x2=23.375 //y2=2.26
cc_1350 ( N_SN_c_1931_n N_noxref_10_c_2367_n ) capacitor c=0.00872421f \
 //x=22.355 //y=2.095 //x2=23.375 //y2=2.26
cc_1351 ( N_SN_c_1931_n N_noxref_10_c_2370_n ) capacitor c=0.00438372f \
 //x=22.355 //y=2.095 //x2=23.375 //y2=2.095
cc_1352 ( N_SN_c_1828_n N_noxref_10_c_2371_n ) capacitor c=0.00219458f \
 //x=22.265 //y=4.88 //x2=23.375 //y2=4.88
cc_1353 ( N_SN_c_1946_p N_noxref_10_c_2371_n ) capacitor c=0.0611812f //x=22.6 \
 //y=4.97 //x2=23.375 //y2=4.88
cc_1354 ( N_SN_c_1933_n N_noxref_10_c_2371_n ) capacitor c=0.00487508f \
 //x=22.265 //y=4.88 //x2=23.375 //y2=4.88
cc_1355 ( SN N_noxref_11_c_2441_n ) capacitor c=3.25852e-19 //x=22.32 //y=4.25 \
 //x2=22.37 //y2=5.335
cc_1356 ( SN N_noxref_11_c_2441_n ) capacitor c=0.00170644f //x=22.32 //y=4.62 \
 //x2=22.37 //y2=5.335
cc_1357 ( N_SN_c_1828_n N_noxref_11_c_2441_n ) capacitor c=0.0149705f \
 //x=22.265 //y=4.88 //x2=22.37 //y2=5.335
cc_1358 ( N_SN_M41_noxref_g N_noxref_11_c_2441_n ) capacitor c=0.0167692f \
 //x=22.235 //y=6.2 //x2=22.37 //y2=5.335
cc_1359 ( N_SN_c_1933_n N_noxref_11_c_2441_n ) capacitor c=0.00325274f \
 //x=22.265 //y=4.88 //x2=22.37 //y2=5.335
cc_1360 ( N_SN_M42_noxref_g N_noxref_11_c_2447_n ) capacitor c=0.019179f \
 //x=22.675 //y=6.2 //x2=23.25 //y2=5.335
cc_1361 ( N_SN_c_1812_n N_noxref_11_c_2438_n ) capacitor c=0.0511447f \
 //x=22.15 //y=2.4 //x2=24.115 //y2=3.51
cc_1362 ( SN N_noxref_11_c_2438_n ) capacitor c=0.00160622f //x=22.32 //y=3.14 \
 //x2=24.115 //y2=3.51
cc_1363 ( N_SN_c_1828_n N_noxref_11_c_2438_n ) capacitor c=5.75692e-19 \
 //x=22.265 //y=4.88 //x2=24.115 //y2=3.51
cc_1364 ( N_SN_c_1824_n N_noxref_11_c_2438_n ) capacitor c=2.07059e-19 \
 //x=22.292 //y=2.685 //x2=24.115 //y2=3.51
cc_1365 ( N_SN_c_1914_n N_noxref_11_c_2438_n ) capacitor c=2.17309e-19 \
 //x=22.292 //y=3.055 //x2=24.115 //y2=3.51
cc_1366 ( N_SN_c_1916_n N_noxref_11_c_2438_n ) capacitor c=0.0237646f \
 //x=22.292 //y=4.165 //x2=24.115 //y2=3.51
cc_1367 ( N_SN_c_1946_p N_noxref_11_c_2494_n ) capacitor c=0.00433172f \
 //x=22.6 //y=4.97 //x2=22.455 //y2=5.335
cc_1368 ( N_SN_M41_noxref_g N_noxref_11_M41_noxref_d ) capacitor c=0.0180032f \
 //x=22.235 //y=6.2 //x2=22.31 //y2=5.2
cc_1369 ( N_SN_M42_noxref_g N_noxref_11_M41_noxref_d ) capacitor c=0.0180032f \
 //x=22.675 //y=6.2 //x2=22.31 //y2=5.2
cc_1370 ( N_SN_c_1849_n N_noxref_16_c_2782_n ) capacitor c=0.0167228f \
 //x=10.36 //y=1.09 //x2=11.02 //y2=0.72
cc_1371 ( N_SN_c_1854_n N_noxref_16_c_2782_n ) capacitor c=0.00534519f \
 //x=10.885 //y=1.09 //x2=11.02 //y2=0.72
cc_1372 ( N_SN_c_1812_n N_noxref_16_c_2808_n ) capacitor c=0.00313179f \
 //x=22.15 //y=2.4 //x2=11.02 //y2=1.77
cc_1373 ( N_SN_c_1822_n N_noxref_16_c_2808_n ) capacitor c=0.00288204f \
 //x=10.91 //y=2.4 //x2=11.02 //y2=1.77
cc_1374 ( N_SN_c_1840_n N_noxref_16_c_2808_n ) capacitor c=0.0130202f \
 //x=10.795 //y=2.485 //x2=11.02 //y2=1.77
cc_1375 ( N_SN_c_1852_n N_noxref_16_c_2808_n ) capacitor c=0.0153695f \
 //x=10.36 //y=1.4 //x2=11.02 //y2=1.77
cc_1376 ( N_SN_c_1857_n N_noxref_16_c_2808_n ) capacitor c=0.0215736f \
 //x=10.885 //y=2.095 //x2=11.02 //y2=1.77
cc_1377 ( N_SN_c_1812_n N_noxref_16_M5_noxref_s ) capacitor c=0.00599513f \
 //x=22.15 //y=2.4 //x2=9.03 //y2=0.555
cc_1378 ( N_SN_c_1849_n N_noxref_16_M5_noxref_s ) capacitor c=0.00798959f \
 //x=10.36 //y=1.09 //x2=9.03 //y2=0.555
cc_1379 ( N_SN_c_1856_n N_noxref_16_M5_noxref_s ) capacitor c=0.00212176f \
 //x=10.885 //y=1.63 //x2=9.03 //y2=0.555
cc_1380 ( N_SN_c_1857_n N_noxref_16_M5_noxref_s ) capacitor c=0.00298115f \
 //x=10.885 //y=2.095 //x2=9.03 //y2=0.555
cc_1381 ( N_SN_c_1812_n N_noxref_17_c_2829_n ) capacitor c=0.00657782f \
 //x=22.15 //y=2.4 //x2=11.59 //y2=1.175
cc_1382 ( N_SN_c_2031_p N_noxref_17_c_2829_n ) capacitor c=2.14837e-19 \
 //x=10.73 //y=0.935 //x2=11.59 //y2=1.175
cc_1383 ( N_SN_c_1854_n N_noxref_17_c_2829_n ) capacitor c=0.00123426f \
 //x=10.885 //y=1.09 //x2=11.59 //y2=1.175
cc_1384 ( N_SN_c_1855_n N_noxref_17_c_2829_n ) capacitor c=0.0129288f \
 //x=10.885 //y=1.4 //x2=11.59 //y2=1.175
cc_1385 ( N_SN_c_1856_n N_noxref_17_c_2829_n ) capacitor c=0.00142359f \
 //x=10.885 //y=1.63 //x2=11.59 //y2=1.175
cc_1386 ( N_SN_c_1812_n N_noxref_17_c_2834_n ) capacitor c=0.00147946f \
 //x=22.15 //y=2.4 //x2=12.56 //y2=0.72
cc_1387 ( N_SN_c_1849_n N_noxref_17_M6_noxref_d ) capacitor c=0.00223875f \
 //x=10.36 //y=1.09 //x2=10.435 //y2=1.09
cc_1388 ( N_SN_c_1852_n N_noxref_17_M6_noxref_d ) capacitor c=0.00262485f \
 //x=10.36 //y=1.4 //x2=10.435 //y2=1.09
cc_1389 ( N_SN_c_2031_p N_noxref_17_M6_noxref_d ) capacitor c=0.00220746f \
 //x=10.73 //y=0.935 //x2=10.435 //y2=1.09
cc_1390 ( N_SN_c_2039_p N_noxref_17_M6_noxref_d ) capacitor c=0.00194798f \
 //x=10.73 //y=1.555 //x2=10.435 //y2=1.09
cc_1391 ( N_SN_c_1854_n N_noxref_17_M6_noxref_d ) capacitor c=0.00198465f \
 //x=10.885 //y=1.09 //x2=10.435 //y2=1.09
cc_1392 ( N_SN_c_1855_n N_noxref_17_M6_noxref_d ) capacitor c=0.00128384f \
 //x=10.885 //y=1.4 //x2=10.435 //y2=1.09
cc_1393 ( N_SN_c_1812_n N_noxref_17_M7_noxref_s ) capacitor c=0.00642985f \
 //x=22.15 //y=2.4 //x2=11.54 //y2=0.555
cc_1394 ( N_SN_c_1854_n N_noxref_17_M7_noxref_s ) capacitor c=7.21316e-19 \
 //x=10.885 //y=1.09 //x2=11.54 //y2=0.555
cc_1395 ( N_SN_c_1855_n N_noxref_17_M7_noxref_s ) capacitor c=0.00348171f \
 //x=10.885 //y=1.4 //x2=11.54 //y2=0.555
cc_1396 ( N_SN_c_1812_n N_noxref_18_c_2901_n ) capacitor c=0.00635755f \
 //x=22.15 //y=2.4 //x2=14.08 //y2=1.675
cc_1397 ( N_SN_c_1812_n N_noxref_18_c_2882_n ) capacitor c=0.0223494f \
 //x=22.15 //y=2.4 //x2=14.965 //y2=1.76
cc_1398 ( N_SN_c_1812_n N_noxref_18_c_2889_n ) capacitor c=0.00649228f \
 //x=22.15 //y=2.4 //x2=15.05 //y2=1.675
cc_1399 ( N_SN_c_1812_n N_noxref_18_c_2890_n ) capacitor c=0.00125967f \
 //x=22.15 //y=2.4 //x2=15.935 //y2=0.71
cc_1400 ( N_SN_c_1812_n N_noxref_18_M8_noxref_s ) capacitor c=0.00113237f \
 //x=22.15 //y=2.4 //x2=13.945 //y2=0.545
cc_1401 ( N_SN_c_1812_n N_noxref_19_c_2954_n ) capacitor c=0.00635755f \
 //x=22.15 //y=2.4 //x2=17.41 //y2=1.675
cc_1402 ( N_SN_c_1812_n N_noxref_19_c_2935_n ) capacitor c=0.0223494f \
 //x=22.15 //y=2.4 //x2=18.295 //y2=1.76
cc_1403 ( N_SN_c_1812_n N_noxref_19_c_2942_n ) capacitor c=0.00649228f \
 //x=22.15 //y=2.4 //x2=18.38 //y2=1.675
cc_1404 ( N_SN_c_1812_n N_noxref_19_c_2943_n ) capacitor c=0.00178534f \
 //x=22.15 //y=2.4 //x2=19.265 //y2=0.71
cc_1405 ( N_SN_c_1812_n N_noxref_19_M10_noxref_s ) capacitor c=7.06596e-19 \
 //x=22.15 //y=2.4 //x2=17.275 //y2=0.545
cc_1406 ( N_SN_c_1812_n N_noxref_20_c_3002_n ) capacitor c=0.00642985f \
 //x=22.15 //y=2.4 //x2=20.635 //y2=1.685
cc_1407 ( N_SN_c_1812_n N_noxref_20_c_2988_n ) capacitor c=0.0218593f \
 //x=22.15 //y=2.4 //x2=21.52 //y2=1.77
cc_1408 ( N_SN_c_1923_n N_noxref_20_c_2995_n ) capacitor c=0.0167228f \
 //x=21.83 //y=1.09 //x2=22.49 //y2=0.72
cc_1409 ( N_SN_c_1928_n N_noxref_20_c_2995_n ) capacitor c=0.00534519f \
 //x=22.355 //y=1.09 //x2=22.49 //y2=0.72
cc_1410 ( N_SN_c_1812_n N_noxref_20_c_3019_n ) capacitor c=0.0161937f \
 //x=22.15 //y=2.4 //x2=22.49 //y2=1.77
cc_1411 ( N_SN_c_1909_n N_noxref_20_c_3019_n ) capacitor c=0.0130142f \
 //x=22.265 //y=2.485 //x2=22.49 //y2=1.77
cc_1412 ( N_SN_c_1926_n N_noxref_20_c_3019_n ) capacitor c=0.0157358f \
 //x=21.83 //y=1.4 //x2=22.49 //y2=1.77
cc_1413 ( N_SN_c_1931_n N_noxref_20_c_3019_n ) capacitor c=0.0219947f \
 //x=22.355 //y=2.095 //x2=22.49 //y2=1.77
cc_1414 ( N_SN_c_1812_n N_noxref_20_M12_noxref_s ) capacitor c=0.00642985f \
 //x=22.15 //y=2.4 //x2=20.5 //y2=0.555
cc_1415 ( N_SN_c_1923_n N_noxref_20_M12_noxref_s ) capacitor c=0.00798959f \
 //x=21.83 //y=1.09 //x2=20.5 //y2=0.555
cc_1416 ( N_SN_c_1930_n N_noxref_20_M12_noxref_s ) capacitor c=0.00212176f \
 //x=22.355 //y=1.63 //x2=20.5 //y2=0.555
cc_1417 ( N_SN_c_1931_n N_noxref_20_M12_noxref_s ) capacitor c=0.00298115f \
 //x=22.355 //y=2.095 //x2=20.5 //y2=0.555
cc_1418 ( N_SN_c_2067_p N_noxref_21_c_3039_n ) capacitor c=2.14837e-19 \
 //x=22.2 //y=0.935 //x2=23.06 //y2=1.175
cc_1419 ( N_SN_c_1928_n N_noxref_21_c_3039_n ) capacitor c=0.00123426f \
 //x=22.355 //y=1.09 //x2=23.06 //y2=1.175
cc_1420 ( N_SN_c_1929_n N_noxref_21_c_3039_n ) capacitor c=0.0129288f \
 //x=22.355 //y=1.4 //x2=23.06 //y2=1.175
cc_1421 ( N_SN_c_1930_n N_noxref_21_c_3039_n ) capacitor c=0.00142359f \
 //x=22.355 //y=1.63 //x2=23.06 //y2=1.175
cc_1422 ( N_SN_c_1923_n N_noxref_21_M13_noxref_d ) capacitor c=0.00223875f \
 //x=21.83 //y=1.09 //x2=21.905 //y2=1.09
cc_1423 ( N_SN_c_1926_n N_noxref_21_M13_noxref_d ) capacitor c=0.00262485f \
 //x=21.83 //y=1.4 //x2=21.905 //y2=1.09
cc_1424 ( N_SN_c_2067_p N_noxref_21_M13_noxref_d ) capacitor c=0.00220746f \
 //x=22.2 //y=0.935 //x2=21.905 //y2=1.09
cc_1425 ( N_SN_c_2074_p N_noxref_21_M13_noxref_d ) capacitor c=0.00194798f \
 //x=22.2 //y=1.555 //x2=21.905 //y2=1.09
cc_1426 ( N_SN_c_1928_n N_noxref_21_M13_noxref_d ) capacitor c=0.00198465f \
 //x=22.355 //y=1.09 //x2=21.905 //y2=1.09
cc_1427 ( N_SN_c_1929_n N_noxref_21_M13_noxref_d ) capacitor c=0.00128384f \
 //x=22.355 //y=1.4 //x2=21.905 //y2=1.09
cc_1428 ( N_SN_c_1928_n N_noxref_21_M14_noxref_s ) capacitor c=7.21316e-19 \
 //x=22.355 //y=1.09 //x2=23.01 //y2=0.555
cc_1429 ( N_SN_c_1929_n N_noxref_21_M14_noxref_s ) capacitor c=0.00348171f \
 //x=22.355 //y=1.4 //x2=23.01 //y2=0.555
cc_1430 ( N_noxref_10_c_2082_n N_noxref_11_c_2445_n ) capacitor c=0.0135617f \
 //x=23.26 //y=3.88 //x2=21.66 //y2=5.335
cc_1431 ( N_noxref_10_M43_noxref_g N_noxref_11_c_2447_n ) capacitor \
 c=0.019179f //x=23.115 //y=6.2 //x2=23.25 //y2=5.335
cc_1432 ( N_noxref_10_c_2082_n N_noxref_11_c_2451_n ) capacitor c=0.00153992f \
 //x=23.26 //y=3.88 //x2=24.03 //y2=5.335
cc_1433 ( N_noxref_10_M44_noxref_g N_noxref_11_c_2451_n ) capacitor \
 c=0.0217141f //x=23.555 //y=6.2 //x2=24.03 //y2=5.335
cc_1434 ( N_noxref_10_c_2371_n N_noxref_11_c_2451_n ) capacitor c=0.00201851f \
 //x=23.375 //y=4.88 //x2=24.03 //y2=5.335
cc_1435 ( N_noxref_10_c_2379_p N_noxref_11_c_2437_n ) capacitor c=0.00359704f \
 //x=23.74 //y=1.595 //x2=24.03 //y2=1.845
cc_1436 ( N_noxref_10_c_2380_p N_noxref_11_c_2437_n ) capacitor c=0.00457401f \
 //x=23.895 //y=1.44 //x2=24.03 //y2=1.845
cc_1437 ( N_noxref_10_c_2082_n N_noxref_11_c_2438_n ) capacitor c=0.420763f \
 //x=23.26 //y=3.88 //x2=24.115 //y2=3.51
cc_1438 ( N_noxref_10_c_2087_n N_noxref_11_c_2438_n ) capacitor c=0.115201f \
 //x=23.375 //y=2.26 //x2=24.115 //y2=3.51
cc_1439 ( N_noxref_10_c_2367_n N_noxref_11_c_2438_n ) capacitor c=0.00772308f \
 //x=23.375 //y=2.26 //x2=24.115 //y2=3.51
cc_1440 ( N_noxref_10_c_2370_n N_noxref_11_c_2438_n ) capacitor c=0.00283672f \
 //x=23.375 //y=2.095 //x2=24.115 //y2=3.51
cc_1441 ( N_noxref_10_c_2371_n N_noxref_11_c_2438_n ) capacitor c=0.013844f \
 //x=23.375 //y=4.88 //x2=24.115 //y2=3.51
cc_1442 ( N_noxref_10_c_2082_n N_noxref_11_c_2494_n ) capacitor c=0.0179687f \
 //x=23.26 //y=3.88 //x2=22.455 //y2=5.335
cc_1443 ( N_noxref_10_c_2082_n N_noxref_11_c_2510_n ) capacitor c=5.7529e-19 \
 //x=23.26 //y=3.88 //x2=23.335 //y2=5.335
cc_1444 ( N_noxref_10_c_2087_n N_noxref_11_c_2510_n ) capacitor c=0.017024f \
 //x=23.375 //y=2.26 //x2=23.335 //y2=5.335
cc_1445 ( N_noxref_10_c_2371_n N_noxref_11_c_2510_n ) capacitor c=0.00476349f \
 //x=23.375 //y=4.88 //x2=23.335 //y2=5.335
cc_1446 ( N_noxref_10_c_2356_n N_noxref_11_M14_noxref_d ) capacitor \
 c=0.00217566f //x=23.365 //y=1.095 //x2=23.44 //y2=1.095
cc_1447 ( N_noxref_10_c_2357_n N_noxref_11_M14_noxref_d ) capacitor \
 c=0.0034598f //x=23.365 //y=1.44 //x2=23.44 //y2=1.095
cc_1448 ( N_noxref_10_c_2358_n N_noxref_11_M14_noxref_d ) capacitor \
 c=0.00544291f //x=23.365 //y=1.75 //x2=23.44 //y2=1.095
cc_1449 ( N_noxref_10_c_2393_p N_noxref_11_M14_noxref_d ) capacitor \
 c=0.00241102f //x=23.74 //y=0.94 //x2=23.44 //y2=1.095
cc_1450 ( N_noxref_10_c_2379_p N_noxref_11_M14_noxref_d ) capacitor \
 c=0.0140297f //x=23.74 //y=1.595 //x2=23.44 //y2=1.095
cc_1451 ( N_noxref_10_c_2395_p N_noxref_11_M14_noxref_d ) capacitor \
 c=0.00219619f //x=23.895 //y=1.095 //x2=23.44 //y2=1.095
cc_1452 ( N_noxref_10_c_2380_p N_noxref_11_M14_noxref_d ) capacitor \
 c=0.00603828f //x=23.895 //y=1.44 //x2=23.44 //y2=1.095
cc_1453 ( N_noxref_10_c_2370_n N_noxref_11_M14_noxref_d ) capacitor \
 c=0.00661782f //x=23.375 //y=2.095 //x2=23.44 //y2=1.095
cc_1454 ( N_noxref_10_M43_noxref_g N_noxref_11_M43_noxref_d ) capacitor \
 c=0.0180032f //x=23.115 //y=6.2 //x2=23.19 //y2=5.2
cc_1455 ( N_noxref_10_M44_noxref_g N_noxref_11_M43_noxref_d ) capacitor \
 c=0.0194246f //x=23.555 //y=6.2 //x2=23.19 //y2=5.2
cc_1456 ( N_noxref_10_c_2083_n N_noxref_15_c_2727_n ) capacitor c=0.0020642f \
 //x=7.095 //y=2.26 //x2=7.75 //y2=0.72
cc_1457 ( N_noxref_10_c_2225_n N_noxref_15_c_2727_n ) capacitor c=0.0194423f \
 //x=7.085 //y=1.095 //x2=7.75 //y2=0.72
cc_1458 ( N_noxref_10_c_2280_n N_noxref_15_c_2727_n ) capacitor c=0.00656458f \
 //x=7.615 //y=1.095 //x2=7.75 //y2=0.72
cc_1459 ( N_noxref_10_c_2140_n N_noxref_15_c_2727_n ) capacitor c=2.20712e-19 \
 //x=7.095 //y=2.26 //x2=7.75 //y2=0.72
cc_1460 ( N_noxref_10_c_2226_n N_noxref_15_c_2753_n ) capacitor c=0.00538033f \
 //x=7.085 //y=1.44 //x2=6.865 //y2=1.175
cc_1461 ( N_noxref_10_c_2225_n N_noxref_15_M4_noxref_s ) capacitor \
 c=0.00538033f //x=7.085 //y=1.095 //x2=6.73 //y2=0.555
cc_1462 ( N_noxref_10_c_2227_n N_noxref_15_M4_noxref_s ) capacitor \
 c=0.00538033f //x=7.085 //y=1.75 //x2=6.73 //y2=0.555
cc_1463 ( N_noxref_10_c_2280_n N_noxref_15_M4_noxref_s ) capacitor \
 c=0.0143002f //x=7.615 //y=1.095 //x2=6.73 //y2=0.555
cc_1464 ( N_noxref_10_c_2281_n N_noxref_15_M4_noxref_s ) capacitor \
 c=0.00290153f //x=7.615 //y=1.44 //x2=6.73 //y2=0.555
cc_1465 ( N_noxref_10_c_2079_n N_noxref_16_c_2775_n ) capacitor c=0.00208074f \
 //x=11.79 //y=3.88 //x2=10.05 //y2=1.77
cc_1466 ( N_noxref_10_c_2079_n N_noxref_16_c_2808_n ) capacitor c=0.00393278f \
 //x=11.79 //y=3.88 //x2=11.02 //y2=1.77
cc_1467 ( N_noxref_10_c_2079_n N_noxref_16_M5_noxref_s ) capacitor \
 c=0.00188576f //x=11.79 //y=3.88 //x2=9.03 //y2=0.555
cc_1468 ( N_noxref_10_c_2084_n N_noxref_17_c_2834_n ) capacitor c=0.00204385f \
 //x=11.905 //y=2.26 //x2=12.56 //y2=0.72
cc_1469 ( N_noxref_10_c_2160_n N_noxref_17_c_2834_n ) capacitor c=0.0194423f \
 //x=11.895 //y=1.095 //x2=12.56 //y2=0.72
cc_1470 ( N_noxref_10_c_2166_n N_noxref_17_c_2834_n ) capacitor c=0.00656458f \
 //x=12.425 //y=1.095 //x2=12.56 //y2=0.72
cc_1471 ( N_noxref_10_c_2169_n N_noxref_17_c_2834_n ) capacitor c=2.20712e-19 \
 //x=11.905 //y=2.26 //x2=12.56 //y2=0.72
cc_1472 ( N_noxref_10_c_2161_n N_noxref_17_c_2845_n ) capacitor c=0.00538829f \
 //x=11.895 //y=1.44 //x2=11.675 //y2=1.175
cc_1473 ( N_noxref_10_c_2160_n N_noxref_17_M7_noxref_s ) capacitor \
 c=0.00538829f //x=11.895 //y=1.095 //x2=11.54 //y2=0.555
cc_1474 ( N_noxref_10_c_2162_n N_noxref_17_M7_noxref_s ) capacitor \
 c=0.00538829f //x=11.895 //y=1.75 //x2=11.54 //y2=0.555
cc_1475 ( N_noxref_10_c_2166_n N_noxref_17_M7_noxref_s ) capacitor \
 c=0.0143002f //x=12.425 //y=1.095 //x2=11.54 //y2=0.555
cc_1476 ( N_noxref_10_c_2167_n N_noxref_17_M7_noxref_s ) capacitor \
 c=0.00290153f //x=12.425 //y=1.44 //x2=11.54 //y2=0.555
cc_1477 ( N_noxref_10_c_2331_n N_noxref_18_c_2901_n ) capacitor c=3.15806e-19 \
 //x=15.62 //y=1.835 //x2=14.08 //y2=1.675
cc_1478 ( N_noxref_10_c_2331_n N_noxref_18_c_2889_n ) capacitor c=0.020324f \
 //x=15.62 //y=1.835 //x2=15.05 //y2=1.675
cc_1479 ( N_noxref_10_c_2085_n N_noxref_18_c_2890_n ) capacitor c=0.00457164f \
 //x=15.89 //y=1.835 //x2=15.935 //y2=0.71
cc_1480 ( N_noxref_10_M9_noxref_d N_noxref_18_c_2890_n ) capacitor \
 c=0.0115831f //x=15.345 //y=1.085 //x2=15.935 //y2=0.71
cc_1481 ( N_noxref_10_c_2085_n N_noxref_18_M8_noxref_s ) capacitor c=0.013435f \
 //x=15.89 //y=1.835 //x2=13.945 //y2=0.545
cc_1482 ( N_noxref_10_M9_noxref_d N_noxref_18_M8_noxref_s ) capacitor \
 c=0.0439476f //x=15.345 //y=1.085 //x2=13.945 //y2=0.545
cc_1483 ( N_noxref_10_c_2085_n N_noxref_19_c_2954_n ) capacitor c=3.22188e-19 \
 //x=15.89 //y=1.835 //x2=17.41 //y2=1.675
cc_1484 ( N_noxref_10_c_2087_n N_noxref_21_c_3044_n ) capacitor c=0.00208576f \
 //x=23.375 //y=2.26 //x2=24.03 //y2=0.72
cc_1485 ( N_noxref_10_c_2356_n N_noxref_21_c_3044_n ) capacitor c=0.0194423f \
 //x=23.365 //y=1.095 //x2=24.03 //y2=0.72
cc_1486 ( N_noxref_10_c_2395_p N_noxref_21_c_3044_n ) capacitor c=0.00656458f \
 //x=23.895 //y=1.095 //x2=24.03 //y2=0.72
cc_1487 ( N_noxref_10_c_2367_n N_noxref_21_c_3044_n ) capacitor c=2.20712e-19 \
 //x=23.375 //y=2.26 //x2=24.03 //y2=0.72
cc_1488 ( N_noxref_10_c_2357_n N_noxref_21_c_3067_n ) capacitor c=0.00538829f \
 //x=23.365 //y=1.44 //x2=23.145 //y2=1.175
cc_1489 ( N_noxref_10_c_2356_n N_noxref_21_M14_noxref_s ) capacitor \
 c=0.00538829f //x=23.365 //y=1.095 //x2=23.01 //y2=0.555
cc_1490 ( N_noxref_10_c_2358_n N_noxref_21_M14_noxref_s ) capacitor \
 c=0.00538829f //x=23.365 //y=1.75 //x2=23.01 //y2=0.555
cc_1491 ( N_noxref_10_c_2395_p N_noxref_21_M14_noxref_s ) capacitor \
 c=0.0143002f //x=23.895 //y=1.095 //x2=23.01 //y2=0.555
cc_1492 ( N_noxref_10_c_2380_p N_noxref_21_M14_noxref_s ) capacitor \
 c=0.00290153f //x=23.895 //y=1.44 //x2=23.01 //y2=0.555
cc_1493 ( N_noxref_11_c_2438_n N_noxref_20_c_3019_n ) capacitor c=0.001384f \
 //x=24.115 //y=3.51 //x2=22.49 //y2=1.77
cc_1494 ( N_noxref_11_c_2438_n N_noxref_20_M12_noxref_s ) capacitor \
 c=0.00227057f //x=24.115 //y=3.51 //x2=20.5 //y2=0.555
cc_1495 ( N_noxref_11_M14_noxref_d N_noxref_20_M12_noxref_s ) capacitor \
 c=0.00309936f //x=23.44 //y=1.095 //x2=20.5 //y2=0.555
cc_1496 ( N_noxref_11_c_2438_n N_noxref_21_c_3039_n ) capacitor c=0.00306157f \
 //x=24.115 //y=3.51 //x2=23.06 //y2=1.175
cc_1497 ( N_noxref_11_c_2437_n N_noxref_21_c_3044_n ) capacitor c=0.00466084f \
 //x=24.03 //y=1.845 //x2=24.03 //y2=0.72
cc_1498 ( N_noxref_11_c_2438_n N_noxref_21_c_3044_n ) capacitor c=5.19687e-19 \
 //x=24.115 //y=3.51 //x2=24.03 //y2=0.72
cc_1499 ( N_noxref_11_M14_noxref_d N_noxref_21_c_3044_n ) capacitor \
 c=0.0117786f //x=23.44 //y=1.095 //x2=24.03 //y2=0.72
cc_1500 ( N_noxref_11_c_2530_p N_noxref_21_c_3067_n ) capacitor c=0.0200405f \
 //x=23.715 //y=1.845 //x2=23.145 //y2=1.175
cc_1501 ( N_noxref_11_M14_noxref_d N_noxref_21_M13_noxref_d ) capacitor \
 c=5.27807e-19 //x=23.44 //y=1.095 //x2=21.905 //y2=1.09
cc_1502 ( N_noxref_11_c_2437_n N_noxref_21_M14_noxref_s ) capacitor \
 c=0.020752f //x=24.03 //y=1.845 //x2=23.01 //y2=0.555
cc_1503 ( N_noxref_11_c_2438_n N_noxref_21_M14_noxref_s ) capacitor \
 c=0.00243521f //x=24.115 //y=3.51 //x2=23.01 //y2=0.555
cc_1504 ( N_noxref_11_M14_noxref_d N_noxref_21_M14_noxref_s ) capacitor \
 c=0.0426368f //x=23.44 //y=1.095 //x2=23.01 //y2=0.555
cc_1505 ( N_D_c_2540_n N_noxref_13_c_2639_n ) capacitor c=0.0034165f //x=1.35 \
 //y=2.095 //x2=1.13 //y2=1.675
cc_1506 ( D N_noxref_13_c_2620_n ) capacitor c=2.91115e-19 //x=1.6 //y=2.77 \
 //x2=2.015 //y2=1.76
cc_1507 ( N_D_c_2535_n N_noxref_13_c_2620_n ) capacitor c=0.0135597f //x=1.545 \
 //y=2.485 //x2=2.015 //y2=1.76
cc_1508 ( N_D_c_2539_n N_noxref_13_c_2620_n ) capacitor c=0.00703567f //x=1.35 \
 //y=1.7 //x2=2.015 //y2=1.76
cc_1509 ( N_D_c_2540_n N_noxref_13_c_2620_n ) capacitor c=0.0209414f //x=1.35 \
 //y=2.095 //x2=2.015 //y2=1.76
cc_1510 ( N_D_c_2542_n N_noxref_13_c_2620_n ) capacitor c=0.00781703f \
 //x=1.725 //y=1.545 //x2=2.015 //y2=1.76
cc_1511 ( N_D_c_2545_n N_noxref_13_c_2620_n ) capacitor c=0.00339872f //x=1.88 \
 //y=1.39 //x2=2.015 //y2=1.76
cc_1512 ( N_D_c_2540_n N_noxref_13_c_2627_n ) capacitor c=6.71402e-19 //x=1.35 \
 //y=2.095 //x2=2.1 //y2=1.675
cc_1513 ( N_D_c_2536_n N_noxref_13_M0_noxref_s ) capacitor c=0.0326577f \
 //x=1.35 //y=1.045 //x2=0.995 //y2=0.545
cc_1514 ( N_D_c_2539_n N_noxref_13_M0_noxref_s ) capacitor c=3.48408e-19 \
 //x=1.35 //y=1.7 //x2=0.995 //y2=0.545
cc_1515 ( N_D_c_2543_n N_noxref_13_M0_noxref_s ) capacitor c=0.0120759f \
 //x=1.88 //y=1.045 //x2=0.995 //y2=0.545
cc_1516 ( N_noxref_13_c_2631_n N_noxref_14_M2_noxref_s ) capacitor \
 c=0.00199452f //x=3.07 //y=0.795 //x2=4.22 //y2=0.555
cc_1517 ( N_noxref_14_c_2676_n N_noxref_15_c_2722_n ) capacitor c=0.0133059f \
 //x=6.21 //y=0.72 //x2=6.78 //y2=1.175
cc_1518 ( N_noxref_14_c_2696_n N_noxref_15_c_2722_n ) capacitor c=0.0100097f \
 //x=6.21 //y=1.77 //x2=6.78 //y2=1.175
cc_1519 ( N_noxref_14_M2_noxref_s N_noxref_15_c_2722_n ) capacitor \
 c=0.0224457f //x=4.22 //y=0.555 //x2=6.78 //y2=1.175
cc_1520 ( N_noxref_14_M2_noxref_s N_noxref_15_c_2724_n ) capacitor \
 c=0.0180035f //x=4.22 //y=0.555 //x2=6.865 //y2=0.805
cc_1521 ( N_noxref_14_c_2676_n N_noxref_15_M3_noxref_d ) capacitor \
 c=0.0128027f //x=6.21 //y=0.72 //x2=5.625 //y2=1.09
cc_1522 ( N_noxref_14_c_2696_n N_noxref_15_M3_noxref_d ) capacitor \
 c=0.00879751f //x=6.21 //y=1.77 //x2=5.625 //y2=1.09
cc_1523 ( N_noxref_14_M2_noxref_s N_noxref_15_M3_noxref_d ) capacitor \
 c=0.0159202f //x=4.22 //y=0.555 //x2=5.625 //y2=1.09
cc_1524 ( N_noxref_14_M2_noxref_s N_noxref_15_M4_noxref_s ) capacitor \
 c=0.0213553f //x=4.22 //y=0.555 //x2=6.73 //y2=0.555
cc_1525 ( N_noxref_15_c_2730_n N_noxref_16_M5_noxref_s ) capacitor \
 c=0.00191848f //x=7.835 //y=0.805 //x2=9.03 //y2=0.555
cc_1526 ( N_noxref_16_c_2782_n N_noxref_17_c_2829_n ) capacitor c=0.0131801f \
 //x=11.02 //y=0.72 //x2=11.59 //y2=1.175
cc_1527 ( N_noxref_16_c_2808_n N_noxref_17_c_2829_n ) capacitor c=0.00980353f \
 //x=11.02 //y=1.77 //x2=11.59 //y2=1.175
cc_1528 ( N_noxref_16_M5_noxref_s N_noxref_17_c_2829_n ) capacitor \
 c=0.0221661f //x=9.03 //y=0.555 //x2=11.59 //y2=1.175
cc_1529 ( N_noxref_16_M5_noxref_s N_noxref_17_c_2831_n ) capacitor \
 c=0.0180035f //x=9.03 //y=0.555 //x2=11.675 //y2=0.805
cc_1530 ( N_noxref_16_c_2782_n N_noxref_17_M6_noxref_d ) capacitor \
 c=0.0128434f //x=11.02 //y=0.72 //x2=10.435 //y2=1.09
cc_1531 ( N_noxref_16_c_2808_n N_noxref_17_M6_noxref_d ) capacitor \
 c=0.00886823f //x=11.02 //y=1.77 //x2=10.435 //y2=1.09
cc_1532 ( N_noxref_16_M5_noxref_s N_noxref_17_M6_noxref_d ) capacitor \
 c=0.0159202f //x=9.03 //y=0.555 //x2=10.435 //y2=1.09
cc_1533 ( N_noxref_16_M5_noxref_s N_noxref_17_M7_noxref_s ) capacitor \
 c=0.0213553f //x=9.03 //y=0.555 //x2=11.54 //y2=0.555
cc_1534 ( N_noxref_17_c_2837_n N_noxref_18_M8_noxref_s ) capacitor \
 c=0.00164795f //x=12.645 //y=0.805 //x2=13.945 //y2=0.545
cc_1535 ( N_noxref_18_c_2893_n N_noxref_19_M10_noxref_s ) capacitor \
 c=0.00174327f //x=16.02 //y=0.795 //x2=17.275 //y2=0.545
cc_1536 ( N_noxref_19_c_2946_n N_noxref_20_M12_noxref_s ) capacitor \
 c=0.00199452f //x=19.35 //y=0.795 //x2=20.5 //y2=0.555
cc_1537 ( N_noxref_20_c_2995_n N_noxref_21_c_3039_n ) capacitor c=0.0132499f \
 //x=22.49 //y=0.72 //x2=23.06 //y2=1.175
cc_1538 ( N_noxref_20_c_3019_n N_noxref_21_c_3039_n ) capacitor c=0.00990814f \
 //x=22.49 //y=1.77 //x2=23.06 //y2=1.175
cc_1539 ( N_noxref_20_M12_noxref_s N_noxref_21_c_3039_n ) capacitor \
 c=0.0227445f //x=20.5 //y=0.555 //x2=23.06 //y2=1.175
cc_1540 ( N_noxref_20_M12_noxref_s N_noxref_21_c_3041_n ) capacitor \
 c=0.0180035f //x=20.5 //y=0.555 //x2=23.145 //y2=0.805
cc_1541 ( N_noxref_20_c_2995_n N_noxref_21_M13_noxref_d ) capacitor \
 c=0.0127176f //x=22.49 //y=0.72 //x2=21.905 //y2=1.09
cc_1542 ( N_noxref_20_c_3019_n N_noxref_21_M13_noxref_d ) capacitor \
 c=0.0086073f //x=22.49 //y=1.77 //x2=21.905 //y2=1.09
cc_1543 ( N_noxref_20_M12_noxref_s N_noxref_21_M13_noxref_d ) capacitor \
 c=0.0159202f //x=20.5 //y=0.555 //x2=21.905 //y2=1.09
cc_1544 ( N_noxref_20_M12_noxref_s N_noxref_21_M14_noxref_s ) capacitor \
 c=0.0213553f //x=20.5 //y=0.555 //x2=23.01 //y2=0.555
