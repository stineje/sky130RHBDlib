// File: TIEHI.spi.pex
// Created: Tue Apr 29 10:44:27 2025
// Program "Calibre xRC"
// Version "v2023.2_27.15"
// Nominal Temperature: 30C
// Circuit Temperature: 30C
//
simulator lang=spectre
subckt PM_TIEHI\%GND ( 1 7 19 23 35 41 48 )
c23 ( 48 0 ) capacitor c=0.0630825f //x=0.985 //y=0.545
c24 ( 41 0 ) capacitor c=0.259135f //x=2.09 //y=0.175
c25 ( 35 0 ) capacitor c=0.211805f //x=1.12 //y=0.175
c26 ( 26 0 ) capacitor c=0.00576908f //x=2.09 //y=0.625
c27 ( 23 0 ) capacitor c=0.00782031f //x=2.005 //y=0.71
c28 ( 22 0 ) capacitor c=0.00468229f //x=1.6 //y=0.625
c29 ( 19 0 ) capacitor c=0.00525773f //x=1.515 //y=0.71
c30 ( 14 0 ) capacitor c=0.00578481f //x=1.12 //y=0.625
c31 ( 7 0 ) capacitor c=0.145824f //x=1.97 //y=0.18
r32 (  40 41 ) resistor r=4.18529 //w=0.367 //l=0.12 //layer=li \
 //thickness=0.1 //x=1.97 //y=0.175 //x2=2.09 //y2=0.175
r33 (  38 40 ) resistor r=12.9046 //w=0.367 //l=0.37 //layer=li \
 //thickness=0.1 //x=1.6 //y=0.175 //x2=1.97 //y2=0.175
r34 (  37 38 ) resistor r=12.9046 //w=0.367 //l=0.37 //layer=li \
 //thickness=0.1 //x=1.23 //y=0.175 //x2=1.6 //y2=0.175
r35 (  35 37 ) resistor r=3.83651 //w=0.367 //l=0.11 //layer=li \
 //thickness=0.1 //x=1.12 //y=0.175 //x2=1.23 //y2=0.175
r36 (  27 48 ) resistor r=5.4201 //w=0.17 //l=0.085 //layer=li //thickness=0.1 \
 //x=2.09 //y=0.795 //x2=2.09 //y2=0.71
r37 (  27 48 ) resistor r=41.4118 //w=0.187 //l=0.605 //layer=li \
 //thickness=0.1 //x=2.09 //y=0.795 //x2=2.09 //y2=1.4
r38 (  26 48 ) resistor r=5.4201 //w=0.17 //l=0.085 //layer=li //thickness=0.1 \
 //x=2.09 //y=0.625 //x2=2.09 //y2=0.71
r39 (  25 41 ) resistor r=5.21862 //w=0.35 //l=0.175 //layer=li \
 //thickness=0.1 //x=2.09 //y=0.35 //x2=2.09 //y2=0.175
r40 (  25 26 ) resistor r=18.8235 //w=0.187 //l=0.275 //layer=li \
 //thickness=0.1 //x=2.09 //y=0.35 //x2=2.09 //y2=0.625
r41 (  24 48 ) resistor r=5.4201 //w=0.17 //l=0.085 //layer=li //thickness=0.1 \
 //x=1.685 //y=0.71 //x2=1.6 //y2=0.71
r42 (  23 48 ) resistor r=1.40859 //w=0.34 //l=0.085 //layer=li \
 //thickness=0.1 //x=2.005 //y=0.71 //x2=2.09 //y2=0.71
r43 (  23 24 ) resistor r=21.9037 //w=0.187 //l=0.32 //layer=li \
 //thickness=0.1 //x=2.005 //y=0.71 //x2=1.685 //y2=0.71
r44 (  22 48 ) resistor r=1.40859 //w=0.34 //l=0.085 //layer=li \
 //thickness=0.1 //x=1.6 //y=0.625 //x2=1.6 //y2=0.71
r45 (  21 38 ) resistor r=5.21862 //w=0.35 //l=0.175 //layer=li \
 //thickness=0.1 //x=1.6 //y=0.35 //x2=1.6 //y2=0.175
r46 (  21 22 ) resistor r=18.8235 //w=0.187 //l=0.275 //layer=li \
 //thickness=0.1 //x=1.6 //y=0.35 //x2=1.6 //y2=0.625
r47 (  20 48 ) resistor r=1.40859 //w=0.34 //l=0.085 //layer=li \
 //thickness=0.1 //x=1.205 //y=0.71 //x2=1.12 //y2=0.71
r48 (  19 48 ) resistor r=5.4201 //w=0.17 //l=0.085 //layer=li //thickness=0.1 \
 //x=1.515 //y=0.71 //x2=1.6 //y2=0.71
r49 (  19 20 ) resistor r=21.2193 //w=0.187 //l=0.31 //layer=li \
 //thickness=0.1 //x=1.515 //y=0.71 //x2=1.205 //y2=0.71
r50 (  15 48 ) resistor r=5.4201 //w=0.17 //l=0.085 //layer=li //thickness=0.1 \
 //x=1.12 //y=0.795 //x2=1.12 //y2=0.71
r51 (  15 48 ) resistor r=41.4118 //w=0.187 //l=0.605 //layer=li \
 //thickness=0.1 //x=1.12 //y=0.795 //x2=1.12 //y2=1.4
r52 (  14 48 ) resistor r=5.4201 //w=0.17 //l=0.085 //layer=li //thickness=0.1 \
 //x=1.12 //y=0.625 //x2=1.12 //y2=0.71
r53 (  13 35 ) resistor r=5.21862 //w=0.35 //l=0.175 //layer=li \
 //thickness=0.1 //x=1.12 //y=0.35 //x2=1.12 //y2=0.175
r54 (  13 14 ) resistor r=18.8235 //w=0.187 //l=0.275 //layer=li \
 //thickness=0.1 //x=1.12 //y=0.35 //x2=1.12 //y2=0.625
r55 (  7 40 ) resistor r=4.65 //w=0.17 //l=0.34 //layer=mcon //count=2 \
 //x=1.97 //y=0.18 //x2=1.97 //y2=0.18
r56 (  3 37 ) resistor r=3.1 //w=0.17 //l=0.51 //layer=mcon //count=3 //x=1.23 \
 //y=0.18 //x2=1.23 //y2=0.18
r57 (  1 7 ) resistor r=0.148714 //w=0.311 //l=0.37 //layer=m1 \
 //thickness=0.36 //x=1.6 //y=0.175 //x2=1.97 //y2=0.175
r58 (  1 3 ) resistor r=0.148714 //w=0.311 //l=0.37 //layer=m1 \
 //thickness=0.36 //x=1.6 //y=0.175 //x2=1.23 //y2=0.175
ends PM_TIEHI\%GND

subckt PM_TIEHI\%VDD ( 1 7 19 32 34 35 36 )
c19 ( 36 0 ) capacitor c=0.0502404f //x=1.895 //y=5.2
c20 ( 35 0 ) capacitor c=0.0446712f //x=1.025 //y=5.2
c21 ( 34 0 ) capacitor c=0.256582f //x=1.97 //y=7.58
c22 ( 32 0 ) capacitor c=0.251657f //x=1.23 //y=7.58
c23 ( 19 0 ) capacitor c=0.0296945f //x=1.955 //y=7.585
c24 ( 7 0 ) capacitor c=0.14636f //x=1.97 //y=7.58
r25 (  21 34 ) resistor r=4.23183 //w=0.7 //l=0.175 //layer=li //thickness=0.1 \
 //x=2.04 //y=7.41 //x2=2.04 //y2=7.585
r26 (  21 36 ) resistor r=56.4706 //w=0.187 //l=0.825 //layer=li \
 //thickness=0.1 //x=2.04 //y=7.41 //x2=2.04 //y2=6.585
r27 (  20 32 ) resistor r=2.87058 //w=0.35 //l=0.085 //layer=li \
 //thickness=0.1 //x=1.245 //y=7.585 //x2=1.16 //y2=7.585
r28 (  19 34 ) resistor r=2.87058 //w=0.35 //l=0.085 //layer=li \
 //thickness=0.1 //x=1.955 //y=7.585 //x2=2.04 //y2=7.585
r29 (  19 20 ) resistor r=24.7629 //w=0.367 //l=0.71 //layer=li \
 //thickness=0.1 //x=1.955 //y=7.585 //x2=1.245 //y2=7.585
r30 (  13 32 ) resistor r=4.23183 //w=0.7 //l=0.175 //layer=li //thickness=0.1 \
 //x=1.16 //y=7.41 //x2=1.16 //y2=7.585
r31 (  13 35 ) resistor r=56.4706 //w=0.187 //l=0.825 //layer=li \
 //thickness=0.1 //x=1.16 //y=7.41 //x2=1.16 //y2=6.585
r32 (  7 34 ) resistor r=4.65 //w=0.17 //l=0.34 //layer=mcon //count=2 \
 //x=1.97 //y=7.58 //x2=1.97 //y2=7.58
r33 (  3 32 ) resistor r=3.1 //w=0.17 //l=0.51 //layer=mcon //count=3 //x=1.23 \
 //y=7.58 //x2=1.23 //y2=7.58
r34 (  1 7 ) resistor r=0.148714 //w=0.311 //l=0.37 //layer=m1 \
 //thickness=0.36 //x=1.6 //y=7.585 //x2=1.97 //y2=7.585
r35 (  1 3 ) resistor r=0.148714 //w=0.311 //l=0.37 //layer=m1 \
 //thickness=0.36 //x=1.6 //y=7.585 //x2=1.23 //y2=7.585
ends PM_TIEHI\%VDD

subckt PM_TIEHI\%noxref_3 ( 1 3 5 13 14 15 16 19 23 24 25 33 34 36 44 )
c37 ( 44 0 ) capacitor c=0.0148159f //x=1.415 //y=1.085
c38 ( 36 0 ) capacitor c=0.0557436f //x=1.23 //y=2.26
c39 ( 34 0 ) capacitor c=0.0450427f //x=1.87 //y=1.43
c40 ( 33 0 ) capacitor c=0.0200386f //x=1.87 //y=1.085
c41 ( 27 0 ) capacitor c=0.0154936f //x=1.715 //y=1.585
c42 ( 25 0 ) capacitor c=0.0157804f //x=1.715 //y=0.93
c43 ( 24 0 ) capacitor c=0.0518706f //x=1.455 //y=4.97
c44 ( 23 0 ) capacitor c=0.0366644f //x=1.745 //y=4.97
c45 ( 19 0 ) capacitor c=0.0290017f //x=1.34 //y=2.095
c46 ( 18 0 ) capacitor c=0.0250027f //x=1.34 //y=1.74
c47 ( 17 0 ) capacitor c=0.0234316f //x=1.34 //y=1.43
c48 ( 16 0 ) capacitor c=0.0200596f //x=1.34 //y=1.085
c49 ( 15 0 ) capacitor c=0.153902f //x=1.82 //y=6.2
c50 ( 14 0 ) capacitor c=0.153904f //x=1.38 //y=6.2
c51 ( 5 0 ) capacitor c=0.0148044f //x=1.515 //y=2.18
c52 ( 3 0 ) capacitor c=0.128829f //x=1.23 //y=4.88
c53 ( 1 0 ) capacitor c=0.00308272f //x=1.23 //y=2.265
r54 (  36 37 ) resistor r=17.5563 //w=0.302 //l=0.11 //layer=ply \
 //thickness=0.18 //x=1.23 //y=2.26 //x2=1.34 //y2=2.26
r55 (  34 43 ) resistor r=45.1352 //w=0.168 //l=0.173853 //layer=ply \
 //thickness=0.18 //x=1.87 //y=1.43 //x2=1.83 //y2=1.585
r56 (  33 42 ) resistor r=45.1352 //w=0.168 //l=0.173853 //layer=ply \
 //thickness=0.18 //x=1.87 //y=1.085 //x2=1.83 //y2=0.93
r57 (  33 34 ) resistor r=176.904 //w=0.094 //l=0.345 //layer=ply \
 //thickness=0.18 //x=1.87 //y=1.085 //x2=1.87 //y2=1.43
r58 (  28 41 ) resistor r=10.701 //w=0.21 //l=0.115 //layer=ply \
 //thickness=0.18 //x=1.495 //y=1.585 //x2=1.38 //y2=1.585
r59 (  27 43 ) resistor r=5.52526 //w=0.168 //l=0.115 //layer=ply \
 //thickness=0.18 //x=1.715 //y=1.585 //x2=1.83 //y2=1.585
r60 (  26 40 ) resistor r=5.52526 //w=0.168 //l=0.115 //layer=ply \
 //thickness=0.18 //x=1.495 //y=0.93 //x2=1.38 //y2=0.93
r61 (  25 42 ) resistor r=5.52526 //w=0.168 //l=0.115 //layer=ply \
 //thickness=0.18 //x=1.715 //y=0.93 //x2=1.83 //y2=0.93
r62 (  25 26 ) resistor r=112.809 //w=0.094 //l=0.22 //layer=ply \
 //thickness=0.18 //x=1.715 //y=0.93 //x2=1.495 //y2=0.93
r63 (  23 30 ) resistor r=26.9307 //w=0.15 //l=0.106066 //layer=ply \
 //thickness=0.18 //x=1.745 //y=4.97 //x2=1.82 //y2=5.045
r64 (  23 24 ) resistor r=148.702 //w=0.094 //l=0.29 //layer=ply \
 //thickness=0.18 //x=1.745 //y=4.97 //x2=1.455 //y2=4.97
r65 (  20 24 ) resistor r=23.4449 //w=0.285 //l=0.106066 //layer=ply \
 //thickness=0.18 //x=1.38 //y=5.045 //x2=1.455 //y2=4.97
r66 (  20 39 ) resistor r=25.3684 //w=0.285 //l=0.22798 //layer=ply \
 //thickness=0.18 //x=1.38 //y=5.045 //x2=1.23 //y2=4.88
r67 (  19 37 ) resistor r=19.1248 //w=0.302 //l=0.165 //layer=ply \
 //thickness=0.18 //x=1.34 //y=2.095 //x2=1.34 //y2=2.26
r68 (  18 41 ) resistor r=39.5823 //w=0.21 //l=0.173853 //layer=ply \
 //thickness=0.18 //x=1.34 //y=1.74 //x2=1.38 //y2=1.585
r69 (  18 19 ) resistor r=182.032 //w=0.094 //l=0.355 //layer=ply \
 //thickness=0.18 //x=1.34 //y=1.74 //x2=1.34 //y2=2.095
r70 (  17 41 ) resistor r=39.5823 //w=0.21 //l=0.173853 //layer=ply \
 //thickness=0.18 //x=1.34 //y=1.43 //x2=1.38 //y2=1.585
r71 (  16 40 ) resistor r=45.1352 //w=0.168 //l=0.173853 //layer=ply \
 //thickness=0.18 //x=1.34 //y=1.085 //x2=1.38 //y2=0.93
r72 (  16 17 ) resistor r=176.904 //w=0.094 //l=0.345 //layer=ply \
 //thickness=0.18 //x=1.34 //y=1.085 //x2=1.34 //y2=1.43
r73 (  15 30 ) resistor r=592.245 //w=0.094 //l=1.155 //layer=ply \
 //thickness=0.18 //x=1.82 //y=6.2 //x2=1.82 //y2=5.045
r74 (  14 20 ) resistor r=592.245 //w=0.094 //l=1.155 //layer=ply \
 //thickness=0.18 //x=1.38 //y=6.2 //x2=1.38 //y2=5.045
r75 (  13 27 ) resistor r=56.4043 //w=0.094 //l=0.11 //layer=ply \
 //thickness=0.18 //x=1.605 //y=1.585 //x2=1.715 //y2=1.585
r76 (  13 28 ) resistor r=56.4043 //w=0.094 //l=0.11 //layer=ply \
 //thickness=0.18 //x=1.605 //y=1.585 //x2=1.495 //y2=1.585
r77 (  12 36 ) resistor r=152 //w=0.17 //l=0.17 //layer=licon //count=1 \
 //x=1.23 //y=2.26 //x2=1.23 //y2=2.26
r78 (  7 44 ) resistor r=62.631 //w=0.187 //l=0.915 //layer=li //thickness=0.1 \
 //x=1.6 //y=2.095 //x2=1.6 //y2=1.18
r79 (  6 12 ) resistor r=3.57586 //w=0.17 //l=0.085 //layer=li //thickness=0.1 \
 //x=1.315 //y=2.18 //x2=1.23 //y2=2.18
r80 (  5 7 ) resistor r=7.15173 //w=0.17 //l=0.120208 //layer=li \
 //thickness=0.1 //x=1.515 //y=2.18 //x2=1.6 //y2=2.095
r81 (  5 6 ) resistor r=13.6898 //w=0.187 //l=0.2 //layer=li //thickness=0.1 \
 //x=1.515 //y=2.18 //x2=1.315 //y2=2.18
r82 (  3 39 ) resistor r=152 //w=0.17 //l=0.17 //layer=licon //count=1 \
 //x=1.23 //y=4.88 //x2=1.23 //y2=4.88
r83 (  1 12 ) resistor r=3.57586 //w=0.17 //l=0.085 //layer=li //thickness=0.1 \
 //x=1.23 //y=2.265 //x2=1.23 //y2=2.18
r84 (  1 3 ) resistor r=178.995 //w=0.187 //l=2.615 //layer=li //thickness=0.1 \
 //x=1.23 //y=2.265 //x2=1.23 //y2=4.88
ends PM_TIEHI\%noxref_3

subckt PM_TIEHI\%Y ( 1 2 3 13 )
c13 ( 1 0 ) capacitor c=0.0739627f //x=1.6 //y=3.88
r14 (  3 13 ) resistor r=87.9572 //w=0.187 //l=1.285 //layer=li \
 //thickness=0.1 //x=1.6 //y=4.62 //x2=1.6 //y2=5.905
r15 (  2 3 ) resistor r=25.3262 //w=0.187 //l=0.37 //layer=li //thickness=0.1 \
 //x=1.6 //y=4.25 //x2=1.6 //y2=4.62
r16 (  1 2 ) resistor r=25.3262 //w=0.187 //l=0.37 //layer=li //thickness=0.1 \
 //x=1.6 //y=3.88 //x2=1.6 //y2=4.25
ends PM_TIEHI\%Y
