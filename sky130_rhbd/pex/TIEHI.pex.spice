// File: TIEHI.spi.pex
// Created: Sun Apr 12 08:35:38 2026
// Program "Calibre xRC"
// Version "v2023.2_27.15"
// Nominal Temperature: 30C
// Circuit Temperature: 30C
//
simulator lang=spectre
subckt PM_TIEHI\%VDD ( 1 7 25 40 42 43 44 )
c35 ( 44 0 ) capacitor c=0.0665501f //x=1.895 //y=5.2
c36 ( 43 0 ) capacitor c=0.0584693f //x=1.025 //y=5.2
c37 ( 42 0 ) capacitor c=0.261792f //x=1.97 //y=7.58
c38 ( 40 0 ) capacitor c=0.256509f //x=1.23 //y=7.58
c39 ( 25 0 ) capacitor c=0.0293203f //x=1.955 //y=7.585
c40 ( 7 0 ) capacitor c=0.147954f //x=1.97 //y=7.58
r41 (  27 42 ) resistor r=4.23183 //w=0.7 //l=0.175 //layer=li //thickness=0.1 \
 //x=2.04 //y=7.41 //x2=2.04 //y2=7.585
r42 (  27 44 ) resistor r=56.4706 //w=0.187 //l=0.825 //layer=li \
 //thickness=0.1 //x=2.04 //y=7.41 //x2=2.04 //y2=6.585
r43 (  26 40 ) resistor r=2.87058 //w=0.35 //l=0.085 //layer=li \
 //thickness=0.1 //x=1.245 //y=7.585 //x2=1.16 //y2=7.585
r44 (  25 42 ) resistor r=2.87058 //w=0.35 //l=0.085 //layer=li \
 //thickness=0.1 //x=1.955 //y=7.585 //x2=2.04 //y2=7.585
r45 (  25 26 ) resistor r=24.7629 //w=0.367 //l=0.71 //layer=li \
 //thickness=0.1 //x=1.955 //y=7.585 //x2=1.245 //y2=7.585
r46 (  17 40 ) resistor r=4.23183 //w=0.7 //l=0.175 //layer=li //thickness=0.1 \
 //x=1.16 //y=7.41 //x2=1.16 //y2=7.585
r47 (  17 43 ) resistor r=56.4706 //w=0.187 //l=0.825 //layer=li \
 //thickness=0.1 //x=1.16 //y=7.41 //x2=1.16 //y2=6.585
r48 (  7 42 ) resistor r=4.65 //w=0.17 //l=0.34 //layer=mcon //count=2 \
 //x=1.97 //y=7.58 //x2=1.97 //y2=7.58
r49 (  3 40 ) resistor r=3.1 //w=0.17 //l=0.51 //layer=mcon //count=3 //x=1.23 \
 //y=7.58 //x2=1.23 //y2=7.58
r50 (  1 7 ) resistor r=0.148714 //w=0.311 //l=0.37 //layer=m1 \
 //thickness=0.36 //x=1.6 //y=7.585 //x2=1.97 //y2=7.585
r51 (  1 3 ) resistor r=0.148714 //w=0.311 //l=0.37 //layer=m1 \
 //thickness=0.36 //x=1.6 //y=7.585 //x2=1.23 //y2=7.585
ends PM_TIEHI\%VDD

subckt PM_TIEHI\%noxref_2 ( 2 3 4 8 13 18 27 28 29 30 32 33 37 38 47 48 50 58 )
c66 ( 58 0 ) capacitor c=0.0087145f //x=1.415 //y=1.085
c67 ( 50 0 ) capacitor c=0.0576936f //x=1.23 //y=2.26
c68 ( 48 0 ) capacitor c=0.0452699f //x=1.87 //y=1.43
c69 ( 47 0 ) capacitor c=0.0199707f //x=1.87 //y=1.085
c70 ( 41 0 ) capacitor c=0.0163334f //x=1.715 //y=1.585
c71 ( 39 0 ) capacitor c=0.0157807f //x=1.715 //y=0.93
c72 ( 38 0 ) capacitor c=0.0556319f //x=1.455 //y=4.97
c73 ( 37 0 ) capacitor c=0.0382227f //x=1.745 //y=4.97
c74 ( 33 0 ) capacitor c=0.0301471f //x=1.34 //y=2.095
c75 ( 32 0 ) capacitor c=0.0255349f //x=1.34 //y=1.74
c76 ( 31 0 ) capacitor c=0.0234346f //x=1.34 //y=1.43
c77 ( 30 0 ) capacitor c=0.0200381f //x=1.34 //y=1.085
c78 ( 29 0 ) capacitor c=0.154341f //x=1.82 //y=6.2
c79 ( 28 0 ) capacitor c=0.153906f //x=1.38 //y=6.2
c80 ( 18 0 ) capacitor c=9.23512e-19 //x=1.23 //y=4.88
c81 ( 13 0 ) capacitor c=9.26053e-19 //x=1.23 //y=2.26
c82 ( 8 0 ) capacitor c=0.0266481f //x=1.23 //y=2.26
c83 ( 4 0 ) capacitor c=0.0332377f //x=1.6 //y=2.155
c84 ( 3 0 ) capacitor c=0.0185951f //x=1.6 //y=1.3
c85 ( 2 0 ) capacitor c=0.138889f //x=1.23 //y=4.765
r86 (  50 51 ) resistor r=17.5563 //w=0.302 //l=0.11 //layer=ply \
 //thickness=0.18 //x=1.23 //y=2.26 //x2=1.34 //y2=2.26
r87 (  48 57 ) resistor r=45.1352 //w=0.168 //l=0.173853 //layer=ply \
 //thickness=0.18 //x=1.87 //y=1.43 //x2=1.83 //y2=1.585
r88 (  47 56 ) resistor r=45.1352 //w=0.168 //l=0.173853 //layer=ply \
 //thickness=0.18 //x=1.87 //y=1.085 //x2=1.83 //y2=0.93
r89 (  47 48 ) resistor r=176.904 //w=0.094 //l=0.345 //layer=ply \
 //thickness=0.18 //x=1.87 //y=1.085 //x2=1.87 //y2=1.43
r90 (  42 55 ) resistor r=10.701 //w=0.21 //l=0.115 //layer=ply \
 //thickness=0.18 //x=1.495 //y=1.585 //x2=1.38 //y2=1.585
r91 (  41 57 ) resistor r=5.52526 //w=0.168 //l=0.115 //layer=ply \
 //thickness=0.18 //x=1.715 //y=1.585 //x2=1.83 //y2=1.585
r92 (  40 54 ) resistor r=5.52526 //w=0.168 //l=0.115 //layer=ply \
 //thickness=0.18 //x=1.495 //y=0.93 //x2=1.38 //y2=0.93
r93 (  39 56 ) resistor r=5.52526 //w=0.168 //l=0.115 //layer=ply \
 //thickness=0.18 //x=1.715 //y=0.93 //x2=1.83 //y2=0.93
r94 (  39 40 ) resistor r=112.809 //w=0.094 //l=0.22 //layer=ply \
 //thickness=0.18 //x=1.715 //y=0.93 //x2=1.495 //y2=0.93
r95 (  37 44 ) resistor r=26.9307 //w=0.15 //l=0.106066 //layer=ply \
 //thickness=0.18 //x=1.745 //y=4.97 //x2=1.82 //y2=5.045
r96 (  37 38 ) resistor r=148.702 //w=0.094 //l=0.29 //layer=ply \
 //thickness=0.18 //x=1.745 //y=4.97 //x2=1.455 //y2=4.97
r97 (  34 38 ) resistor r=23.4449 //w=0.285 //l=0.106066 //layer=ply \
 //thickness=0.18 //x=1.38 //y=5.045 //x2=1.455 //y2=4.97
r98 (  34 53 ) resistor r=25.3684 //w=0.285 //l=0.22798 //layer=ply \
 //thickness=0.18 //x=1.38 //y=5.045 //x2=1.23 //y2=4.88
r99 (  33 51 ) resistor r=19.1248 //w=0.302 //l=0.165 //layer=ply \
 //thickness=0.18 //x=1.34 //y=2.095 //x2=1.34 //y2=2.26
r100 (  32 55 ) resistor r=39.5823 //w=0.21 //l=0.173853 //layer=ply \
 //thickness=0.18 //x=1.34 //y=1.74 //x2=1.38 //y2=1.585
r101 (  32 33 ) resistor r=182.032 //w=0.094 //l=0.355 //layer=ply \
 //thickness=0.18 //x=1.34 //y=1.74 //x2=1.34 //y2=2.095
r102 (  31 55 ) resistor r=39.5823 //w=0.21 //l=0.173853 //layer=ply \
 //thickness=0.18 //x=1.34 //y=1.43 //x2=1.38 //y2=1.585
r103 (  30 54 ) resistor r=45.1352 //w=0.168 //l=0.173853 //layer=ply \
 //thickness=0.18 //x=1.34 //y=1.085 //x2=1.38 //y2=0.93
r104 (  30 31 ) resistor r=176.904 //w=0.094 //l=0.345 //layer=ply \
 //thickness=0.18 //x=1.34 //y=1.085 //x2=1.34 //y2=1.43
r105 (  29 44 ) resistor r=592.245 //w=0.094 //l=1.155 //layer=ply \
 //thickness=0.18 //x=1.82 //y=6.2 //x2=1.82 //y2=5.045
r106 (  28 34 ) resistor r=592.245 //w=0.094 //l=1.155 //layer=ply \
 //thickness=0.18 //x=1.38 //y=6.2 //x2=1.38 //y2=5.045
r107 (  27 41 ) resistor r=56.4043 //w=0.094 //l=0.11 //layer=ply \
 //thickness=0.18 //x=1.605 //y=1.585 //x2=1.715 //y2=1.585
r108 (  27 42 ) resistor r=56.4043 //w=0.094 //l=0.11 //layer=ply \
 //thickness=0.18 //x=1.605 //y=1.585 //x2=1.495 //y2=1.585
r109 (  18 53 ) resistor r=152 //w=0.17 //l=0.17 //layer=licon //count=1 \
 //x=1.23 //y=4.88 //x2=1.23 //y2=4.88
r110 (  13 50 ) resistor r=152 //w=0.17 //l=0.17 //layer=licon //count=1 \
 //x=1.23 //y=2.26 //x2=1.23 //y2=2.26
r111 (  11 58 ) resistor r=9.3 //w=0.17 //l=0.17 //layer=mcon //count=1 \
 //x=1.6 //y=1.18 //x2=1.6 //y2=1.18
r112 (  8 13 ) resistor r=9.3 //w=0.17 //l=0.17 //layer=mcon //count=1 \
 //x=1.23 //y=2.26 //x2=1.23 //y2=2.26
r113 (  6 18 ) resistor r=9.3 //w=0.17 //l=0.17 //layer=mcon //count=1 \
 //x=1.23 //y=4.88 //x2=1.23 //y2=4.88
r114 (  4 8 ) resistor r=0.226716 //w=0.204 //l=0.37 //layer=m1 \
 //thickness=0.36 //x=1.6 //y=2.245 //x2=1.23 //y2=2.245
r115 (  3 11 ) resistor r=0.0741487 //w=0.228 //l=0.120996 //layer=m1 \
 //thickness=0.36 //x=1.6 //y=1.3 //x2=1.602 //y2=1.18
r116 (  3 4 ) resistor r=0.81584 //w=0.131 //l=0.855 //layer=m1 \
 //thickness=0.36 //x=1.6 //y=1.3 //x2=1.6 //y2=2.155
r117 (  2 6 ) resistor r=0.0713327 //w=0.229 //l=0.115996 //layer=m1 \
 //thickness=0.36 //x=1.23 //y=4.765 //x2=1.232 //y2=4.88
r118 (  1 8 ) resistor r=0.0185111 //w=0.204 //l=0.13 //layer=m1 \
 //thickness=0.36 //x=1.23 //y=2.375 //x2=1.23 //y2=2.245
r119 (  1 2 ) resistor r=2.28053 //w=0.131 //l=2.39 //layer=m1 \
 //thickness=0.36 //x=1.23 //y=2.375 //x2=1.23 //y2=4.765
ends PM_TIEHI\%noxref_2

subckt PM_TIEHI\%Y ( 1 2 3 4 12 19 )
c30 ( 12 0 ) capacitor c=0.0261392f //x=1.6 //y=5.565
c31 ( 4 0 ) capacitor c=0.00726145f //x=1.6 //y=5.45
c32 ( 1 0 ) capacitor c=0.059879f //x=1.6 //y=3.88
r33 (  12 19 ) resistor r=23.2727 //w=0.187 //l=0.34 //layer=li \
 //thickness=0.1 //x=1.6 //y=5.565 //x2=1.6 //y2=5.905
r34 (  10 12 ) resistor r=9.3 //w=0.17 //l=0.17 //layer=mcon //count=1 //x=1.6 \
 //y=5.565 //x2=1.6 //y2=5.565
r35 (  4 10 ) resistor r=0.0717383 //w=0.224 //l=0.115996 //layer=m1 \
 //thickness=0.36 //x=1.6 //y=5.45 //x2=1.602 //y2=5.565
r36 (  3 4 ) resistor r=0.791985 //w=0.131 //l=0.83 //layer=m1 \
 //thickness=0.36 //x=1.6 //y=4.62 //x2=1.6 //y2=5.45
r37 (  2 3 ) resistor r=0.353053 //w=0.131 //l=0.37 //layer=m1 \
 //thickness=0.36 //x=1.6 //y=4.25 //x2=1.6 //y2=4.62
r38 (  1 2 ) resistor r=0.353053 //w=0.131 //l=0.37 //layer=m1 \
 //thickness=0.36 //x=1.6 //y=3.88 //x2=1.6 //y2=4.25
ends PM_TIEHI\%Y

subckt PM_TIEHI\%GND ( 1 5 6 11 13 34 36 41 58 )
c39 ( 58 0 ) capacitor c=0.0598326f //x=0.985 //y=0.545
c40 ( 46 0 ) capacitor c=0.00457594f //x=2.09 //y=0.795
c41 ( 41 0 ) capacitor c=0.0204904f //x=2.005 //y=0.71
c42 ( 37 0 ) capacitor c=0.00484224f //x=1.12 //y=0.795
c43 ( 36 0 ) capacitor c=0.287332f //x=1.97 //y=0.18
c44 ( 34 0 ) capacitor c=0.199441f //x=1.23 //y=0.18
c45 ( 22 0 ) capacitor c=0.0884672f //x=2.09 //y=0.175
c46 ( 16 0 ) capacitor c=0.0574302f //x=1.12 //y=0.175
c47 ( 13 0 ) capacitor c=0.0187611f //x=2.09 //y=0.59
c48 ( 11 0 ) capacitor c=0.00259585f //x=1.725 //y=0.71
c49 ( 10 0 ) capacitor c=2.53033e-19 //x=1.97 //y=0.71
c50 ( 9 0 ) capacitor c=0.00216493f //x=1.6 //y=0.59
c51 ( 5 0 ) capacitor c=0.0171034f //x=1.12 //y=0.59
r52 (  46 58 ) resistor r=3.57586 //w=0.17 //l=0.125 //layer=li \
 //thickness=0.1 //x=2.09 //y=0.795 //x2=2.09 //y2=0.67
r53 (  46 58 ) resistor r=41.4118 //w=0.187 //l=0.605 //layer=li \
 //thickness=0.1 //x=2.09 //y=0.795 //x2=2.09 //y2=1.4
r54 (  42 58 ) resistor r=3.57586 //w=0.17 //l=0.103078 //layer=li \
 //thickness=0.1 //x=1.205 //y=0.71 //x2=1.12 //y2=0.67
r55 (  42 58 ) resistor r=27.0374 //w=0.187 //l=0.395 //layer=li \
 //thickness=0.1 //x=1.205 //y=0.71 //x2=1.6 //y2=0.71
r56 (  41 58 ) resistor r=3.57586 //w=0.17 //l=0.103078 //layer=li \
 //thickness=0.1 //x=2.005 //y=0.71 //x2=2.09 //y2=0.67
r57 (  41 58 ) resistor r=27.7219 //w=0.187 //l=0.405 //layer=li \
 //thickness=0.1 //x=2.005 //y=0.71 //x2=1.6 //y2=0.71
r58 (  37 58 ) resistor r=3.57586 //w=0.17 //l=0.125 //layer=li \
 //thickness=0.1 //x=1.12 //y=0.795 //x2=1.12 //y2=0.67
r59 (  37 58 ) resistor r=41.4118 //w=0.187 //l=0.605 //layer=li \
 //thickness=0.1 //x=1.12 //y=0.795 //x2=1.12 //y2=1.4
r60 (  34 36 ) resistor r=25.8093 //w=0.367 //l=0.74 //layer=li \
 //thickness=0.1 //x=1.23 //y=0.175 //x2=1.97 //y2=0.175
r61 (  28 58 ) resistor r=9.3 //w=0.17 //l=0.17 //layer=mcon //count=1 \
 //x=2.09 //y=0.71 //x2=2.09 //y2=0.71
r62 (  26 58 ) resistor r=9.3 //w=0.17 //l=0.17 //layer=mcon //count=1 //x=1.6 \
 //y=0.71 //x2=1.6 //y2=0.71
r63 (  24 58 ) resistor r=9.3 //w=0.17 //l=0.17 //layer=mcon //count=1 \
 //x=1.12 //y=0.71 //x2=1.12 //y2=0.71
r64 (  21 36 ) resistor r=4.65 //w=0.17 //l=0.34 //layer=mcon //count=2 \
 //x=1.97 //y=0.18 //x2=1.97 //y2=0.18
r65 (  21 22 ) resistor r=0.0482315 //w=0.311 //l=0.12 //layer=m1 \
 //thickness=0.36 //x=1.97 //y=0.175 //x2=2.09 //y2=0.175
r66 (  18 34 ) resistor r=3.1 //w=0.17 //l=0.51 //layer=mcon //count=3 \
 //x=1.23 //y=0.18 //x2=1.23 //y2=0.18
r67 (  16 18 ) resistor r=0.0442122 //w=0.311 //l=0.11 //layer=m1 \
 //thickness=0.36 //x=1.12 //y=0.175 //x2=1.23 //y2=0.175
r68 (  13 28 ) resistor r=0.0349206 //w=0.17 //l=0.135 //layer=m1 \
 //thickness=0.36 //x=2.09 //y=0.59 //x2=2.09 //y2=0.725
r69 (  12 22 ) resistor r=0.0509631 //w=0.35 //l=0.175 //layer=m1 \
 //thickness=0.36 //x=2.09 //y=0.35 //x2=2.09 //y2=0.175
r70 (  12 13 ) resistor r=0.229008 //w=0.131 //l=0.24 //layer=m1 \
 //thickness=0.36 //x=2.09 //y=0.35 //x2=2.09 //y2=0.59
r71 (  11 26 ) resistor r=0.0759051 //w=0.24 //l=0.125 //layer=m1 \
 //thickness=0.36 //x=1.725 //y=0.71 //x2=1.6 //y2=0.71
r72 (  10 28 ) resistor r=0.0349206 //w=0.17 //l=0.127279 //layer=m1 \
 //thickness=0.36 //x=1.97 //y=0.71 //x2=2.09 //y2=0.725
r73 (  10 11 ) resistor r=0.233779 //w=0.131 //l=0.245 //layer=m1 \
 //thickness=0.36 //x=1.97 //y=0.71 //x2=1.725 //y2=0.71
r74 (  9 26 ) resistor r=0.0282511 //w=0.24 //l=0.12 //layer=m1 \
 //thickness=0.36 //x=1.6 //y=0.59 //x2=1.6 //y2=0.71
r75 (  8 9 ) resistor r=0.229008 //w=0.131 //l=0.24 //layer=m1 \
 //thickness=0.36 //x=1.6 //y=0.35 //x2=1.6 //y2=0.59
r76 (  7 24 ) resistor r=0.0343915 //w=0.17 //l=0.123855 //layer=m1 \
 //thickness=0.36 //x=1.24 //y=0.71 //x2=1.122 //y2=0.722
r77 (  6 26 ) resistor r=0.0706968 //w=0.24 //l=0.115 //layer=m1 \
 //thickness=0.36 //x=1.485 //y=0.71 //x2=1.6 //y2=0.71
r78 (  6 7 ) resistor r=0.233779 //w=0.131 //l=0.245 //layer=m1 \
 //thickness=0.36 //x=1.485 //y=0.71 //x2=1.24 //y2=0.71
r79 (  5 24 ) resistor r=0.0354497 //w=0.17 //l=0.132996 //layer=m1 \
 //thickness=0.36 //x=1.12 //y=0.59 //x2=1.122 //y2=0.722
r80 (  4 16 ) resistor r=0.0509631 //w=0.35 //l=0.175 //layer=m1 \
 //thickness=0.36 //x=1.12 //y=0.35 //x2=1.12 //y2=0.175
r81 (  4 5 ) resistor r=0.229008 //w=0.131 //l=0.24 //layer=m1 \
 //thickness=0.36 //x=1.12 //y=0.35 //x2=1.12 //y2=0.59
r82 (  1 21 ) resistor r=0.148714 //w=0.311 //l=0.37 //layer=m1 \
 //thickness=0.36 //x=1.6 //y=0.175 //x2=1.97 //y2=0.175
r83 (  1 8 ) resistor r=0.0509631 //w=0.35 //l=0.175 //layer=m1 \
 //thickness=0.36 //x=1.6 //y=0.175 //x2=1.6 //y2=0.35
r84 (  1 18 ) resistor r=0.148714 //w=0.311 //l=0.37 //layer=m1 \
 //thickness=0.36 //x=1.6 //y=0.175 //x2=1.23 //y2=0.175
ends PM_TIEHI\%GND
