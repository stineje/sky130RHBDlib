// File: nmos_side_left.spi.pex
// Created: Tue Apr 29 10:51:08 2025
// Program "Calibre xRC"
// Version "v2023.2_27.15"
// Nominal Temperature: 30C
// Circuit Temperature: 30C
//
simulator lang=spectre
