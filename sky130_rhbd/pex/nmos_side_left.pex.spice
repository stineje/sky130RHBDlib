// File: nmos_side_left.spi.pex
// Created: Fri Feb 20 10:21:20 2026
// Program "Calibre xRC"
// Version "v2023.2_27.15"
// Nominal Temperature: 30C
// Circuit Temperature: 30C
//
simulator lang=spectre
