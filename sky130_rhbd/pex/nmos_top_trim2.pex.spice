// File: nmos_top_trim2.spi.pex
// Created: Sun Mar 15 12:51:30 2026
// Program "Calibre xRC"
// Version "v2023.2_27.15"
// Nominal Temperature: 30C
// Circuit Temperature: 30C
//
simulator lang=spectre
