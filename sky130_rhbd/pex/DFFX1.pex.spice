// File: DFFX1.spi.pex
// Created: Sun Mar 15 12:41:56 2026
// Program "Calibre xRC"
// Version "v2023.2_27.15"
// Nominal Temperature: 30C
// Circuit Temperature: 30C
//
simulator lang=spectre
subckt PM_DFFX1\%noxref_1 ( 1 2 3 4 7 12 13 15 16 18 19 20 22 23 30 34 35 38 \
 40 43 48 50 53 54 56 57 58 60 62 65 72 73 76 85 90 98 115 124 128 129 130 131 \
 132 133 137 138 139 144 146 149 150 151 152 153 154 158 160 163 164 169 170 \
 175 184 187 189 190 )
c411 ( 187 0 ) capacitor c=0.00878249f //x=7.26 //y=1.085
c412 ( 184 0 ) capacitor c=0.0682508f //x=9.74 //y=4.88
c413 ( 175 0 ) capacitor c=0.0710066f //x=3.82 //y=4.88
c414 ( 170 0 ) capacitor c=0.0278202f //x=3.82 //y=2.095
c415 ( 169 0 ) capacitor c=0.0479324f //x=3.82 //y=2.26
c416 ( 164 0 ) capacitor c=0.0318956f //x=10.075 //y=1.39
c417 ( 163 0 ) capacitor c=0.0186809f //x=10.075 //y=1.045
c418 ( 160 0 ) capacitor c=0.0141821f //x=9.92 //y=1.545
c419 ( 158 0 ) capacitor c=0.0158553f //x=9.92 //y=0.89
c420 ( 154 0 ) capacitor c=0.0854171f //x=9.545 //y=2.095
c421 ( 153 0 ) capacitor c=0.0229235f //x=9.545 //y=1.7
c422 ( 152 0 ) capacitor c=0.0234359f //x=9.545 //y=1.39
c423 ( 151 0 ) capacitor c=0.0198759f //x=9.545 //y=1.045
c424 ( 150 0 ) capacitor c=0.0443175f //x=4.34 //y=1.44
c425 ( 149 0 ) capacitor c=0.0199703f //x=4.34 //y=1.095
c426 ( 146 0 ) capacitor c=0.0162526f //x=4.185 //y=1.595
c427 ( 144 0 ) capacitor c=0.0157807f //x=4.185 //y=0.94
c428 ( 139 0 ) capacitor c=0.0220935f //x=3.81 //y=1.75
c429 ( 138 0 ) capacitor c=0.0207489f //x=3.81 //y=1.44
c430 ( 137 0 ) capacitor c=0.0194091f //x=3.81 //y=1.095
c431 ( 133 0 ) capacitor c=0.110369f //x=10.08 //y=6.2
c432 ( 132 0 ) capacitor c=0.154619f //x=9.64 //y=6.2
c433 ( 131 0 ) capacitor c=0.159671f //x=4 //y=6.2
c434 ( 130 0 ) capacitor c=0.110208f //x=3.56 //y=6.2
c435 ( 124 0 ) capacitor c=8.13425e-19 //x=9.74 //y=4.88
c436 ( 115 0 ) capacitor c=7.85889e-19 //x=9.74 //y=2.26
c437 ( 98 0 ) capacitor c=0.0322017f //x=7.41 //y=5.56
c438 ( 90 0 ) capacitor c=0.0290186f //x=6.53 //y=5.56
c439 ( 85 0 ) capacitor c=8.10944e-19 //x=3.82 //y=4.88
c440 ( 76 0 ) capacitor c=0.00101179f //x=3.82 //y=2.26
c441 ( 73 0 ) capacitor c=0.0504173f //x=9.575 //y=3.505
c442 ( 72 0 ) capacitor c=0.00163142f //x=9.735 //y=3.505
c443 ( 65 0 ) capacitor c=0.0259007f //x=8.045 //y=3.51
c444 ( 62 0 ) capacitor c=0.00684519f //x=6.62 //y=3.495
c445 ( 60 0 ) capacitor c=0.0382613f //x=6.02 //y=3.51
c446 ( 58 0 ) capacitor c=0.018822f //x=4.775 //y=3.495
c447 ( 57 0 ) capacitor c=0.00325528f //x=3.985 //y=3.51
c448 ( 56 0 ) capacitor c=0.00669908f //x=4.175 //y=3.51
c449 ( 54 0 ) capacitor c=0.0267314f //x=9.742 //y=4.74
c450 ( 53 0 ) capacitor c=0.00611287f //x=9.74 //y=4.88
c451 ( 50 0 ) capacitor c=0.0064096f //x=9.74 //y=2.26
c452 ( 48 0 ) capacitor c=0.0163473f //x=9.74 //y=3.51
c453 ( 43 0 ) capacitor c=0.0170489f //x=7.885 //y=3.51
c454 ( 40 0 ) capacitor c=0.0114531f //x=7.45 //y=1.18
c455 ( 38 0 ) capacitor c=5.78613e-19 //x=7.41 //y=5.56
c456 ( 35 0 ) capacitor c=0.0105334f //x=7.41 //y=5.38
c457 ( 34 0 ) capacitor c=0.00923791f //x=6.53 //y=5.56
c458 ( 30 0 ) capacitor c=0.0148558f //x=3.82 //y=3.51
c459 ( 23 0 ) capacitor c=0.0133022f //x=9.74 //y=3.665
c460 ( 22 0 ) capacitor c=0.0288905f //x=9.74 //y=3.345
c461 ( 20 0 ) capacitor c=0.0405859f //x=7.89 //y=5.295
c462 ( 19 0 ) capacitor c=0.0134936f //x=7.89 //y=3.67
c463 ( 18 0 ) capacitor c=0.0397593f //x=7.89 //y=3.35
c464 ( 16 0 ) capacitor c=0.00653562f //x=7.535 //y=1.835
c465 ( 15 0 ) capacitor c=0.013278f //x=7.805 //y=1.835
c466 ( 13 0 ) capacitor c=0.0108105f //x=7.805 //y=5.38
c467 ( 12 0 ) capacitor c=0.0102514f //x=7.45 //y=1.75
c468 ( 7 0 ) capacitor c=0.0150818f //x=7.295 //y=5.38
c469 ( 4 0 ) capacitor c=0.0286377f //x=3.82 //y=4.75
c470 ( 3 0 ) capacitor c=0.0126137f //x=3.82 //y=3.67
c471 ( 2 0 ) capacitor c=0.0274817f //x=3.82 //y=3.35
c472 ( 1 0 ) capacitor c=0.00685053f //x=3.82 //y=2.375
r473 (  182 184 ) resistor r=20.6867 //w=0.233 //l=0.1 //layer=ply \
 //thickness=0.18 //x=9.64 //y=4.88 //x2=9.74 //y2=4.88
r474 (  169 170 ) resistor r=52.7279 //w=0.214 //l=0.165 //layer=ply \
 //thickness=0.18 //x=3.82 //y=2.26 //x2=3.82 //y2=2.095
r475 (  165 184 ) resistor r=70.3348 //w=0.233 //l=0.414367 //layer=ply \
 //thickness=0.18 //x=10.08 //y=5.045 //x2=9.74 //y2=4.88
r476 (  164 186 ) resistor r=45.1352 //w=0.168 //l=0.173853 //layer=ply \
 //thickness=0.18 //x=10.075 //y=1.39 //x2=10.035 //y2=1.545
r477 (  163 185 ) resistor r=45.1352 //w=0.168 //l=0.173853 //layer=ply \
 //thickness=0.18 //x=10.075 //y=1.045 //x2=10.035 //y2=0.89
r478 (  163 164 ) resistor r=176.904 //w=0.094 //l=0.345 //layer=ply \
 //thickness=0.18 //x=10.075 //y=1.045 //x2=10.075 //y2=1.39
r479 (  161 181 ) resistor r=10.701 //w=0.21 //l=0.115 //layer=ply \
 //thickness=0.18 //x=9.7 //y=1.545 //x2=9.585 //y2=1.545
r480 (  160 186 ) resistor r=5.52526 //w=0.168 //l=0.115 //layer=ply \
 //thickness=0.18 //x=9.92 //y=1.545 //x2=10.035 //y2=1.545
r481 (  159 180 ) resistor r=5.52526 //w=0.168 //l=0.115 //layer=ply \
 //thickness=0.18 //x=9.7 //y=0.89 //x2=9.585 //y2=0.89
r482 (  158 185 ) resistor r=5.52526 //w=0.168 //l=0.115 //layer=ply \
 //thickness=0.18 //x=9.92 //y=0.89 //x2=10.035 //y2=0.89
r483 (  158 159 ) resistor r=112.809 //w=0.094 //l=0.22 //layer=ply \
 //thickness=0.18 //x=9.92 //y=0.89 //x2=9.7 //y2=0.89
r484 (  155 182 ) resistor r=13.0941 //w=0.233 //l=0.165 //layer=ply \
 //thickness=0.18 //x=9.64 //y=5.045 //x2=9.64 //y2=4.88
r485 (  154 179 ) resistor r=34.8111 //w=0.27 //l=0.264953 //layer=ply \
 //thickness=0.18 //x=9.545 //y=2.095 //x2=9.74 //y2=2.26
r486 (  153 181 ) resistor r=39.5823 //w=0.21 //l=0.173853 //layer=ply \
 //thickness=0.18 //x=9.545 //y=1.7 //x2=9.585 //y2=1.545
r487 (  153 154 ) resistor r=202.543 //w=0.094 //l=0.395 //layer=ply \
 //thickness=0.18 //x=9.545 //y=1.7 //x2=9.545 //y2=2.095
r488 (  152 181 ) resistor r=39.5823 //w=0.21 //l=0.173853 //layer=ply \
 //thickness=0.18 //x=9.545 //y=1.39 //x2=9.585 //y2=1.545
r489 (  151 180 ) resistor r=45.1352 //w=0.168 //l=0.173853 //layer=ply \
 //thickness=0.18 //x=9.545 //y=1.045 //x2=9.585 //y2=0.89
r490 (  151 152 ) resistor r=176.904 //w=0.094 //l=0.345 //layer=ply \
 //thickness=0.18 //x=9.545 //y=1.045 //x2=9.545 //y2=1.39
r491 (  150 177 ) resistor r=45.1352 //w=0.168 //l=0.173853 //layer=ply \
 //thickness=0.18 //x=4.34 //y=1.44 //x2=4.3 //y2=1.595
r492 (  149 176 ) resistor r=45.1352 //w=0.168 //l=0.173853 //layer=ply \
 //thickness=0.18 //x=4.34 //y=1.095 //x2=4.3 //y2=0.94
r493 (  149 150 ) resistor r=176.904 //w=0.094 //l=0.345 //layer=ply \
 //thickness=0.18 //x=4.34 //y=1.095 //x2=4.34 //y2=1.44
r494 (  147 173 ) resistor r=10.701 //w=0.21 //l=0.115 //layer=ply \
 //thickness=0.18 //x=3.965 //y=1.595 //x2=3.85 //y2=1.595
r495 (  146 177 ) resistor r=5.52526 //w=0.168 //l=0.115 //layer=ply \
 //thickness=0.18 //x=4.185 //y=1.595 //x2=4.3 //y2=1.595
r496 (  145 172 ) resistor r=5.52526 //w=0.168 //l=0.115 //layer=ply \
 //thickness=0.18 //x=3.965 //y=0.94 //x2=3.85 //y2=0.94
r497 (  144 176 ) resistor r=5.52526 //w=0.168 //l=0.115 //layer=ply \
 //thickness=0.18 //x=4.185 //y=0.94 //x2=4.3 //y2=0.94
r498 (  144 145 ) resistor r=112.809 //w=0.094 //l=0.22 //layer=ply \
 //thickness=0.18 //x=4.185 //y=0.94 //x2=3.965 //y2=0.94
r499 (  141 175 ) resistor r=37.236 //w=0.233 //l=0.249199 //layer=ply \
 //thickness=0.18 //x=4 //y=5.045 //x2=3.82 //y2=4.88
r500 (  139 173 ) resistor r=39.5823 //w=0.21 //l=0.173853 //layer=ply \
 //thickness=0.18 //x=3.81 //y=1.75 //x2=3.85 //y2=1.595
r501 (  139 170 ) resistor r=176.904 //w=0.094 //l=0.345 //layer=ply \
 //thickness=0.18 //x=3.81 //y=1.75 //x2=3.81 //y2=2.095
r502 (  138 173 ) resistor r=39.5823 //w=0.21 //l=0.173853 //layer=ply \
 //thickness=0.18 //x=3.81 //y=1.44 //x2=3.85 //y2=1.595
r503 (  137 172 ) resistor r=45.1352 //w=0.168 //l=0.173853 //layer=ply \
 //thickness=0.18 //x=3.81 //y=1.095 //x2=3.85 //y2=0.94
r504 (  137 138 ) resistor r=176.904 //w=0.094 //l=0.345 //layer=ply \
 //thickness=0.18 //x=3.81 //y=1.095 //x2=3.81 //y2=1.44
r505 (  134 175 ) resistor r=53.7854 //w=0.233 //l=0.332415 //layer=ply \
 //thickness=0.18 //x=3.56 //y=5.045 //x2=3.82 //y2=4.88
r506 (  133 165 ) resistor r=592.245 //w=0.094 //l=1.155 //layer=ply \
 //thickness=0.18 //x=10.08 //y=6.2 //x2=10.08 //y2=5.045
r507 (  132 155 ) resistor r=592.245 //w=0.094 //l=1.155 //layer=ply \
 //thickness=0.18 //x=9.64 //y=6.2 //x2=9.64 //y2=5.045
r508 (  131 141 ) resistor r=592.245 //w=0.094 //l=1.155 //layer=ply \
 //thickness=0.18 //x=4 //y=6.2 //x2=4 //y2=5.045
r509 (  130 134 ) resistor r=592.245 //w=0.094 //l=1.155 //layer=ply \
 //thickness=0.18 //x=3.56 //y=6.2 //x2=3.56 //y2=5.045
r510 (  129 160 ) resistor r=56.4043 //w=0.094 //l=0.11 //layer=ply \
 //thickness=0.18 //x=9.81 //y=1.545 //x2=9.92 //y2=1.545
r511 (  129 161 ) resistor r=56.4043 //w=0.094 //l=0.11 //layer=ply \
 //thickness=0.18 //x=9.81 //y=1.545 //x2=9.7 //y2=1.545
r512 (  128 146 ) resistor r=56.4043 //w=0.094 //l=0.11 //layer=ply \
 //thickness=0.18 //x=4.075 //y=1.595 //x2=4.185 //y2=1.595
r513 (  128 147 ) resistor r=56.4043 //w=0.094 //l=0.11 //layer=ply \
 //thickness=0.18 //x=4.075 //y=1.595 //x2=3.965 //y2=1.595
r514 (  124 184 ) resistor r=152 //w=0.17 //l=0.17 //layer=licon //count=1 \
 //x=9.74 //y=4.88 //x2=9.74 //y2=4.88
r515 (  115 179 ) resistor r=152 //w=0.17 //l=0.17 //layer=licon //count=1 \
 //x=9.74 //y=2.26 //x2=9.74 //y2=2.26
r516 (  98 190 ) resistor r=23.615 //w=0.187 //l=0.345 //layer=li \
 //thickness=0.1 //x=7.41 //y=5.56 //x2=7.41 //y2=5.905
r517 (  90 189 ) resistor r=23.615 //w=0.187 //l=0.345 //layer=li \
 //thickness=0.1 //x=6.53 //y=5.56 //x2=6.53 //y2=5.905
r518 (  85 175 ) resistor r=152 //w=0.17 //l=0.17 //layer=licon //count=1 \
 //x=3.82 //y=4.88 //x2=3.82 //y2=4.88
r519 (  76 169 ) resistor r=152 //w=0.17 //l=0.17 //layer=licon //count=1 \
 //x=3.82 //y=2.26 //x2=3.82 //y2=2.26
r520 (  72 73 ) resistor r=0.10734 //w=0.281 //l=0.16 //layer=m2 \
 //thickness=0.36 //x=9.735 //y=3.505 //x2=9.575 //y2=3.505
r521 (  65 70 ) resistor r=0.10188 //w=0.204 //l=0.16 //layer=m2 \
 //thickness=0.36 //x=8.045 //y=3.51 //x2=7.885 //y2=3.51
r522 (  65 73 ) resistor r=1.45992 //w=0.131 //l=1.53 //layer=m2 \
 //thickness=0.36 //x=8.045 //y=3.51 //x2=9.575 //y2=3.51
r523 (  62 70 ) resistor r=0.778963 //w=0.204 //l=1.27248 //layer=m2 \
 //thickness=0.36 //x=6.62 //y=3.495 //x2=7.885 //y2=3.51
r524 (  62 63 ) resistor r=0.410305 //w=0.131 //l=0.43 //layer=m2 \
 //thickness=0.36 //x=6.62 //y=3.495 //x2=6.19 //y2=3.495
r525 (  60 63 ) resistor r=0.125 //w=0.17 //l=0.177341 //layer=m2 \
 //thickness=0.36 //x=6.02 //y=3.51 //x2=6.19 //y2=3.495
r526 (  60 61 ) resistor r=0.944656 //w=0.131 //l=0.99 //layer=m2 \
 //thickness=0.36 //x=6.02 //y=3.51 //x2=5.03 //y2=3.51
r527 (  58 61 ) resistor r=0.1875 //w=0.17 //l=0.262393 //layer=m2 \
 //thickness=0.36 //x=4.775 //y=3.495 //x2=5.03 //y2=3.51
r528 (  58 59 ) resistor r=0.410305 //w=0.131 //l=0.43 //layer=m2 \
 //thickness=0.36 //x=4.775 //y=3.495 //x2=4.345 //y2=3.495
r529 (  57 67 ) resistor r=0.10734 //w=0.281 //l=0.16 //layer=m2 \
 //thickness=0.36 //x=3.985 //y=3.51 //x2=3.825 //y2=3.51
r530 (  56 59 ) resistor r=0.125 //w=0.17 //l=0.177341 //layer=m2 \
 //thickness=0.36 //x=4.175 //y=3.51 //x2=4.345 //y2=3.495
r531 (  56 57 ) resistor r=0.181298 //w=0.131 //l=0.19 //layer=m2 \
 //thickness=0.36 //x=4.175 //y=3.51 //x2=3.985 //y2=3.51
r532 (  53 124 ) resistor r=9.3 //w=0.17 //l=0.17 //layer=mcon //count=1 \
 //x=9.74 //y=4.88 //x2=9.74 //y2=4.88
r533 (  53 54 ) resistor r=0.103207 //w=0.196 //l=0.14 //layer=m1 \
 //thickness=0.36 //x=9.742 //y=4.88 //x2=9.742 //y2=4.74
r534 (  50 115 ) resistor r=9.3 //w=0.17 //l=0.17 //layer=mcon //count=1 \
 //x=9.74 //y=2.26 //x2=9.74 //y2=2.26
r535 (  46 72 ) resistor r=4.5 //w=0.15 //l=0.15 //layer=via1 //count=1 \
 //x=9.735 //y=3.505 //x2=9.735 //y2=3.505
r536 (  46 48 ) resistor r=0.00167112 //w=0.374 //l=0.005 //layer=m1 \
 //thickness=0.36 //x=9.685 //y=3.505 //x2=9.685 //y2=3.51
r537 (  43 70 ) resistor r=4.5 //w=0.15 //l=0.15 //layer=via1 //count=1 \
 //x=7.885 //y=3.51 //x2=7.885 //y2=3.51
r538 (  40 187 ) resistor r=9.3 //w=0.17 //l=0.17 //layer=mcon //count=1 \
 //x=7.45 //y=1.18 //x2=7.45 //y2=1.18
r539 (  38 98 ) resistor r=9.3 //w=0.17 //l=0.17 //layer=mcon //count=1 \
 //x=7.41 //y=5.56 //x2=7.41 //y2=5.56
r540 (  35 38 ) resistor r=0.117801 //w=0.191 //l=0.18 //layer=m1 \
 //thickness=0.36 //x=7.41 //y=5.38 //x2=7.41 //y2=5.56
r541 (  34 90 ) resistor r=9.3 //w=0.17 //l=0.17 //layer=mcon //count=1 \
 //x=6.53 //y=5.56 //x2=6.53 //y2=5.56
r542 (  32 34 ) resistor r=0.10274 //w=0.219 //l=0.18 //layer=m1 \
 //thickness=0.36 //x=6.53 //y=5.38 //x2=6.53 //y2=5.56
r543 (  30 67 ) resistor r=4.5 //w=0.15 //l=0.15 //layer=via1 //count=1 \
 //x=3.825 //y=3.51 //x2=3.825 //y2=3.51
r544 (  28 85 ) resistor r=9.3 //w=0.17 //l=0.17 //layer=mcon //count=1 \
 //x=3.82 //y=4.88 //x2=3.82 //y2=4.88
r545 (  26 76 ) resistor r=9.3 //w=0.17 //l=0.17 //layer=mcon //count=1 \
 //x=3.82 //y=2.26 //x2=3.82 //y2=2.26
r546 (  23 48 ) resistor r=0.089409 //w=0.374 //l=0.180416 //layer=m1 \
 //thickness=0.36 //x=9.74 //y=3.665 //x2=9.685 //y2=3.51
r547 (  23 54 ) resistor r=1.02576 //w=0.131 //l=1.075 //layer=m1 \
 //thickness=0.36 //x=9.74 //y=3.665 //x2=9.74 //y2=4.74
r548 (  22 46 ) resistor r=0.0910802 //w=0.374 //l=0.185472 //layer=m1 \
 //thickness=0.36 //x=9.74 //y=3.345 //x2=9.685 //y2=3.505
r549 (  21 50 ) resistor r=0.0933015 //w=0.201 //l=0.125 //layer=m1 \
 //thickness=0.36 //x=9.74 //y=2.385 //x2=9.74 //y2=2.26
r550 (  21 22 ) resistor r=0.916031 //w=0.131 //l=0.96 //layer=m1 \
 //thickness=0.36 //x=9.74 //y=2.385 //x2=9.74 //y2=3.345
r551 (  19 43 ) resistor r=0.0910802 //w=0.374 //l=0.185472 //layer=m1 \
 //thickness=0.36 //x=7.89 //y=3.67 //x2=7.835 //y2=3.51
r552 (  19 20 ) resistor r=1.55057 //w=0.131 //l=1.625 //layer=m1 \
 //thickness=0.36 //x=7.89 //y=3.67 //x2=7.89 //y2=5.295
r553 (  18 43 ) resistor r=0.0910802 //w=0.374 //l=0.185472 //layer=m1 \
 //thickness=0.36 //x=7.89 //y=3.35 //x2=7.835 //y2=3.51
r554 (  17 18 ) resistor r=1.3645 //w=0.131 //l=1.43 //layer=m1 \
 //thickness=0.36 //x=7.89 //y=1.92 //x2=7.89 //y2=3.35
r555 (  15 17 ) resistor r=0.0698411 //w=0.17 //l=0.120208 //layer=m1 \
 //thickness=0.36 //x=7.805 //y=1.835 //x2=7.89 //y2=1.92
r556 (  15 16 ) resistor r=0.257634 //w=0.131 //l=0.27 //layer=m1 \
 //thickness=0.36 //x=7.805 //y=1.835 //x2=7.535 //y2=1.835
r557 (  14 35 ) resistor r=0.0257089 //w=0.23 //l=0.115 //layer=m1 \
 //thickness=0.36 //x=7.525 //y=5.38 //x2=7.41 //y2=5.38
r558 (  13 20 ) resistor r=0.0698411 //w=0.17 //l=0.120208 //layer=m1 \
 //thickness=0.36 //x=7.805 //y=5.38 //x2=7.89 //y2=5.295
r559 (  13 14 ) resistor r=0.267176 //w=0.131 //l=0.28 //layer=m1 \
 //thickness=0.36 //x=7.805 //y=5.38 //x2=7.525 //y2=5.38
r560 (  12 16 ) resistor r=0.0698411 //w=0.17 //l=0.120208 //layer=m1 \
 //thickness=0.36 //x=7.45 //y=1.75 //x2=7.535 //y2=1.835
r561 (  11 40 ) resistor r=0.0913624 //w=0.191 //l=0.12 //layer=m1 \
 //thickness=0.36 //x=7.45 //y=1.3 //x2=7.45 //y2=1.18
r562 (  11 12 ) resistor r=0.429389 //w=0.131 //l=0.45 //layer=m1 \
 //thickness=0.36 //x=7.45 //y=1.3 //x2=7.45 //y2=1.75
r563 (  8 32 ) resistor r=0.0227762 //w=0.219 //l=0.115 //layer=m1 \
 //thickness=0.36 //x=6.645 //y=5.38 //x2=6.53 //y2=5.38
r564 (  7 35 ) resistor r=0.0257089 //w=0.23 //l=0.115 //layer=m1 \
 //thickness=0.36 //x=7.295 //y=5.38 //x2=7.41 //y2=5.38
r565 (  7 8 ) resistor r=0.620229 //w=0.131 //l=0.65 //layer=m1 \
 //thickness=0.36 //x=7.295 //y=5.38 //x2=6.645 //y2=5.38
r566 (  4 28 ) resistor r=0.0801089 //w=0.224 //l=0.13 //layer=m1 \
 //thickness=0.36 //x=3.82 //y=4.75 //x2=3.82 //y2=4.88
r567 (  3 30 ) resistor r=0.0910802 //w=0.374 //l=0.185472 //layer=m1 \
 //thickness=0.36 //x=3.82 //y=3.67 //x2=3.875 //y2=3.51
r568 (  3 4 ) resistor r=1.03053 //w=0.131 //l=1.08 //layer=m1 \
 //thickness=0.36 //x=3.82 //y=3.67 //x2=3.82 //y2=4.75
r569 (  2 30 ) resistor r=0.0910802 //w=0.374 //l=0.185472 //layer=m1 \
 //thickness=0.36 //x=3.82 //y=3.35 //x2=3.875 //y2=3.51
r570 (  1 26 ) resistor r=0.0719237 //w=0.222 //l=0.115 //layer=m1 \
 //thickness=0.36 //x=3.82 //y=2.375 //x2=3.82 //y2=2.26
r571 (  1 2 ) resistor r=0.930344 //w=0.131 //l=0.975 //layer=m1 \
 //thickness=0.36 //x=3.82 //y=2.375 //x2=3.82 //y2=3.35
ends PM_DFFX1\%noxref_1

subckt PM_DFFX1\%noxref_2 ( 3 8 9 11 12 14 15 16 18 19 23 24 27 29 32 35 38 41 \
 42 44 45 50 53 61 78 87 91 92 93 94 95 96 97 101 103 106 107 117 120 122 123 )
c276 ( 120 0 ) capacitor c=0.00878249f //x=10.59 //y=1.085
c277 ( 117 0 ) capacitor c=0.0682508f //x=13.07 //y=4.88
c278 ( 107 0 ) capacitor c=0.0318956f //x=13.405 //y=1.39
c279 ( 106 0 ) capacitor c=0.0186809f //x=13.405 //y=1.045
c280 ( 103 0 ) capacitor c=0.0141821f //x=13.25 //y=1.545
c281 ( 101 0 ) capacitor c=0.0158553f //x=13.25 //y=0.89
c282 ( 97 0 ) capacitor c=0.0854195f //x=12.875 //y=2.095
c283 ( 96 0 ) capacitor c=0.0229235f //x=12.875 //y=1.7
c284 ( 95 0 ) capacitor c=0.0234359f //x=12.875 //y=1.39
c285 ( 94 0 ) capacitor c=0.0198759f //x=12.875 //y=1.045
c286 ( 93 0 ) capacitor c=0.110369f //x=13.41 //y=6.2
c287 ( 92 0 ) capacitor c=0.154619f //x=12.97 //y=6.2
c288 ( 87 0 ) capacitor c=8.13425e-19 //x=13.07 //y=4.88
c289 ( 78 0 ) capacitor c=7.85889e-19 //x=13.07 //y=2.26
c290 ( 61 0 ) capacitor c=0.0322017f //x=10.74 //y=5.56
c291 ( 53 0 ) capacitor c=0.0291714f //x=9.86 //y=5.56
c292 ( 50 0 ) capacitor c=0.00162839f //x=13.065 //y=3.51
c293 ( 45 0 ) capacitor c=0.00317997f //x=11.385 //y=3.51
c294 ( 44 0 ) capacitor c=0.0479792f //x=12.905 //y=3.51
c295 ( 42 0 ) capacitor c=0.0270867f //x=13.072 //y=4.74
c296 ( 41 0 ) capacitor c=0.0060492f //x=13.07 //y=4.88
c297 ( 38 0 ) capacitor c=0.00641145f //x=13.07 //y=2.26
c298 ( 35 0 ) capacitor c=0.0164425f //x=13.065 //y=3.51
c299 ( 32 0 ) capacitor c=0.0167895f //x=11.22 //y=3.51
c300 ( 29 0 ) capacitor c=0.0114498f //x=10.78 //y=1.18
c301 ( 27 0 ) capacitor c=5.78613e-19 //x=10.74 //y=5.56
c302 ( 24 0 ) capacitor c=0.0103127f //x=10.74 //y=5.38
c303 ( 23 0 ) capacitor c=0.00933334f //x=9.86 //y=5.56
c304 ( 19 0 ) capacitor c=0.0132504f //x=13.07 //y=3.67
c305 ( 18 0 ) capacitor c=0.0289239f //x=13.07 //y=3.35
c306 ( 16 0 ) capacitor c=0.0402153f //x=11.22 //y=5.295
c307 ( 15 0 ) capacitor c=0.0132747f //x=11.22 //y=3.67
c308 ( 14 0 ) capacitor c=0.0397593f //x=11.22 //y=3.35
c309 ( 12 0 ) capacitor c=0.00671763f //x=10.865 //y=1.835
c310 ( 11 0 ) capacitor c=0.0143344f //x=11.135 //y=1.835
c311 ( 9 0 ) capacitor c=0.0112475f //x=11.135 //y=5.38
c312 ( 8 0 ) capacitor c=0.0101547f //x=10.78 //y=1.75
c313 ( 3 0 ) capacitor c=0.0134484f //x=10.625 //y=5.38
r314 (  115 117 ) resistor r=20.6867 //w=0.233 //l=0.1 //layer=ply \
 //thickness=0.18 //x=12.97 //y=4.88 //x2=13.07 //y2=4.88
r315 (  108 117 ) resistor r=70.3348 //w=0.233 //l=0.414367 //layer=ply \
 //thickness=0.18 //x=13.41 //y=5.045 //x2=13.07 //y2=4.88
r316 (  107 119 ) resistor r=45.1352 //w=0.168 //l=0.173853 //layer=ply \
 //thickness=0.18 //x=13.405 //y=1.39 //x2=13.365 //y2=1.545
r317 (  106 118 ) resistor r=45.1352 //w=0.168 //l=0.173853 //layer=ply \
 //thickness=0.18 //x=13.405 //y=1.045 //x2=13.365 //y2=0.89
r318 (  106 107 ) resistor r=176.904 //w=0.094 //l=0.345 //layer=ply \
 //thickness=0.18 //x=13.405 //y=1.045 //x2=13.405 //y2=1.39
r319 (  104 114 ) resistor r=10.701 //w=0.21 //l=0.115 //layer=ply \
 //thickness=0.18 //x=13.03 //y=1.545 //x2=12.915 //y2=1.545
r320 (  103 119 ) resistor r=5.52526 //w=0.168 //l=0.115 //layer=ply \
 //thickness=0.18 //x=13.25 //y=1.545 //x2=13.365 //y2=1.545
r321 (  102 113 ) resistor r=5.52526 //w=0.168 //l=0.115 //layer=ply \
 //thickness=0.18 //x=13.03 //y=0.89 //x2=12.915 //y2=0.89
r322 (  101 118 ) resistor r=5.52526 //w=0.168 //l=0.115 //layer=ply \
 //thickness=0.18 //x=13.25 //y=0.89 //x2=13.365 //y2=0.89
r323 (  101 102 ) resistor r=112.809 //w=0.094 //l=0.22 //layer=ply \
 //thickness=0.18 //x=13.25 //y=0.89 //x2=13.03 //y2=0.89
r324 (  98 115 ) resistor r=13.0941 //w=0.233 //l=0.165 //layer=ply \
 //thickness=0.18 //x=12.97 //y=5.045 //x2=12.97 //y2=4.88
r325 (  97 112 ) resistor r=34.8111 //w=0.27 //l=0.264953 //layer=ply \
 //thickness=0.18 //x=12.875 //y=2.095 //x2=13.07 //y2=2.26
r326 (  96 114 ) resistor r=39.5823 //w=0.21 //l=0.173853 //layer=ply \
 //thickness=0.18 //x=12.875 //y=1.7 //x2=12.915 //y2=1.545
r327 (  96 97 ) resistor r=202.543 //w=0.094 //l=0.395 //layer=ply \
 //thickness=0.18 //x=12.875 //y=1.7 //x2=12.875 //y2=2.095
r328 (  95 114 ) resistor r=39.5823 //w=0.21 //l=0.173853 //layer=ply \
 //thickness=0.18 //x=12.875 //y=1.39 //x2=12.915 //y2=1.545
r329 (  94 113 ) resistor r=45.1352 //w=0.168 //l=0.173853 //layer=ply \
 //thickness=0.18 //x=12.875 //y=1.045 //x2=12.915 //y2=0.89
r330 (  94 95 ) resistor r=176.904 //w=0.094 //l=0.345 //layer=ply \
 //thickness=0.18 //x=12.875 //y=1.045 //x2=12.875 //y2=1.39
r331 (  93 108 ) resistor r=592.245 //w=0.094 //l=1.155 //layer=ply \
 //thickness=0.18 //x=13.41 //y=6.2 //x2=13.41 //y2=5.045
r332 (  92 98 ) resistor r=592.245 //w=0.094 //l=1.155 //layer=ply \
 //thickness=0.18 //x=12.97 //y=6.2 //x2=12.97 //y2=5.045
r333 (  91 103 ) resistor r=56.4043 //w=0.094 //l=0.11 //layer=ply \
 //thickness=0.18 //x=13.14 //y=1.545 //x2=13.25 //y2=1.545
r334 (  91 104 ) resistor r=56.4043 //w=0.094 //l=0.11 //layer=ply \
 //thickness=0.18 //x=13.14 //y=1.545 //x2=13.03 //y2=1.545
r335 (  87 117 ) resistor r=152 //w=0.17 //l=0.17 //layer=licon //count=1 \
 //x=13.07 //y=4.88 //x2=13.07 //y2=4.88
r336 (  78 112 ) resistor r=152 //w=0.17 //l=0.17 //layer=licon //count=1 \
 //x=13.07 //y=2.26 //x2=13.07 //y2=2.26
r337 (  61 123 ) resistor r=23.615 //w=0.187 //l=0.345 //layer=li \
 //thickness=0.1 //x=10.74 //y=5.56 //x2=10.74 //y2=5.905
r338 (  53 122 ) resistor r=23.615 //w=0.187 //l=0.345 //layer=li \
 //thickness=0.1 //x=9.86 //y=5.56 //x2=9.86 //y2=5.905
r339 (  45 47 ) resistor r=0.10734 //w=0.281 //l=0.16 //layer=m2 \
 //thickness=0.36 //x=11.385 //y=3.51 //x2=11.225 //y2=3.51
r340 (  44 50 ) resistor r=0.10734 //w=0.281 //l=0.16 //layer=m2 \
 //thickness=0.36 //x=12.905 //y=3.51 //x2=13.065 //y2=3.51
r341 (  44 45 ) resistor r=1.45038 //w=0.131 //l=1.52 //layer=m2 \
 //thickness=0.36 //x=12.905 //y=3.51 //x2=11.385 //y2=3.51
r342 (  41 87 ) resistor r=9.3 //w=0.17 //l=0.17 //layer=mcon //count=1 \
 //x=13.07 //y=4.88 //x2=13.07 //y2=4.88
r343 (  41 42 ) resistor r=0.103207 //w=0.196 //l=0.14 //layer=m1 \
 //thickness=0.36 //x=13.072 //y=4.88 //x2=13.072 //y2=4.74
r344 (  38 78 ) resistor r=9.3 //w=0.17 //l=0.17 //layer=mcon //count=1 \
 //x=13.07 //y=2.26 //x2=13.07 //y2=2.26
r345 (  35 50 ) resistor r=4.5 //w=0.15 //l=0.15 //layer=via1 //count=1 \
 //x=13.065 //y=3.51 //x2=13.065 //y2=3.51
r346 (  32 47 ) resistor r=4.5 //w=0.15 //l=0.15 //layer=via1 //count=1 \
 //x=11.225 //y=3.51 //x2=11.225 //y2=3.51
r347 (  29 120 ) resistor r=9.3 //w=0.17 //l=0.17 //layer=mcon //count=1 \
 //x=10.78 //y=1.18 //x2=10.78 //y2=1.18
r348 (  27 61 ) resistor r=9.3 //w=0.17 //l=0.17 //layer=mcon //count=1 \
 //x=10.74 //y=5.56 //x2=10.74 //y2=5.56
r349 (  24 27 ) resistor r=0.117801 //w=0.191 //l=0.18 //layer=m1 \
 //thickness=0.36 //x=10.74 //y=5.38 //x2=10.74 //y2=5.56
r350 (  23 53 ) resistor r=9.3 //w=0.17 //l=0.17 //layer=mcon //count=1 \
 //x=9.86 //y=5.56 //x2=9.86 //y2=5.56
r351 (  21 23 ) resistor r=0.10274 //w=0.219 //l=0.18 //layer=m1 \
 //thickness=0.36 //x=9.86 //y=5.38 //x2=9.86 //y2=5.56
r352 (  19 35 ) resistor r=0.0910802 //w=0.374 //l=0.185472 //layer=m1 \
 //thickness=0.36 //x=13.07 //y=3.67 //x2=13.015 //y2=3.51
r353 (  19 42 ) resistor r=1.02099 //w=0.131 //l=1.07 //layer=m1 \
 //thickness=0.36 //x=13.07 //y=3.67 //x2=13.07 //y2=4.74
r354 (  18 35 ) resistor r=0.0910802 //w=0.374 //l=0.185472 //layer=m1 \
 //thickness=0.36 //x=13.07 //y=3.35 //x2=13.015 //y2=3.51
r355 (  17 38 ) resistor r=0.0933015 //w=0.201 //l=0.125 //layer=m1 \
 //thickness=0.36 //x=13.07 //y=2.385 //x2=13.07 //y2=2.26
r356 (  17 18 ) resistor r=0.920802 //w=0.131 //l=0.965 //layer=m1 \
 //thickness=0.36 //x=13.07 //y=2.385 //x2=13.07 //y2=3.35
r357 (  15 32 ) resistor r=0.0910802 //w=0.374 //l=0.185472 //layer=m1 \
 //thickness=0.36 //x=11.22 //y=3.67 //x2=11.275 //y2=3.51
r358 (  15 16 ) resistor r=1.55057 //w=0.131 //l=1.625 //layer=m1 \
 //thickness=0.36 //x=11.22 //y=3.67 //x2=11.22 //y2=5.295
r359 (  14 32 ) resistor r=0.0910802 //w=0.374 //l=0.185472 //layer=m1 \
 //thickness=0.36 //x=11.22 //y=3.35 //x2=11.275 //y2=3.51
r360 (  13 14 ) resistor r=1.3645 //w=0.131 //l=1.43 //layer=m1 \
 //thickness=0.36 //x=11.22 //y=1.92 //x2=11.22 //y2=3.35
r361 (  11 13 ) resistor r=0.0698411 //w=0.17 //l=0.120208 //layer=m1 \
 //thickness=0.36 //x=11.135 //y=1.835 //x2=11.22 //y2=1.92
r362 (  11 12 ) resistor r=0.257634 //w=0.131 //l=0.27 //layer=m1 \
 //thickness=0.36 //x=11.135 //y=1.835 //x2=10.865 //y2=1.835
r363 (  10 24 ) resistor r=0.0257089 //w=0.23 //l=0.115 //layer=m1 \
 //thickness=0.36 //x=10.855 //y=5.38 //x2=10.74 //y2=5.38
r364 (  9 16 ) resistor r=0.0698411 //w=0.17 //l=0.120208 //layer=m1 \
 //thickness=0.36 //x=11.135 //y=5.38 //x2=11.22 //y2=5.295
r365 (  9 10 ) resistor r=0.267176 //w=0.131 //l=0.28 //layer=m1 \
 //thickness=0.36 //x=11.135 //y=5.38 //x2=10.855 //y2=5.38
r366 (  8 12 ) resistor r=0.0698411 //w=0.17 //l=0.120208 //layer=m1 \
 //thickness=0.36 //x=10.78 //y=1.75 //x2=10.865 //y2=1.835
r367 (  7 29 ) resistor r=0.0913624 //w=0.191 //l=0.12 //layer=m1 \
 //thickness=0.36 //x=10.78 //y=1.3 //x2=10.78 //y2=1.18
r368 (  7 8 ) resistor r=0.429389 //w=0.131 //l=0.45 //layer=m1 \
 //thickness=0.36 //x=10.78 //y=1.3 //x2=10.78 //y2=1.75
r369 (  4 21 ) resistor r=0.0227762 //w=0.219 //l=0.115 //layer=m1 \
 //thickness=0.36 //x=9.975 //y=5.38 //x2=9.86 //y2=5.38
r370 (  3 24 ) resistor r=0.0257089 //w=0.23 //l=0.115 //layer=m1 \
 //thickness=0.36 //x=10.625 //y=5.38 //x2=10.74 //y2=5.38
r371 (  3 4 ) resistor r=0.620229 //w=0.131 //l=0.65 //layer=m1 \
 //thickness=0.36 //x=10.625 //y=5.38 //x2=9.975 //y2=5.38
ends PM_DFFX1\%noxref_2

subckt PM_DFFX1\%CLK ( 1 2 3 4 5 6 7 8 9 10 11 12 28 34 40 43 45 47 53 58 63 \
 68 72 73 74 75 76 77 78 79 80 82 88 89 90 91 92 97 98 99 104 106 108 114 115 \
 119 128 129 132 )
c287 ( 132 0 ) capacitor c=0.0366322f //x=13.84 //y=4.88
c288 ( 129 0 ) capacitor c=0.0284095f //x=13.81 //y=2.095
c289 ( 128 0 ) capacitor c=0.0476356f //x=13.81 //y=2.26
c290 ( 119 0 ) capacitor c=0.0372825f //x=2.71 //y=4.88
c291 ( 115 0 ) capacitor c=0.0439708f //x=14.375 //y=1.43
c292 ( 114 0 ) capacitor c=0.0192582f //x=14.375 //y=1.085
c293 ( 108 0 ) capacitor c=0.0162526f //x=14.22 //y=1.585
c294 ( 106 0 ) capacitor c=0.0157807f //x=14.22 //y=0.93
c295 ( 104 0 ) capacitor c=0.0353784f //x=14.215 //y=4.97
c296 ( 99 0 ) capacitor c=0.0210762f //x=13.845 //y=1.74
c297 ( 98 0 ) capacitor c=0.0168511f //x=13.845 //y=1.43
c298 ( 97 0 ) capacitor c=0.0175485f //x=13.845 //y=1.085
c299 ( 92 0 ) capacitor c=0.0305913f //x=3.045 //y=4.97
c300 ( 91 0 ) capacitor c=0.0863671f //x=2.8 //y=2.095
c301 ( 90 0 ) capacitor c=0.0170266f //x=2.8 //y=1.63
c302 ( 89 0 ) capacitor c=0.018609f //x=2.8 //y=1.4
c303 ( 88 0 ) capacitor c=0.0186599f //x=2.8 //y=1.09
c304 ( 82 0 ) capacitor c=0.0146988f //x=2.645 //y=1.555
c305 ( 80 0 ) capacitor c=0.0148531f //x=2.645 //y=0.935
c306 ( 79 0 ) capacitor c=0.0334406f //x=2.275 //y=1.4
c307 ( 78 0 ) capacitor c=0.0173191f //x=2.275 //y=1.09
c308 ( 77 0 ) capacitor c=0.155269f //x=14.29 //y=6.2
c309 ( 76 0 ) capacitor c=0.110375f //x=13.85 //y=6.2
c310 ( 75 0 ) capacitor c=0.110208f //x=3.12 //y=6.2
c311 ( 74 0 ) capacitor c=0.110214f //x=2.68 //y=6.2
c312 ( 68 0 ) capacitor c=8.63406e-19 //x=13.84 //y=4.88
c313 ( 63 0 ) capacitor c=7.72439e-19 //x=13.81 //y=2.26
c314 ( 58 0 ) capacitor c=0.00143828f //x=2.71 //y=4.88
c315 ( 53 0 ) capacitor c=0.00121786f //x=2.71 //y=2.26
c316 ( 47 0 ) capacitor c=0.00183922f //x=2.71 //y=4.62
c317 ( 45 0 ) capacitor c=0.0886214f //x=10.7 //y=4.64
c318 ( 43 0 ) capacitor c=0.178908f //x=10.1 //y=4.62
c319 ( 40 0 ) capacitor c=0.00680024f //x=13.81 //y=2.26
c320 ( 34 0 ) capacitor c=0.00622154f //x=13.835 //y=4.865
c321 ( 28 0 ) capacitor c=0.00551512f //x=2.71 //y=4.88
c322 ( 12 0 ) capacitor c=0.00565957f //x=2.71 //y=2.375
c323 ( 7 0 ) capacitor c=0.0509274f //x=13.81 //y=2.4
c324 ( 1 0 ) capacitor c=0.0678123f //x=2.71 //y=2.4
r325 (  134 135 ) resistor r=32.4568 //w=0.214 //l=0.075 //layer=ply \
 //thickness=0.18 //x=13.84 //y=4.97 //x2=13.84 //y2=5.045
r326 (  132 134 ) resistor r=20.271 //w=0.214 //l=0.09 //layer=ply \
 //thickness=0.18 //x=13.84 //y=4.88 //x2=13.84 //y2=4.97
r327 (  128 129 ) resistor r=52.7279 //w=0.214 //l=0.165 //layer=ply \
 //thickness=0.18 //x=13.81 //y=2.26 //x2=13.81 //y2=2.095
r328 (  121 122 ) resistor r=32.4568 //w=0.214 //l=0.075 //layer=ply \
 //thickness=0.18 //x=2.71 //y=4.97 //x2=2.71 //y2=5.045
r329 (  119 121 ) resistor r=20.271 //w=0.214 //l=0.09 //layer=ply \
 //thickness=0.18 //x=2.71 //y=4.88 //x2=2.71 //y2=4.97
r330 (  115 139 ) resistor r=45.1352 //w=0.168 //l=0.173853 //layer=ply \
 //thickness=0.18 //x=14.375 //y=1.43 //x2=14.335 //y2=1.585
r331 (  114 138 ) resistor r=45.1352 //w=0.168 //l=0.173853 //layer=ply \
 //thickness=0.18 //x=14.375 //y=1.085 //x2=14.335 //y2=0.93
r332 (  114 115 ) resistor r=176.904 //w=0.094 //l=0.345 //layer=ply \
 //thickness=0.18 //x=14.375 //y=1.085 //x2=14.375 //y2=1.43
r333 (  109 137 ) resistor r=10.701 //w=0.21 //l=0.115 //layer=ply \
 //thickness=0.18 //x=14 //y=1.585 //x2=13.885 //y2=1.585
r334 (  108 139 ) resistor r=5.52526 //w=0.168 //l=0.115 //layer=ply \
 //thickness=0.18 //x=14.22 //y=1.585 //x2=14.335 //y2=1.585
r335 (  107 136 ) resistor r=5.52526 //w=0.168 //l=0.115 //layer=ply \
 //thickness=0.18 //x=14 //y=0.93 //x2=13.885 //y2=0.93
r336 (  106 138 ) resistor r=5.52526 //w=0.168 //l=0.115 //layer=ply \
 //thickness=0.18 //x=14.22 //y=0.93 //x2=14.335 //y2=0.93
r337 (  106 107 ) resistor r=112.809 //w=0.094 //l=0.22 //layer=ply \
 //thickness=0.18 //x=14.22 //y=0.93 //x2=14 //y2=0.93
r338 (  105 134 ) resistor r=16.5046 //w=0.27 //l=0.135 //layer=ply \
 //thickness=0.18 //x=13.975 //y=4.97 //x2=13.84 //y2=4.97
r339 (  104 111 ) resistor r=26.9307 //w=0.15 //l=0.106066 //layer=ply \
 //thickness=0.18 //x=14.215 //y=4.97 //x2=14.29 //y2=5.045
r340 (  104 105 ) resistor r=123.064 //w=0.094 //l=0.24 //layer=ply \
 //thickness=0.18 //x=14.215 //y=4.97 //x2=13.975 //y2=4.97
r341 (  99 137 ) resistor r=39.5823 //w=0.21 //l=0.173853 //layer=ply \
 //thickness=0.18 //x=13.845 //y=1.74 //x2=13.885 //y2=1.585
r342 (  99 129 ) resistor r=182.032 //w=0.094 //l=0.355 //layer=ply \
 //thickness=0.18 //x=13.845 //y=1.74 //x2=13.845 //y2=2.095
r343 (  98 137 ) resistor r=39.5823 //w=0.21 //l=0.173853 //layer=ply \
 //thickness=0.18 //x=13.845 //y=1.43 //x2=13.885 //y2=1.585
r344 (  97 136 ) resistor r=45.1352 //w=0.168 //l=0.173853 //layer=ply \
 //thickness=0.18 //x=13.845 //y=1.085 //x2=13.885 //y2=0.93
r345 (  97 98 ) resistor r=176.904 //w=0.094 //l=0.345 //layer=ply \
 //thickness=0.18 //x=13.845 //y=1.085 //x2=13.845 //y2=1.43
r346 (  93 121 ) resistor r=16.5046 //w=0.27 //l=0.135 //layer=ply \
 //thickness=0.18 //x=2.845 //y=4.97 //x2=2.71 //y2=4.97
r347 (  92 94 ) resistor r=26.9307 //w=0.15 //l=0.106066 //layer=ply \
 //thickness=0.18 //x=3.045 //y=4.97 //x2=3.12 //y2=5.045
r348 (  92 93 ) resistor r=102.553 //w=0.094 //l=0.2 //layer=ply \
 //thickness=0.18 //x=3.045 //y=4.97 //x2=2.845 //y2=4.97
r349 (  91 126 ) resistor r=38.6777 //w=0.284 //l=0.198997 //layer=ply \
 //thickness=0.18 //x=2.8 //y=2.095 //x2=2.725 //y2=2.26
r350 (  90 124 ) resistor r=21.2976 //w=0.217 //l=0.0928709 //layer=ply \
 //thickness=0.18 //x=2.8 //y=1.63 //x2=2.76 //y2=1.555
r351 (  90 91 ) resistor r=238.436 //w=0.094 //l=0.465 //layer=ply \
 //thickness=0.18 //x=2.8 //y=1.63 //x2=2.8 //y2=2.095
r352 (  89 124 ) resistor r=39.0671 //w=0.217 //l=0.173853 //layer=ply \
 //thickness=0.18 //x=2.8 //y=1.4 //x2=2.76 //y2=1.555
r353 (  88 123 ) resistor r=45.1352 //w=0.168 //l=0.173853 //layer=ply \
 //thickness=0.18 //x=2.8 //y=1.09 //x2=2.76 //y2=0.935
r354 (  88 89 ) resistor r=158.957 //w=0.094 //l=0.31 //layer=ply \
 //thickness=0.18 //x=2.8 //y=1.09 //x2=2.8 //y2=1.4
r355 (  83 117 ) resistor r=5.52526 //w=0.168 //l=0.115 //layer=ply \
 //thickness=0.18 //x=2.43 //y=1.555 //x2=2.315 //y2=1.555
r356 (  82 124 ) resistor r=11.4558 //w=0.217 //l=0.115 //layer=ply \
 //thickness=0.18 //x=2.645 //y=1.555 //x2=2.76 //y2=1.555
r357 (  81 116 ) resistor r=5.52526 //w=0.168 //l=0.115 //layer=ply \
 //thickness=0.18 //x=2.43 //y=0.935 //x2=2.315 //y2=0.935
r358 (  80 123 ) resistor r=5.52526 //w=0.168 //l=0.115 //layer=ply \
 //thickness=0.18 //x=2.645 //y=0.935 //x2=2.76 //y2=0.935
r359 (  80 81 ) resistor r=110.245 //w=0.094 //l=0.215 //layer=ply \
 //thickness=0.18 //x=2.645 //y=0.935 //x2=2.43 //y2=0.935
r360 (  79 117 ) resistor r=45.1352 //w=0.168 //l=0.173853 //layer=ply \
 //thickness=0.18 //x=2.275 //y=1.4 //x2=2.315 //y2=1.555
r361 (  78 116 ) resistor r=45.1352 //w=0.168 //l=0.173853 //layer=ply \
 //thickness=0.18 //x=2.275 //y=1.09 //x2=2.315 //y2=0.935
r362 (  78 79 ) resistor r=158.957 //w=0.094 //l=0.31 //layer=ply \
 //thickness=0.18 //x=2.275 //y=1.09 //x2=2.275 //y2=1.4
r363 (  77 111 ) resistor r=592.245 //w=0.094 //l=1.155 //layer=ply \
 //thickness=0.18 //x=14.29 //y=6.2 //x2=14.29 //y2=5.045
r364 (  76 135 ) resistor r=592.245 //w=0.094 //l=1.155 //layer=ply \
 //thickness=0.18 //x=13.85 //y=6.2 //x2=13.85 //y2=5.045
r365 (  75 94 ) resistor r=592.245 //w=0.094 //l=1.155 //layer=ply \
 //thickness=0.18 //x=3.12 //y=6.2 //x2=3.12 //y2=5.045
r366 (  74 122 ) resistor r=592.245 //w=0.094 //l=1.155 //layer=ply \
 //thickness=0.18 //x=2.68 //y=6.2 //x2=2.68 //y2=5.045
r367 (  73 108 ) resistor r=56.4043 //w=0.094 //l=0.11 //layer=ply \
 //thickness=0.18 //x=14.11 //y=1.585 //x2=14.22 //y2=1.585
r368 (  73 109 ) resistor r=56.4043 //w=0.094 //l=0.11 //layer=ply \
 //thickness=0.18 //x=14.11 //y=1.585 //x2=14 //y2=1.585
r369 (  72 82 ) resistor r=55.3787 //w=0.094 //l=0.108 //layer=ply \
 //thickness=0.18 //x=2.537 //y=1.555 //x2=2.645 //y2=1.555
r370 (  72 83 ) resistor r=54.866 //w=0.094 //l=0.107 //layer=ply \
 //thickness=0.18 //x=2.537 //y=1.555 //x2=2.43 //y2=1.555
r371 (  68 132 ) resistor r=152 //w=0.17 //l=0.17 //layer=licon //count=1 \
 //x=13.84 //y=4.88 //x2=13.84 //y2=4.88
r372 (  63 128 ) resistor r=152 //w=0.17 //l=0.17 //layer=licon //count=1 \
 //x=13.81 //y=2.26 //x2=13.81 //y2=2.26
r373 (  58 119 ) resistor r=152 //w=0.17 //l=0.17 //layer=licon //count=1 \
 //x=2.71 //y=4.88 //x2=2.71 //y2=4.88
r374 (  53 126 ) resistor r=152 //w=0.17 //l=0.17 //layer=licon //count=1 \
 //x=2.71 //y=2.26 //x2=2.71 //y2=2.26
r375 (  47 49 ) resistor r=0.110922 //w=0.293 //l=0.26 //layer=m2 \
 //thickness=0.36 //x=2.71 //y=4.62 //x2=2.71 //y2=4.88
r376 (  45 51 ) resistor r=1.99191 //w=0.197 //l=3.16733 //layer=m2 \
 //thickness=0.36 //x=10.7 //y=4.64 //x2=13.835 //y2=4.705
r377 (  45 46 ) resistor r=0.329198 //w=0.131 //l=0.345 //layer=m2 \
 //thickness=0.36 //x=10.7 //y=4.64 //x2=10.355 //y2=4.64
r378 (  44 47 ) resistor r=0.040188 //w=0.293 //l=0.16 //layer=m2 \
 //thickness=0.36 //x=2.87 //y=4.62 //x2=2.71 //y2=4.62
r379 (  43 46 ) resistor r=0.1875 //w=0.17 //l=0.264811 //layer=m2 \
 //thickness=0.36 //x=10.1 //y=4.62 //x2=10.355 //y2=4.64
r380 (  43 44 ) resistor r=6.89885 //w=0.131 //l=7.23 //layer=m2 \
 //thickness=0.36 //x=10.1 //y=4.62 //x2=2.87 //y2=4.62
r381 (  40 63 ) resistor r=9.3 //w=0.17 //l=0.17 //layer=mcon //count=1 \
 //x=13.81 //y=2.26 //x2=13.81 //y2=2.26
r382 (  40 42 ) resistor r=0.0936408 //w=0.196 //l=0.125 //layer=m1 \
 //thickness=0.36 //x=13.812 //y=2.26 //x2=13.812 //y2=2.385
r383 (  37 68 ) resistor r=9.3 //w=0.17 //l=0.17 //layer=mcon //count=1 \
 //x=13.84 //y=4.88 //x2=13.84 //y2=4.88
r384 (  34 51 ) resistor r=4.5 //w=0.15 //l=0.15 //layer=via1 //count=1 \
 //x=13.835 //y=4.865 //x2=13.835 //y2=4.865
r385 (  34 37 ) resistor r=0.0066726 //w=0.281 //l=0.015 //layer=m1 \
 //thickness=0.36 //x=13.835 //y=4.865 //x2=13.835 //y2=4.88
r386 (  34 35 ) resistor r=0.10734 //w=0.281 //l=0.16 //layer=m1 \
 //thickness=0.36 //x=13.835 //y=4.865 //x2=13.835 //y2=4.705
r387 (  32 53 ) resistor r=9.3 //w=0.17 //l=0.17 //layer=mcon //count=1 \
 //x=2.71 //y=2.26 //x2=2.71 //y2=2.26
r388 (  28 58 ) resistor r=9.3 //w=0.17 //l=0.17 //layer=mcon //count=1 \
 //x=2.71 //y=4.88 //x2=2.71 //y2=4.88
r389 (  28 49 ) resistor r=4.5 //w=0.15 //l=0.15 //layer=via1 //count=1 \
 //x=2.71 //y=4.88 //x2=2.71 //y2=4.88
r390 (  13 28 ) resistor r=0.10734 //w=0.281 //l=0.16 //layer=m1 \
 //thickness=0.36 //x=2.71 //y=4.72 //x2=2.71 //y2=4.88
r391 (  12 32 ) resistor r=0.0715665 //w=0.226 //l=0.115996 //layer=m1 \
 //thickness=0.36 //x=2.71 //y=2.375 //x2=2.712 //y2=2.26
r392 (  11 35 ) resistor r=0.0811069 //w=0.131 //l=0.085 //layer=m1 \
 //thickness=0.36 //x=13.81 //y=4.62 //x2=13.81 //y2=4.705
r393 (  10 11 ) resistor r=1.05916 //w=0.131 //l=1.11 //layer=m1 \
 //thickness=0.36 //x=13.81 //y=3.51 //x2=13.81 //y2=4.62
r394 (  9 10 ) resistor r=0.353053 //w=0.131 //l=0.37 //layer=m1 \
 //thickness=0.36 //x=13.81 //y=3.14 //x2=13.81 //y2=3.51
r395 (  8 9 ) resistor r=0.353053 //w=0.131 //l=0.37 //layer=m1 \
 //thickness=0.36 //x=13.81 //y=2.77 //x2=13.81 //y2=3.14
r396 (  7 8 ) resistor r=0.353053 //w=0.131 //l=0.37 //layer=m1 \
 //thickness=0.36 //x=13.81 //y=2.4 //x2=13.81 //y2=2.77
r397 (  7 42 ) resistor r=0.014313 //w=0.131 //l=0.015 //layer=m1 \
 //thickness=0.36 //x=13.81 //y=2.4 //x2=13.81 //y2=2.385
r398 (  6 13 ) resistor r=0.0954198 //w=0.131 //l=0.1 //layer=m1 \
 //thickness=0.36 //x=2.71 //y=4.62 //x2=2.71 //y2=4.72
r399 (  5 6 ) resistor r=0.706107 //w=0.131 //l=0.74 //layer=m1 \
 //thickness=0.36 //x=2.71 //y=3.88 //x2=2.71 //y2=4.62
r400 (  4 5 ) resistor r=0.353053 //w=0.131 //l=0.37 //layer=m1 \
 //thickness=0.36 //x=2.71 //y=3.51 //x2=2.71 //y2=3.88
r401 (  3 4 ) resistor r=0.353053 //w=0.131 //l=0.37 //layer=m1 \
 //thickness=0.36 //x=2.71 //y=3.14 //x2=2.71 //y2=3.51
r402 (  2 3 ) resistor r=0.353053 //w=0.131 //l=0.37 //layer=m1 \
 //thickness=0.36 //x=2.71 //y=2.77 //x2=2.71 //y2=3.14
r403 (  1 2 ) resistor r=0.353053 //w=0.131 //l=0.37 //layer=m1 \
 //thickness=0.36 //x=2.71 //y=2.4 //x2=2.71 //y2=2.77
r404 (  1 12 ) resistor r=0.023855 //w=0.131 //l=0.025 //layer=m1 \
 //thickness=0.36 //x=2.71 //y=2.4 //x2=2.71 //y2=2.375
ends PM_DFFX1\%CLK

subckt PM_DFFX1\%noxref_4 ( 1 3 6 7 9 10 11 12 14 15 16 18 19 22 23 25 28 31 \
 37 40 43 46 47 50 54 57 58 60 61 62 63 64 66 68 70 72 74 84 92 100 117 126 \
 131 140 144 145 146 147 148 149 150 151 152 153 157 159 162 163 167 168 169 \
 170 174 176 179 180 190 199 202 204 205 206 )
c477 ( 202 0 ) capacitor c=0.00885916f //x=3.885 //y=1.095
c478 ( 199 0 ) capacitor c=0.0645411f //x=16.4 //y=4.88
c479 ( 190 0 ) capacitor c=0.0645923f //x=6.41 //y=4.88
c480 ( 180 0 ) capacitor c=0.0318956f //x=16.735 //y=1.39
c481 ( 179 0 ) capacitor c=0.0186809f //x=16.735 //y=1.045
c482 ( 176 0 ) capacitor c=0.0141821f //x=16.58 //y=1.545
c483 ( 174 0 ) capacitor c=0.0158553f //x=16.58 //y=0.89
c484 ( 170 0 ) capacitor c=0.088055f //x=16.205 //y=2.095
c485 ( 169 0 ) capacitor c=0.0229235f //x=16.205 //y=1.7
c486 ( 168 0 ) capacitor c=0.0234359f //x=16.205 //y=1.39
c487 ( 167 0 ) capacitor c=0.0198759f //x=16.205 //y=1.045
c488 ( 163 0 ) capacitor c=0.0318956f //x=6.745 //y=1.39
c489 ( 162 0 ) capacitor c=0.0186809f //x=6.745 //y=1.045
c490 ( 159 0 ) capacitor c=0.0141821f //x=6.59 //y=1.545
c491 ( 157 0 ) capacitor c=0.0158553f //x=6.59 //y=0.89
c492 ( 153 0 ) capacitor c=0.088055f //x=6.215 //y=2.095
c493 ( 152 0 ) capacitor c=0.0229235f //x=6.215 //y=1.7
c494 ( 151 0 ) capacitor c=0.0234359f //x=6.215 //y=1.39
c495 ( 150 0 ) capacitor c=0.0198759f //x=6.215 //y=1.045
c496 ( 149 0 ) capacitor c=0.110369f //x=16.74 //y=6.2
c497 ( 148 0 ) capacitor c=0.154619f //x=16.3 //y=6.2
c498 ( 147 0 ) capacitor c=0.110369f //x=6.75 //y=6.2
c499 ( 146 0 ) capacitor c=0.154619f //x=6.31 //y=6.2
c500 ( 140 0 ) capacitor c=8.13425e-19 //x=16.4 //y=4.88
c501 ( 131 0 ) capacitor c=7.85889e-19 //x=16.4 //y=2.26
c502 ( 126 0 ) capacitor c=8.13425e-19 //x=6.41 //y=4.88
c503 ( 117 0 ) capacitor c=7.85889e-19 //x=6.41 //y=2.26
c504 ( 100 0 ) capacitor c=0.0293071f //x=3.78 //y=5.56
c505 ( 92 0 ) capacitor c=0.029137f //x=2.9 //y=5.56
c506 ( 84 0 ) capacitor c=0.0278099f //x=2.02 //y=5.56
c507 ( 74 0 ) capacitor c=0.0891228f //x=13.28 //y=3.895
c508 ( 72 0 ) capacitor c=0.0175525f //x=12.68 //y=3.88
c509 ( 70 0 ) capacitor c=0.00410953f //x=11.44 //y=3.895
c510 ( 68 0 ) capacitor c=0.0176014f //x=10.7 //y=3.87
c511 ( 66 0 ) capacitor c=0.0106365f //x=9.95 //y=3.89
c512 ( 64 0 ) capacitor c=0.0178779f //x=9.35 //y=3.88
c513 ( 63 0 ) capacitor c=0.0105169f //x=7.755 //y=3.895
c514 ( 62 0 ) capacitor c=0.00467954f //x=8.1 //y=3.895
c515 ( 61 0 ) capacitor c=7.05145e-19 //x=4.72 //y=3.88
c516 ( 60 0 ) capacitor c=0.0193144f //x=6.245 //y=3.88
c517 ( 58 0 ) capacitor c=0.0167537f //x=16.402 //y=4.74
c518 ( 57 0 ) capacitor c=0.00598189f //x=16.4 //y=4.88
c519 ( 54 0 ) capacitor c=0.00654828f //x=16.4 //y=2.26
c520 ( 50 0 ) capacitor c=0.0142994f //x=16.4 //y=3.88
c521 ( 47 0 ) capacitor c=0.0172769f //x=6.412 //y=4.74
c522 ( 46 0 ) capacitor c=0.00598357f //x=6.41 //y=4.88
c523 ( 43 0 ) capacitor c=0.00654649f //x=6.41 //y=2.26
c524 ( 40 0 ) capacitor c=0.0163193f //x=6.405 //y=3.88
c525 ( 37 0 ) capacitor c=0.0170864f //x=4.56 //y=3.88
c526 ( 31 0 ) capacitor c=9.55882e-19 //x=3.78 //y=5.335
c527 ( 28 0 ) capacitor c=0.00753245f //x=2.9 //y=5.335
c528 ( 25 0 ) capacitor c=0.0123281f //x=2.022 //y=5.335
c529 ( 23 0 ) capacitor c=0.0124767f //x=16.4 //y=4.045
c530 ( 22 0 ) capacitor c=0.0406685f //x=16.4 //y=3.725
c531 ( 19 0 ) capacitor c=0.0124834f //x=6.41 //y=4.04
c532 ( 18 0 ) capacitor c=0.0389536f //x=6.41 //y=3.72
c533 ( 16 0 ) capacitor c=0.0309857f //x=4.56 //y=5.25
c534 ( 15 0 ) capacitor c=0.0132732f //x=4.56 //y=4.04
c535 ( 14 0 ) capacitor c=0.0507527f //x=4.56 //y=3.72
c536 ( 12 0 ) capacitor c=0.00686157f //x=4.16 //y=1.845
c537 ( 11 0 ) capacitor c=0.0159771f //x=4.475 //y=1.845
c538 ( 10 0 ) capacitor c=0.0136149f //x=4.075 //y=1.76
c539 ( 9 0 ) capacitor c=0.0112344f //x=4.075 //y=1.305
c540 ( 7 0 ) capacitor c=0.0228253f //x=4.475 //y=5.335
c541 ( 6 0 ) capacitor c=0.00906713f //x=3.78 //y=5.56
c542 ( 3 0 ) capacitor c=0.019596f //x=3.665 //y=5.335
c543 ( 1 0 ) capacitor c=0.0150747f //x=2.78 //y=5.335
r544 (  197 199 ) resistor r=20.6867 //w=0.233 //l=0.1 //layer=ply \
 //thickness=0.18 //x=16.3 //y=4.88 //x2=16.4 //y2=4.88
r545 (  188 190 ) resistor r=20.6867 //w=0.233 //l=0.1 //layer=ply \
 //thickness=0.18 //x=6.31 //y=4.88 //x2=6.41 //y2=4.88
r546 (  181 199 ) resistor r=70.3348 //w=0.233 //l=0.414367 //layer=ply \
 //thickness=0.18 //x=16.74 //y=5.045 //x2=16.4 //y2=4.88
r547 (  180 201 ) resistor r=45.1352 //w=0.168 //l=0.173853 //layer=ply \
 //thickness=0.18 //x=16.735 //y=1.39 //x2=16.695 //y2=1.545
r548 (  179 200 ) resistor r=45.1352 //w=0.168 //l=0.173853 //layer=ply \
 //thickness=0.18 //x=16.735 //y=1.045 //x2=16.695 //y2=0.89
r549 (  179 180 ) resistor r=176.904 //w=0.094 //l=0.345 //layer=ply \
 //thickness=0.18 //x=16.735 //y=1.045 //x2=16.735 //y2=1.39
r550 (  177 196 ) resistor r=10.701 //w=0.21 //l=0.115 //layer=ply \
 //thickness=0.18 //x=16.36 //y=1.545 //x2=16.245 //y2=1.545
r551 (  176 201 ) resistor r=5.52526 //w=0.168 //l=0.115 //layer=ply \
 //thickness=0.18 //x=16.58 //y=1.545 //x2=16.695 //y2=1.545
r552 (  175 195 ) resistor r=5.52526 //w=0.168 //l=0.115 //layer=ply \
 //thickness=0.18 //x=16.36 //y=0.89 //x2=16.245 //y2=0.89
r553 (  174 200 ) resistor r=5.52526 //w=0.168 //l=0.115 //layer=ply \
 //thickness=0.18 //x=16.58 //y=0.89 //x2=16.695 //y2=0.89
r554 (  174 175 ) resistor r=112.809 //w=0.094 //l=0.22 //layer=ply \
 //thickness=0.18 //x=16.58 //y=0.89 //x2=16.36 //y2=0.89
r555 (  171 197 ) resistor r=13.0941 //w=0.233 //l=0.165 //layer=ply \
 //thickness=0.18 //x=16.3 //y=5.045 //x2=16.3 //y2=4.88
r556 (  170 194 ) resistor r=34.8111 //w=0.27 //l=0.264953 //layer=ply \
 //thickness=0.18 //x=16.205 //y=2.095 //x2=16.4 //y2=2.26
r557 (  169 196 ) resistor r=39.5823 //w=0.21 //l=0.173853 //layer=ply \
 //thickness=0.18 //x=16.205 //y=1.7 //x2=16.245 //y2=1.545
r558 (  169 170 ) resistor r=202.543 //w=0.094 //l=0.395 //layer=ply \
 //thickness=0.18 //x=16.205 //y=1.7 //x2=16.205 //y2=2.095
r559 (  168 196 ) resistor r=39.5823 //w=0.21 //l=0.173853 //layer=ply \
 //thickness=0.18 //x=16.205 //y=1.39 //x2=16.245 //y2=1.545
r560 (  167 195 ) resistor r=45.1352 //w=0.168 //l=0.173853 //layer=ply \
 //thickness=0.18 //x=16.205 //y=1.045 //x2=16.245 //y2=0.89
r561 (  167 168 ) resistor r=176.904 //w=0.094 //l=0.345 //layer=ply \
 //thickness=0.18 //x=16.205 //y=1.045 //x2=16.205 //y2=1.39
r562 (  164 190 ) resistor r=70.3348 //w=0.233 //l=0.414367 //layer=ply \
 //thickness=0.18 //x=6.75 //y=5.045 //x2=6.41 //y2=4.88
r563 (  163 192 ) resistor r=45.1352 //w=0.168 //l=0.173853 //layer=ply \
 //thickness=0.18 //x=6.745 //y=1.39 //x2=6.705 //y2=1.545
r564 (  162 191 ) resistor r=45.1352 //w=0.168 //l=0.173853 //layer=ply \
 //thickness=0.18 //x=6.745 //y=1.045 //x2=6.705 //y2=0.89
r565 (  162 163 ) resistor r=176.904 //w=0.094 //l=0.345 //layer=ply \
 //thickness=0.18 //x=6.745 //y=1.045 //x2=6.745 //y2=1.39
r566 (  160 187 ) resistor r=10.701 //w=0.21 //l=0.115 //layer=ply \
 //thickness=0.18 //x=6.37 //y=1.545 //x2=6.255 //y2=1.545
r567 (  159 192 ) resistor r=5.52526 //w=0.168 //l=0.115 //layer=ply \
 //thickness=0.18 //x=6.59 //y=1.545 //x2=6.705 //y2=1.545
r568 (  158 186 ) resistor r=5.52526 //w=0.168 //l=0.115 //layer=ply \
 //thickness=0.18 //x=6.37 //y=0.89 //x2=6.255 //y2=0.89
r569 (  157 191 ) resistor r=5.52526 //w=0.168 //l=0.115 //layer=ply \
 //thickness=0.18 //x=6.59 //y=0.89 //x2=6.705 //y2=0.89
r570 (  157 158 ) resistor r=112.809 //w=0.094 //l=0.22 //layer=ply \
 //thickness=0.18 //x=6.59 //y=0.89 //x2=6.37 //y2=0.89
r571 (  154 188 ) resistor r=13.0941 //w=0.233 //l=0.165 //layer=ply \
 //thickness=0.18 //x=6.31 //y=5.045 //x2=6.31 //y2=4.88
r572 (  153 185 ) resistor r=34.8111 //w=0.27 //l=0.264953 //layer=ply \
 //thickness=0.18 //x=6.215 //y=2.095 //x2=6.41 //y2=2.26
r573 (  152 187 ) resistor r=39.5823 //w=0.21 //l=0.173853 //layer=ply \
 //thickness=0.18 //x=6.215 //y=1.7 //x2=6.255 //y2=1.545
r574 (  152 153 ) resistor r=202.543 //w=0.094 //l=0.395 //layer=ply \
 //thickness=0.18 //x=6.215 //y=1.7 //x2=6.215 //y2=2.095
r575 (  151 187 ) resistor r=39.5823 //w=0.21 //l=0.173853 //layer=ply \
 //thickness=0.18 //x=6.215 //y=1.39 //x2=6.255 //y2=1.545
r576 (  150 186 ) resistor r=45.1352 //w=0.168 //l=0.173853 //layer=ply \
 //thickness=0.18 //x=6.215 //y=1.045 //x2=6.255 //y2=0.89
r577 (  150 151 ) resistor r=176.904 //w=0.094 //l=0.345 //layer=ply \
 //thickness=0.18 //x=6.215 //y=1.045 //x2=6.215 //y2=1.39
r578 (  149 181 ) resistor r=592.245 //w=0.094 //l=1.155 //layer=ply \
 //thickness=0.18 //x=16.74 //y=6.2 //x2=16.74 //y2=5.045
r579 (  148 171 ) resistor r=592.245 //w=0.094 //l=1.155 //layer=ply \
 //thickness=0.18 //x=16.3 //y=6.2 //x2=16.3 //y2=5.045
r580 (  147 164 ) resistor r=592.245 //w=0.094 //l=1.155 //layer=ply \
 //thickness=0.18 //x=6.75 //y=6.2 //x2=6.75 //y2=5.045
r581 (  146 154 ) resistor r=592.245 //w=0.094 //l=1.155 //layer=ply \
 //thickness=0.18 //x=6.31 //y=6.2 //x2=6.31 //y2=5.045
r582 (  145 176 ) resistor r=56.4043 //w=0.094 //l=0.11 //layer=ply \
 //thickness=0.18 //x=16.47 //y=1.545 //x2=16.58 //y2=1.545
r583 (  145 177 ) resistor r=56.4043 //w=0.094 //l=0.11 //layer=ply \
 //thickness=0.18 //x=16.47 //y=1.545 //x2=16.36 //y2=1.545
r584 (  144 159 ) resistor r=56.4043 //w=0.094 //l=0.11 //layer=ply \
 //thickness=0.18 //x=6.48 //y=1.545 //x2=6.59 //y2=1.545
r585 (  144 160 ) resistor r=56.4043 //w=0.094 //l=0.11 //layer=ply \
 //thickness=0.18 //x=6.48 //y=1.545 //x2=6.37 //y2=1.545
r586 (  140 199 ) resistor r=152 //w=0.17 //l=0.17 //layer=licon //count=1 \
 //x=16.4 //y=4.88 //x2=16.4 //y2=4.88
r587 (  131 194 ) resistor r=152 //w=0.17 //l=0.17 //layer=licon //count=1 \
 //x=16.4 //y=2.26 //x2=16.4 //y2=2.26
r588 (  126 190 ) resistor r=152 //w=0.17 //l=0.17 //layer=licon //count=1 \
 //x=6.41 //y=4.88 //x2=6.41 //y2=4.88
r589 (  117 185 ) resistor r=152 //w=0.17 //l=0.17 //layer=licon //count=1 \
 //x=6.41 //y=2.26 //x2=6.41 //y2=2.26
r590 (  100 206 ) resistor r=23.615 //w=0.187 //l=0.345 //layer=li \
 //thickness=0.1 //x=3.78 //y=5.56 //x2=3.78 //y2=5.905
r591 (  92 205 ) resistor r=23.615 //w=0.187 //l=0.345 //layer=li \
 //thickness=0.1 //x=2.9 //y=5.56 //x2=2.9 //y2=5.905
r592 (  84 204 ) resistor r=23.615 //w=0.187 //l=0.345 //layer=li \
 //thickness=0.1 //x=2.02 //y=5.56 //x2=2.02 //y2=5.905
r593 (  74 82 ) resistor r=2.10915 //w=0.185 //l=3.125 //layer=m2 \
 //thickness=0.36 //x=13.28 //y=3.895 //x2=16.4 //y2=3.885
r594 (  74 75 ) resistor r=0.329198 //w=0.131 //l=0.345 //layer=m2 \
 //thickness=0.36 //x=13.28 //y=3.895 //x2=12.935 //y2=3.895
r595 (  72 75 ) resistor r=0.1875 //w=0.17 //l=0.262393 //layer=m2 \
 //thickness=0.36 //x=12.68 //y=3.88 //x2=12.935 //y2=3.895
r596 (  72 73 ) resistor r=1.02099 //w=0.131 //l=1.07 //layer=m2 \
 //thickness=0.36 //x=12.68 //y=3.88 //x2=11.61 //y2=3.88
r597 (  70 73 ) resistor r=0.125 //w=0.17 //l=0.177341 //layer=m2 \
 //thickness=0.36 //x=11.44 //y=3.895 //x2=11.61 //y2=3.88
r598 (  70 71 ) resistor r=0.329198 //w=0.131 //l=0.345 //layer=m2 \
 //thickness=0.36 //x=11.44 //y=3.895 //x2=11.095 //y2=3.895
r599 (  68 71 ) resistor r=0.290441 //w=0.17 //l=0.407308 //layer=m2 \
 //thickness=0.36 //x=10.7 //y=3.87 //x2=11.095 //y2=3.895
r600 (  68 69 ) resistor r=0.410305 //w=0.131 //l=0.43 //layer=m2 \
 //thickness=0.36 //x=10.7 //y=3.87 //x2=10.27 //y2=3.87
r601 (  66 69 ) resistor r=0.235294 //w=0.17 //l=0.329848 //layer=m2 \
 //thickness=0.36 //x=9.95 //y=3.89 //x2=10.27 //y2=3.87
r602 (  66 67 ) resistor r=0.329198 //w=0.131 //l=0.345 //layer=m2 \
 //thickness=0.36 //x=9.95 //y=3.89 //x2=9.605 //y2=3.89
r603 (  64 67 ) resistor r=0.1875 //w=0.17 //l=0.259952 //layer=m2 \
 //thickness=0.36 //x=9.35 //y=3.88 //x2=9.605 //y2=3.89
r604 (  64 65 ) resistor r=1.03053 //w=0.131 //l=1.08 //layer=m2 \
 //thickness=0.36 //x=9.35 //y=3.88 //x2=8.27 //y2=3.88
r605 (  63 80 ) resistor r=0.838898 //w=0.202 //l=1.35748 //layer=m2 \
 //thickness=0.36 //x=7.755 //y=3.895 //x2=6.405 //y2=3.88
r606 (  62 65 ) resistor r=0.125 //w=0.17 //l=0.177341 //layer=m2 \
 //thickness=0.36 //x=8.1 //y=3.895 //x2=8.27 //y2=3.88
r607 (  62 63 ) resistor r=0.329198 //w=0.131 //l=0.345 //layer=m2 \
 //thickness=0.36 //x=8.1 //y=3.895 //x2=7.755 //y2=3.895
r608 (  61 77 ) resistor r=0.10734 //w=0.281 //l=0.16 //layer=m2 \
 //thickness=0.36 //x=4.72 //y=3.88 //x2=4.56 //y2=3.88
r609 (  60 80 ) resistor r=0.102512 //w=0.202 //l=0.16 //layer=m2 \
 //thickness=0.36 //x=6.245 //y=3.88 //x2=6.405 //y2=3.88
r610 (  60 61 ) resistor r=1.45515 //w=0.131 //l=1.525 //layer=m2 \
 //thickness=0.36 //x=6.245 //y=3.88 //x2=4.72 //y2=3.88
r611 (  57 140 ) resistor r=9.3 //w=0.17 //l=0.17 //layer=mcon //count=1 \
 //x=16.4 //y=4.88 //x2=16.4 //y2=4.88
r612 (  57 58 ) resistor r=0.103207 //w=0.196 //l=0.14 //layer=m1 \
 //thickness=0.36 //x=16.402 //y=4.88 //x2=16.402 //y2=4.74
r613 (  54 131 ) resistor r=9.3 //w=0.17 //l=0.17 //layer=mcon //count=1 \
 //x=16.4 //y=2.26 //x2=16.4 //y2=2.26
r614 (  52 82 ) resistor r=4.5 //w=0.15 //l=0.15 //layer=via1 //count=1 \
 //x=16.4 //y=3.885 //x2=16.4 //y2=3.885
r615 (  50 52 ) resistor r=0.00166223 //w=0.376 //l=0.005 //layer=m1 \
 //thickness=0.36 //x=16.347 //y=3.88 //x2=16.347 //y2=3.885
r616 (  46 126 ) resistor r=9.3 //w=0.17 //l=0.17 //layer=mcon //count=1 \
 //x=6.41 //y=4.88 //x2=6.41 //y2=4.88
r617 (  46 47 ) resistor r=0.103207 //w=0.196 //l=0.14 //layer=m1 \
 //thickness=0.36 //x=6.412 //y=4.88 //x2=6.412 //y2=4.74
r618 (  43 117 ) resistor r=9.3 //w=0.17 //l=0.17 //layer=mcon //count=1 \
 //x=6.41 //y=2.26 //x2=6.41 //y2=2.26
r619 (  40 80 ) resistor r=4.5 //w=0.15 //l=0.15 //layer=via1 //count=1 \
 //x=6.405 //y=3.88 //x2=6.405 //y2=3.88
r620 (  37 77 ) resistor r=4.5 //w=0.15 //l=0.15 //layer=via1 //count=1 \
 //x=4.56 //y=3.88 //x2=4.56 //y2=3.88
r621 (  35 202 ) resistor r=9.3 //w=0.17 //l=0.17 //layer=mcon //count=1 \
 //x=4.075 //y=1.19 //x2=4.075 //y2=1.19
r622 (  33 100 ) resistor r=9.3 //w=0.17 //l=0.17 //layer=mcon //count=1 \
 //x=3.78 //y=5.56 //x2=3.78 //y2=5.56
r623 (  30 92 ) resistor r=9.3 //w=0.17 //l=0.17 //layer=mcon //count=1 \
 //x=2.9 //y=5.56 //x2=2.9 //y2=5.56
r624 (  28 30 ) resistor r=0.121228 //w=0.232 //l=0.225 //layer=m1 \
 //thickness=0.36 //x=2.9 //y=5.335 //x2=2.9 //y2=5.56
r625 (  27 84 ) resistor r=9.3 //w=0.17 //l=0.17 //layer=mcon //count=1 \
 //x=2.02 //y=5.56 //x2=2.02 //y2=5.56
r626 (  25 27 ) resistor r=0.129608 //w=0.217 //l=0.225 //layer=m1 \
 //thickness=0.36 //x=2.022 //y=5.335 //x2=2.022 //y2=5.56
r627 (  23 52 ) resistor r=0.0911593 //w=0.376 //l=0.184608 //layer=m1 \
 //thickness=0.36 //x=16.4 //y=4.045 //x2=16.347 //y2=3.885
r628 (  23 58 ) resistor r=0.663168 //w=0.131 //l=0.695 //layer=m1 \
 //thickness=0.36 //x=16.4 //y=4.045 //x2=16.4 //y2=4.74
r629 (  22 50 ) resistor r=0.0894971 //w=0.376 //l=0.179555 //layer=m1 \
 //thickness=0.36 //x=16.4 //y=3.725 //x2=16.347 //y2=3.88
r630 (  21 54 ) resistor r=0.0933015 //w=0.201 //l=0.125 //layer=m1 \
 //thickness=0.36 //x=16.4 //y=2.385 //x2=16.4 //y2=2.26
r631 (  21 22 ) resistor r=1.27863 //w=0.131 //l=1.34 //layer=m1 \
 //thickness=0.36 //x=16.4 //y=2.385 //x2=16.4 //y2=3.725
r632 (  19 40 ) resistor r=0.0910802 //w=0.374 //l=0.185472 //layer=m1 \
 //thickness=0.36 //x=6.41 //y=4.04 //x2=6.355 //y2=3.88
r633 (  19 47 ) resistor r=0.667939 //w=0.131 //l=0.7 //layer=m1 \
 //thickness=0.36 //x=6.41 //y=4.04 //x2=6.41 //y2=4.74
r634 (  18 40 ) resistor r=0.0910802 //w=0.374 //l=0.185472 //layer=m1 \
 //thickness=0.36 //x=6.41 //y=3.72 //x2=6.355 //y2=3.88
r635 (  17 43 ) resistor r=0.0933015 //w=0.201 //l=0.125 //layer=m1 \
 //thickness=0.36 //x=6.41 //y=2.385 //x2=6.41 //y2=2.26
r636 (  17 18 ) resistor r=1.27385 //w=0.131 //l=1.335 //layer=m1 \
 //thickness=0.36 //x=6.41 //y=2.385 //x2=6.41 //y2=3.72
r637 (  15 37 ) resistor r=0.0911593 //w=0.376 //l=0.184174 //layer=m1 \
 //thickness=0.36 //x=4.56 //y=4.04 //x2=4.612 //y2=3.88
r638 (  15 16 ) resistor r=1.15458 //w=0.131 //l=1.21 //layer=m1 \
 //thickness=0.36 //x=4.56 //y=4.04 //x2=4.56 //y2=5.25
r639 (  14 37 ) resistor r=0.0911593 //w=0.376 //l=0.184174 //layer=m1 \
 //thickness=0.36 //x=4.56 //y=3.72 //x2=4.612 //y2=3.88
r640 (  13 14 ) resistor r=1.70802 //w=0.131 //l=1.79 //layer=m1 \
 //thickness=0.36 //x=4.56 //y=1.93 //x2=4.56 //y2=3.72
r641 (  11 13 ) resistor r=0.0698411 //w=0.17 //l=0.120208 //layer=m1 \
 //thickness=0.36 //x=4.475 //y=1.845 //x2=4.56 //y2=1.93
r642 (  11 12 ) resistor r=0.300573 //w=0.131 //l=0.315 //layer=m1 \
 //thickness=0.36 //x=4.475 //y=1.845 //x2=4.16 //y2=1.845
r643 (  10 12 ) resistor r=0.0698411 //w=0.17 //l=0.120208 //layer=m1 \
 //thickness=0.36 //x=4.075 //y=1.76 //x2=4.16 //y2=1.845
r644 (  9 35 ) resistor r=0.0717383 //w=0.224 //l=0.115 //layer=m1 \
 //thickness=0.36 //x=4.075 //y=1.305 //x2=4.075 //y2=1.19
r645 (  9 10 ) resistor r=0.43416 //w=0.131 //l=0.455 //layer=m1 \
 //thickness=0.36 //x=4.075 //y=1.305 //x2=4.075 //y2=1.76
r646 (  8 31 ) resistor r=0.0675342 //w=0.23 //l=0.115 //layer=m1 \
 //thickness=0.36 //x=3.895 //y=5.335 //x2=3.78 //y2=5.335
r647 (  7 16 ) resistor r=0.0698411 //w=0.17 //l=0.120208 //layer=m1 \
 //thickness=0.36 //x=4.475 //y=5.335 //x2=4.56 //y2=5.25
r648 (  7 8 ) resistor r=0.553435 //w=0.131 //l=0.58 //layer=m1 \
 //thickness=0.36 //x=4.475 //y=5.335 //x2=3.895 //y2=5.335
r649 (  6 33 ) resistor r=0.00118313 //w=0.23 //layer=m1 //thickness=0.36 \
 //x=3.78 //y=5.56 //x2=3.78 //y2=5.56
r650 (  5 31 ) resistor r=0.002872 //w=0.34 //l=0.085 //layer=m1 \
 //thickness=0.36 //x=3.78 //y=5.42 //x2=3.78 //y2=5.335
r651 (  5 6 ) resistor r=0.091623 //w=0.191 //l=0.14 //layer=m1 \
 //thickness=0.36 //x=3.78 //y=5.42 //x2=3.78 //y2=5.56
r652 (  4 28 ) resistor r=0.0262263 //w=0.232 //l=0.12 //layer=m1 \
 //thickness=0.36 //x=3.02 //y=5.335 //x2=2.9 //y2=5.335
r653 (  3 31 ) resistor r=0.0675342 //w=0.23 //l=0.115 //layer=m1 \
 //thickness=0.36 //x=3.665 //y=5.335 //x2=3.78 //y2=5.335
r654 (  3 4 ) resistor r=0.615458 //w=0.131 //l=0.645 //layer=m1 \
 //thickness=0.36 //x=3.665 //y=5.335 //x2=3.02 //y2=5.335
r655 (  2 25 ) resistor r=0.0222262 //w=0.217 //l=0.118 //layer=m1 \
 //thickness=0.36 //x=2.14 //y=5.335 //x2=2.022 //y2=5.335
r656 (  1 28 ) resistor r=0.0262263 //w=0.232 //l=0.12 //layer=m1 \
 //thickness=0.36 //x=2.78 //y=5.335 //x2=2.9 //y2=5.335
r657 (  1 2 ) resistor r=0.610687 //w=0.131 //l=0.64 //layer=m1 \
 //thickness=0.36 //x=2.78 //y=5.335 //x2=2.14 //y2=5.335
ends PM_DFFX1\%noxref_4

subckt PM_DFFX1\%QN ( 1 2 3 4 5 6 7 8 9 10 11 14 19 20 22 23 29 38 43 44 47 49 \
 60 63 71 73 74 77 85 102 111 115 116 117 118 119 120 121 125 127 130 131 141 \
 144 146 147 )
c275 ( 144 0 ) capacitor c=0.00878249f //x=17.25 //y=1.085
c276 ( 141 0 ) capacitor c=0.0682508f //x=19.73 //y=4.88
c277 ( 131 0 ) capacitor c=0.0318956f //x=20.065 //y=1.39
c278 ( 130 0 ) capacitor c=0.0186809f //x=20.065 //y=1.045
c279 ( 127 0 ) capacitor c=0.0141821f //x=19.91 //y=1.545
c280 ( 125 0 ) capacitor c=0.0158553f //x=19.91 //y=0.89
c281 ( 121 0 ) capacitor c=0.0854122f //x=19.535 //y=2.095
c282 ( 120 0 ) capacitor c=0.0229235f //x=19.535 //y=1.7
c283 ( 119 0 ) capacitor c=0.0234359f //x=19.535 //y=1.39
c284 ( 118 0 ) capacitor c=0.0198759f //x=19.535 //y=1.045
c285 ( 117 0 ) capacitor c=0.110369f //x=20.07 //y=6.2
c286 ( 116 0 ) capacitor c=0.154619f //x=19.63 //y=6.2
c287 ( 111 0 ) capacitor c=8.13425e-19 //x=19.73 //y=4.88
c288 ( 102 0 ) capacitor c=7.85889e-19 //x=19.73 //y=2.26
c289 ( 85 0 ) capacitor c=0.0322017f //x=17.4 //y=5.56
c290 ( 77 0 ) capacitor c=0.0290186f //x=16.52 //y=5.56
c291 ( 74 0 ) capacitor c=0.0480796f //x=19.565 //y=3.495
c292 ( 73 0 ) capacitor c=0.00163754f //x=19.725 //y=3.495
c293 ( 71 0 ) capacitor c=0.00306238f //x=18.04 //y=3.495
c294 ( 63 0 ) capacitor c=0.00611632f //x=19.73 //y=4.88
c295 ( 60 0 ) capacitor c=0.0064059f //x=19.73 //y=2.26
c296 ( 49 0 ) capacitor c=0.0113657f //x=17.44 //y=1.18
c297 ( 47 0 ) capacitor c=5.78613e-19 //x=17.4 //y=5.56
c298 ( 44 0 ) capacitor c=0.0112577f //x=17.4 //y=5.38
c299 ( 43 0 ) capacitor c=0.00921781f //x=16.52 //y=5.56
c300 ( 38 0 ) capacitor c=0.0132863f //x=19.73 //y=3.655
c301 ( 29 0 ) capacitor c=0.0134988f //x=17.88 //y=3.655
c302 ( 23 0 ) capacitor c=0.00622751f //x=17.525 //y=1.835
c303 ( 22 0 ) capacitor c=0.0142752f //x=17.795 //y=1.835
c304 ( 20 0 ) capacitor c=0.0116047f //x=17.795 //y=5.38
c305 ( 19 0 ) capacitor c=0.0101547f //x=17.44 //y=1.75
c306 ( 14 0 ) capacitor c=0.0148064f //x=17.285 //y=5.38
c307 ( 11 0 ) capacitor c=0.0167165f //x=19.73 //y=3.51
c308 ( 10 0 ) capacitor c=0.017322f //x=17.88 //y=3.51
c309 ( 9 0 ) capacitor c=0.0267299f //x=19.73 //y=4.62
c310 ( 6 0 ) capacitor c=0.0285574f //x=19.73 //y=2.4
c311 ( 4 0 ) capacitor c=0.0402498f //x=17.88 //y=4.62
c312 ( 1 0 ) capacitor c=0.0393928f //x=17.88 //y=2.4
r313 (  139 141 ) resistor r=20.6867 //w=0.233 //l=0.1 //layer=ply \
 //thickness=0.18 //x=19.63 //y=4.88 //x2=19.73 //y2=4.88
r314 (  132 141 ) resistor r=70.3348 //w=0.233 //l=0.414367 //layer=ply \
 //thickness=0.18 //x=20.07 //y=5.045 //x2=19.73 //y2=4.88
r315 (  131 143 ) resistor r=45.1352 //w=0.168 //l=0.173853 //layer=ply \
 //thickness=0.18 //x=20.065 //y=1.39 //x2=20.025 //y2=1.545
r316 (  130 142 ) resistor r=45.1352 //w=0.168 //l=0.173853 //layer=ply \
 //thickness=0.18 //x=20.065 //y=1.045 //x2=20.025 //y2=0.89
r317 (  130 131 ) resistor r=176.904 //w=0.094 //l=0.345 //layer=ply \
 //thickness=0.18 //x=20.065 //y=1.045 //x2=20.065 //y2=1.39
r318 (  128 138 ) resistor r=10.701 //w=0.21 //l=0.115 //layer=ply \
 //thickness=0.18 //x=19.69 //y=1.545 //x2=19.575 //y2=1.545
r319 (  127 143 ) resistor r=5.52526 //w=0.168 //l=0.115 //layer=ply \
 //thickness=0.18 //x=19.91 //y=1.545 //x2=20.025 //y2=1.545
r320 (  126 137 ) resistor r=5.52526 //w=0.168 //l=0.115 //layer=ply \
 //thickness=0.18 //x=19.69 //y=0.89 //x2=19.575 //y2=0.89
r321 (  125 142 ) resistor r=5.52526 //w=0.168 //l=0.115 //layer=ply \
 //thickness=0.18 //x=19.91 //y=0.89 //x2=20.025 //y2=0.89
r322 (  125 126 ) resistor r=112.809 //w=0.094 //l=0.22 //layer=ply \
 //thickness=0.18 //x=19.91 //y=0.89 //x2=19.69 //y2=0.89
r323 (  122 139 ) resistor r=13.0941 //w=0.233 //l=0.165 //layer=ply \
 //thickness=0.18 //x=19.63 //y=5.045 //x2=19.63 //y2=4.88
r324 (  121 136 ) resistor r=34.8111 //w=0.27 //l=0.264953 //layer=ply \
 //thickness=0.18 //x=19.535 //y=2.095 //x2=19.73 //y2=2.26
r325 (  120 138 ) resistor r=39.5823 //w=0.21 //l=0.173853 //layer=ply \
 //thickness=0.18 //x=19.535 //y=1.7 //x2=19.575 //y2=1.545
r326 (  120 121 ) resistor r=202.543 //w=0.094 //l=0.395 //layer=ply \
 //thickness=0.18 //x=19.535 //y=1.7 //x2=19.535 //y2=2.095
r327 (  119 138 ) resistor r=39.5823 //w=0.21 //l=0.173853 //layer=ply \
 //thickness=0.18 //x=19.535 //y=1.39 //x2=19.575 //y2=1.545
r328 (  118 137 ) resistor r=45.1352 //w=0.168 //l=0.173853 //layer=ply \
 //thickness=0.18 //x=19.535 //y=1.045 //x2=19.575 //y2=0.89
r329 (  118 119 ) resistor r=176.904 //w=0.094 //l=0.345 //layer=ply \
 //thickness=0.18 //x=19.535 //y=1.045 //x2=19.535 //y2=1.39
r330 (  117 132 ) resistor r=592.245 //w=0.094 //l=1.155 //layer=ply \
 //thickness=0.18 //x=20.07 //y=6.2 //x2=20.07 //y2=5.045
r331 (  116 122 ) resistor r=592.245 //w=0.094 //l=1.155 //layer=ply \
 //thickness=0.18 //x=19.63 //y=6.2 //x2=19.63 //y2=5.045
r332 (  115 127 ) resistor r=56.4043 //w=0.094 //l=0.11 //layer=ply \
 //thickness=0.18 //x=19.8 //y=1.545 //x2=19.91 //y2=1.545
r333 (  115 128 ) resistor r=56.4043 //w=0.094 //l=0.11 //layer=ply \
 //thickness=0.18 //x=19.8 //y=1.545 //x2=19.69 //y2=1.545
r334 (  111 141 ) resistor r=152 //w=0.17 //l=0.17 //layer=licon //count=1 \
 //x=19.73 //y=4.88 //x2=19.73 //y2=4.88
r335 (  102 136 ) resistor r=152 //w=0.17 //l=0.17 //layer=licon //count=1 \
 //x=19.73 //y=2.26 //x2=19.73 //y2=2.26
r336 (  85 147 ) resistor r=23.615 //w=0.187 //l=0.345 //layer=li \
 //thickness=0.1 //x=17.4 //y=5.56 //x2=17.4 //y2=5.905
r337 (  77 146 ) resistor r=23.615 //w=0.187 //l=0.345 //layer=li \
 //thickness=0.1 //x=16.52 //y=5.56 //x2=16.52 //y2=5.905
r338 (  73 74 ) resistor r=0.10734 //w=0.281 //l=0.16 //layer=m2 \
 //thickness=0.36 //x=19.725 //y=3.495 //x2=19.565 //y2=3.495
r339 (  71 74 ) resistor r=1.45515 //w=0.131 //l=1.525 //layer=m2 \
 //thickness=0.36 //x=18.04 //y=3.51 //x2=19.565 //y2=3.51
r340 (  69 71 ) resistor r=0.10734 //w=0.281 //l=0.16 //layer=m2 \
 //thickness=0.36 //x=17.88 //y=3.495 //x2=18.04 //y2=3.495
r341 (  63 111 ) resistor r=9.3 //w=0.17 //l=0.17 //layer=mcon //count=1 \
 //x=19.73 //y=4.88 //x2=19.73 //y2=4.88
r342 (  63 64 ) resistor r=0.103207 //w=0.196 //l=0.14 //layer=m1 \
 //thickness=0.36 //x=19.732 //y=4.88 //x2=19.732 //y2=4.74
r343 (  60 102 ) resistor r=9.3 //w=0.17 //l=0.17 //layer=mcon //count=1 \
 //x=19.73 //y=2.26 //x2=19.73 //y2=2.26
r344 (  56 73 ) resistor r=4.5 //w=0.15 //l=0.15 //layer=via1 //count=1 \
 //x=19.725 //y=3.495 //x2=19.725 //y2=3.495
r345 (  52 69 ) resistor r=4.5 //w=0.15 //l=0.15 //layer=via1 //count=1 \
 //x=17.88 //y=3.495 //x2=17.88 //y2=3.495
r346 (  49 144 ) resistor r=9.3 //w=0.17 //l=0.17 //layer=mcon //count=1 \
 //x=17.44 //y=1.18 //x2=17.44 //y2=1.18
r347 (  47 85 ) resistor r=9.3 //w=0.17 //l=0.17 //layer=mcon //count=1 \
 //x=17.4 //y=5.56 //x2=17.4 //y2=5.56
r348 (  44 47 ) resistor r=0.117801 //w=0.191 //l=0.18 //layer=m1 \
 //thickness=0.36 //x=17.4 //y=5.38 //x2=17.4 //y2=5.56
r349 (  43 77 ) resistor r=9.3 //w=0.17 //l=0.17 //layer=mcon //count=1 \
 //x=16.52 //y=5.56 //x2=16.52 //y2=5.56
r350 (  41 43 ) resistor r=0.10274 //w=0.219 //l=0.18 //layer=m1 \
 //thickness=0.36 //x=16.52 //y=5.38 //x2=16.52 //y2=5.56
r351 (  34 56 ) resistor r=0.0910802 //w=0.374 //l=0.185472 //layer=m1 \
 //thickness=0.36 //x=19.73 //y=3.335 //x2=19.675 //y2=3.495
r352 (  33 60 ) resistor r=0.0933015 //w=0.201 //l=0.125 //layer=m1 \
 //thickness=0.36 //x=19.73 //y=2.385 //x2=19.73 //y2=2.26
r353 (  25 52 ) resistor r=0.0911593 //w=0.376 //l=0.184174 //layer=m1 \
 //thickness=0.36 //x=17.88 //y=3.335 //x2=17.932 //y2=3.495
r354 (  22 24 ) resistor r=0.0698411 //w=0.17 //l=0.120208 //layer=m1 \
 //thickness=0.36 //x=17.795 //y=1.835 //x2=17.88 //y2=1.92
r355 (  22 23 ) resistor r=0.257634 //w=0.131 //l=0.27 //layer=m1 \
 //thickness=0.36 //x=17.795 //y=1.835 //x2=17.525 //y2=1.835
r356 (  21 44 ) resistor r=0.0257089 //w=0.23 //l=0.115 //layer=m1 \
 //thickness=0.36 //x=17.515 //y=5.38 //x2=17.4 //y2=5.38
r357 (  20 30 ) resistor r=0.0698411 //w=0.17 //l=0.120208 //layer=m1 \
 //thickness=0.36 //x=17.795 //y=5.38 //x2=17.88 //y2=5.295
r358 (  20 21 ) resistor r=0.267176 //w=0.131 //l=0.28 //layer=m1 \
 //thickness=0.36 //x=17.795 //y=5.38 //x2=17.515 //y2=5.38
r359 (  19 23 ) resistor r=0.0698411 //w=0.17 //l=0.120208 //layer=m1 \
 //thickness=0.36 //x=17.44 //y=1.75 //x2=17.525 //y2=1.835
r360 (  18 49 ) resistor r=0.0913624 //w=0.191 //l=0.12 //layer=m1 \
 //thickness=0.36 //x=17.44 //y=1.3 //x2=17.44 //y2=1.18
r361 (  18 19 ) resistor r=0.429389 //w=0.131 //l=0.45 //layer=m1 \
 //thickness=0.36 //x=17.44 //y=1.3 //x2=17.44 //y2=1.75
r362 (  15 41 ) resistor r=0.0227762 //w=0.219 //l=0.115 //layer=m1 \
 //thickness=0.36 //x=16.635 //y=5.38 //x2=16.52 //y2=5.38
r363 (  14 44 ) resistor r=0.0257089 //w=0.23 //l=0.115 //layer=m1 \
 //thickness=0.36 //x=17.285 //y=5.38 //x2=17.4 //y2=5.38
r364 (  14 15 ) resistor r=0.620229 //w=0.131 //l=0.65 //layer=m1 \
 //thickness=0.36 //x=17.285 //y=5.38 //x2=16.635 //y2=5.38
r365 (  11 38 ) resistor r=0.0860668 //w=0.374 //l=0.170294 //layer=m1 \
 //thickness=0.36 //x=19.675 //y=3.51 //x2=19.73 //y2=3.655
r366 (  11 56 ) resistor r=0.00501337 //w=0.374 //l=0.015 //layer=m1 \
 //thickness=0.36 //x=19.675 //y=3.51 //x2=19.675 //y2=3.495
r367 (  10 29 ) resistor r=0.0861726 //w=0.376 //l=0.169012 //layer=m1 \
 //thickness=0.36 //x=17.932 //y=3.51 //x2=17.88 //y2=3.655
r368 (  10 52 ) resistor r=0.0049867 //w=0.376 //l=0.015 //layer=m1 \
 //thickness=0.36 //x=17.932 //y=3.51 //x2=17.932 //y2=3.495
r369 (  9 64 ) resistor r=0.114504 //w=0.131 //l=0.12 //layer=m1 \
 //thickness=0.36 //x=19.73 //y=4.62 //x2=19.73 //y2=4.74
r370 (  9 38 ) resistor r=0.920802 //w=0.131 //l=0.965 //layer=m1 \
 //thickness=0.36 //x=19.73 //y=4.62 //x2=19.73 //y2=3.655
r371 (  8 34 ) resistor r=0.186069 //w=0.131 //l=0.195 //layer=m1 \
 //thickness=0.36 //x=19.73 //y=3.14 //x2=19.73 //y2=3.335
r372 (  7 8 ) resistor r=0.353053 //w=0.131 //l=0.37 //layer=m1 \
 //thickness=0.36 //x=19.73 //y=2.77 //x2=19.73 //y2=3.14
r373 (  6 7 ) resistor r=0.353053 //w=0.131 //l=0.37 //layer=m1 \
 //thickness=0.36 //x=19.73 //y=2.4 //x2=19.73 //y2=2.77
r374 (  6 33 ) resistor r=0.014313 //w=0.131 //l=0.015 //layer=m1 \
 //thickness=0.36 //x=19.73 //y=2.4 //x2=19.73 //y2=2.385
r375 (  5 30 ) resistor r=0.291031 //w=0.131 //l=0.305 //layer=m1 \
 //thickness=0.36 //x=17.88 //y=4.99 //x2=17.88 //y2=5.295
r376 (  4 5 ) resistor r=0.353053 //w=0.131 //l=0.37 //layer=m1 \
 //thickness=0.36 //x=17.88 //y=4.62 //x2=17.88 //y2=4.99
r377 (  4 29 ) resistor r=0.920802 //w=0.131 //l=0.965 //layer=m1 \
 //thickness=0.36 //x=17.88 //y=4.62 //x2=17.88 //y2=3.655
r378 (  3 25 ) resistor r=0.186069 //w=0.131 //l=0.195 //layer=m1 \
 //thickness=0.36 //x=17.88 //y=3.14 //x2=17.88 //y2=3.335
r379 (  2 3 ) resistor r=0.353053 //w=0.131 //l=0.37 //layer=m1 \
 //thickness=0.36 //x=17.88 //y=2.77 //x2=17.88 //y2=3.14
r380 (  1 2 ) resistor r=0.353053 //w=0.131 //l=0.37 //layer=m1 \
 //thickness=0.36 //x=17.88 //y=2.4 //x2=17.88 //y2=2.77
r381 (  1 24 ) resistor r=0.458015 //w=0.131 //l=0.48 //layer=m1 \
 //thickness=0.36 //x=17.88 //y=2.4 //x2=17.88 //y2=1.92
ends PM_DFFX1\%QN

subckt PM_DFFX1\%noxref_6 ( 1 2 3 4 6 7 8 11 16 17 19 20 22 23 24 26 27 28 34 \
 38 42 49 50 53 55 58 62 65 70 72 74 76 78 79 80 81 85 93 102 107 116 121 129 \
 146 155 159 160 161 162 163 164 165 166 167 168 169 170 171 172 174 180 181 \
 182 183 187 188 189 194 196 198 204 205 206 207 208 213 215 217 223 224 234 \
 235 238 247 248 251 259 261 262 )
c591 ( 259 0 ) capacitor c=0.00878249f //x=13.92 //y=1.085
c592 ( 251 0 ) capacitor c=0.0356006f //x=20.5 //y=4.88
c593 ( 248 0 ) capacitor c=0.0284095f //x=20.47 //y=2.095
c594 ( 247 0 ) capacitor c=0.0476356f //x=20.47 //y=2.26
c595 ( 238 0 ) capacitor c=0.0354915f //x=10.51 //y=4.88
c596 ( 235 0 ) capacitor c=0.0284095f //x=10.48 //y=2.095
c597 ( 234 0 ) capacitor c=0.0476356f //x=10.48 //y=2.26
c598 ( 224 0 ) capacitor c=0.0439708f //x=21.035 //y=1.43
c599 ( 223 0 ) capacitor c=0.0192582f //x=21.035 //y=1.085
c600 ( 217 0 ) capacitor c=0.0162526f //x=20.88 //y=1.585
c601 ( 215 0 ) capacitor c=0.0157807f //x=20.88 //y=0.93
c602 ( 213 0 ) capacitor c=0.035926f //x=20.875 //y=4.97
c603 ( 208 0 ) capacitor c=0.0210762f //x=20.505 //y=1.74
c604 ( 207 0 ) capacitor c=0.0168511f //x=20.505 //y=1.43
c605 ( 206 0 ) capacitor c=0.0175485f //x=20.505 //y=1.085
c606 ( 205 0 ) capacitor c=0.0439708f //x=11.045 //y=1.43
c607 ( 204 0 ) capacitor c=0.0192582f //x=11.045 //y=1.085
c608 ( 198 0 ) capacitor c=0.0162526f //x=10.89 //y=1.585
c609 ( 196 0 ) capacitor c=0.0157807f //x=10.89 //y=0.93
c610 ( 194 0 ) capacitor c=0.0372668f //x=10.885 //y=4.97
c611 ( 189 0 ) capacitor c=0.0210762f //x=10.515 //y=1.74
c612 ( 188 0 ) capacitor c=0.0168511f //x=10.515 //y=1.43
c613 ( 187 0 ) capacitor c=0.0175485f //x=10.515 //y=1.085
c614 ( 183 0 ) capacitor c=0.0551643f //x=1.875 //y=4.97
c615 ( 182 0 ) capacitor c=0.0376038f //x=2.165 //y=4.97
c616 ( 181 0 ) capacitor c=0.0346489f //x=1.83 //y=1.4
c617 ( 180 0 ) capacitor c=0.018692f //x=1.83 //y=1.055
c618 ( 174 0 ) capacitor c=0.0137077f //x=1.675 //y=1.555
c619 ( 172 0 ) capacitor c=0.0158585f //x=1.675 //y=0.9
c620 ( 171 0 ) capacitor c=0.103534f //x=1.3 //y=2.095
c621 ( 170 0 ) capacitor c=0.0229444f //x=1.3 //y=1.71
c622 ( 169 0 ) capacitor c=0.0234359f //x=1.3 //y=1.4
c623 ( 168 0 ) capacitor c=0.019815f //x=1.3 //y=1.055
c624 ( 167 0 ) capacitor c=0.155269f //x=20.95 //y=6.2
c625 ( 166 0 ) capacitor c=0.110375f //x=20.51 //y=6.2
c626 ( 165 0 ) capacitor c=0.155269f //x=10.96 //y=6.2
c627 ( 164 0 ) capacitor c=0.110375f //x=10.52 //y=6.2
c628 ( 163 0 ) capacitor c=0.110208f //x=2.24 //y=6.2
c629 ( 162 0 ) capacitor c=0.158957f //x=1.8 //y=6.2
c630 ( 155 0 ) capacitor c=5.80994e-19 //x=20.5 //y=4.88
c631 ( 146 0 ) capacitor c=5.78095e-19 //x=20.47 //y=2.26
c632 ( 129 0 ) capacitor c=0.0319332f //x=14.07 //y=5.56
c633 ( 121 0 ) capacitor c=0.0291719f //x=13.19 //y=5.56
c634 ( 116 0 ) capacitor c=5.80994e-19 //x=10.51 //y=4.88
c635 ( 107 0 ) capacitor c=5.78095e-19 //x=10.48 //y=2.26
c636 ( 102 0 ) capacitor c=0.0012433f //x=1.6 //y=4.88
c637 ( 93 0 ) capacitor c=0.0012618f //x=1.6 //y=2.26
c638 ( 85 0 ) capacitor c=0.0110688f //x=1.765 //y=4.255
c639 ( 81 0 ) capacitor c=0.0516669f //x=16.27 //y=4.27
c640 ( 80 0 ) capacitor c=0.107276f //x=16.615 //y=4.27
c641 ( 79 0 ) capacitor c=0.0371529f //x=10.645 //y=4.25
c642 ( 78 0 ) capacitor c=0.0401039f //x=14.38 //y=4.25
c643 ( 76 0 ) capacitor c=0.00148682f //x=6.62 //y=4.265
c644 ( 74 0 ) capacitor c=0.0158261f //x=6.02 //y=4.25
c645 ( 72 0 ) capacitor c=0.00410955f //x=4.775 //y=4.265
c646 ( 70 0 ) capacitor c=0.0805297f //x=4.175 //y=4.25
c647 ( 65 0 ) capacitor c=0.0066236f //x=20.47 //y=2.26
c648 ( 62 0 ) capacitor c=0.0141348f //x=20.47 //y=4.25
c649 ( 58 0 ) capacitor c=0.015184f //x=14.55 //y=4.25
c650 ( 55 0 ) capacitor c=0.0114498f //x=14.11 //y=1.18
c651 ( 53 0 ) capacitor c=5.78613e-19 //x=14.07 //y=5.56
c652 ( 50 0 ) capacitor c=0.0106343f //x=14.07 //y=5.38
c653 ( 49 0 ) capacitor c=0.00933207f //x=13.19 //y=5.56
c654 ( 42 0 ) capacitor c=0.00662515f //x=10.48 //y=2.26
c655 ( 38 0 ) capacitor c=0.0143744f //x=10.48 //y=4.25
c656 ( 34 0 ) capacitor c=0.0160407f //x=1.6 //y=4.25
c657 ( 28 0 ) capacitor c=0.00985447f //x=20.47 //y=4.735
c658 ( 27 0 ) capacitor c=0.0096151f //x=20.47 //y=4.41
c659 ( 26 0 ) capacitor c=0.0378789f //x=20.47 //y=4.09
c660 ( 24 0 ) capacitor c=0.0186555f //x=14.55 //y=5.295
c661 ( 23 0 ) capacitor c=0.0128691f //x=14.55 //y=4.425
c662 ( 22 0 ) capacitor c=0.0617041f //x=14.55 //y=4.105
c663 ( 20 0 ) capacitor c=0.00671966f //x=14.195 //y=1.835
c664 ( 19 0 ) capacitor c=0.0142356f //x=14.465 //y=1.835
c665 ( 17 0 ) capacitor c=0.0102685f //x=14.465 //y=5.38
c666 ( 16 0 ) capacitor c=0.0101547f //x=14.11 //y=1.75
c667 ( 11 0 ) capacitor c=0.0142466f //x=13.955 //y=5.38
c668 ( 8 0 ) capacitor c=0.00908133f //x=10.48 //y=4.735
c669 ( 7 0 ) capacitor c=0.00971944f //x=10.48 //y=4.415
c670 ( 6 0 ) capacitor c=0.0367292f //x=10.48 //y=4.095
c671 ( 4 0 ) capacitor c=0.0228118f //x=1.6 //y=4.755
c672 ( 3 0 ) capacitor c=0.0128906f //x=1.6 //y=4.415
c673 ( 2 0 ) capacitor c=0.0862595f //x=1.6 //y=4.095
c674 ( 1 0 ) capacitor c=0.0113406f //x=1.6 //y=2.375
r675 (  253 254 ) resistor r=32.4568 //w=0.214 //l=0.075 //layer=ply \
 //thickness=0.18 //x=20.5 //y=4.97 //x2=20.5 //y2=5.045
r676 (  251 253 ) resistor r=20.271 //w=0.214 //l=0.09 //layer=ply \
 //thickness=0.18 //x=20.5 //y=4.88 //x2=20.5 //y2=4.97
r677 (  247 248 ) resistor r=52.7279 //w=0.214 //l=0.165 //layer=ply \
 //thickness=0.18 //x=20.47 //y=2.26 //x2=20.47 //y2=2.095
r678 (  240 241 ) resistor r=32.4568 //w=0.214 //l=0.075 //layer=ply \
 //thickness=0.18 //x=10.51 //y=4.97 //x2=10.51 //y2=5.045
r679 (  238 240 ) resistor r=20.271 //w=0.214 //l=0.09 //layer=ply \
 //thickness=0.18 //x=10.51 //y=4.88 //x2=10.51 //y2=4.97
r680 (  234 235 ) resistor r=52.7279 //w=0.214 //l=0.165 //layer=ply \
 //thickness=0.18 //x=10.48 //y=2.26 //x2=10.48 //y2=2.095
r681 (  224 258 ) resistor r=45.1352 //w=0.168 //l=0.173853 //layer=ply \
 //thickness=0.18 //x=21.035 //y=1.43 //x2=20.995 //y2=1.585
r682 (  223 257 ) resistor r=45.1352 //w=0.168 //l=0.173853 //layer=ply \
 //thickness=0.18 //x=21.035 //y=1.085 //x2=20.995 //y2=0.93
r683 (  223 224 ) resistor r=176.904 //w=0.094 //l=0.345 //layer=ply \
 //thickness=0.18 //x=21.035 //y=1.085 //x2=21.035 //y2=1.43
r684 (  218 256 ) resistor r=10.701 //w=0.21 //l=0.115 //layer=ply \
 //thickness=0.18 //x=20.66 //y=1.585 //x2=20.545 //y2=1.585
r685 (  217 258 ) resistor r=5.52526 //w=0.168 //l=0.115 //layer=ply \
 //thickness=0.18 //x=20.88 //y=1.585 //x2=20.995 //y2=1.585
r686 (  216 255 ) resistor r=5.52526 //w=0.168 //l=0.115 //layer=ply \
 //thickness=0.18 //x=20.66 //y=0.93 //x2=20.545 //y2=0.93
r687 (  215 257 ) resistor r=5.52526 //w=0.168 //l=0.115 //layer=ply \
 //thickness=0.18 //x=20.88 //y=0.93 //x2=20.995 //y2=0.93
r688 (  215 216 ) resistor r=112.809 //w=0.094 //l=0.22 //layer=ply \
 //thickness=0.18 //x=20.88 //y=0.93 //x2=20.66 //y2=0.93
r689 (  214 253 ) resistor r=16.5046 //w=0.27 //l=0.135 //layer=ply \
 //thickness=0.18 //x=20.635 //y=4.97 //x2=20.5 //y2=4.97
r690 (  213 220 ) resistor r=26.9307 //w=0.15 //l=0.106066 //layer=ply \
 //thickness=0.18 //x=20.875 //y=4.97 //x2=20.95 //y2=5.045
r691 (  213 214 ) resistor r=123.064 //w=0.094 //l=0.24 //layer=ply \
 //thickness=0.18 //x=20.875 //y=4.97 //x2=20.635 //y2=4.97
r692 (  208 256 ) resistor r=39.5823 //w=0.21 //l=0.173853 //layer=ply \
 //thickness=0.18 //x=20.505 //y=1.74 //x2=20.545 //y2=1.585
r693 (  208 248 ) resistor r=182.032 //w=0.094 //l=0.355 //layer=ply \
 //thickness=0.18 //x=20.505 //y=1.74 //x2=20.505 //y2=2.095
r694 (  207 256 ) resistor r=39.5823 //w=0.21 //l=0.173853 //layer=ply \
 //thickness=0.18 //x=20.505 //y=1.43 //x2=20.545 //y2=1.585
r695 (  206 255 ) resistor r=45.1352 //w=0.168 //l=0.173853 //layer=ply \
 //thickness=0.18 //x=20.505 //y=1.085 //x2=20.545 //y2=0.93
r696 (  206 207 ) resistor r=176.904 //w=0.094 //l=0.345 //layer=ply \
 //thickness=0.18 //x=20.505 //y=1.085 //x2=20.505 //y2=1.43
r697 (  205 245 ) resistor r=45.1352 //w=0.168 //l=0.173853 //layer=ply \
 //thickness=0.18 //x=11.045 //y=1.43 //x2=11.005 //y2=1.585
r698 (  204 244 ) resistor r=45.1352 //w=0.168 //l=0.173853 //layer=ply \
 //thickness=0.18 //x=11.045 //y=1.085 //x2=11.005 //y2=0.93
r699 (  204 205 ) resistor r=176.904 //w=0.094 //l=0.345 //layer=ply \
 //thickness=0.18 //x=11.045 //y=1.085 //x2=11.045 //y2=1.43
r700 (  199 243 ) resistor r=10.701 //w=0.21 //l=0.115 //layer=ply \
 //thickness=0.18 //x=10.67 //y=1.585 //x2=10.555 //y2=1.585
r701 (  198 245 ) resistor r=5.52526 //w=0.168 //l=0.115 //layer=ply \
 //thickness=0.18 //x=10.89 //y=1.585 //x2=11.005 //y2=1.585
r702 (  197 242 ) resistor r=5.52526 //w=0.168 //l=0.115 //layer=ply \
 //thickness=0.18 //x=10.67 //y=0.93 //x2=10.555 //y2=0.93
r703 (  196 244 ) resistor r=5.52526 //w=0.168 //l=0.115 //layer=ply \
 //thickness=0.18 //x=10.89 //y=0.93 //x2=11.005 //y2=0.93
r704 (  196 197 ) resistor r=112.809 //w=0.094 //l=0.22 //layer=ply \
 //thickness=0.18 //x=10.89 //y=0.93 //x2=10.67 //y2=0.93
r705 (  195 240 ) resistor r=16.5046 //w=0.27 //l=0.135 //layer=ply \
 //thickness=0.18 //x=10.645 //y=4.97 //x2=10.51 //y2=4.97
r706 (  194 201 ) resistor r=26.9307 //w=0.15 //l=0.106066 //layer=ply \
 //thickness=0.18 //x=10.885 //y=4.97 //x2=10.96 //y2=5.045
r707 (  194 195 ) resistor r=123.064 //w=0.094 //l=0.24 //layer=ply \
 //thickness=0.18 //x=10.885 //y=4.97 //x2=10.645 //y2=4.97
r708 (  189 243 ) resistor r=39.5823 //w=0.21 //l=0.173853 //layer=ply \
 //thickness=0.18 //x=10.515 //y=1.74 //x2=10.555 //y2=1.585
r709 (  189 235 ) resistor r=182.032 //w=0.094 //l=0.355 //layer=ply \
 //thickness=0.18 //x=10.515 //y=1.74 //x2=10.515 //y2=2.095
r710 (  188 243 ) resistor r=39.5823 //w=0.21 //l=0.173853 //layer=ply \
 //thickness=0.18 //x=10.515 //y=1.43 //x2=10.555 //y2=1.585
r711 (  187 242 ) resistor r=45.1352 //w=0.168 //l=0.173853 //layer=ply \
 //thickness=0.18 //x=10.515 //y=1.085 //x2=10.555 //y2=0.93
r712 (  187 188 ) resistor r=176.904 //w=0.094 //l=0.345 //layer=ply \
 //thickness=0.18 //x=10.515 //y=1.085 //x2=10.515 //y2=1.43
r713 (  182 184 ) resistor r=26.9307 //w=0.15 //l=0.106066 //layer=ply \
 //thickness=0.18 //x=2.165 //y=4.97 //x2=2.24 //y2=5.045
r714 (  182 183 ) resistor r=148.702 //w=0.094 //l=0.29 //layer=ply \
 //thickness=0.18 //x=2.165 //y=4.97 //x2=1.875 //y2=4.97
r715 (  181 232 ) resistor r=45.1352 //w=0.168 //l=0.173853 //layer=ply \
 //thickness=0.18 //x=1.83 //y=1.4 //x2=1.79 //y2=1.555
r716 (  180 231 ) resistor r=45.1352 //w=0.168 //l=0.173853 //layer=ply \
 //thickness=0.18 //x=1.83 //y=1.055 //x2=1.79 //y2=0.9
r717 (  180 181 ) resistor r=176.904 //w=0.094 //l=0.345 //layer=ply \
 //thickness=0.18 //x=1.83 //y=1.055 //x2=1.83 //y2=1.4
r718 (  177 183 ) resistor r=22.7971 //w=0.269 //l=0.106066 //layer=ply \
 //thickness=0.18 //x=1.8 //y=5.045 //x2=1.875 //y2=4.97
r719 (  177 230 ) resistor r=35.8364 //w=0.269 //l=0.270185 //layer=ply \
 //thickness=0.18 //x=1.8 //y=5.045 //x2=1.6 //y2=4.88
r720 (  175 226 ) resistor r=10.701 //w=0.21 //l=0.115 //layer=ply \
 //thickness=0.18 //x=1.455 //y=1.555 //x2=1.34 //y2=1.555
r721 (  174 232 ) resistor r=5.52526 //w=0.168 //l=0.115 //layer=ply \
 //thickness=0.18 //x=1.675 //y=1.555 //x2=1.79 //y2=1.555
r722 (  173 225 ) resistor r=5.52526 //w=0.168 //l=0.115 //layer=ply \
 //thickness=0.18 //x=1.455 //y=0.9 //x2=1.34 //y2=0.9
r723 (  172 231 ) resistor r=5.52526 //w=0.168 //l=0.115 //layer=ply \
 //thickness=0.18 //x=1.675 //y=0.9 //x2=1.79 //y2=0.9
r724 (  172 173 ) resistor r=112.809 //w=0.094 //l=0.22 //layer=ply \
 //thickness=0.18 //x=1.675 //y=0.9 //x2=1.455 //y2=0.9
r725 (  171 228 ) resistor r=58.7805 //w=0.246 //l=0.373497 //layer=ply \
 //thickness=0.18 //x=1.3 //y=2.095 //x2=1.6 //y2=2.26
r726 (  170 226 ) resistor r=39.5823 //w=0.21 //l=0.173853 //layer=ply \
 //thickness=0.18 //x=1.3 //y=1.71 //x2=1.34 //y2=1.555
r727 (  170 171 ) resistor r=197.415 //w=0.094 //l=0.385 //layer=ply \
 //thickness=0.18 //x=1.3 //y=1.71 //x2=1.3 //y2=2.095
r728 (  169 226 ) resistor r=39.5823 //w=0.21 //l=0.173853 //layer=ply \
 //thickness=0.18 //x=1.3 //y=1.4 //x2=1.34 //y2=1.555
r729 (  168 225 ) resistor r=45.1352 //w=0.168 //l=0.173853 //layer=ply \
 //thickness=0.18 //x=1.3 //y=1.055 //x2=1.34 //y2=0.9
r730 (  168 169 ) resistor r=176.904 //w=0.094 //l=0.345 //layer=ply \
 //thickness=0.18 //x=1.3 //y=1.055 //x2=1.3 //y2=1.4
r731 (  167 220 ) resistor r=592.245 //w=0.094 //l=1.155 //layer=ply \
 //thickness=0.18 //x=20.95 //y=6.2 //x2=20.95 //y2=5.045
r732 (  166 254 ) resistor r=592.245 //w=0.094 //l=1.155 //layer=ply \
 //thickness=0.18 //x=20.51 //y=6.2 //x2=20.51 //y2=5.045
r733 (  165 201 ) resistor r=592.245 //w=0.094 //l=1.155 //layer=ply \
 //thickness=0.18 //x=10.96 //y=6.2 //x2=10.96 //y2=5.045
r734 (  164 241 ) resistor r=592.245 //w=0.094 //l=1.155 //layer=ply \
 //thickness=0.18 //x=10.52 //y=6.2 //x2=10.52 //y2=5.045
r735 (  163 184 ) resistor r=592.245 //w=0.094 //l=1.155 //layer=ply \
 //thickness=0.18 //x=2.24 //y=6.2 //x2=2.24 //y2=5.045
r736 (  162 177 ) resistor r=592.245 //w=0.094 //l=1.155 //layer=ply \
 //thickness=0.18 //x=1.8 //y=6.2 //x2=1.8 //y2=5.045
r737 (  161 217 ) resistor r=56.4043 //w=0.094 //l=0.11 //layer=ply \
 //thickness=0.18 //x=20.77 //y=1.585 //x2=20.88 //y2=1.585
r738 (  161 218 ) resistor r=56.4043 //w=0.094 //l=0.11 //layer=ply \
 //thickness=0.18 //x=20.77 //y=1.585 //x2=20.66 //y2=1.585
r739 (  160 198 ) resistor r=56.4043 //w=0.094 //l=0.11 //layer=ply \
 //thickness=0.18 //x=10.78 //y=1.585 //x2=10.89 //y2=1.585
r740 (  160 199 ) resistor r=56.4043 //w=0.094 //l=0.11 //layer=ply \
 //thickness=0.18 //x=10.78 //y=1.585 //x2=10.67 //y2=1.585
r741 (  159 174 ) resistor r=56.4043 //w=0.094 //l=0.11 //layer=ply \
 //thickness=0.18 //x=1.565 //y=1.555 //x2=1.675 //y2=1.555
r742 (  159 175 ) resistor r=56.4043 //w=0.094 //l=0.11 //layer=ply \
 //thickness=0.18 //x=1.565 //y=1.555 //x2=1.455 //y2=1.555
r743 (  155 251 ) resistor r=152 //w=0.17 //l=0.17 //layer=licon //count=1 \
 //x=20.5 //y=4.88 //x2=20.5 //y2=4.88
r744 (  146 247 ) resistor r=152 //w=0.17 //l=0.17 //layer=licon //count=1 \
 //x=20.47 //y=2.26 //x2=20.47 //y2=2.26
r745 (  129 262 ) resistor r=23.615 //w=0.187 //l=0.345 //layer=li \
 //thickness=0.1 //x=14.07 //y=5.56 //x2=14.07 //y2=5.905
r746 (  121 261 ) resistor r=23.615 //w=0.187 //l=0.345 //layer=li \
 //thickness=0.1 //x=13.19 //y=5.56 //x2=13.19 //y2=5.905
r747 (  116 238 ) resistor r=152 //w=0.17 //l=0.17 //layer=licon //count=1 \
 //x=10.51 //y=4.88 //x2=10.51 //y2=4.88
r748 (  107 234 ) resistor r=152 //w=0.17 //l=0.17 //layer=licon //count=1 \
 //x=10.48 //y=2.26 //x2=10.48 //y2=2.26
r749 (  102 230 ) resistor r=152 //w=0.17 //l=0.17 //layer=licon //count=1 \
 //x=1.6 //y=4.88 //x2=1.6 //y2=4.88
r750 (  93 228 ) resistor r=152 //w=0.17 //l=0.17 //layer=licon //count=1 \
 //x=1.6 //y=2.26 //x2=1.6 //y2=2.26
r751 (  83 85 ) resistor r=0.10734 //w=0.281 //l=0.16 //layer=m2 \
 //thickness=0.36 //x=1.605 //y=4.255 //x2=1.765 //y2=4.255
r752 (  81 89 ) resistor r=1.10585 //w=0.196 //l=1.7325 //layer=m2 \
 //thickness=0.36 //x=16.27 //y=4.27 //x2=14.54 //y2=4.265
r753 (  80 91 ) resistor r=2.64838 //w=0.182 //l=3.86499 //layer=m2 \
 //thickness=0.36 //x=16.615 //y=4.27 //x2=20.47 //y2=4.25
r754 (  80 81 ) resistor r=0.329198 //w=0.131 //l=0.345 //layer=m2 \
 //thickness=0.36 //x=16.615 //y=4.27 //x2=16.27 //y2=4.27
r755 (  79 87 ) resistor r=0.110608 //w=0.182 //l=0.162481 //layer=m2 \
 //thickness=0.36 //x=10.645 //y=4.25 //x2=10.485 //y2=4.255
r756 (  78 89 ) resistor r=0.104578 //w=0.196 //l=0.167332 //layer=m2 \
 //thickness=0.36 //x=14.38 //y=4.25 //x2=14.54 //y2=4.265
r757 (  78 79 ) resistor r=3.56393 //w=0.131 //l=3.735 //layer=m2 \
 //thickness=0.36 //x=14.38 //y=4.25 //x2=10.645 //y2=4.25
r758 (  76 87 ) resistor r=2.65525 //w=0.182 //l=3.87 //layer=m2 \
 //thickness=0.36 //x=6.62 //y=4.265 //x2=10.485 //y2=4.255
r759 (  76 77 ) resistor r=0.329198 //w=0.131 //l=0.345 //layer=m2 \
 //thickness=0.36 //x=6.62 //y=4.265 //x2=6.275 //y2=4.265
r760 (  74 77 ) resistor r=0.1875 //w=0.17 //l=0.262393 //layer=m2 \
 //thickness=0.36 //x=6.02 //y=4.25 //x2=6.275 //y2=4.265
r761 (  74 75 ) resistor r=1.02576 //w=0.131 //l=1.075 //layer=m2 \
 //thickness=0.36 //x=6.02 //y=4.25 //x2=4.945 //y2=4.25
r762 (  72 75 ) resistor r=0.125 //w=0.17 //l=0.177341 //layer=m2 \
 //thickness=0.36 //x=4.775 //y=4.265 //x2=4.945 //y2=4.25
r763 (  72 73 ) resistor r=0.329198 //w=0.131 //l=0.345 //layer=m2 \
 //thickness=0.36 //x=4.775 //y=4.265 //x2=4.43 //y2=4.265
r764 (  70 73 ) resistor r=0.1875 //w=0.17 //l=0.262393 //layer=m2 \
 //thickness=0.36 //x=4.175 //y=4.25 //x2=4.43 //y2=4.265
r765 (  70 85 ) resistor r=2.29962 //w=0.131 //l=2.41 //layer=m2 \
 //thickness=0.36 //x=4.175 //y=4.25 //x2=1.765 //y2=4.25
r766 (  69 155 ) resistor r=9.3 //w=0.17 //l=0.17 //layer=mcon //count=1 \
 //x=20.5 //y=4.88 //x2=20.5 //y2=4.88
r767 (  65 146 ) resistor r=9.3 //w=0.17 //l=0.17 //layer=mcon //count=1 \
 //x=20.47 //y=2.26 //x2=20.47 //y2=2.26
r768 (  65 67 ) resistor r=0.0936408 //w=0.196 //l=0.125 //layer=m1 \
 //thickness=0.36 //x=20.472 //y=2.26 //x2=20.472 //y2=2.385
r769 (  62 91 ) resistor r=4.5 //w=0.15 //l=0.15 //layer=via1 //count=1 \
 //x=20.47 //y=4.25 //x2=20.47 //y2=4.25
r770 (  60 89 ) resistor r=4.5 //w=0.15 //l=0.15 //layer=via1 //count=1 \
 //x=14.54 //y=4.265 //x2=14.54 //y2=4.265
r771 (  58 60 ) resistor r=0.00505391 //w=0.371 //l=0.015 //layer=m1 \
 //thickness=0.36 //x=14.492 //y=4.25 //x2=14.492 //y2=4.265
r772 (  55 259 ) resistor r=9.3 //w=0.17 //l=0.17 //layer=mcon //count=1 \
 //x=14.11 //y=1.18 //x2=14.11 //y2=1.18
r773 (  53 129 ) resistor r=9.3 //w=0.17 //l=0.17 //layer=mcon //count=1 \
 //x=14.07 //y=5.56 //x2=14.07 //y2=5.56
r774 (  50 53 ) resistor r=0.117801 //w=0.191 //l=0.18 //layer=m1 \
 //thickness=0.36 //x=14.07 //y=5.38 //x2=14.07 //y2=5.56
r775 (  49 121 ) resistor r=9.3 //w=0.17 //l=0.17 //layer=mcon //count=1 \
 //x=13.19 //y=5.56 //x2=13.19 //y2=5.56
r776 (  47 49 ) resistor r=0.10274 //w=0.219 //l=0.18 //layer=m1 \
 //thickness=0.36 //x=13.19 //y=5.38 //x2=13.19 //y2=5.56
r777 (  46 116 ) resistor r=9.3 //w=0.17 //l=0.17 //layer=mcon //count=1 \
 //x=10.51 //y=4.88 //x2=10.51 //y2=4.88
r778 (  42 107 ) resistor r=9.3 //w=0.17 //l=0.17 //layer=mcon //count=1 \
 //x=10.48 //y=2.26 //x2=10.48 //y2=2.26
r779 (  42 44 ) resistor r=0.0936408 //w=0.196 //l=0.125 //layer=m1 \
 //thickness=0.36 //x=10.482 //y=2.26 //x2=10.482 //y2=2.385
r780 (  40 87 ) resistor r=4.5 //w=0.15 //l=0.15 //layer=via1 //count=1 \
 //x=10.485 //y=4.255 //x2=10.485 //y2=4.255
r781 (  38 40 ) resistor r=0.00164908 //w=0.379 //l=0.005 //layer=m1 \
 //thickness=0.36 //x=10.43 //y=4.25 //x2=10.43 //y2=4.255
r782 (  36 83 ) resistor r=4.5 //w=0.15 //l=0.15 //layer=via1 //count=1 \
 //x=1.605 //y=4.255 //x2=1.605 //y2=4.255
r783 (  34 36 ) resistor r=0.00167112 //w=0.374 //l=0.005 //layer=m1 \
 //thickness=0.36 //x=1.655 //y=4.25 //x2=1.655 //y2=4.255
r784 (  32 102 ) resistor r=9.3 //w=0.17 //l=0.17 //layer=mcon //count=1 \
 //x=1.6 //y=4.88 //x2=1.6 //y2=4.88
r785 (  30 93 ) resistor r=9.3 //w=0.17 //l=0.17 //layer=mcon //count=1 \
 //x=1.6 //y=2.26 //x2=1.6 //y2=2.26
r786 (  28 69 ) resistor r=0.0878548 //w=0.228 //l=0.159295 //layer=m1 \
 //thickness=0.36 //x=20.47 //y=4.735 //x2=20.5 //y2=4.88
r787 (  27 62 ) resistor r=0.0911593 //w=0.376 //l=0.184608 //layer=m1 \
 //thickness=0.36 //x=20.47 //y=4.41 //x2=20.417 //y2=4.25
r788 (  27 28 ) resistor r=0.310115 //w=0.131 //l=0.325 //layer=m1 \
 //thickness=0.36 //x=20.47 //y=4.41 //x2=20.47 //y2=4.735
r789 (  26 62 ) resistor r=0.0911593 //w=0.376 //l=0.184608 //layer=m1 \
 //thickness=0.36 //x=20.47 //y=4.09 //x2=20.417 //y2=4.25
r790 (  26 67 ) resistor r=1.62691 //w=0.131 //l=1.705 //layer=m1 \
 //thickness=0.36 //x=20.47 //y=4.09 //x2=20.47 //y2=2.385
r791 (  23 60 ) resistor r=0.0909648 //w=0.371 //l=0.186762 //layer=m1 \
 //thickness=0.36 //x=14.55 //y=4.425 //x2=14.492 //y2=4.265
r792 (  23 24 ) resistor r=0.830153 //w=0.131 //l=0.87 //layer=m1 \
 //thickness=0.36 //x=14.55 //y=4.425 //x2=14.55 //y2=5.295
r793 (  22 58 ) resistor r=0.0859108 //w=0.371 //l=0.171566 //layer=m1 \
 //thickness=0.36 //x=14.55 //y=4.105 //x2=14.492 //y2=4.25
r794 (  21 22 ) resistor r=2.08492 //w=0.131 //l=2.185 //layer=m1 \
 //thickness=0.36 //x=14.55 //y=1.92 //x2=14.55 //y2=4.105
r795 (  19 21 ) resistor r=0.0698411 //w=0.17 //l=0.120208 //layer=m1 \
 //thickness=0.36 //x=14.465 //y=1.835 //x2=14.55 //y2=1.92
r796 (  19 20 ) resistor r=0.257634 //w=0.131 //l=0.27 //layer=m1 \
 //thickness=0.36 //x=14.465 //y=1.835 //x2=14.195 //y2=1.835
r797 (  18 50 ) resistor r=0.0257089 //w=0.23 //l=0.115 //layer=m1 \
 //thickness=0.36 //x=14.185 //y=5.38 //x2=14.07 //y2=5.38
r798 (  17 24 ) resistor r=0.0698411 //w=0.17 //l=0.120208 //layer=m1 \
 //thickness=0.36 //x=14.465 //y=5.38 //x2=14.55 //y2=5.295
r799 (  17 18 ) resistor r=0.267176 //w=0.131 //l=0.28 //layer=m1 \
 //thickness=0.36 //x=14.465 //y=5.38 //x2=14.185 //y2=5.38
r800 (  16 20 ) resistor r=0.0698411 //w=0.17 //l=0.120208 //layer=m1 \
 //thickness=0.36 //x=14.11 //y=1.75 //x2=14.195 //y2=1.835
r801 (  15 55 ) resistor r=0.0913624 //w=0.191 //l=0.12 //layer=m1 \
 //thickness=0.36 //x=14.11 //y=1.3 //x2=14.11 //y2=1.18
r802 (  15 16 ) resistor r=0.429389 //w=0.131 //l=0.45 //layer=m1 \
 //thickness=0.36 //x=14.11 //y=1.3 //x2=14.11 //y2=1.75
r803 (  12 47 ) resistor r=0.0227762 //w=0.219 //l=0.115 //layer=m1 \
 //thickness=0.36 //x=13.305 //y=5.38 //x2=13.19 //y2=5.38
r804 (  11 50 ) resistor r=0.0257089 //w=0.23 //l=0.115 //layer=m1 \
 //thickness=0.36 //x=13.955 //y=5.38 //x2=14.07 //y2=5.38
r805 (  11 12 ) resistor r=0.620229 //w=0.131 //l=0.65 //layer=m1 \
 //thickness=0.36 //x=13.955 //y=5.38 //x2=13.305 //y2=5.38
r806 (  8 46 ) resistor r=0.0878548 //w=0.228 //l=0.159295 //layer=m1 \
 //thickness=0.36 //x=10.48 //y=4.735 //x2=10.51 //y2=4.88
r807 (  7 40 ) resistor r=0.0912814 //w=0.379 //l=0.183303 //layer=m1 \
 //thickness=0.36 //x=10.48 //y=4.415 //x2=10.43 //y2=4.255
r808 (  7 8 ) resistor r=0.305344 //w=0.131 //l=0.32 //layer=m1 \
 //thickness=0.36 //x=10.48 //y=4.415 //x2=10.48 //y2=4.735
r809 (  6 38 ) resistor r=0.0896323 //w=0.379 //l=0.178255 //layer=m1 \
 //thickness=0.36 //x=10.48 //y=4.095 //x2=10.43 //y2=4.25
r810 (  6 44 ) resistor r=1.63168 //w=0.131 //l=1.71 //layer=m1 \
 //thickness=0.36 //x=10.48 //y=4.095 //x2=10.48 //y2=2.385
r811 (  4 32 ) resistor r=0.0760407 //w=0.238 //l=0.125 //layer=m1 \
 //thickness=0.36 //x=1.6 //y=4.755 //x2=1.6 //y2=4.88
r812 (  3 36 ) resistor r=0.0910802 //w=0.374 //l=0.185472 //layer=m1 \
 //thickness=0.36 //x=1.6 //y=4.415 //x2=1.655 //y2=4.255
r813 (  3 4 ) resistor r=0.324427 //w=0.131 //l=0.34 //layer=m1 \
 //thickness=0.36 //x=1.6 //y=4.415 //x2=1.6 //y2=4.755
r814 (  2 34 ) resistor r=0.089409 //w=0.374 //l=0.180416 //layer=m1 \
 //thickness=0.36 //x=1.6 //y=4.095 //x2=1.655 //y2=4.25
r815 (  1 30 ) resistor r=0.0719237 //w=0.222 //l=0.115 //layer=m1 \
 //thickness=0.36 //x=1.6 //y=2.375 //x2=1.6 //y2=2.26
r816 (  1 2 ) resistor r=1.64122 //w=0.131 //l=1.72 //layer=m1 \
 //thickness=0.36 //x=1.6 //y=2.375 //x2=1.6 //y2=4.095
ends PM_DFFX1\%noxref_6

subckt PM_DFFX1\%Q ( 1 2 3 4 5 6 7 8 9 10 11 12 13 14 21 22 26 31 32 34 35 42 \
 48 59 60 63 65 71 73 78 82 91 96 104 120 121 122 123 124 125 130 132 134 140 \
 141 143 144 147 155 157 158 )
c277 ( 155 0 ) capacitor c=0.00878249f //x=20.58 //y=1.085
c278 ( 147 0 ) capacitor c=0.036522f //x=17.17 //y=4.88
c279 ( 144 0 ) capacitor c=0.0284095f //x=17.14 //y=2.095
c280 ( 143 0 ) capacitor c=0.0476356f //x=17.14 //y=2.26
c281 ( 141 0 ) capacitor c=0.0439708f //x=17.705 //y=1.43
c282 ( 140 0 ) capacitor c=0.0192582f //x=17.705 //y=1.085
c283 ( 134 0 ) capacitor c=0.0162526f //x=17.55 //y=1.585
c284 ( 132 0 ) capacitor c=0.0157807f //x=17.55 //y=0.93
c285 ( 130 0 ) capacitor c=0.0359568f //x=17.545 //y=4.97
c286 ( 125 0 ) capacitor c=0.0210762f //x=17.175 //y=1.74
c287 ( 124 0 ) capacitor c=0.0168511f //x=17.175 //y=1.43
c288 ( 123 0 ) capacitor c=0.0175485f //x=17.175 //y=1.085
c289 ( 122 0 ) capacitor c=0.155269f //x=17.62 //y=6.2
c290 ( 121 0 ) capacitor c=0.110375f //x=17.18 //y=6.2
c291 ( 104 0 ) capacitor c=0.0322017f //x=20.73 //y=5.56
c292 ( 96 0 ) capacitor c=0.0291703f //x=19.85 //y=5.56
c293 ( 91 0 ) capacitor c=8.90417e-19 //x=17.17 //y=4.88
c294 ( 82 0 ) capacitor c=5.78095e-19 //x=17.14 //y=2.26
c295 ( 78 0 ) capacitor c=0.00315392f //x=17.3 //y=3.865
c296 ( 73 0 ) capacitor c=0.0321357f //x=20.685 //y=3.865
c297 ( 71 0 ) capacitor c=0.0411407f //x=20.085 //y=3.88
c298 ( 65 0 ) capacitor c=0.014893f //x=20.77 //y=1.18
c299 ( 63 0 ) capacitor c=5.78613e-19 //x=20.73 //y=5.56
c300 ( 60 0 ) capacitor c=0.014706f //x=20.73 //y=5.38
c301 ( 59 0 ) capacitor c=0.00919281f //x=19.85 //y=5.56
c302 ( 48 0 ) capacitor c=0.00650008f //x=17.14 //y=2.26
c303 ( 42 0 ) capacitor c=0.012706f //x=21.21 //y=4.045
c304 ( 35 0 ) capacitor c=0.00671677f //x=20.855 //y=1.835
c305 ( 34 0 ) capacitor c=0.0151258f //x=21.125 //y=1.835
c306 ( 32 0 ) capacitor c=0.0125798f //x=21.125 //y=5.38
c307 ( 31 0 ) capacitor c=0.0133876f //x=20.77 //y=1.75
c308 ( 26 0 ) capacitor c=0.0136628f //x=20.615 //y=5.38
c309 ( 22 0 ) capacitor c=0.00421628f //x=17.14 //y=4.735
c310 ( 21 0 ) capacitor c=0.00981483f //x=17.14 //y=4.025
c311 ( 14 0 ) capacitor c=0.0184461f //x=21.21 //y=3.88
c312 ( 13 0 ) capacitor c=0.0139575f //x=17.14 //y=3.88
c313 ( 10 0 ) capacitor c=0.0431109f //x=21.21 //y=4.25
c314 ( 6 0 ) capacitor c=0.0742426f //x=21.21 //y=2.4
c315 ( 5 0 ) capacitor c=0.0139859f //x=17.14 //y=4.62
c316 ( 1 0 ) capacitor c=0.0306875f //x=17.14 //y=2.4
r317 (  149 150 ) resistor r=32.4568 //w=0.214 //l=0.075 //layer=ply \
 //thickness=0.18 //x=17.17 //y=4.97 //x2=17.17 //y2=5.045
r318 (  147 149 ) resistor r=20.271 //w=0.214 //l=0.09 //layer=ply \
 //thickness=0.18 //x=17.17 //y=4.88 //x2=17.17 //y2=4.97
r319 (  143 144 ) resistor r=52.7279 //w=0.214 //l=0.165 //layer=ply \
 //thickness=0.18 //x=17.14 //y=2.26 //x2=17.14 //y2=2.095
r320 (  141 154 ) resistor r=45.1352 //w=0.168 //l=0.173853 //layer=ply \
 //thickness=0.18 //x=17.705 //y=1.43 //x2=17.665 //y2=1.585
r321 (  140 153 ) resistor r=45.1352 //w=0.168 //l=0.173853 //layer=ply \
 //thickness=0.18 //x=17.705 //y=1.085 //x2=17.665 //y2=0.93
r322 (  140 141 ) resistor r=176.904 //w=0.094 //l=0.345 //layer=ply \
 //thickness=0.18 //x=17.705 //y=1.085 //x2=17.705 //y2=1.43
r323 (  135 152 ) resistor r=10.701 //w=0.21 //l=0.115 //layer=ply \
 //thickness=0.18 //x=17.33 //y=1.585 //x2=17.215 //y2=1.585
r324 (  134 154 ) resistor r=5.52526 //w=0.168 //l=0.115 //layer=ply \
 //thickness=0.18 //x=17.55 //y=1.585 //x2=17.665 //y2=1.585
r325 (  133 151 ) resistor r=5.52526 //w=0.168 //l=0.115 //layer=ply \
 //thickness=0.18 //x=17.33 //y=0.93 //x2=17.215 //y2=0.93
r326 (  132 153 ) resistor r=5.52526 //w=0.168 //l=0.115 //layer=ply \
 //thickness=0.18 //x=17.55 //y=0.93 //x2=17.665 //y2=0.93
r327 (  132 133 ) resistor r=112.809 //w=0.094 //l=0.22 //layer=ply \
 //thickness=0.18 //x=17.55 //y=0.93 //x2=17.33 //y2=0.93
r328 (  131 149 ) resistor r=16.5046 //w=0.27 //l=0.135 //layer=ply \
 //thickness=0.18 //x=17.305 //y=4.97 //x2=17.17 //y2=4.97
r329 (  130 137 ) resistor r=26.9307 //w=0.15 //l=0.106066 //layer=ply \
 //thickness=0.18 //x=17.545 //y=4.97 //x2=17.62 //y2=5.045
r330 (  130 131 ) resistor r=123.064 //w=0.094 //l=0.24 //layer=ply \
 //thickness=0.18 //x=17.545 //y=4.97 //x2=17.305 //y2=4.97
r331 (  125 152 ) resistor r=39.5823 //w=0.21 //l=0.173853 //layer=ply \
 //thickness=0.18 //x=17.175 //y=1.74 //x2=17.215 //y2=1.585
r332 (  125 144 ) resistor r=182.032 //w=0.094 //l=0.355 //layer=ply \
 //thickness=0.18 //x=17.175 //y=1.74 //x2=17.175 //y2=2.095
r333 (  124 152 ) resistor r=39.5823 //w=0.21 //l=0.173853 //layer=ply \
 //thickness=0.18 //x=17.175 //y=1.43 //x2=17.215 //y2=1.585
r334 (  123 151 ) resistor r=45.1352 //w=0.168 //l=0.173853 //layer=ply \
 //thickness=0.18 //x=17.175 //y=1.085 //x2=17.215 //y2=0.93
r335 (  123 124 ) resistor r=176.904 //w=0.094 //l=0.345 //layer=ply \
 //thickness=0.18 //x=17.175 //y=1.085 //x2=17.175 //y2=1.43
r336 (  122 137 ) resistor r=592.245 //w=0.094 //l=1.155 //layer=ply \
 //thickness=0.18 //x=17.62 //y=6.2 //x2=17.62 //y2=5.045
r337 (  121 150 ) resistor r=592.245 //w=0.094 //l=1.155 //layer=ply \
 //thickness=0.18 //x=17.18 //y=6.2 //x2=17.18 //y2=5.045
r338 (  120 134 ) resistor r=56.4043 //w=0.094 //l=0.11 //layer=ply \
 //thickness=0.18 //x=17.44 //y=1.585 //x2=17.55 //y2=1.585
r339 (  120 135 ) resistor r=56.4043 //w=0.094 //l=0.11 //layer=ply \
 //thickness=0.18 //x=17.44 //y=1.585 //x2=17.33 //y2=1.585
r340 (  104 158 ) resistor r=23.615 //w=0.187 //l=0.345 //layer=li \
 //thickness=0.1 //x=20.73 //y=5.56 //x2=20.73 //y2=5.905
r341 (  96 157 ) resistor r=23.615 //w=0.187 //l=0.345 //layer=li \
 //thickness=0.1 //x=19.85 //y=5.56 //x2=19.85 //y2=5.905
r342 (  91 147 ) resistor r=152 //w=0.17 //l=0.17 //layer=licon //count=1 \
 //x=17.17 //y=4.88 //x2=17.17 //y2=4.88
r343 (  82 143 ) resistor r=152 //w=0.17 //l=0.17 //layer=licon //count=1 \
 //x=17.14 //y=2.26 //x2=17.14 //y2=2.26
r344 (  76 78 ) resistor r=0.10734 //w=0.281 //l=0.16 //layer=m2 \
 //thickness=0.36 //x=17.14 //y=3.865 //x2=17.3 //y2=3.865
r345 (  73 80 ) resistor r=0.280717 //w=0.241 //l=0.529906 //layer=m2 \
 //thickness=0.36 //x=20.685 //y=3.865 //x2=21.205 //y2=3.885
r346 (  73 74 ) resistor r=0.410305 //w=0.131 //l=0.43 //layer=m2 \
 //thickness=0.36 //x=20.685 //y=3.865 //x2=20.255 //y2=3.865
r347 (  71 74 ) resistor r=0.125 //w=0.17 //l=0.177341 //layer=m2 \
 //thickness=0.36 //x=20.085 //y=3.88 //x2=20.255 //y2=3.865
r348 (  71 78 ) resistor r=2.65744 //w=0.131 //l=2.785 //layer=m2 \
 //thickness=0.36 //x=20.085 //y=3.88 //x2=17.3 //y2=3.88
r349 (  70 80 ) resistor r=4.5 //w=0.15 //l=0.15 //layer=via1 //count=1 \
 //x=21.205 //y=3.885 //x2=21.205 //y2=3.885
r350 (  65 155 ) resistor r=9.3 //w=0.17 //l=0.17 //layer=mcon //count=1 \
 //x=20.77 //y=1.18 //x2=20.77 //y2=1.18
r351 (  63 104 ) resistor r=9.3 //w=0.17 //l=0.17 //layer=mcon //count=1 \
 //x=20.73 //y=5.56 //x2=20.73 //y2=5.56
r352 (  60 63 ) resistor r=0.117801 //w=0.191 //l=0.18 //layer=m1 \
 //thickness=0.36 //x=20.73 //y=5.38 //x2=20.73 //y2=5.56
r353 (  59 96 ) resistor r=9.3 //w=0.17 //l=0.17 //layer=mcon //count=1 \
 //x=19.85 //y=5.56 //x2=19.85 //y2=5.56
r354 (  57 59 ) resistor r=0.10274 //w=0.219 //l=0.18 //layer=m1 \
 //thickness=0.36 //x=19.85 //y=5.38 //x2=19.85 //y2=5.56
r355 (  54 76 ) resistor r=4.5 //w=0.15 //l=0.15 //layer=via1 //count=1 \
 //x=17.14 //y=3.865 //x2=17.14 //y2=3.865
r356 (  52 91 ) resistor r=9.3 //w=0.17 //l=0.17 //layer=mcon //count=1 \
 //x=17.17 //y=4.88 //x2=17.17 //y2=4.88
r357 (  48 82 ) resistor r=9.3 //w=0.17 //l=0.17 //layer=mcon //count=1 \
 //x=17.14 //y=2.26 //x2=17.14 //y2=2.26
r358 (  48 50 ) resistor r=0.0936408 //w=0.196 //l=0.125 //layer=m1 \
 //thickness=0.36 //x=17.142 //y=2.26 //x2=17.142 //y2=2.385
r359 (  42 70 ) resistor r=0.0910802 //w=0.374 //l=0.185472 //layer=m1 \
 //thickness=0.36 //x=21.21 //y=4.045 //x2=21.155 //y2=3.885
r360 (  34 36 ) resistor r=0.0698411 //w=0.17 //l=0.120208 //layer=m1 \
 //thickness=0.36 //x=21.125 //y=1.835 //x2=21.21 //y2=1.92
r361 (  34 35 ) resistor r=0.257634 //w=0.131 //l=0.27 //layer=m1 \
 //thickness=0.36 //x=21.125 //y=1.835 //x2=20.855 //y2=1.835
r362 (  33 60 ) resistor r=0.0257089 //w=0.23 //l=0.115 //layer=m1 \
 //thickness=0.36 //x=20.845 //y=5.38 //x2=20.73 //y2=5.38
r363 (  32 43 ) resistor r=0.0698411 //w=0.17 //l=0.120208 //layer=m1 \
 //thickness=0.36 //x=21.125 //y=5.38 //x2=21.21 //y2=5.295
r364 (  32 33 ) resistor r=0.267176 //w=0.131 //l=0.28 //layer=m1 \
 //thickness=0.36 //x=21.125 //y=5.38 //x2=20.845 //y2=5.38
r365 (  31 35 ) resistor r=0.0698411 //w=0.17 //l=0.120208 //layer=m1 \
 //thickness=0.36 //x=20.77 //y=1.75 //x2=20.855 //y2=1.835
r366 (  30 65 ) resistor r=0.0913624 //w=0.191 //l=0.12 //layer=m1 \
 //thickness=0.36 //x=20.77 //y=1.3 //x2=20.77 //y2=1.18
r367 (  30 31 ) resistor r=0.429389 //w=0.131 //l=0.45 //layer=m1 \
 //thickness=0.36 //x=20.77 //y=1.3 //x2=20.77 //y2=1.75
r368 (  27 57 ) resistor r=0.0227762 //w=0.219 //l=0.115 //layer=m1 \
 //thickness=0.36 //x=19.965 //y=5.38 //x2=19.85 //y2=5.38
r369 (  26 60 ) resistor r=0.0257089 //w=0.23 //l=0.115 //layer=m1 \
 //thickness=0.36 //x=20.615 //y=5.38 //x2=20.73 //y2=5.38
r370 (  26 27 ) resistor r=0.620229 //w=0.131 //l=0.65 //layer=m1 \
 //thickness=0.36 //x=20.615 //y=5.38 //x2=19.965 //y2=5.38
r371 (  22 52 ) resistor r=0.0878548 //w=0.228 //l=0.159295 //layer=m1 \
 //thickness=0.36 //x=17.14 //y=4.735 //x2=17.17 //y2=4.88
r372 (  16 54 ) resistor r=0.0911593 //w=0.376 //l=0.184174 //layer=m1 \
 //thickness=0.36 //x=17.14 //y=3.705 //x2=17.192 //y2=3.865
r373 (  14 70 ) resistor r=0.00167112 //w=0.374 //l=0.005 //layer=m1 \
 //thickness=0.36 //x=21.155 //y=3.88 //x2=21.155 //y2=3.885
r374 (  14 37 ) resistor r=0.089409 //w=0.374 //l=0.180416 //layer=m1 \
 //thickness=0.36 //x=21.155 //y=3.88 //x2=21.21 //y2=3.725
r375 (  13 21 ) resistor r=0.0861726 //w=0.376 //l=0.169012 //layer=m1 \
 //thickness=0.36 //x=17.192 //y=3.88 //x2=17.14 //y2=4.025
r376 (  13 54 ) resistor r=0.0049867 //w=0.376 //l=0.015 //layer=m1 \
 //thickness=0.36 //x=17.192 //y=3.88 //x2=17.192 //y2=3.865
r377 (  12 43 ) resistor r=0.291031 //w=0.131 //l=0.305 //layer=m1 \
 //thickness=0.36 //x=21.21 //y=4.99 //x2=21.21 //y2=5.295
r378 (  11 12 ) resistor r=0.353053 //w=0.131 //l=0.37 //layer=m1 \
 //thickness=0.36 //x=21.21 //y=4.62 //x2=21.21 //y2=4.99
r379 (  10 11 ) resistor r=0.353053 //w=0.131 //l=0.37 //layer=m1 \
 //thickness=0.36 //x=21.21 //y=4.25 //x2=21.21 //y2=4.62
r380 (  10 42 ) resistor r=0.195611 //w=0.131 //l=0.205 //layer=m1 \
 //thickness=0.36 //x=21.21 //y=4.25 //x2=21.21 //y2=4.045
r381 (  9 37 ) resistor r=0.205153 //w=0.131 //l=0.215 //layer=m1 \
 //thickness=0.36 //x=21.21 //y=3.51 //x2=21.21 //y2=3.725
r382 (  8 9 ) resistor r=0.353053 //w=0.131 //l=0.37 //layer=m1 \
 //thickness=0.36 //x=21.21 //y=3.14 //x2=21.21 //y2=3.51
r383 (  7 8 ) resistor r=0.353053 //w=0.131 //l=0.37 //layer=m1 \
 //thickness=0.36 //x=21.21 //y=2.77 //x2=21.21 //y2=3.14
r384 (  6 7 ) resistor r=0.353053 //w=0.131 //l=0.37 //layer=m1 \
 //thickness=0.36 //x=21.21 //y=2.4 //x2=21.21 //y2=2.77
r385 (  6 36 ) resistor r=0.458015 //w=0.131 //l=0.48 //layer=m1 \
 //thickness=0.36 //x=21.21 //y=2.4 //x2=21.21 //y2=1.92
r386 (  5 22 ) resistor r=0.109733 //w=0.131 //l=0.115 //layer=m1 \
 //thickness=0.36 //x=17.14 //y=4.62 //x2=17.14 //y2=4.735
r387 (  5 21 ) resistor r=0.567748 //w=0.131 //l=0.595 //layer=m1 \
 //thickness=0.36 //x=17.14 //y=4.62 //x2=17.14 //y2=4.025
r388 (  4 16 ) resistor r=0.186069 //w=0.131 //l=0.195 //layer=m1 \
 //thickness=0.36 //x=17.14 //y=3.51 //x2=17.14 //y2=3.705
r389 (  3 4 ) resistor r=0.353053 //w=0.131 //l=0.37 //layer=m1 \
 //thickness=0.36 //x=17.14 //y=3.14 //x2=17.14 //y2=3.51
r390 (  2 3 ) resistor r=0.353053 //w=0.131 //l=0.37 //layer=m1 \
 //thickness=0.36 //x=17.14 //y=2.77 //x2=17.14 //y2=3.14
r391 (  1 2 ) resistor r=0.353053 //w=0.131 //l=0.37 //layer=m1 \
 //thickness=0.36 //x=17.14 //y=2.4 //x2=17.14 //y2=2.77
r392 (  1 50 ) resistor r=0.014313 //w=0.131 //l=0.015 //layer=m1 \
 //thickness=0.36 //x=17.14 //y=2.4 //x2=17.14 //y2=2.385
ends PM_DFFX1\%Q

subckt PM_DFFX1\%VDD ( 1 39 58 67 77 85 95 111 119 145 155 181 191 213 221 247 \
 257 270 277 282 286 291 296 300 301 302 303 304 305 306 307 308 309 310 311 \
 312 313 314 315 316 317 318 )
c386 ( 318 0 ) capacitor c=0.0393089f //x=21.025 //y=5.2
c387 ( 317 0 ) capacitor c=0.0248174f //x=20.145 //y=5.2
c388 ( 316 0 ) capacitor c=0.0625788f //x=19.275 //y=5.2
c389 ( 315 0 ) capacitor c=0.039544f //x=17.695 //y=5.2
c390 ( 314 0 ) capacitor c=0.0248174f //x=16.815 //y=5.2
c391 ( 313 0 ) capacitor c=0.062487f //x=15.945 //y=5.2
c392 ( 312 0 ) capacitor c=0.0390282f //x=14.365 //y=5.2
c393 ( 311 0 ) capacitor c=0.0248174f //x=13.485 //y=5.2
c394 ( 310 0 ) capacitor c=0.0623361f //x=12.615 //y=5.2
c395 ( 309 0 ) capacitor c=0.039544f //x=11.035 //y=5.2
c396 ( 308 0 ) capacitor c=0.0248174f //x=10.155 //y=5.2
c397 ( 307 0 ) capacitor c=0.0623361f //x=9.285 //y=5.2
c398 ( 306 0 ) capacitor c=0.039544f //x=7.705 //y=5.2
c399 ( 305 0 ) capacitor c=0.0248174f //x=6.825 //y=5.2
c400 ( 304 0 ) capacitor c=0.0627254f //x=5.955 //y=5.2
c401 ( 303 0 ) capacitor c=0.0466891f //x=4.075 //y=5.2
c402 ( 302 0 ) capacitor c=0.0255836f //x=3.195 //y=5.2
c403 ( 301 0 ) capacitor c=0.0256114f //x=2.315 //y=5.2
c404 ( 300 0 ) capacitor c=0.0693239f //x=1.445 //y=5.2
c405 ( 299 0 ) capacitor c=0.00597439f //x=21.17 //y=7.585
c406 ( 298 0 ) capacitor c=0.00597439f //x=20.29 //y=7.585
c407 ( 297 0 ) capacitor c=0.00597439f //x=19.41 //y=7.585
c408 ( 296 0 ) capacitor c=0.127979f //x=18.62 //y=7.585
c409 ( 295 0 ) capacitor c=0.00597439f //x=17.84 //y=7.585
c410 ( 294 0 ) capacitor c=0.00597439f //x=16.96 //y=7.585
c411 ( 293 0 ) capacitor c=0.00597439f //x=16.03 //y=7.58
c412 ( 291 0 ) capacitor c=0.127181f //x=15.29 //y=7.585
c413 ( 290 0 ) capacitor c=0.00597439f //x=14.55 //y=7.58
c414 ( 288 0 ) capacitor c=0.00597439f //x=13.63 //y=7.585
c415 ( 287 0 ) capacitor c=0.00597439f //x=12.75 //y=7.585
c416 ( 286 0 ) capacitor c=0.126609f //x=11.96 //y=7.585
c417 ( 285 0 ) capacitor c=0.00597439f //x=11.18 //y=7.585
c418 ( 284 0 ) capacitor c=0.00597439f //x=10.3 //y=7.585
c419 ( 283 0 ) capacitor c=0.00597439f //x=9.42 //y=7.585
c420 ( 282 0 ) capacitor c=0.126767f //x=8.63 //y=7.585
c421 ( 281 0 ) capacitor c=0.00597439f //x=7.85 //y=7.585
c422 ( 280 0 ) capacitor c=0.00597439f //x=6.97 //y=7.585
c423 ( 279 0 ) capacitor c=0.00597439f //x=6.04 //y=7.58
c424 ( 277 0 ) capacitor c=0.145722f //x=5.3 //y=7.585
c425 ( 276 0 ) capacitor c=0.00597439f //x=4.22 //y=7.585
c426 ( 275 0 ) capacitor c=0.00597439f //x=3.34 //y=7.585
c427 ( 274 0 ) capacitor c=0.00597439f //x=2.46 //y=7.585
c428 ( 273 0 ) capacitor c=0.00597439f //x=1.58 //y=7.585
c429 ( 270 0 ) capacitor c=0.261935f //x=21.58 //y=7.58
c430 ( 257 0 ) capacitor c=0.0287376f //x=21.085 //y=7.585
c431 ( 247 0 ) capacitor c=0.0291078f //x=20.205 //y=7.585
c432 ( 237 0 ) capacitor c=0.0283511f //x=19.325 //y=7.585
c433 ( 231 0 ) capacitor c=0.0277785f //x=18.45 //y=7.585
c434 ( 221 0 ) capacitor c=0.0287375f //x=17.755 //y=7.585
c435 ( 213 0 ) capacitor c=0.0291078f //x=16.875 //y=7.585
c436 ( 203 0 ) capacitor c=0.0283511f //x=15.995 //y=7.585
c437 ( 199 0 ) capacitor c=0.0273918f //x=15.12 //y=7.585
c438 ( 191 0 ) capacitor c=0.0287377f //x=14.425 //y=7.585
c439 ( 181 0 ) capacitor c=0.0291078f //x=13.545 //y=7.585
c440 ( 169 0 ) capacitor c=0.0283511f //x=12.665 //y=7.585
c441 ( 165 0 ) capacitor c=0.0277785f //x=11.79 //y=7.585
c442 ( 155 0 ) capacitor c=0.0287376f //x=11.095 //y=7.585
c443 ( 145 0 ) capacitor c=0.0291078f //x=10.215 //y=7.585
c444 ( 135 0 ) capacitor c=0.0283511f //x=9.335 //y=7.585
c445 ( 129 0 ) capacitor c=0.0277785f //x=8.46 //y=7.585
c446 ( 119 0 ) capacitor c=0.0287375f //x=7.765 //y=7.585
c447 ( 111 0 ) capacitor c=0.0291078f //x=6.885 //y=7.585
c448 ( 101 0 ) capacitor c=0.0283511f //x=6.005 //y=7.585
c449 ( 95 0 ) capacitor c=0.042257f //x=5.13 //y=7.585
c450 ( 85 0 ) capacitor c=0.0288858f //x=4.135 //y=7.585
c451 ( 77 0 ) capacitor c=0.0288441f //x=3.255 //y=7.585
c452 ( 67 0 ) capacitor c=0.0289834f //x=2.375 //y=7.585
c453 ( 58 0 ) capacitor c=0.253472f //x=1.23 //y=7.58
c454 ( 55 0 ) capacitor c=0.0455283f //x=1.495 //y=7.585
c455 ( 39 0 ) capacitor c=0.82416f //x=21.58 //y=7.58
r456 (  268 299 ) resistor r=2.87058 //w=0.35 //l=0.085 //layer=li \
 //thickness=0.1 //x=21.255 //y=7.585 //x2=21.17 //y2=7.585
r457 (  268 270 ) resistor r=11.3351 //w=0.367 //l=0.325 //layer=li \
 //thickness=0.1 //x=21.255 //y=7.585 //x2=21.58 //y2=7.585
r458 (  261 299 ) resistor r=4.23183 //w=0.7 //l=0.175 //layer=li \
 //thickness=0.1 //x=21.17 //y=7.41 //x2=21.17 //y2=7.585
r459 (  261 318 ) resistor r=33.1979 //w=0.187 //l=0.485 //layer=li \
 //thickness=0.1 //x=21.17 //y=7.41 //x2=21.17 //y2=6.925
r460 (  258 298 ) resistor r=2.87058 //w=0.35 //l=0.085 //layer=li \
 //thickness=0.1 //x=20.375 //y=7.585 //x2=20.29 //y2=7.585
r461 (  258 260 ) resistor r=16.218 //w=0.367 //l=0.465 //layer=li \
 //thickness=0.1 //x=20.375 //y=7.585 //x2=20.84 //y2=7.585
r462 (  257 299 ) resistor r=2.87058 //w=0.35 //l=0.085 //layer=li \
 //thickness=0.1 //x=21.085 //y=7.585 //x2=21.17 //y2=7.585
r463 (  257 260 ) resistor r=8.54496 //w=0.367 //l=0.245 //layer=li \
 //thickness=0.1 //x=21.085 //y=7.585 //x2=20.84 //y2=7.585
r464 (  251 298 ) resistor r=4.23183 //w=0.7 //l=0.175 //layer=li \
 //thickness=0.1 //x=20.29 //y=7.41 //x2=20.29 //y2=7.585
r465 (  251 317 ) resistor r=33.1979 //w=0.187 //l=0.485 //layer=li \
 //thickness=0.1 //x=20.29 //y=7.41 //x2=20.29 //y2=6.925
r466 (  248 297 ) resistor r=2.87058 //w=0.35 //l=0.085 //layer=li \
 //thickness=0.1 //x=19.495 //y=7.585 //x2=19.41 //y2=7.585
r467 (  248 250 ) resistor r=8.19619 //w=0.367 //l=0.235 //layer=li \
 //thickness=0.1 //x=19.495 //y=7.585 //x2=19.73 //y2=7.585
r468 (  247 298 ) resistor r=2.87058 //w=0.35 //l=0.085 //layer=li \
 //thickness=0.1 //x=20.205 //y=7.585 //x2=20.29 //y2=7.585
r469 (  247 250 ) resistor r=16.5668 //w=0.367 //l=0.475 //layer=li \
 //thickness=0.1 //x=20.205 //y=7.585 //x2=19.73 //y2=7.585
r470 (  239 297 ) resistor r=4.23183 //w=0.7 //l=0.175 //layer=li \
 //thickness=0.1 //x=19.41 //y=7.41 //x2=19.41 //y2=7.585
r471 (  239 316 ) resistor r=56.4706 //w=0.187 //l=0.825 //layer=li \
 //thickness=0.1 //x=19.41 //y=7.41 //x2=19.41 //y2=6.585
r472 (  238 296 ) resistor r=5.29055 //w=0.35 //l=0.17 //layer=li \
 //thickness=0.1 //x=18.79 //y=7.585 //x2=18.62 //y2=7.585
r473 (  237 297 ) resistor r=2.87058 //w=0.35 //l=0.085 //layer=li \
 //thickness=0.1 //x=19.325 //y=7.585 //x2=19.41 //y2=7.585
r474 (  237 238 ) resistor r=18.6594 //w=0.367 //l=0.535 //layer=li \
 //thickness=0.1 //x=19.325 //y=7.585 //x2=18.79 //y2=7.585
r475 (  232 295 ) resistor r=2.87058 //w=0.35 //l=0.085 //layer=li \
 //thickness=0.1 //x=17.925 //y=7.585 //x2=17.84 //y2=7.585
r476 (  232 234 ) resistor r=11.3351 //w=0.367 //l=0.325 //layer=li \
 //thickness=0.1 //x=17.925 //y=7.585 //x2=18.25 //y2=7.585
r477 (  231 296 ) resistor r=5.29055 //w=0.35 //l=0.17 //layer=li \
 //thickness=0.1 //x=18.45 //y=7.585 //x2=18.62 //y2=7.585
r478 (  231 234 ) resistor r=6.97548 //w=0.367 //l=0.2 //layer=li \
 //thickness=0.1 //x=18.45 //y=7.585 //x2=18.25 //y2=7.585
r479 (  225 295 ) resistor r=4.23183 //w=0.7 //l=0.175 //layer=li \
 //thickness=0.1 //x=17.84 //y=7.41 //x2=17.84 //y2=7.585
r480 (  225 315 ) resistor r=33.1979 //w=0.187 //l=0.485 //layer=li \
 //thickness=0.1 //x=17.84 //y=7.41 //x2=17.84 //y2=6.925
r481 (  222 294 ) resistor r=2.87058 //w=0.35 //l=0.085 //layer=li \
 //thickness=0.1 //x=17.045 //y=7.585 //x2=16.96 //y2=7.585
r482 (  222 224 ) resistor r=3.31335 //w=0.367 //l=0.095 //layer=li \
 //thickness=0.1 //x=17.045 //y=7.585 //x2=17.14 //y2=7.585
r483 (  221 295 ) resistor r=2.87058 //w=0.35 //l=0.085 //layer=li \
 //thickness=0.1 //x=17.755 //y=7.585 //x2=17.84 //y2=7.585
r484 (  221 224 ) resistor r=21.4496 //w=0.367 //l=0.615 //layer=li \
 //thickness=0.1 //x=17.755 //y=7.585 //x2=17.14 //y2=7.585
r485 (  215 294 ) resistor r=4.23183 //w=0.7 //l=0.175 //layer=li \
 //thickness=0.1 //x=16.96 //y=7.41 //x2=16.96 //y2=7.585
r486 (  215 314 ) resistor r=33.1979 //w=0.187 //l=0.485 //layer=li \
 //thickness=0.1 //x=16.96 //y=7.41 //x2=16.96 //y2=6.925
r487 (  214 293 ) resistor r=2.87058 //w=0.35 //l=0.085 //layer=li \
 //thickness=0.1 //x=16.165 //y=7.585 //x2=16.08 //y2=7.585
r488 (  213 294 ) resistor r=2.87058 //w=0.35 //l=0.085 //layer=li \
 //thickness=0.1 //x=16.875 //y=7.585 //x2=16.96 //y2=7.585
r489 (  213 214 ) resistor r=24.7629 //w=0.367 //l=0.71 //layer=li \
 //thickness=0.1 //x=16.875 //y=7.585 //x2=16.165 //y2=7.585
r490 (  205 293 ) resistor r=4.23183 //w=0.7 //l=0.175 //layer=li \
 //thickness=0.1 //x=16.08 //y=7.41 //x2=16.08 //y2=7.585
r491 (  205 313 ) resistor r=56.4706 //w=0.187 //l=0.825 //layer=li \
 //thickness=0.1 //x=16.08 //y=7.41 //x2=16.08 //y2=6.585
r492 (  204 291 ) resistor r=5.29055 //w=0.35 //l=0.17 //layer=li \
 //thickness=0.1 //x=15.46 //y=7.585 //x2=15.29 //y2=7.585
r493 (  203 293 ) resistor r=2.87058 //w=0.35 //l=0.085 //layer=li \
 //thickness=0.1 //x=15.995 //y=7.585 //x2=16.08 //y2=7.585
r494 (  203 204 ) resistor r=18.6594 //w=0.367 //l=0.535 //layer=li \
 //thickness=0.1 //x=15.995 //y=7.585 //x2=15.46 //y2=7.585
r495 (  200 290 ) resistor r=2.87058 //w=0.35 //l=0.085 //layer=li \
 //thickness=0.1 //x=14.595 //y=7.585 //x2=14.51 //y2=7.585
r496 (  199 291 ) resistor r=5.29055 //w=0.35 //l=0.17 //layer=li \
 //thickness=0.1 //x=15.12 //y=7.585 //x2=15.29 //y2=7.585
r497 (  199 200 ) resistor r=18.3106 //w=0.367 //l=0.525 //layer=li \
 //thickness=0.1 //x=15.12 //y=7.585 //x2=14.595 //y2=7.585
r498 (  193 290 ) resistor r=4.23183 //w=0.7 //l=0.175 //layer=li \
 //thickness=0.1 //x=14.51 //y=7.41 //x2=14.51 //y2=7.585
r499 (  193 312 ) resistor r=33.1979 //w=0.187 //l=0.485 //layer=li \
 //thickness=0.1 //x=14.51 //y=7.41 //x2=14.51 //y2=6.925
r500 (  192 288 ) resistor r=2.87058 //w=0.35 //l=0.085 //layer=li \
 //thickness=0.1 //x=13.715 //y=7.585 //x2=13.63 //y2=7.585
r501 (  191 290 ) resistor r=2.87058 //w=0.35 //l=0.085 //layer=li \
 //thickness=0.1 //x=14.425 //y=7.585 //x2=14.51 //y2=7.585
r502 (  191 192 ) resistor r=24.7629 //w=0.367 //l=0.71 //layer=li \
 //thickness=0.1 //x=14.425 //y=7.585 //x2=13.715 //y2=7.585
r503 (  185 288 ) resistor r=4.23183 //w=0.7 //l=0.175 //layer=li \
 //thickness=0.1 //x=13.63 //y=7.41 //x2=13.63 //y2=7.585
r504 (  185 311 ) resistor r=33.1979 //w=0.187 //l=0.485 //layer=li \
 //thickness=0.1 //x=13.63 //y=7.41 //x2=13.63 //y2=6.925
r505 (  182 287 ) resistor r=2.87058 //w=0.35 //l=0.085 //layer=li \
 //thickness=0.1 //x=12.835 //y=7.585 //x2=12.75 //y2=7.585
r506 (  182 184 ) resistor r=21.1008 //w=0.367 //l=0.605 //layer=li \
 //thickness=0.1 //x=12.835 //y=7.585 //x2=13.44 //y2=7.585
r507 (  181 288 ) resistor r=2.87058 //w=0.35 //l=0.085 //layer=li \
 //thickness=0.1 //x=13.545 //y=7.585 //x2=13.63 //y2=7.585
r508 (  181 184 ) resistor r=3.66213 //w=0.367 //l=0.105 //layer=li \
 //thickness=0.1 //x=13.545 //y=7.585 //x2=13.44 //y2=7.585
r509 (  173 287 ) resistor r=4.23183 //w=0.7 //l=0.175 //layer=li \
 //thickness=0.1 //x=12.75 //y=7.41 //x2=12.75 //y2=7.585
r510 (  173 310 ) resistor r=56.4706 //w=0.187 //l=0.825 //layer=li \
 //thickness=0.1 //x=12.75 //y=7.41 //x2=12.75 //y2=6.585
r511 (  170 286 ) resistor r=5.29055 //w=0.35 //l=0.17 //layer=li \
 //thickness=0.1 //x=12.13 //y=7.585 //x2=11.96 //y2=7.585
r512 (  170 172 ) resistor r=6.97548 //w=0.367 //l=0.2 //layer=li \
 //thickness=0.1 //x=12.13 //y=7.585 //x2=12.33 //y2=7.585
r513 (  169 287 ) resistor r=2.87058 //w=0.35 //l=0.085 //layer=li \
 //thickness=0.1 //x=12.665 //y=7.585 //x2=12.75 //y2=7.585
r514 (  169 172 ) resistor r=11.6839 //w=0.367 //l=0.335 //layer=li \
 //thickness=0.1 //x=12.665 //y=7.585 //x2=12.33 //y2=7.585
r515 (  166 285 ) resistor r=2.87058 //w=0.35 //l=0.085 //layer=li \
 //thickness=0.1 //x=11.265 //y=7.585 //x2=11.18 //y2=7.585
r516 (  165 286 ) resistor r=5.29055 //w=0.35 //l=0.17 //layer=li \
 //thickness=0.1 //x=11.79 //y=7.585 //x2=11.96 //y2=7.585
r517 (  165 166 ) resistor r=18.3106 //w=0.367 //l=0.525 //layer=li \
 //thickness=0.1 //x=11.79 //y=7.585 //x2=11.265 //y2=7.585
r518 (  159 285 ) resistor r=4.23183 //w=0.7 //l=0.175 //layer=li \
 //thickness=0.1 //x=11.18 //y=7.41 //x2=11.18 //y2=7.585
r519 (  159 309 ) resistor r=33.1979 //w=0.187 //l=0.485 //layer=li \
 //thickness=0.1 //x=11.18 //y=7.41 //x2=11.18 //y2=6.925
r520 (  156 284 ) resistor r=2.87058 //w=0.35 //l=0.085 //layer=li \
 //thickness=0.1 //x=10.385 //y=7.585 //x2=10.3 //y2=7.585
r521 (  156 158 ) resistor r=16.218 //w=0.367 //l=0.465 //layer=li \
 //thickness=0.1 //x=10.385 //y=7.585 //x2=10.85 //y2=7.585
r522 (  155 285 ) resistor r=2.87058 //w=0.35 //l=0.085 //layer=li \
 //thickness=0.1 //x=11.095 //y=7.585 //x2=11.18 //y2=7.585
r523 (  155 158 ) resistor r=8.54496 //w=0.367 //l=0.245 //layer=li \
 //thickness=0.1 //x=11.095 //y=7.585 //x2=10.85 //y2=7.585
r524 (  149 284 ) resistor r=4.23183 //w=0.7 //l=0.175 //layer=li \
 //thickness=0.1 //x=10.3 //y=7.41 //x2=10.3 //y2=7.585
r525 (  149 308 ) resistor r=33.1979 //w=0.187 //l=0.485 //layer=li \
 //thickness=0.1 //x=10.3 //y=7.41 //x2=10.3 //y2=6.925
r526 (  146 283 ) resistor r=2.87058 //w=0.35 //l=0.085 //layer=li \
 //thickness=0.1 //x=9.505 //y=7.585 //x2=9.42 //y2=7.585
r527 (  146 148 ) resistor r=8.19619 //w=0.367 //l=0.235 //layer=li \
 //thickness=0.1 //x=9.505 //y=7.585 //x2=9.74 //y2=7.585
r528 (  145 284 ) resistor r=2.87058 //w=0.35 //l=0.085 //layer=li \
 //thickness=0.1 //x=10.215 //y=7.585 //x2=10.3 //y2=7.585
r529 (  145 148 ) resistor r=16.5668 //w=0.367 //l=0.475 //layer=li \
 //thickness=0.1 //x=10.215 //y=7.585 //x2=9.74 //y2=7.585
r530 (  137 283 ) resistor r=4.23183 //w=0.7 //l=0.175 //layer=li \
 //thickness=0.1 //x=9.42 //y=7.41 //x2=9.42 //y2=7.585
r531 (  137 307 ) resistor r=56.4706 //w=0.187 //l=0.825 //layer=li \
 //thickness=0.1 //x=9.42 //y=7.41 //x2=9.42 //y2=6.585
r532 (  136 282 ) resistor r=5.29055 //w=0.35 //l=0.17 //layer=li \
 //thickness=0.1 //x=8.8 //y=7.585 //x2=8.63 //y2=7.585
r533 (  135 283 ) resistor r=2.87058 //w=0.35 //l=0.085 //layer=li \
 //thickness=0.1 //x=9.335 //y=7.585 //x2=9.42 //y2=7.585
r534 (  135 136 ) resistor r=18.6594 //w=0.367 //l=0.535 //layer=li \
 //thickness=0.1 //x=9.335 //y=7.585 //x2=8.8 //y2=7.585
r535 (  130 281 ) resistor r=2.87058 //w=0.35 //l=0.085 //layer=li \
 //thickness=0.1 //x=7.935 //y=7.585 //x2=7.85 //y2=7.585
r536 (  130 132 ) resistor r=11.3351 //w=0.367 //l=0.325 //layer=li \
 //thickness=0.1 //x=7.935 //y=7.585 //x2=8.26 //y2=7.585
r537 (  129 282 ) resistor r=5.29055 //w=0.35 //l=0.17 //layer=li \
 //thickness=0.1 //x=8.46 //y=7.585 //x2=8.63 //y2=7.585
r538 (  129 132 ) resistor r=6.97548 //w=0.367 //l=0.2 //layer=li \
 //thickness=0.1 //x=8.46 //y=7.585 //x2=8.26 //y2=7.585
r539 (  123 281 ) resistor r=4.23183 //w=0.7 //l=0.175 //layer=li \
 //thickness=0.1 //x=7.85 //y=7.41 //x2=7.85 //y2=7.585
r540 (  123 306 ) resistor r=33.1979 //w=0.187 //l=0.485 //layer=li \
 //thickness=0.1 //x=7.85 //y=7.41 //x2=7.85 //y2=6.925
r541 (  120 280 ) resistor r=2.87058 //w=0.35 //l=0.085 //layer=li \
 //thickness=0.1 //x=7.055 //y=7.585 //x2=6.97 //y2=7.585
r542 (  120 122 ) resistor r=3.31335 //w=0.367 //l=0.095 //layer=li \
 //thickness=0.1 //x=7.055 //y=7.585 //x2=7.15 //y2=7.585
r543 (  119 281 ) resistor r=2.87058 //w=0.35 //l=0.085 //layer=li \
 //thickness=0.1 //x=7.765 //y=7.585 //x2=7.85 //y2=7.585
r544 (  119 122 ) resistor r=21.4496 //w=0.367 //l=0.615 //layer=li \
 //thickness=0.1 //x=7.765 //y=7.585 //x2=7.15 //y2=7.585
r545 (  113 280 ) resistor r=4.23183 //w=0.7 //l=0.175 //layer=li \
 //thickness=0.1 //x=6.97 //y=7.41 //x2=6.97 //y2=7.585
r546 (  113 305 ) resistor r=33.1979 //w=0.187 //l=0.485 //layer=li \
 //thickness=0.1 //x=6.97 //y=7.41 //x2=6.97 //y2=6.925
r547 (  112 279 ) resistor r=2.87058 //w=0.35 //l=0.085 //layer=li \
 //thickness=0.1 //x=6.175 //y=7.585 //x2=6.09 //y2=7.585
r548 (  111 280 ) resistor r=2.87058 //w=0.35 //l=0.085 //layer=li \
 //thickness=0.1 //x=6.885 //y=7.585 //x2=6.97 //y2=7.585
r549 (  111 112 ) resistor r=24.7629 //w=0.367 //l=0.71 //layer=li \
 //thickness=0.1 //x=6.885 //y=7.585 //x2=6.175 //y2=7.585
r550 (  103 279 ) resistor r=4.23183 //w=0.7 //l=0.175 //layer=li \
 //thickness=0.1 //x=6.09 //y=7.41 //x2=6.09 //y2=7.585
r551 (  103 304 ) resistor r=56.4706 //w=0.187 //l=0.825 //layer=li \
 //thickness=0.1 //x=6.09 //y=7.41 //x2=6.09 //y2=6.585
r552 (  102 277 ) resistor r=5.29055 //w=0.35 //l=0.17 //layer=li \
 //thickness=0.1 //x=5.47 //y=7.585 //x2=5.3 //y2=7.585
r553 (  101 279 ) resistor r=2.87058 //w=0.35 //l=0.085 //layer=li \
 //thickness=0.1 //x=6.005 //y=7.585 //x2=6.09 //y2=7.585
r554 (  101 102 ) resistor r=18.6594 //w=0.367 //l=0.535 //layer=li \
 //thickness=0.1 //x=6.005 //y=7.585 //x2=5.47 //y2=7.585
r555 (  96 276 ) resistor r=2.87058 //w=0.35 //l=0.085 //layer=li \
 //thickness=0.1 //x=4.305 //y=7.585 //x2=4.22 //y2=7.585
r556 (  96 98 ) resistor r=8.89373 //w=0.367 //l=0.255 //layer=li \
 //thickness=0.1 //x=4.305 //y=7.585 //x2=4.56 //y2=7.585
r557 (  95 277 ) resistor r=5.29055 //w=0.35 //l=0.17 //layer=li \
 //thickness=0.1 //x=5.13 //y=7.585 //x2=5.3 //y2=7.585
r558 (  95 98 ) resistor r=19.8801 //w=0.367 //l=0.57 //layer=li \
 //thickness=0.1 //x=5.13 //y=7.585 //x2=4.56 //y2=7.585
r559 (  89 276 ) resistor r=4.23183 //w=0.7 //l=0.175 //layer=li \
 //thickness=0.1 //x=4.22 //y=7.41 //x2=4.22 //y2=7.585
r560 (  89 303 ) resistor r=33.1979 //w=0.187 //l=0.485 //layer=li \
 //thickness=0.1 //x=4.22 //y=7.41 //x2=4.22 //y2=6.925
r561 (  86 275 ) resistor r=2.87058 //w=0.35 //l=0.085 //layer=li \
 //thickness=0.1 //x=3.425 //y=7.585 //x2=3.34 //y2=7.585
r562 (  86 88 ) resistor r=0.871935 //w=0.367 //l=0.025 //layer=li \
 //thickness=0.1 //x=3.425 //y=7.585 //x2=3.45 //y2=7.585
r563 (  85 276 ) resistor r=2.87058 //w=0.35 //l=0.085 //layer=li \
 //thickness=0.1 //x=4.135 //y=7.585 //x2=4.22 //y2=7.585
r564 (  85 88 ) resistor r=23.891 //w=0.367 //l=0.685 //layer=li \
 //thickness=0.1 //x=4.135 //y=7.585 //x2=3.45 //y2=7.585
r565 (  79 275 ) resistor r=4.23183 //w=0.7 //l=0.175 //layer=li \
 //thickness=0.1 //x=3.34 //y=7.41 //x2=3.34 //y2=7.585
r566 (  79 302 ) resistor r=33.1979 //w=0.187 //l=0.485 //layer=li \
 //thickness=0.1 //x=3.34 //y=7.41 //x2=3.34 //y2=6.925
r567 (  78 274 ) resistor r=2.87058 //w=0.35 //l=0.085 //layer=li \
 //thickness=0.1 //x=2.545 //y=7.585 //x2=2.46 //y2=7.585
r568 (  77 275 ) resistor r=2.87058 //w=0.35 //l=0.085 //layer=li \
 //thickness=0.1 //x=3.255 //y=7.585 //x2=3.34 //y2=7.585
r569 (  77 78 ) resistor r=24.7629 //w=0.367 //l=0.71 //layer=li \
 //thickness=0.1 //x=3.255 //y=7.585 //x2=2.545 //y2=7.585
r570 (  71 274 ) resistor r=4.23183 //w=0.7 //l=0.175 //layer=li \
 //thickness=0.1 //x=2.46 //y=7.41 //x2=2.46 //y2=7.585
r571 (  71 301 ) resistor r=33.1979 //w=0.187 //l=0.485 //layer=li \
 //thickness=0.1 //x=2.46 //y=7.41 //x2=2.46 //y2=6.925
r572 (  68 273 ) resistor r=2.87058 //w=0.35 //l=0.085 //layer=li \
 //thickness=0.1 //x=1.665 //y=7.585 //x2=1.58 //y2=7.585
r573 (  68 70 ) resistor r=23.5422 //w=0.367 //l=0.675 //layer=li \
 //thickness=0.1 //x=1.665 //y=7.585 //x2=2.34 //y2=7.585
r574 (  67 274 ) resistor r=2.87058 //w=0.35 //l=0.085 //layer=li \
 //thickness=0.1 //x=2.375 //y=7.585 //x2=2.46 //y2=7.585
r575 (  67 70 ) resistor r=1.22071 //w=0.367 //l=0.035 //layer=li \
 //thickness=0.1 //x=2.375 //y=7.585 //x2=2.34 //y2=7.585
r576 (  59 273 ) resistor r=4.23183 //w=0.7 //l=0.175 //layer=li \
 //thickness=0.1 //x=1.58 //y=7.41 //x2=1.58 //y2=7.585
r577 (  59 300 ) resistor r=56.4706 //w=0.187 //l=0.825 //layer=li \
 //thickness=0.1 //x=1.58 //y=7.41 //x2=1.58 //y2=6.585
r578 (  55 273 ) resistor r=2.87058 //w=0.35 //l=0.085 //layer=li \
 //thickness=0.1 //x=1.495 //y=7.585 //x2=1.58 //y2=7.585
r579 (  55 58 ) resistor r=9.24251 //w=0.367 //l=0.265 //layer=li \
 //thickness=0.1 //x=1.495 //y=7.585 //x2=1.23 //y2=7.585
r580 (  39 270 ) resistor r=9.3 //w=0.17 //l=0.17 //layer=mcon //count=1 \
 //x=21.58 //y=7.58 //x2=21.58 //y2=7.58
r581 (  37 260 ) resistor r=3.1 //w=0.17 //l=0.51 //layer=mcon //count=3 \
 //x=20.84 //y=7.58 //x2=20.84 //y2=7.58
r582 (  37 39 ) resistor r=0.297428 //w=0.311 //l=0.74 //layer=m1 \
 //thickness=0.36 //x=20.84 //y=7.585 //x2=21.58 //y2=7.585
r583 (  35 250 ) resistor r=3.1 //w=0.17 //l=0.51 //layer=mcon //count=3 \
 //x=19.73 //y=7.58 //x2=19.73 //y2=7.58
r584 (  35 37 ) resistor r=0.446141 //w=0.311 //l=1.11 //layer=m1 \
 //thickness=0.36 //x=19.73 //y=7.585 //x2=20.84 //y2=7.585
r585 (  33 234 ) resistor r=3.1 //w=0.17 //l=0.51 //layer=mcon //count=3 \
 //x=18.25 //y=7.58 //x2=18.25 //y2=7.58
r586 (  33 35 ) resistor r=0.594855 //w=0.311 //l=1.48 //layer=m1 \
 //thickness=0.36 //x=18.25 //y=7.585 //x2=19.73 //y2=7.585
r587 (  31 224 ) resistor r=3.1 //w=0.17 //l=0.51 //layer=mcon //count=3 \
 //x=17.14 //y=7.58 //x2=17.14 //y2=7.58
r588 (  31 33 ) resistor r=0.446141 //w=0.311 //l=1.11 //layer=m1 \
 //thickness=0.36 //x=17.14 //y=7.585 //x2=18.25 //y2=7.585
r589 (  29 293 ) resistor r=3.1 //w=0.17 //l=0.51 //layer=mcon //count=3 \
 //x=16.03 //y=7.58 //x2=16.03 //y2=7.58
r590 (  29 31 ) resistor r=0.446141 //w=0.311 //l=1.11 //layer=m1 \
 //thickness=0.36 //x=16.03 //y=7.585 //x2=17.14 //y2=7.585
r591 (  27 290 ) resistor r=3.1 //w=0.17 //l=0.51 //layer=mcon //count=3 \
 //x=14.55 //y=7.58 //x2=14.55 //y2=7.58
r592 (  27 29 ) resistor r=0.594855 //w=0.311 //l=1.48 //layer=m1 \
 //thickness=0.36 //x=14.55 //y=7.585 //x2=16.03 //y2=7.585
r593 (  25 184 ) resistor r=3.1 //w=0.17 //l=0.51 //layer=mcon //count=3 \
 //x=13.44 //y=7.58 //x2=13.44 //y2=7.58
r594 (  25 27 ) resistor r=0.446141 //w=0.311 //l=1.11 //layer=m1 \
 //thickness=0.36 //x=13.44 //y=7.585 //x2=14.55 //y2=7.585
r595 (  23 172 ) resistor r=3.1 //w=0.17 //l=0.51 //layer=mcon //count=3 \
 //x=12.33 //y=7.58 //x2=12.33 //y2=7.58
r596 (  23 25 ) resistor r=0.446141 //w=0.311 //l=1.11 //layer=m1 \
 //thickness=0.36 //x=12.33 //y=7.585 //x2=13.44 //y2=7.585
r597 (  20 158 ) resistor r=3.1 //w=0.17 //l=0.51 //layer=mcon //count=3 \
 //x=10.85 //y=7.58 //x2=10.85 //y2=7.58
r598 (  18 148 ) resistor r=3.1 //w=0.17 //l=0.51 //layer=mcon //count=3 \
 //x=9.74 //y=7.58 //x2=9.74 //y2=7.58
r599 (  18 20 ) resistor r=0.446141 //w=0.311 //l=1.11 //layer=m1 \
 //thickness=0.36 //x=9.74 //y=7.585 //x2=10.85 //y2=7.585
r600 (  16 132 ) resistor r=3.1 //w=0.17 //l=0.51 //layer=mcon //count=3 \
 //x=8.26 //y=7.58 //x2=8.26 //y2=7.58
r601 (  16 18 ) resistor r=0.594855 //w=0.311 //l=1.48 //layer=m1 \
 //thickness=0.36 //x=8.26 //y=7.585 //x2=9.74 //y2=7.585
r602 (  14 122 ) resistor r=3.1 //w=0.17 //l=0.51 //layer=mcon //count=3 \
 //x=7.15 //y=7.58 //x2=7.15 //y2=7.58
r603 (  14 16 ) resistor r=0.446141 //w=0.311 //l=1.11 //layer=m1 \
 //thickness=0.36 //x=7.15 //y=7.585 //x2=8.26 //y2=7.585
r604 (  12 279 ) resistor r=3.1 //w=0.17 //l=0.51 //layer=mcon //count=3 \
 //x=6.04 //y=7.58 //x2=6.04 //y2=7.58
r605 (  12 14 ) resistor r=0.446141 //w=0.311 //l=1.11 //layer=m1 \
 //thickness=0.36 //x=6.04 //y=7.585 //x2=7.15 //y2=7.585
r606 (  10 98 ) resistor r=3.1 //w=0.17 //l=0.51 //layer=mcon //count=3 \
 //x=4.56 //y=7.58 //x2=4.56 //y2=7.58
r607 (  10 12 ) resistor r=0.594855 //w=0.311 //l=1.48 //layer=m1 \
 //thickness=0.36 //x=4.56 //y=7.585 //x2=6.04 //y2=7.585
r608 (  8 88 ) resistor r=3.1 //w=0.17 //l=0.51 //layer=mcon //count=3 \
 //x=3.45 //y=7.58 //x2=3.45 //y2=7.58
r609 (  8 10 ) resistor r=0.446141 //w=0.311 //l=1.11 //layer=m1 \
 //thickness=0.36 //x=3.45 //y=7.585 //x2=4.56 //y2=7.585
r610 (  6 70 ) resistor r=3.1 //w=0.17 //l=0.51 //layer=mcon //count=3 \
 //x=2.34 //y=7.58 //x2=2.34 //y2=7.58
r611 (  6 8 ) resistor r=0.446141 //w=0.311 //l=1.11 //layer=m1 \
 //thickness=0.36 //x=2.34 //y=7.585 //x2=3.45 //y2=7.585
r612 (  3 58 ) resistor r=3.1 //w=0.17 //l=0.51 //layer=mcon //count=3 \
 //x=1.23 //y=7.58 //x2=1.23 //y2=7.58
r613 (  3 6 ) resistor r=0.446141 //w=0.311 //l=1.11 //layer=m1 \
 //thickness=0.36 //x=1.23 //y=7.585 //x2=2.34 //y2=7.585
r614 (  1 23 ) resistor r=0.446141 //w=0.311 //l=1.11 //layer=m1 \
 //thickness=0.36 //x=11.22 //y=7.585 //x2=12.33 //y2=7.585
r615 (  1 20 ) resistor r=0.148714 //w=0.311 //l=0.37 //layer=m1 \
 //thickness=0.36 //x=11.22 //y=7.585 //x2=10.85 //y2=7.585
ends PM_DFFX1\%VDD

subckt PM_DFFX1\%noxref_9 ( 5 7 15 19 30 33 34 )
c64 ( 34 0 ) capacitor c=0.0486635f //x=3.455 //y=0.555
c65 ( 33 0 ) capacitor c=0.0198746f //x=2.35 //y=1.09
c66 ( 30 0 ) capacitor c=0.00141302f //x=3.59 //y=1.175
c67 ( 19 0 ) capacitor c=0.00695768f //x=4.56 //y=0.805
c68 ( 15 0 ) capacitor c=0.0154966f //x=4.475 //y=0.72
c69 ( 7 0 ) capacitor c=0.00689476f //x=3.59 //y=0.805
c70 ( 5 0 ) capacitor c=0.0290436f //x=3.505 //y=1.175
r71 (  19 34 ) resistor r=3.57586 //w=0.17 //l=0.125 //layer=li \
 //thickness=0.1 //x=4.56 //y=0.805 //x2=4.56 //y2=0.68
r72 (  19 34 ) resistor r=18.139 //w=0.187 //l=0.265 //layer=li \
 //thickness=0.1 //x=4.56 //y=0.805 //x2=4.56 //y2=1.07
r73 (  16 34 ) resistor r=3.57586 //w=0.17 //l=0.103078 //layer=li \
 //thickness=0.1 //x=3.675 //y=0.72 //x2=3.59 //y2=0.68
r74 (  16 34 ) resistor r=27.3797 //w=0.187 //l=0.4 //layer=li //thickness=0.1 \
 //x=3.675 //y=0.72 //x2=4.075 //y2=0.72
r75 (  15 34 ) resistor r=3.57586 //w=0.17 //l=0.103078 //layer=li \
 //thickness=0.1 //x=4.475 //y=0.72 //x2=4.56 //y2=0.68
r76 (  15 34 ) resistor r=27.3797 //w=0.187 //l=0.4 //layer=li //thickness=0.1 \
 //x=4.475 //y=0.72 //x2=4.075 //y2=0.72
r77 (  11 30 ) resistor r=5.4201 //w=0.17 //l=0.085 //layer=li //thickness=0.1 \
 //x=3.59 //y=1.26 //x2=3.59 //y2=1.175
r78 (  11 34 ) resistor r=10.2674 //w=0.187 //l=0.15 //layer=li \
 //thickness=0.1 //x=3.59 //y=1.26 //x2=3.59 //y2=1.41
r79 (  8 30 ) resistor r=5.4201 //w=0.17 //l=0.085 //layer=li //thickness=0.1 \
 //x=3.59 //y=1.09 //x2=3.59 //y2=1.175
r80 (  8 34 ) resistor r=1.36898 //w=0.187 //l=0.02 //layer=li //thickness=0.1 \
 //x=3.59 //y=1.09 //x2=3.59 //y2=1.07
r81 (  7 34 ) resistor r=3.57586 //w=0.17 //l=0.125 //layer=li //thickness=0.1 \
 //x=3.59 //y=0.805 //x2=3.59 //y2=0.68
r82 (  7 34 ) resistor r=18.139 //w=0.187 //l=0.265 //layer=li //thickness=0.1 \
 //x=3.59 //y=0.805 //x2=3.59 //y2=1.07
r83 (  6 33 ) resistor r=0.751729 //w=0.17 //l=0.085 //layer=li \
 //thickness=0.1 //x=2.625 //y=1.175 //x2=2.54 //y2=1.175
r84 (  5 30 ) resistor r=1.40859 //w=0.34 //l=0.085 //layer=li //thickness=0.1 \
 //x=3.505 //y=1.175 //x2=3.59 //y2=1.175
r85 (  5 6 ) resistor r=60.2353 //w=0.187 //l=0.88 //layer=li //thickness=0.1 \
 //x=3.505 //y=1.175 //x2=2.625 //y2=1.175
ends PM_DFFX1\%noxref_9

subckt PM_DFFX1\%D ( 1 2 3 5 10 16 21 25 26 27 28 29 30 35 37 39 45 46 48 49 \
 52 )
c115 ( 52 0 ) capacitor c=0.0393541f //x=7.18 //y=4.88
c116 ( 49 0 ) capacitor c=0.0284095f //x=7.15 //y=2.095
c117 ( 48 0 ) capacitor c=0.0476356f //x=7.15 //y=2.26
c118 ( 46 0 ) capacitor c=0.0439708f //x=7.715 //y=1.43
c119 ( 45 0 ) capacitor c=0.0192582f //x=7.715 //y=1.085
c120 ( 39 0 ) capacitor c=0.0162526f //x=7.56 //y=1.585
c121 ( 37 0 ) capacitor c=0.0157807f //x=7.56 //y=0.93
c122 ( 35 0 ) capacitor c=0.0372668f //x=7.555 //y=4.97
c123 ( 30 0 ) capacitor c=0.0210762f //x=7.185 //y=1.74
c124 ( 29 0 ) capacitor c=0.0168511f //x=7.185 //y=1.43
c125 ( 28 0 ) capacitor c=0.0175485f //x=7.185 //y=1.085
c126 ( 27 0 ) capacitor c=0.155269f //x=7.63 //y=6.2
c127 ( 26 0 ) capacitor c=0.110375f //x=7.19 //y=6.2
c128 ( 21 0 ) capacitor c=8.90417e-19 //x=7.18 //y=4.88
c129 ( 16 0 ) capacitor c=7.72439e-19 //x=7.15 //y=2.26
c130 ( 10 0 ) capacitor c=0.00706019f //x=7.15 //y=2.26
c131 ( 5 0 ) capacitor c=0.00487504f //x=7.15 //y=4.735
c132 ( 1 0 ) capacitor c=0.0504672f //x=7.15 //y=2.4
r133 (  54 55 ) resistor r=32.4568 //w=0.214 //l=0.075 //layer=ply \
 //thickness=0.18 //x=7.18 //y=4.97 //x2=7.18 //y2=5.045
r134 (  52 54 ) resistor r=20.271 //w=0.214 //l=0.09 //layer=ply \
 //thickness=0.18 //x=7.18 //y=4.88 //x2=7.18 //y2=4.97
r135 (  48 49 ) resistor r=52.7279 //w=0.214 //l=0.165 //layer=ply \
 //thickness=0.18 //x=7.15 //y=2.26 //x2=7.15 //y2=2.095
r136 (  46 59 ) resistor r=45.1352 //w=0.168 //l=0.173853 //layer=ply \
 //thickness=0.18 //x=7.715 //y=1.43 //x2=7.675 //y2=1.585
r137 (  45 58 ) resistor r=45.1352 //w=0.168 //l=0.173853 //layer=ply \
 //thickness=0.18 //x=7.715 //y=1.085 //x2=7.675 //y2=0.93
r138 (  45 46 ) resistor r=176.904 //w=0.094 //l=0.345 //layer=ply \
 //thickness=0.18 //x=7.715 //y=1.085 //x2=7.715 //y2=1.43
r139 (  40 57 ) resistor r=10.701 //w=0.21 //l=0.115 //layer=ply \
 //thickness=0.18 //x=7.34 //y=1.585 //x2=7.225 //y2=1.585
r140 (  39 59 ) resistor r=5.52526 //w=0.168 //l=0.115 //layer=ply \
 //thickness=0.18 //x=7.56 //y=1.585 //x2=7.675 //y2=1.585
r141 (  38 56 ) resistor r=5.52526 //w=0.168 //l=0.115 //layer=ply \
 //thickness=0.18 //x=7.34 //y=0.93 //x2=7.225 //y2=0.93
r142 (  37 58 ) resistor r=5.52526 //w=0.168 //l=0.115 //layer=ply \
 //thickness=0.18 //x=7.56 //y=0.93 //x2=7.675 //y2=0.93
r143 (  37 38 ) resistor r=112.809 //w=0.094 //l=0.22 //layer=ply \
 //thickness=0.18 //x=7.56 //y=0.93 //x2=7.34 //y2=0.93
r144 (  36 54 ) resistor r=16.5046 //w=0.27 //l=0.135 //layer=ply \
 //thickness=0.18 //x=7.315 //y=4.97 //x2=7.18 //y2=4.97
r145 (  35 42 ) resistor r=26.9307 //w=0.15 //l=0.106066 //layer=ply \
 //thickness=0.18 //x=7.555 //y=4.97 //x2=7.63 //y2=5.045
r146 (  35 36 ) resistor r=123.064 //w=0.094 //l=0.24 //layer=ply \
 //thickness=0.18 //x=7.555 //y=4.97 //x2=7.315 //y2=4.97
r147 (  30 57 ) resistor r=39.5823 //w=0.21 //l=0.173853 //layer=ply \
 //thickness=0.18 //x=7.185 //y=1.74 //x2=7.225 //y2=1.585
r148 (  30 49 ) resistor r=182.032 //w=0.094 //l=0.355 //layer=ply \
 //thickness=0.18 //x=7.185 //y=1.74 //x2=7.185 //y2=2.095
r149 (  29 57 ) resistor r=39.5823 //w=0.21 //l=0.173853 //layer=ply \
 //thickness=0.18 //x=7.185 //y=1.43 //x2=7.225 //y2=1.585
r150 (  28 56 ) resistor r=45.1352 //w=0.168 //l=0.173853 //layer=ply \
 //thickness=0.18 //x=7.185 //y=1.085 //x2=7.225 //y2=0.93
r151 (  28 29 ) resistor r=176.904 //w=0.094 //l=0.345 //layer=ply \
 //thickness=0.18 //x=7.185 //y=1.085 //x2=7.185 //y2=1.43
r152 (  27 42 ) resistor r=592.245 //w=0.094 //l=1.155 //layer=ply \
 //thickness=0.18 //x=7.63 //y=6.2 //x2=7.63 //y2=5.045
r153 (  26 55 ) resistor r=592.245 //w=0.094 //l=1.155 //layer=ply \
 //thickness=0.18 //x=7.19 //y=6.2 //x2=7.19 //y2=5.045
r154 (  25 39 ) resistor r=56.4043 //w=0.094 //l=0.11 //layer=ply \
 //thickness=0.18 //x=7.45 //y=1.585 //x2=7.56 //y2=1.585
r155 (  25 40 ) resistor r=56.4043 //w=0.094 //l=0.11 //layer=ply \
 //thickness=0.18 //x=7.45 //y=1.585 //x2=7.34 //y2=1.585
r156 (  21 52 ) resistor r=152 //w=0.17 //l=0.17 //layer=licon //count=1 \
 //x=7.18 //y=4.88 //x2=7.18 //y2=4.88
r157 (  16 48 ) resistor r=152 //w=0.17 //l=0.17 //layer=licon //count=1 \
 //x=7.15 //y=2.26 //x2=7.15 //y2=2.26
r158 (  14 21 ) resistor r=9.3 //w=0.17 //l=0.17 //layer=mcon //count=1 \
 //x=7.18 //y=4.88 //x2=7.18 //y2=4.88
r159 (  10 16 ) resistor r=9.3 //w=0.17 //l=0.17 //layer=mcon //count=1 \
 //x=7.15 //y=2.26 //x2=7.15 //y2=2.26
r160 (  10 12 ) resistor r=0.0936408 //w=0.196 //l=0.125 //layer=m1 \
 //thickness=0.36 //x=7.152 //y=2.26 //x2=7.152 //y2=2.385
r161 (  5 14 ) resistor r=0.0878548 //w=0.228 //l=0.159295 //layer=m1 \
 //thickness=0.36 //x=7.15 //y=4.735 //x2=7.18 //y2=4.88
r162 (  3 5 ) resistor r=1.52195 //w=0.131 //l=1.595 //layer=m1 \
 //thickness=0.36 //x=7.15 //y=3.14 //x2=7.15 //y2=4.735
r163 (  2 3 ) resistor r=0.353053 //w=0.131 //l=0.37 //layer=m1 \
 //thickness=0.36 //x=7.15 //y=2.77 //x2=7.15 //y2=3.14
r164 (  1 2 ) resistor r=0.353053 //w=0.131 //l=0.37 //layer=m1 \
 //thickness=0.36 //x=7.15 //y=2.4 //x2=7.15 //y2=2.77
r165 (  1 12 ) resistor r=0.014313 //w=0.131 //l=0.015 //layer=m1 \
 //thickness=0.36 //x=7.15 //y=2.4 //x2=7.15 //y2=2.385
ends PM_DFFX1\%D

subckt PM_DFFX1\%GND ( 1 2 6 7 19 27 36 46 58 61 65 66 70 71 76 77 81 82 86 87 \
 93 96 110 125 138 153 175 183 184 185 186 187 188 189 190 191 192 193 )
c424 ( 193 0 ) capacitor c=0.00843555f //x=19.61 //y=1.045
c425 ( 192 0 ) capacitor c=0.00843555f //x=16.28 //y=1.045
c426 ( 191 0 ) capacitor c=0.00843555f //x=12.95 //y=1.045
c427 ( 190 0 ) capacitor c=0.00843555f //x=9.62 //y=1.045
c428 ( 189 0 ) capacitor c=0.00843555f //x=6.29 //y=1.045
c429 ( 188 0 ) capacitor c=0.00840423f //x=1.375 //y=1.055
c430 ( 187 0 ) capacitor c=0.117691f //x=18.62 //y=0.175
c431 ( 186 0 ) capacitor c=0.11793f //x=15.29 //y=0.175
c432 ( 185 0 ) capacitor c=0.117691f //x=11.96 //y=0.175
c433 ( 184 0 ) capacitor c=0.117691f //x=8.63 //y=0.175
c434 ( 183 0 ) capacitor c=0.118861f //x=5.3 //y=0.175
c435 ( 175 0 ) capacitor c=0.335491f //x=21.58 //y=0.18
c436 ( 153 0 ) capacitor c=0.125256f //x=18.45 //y=0.175
c437 ( 138 0 ) capacitor c=0.126434f //x=15.12 //y=0.175
c438 ( 125 0 ) capacitor c=0.125256f //x=11.79 //y=0.175
c439 ( 110 0 ) capacitor c=0.126356f //x=8.46 //y=0.175
c440 ( 96 0 ) capacitor c=0.197064f //x=1.23 //y=0.18
c441 ( 93 0 ) capacitor c=0.181445f //x=5.13 //y=0.175
c442 ( 90 0 ) capacitor c=0.00509083f //x=19.73 //y=0.18
c443 ( 87 0 ) capacitor c=0.0232551f //x=19.797 //y=1.005
c444 ( 86 0 ) capacitor c=0.012916f //x=19.8 //y=1.135
c445 ( 84 0 ) capacitor c=0.00509083f //x=16.47 //y=0.175
c446 ( 82 0 ) capacitor c=0.0188922f //x=16.467 //y=1.005
c447 ( 81 0 ) capacitor c=0.0127521f //x=16.47 //y=1.135
c448 ( 79 0 ) capacitor c=0.00509083f //x=13.14 //y=0.175
c449 ( 77 0 ) capacitor c=0.0188922f //x=13.137 //y=1.005
c450 ( 76 0 ) capacitor c=0.0127968f //x=13.14 //y=1.135
c451 ( 74 0 ) capacitor c=0.00509083f //x=9.74 //y=0.18
c452 ( 71 0 ) capacitor c=0.0188922f //x=9.807 //y=1.005
c453 ( 70 0 ) capacitor c=0.0127973f //x=9.81 //y=1.135
c454 ( 68 0 ) capacitor c=0.00509083f //x=6.48 //y=0.175
c455 ( 66 0 ) capacitor c=0.0235363f //x=6.477 //y=1.005
c456 ( 65 0 ) capacitor c=0.0138363f //x=6.48 //y=1.135
c457 ( 63 0 ) capacitor c=0.00509414f //x=1.565 //y=0.175
c458 ( 61 0 ) capacitor c=0.017081f //x=1.565 //y=1.145
c459 ( 58 0 ) capacitor c=0.102367f //x=21.58 //y=0.18
c460 ( 46 0 ) capacitor c=0.110954f //x=19.715 //y=0.175
c461 ( 36 0 ) capacitor c=0.112419f //x=16.385 //y=0.175
c462 ( 27 0 ) capacitor c=0.110896f //x=13.055 //y=0.175
c463 ( 19 0 ) capacitor c=0.112292f //x=9.725 //y=0.175
c464 ( 7 0 ) capacitor c=0.154867f //x=6.395 //y=0.175
c465 ( 6 0 ) capacitor c=0.0302305f //x=1.565 //y=1.015
c466 ( 2 0 ) capacitor c=0.0710427f //x=1.48 //y=0.175
r467 (  173 175 ) resistor r=25.8093 //w=0.367 //l=0.74 //layer=li \
 //thickness=0.1 //x=20.84 //y=0.175 //x2=21.58 //y2=0.175
r468 (  171 173 ) resistor r=38.7139 //w=0.367 //l=1.11 //layer=li \
 //thickness=0.1 //x=19.73 //y=0.175 //x2=20.84 //y2=0.175
r469 (  169 187 ) resistor r=5.29055 //w=0.35 //l=0.17 //layer=li \
 //thickness=0.1 //x=18.79 //y=0.175 //x2=18.62 //y2=0.175
r470 (  169 171 ) resistor r=32.7847 //w=0.367 //l=0.94 //layer=li \
 //thickness=0.1 //x=18.79 //y=0.175 //x2=19.73 //y2=0.175
r471 (  158 160 ) resistor r=38.7139 //w=0.367 //l=1.11 //layer=li \
 //thickness=0.1 //x=17.14 //y=0.175 //x2=18.25 //y2=0.175
r472 (  156 158 ) resistor r=38.7139 //w=0.367 //l=1.11 //layer=li \
 //thickness=0.1 //x=16.03 //y=0.175 //x2=17.14 //y2=0.175
r473 (  154 186 ) resistor r=5.29055 //w=0.35 //l=0.17 //layer=li \
 //thickness=0.1 //x=15.46 //y=0.175 //x2=15.29 //y2=0.175
r474 (  154 156 ) resistor r=19.8801 //w=0.367 //l=0.57 //layer=li \
 //thickness=0.1 //x=15.46 //y=0.175 //x2=16.03 //y2=0.175
r475 (  153 187 ) resistor r=5.29055 //w=0.35 //l=0.17 //layer=li \
 //thickness=0.1 //x=18.45 //y=0.175 //x2=18.62 //y2=0.175
r476 (  153 160 ) resistor r=6.97548 //w=0.367 //l=0.2 //layer=li \
 //thickness=0.1 //x=18.45 //y=0.175 //x2=18.25 //y2=0.175
r477 (  143 145 ) resistor r=38.7139 //w=0.367 //l=1.11 //layer=li \
 //thickness=0.1 //x=13.44 //y=0.175 //x2=14.55 //y2=0.175
r478 (  141 143 ) resistor r=38.7139 //w=0.367 //l=1.11 //layer=li \
 //thickness=0.1 //x=12.33 //y=0.175 //x2=13.44 //y2=0.175
r479 (  139 185 ) resistor r=5.29055 //w=0.35 //l=0.17 //layer=li \
 //thickness=0.1 //x=12.13 //y=0.175 //x2=11.96 //y2=0.175
r480 (  139 141 ) resistor r=6.97548 //w=0.367 //l=0.2 //layer=li \
 //thickness=0.1 //x=12.13 //y=0.175 //x2=12.33 //y2=0.175
r481 (  138 186 ) resistor r=5.29055 //w=0.35 //l=0.17 //layer=li \
 //thickness=0.1 //x=15.12 //y=0.175 //x2=15.29 //y2=0.175
r482 (  138 145 ) resistor r=19.8801 //w=0.367 //l=0.57 //layer=li \
 //thickness=0.1 //x=15.12 //y=0.175 //x2=14.55 //y2=0.175
r483 (  128 130 ) resistor r=38.7139 //w=0.367 //l=1.11 //layer=li \
 //thickness=0.1 //x=9.74 //y=0.175 //x2=10.85 //y2=0.175
r484 (  126 184 ) resistor r=5.29055 //w=0.35 //l=0.17 //layer=li \
 //thickness=0.1 //x=8.8 //y=0.175 //x2=8.63 //y2=0.175
r485 (  126 128 ) resistor r=32.7847 //w=0.367 //l=0.94 //layer=li \
 //thickness=0.1 //x=8.8 //y=0.175 //x2=9.74 //y2=0.175
r486 (  125 185 ) resistor r=5.29055 //w=0.35 //l=0.17 //layer=li \
 //thickness=0.1 //x=11.79 //y=0.175 //x2=11.96 //y2=0.175
r487 (  125 130 ) resistor r=32.7847 //w=0.367 //l=0.94 //layer=li \
 //thickness=0.1 //x=11.79 //y=0.175 //x2=10.85 //y2=0.175
r488 (  115 117 ) resistor r=38.7139 //w=0.367 //l=1.11 //layer=li \
 //thickness=0.1 //x=7.15 //y=0.175 //x2=8.26 //y2=0.175
r489 (  113 115 ) resistor r=38.7139 //w=0.367 //l=1.11 //layer=li \
 //thickness=0.1 //x=6.04 //y=0.175 //x2=7.15 //y2=0.175
r490 (  111 183 ) resistor r=5.29055 //w=0.35 //l=0.17 //layer=li \
 //thickness=0.1 //x=5.47 //y=0.175 //x2=5.3 //y2=0.175
r491 (  111 113 ) resistor r=19.8801 //w=0.367 //l=0.57 //layer=li \
 //thickness=0.1 //x=5.47 //y=0.175 //x2=6.04 //y2=0.175
r492 (  110 184 ) resistor r=5.29055 //w=0.35 //l=0.17 //layer=li \
 //thickness=0.1 //x=8.46 //y=0.175 //x2=8.63 //y2=0.175
r493 (  110 117 ) resistor r=6.97548 //w=0.367 //l=0.2 //layer=li \
 //thickness=0.1 //x=8.46 //y=0.175 //x2=8.26 //y2=0.175
r494 (  100 102 ) resistor r=38.7139 //w=0.367 //l=1.11 //layer=li \
 //thickness=0.1 //x=3.45 //y=0.175 //x2=4.56 //y2=0.175
r495 (  98 100 ) resistor r=38.7139 //w=0.367 //l=1.11 //layer=li \
 //thickness=0.1 //x=2.34 //y=0.175 //x2=3.45 //y2=0.175
r496 (  96 98 ) resistor r=38.7139 //w=0.367 //l=1.11 //layer=li \
 //thickness=0.1 //x=1.23 //y=0.175 //x2=2.34 //y2=0.175
r497 (  93 183 ) resistor r=5.29055 //w=0.35 //l=0.17 //layer=li \
 //thickness=0.1 //x=5.13 //y=0.175 //x2=5.3 //y2=0.175
r498 (  93 102 ) resistor r=19.8801 //w=0.367 //l=0.57 //layer=li \
 //thickness=0.1 //x=5.13 //y=0.175 //x2=4.56 //y2=0.175
r499 (  90 171 ) resistor r=3.1 //w=0.17 //l=0.51 //layer=mcon //count=3 \
 //x=19.73 //y=0.18 //x2=19.73 //y2=0.18
r500 (  86 193 ) resistor r=9.3 //w=0.17 //l=0.17 //layer=mcon //count=1 \
 //x=19.8 //y=1.135 //x2=19.8 //y2=1.135
r501 (  86 87 ) resistor r=0.0939994 //w=0.226 //l=0.13 //layer=m1 \
 //thickness=0.36 //x=19.797 //y=1.135 //x2=19.797 //y2=1.005
r502 (  81 192 ) resistor r=9.3 //w=0.17 //l=0.17 //layer=mcon //count=1 \
 //x=16.47 //y=1.135 //x2=16.47 //y2=1.135
r503 (  81 82 ) resistor r=0.0939994 //w=0.226 //l=0.13 //layer=m1 \
 //thickness=0.36 //x=16.467 //y=1.135 //x2=16.467 //y2=1.005
r504 (  76 191 ) resistor r=9.3 //w=0.17 //l=0.17 //layer=mcon //count=1 \
 //x=13.14 //y=1.135 //x2=13.14 //y2=1.135
r505 (  76 77 ) resistor r=0.0939994 //w=0.226 //l=0.13 //layer=m1 \
 //thickness=0.36 //x=13.137 //y=1.135 //x2=13.137 //y2=1.005
r506 (  74 128 ) resistor r=3.1 //w=0.17 //l=0.51 //layer=mcon //count=3 \
 //x=9.74 //y=0.18 //x2=9.74 //y2=0.18
r507 (  70 190 ) resistor r=9.3 //w=0.17 //l=0.17 //layer=mcon //count=1 \
 //x=9.81 //y=1.135 //x2=9.81 //y2=1.135
r508 (  70 71 ) resistor r=0.0939994 //w=0.226 //l=0.13 //layer=m1 \
 //thickness=0.36 //x=9.807 //y=1.135 //x2=9.807 //y2=1.005
r509 (  65 189 ) resistor r=9.3 //w=0.17 //l=0.17 //layer=mcon //count=1 \
 //x=6.48 //y=1.135 //x2=6.48 //y2=1.135
r510 (  65 66 ) resistor r=0.0939994 //w=0.226 //l=0.13 //layer=m1 \
 //thickness=0.36 //x=6.477 //y=1.135 //x2=6.477 //y2=1.005
r511 (  61 188 ) resistor r=9.3 //w=0.17 //l=0.17 //layer=mcon //count=1 \
 //x=1.565 //y=1.145 //x2=1.565 //y2=1.145
r512 (  58 175 ) resistor r=9.3 //w=0.17 //l=0.17 //layer=mcon //count=1 \
 //x=21.58 //y=0.18 //x2=21.58 //y2=0.18
r513 (  56 173 ) resistor r=3.1 //w=0.17 //l=0.51 //layer=mcon //count=3 \
 //x=20.84 //y=0.18 //x2=20.84 //y2=0.18
r514 (  56 58 ) resistor r=0.297428 //w=0.311 //l=0.74 //layer=m1 \
 //thickness=0.36 //x=20.84 //y=0.175 //x2=21.58 //y2=0.175
r515 (  54 90 ) resistor r=0.028033 //w=0.35 //l=0.085 //layer=m1 \
 //thickness=0.36 //x=19.885 //y=0.175 //x2=19.8 //y2=0.175
r516 (  54 56 ) resistor r=0.383842 //w=0.311 //l=0.955 //layer=m1 \
 //thickness=0.36 //x=19.885 //y=0.175 //x2=20.84 //y2=0.175
r517 (  52 90 ) resistor r=0.0413265 //w=0.7 //l=0.175 //layer=m1 \
 //thickness=0.36 //x=19.8 //y=0.35 //x2=19.8 //y2=0.175
r518 (  52 87 ) resistor r=0.625 //w=0.131 //l=0.655 //layer=m1 \
 //thickness=0.36 //x=19.8 //y=0.35 //x2=19.8 //y2=1.005
r519 (  51 160 ) resistor r=3.1 //w=0.17 //l=0.51 //layer=mcon //count=3 \
 //x=18.25 //y=0.18 //x2=18.25 //y2=0.18
r520 (  49 158 ) resistor r=3.1 //w=0.17 //l=0.51 //layer=mcon //count=3 \
 //x=17.14 //y=0.18 //x2=17.14 //y2=0.18
r521 (  49 51 ) resistor r=0.446141 //w=0.311 //l=1.11 //layer=m1 \
 //thickness=0.36 //x=17.14 //y=0.175 //x2=18.25 //y2=0.175
r522 (  47 84 ) resistor r=0.028033 //w=0.35 //l=0.085 //layer=m1 \
 //thickness=0.36 //x=16.555 //y=0.175 //x2=16.47 //y2=0.175
r523 (  47 49 ) resistor r=0.235129 //w=0.311 //l=0.585 //layer=m1 \
 //thickness=0.36 //x=16.555 //y=0.175 //x2=17.14 //y2=0.175
r524 (  46 90 ) resistor r=0.028033 //w=0.35 //l=0.085 //layer=m1 \
 //thickness=0.36 //x=19.715 //y=0.175 //x2=19.8 //y2=0.175
r525 (  46 51 ) resistor r=0.588826 //w=0.311 //l=1.465 //layer=m1 \
 //thickness=0.36 //x=19.715 //y=0.175 //x2=18.25 //y2=0.175
r526 (  44 84 ) resistor r=0.0413265 //w=0.7 //l=0.175 //layer=m1 \
 //thickness=0.36 //x=16.47 //y=0.35 //x2=16.47 //y2=0.175
r527 (  44 82 ) resistor r=0.625 //w=0.131 //l=0.655 //layer=m1 \
 //thickness=0.36 //x=16.47 //y=0.35 //x2=16.47 //y2=1.005
r528 (  43 156 ) resistor r=3.1 //w=0.17 //l=0.51 //layer=mcon //count=3 \
 //x=16.03 //y=0.18 //x2=16.03 //y2=0.18
r529 (  41 145 ) resistor r=3.1 //w=0.17 //l=0.51 //layer=mcon //count=3 \
 //x=14.55 //y=0.18 //x2=14.55 //y2=0.18
r530 (  41 43 ) resistor r=0.594855 //w=0.311 //l=1.48 //layer=m1 \
 //thickness=0.36 //x=14.55 //y=0.175 //x2=16.03 //y2=0.175
r531 (  39 143 ) resistor r=3.1 //w=0.17 //l=0.51 //layer=mcon //count=3 \
 //x=13.44 //y=0.18 //x2=13.44 //y2=0.18
r532 (  39 41 ) resistor r=0.446141 //w=0.311 //l=1.11 //layer=m1 \
 //thickness=0.36 //x=13.44 //y=0.175 //x2=14.55 //y2=0.175
r533 (  37 79 ) resistor r=0.028033 //w=0.35 //l=0.085 //layer=m1 \
 //thickness=0.36 //x=13.225 //y=0.175 //x2=13.14 //y2=0.175
r534 (  37 39 ) resistor r=0.0864148 //w=0.311 //l=0.215 //layer=m1 \
 //thickness=0.36 //x=13.225 //y=0.175 //x2=13.44 //y2=0.175
r535 (  36 84 ) resistor r=0.028033 //w=0.35 //l=0.085 //layer=m1 \
 //thickness=0.36 //x=16.385 //y=0.175 //x2=16.47 //y2=0.175
r536 (  36 43 ) resistor r=0.142685 //w=0.311 //l=0.355 //layer=m1 \
 //thickness=0.36 //x=16.385 //y=0.175 //x2=16.03 //y2=0.175
r537 (  34 79 ) resistor r=0.0413265 //w=0.7 //l=0.175 //layer=m1 \
 //thickness=0.36 //x=13.14 //y=0.35 //x2=13.14 //y2=0.175
r538 (  34 77 ) resistor r=0.625 //w=0.131 //l=0.655 //layer=m1 \
 //thickness=0.36 //x=13.14 //y=0.35 //x2=13.14 //y2=1.005
r539 (  33 141 ) resistor r=3.1 //w=0.17 //l=0.51 //layer=mcon //count=3 \
 //x=12.33 //y=0.18 //x2=12.33 //y2=0.18
r540 (  30 130 ) resistor r=3.1 //w=0.17 //l=0.51 //layer=mcon //count=3 \
 //x=10.85 //y=0.18 //x2=10.85 //y2=0.18
r541 (  28 74 ) resistor r=0.028033 //w=0.35 //l=0.085 //layer=m1 \
 //thickness=0.36 //x=9.895 //y=0.175 //x2=9.81 //y2=0.175
r542 (  28 30 ) resistor r=0.383842 //w=0.311 //l=0.955 //layer=m1 \
 //thickness=0.36 //x=9.895 //y=0.175 //x2=10.85 //y2=0.175
r543 (  27 79 ) resistor r=0.028033 //w=0.35 //l=0.085 //layer=m1 \
 //thickness=0.36 //x=13.055 //y=0.175 //x2=13.14 //y2=0.175
r544 (  27 33 ) resistor r=0.291399 //w=0.311 //l=0.725 //layer=m1 \
 //thickness=0.36 //x=13.055 //y=0.175 //x2=12.33 //y2=0.175
r545 (  25 74 ) resistor r=0.0413265 //w=0.7 //l=0.175 //layer=m1 \
 //thickness=0.36 //x=9.81 //y=0.35 //x2=9.81 //y2=0.175
r546 (  25 71 ) resistor r=0.625 //w=0.131 //l=0.655 //layer=m1 \
 //thickness=0.36 //x=9.81 //y=0.35 //x2=9.81 //y2=1.005
r547 (  24 117 ) resistor r=3.1 //w=0.17 //l=0.51 //layer=mcon //count=3 \
 //x=8.26 //y=0.18 //x2=8.26 //y2=0.18
r548 (  22 115 ) resistor r=3.1 //w=0.17 //l=0.51 //layer=mcon //count=3 \
 //x=7.15 //y=0.18 //x2=7.15 //y2=0.18
r549 (  22 24 ) resistor r=0.446141 //w=0.311 //l=1.11 //layer=m1 \
 //thickness=0.36 //x=7.15 //y=0.175 //x2=8.26 //y2=0.175
r550 (  20 68 ) resistor r=0.028033 //w=0.35 //l=0.085 //layer=m1 \
 //thickness=0.36 //x=6.565 //y=0.175 //x2=6.48 //y2=0.175
r551 (  20 22 ) resistor r=0.235129 //w=0.311 //l=0.585 //layer=m1 \
 //thickness=0.36 //x=6.565 //y=0.175 //x2=7.15 //y2=0.175
r552 (  19 74 ) resistor r=0.028033 //w=0.35 //l=0.085 //layer=m1 \
 //thickness=0.36 //x=9.725 //y=0.175 //x2=9.81 //y2=0.175
r553 (  19 24 ) resistor r=0.588826 //w=0.311 //l=1.465 //layer=m1 \
 //thickness=0.36 //x=9.725 //y=0.175 //x2=8.26 //y2=0.175
r554 (  17 68 ) resistor r=0.0413265 //w=0.7 //l=0.175 //layer=m1 \
 //thickness=0.36 //x=6.48 //y=0.35 //x2=6.48 //y2=0.175
r555 (  17 66 ) resistor r=0.625 //w=0.131 //l=0.655 //layer=m1 \
 //thickness=0.36 //x=6.48 //y=0.35 //x2=6.48 //y2=1.005
r556 (  16 113 ) resistor r=3.1 //w=0.17 //l=0.51 //layer=mcon //count=3 \
 //x=6.04 //y=0.18 //x2=6.04 //y2=0.18
r557 (  14 102 ) resistor r=3.1 //w=0.17 //l=0.51 //layer=mcon //count=3 \
 //x=4.56 //y=0.18 //x2=4.56 //y2=0.18
r558 (  14 16 ) resistor r=0.594855 //w=0.311 //l=1.48 //layer=m1 \
 //thickness=0.36 //x=4.56 //y=0.175 //x2=6.04 //y2=0.175
r559 (  12 100 ) resistor r=3.1 //w=0.17 //l=0.51 //layer=mcon //count=3 \
 //x=3.45 //y=0.18 //x2=3.45 //y2=0.18
r560 (  12 14 ) resistor r=0.446141 //w=0.311 //l=1.11 //layer=m1 \
 //thickness=0.36 //x=3.45 //y=0.175 //x2=4.56 //y2=0.175
r561 (  10 98 ) resistor r=3.1 //w=0.17 //l=0.51 //layer=mcon //count=3 \
 //x=2.34 //y=0.18 //x2=2.34 //y2=0.18
r562 (  10 12 ) resistor r=0.446141 //w=0.311 //l=1.11 //layer=m1 \
 //thickness=0.36 //x=2.34 //y=0.175 //x2=3.45 //y2=0.175
r563 (  8 63 ) resistor r=0.028033 //w=0.35 //l=0.085 //layer=m1 \
 //thickness=0.36 //x=1.65 //y=0.175 //x2=1.565 //y2=0.175
r564 (  8 10 ) resistor r=0.277331 //w=0.311 //l=0.69 //layer=m1 \
 //thickness=0.36 //x=1.65 //y=0.175 //x2=2.34 //y2=0.175
r565 (  7 68 ) resistor r=0.028033 //w=0.35 //l=0.085 //layer=m1 \
 //thickness=0.36 //x=6.395 //y=0.175 //x2=6.48 //y2=0.175
r566 (  7 16 ) resistor r=0.142685 //w=0.311 //l=0.355 //layer=m1 \
 //thickness=0.36 //x=6.395 //y=0.175 //x2=6.04 //y2=0.175
r567 (  6 61 ) resistor r=0.0942778 //w=0.221 //l=0.13 //layer=m1 \
 //thickness=0.36 //x=1.565 //y=1.015 //x2=1.565 //y2=1.145
r568 (  5 63 ) resistor r=0.0413265 //w=0.7 //l=0.175 //layer=m1 \
 //thickness=0.36 //x=1.565 //y=0.35 //x2=1.565 //y2=0.175
r569 (  5 6 ) resistor r=0.634542 //w=0.131 //l=0.665 //layer=m1 \
 //thickness=0.36 //x=1.565 //y=0.35 //x2=1.565 //y2=1.015
r570 (  4 96 ) resistor r=3.1 //w=0.17 //l=0.51 //layer=mcon //count=3 \
 //x=1.23 //y=0.18 //x2=1.23 //y2=0.18
r571 (  2 63 ) resistor r=0.028033 //w=0.35 //l=0.085 //layer=m1 \
 //thickness=0.36 //x=1.48 //y=0.175 //x2=1.565 //y2=0.175
r572 (  2 4 ) resistor r=0.0892857 //w=0.35 //l=0.25 //layer=m1 \
 //thickness=0.36 //x=1.48 //y=0.175 //x2=1.23 //y2=0.175
r573 (  1 33 ) resistor r=0.446141 //w=0.311 //l=1.11 //layer=m1 \
 //thickness=0.36 //x=11.22 //y=0.175 //x2=12.33 //y2=0.175
r574 (  1 30 ) resistor r=0.148714 //w=0.311 //l=0.37 //layer=m1 \
 //thickness=0.36 //x=11.22 //y=0.175 //x2=10.85 //y2=0.175
ends PM_DFFX1\%GND

subckt PM_DFFX1\%noxref_12 ( 1 5 9 13 17 35 )
c52 ( 35 0 ) capacitor c=0.076261f //x=0.945 //y=0.555
c53 ( 17 0 ) capacitor c=0.0259769f //x=2.935 //y=1.77
c54 ( 13 0 ) capacitor c=0.0153941f //x=2.935 //y=0.72
c55 ( 9 0 ) capacitor c=0.00772076f //x=2.05 //y=0.805
c56 ( 5 0 ) capacitor c=0.0211674f //x=1.965 //y=1.77
c57 ( 1 0 ) capacitor c=0.0109947f //x=1.08 //y=1.685
r58 (  18 35 ) resistor r=5.4201 //w=0.17 //l=0.103078 //layer=li \
 //thickness=0.1 //x=2.135 //y=1.77 //x2=2.05 //y2=1.81
r59 (  18 35 ) resistor r=27.3797 //w=0.187 //l=0.4 //layer=li //thickness=0.1 \
 //x=2.135 //y=1.77 //x2=2.535 //y2=1.77
r60 (  17 35 ) resistor r=0.751729 //w=0.17 //l=0.085 //layer=li \
 //thickness=0.1 //x=2.935 //y=1.77 //x2=3.02 //y2=1.77
r61 (  17 35 ) resistor r=27.3797 //w=0.187 //l=0.4 //layer=li //thickness=0.1 \
 //x=2.935 //y=1.77 //x2=2.535 //y2=1.77
r62 (  14 35 ) resistor r=3.57586 //w=0.17 //l=0.103078 //layer=li \
 //thickness=0.1 //x=2.135 //y=0.72 //x2=2.05 //y2=0.68
r63 (  14 35 ) resistor r=27.3797 //w=0.187 //l=0.4 //layer=li //thickness=0.1 \
 //x=2.135 //y=0.72 //x2=2.535 //y2=0.72
r64 (  13 35 ) resistor r=0.751729 //w=0.17 //l=0.085 //layer=li \
 //thickness=0.1 //x=2.935 //y=0.72 //x2=3.02 //y2=0.72
r65 (  13 35 ) resistor r=27.3797 //w=0.187 //l=0.4 //layer=li //thickness=0.1 \
 //x=2.935 //y=0.72 //x2=2.535 //y2=0.72
r66 (  10 35 ) resistor r=1.40859 //w=0.34 //l=0.125 //layer=li \
 //thickness=0.1 //x=2.05 //y=1.685 //x2=2.05 //y2=1.81
r67 (  10 35 ) resistor r=42.0963 //w=0.187 //l=0.615 //layer=li \
 //thickness=0.1 //x=2.05 //y=1.685 //x2=2.05 //y2=1.07
r68 (  9 35 ) resistor r=3.57586 //w=0.17 //l=0.125 //layer=li //thickness=0.1 \
 //x=2.05 //y=0.805 //x2=2.05 //y2=0.68
r69 (  9 35 ) resistor r=18.139 //w=0.187 //l=0.265 //layer=li //thickness=0.1 \
 //x=2.05 //y=0.805 //x2=2.05 //y2=1.07
r70 (  6 35 ) resistor r=3.57586 //w=0.17 //l=0.103078 //layer=li \
 //thickness=0.1 //x=1.165 //y=1.77 //x2=1.08 //y2=1.81
r71 (  6 35 ) resistor r=27.3797 //w=0.187 //l=0.4 //layer=li //thickness=0.1 \
 //x=1.165 //y=1.77 //x2=1.565 //y2=1.77
r72 (  5 35 ) resistor r=5.4201 //w=0.17 //l=0.103078 //layer=li \
 //thickness=0.1 //x=1.965 //y=1.77 //x2=2.05 //y2=1.81
r73 (  5 35 ) resistor r=27.3797 //w=0.187 //l=0.4 //layer=li //thickness=0.1 \
 //x=1.965 //y=1.77 //x2=1.565 //y2=1.77
r74 (  1 35 ) resistor r=3.57586 //w=0.17 //l=0.125 //layer=li //thickness=0.1 \
 //x=1.08 //y=1.685 //x2=1.08 //y2=1.81
r75 (  1 35 ) resistor r=42.0963 //w=0.187 //l=0.615 //layer=li \
 //thickness=0.1 //x=1.08 //y=1.685 //x2=1.08 //y2=1.07
ends PM_DFFX1\%noxref_12

subckt PM_DFFX1\%noxref_13 ( 1 5 9 10 13 17 29 )
c66 ( 29 0 ) capacitor c=0.0671084f //x=5.86 //y=0.545
c67 ( 17 0 ) capacitor c=0.0067865f //x=7.935 //y=0.795
c68 ( 13 0 ) capacitor c=0.0157877f //x=7.85 //y=0.71
c69 ( 10 0 ) capacitor c=0.00724577f //x=6.965 //y=1.675
c70 ( 9 0 ) capacitor c=0.00770028f //x=6.965 //y=0.795
c71 ( 5 0 ) capacitor c=0.0193892f //x=6.88 //y=1.76
c72 ( 1 0 ) capacitor c=0.00822695f //x=5.995 //y=1.675
r73 (  17 29 ) resistor r=3.57586 //w=0.17 //l=0.125 //layer=li \
 //thickness=0.1 //x=7.935 //y=0.795 //x2=7.935 //y2=0.67
r74 (  17 29 ) resistor r=18.139 //w=0.187 //l=0.265 //layer=li \
 //thickness=0.1 //x=7.935 //y=0.795 //x2=7.935 //y2=1.06
r75 (  14 29 ) resistor r=3.57586 //w=0.17 //l=0.103078 //layer=li \
 //thickness=0.1 //x=7.05 //y=0.71 //x2=6.965 //y2=0.67
r76 (  14 29 ) resistor r=27.3797 //w=0.187 //l=0.4 //layer=li //thickness=0.1 \
 //x=7.05 //y=0.71 //x2=7.45 //y2=0.71
r77 (  13 29 ) resistor r=3.57586 //w=0.17 //l=0.103078 //layer=li \
 //thickness=0.1 //x=7.85 //y=0.71 //x2=7.935 //y2=0.67
r78 (  13 29 ) resistor r=27.3797 //w=0.187 //l=0.4 //layer=li //thickness=0.1 \
 //x=7.85 //y=0.71 //x2=7.45 //y2=0.71
r79 (  10 29 ) resistor r=3.57586 //w=0.17 //l=0.125 //layer=li \
 //thickness=0.1 //x=6.965 //y=1.675 //x2=6.965 //y2=1.8
r80 (  10 29 ) resistor r=42.0963 //w=0.187 //l=0.615 //layer=li \
 //thickness=0.1 //x=6.965 //y=1.675 //x2=6.965 //y2=1.06
r81 (  9 29 ) resistor r=3.57586 //w=0.17 //l=0.125 //layer=li //thickness=0.1 \
 //x=6.965 //y=0.795 //x2=6.965 //y2=0.67
r82 (  9 29 ) resistor r=18.139 //w=0.187 //l=0.265 //layer=li //thickness=0.1 \
 //x=6.965 //y=0.795 //x2=6.965 //y2=1.06
r83 (  6 29 ) resistor r=3.57586 //w=0.17 //l=0.103078 //layer=li \
 //thickness=0.1 //x=6.08 //y=1.76 //x2=5.995 //y2=1.8
r84 (  6 29 ) resistor r=27.3797 //w=0.187 //l=0.4 //layer=li //thickness=0.1 \
 //x=6.08 //y=1.76 //x2=6.48 //y2=1.76
r85 (  5 29 ) resistor r=3.57586 //w=0.17 //l=0.103078 //layer=li \
 //thickness=0.1 //x=6.88 //y=1.76 //x2=6.965 //y2=1.8
r86 (  5 29 ) resistor r=27.3797 //w=0.187 //l=0.4 //layer=li //thickness=0.1 \
 //x=6.88 //y=1.76 //x2=6.48 //y2=1.76
r87 (  1 29 ) resistor r=3.57586 //w=0.17 //l=0.125 //layer=li //thickness=0.1 \
 //x=5.995 //y=1.675 //x2=5.995 //y2=1.8
r88 (  1 29 ) resistor r=42.0963 //w=0.187 //l=0.615 //layer=li \
 //thickness=0.1 //x=5.995 //y=1.675 //x2=5.995 //y2=1.06
ends PM_DFFX1\%noxref_13

subckt PM_DFFX1\%noxref_14 ( 1 5 9 10 13 17 29 )
c68 ( 29 0 ) capacitor c=0.0668051f //x=9.19 //y=0.545
c69 ( 17 0 ) capacitor c=0.0067865f //x=11.265 //y=0.795
c70 ( 13 0 ) capacitor c=0.0157426f //x=11.18 //y=0.71
c71 ( 10 0 ) capacitor c=0.00742952f //x=10.295 //y=1.675
c72 ( 9 0 ) capacitor c=0.00770028f //x=10.295 //y=0.795
c73 ( 5 0 ) capacitor c=0.0197708f //x=10.21 //y=1.76
c74 ( 1 0 ) capacitor c=0.00821716f //x=9.325 //y=1.675
r75 (  17 29 ) resistor r=3.57586 //w=0.17 //l=0.125 //layer=li \
 //thickness=0.1 //x=11.265 //y=0.795 //x2=11.265 //y2=0.67
r76 (  17 29 ) resistor r=18.139 //w=0.187 //l=0.265 //layer=li \
 //thickness=0.1 //x=11.265 //y=0.795 //x2=11.265 //y2=1.06
r77 (  14 29 ) resistor r=3.57586 //w=0.17 //l=0.103078 //layer=li \
 //thickness=0.1 //x=10.38 //y=0.71 //x2=10.295 //y2=0.67
r78 (  14 29 ) resistor r=27.3797 //w=0.187 //l=0.4 //layer=li //thickness=0.1 \
 //x=10.38 //y=0.71 //x2=10.78 //y2=0.71
r79 (  13 29 ) resistor r=3.57586 //w=0.17 //l=0.103078 //layer=li \
 //thickness=0.1 //x=11.18 //y=0.71 //x2=11.265 //y2=0.67
r80 (  13 29 ) resistor r=27.3797 //w=0.187 //l=0.4 //layer=li //thickness=0.1 \
 //x=11.18 //y=0.71 //x2=10.78 //y2=0.71
r81 (  10 29 ) resistor r=3.57586 //w=0.17 //l=0.125 //layer=li \
 //thickness=0.1 //x=10.295 //y=1.675 //x2=10.295 //y2=1.8
r82 (  10 29 ) resistor r=42.0963 //w=0.187 //l=0.615 //layer=li \
 //thickness=0.1 //x=10.295 //y=1.675 //x2=10.295 //y2=1.06
r83 (  9 29 ) resistor r=3.57586 //w=0.17 //l=0.125 //layer=li //thickness=0.1 \
 //x=10.295 //y=0.795 //x2=10.295 //y2=0.67
r84 (  9 29 ) resistor r=18.139 //w=0.187 //l=0.265 //layer=li //thickness=0.1 \
 //x=10.295 //y=0.795 //x2=10.295 //y2=1.06
r85 (  6 29 ) resistor r=3.57586 //w=0.17 //l=0.103078 //layer=li \
 //thickness=0.1 //x=9.41 //y=1.76 //x2=9.325 //y2=1.8
r86 (  6 29 ) resistor r=27.3797 //w=0.187 //l=0.4 //layer=li //thickness=0.1 \
 //x=9.41 //y=1.76 //x2=9.81 //y2=1.76
r87 (  5 29 ) resistor r=3.57586 //w=0.17 //l=0.103078 //layer=li \
 //thickness=0.1 //x=10.21 //y=1.76 //x2=10.295 //y2=1.8
r88 (  5 29 ) resistor r=27.3797 //w=0.187 //l=0.4 //layer=li //thickness=0.1 \
 //x=10.21 //y=1.76 //x2=9.81 //y2=1.76
r89 (  1 29 ) resistor r=3.57586 //w=0.17 //l=0.125 //layer=li //thickness=0.1 \
 //x=9.325 //y=1.675 //x2=9.325 //y2=1.8
r90 (  1 29 ) resistor r=42.0963 //w=0.187 //l=0.615 //layer=li \
 //thickness=0.1 //x=9.325 //y=1.675 //x2=9.325 //y2=1.06
ends PM_DFFX1\%noxref_14

subckt PM_DFFX1\%noxref_15 ( 1 5 9 10 13 17 29 )
c66 ( 29 0 ) capacitor c=0.0675014f //x=12.52 //y=0.545
c67 ( 17 0 ) capacitor c=0.0067865f //x=14.595 //y=0.795
c68 ( 13 0 ) capacitor c=0.0157877f //x=14.51 //y=0.71
c69 ( 10 0 ) capacitor c=0.00753446f //x=13.625 //y=1.675
c70 ( 9 0 ) capacitor c=0.00770028f //x=13.625 //y=0.795
c71 ( 5 0 ) capacitor c=0.0197745f //x=13.54 //y=1.76
c72 ( 1 0 ) capacitor c=0.00821716f //x=12.655 //y=1.675
r73 (  17 29 ) resistor r=3.57586 //w=0.17 //l=0.125 //layer=li \
 //thickness=0.1 //x=14.595 //y=0.795 //x2=14.595 //y2=0.67
r74 (  17 29 ) resistor r=18.139 //w=0.187 //l=0.265 //layer=li \
 //thickness=0.1 //x=14.595 //y=0.795 //x2=14.595 //y2=1.06
r75 (  14 29 ) resistor r=3.57586 //w=0.17 //l=0.103078 //layer=li \
 //thickness=0.1 //x=13.71 //y=0.71 //x2=13.625 //y2=0.67
r76 (  14 29 ) resistor r=27.3797 //w=0.187 //l=0.4 //layer=li //thickness=0.1 \
 //x=13.71 //y=0.71 //x2=14.11 //y2=0.71
r77 (  13 29 ) resistor r=3.57586 //w=0.17 //l=0.103078 //layer=li \
 //thickness=0.1 //x=14.51 //y=0.71 //x2=14.595 //y2=0.67
r78 (  13 29 ) resistor r=27.3797 //w=0.187 //l=0.4 //layer=li //thickness=0.1 \
 //x=14.51 //y=0.71 //x2=14.11 //y2=0.71
r79 (  10 29 ) resistor r=3.57586 //w=0.17 //l=0.125 //layer=li \
 //thickness=0.1 //x=13.625 //y=1.675 //x2=13.625 //y2=1.8
r80 (  10 29 ) resistor r=42.0963 //w=0.187 //l=0.615 //layer=li \
 //thickness=0.1 //x=13.625 //y=1.675 //x2=13.625 //y2=1.06
r81 (  9 29 ) resistor r=3.57586 //w=0.17 //l=0.125 //layer=li //thickness=0.1 \
 //x=13.625 //y=0.795 //x2=13.625 //y2=0.67
r82 (  9 29 ) resistor r=18.139 //w=0.187 //l=0.265 //layer=li //thickness=0.1 \
 //x=13.625 //y=0.795 //x2=13.625 //y2=1.06
r83 (  6 29 ) resistor r=3.57586 //w=0.17 //l=0.103078 //layer=li \
 //thickness=0.1 //x=12.74 //y=1.76 //x2=12.655 //y2=1.8
r84 (  6 29 ) resistor r=27.3797 //w=0.187 //l=0.4 //layer=li //thickness=0.1 \
 //x=12.74 //y=1.76 //x2=13.14 //y2=1.76
r85 (  5 29 ) resistor r=3.57586 //w=0.17 //l=0.103078 //layer=li \
 //thickness=0.1 //x=13.54 //y=1.76 //x2=13.625 //y2=1.8
r86 (  5 29 ) resistor r=27.3797 //w=0.187 //l=0.4 //layer=li //thickness=0.1 \
 //x=13.54 //y=1.76 //x2=13.14 //y2=1.76
r87 (  1 29 ) resistor r=3.57586 //w=0.17 //l=0.125 //layer=li //thickness=0.1 \
 //x=12.655 //y=1.675 //x2=12.655 //y2=1.8
r88 (  1 29 ) resistor r=42.0963 //w=0.187 //l=0.615 //layer=li \
 //thickness=0.1 //x=12.655 //y=1.675 //x2=12.655 //y2=1.06
ends PM_DFFX1\%noxref_15

subckt PM_DFFX1\%noxref_16 ( 1 5 9 10 13 17 29 )
c66 ( 29 0 ) capacitor c=0.0668023f //x=15.85 //y=0.545
c67 ( 17 0 ) capacitor c=0.0067865f //x=17.925 //y=0.795
c68 ( 13 0 ) capacitor c=0.0157377f //x=17.84 //y=0.71
c69 ( 10 0 ) capacitor c=0.00911004f //x=16.955 //y=1.675
c70 ( 9 0 ) capacitor c=0.00770028f //x=16.955 //y=0.795
c71 ( 5 0 ) capacitor c=0.0232545f //x=16.87 //y=1.76
c72 ( 1 0 ) capacitor c=0.00844422f //x=15.985 //y=1.675
r73 (  17 29 ) resistor r=3.57586 //w=0.17 //l=0.125 //layer=li \
 //thickness=0.1 //x=17.925 //y=0.795 //x2=17.925 //y2=0.67
r74 (  17 29 ) resistor r=18.139 //w=0.187 //l=0.265 //layer=li \
 //thickness=0.1 //x=17.925 //y=0.795 //x2=17.925 //y2=1.06
r75 (  14 29 ) resistor r=3.57586 //w=0.17 //l=0.103078 //layer=li \
 //thickness=0.1 //x=17.04 //y=0.71 //x2=16.955 //y2=0.67
r76 (  14 29 ) resistor r=27.3797 //w=0.187 //l=0.4 //layer=li //thickness=0.1 \
 //x=17.04 //y=0.71 //x2=17.44 //y2=0.71
r77 (  13 29 ) resistor r=3.57586 //w=0.17 //l=0.103078 //layer=li \
 //thickness=0.1 //x=17.84 //y=0.71 //x2=17.925 //y2=0.67
r78 (  13 29 ) resistor r=27.3797 //w=0.187 //l=0.4 //layer=li //thickness=0.1 \
 //x=17.84 //y=0.71 //x2=17.44 //y2=0.71
r79 (  10 29 ) resistor r=3.57586 //w=0.17 //l=0.125 //layer=li \
 //thickness=0.1 //x=16.955 //y=1.675 //x2=16.955 //y2=1.8
r80 (  10 29 ) resistor r=42.0963 //w=0.187 //l=0.615 //layer=li \
 //thickness=0.1 //x=16.955 //y=1.675 //x2=16.955 //y2=1.06
r81 (  9 29 ) resistor r=3.57586 //w=0.17 //l=0.125 //layer=li //thickness=0.1 \
 //x=16.955 //y=0.795 //x2=16.955 //y2=0.67
r82 (  9 29 ) resistor r=18.139 //w=0.187 //l=0.265 //layer=li //thickness=0.1 \
 //x=16.955 //y=0.795 //x2=16.955 //y2=1.06
r83 (  6 29 ) resistor r=3.57586 //w=0.17 //l=0.103078 //layer=li \
 //thickness=0.1 //x=16.07 //y=1.76 //x2=15.985 //y2=1.8
r84 (  6 29 ) resistor r=27.3797 //w=0.187 //l=0.4 //layer=li //thickness=0.1 \
 //x=16.07 //y=1.76 //x2=16.47 //y2=1.76
r85 (  5 29 ) resistor r=3.57586 //w=0.17 //l=0.103078 //layer=li \
 //thickness=0.1 //x=16.87 //y=1.76 //x2=16.955 //y2=1.8
r86 (  5 29 ) resistor r=27.3797 //w=0.187 //l=0.4 //layer=li //thickness=0.1 \
 //x=16.87 //y=1.76 //x2=16.47 //y2=1.76
r87 (  1 29 ) resistor r=3.57586 //w=0.17 //l=0.125 //layer=li //thickness=0.1 \
 //x=15.985 //y=1.675 //x2=15.985 //y2=1.8
r88 (  1 29 ) resistor r=42.0963 //w=0.187 //l=0.615 //layer=li \
 //thickness=0.1 //x=15.985 //y=1.675 //x2=15.985 //y2=1.06
ends PM_DFFX1\%noxref_16

subckt PM_DFFX1\%noxref_17 ( 1 5 9 10 13 17 29 )
c61 ( 29 0 ) capacitor c=0.0678378f //x=19.18 //y=0.545
c62 ( 17 0 ) capacitor c=0.00709791f //x=21.255 //y=0.795
c63 ( 13 0 ) capacitor c=0.0157477f //x=21.17 //y=0.71
c64 ( 10 0 ) capacitor c=0.00742703f //x=20.285 //y=1.675
c65 ( 9 0 ) capacitor c=0.00770028f //x=20.285 //y=0.795
c66 ( 5 0 ) capacitor c=0.019656f //x=20.2 //y=1.76
c67 ( 1 0 ) capacitor c=0.00821716f //x=19.315 //y=1.675
r68 (  17 29 ) resistor r=3.57586 //w=0.17 //l=0.125 //layer=li \
 //thickness=0.1 //x=21.255 //y=0.795 //x2=21.255 //y2=0.67
r69 (  17 29 ) resistor r=18.139 //w=0.187 //l=0.265 //layer=li \
 //thickness=0.1 //x=21.255 //y=0.795 //x2=21.255 //y2=1.06
r70 (  14 29 ) resistor r=3.57586 //w=0.17 //l=0.103078 //layer=li \
 //thickness=0.1 //x=20.37 //y=0.71 //x2=20.285 //y2=0.67
r71 (  14 29 ) resistor r=27.3797 //w=0.187 //l=0.4 //layer=li //thickness=0.1 \
 //x=20.37 //y=0.71 //x2=20.77 //y2=0.71
r72 (  13 29 ) resistor r=3.57586 //w=0.17 //l=0.103078 //layer=li \
 //thickness=0.1 //x=21.17 //y=0.71 //x2=21.255 //y2=0.67
r73 (  13 29 ) resistor r=27.3797 //w=0.187 //l=0.4 //layer=li //thickness=0.1 \
 //x=21.17 //y=0.71 //x2=20.77 //y2=0.71
r74 (  10 29 ) resistor r=3.57586 //w=0.17 //l=0.125 //layer=li \
 //thickness=0.1 //x=20.285 //y=1.675 //x2=20.285 //y2=1.8
r75 (  10 29 ) resistor r=42.0963 //w=0.187 //l=0.615 //layer=li \
 //thickness=0.1 //x=20.285 //y=1.675 //x2=20.285 //y2=1.06
r76 (  9 29 ) resistor r=3.57586 //w=0.17 //l=0.125 //layer=li //thickness=0.1 \
 //x=20.285 //y=0.795 //x2=20.285 //y2=0.67
r77 (  9 29 ) resistor r=18.139 //w=0.187 //l=0.265 //layer=li //thickness=0.1 \
 //x=20.285 //y=0.795 //x2=20.285 //y2=1.06
r78 (  6 29 ) resistor r=3.57586 //w=0.17 //l=0.103078 //layer=li \
 //thickness=0.1 //x=19.4 //y=1.76 //x2=19.315 //y2=1.8
r79 (  6 29 ) resistor r=27.3797 //w=0.187 //l=0.4 //layer=li //thickness=0.1 \
 //x=19.4 //y=1.76 //x2=19.8 //y2=1.76
r80 (  5 29 ) resistor r=3.57586 //w=0.17 //l=0.103078 //layer=li \
 //thickness=0.1 //x=20.2 //y=1.76 //x2=20.285 //y2=1.8
r81 (  5 29 ) resistor r=27.3797 //w=0.187 //l=0.4 //layer=li //thickness=0.1 \
 //x=20.2 //y=1.76 //x2=19.8 //y2=1.76
r82 (  1 29 ) resistor r=3.57586 //w=0.17 //l=0.125 //layer=li //thickness=0.1 \
 //x=19.315 //y=1.675 //x2=19.315 //y2=1.8
r83 (  1 29 ) resistor r=42.0963 //w=0.187 //l=0.615 //layer=li \
 //thickness=0.1 //x=19.315 //y=1.675 //x2=19.315 //y2=1.06
ends PM_DFFX1\%noxref_17
