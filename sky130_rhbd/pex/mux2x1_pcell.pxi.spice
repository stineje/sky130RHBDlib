// File: mux2x1_pcell.spi.MUX2X1_PCELL.pxi
// Created: Thu Jan 22 07:13:54 2026
//
simulator lang=spectre
x_PM_MUX2X1_PCELL\%noxref_1 ( N_noxref_1_c_15_p N_noxref_1_c_16_p \
 N_noxref_1_c_17_p N_noxref_1_c_18_p N_noxref_1_c_19_p N_noxref_1_c_20_p \
 N_noxref_1_c_21_p N_noxref_1_c_73_p N_noxref_1_c_22_p N_noxref_1_c_33_p \
 N_noxref_1_c_23_p N_noxref_1_c_24_p N_noxref_1_c_25_p N_noxref_1_c_9_p \
 N_noxref_1_c_27_p N_noxref_1_c_35_p N_noxref_1_c_117_p N_noxref_1_c_69_p \
 N_noxref_1_M0_noxref_g N_noxref_1_M1_noxref_g N_noxref_1_M7_noxref_g \
 N_noxref_1_M8_noxref_g N_noxref_1_M9_noxref_g N_noxref_1_M10_noxref_g \
 N_noxref_1_c_39_p N_noxref_1_c_1_p N_noxref_1_c_2_p N_noxref_1_c_3_p \
 N_noxref_1_c_14_p N_noxref_1_c_37_p N_noxref_1_c_41_p N_noxref_1_c_4_p \
 N_noxref_1_c_43_p N_noxref_1_c_5_p N_noxref_1_c_133_p N_noxref_1_c_134_p \
 N_noxref_1_c_136_p N_noxref_1_c_122_p N_noxref_1_c_161_p N_noxref_1_c_162_p \
 N_noxref_1_c_135_p N_noxref_1_c_137_p N_noxref_1_c_10_p N_noxref_1_c_72_p )  \
 PM_MUX2X1_PCELL\%noxref_1
x_PM_MUX2X1_PCELL\%noxref_2 ( N_noxref_2_c_219_n N_noxref_2_c_224_n \
 N_noxref_2_c_226_n N_noxref_2_c_227_n N_noxref_2_c_229_n N_noxref_2_c_230_n \
 N_noxref_2_c_233_n N_noxref_2_c_247_n N_noxref_2_c_250_n N_noxref_2_c_286_p \
 N_noxref_2_c_293_p N_noxref_2_c_256_n N_noxref_2_c_263_n N_noxref_2_c_321_p \
 N_noxref_2_c_287_p N_noxref_2_c_294_p N_noxref_2_c_295_p N_noxref_2_c_265_n \
 N_noxref_2_c_296_p N_noxref_2_c_268_n N_noxref_2_c_273_n N_noxref_2_c_379_p \
 N_noxref_2_c_317_p N_noxref_2_M3_noxref_g N_noxref_2_M13_noxref_g \
 N_noxref_2_M14_noxref_g N_noxref_2_c_395_p N_noxref_2_c_396_p \
 N_noxref_2_c_398_p N_noxref_2_c_384_p N_noxref_2_c_422_p N_noxref_2_c_423_p \
 N_noxref_2_c_397_p N_noxref_2_c_399_p N_noxref_2_c_320_p \
 N_noxref_2_M0_noxref_d N_noxref_2_M7_noxref_d )  PM_MUX2X1_PCELL\%noxref_2
x_PM_MUX2X1_PCELL\%noxref_3 ( N_noxref_3_c_471_n N_noxref_3_c_487_n \
 N_noxref_3_c_544_p N_noxref_3_c_518_p N_noxref_3_c_489_n N_noxref_3_c_472_n \
 N_noxref_3_c_493_n N_noxref_3_c_473_n N_noxref_3_c_521_p N_noxref_3_c_522_p \
 N_noxref_3_c_474_n N_noxref_3_c_505_n N_noxref_3_c_546_p N_noxref_3_c_506_n \
 N_noxref_3_c_480_n N_noxref_3_c_523_p N_noxref_3_c_524_p N_noxref_3_c_531_p \
 N_noxref_3_c_525_p N_noxref_3_c_507_n N_noxref_3_c_510_n N_noxref_3_c_517_p \
 N_noxref_3_c_527_p N_noxref_3_c_481_n N_noxref_3_c_482_n N_noxref_3_c_594_p \
 N_noxref_3_c_538_p N_noxref_3_c_542_p N_noxref_3_M5_noxref_g \
 N_noxref_3_M17_noxref_g N_noxref_3_M18_noxref_g N_noxref_3_c_570_p \
 N_noxref_3_c_571_p N_noxref_3_c_573_p N_noxref_3_c_552_p N_noxref_3_c_703_p \
 N_noxref_3_c_704_p N_noxref_3_c_572_p N_noxref_3_c_574_p N_noxref_3_c_543_p \
 N_noxref_3_M2_noxref_d N_noxref_3_M9_noxref_d N_noxref_3_M11_noxref_d )  \
 PM_MUX2X1_PCELL\%noxref_3
x_PM_MUX2X1_PCELL\%noxref_4 ( N_noxref_4_c_775_n N_noxref_4_c_792_n \
 N_noxref_4_c_863_p N_noxref_4_c_793_n N_noxref_4_c_794_n N_noxref_4_c_776_n \
 N_noxref_4_c_804_n N_noxref_4_c_777_n N_noxref_4_c_809_n N_noxref_4_c_815_n \
 N_noxref_4_c_816_n N_noxref_4_c_778_n N_noxref_4_c_866_p N_noxref_4_c_867_p \
 N_noxref_4_c_823_n N_noxref_4_c_785_n N_noxref_4_c_825_n N_noxref_4_c_826_n \
 N_noxref_4_c_829_n N_noxref_4_c_786_n N_noxref_4_c_835_n N_noxref_4_c_787_n \
 N_noxref_4_c_869_p N_noxref_4_c_836_n N_noxref_4_c_840_n \
 N_noxref_4_M6_noxref_g N_noxref_4_M19_noxref_g N_noxref_4_M20_noxref_g \
 N_noxref_4_c_846_n N_noxref_4_c_849_n N_noxref_4_c_851_n N_noxref_4_c_891_p \
 N_noxref_4_c_1014_p N_noxref_4_c_985_p N_noxref_4_c_854_n N_noxref_4_c_855_n \
 N_noxref_4_c_856_n N_noxref_4_c_987_p N_noxref_4_c_859_n \
 N_noxref_4_M4_noxref_d N_noxref_4_M13_noxref_d N_noxref_4_M15_noxref_d )  \
 PM_MUX2X1_PCELL\%noxref_4
x_PM_MUX2X1_PCELL\%noxref_5 ( N_noxref_5_c_1050_n N_noxref_5_c_1055_n \
 N_noxref_5_c_1058_n N_noxref_5_c_1133_n N_noxref_5_c_1089_n \
 N_noxref_5_c_1184_n N_noxref_5_c_1138_n N_noxref_5_c_1189_n \
 N_noxref_5_c_1061_n N_noxref_5_c_1065_n N_noxref_5_c_1099_n \
 N_noxref_5_c_1148_n N_noxref_5_c_1104_n N_noxref_5_M7_noxref_s \
 N_noxref_5_M8_noxref_d N_noxref_5_M9_noxref_s N_noxref_5_M10_noxref_d \
 N_noxref_5_M12_noxref_d N_noxref_5_M13_noxref_s N_noxref_5_M14_noxref_d \
 N_noxref_5_M16_noxref_d N_noxref_5_M17_noxref_s N_noxref_5_M18_noxref_d \
 N_noxref_5_M20_noxref_d )  PM_MUX2X1_PCELL\%noxref_5
x_PM_MUX2X1_PCELL\%noxref_6 ( N_noxref_6_c_1278_n N_noxref_6_c_1287_n \
 N_noxref_6_c_1290_n N_noxref_6_c_1294_n N_noxref_6_M2_noxref_g \
 N_noxref_6_M11_noxref_g N_noxref_6_M12_noxref_g N_noxref_6_c_1300_n \
 N_noxref_6_c_1303_n N_noxref_6_c_1305_n N_noxref_6_c_1345_n \
 N_noxref_6_c_1348_n N_noxref_6_c_1350_n N_noxref_6_c_1308_n \
 N_noxref_6_c_1309_n N_noxref_6_c_1310_n N_noxref_6_c_1361_n \
 N_noxref_6_c_1313_n )  PM_MUX2X1_PCELL\%noxref_6
x_PM_MUX2X1_PCELL\%noxref_7 ( N_noxref_7_c_1389_n N_noxref_7_c_1398_n \
 N_noxref_7_c_1401_n N_noxref_7_c_1405_n N_noxref_7_M4_noxref_g \
 N_noxref_7_M15_noxref_g N_noxref_7_M16_noxref_g N_noxref_7_c_1411_n \
 N_noxref_7_c_1414_n N_noxref_7_c_1416_n N_noxref_7_c_1455_n \
 N_noxref_7_c_1458_n N_noxref_7_c_1460_n N_noxref_7_c_1419_n \
 N_noxref_7_c_1420_n N_noxref_7_c_1421_n N_noxref_7_c_1471_n \
 N_noxref_7_c_1424_n )  PM_MUX2X1_PCELL\%noxref_7
x_PM_MUX2X1_PCELL\%noxref_8 ( N_noxref_8_c_1499_n N_noxref_8_c_1601_n \
 N_noxref_8_c_1645_n N_noxref_8_c_1649_n N_noxref_8_c_1504_n \
 N_noxref_8_c_1515_n N_noxref_8_c_1561_n N_noxref_8_c_1570_n \
 N_noxref_8_c_1610_n N_noxref_8_c_1620_n N_noxref_8_c_1518_n \
 N_noxref_8_c_1523_n N_noxref_8_c_1715_p N_noxref_8_c_1524_n \
 N_noxref_8_c_1577_n N_noxref_8_c_1578_n N_noxref_8_c_1525_n \
 N_noxref_8_c_1530_n N_noxref_8_c_1583_n N_noxref_8_c_1631_n \
 N_noxref_8_M0_noxref_s N_noxref_8_M1_noxref_d N_noxref_8_M3_noxref_d \
 N_noxref_8_M5_noxref_d )  PM_MUX2X1_PCELL\%noxref_8
x_PM_MUX2X1_PCELL\%noxref_9 ( N_noxref_9_c_1768_n N_noxref_9_c_1789_n \
 N_noxref_9_c_1795_n N_noxref_9_c_1796_n N_noxref_9_c_1798_n \
 N_noxref_9_c_1769_n N_noxref_9_c_1771_n N_noxref_9_c_1815_n \
 N_noxref_9_c_1852_n N_noxref_9_c_1818_n N_noxref_9_c_1777_n \
 N_noxref_9_c_1825_n N_noxref_9_M6_noxref_d N_noxref_9_M17_noxref_d \
 N_noxref_9_M19_noxref_d )  PM_MUX2X1_PCELL\%noxref_9
x_PM_MUX2X1_PCELL\%noxref_10 ( N_noxref_10_c_1887_n N_noxref_10_c_1889_n \
 N_noxref_10_c_1930_n N_noxref_10_c_1897_n N_noxref_10_c_1904_n \
 N_noxref_10_c_1940_n N_noxref_10_M1_noxref_s )  PM_MUX2X1_PCELL\%noxref_10
x_PM_MUX2X1_PCELL\%noxref_11 ( N_noxref_11_c_1956_n N_noxref_11_c_1957_n \
 N_noxref_11_c_1999_n N_noxref_11_c_1964_n N_noxref_11_c_1974_n \
 N_noxref_11_c_2009_n N_noxref_11_M3_noxref_s )  PM_MUX2X1_PCELL\%noxref_11
x_PM_MUX2X1_PCELL\%noxref_12 ( N_noxref_12_c_2027_n N_noxref_12_c_2029_n \
 N_noxref_12_c_2059_n N_noxref_12_c_2037_n N_noxref_12_c_2046_n \
 N_noxref_12_c_2066_n N_noxref_12_M5_noxref_s )  PM_MUX2X1_PCELL\%noxref_12
cc_1 ( N_noxref_1_c_1_p N_noxref_2_c_219_n ) capacitor c=0.0012792f //x=0.85 \
 //y=1.255 //x2=1.11 //y2=1.755
cc_2 ( N_noxref_1_c_2_p N_noxref_2_c_219_n ) capacitor c=0.00561986f //x=0.85 \
 //y=1.565 //x2=1.11 //y2=1.755
cc_3 ( N_noxref_1_c_3_p N_noxref_2_c_219_n ) capacitor c=0.00440271f //x=0.85 \
 //y=1.92 //x2=1.11 //y2=1.755
cc_4 ( N_noxref_1_c_4_p N_noxref_2_c_219_n ) capacitor c=0.00953922f //x=1.225 \
 //y=1.41 //x2=1.11 //y2=1.755
cc_5 ( N_noxref_1_c_5_p N_noxref_2_c_219_n ) capacitor c=0.00344663f //x=1.38 \
 //y=1.255 //x2=1.11 //y2=1.755
cc_6 ( N_noxref_1_M7_noxref_g N_noxref_2_c_224_n ) capacitor c=0.00141266f \
 //x=0.895 //y=6.02 //x2=1.115 //y2=5.24
cc_7 ( N_noxref_1_M8_noxref_g N_noxref_2_c_224_n ) capacitor c=0.0035262f \
 //x=1.335 //y=6.02 //x2=1.115 //y2=5.24
cc_8 ( N_noxref_1_c_4_p N_noxref_2_c_226_n ) capacitor c=0.00180253f //x=1.225 \
 //y=1.41 //x2=1.395 //y2=1.84
cc_9 ( N_noxref_1_c_9_p N_noxref_2_c_227_n ) capacitor c=0.00946645f //x=3.17 \
 //y=2.94 //x2=1.195 //y2=1.84
cc_10 ( N_noxref_1_c_10_p N_noxref_2_c_227_n ) capacitor c=0.00440271f \
 //x=0.74 //y=2.085 //x2=1.195 //y2=1.84
cc_11 ( N_noxref_1_M8_noxref_g N_noxref_2_c_229_n ) capacitor c=0.00943784f \
 //x=1.335 //y=6.02 //x2=1.395 //y2=4.96
cc_12 ( N_noxref_1_c_9_p N_noxref_2_c_230_n ) capacitor c=0.00479539f //x=3.17 \
 //y=2.94 //x2=1.2 //y2=4.96
cc_13 ( N_noxref_1_M7_noxref_g N_noxref_2_c_230_n ) capacitor c=0.00534267f \
 //x=0.895 //y=6.02 //x2=1.2 //y2=4.96
cc_14 ( N_noxref_1_c_14_p N_noxref_2_c_230_n ) capacitor c=0.00262283f \
 //x=1.26 //y=4.79 //x2=1.2 //y2=4.96
cc_15 ( N_noxref_1_c_15_p N_noxref_2_c_233_n ) capacitor c=0.0243781f //x=0.74 \
 //y=2.8 //x2=1.48 //y2=3.19
cc_16 ( N_noxref_1_c_16_p N_noxref_2_c_233_n ) capacitor c=0.0176785f //x=0.74 \
 //y=3.12 //x2=1.48 //y2=3.19
cc_17 ( N_noxref_1_c_17_p N_noxref_2_c_233_n ) capacitor c=0.00307216f \
 //x=0.74 //y=4.58 //x2=1.48 //y2=3.19
cc_18 ( N_noxref_1_c_18_p N_noxref_2_c_233_n ) capacitor c=0.00929985f \
 //x=3.33 //y=2.78 //x2=1.48 //y2=3.19
cc_19 ( N_noxref_1_c_19_p N_noxref_2_c_233_n ) capacitor c=0.00254755f \
 //x=3.33 //y=3.1 //x2=1.48 //y2=3.19
cc_20 ( N_noxref_1_c_20_p N_noxref_2_c_233_n ) capacitor c=0.0181783f //x=0.74 \
 //y=2.085 //x2=1.48 //y2=3.19
cc_21 ( N_noxref_1_c_21_p N_noxref_2_c_233_n ) capacitor c=5.62253e-19 \
 //x=0.74 //y=2.96 //x2=1.48 //y2=3.19
cc_22 ( N_noxref_1_c_22_p N_noxref_2_c_233_n ) capacitor c=0.00457386f \
 //x=3.33 //y=2.08 //x2=1.48 //y2=3.19
cc_23 ( N_noxref_1_c_23_p N_noxref_2_c_233_n ) capacitor c=0.0014142f \
 //x=3.332 //y=4.56 //x2=1.48 //y2=3.19
cc_24 ( N_noxref_1_c_24_p N_noxref_2_c_233_n ) capacitor c=0.0032735f //x=0.9 \
 //y=2.96 //x2=1.48 //y2=3.19
cc_25 ( N_noxref_1_c_25_p N_noxref_2_c_233_n ) capacitor c=0.00160717f \
 //x=3.33 //y=2.94 //x2=1.48 //y2=3.19
cc_26 ( N_noxref_1_c_9_p N_noxref_2_c_233_n ) capacitor c=0.0277399f //x=3.17 \
 //y=2.94 //x2=1.48 //y2=3.19
cc_27 ( N_noxref_1_c_27_p N_noxref_2_c_233_n ) capacitor c=4.71798e-19 \
 //x=0.74 //y=2.085 //x2=1.48 //y2=3.19
cc_28 ( N_noxref_1_c_10_p N_noxref_2_c_233_n ) capacitor c=0.00275704f \
 //x=0.74 //y=2.085 //x2=1.48 //y2=3.19
cc_29 ( N_noxref_1_c_17_p N_noxref_2_c_247_n ) capacitor c=0.0151957f //x=0.74 \
 //y=4.58 //x2=1.48 //y2=3.51
cc_30 ( N_noxref_1_c_23_p N_noxref_2_c_247_n ) capacitor c=0.00254755f \
 //x=3.332 //y=4.56 //x2=1.48 //y2=3.51
cc_31 ( N_noxref_1_c_9_p N_noxref_2_c_247_n ) capacitor c=0.0069774f //x=3.17 \
 //y=2.94 //x2=1.48 //y2=3.51
cc_32 ( N_noxref_1_c_17_p N_noxref_2_c_250_n ) capacitor c=0.0664716f //x=0.74 \
 //y=4.58 //x2=1.48 //y2=4.875
cc_33 ( N_noxref_1_c_33_p N_noxref_2_c_250_n ) capacitor c=0.00476843f \
 //x=3.33 //y=4.7 //x2=1.48 //y2=4.875
cc_34 ( N_noxref_1_c_23_p N_noxref_2_c_250_n ) capacitor c=0.0192326f \
 //x=3.332 //y=4.56 //x2=1.48 //y2=4.875
cc_35 ( N_noxref_1_c_35_p N_noxref_2_c_250_n ) capacitor c=0.00160039f \
 //x=0.74 //y=4.7 //x2=1.48 //y2=4.875
cc_36 ( N_noxref_1_c_14_p N_noxref_2_c_250_n ) capacitor c=0.00208891f \
 //x=1.26 //y=4.79 //x2=1.48 //y2=4.875
cc_37 ( N_noxref_1_c_37_p N_noxref_2_c_250_n ) capacitor c=0.00140024f \
 //x=0.97 //y=4.79 //x2=1.48 //y2=4.875
cc_38 ( N_noxref_1_c_9_p N_noxref_2_c_256_n ) capacitor c=4.71823e-19 //x=3.17 \
 //y=2.94 //x2=1.11 //y2=1.005
cc_39 ( N_noxref_1_c_39_p N_noxref_2_c_256_n ) capacitor c=0.00187726f \
 //x=0.85 //y=0.91 //x2=1.11 //y2=1.005
cc_40 ( N_noxref_1_c_1_p N_noxref_2_c_256_n ) capacitor c=0.00414335f //x=0.85 \
 //y=1.255 //x2=1.11 //y2=1.005
cc_41 ( N_noxref_1_c_41_p N_noxref_2_c_256_n ) capacitor c=5.57924e-19 \
 //x=1.225 //y=0.755 //x2=1.11 //y2=1.005
cc_42 ( N_noxref_1_c_4_p N_noxref_2_c_256_n ) capacitor c=5.75878e-19 \
 //x=1.225 //y=1.41 //x2=1.11 //y2=1.005
cc_43 ( N_noxref_1_c_43_p N_noxref_2_c_256_n ) capacitor c=0.00148146f \
 //x=1.38 //y=0.91 //x2=1.11 //y2=1.005
cc_44 ( N_noxref_1_c_5_p N_noxref_2_c_256_n ) capacitor c=0.00356478f //x=1.38 \
 //y=1.255 //x2=1.11 //y2=1.005
cc_45 ( N_noxref_1_c_17_p N_noxref_2_c_263_n ) capacitor c=0.00560445f \
 //x=0.74 //y=4.58 //x2=1.48 //y2=3.33
cc_46 ( N_noxref_1_c_23_p N_noxref_2_c_263_n ) capacitor c=2.11402e-19 \
 //x=3.332 //y=4.56 //x2=1.48 //y2=3.33
cc_47 ( N_noxref_1_c_17_p N_noxref_2_c_265_n ) capacitor c=0.00700934f \
 //x=0.74 //y=4.58 //x2=1.64 //y2=3.35
cc_48 ( N_noxref_1_c_23_p N_noxref_2_c_265_n ) capacitor c=0.00160717f \
 //x=3.332 //y=4.56 //x2=1.64 //y2=3.35
cc_49 ( N_noxref_1_c_9_p N_noxref_2_c_265_n ) capacitor c=0.0369869f //x=3.17 \
 //y=2.94 //x2=1.64 //y2=3.35
cc_50 ( N_noxref_1_c_19_p N_noxref_2_c_268_n ) capacitor c=0.00622005f \
 //x=3.33 //y=3.1 //x2=6.5 //y2=3.34
cc_51 ( N_noxref_1_c_33_p N_noxref_2_c_268_n ) capacitor c=0.00180599f \
 //x=3.33 //y=4.7 //x2=6.5 //y2=3.34
cc_52 ( N_noxref_1_c_23_p N_noxref_2_c_268_n ) capacitor c=0.027735f //x=3.332 \
 //y=4.56 //x2=6.5 //y2=3.34
cc_53 ( N_noxref_1_c_25_p N_noxref_2_c_268_n ) capacitor c=0.0369869f //x=3.33 \
 //y=2.94 //x2=6.5 //y2=3.34
cc_54 ( N_noxref_1_c_9_p N_noxref_2_c_268_n ) capacitor c=0.145292f //x=3.17 \
 //y=2.94 //x2=6.5 //y2=3.34
cc_55 ( N_noxref_1_M7_noxref_g N_noxref_2_c_273_n ) capacitor c=0.0162066f \
 //x=0.895 //y=6.02 //x2=1.115 //y2=5.38
cc_56 ( N_noxref_1_M8_noxref_g N_noxref_2_c_273_n ) capacitor c=0.0162066f \
 //x=1.335 //y=6.02 //x2=1.115 //y2=5.38
cc_57 ( N_noxref_1_c_14_p N_noxref_2_c_273_n ) capacitor c=0.00290963f \
 //x=1.26 //y=4.79 //x2=1.115 //y2=5.38
cc_58 ( N_noxref_1_c_39_p N_noxref_2_M0_noxref_d ) capacitor c=0.00137914f \
 //x=0.85 //y=0.91 //x2=0.925 //y2=0.91
cc_59 ( N_noxref_1_c_1_p N_noxref_2_M0_noxref_d ) capacitor c=0.0023891f \
 //x=0.85 //y=1.255 //x2=0.925 //y2=0.91
cc_60 ( N_noxref_1_c_41_p N_noxref_2_M0_noxref_d ) capacitor c=0.0020782f \
 //x=1.225 //y=0.755 //x2=0.925 //y2=0.91
cc_61 ( N_noxref_1_c_4_p N_noxref_2_M0_noxref_d ) capacitor c=0.00356097f \
 //x=1.225 //y=1.41 //x2=0.925 //y2=0.91
cc_62 ( N_noxref_1_c_43_p N_noxref_2_M0_noxref_d ) capacitor c=0.00138452f \
 //x=1.38 //y=0.91 //x2=0.925 //y2=0.91
cc_63 ( N_noxref_1_c_5_p N_noxref_2_M0_noxref_d ) capacitor c=0.00235934f \
 //x=1.38 //y=1.255 //x2=0.925 //y2=0.91
cc_64 ( N_noxref_1_M10_noxref_g N_noxref_3_c_471_n ) capacitor c=0.0108476f \
 //x=3.67 //y=6.02 //x2=4.215 //y2=5.2
cc_65 ( N_noxref_1_c_18_p N_noxref_3_c_472_n ) capacitor c=0.00261412f \
 //x=3.33 //y=2.78 //x2=4.81 //y2=2.78
cc_66 ( N_noxref_1_c_23_p N_noxref_3_c_473_n ) capacitor c=0.00414685f \
 //x=3.332 //y=4.56 //x2=4.81 //y2=5.115
cc_67 ( N_noxref_1_c_19_p N_noxref_3_c_474_n ) capacitor c=5.01534e-19 \
 //x=3.33 //y=3.1 //x2=3.45 //y2=5.38
cc_68 ( N_noxref_1_c_33_p N_noxref_3_c_474_n ) capacitor c=0.0118323f //x=3.33 \
 //y=4.7 //x2=3.45 //y2=5.38
cc_69 ( N_noxref_1_c_69_p N_noxref_3_c_474_n ) capacitor c=0.00277154f \
 //x=3.33 //y=4.7 //x2=3.45 //y2=5.38
cc_70 ( N_noxref_1_M9_noxref_g N_noxref_3_c_474_n ) capacitor c=0.00203628f \
 //x=3.23 //y=6.02 //x2=3.45 //y2=5.38
cc_71 ( N_noxref_1_M10_noxref_g N_noxref_3_c_474_n ) capacitor c=0.00192712f \
 //x=3.67 //y=6.02 //x2=3.45 //y2=5.38
cc_72 ( N_noxref_1_c_72_p N_noxref_3_c_474_n ) capacitor c=0.00196913f \
 //x=3.33 //y=4.7 //x2=3.45 //y2=5.38
cc_73 ( N_noxref_1_c_73_p N_noxref_3_c_480_n ) capacitor c=0.00251935f \
 //x=3.33 //y=2.96 //x2=4.81 //y2=2.96
cc_74 ( N_noxref_1_c_25_p N_noxref_3_c_481_n ) capacitor c=0.00541921f \
 //x=3.33 //y=2.94 //x2=4.97 //y2=2.94
cc_75 ( N_noxref_1_c_33_p N_noxref_3_c_482_n ) capacitor c=0.00104426f \
 //x=3.33 //y=4.7 //x2=3.45 //y2=5.38
cc_76 ( N_noxref_1_c_69_p N_noxref_3_c_482_n ) capacitor c=0.00377369f \
 //x=3.33 //y=4.7 //x2=3.45 //y2=5.38
cc_77 ( N_noxref_1_M9_noxref_g N_noxref_3_c_482_n ) capacitor c=0.0158358f \
 //x=3.23 //y=6.02 //x2=3.45 //y2=5.38
cc_78 ( N_noxref_1_M10_noxref_g N_noxref_3_c_482_n ) capacitor c=0.0178987f \
 //x=3.67 //y=6.02 //x2=3.45 //y2=5.38
cc_79 ( N_noxref_1_c_72_p N_noxref_3_c_482_n ) capacitor c=0.0043218f //x=3.33 \
 //y=4.7 //x2=3.45 //y2=5.38
cc_80 ( N_noxref_1_c_16_p N_noxref_5_c_1050_n ) capacitor c=2.36503e-19 \
 //x=0.74 //y=3.12 //x2=11.47 //y2=7.4
cc_81 ( N_noxref_1_c_17_p N_noxref_5_c_1050_n ) capacitor c=5.72118e-19 \
 //x=0.74 //y=4.58 //x2=11.47 //y2=7.4
cc_82 ( N_noxref_1_c_33_p N_noxref_5_c_1050_n ) capacitor c=9.05427e-19 \
 //x=3.33 //y=4.7 //x2=11.47 //y2=7.4
cc_83 ( N_noxref_1_c_35_p N_noxref_5_c_1050_n ) capacitor c=3.40875e-19 \
 //x=0.74 //y=4.7 //x2=11.47 //y2=7.4
cc_84 ( N_noxref_1_c_69_p N_noxref_5_c_1050_n ) capacitor c=6.23118e-19 \
 //x=3.33 //y=4.7 //x2=11.47 //y2=7.4
cc_85 ( N_noxref_1_c_17_p N_noxref_5_c_1055_n ) capacitor c=5.4912e-19 \
 //x=0.74 //y=4.58 //x2=1.47 //y2=7.4
cc_86 ( N_noxref_1_M7_noxref_g N_noxref_5_c_1055_n ) capacitor c=0.00748034f \
 //x=0.895 //y=6.02 //x2=1.47 //y2=7.4
cc_87 ( N_noxref_1_M8_noxref_g N_noxref_5_c_1055_n ) capacitor c=0.00749619f \
 //x=1.335 //y=6.02 //x2=1.47 //y2=7.4
cc_88 ( N_noxref_1_c_33_p N_noxref_5_c_1058_n ) capacitor c=6.28732e-19 \
 //x=3.33 //y=4.7 //x2=3.805 //y2=7.4
cc_89 ( N_noxref_1_M9_noxref_g N_noxref_5_c_1058_n ) capacitor c=0.0072715f \
 //x=3.23 //y=6.02 //x2=3.805 //y2=7.4
cc_90 ( N_noxref_1_M10_noxref_g N_noxref_5_c_1058_n ) capacitor c=0.00749619f \
 //x=3.67 //y=6.02 //x2=3.805 //y2=7.4
cc_91 ( N_noxref_1_c_17_p N_noxref_5_c_1061_n ) capacitor c=0.022723f //x=0.74 \
 //y=4.58 //x2=0.74 //y2=7.4
cc_92 ( N_noxref_1_c_35_p N_noxref_5_c_1061_n ) capacitor c=0.00795821f \
 //x=0.74 //y=4.7 //x2=0.74 //y2=7.4
cc_93 ( N_noxref_1_M7_noxref_g N_noxref_5_c_1061_n ) capacitor c=0.0186157f \
 //x=0.895 //y=6.02 //x2=0.74 //y2=7.4
cc_94 ( N_noxref_1_c_37_p N_noxref_5_c_1061_n ) capacitor c=0.00799922f \
 //x=0.97 //y=4.79 //x2=0.74 //y2=7.4
cc_95 ( N_noxref_1_c_33_p N_noxref_5_c_1065_n ) capacitor c=0.00447349f \
 //x=3.33 //y=4.7 //x2=2.22 //y2=7.4
cc_96 ( N_noxref_1_c_23_p N_noxref_5_c_1065_n ) capacitor c=0.00733791f \
 //x=3.332 //y=4.56 //x2=2.22 //y2=7.4
cc_97 ( N_noxref_1_c_35_p N_noxref_5_c_1065_n ) capacitor c=0.00235165f \
 //x=0.74 //y=4.7 //x2=2.22 //y2=7.4
cc_98 ( N_noxref_1_c_69_p N_noxref_5_c_1065_n ) capacitor c=0.00370494f \
 //x=3.33 //y=4.7 //x2=2.22 //y2=7.4
cc_99 ( N_noxref_1_c_14_p N_noxref_5_c_1065_n ) capacitor c=0.00780996f \
 //x=1.26 //y=4.79 //x2=2.22 //y2=7.4
cc_100 ( N_noxref_1_c_37_p N_noxref_5_c_1065_n ) capacitor c=2.63786e-19 \
 //x=0.97 //y=4.79 //x2=2.22 //y2=7.4
cc_101 ( N_noxref_1_c_72_p N_noxref_5_c_1065_n ) capacitor c=0.0121704f \
 //x=3.33 //y=4.7 //x2=2.22 //y2=7.4
cc_102 ( N_noxref_1_c_16_p N_noxref_5_M7_noxref_s ) capacitor c=8.04718e-19 \
 //x=0.74 //y=3.12 //x2=0.54 //y2=5.02
cc_103 ( N_noxref_1_c_17_p N_noxref_5_M7_noxref_s ) capacitor c=0.0211972f \
 //x=0.74 //y=4.58 //x2=0.54 //y2=5.02
cc_104 ( N_noxref_1_c_35_p N_noxref_5_M7_noxref_s ) capacitor c=0.00914062f \
 //x=0.74 //y=4.7 //x2=0.54 //y2=5.02
cc_105 ( N_noxref_1_M7_noxref_g N_noxref_5_M7_noxref_s ) capacitor \
 c=0.0573441f //x=0.895 //y=6.02 //x2=0.54 //y2=5.02
cc_106 ( N_noxref_1_c_37_p N_noxref_5_M7_noxref_s ) capacitor c=0.00526099f \
 //x=0.97 //y=4.79 //x2=0.54 //y2=5.02
cc_107 ( N_noxref_1_M8_noxref_g N_noxref_5_M8_noxref_d ) capacitor \
 c=0.0572684f //x=1.335 //y=6.02 //x2=1.41 //y2=5.02
cc_108 ( N_noxref_1_c_19_p N_noxref_5_M9_noxref_s ) capacitor c=9.04186e-19 \
 //x=3.33 //y=3.1 //x2=2.875 //y2=5.02
cc_109 ( N_noxref_1_M9_noxref_g N_noxref_5_M9_noxref_s ) capacitor \
 c=0.0567929f //x=3.23 //y=6.02 //x2=2.875 //y2=5.02
cc_110 ( N_noxref_1_M10_noxref_g N_noxref_5_M10_noxref_d ) capacitor \
 c=0.015318f //x=3.67 //y=6.02 //x2=3.745 //y2=5.02
cc_111 ( N_noxref_1_c_18_p N_noxref_6_c_1278_n ) capacitor c=0.0242931f \
 //x=3.33 //y=2.78 //x2=4.07 //y2=4.555
cc_112 ( N_noxref_1_c_19_p N_noxref_6_c_1278_n ) capacitor c=0.0151778f \
 //x=3.33 //y=3.1 //x2=4.07 //y2=4.555
cc_113 ( N_noxref_1_c_73_p N_noxref_6_c_1278_n ) capacitor c=6.92705e-19 \
 //x=3.33 //y=2.96 //x2=4.07 //y2=4.555
cc_114 ( N_noxref_1_c_33_p N_noxref_6_c_1278_n ) capacitor c=0.0172958f \
 //x=3.33 //y=4.7 //x2=4.07 //y2=4.555
cc_115 ( N_noxref_1_c_23_p N_noxref_6_c_1278_n ) capacitor c=0.0632049f \
 //x=3.332 //y=4.56 //x2=4.07 //y2=4.555
cc_116 ( N_noxref_1_c_25_p N_noxref_6_c_1278_n ) capacitor c=0.00360383f \
 //x=3.33 //y=2.94 //x2=4.07 //y2=4.555
cc_117 ( N_noxref_1_c_117_p N_noxref_6_c_1278_n ) capacitor c=3.49899e-19 \
 //x=3.33 //y=2.08 //x2=4.07 //y2=4.555
cc_118 ( N_noxref_1_c_69_p N_noxref_6_c_1278_n ) capacitor c=7.76143e-19 \
 //x=3.33 //y=4.7 //x2=4.07 //y2=4.555
cc_119 ( N_noxref_1_c_72_p N_noxref_6_c_1278_n ) capacitor c=0.00201171f \
 //x=3.33 //y=4.7 //x2=4.07 //y2=4.555
cc_120 ( N_noxref_1_c_22_p N_noxref_6_c_1287_n ) capacitor c=0.0205342f \
 //x=3.33 //y=2.08 //x2=4.07 //y2=2.08
cc_121 ( N_noxref_1_c_117_p N_noxref_6_c_1287_n ) capacitor c=5.16867e-19 \
 //x=3.33 //y=2.08 //x2=4.07 //y2=2.08
cc_122 ( N_noxref_1_c_122_p N_noxref_6_c_1287_n ) capacitor c=0.00167888f \
 //x=3.135 //y=1.915 //x2=4.07 //y2=2.08
cc_123 ( N_noxref_1_c_18_p N_noxref_6_c_1290_n ) capacitor c=3.49899e-19 \
 //x=3.33 //y=2.78 //x2=4.07 //y2=2.08
cc_124 ( N_noxref_1_c_22_p N_noxref_6_c_1290_n ) capacitor c=5.24723e-19 \
 //x=3.33 //y=2.08 //x2=4.07 //y2=2.08
cc_125 ( N_noxref_1_c_117_p N_noxref_6_c_1290_n ) capacitor c=0.00525888f \
 //x=3.33 //y=2.08 //x2=4.07 //y2=2.08
cc_126 ( N_noxref_1_c_122_p N_noxref_6_c_1290_n ) capacitor c=0.00190888f \
 //x=3.135 //y=1.915 //x2=4.07 //y2=2.08
cc_127 ( N_noxref_1_c_33_p N_noxref_6_c_1294_n ) capacitor c=4.80626e-19 \
 //x=3.33 //y=4.7 //x2=4.1 //y2=4.7
cc_128 ( N_noxref_1_c_69_p N_noxref_6_c_1294_n ) capacitor c=0.00397338f \
 //x=3.33 //y=4.7 //x2=4.1 //y2=4.7
cc_129 ( N_noxref_1_c_72_p N_noxref_6_c_1294_n ) capacitor c=0.00283894f \
 //x=3.33 //y=4.7 //x2=4.1 //y2=4.7
cc_130 ( N_noxref_1_M9_noxref_g N_noxref_6_M11_noxref_g ) capacitor \
 c=0.0104892f //x=3.23 //y=6.02 //x2=4.11 //y2=6.02
cc_131 ( N_noxref_1_M10_noxref_g N_noxref_6_M11_noxref_g ) capacitor \
 c=0.107636f //x=3.67 //y=6.02 //x2=4.11 //y2=6.02
cc_132 ( N_noxref_1_M10_noxref_g N_noxref_6_M12_noxref_g ) capacitor \
 c=0.0100341f //x=3.67 //y=6.02 //x2=4.55 //y2=6.02
cc_133 ( N_noxref_1_c_133_p N_noxref_6_c_1300_n ) capacitor c=4.86545e-19 \
 //x=3.135 //y=0.865 //x2=4.105 //y2=0.905
cc_134 ( N_noxref_1_c_134_p N_noxref_6_c_1300_n ) capacitor c=0.00152405f \
 //x=3.135 //y=1.21 //x2=4.105 //y2=0.905
cc_135 ( N_noxref_1_c_135_p N_noxref_6_c_1300_n ) capacitor c=0.0151475f \
 //x=3.665 //y=0.865 //x2=4.105 //y2=0.905
cc_136 ( N_noxref_1_c_136_p N_noxref_6_c_1303_n ) capacitor c=0.00109982f \
 //x=3.135 //y=1.52 //x2=4.105 //y2=1.25
cc_137 ( N_noxref_1_c_137_p N_noxref_6_c_1303_n ) capacitor c=0.0111064f \
 //x=3.665 //y=1.21 //x2=4.105 //y2=1.25
cc_138 ( N_noxref_1_c_136_p N_noxref_6_c_1305_n ) capacitor c=9.58243e-19 \
 //x=3.135 //y=1.52 //x2=4.105 //y2=1.56
cc_139 ( N_noxref_1_c_122_p N_noxref_6_c_1305_n ) capacitor c=0.00662747f \
 //x=3.135 //y=1.915 //x2=4.105 //y2=1.56
cc_140 ( N_noxref_1_c_137_p N_noxref_6_c_1305_n ) capacitor c=0.00862358f \
 //x=3.665 //y=1.21 //x2=4.105 //y2=1.56
cc_141 ( N_noxref_1_c_135_p N_noxref_6_c_1308_n ) capacitor c=0.00127211f \
 //x=3.665 //y=0.865 //x2=4.635 //y2=0.905
cc_142 ( N_noxref_1_c_137_p N_noxref_6_c_1309_n ) capacitor c=0.00204774f \
 //x=3.665 //y=1.21 //x2=4.635 //y2=1.25
cc_143 ( N_noxref_1_c_22_p N_noxref_6_c_1310_n ) capacitor c=0.00167305f \
 //x=3.33 //y=2.08 //x2=4.07 //y2=2.08
cc_144 ( N_noxref_1_c_117_p N_noxref_6_c_1310_n ) capacitor c=0.0018937f \
 //x=3.33 //y=2.08 //x2=4.07 //y2=2.08
cc_145 ( N_noxref_1_c_122_p N_noxref_6_c_1310_n ) capacitor c=0.0181449f \
 //x=3.135 //y=1.915 //x2=4.07 //y2=2.08
cc_146 ( N_noxref_1_c_33_p N_noxref_6_c_1313_n ) capacitor c=0.00158715f \
 //x=3.33 //y=4.7 //x2=4.1 //y2=4.7
cc_147 ( N_noxref_1_c_69_p N_noxref_6_c_1313_n ) capacitor c=0.00237977f \
 //x=3.33 //y=4.7 //x2=4.1 //y2=4.7
cc_148 ( N_noxref_1_c_72_p N_noxref_6_c_1313_n ) capacitor c=0.0297875f \
 //x=3.33 //y=4.7 //x2=4.1 //y2=4.7
cc_149 ( N_noxref_1_c_16_p N_noxref_8_c_1499_n ) capacitor c=3.88844e-19 \
 //x=0.74 //y=3.12 //x2=3.315 //y2=0
cc_150 ( N_noxref_1_c_19_p N_noxref_8_c_1499_n ) capacitor c=4.05983e-19 \
 //x=3.33 //y=3.1 //x2=3.315 //y2=0
cc_151 ( N_noxref_1_c_20_p N_noxref_8_c_1499_n ) capacitor c=0.00248634f \
 //x=0.74 //y=2.085 //x2=3.315 //y2=0
cc_152 ( N_noxref_1_c_22_p N_noxref_8_c_1499_n ) capacitor c=6.60635e-19 \
 //x=3.33 //y=2.08 //x2=3.315 //y2=0
cc_153 ( N_noxref_1_c_27_p N_noxref_8_c_1499_n ) capacitor c=7.53892e-19 \
 //x=0.74 //y=2.085 //x2=3.315 //y2=0
cc_154 ( N_noxref_1_c_19_p N_noxref_8_c_1504_n ) capacitor c=2.36744e-19 \
 //x=3.33 //y=3.1 //x2=3.4 //y2=0.955
cc_155 ( N_noxref_1_c_22_p N_noxref_8_c_1504_n ) capacitor c=0.00677989f \
 //x=3.33 //y=2.08 //x2=3.4 //y2=0.955
cc_156 ( N_noxref_1_c_25_p N_noxref_8_c_1504_n ) capacitor c=0.00257254f \
 //x=3.33 //y=2.94 //x2=3.4 //y2=0.955
cc_157 ( N_noxref_1_c_117_p N_noxref_8_c_1504_n ) capacitor c=2.13705e-19 \
 //x=3.33 //y=2.08 //x2=3.4 //y2=0.955
cc_158 ( N_noxref_1_c_133_p N_noxref_8_c_1504_n ) capacitor c=0.00154831f \
 //x=3.135 //y=0.865 //x2=3.4 //y2=0.955
cc_159 ( N_noxref_1_c_134_p N_noxref_8_c_1504_n ) capacitor c=0.00354198f \
 //x=3.135 //y=1.21 //x2=3.4 //y2=0.955
cc_160 ( N_noxref_1_c_136_p N_noxref_8_c_1504_n ) capacitor c=4.2764e-19 \
 //x=3.135 //y=1.52 //x2=3.4 //y2=0.955
cc_161 ( N_noxref_1_c_161_p N_noxref_8_c_1504_n ) capacitor c=7.35788e-19 \
 //x=3.51 //y=0.71 //x2=3.4 //y2=0.955
cc_162 ( N_noxref_1_c_162_p N_noxref_8_c_1504_n ) capacitor c=6.22762e-19 \
 //x=3.51 //y=1.365 //x2=3.4 //y2=0.955
cc_163 ( N_noxref_1_c_135_p N_noxref_8_c_1504_n ) capacitor c=0.00171721f \
 //x=3.665 //y=0.865 //x2=3.4 //y2=0.955
cc_164 ( N_noxref_1_c_137_p N_noxref_8_c_1504_n ) capacitor c=0.00296337f \
 //x=3.665 //y=1.21 //x2=3.4 //y2=0.955
cc_165 ( N_noxref_1_c_133_p N_noxref_8_c_1515_n ) capacitor c=3.51399e-19 \
 //x=3.135 //y=0.865 //x2=3.397 //y2=0.825
cc_166 ( N_noxref_1_c_161_p N_noxref_8_c_1515_n ) capacitor c=0.00852028f \
 //x=3.51 //y=0.71 //x2=3.397 //y2=0.825
cc_167 ( N_noxref_1_c_135_p N_noxref_8_c_1515_n ) capacitor c=4.40641e-19 \
 //x=3.665 //y=0.865 //x2=3.397 //y2=0.825
cc_168 ( N_noxref_1_c_16_p N_noxref_8_c_1518_n ) capacitor c=5.03144e-19 \
 //x=0.74 //y=3.12 //x2=1.025 //y2=0.535
cc_169 ( N_noxref_1_c_20_p N_noxref_8_c_1518_n ) capacitor c=0.00114179f \
 //x=0.74 //y=2.085 //x2=1.025 //y2=0.535
cc_170 ( N_noxref_1_c_27_p N_noxref_8_c_1518_n ) capacitor c=3.95714e-19 \
 //x=0.74 //y=2.085 //x2=1.025 //y2=0.535
cc_171 ( N_noxref_1_c_39_p N_noxref_8_c_1518_n ) capacitor c=0.0126436f \
 //x=0.85 //y=0.91 //x2=1.025 //y2=0.535
cc_172 ( N_noxref_1_c_10_p N_noxref_8_c_1518_n ) capacitor c=2.1838e-19 \
 //x=0.74 //y=2.085 //x2=1.025 //y2=0.535
cc_173 ( N_noxref_1_c_43_p N_noxref_8_c_1523_n ) capacitor c=0.0132638f \
 //x=1.38 //y=0.91 //x2=1.515 //y2=0.535
cc_174 ( N_noxref_1_c_133_p N_noxref_8_c_1524_n ) capacitor c=0.00688065f \
 //x=3.135 //y=0.865 //x2=5.38 //y2=0
cc_175 ( N_noxref_1_c_15_p N_noxref_8_c_1525_n ) capacitor c=0.0146622f \
 //x=0.74 //y=2.8 //x2=0.63 //y2=0
cc_176 ( N_noxref_1_c_20_p N_noxref_8_c_1525_n ) capacitor c=0.0100674f \
 //x=0.74 //y=2.085 //x2=0.63 //y2=0
cc_177 ( N_noxref_1_c_27_p N_noxref_8_c_1525_n ) capacitor c=0.00789228f \
 //x=0.74 //y=2.085 //x2=0.63 //y2=0
cc_178 ( N_noxref_1_c_3_p N_noxref_8_c_1525_n ) capacitor c=0.00552086f \
 //x=0.85 //y=1.92 //x2=0.63 //y2=0
cc_179 ( N_noxref_1_c_10_p N_noxref_8_c_1525_n ) capacitor c=0.00687518f \
 //x=0.74 //y=2.085 //x2=0.63 //y2=0
cc_180 ( N_noxref_1_c_18_p N_noxref_8_c_1530_n ) capacitor c=0.00829739f \
 //x=3.33 //y=2.78 //x2=2.22 //y2=0
cc_181 ( N_noxref_1_c_22_p N_noxref_8_c_1530_n ) capacitor c=0.00427323f \
 //x=3.33 //y=2.08 //x2=2.22 //y2=0
cc_182 ( N_noxref_1_c_9_p N_noxref_8_c_1530_n ) capacitor c=0.00725422f \
 //x=3.17 //y=2.94 //x2=2.22 //y2=0
cc_183 ( N_noxref_1_c_27_p N_noxref_8_c_1530_n ) capacitor c=0.0022444f \
 //x=0.74 //y=2.085 //x2=2.22 //y2=0
cc_184 ( N_noxref_1_c_117_p N_noxref_8_c_1530_n ) capacitor c=0.0038607f \
 //x=3.33 //y=2.08 //x2=2.22 //y2=0
cc_185 ( N_noxref_1_c_122_p N_noxref_8_c_1530_n ) capacitor c=0.00887845f \
 //x=3.135 //y=1.915 //x2=2.22 //y2=0
cc_186 ( N_noxref_1_c_10_p N_noxref_8_c_1530_n ) capacitor c=2.63786e-19 \
 //x=0.74 //y=2.085 //x2=2.22 //y2=0
cc_187 ( N_noxref_1_c_16_p N_noxref_8_M0_noxref_s ) capacitor c=6.43426e-19 \
 //x=0.74 //y=3.12 //x2=0.495 //y2=0.37
cc_188 ( N_noxref_1_c_20_p N_noxref_8_M0_noxref_s ) capacitor c=0.00297844f \
 //x=0.74 //y=2.085 //x2=0.495 //y2=0.37
cc_189 ( N_noxref_1_c_9_p N_noxref_8_M0_noxref_s ) capacitor c=0.00184877f \
 //x=3.17 //y=2.94 //x2=0.495 //y2=0.37
cc_190 ( N_noxref_1_c_27_p N_noxref_8_M0_noxref_s ) capacitor c=0.00651272f \
 //x=0.74 //y=2.085 //x2=0.495 //y2=0.37
cc_191 ( N_noxref_1_c_39_p N_noxref_8_M0_noxref_s ) capacitor c=0.0300221f \
 //x=0.85 //y=0.91 //x2=0.495 //y2=0.37
cc_192 ( N_noxref_1_c_2_p N_noxref_8_M0_noxref_s ) capacitor c=0.002132f \
 //x=0.85 //y=1.565 //x2=0.495 //y2=0.37
cc_193 ( N_noxref_1_c_3_p N_noxref_8_M0_noxref_s ) capacitor c=0.00304786f \
 //x=0.85 //y=1.92 //x2=0.495 //y2=0.37
cc_194 ( N_noxref_1_c_41_p N_noxref_8_M0_noxref_s ) capacitor c=0.0052107f \
 //x=1.225 //y=0.755 //x2=0.495 //y2=0.37
cc_195 ( N_noxref_1_c_43_p N_noxref_8_M0_noxref_s ) capacitor c=0.0153553f \
 //x=1.38 //y=0.91 //x2=0.495 //y2=0.37
cc_196 ( N_noxref_1_c_5_p N_noxref_8_M0_noxref_s ) capacitor c=0.00629878f \
 //x=1.38 //y=1.255 //x2=0.495 //y2=0.37
cc_197 ( N_noxref_1_c_10_p N_noxref_8_M0_noxref_s ) capacitor c=0.00659899f \
 //x=0.74 //y=2.085 //x2=0.495 //y2=0.37
cc_198 ( N_noxref_1_c_22_p N_noxref_8_M1_noxref_d ) capacitor c=2.20438e-19 \
 //x=3.33 //y=2.08 //x2=3.21 //y2=0.865
cc_199 ( N_noxref_1_c_133_p N_noxref_8_M1_noxref_d ) capacitor c=0.00192399f \
 //x=3.135 //y=0.865 //x2=3.21 //y2=0.865
cc_200 ( N_noxref_1_c_134_p N_noxref_8_M1_noxref_d ) capacitor c=0.00210798f \
 //x=3.135 //y=1.21 //x2=3.21 //y2=0.865
cc_201 ( N_noxref_1_c_161_p N_noxref_8_M1_noxref_d ) capacitor c=0.00472259f \
 //x=3.51 //y=0.71 //x2=3.21 //y2=0.865
cc_202 ( N_noxref_1_c_162_p N_noxref_8_M1_noxref_d ) capacitor c=0.00166857f \
 //x=3.51 //y=1.365 //x2=3.21 //y2=0.865
cc_203 ( N_noxref_1_c_135_p N_noxref_8_M1_noxref_d ) capacitor c=0.00230174f \
 //x=3.665 //y=0.865 //x2=3.21 //y2=0.865
cc_204 ( N_noxref_1_c_137_p N_noxref_8_M1_noxref_d ) capacitor c=0.00210798f \
 //x=3.665 //y=1.21 //x2=3.21 //y2=0.865
cc_205 ( N_noxref_1_c_9_p N_noxref_10_c_1887_n ) capacitor c=0.00317601f \
 //x=3.17 //y=2.94 //x2=2.915 //y2=1.495
cc_206 ( N_noxref_1_c_122_p N_noxref_10_c_1887_n ) capacitor c=0.00262672f \
 //x=3.135 //y=1.915 //x2=2.915 //y2=1.495
cc_207 ( N_noxref_1_c_19_p N_noxref_10_c_1889_n ) capacitor c=0.00444167f \
 //x=3.33 //y=3.1 //x2=3.8 //y2=1.58
cc_208 ( N_noxref_1_c_22_p N_noxref_10_c_1889_n ) capacitor c=0.00459552f \
 //x=3.33 //y=2.08 //x2=3.8 //y2=1.58
cc_209 ( N_noxref_1_c_9_p N_noxref_10_c_1889_n ) capacitor c=0.00118517f \
 //x=3.17 //y=2.94 //x2=3.8 //y2=1.58
cc_210 ( N_noxref_1_c_117_p N_noxref_10_c_1889_n ) capacitor c=0.00763108f \
 //x=3.33 //y=2.08 //x2=3.8 //y2=1.58
cc_211 ( N_noxref_1_c_136_p N_noxref_10_c_1889_n ) capacitor c=0.00695869f \
 //x=3.135 //y=1.52 //x2=3.8 //y2=1.58
cc_212 ( N_noxref_1_c_122_p N_noxref_10_c_1889_n ) capacitor c=0.0175635f \
 //x=3.135 //y=1.915 //x2=3.8 //y2=1.58
cc_213 ( N_noxref_1_c_162_p N_noxref_10_c_1889_n ) capacitor c=0.00723574f \
 //x=3.51 //y=1.365 //x2=3.8 //y2=1.58
cc_214 ( N_noxref_1_c_137_p N_noxref_10_c_1889_n ) capacitor c=0.00339872f \
 //x=3.665 //y=1.21 //x2=3.8 //y2=1.58
cc_215 ( N_noxref_1_c_122_p N_noxref_10_c_1897_n ) capacitor c=6.71402e-19 \
 //x=3.135 //y=1.915 //x2=3.885 //y2=1.495
cc_216 ( N_noxref_1_c_133_p N_noxref_10_M1_noxref_s ) capacitor c=0.0294925f \
 //x=3.135 //y=0.865 //x2=2.78 //y2=0.365
cc_217 ( N_noxref_1_c_136_p N_noxref_10_M1_noxref_s ) capacitor c=3.48408e-19 \
 //x=3.135 //y=1.52 //x2=2.78 //y2=0.365
cc_218 ( N_noxref_1_c_135_p N_noxref_10_M1_noxref_s ) capacitor c=0.0125442f \
 //x=3.665 //y=0.865 //x2=2.78 //y2=0.365
cc_219 ( N_noxref_2_c_219_n N_noxref_3_c_487_n ) capacitor c=0.00495291f \
 //x=1.11 //y=1.755 //x2=4.37 //y2=1.57
cc_220 ( N_noxref_2_c_256_n N_noxref_3_c_487_n ) capacitor c=4.16137e-19 \
 //x=1.11 //y=1.005 //x2=4.37 //y2=1.57
cc_221 ( N_noxref_2_c_268_n N_noxref_3_c_489_n ) capacitor c=0.00651645f \
 //x=6.5 //y=3.34 //x2=4.455 //y2=1.655
cc_222 ( N_noxref_2_c_226_n N_noxref_3_c_472_n ) capacitor c=0.00198397f \
 //x=1.395 //y=1.84 //x2=4.81 //y2=2.78
cc_223 ( N_noxref_2_c_286_p N_noxref_3_c_472_n ) capacitor c=0.00929985f \
 //x=6.66 //y=3.18 //x2=4.81 //y2=2.78
cc_224 ( N_noxref_2_c_287_p N_noxref_3_c_472_n ) capacitor c=0.00457386f \
 //x=6.66 //y=2.08 //x2=4.81 //y2=2.78
cc_225 ( N_noxref_2_c_286_p N_noxref_3_c_493_n ) capacitor c=0.00256905f \
 //x=6.66 //y=3.18 //x2=4.81 //y2=3.1
cc_226 ( N_noxref_2_c_268_n N_noxref_3_c_493_n ) capacitor c=0.00857174f \
 //x=6.5 //y=3.34 //x2=4.81 //y2=3.1
cc_227 ( N_noxref_2_c_224_n N_noxref_3_c_473_n ) capacitor c=6.68558e-19 \
 //x=1.115 //y=5.24 //x2=4.81 //y2=5.115
cc_228 ( N_noxref_2_c_250_n N_noxref_3_c_473_n ) capacitor c=0.00212579f \
 //x=1.48 //y=4.875 //x2=4.81 //y2=5.115
cc_229 ( N_noxref_2_c_286_p N_noxref_3_c_473_n ) capacitor c=0.00129137f \
 //x=6.66 //y=3.18 //x2=4.81 //y2=5.115
cc_230 ( N_noxref_2_c_293_p N_noxref_3_c_473_n ) capacitor c=0.00254639f \
 //x=6.66 //y=3.5 //x2=4.81 //y2=5.115
cc_231 ( N_noxref_2_c_294_p N_noxref_3_c_473_n ) capacitor c=0.00476843f \
 //x=6.66 //y=4.7 //x2=4.81 //y2=5.115
cc_232 ( N_noxref_2_c_295_p N_noxref_3_c_473_n ) capacitor c=0.0194346f \
 //x=6.662 //y=4.56 //x2=4.81 //y2=5.115
cc_233 ( N_noxref_2_c_296_p N_noxref_3_c_473_n ) capacitor c=0.00158959f \
 //x=6.66 //y=3.34 //x2=4.81 //y2=5.115
cc_234 ( N_noxref_2_c_268_n N_noxref_3_c_473_n ) capacitor c=0.0292806f \
 //x=6.5 //y=3.34 //x2=4.81 //y2=5.115
cc_235 ( N_noxref_2_c_224_n N_noxref_3_c_474_n ) capacitor c=6.32156e-19 \
 //x=1.115 //y=5.24 //x2=3.45 //y2=5.38
cc_236 ( N_noxref_2_c_268_n N_noxref_3_c_474_n ) capacitor c=0.0131021f \
 //x=6.5 //y=3.34 //x2=3.45 //y2=5.38
cc_237 ( N_noxref_2_c_268_n N_noxref_3_c_505_n ) capacitor c=0.00981136f \
 //x=6.5 //y=3.34 //x2=4.33 //y2=5.2
cc_238 ( N_noxref_2_c_256_n N_noxref_3_c_506_n ) capacitor c=6.80839e-19 \
 //x=1.11 //y=1.005 //x2=4.37 //y2=1
cc_239 ( N_noxref_2_c_286_p N_noxref_3_c_507_n ) capacitor c=3.24031e-19 \
 //x=6.66 //y=3.18 //x2=6.275 //y2=2.96
cc_240 ( N_noxref_2_c_293_p N_noxref_3_c_507_n ) capacitor c=0.00244307f \
 //x=6.66 //y=3.5 //x2=6.275 //y2=2.96
cc_241 ( N_noxref_2_c_268_n N_noxref_3_c_507_n ) capacitor c=0.144922f //x=6.5 \
 //y=3.34 //x2=6.275 //y2=2.96
cc_242 ( N_noxref_2_c_286_p N_noxref_3_c_510_n ) capacitor c=0.0268444f \
 //x=6.66 //y=3.18 //x2=6.875 //y2=2.95
cc_243 ( N_noxref_2_c_293_p N_noxref_3_c_510_n ) capacitor c=0.00472421f \
 //x=6.66 //y=3.5 //x2=6.875 //y2=2.95
cc_244 ( N_noxref_2_c_287_p N_noxref_3_c_510_n ) capacitor c=0.00245317f \
 //x=6.66 //y=2.08 //x2=6.875 //y2=2.95
cc_245 ( N_noxref_2_c_296_p N_noxref_3_c_510_n ) capacitor c=0.0369869f \
 //x=6.66 //y=3.34 //x2=6.875 //y2=2.95
cc_246 ( N_noxref_2_c_286_p N_noxref_3_c_481_n ) capacitor c=0.00150178f \
 //x=6.66 //y=3.18 //x2=4.97 //y2=2.94
cc_247 ( N_noxref_2_c_268_n N_noxref_3_c_481_n ) capacitor c=0.0369869f \
 //x=6.5 //y=3.34 //x2=4.97 //y2=2.94
cc_248 ( N_noxref_2_M14_noxref_g N_noxref_4_c_775_n ) capacitor c=0.0129249f \
 //x=7 //y=6.02 //x2=7.545 //y2=5.2
cc_249 ( N_noxref_2_c_286_p N_noxref_4_c_776_n ) capacitor c=0.00351945f \
 //x=6.66 //y=3.18 //x2=8.14 //y2=3.18
cc_250 ( N_noxref_2_c_295_p N_noxref_4_c_777_n ) capacitor c=0.00325019f \
 //x=6.662 //y=4.56 //x2=8.14 //y2=5.115
cc_251 ( N_noxref_2_c_293_p N_noxref_4_c_778_n ) capacitor c=6.41839e-19 \
 //x=6.66 //y=3.5 //x2=6.78 //y2=5.38
cc_252 ( N_noxref_2_c_294_p N_noxref_4_c_778_n ) capacitor c=0.01183f //x=6.66 \
 //y=4.7 //x2=6.78 //y2=5.38
cc_253 ( N_noxref_2_c_296_p N_noxref_4_c_778_n ) capacitor c=4.40123e-19 \
 //x=6.66 //y=3.34 //x2=6.78 //y2=5.38
cc_254 ( N_noxref_2_c_317_p N_noxref_4_c_778_n ) capacitor c=0.00277154f \
 //x=6.66 //y=4.7 //x2=6.78 //y2=5.38
cc_255 ( N_noxref_2_M13_noxref_g N_noxref_4_c_778_n ) capacitor c=0.00201806f \
 //x=6.56 //y=6.02 //x2=6.78 //y2=5.38
cc_256 ( N_noxref_2_M14_noxref_g N_noxref_4_c_778_n ) capacitor c=0.00192712f \
 //x=7 //y=6.02 //x2=6.78 //y2=5.38
cc_257 ( N_noxref_2_c_320_p N_noxref_4_c_778_n ) capacitor c=0.00192579f \
 //x=6.66 //y=4.7 //x2=6.78 //y2=5.38
cc_258 ( N_noxref_2_c_321_p N_noxref_4_c_785_n ) capacitor c=0.00251935f \
 //x=6.66 //y=3.33 //x2=8.14 //y2=3.33
cc_259 ( N_noxref_2_c_296_p N_noxref_4_c_786_n ) capacitor c=0.00541849f \
 //x=6.66 //y=3.34 //x2=8.3 //y2=3.34
cc_260 ( N_noxref_2_c_294_p N_noxref_4_c_787_n ) capacitor c=0.00104426f \
 //x=6.66 //y=4.7 //x2=6.78 //y2=5.38
cc_261 ( N_noxref_2_c_317_p N_noxref_4_c_787_n ) capacitor c=0.00377369f \
 //x=6.66 //y=4.7 //x2=6.78 //y2=5.38
cc_262 ( N_noxref_2_M13_noxref_g N_noxref_4_c_787_n ) capacitor c=0.0158358f \
 //x=6.56 //y=6.02 //x2=6.78 //y2=5.38
cc_263 ( N_noxref_2_M14_noxref_g N_noxref_4_c_787_n ) capacitor c=0.0178987f \
 //x=7 //y=6.02 //x2=6.78 //y2=5.38
cc_264 ( N_noxref_2_c_320_p N_noxref_4_c_787_n ) capacitor c=0.0043218f \
 //x=6.66 //y=4.7 //x2=6.78 //y2=5.38
cc_265 ( N_noxref_2_c_224_n N_noxref_5_c_1050_n ) capacitor c=0.00259272f \
 //x=1.115 //y=5.24 //x2=11.47 //y2=7.4
cc_266 ( N_noxref_2_c_229_n N_noxref_5_c_1050_n ) capacitor c=0.00266287f \
 //x=1.395 //y=4.96 //x2=11.47 //y2=7.4
cc_267 ( N_noxref_2_c_294_p N_noxref_5_c_1050_n ) capacitor c=9.05427e-19 \
 //x=6.66 //y=4.7 //x2=11.47 //y2=7.4
cc_268 ( N_noxref_2_c_273_n N_noxref_5_c_1050_n ) capacitor c=0.0024144f \
 //x=1.115 //y=5.38 //x2=11.47 //y2=7.4
cc_269 ( N_noxref_2_c_317_p N_noxref_5_c_1050_n ) capacitor c=6.23118e-19 \
 //x=6.66 //y=4.7 //x2=11.47 //y2=7.4
cc_270 ( N_noxref_2_c_224_n N_noxref_5_c_1055_n ) capacitor c=0.0010065f \
 //x=1.115 //y=5.24 //x2=1.47 //y2=7.4
cc_271 ( N_noxref_2_c_229_n N_noxref_5_c_1055_n ) capacitor c=0.00197518f \
 //x=1.395 //y=4.96 //x2=1.47 //y2=7.4
cc_272 ( N_noxref_2_c_273_n N_noxref_5_c_1055_n ) capacitor c=0.0137788f \
 //x=1.115 //y=5.38 //x2=1.47 //y2=7.4
cc_273 ( N_noxref_2_c_294_p N_noxref_5_c_1089_n ) capacitor c=6.28732e-19 \
 //x=6.66 //y=4.7 //x2=7.135 //y2=7.4
cc_274 ( N_noxref_2_M13_noxref_g N_noxref_5_c_1089_n ) capacitor c=0.0072715f \
 //x=6.56 //y=6.02 //x2=7.135 //y2=7.4
cc_275 ( N_noxref_2_M14_noxref_g N_noxref_5_c_1089_n ) capacitor c=0.00749619f \
 //x=7 //y=6.02 //x2=7.135 //y2=7.4
cc_276 ( N_noxref_2_c_230_n N_noxref_5_c_1061_n ) capacitor c=0.00685597f \
 //x=1.2 //y=4.96 //x2=0.74 //y2=7.4
cc_277 ( N_noxref_2_c_250_n N_noxref_5_c_1061_n ) capacitor c=2.43252e-19 \
 //x=1.48 //y=4.875 //x2=0.74 //y2=7.4
cc_278 ( N_noxref_2_c_273_n N_noxref_5_c_1061_n ) capacitor c=0.00823838f \
 //x=1.115 //y=5.38 //x2=0.74 //y2=7.4
cc_279 ( N_noxref_2_c_224_n N_noxref_5_c_1065_n ) capacitor c=0.00231872f \
 //x=1.115 //y=5.24 //x2=2.22 //y2=7.4
cc_280 ( N_noxref_2_c_250_n N_noxref_5_c_1065_n ) capacitor c=0.022346f \
 //x=1.48 //y=4.875 //x2=2.22 //y2=7.4
cc_281 ( N_noxref_2_c_268_n N_noxref_5_c_1065_n ) capacitor c=0.00501351f \
 //x=6.5 //y=3.34 //x2=2.22 //y2=7.4
cc_282 ( N_noxref_2_c_273_n N_noxref_5_c_1065_n ) capacitor c=0.00824867f \
 //x=1.115 //y=5.38 //x2=2.22 //y2=7.4
cc_283 ( N_noxref_2_c_294_p N_noxref_5_c_1099_n ) capacitor c=0.00447349f \
 //x=6.66 //y=4.7 //x2=5.55 //y2=7.4
cc_284 ( N_noxref_2_c_295_p N_noxref_5_c_1099_n ) capacitor c=0.00733791f \
 //x=6.662 //y=4.56 //x2=5.55 //y2=7.4
cc_285 ( N_noxref_2_c_268_n N_noxref_5_c_1099_n ) capacitor c=0.00501351f \
 //x=6.5 //y=3.34 //x2=5.55 //y2=7.4
cc_286 ( N_noxref_2_c_317_p N_noxref_5_c_1099_n ) capacitor c=0.00370494f \
 //x=6.66 //y=4.7 //x2=5.55 //y2=7.4
cc_287 ( N_noxref_2_c_320_p N_noxref_5_c_1099_n ) capacitor c=0.0129564f \
 //x=6.66 //y=4.7 //x2=5.55 //y2=7.4
cc_288 ( N_noxref_2_c_273_n N_noxref_5_c_1104_n ) capacitor c=0.00135089f \
 //x=1.115 //y=5.38 //x2=11.47 //y2=7.4
cc_289 ( N_noxref_2_c_224_n N_noxref_5_M7_noxref_s ) capacitor c=0.0480012f \
 //x=1.115 //y=5.24 //x2=0.54 //y2=5.02
cc_290 ( N_noxref_2_c_273_n N_noxref_5_M7_noxref_s ) capacitor c=0.0922749f \
 //x=1.115 //y=5.38 //x2=0.54 //y2=5.02
cc_291 ( N_noxref_2_c_224_n N_noxref_5_M8_noxref_d ) capacitor c=0.0474638f \
 //x=1.115 //y=5.24 //x2=1.41 //y2=5.02
cc_292 ( N_noxref_2_c_229_n N_noxref_5_M8_noxref_d ) capacitor c=0.0212582f \
 //x=1.395 //y=4.96 //x2=1.41 //y2=5.02
cc_293 ( N_noxref_2_c_247_n N_noxref_5_M8_noxref_d ) capacitor c=0.00236133f \
 //x=1.48 //y=3.51 //x2=1.41 //y2=5.02
cc_294 ( N_noxref_2_c_263_n N_noxref_5_M8_noxref_d ) capacitor c=3.07468e-19 \
 //x=1.48 //y=3.33 //x2=1.41 //y2=5.02
cc_295 ( N_noxref_2_c_265_n N_noxref_5_M8_noxref_d ) capacitor c=7.86037e-19 \
 //x=1.64 //y=3.35 //x2=1.41 //y2=5.02
cc_296 ( N_noxref_2_c_268_n N_noxref_5_M8_noxref_d ) capacitor c=3.76077e-19 \
 //x=6.5 //y=3.34 //x2=1.41 //y2=5.02
cc_297 ( N_noxref_2_c_273_n N_noxref_5_M8_noxref_d ) capacitor c=0.0911955f \
 //x=1.115 //y=5.38 //x2=1.41 //y2=5.02
cc_298 ( N_noxref_2_c_224_n N_noxref_5_M9_noxref_s ) capacitor c=0.00155698f \
 //x=1.115 //y=5.24 //x2=2.875 //y2=5.02
cc_299 ( N_noxref_2_c_268_n N_noxref_5_M9_noxref_s ) capacitor c=0.0037282f \
 //x=6.5 //y=3.34 //x2=2.875 //y2=5.02
cc_300 ( N_noxref_2_c_293_p N_noxref_5_M13_noxref_s ) capacitor c=0.0010689f \
 //x=6.66 //y=3.5 //x2=6.205 //y2=5.02
cc_301 ( N_noxref_2_c_268_n N_noxref_5_M13_noxref_s ) capacitor c=0.00359545f \
 //x=6.5 //y=3.34 //x2=6.205 //y2=5.02
cc_302 ( N_noxref_2_M13_noxref_g N_noxref_5_M13_noxref_s ) capacitor \
 c=0.0567929f //x=6.56 //y=6.02 //x2=6.205 //y2=5.02
cc_303 ( N_noxref_2_M14_noxref_g N_noxref_5_M14_noxref_d ) capacitor \
 c=0.015318f //x=7 //y=6.02 //x2=7.075 //y2=5.02
cc_304 ( N_noxref_2_c_233_n N_noxref_6_c_1278_n ) capacitor c=0.00284096f \
 //x=1.48 //y=3.19 //x2=4.07 //y2=4.555
cc_305 ( N_noxref_2_c_250_n N_noxref_6_c_1278_n ) capacitor c=0.00238388f \
 //x=1.48 //y=4.875 //x2=4.07 //y2=4.555
cc_306 ( N_noxref_2_c_286_p N_noxref_6_c_1278_n ) capacitor c=0.00277806f \
 //x=6.66 //y=3.18 //x2=4.07 //y2=4.555
cc_307 ( N_noxref_2_c_295_p N_noxref_6_c_1278_n ) capacitor c=0.00209698f \
 //x=6.662 //y=4.56 //x2=4.07 //y2=4.555
cc_308 ( N_noxref_2_c_268_n N_noxref_6_c_1278_n ) capacitor c=0.0330093f \
 //x=6.5 //y=3.34 //x2=4.07 //y2=4.555
cc_309 ( N_noxref_2_c_268_n N_noxref_6_c_1287_n ) capacitor c=0.00255328f \
 //x=6.5 //y=3.34 //x2=4.07 //y2=2.08
cc_310 ( N_noxref_2_c_286_p N_noxref_7_c_1389_n ) capacitor c=0.0394956f \
 //x=6.66 //y=3.18 //x2=7.4 //y2=4.555
cc_311 ( N_noxref_2_c_293_p N_noxref_7_c_1389_n ) capacitor c=0.0148747f \
 //x=6.66 //y=3.5 //x2=7.4 //y2=4.555
cc_312 ( N_noxref_2_c_321_p N_noxref_7_c_1389_n ) capacitor c=6.02403e-19 \
 //x=6.66 //y=3.33 //x2=7.4 //y2=4.555
cc_313 ( N_noxref_2_c_294_p N_noxref_7_c_1389_n ) capacitor c=0.0172958f \
 //x=6.66 //y=4.7 //x2=7.4 //y2=4.555
cc_314 ( N_noxref_2_c_295_p N_noxref_7_c_1389_n ) capacitor c=0.0480316f \
 //x=6.662 //y=4.56 //x2=7.4 //y2=4.555
cc_315 ( N_noxref_2_c_296_p N_noxref_7_c_1389_n ) capacitor c=0.00360246f \
 //x=6.66 //y=3.34 //x2=7.4 //y2=4.555
cc_316 ( N_noxref_2_c_379_p N_noxref_7_c_1389_n ) capacitor c=3.49899e-19 \
 //x=6.66 //y=2.08 //x2=7.4 //y2=4.555
cc_317 ( N_noxref_2_c_317_p N_noxref_7_c_1389_n ) capacitor c=7.76099e-19 \
 //x=6.66 //y=4.7 //x2=7.4 //y2=4.555
cc_318 ( N_noxref_2_c_320_p N_noxref_7_c_1389_n ) capacitor c=0.00201171f \
 //x=6.66 //y=4.7 //x2=7.4 //y2=4.555
cc_319 ( N_noxref_2_c_287_p N_noxref_7_c_1398_n ) capacitor c=0.0205342f \
 //x=6.66 //y=2.08 //x2=7.4 //y2=2.08
cc_320 ( N_noxref_2_c_379_p N_noxref_7_c_1398_n ) capacitor c=5.16867e-19 \
 //x=6.66 //y=2.08 //x2=7.4 //y2=2.08
cc_321 ( N_noxref_2_c_384_p N_noxref_7_c_1398_n ) capacitor c=0.00167888f \
 //x=6.465 //y=1.915 //x2=7.4 //y2=2.08
cc_322 ( N_noxref_2_c_286_p N_noxref_7_c_1401_n ) capacitor c=3.49899e-19 \
 //x=6.66 //y=3.18 //x2=7.4 //y2=2.08
cc_323 ( N_noxref_2_c_287_p N_noxref_7_c_1401_n ) capacitor c=5.24723e-19 \
 //x=6.66 //y=2.08 //x2=7.4 //y2=2.08
cc_324 ( N_noxref_2_c_379_p N_noxref_7_c_1401_n ) capacitor c=0.00525888f \
 //x=6.66 //y=2.08 //x2=7.4 //y2=2.08
cc_325 ( N_noxref_2_c_384_p N_noxref_7_c_1401_n ) capacitor c=0.00190888f \
 //x=6.465 //y=1.915 //x2=7.4 //y2=2.08
cc_326 ( N_noxref_2_c_294_p N_noxref_7_c_1405_n ) capacitor c=4.80626e-19 \
 //x=6.66 //y=4.7 //x2=7.43 //y2=4.7
cc_327 ( N_noxref_2_c_317_p N_noxref_7_c_1405_n ) capacitor c=0.00397338f \
 //x=6.66 //y=4.7 //x2=7.43 //y2=4.7
cc_328 ( N_noxref_2_c_320_p N_noxref_7_c_1405_n ) capacitor c=0.00283894f \
 //x=6.66 //y=4.7 //x2=7.43 //y2=4.7
cc_329 ( N_noxref_2_M13_noxref_g N_noxref_7_M15_noxref_g ) capacitor \
 c=0.0104892f //x=6.56 //y=6.02 //x2=7.44 //y2=6.02
cc_330 ( N_noxref_2_M14_noxref_g N_noxref_7_M15_noxref_g ) capacitor \
 c=0.107636f //x=7 //y=6.02 //x2=7.44 //y2=6.02
cc_331 ( N_noxref_2_M14_noxref_g N_noxref_7_M16_noxref_g ) capacitor \
 c=0.0100341f //x=7 //y=6.02 //x2=7.88 //y2=6.02
cc_332 ( N_noxref_2_c_395_p N_noxref_7_c_1411_n ) capacitor c=4.86545e-19 \
 //x=6.465 //y=0.865 //x2=7.435 //y2=0.905
cc_333 ( N_noxref_2_c_396_p N_noxref_7_c_1411_n ) capacitor c=0.00152405f \
 //x=6.465 //y=1.21 //x2=7.435 //y2=0.905
cc_334 ( N_noxref_2_c_397_p N_noxref_7_c_1411_n ) capacitor c=0.0151475f \
 //x=6.995 //y=0.865 //x2=7.435 //y2=0.905
cc_335 ( N_noxref_2_c_398_p N_noxref_7_c_1414_n ) capacitor c=0.00109982f \
 //x=6.465 //y=1.52 //x2=7.435 //y2=1.25
cc_336 ( N_noxref_2_c_399_p N_noxref_7_c_1414_n ) capacitor c=0.0111064f \
 //x=6.995 //y=1.21 //x2=7.435 //y2=1.25
cc_337 ( N_noxref_2_c_398_p N_noxref_7_c_1416_n ) capacitor c=9.58243e-19 \
 //x=6.465 //y=1.52 //x2=7.435 //y2=1.56
cc_338 ( N_noxref_2_c_384_p N_noxref_7_c_1416_n ) capacitor c=0.00662747f \
 //x=6.465 //y=1.915 //x2=7.435 //y2=1.56
cc_339 ( N_noxref_2_c_399_p N_noxref_7_c_1416_n ) capacitor c=0.00862358f \
 //x=6.995 //y=1.21 //x2=7.435 //y2=1.56
cc_340 ( N_noxref_2_c_397_p N_noxref_7_c_1419_n ) capacitor c=0.00127211f \
 //x=6.995 //y=0.865 //x2=7.965 //y2=0.905
cc_341 ( N_noxref_2_c_399_p N_noxref_7_c_1420_n ) capacitor c=0.00204774f \
 //x=6.995 //y=1.21 //x2=7.965 //y2=1.25
cc_342 ( N_noxref_2_c_287_p N_noxref_7_c_1421_n ) capacitor c=0.00167305f \
 //x=6.66 //y=2.08 //x2=7.4 //y2=2.08
cc_343 ( N_noxref_2_c_379_p N_noxref_7_c_1421_n ) capacitor c=0.0018937f \
 //x=6.66 //y=2.08 //x2=7.4 //y2=2.08
cc_344 ( N_noxref_2_c_384_p N_noxref_7_c_1421_n ) capacitor c=0.0181449f \
 //x=6.465 //y=1.915 //x2=7.4 //y2=2.08
cc_345 ( N_noxref_2_c_294_p N_noxref_7_c_1424_n ) capacitor c=0.00158715f \
 //x=6.66 //y=4.7 //x2=7.43 //y2=4.7
cc_346 ( N_noxref_2_c_317_p N_noxref_7_c_1424_n ) capacitor c=0.00237977f \
 //x=6.66 //y=4.7 //x2=7.43 //y2=4.7
cc_347 ( N_noxref_2_c_320_p N_noxref_7_c_1424_n ) capacitor c=0.0297875f \
 //x=6.66 //y=4.7 //x2=7.43 //y2=4.7
cc_348 ( N_noxref_2_c_226_n N_noxref_8_c_1499_n ) capacitor c=0.00498327f \
 //x=1.395 //y=1.84 //x2=3.315 //y2=0
cc_349 ( N_noxref_2_c_247_n N_noxref_8_c_1499_n ) capacitor c=5.20215e-19 \
 //x=1.48 //y=3.51 //x2=3.315 //y2=0
cc_350 ( N_noxref_2_c_256_n N_noxref_8_c_1499_n ) capacitor c=0.00996824f \
 //x=1.11 //y=1.005 //x2=3.315 //y2=0
cc_351 ( N_noxref_2_c_263_n N_noxref_8_c_1499_n ) capacitor c=2.38705e-19 \
 //x=1.48 //y=3.33 //x2=3.315 //y2=0
cc_352 ( N_noxref_2_M0_noxref_d N_noxref_8_c_1499_n ) capacitor c=0.00119583f \
 //x=0.925 //y=0.91 //x2=3.315 //y2=0
cc_353 ( N_noxref_2_c_256_n N_noxref_8_c_1504_n ) capacitor c=0.00524331f \
 //x=1.11 //y=1.005 //x2=3.4 //y2=0.955
cc_354 ( N_noxref_2_c_287_p N_noxref_8_c_1561_n ) capacitor c=0.00680904f \
 //x=6.66 //y=2.08 //x2=6.73 //y2=0.955
cc_355 ( N_noxref_2_c_379_p N_noxref_8_c_1561_n ) capacitor c=2.13705e-19 \
 //x=6.66 //y=2.08 //x2=6.73 //y2=0.955
cc_356 ( N_noxref_2_c_395_p N_noxref_8_c_1561_n ) capacitor c=0.00171023f \
 //x=6.465 //y=0.865 //x2=6.73 //y2=0.955
cc_357 ( N_noxref_2_c_396_p N_noxref_8_c_1561_n ) capacitor c=0.00357815f \
 //x=6.465 //y=1.21 //x2=6.73 //y2=0.955
cc_358 ( N_noxref_2_c_398_p N_noxref_8_c_1561_n ) capacitor c=4.2764e-19 \
 //x=6.465 //y=1.52 //x2=6.73 //y2=0.955
cc_359 ( N_noxref_2_c_422_p N_noxref_8_c_1561_n ) capacitor c=9.36995e-19 \
 //x=6.84 //y=0.71 //x2=6.73 //y2=0.955
cc_360 ( N_noxref_2_c_423_p N_noxref_8_c_1561_n ) capacitor c=6.27576e-19 \
 //x=6.84 //y=1.365 //x2=6.73 //y2=0.955
cc_361 ( N_noxref_2_c_397_p N_noxref_8_c_1561_n ) capacitor c=0.00171721f \
 //x=6.995 //y=0.865 //x2=6.73 //y2=0.955
cc_362 ( N_noxref_2_c_399_p N_noxref_8_c_1561_n ) capacitor c=0.00296337f \
 //x=6.995 //y=1.21 //x2=6.73 //y2=0.955
cc_363 ( N_noxref_2_c_395_p N_noxref_8_c_1570_n ) capacitor c=3.46594e-19 \
 //x=6.465 //y=0.865 //x2=6.727 //y2=0.825
cc_364 ( N_noxref_2_c_422_p N_noxref_8_c_1570_n ) capacitor c=0.00839621f \
 //x=6.84 //y=0.71 //x2=6.727 //y2=0.825
cc_365 ( N_noxref_2_c_397_p N_noxref_8_c_1570_n ) capacitor c=4.40641e-19 \
 //x=6.995 //y=0.865 //x2=6.727 //y2=0.825
cc_366 ( N_noxref_2_c_256_n N_noxref_8_c_1518_n ) capacitor c=0.00127229f \
 //x=1.11 //y=1.005 //x2=1.025 //y2=0.535
cc_367 ( N_noxref_2_c_226_n N_noxref_8_c_1523_n ) capacitor c=0.0031589f \
 //x=1.395 //y=1.84 //x2=1.515 //y2=0.535
cc_368 ( N_noxref_2_c_256_n N_noxref_8_c_1523_n ) capacitor c=0.00130436f \
 //x=1.11 //y=1.005 //x2=1.515 //y2=0.535
cc_369 ( N_noxref_2_c_263_n N_noxref_8_c_1523_n ) capacitor c=2.81376e-19 \
 //x=1.48 //y=3.33 //x2=1.515 //y2=0.535
cc_370 ( N_noxref_2_c_395_p N_noxref_8_c_1577_n ) capacitor c=0.00685132f \
 //x=6.465 //y=0.865 //x2=8.71 //y2=0
cc_371 ( N_noxref_2_c_256_n N_noxref_8_c_1578_n ) capacitor c=2.8029e-19 \
 //x=1.11 //y=1.005 //x2=11.47 //y2=0
cc_372 ( N_noxref_2_M0_noxref_d N_noxref_8_c_1578_n ) capacitor c=2.70835e-19 \
 //x=0.925 //y=0.91 //x2=11.47 //y2=0
cc_373 ( N_noxref_2_c_219_n N_noxref_8_c_1525_n ) capacitor c=0.00520602f \
 //x=1.11 //y=1.755 //x2=0.63 //y2=0
cc_374 ( N_noxref_2_c_233_n N_noxref_8_c_1525_n ) capacitor c=2.14154e-19 \
 //x=1.48 //y=3.19 //x2=0.63 //y2=0
cc_375 ( N_noxref_2_c_226_n N_noxref_8_c_1530_n ) capacitor c=0.0230294f \
 //x=1.395 //y=1.84 //x2=2.22 //y2=0
cc_376 ( N_noxref_2_c_286_p N_noxref_8_c_1583_n ) capacitor c=0.00829739f \
 //x=6.66 //y=3.18 //x2=5.55 //y2=0
cc_377 ( N_noxref_2_c_287_p N_noxref_8_c_1583_n ) capacitor c=0.00427323f \
 //x=6.66 //y=2.08 //x2=5.55 //y2=0
cc_378 ( N_noxref_2_c_379_p N_noxref_8_c_1583_n ) capacitor c=0.00369427f \
 //x=6.66 //y=2.08 //x2=5.55 //y2=0
cc_379 ( N_noxref_2_c_398_p N_noxref_8_c_1583_n ) capacitor c=0.0015404f \
 //x=6.465 //y=1.52 //x2=5.55 //y2=0
cc_380 ( N_noxref_2_c_384_p N_noxref_8_c_1583_n ) capacitor c=0.00950704f \
 //x=6.465 //y=1.915 //x2=5.55 //y2=0
cc_381 ( N_noxref_2_c_219_n N_noxref_8_M0_noxref_s ) capacitor c=0.0339428f \
 //x=1.11 //y=1.755 //x2=0.495 //y2=0.37
cc_382 ( N_noxref_2_c_226_n N_noxref_8_M0_noxref_s ) capacitor c=0.00386149f \
 //x=1.395 //y=1.84 //x2=0.495 //y2=0.37
cc_383 ( N_noxref_2_c_247_n N_noxref_8_M0_noxref_s ) capacitor c=0.00140561f \
 //x=1.48 //y=3.51 //x2=0.495 //y2=0.37
cc_384 ( N_noxref_2_c_256_n N_noxref_8_M0_noxref_s ) capacitor c=0.0157313f \
 //x=1.11 //y=1.005 //x2=0.495 //y2=0.37
cc_385 ( N_noxref_2_c_263_n N_noxref_8_M0_noxref_s ) capacitor c=7.90259e-19 \
 //x=1.48 //y=3.33 //x2=0.495 //y2=0.37
cc_386 ( N_noxref_2_M0_noxref_d N_noxref_8_M0_noxref_s ) capacitor \
 c=0.0377604f //x=0.925 //y=0.91 //x2=0.495 //y2=0.37
cc_387 ( N_noxref_2_c_287_p N_noxref_8_M3_noxref_d ) capacitor c=2.20438e-19 \
 //x=6.66 //y=2.08 //x2=6.54 //y2=0.865
cc_388 ( N_noxref_2_c_395_p N_noxref_8_M3_noxref_d ) capacitor c=0.00192399f \
 //x=6.465 //y=0.865 //x2=6.54 //y2=0.865
cc_389 ( N_noxref_2_c_396_p N_noxref_8_M3_noxref_d ) capacitor c=0.00210798f \
 //x=6.465 //y=1.21 //x2=6.54 //y2=0.865
cc_390 ( N_noxref_2_c_422_p N_noxref_8_M3_noxref_d ) capacitor c=0.00472259f \
 //x=6.84 //y=0.71 //x2=6.54 //y2=0.865
cc_391 ( N_noxref_2_c_423_p N_noxref_8_M3_noxref_d ) capacitor c=0.00166857f \
 //x=6.84 //y=1.365 //x2=6.54 //y2=0.865
cc_392 ( N_noxref_2_c_397_p N_noxref_8_M3_noxref_d ) capacitor c=0.00230174f \
 //x=6.995 //y=0.865 //x2=6.54 //y2=0.865
cc_393 ( N_noxref_2_c_399_p N_noxref_8_M3_noxref_d ) capacitor c=0.00210798f \
 //x=6.995 //y=1.21 //x2=6.54 //y2=0.865
cc_394 ( N_noxref_2_c_268_n N_noxref_10_c_1889_n ) capacitor c=0.00417624f \
 //x=6.5 //y=3.34 //x2=3.8 //y2=1.58
cc_395 ( N_noxref_2_c_268_n N_noxref_10_c_1897_n ) capacitor c=0.00225522f \
 //x=6.5 //y=3.34 //x2=3.885 //y2=1.495
cc_396 ( N_noxref_2_c_384_p N_noxref_11_c_1956_n ) capacitor c=0.00262672f \
 //x=6.465 //y=1.915 //x2=6.245 //y2=1.495
cc_397 ( N_noxref_2_c_293_p N_noxref_11_c_1957_n ) capacitor c=0.00405959f \
 //x=6.66 //y=3.5 //x2=7.13 //y2=1.58
cc_398 ( N_noxref_2_c_287_p N_noxref_11_c_1957_n ) capacitor c=0.00509504f \
 //x=6.66 //y=2.08 //x2=7.13 //y2=1.58
cc_399 ( N_noxref_2_c_379_p N_noxref_11_c_1957_n ) capacitor c=0.00763108f \
 //x=6.66 //y=2.08 //x2=7.13 //y2=1.58
cc_400 ( N_noxref_2_c_398_p N_noxref_11_c_1957_n ) capacitor c=0.00697076f \
 //x=6.465 //y=1.52 //x2=7.13 //y2=1.58
cc_401 ( N_noxref_2_c_384_p N_noxref_11_c_1957_n ) capacitor c=0.017926f \
 //x=6.465 //y=1.915 //x2=7.13 //y2=1.58
cc_402 ( N_noxref_2_c_423_p N_noxref_11_c_1957_n ) capacitor c=0.00723574f \
 //x=6.84 //y=1.365 //x2=7.13 //y2=1.58
cc_403 ( N_noxref_2_c_399_p N_noxref_11_c_1957_n ) capacitor c=0.00339872f \
 //x=6.995 //y=1.21 //x2=7.13 //y2=1.58
cc_404 ( N_noxref_2_c_384_p N_noxref_11_c_1964_n ) capacitor c=6.71402e-19 \
 //x=6.465 //y=1.915 //x2=7.215 //y2=1.495
cc_405 ( N_noxref_2_c_395_p N_noxref_11_M3_noxref_s ) capacitor c=0.0294925f \
 //x=6.465 //y=0.865 //x2=6.11 //y2=0.365
cc_406 ( N_noxref_2_c_398_p N_noxref_11_M3_noxref_s ) capacitor c=3.48408e-19 \
 //x=6.465 //y=1.52 //x2=6.11 //y2=0.365
cc_407 ( N_noxref_2_c_397_p N_noxref_11_M3_noxref_s ) capacitor c=0.0125442f \
 //x=6.995 //y=0.865 //x2=6.11 //y2=0.365
cc_408 ( N_noxref_3_c_487_n N_noxref_4_c_792_n ) capacitor c=0.00324213f \
 //x=4.37 //y=1.57 //x2=7.7 //y2=1.57
cc_409 ( N_noxref_3_c_517_p N_noxref_4_c_793_n ) capacitor c=0.00434482f \
 //x=7.755 //y=2.96 //x2=8.055 //y2=1.655
cc_410 ( N_noxref_3_c_518_p N_noxref_4_c_794_n ) capacitor c=0.00231467f \
 //x=4.725 //y=1.655 //x2=7.785 //y2=1.655
cc_411 ( N_noxref_3_c_517_p N_noxref_4_c_794_n ) capacitor c=0.00482943f \
 //x=7.755 //y=2.96 //x2=7.785 //y2=1.655
cc_412 ( N_noxref_3_c_472_n N_noxref_4_c_776_n ) capacitor c=0.00204244f \
 //x=4.81 //y=2.78 //x2=8.14 //y2=3.18
cc_413 ( N_noxref_3_c_521_p N_noxref_4_c_776_n ) capacitor c=0.00929985f \
 //x=9.99 //y=2.78 //x2=8.14 //y2=3.18
cc_414 ( N_noxref_3_c_522_p N_noxref_4_c_776_n ) capacitor c=0.00257908f \
 //x=9.99 //y=3.1 //x2=8.14 //y2=3.18
cc_415 ( N_noxref_3_c_523_p N_noxref_4_c_776_n ) capacitor c=2.11402e-19 \
 //x=9.99 //y=2.96 //x2=8.14 //y2=3.18
cc_416 ( N_noxref_3_c_524_p N_noxref_4_c_776_n ) capacitor c=0.00457386f \
 //x=9.99 //y=2.08 //x2=8.14 //y2=3.18
cc_417 ( N_noxref_3_c_525_p N_noxref_4_c_776_n ) capacitor c=0.00129144f \
 //x=9.992 //y=4.56 //x2=8.14 //y2=3.18
cc_418 ( N_noxref_3_c_517_p N_noxref_4_c_776_n ) capacitor c=2.15578e-19 \
 //x=7.755 //y=2.96 //x2=8.14 //y2=3.18
cc_419 ( N_noxref_3_c_527_p N_noxref_4_c_776_n ) capacitor c=0.030056f \
 //x=8.355 //y=2.95 //x2=8.14 //y2=3.18
cc_420 ( N_noxref_3_c_525_p N_noxref_4_c_804_n ) capacitor c=0.00254639f \
 //x=9.992 //y=4.56 //x2=8.14 //y2=3.5
cc_421 ( N_noxref_3_c_527_p N_noxref_4_c_804_n ) capacitor c=0.00802904f \
 //x=8.355 //y=2.95 //x2=8.14 //y2=3.5
cc_422 ( N_noxref_3_c_473_n N_noxref_4_c_777_n ) capacitor c=0.00281705f \
 //x=4.81 //y=5.115 //x2=8.14 //y2=5.115
cc_423 ( N_noxref_3_c_531_p N_noxref_4_c_777_n ) capacitor c=0.00476843f \
 //x=9.99 //y=4.7 //x2=8.14 //y2=5.115
cc_424 ( N_noxref_3_c_525_p N_noxref_4_c_777_n ) capacitor c=0.0194346f \
 //x=9.992 //y=4.56 //x2=8.14 //y2=5.115
cc_425 ( N_noxref_3_c_521_p N_noxref_4_c_809_n ) capacitor c=0.0242931f \
 //x=9.99 //y=2.78 //x2=10.73 //y2=3.17
cc_426 ( N_noxref_3_c_522_p N_noxref_4_c_809_n ) capacitor c=0.0148049f \
 //x=9.99 //y=3.1 //x2=10.73 //y2=3.17
cc_427 ( N_noxref_3_c_523_p N_noxref_4_c_809_n ) capacitor c=0.00103412f \
 //x=9.99 //y=2.96 //x2=10.73 //y2=3.17
cc_428 ( N_noxref_3_c_525_p N_noxref_4_c_809_n ) capacitor c=0.00302581f \
 //x=9.992 //y=4.56 //x2=10.73 //y2=3.17
cc_429 ( N_noxref_3_c_527_p N_noxref_4_c_809_n ) capacitor c=0.0069403f \
 //x=8.355 //y=2.95 //x2=10.73 //y2=3.17
cc_430 ( N_noxref_3_c_538_p N_noxref_4_c_809_n ) capacitor c=3.49899e-19 \
 //x=9.99 //y=2.08 //x2=10.73 //y2=3.17
cc_431 ( N_noxref_3_c_525_p N_noxref_4_c_815_n ) capacitor c=0.0173413f \
 //x=9.992 //y=4.56 //x2=10.73 //y2=3.49
cc_432 ( N_noxref_3_c_531_p N_noxref_4_c_816_n ) capacitor c=0.0172958f \
 //x=9.99 //y=4.7 //x2=10.73 //y2=4.555
cc_433 ( N_noxref_3_c_525_p N_noxref_4_c_816_n ) capacitor c=0.0484678f \
 //x=9.992 //y=4.56 //x2=10.73 //y2=4.555
cc_434 ( N_noxref_3_c_542_p N_noxref_4_c_816_n ) capacitor c=7.76099e-19 \
 //x=9.99 //y=4.7 //x2=10.73 //y2=4.555
cc_435 ( N_noxref_3_c_543_p N_noxref_4_c_816_n ) capacitor c=0.00201171f \
 //x=9.99 //y=4.7 //x2=10.73 //y2=4.555
cc_436 ( N_noxref_3_c_544_p N_noxref_4_c_778_n ) capacitor c=0.00114153f \
 //x=4.725 //y=5.2 //x2=6.78 //y2=5.38
cc_437 ( N_noxref_3_c_505_n N_noxref_4_c_778_n ) capacitor c=5.29822e-19 \
 //x=4.33 //y=5.2 //x2=6.78 //y2=5.38
cc_438 ( N_noxref_3_c_546_p N_noxref_4_c_778_n ) capacitor c=0.00147119f \
 //x=4.33 //y=5.38 //x2=6.78 //y2=5.38
cc_439 ( N_noxref_3_c_506_n N_noxref_4_c_823_n ) capacitor c=6.99317e-19 \
 //x=4.37 //y=1 //x2=7.7 //y2=1
cc_440 ( N_noxref_3_c_517_p N_noxref_4_c_823_n ) capacitor c=4.69652e-19 \
 //x=7.755 //y=2.96 //x2=7.7 //y2=1
cc_441 ( N_noxref_3_c_525_p N_noxref_4_c_825_n ) capacitor c=5.62253e-19 \
 //x=9.992 //y=4.56 //x2=10.73 //y2=3.33
cc_442 ( N_noxref_3_c_524_p N_noxref_4_c_826_n ) capacitor c=0.0205342f \
 //x=9.99 //y=2.08 //x2=10.73 //y2=2.08
cc_443 ( N_noxref_3_c_538_p N_noxref_4_c_826_n ) capacitor c=5.16867e-19 \
 //x=9.99 //y=2.08 //x2=10.73 //y2=2.08
cc_444 ( N_noxref_3_c_552_p N_noxref_4_c_826_n ) capacitor c=0.00167888f \
 //x=9.795 //y=1.915 //x2=10.73 //y2=2.08
cc_445 ( N_noxref_3_c_522_p N_noxref_4_c_829_n ) capacitor c=0.0060726f \
 //x=9.99 //y=3.1 //x2=10.57 //y2=3.33
cc_446 ( N_noxref_3_c_531_p N_noxref_4_c_829_n ) capacitor c=0.00180599f \
 //x=9.99 //y=4.7 //x2=10.57 //y2=3.33
cc_447 ( N_noxref_3_c_525_p N_noxref_4_c_829_n ) capacitor c=0.0266467f \
 //x=9.992 //y=4.56 //x2=10.57 //y2=3.33
cc_448 ( N_noxref_3_c_527_p N_noxref_4_c_829_n ) capacitor c=0.181163f \
 //x=8.355 //y=2.95 //x2=10.57 //y2=3.33
cc_449 ( N_noxref_3_c_525_p N_noxref_4_c_786_n ) capacitor c=0.00158959f \
 //x=9.992 //y=4.56 //x2=8.3 //y2=3.34
cc_450 ( N_noxref_3_c_527_p N_noxref_4_c_786_n ) capacitor c=0.0369869f \
 //x=8.355 //y=2.95 //x2=8.3 //y2=3.34
cc_451 ( N_noxref_3_c_525_p N_noxref_4_c_835_n ) capacitor c=0.0032735f \
 //x=9.992 //y=4.56 //x2=10.73 //y2=3.33
cc_452 ( N_noxref_3_c_521_p N_noxref_4_c_836_n ) capacitor c=3.49899e-19 \
 //x=9.99 //y=2.78 //x2=10.73 //y2=2.08
cc_453 ( N_noxref_3_c_524_p N_noxref_4_c_836_n ) capacitor c=5.24723e-19 \
 //x=9.99 //y=2.08 //x2=10.73 //y2=2.08
cc_454 ( N_noxref_3_c_538_p N_noxref_4_c_836_n ) capacitor c=0.00445529f \
 //x=9.99 //y=2.08 //x2=10.73 //y2=2.08
cc_455 ( N_noxref_3_c_552_p N_noxref_4_c_836_n ) capacitor c=0.00267961f \
 //x=9.795 //y=1.915 //x2=10.73 //y2=2.08
cc_456 ( N_noxref_3_c_531_p N_noxref_4_c_840_n ) capacitor c=4.80626e-19 \
 //x=9.99 //y=4.7 //x2=10.76 //y2=4.7
cc_457 ( N_noxref_3_c_542_p N_noxref_4_c_840_n ) capacitor c=0.00397338f \
 //x=9.99 //y=4.7 //x2=10.76 //y2=4.7
cc_458 ( N_noxref_3_c_543_p N_noxref_4_c_840_n ) capacitor c=0.00283894f \
 //x=9.99 //y=4.7 //x2=10.76 //y2=4.7
cc_459 ( N_noxref_3_M17_noxref_g N_noxref_4_M19_noxref_g ) capacitor \
 c=0.0104892f //x=9.89 //y=6.02 //x2=10.77 //y2=6.02
cc_460 ( N_noxref_3_M18_noxref_g N_noxref_4_M19_noxref_g ) capacitor \
 c=0.107636f //x=10.33 //y=6.02 //x2=10.77 //y2=6.02
cc_461 ( N_noxref_3_M18_noxref_g N_noxref_4_M20_noxref_g ) capacitor \
 c=0.0100341f //x=10.33 //y=6.02 //x2=11.21 //y2=6.02
cc_462 ( N_noxref_3_c_570_p N_noxref_4_c_846_n ) capacitor c=4.86545e-19 \
 //x=9.795 //y=0.865 //x2=10.765 //y2=0.905
cc_463 ( N_noxref_3_c_571_p N_noxref_4_c_846_n ) capacitor c=0.00152405f \
 //x=9.795 //y=1.21 //x2=10.765 //y2=0.905
cc_464 ( N_noxref_3_c_572_p N_noxref_4_c_846_n ) capacitor c=0.0151475f \
 //x=10.325 //y=0.865 //x2=10.765 //y2=0.905
cc_465 ( N_noxref_3_c_573_p N_noxref_4_c_849_n ) capacitor c=0.00109982f \
 //x=9.795 //y=1.52 //x2=10.765 //y2=1.25
cc_466 ( N_noxref_3_c_574_p N_noxref_4_c_849_n ) capacitor c=0.0111064f \
 //x=10.325 //y=1.21 //x2=10.765 //y2=1.25
cc_467 ( N_noxref_3_c_573_p N_noxref_4_c_851_n ) capacitor c=9.58243e-19 \
 //x=9.795 //y=1.52 //x2=10.765 //y2=1.56
cc_468 ( N_noxref_3_c_552_p N_noxref_4_c_851_n ) capacitor c=0.00662747f \
 //x=9.795 //y=1.915 //x2=10.765 //y2=1.56
cc_469 ( N_noxref_3_c_574_p N_noxref_4_c_851_n ) capacitor c=0.00862358f \
 //x=10.325 //y=1.21 //x2=10.765 //y2=1.56
cc_470 ( N_noxref_3_c_572_p N_noxref_4_c_854_n ) capacitor c=0.00127211f \
 //x=10.325 //y=0.865 //x2=11.295 //y2=0.905
cc_471 ( N_noxref_3_c_574_p N_noxref_4_c_855_n ) capacitor c=0.00204774f \
 //x=10.325 //y=1.21 //x2=11.295 //y2=1.25
cc_472 ( N_noxref_3_c_524_p N_noxref_4_c_856_n ) capacitor c=0.00167305f \
 //x=9.99 //y=2.08 //x2=10.73 //y2=2.08
cc_473 ( N_noxref_3_c_538_p N_noxref_4_c_856_n ) capacitor c=0.00266443f \
 //x=9.99 //y=2.08 //x2=10.73 //y2=2.08
cc_474 ( N_noxref_3_c_552_p N_noxref_4_c_856_n ) capacitor c=0.0181449f \
 //x=9.795 //y=1.915 //x2=10.73 //y2=2.08
cc_475 ( N_noxref_3_c_531_p N_noxref_4_c_859_n ) capacitor c=0.00158715f \
 //x=9.99 //y=4.7 //x2=10.76 //y2=4.7
cc_476 ( N_noxref_3_c_542_p N_noxref_4_c_859_n ) capacitor c=0.00237977f \
 //x=9.99 //y=4.7 //x2=10.76 //y2=4.7
cc_477 ( N_noxref_3_c_543_p N_noxref_4_c_859_n ) capacitor c=0.0297875f \
 //x=9.99 //y=4.7 //x2=10.76 //y2=4.7
cc_478 ( N_noxref_3_c_471_n N_noxref_5_c_1050_n ) capacitor c=0.00647565f \
 //x=4.215 //y=5.2 //x2=11.47 //y2=7.4
cc_479 ( N_noxref_3_c_544_p N_noxref_5_c_1050_n ) capacitor c=0.00491449f \
 //x=4.725 //y=5.2 //x2=11.47 //y2=7.4
cc_480 ( N_noxref_3_c_493_n N_noxref_5_c_1050_n ) capacitor c=4.16995e-19 \
 //x=4.81 //y=3.1 //x2=11.47 //y2=7.4
cc_481 ( N_noxref_3_c_474_n N_noxref_5_c_1050_n ) capacitor c=0.00368144f \
 //x=3.45 //y=5.38 //x2=11.47 //y2=7.4
cc_482 ( N_noxref_3_c_505_n N_noxref_5_c_1050_n ) capacitor c=8.41206e-19 \
 //x=4.33 //y=5.2 //x2=11.47 //y2=7.4
cc_483 ( N_noxref_3_c_546_p N_noxref_5_c_1050_n ) capacitor c=0.00285294f \
 //x=4.33 //y=5.38 //x2=11.47 //y2=7.4
cc_484 ( N_noxref_3_c_531_p N_noxref_5_c_1050_n ) capacitor c=9.05427e-19 \
 //x=9.99 //y=4.7 //x2=11.47 //y2=7.4
cc_485 ( N_noxref_3_c_482_n N_noxref_5_c_1050_n ) capacitor c=0.00224727f \
 //x=3.45 //y=5.38 //x2=11.47 //y2=7.4
cc_486 ( N_noxref_3_c_594_p N_noxref_5_c_1050_n ) capacitor c=0.00224727f \
 //x=4.33 //y=5.38 //x2=11.47 //y2=7.4
cc_487 ( N_noxref_3_c_542_p N_noxref_5_c_1050_n ) capacitor c=6.23118e-19 \
 //x=9.99 //y=4.7 //x2=11.47 //y2=7.4
cc_488 ( N_noxref_3_c_471_n N_noxref_5_c_1058_n ) capacitor c=0.00208112f \
 //x=4.215 //y=5.2 //x2=3.805 //y2=7.4
cc_489 ( N_noxref_3_c_474_n N_noxref_5_c_1058_n ) capacitor c=9.98713e-19 \
 //x=3.45 //y=5.38 //x2=3.805 //y2=7.4
cc_490 ( N_noxref_3_c_482_n N_noxref_5_c_1058_n ) capacitor c=0.0136475f \
 //x=3.45 //y=5.38 //x2=3.805 //y2=7.4
cc_491 ( N_noxref_3_c_471_n N_noxref_5_c_1133_n ) capacitor c=0.00180744f \
 //x=4.215 //y=5.2 //x2=4.685 //y2=7.4
cc_492 ( N_noxref_3_c_544_p N_noxref_5_c_1133_n ) capacitor c=0.00208112f \
 //x=4.725 //y=5.2 //x2=4.685 //y2=7.4
cc_493 ( N_noxref_3_c_505_n N_noxref_5_c_1133_n ) capacitor c=5.38567e-19 \
 //x=4.33 //y=5.2 //x2=4.685 //y2=7.4
cc_494 ( N_noxref_3_c_546_p N_noxref_5_c_1133_n ) capacitor c=5.78261e-19 \
 //x=4.33 //y=5.38 //x2=4.685 //y2=7.4
cc_495 ( N_noxref_3_c_594_p N_noxref_5_c_1133_n ) capacitor c=0.0136475f \
 //x=4.33 //y=5.38 //x2=4.685 //y2=7.4
cc_496 ( N_noxref_3_c_531_p N_noxref_5_c_1138_n ) capacitor c=6.28732e-19 \
 //x=9.99 //y=4.7 //x2=10.465 //y2=7.4
cc_497 ( N_noxref_3_M17_noxref_g N_noxref_5_c_1138_n ) capacitor c=0.0072715f \
 //x=9.89 //y=6.02 //x2=10.465 //y2=7.4
cc_498 ( N_noxref_3_M18_noxref_g N_noxref_5_c_1138_n ) capacitor c=0.00749619f \
 //x=10.33 //y=6.02 //x2=10.465 //y2=7.4
cc_499 ( N_noxref_3_c_473_n N_noxref_5_c_1065_n ) capacitor c=0.00133592f \
 //x=4.81 //y=5.115 //x2=2.22 //y2=7.4
cc_500 ( N_noxref_3_c_474_n N_noxref_5_c_1065_n ) capacitor c=5.11447e-19 \
 //x=3.45 //y=5.38 //x2=2.22 //y2=7.4
cc_501 ( N_noxref_3_c_482_n N_noxref_5_c_1065_n ) capacitor c=0.0064135f \
 //x=3.45 //y=5.38 //x2=2.22 //y2=7.4
cc_502 ( N_noxref_3_c_473_n N_noxref_5_c_1099_n ) capacitor c=0.0307343f \
 //x=4.81 //y=5.115 //x2=5.55 //y2=7.4
cc_503 ( N_noxref_3_c_505_n N_noxref_5_c_1099_n ) capacitor c=0.00240948f \
 //x=4.33 //y=5.2 //x2=5.55 //y2=7.4
cc_504 ( N_noxref_3_c_546_p N_noxref_5_c_1099_n ) capacitor c=4.09141e-19 \
 //x=4.33 //y=5.38 //x2=5.55 //y2=7.4
cc_505 ( N_noxref_3_c_594_p N_noxref_5_c_1099_n ) capacitor c=0.0101861f \
 //x=4.33 //y=5.38 //x2=5.55 //y2=7.4
cc_506 ( N_noxref_3_c_531_p N_noxref_5_c_1148_n ) capacitor c=0.00447349f \
 //x=9.99 //y=4.7 //x2=8.88 //y2=7.4
cc_507 ( N_noxref_3_c_525_p N_noxref_5_c_1148_n ) capacitor c=0.00733791f \
 //x=9.992 //y=4.56 //x2=8.88 //y2=7.4
cc_508 ( N_noxref_3_c_542_p N_noxref_5_c_1148_n ) capacitor c=0.00370494f \
 //x=9.99 //y=4.7 //x2=8.88 //y2=7.4
cc_509 ( N_noxref_3_c_543_p N_noxref_5_c_1148_n ) capacitor c=0.0129564f \
 //x=9.99 //y=4.7 //x2=8.88 //y2=7.4
cc_510 ( N_noxref_3_c_482_n N_noxref_5_c_1104_n ) capacitor c=0.00135089f \
 //x=3.45 //y=5.38 //x2=11.47 //y2=7.4
cc_511 ( N_noxref_3_c_594_p N_noxref_5_c_1104_n ) capacitor c=0.00135089f \
 //x=4.33 //y=5.38 //x2=11.47 //y2=7.4
cc_512 ( N_noxref_3_c_474_n N_noxref_5_M8_noxref_d ) capacitor c=0.00114029f \
 //x=3.45 //y=5.38 //x2=1.41 //y2=5.02
cc_513 ( N_noxref_3_c_474_n N_noxref_5_M9_noxref_s ) capacitor c=0.0604727f \
 //x=3.45 //y=5.38 //x2=2.875 //y2=5.02
cc_514 ( N_noxref_3_c_505_n N_noxref_5_M9_noxref_s ) capacitor c=6.52457e-19 \
 //x=4.33 //y=5.2 //x2=2.875 //y2=5.02
cc_515 ( N_noxref_3_c_482_n N_noxref_5_M9_noxref_s ) capacitor c=0.0887533f \
 //x=3.45 //y=5.38 //x2=2.875 //y2=5.02
cc_516 ( N_noxref_3_c_471_n N_noxref_5_M10_noxref_d ) capacitor c=0.00722836f \
 //x=4.215 //y=5.2 //x2=3.745 //y2=5.02
cc_517 ( N_noxref_3_c_474_n N_noxref_5_M10_noxref_d ) capacitor c=0.0043528f \
 //x=3.45 //y=5.38 //x2=3.745 //y2=5.02
cc_518 ( N_noxref_3_c_546_p N_noxref_5_M10_noxref_d ) capacitor c=0.0043528f \
 //x=4.33 //y=5.38 //x2=3.745 //y2=5.02
cc_519 ( N_noxref_3_c_482_n N_noxref_5_M10_noxref_d ) capacitor c=0.065554f \
 //x=3.45 //y=5.38 //x2=3.745 //y2=5.02
cc_520 ( N_noxref_3_c_594_p N_noxref_5_M10_noxref_d ) capacitor c=0.065554f \
 //x=4.33 //y=5.38 //x2=3.745 //y2=5.02
cc_521 ( N_noxref_3_c_544_p N_noxref_5_M12_noxref_d ) capacitor c=0.00961146f \
 //x=4.725 //y=5.2 //x2=4.625 //y2=5.02
cc_522 ( N_noxref_3_c_546_p N_noxref_5_M12_noxref_d ) capacitor c=0.00587834f \
 //x=4.33 //y=5.38 //x2=4.625 //y2=5.02
cc_523 ( N_noxref_3_c_480_n N_noxref_5_M12_noxref_d ) capacitor c=8.01837e-19 \
 //x=4.81 //y=2.96 //x2=4.625 //y2=5.02
cc_524 ( N_noxref_3_c_594_p N_noxref_5_M12_noxref_d ) capacitor c=0.065554f \
 //x=4.33 //y=5.38 //x2=4.625 //y2=5.02
cc_525 ( N_noxref_3_c_544_p N_noxref_5_M13_noxref_s ) capacitor c=0.00326953f \
 //x=4.725 //y=5.2 //x2=6.205 //y2=5.02
cc_526 ( N_noxref_3_c_505_n N_noxref_5_M13_noxref_s ) capacitor c=0.00515461f \
 //x=4.33 //y=5.2 //x2=6.205 //y2=5.02
cc_527 ( N_noxref_3_c_546_p N_noxref_5_M13_noxref_s ) capacitor c=3.28075e-19 \
 //x=4.33 //y=5.38 //x2=6.205 //y2=5.02
cc_528 ( N_noxref_3_c_522_p N_noxref_5_M17_noxref_s ) capacitor c=9.04186e-19 \
 //x=9.99 //y=3.1 //x2=9.535 //y2=5.02
cc_529 ( N_noxref_3_M17_noxref_g N_noxref_5_M17_noxref_s ) capacitor \
 c=0.0567929f //x=9.89 //y=6.02 //x2=9.535 //y2=5.02
cc_530 ( N_noxref_3_M18_noxref_g N_noxref_5_M18_noxref_d ) capacitor \
 c=0.015318f //x=10.33 //y=6.02 //x2=10.405 //y2=5.02
cc_531 ( N_noxref_3_c_471_n N_noxref_6_c_1278_n ) capacitor c=0.022731f \
 //x=4.215 //y=5.2 //x2=4.07 //y2=4.555
cc_532 ( N_noxref_3_c_472_n N_noxref_6_c_1278_n ) capacitor c=0.024283f \
 //x=4.81 //y=2.78 //x2=4.07 //y2=4.555
cc_533 ( N_noxref_3_c_493_n N_noxref_6_c_1278_n ) capacitor c=0.0151778f \
 //x=4.81 //y=3.1 //x2=4.07 //y2=4.555
cc_534 ( N_noxref_3_c_473_n N_noxref_6_c_1278_n ) capacitor c=0.0797923f \
 //x=4.81 //y=5.115 //x2=4.07 //y2=4.555
cc_535 ( N_noxref_3_c_480_n N_noxref_6_c_1278_n ) capacitor c=6.92705e-19 \
 //x=4.81 //y=2.96 //x2=4.07 //y2=4.555
cc_536 ( N_noxref_3_c_481_n N_noxref_6_c_1278_n ) capacitor c=0.00360267f \
 //x=4.97 //y=2.94 //x2=4.07 //y2=4.555
cc_537 ( N_noxref_3_c_471_n N_noxref_6_c_1287_n ) capacitor c=2.0313e-19 \
 //x=4.215 //y=5.2 //x2=4.07 //y2=2.08
cc_538 ( N_noxref_3_c_472_n N_noxref_6_c_1287_n ) capacitor c=0.015397f \
 //x=4.81 //y=2.78 //x2=4.07 //y2=2.08
cc_539 ( N_noxref_3_c_472_n N_noxref_6_c_1290_n ) capacitor c=9.90728e-19 \
 //x=4.81 //y=2.78 //x2=4.07 //y2=2.08
cc_540 ( N_noxref_3_c_471_n N_noxref_6_c_1294_n ) capacitor c=0.00469257f \
 //x=4.215 //y=5.2 //x2=4.1 //y2=4.7
cc_541 ( N_noxref_3_c_473_n N_noxref_6_c_1294_n ) capacitor c=7.76118e-19 \
 //x=4.81 //y=5.115 //x2=4.1 //y2=4.7
cc_542 ( N_noxref_3_c_471_n N_noxref_6_M11_noxref_g ) capacitor c=0.00842859f \
 //x=4.215 //y=5.2 //x2=4.11 //y2=6.02
cc_543 ( N_noxref_3_c_505_n N_noxref_6_M11_noxref_g ) capacitor c=0.00192712f \
 //x=4.33 //y=5.2 //x2=4.11 //y2=6.02
cc_544 ( N_noxref_3_c_594_p N_noxref_6_M11_noxref_g ) capacitor c=0.0178987f \
 //x=4.33 //y=5.38 //x2=4.11 //y2=6.02
cc_545 ( N_noxref_3_c_544_p N_noxref_6_M12_noxref_g ) capacitor c=0.0114149f \
 //x=4.725 //y=5.2 //x2=4.55 //y2=6.02
cc_546 ( N_noxref_3_c_505_n N_noxref_6_M12_noxref_g ) capacitor c=0.00298276f \
 //x=4.33 //y=5.2 //x2=4.55 //y2=6.02
cc_547 ( N_noxref_3_c_594_p N_noxref_6_M12_noxref_g ) capacitor c=0.0178506f \
 //x=4.33 //y=5.38 //x2=4.55 //y2=6.02
cc_548 ( N_noxref_3_c_506_n N_noxref_6_c_1300_n ) capacitor c=0.00120406f \
 //x=4.37 //y=1 //x2=4.105 //y2=0.905
cc_549 ( N_noxref_3_M2_noxref_d N_noxref_6_c_1300_n ) capacitor c=0.00137165f \
 //x=4.18 //y=0.905 //x2=4.105 //y2=0.905
cc_550 ( N_noxref_3_c_487_n N_noxref_6_c_1303_n ) capacitor c=0.00118531f \
 //x=4.37 //y=1.57 //x2=4.105 //y2=1.25
cc_551 ( N_noxref_3_c_506_n N_noxref_6_c_1303_n ) capacitor c=0.00218558f \
 //x=4.37 //y=1 //x2=4.105 //y2=1.25
cc_552 ( N_noxref_3_M2_noxref_d N_noxref_6_c_1303_n ) capacitor c=0.00237422f \
 //x=4.18 //y=0.905 //x2=4.105 //y2=1.25
cc_553 ( N_noxref_3_c_487_n N_noxref_6_c_1305_n ) capacitor c=0.00437687f \
 //x=4.37 //y=1.57 //x2=4.105 //y2=1.56
cc_554 ( N_noxref_3_c_473_n N_noxref_6_c_1345_n ) capacitor c=0.0084741f \
 //x=4.81 //y=5.115 //x2=4.475 //y2=4.79
cc_555 ( N_noxref_3_c_505_n N_noxref_6_c_1345_n ) capacitor c=0.0020909f \
 //x=4.33 //y=5.2 //x2=4.475 //y2=4.79
cc_556 ( N_noxref_3_c_594_p N_noxref_6_c_1345_n ) capacitor c=0.00291714f \
 //x=4.33 //y=5.38 //x2=4.475 //y2=4.79
cc_557 ( N_noxref_3_c_506_n N_noxref_6_c_1348_n ) capacitor c=5.50523e-19 \
 //x=4.37 //y=1 //x2=4.48 //y2=0.75
cc_558 ( N_noxref_3_M2_noxref_d N_noxref_6_c_1348_n ) capacitor c=0.0020782f \
 //x=4.18 //y=0.905 //x2=4.48 //y2=0.75
cc_559 ( N_noxref_3_c_487_n N_noxref_6_c_1350_n ) capacitor c=0.00916011f \
 //x=4.37 //y=1.57 //x2=4.48 //y2=1.405
cc_560 ( N_noxref_3_c_518_p N_noxref_6_c_1350_n ) capacitor c=0.00194324f \
 //x=4.725 //y=1.655 //x2=4.48 //y2=1.405
cc_561 ( N_noxref_3_c_506_n N_noxref_6_c_1350_n ) capacitor c=5.67071e-19 \
 //x=4.37 //y=1 //x2=4.48 //y2=1.405
cc_562 ( N_noxref_3_M2_noxref_d N_noxref_6_c_1350_n ) capacitor c=0.00356097f \
 //x=4.18 //y=0.905 //x2=4.48 //y2=1.405
cc_563 ( N_noxref_3_c_506_n N_noxref_6_c_1308_n ) capacitor c=0.00109205f \
 //x=4.37 //y=1 //x2=4.635 //y2=0.905
cc_564 ( N_noxref_3_M2_noxref_d N_noxref_6_c_1308_n ) capacitor c=8.50095e-19 \
 //x=4.18 //y=0.905 //x2=4.635 //y2=0.905
cc_565 ( N_noxref_3_c_487_n N_noxref_6_c_1309_n ) capacitor c=0.003249f \
 //x=4.37 //y=1.57 //x2=4.635 //y2=1.25
cc_566 ( N_noxref_3_c_518_p N_noxref_6_c_1309_n ) capacitor c=0.00323005f \
 //x=4.725 //y=1.655 //x2=4.635 //y2=1.25
cc_567 ( N_noxref_3_c_506_n N_noxref_6_c_1309_n ) capacitor c=0.00317092f \
 //x=4.37 //y=1 //x2=4.635 //y2=1.25
cc_568 ( N_noxref_3_M2_noxref_d N_noxref_6_c_1309_n ) capacitor c=0.00237422f \
 //x=4.18 //y=0.905 //x2=4.635 //y2=1.25
cc_569 ( N_noxref_3_c_472_n N_noxref_6_c_1310_n ) capacitor c=0.00281392f \
 //x=4.81 //y=2.78 //x2=4.07 //y2=2.08
cc_570 ( N_noxref_3_c_487_n N_noxref_6_c_1361_n ) capacitor c=0.00348382f \
 //x=4.37 //y=1.57 //x2=4.07 //y2=1.915
cc_571 ( N_noxref_3_c_472_n N_noxref_6_c_1361_n ) capacitor c=0.00309521f \
 //x=4.81 //y=2.78 //x2=4.07 //y2=1.915
cc_572 ( N_noxref_3_c_471_n N_noxref_6_c_1313_n ) capacitor c=9.61466e-19 \
 //x=4.215 //y=5.2 //x2=4.1 //y2=4.7
cc_573 ( N_noxref_3_c_473_n N_noxref_6_c_1313_n ) capacitor c=0.00142201f \
 //x=4.81 //y=5.115 //x2=4.1 //y2=4.7
cc_574 ( N_noxref_3_c_472_n N_noxref_7_c_1389_n ) capacitor c=0.00174497f \
 //x=4.81 //y=2.78 //x2=7.4 //y2=4.555
cc_575 ( N_noxref_3_c_473_n N_noxref_7_c_1389_n ) capacitor c=0.0034543f \
 //x=4.81 //y=5.115 //x2=7.4 //y2=4.555
cc_576 ( N_noxref_3_c_521_p N_noxref_7_c_1389_n ) capacitor c=0.00170831f \
 //x=9.99 //y=2.78 //x2=7.4 //y2=4.555
cc_577 ( N_noxref_3_c_525_p N_noxref_7_c_1389_n ) capacitor c=0.00315718f \
 //x=9.992 //y=4.56 //x2=7.4 //y2=4.555
cc_578 ( N_noxref_3_c_517_p N_noxref_7_c_1389_n ) capacitor c=0.032616f \
 //x=7.755 //y=2.96 //x2=7.4 //y2=4.555
cc_579 ( N_noxref_3_c_517_p N_noxref_7_c_1398_n ) capacitor c=0.00314446f \
 //x=7.755 //y=2.96 //x2=7.4 //y2=2.08
cc_580 ( N_noxref_3_c_518_p N_noxref_8_c_1601_n ) capacitor c=0.00653239f \
 //x=4.725 //y=1.655 //x2=6.645 //y2=0
cc_581 ( N_noxref_3_c_493_n N_noxref_8_c_1601_n ) capacitor c=5.10107e-19 \
 //x=4.81 //y=3.1 //x2=6.645 //y2=0
cc_582 ( N_noxref_3_c_506_n N_noxref_8_c_1601_n ) capacitor c=0.00963092f \
 //x=4.37 //y=1 //x2=6.645 //y2=0
cc_583 ( N_noxref_3_M2_noxref_d N_noxref_8_c_1601_n ) capacitor c=3.01654e-19 \
 //x=4.18 //y=0.905 //x2=6.645 //y2=0
cc_584 ( N_noxref_3_c_474_n N_noxref_8_c_1504_n ) capacitor c=7.06445e-19 \
 //x=3.45 //y=5.38 //x2=3.4 //y2=0.955
cc_585 ( N_noxref_3_c_506_n N_noxref_8_c_1504_n ) capacitor c=0.0140149f \
 //x=4.37 //y=1 //x2=3.4 //y2=0.955
cc_586 ( N_noxref_3_M2_noxref_d N_noxref_8_c_1504_n ) capacitor c=2.93544e-19 \
 //x=4.18 //y=0.905 //x2=3.4 //y2=0.955
cc_587 ( N_noxref_3_c_506_n N_noxref_8_c_1561_n ) capacitor c=0.00549186f \
 //x=4.37 //y=1 //x2=6.73 //y2=0.955
cc_588 ( N_noxref_3_c_510_n N_noxref_8_c_1561_n ) capacitor c=0.00326582f \
 //x=6.875 //y=2.95 //x2=6.73 //y2=0.955
cc_589 ( N_noxref_3_c_524_p N_noxref_8_c_1610_n ) capacitor c=0.00677989f \
 //x=9.99 //y=2.08 //x2=10.06 //y2=0.955
cc_590 ( N_noxref_3_c_527_p N_noxref_8_c_1610_n ) capacitor c=0.0025393f \
 //x=8.355 //y=2.95 //x2=10.06 //y2=0.955
cc_591 ( N_noxref_3_c_538_p N_noxref_8_c_1610_n ) capacitor c=2.13705e-19 \
 //x=9.99 //y=2.08 //x2=10.06 //y2=0.955
cc_592 ( N_noxref_3_c_570_p N_noxref_8_c_1610_n ) capacitor c=0.00171023f \
 //x=9.795 //y=0.865 //x2=10.06 //y2=0.955
cc_593 ( N_noxref_3_c_571_p N_noxref_8_c_1610_n ) capacitor c=0.00357815f \
 //x=9.795 //y=1.21 //x2=10.06 //y2=0.955
cc_594 ( N_noxref_3_c_573_p N_noxref_8_c_1610_n ) capacitor c=4.2764e-19 \
 //x=9.795 //y=1.52 //x2=10.06 //y2=0.955
cc_595 ( N_noxref_3_c_703_p N_noxref_8_c_1610_n ) capacitor c=7.35788e-19 \
 //x=10.17 //y=0.71 //x2=10.06 //y2=0.955
cc_596 ( N_noxref_3_c_704_p N_noxref_8_c_1610_n ) capacitor c=6.38426e-19 \
 //x=10.17 //y=1.365 //x2=10.06 //y2=0.955
cc_597 ( N_noxref_3_c_572_p N_noxref_8_c_1610_n ) capacitor c=0.00158609f \
 //x=10.325 //y=0.865 //x2=10.06 //y2=0.955
cc_598 ( N_noxref_3_c_574_p N_noxref_8_c_1610_n ) capacitor c=0.00296337f \
 //x=10.325 //y=1.21 //x2=10.06 //y2=0.955
cc_599 ( N_noxref_3_c_570_p N_noxref_8_c_1620_n ) capacitor c=3.46594e-19 \
 //x=9.795 //y=0.865 //x2=10.057 //y2=0.825
cc_600 ( N_noxref_3_c_703_p N_noxref_8_c_1620_n ) capacitor c=0.00852028f \
 //x=10.17 //y=0.71 //x2=10.057 //y2=0.825
cc_601 ( N_noxref_3_c_572_p N_noxref_8_c_1620_n ) capacitor c=4.45447e-19 \
 //x=10.325 //y=0.865 //x2=10.057 //y2=0.825
cc_602 ( N_noxref_3_c_518_p N_noxref_8_c_1524_n ) capacitor c=7.76556e-19 \
 //x=4.725 //y=1.655 //x2=5.38 //y2=0
cc_603 ( N_noxref_3_c_493_n N_noxref_8_c_1524_n ) capacitor c=3.903e-19 \
 //x=4.81 //y=3.1 //x2=5.38 //y2=0
cc_604 ( N_noxref_3_c_506_n N_noxref_8_c_1578_n ) capacitor c=2.83275e-19 \
 //x=4.37 //y=1 //x2=11.47 //y2=0
cc_605 ( N_noxref_3_c_570_p N_noxref_8_c_1578_n ) capacitor c=0.00689257f \
 //x=9.795 //y=0.865 //x2=11.47 //y2=0
cc_606 ( N_noxref_3_c_472_n N_noxref_8_c_1530_n ) capacitor c=9.34543e-19 \
 //x=4.81 //y=2.78 //x2=2.22 //y2=0
cc_607 ( N_noxref_3_c_487_n N_noxref_8_c_1583_n ) capacitor c=0.002973f \
 //x=4.37 //y=1.57 //x2=5.55 //y2=0
cc_608 ( N_noxref_3_c_518_p N_noxref_8_c_1583_n ) capacitor c=0.0300121f \
 //x=4.725 //y=1.655 //x2=5.55 //y2=0
cc_609 ( N_noxref_3_c_507_n N_noxref_8_c_1583_n ) capacitor c=0.00725422f \
 //x=6.275 //y=2.96 //x2=5.55 //y2=0
cc_610 ( N_noxref_3_c_521_p N_noxref_8_c_1631_n ) capacitor c=0.00829739f \
 //x=9.99 //y=2.78 //x2=8.88 //y2=0
cc_611 ( N_noxref_3_c_524_p N_noxref_8_c_1631_n ) capacitor c=0.00427323f \
 //x=9.99 //y=2.08 //x2=8.88 //y2=0
cc_612 ( N_noxref_3_c_527_p N_noxref_8_c_1631_n ) capacitor c=0.00725422f \
 //x=8.355 //y=2.95 //x2=8.88 //y2=0
cc_613 ( N_noxref_3_c_538_p N_noxref_8_c_1631_n ) capacitor c=0.0038607f \
 //x=9.99 //y=2.08 //x2=8.88 //y2=0
cc_614 ( N_noxref_3_c_573_p N_noxref_8_c_1631_n ) capacitor c=0.0015404f \
 //x=9.795 //y=1.52 //x2=8.88 //y2=0
cc_615 ( N_noxref_3_c_552_p N_noxref_8_c_1631_n ) capacitor c=0.00908419f \
 //x=9.795 //y=1.915 //x2=8.88 //y2=0
cc_616 ( N_noxref_3_c_506_n N_noxref_8_M1_noxref_d ) capacitor c=2.82748e-19 \
 //x=4.37 //y=1 //x2=3.21 //y2=0.865
cc_617 ( N_noxref_3_c_524_p N_noxref_8_M5_noxref_d ) capacitor c=2.20438e-19 \
 //x=9.99 //y=2.08 //x2=9.87 //y2=0.865
cc_618 ( N_noxref_3_c_570_p N_noxref_8_M5_noxref_d ) capacitor c=0.00192399f \
 //x=9.795 //y=0.865 //x2=9.87 //y2=0.865
cc_619 ( N_noxref_3_c_571_p N_noxref_8_M5_noxref_d ) capacitor c=0.00210798f \
 //x=9.795 //y=1.21 //x2=9.87 //y2=0.865
cc_620 ( N_noxref_3_c_703_p N_noxref_8_M5_noxref_d ) capacitor c=0.00472259f \
 //x=10.17 //y=0.71 //x2=9.87 //y2=0.865
cc_621 ( N_noxref_3_c_704_p N_noxref_8_M5_noxref_d ) capacitor c=0.00166857f \
 //x=10.17 //y=1.365 //x2=9.87 //y2=0.865
cc_622 ( N_noxref_3_c_572_p N_noxref_8_M5_noxref_d ) capacitor c=0.00230174f \
 //x=10.325 //y=0.865 //x2=9.87 //y2=0.865
cc_623 ( N_noxref_3_c_574_p N_noxref_8_M5_noxref_d ) capacitor c=0.00210798f \
 //x=10.325 //y=1.21 //x2=9.87 //y2=0.865
cc_624 ( N_noxref_3_M18_noxref_g N_noxref_9_c_1768_n ) capacitor c=0.0108476f \
 //x=10.33 //y=6.02 //x2=10.875 //y2=5.2
cc_625 ( N_noxref_3_c_521_p N_noxref_9_c_1769_n ) capacitor c=0.00261496f \
 //x=9.99 //y=2.78 //x2=11.47 //y2=5.115
cc_626 ( N_noxref_3_c_525_p N_noxref_9_c_1769_n ) capacitor c=0.00454526f \
 //x=9.992 //y=4.56 //x2=11.47 //y2=5.115
cc_627 ( N_noxref_3_c_522_p N_noxref_9_c_1771_n ) capacitor c=3.93756e-19 \
 //x=9.99 //y=3.1 //x2=10.11 //y2=5.38
cc_628 ( N_noxref_3_c_531_p N_noxref_9_c_1771_n ) capacitor c=0.0118323f \
 //x=9.99 //y=4.7 //x2=10.11 //y2=5.38
cc_629 ( N_noxref_3_c_542_p N_noxref_9_c_1771_n ) capacitor c=0.00277154f \
 //x=9.99 //y=4.7 //x2=10.11 //y2=5.38
cc_630 ( N_noxref_3_M17_noxref_g N_noxref_9_c_1771_n ) capacitor c=0.00201806f \
 //x=9.89 //y=6.02 //x2=10.11 //y2=5.38
cc_631 ( N_noxref_3_M18_noxref_g N_noxref_9_c_1771_n ) capacitor c=0.00192712f \
 //x=10.33 //y=6.02 //x2=10.11 //y2=5.38
cc_632 ( N_noxref_3_c_543_p N_noxref_9_c_1771_n ) capacitor c=0.00199495f \
 //x=9.99 //y=4.7 //x2=10.11 //y2=5.38
cc_633 ( N_noxref_3_c_531_p N_noxref_9_c_1777_n ) capacitor c=0.00104426f \
 //x=9.99 //y=4.7 //x2=10.11 //y2=5.38
cc_634 ( N_noxref_3_c_542_p N_noxref_9_c_1777_n ) capacitor c=0.00377369f \
 //x=9.99 //y=4.7 //x2=10.11 //y2=5.38
cc_635 ( N_noxref_3_M17_noxref_g N_noxref_9_c_1777_n ) capacitor c=0.0158358f \
 //x=9.89 //y=6.02 //x2=10.11 //y2=5.38
cc_636 ( N_noxref_3_M18_noxref_g N_noxref_9_c_1777_n ) capacitor c=0.0178987f \
 //x=10.33 //y=6.02 //x2=10.11 //y2=5.38
cc_637 ( N_noxref_3_c_543_p N_noxref_9_c_1777_n ) capacitor c=0.0043218f \
 //x=9.99 //y=4.7 //x2=10.11 //y2=5.38
cc_638 ( N_noxref_3_c_489_n N_noxref_10_c_1897_n ) capacitor c=0.00900974f \
 //x=4.455 //y=1.655 //x2=3.885 //y2=1.495
cc_639 ( N_noxref_3_c_518_p N_noxref_10_c_1904_n ) capacitor c=0.00373013f \
 //x=4.725 //y=1.655 //x2=4.77 //y2=0.53
cc_640 ( N_noxref_3_c_506_n N_noxref_10_c_1904_n ) capacitor c=0.00367971f \
 //x=4.37 //y=1 //x2=4.77 //y2=0.53
cc_641 ( N_noxref_3_M2_noxref_d N_noxref_10_c_1904_n ) capacitor c=0.00910163f \
 //x=4.18 //y=0.905 //x2=4.77 //y2=0.53
cc_642 ( N_noxref_3_c_487_n N_noxref_10_M1_noxref_s ) capacitor c=0.0161378f \
 //x=4.37 //y=1.57 //x2=2.78 //y2=0.365
cc_643 ( N_noxref_3_c_518_p N_noxref_10_M1_noxref_s ) capacitor c=0.00603051f \
 //x=4.725 //y=1.655 //x2=2.78 //y2=0.365
cc_644 ( N_noxref_3_c_493_n N_noxref_10_M1_noxref_s ) capacitor c=5.71487e-19 \
 //x=4.81 //y=3.1 //x2=2.78 //y2=0.365
cc_645 ( N_noxref_3_c_506_n N_noxref_10_M1_noxref_s ) capacitor c=0.00904877f \
 //x=4.37 //y=1 //x2=2.78 //y2=0.365
cc_646 ( N_noxref_3_c_480_n N_noxref_10_M1_noxref_s ) capacitor c=0.00140776f \
 //x=4.81 //y=2.96 //x2=2.78 //y2=0.365
cc_647 ( N_noxref_3_M2_noxref_d N_noxref_10_M1_noxref_s ) capacitor \
 c=0.0275552f //x=4.18 //y=0.905 //x2=2.78 //y2=0.365
cc_648 ( N_noxref_3_c_507_n N_noxref_11_c_1956_n ) capacitor c=0.0031675f \
 //x=6.275 //y=2.96 //x2=6.245 //y2=1.495
cc_649 ( N_noxref_3_c_507_n N_noxref_11_c_1957_n ) capacitor c=0.00691616f \
 //x=6.275 //y=2.96 //x2=7.13 //y2=1.58
cc_650 ( N_noxref_3_c_510_n N_noxref_11_c_1957_n ) capacitor c=0.00279672f \
 //x=6.875 //y=2.95 //x2=7.13 //y2=1.58
cc_651 ( N_noxref_3_c_517_p N_noxref_11_c_1964_n ) capacitor c=0.00273243f \
 //x=7.755 //y=2.96 //x2=7.215 //y2=1.495
cc_652 ( N_noxref_3_c_527_p N_noxref_11_M3_noxref_s ) capacitor c=5.85096e-19 \
 //x=8.355 //y=2.95 //x2=6.11 //y2=0.365
cc_653 ( N_noxref_3_c_527_p N_noxref_12_c_2027_n ) capacitor c=0.00317601f \
 //x=8.355 //y=2.95 //x2=9.575 //y2=1.495
cc_654 ( N_noxref_3_c_552_p N_noxref_12_c_2027_n ) capacitor c=0.00262672f \
 //x=9.795 //y=1.915 //x2=9.575 //y2=1.495
cc_655 ( N_noxref_3_c_522_p N_noxref_12_c_2029_n ) capacitor c=0.00447516f \
 //x=9.99 //y=3.1 //x2=10.46 //y2=1.58
cc_656 ( N_noxref_3_c_524_p N_noxref_12_c_2029_n ) capacitor c=0.00509504f \
 //x=9.99 //y=2.08 //x2=10.46 //y2=1.58
cc_657 ( N_noxref_3_c_527_p N_noxref_12_c_2029_n ) capacitor c=0.00118517f \
 //x=8.355 //y=2.95 //x2=10.46 //y2=1.58
cc_658 ( N_noxref_3_c_538_p N_noxref_12_c_2029_n ) capacitor c=0.00763108f \
 //x=9.99 //y=2.08 //x2=10.46 //y2=1.58
cc_659 ( N_noxref_3_c_573_p N_noxref_12_c_2029_n ) capacitor c=0.00697076f \
 //x=9.795 //y=1.52 //x2=10.46 //y2=1.58
cc_660 ( N_noxref_3_c_552_p N_noxref_12_c_2029_n ) capacitor c=0.0173953f \
 //x=9.795 //y=1.915 //x2=10.46 //y2=1.58
cc_661 ( N_noxref_3_c_704_p N_noxref_12_c_2029_n ) capacitor c=0.00723574f \
 //x=10.17 //y=1.365 //x2=10.46 //y2=1.58
cc_662 ( N_noxref_3_c_574_p N_noxref_12_c_2029_n ) capacitor c=0.00339872f \
 //x=10.325 //y=1.21 //x2=10.46 //y2=1.58
cc_663 ( N_noxref_3_c_552_p N_noxref_12_c_2037_n ) capacitor c=6.71402e-19 \
 //x=9.795 //y=1.915 //x2=10.545 //y2=1.495
cc_664 ( N_noxref_3_c_570_p N_noxref_12_M5_noxref_s ) capacitor c=0.0294925f \
 //x=9.795 //y=0.865 //x2=9.44 //y2=0.365
cc_665 ( N_noxref_3_c_573_p N_noxref_12_M5_noxref_s ) capacitor c=3.48408e-19 \
 //x=9.795 //y=1.52 //x2=9.44 //y2=0.365
cc_666 ( N_noxref_3_c_572_p N_noxref_12_M5_noxref_s ) capacitor c=0.0125442f \
 //x=10.325 //y=0.865 //x2=9.44 //y2=0.365
cc_667 ( N_noxref_4_c_775_n N_noxref_5_c_1050_n ) capacitor c=0.00647565f \
 //x=7.545 //y=5.2 //x2=11.47 //y2=7.4
cc_668 ( N_noxref_4_c_863_p N_noxref_5_c_1050_n ) capacitor c=0.00491449f \
 //x=8.055 //y=5.2 //x2=11.47 //y2=7.4
cc_669 ( N_noxref_4_c_804_n N_noxref_5_c_1050_n ) capacitor c=4.28171e-19 \
 //x=8.14 //y=3.5 //x2=11.47 //y2=7.4
cc_670 ( N_noxref_4_c_778_n N_noxref_5_c_1050_n ) capacitor c=0.00368144f \
 //x=6.78 //y=5.38 //x2=11.47 //y2=7.4
cc_671 ( N_noxref_4_c_866_p N_noxref_5_c_1050_n ) capacitor c=8.41206e-19 \
 //x=7.66 //y=5.2 //x2=11.47 //y2=7.4
cc_672 ( N_noxref_4_c_867_p N_noxref_5_c_1050_n ) capacitor c=0.00285294f \
 //x=7.66 //y=5.38 //x2=11.47 //y2=7.4
cc_673 ( N_noxref_4_c_787_n N_noxref_5_c_1050_n ) capacitor c=0.00224727f \
 //x=6.78 //y=5.38 //x2=11.47 //y2=7.4
cc_674 ( N_noxref_4_c_869_p N_noxref_5_c_1050_n ) capacitor c=0.00224727f \
 //x=7.66 //y=5.38 //x2=11.47 //y2=7.4
cc_675 ( N_noxref_4_c_775_n N_noxref_5_c_1089_n ) capacitor c=0.00213214f \
 //x=7.545 //y=5.2 //x2=7.135 //y2=7.4
cc_676 ( N_noxref_4_c_778_n N_noxref_5_c_1089_n ) capacitor c=9.98713e-19 \
 //x=6.78 //y=5.38 //x2=7.135 //y2=7.4
cc_677 ( N_noxref_4_c_787_n N_noxref_5_c_1089_n ) capacitor c=0.0136475f \
 //x=6.78 //y=5.38 //x2=7.135 //y2=7.4
cc_678 ( N_noxref_4_c_775_n N_noxref_5_c_1184_n ) capacitor c=0.00184538f \
 //x=7.545 //y=5.2 //x2=8.015 //y2=7.4
cc_679 ( N_noxref_4_c_863_p N_noxref_5_c_1184_n ) capacitor c=0.00213214f \
 //x=8.055 //y=5.2 //x2=8.015 //y2=7.4
cc_680 ( N_noxref_4_c_866_p N_noxref_5_c_1184_n ) capacitor c=5.38567e-19 \
 //x=7.66 //y=5.2 //x2=8.015 //y2=7.4
cc_681 ( N_noxref_4_c_867_p N_noxref_5_c_1184_n ) capacitor c=5.78261e-19 \
 //x=7.66 //y=5.38 //x2=8.015 //y2=7.4
cc_682 ( N_noxref_4_c_869_p N_noxref_5_c_1184_n ) capacitor c=0.0136475f \
 //x=7.66 //y=5.38 //x2=8.015 //y2=7.4
cc_683 ( N_noxref_4_M19_noxref_g N_noxref_5_c_1189_n ) capacitor c=0.00692597f \
 //x=10.77 //y=6.02 //x2=11.345 //y2=7.4
cc_684 ( N_noxref_4_M20_noxref_g N_noxref_5_c_1189_n ) capacitor c=0.00749619f \
 //x=11.21 //y=6.02 //x2=11.345 //y2=7.4
cc_685 ( N_noxref_4_c_777_n N_noxref_5_c_1099_n ) capacitor c=0.0013228f \
 //x=8.14 //y=5.115 //x2=5.55 //y2=7.4
cc_686 ( N_noxref_4_c_778_n N_noxref_5_c_1099_n ) capacitor c=4.91377e-19 \
 //x=6.78 //y=5.38 //x2=5.55 //y2=7.4
cc_687 ( N_noxref_4_c_787_n N_noxref_5_c_1099_n ) capacitor c=0.0064135f \
 //x=6.78 //y=5.38 //x2=5.55 //y2=7.4
cc_688 ( N_noxref_4_c_777_n N_noxref_5_c_1148_n ) capacitor c=0.0312058f \
 //x=8.14 //y=5.115 //x2=8.88 //y2=7.4
cc_689 ( N_noxref_4_c_866_p N_noxref_5_c_1148_n ) capacitor c=0.00240948f \
 //x=7.66 //y=5.2 //x2=8.88 //y2=7.4
cc_690 ( N_noxref_4_c_867_p N_noxref_5_c_1148_n ) capacitor c=4.09141e-19 \
 //x=7.66 //y=5.38 //x2=8.88 //y2=7.4
cc_691 ( N_noxref_4_c_829_n N_noxref_5_c_1148_n ) capacitor c=0.00501351f \
 //x=10.57 //y=3.33 //x2=8.88 //y2=7.4
cc_692 ( N_noxref_4_c_869_p N_noxref_5_c_1148_n ) capacitor c=0.0101861f \
 //x=7.66 //y=5.38 //x2=8.88 //y2=7.4
cc_693 ( N_noxref_4_c_787_n N_noxref_5_c_1104_n ) capacitor c=0.00135089f \
 //x=6.78 //y=5.38 //x2=11.47 //y2=7.4
cc_694 ( N_noxref_4_c_869_p N_noxref_5_c_1104_n ) capacitor c=0.00135089f \
 //x=7.66 //y=5.38 //x2=11.47 //y2=7.4
cc_695 ( N_noxref_4_c_840_n N_noxref_5_c_1104_n ) capacitor c=0.00226427f \
 //x=10.76 //y=4.7 //x2=11.47 //y2=7.4
cc_696 ( N_noxref_4_c_891_p N_noxref_5_c_1104_n ) capacitor c=0.0237963f \
 //x=11.135 //y=4.79 //x2=11.47 //y2=7.4
cc_697 ( N_noxref_4_c_859_n N_noxref_5_c_1104_n ) capacitor c=2.73429e-19 \
 //x=10.76 //y=4.7 //x2=11.47 //y2=7.4
cc_698 ( N_noxref_4_c_778_n N_noxref_5_M13_noxref_s ) capacitor c=0.0572211f \
 //x=6.78 //y=5.38 //x2=6.205 //y2=5.02
cc_699 ( N_noxref_4_c_866_p N_noxref_5_M13_noxref_s ) capacitor c=6.52457e-19 \
 //x=7.66 //y=5.2 //x2=6.205 //y2=5.02
cc_700 ( N_noxref_4_c_787_n N_noxref_5_M13_noxref_s ) capacitor c=0.0887533f \
 //x=6.78 //y=5.38 //x2=6.205 //y2=5.02
cc_701 ( N_noxref_4_c_775_n N_noxref_5_M14_noxref_d ) capacitor c=0.00810167f \
 //x=7.545 //y=5.2 //x2=7.075 //y2=5.02
cc_702 ( N_noxref_4_c_778_n N_noxref_5_M14_noxref_d ) capacitor c=0.0043528f \
 //x=6.78 //y=5.38 //x2=7.075 //y2=5.02
cc_703 ( N_noxref_4_c_867_p N_noxref_5_M14_noxref_d ) capacitor c=0.0043528f \
 //x=7.66 //y=5.38 //x2=7.075 //y2=5.02
cc_704 ( N_noxref_4_c_787_n N_noxref_5_M14_noxref_d ) capacitor c=0.065554f \
 //x=6.78 //y=5.38 //x2=7.075 //y2=5.02
cc_705 ( N_noxref_4_c_869_p N_noxref_5_M14_noxref_d ) capacitor c=0.065554f \
 //x=7.66 //y=5.38 //x2=7.075 //y2=5.02
cc_706 ( N_noxref_4_c_863_p N_noxref_5_M16_noxref_d ) capacitor c=0.00933287f \
 //x=8.055 //y=5.2 //x2=7.955 //y2=5.02
cc_707 ( N_noxref_4_c_867_p N_noxref_5_M16_noxref_d ) capacitor c=0.00587834f \
 //x=7.66 //y=5.38 //x2=7.955 //y2=5.02
cc_708 ( N_noxref_4_c_785_n N_noxref_5_M16_noxref_d ) capacitor c=9.65858e-19 \
 //x=8.14 //y=3.33 //x2=7.955 //y2=5.02
cc_709 ( N_noxref_4_c_869_p N_noxref_5_M16_noxref_d ) capacitor c=0.065554f \
 //x=7.66 //y=5.38 //x2=7.955 //y2=5.02
cc_710 ( N_noxref_4_c_863_p N_noxref_5_M17_noxref_s ) capacitor c=0.00326953f \
 //x=8.055 //y=5.2 //x2=9.535 //y2=5.02
cc_711 ( N_noxref_4_c_866_p N_noxref_5_M17_noxref_s ) capacitor c=0.00515461f \
 //x=7.66 //y=5.2 //x2=9.535 //y2=5.02
cc_712 ( N_noxref_4_c_867_p N_noxref_5_M17_noxref_s ) capacitor c=3.28075e-19 \
 //x=7.66 //y=5.38 //x2=9.535 //y2=5.02
cc_713 ( N_noxref_4_c_829_n N_noxref_5_M17_noxref_s ) capacitor c=0.0037282f \
 //x=10.57 //y=3.33 //x2=9.535 //y2=5.02
cc_714 ( N_noxref_4_M19_noxref_g N_noxref_5_M18_noxref_d ) capacitor \
 c=0.015318f //x=10.77 //y=6.02 //x2=10.405 //y2=5.02
cc_715 ( N_noxref_4_c_859_n N_noxref_5_M18_noxref_d ) capacitor c=3.32274e-19 \
 //x=10.76 //y=4.7 //x2=10.405 //y2=5.02
cc_716 ( N_noxref_4_M20_noxref_g N_noxref_5_M20_noxref_d ) capacitor \
 c=0.0430452f //x=11.21 //y=6.02 //x2=11.285 //y2=5.02
cc_717 ( N_noxref_4_c_775_n N_noxref_7_c_1389_n ) capacitor c=0.0228479f \
 //x=7.545 //y=5.2 //x2=7.4 //y2=4.555
cc_718 ( N_noxref_4_c_776_n N_noxref_7_c_1389_n ) capacitor c=0.0394854f \
 //x=8.14 //y=3.18 //x2=7.4 //y2=4.555
cc_719 ( N_noxref_4_c_804_n N_noxref_7_c_1389_n ) capacitor c=0.0148747f \
 //x=8.14 //y=3.5 //x2=7.4 //y2=4.555
cc_720 ( N_noxref_4_c_777_n N_noxref_7_c_1389_n ) capacitor c=0.0646184f \
 //x=8.14 //y=5.115 //x2=7.4 //y2=4.555
cc_721 ( N_noxref_4_c_785_n N_noxref_7_c_1389_n ) capacitor c=6.02403e-19 \
 //x=8.14 //y=3.33 //x2=7.4 //y2=4.555
cc_722 ( N_noxref_4_c_786_n N_noxref_7_c_1389_n ) capacitor c=0.00360383f \
 //x=8.3 //y=3.34 //x2=7.4 //y2=4.555
cc_723 ( N_noxref_4_c_776_n N_noxref_7_c_1398_n ) capacitor c=0.015397f \
 //x=8.14 //y=3.18 //x2=7.4 //y2=2.08
cc_724 ( N_noxref_4_c_776_n N_noxref_7_c_1401_n ) capacitor c=9.90728e-19 \
 //x=8.14 //y=3.18 //x2=7.4 //y2=2.08
cc_725 ( N_noxref_4_c_775_n N_noxref_7_c_1405_n ) capacitor c=0.00469257f \
 //x=7.545 //y=5.2 //x2=7.43 //y2=4.7
cc_726 ( N_noxref_4_c_777_n N_noxref_7_c_1405_n ) capacitor c=7.76118e-19 \
 //x=8.14 //y=5.115 //x2=7.43 //y2=4.7
cc_727 ( N_noxref_4_c_775_n N_noxref_7_M15_noxref_g ) capacitor c=0.00842859f \
 //x=7.545 //y=5.2 //x2=7.44 //y2=6.02
cc_728 ( N_noxref_4_c_866_p N_noxref_7_M15_noxref_g ) capacitor c=0.00192712f \
 //x=7.66 //y=5.2 //x2=7.44 //y2=6.02
cc_729 ( N_noxref_4_c_869_p N_noxref_7_M15_noxref_g ) capacitor c=0.0178987f \
 //x=7.66 //y=5.38 //x2=7.44 //y2=6.02
cc_730 ( N_noxref_4_c_863_p N_noxref_7_M16_noxref_g ) capacitor c=0.0115937f \
 //x=8.055 //y=5.2 //x2=7.88 //y2=6.02
cc_731 ( N_noxref_4_c_866_p N_noxref_7_M16_noxref_g ) capacitor c=0.00298276f \
 //x=7.66 //y=5.2 //x2=7.88 //y2=6.02
cc_732 ( N_noxref_4_c_869_p N_noxref_7_M16_noxref_g ) capacitor c=0.0178506f \
 //x=7.66 //y=5.38 //x2=7.88 //y2=6.02
cc_733 ( N_noxref_4_c_823_n N_noxref_7_c_1411_n ) capacitor c=0.00120406f \
 //x=7.7 //y=1 //x2=7.435 //y2=0.905
cc_734 ( N_noxref_4_M4_noxref_d N_noxref_7_c_1411_n ) capacitor c=0.00137165f \
 //x=7.51 //y=0.905 //x2=7.435 //y2=0.905
cc_735 ( N_noxref_4_c_792_n N_noxref_7_c_1414_n ) capacitor c=0.00119008f \
 //x=7.7 //y=1.57 //x2=7.435 //y2=1.25
cc_736 ( N_noxref_4_c_823_n N_noxref_7_c_1414_n ) capacitor c=0.00218694f \
 //x=7.7 //y=1 //x2=7.435 //y2=1.25
cc_737 ( N_noxref_4_M4_noxref_d N_noxref_7_c_1414_n ) capacitor c=0.00237422f \
 //x=7.51 //y=0.905 //x2=7.435 //y2=1.25
cc_738 ( N_noxref_4_c_792_n N_noxref_7_c_1416_n ) capacitor c=0.00438634f \
 //x=7.7 //y=1.57 //x2=7.435 //y2=1.56
cc_739 ( N_noxref_4_c_777_n N_noxref_7_c_1455_n ) capacitor c=0.00845606f \
 //x=8.14 //y=5.115 //x2=7.805 //y2=4.79
cc_740 ( N_noxref_4_c_866_p N_noxref_7_c_1455_n ) capacitor c=0.0020909f \
 //x=7.66 //y=5.2 //x2=7.805 //y2=4.79
cc_741 ( N_noxref_4_c_869_p N_noxref_7_c_1455_n ) capacitor c=0.00291714f \
 //x=7.66 //y=5.38 //x2=7.805 //y2=4.79
cc_742 ( N_noxref_4_c_823_n N_noxref_7_c_1458_n ) capacitor c=5.50523e-19 \
 //x=7.7 //y=1 //x2=7.81 //y2=0.75
cc_743 ( N_noxref_4_M4_noxref_d N_noxref_7_c_1458_n ) capacitor c=0.0020782f \
 //x=7.51 //y=0.905 //x2=7.81 //y2=0.75
cc_744 ( N_noxref_4_c_792_n N_noxref_7_c_1460_n ) capacitor c=0.00916852f \
 //x=7.7 //y=1.57 //x2=7.81 //y2=1.405
cc_745 ( N_noxref_4_c_793_n N_noxref_7_c_1460_n ) capacitor c=0.00194324f \
 //x=8.055 //y=1.655 //x2=7.81 //y2=1.405
cc_746 ( N_noxref_4_c_823_n N_noxref_7_c_1460_n ) capacitor c=5.67071e-19 \
 //x=7.7 //y=1 //x2=7.81 //y2=1.405
cc_747 ( N_noxref_4_M4_noxref_d N_noxref_7_c_1460_n ) capacitor c=0.00356097f \
 //x=7.51 //y=0.905 //x2=7.81 //y2=1.405
cc_748 ( N_noxref_4_c_823_n N_noxref_7_c_1419_n ) capacitor c=0.00109205f \
 //x=7.7 //y=1 //x2=7.965 //y2=0.905
cc_749 ( N_noxref_4_M4_noxref_d N_noxref_7_c_1419_n ) capacitor c=8.50095e-19 \
 //x=7.51 //y=0.905 //x2=7.965 //y2=0.905
cc_750 ( N_noxref_4_c_792_n N_noxref_7_c_1420_n ) capacitor c=0.003249f \
 //x=7.7 //y=1.57 //x2=7.965 //y2=1.25
cc_751 ( N_noxref_4_c_793_n N_noxref_7_c_1420_n ) capacitor c=0.00323005f \
 //x=8.055 //y=1.655 //x2=7.965 //y2=1.25
cc_752 ( N_noxref_4_c_823_n N_noxref_7_c_1420_n ) capacitor c=0.00317092f \
 //x=7.7 //y=1 //x2=7.965 //y2=1.25
cc_753 ( N_noxref_4_M4_noxref_d N_noxref_7_c_1420_n ) capacitor c=0.00237422f \
 //x=7.51 //y=0.905 //x2=7.965 //y2=1.25
cc_754 ( N_noxref_4_c_776_n N_noxref_7_c_1421_n ) capacitor c=0.00281392f \
 //x=8.14 //y=3.18 //x2=7.4 //y2=2.08
cc_755 ( N_noxref_4_c_792_n N_noxref_7_c_1471_n ) capacitor c=0.00341114f \
 //x=7.7 //y=1.57 //x2=7.4 //y2=1.915
cc_756 ( N_noxref_4_c_776_n N_noxref_7_c_1471_n ) capacitor c=0.00309058f \
 //x=8.14 //y=3.18 //x2=7.4 //y2=1.915
cc_757 ( N_noxref_4_c_775_n N_noxref_7_c_1424_n ) capacitor c=9.8107e-19 \
 //x=7.545 //y=5.2 //x2=7.43 //y2=4.7
cc_758 ( N_noxref_4_c_777_n N_noxref_7_c_1424_n ) capacitor c=0.00142201f \
 //x=8.14 //y=5.115 //x2=7.43 //y2=4.7
cc_759 ( N_noxref_4_c_793_n N_noxref_8_c_1645_n ) capacitor c=0.00653239f \
 //x=8.055 //y=1.655 //x2=9.975 //y2=0
cc_760 ( N_noxref_4_c_804_n N_noxref_8_c_1645_n ) capacitor c=4.51564e-19 \
 //x=8.14 //y=3.5 //x2=9.975 //y2=0
cc_761 ( N_noxref_4_c_823_n N_noxref_8_c_1645_n ) capacitor c=0.00949587f \
 //x=7.7 //y=1 //x2=9.975 //y2=0
cc_762 ( N_noxref_4_M4_noxref_d N_noxref_8_c_1645_n ) capacitor c=3.01654e-19 \
 //x=7.51 //y=0.905 //x2=9.975 //y2=0
cc_763 ( N_noxref_4_c_815_n N_noxref_8_c_1649_n ) capacitor c=3.36916e-19 \
 //x=10.73 //y=3.49 //x2=11.47 //y2=0
cc_764 ( N_noxref_4_c_826_n N_noxref_8_c_1649_n ) capacitor c=0.00234099f \
 //x=10.73 //y=2.08 //x2=11.47 //y2=0
cc_765 ( N_noxref_4_c_778_n N_noxref_8_c_1561_n ) capacitor c=6.97093e-19 \
 //x=6.78 //y=5.38 //x2=6.73 //y2=0.955
cc_766 ( N_noxref_4_c_823_n N_noxref_8_c_1561_n ) capacitor c=0.0140087f \
 //x=7.7 //y=1 //x2=6.73 //y2=0.955
cc_767 ( N_noxref_4_M4_noxref_d N_noxref_8_c_1561_n ) capacitor c=2.93544e-19 \
 //x=7.51 //y=0.905 //x2=6.73 //y2=0.955
cc_768 ( N_noxref_4_c_823_n N_noxref_8_c_1610_n ) capacitor c=0.00549186f \
 //x=7.7 //y=1 //x2=10.06 //y2=0.955
cc_769 ( N_noxref_4_c_793_n N_noxref_8_c_1577_n ) capacitor c=7.76556e-19 \
 //x=8.055 //y=1.655 //x2=8.71 //y2=0
cc_770 ( N_noxref_4_c_804_n N_noxref_8_c_1577_n ) capacitor c=3.21189e-19 \
 //x=8.14 //y=3.5 //x2=8.71 //y2=0
cc_771 ( N_noxref_4_c_823_n N_noxref_8_c_1578_n ) capacitor c=2.83275e-19 \
 //x=7.7 //y=1 //x2=11.47 //y2=0
cc_772 ( N_noxref_4_c_826_n N_noxref_8_c_1578_n ) capacitor c=3.77673e-19 \
 //x=10.73 //y=2.08 //x2=11.47 //y2=0
cc_773 ( N_noxref_4_c_836_n N_noxref_8_c_1578_n ) capacitor c=0.00224736f \
 //x=10.73 //y=2.08 //x2=11.47 //y2=0
cc_774 ( N_noxref_4_c_855_n N_noxref_8_c_1578_n ) capacitor c=0.0028807f \
 //x=11.295 //y=1.25 //x2=11.47 //y2=0
cc_775 ( N_noxref_4_c_856_n N_noxref_8_c_1578_n ) capacitor c=2.63786e-19 \
 //x=10.73 //y=2.08 //x2=11.47 //y2=0
cc_776 ( N_noxref_4_c_776_n N_noxref_8_c_1583_n ) capacitor c=9.32616e-19 \
 //x=8.14 //y=3.18 //x2=5.55 //y2=0
cc_777 ( N_noxref_4_c_792_n N_noxref_8_c_1631_n ) capacitor c=0.002973f \
 //x=7.7 //y=1.57 //x2=8.88 //y2=0
cc_778 ( N_noxref_4_c_793_n N_noxref_8_c_1631_n ) capacitor c=0.0308456f \
 //x=8.055 //y=1.655 //x2=8.88 //y2=0
cc_779 ( N_noxref_4_c_823_n N_noxref_8_M3_noxref_d ) capacitor c=2.82748e-19 \
 //x=7.7 //y=1 //x2=6.54 //y2=0.865
cc_780 ( N_noxref_4_c_815_n N_noxref_9_c_1768_n ) capacitor c=0.00225132f \
 //x=10.73 //y=3.49 //x2=10.875 //y2=5.2
cc_781 ( N_noxref_4_c_816_n N_noxref_9_c_1768_n ) capacitor c=0.0226171f \
 //x=10.73 //y=4.555 //x2=10.875 //y2=5.2
cc_782 ( N_noxref_4_c_829_n N_noxref_9_c_1768_n ) capacitor c=0.00104016f \
 //x=10.57 //y=3.33 //x2=10.875 //y2=5.2
cc_783 ( N_noxref_4_c_835_n N_noxref_9_c_1768_n ) capacitor c=7.82777e-19 \
 //x=10.73 //y=3.33 //x2=10.875 //y2=5.2
cc_784 ( N_noxref_4_c_840_n N_noxref_9_c_1768_n ) capacitor c=0.00469257f \
 //x=10.76 //y=4.7 //x2=10.875 //y2=5.2
cc_785 ( N_noxref_4_M19_noxref_g N_noxref_9_c_1768_n ) capacitor c=0.00842859f \
 //x=10.77 //y=6.02 //x2=10.875 //y2=5.2
cc_786 ( N_noxref_4_c_859_n N_noxref_9_c_1768_n ) capacitor c=9.10962e-19 \
 //x=10.76 //y=4.7 //x2=10.875 //y2=5.2
cc_787 ( N_noxref_4_c_792_n N_noxref_9_c_1789_n ) capacitor c=0.00324213f \
 //x=7.7 //y=1.57 //x2=11.03 //y2=1.57
cc_788 ( N_noxref_4_c_849_n N_noxref_9_c_1789_n ) capacitor c=0.00119008f \
 //x=10.765 //y=1.25 //x2=11.03 //y2=1.57
cc_789 ( N_noxref_4_c_851_n N_noxref_9_c_1789_n ) capacitor c=0.00438634f \
 //x=10.765 //y=1.56 //x2=11.03 //y2=1.57
cc_790 ( N_noxref_4_c_985_p N_noxref_9_c_1789_n ) capacitor c=0.00929259f \
 //x=11.14 //y=1.405 //x2=11.03 //y2=1.57
cc_791 ( N_noxref_4_c_855_n N_noxref_9_c_1789_n ) capacitor c=0.00341295f \
 //x=11.295 //y=1.25 //x2=11.03 //y2=1.57
cc_792 ( N_noxref_4_c_987_p N_noxref_9_c_1789_n ) capacitor c=0.00341114f \
 //x=10.73 //y=1.915 //x2=11.03 //y2=1.57
cc_793 ( N_noxref_4_M20_noxref_g N_noxref_9_c_1795_n ) capacitor c=0.0115937f \
 //x=11.21 //y=6.02 //x2=11.385 //y2=5.2
cc_794 ( N_noxref_4_c_985_p N_noxref_9_c_1796_n ) capacitor c=0.00194324f \
 //x=11.14 //y=1.405 //x2=11.385 //y2=1.655
cc_795 ( N_noxref_4_c_855_n N_noxref_9_c_1796_n ) capacitor c=0.00323005f \
 //x=11.295 //y=1.25 //x2=11.385 //y2=1.655
cc_796 ( N_noxref_4_c_793_n N_noxref_9_c_1798_n ) capacitor c=0.00231467f \
 //x=8.055 //y=1.655 //x2=11.115 //y2=1.655
cc_797 ( N_noxref_4_c_777_n N_noxref_9_c_1769_n ) capacitor c=9.42509e-19 \
 //x=8.14 //y=5.115 //x2=11.47 //y2=5.115
cc_798 ( N_noxref_4_c_809_n N_noxref_9_c_1769_n ) capacitor c=0.0428994f \
 //x=10.73 //y=3.17 //x2=11.47 //y2=5.115
cc_799 ( N_noxref_4_c_815_n N_noxref_9_c_1769_n ) capacitor c=0.0149195f \
 //x=10.73 //y=3.49 //x2=11.47 //y2=5.115
cc_800 ( N_noxref_4_c_816_n N_noxref_9_c_1769_n ) capacitor c=0.0664964f \
 //x=10.73 //y=4.555 //x2=11.47 //y2=5.115
cc_801 ( N_noxref_4_c_825_n N_noxref_9_c_1769_n ) capacitor c=0.00539899f \
 //x=10.73 //y=3.33 //x2=11.47 //y2=5.115
cc_802 ( N_noxref_4_c_826_n N_noxref_9_c_1769_n ) capacitor c=0.015397f \
 //x=10.73 //y=2.08 //x2=11.47 //y2=5.115
cc_803 ( N_noxref_4_c_835_n N_noxref_9_c_1769_n ) capacitor c=0.00687201f \
 //x=10.73 //y=3.33 //x2=11.47 //y2=5.115
cc_804 ( N_noxref_4_c_836_n N_noxref_9_c_1769_n ) capacitor c=0.00440663f \
 //x=10.73 //y=2.08 //x2=11.47 //y2=5.115
cc_805 ( N_noxref_4_c_840_n N_noxref_9_c_1769_n ) capacitor c=0.00448306f \
 //x=10.76 //y=4.7 //x2=11.47 //y2=5.115
cc_806 ( N_noxref_4_c_891_p N_noxref_9_c_1769_n ) capacitor c=0.00461871f \
 //x=11.135 //y=4.79 //x2=11.47 //y2=5.115
cc_807 ( N_noxref_4_c_856_n N_noxref_9_c_1769_n ) capacitor c=0.00271446f \
 //x=10.73 //y=2.08 //x2=11.47 //y2=5.115
cc_808 ( N_noxref_4_c_859_n N_noxref_9_c_1769_n ) capacitor c=0.00142201f \
 //x=10.76 //y=4.7 //x2=11.47 //y2=5.115
cc_809 ( N_noxref_4_c_863_p N_noxref_9_c_1771_n ) capacitor c=0.00114153f \
 //x=8.055 //y=5.2 //x2=10.11 //y2=5.38
cc_810 ( N_noxref_4_c_866_p N_noxref_9_c_1771_n ) capacitor c=5.29822e-19 \
 //x=7.66 //y=5.2 //x2=10.11 //y2=5.38
cc_811 ( N_noxref_4_c_867_p N_noxref_9_c_1771_n ) capacitor c=0.00147119f \
 //x=7.66 //y=5.38 //x2=10.11 //y2=5.38
cc_812 ( N_noxref_4_c_829_n N_noxref_9_c_1771_n ) capacitor c=0.0100578f \
 //x=10.57 //y=3.33 //x2=10.11 //y2=5.38
cc_813 ( N_noxref_4_M19_noxref_g N_noxref_9_c_1815_n ) capacitor c=0.00192712f \
 //x=10.77 //y=6.02 //x2=10.99 //y2=5.2
cc_814 ( N_noxref_4_M20_noxref_g N_noxref_9_c_1815_n ) capacitor c=0.00362563f \
 //x=11.21 //y=6.02 //x2=10.99 //y2=5.2
cc_815 ( N_noxref_4_c_891_p N_noxref_9_c_1815_n ) capacitor c=0.0020909f \
 //x=11.135 //y=4.79 //x2=10.99 //y2=5.2
cc_816 ( N_noxref_4_c_823_n N_noxref_9_c_1818_n ) capacitor c=6.99317e-19 \
 //x=7.7 //y=1 //x2=11.03 //y2=1
cc_817 ( N_noxref_4_c_846_n N_noxref_9_c_1818_n ) capacitor c=0.00120406f \
 //x=10.765 //y=0.905 //x2=11.03 //y2=1
cc_818 ( N_noxref_4_c_849_n N_noxref_9_c_1818_n ) capacitor c=0.00218694f \
 //x=10.765 //y=1.25 //x2=11.03 //y2=1
cc_819 ( N_noxref_4_c_1014_p N_noxref_9_c_1818_n ) capacitor c=5.50523e-19 \
 //x=11.14 //y=0.75 //x2=11.03 //y2=1
cc_820 ( N_noxref_4_c_985_p N_noxref_9_c_1818_n ) capacitor c=5.67071e-19 \
 //x=11.14 //y=1.405 //x2=11.03 //y2=1
cc_821 ( N_noxref_4_c_854_n N_noxref_9_c_1818_n ) capacitor c=0.00121175f \
 //x=11.295 //y=0.905 //x2=11.03 //y2=1
cc_822 ( N_noxref_4_c_855_n N_noxref_9_c_1818_n ) capacitor c=0.00366282f \
 //x=11.295 //y=1.25 //x2=11.03 //y2=1
cc_823 ( N_noxref_4_M19_noxref_g N_noxref_9_c_1825_n ) capacitor c=0.0178987f \
 //x=10.77 //y=6.02 //x2=10.99 //y2=5.38
cc_824 ( N_noxref_4_M20_noxref_g N_noxref_9_c_1825_n ) capacitor c=0.0178506f \
 //x=11.21 //y=6.02 //x2=10.99 //y2=5.38
cc_825 ( N_noxref_4_c_891_p N_noxref_9_c_1825_n ) capacitor c=0.00291714f \
 //x=11.135 //y=4.79 //x2=10.99 //y2=5.38
cc_826 ( N_noxref_4_c_846_n N_noxref_9_M6_noxref_d ) capacitor c=0.00137165f \
 //x=10.765 //y=0.905 //x2=10.84 //y2=0.905
cc_827 ( N_noxref_4_c_849_n N_noxref_9_M6_noxref_d ) capacitor c=0.00237422f \
 //x=10.765 //y=1.25 //x2=10.84 //y2=0.905
cc_828 ( N_noxref_4_c_1014_p N_noxref_9_M6_noxref_d ) capacitor c=0.0020782f \
 //x=11.14 //y=0.75 //x2=10.84 //y2=0.905
cc_829 ( N_noxref_4_c_985_p N_noxref_9_M6_noxref_d ) capacitor c=0.00356097f \
 //x=11.14 //y=1.405 //x2=10.84 //y2=0.905
cc_830 ( N_noxref_4_c_854_n N_noxref_9_M6_noxref_d ) capacitor c=8.50095e-19 \
 //x=11.295 //y=0.905 //x2=10.84 //y2=0.905
cc_831 ( N_noxref_4_c_855_n N_noxref_9_M6_noxref_d ) capacitor c=0.00237422f \
 //x=11.295 //y=1.25 //x2=10.84 //y2=0.905
cc_832 ( N_noxref_4_c_794_n N_noxref_11_c_1964_n ) capacitor c=0.00911498f \
 //x=7.785 //y=1.655 //x2=7.215 //y2=1.495
cc_833 ( N_noxref_4_c_793_n N_noxref_11_c_1974_n ) capacitor c=0.00373013f \
 //x=8.055 //y=1.655 //x2=8.1 //y2=0.53
cc_834 ( N_noxref_4_c_823_n N_noxref_11_c_1974_n ) capacitor c=0.00367971f \
 //x=7.7 //y=1 //x2=8.1 //y2=0.53
cc_835 ( N_noxref_4_M4_noxref_d N_noxref_11_c_1974_n ) capacitor c=0.00910163f \
 //x=7.51 //y=0.905 //x2=8.1 //y2=0.53
cc_836 ( N_noxref_4_c_792_n N_noxref_11_M3_noxref_s ) capacitor c=0.0162484f \
 //x=7.7 //y=1.57 //x2=6.11 //y2=0.365
cc_837 ( N_noxref_4_c_793_n N_noxref_11_M3_noxref_s ) capacitor c=0.00640979f \
 //x=8.055 //y=1.655 //x2=6.11 //y2=0.365
cc_838 ( N_noxref_4_c_804_n N_noxref_11_M3_noxref_s ) capacitor c=4.13941e-19 \
 //x=8.14 //y=3.5 //x2=6.11 //y2=0.365
cc_839 ( N_noxref_4_c_823_n N_noxref_11_M3_noxref_s ) capacitor c=0.00905169f \
 //x=7.7 //y=1 //x2=6.11 //y2=0.365
cc_840 ( N_noxref_4_c_785_n N_noxref_11_M3_noxref_s ) capacitor c=0.0010514f \
 //x=8.14 //y=3.33 //x2=6.11 //y2=0.365
cc_841 ( N_noxref_4_M4_noxref_d N_noxref_11_M3_noxref_s ) capacitor \
 c=0.0275552f //x=7.51 //y=0.905 //x2=6.11 //y2=0.365
cc_842 ( N_noxref_4_c_829_n N_noxref_12_c_2029_n ) capacitor c=0.00436777f \
 //x=10.57 //y=3.33 //x2=10.46 //y2=1.58
cc_843 ( N_noxref_4_c_815_n N_noxref_12_c_2037_n ) capacitor c=0.00167766f \
 //x=10.73 //y=3.49 //x2=10.545 //y2=1.495
cc_844 ( N_noxref_4_c_826_n N_noxref_12_c_2037_n ) capacitor c=7.50092e-19 \
 //x=10.73 //y=2.08 //x2=10.545 //y2=1.495
cc_845 ( N_noxref_4_c_851_n N_noxref_12_c_2037_n ) capacitor c=0.00890678f \
 //x=10.765 //y=1.56 //x2=10.545 //y2=1.495
cc_846 ( N_noxref_4_c_856_n N_noxref_12_c_2037_n ) capacitor c=0.00175171f \
 //x=10.73 //y=2.08 //x2=10.545 //y2=1.495
cc_847 ( N_noxref_4_c_826_n N_noxref_12_c_2046_n ) capacitor c=0.001463f \
 //x=10.73 //y=2.08 //x2=11.43 //y2=0.53
cc_848 ( N_noxref_4_c_836_n N_noxref_12_c_2046_n ) capacitor c=8.82141e-19 \
 //x=10.73 //y=2.08 //x2=11.43 //y2=0.53
cc_849 ( N_noxref_4_c_846_n N_noxref_12_c_2046_n ) capacitor c=0.0200262f \
 //x=10.765 //y=0.905 //x2=11.43 //y2=0.53
cc_850 ( N_noxref_4_c_854_n N_noxref_12_c_2046_n ) capacitor c=0.00825432f \
 //x=11.295 //y=0.905 //x2=11.43 //y2=0.53
cc_851 ( N_noxref_4_c_856_n N_noxref_12_c_2046_n ) capacitor c=2.1838e-19 \
 //x=10.73 //y=2.08 //x2=11.43 //y2=0.53
cc_852 ( N_noxref_4_c_846_n N_noxref_12_M5_noxref_s ) capacitor c=0.00890678f \
 //x=10.765 //y=0.905 //x2=9.44 //y2=0.365
cc_853 ( N_noxref_4_c_854_n N_noxref_12_M5_noxref_s ) capacitor c=0.015333f \
 //x=11.295 //y=0.905 //x2=9.44 //y2=0.365
cc_854 ( N_noxref_4_c_855_n N_noxref_12_M5_noxref_s ) capacitor c=0.00248746f \
 //x=11.295 //y=1.25 //x2=9.44 //y2=0.365
cc_855 ( N_noxref_5_c_1099_n N_noxref_6_c_1294_n ) capacitor c=0.00226427f \
 //x=5.55 //y=7.4 //x2=4.1 //y2=4.7
cc_856 ( N_noxref_5_c_1133_n N_noxref_6_M11_noxref_g ) capacitor c=0.00692597f \
 //x=4.685 //y=7.4 //x2=4.11 //y2=6.02
cc_857 ( N_noxref_5_M10_noxref_d N_noxref_6_M11_noxref_g ) capacitor \
 c=0.015318f //x=3.745 //y=5.02 //x2=4.11 //y2=6.02
cc_858 ( N_noxref_5_c_1133_n N_noxref_6_M12_noxref_g ) capacitor c=0.00749619f \
 //x=4.685 //y=7.4 //x2=4.55 //y2=6.02
cc_859 ( N_noxref_5_M12_noxref_d N_noxref_6_M12_noxref_g ) capacitor \
 c=0.0430452f //x=4.625 //y=5.02 //x2=4.55 //y2=6.02
cc_860 ( N_noxref_5_c_1099_n N_noxref_6_c_1345_n ) capacitor c=0.0129149f \
 //x=5.55 //y=7.4 //x2=4.475 //y2=4.79
cc_861 ( N_noxref_5_c_1099_n N_noxref_6_c_1313_n ) capacitor c=2.73429e-19 \
 //x=5.55 //y=7.4 //x2=4.1 //y2=4.7
cc_862 ( N_noxref_5_M10_noxref_d N_noxref_6_c_1313_n ) capacitor c=3.32274e-19 \
 //x=3.745 //y=5.02 //x2=4.1 //y2=4.7
cc_863 ( N_noxref_5_c_1148_n N_noxref_7_c_1405_n ) capacitor c=0.00226427f \
 //x=8.88 //y=7.4 //x2=7.43 //y2=4.7
cc_864 ( N_noxref_5_c_1184_n N_noxref_7_M15_noxref_g ) capacitor c=0.00692597f \
 //x=8.015 //y=7.4 //x2=7.44 //y2=6.02
cc_865 ( N_noxref_5_M14_noxref_d N_noxref_7_M15_noxref_g ) capacitor \
 c=0.015318f //x=7.075 //y=5.02 //x2=7.44 //y2=6.02
cc_866 ( N_noxref_5_c_1184_n N_noxref_7_M16_noxref_g ) capacitor c=0.00749619f \
 //x=8.015 //y=7.4 //x2=7.88 //y2=6.02
cc_867 ( N_noxref_5_M16_noxref_d N_noxref_7_M16_noxref_g ) capacitor \
 c=0.0430452f //x=7.955 //y=5.02 //x2=7.88 //y2=6.02
cc_868 ( N_noxref_5_c_1148_n N_noxref_7_c_1455_n ) capacitor c=0.0129149f \
 //x=8.88 //y=7.4 //x2=7.805 //y2=4.79
cc_869 ( N_noxref_5_c_1148_n N_noxref_7_c_1424_n ) capacitor c=2.73429e-19 \
 //x=8.88 //y=7.4 //x2=7.43 //y2=4.7
cc_870 ( N_noxref_5_M14_noxref_d N_noxref_7_c_1424_n ) capacitor c=3.32274e-19 \
 //x=7.075 //y=5.02 //x2=7.43 //y2=4.7
cc_871 ( N_noxref_5_c_1104_n N_noxref_8_c_1578_n ) capacitor c=0.00989031f \
 //x=11.47 //y=7.4 //x2=11.47 //y2=0
cc_872 ( N_noxref_5_c_1061_n N_noxref_8_c_1525_n ) capacitor c=0.00989031f \
 //x=0.74 //y=7.4 //x2=0.63 //y2=0
cc_873 ( N_noxref_5_c_1065_n N_noxref_8_c_1530_n ) capacitor c=0.00905767f \
 //x=2.22 //y=7.4 //x2=2.22 //y2=0
cc_874 ( N_noxref_5_c_1099_n N_noxref_8_c_1583_n ) capacitor c=0.00905767f \
 //x=5.55 //y=7.4 //x2=5.55 //y2=0
cc_875 ( N_noxref_5_c_1148_n N_noxref_8_c_1631_n ) capacitor c=0.00905767f \
 //x=8.88 //y=7.4 //x2=8.88 //y2=0
cc_876 ( N_noxref_5_c_1050_n N_noxref_9_c_1768_n ) capacitor c=0.0064752f \
 //x=11.47 //y=7.4 //x2=10.875 //y2=5.2
cc_877 ( N_noxref_5_c_1138_n N_noxref_9_c_1768_n ) capacitor c=0.00208112f \
 //x=10.465 //y=7.4 //x2=10.875 //y2=5.2
cc_878 ( N_noxref_5_c_1189_n N_noxref_9_c_1768_n ) capacitor c=0.00180744f \
 //x=11.345 //y=7.4 //x2=10.875 //y2=5.2
cc_879 ( N_noxref_5_M18_noxref_d N_noxref_9_c_1768_n ) capacitor c=0.00734028f \
 //x=10.405 //y=5.02 //x2=10.875 //y2=5.2
cc_880 ( N_noxref_5_c_1050_n N_noxref_9_c_1795_n ) capacitor c=0.0048744f \
 //x=11.47 //y=7.4 //x2=11.385 //y2=5.2
cc_881 ( N_noxref_5_c_1189_n N_noxref_9_c_1795_n ) capacitor c=0.00213214f \
 //x=11.345 //y=7.4 //x2=11.385 //y2=5.2
cc_882 ( N_noxref_5_M20_noxref_d N_noxref_9_c_1795_n ) capacitor c=0.0125278f \
 //x=11.285 //y=5.02 //x2=11.385 //y2=5.2
cc_883 ( N_noxref_5_c_1148_n N_noxref_9_c_1769_n ) capacitor c=6.93347e-19 \
 //x=8.88 //y=7.4 //x2=11.47 //y2=5.115
cc_884 ( N_noxref_5_c_1104_n N_noxref_9_c_1769_n ) capacitor c=0.0392011f \
 //x=11.47 //y=7.4 //x2=11.47 //y2=5.115
cc_885 ( N_noxref_5_c_1050_n N_noxref_9_c_1771_n ) capacitor c=0.00368144f \
 //x=11.47 //y=7.4 //x2=10.11 //y2=5.38
cc_886 ( N_noxref_5_c_1138_n N_noxref_9_c_1771_n ) capacitor c=9.98713e-19 \
 //x=10.465 //y=7.4 //x2=10.11 //y2=5.38
cc_887 ( N_noxref_5_c_1148_n N_noxref_9_c_1771_n ) capacitor c=4.91377e-19 \
 //x=8.88 //y=7.4 //x2=10.11 //y2=5.38
cc_888 ( N_noxref_5_M17_noxref_s N_noxref_9_c_1771_n ) capacitor c=0.0577058f \
 //x=9.535 //y=5.02 //x2=10.11 //y2=5.38
cc_889 ( N_noxref_5_M18_noxref_d N_noxref_9_c_1771_n ) capacitor c=0.0043528f \
 //x=10.405 //y=5.02 //x2=10.11 //y2=5.38
cc_890 ( N_noxref_5_c_1050_n N_noxref_9_c_1815_n ) capacitor c=8.4112e-19 \
 //x=11.47 //y=7.4 //x2=10.99 //y2=5.2
cc_891 ( N_noxref_5_c_1189_n N_noxref_9_c_1815_n ) capacitor c=5.09756e-19 \
 //x=11.345 //y=7.4 //x2=10.99 //y2=5.2
cc_892 ( N_noxref_5_c_1104_n N_noxref_9_c_1815_n ) capacitor c=0.00379179f \
 //x=11.47 //y=7.4 //x2=10.99 //y2=5.2
cc_893 ( N_noxref_5_M17_noxref_s N_noxref_9_c_1815_n ) capacitor c=6.52457e-19 \
 //x=9.535 //y=5.02 //x2=10.99 //y2=5.2
cc_894 ( N_noxref_5_c_1050_n N_noxref_9_c_1852_n ) capacitor c=0.00285294f \
 //x=11.47 //y=7.4 //x2=10.99 //y2=5.38
cc_895 ( N_noxref_5_c_1189_n N_noxref_9_c_1852_n ) capacitor c=5.78261e-19 \
 //x=11.345 //y=7.4 //x2=10.99 //y2=5.38
cc_896 ( N_noxref_5_c_1104_n N_noxref_9_c_1852_n ) capacitor c=0.0016115f \
 //x=11.47 //y=7.4 //x2=10.99 //y2=5.38
cc_897 ( N_noxref_5_M18_noxref_d N_noxref_9_c_1852_n ) capacitor c=0.0043528f \
 //x=10.405 //y=5.02 //x2=10.99 //y2=5.38
cc_898 ( N_noxref_5_M20_noxref_d N_noxref_9_c_1852_n ) capacitor c=0.00979407f \
 //x=11.285 //y=5.02 //x2=10.99 //y2=5.38
cc_899 ( N_noxref_5_c_1050_n N_noxref_9_c_1777_n ) capacitor c=0.00224727f \
 //x=11.47 //y=7.4 //x2=10.11 //y2=5.38
cc_900 ( N_noxref_5_c_1138_n N_noxref_9_c_1777_n ) capacitor c=0.0136475f \
 //x=10.465 //y=7.4 //x2=10.11 //y2=5.38
cc_901 ( N_noxref_5_c_1148_n N_noxref_9_c_1777_n ) capacitor c=0.0064135f \
 //x=8.88 //y=7.4 //x2=10.11 //y2=5.38
cc_902 ( N_noxref_5_c_1104_n N_noxref_9_c_1777_n ) capacitor c=0.00135089f \
 //x=11.47 //y=7.4 //x2=10.11 //y2=5.38
cc_903 ( N_noxref_5_M17_noxref_s N_noxref_9_c_1777_n ) capacitor c=0.0887533f \
 //x=9.535 //y=5.02 //x2=10.11 //y2=5.38
cc_904 ( N_noxref_5_M18_noxref_d N_noxref_9_c_1777_n ) capacitor c=0.065554f \
 //x=10.405 //y=5.02 //x2=10.11 //y2=5.38
cc_905 ( N_noxref_5_c_1050_n N_noxref_9_c_1825_n ) capacitor c=0.00224727f \
 //x=11.47 //y=7.4 //x2=10.99 //y2=5.38
cc_906 ( N_noxref_5_c_1189_n N_noxref_9_c_1825_n ) capacitor c=0.0136475f \
 //x=11.345 //y=7.4 //x2=10.99 //y2=5.38
cc_907 ( N_noxref_5_c_1104_n N_noxref_9_c_1825_n ) capacitor c=0.0115375f \
 //x=11.47 //y=7.4 //x2=10.99 //y2=5.38
cc_908 ( N_noxref_5_M18_noxref_d N_noxref_9_c_1825_n ) capacitor c=0.065554f \
 //x=10.405 //y=5.02 //x2=10.99 //y2=5.38
cc_909 ( N_noxref_5_M20_noxref_d N_noxref_9_c_1825_n ) capacitor c=0.065554f \
 //x=11.285 //y=5.02 //x2=10.99 //y2=5.38
cc_910 ( N_noxref_6_c_1287_n N_noxref_8_c_1601_n ) capacitor c=0.00234099f \
 //x=4.07 //y=2.08 //x2=6.645 //y2=0
cc_911 ( N_noxref_6_c_1287_n N_noxref_8_c_1524_n ) capacitor c=3.77673e-19 \
 //x=4.07 //y=2.08 //x2=5.38 //y2=0
cc_912 ( N_noxref_6_c_1290_n N_noxref_8_c_1583_n ) capacitor c=0.00224736f \
 //x=4.07 //y=2.08 //x2=5.55 //y2=0
cc_913 ( N_noxref_6_c_1309_n N_noxref_8_c_1583_n ) capacitor c=0.00275184f \
 //x=4.635 //y=1.25 //x2=5.55 //y2=0
cc_914 ( N_noxref_6_c_1310_n N_noxref_8_c_1583_n ) capacitor c=2.63786e-19 \
 //x=4.07 //y=2.08 //x2=5.55 //y2=0
cc_915 ( N_noxref_6_c_1287_n N_noxref_10_c_1897_n ) capacitor c=7.50092e-19 \
 //x=4.07 //y=2.08 //x2=3.885 //y2=1.495
cc_916 ( N_noxref_6_c_1305_n N_noxref_10_c_1897_n ) capacitor c=0.00888238f \
 //x=4.105 //y=1.56 //x2=3.885 //y2=1.495
cc_917 ( N_noxref_6_c_1310_n N_noxref_10_c_1897_n ) capacitor c=0.00175171f \
 //x=4.07 //y=2.08 //x2=3.885 //y2=1.495
cc_918 ( N_noxref_6_c_1287_n N_noxref_10_c_1904_n ) capacitor c=0.00141156f \
 //x=4.07 //y=2.08 //x2=4.77 //y2=0.53
cc_919 ( N_noxref_6_c_1290_n N_noxref_10_c_1904_n ) capacitor c=8.82141e-19 \
 //x=4.07 //y=2.08 //x2=4.77 //y2=0.53
cc_920 ( N_noxref_6_c_1300_n N_noxref_10_c_1904_n ) capacitor c=0.0199501f \
 //x=4.105 //y=0.905 //x2=4.77 //y2=0.53
cc_921 ( N_noxref_6_c_1308_n N_noxref_10_c_1904_n ) capacitor c=0.00825432f \
 //x=4.635 //y=0.905 //x2=4.77 //y2=0.53
cc_922 ( N_noxref_6_c_1310_n N_noxref_10_c_1904_n ) capacitor c=2.1838e-19 \
 //x=4.07 //y=2.08 //x2=4.77 //y2=0.53
cc_923 ( N_noxref_6_c_1300_n N_noxref_10_M1_noxref_s ) capacitor c=0.00888238f \
 //x=4.105 //y=0.905 //x2=2.78 //y2=0.365
cc_924 ( N_noxref_6_c_1308_n N_noxref_10_M1_noxref_s ) capacitor c=0.015333f \
 //x=4.635 //y=0.905 //x2=2.78 //y2=0.365
cc_925 ( N_noxref_6_c_1309_n N_noxref_10_M1_noxref_s ) capacitor c=0.00248746f \
 //x=4.635 //y=1.25 //x2=2.78 //y2=0.365
cc_926 ( N_noxref_7_c_1398_n N_noxref_8_c_1645_n ) capacitor c=0.00234099f \
 //x=7.4 //y=2.08 //x2=9.975 //y2=0
cc_927 ( N_noxref_7_c_1398_n N_noxref_8_c_1577_n ) capacitor c=3.77673e-19 \
 //x=7.4 //y=2.08 //x2=8.71 //y2=0
cc_928 ( N_noxref_7_c_1401_n N_noxref_8_c_1631_n ) capacitor c=0.00224736f \
 //x=7.4 //y=2.08 //x2=8.88 //y2=0
cc_929 ( N_noxref_7_c_1420_n N_noxref_8_c_1631_n ) capacitor c=0.00275184f \
 //x=7.965 //y=1.25 //x2=8.88 //y2=0
cc_930 ( N_noxref_7_c_1421_n N_noxref_8_c_1631_n ) capacitor c=2.63786e-19 \
 //x=7.4 //y=2.08 //x2=8.88 //y2=0
cc_931 ( N_noxref_7_c_1398_n N_noxref_11_c_1964_n ) capacitor c=7.50092e-19 \
 //x=7.4 //y=2.08 //x2=7.215 //y2=1.495
cc_932 ( N_noxref_7_c_1416_n N_noxref_11_c_1964_n ) capacitor c=0.00888238f \
 //x=7.435 //y=1.56 //x2=7.215 //y2=1.495
cc_933 ( N_noxref_7_c_1421_n N_noxref_11_c_1964_n ) capacitor c=0.00175171f \
 //x=7.4 //y=2.08 //x2=7.215 //y2=1.495
cc_934 ( N_noxref_7_c_1398_n N_noxref_11_c_1974_n ) capacitor c=0.00141156f \
 //x=7.4 //y=2.08 //x2=8.1 //y2=0.53
cc_935 ( N_noxref_7_c_1401_n N_noxref_11_c_1974_n ) capacitor c=8.82141e-19 \
 //x=7.4 //y=2.08 //x2=8.1 //y2=0.53
cc_936 ( N_noxref_7_c_1411_n N_noxref_11_c_1974_n ) capacitor c=0.0199501f \
 //x=7.435 //y=0.905 //x2=8.1 //y2=0.53
cc_937 ( N_noxref_7_c_1419_n N_noxref_11_c_1974_n ) capacitor c=0.00825432f \
 //x=7.965 //y=0.905 //x2=8.1 //y2=0.53
cc_938 ( N_noxref_7_c_1421_n N_noxref_11_c_1974_n ) capacitor c=2.1838e-19 \
 //x=7.4 //y=2.08 //x2=8.1 //y2=0.53
cc_939 ( N_noxref_7_c_1411_n N_noxref_11_M3_noxref_s ) capacitor c=0.00888238f \
 //x=7.435 //y=0.905 //x2=6.11 //y2=0.365
cc_940 ( N_noxref_7_c_1419_n N_noxref_11_M3_noxref_s ) capacitor c=0.015333f \
 //x=7.965 //y=0.905 //x2=6.11 //y2=0.365
cc_941 ( N_noxref_7_c_1420_n N_noxref_11_M3_noxref_s ) capacitor c=0.00248746f \
 //x=7.965 //y=1.25 //x2=6.11 //y2=0.365
cc_942 ( N_noxref_8_c_1578_n N_noxref_9_c_1789_n ) capacitor c=0.00528499f \
 //x=11.47 //y=0 //x2=11.03 //y2=1.57
cc_943 ( N_noxref_8_c_1649_n N_noxref_9_c_1796_n ) capacitor c=0.00651357f \
 //x=11.47 //y=0 //x2=11.385 //y2=1.655
cc_944 ( N_noxref_8_c_1578_n N_noxref_9_c_1796_n ) capacitor c=0.0406521f \
 //x=11.47 //y=0 //x2=11.385 //y2=1.655
cc_945 ( N_noxref_8_c_1631_n N_noxref_9_c_1769_n ) capacitor c=3.54807e-19 \
 //x=8.88 //y=0 //x2=11.47 //y2=5.115
cc_946 ( N_noxref_8_c_1610_n N_noxref_9_c_1771_n ) capacitor c=8.02544e-19 \
 //x=10.06 //y=0.955 //x2=10.11 //y2=5.38
cc_947 ( N_noxref_8_c_1649_n N_noxref_9_c_1818_n ) capacitor c=0.00963092f \
 //x=11.47 //y=0 //x2=11.03 //y2=1
cc_948 ( N_noxref_8_c_1610_n N_noxref_9_c_1818_n ) capacitor c=0.0141824f \
 //x=10.06 //y=0.955 //x2=11.03 //y2=1
cc_949 ( N_noxref_8_c_1578_n N_noxref_9_c_1818_n ) capacitor c=2.83275e-19 \
 //x=11.47 //y=0 //x2=11.03 //y2=1
cc_950 ( N_noxref_8_M5_noxref_d N_noxref_9_c_1818_n ) capacitor c=2.82748e-19 \
 //x=9.87 //y=0.865 //x2=11.03 //y2=1
cc_951 ( N_noxref_8_c_1649_n N_noxref_9_M6_noxref_d ) capacitor c=3.01654e-19 \
 //x=11.47 //y=0 //x2=10.84 //y2=0.905
cc_952 ( N_noxref_8_c_1610_n N_noxref_9_M6_noxref_d ) capacitor c=2.93544e-19 \
 //x=10.06 //y=0.955 //x2=10.84 //y2=0.905
cc_953 ( N_noxref_8_M0_noxref_s N_noxref_10_c_1887_n ) capacitor c=0.0029758f \
 //x=0.495 //y=0.37 //x2=2.915 //y2=1.495
cc_954 ( N_noxref_8_c_1499_n N_noxref_10_c_1889_n ) capacitor c=0.00238324f \
 //x=3.315 //y=0 //x2=3.8 //y2=1.58
cc_955 ( N_noxref_8_c_1601_n N_noxref_10_c_1889_n ) capacitor c=7.45312e-19 \
 //x=6.645 //y=0 //x2=3.8 //y2=1.58
cc_956 ( N_noxref_8_c_1504_n N_noxref_10_c_1889_n ) capacitor c=0.0039599f \
 //x=3.4 //y=0.955 //x2=3.8 //y2=1.58
cc_957 ( N_noxref_8_c_1524_n N_noxref_10_c_1889_n ) capacitor c=0.00374872f \
 //x=5.38 //y=0 //x2=3.8 //y2=1.58
cc_958 ( N_noxref_8_M1_noxref_d N_noxref_10_c_1889_n ) capacitor c=0.00578453f \
 //x=3.21 //y=0.865 //x2=3.8 //y2=1.58
cc_959 ( N_noxref_8_c_1601_n N_noxref_10_c_1930_n ) capacitor c=0.00681952f \
 //x=6.645 //y=0 //x2=3.885 //y2=0.615
cc_960 ( N_noxref_8_c_1515_n N_noxref_10_c_1930_n ) capacitor c=0.0120153f \
 //x=3.397 //y=0.825 //x2=3.885 //y2=0.615
cc_961 ( N_noxref_8_c_1524_n N_noxref_10_c_1930_n ) capacitor c=0.0146219f \
 //x=5.38 //y=0 //x2=3.885 //y2=0.615
cc_962 ( N_noxref_8_c_1578_n N_noxref_10_c_1930_n ) capacitor c=0.00145873f \
 //x=11.47 //y=0 //x2=3.885 //y2=0.615
cc_963 ( N_noxref_8_c_1530_n N_noxref_10_c_1930_n ) capacitor c=0.00282499f \
 //x=2.22 //y=0 //x2=3.885 //y2=0.615
cc_964 ( N_noxref_8_c_1583_n N_noxref_10_c_1930_n ) capacitor c=2.99356e-19 \
 //x=5.55 //y=0 //x2=3.885 //y2=0.615
cc_965 ( N_noxref_8_c_1530_n N_noxref_10_c_1897_n ) capacitor c=2.84609e-19 \
 //x=2.22 //y=0 //x2=3.885 //y2=1.495
cc_966 ( N_noxref_8_c_1601_n N_noxref_10_c_1904_n ) capacitor c=0.0100354f \
 //x=6.645 //y=0 //x2=4.77 //y2=0.53
cc_967 ( N_noxref_8_c_1524_n N_noxref_10_c_1904_n ) capacitor c=0.0374402f \
 //x=5.38 //y=0 //x2=4.77 //y2=0.53
cc_968 ( N_noxref_8_c_1578_n N_noxref_10_c_1904_n ) capacitor c=0.00199095f \
 //x=11.47 //y=0 //x2=4.77 //y2=0.53
cc_969 ( N_noxref_8_c_1601_n N_noxref_10_c_1940_n ) capacitor c=0.00247862f \
 //x=6.645 //y=0 //x2=4.855 //y2=0.615
cc_970 ( N_noxref_8_c_1524_n N_noxref_10_c_1940_n ) capacitor c=0.014537f \
 //x=5.38 //y=0 //x2=4.855 //y2=0.615
cc_971 ( N_noxref_8_c_1578_n N_noxref_10_c_1940_n ) capacitor c=0.00145015f \
 //x=11.47 //y=0 //x2=4.855 //y2=0.615
cc_972 ( N_noxref_8_c_1583_n N_noxref_10_c_1940_n ) capacitor c=0.0392026f \
 //x=5.55 //y=0 //x2=4.855 //y2=0.615
cc_973 ( N_noxref_8_c_1499_n N_noxref_10_M1_noxref_s ) capacitor c=0.00723598f \
 //x=3.315 //y=0 //x2=2.78 //y2=0.365
cc_974 ( N_noxref_8_c_1504_n N_noxref_10_M1_noxref_s ) capacitor c=0.00996107f \
 //x=3.4 //y=0.955 //x2=2.78 //y2=0.365
cc_975 ( N_noxref_8_c_1515_n N_noxref_10_M1_noxref_s ) capacitor c=0.0170652f \
 //x=3.397 //y=0.825 //x2=2.78 //y2=0.365
cc_976 ( N_noxref_8_c_1715_p N_noxref_10_M1_noxref_s ) capacitor c=0.0029758f \
 //x=1.6 //y=0.45 //x2=2.78 //y2=0.365
cc_977 ( N_noxref_8_c_1524_n N_noxref_10_M1_noxref_s ) capacitor c=0.0146208f \
 //x=5.38 //y=0 //x2=2.78 //y2=0.365
cc_978 ( N_noxref_8_c_1578_n N_noxref_10_M1_noxref_s ) capacitor c=0.00145873f \
 //x=11.47 //y=0 //x2=2.78 //y2=0.365
cc_979 ( N_noxref_8_c_1530_n N_noxref_10_M1_noxref_s ) capacitor c=0.0528146f \
 //x=2.22 //y=0 //x2=2.78 //y2=0.365
cc_980 ( N_noxref_8_c_1583_n N_noxref_10_M1_noxref_s ) capacitor c=0.0064811f \
 //x=5.55 //y=0 //x2=2.78 //y2=0.365
cc_981 ( N_noxref_8_M1_noxref_d N_noxref_10_M1_noxref_s ) capacitor \
 c=0.0271276f //x=3.21 //y=0.865 //x2=2.78 //y2=0.365
cc_982 ( N_noxref_8_c_1601_n N_noxref_11_c_1957_n ) capacitor c=9.7972e-19 \
 //x=6.645 //y=0 //x2=7.13 //y2=1.58
cc_983 ( N_noxref_8_c_1645_n N_noxref_11_c_1957_n ) capacitor c=7.45312e-19 \
 //x=9.975 //y=0 //x2=7.13 //y2=1.58
cc_984 ( N_noxref_8_c_1561_n N_noxref_11_c_1957_n ) capacitor c=0.00398707f \
 //x=6.73 //y=0.955 //x2=7.13 //y2=1.58
cc_985 ( N_noxref_8_c_1577_n N_noxref_11_c_1957_n ) capacitor c=0.00392341f \
 //x=8.71 //y=0 //x2=7.13 //y2=1.58
cc_986 ( N_noxref_8_M3_noxref_d N_noxref_11_c_1957_n ) capacitor c=0.00578453f \
 //x=6.54 //y=0.865 //x2=7.13 //y2=1.58
cc_987 ( N_noxref_8_c_1645_n N_noxref_11_c_1999_n ) capacitor c=0.00681952f \
 //x=9.975 //y=0 //x2=7.215 //y2=0.615
cc_988 ( N_noxref_8_c_1570_n N_noxref_11_c_1999_n ) capacitor c=0.0120153f \
 //x=6.727 //y=0.825 //x2=7.215 //y2=0.615
cc_989 ( N_noxref_8_c_1577_n N_noxref_11_c_1999_n ) capacitor c=0.0146219f \
 //x=8.71 //y=0 //x2=7.215 //y2=0.615
cc_990 ( N_noxref_8_c_1578_n N_noxref_11_c_1999_n ) capacitor c=0.00145873f \
 //x=11.47 //y=0 //x2=7.215 //y2=0.615
cc_991 ( N_noxref_8_c_1583_n N_noxref_11_c_1999_n ) capacitor c=0.00282552f \
 //x=5.55 //y=0 //x2=7.215 //y2=0.615
cc_992 ( N_noxref_8_c_1631_n N_noxref_11_c_1999_n ) capacitor c=2.99356e-19 \
 //x=8.88 //y=0 //x2=7.215 //y2=0.615
cc_993 ( N_noxref_8_c_1583_n N_noxref_11_c_1964_n ) capacitor c=2.8386e-19 \
 //x=5.55 //y=0 //x2=7.215 //y2=1.495
cc_994 ( N_noxref_8_c_1645_n N_noxref_11_c_1974_n ) capacitor c=0.0100493f \
 //x=9.975 //y=0 //x2=8.1 //y2=0.53
cc_995 ( N_noxref_8_c_1577_n N_noxref_11_c_1974_n ) capacitor c=0.0374392f \
 //x=8.71 //y=0 //x2=8.1 //y2=0.53
cc_996 ( N_noxref_8_c_1578_n N_noxref_11_c_1974_n ) capacitor c=0.00199095f \
 //x=11.47 //y=0 //x2=8.1 //y2=0.53
cc_997 ( N_noxref_8_c_1645_n N_noxref_11_c_2009_n ) capacitor c=0.00250908f \
 //x=9.975 //y=0 //x2=8.185 //y2=0.615
cc_998 ( N_noxref_8_c_1577_n N_noxref_11_c_2009_n ) capacitor c=0.0145582f \
 //x=8.71 //y=0 //x2=8.185 //y2=0.615
cc_999 ( N_noxref_8_c_1578_n N_noxref_11_c_2009_n ) capacitor c=0.00145015f \
 //x=11.47 //y=0 //x2=8.185 //y2=0.615
cc_1000 ( N_noxref_8_c_1631_n N_noxref_11_c_2009_n ) capacitor c=0.0392026f \
 //x=8.88 //y=0 //x2=8.185 //y2=0.615
cc_1001 ( N_noxref_8_c_1601_n N_noxref_11_M3_noxref_s ) capacitor \
 c=0.00723598f //x=6.645 //y=0 //x2=6.11 //y2=0.365
cc_1002 ( N_noxref_8_c_1561_n N_noxref_11_M3_noxref_s ) capacitor c=0.0099136f \
 //x=6.73 //y=0.955 //x2=6.11 //y2=0.365
cc_1003 ( N_noxref_8_c_1570_n N_noxref_11_M3_noxref_s ) capacitor c=0.0123761f \
 //x=6.727 //y=0.825 //x2=6.11 //y2=0.365
cc_1004 ( N_noxref_8_c_1577_n N_noxref_11_M3_noxref_s ) capacitor c=0.0146208f \
 //x=8.71 //y=0 //x2=6.11 //y2=0.365
cc_1005 ( N_noxref_8_c_1578_n N_noxref_11_M3_noxref_s ) capacitor \
 c=0.00145873f //x=11.47 //y=0 //x2=6.11 //y2=0.365
cc_1006 ( N_noxref_8_c_1583_n N_noxref_11_M3_noxref_s ) capacitor c=0.0518718f \
 //x=5.55 //y=0 //x2=6.11 //y2=0.365
cc_1007 ( N_noxref_8_c_1631_n N_noxref_11_M3_noxref_s ) capacitor c=0.0064811f \
 //x=8.88 //y=0 //x2=6.11 //y2=0.365
cc_1008 ( N_noxref_8_M3_noxref_d N_noxref_11_M3_noxref_s ) capacitor \
 c=0.0271276f //x=6.54 //y=0.865 //x2=6.11 //y2=0.365
cc_1009 ( N_noxref_8_c_1645_n N_noxref_12_c_2029_n ) capacitor c=9.69392e-19 \
 //x=9.975 //y=0 //x2=10.46 //y2=1.58
cc_1010 ( N_noxref_8_c_1649_n N_noxref_12_c_2029_n ) capacitor c=0.00200855f \
 //x=11.47 //y=0 //x2=10.46 //y2=1.58
cc_1011 ( N_noxref_8_c_1610_n N_noxref_12_c_2029_n ) capacitor c=0.00400058f \
 //x=10.06 //y=0.955 //x2=10.46 //y2=1.58
cc_1012 ( N_noxref_8_c_1578_n N_noxref_12_c_2029_n ) capacitor c=0.00386563f \
 //x=11.47 //y=0 //x2=10.46 //y2=1.58
cc_1013 ( N_noxref_8_M5_noxref_d N_noxref_12_c_2029_n ) capacitor \
 c=0.00578453f //x=9.87 //y=0.865 //x2=10.46 //y2=1.58
cc_1014 ( N_noxref_8_c_1649_n N_noxref_12_c_2059_n ) capacitor c=0.00301778f \
 //x=11.47 //y=0 //x2=10.545 //y2=0.615
cc_1015 ( N_noxref_8_c_1620_n N_noxref_12_c_2059_n ) capacitor c=0.0167642f \
 //x=10.057 //y=0.825 //x2=10.545 //y2=0.615
cc_1016 ( N_noxref_8_c_1578_n N_noxref_12_c_2059_n ) capacitor c=0.0165766f \
 //x=11.47 //y=0 //x2=10.545 //y2=0.615
cc_1017 ( N_noxref_8_c_1631_n N_noxref_12_c_2059_n ) capacitor c=0.00282552f \
 //x=8.88 //y=0 //x2=10.545 //y2=0.615
cc_1018 ( N_noxref_8_c_1631_n N_noxref_12_c_2037_n ) capacitor c=2.84067e-19 \
 //x=8.88 //y=0 //x2=10.545 //y2=1.495
cc_1019 ( N_noxref_8_c_1649_n N_noxref_12_c_2046_n ) capacitor c=0.00989959f \
 //x=11.47 //y=0 //x2=11.43 //y2=0.53
cc_1020 ( N_noxref_8_c_1578_n N_noxref_12_c_2046_n ) capacitor c=0.039509f \
 //x=11.47 //y=0 //x2=11.43 //y2=0.53
cc_1021 ( N_noxref_8_c_1649_n N_noxref_12_c_2066_n ) capacitor c=0.00364221f \
 //x=11.47 //y=0 //x2=11.515 //y2=0.615
cc_1022 ( N_noxref_8_c_1578_n N_noxref_12_c_2066_n ) capacitor c=0.0581984f \
 //x=11.47 //y=0 //x2=11.515 //y2=0.615
cc_1023 ( N_noxref_8_c_1645_n N_noxref_12_M5_noxref_s ) capacitor \
 c=0.00723598f //x=9.975 //y=0 //x2=9.44 //y2=0.365
cc_1024 ( N_noxref_8_c_1610_n N_noxref_12_M5_noxref_s ) capacitor c=0.0100024f \
 //x=10.06 //y=0.955 //x2=9.44 //y2=0.365
cc_1025 ( N_noxref_8_c_1620_n N_noxref_12_M5_noxref_s ) capacitor c=0.012617f \
 //x=10.057 //y=0.825 //x2=9.44 //y2=0.365
cc_1026 ( N_noxref_8_c_1578_n N_noxref_12_M5_noxref_s ) capacitor c=0.0227223f \
 //x=11.47 //y=0 //x2=9.44 //y2=0.365
cc_1027 ( N_noxref_8_c_1631_n N_noxref_12_M5_noxref_s ) capacitor c=0.0518734f \
 //x=8.88 //y=0 //x2=9.44 //y2=0.365
cc_1028 ( N_noxref_8_M5_noxref_d N_noxref_12_M5_noxref_s ) capacitor \
 c=0.0271276f //x=9.87 //y=0.865 //x2=9.44 //y2=0.365
cc_1029 ( N_noxref_9_c_1798_n N_noxref_12_c_2037_n ) capacitor c=0.00911498f \
 //x=11.115 //y=1.655 //x2=10.545 //y2=1.495
cc_1030 ( N_noxref_9_c_1796_n N_noxref_12_c_2046_n ) capacitor c=0.00361884f \
 //x=11.385 //y=1.655 //x2=11.43 //y2=0.53
cc_1031 ( N_noxref_9_c_1818_n N_noxref_12_c_2046_n ) capacitor c=0.00367971f \
 //x=11.03 //y=1 //x2=11.43 //y2=0.53
cc_1032 ( N_noxref_9_M6_noxref_d N_noxref_12_c_2046_n ) capacitor \
 c=0.00910163f //x=10.84 //y=0.905 //x2=11.43 //y2=0.53
cc_1033 ( N_noxref_9_c_1789_n N_noxref_12_M5_noxref_s ) capacitor c=0.0175047f \
 //x=11.03 //y=1.57 //x2=9.44 //y2=0.365
cc_1034 ( N_noxref_9_c_1796_n N_noxref_12_M5_noxref_s ) capacitor c=0.0078077f \
 //x=11.385 //y=1.655 //x2=9.44 //y2=0.365
cc_1035 ( N_noxref_9_c_1818_n N_noxref_12_M5_noxref_s ) capacitor c=0.0104658f \
 //x=11.03 //y=1 //x2=9.44 //y2=0.365
cc_1036 ( N_noxref_9_M6_noxref_d N_noxref_12_M5_noxref_s ) capacitor \
 c=0.0275552f //x=10.84 //y=0.905 //x2=9.44 //y2=0.365
cc_1037 ( N_noxref_10_c_1897_n N_noxref_11_c_1956_n ) capacitor c=5.34352e-19 \
 //x=3.885 //y=1.495 //x2=6.245 //y2=1.495
cc_1038 ( N_noxref_10_c_1940_n N_noxref_11_M3_noxref_s ) capacitor \
 c=0.0045327f //x=4.855 //y=0.615 //x2=6.11 //y2=0.365
cc_1039 ( N_noxref_10_M1_noxref_s N_noxref_11_M3_noxref_s ) capacitor \
 c=5.34352e-19 //x=2.78 //y=0.365 //x2=6.11 //y2=0.365
cc_1040 ( N_noxref_11_c_1964_n N_noxref_12_c_2027_n ) capacitor c=5.34352e-19 \
 //x=7.215 //y=1.495 //x2=9.575 //y2=1.495
cc_1041 ( N_noxref_11_c_2009_n N_noxref_12_M5_noxref_s ) capacitor \
 c=0.0045327f //x=8.185 //y=0.615 //x2=9.44 //y2=0.365
cc_1042 ( N_noxref_11_M3_noxref_s N_noxref_12_M5_noxref_s ) capacitor \
 c=5.34352e-19 //x=6.11 //y=0.365 //x2=9.44 //y2=0.365
