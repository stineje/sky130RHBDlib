// File: DFFQNX1.spi.pex
// Created: Fri Feb 20 10:09:41 2026
// Program "Calibre xRC"
// Version "v2023.2_27.15"
// Nominal Temperature: 30C
// Circuit Temperature: 30C
//
simulator lang=spectre
subckt PM_DFFQNX1\%noxref_1 ( 1 2 3 4 7 12 13 15 16 18 19 20 22 23 30 34 35 38 \
 40 43 48 50 53 54 56 57 58 60 62 65 72 73 76 85 90 98 115 124 128 129 130 131 \
 132 133 137 138 139 144 146 149 150 151 152 153 154 158 160 163 164 169 170 \
 175 184 187 189 190 )
c411 ( 187 0 ) capacitor c=0.00878249f //x=7.26 //y=1.085
c412 ( 184 0 ) capacitor c=0.0682508f //x=9.74 //y=4.88
c413 ( 175 0 ) capacitor c=0.0710066f //x=3.82 //y=4.88
c414 ( 170 0 ) capacitor c=0.0278202f //x=3.82 //y=2.095
c415 ( 169 0 ) capacitor c=0.0479324f //x=3.82 //y=2.26
c416 ( 164 0 ) capacitor c=0.0318956f //x=10.075 //y=1.39
c417 ( 163 0 ) capacitor c=0.0186809f //x=10.075 //y=1.045
c418 ( 160 0 ) capacitor c=0.0141821f //x=9.92 //y=1.545
c419 ( 158 0 ) capacitor c=0.0158553f //x=9.92 //y=0.89
c420 ( 154 0 ) capacitor c=0.0854171f //x=9.545 //y=2.095
c421 ( 153 0 ) capacitor c=0.0229235f //x=9.545 //y=1.7
c422 ( 152 0 ) capacitor c=0.0234359f //x=9.545 //y=1.39
c423 ( 151 0 ) capacitor c=0.0198759f //x=9.545 //y=1.045
c424 ( 150 0 ) capacitor c=0.0443175f //x=4.34 //y=1.44
c425 ( 149 0 ) capacitor c=0.0199703f //x=4.34 //y=1.095
c426 ( 146 0 ) capacitor c=0.0162526f //x=4.185 //y=1.595
c427 ( 144 0 ) capacitor c=0.0157807f //x=4.185 //y=0.94
c428 ( 139 0 ) capacitor c=0.0220935f //x=3.81 //y=1.75
c429 ( 138 0 ) capacitor c=0.0207489f //x=3.81 //y=1.44
c430 ( 137 0 ) capacitor c=0.0194091f //x=3.81 //y=1.095
c431 ( 133 0 ) capacitor c=0.110369f //x=10.08 //y=6.2
c432 ( 132 0 ) capacitor c=0.154619f //x=9.64 //y=6.2
c433 ( 131 0 ) capacitor c=0.159671f //x=4 //y=6.2
c434 ( 130 0 ) capacitor c=0.110208f //x=3.56 //y=6.2
c435 ( 124 0 ) capacitor c=8.13425e-19 //x=9.74 //y=4.88
c436 ( 115 0 ) capacitor c=7.85889e-19 //x=9.74 //y=2.26
c437 ( 98 0 ) capacitor c=0.0322017f //x=7.41 //y=5.56
c438 ( 90 0 ) capacitor c=0.0290186f //x=6.53 //y=5.56
c439 ( 85 0 ) capacitor c=8.10944e-19 //x=3.82 //y=4.88
c440 ( 76 0 ) capacitor c=0.00101179f //x=3.82 //y=2.26
c441 ( 73 0 ) capacitor c=0.0504173f //x=9.575 //y=3.505
c442 ( 72 0 ) capacitor c=0.00163142f //x=9.735 //y=3.505
c443 ( 65 0 ) capacitor c=0.0259007f //x=8.045 //y=3.51
c444 ( 62 0 ) capacitor c=0.00684519f //x=6.62 //y=3.495
c445 ( 60 0 ) capacitor c=0.0382613f //x=6.02 //y=3.51
c446 ( 58 0 ) capacitor c=0.018822f //x=4.775 //y=3.495
c447 ( 57 0 ) capacitor c=0.00325528f //x=3.985 //y=3.51
c448 ( 56 0 ) capacitor c=0.00669908f //x=4.175 //y=3.51
c449 ( 54 0 ) capacitor c=0.0267314f //x=9.742 //y=4.74
c450 ( 53 0 ) capacitor c=0.00611287f //x=9.74 //y=4.88
c451 ( 50 0 ) capacitor c=0.0064096f //x=9.74 //y=2.26
c452 ( 48 0 ) capacitor c=0.0163473f //x=9.74 //y=3.51
c453 ( 43 0 ) capacitor c=0.0170489f //x=7.885 //y=3.51
c454 ( 40 0 ) capacitor c=0.0114531f //x=7.45 //y=1.18
c455 ( 38 0 ) capacitor c=5.78613e-19 //x=7.41 //y=5.56
c456 ( 35 0 ) capacitor c=0.0105334f //x=7.41 //y=5.38
c457 ( 34 0 ) capacitor c=0.00923791f //x=6.53 //y=5.56
c458 ( 30 0 ) capacitor c=0.0148558f //x=3.82 //y=3.51
c459 ( 23 0 ) capacitor c=0.0133022f //x=9.74 //y=3.665
c460 ( 22 0 ) capacitor c=0.0288905f //x=9.74 //y=3.345
c461 ( 20 0 ) capacitor c=0.0405859f //x=7.89 //y=5.295
c462 ( 19 0 ) capacitor c=0.0134936f //x=7.89 //y=3.67
c463 ( 18 0 ) capacitor c=0.0397593f //x=7.89 //y=3.35
c464 ( 16 0 ) capacitor c=0.00653562f //x=7.535 //y=1.835
c465 ( 15 0 ) capacitor c=0.013278f //x=7.805 //y=1.835
c466 ( 13 0 ) capacitor c=0.0108105f //x=7.805 //y=5.38
c467 ( 12 0 ) capacitor c=0.0102514f //x=7.45 //y=1.75
c468 ( 7 0 ) capacitor c=0.0150818f //x=7.295 //y=5.38
c469 ( 4 0 ) capacitor c=0.0286377f //x=3.82 //y=4.75
c470 ( 3 0 ) capacitor c=0.0126137f //x=3.82 //y=3.67
c471 ( 2 0 ) capacitor c=0.0274817f //x=3.82 //y=3.35
c472 ( 1 0 ) capacitor c=0.00685053f //x=3.82 //y=2.375
r473 (  182 184 ) resistor r=20.6867 //w=0.233 //l=0.1 //layer=ply \
 //thickness=0.18 //x=9.64 //y=4.88 //x2=9.74 //y2=4.88
r474 (  169 170 ) resistor r=52.7279 //w=0.214 //l=0.165 //layer=ply \
 //thickness=0.18 //x=3.82 //y=2.26 //x2=3.82 //y2=2.095
r475 (  165 184 ) resistor r=70.3348 //w=0.233 //l=0.414367 //layer=ply \
 //thickness=0.18 //x=10.08 //y=5.045 //x2=9.74 //y2=4.88
r476 (  164 186 ) resistor r=45.1352 //w=0.168 //l=0.173853 //layer=ply \
 //thickness=0.18 //x=10.075 //y=1.39 //x2=10.035 //y2=1.545
r477 (  163 185 ) resistor r=45.1352 //w=0.168 //l=0.173853 //layer=ply \
 //thickness=0.18 //x=10.075 //y=1.045 //x2=10.035 //y2=0.89
r478 (  163 164 ) resistor r=176.904 //w=0.094 //l=0.345 //layer=ply \
 //thickness=0.18 //x=10.075 //y=1.045 //x2=10.075 //y2=1.39
r479 (  161 181 ) resistor r=10.701 //w=0.21 //l=0.115 //layer=ply \
 //thickness=0.18 //x=9.7 //y=1.545 //x2=9.585 //y2=1.545
r480 (  160 186 ) resistor r=5.52526 //w=0.168 //l=0.115 //layer=ply \
 //thickness=0.18 //x=9.92 //y=1.545 //x2=10.035 //y2=1.545
r481 (  159 180 ) resistor r=5.52526 //w=0.168 //l=0.115 //layer=ply \
 //thickness=0.18 //x=9.7 //y=0.89 //x2=9.585 //y2=0.89
r482 (  158 185 ) resistor r=5.52526 //w=0.168 //l=0.115 //layer=ply \
 //thickness=0.18 //x=9.92 //y=0.89 //x2=10.035 //y2=0.89
r483 (  158 159 ) resistor r=112.809 //w=0.094 //l=0.22 //layer=ply \
 //thickness=0.18 //x=9.92 //y=0.89 //x2=9.7 //y2=0.89
r484 (  155 182 ) resistor r=13.0941 //w=0.233 //l=0.165 //layer=ply \
 //thickness=0.18 //x=9.64 //y=5.045 //x2=9.64 //y2=4.88
r485 (  154 179 ) resistor r=34.8111 //w=0.27 //l=0.264953 //layer=ply \
 //thickness=0.18 //x=9.545 //y=2.095 //x2=9.74 //y2=2.26
r486 (  153 181 ) resistor r=39.5823 //w=0.21 //l=0.173853 //layer=ply \
 //thickness=0.18 //x=9.545 //y=1.7 //x2=9.585 //y2=1.545
r487 (  153 154 ) resistor r=202.543 //w=0.094 //l=0.395 //layer=ply \
 //thickness=0.18 //x=9.545 //y=1.7 //x2=9.545 //y2=2.095
r488 (  152 181 ) resistor r=39.5823 //w=0.21 //l=0.173853 //layer=ply \
 //thickness=0.18 //x=9.545 //y=1.39 //x2=9.585 //y2=1.545
r489 (  151 180 ) resistor r=45.1352 //w=0.168 //l=0.173853 //layer=ply \
 //thickness=0.18 //x=9.545 //y=1.045 //x2=9.585 //y2=0.89
r490 (  151 152 ) resistor r=176.904 //w=0.094 //l=0.345 //layer=ply \
 //thickness=0.18 //x=9.545 //y=1.045 //x2=9.545 //y2=1.39
r491 (  150 177 ) resistor r=45.1352 //w=0.168 //l=0.173853 //layer=ply \
 //thickness=0.18 //x=4.34 //y=1.44 //x2=4.3 //y2=1.595
r492 (  149 176 ) resistor r=45.1352 //w=0.168 //l=0.173853 //layer=ply \
 //thickness=0.18 //x=4.34 //y=1.095 //x2=4.3 //y2=0.94
r493 (  149 150 ) resistor r=176.904 //w=0.094 //l=0.345 //layer=ply \
 //thickness=0.18 //x=4.34 //y=1.095 //x2=4.34 //y2=1.44
r494 (  147 173 ) resistor r=10.701 //w=0.21 //l=0.115 //layer=ply \
 //thickness=0.18 //x=3.965 //y=1.595 //x2=3.85 //y2=1.595
r495 (  146 177 ) resistor r=5.52526 //w=0.168 //l=0.115 //layer=ply \
 //thickness=0.18 //x=4.185 //y=1.595 //x2=4.3 //y2=1.595
r496 (  145 172 ) resistor r=5.52526 //w=0.168 //l=0.115 //layer=ply \
 //thickness=0.18 //x=3.965 //y=0.94 //x2=3.85 //y2=0.94
r497 (  144 176 ) resistor r=5.52526 //w=0.168 //l=0.115 //layer=ply \
 //thickness=0.18 //x=4.185 //y=0.94 //x2=4.3 //y2=0.94
r498 (  144 145 ) resistor r=112.809 //w=0.094 //l=0.22 //layer=ply \
 //thickness=0.18 //x=4.185 //y=0.94 //x2=3.965 //y2=0.94
r499 (  141 175 ) resistor r=37.236 //w=0.233 //l=0.249199 //layer=ply \
 //thickness=0.18 //x=4 //y=5.045 //x2=3.82 //y2=4.88
r500 (  139 173 ) resistor r=39.5823 //w=0.21 //l=0.173853 //layer=ply \
 //thickness=0.18 //x=3.81 //y=1.75 //x2=3.85 //y2=1.595
r501 (  139 170 ) resistor r=176.904 //w=0.094 //l=0.345 //layer=ply \
 //thickness=0.18 //x=3.81 //y=1.75 //x2=3.81 //y2=2.095
r502 (  138 173 ) resistor r=39.5823 //w=0.21 //l=0.173853 //layer=ply \
 //thickness=0.18 //x=3.81 //y=1.44 //x2=3.85 //y2=1.595
r503 (  137 172 ) resistor r=45.1352 //w=0.168 //l=0.173853 //layer=ply \
 //thickness=0.18 //x=3.81 //y=1.095 //x2=3.85 //y2=0.94
r504 (  137 138 ) resistor r=176.904 //w=0.094 //l=0.345 //layer=ply \
 //thickness=0.18 //x=3.81 //y=1.095 //x2=3.81 //y2=1.44
r505 (  134 175 ) resistor r=53.7854 //w=0.233 //l=0.332415 //layer=ply \
 //thickness=0.18 //x=3.56 //y=5.045 //x2=3.82 //y2=4.88
r506 (  133 165 ) resistor r=592.245 //w=0.094 //l=1.155 //layer=ply \
 //thickness=0.18 //x=10.08 //y=6.2 //x2=10.08 //y2=5.045
r507 (  132 155 ) resistor r=592.245 //w=0.094 //l=1.155 //layer=ply \
 //thickness=0.18 //x=9.64 //y=6.2 //x2=9.64 //y2=5.045
r508 (  131 141 ) resistor r=592.245 //w=0.094 //l=1.155 //layer=ply \
 //thickness=0.18 //x=4 //y=6.2 //x2=4 //y2=5.045
r509 (  130 134 ) resistor r=592.245 //w=0.094 //l=1.155 //layer=ply \
 //thickness=0.18 //x=3.56 //y=6.2 //x2=3.56 //y2=5.045
r510 (  129 160 ) resistor r=56.4043 //w=0.094 //l=0.11 //layer=ply \
 //thickness=0.18 //x=9.81 //y=1.545 //x2=9.92 //y2=1.545
r511 (  129 161 ) resistor r=56.4043 //w=0.094 //l=0.11 //layer=ply \
 //thickness=0.18 //x=9.81 //y=1.545 //x2=9.7 //y2=1.545
r512 (  128 146 ) resistor r=56.4043 //w=0.094 //l=0.11 //layer=ply \
 //thickness=0.18 //x=4.075 //y=1.595 //x2=4.185 //y2=1.595
r513 (  128 147 ) resistor r=56.4043 //w=0.094 //l=0.11 //layer=ply \
 //thickness=0.18 //x=4.075 //y=1.595 //x2=3.965 //y2=1.595
r514 (  124 184 ) resistor r=152 //w=0.17 //l=0.17 //layer=licon //count=1 \
 //x=9.74 //y=4.88 //x2=9.74 //y2=4.88
r515 (  115 179 ) resistor r=152 //w=0.17 //l=0.17 //layer=licon //count=1 \
 //x=9.74 //y=2.26 //x2=9.74 //y2=2.26
r516 (  98 190 ) resistor r=23.615 //w=0.187 //l=0.345 //layer=li \
 //thickness=0.1 //x=7.41 //y=5.56 //x2=7.41 //y2=5.905
r517 (  90 189 ) resistor r=23.615 //w=0.187 //l=0.345 //layer=li \
 //thickness=0.1 //x=6.53 //y=5.56 //x2=6.53 //y2=5.905
r518 (  85 175 ) resistor r=152 //w=0.17 //l=0.17 //layer=licon //count=1 \
 //x=3.82 //y=4.88 //x2=3.82 //y2=4.88
r519 (  76 169 ) resistor r=152 //w=0.17 //l=0.17 //layer=licon //count=1 \
 //x=3.82 //y=2.26 //x2=3.82 //y2=2.26
r520 (  72 73 ) resistor r=0.10734 //w=0.281 //l=0.16 //layer=m2 \
 //thickness=0.36 //x=9.735 //y=3.505 //x2=9.575 //y2=3.505
r521 (  65 70 ) resistor r=0.10188 //w=0.204 //l=0.16 //layer=m2 \
 //thickness=0.36 //x=8.045 //y=3.51 //x2=7.885 //y2=3.51
r522 (  65 73 ) resistor r=1.45992 //w=0.131 //l=1.53 //layer=m2 \
 //thickness=0.36 //x=8.045 //y=3.51 //x2=9.575 //y2=3.51
r523 (  62 70 ) resistor r=0.778963 //w=0.204 //l=1.27248 //layer=m2 \
 //thickness=0.36 //x=6.62 //y=3.495 //x2=7.885 //y2=3.51
r524 (  62 63 ) resistor r=0.410305 //w=0.131 //l=0.43 //layer=m2 \
 //thickness=0.36 //x=6.62 //y=3.495 //x2=6.19 //y2=3.495
r525 (  60 63 ) resistor r=0.125 //w=0.17 //l=0.177341 //layer=m2 \
 //thickness=0.36 //x=6.02 //y=3.51 //x2=6.19 //y2=3.495
r526 (  60 61 ) resistor r=0.944656 //w=0.131 //l=0.99 //layer=m2 \
 //thickness=0.36 //x=6.02 //y=3.51 //x2=5.03 //y2=3.51
r527 (  58 61 ) resistor r=0.1875 //w=0.17 //l=0.262393 //layer=m2 \
 //thickness=0.36 //x=4.775 //y=3.495 //x2=5.03 //y2=3.51
r528 (  58 59 ) resistor r=0.410305 //w=0.131 //l=0.43 //layer=m2 \
 //thickness=0.36 //x=4.775 //y=3.495 //x2=4.345 //y2=3.495
r529 (  57 67 ) resistor r=0.10734 //w=0.281 //l=0.16 //layer=m2 \
 //thickness=0.36 //x=3.985 //y=3.51 //x2=3.825 //y2=3.51
r530 (  56 59 ) resistor r=0.125 //w=0.17 //l=0.177341 //layer=m2 \
 //thickness=0.36 //x=4.175 //y=3.51 //x2=4.345 //y2=3.495
r531 (  56 57 ) resistor r=0.181298 //w=0.131 //l=0.19 //layer=m2 \
 //thickness=0.36 //x=4.175 //y=3.51 //x2=3.985 //y2=3.51
r532 (  53 124 ) resistor r=9.3 //w=0.17 //l=0.17 //layer=mcon //count=1 \
 //x=9.74 //y=4.88 //x2=9.74 //y2=4.88
r533 (  53 54 ) resistor r=0.103207 //w=0.196 //l=0.14 //layer=m1 \
 //thickness=0.36 //x=9.742 //y=4.88 //x2=9.742 //y2=4.74
r534 (  50 115 ) resistor r=9.3 //w=0.17 //l=0.17 //layer=mcon //count=1 \
 //x=9.74 //y=2.26 //x2=9.74 //y2=2.26
r535 (  46 72 ) resistor r=4.5 //w=0.15 //l=0.15 //layer=via1 //count=1 \
 //x=9.735 //y=3.505 //x2=9.735 //y2=3.505
r536 (  46 48 ) resistor r=0.00167112 //w=0.374 //l=0.005 //layer=m1 \
 //thickness=0.36 //x=9.685 //y=3.505 //x2=9.685 //y2=3.51
r537 (  43 70 ) resistor r=4.5 //w=0.15 //l=0.15 //layer=via1 //count=1 \
 //x=7.885 //y=3.51 //x2=7.885 //y2=3.51
r538 (  40 187 ) resistor r=9.3 //w=0.17 //l=0.17 //layer=mcon //count=1 \
 //x=7.45 //y=1.18 //x2=7.45 //y2=1.18
r539 (  38 98 ) resistor r=9.3 //w=0.17 //l=0.17 //layer=mcon //count=1 \
 //x=7.41 //y=5.56 //x2=7.41 //y2=5.56
r540 (  35 38 ) resistor r=0.117801 //w=0.191 //l=0.18 //layer=m1 \
 //thickness=0.36 //x=7.41 //y=5.38 //x2=7.41 //y2=5.56
r541 (  34 90 ) resistor r=9.3 //w=0.17 //l=0.17 //layer=mcon //count=1 \
 //x=6.53 //y=5.56 //x2=6.53 //y2=5.56
r542 (  32 34 ) resistor r=0.10274 //w=0.219 //l=0.18 //layer=m1 \
 //thickness=0.36 //x=6.53 //y=5.38 //x2=6.53 //y2=5.56
r543 (  30 67 ) resistor r=4.5 //w=0.15 //l=0.15 //layer=via1 //count=1 \
 //x=3.825 //y=3.51 //x2=3.825 //y2=3.51
r544 (  28 85 ) resistor r=9.3 //w=0.17 //l=0.17 //layer=mcon //count=1 \
 //x=3.82 //y=4.88 //x2=3.82 //y2=4.88
r545 (  26 76 ) resistor r=9.3 //w=0.17 //l=0.17 //layer=mcon //count=1 \
 //x=3.82 //y=2.26 //x2=3.82 //y2=2.26
r546 (  23 48 ) resistor r=0.089409 //w=0.374 //l=0.180416 //layer=m1 \
 //thickness=0.36 //x=9.74 //y=3.665 //x2=9.685 //y2=3.51
r547 (  23 54 ) resistor r=1.02576 //w=0.131 //l=1.075 //layer=m1 \
 //thickness=0.36 //x=9.74 //y=3.665 //x2=9.74 //y2=4.74
r548 (  22 46 ) resistor r=0.0910802 //w=0.374 //l=0.185472 //layer=m1 \
 //thickness=0.36 //x=9.74 //y=3.345 //x2=9.685 //y2=3.505
r549 (  21 50 ) resistor r=0.0933015 //w=0.201 //l=0.125 //layer=m1 \
 //thickness=0.36 //x=9.74 //y=2.385 //x2=9.74 //y2=2.26
r550 (  21 22 ) resistor r=0.916031 //w=0.131 //l=0.96 //layer=m1 \
 //thickness=0.36 //x=9.74 //y=2.385 //x2=9.74 //y2=3.345
r551 (  19 43 ) resistor r=0.0910802 //w=0.374 //l=0.185472 //layer=m1 \
 //thickness=0.36 //x=7.89 //y=3.67 //x2=7.835 //y2=3.51
r552 (  19 20 ) resistor r=1.55057 //w=0.131 //l=1.625 //layer=m1 \
 //thickness=0.36 //x=7.89 //y=3.67 //x2=7.89 //y2=5.295
r553 (  18 43 ) resistor r=0.0910802 //w=0.374 //l=0.185472 //layer=m1 \
 //thickness=0.36 //x=7.89 //y=3.35 //x2=7.835 //y2=3.51
r554 (  17 18 ) resistor r=1.3645 //w=0.131 //l=1.43 //layer=m1 \
 //thickness=0.36 //x=7.89 //y=1.92 //x2=7.89 //y2=3.35
r555 (  15 17 ) resistor r=0.0698411 //w=0.17 //l=0.120208 //layer=m1 \
 //thickness=0.36 //x=7.805 //y=1.835 //x2=7.89 //y2=1.92
r556 (  15 16 ) resistor r=0.257634 //w=0.131 //l=0.27 //layer=m1 \
 //thickness=0.36 //x=7.805 //y=1.835 //x2=7.535 //y2=1.835
r557 (  14 35 ) resistor r=0.0257089 //w=0.23 //l=0.115 //layer=m1 \
 //thickness=0.36 //x=7.525 //y=5.38 //x2=7.41 //y2=5.38
r558 (  13 20 ) resistor r=0.0698411 //w=0.17 //l=0.120208 //layer=m1 \
 //thickness=0.36 //x=7.805 //y=5.38 //x2=7.89 //y2=5.295
r559 (  13 14 ) resistor r=0.267176 //w=0.131 //l=0.28 //layer=m1 \
 //thickness=0.36 //x=7.805 //y=5.38 //x2=7.525 //y2=5.38
r560 (  12 16 ) resistor r=0.0698411 //w=0.17 //l=0.120208 //layer=m1 \
 //thickness=0.36 //x=7.45 //y=1.75 //x2=7.535 //y2=1.835
r561 (  11 40 ) resistor r=0.0913624 //w=0.191 //l=0.12 //layer=m1 \
 //thickness=0.36 //x=7.45 //y=1.3 //x2=7.45 //y2=1.18
r562 (  11 12 ) resistor r=0.429389 //w=0.131 //l=0.45 //layer=m1 \
 //thickness=0.36 //x=7.45 //y=1.3 //x2=7.45 //y2=1.75
r563 (  8 32 ) resistor r=0.0227762 //w=0.219 //l=0.115 //layer=m1 \
 //thickness=0.36 //x=6.645 //y=5.38 //x2=6.53 //y2=5.38
r564 (  7 35 ) resistor r=0.0257089 //w=0.23 //l=0.115 //layer=m1 \
 //thickness=0.36 //x=7.295 //y=5.38 //x2=7.41 //y2=5.38
r565 (  7 8 ) resistor r=0.620229 //w=0.131 //l=0.65 //layer=m1 \
 //thickness=0.36 //x=7.295 //y=5.38 //x2=6.645 //y2=5.38
r566 (  4 28 ) resistor r=0.0801089 //w=0.224 //l=0.13 //layer=m1 \
 //thickness=0.36 //x=3.82 //y=4.75 //x2=3.82 //y2=4.88
r567 (  3 30 ) resistor r=0.0910802 //w=0.374 //l=0.185472 //layer=m1 \
 //thickness=0.36 //x=3.82 //y=3.67 //x2=3.875 //y2=3.51
r568 (  3 4 ) resistor r=1.03053 //w=0.131 //l=1.08 //layer=m1 \
 //thickness=0.36 //x=3.82 //y=3.67 //x2=3.82 //y2=4.75
r569 (  2 30 ) resistor r=0.0910802 //w=0.374 //l=0.185472 //layer=m1 \
 //thickness=0.36 //x=3.82 //y=3.35 //x2=3.875 //y2=3.51
r570 (  1 26 ) resistor r=0.0719237 //w=0.222 //l=0.115 //layer=m1 \
 //thickness=0.36 //x=3.82 //y=2.375 //x2=3.82 //y2=2.26
r571 (  1 2 ) resistor r=0.930344 //w=0.131 //l=0.975 //layer=m1 \
 //thickness=0.36 //x=3.82 //y=2.375 //x2=3.82 //y2=3.35
ends PM_DFFQNX1\%noxref_1

subckt PM_DFFQNX1\%noxref_2 ( 3 8 9 11 12 14 15 16 18 19 23 24 27 29 32 35 38 \
 41 42 44 45 50 53 61 78 87 91 92 93 94 95 96 97 101 103 106 107 117 120 122 \
 123 )
c276 ( 120 0 ) capacitor c=0.00878249f //x=10.59 //y=1.085
c277 ( 117 0 ) capacitor c=0.0682508f //x=13.07 //y=4.88
c278 ( 107 0 ) capacitor c=0.0318956f //x=13.405 //y=1.39
c279 ( 106 0 ) capacitor c=0.0186809f //x=13.405 //y=1.045
c280 ( 103 0 ) capacitor c=0.0141821f //x=13.25 //y=1.545
c281 ( 101 0 ) capacitor c=0.0158553f //x=13.25 //y=0.89
c282 ( 97 0 ) capacitor c=0.0854195f //x=12.875 //y=2.095
c283 ( 96 0 ) capacitor c=0.0229235f //x=12.875 //y=1.7
c284 ( 95 0 ) capacitor c=0.0234359f //x=12.875 //y=1.39
c285 ( 94 0 ) capacitor c=0.0198759f //x=12.875 //y=1.045
c286 ( 93 0 ) capacitor c=0.110369f //x=13.41 //y=6.2
c287 ( 92 0 ) capacitor c=0.154619f //x=12.97 //y=6.2
c288 ( 87 0 ) capacitor c=8.13425e-19 //x=13.07 //y=4.88
c289 ( 78 0 ) capacitor c=7.85889e-19 //x=13.07 //y=2.26
c290 ( 61 0 ) capacitor c=0.0322017f //x=10.74 //y=5.56
c291 ( 53 0 ) capacitor c=0.0291714f //x=9.86 //y=5.56
c292 ( 50 0 ) capacitor c=0.00162839f //x=13.065 //y=3.51
c293 ( 45 0 ) capacitor c=0.00317997f //x=11.385 //y=3.51
c294 ( 44 0 ) capacitor c=0.0479792f //x=12.905 //y=3.51
c295 ( 42 0 ) capacitor c=0.0270867f //x=13.072 //y=4.74
c296 ( 41 0 ) capacitor c=0.0060492f //x=13.07 //y=4.88
c297 ( 38 0 ) capacitor c=0.00641145f //x=13.07 //y=2.26
c298 ( 35 0 ) capacitor c=0.0164425f //x=13.065 //y=3.51
c299 ( 32 0 ) capacitor c=0.0167895f //x=11.22 //y=3.51
c300 ( 29 0 ) capacitor c=0.0114498f //x=10.78 //y=1.18
c301 ( 27 0 ) capacitor c=5.78613e-19 //x=10.74 //y=5.56
c302 ( 24 0 ) capacitor c=0.0103127f //x=10.74 //y=5.38
c303 ( 23 0 ) capacitor c=0.00933334f //x=9.86 //y=5.56
c304 ( 19 0 ) capacitor c=0.0132504f //x=13.07 //y=3.67
c305 ( 18 0 ) capacitor c=0.0289239f //x=13.07 //y=3.35
c306 ( 16 0 ) capacitor c=0.0402153f //x=11.22 //y=5.295
c307 ( 15 0 ) capacitor c=0.0132747f //x=11.22 //y=3.67
c308 ( 14 0 ) capacitor c=0.0397593f //x=11.22 //y=3.35
c309 ( 12 0 ) capacitor c=0.00671763f //x=10.865 //y=1.835
c310 ( 11 0 ) capacitor c=0.0143344f //x=11.135 //y=1.835
c311 ( 9 0 ) capacitor c=0.0112475f //x=11.135 //y=5.38
c312 ( 8 0 ) capacitor c=0.0101547f //x=10.78 //y=1.75
c313 ( 3 0 ) capacitor c=0.0134484f //x=10.625 //y=5.38
r314 (  115 117 ) resistor r=20.6867 //w=0.233 //l=0.1 //layer=ply \
 //thickness=0.18 //x=12.97 //y=4.88 //x2=13.07 //y2=4.88
r315 (  108 117 ) resistor r=70.3348 //w=0.233 //l=0.414367 //layer=ply \
 //thickness=0.18 //x=13.41 //y=5.045 //x2=13.07 //y2=4.88
r316 (  107 119 ) resistor r=45.1352 //w=0.168 //l=0.173853 //layer=ply \
 //thickness=0.18 //x=13.405 //y=1.39 //x2=13.365 //y2=1.545
r317 (  106 118 ) resistor r=45.1352 //w=0.168 //l=0.173853 //layer=ply \
 //thickness=0.18 //x=13.405 //y=1.045 //x2=13.365 //y2=0.89
r318 (  106 107 ) resistor r=176.904 //w=0.094 //l=0.345 //layer=ply \
 //thickness=0.18 //x=13.405 //y=1.045 //x2=13.405 //y2=1.39
r319 (  104 114 ) resistor r=10.701 //w=0.21 //l=0.115 //layer=ply \
 //thickness=0.18 //x=13.03 //y=1.545 //x2=12.915 //y2=1.545
r320 (  103 119 ) resistor r=5.52526 //w=0.168 //l=0.115 //layer=ply \
 //thickness=0.18 //x=13.25 //y=1.545 //x2=13.365 //y2=1.545
r321 (  102 113 ) resistor r=5.52526 //w=0.168 //l=0.115 //layer=ply \
 //thickness=0.18 //x=13.03 //y=0.89 //x2=12.915 //y2=0.89
r322 (  101 118 ) resistor r=5.52526 //w=0.168 //l=0.115 //layer=ply \
 //thickness=0.18 //x=13.25 //y=0.89 //x2=13.365 //y2=0.89
r323 (  101 102 ) resistor r=112.809 //w=0.094 //l=0.22 //layer=ply \
 //thickness=0.18 //x=13.25 //y=0.89 //x2=13.03 //y2=0.89
r324 (  98 115 ) resistor r=13.0941 //w=0.233 //l=0.165 //layer=ply \
 //thickness=0.18 //x=12.97 //y=5.045 //x2=12.97 //y2=4.88
r325 (  97 112 ) resistor r=34.8111 //w=0.27 //l=0.264953 //layer=ply \
 //thickness=0.18 //x=12.875 //y=2.095 //x2=13.07 //y2=2.26
r326 (  96 114 ) resistor r=39.5823 //w=0.21 //l=0.173853 //layer=ply \
 //thickness=0.18 //x=12.875 //y=1.7 //x2=12.915 //y2=1.545
r327 (  96 97 ) resistor r=202.543 //w=0.094 //l=0.395 //layer=ply \
 //thickness=0.18 //x=12.875 //y=1.7 //x2=12.875 //y2=2.095
r328 (  95 114 ) resistor r=39.5823 //w=0.21 //l=0.173853 //layer=ply \
 //thickness=0.18 //x=12.875 //y=1.39 //x2=12.915 //y2=1.545
r329 (  94 113 ) resistor r=45.1352 //w=0.168 //l=0.173853 //layer=ply \
 //thickness=0.18 //x=12.875 //y=1.045 //x2=12.915 //y2=0.89
r330 (  94 95 ) resistor r=176.904 //w=0.094 //l=0.345 //layer=ply \
 //thickness=0.18 //x=12.875 //y=1.045 //x2=12.875 //y2=1.39
r331 (  93 108 ) resistor r=592.245 //w=0.094 //l=1.155 //layer=ply \
 //thickness=0.18 //x=13.41 //y=6.2 //x2=13.41 //y2=5.045
r332 (  92 98 ) resistor r=592.245 //w=0.094 //l=1.155 //layer=ply \
 //thickness=0.18 //x=12.97 //y=6.2 //x2=12.97 //y2=5.045
r333 (  91 103 ) resistor r=56.4043 //w=0.094 //l=0.11 //layer=ply \
 //thickness=0.18 //x=13.14 //y=1.545 //x2=13.25 //y2=1.545
r334 (  91 104 ) resistor r=56.4043 //w=0.094 //l=0.11 //layer=ply \
 //thickness=0.18 //x=13.14 //y=1.545 //x2=13.03 //y2=1.545
r335 (  87 117 ) resistor r=152 //w=0.17 //l=0.17 //layer=licon //count=1 \
 //x=13.07 //y=4.88 //x2=13.07 //y2=4.88
r336 (  78 112 ) resistor r=152 //w=0.17 //l=0.17 //layer=licon //count=1 \
 //x=13.07 //y=2.26 //x2=13.07 //y2=2.26
r337 (  61 123 ) resistor r=23.615 //w=0.187 //l=0.345 //layer=li \
 //thickness=0.1 //x=10.74 //y=5.56 //x2=10.74 //y2=5.905
r338 (  53 122 ) resistor r=23.615 //w=0.187 //l=0.345 //layer=li \
 //thickness=0.1 //x=9.86 //y=5.56 //x2=9.86 //y2=5.905
r339 (  45 47 ) resistor r=0.10734 //w=0.281 //l=0.16 //layer=m2 \
 //thickness=0.36 //x=11.385 //y=3.51 //x2=11.225 //y2=3.51
r340 (  44 50 ) resistor r=0.10734 //w=0.281 //l=0.16 //layer=m2 \
 //thickness=0.36 //x=12.905 //y=3.51 //x2=13.065 //y2=3.51
r341 (  44 45 ) resistor r=1.45038 //w=0.131 //l=1.52 //layer=m2 \
 //thickness=0.36 //x=12.905 //y=3.51 //x2=11.385 //y2=3.51
r342 (  41 87 ) resistor r=9.3 //w=0.17 //l=0.17 //layer=mcon //count=1 \
 //x=13.07 //y=4.88 //x2=13.07 //y2=4.88
r343 (  41 42 ) resistor r=0.103207 //w=0.196 //l=0.14 //layer=m1 \
 //thickness=0.36 //x=13.072 //y=4.88 //x2=13.072 //y2=4.74
r344 (  38 78 ) resistor r=9.3 //w=0.17 //l=0.17 //layer=mcon //count=1 \
 //x=13.07 //y=2.26 //x2=13.07 //y2=2.26
r345 (  35 50 ) resistor r=4.5 //w=0.15 //l=0.15 //layer=via1 //count=1 \
 //x=13.065 //y=3.51 //x2=13.065 //y2=3.51
r346 (  32 47 ) resistor r=4.5 //w=0.15 //l=0.15 //layer=via1 //count=1 \
 //x=11.225 //y=3.51 //x2=11.225 //y2=3.51
r347 (  29 120 ) resistor r=9.3 //w=0.17 //l=0.17 //layer=mcon //count=1 \
 //x=10.78 //y=1.18 //x2=10.78 //y2=1.18
r348 (  27 61 ) resistor r=9.3 //w=0.17 //l=0.17 //layer=mcon //count=1 \
 //x=10.74 //y=5.56 //x2=10.74 //y2=5.56
r349 (  24 27 ) resistor r=0.117801 //w=0.191 //l=0.18 //layer=m1 \
 //thickness=0.36 //x=10.74 //y=5.38 //x2=10.74 //y2=5.56
r350 (  23 53 ) resistor r=9.3 //w=0.17 //l=0.17 //layer=mcon //count=1 \
 //x=9.86 //y=5.56 //x2=9.86 //y2=5.56
r351 (  21 23 ) resistor r=0.10274 //w=0.219 //l=0.18 //layer=m1 \
 //thickness=0.36 //x=9.86 //y=5.38 //x2=9.86 //y2=5.56
r352 (  19 35 ) resistor r=0.0910802 //w=0.374 //l=0.185472 //layer=m1 \
 //thickness=0.36 //x=13.07 //y=3.67 //x2=13.015 //y2=3.51
r353 (  19 42 ) resistor r=1.02099 //w=0.131 //l=1.07 //layer=m1 \
 //thickness=0.36 //x=13.07 //y=3.67 //x2=13.07 //y2=4.74
r354 (  18 35 ) resistor r=0.0910802 //w=0.374 //l=0.185472 //layer=m1 \
 //thickness=0.36 //x=13.07 //y=3.35 //x2=13.015 //y2=3.51
r355 (  17 38 ) resistor r=0.0933015 //w=0.201 //l=0.125 //layer=m1 \
 //thickness=0.36 //x=13.07 //y=2.385 //x2=13.07 //y2=2.26
r356 (  17 18 ) resistor r=0.920802 //w=0.131 //l=0.965 //layer=m1 \
 //thickness=0.36 //x=13.07 //y=2.385 //x2=13.07 //y2=3.35
r357 (  15 32 ) resistor r=0.0910802 //w=0.374 //l=0.185472 //layer=m1 \
 //thickness=0.36 //x=11.22 //y=3.67 //x2=11.275 //y2=3.51
r358 (  15 16 ) resistor r=1.55057 //w=0.131 //l=1.625 //layer=m1 \
 //thickness=0.36 //x=11.22 //y=3.67 //x2=11.22 //y2=5.295
r359 (  14 32 ) resistor r=0.0910802 //w=0.374 //l=0.185472 //layer=m1 \
 //thickness=0.36 //x=11.22 //y=3.35 //x2=11.275 //y2=3.51
r360 (  13 14 ) resistor r=1.3645 //w=0.131 //l=1.43 //layer=m1 \
 //thickness=0.36 //x=11.22 //y=1.92 //x2=11.22 //y2=3.35
r361 (  11 13 ) resistor r=0.0698411 //w=0.17 //l=0.120208 //layer=m1 \
 //thickness=0.36 //x=11.135 //y=1.835 //x2=11.22 //y2=1.92
r362 (  11 12 ) resistor r=0.257634 //w=0.131 //l=0.27 //layer=m1 \
 //thickness=0.36 //x=11.135 //y=1.835 //x2=10.865 //y2=1.835
r363 (  10 24 ) resistor r=0.0257089 //w=0.23 //l=0.115 //layer=m1 \
 //thickness=0.36 //x=10.855 //y=5.38 //x2=10.74 //y2=5.38
r364 (  9 16 ) resistor r=0.0698411 //w=0.17 //l=0.120208 //layer=m1 \
 //thickness=0.36 //x=11.135 //y=5.38 //x2=11.22 //y2=5.295
r365 (  9 10 ) resistor r=0.267176 //w=0.131 //l=0.28 //layer=m1 \
 //thickness=0.36 //x=11.135 //y=5.38 //x2=10.855 //y2=5.38
r366 (  8 12 ) resistor r=0.0698411 //w=0.17 //l=0.120208 //layer=m1 \
 //thickness=0.36 //x=10.78 //y=1.75 //x2=10.865 //y2=1.835
r367 (  7 29 ) resistor r=0.0913624 //w=0.191 //l=0.12 //layer=m1 \
 //thickness=0.36 //x=10.78 //y=1.3 //x2=10.78 //y2=1.18
r368 (  7 8 ) resistor r=0.429389 //w=0.131 //l=0.45 //layer=m1 \
 //thickness=0.36 //x=10.78 //y=1.3 //x2=10.78 //y2=1.75
r369 (  4 21 ) resistor r=0.0227762 //w=0.219 //l=0.115 //layer=m1 \
 //thickness=0.36 //x=9.975 //y=5.38 //x2=9.86 //y2=5.38
r370 (  3 24 ) resistor r=0.0257089 //w=0.23 //l=0.115 //layer=m1 \
 //thickness=0.36 //x=10.625 //y=5.38 //x2=10.74 //y2=5.38
r371 (  3 4 ) resistor r=0.620229 //w=0.131 //l=0.65 //layer=m1 \
 //thickness=0.36 //x=10.625 //y=5.38 //x2=9.975 //y2=5.38
ends PM_DFFQNX1\%noxref_2

subckt PM_DFFQNX1\%CLK ( 1 2 3 4 5 6 7 8 9 10 24 30 36 39 41 43 49 54 59 64 68 \
 69 70 71 72 73 74 75 76 78 84 85 86 87 88 93 94 95 100 102 104 110 111 115 \
 124 125 128 )
c287 ( 128 0 ) capacitor c=0.0366322f //x=13.84 //y=4.88
c288 ( 125 0 ) capacitor c=0.0284095f //x=13.81 //y=2.095
c289 ( 124 0 ) capacitor c=0.0476356f //x=13.81 //y=2.26
c290 ( 115 0 ) capacitor c=0.0372825f //x=2.71 //y=4.88
c291 ( 111 0 ) capacitor c=0.0439708f //x=14.375 //y=1.43
c292 ( 110 0 ) capacitor c=0.0192582f //x=14.375 //y=1.085
c293 ( 104 0 ) capacitor c=0.0162526f //x=14.22 //y=1.585
c294 ( 102 0 ) capacitor c=0.0157807f //x=14.22 //y=0.93
c295 ( 100 0 ) capacitor c=0.0353784f //x=14.215 //y=4.97
c296 ( 95 0 ) capacitor c=0.0210762f //x=13.845 //y=1.74
c297 ( 94 0 ) capacitor c=0.0168511f //x=13.845 //y=1.43
c298 ( 93 0 ) capacitor c=0.0175485f //x=13.845 //y=1.085
c299 ( 88 0 ) capacitor c=0.0305913f //x=3.045 //y=4.97
c300 ( 87 0 ) capacitor c=0.0863671f //x=2.8 //y=2.095
c301 ( 86 0 ) capacitor c=0.0170266f //x=2.8 //y=1.63
c302 ( 85 0 ) capacitor c=0.018609f //x=2.8 //y=1.4
c303 ( 84 0 ) capacitor c=0.0186599f //x=2.8 //y=1.09
c304 ( 78 0 ) capacitor c=0.0146988f //x=2.645 //y=1.555
c305 ( 76 0 ) capacitor c=0.0148531f //x=2.645 //y=0.935
c306 ( 75 0 ) capacitor c=0.0334406f //x=2.275 //y=1.4
c307 ( 74 0 ) capacitor c=0.0173191f //x=2.275 //y=1.09
c308 ( 73 0 ) capacitor c=0.155269f //x=14.29 //y=6.2
c309 ( 72 0 ) capacitor c=0.110375f //x=13.85 //y=6.2
c310 ( 71 0 ) capacitor c=0.110208f //x=3.12 //y=6.2
c311 ( 70 0 ) capacitor c=0.110214f //x=2.68 //y=6.2
c312 ( 64 0 ) capacitor c=8.63406e-19 //x=13.84 //y=4.88
c313 ( 59 0 ) capacitor c=7.72439e-19 //x=13.81 //y=2.26
c314 ( 54 0 ) capacitor c=0.00143828f //x=2.71 //y=4.88
c315 ( 49 0 ) capacitor c=0.00121786f //x=2.71 //y=2.26
c316 ( 43 0 ) capacitor c=0.00183922f //x=2.71 //y=4.62
c317 ( 41 0 ) capacitor c=0.0886214f //x=10.7 //y=4.64
c318 ( 39 0 ) capacitor c=0.178908f //x=10.1 //y=4.62
c319 ( 36 0 ) capacitor c=0.00680024f //x=13.81 //y=2.26
c320 ( 30 0 ) capacitor c=0.00622154f //x=13.835 //y=4.865
c321 ( 24 0 ) capacitor c=0.00551512f //x=2.71 //y=4.88
c322 ( 10 0 ) capacitor c=0.00565957f //x=2.71 //y=2.375
c323 ( 6 0 ) capacitor c=0.0509274f //x=13.81 //y=2.77
c324 ( 1 0 ) capacitor c=0.0678123f //x=2.71 //y=2.77
r325 (  130 131 ) resistor r=32.4568 //w=0.214 //l=0.075 //layer=ply \
 //thickness=0.18 //x=13.84 //y=4.97 //x2=13.84 //y2=5.045
r326 (  128 130 ) resistor r=20.271 //w=0.214 //l=0.09 //layer=ply \
 //thickness=0.18 //x=13.84 //y=4.88 //x2=13.84 //y2=4.97
r327 (  124 125 ) resistor r=52.7279 //w=0.214 //l=0.165 //layer=ply \
 //thickness=0.18 //x=13.81 //y=2.26 //x2=13.81 //y2=2.095
r328 (  117 118 ) resistor r=32.4568 //w=0.214 //l=0.075 //layer=ply \
 //thickness=0.18 //x=2.71 //y=4.97 //x2=2.71 //y2=5.045
r329 (  115 117 ) resistor r=20.271 //w=0.214 //l=0.09 //layer=ply \
 //thickness=0.18 //x=2.71 //y=4.88 //x2=2.71 //y2=4.97
r330 (  111 135 ) resistor r=45.1352 //w=0.168 //l=0.173853 //layer=ply \
 //thickness=0.18 //x=14.375 //y=1.43 //x2=14.335 //y2=1.585
r331 (  110 134 ) resistor r=45.1352 //w=0.168 //l=0.173853 //layer=ply \
 //thickness=0.18 //x=14.375 //y=1.085 //x2=14.335 //y2=0.93
r332 (  110 111 ) resistor r=176.904 //w=0.094 //l=0.345 //layer=ply \
 //thickness=0.18 //x=14.375 //y=1.085 //x2=14.375 //y2=1.43
r333 (  105 133 ) resistor r=10.701 //w=0.21 //l=0.115 //layer=ply \
 //thickness=0.18 //x=14 //y=1.585 //x2=13.885 //y2=1.585
r334 (  104 135 ) resistor r=5.52526 //w=0.168 //l=0.115 //layer=ply \
 //thickness=0.18 //x=14.22 //y=1.585 //x2=14.335 //y2=1.585
r335 (  103 132 ) resistor r=5.52526 //w=0.168 //l=0.115 //layer=ply \
 //thickness=0.18 //x=14 //y=0.93 //x2=13.885 //y2=0.93
r336 (  102 134 ) resistor r=5.52526 //w=0.168 //l=0.115 //layer=ply \
 //thickness=0.18 //x=14.22 //y=0.93 //x2=14.335 //y2=0.93
r337 (  102 103 ) resistor r=112.809 //w=0.094 //l=0.22 //layer=ply \
 //thickness=0.18 //x=14.22 //y=0.93 //x2=14 //y2=0.93
r338 (  101 130 ) resistor r=16.5046 //w=0.27 //l=0.135 //layer=ply \
 //thickness=0.18 //x=13.975 //y=4.97 //x2=13.84 //y2=4.97
r339 (  100 107 ) resistor r=26.9307 //w=0.15 //l=0.106066 //layer=ply \
 //thickness=0.18 //x=14.215 //y=4.97 //x2=14.29 //y2=5.045
r340 (  100 101 ) resistor r=123.064 //w=0.094 //l=0.24 //layer=ply \
 //thickness=0.18 //x=14.215 //y=4.97 //x2=13.975 //y2=4.97
r341 (  95 133 ) resistor r=39.5823 //w=0.21 //l=0.173853 //layer=ply \
 //thickness=0.18 //x=13.845 //y=1.74 //x2=13.885 //y2=1.585
r342 (  95 125 ) resistor r=182.032 //w=0.094 //l=0.355 //layer=ply \
 //thickness=0.18 //x=13.845 //y=1.74 //x2=13.845 //y2=2.095
r343 (  94 133 ) resistor r=39.5823 //w=0.21 //l=0.173853 //layer=ply \
 //thickness=0.18 //x=13.845 //y=1.43 //x2=13.885 //y2=1.585
r344 (  93 132 ) resistor r=45.1352 //w=0.168 //l=0.173853 //layer=ply \
 //thickness=0.18 //x=13.845 //y=1.085 //x2=13.885 //y2=0.93
r345 (  93 94 ) resistor r=176.904 //w=0.094 //l=0.345 //layer=ply \
 //thickness=0.18 //x=13.845 //y=1.085 //x2=13.845 //y2=1.43
r346 (  89 117 ) resistor r=16.5046 //w=0.27 //l=0.135 //layer=ply \
 //thickness=0.18 //x=2.845 //y=4.97 //x2=2.71 //y2=4.97
r347 (  88 90 ) resistor r=26.9307 //w=0.15 //l=0.106066 //layer=ply \
 //thickness=0.18 //x=3.045 //y=4.97 //x2=3.12 //y2=5.045
r348 (  88 89 ) resistor r=102.553 //w=0.094 //l=0.2 //layer=ply \
 //thickness=0.18 //x=3.045 //y=4.97 //x2=2.845 //y2=4.97
r349 (  87 122 ) resistor r=38.6777 //w=0.284 //l=0.198997 //layer=ply \
 //thickness=0.18 //x=2.8 //y=2.095 //x2=2.725 //y2=2.26
r350 (  86 120 ) resistor r=21.2976 //w=0.217 //l=0.0928709 //layer=ply \
 //thickness=0.18 //x=2.8 //y=1.63 //x2=2.76 //y2=1.555
r351 (  86 87 ) resistor r=238.436 //w=0.094 //l=0.465 //layer=ply \
 //thickness=0.18 //x=2.8 //y=1.63 //x2=2.8 //y2=2.095
r352 (  85 120 ) resistor r=39.0671 //w=0.217 //l=0.173853 //layer=ply \
 //thickness=0.18 //x=2.8 //y=1.4 //x2=2.76 //y2=1.555
r353 (  84 119 ) resistor r=45.1352 //w=0.168 //l=0.173853 //layer=ply \
 //thickness=0.18 //x=2.8 //y=1.09 //x2=2.76 //y2=0.935
r354 (  84 85 ) resistor r=158.957 //w=0.094 //l=0.31 //layer=ply \
 //thickness=0.18 //x=2.8 //y=1.09 //x2=2.8 //y2=1.4
r355 (  79 113 ) resistor r=5.52526 //w=0.168 //l=0.115 //layer=ply \
 //thickness=0.18 //x=2.43 //y=1.555 //x2=2.315 //y2=1.555
r356 (  78 120 ) resistor r=11.4558 //w=0.217 //l=0.115 //layer=ply \
 //thickness=0.18 //x=2.645 //y=1.555 //x2=2.76 //y2=1.555
r357 (  77 112 ) resistor r=5.52526 //w=0.168 //l=0.115 //layer=ply \
 //thickness=0.18 //x=2.43 //y=0.935 //x2=2.315 //y2=0.935
r358 (  76 119 ) resistor r=5.52526 //w=0.168 //l=0.115 //layer=ply \
 //thickness=0.18 //x=2.645 //y=0.935 //x2=2.76 //y2=0.935
r359 (  76 77 ) resistor r=110.245 //w=0.094 //l=0.215 //layer=ply \
 //thickness=0.18 //x=2.645 //y=0.935 //x2=2.43 //y2=0.935
r360 (  75 113 ) resistor r=45.1352 //w=0.168 //l=0.173853 //layer=ply \
 //thickness=0.18 //x=2.275 //y=1.4 //x2=2.315 //y2=1.555
r361 (  74 112 ) resistor r=45.1352 //w=0.168 //l=0.173853 //layer=ply \
 //thickness=0.18 //x=2.275 //y=1.09 //x2=2.315 //y2=0.935
r362 (  74 75 ) resistor r=158.957 //w=0.094 //l=0.31 //layer=ply \
 //thickness=0.18 //x=2.275 //y=1.09 //x2=2.275 //y2=1.4
r363 (  73 107 ) resistor r=592.245 //w=0.094 //l=1.155 //layer=ply \
 //thickness=0.18 //x=14.29 //y=6.2 //x2=14.29 //y2=5.045
r364 (  72 131 ) resistor r=592.245 //w=0.094 //l=1.155 //layer=ply \
 //thickness=0.18 //x=13.85 //y=6.2 //x2=13.85 //y2=5.045
r365 (  71 90 ) resistor r=592.245 //w=0.094 //l=1.155 //layer=ply \
 //thickness=0.18 //x=3.12 //y=6.2 //x2=3.12 //y2=5.045
r366 (  70 118 ) resistor r=592.245 //w=0.094 //l=1.155 //layer=ply \
 //thickness=0.18 //x=2.68 //y=6.2 //x2=2.68 //y2=5.045
r367 (  69 104 ) resistor r=56.4043 //w=0.094 //l=0.11 //layer=ply \
 //thickness=0.18 //x=14.11 //y=1.585 //x2=14.22 //y2=1.585
r368 (  69 105 ) resistor r=56.4043 //w=0.094 //l=0.11 //layer=ply \
 //thickness=0.18 //x=14.11 //y=1.585 //x2=14 //y2=1.585
r369 (  68 78 ) resistor r=55.3787 //w=0.094 //l=0.108 //layer=ply \
 //thickness=0.18 //x=2.537 //y=1.555 //x2=2.645 //y2=1.555
r370 (  68 79 ) resistor r=54.866 //w=0.094 //l=0.107 //layer=ply \
 //thickness=0.18 //x=2.537 //y=1.555 //x2=2.43 //y2=1.555
r371 (  64 128 ) resistor r=152 //w=0.17 //l=0.17 //layer=licon //count=1 \
 //x=13.84 //y=4.88 //x2=13.84 //y2=4.88
r372 (  59 124 ) resistor r=152 //w=0.17 //l=0.17 //layer=licon //count=1 \
 //x=13.81 //y=2.26 //x2=13.81 //y2=2.26
r373 (  54 115 ) resistor r=152 //w=0.17 //l=0.17 //layer=licon //count=1 \
 //x=2.71 //y=4.88 //x2=2.71 //y2=4.88
r374 (  49 122 ) resistor r=152 //w=0.17 //l=0.17 //layer=licon //count=1 \
 //x=2.71 //y=2.26 //x2=2.71 //y2=2.26
r375 (  43 45 ) resistor r=0.110922 //w=0.293 //l=0.26 //layer=m2 \
 //thickness=0.36 //x=2.71 //y=4.62 //x2=2.71 //y2=4.88
r376 (  41 47 ) resistor r=1.99191 //w=0.197 //l=3.16733 //layer=m2 \
 //thickness=0.36 //x=10.7 //y=4.64 //x2=13.835 //y2=4.705
r377 (  41 42 ) resistor r=0.329198 //w=0.131 //l=0.345 //layer=m2 \
 //thickness=0.36 //x=10.7 //y=4.64 //x2=10.355 //y2=4.64
r378 (  40 43 ) resistor r=0.040188 //w=0.293 //l=0.16 //layer=m2 \
 //thickness=0.36 //x=2.87 //y=4.62 //x2=2.71 //y2=4.62
r379 (  39 42 ) resistor r=0.1875 //w=0.17 //l=0.264811 //layer=m2 \
 //thickness=0.36 //x=10.1 //y=4.62 //x2=10.355 //y2=4.64
r380 (  39 40 ) resistor r=6.89885 //w=0.131 //l=7.23 //layer=m2 \
 //thickness=0.36 //x=10.1 //y=4.62 //x2=2.87 //y2=4.62
r381 (  36 59 ) resistor r=9.3 //w=0.17 //l=0.17 //layer=mcon //count=1 \
 //x=13.81 //y=2.26 //x2=13.81 //y2=2.26
r382 (  36 38 ) resistor r=0.0936408 //w=0.196 //l=0.125 //layer=m1 \
 //thickness=0.36 //x=13.812 //y=2.26 //x2=13.812 //y2=2.385
r383 (  33 64 ) resistor r=9.3 //w=0.17 //l=0.17 //layer=mcon //count=1 \
 //x=13.84 //y=4.88 //x2=13.84 //y2=4.88
r384 (  30 47 ) resistor r=4.5 //w=0.15 //l=0.15 //layer=via1 //count=1 \
 //x=13.835 //y=4.865 //x2=13.835 //y2=4.865
r385 (  30 33 ) resistor r=0.0066726 //w=0.281 //l=0.015 //layer=m1 \
 //thickness=0.36 //x=13.835 //y=4.865 //x2=13.835 //y2=4.88
r386 (  30 31 ) resistor r=0.10734 //w=0.281 //l=0.16 //layer=m1 \
 //thickness=0.36 //x=13.835 //y=4.865 //x2=13.835 //y2=4.705
r387 (  28 49 ) resistor r=9.3 //w=0.17 //l=0.17 //layer=mcon //count=1 \
 //x=2.71 //y=2.26 //x2=2.71 //y2=2.26
r388 (  24 54 ) resistor r=9.3 //w=0.17 //l=0.17 //layer=mcon //count=1 \
 //x=2.71 //y=4.88 //x2=2.71 //y2=4.88
r389 (  24 45 ) resistor r=4.5 //w=0.15 //l=0.15 //layer=via1 //count=1 \
 //x=2.71 //y=4.88 //x2=2.71 //y2=4.88
r390 (  11 24 ) resistor r=0.10734 //w=0.281 //l=0.16 //layer=m1 \
 //thickness=0.36 //x=2.71 //y=4.72 //x2=2.71 //y2=4.88
r391 (  10 28 ) resistor r=0.0715665 //w=0.226 //l=0.115996 //layer=m1 \
 //thickness=0.36 //x=2.71 //y=2.375 //x2=2.712 //y2=2.26
r392 (  9 31 ) resistor r=0.0811069 //w=0.131 //l=0.085 //layer=m1 \
 //thickness=0.36 //x=13.81 //y=4.62 //x2=13.81 //y2=4.705
r393 (  8 9 ) resistor r=1.05916 //w=0.131 //l=1.11 //layer=m1 \
 //thickness=0.36 //x=13.81 //y=3.51 //x2=13.81 //y2=4.62
r394 (  7 8 ) resistor r=0.353053 //w=0.131 //l=0.37 //layer=m1 \
 //thickness=0.36 //x=13.81 //y=3.14 //x2=13.81 //y2=3.51
r395 (  6 7 ) resistor r=0.353053 //w=0.131 //l=0.37 //layer=m1 \
 //thickness=0.36 //x=13.81 //y=2.77 //x2=13.81 //y2=3.14
r396 (  6 38 ) resistor r=0.367366 //w=0.131 //l=0.385 //layer=m1 \
 //thickness=0.36 //x=13.81 //y=2.77 //x2=13.81 //y2=2.385
r397 (  5 11 ) resistor r=0.0954198 //w=0.131 //l=0.1 //layer=m1 \
 //thickness=0.36 //x=2.71 //y=4.62 //x2=2.71 //y2=4.72
r398 (  4 5 ) resistor r=0.706107 //w=0.131 //l=0.74 //layer=m1 \
 //thickness=0.36 //x=2.71 //y=3.88 //x2=2.71 //y2=4.62
r399 (  3 4 ) resistor r=0.353053 //w=0.131 //l=0.37 //layer=m1 \
 //thickness=0.36 //x=2.71 //y=3.51 //x2=2.71 //y2=3.88
r400 (  2 3 ) resistor r=0.353053 //w=0.131 //l=0.37 //layer=m1 \
 //thickness=0.36 //x=2.71 //y=3.14 //x2=2.71 //y2=3.51
r401 (  1 2 ) resistor r=0.353053 //w=0.131 //l=0.37 //layer=m1 \
 //thickness=0.36 //x=2.71 //y=2.77 //x2=2.71 //y2=3.14
r402 (  1 10 ) resistor r=0.376908 //w=0.131 //l=0.395 //layer=m1 \
 //thickness=0.36 //x=2.71 //y=2.77 //x2=2.71 //y2=2.375
ends PM_DFFQNX1\%CLK

subckt PM_DFFQNX1\%noxref_4 ( 1 3 6 7 9 10 11 12 14 15 16 18 19 22 23 25 28 31 \
 37 40 43 46 47 50 54 57 58 60 61 62 63 64 66 68 70 72 74 84 92 100 117 126 \
 131 140 144 145 146 147 148 149 150 151 152 153 157 159 162 163 167 168 169 \
 170 174 176 179 180 190 199 202 204 205 206 )
c475 ( 202 0 ) capacitor c=0.00885916f //x=3.885 //y=1.095
c476 ( 199 0 ) capacitor c=0.0645411f //x=16.4 //y=4.88
c477 ( 190 0 ) capacitor c=0.0645923f //x=6.41 //y=4.88
c478 ( 180 0 ) capacitor c=0.0318956f //x=16.735 //y=1.39
c479 ( 179 0 ) capacitor c=0.0186809f //x=16.735 //y=1.045
c480 ( 176 0 ) capacitor c=0.0141821f //x=16.58 //y=1.545
c481 ( 174 0 ) capacitor c=0.0158553f //x=16.58 //y=0.89
c482 ( 170 0 ) capacitor c=0.088055f //x=16.205 //y=2.095
c483 ( 169 0 ) capacitor c=0.0229235f //x=16.205 //y=1.7
c484 ( 168 0 ) capacitor c=0.0234359f //x=16.205 //y=1.39
c485 ( 167 0 ) capacitor c=0.0198759f //x=16.205 //y=1.045
c486 ( 163 0 ) capacitor c=0.0318956f //x=6.745 //y=1.39
c487 ( 162 0 ) capacitor c=0.0186809f //x=6.745 //y=1.045
c488 ( 159 0 ) capacitor c=0.0141821f //x=6.59 //y=1.545
c489 ( 157 0 ) capacitor c=0.0158553f //x=6.59 //y=0.89
c490 ( 153 0 ) capacitor c=0.088055f //x=6.215 //y=2.095
c491 ( 152 0 ) capacitor c=0.0229235f //x=6.215 //y=1.7
c492 ( 151 0 ) capacitor c=0.0234359f //x=6.215 //y=1.39
c493 ( 150 0 ) capacitor c=0.0198759f //x=6.215 //y=1.045
c494 ( 149 0 ) capacitor c=0.110369f //x=16.74 //y=6.2
c495 ( 148 0 ) capacitor c=0.154619f //x=16.3 //y=6.2
c496 ( 147 0 ) capacitor c=0.110369f //x=6.75 //y=6.2
c497 ( 146 0 ) capacitor c=0.154619f //x=6.31 //y=6.2
c498 ( 140 0 ) capacitor c=8.13425e-19 //x=16.4 //y=4.88
c499 ( 131 0 ) capacitor c=7.85889e-19 //x=16.4 //y=2.26
c500 ( 126 0 ) capacitor c=8.13425e-19 //x=6.41 //y=4.88
c501 ( 117 0 ) capacitor c=7.85889e-19 //x=6.41 //y=2.26
c502 ( 100 0 ) capacitor c=0.0293071f //x=3.78 //y=5.56
c503 ( 92 0 ) capacitor c=0.029137f //x=2.9 //y=5.56
c504 ( 84 0 ) capacitor c=0.0278099f //x=2.02 //y=5.56
c505 ( 74 0 ) capacitor c=0.0891228f //x=13.28 //y=3.895
c506 ( 72 0 ) capacitor c=0.0175525f //x=12.68 //y=3.88
c507 ( 70 0 ) capacitor c=0.00410953f //x=11.44 //y=3.895
c508 ( 68 0 ) capacitor c=0.0176014f //x=10.7 //y=3.87
c509 ( 66 0 ) capacitor c=0.0106365f //x=9.95 //y=3.89
c510 ( 64 0 ) capacitor c=0.0178779f //x=9.35 //y=3.88
c511 ( 63 0 ) capacitor c=0.0105169f //x=7.755 //y=3.895
c512 ( 62 0 ) capacitor c=0.00467954f //x=8.1 //y=3.895
c513 ( 61 0 ) capacitor c=7.05145e-19 //x=4.72 //y=3.88
c514 ( 60 0 ) capacitor c=0.0193144f //x=6.245 //y=3.88
c515 ( 58 0 ) capacitor c=0.0167537f //x=16.402 //y=4.74
c516 ( 57 0 ) capacitor c=0.00598189f //x=16.4 //y=4.88
c517 ( 54 0 ) capacitor c=0.00654828f //x=16.4 //y=2.26
c518 ( 50 0 ) capacitor c=0.0142994f //x=16.4 //y=3.88
c519 ( 47 0 ) capacitor c=0.0172769f //x=6.412 //y=4.74
c520 ( 46 0 ) capacitor c=0.00598357f //x=6.41 //y=4.88
c521 ( 43 0 ) capacitor c=0.00654649f //x=6.41 //y=2.26
c522 ( 40 0 ) capacitor c=0.0163193f //x=6.405 //y=3.88
c523 ( 37 0 ) capacitor c=0.0170864f //x=4.56 //y=3.88
c524 ( 31 0 ) capacitor c=9.55882e-19 //x=3.78 //y=5.335
c525 ( 28 0 ) capacitor c=0.00753245f //x=2.9 //y=5.335
c526 ( 25 0 ) capacitor c=0.0123281f //x=2.022 //y=5.335
c527 ( 23 0 ) capacitor c=0.0124767f //x=16.4 //y=4.045
c528 ( 22 0 ) capacitor c=0.0406685f //x=16.4 //y=3.725
c529 ( 19 0 ) capacitor c=0.0124834f //x=6.41 //y=4.04
c530 ( 18 0 ) capacitor c=0.0389536f //x=6.41 //y=3.72
c531 ( 16 0 ) capacitor c=0.0309857f //x=4.56 //y=5.25
c532 ( 15 0 ) capacitor c=0.0132732f //x=4.56 //y=4.04
c533 ( 14 0 ) capacitor c=0.0507527f //x=4.56 //y=3.72
c534 ( 12 0 ) capacitor c=0.00686157f //x=4.16 //y=1.845
c535 ( 11 0 ) capacitor c=0.0159771f //x=4.475 //y=1.845
c536 ( 10 0 ) capacitor c=0.0136149f //x=4.075 //y=1.76
c537 ( 9 0 ) capacitor c=0.0112344f //x=4.075 //y=1.305
c538 ( 7 0 ) capacitor c=0.0228253f //x=4.475 //y=5.335
c539 ( 6 0 ) capacitor c=0.00906713f //x=3.78 //y=5.56
c540 ( 3 0 ) capacitor c=0.019596f //x=3.665 //y=5.335
c541 ( 1 0 ) capacitor c=0.0150747f //x=2.78 //y=5.335
r542 (  197 199 ) resistor r=20.6867 //w=0.233 //l=0.1 //layer=ply \
 //thickness=0.18 //x=16.3 //y=4.88 //x2=16.4 //y2=4.88
r543 (  188 190 ) resistor r=20.6867 //w=0.233 //l=0.1 //layer=ply \
 //thickness=0.18 //x=6.31 //y=4.88 //x2=6.41 //y2=4.88
r544 (  181 199 ) resistor r=70.3348 //w=0.233 //l=0.414367 //layer=ply \
 //thickness=0.18 //x=16.74 //y=5.045 //x2=16.4 //y2=4.88
r545 (  180 201 ) resistor r=45.1352 //w=0.168 //l=0.173853 //layer=ply \
 //thickness=0.18 //x=16.735 //y=1.39 //x2=16.695 //y2=1.545
r546 (  179 200 ) resistor r=45.1352 //w=0.168 //l=0.173853 //layer=ply \
 //thickness=0.18 //x=16.735 //y=1.045 //x2=16.695 //y2=0.89
r547 (  179 180 ) resistor r=176.904 //w=0.094 //l=0.345 //layer=ply \
 //thickness=0.18 //x=16.735 //y=1.045 //x2=16.735 //y2=1.39
r548 (  177 196 ) resistor r=10.701 //w=0.21 //l=0.115 //layer=ply \
 //thickness=0.18 //x=16.36 //y=1.545 //x2=16.245 //y2=1.545
r549 (  176 201 ) resistor r=5.52526 //w=0.168 //l=0.115 //layer=ply \
 //thickness=0.18 //x=16.58 //y=1.545 //x2=16.695 //y2=1.545
r550 (  175 195 ) resistor r=5.52526 //w=0.168 //l=0.115 //layer=ply \
 //thickness=0.18 //x=16.36 //y=0.89 //x2=16.245 //y2=0.89
r551 (  174 200 ) resistor r=5.52526 //w=0.168 //l=0.115 //layer=ply \
 //thickness=0.18 //x=16.58 //y=0.89 //x2=16.695 //y2=0.89
r552 (  174 175 ) resistor r=112.809 //w=0.094 //l=0.22 //layer=ply \
 //thickness=0.18 //x=16.58 //y=0.89 //x2=16.36 //y2=0.89
r553 (  171 197 ) resistor r=13.0941 //w=0.233 //l=0.165 //layer=ply \
 //thickness=0.18 //x=16.3 //y=5.045 //x2=16.3 //y2=4.88
r554 (  170 194 ) resistor r=34.8111 //w=0.27 //l=0.264953 //layer=ply \
 //thickness=0.18 //x=16.205 //y=2.095 //x2=16.4 //y2=2.26
r555 (  169 196 ) resistor r=39.5823 //w=0.21 //l=0.173853 //layer=ply \
 //thickness=0.18 //x=16.205 //y=1.7 //x2=16.245 //y2=1.545
r556 (  169 170 ) resistor r=202.543 //w=0.094 //l=0.395 //layer=ply \
 //thickness=0.18 //x=16.205 //y=1.7 //x2=16.205 //y2=2.095
r557 (  168 196 ) resistor r=39.5823 //w=0.21 //l=0.173853 //layer=ply \
 //thickness=0.18 //x=16.205 //y=1.39 //x2=16.245 //y2=1.545
r558 (  167 195 ) resistor r=45.1352 //w=0.168 //l=0.173853 //layer=ply \
 //thickness=0.18 //x=16.205 //y=1.045 //x2=16.245 //y2=0.89
r559 (  167 168 ) resistor r=176.904 //w=0.094 //l=0.345 //layer=ply \
 //thickness=0.18 //x=16.205 //y=1.045 //x2=16.205 //y2=1.39
r560 (  164 190 ) resistor r=70.3348 //w=0.233 //l=0.414367 //layer=ply \
 //thickness=0.18 //x=6.75 //y=5.045 //x2=6.41 //y2=4.88
r561 (  163 192 ) resistor r=45.1352 //w=0.168 //l=0.173853 //layer=ply \
 //thickness=0.18 //x=6.745 //y=1.39 //x2=6.705 //y2=1.545
r562 (  162 191 ) resistor r=45.1352 //w=0.168 //l=0.173853 //layer=ply \
 //thickness=0.18 //x=6.745 //y=1.045 //x2=6.705 //y2=0.89
r563 (  162 163 ) resistor r=176.904 //w=0.094 //l=0.345 //layer=ply \
 //thickness=0.18 //x=6.745 //y=1.045 //x2=6.745 //y2=1.39
r564 (  160 187 ) resistor r=10.701 //w=0.21 //l=0.115 //layer=ply \
 //thickness=0.18 //x=6.37 //y=1.545 //x2=6.255 //y2=1.545
r565 (  159 192 ) resistor r=5.52526 //w=0.168 //l=0.115 //layer=ply \
 //thickness=0.18 //x=6.59 //y=1.545 //x2=6.705 //y2=1.545
r566 (  158 186 ) resistor r=5.52526 //w=0.168 //l=0.115 //layer=ply \
 //thickness=0.18 //x=6.37 //y=0.89 //x2=6.255 //y2=0.89
r567 (  157 191 ) resistor r=5.52526 //w=0.168 //l=0.115 //layer=ply \
 //thickness=0.18 //x=6.59 //y=0.89 //x2=6.705 //y2=0.89
r568 (  157 158 ) resistor r=112.809 //w=0.094 //l=0.22 //layer=ply \
 //thickness=0.18 //x=6.59 //y=0.89 //x2=6.37 //y2=0.89
r569 (  154 188 ) resistor r=13.0941 //w=0.233 //l=0.165 //layer=ply \
 //thickness=0.18 //x=6.31 //y=5.045 //x2=6.31 //y2=4.88
r570 (  153 185 ) resistor r=34.8111 //w=0.27 //l=0.264953 //layer=ply \
 //thickness=0.18 //x=6.215 //y=2.095 //x2=6.41 //y2=2.26
r571 (  152 187 ) resistor r=39.5823 //w=0.21 //l=0.173853 //layer=ply \
 //thickness=0.18 //x=6.215 //y=1.7 //x2=6.255 //y2=1.545
r572 (  152 153 ) resistor r=202.543 //w=0.094 //l=0.395 //layer=ply \
 //thickness=0.18 //x=6.215 //y=1.7 //x2=6.215 //y2=2.095
r573 (  151 187 ) resistor r=39.5823 //w=0.21 //l=0.173853 //layer=ply \
 //thickness=0.18 //x=6.215 //y=1.39 //x2=6.255 //y2=1.545
r574 (  150 186 ) resistor r=45.1352 //w=0.168 //l=0.173853 //layer=ply \
 //thickness=0.18 //x=6.215 //y=1.045 //x2=6.255 //y2=0.89
r575 (  150 151 ) resistor r=176.904 //w=0.094 //l=0.345 //layer=ply \
 //thickness=0.18 //x=6.215 //y=1.045 //x2=6.215 //y2=1.39
r576 (  149 181 ) resistor r=592.245 //w=0.094 //l=1.155 //layer=ply \
 //thickness=0.18 //x=16.74 //y=6.2 //x2=16.74 //y2=5.045
r577 (  148 171 ) resistor r=592.245 //w=0.094 //l=1.155 //layer=ply \
 //thickness=0.18 //x=16.3 //y=6.2 //x2=16.3 //y2=5.045
r578 (  147 164 ) resistor r=592.245 //w=0.094 //l=1.155 //layer=ply \
 //thickness=0.18 //x=6.75 //y=6.2 //x2=6.75 //y2=5.045
r579 (  146 154 ) resistor r=592.245 //w=0.094 //l=1.155 //layer=ply \
 //thickness=0.18 //x=6.31 //y=6.2 //x2=6.31 //y2=5.045
r580 (  145 176 ) resistor r=56.4043 //w=0.094 //l=0.11 //layer=ply \
 //thickness=0.18 //x=16.47 //y=1.545 //x2=16.58 //y2=1.545
r581 (  145 177 ) resistor r=56.4043 //w=0.094 //l=0.11 //layer=ply \
 //thickness=0.18 //x=16.47 //y=1.545 //x2=16.36 //y2=1.545
r582 (  144 159 ) resistor r=56.4043 //w=0.094 //l=0.11 //layer=ply \
 //thickness=0.18 //x=6.48 //y=1.545 //x2=6.59 //y2=1.545
r583 (  144 160 ) resistor r=56.4043 //w=0.094 //l=0.11 //layer=ply \
 //thickness=0.18 //x=6.48 //y=1.545 //x2=6.37 //y2=1.545
r584 (  140 199 ) resistor r=152 //w=0.17 //l=0.17 //layer=licon //count=1 \
 //x=16.4 //y=4.88 //x2=16.4 //y2=4.88
r585 (  131 194 ) resistor r=152 //w=0.17 //l=0.17 //layer=licon //count=1 \
 //x=16.4 //y=2.26 //x2=16.4 //y2=2.26
r586 (  126 190 ) resistor r=152 //w=0.17 //l=0.17 //layer=licon //count=1 \
 //x=6.41 //y=4.88 //x2=6.41 //y2=4.88
r587 (  117 185 ) resistor r=152 //w=0.17 //l=0.17 //layer=licon //count=1 \
 //x=6.41 //y=2.26 //x2=6.41 //y2=2.26
r588 (  100 206 ) resistor r=23.615 //w=0.187 //l=0.345 //layer=li \
 //thickness=0.1 //x=3.78 //y=5.56 //x2=3.78 //y2=5.905
r589 (  92 205 ) resistor r=23.615 //w=0.187 //l=0.345 //layer=li \
 //thickness=0.1 //x=2.9 //y=5.56 //x2=2.9 //y2=5.905
r590 (  84 204 ) resistor r=23.615 //w=0.187 //l=0.345 //layer=li \
 //thickness=0.1 //x=2.02 //y=5.56 //x2=2.02 //y2=5.905
r591 (  74 82 ) resistor r=2.10915 //w=0.185 //l=3.125 //layer=m2 \
 //thickness=0.36 //x=13.28 //y=3.895 //x2=16.4 //y2=3.885
r592 (  74 75 ) resistor r=0.329198 //w=0.131 //l=0.345 //layer=m2 \
 //thickness=0.36 //x=13.28 //y=3.895 //x2=12.935 //y2=3.895
r593 (  72 75 ) resistor r=0.1875 //w=0.17 //l=0.262393 //layer=m2 \
 //thickness=0.36 //x=12.68 //y=3.88 //x2=12.935 //y2=3.895
r594 (  72 73 ) resistor r=1.02099 //w=0.131 //l=1.07 //layer=m2 \
 //thickness=0.36 //x=12.68 //y=3.88 //x2=11.61 //y2=3.88
r595 (  70 73 ) resistor r=0.125 //w=0.17 //l=0.177341 //layer=m2 \
 //thickness=0.36 //x=11.44 //y=3.895 //x2=11.61 //y2=3.88
r596 (  70 71 ) resistor r=0.329198 //w=0.131 //l=0.345 //layer=m2 \
 //thickness=0.36 //x=11.44 //y=3.895 //x2=11.095 //y2=3.895
r597 (  68 71 ) resistor r=0.290441 //w=0.17 //l=0.407308 //layer=m2 \
 //thickness=0.36 //x=10.7 //y=3.87 //x2=11.095 //y2=3.895
r598 (  68 69 ) resistor r=0.410305 //w=0.131 //l=0.43 //layer=m2 \
 //thickness=0.36 //x=10.7 //y=3.87 //x2=10.27 //y2=3.87
r599 (  66 69 ) resistor r=0.235294 //w=0.17 //l=0.329848 //layer=m2 \
 //thickness=0.36 //x=9.95 //y=3.89 //x2=10.27 //y2=3.87
r600 (  66 67 ) resistor r=0.329198 //w=0.131 //l=0.345 //layer=m2 \
 //thickness=0.36 //x=9.95 //y=3.89 //x2=9.605 //y2=3.89
r601 (  64 67 ) resistor r=0.1875 //w=0.17 //l=0.259952 //layer=m2 \
 //thickness=0.36 //x=9.35 //y=3.88 //x2=9.605 //y2=3.89
r602 (  64 65 ) resistor r=1.03053 //w=0.131 //l=1.08 //layer=m2 \
 //thickness=0.36 //x=9.35 //y=3.88 //x2=8.27 //y2=3.88
r603 (  63 80 ) resistor r=0.838898 //w=0.202 //l=1.35748 //layer=m2 \
 //thickness=0.36 //x=7.755 //y=3.895 //x2=6.405 //y2=3.88
r604 (  62 65 ) resistor r=0.125 //w=0.17 //l=0.177341 //layer=m2 \
 //thickness=0.36 //x=8.1 //y=3.895 //x2=8.27 //y2=3.88
r605 (  62 63 ) resistor r=0.329198 //w=0.131 //l=0.345 //layer=m2 \
 //thickness=0.36 //x=8.1 //y=3.895 //x2=7.755 //y2=3.895
r606 (  61 77 ) resistor r=0.10734 //w=0.281 //l=0.16 //layer=m2 \
 //thickness=0.36 //x=4.72 //y=3.88 //x2=4.56 //y2=3.88
r607 (  60 80 ) resistor r=0.102512 //w=0.202 //l=0.16 //layer=m2 \
 //thickness=0.36 //x=6.245 //y=3.88 //x2=6.405 //y2=3.88
r608 (  60 61 ) resistor r=1.45515 //w=0.131 //l=1.525 //layer=m2 \
 //thickness=0.36 //x=6.245 //y=3.88 //x2=4.72 //y2=3.88
r609 (  57 140 ) resistor r=9.3 //w=0.17 //l=0.17 //layer=mcon //count=1 \
 //x=16.4 //y=4.88 //x2=16.4 //y2=4.88
r610 (  57 58 ) resistor r=0.103207 //w=0.196 //l=0.14 //layer=m1 \
 //thickness=0.36 //x=16.402 //y=4.88 //x2=16.402 //y2=4.74
r611 (  54 131 ) resistor r=9.3 //w=0.17 //l=0.17 //layer=mcon //count=1 \
 //x=16.4 //y=2.26 //x2=16.4 //y2=2.26
r612 (  52 82 ) resistor r=4.5 //w=0.15 //l=0.15 //layer=via1 //count=1 \
 //x=16.4 //y=3.885 //x2=16.4 //y2=3.885
r613 (  50 52 ) resistor r=0.00166223 //w=0.376 //l=0.005 //layer=m1 \
 //thickness=0.36 //x=16.347 //y=3.88 //x2=16.347 //y2=3.885
r614 (  46 126 ) resistor r=9.3 //w=0.17 //l=0.17 //layer=mcon //count=1 \
 //x=6.41 //y=4.88 //x2=6.41 //y2=4.88
r615 (  46 47 ) resistor r=0.103207 //w=0.196 //l=0.14 //layer=m1 \
 //thickness=0.36 //x=6.412 //y=4.88 //x2=6.412 //y2=4.74
r616 (  43 117 ) resistor r=9.3 //w=0.17 //l=0.17 //layer=mcon //count=1 \
 //x=6.41 //y=2.26 //x2=6.41 //y2=2.26
r617 (  40 80 ) resistor r=4.5 //w=0.15 //l=0.15 //layer=via1 //count=1 \
 //x=6.405 //y=3.88 //x2=6.405 //y2=3.88
r618 (  37 77 ) resistor r=4.5 //w=0.15 //l=0.15 //layer=via1 //count=1 \
 //x=4.56 //y=3.88 //x2=4.56 //y2=3.88
r619 (  35 202 ) resistor r=9.3 //w=0.17 //l=0.17 //layer=mcon //count=1 \
 //x=4.075 //y=1.19 //x2=4.075 //y2=1.19
r620 (  33 100 ) resistor r=9.3 //w=0.17 //l=0.17 //layer=mcon //count=1 \
 //x=3.78 //y=5.56 //x2=3.78 //y2=5.56
r621 (  30 92 ) resistor r=9.3 //w=0.17 //l=0.17 //layer=mcon //count=1 \
 //x=2.9 //y=5.56 //x2=2.9 //y2=5.56
r622 (  28 30 ) resistor r=0.121228 //w=0.232 //l=0.225 //layer=m1 \
 //thickness=0.36 //x=2.9 //y=5.335 //x2=2.9 //y2=5.56
r623 (  27 84 ) resistor r=9.3 //w=0.17 //l=0.17 //layer=mcon //count=1 \
 //x=2.02 //y=5.56 //x2=2.02 //y2=5.56
r624 (  25 27 ) resistor r=0.129608 //w=0.217 //l=0.225 //layer=m1 \
 //thickness=0.36 //x=2.022 //y=5.335 //x2=2.022 //y2=5.56
r625 (  23 52 ) resistor r=0.0911593 //w=0.376 //l=0.184608 //layer=m1 \
 //thickness=0.36 //x=16.4 //y=4.045 //x2=16.347 //y2=3.885
r626 (  23 58 ) resistor r=0.663168 //w=0.131 //l=0.695 //layer=m1 \
 //thickness=0.36 //x=16.4 //y=4.045 //x2=16.4 //y2=4.74
r627 (  22 50 ) resistor r=0.0894971 //w=0.376 //l=0.179555 //layer=m1 \
 //thickness=0.36 //x=16.4 //y=3.725 //x2=16.347 //y2=3.88
r628 (  21 54 ) resistor r=0.0933015 //w=0.201 //l=0.125 //layer=m1 \
 //thickness=0.36 //x=16.4 //y=2.385 //x2=16.4 //y2=2.26
r629 (  21 22 ) resistor r=1.27863 //w=0.131 //l=1.34 //layer=m1 \
 //thickness=0.36 //x=16.4 //y=2.385 //x2=16.4 //y2=3.725
r630 (  19 40 ) resistor r=0.0910802 //w=0.374 //l=0.185472 //layer=m1 \
 //thickness=0.36 //x=6.41 //y=4.04 //x2=6.355 //y2=3.88
r631 (  19 47 ) resistor r=0.667939 //w=0.131 //l=0.7 //layer=m1 \
 //thickness=0.36 //x=6.41 //y=4.04 //x2=6.41 //y2=4.74
r632 (  18 40 ) resistor r=0.0910802 //w=0.374 //l=0.185472 //layer=m1 \
 //thickness=0.36 //x=6.41 //y=3.72 //x2=6.355 //y2=3.88
r633 (  17 43 ) resistor r=0.0933015 //w=0.201 //l=0.125 //layer=m1 \
 //thickness=0.36 //x=6.41 //y=2.385 //x2=6.41 //y2=2.26
r634 (  17 18 ) resistor r=1.27385 //w=0.131 //l=1.335 //layer=m1 \
 //thickness=0.36 //x=6.41 //y=2.385 //x2=6.41 //y2=3.72
r635 (  15 37 ) resistor r=0.0911593 //w=0.376 //l=0.184174 //layer=m1 \
 //thickness=0.36 //x=4.56 //y=4.04 //x2=4.612 //y2=3.88
r636 (  15 16 ) resistor r=1.15458 //w=0.131 //l=1.21 //layer=m1 \
 //thickness=0.36 //x=4.56 //y=4.04 //x2=4.56 //y2=5.25
r637 (  14 37 ) resistor r=0.0911593 //w=0.376 //l=0.184174 //layer=m1 \
 //thickness=0.36 //x=4.56 //y=3.72 //x2=4.612 //y2=3.88
r638 (  13 14 ) resistor r=1.70802 //w=0.131 //l=1.79 //layer=m1 \
 //thickness=0.36 //x=4.56 //y=1.93 //x2=4.56 //y2=3.72
r639 (  11 13 ) resistor r=0.0698411 //w=0.17 //l=0.120208 //layer=m1 \
 //thickness=0.36 //x=4.475 //y=1.845 //x2=4.56 //y2=1.93
r640 (  11 12 ) resistor r=0.300573 //w=0.131 //l=0.315 //layer=m1 \
 //thickness=0.36 //x=4.475 //y=1.845 //x2=4.16 //y2=1.845
r641 (  10 12 ) resistor r=0.0698411 //w=0.17 //l=0.120208 //layer=m1 \
 //thickness=0.36 //x=4.075 //y=1.76 //x2=4.16 //y2=1.845
r642 (  9 35 ) resistor r=0.0717383 //w=0.224 //l=0.115 //layer=m1 \
 //thickness=0.36 //x=4.075 //y=1.305 //x2=4.075 //y2=1.19
r643 (  9 10 ) resistor r=0.43416 //w=0.131 //l=0.455 //layer=m1 \
 //thickness=0.36 //x=4.075 //y=1.305 //x2=4.075 //y2=1.76
r644 (  8 31 ) resistor r=0.0675342 //w=0.23 //l=0.115 //layer=m1 \
 //thickness=0.36 //x=3.895 //y=5.335 //x2=3.78 //y2=5.335
r645 (  7 16 ) resistor r=0.0698411 //w=0.17 //l=0.120208 //layer=m1 \
 //thickness=0.36 //x=4.475 //y=5.335 //x2=4.56 //y2=5.25
r646 (  7 8 ) resistor r=0.553435 //w=0.131 //l=0.58 //layer=m1 \
 //thickness=0.36 //x=4.475 //y=5.335 //x2=3.895 //y2=5.335
r647 (  6 33 ) resistor r=0.00118313 //w=0.23 //layer=m1 //thickness=0.36 \
 //x=3.78 //y=5.56 //x2=3.78 //y2=5.56
r648 (  5 31 ) resistor r=0.002872 //w=0.34 //l=0.085 //layer=m1 \
 //thickness=0.36 //x=3.78 //y=5.42 //x2=3.78 //y2=5.335
r649 (  5 6 ) resistor r=0.091623 //w=0.191 //l=0.14 //layer=m1 \
 //thickness=0.36 //x=3.78 //y=5.42 //x2=3.78 //y2=5.56
r650 (  4 28 ) resistor r=0.0262263 //w=0.232 //l=0.12 //layer=m1 \
 //thickness=0.36 //x=3.02 //y=5.335 //x2=2.9 //y2=5.335
r651 (  3 31 ) resistor r=0.0675342 //w=0.23 //l=0.115 //layer=m1 \
 //thickness=0.36 //x=3.665 //y=5.335 //x2=3.78 //y2=5.335
r652 (  3 4 ) resistor r=0.615458 //w=0.131 //l=0.645 //layer=m1 \
 //thickness=0.36 //x=3.665 //y=5.335 //x2=3.02 //y2=5.335
r653 (  2 25 ) resistor r=0.0222262 //w=0.217 //l=0.118 //layer=m1 \
 //thickness=0.36 //x=2.14 //y=5.335 //x2=2.022 //y2=5.335
r654 (  1 28 ) resistor r=0.0262263 //w=0.232 //l=0.12 //layer=m1 \
 //thickness=0.36 //x=2.78 //y=5.335 //x2=2.9 //y2=5.335
r655 (  1 2 ) resistor r=0.610687 //w=0.131 //l=0.64 //layer=m1 \
 //thickness=0.36 //x=2.78 //y=5.335 //x2=2.14 //y2=5.335
ends PM_DFFQNX1\%noxref_4

subckt PM_DFFQNX1\%QN ( 1 2 3 4 5 6 7 8 9 10 13 18 19 21 22 28 36 41 42 45 47 \
 58 61 69 71 72 75 83 100 109 113 114 115 116 117 118 119 123 125 128 129 139 \
 142 144 145 )
c273 ( 142 0 ) capacitor c=0.00878249f //x=17.25 //y=1.085
c274 ( 139 0 ) capacitor c=0.0682508f //x=19.73 //y=4.88
c275 ( 129 0 ) capacitor c=0.0318956f //x=20.065 //y=1.39
c276 ( 128 0 ) capacitor c=0.0186809f //x=20.065 //y=1.045
c277 ( 125 0 ) capacitor c=0.0141821f //x=19.91 //y=1.545
c278 ( 123 0 ) capacitor c=0.0158553f //x=19.91 //y=0.89
c279 ( 119 0 ) capacitor c=0.0854122f //x=19.535 //y=2.095
c280 ( 118 0 ) capacitor c=0.0229235f //x=19.535 //y=1.7
c281 ( 117 0 ) capacitor c=0.0234359f //x=19.535 //y=1.39
c282 ( 116 0 ) capacitor c=0.0198759f //x=19.535 //y=1.045
c283 ( 115 0 ) capacitor c=0.110369f //x=20.07 //y=6.2
c284 ( 114 0 ) capacitor c=0.154619f //x=19.63 //y=6.2
c285 ( 109 0 ) capacitor c=8.13425e-19 //x=19.73 //y=4.88
c286 ( 100 0 ) capacitor c=7.85889e-19 //x=19.73 //y=2.26
c287 ( 83 0 ) capacitor c=0.0322017f //x=17.4 //y=5.56
c288 ( 75 0 ) capacitor c=0.0290186f //x=16.52 //y=5.56
c289 ( 72 0 ) capacitor c=0.0480964f //x=19.57 //y=3.495
c290 ( 71 0 ) capacitor c=0.00162195f //x=19.73 //y=3.495
c291 ( 69 0 ) capacitor c=0.00306238f //x=18.04 //y=3.495
c292 ( 61 0 ) capacitor c=0.00611632f //x=19.73 //y=4.88
c293 ( 58 0 ) capacitor c=0.0064059f //x=19.73 //y=2.26
c294 ( 47 0 ) capacitor c=0.0113657f //x=17.44 //y=1.18
c295 ( 45 0 ) capacitor c=5.78613e-19 //x=17.4 //y=5.56
c296 ( 42 0 ) capacitor c=0.0112577f //x=17.4 //y=5.38
c297 ( 41 0 ) capacitor c=0.00921781f //x=16.52 //y=5.56
c298 ( 36 0 ) capacitor c=0.0136965f //x=19.73 //y=3.655
c299 ( 28 0 ) capacitor c=0.0135005f //x=17.88 //y=3.655
c300 ( 22 0 ) capacitor c=0.00622751f //x=17.525 //y=1.835
c301 ( 21 0 ) capacitor c=0.0142752f //x=17.795 //y=1.835
c302 ( 19 0 ) capacitor c=0.0116047f //x=17.795 //y=5.38
c303 ( 18 0 ) capacitor c=0.0101547f //x=17.44 //y=1.75
c304 ( 13 0 ) capacitor c=0.0148064f //x=17.285 //y=5.38
c305 ( 10 0 ) capacitor c=0.0167165f //x=19.73 //y=3.51
c306 ( 9 0 ) capacitor c=0.0173226f //x=17.88 //y=3.51
c307 ( 8 0 ) capacitor c=0.0266662f //x=19.73 //y=4.62
c308 ( 6 0 ) capacitor c=0.0285574f //x=19.73 //y=2.77
c309 ( 4 0 ) capacitor c=0.0402498f //x=17.88 //y=4.62
c310 ( 1 0 ) capacitor c=0.0393928f //x=17.88 //y=2.4
r311 (  137 139 ) resistor r=20.6867 //w=0.233 //l=0.1 //layer=ply \
 //thickness=0.18 //x=19.63 //y=4.88 //x2=19.73 //y2=4.88
r312 (  130 139 ) resistor r=70.3348 //w=0.233 //l=0.414367 //layer=ply \
 //thickness=0.18 //x=20.07 //y=5.045 //x2=19.73 //y2=4.88
r313 (  129 141 ) resistor r=45.1352 //w=0.168 //l=0.173853 //layer=ply \
 //thickness=0.18 //x=20.065 //y=1.39 //x2=20.025 //y2=1.545
r314 (  128 140 ) resistor r=45.1352 //w=0.168 //l=0.173853 //layer=ply \
 //thickness=0.18 //x=20.065 //y=1.045 //x2=20.025 //y2=0.89
r315 (  128 129 ) resistor r=176.904 //w=0.094 //l=0.345 //layer=ply \
 //thickness=0.18 //x=20.065 //y=1.045 //x2=20.065 //y2=1.39
r316 (  126 136 ) resistor r=10.701 //w=0.21 //l=0.115 //layer=ply \
 //thickness=0.18 //x=19.69 //y=1.545 //x2=19.575 //y2=1.545
r317 (  125 141 ) resistor r=5.52526 //w=0.168 //l=0.115 //layer=ply \
 //thickness=0.18 //x=19.91 //y=1.545 //x2=20.025 //y2=1.545
r318 (  124 135 ) resistor r=5.52526 //w=0.168 //l=0.115 //layer=ply \
 //thickness=0.18 //x=19.69 //y=0.89 //x2=19.575 //y2=0.89
r319 (  123 140 ) resistor r=5.52526 //w=0.168 //l=0.115 //layer=ply \
 //thickness=0.18 //x=19.91 //y=0.89 //x2=20.025 //y2=0.89
r320 (  123 124 ) resistor r=112.809 //w=0.094 //l=0.22 //layer=ply \
 //thickness=0.18 //x=19.91 //y=0.89 //x2=19.69 //y2=0.89
r321 (  120 137 ) resistor r=13.0941 //w=0.233 //l=0.165 //layer=ply \
 //thickness=0.18 //x=19.63 //y=5.045 //x2=19.63 //y2=4.88
r322 (  119 134 ) resistor r=34.8111 //w=0.27 //l=0.264953 //layer=ply \
 //thickness=0.18 //x=19.535 //y=2.095 //x2=19.73 //y2=2.26
r323 (  118 136 ) resistor r=39.5823 //w=0.21 //l=0.173853 //layer=ply \
 //thickness=0.18 //x=19.535 //y=1.7 //x2=19.575 //y2=1.545
r324 (  118 119 ) resistor r=202.543 //w=0.094 //l=0.395 //layer=ply \
 //thickness=0.18 //x=19.535 //y=1.7 //x2=19.535 //y2=2.095
r325 (  117 136 ) resistor r=39.5823 //w=0.21 //l=0.173853 //layer=ply \
 //thickness=0.18 //x=19.535 //y=1.39 //x2=19.575 //y2=1.545
r326 (  116 135 ) resistor r=45.1352 //w=0.168 //l=0.173853 //layer=ply \
 //thickness=0.18 //x=19.535 //y=1.045 //x2=19.575 //y2=0.89
r327 (  116 117 ) resistor r=176.904 //w=0.094 //l=0.345 //layer=ply \
 //thickness=0.18 //x=19.535 //y=1.045 //x2=19.535 //y2=1.39
r328 (  115 130 ) resistor r=592.245 //w=0.094 //l=1.155 //layer=ply \
 //thickness=0.18 //x=20.07 //y=6.2 //x2=20.07 //y2=5.045
r329 (  114 120 ) resistor r=592.245 //w=0.094 //l=1.155 //layer=ply \
 //thickness=0.18 //x=19.63 //y=6.2 //x2=19.63 //y2=5.045
r330 (  113 125 ) resistor r=56.4043 //w=0.094 //l=0.11 //layer=ply \
 //thickness=0.18 //x=19.8 //y=1.545 //x2=19.91 //y2=1.545
r331 (  113 126 ) resistor r=56.4043 //w=0.094 //l=0.11 //layer=ply \
 //thickness=0.18 //x=19.8 //y=1.545 //x2=19.69 //y2=1.545
r332 (  109 139 ) resistor r=152 //w=0.17 //l=0.17 //layer=licon //count=1 \
 //x=19.73 //y=4.88 //x2=19.73 //y2=4.88
r333 (  100 134 ) resistor r=152 //w=0.17 //l=0.17 //layer=licon //count=1 \
 //x=19.73 //y=2.26 //x2=19.73 //y2=2.26
r334 (  83 145 ) resistor r=23.615 //w=0.187 //l=0.345 //layer=li \
 //thickness=0.1 //x=17.4 //y=5.56 //x2=17.4 //y2=5.905
r335 (  75 144 ) resistor r=23.615 //w=0.187 //l=0.345 //layer=li \
 //thickness=0.1 //x=16.52 //y=5.56 //x2=16.52 //y2=5.905
r336 (  71 72 ) resistor r=0.10734 //w=0.281 //l=0.16 //layer=m2 \
 //thickness=0.36 //x=19.73 //y=3.495 //x2=19.57 //y2=3.495
r337 (  69 72 ) resistor r=1.45992 //w=0.131 //l=1.53 //layer=m2 \
 //thickness=0.36 //x=18.04 //y=3.51 //x2=19.57 //y2=3.51
r338 (  67 69 ) resistor r=0.10734 //w=0.281 //l=0.16 //layer=m2 \
 //thickness=0.36 //x=17.88 //y=3.495 //x2=18.04 //y2=3.495
r339 (  61 109 ) resistor r=9.3 //w=0.17 //l=0.17 //layer=mcon //count=1 \
 //x=19.73 //y=4.88 //x2=19.73 //y2=4.88
r340 (  61 62 ) resistor r=0.103207 //w=0.196 //l=0.14 //layer=m1 \
 //thickness=0.36 //x=19.732 //y=4.88 //x2=19.732 //y2=4.74
r341 (  58 100 ) resistor r=9.3 //w=0.17 //l=0.17 //layer=mcon //count=1 \
 //x=19.73 //y=2.26 //x2=19.73 //y2=2.26
r342 (  54 71 ) resistor r=4.5 //w=0.15 //l=0.15 //layer=via1 //count=1 \
 //x=19.73 //y=3.495 //x2=19.73 //y2=3.495
r343 (  50 67 ) resistor r=4.5 //w=0.15 //l=0.15 //layer=via1 //count=1 \
 //x=17.88 //y=3.495 //x2=17.88 //y2=3.495
r344 (  47 142 ) resistor r=9.3 //w=0.17 //l=0.17 //layer=mcon //count=1 \
 //x=17.44 //y=1.18 //x2=17.44 //y2=1.18
r345 (  45 83 ) resistor r=9.3 //w=0.17 //l=0.17 //layer=mcon //count=1 \
 //x=17.4 //y=5.56 //x2=17.4 //y2=5.56
r346 (  42 45 ) resistor r=0.117801 //w=0.191 //l=0.18 //layer=m1 \
 //thickness=0.36 //x=17.4 //y=5.38 //x2=17.4 //y2=5.56
r347 (  41 75 ) resistor r=9.3 //w=0.17 //l=0.17 //layer=mcon //count=1 \
 //x=16.52 //y=5.56 //x2=16.52 //y2=5.56
r348 (  39 41 ) resistor r=0.10274 //w=0.219 //l=0.18 //layer=m1 \
 //thickness=0.36 //x=16.52 //y=5.38 //x2=16.52 //y2=5.56
r349 (  33 54 ) resistor r=0.0911593 //w=0.376 //l=0.184608 //layer=m1 \
 //thickness=0.36 //x=19.73 //y=3.335 //x2=19.677 //y2=3.495
r350 (  32 58 ) resistor r=0.0933015 //w=0.201 //l=0.125 //layer=m1 \
 //thickness=0.36 //x=19.73 //y=2.385 //x2=19.73 //y2=2.26
r351 (  24 50 ) resistor r=0.0911593 //w=0.376 //l=0.184174 //layer=m1 \
 //thickness=0.36 //x=17.88 //y=3.335 //x2=17.932 //y2=3.495
r352 (  21 23 ) resistor r=0.0698411 //w=0.17 //l=0.120208 //layer=m1 \
 //thickness=0.36 //x=17.795 //y=1.835 //x2=17.88 //y2=1.92
r353 (  21 22 ) resistor r=0.257634 //w=0.131 //l=0.27 //layer=m1 \
 //thickness=0.36 //x=17.795 //y=1.835 //x2=17.525 //y2=1.835
r354 (  20 42 ) resistor r=0.0257089 //w=0.23 //l=0.115 //layer=m1 \
 //thickness=0.36 //x=17.515 //y=5.38 //x2=17.4 //y2=5.38
r355 (  19 29 ) resistor r=0.0698411 //w=0.17 //l=0.120208 //layer=m1 \
 //thickness=0.36 //x=17.795 //y=5.38 //x2=17.88 //y2=5.295
r356 (  19 20 ) resistor r=0.267176 //w=0.131 //l=0.28 //layer=m1 \
 //thickness=0.36 //x=17.795 //y=5.38 //x2=17.515 //y2=5.38
r357 (  18 22 ) resistor r=0.0698411 //w=0.17 //l=0.120208 //layer=m1 \
 //thickness=0.36 //x=17.44 //y=1.75 //x2=17.525 //y2=1.835
r358 (  17 47 ) resistor r=0.0913624 //w=0.191 //l=0.12 //layer=m1 \
 //thickness=0.36 //x=17.44 //y=1.3 //x2=17.44 //y2=1.18
r359 (  17 18 ) resistor r=0.429389 //w=0.131 //l=0.45 //layer=m1 \
 //thickness=0.36 //x=17.44 //y=1.3 //x2=17.44 //y2=1.75
r360 (  14 39 ) resistor r=0.0227762 //w=0.219 //l=0.115 //layer=m1 \
 //thickness=0.36 //x=16.635 //y=5.38 //x2=16.52 //y2=5.38
r361 (  13 42 ) resistor r=0.0257089 //w=0.23 //l=0.115 //layer=m1 \
 //thickness=0.36 //x=17.285 //y=5.38 //x2=17.4 //y2=5.38
r362 (  13 14 ) resistor r=0.620229 //w=0.131 //l=0.65 //layer=m1 \
 //thickness=0.36 //x=17.285 //y=5.38 //x2=16.635 //y2=5.38
r363 (  10 36 ) resistor r=0.0861726 //w=0.376 //l=0.16944 //layer=m1 \
 //thickness=0.36 //x=19.677 //y=3.51 //x2=19.73 //y2=3.655
r364 (  10 54 ) resistor r=0.0049867 //w=0.376 //l=0.015 //layer=m1 \
 //thickness=0.36 //x=19.677 //y=3.51 //x2=19.677 //y2=3.495
r365 (  9 28 ) resistor r=0.0861726 //w=0.376 //l=0.169012 //layer=m1 \
 //thickness=0.36 //x=17.932 //y=3.51 //x2=17.88 //y2=3.655
r366 (  9 50 ) resistor r=0.0049867 //w=0.376 //l=0.015 //layer=m1 \
 //thickness=0.36 //x=17.932 //y=3.51 //x2=17.932 //y2=3.495
r367 (  8 62 ) resistor r=0.114504 //w=0.131 //l=0.12 //layer=m1 \
 //thickness=0.36 //x=19.73 //y=4.62 //x2=19.73 //y2=4.74
r368 (  8 36 ) resistor r=0.920802 //w=0.131 //l=0.965 //layer=m1 \
 //thickness=0.36 //x=19.73 //y=4.62 //x2=19.73 //y2=3.655
r369 (  7 33 ) resistor r=0.186069 //w=0.131 //l=0.195 //layer=m1 \
 //thickness=0.36 //x=19.73 //y=3.14 //x2=19.73 //y2=3.335
r370 (  6 7 ) resistor r=0.353053 //w=0.131 //l=0.37 //layer=m1 \
 //thickness=0.36 //x=19.73 //y=2.77 //x2=19.73 //y2=3.14
r371 (  6 32 ) resistor r=0.367366 //w=0.131 //l=0.385 //layer=m1 \
 //thickness=0.36 //x=19.73 //y=2.77 //x2=19.73 //y2=2.385
r372 (  5 29 ) resistor r=0.291031 //w=0.131 //l=0.305 //layer=m1 \
 //thickness=0.36 //x=17.88 //y=4.99 //x2=17.88 //y2=5.295
r373 (  4 5 ) resistor r=0.353053 //w=0.131 //l=0.37 //layer=m1 \
 //thickness=0.36 //x=17.88 //y=4.62 //x2=17.88 //y2=4.99
r374 (  4 28 ) resistor r=0.920802 //w=0.131 //l=0.965 //layer=m1 \
 //thickness=0.36 //x=17.88 //y=4.62 //x2=17.88 //y2=3.655
r375 (  3 24 ) resistor r=0.186069 //w=0.131 //l=0.195 //layer=m1 \
 //thickness=0.36 //x=17.88 //y=3.14 //x2=17.88 //y2=3.335
r376 (  2 3 ) resistor r=0.353053 //w=0.131 //l=0.37 //layer=m1 \
 //thickness=0.36 //x=17.88 //y=2.77 //x2=17.88 //y2=3.14
r377 (  1 2 ) resistor r=0.353053 //w=0.131 //l=0.37 //layer=m1 \
 //thickness=0.36 //x=17.88 //y=2.4 //x2=17.88 //y2=2.77
r378 (  1 23 ) resistor r=0.458015 //w=0.131 //l=0.48 //layer=m1 \
 //thickness=0.36 //x=17.88 //y=2.4 //x2=17.88 //y2=1.92
ends PM_DFFQNX1\%QN

subckt PM_DFFQNX1\%noxref_6 ( 1 2 3 4 6 7 8 11 16 17 19 20 22 23 24 26 27 28 \
 34 38 42 49 50 53 55 58 62 65 70 72 74 76 78 79 80 81 85 93 102 107 116 121 \
 129 146 155 159 160 161 162 163 164 165 166 167 168 169 170 171 172 174 180 \
 181 182 183 187 188 189 194 196 198 204 205 206 207 208 213 215 217 223 224 \
 234 235 238 247 248 251 259 261 262 )
c590 ( 259 0 ) capacitor c=0.00878249f //x=13.92 //y=1.085
c591 ( 251 0 ) capacitor c=0.0356006f //x=20.5 //y=4.88
c592 ( 248 0 ) capacitor c=0.0284095f //x=20.47 //y=2.095
c593 ( 247 0 ) capacitor c=0.0476356f //x=20.47 //y=2.26
c594 ( 238 0 ) capacitor c=0.0354915f //x=10.51 //y=4.88
c595 ( 235 0 ) capacitor c=0.0284095f //x=10.48 //y=2.095
c596 ( 234 0 ) capacitor c=0.0476356f //x=10.48 //y=2.26
c597 ( 224 0 ) capacitor c=0.0439708f //x=21.035 //y=1.43
c598 ( 223 0 ) capacitor c=0.0192582f //x=21.035 //y=1.085
c599 ( 217 0 ) capacitor c=0.0162526f //x=20.88 //y=1.585
c600 ( 215 0 ) capacitor c=0.0157807f //x=20.88 //y=0.93
c601 ( 213 0 ) capacitor c=0.035926f //x=20.875 //y=4.97
c602 ( 208 0 ) capacitor c=0.0210762f //x=20.505 //y=1.74
c603 ( 207 0 ) capacitor c=0.0168511f //x=20.505 //y=1.43
c604 ( 206 0 ) capacitor c=0.0175485f //x=20.505 //y=1.085
c605 ( 205 0 ) capacitor c=0.0439708f //x=11.045 //y=1.43
c606 ( 204 0 ) capacitor c=0.0192582f //x=11.045 //y=1.085
c607 ( 198 0 ) capacitor c=0.0162526f //x=10.89 //y=1.585
c608 ( 196 0 ) capacitor c=0.0157807f //x=10.89 //y=0.93
c609 ( 194 0 ) capacitor c=0.0372668f //x=10.885 //y=4.97
c610 ( 189 0 ) capacitor c=0.0210762f //x=10.515 //y=1.74
c611 ( 188 0 ) capacitor c=0.0168511f //x=10.515 //y=1.43
c612 ( 187 0 ) capacitor c=0.0175485f //x=10.515 //y=1.085
c613 ( 183 0 ) capacitor c=0.0551643f //x=1.875 //y=4.97
c614 ( 182 0 ) capacitor c=0.0376038f //x=2.165 //y=4.97
c615 ( 181 0 ) capacitor c=0.0346489f //x=1.83 //y=1.4
c616 ( 180 0 ) capacitor c=0.018692f //x=1.83 //y=1.055
c617 ( 174 0 ) capacitor c=0.0137077f //x=1.675 //y=1.555
c618 ( 172 0 ) capacitor c=0.0158585f //x=1.675 //y=0.9
c619 ( 171 0 ) capacitor c=0.103534f //x=1.3 //y=2.095
c620 ( 170 0 ) capacitor c=0.0229444f //x=1.3 //y=1.71
c621 ( 169 0 ) capacitor c=0.0234359f //x=1.3 //y=1.4
c622 ( 168 0 ) capacitor c=0.019815f //x=1.3 //y=1.055
c623 ( 167 0 ) capacitor c=0.155269f //x=20.95 //y=6.2
c624 ( 166 0 ) capacitor c=0.110375f //x=20.51 //y=6.2
c625 ( 165 0 ) capacitor c=0.155269f //x=10.96 //y=6.2
c626 ( 164 0 ) capacitor c=0.110375f //x=10.52 //y=6.2
c627 ( 163 0 ) capacitor c=0.110208f //x=2.24 //y=6.2
c628 ( 162 0 ) capacitor c=0.158957f //x=1.8 //y=6.2
c629 ( 155 0 ) capacitor c=5.80994e-19 //x=20.5 //y=4.88
c630 ( 146 0 ) capacitor c=5.78095e-19 //x=20.47 //y=2.26
c631 ( 129 0 ) capacitor c=0.0319332f //x=14.07 //y=5.56
c632 ( 121 0 ) capacitor c=0.0291719f //x=13.19 //y=5.56
c633 ( 116 0 ) capacitor c=5.80994e-19 //x=10.51 //y=4.88
c634 ( 107 0 ) capacitor c=5.78095e-19 //x=10.48 //y=2.26
c635 ( 102 0 ) capacitor c=0.0012433f //x=1.6 //y=4.88
c636 ( 93 0 ) capacitor c=0.0012618f //x=1.6 //y=2.26
c637 ( 85 0 ) capacitor c=0.0110688f //x=1.765 //y=4.255
c638 ( 81 0 ) capacitor c=0.0516669f //x=16.27 //y=4.27
c639 ( 80 0 ) capacitor c=0.107253f //x=16.615 //y=4.27
c640 ( 79 0 ) capacitor c=0.0371529f //x=10.645 //y=4.25
c641 ( 78 0 ) capacitor c=0.0401039f //x=14.38 //y=4.25
c642 ( 76 0 ) capacitor c=0.00148682f //x=6.62 //y=4.265
c643 ( 74 0 ) capacitor c=0.0158261f //x=6.02 //y=4.25
c644 ( 72 0 ) capacitor c=0.00410955f //x=4.775 //y=4.265
c645 ( 70 0 ) capacitor c=0.0805297f //x=4.175 //y=4.25
c646 ( 65 0 ) capacitor c=0.0066236f //x=20.47 //y=2.26
c647 ( 62 0 ) capacitor c=0.0141348f //x=20.47 //y=4.25
c648 ( 58 0 ) capacitor c=0.015184f //x=14.55 //y=4.25
c649 ( 55 0 ) capacitor c=0.0114498f //x=14.11 //y=1.18
c650 ( 53 0 ) capacitor c=5.78613e-19 //x=14.07 //y=5.56
c651 ( 50 0 ) capacitor c=0.0106343f //x=14.07 //y=5.38
c652 ( 49 0 ) capacitor c=0.00933207f //x=13.19 //y=5.56
c653 ( 42 0 ) capacitor c=0.00662515f //x=10.48 //y=2.26
c654 ( 38 0 ) capacitor c=0.0143744f //x=10.48 //y=4.25
c655 ( 34 0 ) capacitor c=0.0160407f //x=1.6 //y=4.25
c656 ( 28 0 ) capacitor c=0.00985447f //x=20.47 //y=4.735
c657 ( 27 0 ) capacitor c=0.0096151f //x=20.47 //y=4.41
c658 ( 26 0 ) capacitor c=0.0378391f //x=20.47 //y=4.09
c659 ( 24 0 ) capacitor c=0.0186555f //x=14.55 //y=5.295
c660 ( 23 0 ) capacitor c=0.0128691f //x=14.55 //y=4.425
c661 ( 22 0 ) capacitor c=0.0617041f //x=14.55 //y=4.105
c662 ( 20 0 ) capacitor c=0.00671966f //x=14.195 //y=1.835
c663 ( 19 0 ) capacitor c=0.0142356f //x=14.465 //y=1.835
c664 ( 17 0 ) capacitor c=0.0102685f //x=14.465 //y=5.38
c665 ( 16 0 ) capacitor c=0.0101547f //x=14.11 //y=1.75
c666 ( 11 0 ) capacitor c=0.0142466f //x=13.955 //y=5.38
c667 ( 8 0 ) capacitor c=0.00908133f //x=10.48 //y=4.735
c668 ( 7 0 ) capacitor c=0.00971944f //x=10.48 //y=4.415
c669 ( 6 0 ) capacitor c=0.0367292f //x=10.48 //y=4.095
c670 ( 4 0 ) capacitor c=0.0228118f //x=1.6 //y=4.755
c671 ( 3 0 ) capacitor c=0.0128906f //x=1.6 //y=4.415
c672 ( 2 0 ) capacitor c=0.0862595f //x=1.6 //y=4.095
c673 ( 1 0 ) capacitor c=0.0113406f //x=1.6 //y=2.375
r674 (  253 254 ) resistor r=32.4568 //w=0.214 //l=0.075 //layer=ply \
 //thickness=0.18 //x=20.5 //y=4.97 //x2=20.5 //y2=5.045
r675 (  251 253 ) resistor r=20.271 //w=0.214 //l=0.09 //layer=ply \
 //thickness=0.18 //x=20.5 //y=4.88 //x2=20.5 //y2=4.97
r676 (  247 248 ) resistor r=52.7279 //w=0.214 //l=0.165 //layer=ply \
 //thickness=0.18 //x=20.47 //y=2.26 //x2=20.47 //y2=2.095
r677 (  240 241 ) resistor r=32.4568 //w=0.214 //l=0.075 //layer=ply \
 //thickness=0.18 //x=10.51 //y=4.97 //x2=10.51 //y2=5.045
r678 (  238 240 ) resistor r=20.271 //w=0.214 //l=0.09 //layer=ply \
 //thickness=0.18 //x=10.51 //y=4.88 //x2=10.51 //y2=4.97
r679 (  234 235 ) resistor r=52.7279 //w=0.214 //l=0.165 //layer=ply \
 //thickness=0.18 //x=10.48 //y=2.26 //x2=10.48 //y2=2.095
r680 (  224 258 ) resistor r=45.1352 //w=0.168 //l=0.173853 //layer=ply \
 //thickness=0.18 //x=21.035 //y=1.43 //x2=20.995 //y2=1.585
r681 (  223 257 ) resistor r=45.1352 //w=0.168 //l=0.173853 //layer=ply \
 //thickness=0.18 //x=21.035 //y=1.085 //x2=20.995 //y2=0.93
r682 (  223 224 ) resistor r=176.904 //w=0.094 //l=0.345 //layer=ply \
 //thickness=0.18 //x=21.035 //y=1.085 //x2=21.035 //y2=1.43
r683 (  218 256 ) resistor r=10.701 //w=0.21 //l=0.115 //layer=ply \
 //thickness=0.18 //x=20.66 //y=1.585 //x2=20.545 //y2=1.585
r684 (  217 258 ) resistor r=5.52526 //w=0.168 //l=0.115 //layer=ply \
 //thickness=0.18 //x=20.88 //y=1.585 //x2=20.995 //y2=1.585
r685 (  216 255 ) resistor r=5.52526 //w=0.168 //l=0.115 //layer=ply \
 //thickness=0.18 //x=20.66 //y=0.93 //x2=20.545 //y2=0.93
r686 (  215 257 ) resistor r=5.52526 //w=0.168 //l=0.115 //layer=ply \
 //thickness=0.18 //x=20.88 //y=0.93 //x2=20.995 //y2=0.93
r687 (  215 216 ) resistor r=112.809 //w=0.094 //l=0.22 //layer=ply \
 //thickness=0.18 //x=20.88 //y=0.93 //x2=20.66 //y2=0.93
r688 (  214 253 ) resistor r=16.5046 //w=0.27 //l=0.135 //layer=ply \
 //thickness=0.18 //x=20.635 //y=4.97 //x2=20.5 //y2=4.97
r689 (  213 220 ) resistor r=26.9307 //w=0.15 //l=0.106066 //layer=ply \
 //thickness=0.18 //x=20.875 //y=4.97 //x2=20.95 //y2=5.045
r690 (  213 214 ) resistor r=123.064 //w=0.094 //l=0.24 //layer=ply \
 //thickness=0.18 //x=20.875 //y=4.97 //x2=20.635 //y2=4.97
r691 (  208 256 ) resistor r=39.5823 //w=0.21 //l=0.173853 //layer=ply \
 //thickness=0.18 //x=20.505 //y=1.74 //x2=20.545 //y2=1.585
r692 (  208 248 ) resistor r=182.032 //w=0.094 //l=0.355 //layer=ply \
 //thickness=0.18 //x=20.505 //y=1.74 //x2=20.505 //y2=2.095
r693 (  207 256 ) resistor r=39.5823 //w=0.21 //l=0.173853 //layer=ply \
 //thickness=0.18 //x=20.505 //y=1.43 //x2=20.545 //y2=1.585
r694 (  206 255 ) resistor r=45.1352 //w=0.168 //l=0.173853 //layer=ply \
 //thickness=0.18 //x=20.505 //y=1.085 //x2=20.545 //y2=0.93
r695 (  206 207 ) resistor r=176.904 //w=0.094 //l=0.345 //layer=ply \
 //thickness=0.18 //x=20.505 //y=1.085 //x2=20.505 //y2=1.43
r696 (  205 245 ) resistor r=45.1352 //w=0.168 //l=0.173853 //layer=ply \
 //thickness=0.18 //x=11.045 //y=1.43 //x2=11.005 //y2=1.585
r697 (  204 244 ) resistor r=45.1352 //w=0.168 //l=0.173853 //layer=ply \
 //thickness=0.18 //x=11.045 //y=1.085 //x2=11.005 //y2=0.93
r698 (  204 205 ) resistor r=176.904 //w=0.094 //l=0.345 //layer=ply \
 //thickness=0.18 //x=11.045 //y=1.085 //x2=11.045 //y2=1.43
r699 (  199 243 ) resistor r=10.701 //w=0.21 //l=0.115 //layer=ply \
 //thickness=0.18 //x=10.67 //y=1.585 //x2=10.555 //y2=1.585
r700 (  198 245 ) resistor r=5.52526 //w=0.168 //l=0.115 //layer=ply \
 //thickness=0.18 //x=10.89 //y=1.585 //x2=11.005 //y2=1.585
r701 (  197 242 ) resistor r=5.52526 //w=0.168 //l=0.115 //layer=ply \
 //thickness=0.18 //x=10.67 //y=0.93 //x2=10.555 //y2=0.93
r702 (  196 244 ) resistor r=5.52526 //w=0.168 //l=0.115 //layer=ply \
 //thickness=0.18 //x=10.89 //y=0.93 //x2=11.005 //y2=0.93
r703 (  196 197 ) resistor r=112.809 //w=0.094 //l=0.22 //layer=ply \
 //thickness=0.18 //x=10.89 //y=0.93 //x2=10.67 //y2=0.93
r704 (  195 240 ) resistor r=16.5046 //w=0.27 //l=0.135 //layer=ply \
 //thickness=0.18 //x=10.645 //y=4.97 //x2=10.51 //y2=4.97
r705 (  194 201 ) resistor r=26.9307 //w=0.15 //l=0.106066 //layer=ply \
 //thickness=0.18 //x=10.885 //y=4.97 //x2=10.96 //y2=5.045
r706 (  194 195 ) resistor r=123.064 //w=0.094 //l=0.24 //layer=ply \
 //thickness=0.18 //x=10.885 //y=4.97 //x2=10.645 //y2=4.97
r707 (  189 243 ) resistor r=39.5823 //w=0.21 //l=0.173853 //layer=ply \
 //thickness=0.18 //x=10.515 //y=1.74 //x2=10.555 //y2=1.585
r708 (  189 235 ) resistor r=182.032 //w=0.094 //l=0.355 //layer=ply \
 //thickness=0.18 //x=10.515 //y=1.74 //x2=10.515 //y2=2.095
r709 (  188 243 ) resistor r=39.5823 //w=0.21 //l=0.173853 //layer=ply \
 //thickness=0.18 //x=10.515 //y=1.43 //x2=10.555 //y2=1.585
r710 (  187 242 ) resistor r=45.1352 //w=0.168 //l=0.173853 //layer=ply \
 //thickness=0.18 //x=10.515 //y=1.085 //x2=10.555 //y2=0.93
r711 (  187 188 ) resistor r=176.904 //w=0.094 //l=0.345 //layer=ply \
 //thickness=0.18 //x=10.515 //y=1.085 //x2=10.515 //y2=1.43
r712 (  182 184 ) resistor r=26.9307 //w=0.15 //l=0.106066 //layer=ply \
 //thickness=0.18 //x=2.165 //y=4.97 //x2=2.24 //y2=5.045
r713 (  182 183 ) resistor r=148.702 //w=0.094 //l=0.29 //layer=ply \
 //thickness=0.18 //x=2.165 //y=4.97 //x2=1.875 //y2=4.97
r714 (  181 232 ) resistor r=45.1352 //w=0.168 //l=0.173853 //layer=ply \
 //thickness=0.18 //x=1.83 //y=1.4 //x2=1.79 //y2=1.555
r715 (  180 231 ) resistor r=45.1352 //w=0.168 //l=0.173853 //layer=ply \
 //thickness=0.18 //x=1.83 //y=1.055 //x2=1.79 //y2=0.9
r716 (  180 181 ) resistor r=176.904 //w=0.094 //l=0.345 //layer=ply \
 //thickness=0.18 //x=1.83 //y=1.055 //x2=1.83 //y2=1.4
r717 (  177 183 ) resistor r=22.7971 //w=0.269 //l=0.106066 //layer=ply \
 //thickness=0.18 //x=1.8 //y=5.045 //x2=1.875 //y2=4.97
r718 (  177 230 ) resistor r=35.8364 //w=0.269 //l=0.270185 //layer=ply \
 //thickness=0.18 //x=1.8 //y=5.045 //x2=1.6 //y2=4.88
r719 (  175 226 ) resistor r=10.701 //w=0.21 //l=0.115 //layer=ply \
 //thickness=0.18 //x=1.455 //y=1.555 //x2=1.34 //y2=1.555
r720 (  174 232 ) resistor r=5.52526 //w=0.168 //l=0.115 //layer=ply \
 //thickness=0.18 //x=1.675 //y=1.555 //x2=1.79 //y2=1.555
r721 (  173 225 ) resistor r=5.52526 //w=0.168 //l=0.115 //layer=ply \
 //thickness=0.18 //x=1.455 //y=0.9 //x2=1.34 //y2=0.9
r722 (  172 231 ) resistor r=5.52526 //w=0.168 //l=0.115 //layer=ply \
 //thickness=0.18 //x=1.675 //y=0.9 //x2=1.79 //y2=0.9
r723 (  172 173 ) resistor r=112.809 //w=0.094 //l=0.22 //layer=ply \
 //thickness=0.18 //x=1.675 //y=0.9 //x2=1.455 //y2=0.9
r724 (  171 228 ) resistor r=58.7805 //w=0.246 //l=0.373497 //layer=ply \
 //thickness=0.18 //x=1.3 //y=2.095 //x2=1.6 //y2=2.26
r725 (  170 226 ) resistor r=39.5823 //w=0.21 //l=0.173853 //layer=ply \
 //thickness=0.18 //x=1.3 //y=1.71 //x2=1.34 //y2=1.555
r726 (  170 171 ) resistor r=197.415 //w=0.094 //l=0.385 //layer=ply \
 //thickness=0.18 //x=1.3 //y=1.71 //x2=1.3 //y2=2.095
r727 (  169 226 ) resistor r=39.5823 //w=0.21 //l=0.173853 //layer=ply \
 //thickness=0.18 //x=1.3 //y=1.4 //x2=1.34 //y2=1.555
r728 (  168 225 ) resistor r=45.1352 //w=0.168 //l=0.173853 //layer=ply \
 //thickness=0.18 //x=1.3 //y=1.055 //x2=1.34 //y2=0.9
r729 (  168 169 ) resistor r=176.904 //w=0.094 //l=0.345 //layer=ply \
 //thickness=0.18 //x=1.3 //y=1.055 //x2=1.3 //y2=1.4
r730 (  167 220 ) resistor r=592.245 //w=0.094 //l=1.155 //layer=ply \
 //thickness=0.18 //x=20.95 //y=6.2 //x2=20.95 //y2=5.045
r731 (  166 254 ) resistor r=592.245 //w=0.094 //l=1.155 //layer=ply \
 //thickness=0.18 //x=20.51 //y=6.2 //x2=20.51 //y2=5.045
r732 (  165 201 ) resistor r=592.245 //w=0.094 //l=1.155 //layer=ply \
 //thickness=0.18 //x=10.96 //y=6.2 //x2=10.96 //y2=5.045
r733 (  164 241 ) resistor r=592.245 //w=0.094 //l=1.155 //layer=ply \
 //thickness=0.18 //x=10.52 //y=6.2 //x2=10.52 //y2=5.045
r734 (  163 184 ) resistor r=592.245 //w=0.094 //l=1.155 //layer=ply \
 //thickness=0.18 //x=2.24 //y=6.2 //x2=2.24 //y2=5.045
r735 (  162 177 ) resistor r=592.245 //w=0.094 //l=1.155 //layer=ply \
 //thickness=0.18 //x=1.8 //y=6.2 //x2=1.8 //y2=5.045
r736 (  161 217 ) resistor r=56.4043 //w=0.094 //l=0.11 //layer=ply \
 //thickness=0.18 //x=20.77 //y=1.585 //x2=20.88 //y2=1.585
r737 (  161 218 ) resistor r=56.4043 //w=0.094 //l=0.11 //layer=ply \
 //thickness=0.18 //x=20.77 //y=1.585 //x2=20.66 //y2=1.585
r738 (  160 198 ) resistor r=56.4043 //w=0.094 //l=0.11 //layer=ply \
 //thickness=0.18 //x=10.78 //y=1.585 //x2=10.89 //y2=1.585
r739 (  160 199 ) resistor r=56.4043 //w=0.094 //l=0.11 //layer=ply \
 //thickness=0.18 //x=10.78 //y=1.585 //x2=10.67 //y2=1.585
r740 (  159 174 ) resistor r=56.4043 //w=0.094 //l=0.11 //layer=ply \
 //thickness=0.18 //x=1.565 //y=1.555 //x2=1.675 //y2=1.555
r741 (  159 175 ) resistor r=56.4043 //w=0.094 //l=0.11 //layer=ply \
 //thickness=0.18 //x=1.565 //y=1.555 //x2=1.455 //y2=1.555
r742 (  155 251 ) resistor r=152 //w=0.17 //l=0.17 //layer=licon //count=1 \
 //x=20.5 //y=4.88 //x2=20.5 //y2=4.88
r743 (  146 247 ) resistor r=152 //w=0.17 //l=0.17 //layer=licon //count=1 \
 //x=20.47 //y=2.26 //x2=20.47 //y2=2.26
r744 (  129 262 ) resistor r=23.615 //w=0.187 //l=0.345 //layer=li \
 //thickness=0.1 //x=14.07 //y=5.56 //x2=14.07 //y2=5.905
r745 (  121 261 ) resistor r=23.615 //w=0.187 //l=0.345 //layer=li \
 //thickness=0.1 //x=13.19 //y=5.56 //x2=13.19 //y2=5.905
r746 (  116 238 ) resistor r=152 //w=0.17 //l=0.17 //layer=licon //count=1 \
 //x=10.51 //y=4.88 //x2=10.51 //y2=4.88
r747 (  107 234 ) resistor r=152 //w=0.17 //l=0.17 //layer=licon //count=1 \
 //x=10.48 //y=2.26 //x2=10.48 //y2=2.26
r748 (  102 230 ) resistor r=152 //w=0.17 //l=0.17 //layer=licon //count=1 \
 //x=1.6 //y=4.88 //x2=1.6 //y2=4.88
r749 (  93 228 ) resistor r=152 //w=0.17 //l=0.17 //layer=licon //count=1 \
 //x=1.6 //y=2.26 //x2=1.6 //y2=2.26
r750 (  83 85 ) resistor r=0.10734 //w=0.281 //l=0.16 //layer=m2 \
 //thickness=0.36 //x=1.605 //y=4.255 //x2=1.765 //y2=4.255
r751 (  81 89 ) resistor r=1.10585 //w=0.196 //l=1.7325 //layer=m2 \
 //thickness=0.36 //x=16.27 //y=4.27 //x2=14.54 //y2=4.265
r752 (  80 91 ) resistor r=2.64838 //w=0.182 //l=3.86499 //layer=m2 \
 //thickness=0.36 //x=16.615 //y=4.27 //x2=20.47 //y2=4.25
r753 (  80 81 ) resistor r=0.329198 //w=0.131 //l=0.345 //layer=m2 \
 //thickness=0.36 //x=16.615 //y=4.27 //x2=16.27 //y2=4.27
r754 (  79 87 ) resistor r=0.110608 //w=0.182 //l=0.162481 //layer=m2 \
 //thickness=0.36 //x=10.645 //y=4.25 //x2=10.485 //y2=4.255
r755 (  78 89 ) resistor r=0.104578 //w=0.196 //l=0.167332 //layer=m2 \
 //thickness=0.36 //x=14.38 //y=4.25 //x2=14.54 //y2=4.265
r756 (  78 79 ) resistor r=3.56393 //w=0.131 //l=3.735 //layer=m2 \
 //thickness=0.36 //x=14.38 //y=4.25 //x2=10.645 //y2=4.25
r757 (  76 87 ) resistor r=2.65525 //w=0.182 //l=3.87 //layer=m2 \
 //thickness=0.36 //x=6.62 //y=4.265 //x2=10.485 //y2=4.255
r758 (  76 77 ) resistor r=0.329198 //w=0.131 //l=0.345 //layer=m2 \
 //thickness=0.36 //x=6.62 //y=4.265 //x2=6.275 //y2=4.265
r759 (  74 77 ) resistor r=0.1875 //w=0.17 //l=0.262393 //layer=m2 \
 //thickness=0.36 //x=6.02 //y=4.25 //x2=6.275 //y2=4.265
r760 (  74 75 ) resistor r=1.02576 //w=0.131 //l=1.075 //layer=m2 \
 //thickness=0.36 //x=6.02 //y=4.25 //x2=4.945 //y2=4.25
r761 (  72 75 ) resistor r=0.125 //w=0.17 //l=0.177341 //layer=m2 \
 //thickness=0.36 //x=4.775 //y=4.265 //x2=4.945 //y2=4.25
r762 (  72 73 ) resistor r=0.329198 //w=0.131 //l=0.345 //layer=m2 \
 //thickness=0.36 //x=4.775 //y=4.265 //x2=4.43 //y2=4.265
r763 (  70 73 ) resistor r=0.1875 //w=0.17 //l=0.262393 //layer=m2 \
 //thickness=0.36 //x=4.175 //y=4.25 //x2=4.43 //y2=4.265
r764 (  70 85 ) resistor r=2.29962 //w=0.131 //l=2.41 //layer=m2 \
 //thickness=0.36 //x=4.175 //y=4.25 //x2=1.765 //y2=4.25
r765 (  69 155 ) resistor r=9.3 //w=0.17 //l=0.17 //layer=mcon //count=1 \
 //x=20.5 //y=4.88 //x2=20.5 //y2=4.88
r766 (  65 146 ) resistor r=9.3 //w=0.17 //l=0.17 //layer=mcon //count=1 \
 //x=20.47 //y=2.26 //x2=20.47 //y2=2.26
r767 (  65 67 ) resistor r=0.0936408 //w=0.196 //l=0.125 //layer=m1 \
 //thickness=0.36 //x=20.472 //y=2.26 //x2=20.472 //y2=2.385
r768 (  62 91 ) resistor r=4.5 //w=0.15 //l=0.15 //layer=via1 //count=1 \
 //x=20.47 //y=4.25 //x2=20.47 //y2=4.25
r769 (  60 89 ) resistor r=4.5 //w=0.15 //l=0.15 //layer=via1 //count=1 \
 //x=14.54 //y=4.265 //x2=14.54 //y2=4.265
r770 (  58 60 ) resistor r=0.00505391 //w=0.371 //l=0.015 //layer=m1 \
 //thickness=0.36 //x=14.492 //y=4.25 //x2=14.492 //y2=4.265
r771 (  55 259 ) resistor r=9.3 //w=0.17 //l=0.17 //layer=mcon //count=1 \
 //x=14.11 //y=1.18 //x2=14.11 //y2=1.18
r772 (  53 129 ) resistor r=9.3 //w=0.17 //l=0.17 //layer=mcon //count=1 \
 //x=14.07 //y=5.56 //x2=14.07 //y2=5.56
r773 (  50 53 ) resistor r=0.117801 //w=0.191 //l=0.18 //layer=m1 \
 //thickness=0.36 //x=14.07 //y=5.38 //x2=14.07 //y2=5.56
r774 (  49 121 ) resistor r=9.3 //w=0.17 //l=0.17 //layer=mcon //count=1 \
 //x=13.19 //y=5.56 //x2=13.19 //y2=5.56
r775 (  47 49 ) resistor r=0.10274 //w=0.219 //l=0.18 //layer=m1 \
 //thickness=0.36 //x=13.19 //y=5.38 //x2=13.19 //y2=5.56
r776 (  46 116 ) resistor r=9.3 //w=0.17 //l=0.17 //layer=mcon //count=1 \
 //x=10.51 //y=4.88 //x2=10.51 //y2=4.88
r777 (  42 107 ) resistor r=9.3 //w=0.17 //l=0.17 //layer=mcon //count=1 \
 //x=10.48 //y=2.26 //x2=10.48 //y2=2.26
r778 (  42 44 ) resistor r=0.0936408 //w=0.196 //l=0.125 //layer=m1 \
 //thickness=0.36 //x=10.482 //y=2.26 //x2=10.482 //y2=2.385
r779 (  40 87 ) resistor r=4.5 //w=0.15 //l=0.15 //layer=via1 //count=1 \
 //x=10.485 //y=4.255 //x2=10.485 //y2=4.255
r780 (  38 40 ) resistor r=0.00164908 //w=0.379 //l=0.005 //layer=m1 \
 //thickness=0.36 //x=10.43 //y=4.25 //x2=10.43 //y2=4.255
r781 (  36 83 ) resistor r=4.5 //w=0.15 //l=0.15 //layer=via1 //count=1 \
 //x=1.605 //y=4.255 //x2=1.605 //y2=4.255
r782 (  34 36 ) resistor r=0.00167112 //w=0.374 //l=0.005 //layer=m1 \
 //thickness=0.36 //x=1.655 //y=4.25 //x2=1.655 //y2=4.255
r783 (  32 102 ) resistor r=9.3 //w=0.17 //l=0.17 //layer=mcon //count=1 \
 //x=1.6 //y=4.88 //x2=1.6 //y2=4.88
r784 (  30 93 ) resistor r=9.3 //w=0.17 //l=0.17 //layer=mcon //count=1 \
 //x=1.6 //y=2.26 //x2=1.6 //y2=2.26
r785 (  28 69 ) resistor r=0.0878548 //w=0.228 //l=0.159295 //layer=m1 \
 //thickness=0.36 //x=20.47 //y=4.735 //x2=20.5 //y2=4.88
r786 (  27 62 ) resistor r=0.0911593 //w=0.376 //l=0.184608 //layer=m1 \
 //thickness=0.36 //x=20.47 //y=4.41 //x2=20.417 //y2=4.25
r787 (  27 28 ) resistor r=0.310115 //w=0.131 //l=0.325 //layer=m1 \
 //thickness=0.36 //x=20.47 //y=4.41 //x2=20.47 //y2=4.735
r788 (  26 62 ) resistor r=0.0911593 //w=0.376 //l=0.184608 //layer=m1 \
 //thickness=0.36 //x=20.47 //y=4.09 //x2=20.417 //y2=4.25
r789 (  26 67 ) resistor r=1.62691 //w=0.131 //l=1.705 //layer=m1 \
 //thickness=0.36 //x=20.47 //y=4.09 //x2=20.47 //y2=2.385
r790 (  23 60 ) resistor r=0.0909648 //w=0.371 //l=0.186762 //layer=m1 \
 //thickness=0.36 //x=14.55 //y=4.425 //x2=14.492 //y2=4.265
r791 (  23 24 ) resistor r=0.830153 //w=0.131 //l=0.87 //layer=m1 \
 //thickness=0.36 //x=14.55 //y=4.425 //x2=14.55 //y2=5.295
r792 (  22 58 ) resistor r=0.0859108 //w=0.371 //l=0.171566 //layer=m1 \
 //thickness=0.36 //x=14.55 //y=4.105 //x2=14.492 //y2=4.25
r793 (  21 22 ) resistor r=2.08492 //w=0.131 //l=2.185 //layer=m1 \
 //thickness=0.36 //x=14.55 //y=1.92 //x2=14.55 //y2=4.105
r794 (  19 21 ) resistor r=0.0698411 //w=0.17 //l=0.120208 //layer=m1 \
 //thickness=0.36 //x=14.465 //y=1.835 //x2=14.55 //y2=1.92
r795 (  19 20 ) resistor r=0.257634 //w=0.131 //l=0.27 //layer=m1 \
 //thickness=0.36 //x=14.465 //y=1.835 //x2=14.195 //y2=1.835
r796 (  18 50 ) resistor r=0.0257089 //w=0.23 //l=0.115 //layer=m1 \
 //thickness=0.36 //x=14.185 //y=5.38 //x2=14.07 //y2=5.38
r797 (  17 24 ) resistor r=0.0698411 //w=0.17 //l=0.120208 //layer=m1 \
 //thickness=0.36 //x=14.465 //y=5.38 //x2=14.55 //y2=5.295
r798 (  17 18 ) resistor r=0.267176 //w=0.131 //l=0.28 //layer=m1 \
 //thickness=0.36 //x=14.465 //y=5.38 //x2=14.185 //y2=5.38
r799 (  16 20 ) resistor r=0.0698411 //w=0.17 //l=0.120208 //layer=m1 \
 //thickness=0.36 //x=14.11 //y=1.75 //x2=14.195 //y2=1.835
r800 (  15 55 ) resistor r=0.0913624 //w=0.191 //l=0.12 //layer=m1 \
 //thickness=0.36 //x=14.11 //y=1.3 //x2=14.11 //y2=1.18
r801 (  15 16 ) resistor r=0.429389 //w=0.131 //l=0.45 //layer=m1 \
 //thickness=0.36 //x=14.11 //y=1.3 //x2=14.11 //y2=1.75
r802 (  12 47 ) resistor r=0.0227762 //w=0.219 //l=0.115 //layer=m1 \
 //thickness=0.36 //x=13.305 //y=5.38 //x2=13.19 //y2=5.38
r803 (  11 50 ) resistor r=0.0257089 //w=0.23 //l=0.115 //layer=m1 \
 //thickness=0.36 //x=13.955 //y=5.38 //x2=14.07 //y2=5.38
r804 (  11 12 ) resistor r=0.620229 //w=0.131 //l=0.65 //layer=m1 \
 //thickness=0.36 //x=13.955 //y=5.38 //x2=13.305 //y2=5.38
r805 (  8 46 ) resistor r=0.0878548 //w=0.228 //l=0.159295 //layer=m1 \
 //thickness=0.36 //x=10.48 //y=4.735 //x2=10.51 //y2=4.88
r806 (  7 40 ) resistor r=0.0912814 //w=0.379 //l=0.183303 //layer=m1 \
 //thickness=0.36 //x=10.48 //y=4.415 //x2=10.43 //y2=4.255
r807 (  7 8 ) resistor r=0.305344 //w=0.131 //l=0.32 //layer=m1 \
 //thickness=0.36 //x=10.48 //y=4.415 //x2=10.48 //y2=4.735
r808 (  6 38 ) resistor r=0.0896323 //w=0.379 //l=0.178255 //layer=m1 \
 //thickness=0.36 //x=10.48 //y=4.095 //x2=10.43 //y2=4.25
r809 (  6 44 ) resistor r=1.63168 //w=0.131 //l=1.71 //layer=m1 \
 //thickness=0.36 //x=10.48 //y=4.095 //x2=10.48 //y2=2.385
r810 (  4 32 ) resistor r=0.0760407 //w=0.238 //l=0.125 //layer=m1 \
 //thickness=0.36 //x=1.6 //y=4.755 //x2=1.6 //y2=4.88
r811 (  3 36 ) resistor r=0.0910802 //w=0.374 //l=0.185472 //layer=m1 \
 //thickness=0.36 //x=1.6 //y=4.415 //x2=1.655 //y2=4.255
r812 (  3 4 ) resistor r=0.324427 //w=0.131 //l=0.34 //layer=m1 \
 //thickness=0.36 //x=1.6 //y=4.415 //x2=1.6 //y2=4.755
r813 (  2 34 ) resistor r=0.089409 //w=0.374 //l=0.180416 //layer=m1 \
 //thickness=0.36 //x=1.6 //y=4.095 //x2=1.655 //y2=4.25
r814 (  1 30 ) resistor r=0.0719237 //w=0.222 //l=0.115 //layer=m1 \
 //thickness=0.36 //x=1.6 //y=2.375 //x2=1.6 //y2=2.26
r815 (  1 2 ) resistor r=1.64122 //w=0.131 //l=1.72 //layer=m1 \
 //thickness=0.36 //x=1.6 //y=2.375 //x2=1.6 //y2=4.095
ends PM_DFFQNX1\%noxref_6

subckt PM_DFFQNX1\%noxref_7 ( 2 3 4 7 12 13 15 16 18 19 20 22 30 33 34 37 39 \
 44 45 47 52 56 65 70 78 94 95 96 97 98 99 104 106 108 114 115 117 118 121 129 \
 131 132 )
c273 ( 129 0 ) capacitor c=0.00878249f //x=20.58 //y=1.085
c274 ( 121 0 ) capacitor c=0.036522f //x=17.17 //y=4.88
c275 ( 118 0 ) capacitor c=0.0284095f //x=17.14 //y=2.095
c276 ( 117 0 ) capacitor c=0.0476356f //x=17.14 //y=2.26
c277 ( 115 0 ) capacitor c=0.0439708f //x=17.705 //y=1.43
c278 ( 114 0 ) capacitor c=0.0192582f //x=17.705 //y=1.085
c279 ( 108 0 ) capacitor c=0.0162526f //x=17.55 //y=1.585
c280 ( 106 0 ) capacitor c=0.0157807f //x=17.55 //y=0.93
c281 ( 104 0 ) capacitor c=0.0359568f //x=17.545 //y=4.97
c282 ( 99 0 ) capacitor c=0.0210762f //x=17.175 //y=1.74
c283 ( 98 0 ) capacitor c=0.0168511f //x=17.175 //y=1.43
c284 ( 97 0 ) capacitor c=0.0175485f //x=17.175 //y=1.085
c285 ( 96 0 ) capacitor c=0.155269f //x=17.62 //y=6.2
c286 ( 95 0 ) capacitor c=0.110375f //x=17.18 //y=6.2
c287 ( 78 0 ) capacitor c=0.0322017f //x=20.73 //y=5.56
c288 ( 70 0 ) capacitor c=0.0291919f //x=19.85 //y=5.56
c289 ( 65 0 ) capacitor c=8.90417e-19 //x=17.17 //y=4.88
c290 ( 56 0 ) capacitor c=5.78095e-19 //x=17.14 //y=2.26
c291 ( 52 0 ) capacitor c=0.00315392f //x=17.3 //y=3.865
c292 ( 47 0 ) capacitor c=0.0323493f //x=20.685 //y=3.865
c293 ( 45 0 ) capacitor c=0.0410441f //x=20.085 //y=3.88
c294 ( 44 0 ) capacitor c=0.0184327f //x=21.21 //y=3.88
c295 ( 39 0 ) capacitor c=0.014893f //x=20.77 //y=1.18
c296 ( 37 0 ) capacitor c=5.78613e-19 //x=20.73 //y=5.56
c297 ( 34 0 ) capacitor c=0.014706f //x=20.73 //y=5.38
c298 ( 33 0 ) capacitor c=0.00914121f //x=19.85 //y=5.56
c299 ( 30 0 ) capacitor c=0.0139575f //x=17.14 //y=3.88
c300 ( 22 0 ) capacitor c=0.00650008f //x=17.14 //y=2.26
c301 ( 20 0 ) capacitor c=0.0437522f //x=21.21 //y=5.295
c302 ( 19 0 ) capacitor c=0.0129865f //x=21.21 //y=4.025
c303 ( 18 0 ) capacitor c=0.0733744f //x=21.21 //y=3.705
c304 ( 16 0 ) capacitor c=0.00671677f //x=20.855 //y=1.835
c305 ( 15 0 ) capacitor c=0.0151185f //x=21.125 //y=1.835
c306 ( 13 0 ) capacitor c=0.0125962f //x=21.125 //y=5.38
c307 ( 12 0 ) capacitor c=0.0133876f //x=20.77 //y=1.75
c308 ( 7 0 ) capacitor c=0.0136628f //x=20.615 //y=5.38
c309 ( 4 0 ) capacitor c=0.0182022f //x=17.14 //y=4.735
c310 ( 3 0 ) capacitor c=0.00981483f //x=17.14 //y=4.025
c311 ( 2 0 ) capacitor c=0.0306875f //x=17.14 //y=3.705
r312 (  123 124 ) resistor r=32.4568 //w=0.214 //l=0.075 //layer=ply \
 //thickness=0.18 //x=17.17 //y=4.97 //x2=17.17 //y2=5.045
r313 (  121 123 ) resistor r=20.271 //w=0.214 //l=0.09 //layer=ply \
 //thickness=0.18 //x=17.17 //y=4.88 //x2=17.17 //y2=4.97
r314 (  117 118 ) resistor r=52.7279 //w=0.214 //l=0.165 //layer=ply \
 //thickness=0.18 //x=17.14 //y=2.26 //x2=17.14 //y2=2.095
r315 (  115 128 ) resistor r=45.1352 //w=0.168 //l=0.173853 //layer=ply \
 //thickness=0.18 //x=17.705 //y=1.43 //x2=17.665 //y2=1.585
r316 (  114 127 ) resistor r=45.1352 //w=0.168 //l=0.173853 //layer=ply \
 //thickness=0.18 //x=17.705 //y=1.085 //x2=17.665 //y2=0.93
r317 (  114 115 ) resistor r=176.904 //w=0.094 //l=0.345 //layer=ply \
 //thickness=0.18 //x=17.705 //y=1.085 //x2=17.705 //y2=1.43
r318 (  109 126 ) resistor r=10.701 //w=0.21 //l=0.115 //layer=ply \
 //thickness=0.18 //x=17.33 //y=1.585 //x2=17.215 //y2=1.585
r319 (  108 128 ) resistor r=5.52526 //w=0.168 //l=0.115 //layer=ply \
 //thickness=0.18 //x=17.55 //y=1.585 //x2=17.665 //y2=1.585
r320 (  107 125 ) resistor r=5.52526 //w=0.168 //l=0.115 //layer=ply \
 //thickness=0.18 //x=17.33 //y=0.93 //x2=17.215 //y2=0.93
r321 (  106 127 ) resistor r=5.52526 //w=0.168 //l=0.115 //layer=ply \
 //thickness=0.18 //x=17.55 //y=0.93 //x2=17.665 //y2=0.93
r322 (  106 107 ) resistor r=112.809 //w=0.094 //l=0.22 //layer=ply \
 //thickness=0.18 //x=17.55 //y=0.93 //x2=17.33 //y2=0.93
r323 (  105 123 ) resistor r=16.5046 //w=0.27 //l=0.135 //layer=ply \
 //thickness=0.18 //x=17.305 //y=4.97 //x2=17.17 //y2=4.97
r324 (  104 111 ) resistor r=26.9307 //w=0.15 //l=0.106066 //layer=ply \
 //thickness=0.18 //x=17.545 //y=4.97 //x2=17.62 //y2=5.045
r325 (  104 105 ) resistor r=123.064 //w=0.094 //l=0.24 //layer=ply \
 //thickness=0.18 //x=17.545 //y=4.97 //x2=17.305 //y2=4.97
r326 (  99 126 ) resistor r=39.5823 //w=0.21 //l=0.173853 //layer=ply \
 //thickness=0.18 //x=17.175 //y=1.74 //x2=17.215 //y2=1.585
r327 (  99 118 ) resistor r=182.032 //w=0.094 //l=0.355 //layer=ply \
 //thickness=0.18 //x=17.175 //y=1.74 //x2=17.175 //y2=2.095
r328 (  98 126 ) resistor r=39.5823 //w=0.21 //l=0.173853 //layer=ply \
 //thickness=0.18 //x=17.175 //y=1.43 //x2=17.215 //y2=1.585
r329 (  97 125 ) resistor r=45.1352 //w=0.168 //l=0.173853 //layer=ply \
 //thickness=0.18 //x=17.175 //y=1.085 //x2=17.215 //y2=0.93
r330 (  97 98 ) resistor r=176.904 //w=0.094 //l=0.345 //layer=ply \
 //thickness=0.18 //x=17.175 //y=1.085 //x2=17.175 //y2=1.43
r331 (  96 111 ) resistor r=592.245 //w=0.094 //l=1.155 //layer=ply \
 //thickness=0.18 //x=17.62 //y=6.2 //x2=17.62 //y2=5.045
r332 (  95 124 ) resistor r=592.245 //w=0.094 //l=1.155 //layer=ply \
 //thickness=0.18 //x=17.18 //y=6.2 //x2=17.18 //y2=5.045
r333 (  94 108 ) resistor r=56.4043 //w=0.094 //l=0.11 //layer=ply \
 //thickness=0.18 //x=17.44 //y=1.585 //x2=17.55 //y2=1.585
r334 (  94 109 ) resistor r=56.4043 //w=0.094 //l=0.11 //layer=ply \
 //thickness=0.18 //x=17.44 //y=1.585 //x2=17.33 //y2=1.585
r335 (  78 132 ) resistor r=23.615 //w=0.187 //l=0.345 //layer=li \
 //thickness=0.1 //x=20.73 //y=5.56 //x2=20.73 //y2=5.905
r336 (  70 131 ) resistor r=23.615 //w=0.187 //l=0.345 //layer=li \
 //thickness=0.1 //x=19.85 //y=5.56 //x2=19.85 //y2=5.905
r337 (  65 121 ) resistor r=152 //w=0.17 //l=0.17 //layer=licon //count=1 \
 //x=17.17 //y=4.88 //x2=17.17 //y2=4.88
r338 (  56 117 ) resistor r=152 //w=0.17 //l=0.17 //layer=licon //count=1 \
 //x=17.14 //y=2.26 //x2=17.14 //y2=2.26
r339 (  50 52 ) resistor r=0.10734 //w=0.281 //l=0.16 //layer=m2 \
 //thickness=0.36 //x=17.14 //y=3.865 //x2=17.3 //y2=3.865
r340 (  47 54 ) resistor r=0.28331 //w=0.241 //l=0.525 //layer=m2 \
 //thickness=0.36 //x=20.685 //y=3.865 //x2=21.21 //y2=3.865
r341 (  47 48 ) resistor r=0.410305 //w=0.131 //l=0.43 //layer=m2 \
 //thickness=0.36 //x=20.685 //y=3.865 //x2=20.255 //y2=3.865
r342 (  45 48 ) resistor r=0.125 //w=0.17 //l=0.177341 //layer=m2 \
 //thickness=0.36 //x=20.085 //y=3.88 //x2=20.255 //y2=3.865
r343 (  45 52 ) resistor r=2.65744 //w=0.131 //l=2.785 //layer=m2 \
 //thickness=0.36 //x=20.085 //y=3.88 //x2=17.3 //y2=3.88
r344 (  42 54 ) resistor r=4.5 //w=0.15 //l=0.15 //layer=via1 //count=1 \
 //x=21.21 //y=3.865 //x2=21.21 //y2=3.865
r345 (  42 44 ) resistor r=0.0049867 //w=0.376 //l=0.015 //layer=m1 \
 //thickness=0.36 //x=21.157 //y=3.865 //x2=21.157 //y2=3.88
r346 (  39 129 ) resistor r=9.3 //w=0.17 //l=0.17 //layer=mcon //count=1 \
 //x=20.77 //y=1.18 //x2=20.77 //y2=1.18
r347 (  37 78 ) resistor r=9.3 //w=0.17 //l=0.17 //layer=mcon //count=1 \
 //x=20.73 //y=5.56 //x2=20.73 //y2=5.56
r348 (  34 37 ) resistor r=0.117801 //w=0.191 //l=0.18 //layer=m1 \
 //thickness=0.36 //x=20.73 //y=5.38 //x2=20.73 //y2=5.56
r349 (  33 70 ) resistor r=9.3 //w=0.17 //l=0.17 //layer=mcon //count=1 \
 //x=19.85 //y=5.56 //x2=19.85 //y2=5.56
r350 (  31 33 ) resistor r=0.10274 //w=0.219 //l=0.18 //layer=m1 \
 //thickness=0.36 //x=19.85 //y=5.38 //x2=19.85 //y2=5.56
r351 (  28 50 ) resistor r=4.5 //w=0.15 //l=0.15 //layer=via1 //count=1 \
 //x=17.14 //y=3.865 //x2=17.14 //y2=3.865
r352 (  28 30 ) resistor r=0.0049867 //w=0.376 //l=0.015 //layer=m1 \
 //thickness=0.36 //x=17.192 //y=3.865 //x2=17.192 //y2=3.88
r353 (  26 65 ) resistor r=9.3 //w=0.17 //l=0.17 //layer=mcon //count=1 \
 //x=17.17 //y=4.88 //x2=17.17 //y2=4.88
r354 (  22 56 ) resistor r=9.3 //w=0.17 //l=0.17 //layer=mcon //count=1 \
 //x=17.14 //y=2.26 //x2=17.14 //y2=2.26
r355 (  22 24 ) resistor r=0.0936408 //w=0.196 //l=0.125 //layer=m1 \
 //thickness=0.36 //x=17.142 //y=2.26 //x2=17.142 //y2=2.385
r356 (  19 44 ) resistor r=0.0861726 //w=0.376 //l=0.16944 //layer=m1 \
 //thickness=0.36 //x=21.21 //y=4.025 //x2=21.157 //y2=3.88
r357 (  19 20 ) resistor r=1.21183 //w=0.131 //l=1.27 //layer=m1 \
 //thickness=0.36 //x=21.21 //y=4.025 //x2=21.21 //y2=5.295
r358 (  18 42 ) resistor r=0.0911593 //w=0.376 //l=0.184608 //layer=m1 \
 //thickness=0.36 //x=21.21 //y=3.705 //x2=21.157 //y2=3.865
r359 (  17 18 ) resistor r=1.70324 //w=0.131 //l=1.785 //layer=m1 \
 //thickness=0.36 //x=21.21 //y=1.92 //x2=21.21 //y2=3.705
r360 (  15 17 ) resistor r=0.0698411 //w=0.17 //l=0.120208 //layer=m1 \
 //thickness=0.36 //x=21.125 //y=1.835 //x2=21.21 //y2=1.92
r361 (  15 16 ) resistor r=0.257634 //w=0.131 //l=0.27 //layer=m1 \
 //thickness=0.36 //x=21.125 //y=1.835 //x2=20.855 //y2=1.835
r362 (  14 34 ) resistor r=0.0257089 //w=0.23 //l=0.115 //layer=m1 \
 //thickness=0.36 //x=20.845 //y=5.38 //x2=20.73 //y2=5.38
r363 (  13 20 ) resistor r=0.0698411 //w=0.17 //l=0.120208 //layer=m1 \
 //thickness=0.36 //x=21.125 //y=5.38 //x2=21.21 //y2=5.295
r364 (  13 14 ) resistor r=0.267176 //w=0.131 //l=0.28 //layer=m1 \
 //thickness=0.36 //x=21.125 //y=5.38 //x2=20.845 //y2=5.38
r365 (  12 16 ) resistor r=0.0698411 //w=0.17 //l=0.120208 //layer=m1 \
 //thickness=0.36 //x=20.77 //y=1.75 //x2=20.855 //y2=1.835
r366 (  11 39 ) resistor r=0.0913624 //w=0.191 //l=0.12 //layer=m1 \
 //thickness=0.36 //x=20.77 //y=1.3 //x2=20.77 //y2=1.18
r367 (  11 12 ) resistor r=0.429389 //w=0.131 //l=0.45 //layer=m1 \
 //thickness=0.36 //x=20.77 //y=1.3 //x2=20.77 //y2=1.75
r368 (  8 31 ) resistor r=0.0227762 //w=0.219 //l=0.115 //layer=m1 \
 //thickness=0.36 //x=19.965 //y=5.38 //x2=19.85 //y2=5.38
r369 (  7 34 ) resistor r=0.0257089 //w=0.23 //l=0.115 //layer=m1 \
 //thickness=0.36 //x=20.615 //y=5.38 //x2=20.73 //y2=5.38
r370 (  7 8 ) resistor r=0.620229 //w=0.131 //l=0.65 //layer=m1 \
 //thickness=0.36 //x=20.615 //y=5.38 //x2=19.965 //y2=5.38
r371 (  4 26 ) resistor r=0.0878548 //w=0.228 //l=0.159295 //layer=m1 \
 //thickness=0.36 //x=17.14 //y=4.735 //x2=17.17 //y2=4.88
r372 (  3 30 ) resistor r=0.0861726 //w=0.376 //l=0.169012 //layer=m1 \
 //thickness=0.36 //x=17.14 //y=4.025 //x2=17.192 //y2=3.88
r373 (  3 4 ) resistor r=0.677481 //w=0.131 //l=0.71 //layer=m1 \
 //thickness=0.36 //x=17.14 //y=4.025 //x2=17.14 //y2=4.735
r374 (  2 28 ) resistor r=0.0911593 //w=0.376 //l=0.184174 //layer=m1 \
 //thickness=0.36 //x=17.14 //y=3.705 //x2=17.192 //y2=3.865
r375 (  2 24 ) resistor r=1.25954 //w=0.131 //l=1.32 //layer=m1 \
 //thickness=0.36 //x=17.14 //y=3.705 //x2=17.14 //y2=2.385
ends PM_DFFQNX1\%noxref_7

subckt PM_DFFQNX1\%VDD ( 1 39 58 67 77 85 95 111 119 145 155 181 191 213 221 \
 247 257 270 277 282 286 291 296 300 301 302 303 304 305 306 307 308 309 310 \
 311 312 313 314 315 316 317 318 )
c385 ( 318 0 ) capacitor c=0.0393089f //x=21.025 //y=5.2
c386 ( 317 0 ) capacitor c=0.0248174f //x=20.145 //y=5.2
c387 ( 316 0 ) capacitor c=0.0625788f //x=19.275 //y=5.2
c388 ( 315 0 ) capacitor c=0.039544f //x=17.695 //y=5.2
c389 ( 314 0 ) capacitor c=0.0248174f //x=16.815 //y=5.2
c390 ( 313 0 ) capacitor c=0.062487f //x=15.945 //y=5.2
c391 ( 312 0 ) capacitor c=0.0390282f //x=14.365 //y=5.2
c392 ( 311 0 ) capacitor c=0.0248174f //x=13.485 //y=5.2
c393 ( 310 0 ) capacitor c=0.0623361f //x=12.615 //y=5.2
c394 ( 309 0 ) capacitor c=0.039544f //x=11.035 //y=5.2
c395 ( 308 0 ) capacitor c=0.0248174f //x=10.155 //y=5.2
c396 ( 307 0 ) capacitor c=0.0623361f //x=9.285 //y=5.2
c397 ( 306 0 ) capacitor c=0.039544f //x=7.705 //y=5.2
c398 ( 305 0 ) capacitor c=0.0248174f //x=6.825 //y=5.2
c399 ( 304 0 ) capacitor c=0.0627254f //x=5.955 //y=5.2
c400 ( 303 0 ) capacitor c=0.0466891f //x=4.075 //y=5.2
c401 ( 302 0 ) capacitor c=0.0255836f //x=3.195 //y=5.2
c402 ( 301 0 ) capacitor c=0.0256114f //x=2.315 //y=5.2
c403 ( 300 0 ) capacitor c=0.0693239f //x=1.445 //y=5.2
c404 ( 299 0 ) capacitor c=0.00597439f //x=21.17 //y=7.585
c405 ( 298 0 ) capacitor c=0.00597439f //x=20.29 //y=7.585
c406 ( 297 0 ) capacitor c=0.00597439f //x=19.41 //y=7.585
c407 ( 296 0 ) capacitor c=0.127979f //x=18.62 //y=7.585
c408 ( 295 0 ) capacitor c=0.00597439f //x=17.84 //y=7.585
c409 ( 294 0 ) capacitor c=0.00597439f //x=16.96 //y=7.585
c410 ( 293 0 ) capacitor c=0.00597439f //x=16.03 //y=7.58
c411 ( 291 0 ) capacitor c=0.127181f //x=15.29 //y=7.585
c412 ( 290 0 ) capacitor c=0.00597439f //x=14.55 //y=7.58
c413 ( 288 0 ) capacitor c=0.00597439f //x=13.63 //y=7.585
c414 ( 287 0 ) capacitor c=0.00597439f //x=12.75 //y=7.585
c415 ( 286 0 ) capacitor c=0.126609f //x=11.96 //y=7.585
c416 ( 285 0 ) capacitor c=0.00597439f //x=11.18 //y=7.585
c417 ( 284 0 ) capacitor c=0.00597439f //x=10.3 //y=7.585
c418 ( 283 0 ) capacitor c=0.00597439f //x=9.42 //y=7.585
c419 ( 282 0 ) capacitor c=0.126767f //x=8.63 //y=7.585
c420 ( 281 0 ) capacitor c=0.00597439f //x=7.85 //y=7.585
c421 ( 280 0 ) capacitor c=0.00597439f //x=6.97 //y=7.585
c422 ( 279 0 ) capacitor c=0.00597439f //x=6.04 //y=7.58
c423 ( 277 0 ) capacitor c=0.145722f //x=5.3 //y=7.585
c424 ( 276 0 ) capacitor c=0.00597439f //x=4.22 //y=7.585
c425 ( 275 0 ) capacitor c=0.00597439f //x=3.34 //y=7.585
c426 ( 274 0 ) capacitor c=0.00597439f //x=2.46 //y=7.585
c427 ( 273 0 ) capacitor c=0.00597439f //x=1.58 //y=7.585
c428 ( 270 0 ) capacitor c=0.261935f //x=21.58 //y=7.58
c429 ( 257 0 ) capacitor c=0.0287376f //x=21.085 //y=7.585
c430 ( 247 0 ) capacitor c=0.0291078f //x=20.205 //y=7.585
c431 ( 237 0 ) capacitor c=0.0283511f //x=19.325 //y=7.585
c432 ( 231 0 ) capacitor c=0.0277785f //x=18.45 //y=7.585
c433 ( 221 0 ) capacitor c=0.0287375f //x=17.755 //y=7.585
c434 ( 213 0 ) capacitor c=0.0291078f //x=16.875 //y=7.585
c435 ( 203 0 ) capacitor c=0.0283511f //x=15.995 //y=7.585
c436 ( 199 0 ) capacitor c=0.0273918f //x=15.12 //y=7.585
c437 ( 191 0 ) capacitor c=0.0287377f //x=14.425 //y=7.585
c438 ( 181 0 ) capacitor c=0.0291078f //x=13.545 //y=7.585
c439 ( 169 0 ) capacitor c=0.0283511f //x=12.665 //y=7.585
c440 ( 165 0 ) capacitor c=0.0277785f //x=11.79 //y=7.585
c441 ( 155 0 ) capacitor c=0.0287376f //x=11.095 //y=7.585
c442 ( 145 0 ) capacitor c=0.0291078f //x=10.215 //y=7.585
c443 ( 135 0 ) capacitor c=0.0283511f //x=9.335 //y=7.585
c444 ( 129 0 ) capacitor c=0.0277785f //x=8.46 //y=7.585
c445 ( 119 0 ) capacitor c=0.0287375f //x=7.765 //y=7.585
c446 ( 111 0 ) capacitor c=0.0291078f //x=6.885 //y=7.585
c447 ( 101 0 ) capacitor c=0.0283511f //x=6.005 //y=7.585
c448 ( 95 0 ) capacitor c=0.042257f //x=5.13 //y=7.585
c449 ( 85 0 ) capacitor c=0.0288858f //x=4.135 //y=7.585
c450 ( 77 0 ) capacitor c=0.0288441f //x=3.255 //y=7.585
c451 ( 67 0 ) capacitor c=0.0289834f //x=2.375 //y=7.585
c452 ( 58 0 ) capacitor c=0.253472f //x=1.23 //y=7.58
c453 ( 55 0 ) capacitor c=0.0455283f //x=1.495 //y=7.585
c454 ( 39 0 ) capacitor c=0.824324f //x=21.58 //y=7.58
r455 (  268 299 ) resistor r=2.87058 //w=0.35 //l=0.085 //layer=li \
 //thickness=0.1 //x=21.255 //y=7.585 //x2=21.17 //y2=7.585
r456 (  268 270 ) resistor r=11.3351 //w=0.367 //l=0.325 //layer=li \
 //thickness=0.1 //x=21.255 //y=7.585 //x2=21.58 //y2=7.585
r457 (  261 299 ) resistor r=4.23183 //w=0.7 //l=0.175 //layer=li \
 //thickness=0.1 //x=21.17 //y=7.41 //x2=21.17 //y2=7.585
r458 (  261 318 ) resistor r=33.1979 //w=0.187 //l=0.485 //layer=li \
 //thickness=0.1 //x=21.17 //y=7.41 //x2=21.17 //y2=6.925
r459 (  258 298 ) resistor r=2.87058 //w=0.35 //l=0.085 //layer=li \
 //thickness=0.1 //x=20.375 //y=7.585 //x2=20.29 //y2=7.585
r460 (  258 260 ) resistor r=16.218 //w=0.367 //l=0.465 //layer=li \
 //thickness=0.1 //x=20.375 //y=7.585 //x2=20.84 //y2=7.585
r461 (  257 299 ) resistor r=2.87058 //w=0.35 //l=0.085 //layer=li \
 //thickness=0.1 //x=21.085 //y=7.585 //x2=21.17 //y2=7.585
r462 (  257 260 ) resistor r=8.54496 //w=0.367 //l=0.245 //layer=li \
 //thickness=0.1 //x=21.085 //y=7.585 //x2=20.84 //y2=7.585
r463 (  251 298 ) resistor r=4.23183 //w=0.7 //l=0.175 //layer=li \
 //thickness=0.1 //x=20.29 //y=7.41 //x2=20.29 //y2=7.585
r464 (  251 317 ) resistor r=33.1979 //w=0.187 //l=0.485 //layer=li \
 //thickness=0.1 //x=20.29 //y=7.41 //x2=20.29 //y2=6.925
r465 (  248 297 ) resistor r=2.87058 //w=0.35 //l=0.085 //layer=li \
 //thickness=0.1 //x=19.495 //y=7.585 //x2=19.41 //y2=7.585
r466 (  248 250 ) resistor r=8.19619 //w=0.367 //l=0.235 //layer=li \
 //thickness=0.1 //x=19.495 //y=7.585 //x2=19.73 //y2=7.585
r467 (  247 298 ) resistor r=2.87058 //w=0.35 //l=0.085 //layer=li \
 //thickness=0.1 //x=20.205 //y=7.585 //x2=20.29 //y2=7.585
r468 (  247 250 ) resistor r=16.5668 //w=0.367 //l=0.475 //layer=li \
 //thickness=0.1 //x=20.205 //y=7.585 //x2=19.73 //y2=7.585
r469 (  239 297 ) resistor r=4.23183 //w=0.7 //l=0.175 //layer=li \
 //thickness=0.1 //x=19.41 //y=7.41 //x2=19.41 //y2=7.585
r470 (  239 316 ) resistor r=56.4706 //w=0.187 //l=0.825 //layer=li \
 //thickness=0.1 //x=19.41 //y=7.41 //x2=19.41 //y2=6.585
r471 (  238 296 ) resistor r=5.29055 //w=0.35 //l=0.17 //layer=li \
 //thickness=0.1 //x=18.79 //y=7.585 //x2=18.62 //y2=7.585
r472 (  237 297 ) resistor r=2.87058 //w=0.35 //l=0.085 //layer=li \
 //thickness=0.1 //x=19.325 //y=7.585 //x2=19.41 //y2=7.585
r473 (  237 238 ) resistor r=18.6594 //w=0.367 //l=0.535 //layer=li \
 //thickness=0.1 //x=19.325 //y=7.585 //x2=18.79 //y2=7.585
r474 (  232 295 ) resistor r=2.87058 //w=0.35 //l=0.085 //layer=li \
 //thickness=0.1 //x=17.925 //y=7.585 //x2=17.84 //y2=7.585
r475 (  232 234 ) resistor r=11.3351 //w=0.367 //l=0.325 //layer=li \
 //thickness=0.1 //x=17.925 //y=7.585 //x2=18.25 //y2=7.585
r476 (  231 296 ) resistor r=5.29055 //w=0.35 //l=0.17 //layer=li \
 //thickness=0.1 //x=18.45 //y=7.585 //x2=18.62 //y2=7.585
r477 (  231 234 ) resistor r=6.97548 //w=0.367 //l=0.2 //layer=li \
 //thickness=0.1 //x=18.45 //y=7.585 //x2=18.25 //y2=7.585
r478 (  225 295 ) resistor r=4.23183 //w=0.7 //l=0.175 //layer=li \
 //thickness=0.1 //x=17.84 //y=7.41 //x2=17.84 //y2=7.585
r479 (  225 315 ) resistor r=33.1979 //w=0.187 //l=0.485 //layer=li \
 //thickness=0.1 //x=17.84 //y=7.41 //x2=17.84 //y2=6.925
r480 (  222 294 ) resistor r=2.87058 //w=0.35 //l=0.085 //layer=li \
 //thickness=0.1 //x=17.045 //y=7.585 //x2=16.96 //y2=7.585
r481 (  222 224 ) resistor r=3.31335 //w=0.367 //l=0.095 //layer=li \
 //thickness=0.1 //x=17.045 //y=7.585 //x2=17.14 //y2=7.585
r482 (  221 295 ) resistor r=2.87058 //w=0.35 //l=0.085 //layer=li \
 //thickness=0.1 //x=17.755 //y=7.585 //x2=17.84 //y2=7.585
r483 (  221 224 ) resistor r=21.4496 //w=0.367 //l=0.615 //layer=li \
 //thickness=0.1 //x=17.755 //y=7.585 //x2=17.14 //y2=7.585
r484 (  215 294 ) resistor r=4.23183 //w=0.7 //l=0.175 //layer=li \
 //thickness=0.1 //x=16.96 //y=7.41 //x2=16.96 //y2=7.585
r485 (  215 314 ) resistor r=33.1979 //w=0.187 //l=0.485 //layer=li \
 //thickness=0.1 //x=16.96 //y=7.41 //x2=16.96 //y2=6.925
r486 (  214 293 ) resistor r=2.87058 //w=0.35 //l=0.085 //layer=li \
 //thickness=0.1 //x=16.165 //y=7.585 //x2=16.08 //y2=7.585
r487 (  213 294 ) resistor r=2.87058 //w=0.35 //l=0.085 //layer=li \
 //thickness=0.1 //x=16.875 //y=7.585 //x2=16.96 //y2=7.585
r488 (  213 214 ) resistor r=24.7629 //w=0.367 //l=0.71 //layer=li \
 //thickness=0.1 //x=16.875 //y=7.585 //x2=16.165 //y2=7.585
r489 (  205 293 ) resistor r=4.23183 //w=0.7 //l=0.175 //layer=li \
 //thickness=0.1 //x=16.08 //y=7.41 //x2=16.08 //y2=7.585
r490 (  205 313 ) resistor r=56.4706 //w=0.187 //l=0.825 //layer=li \
 //thickness=0.1 //x=16.08 //y=7.41 //x2=16.08 //y2=6.585
r491 (  204 291 ) resistor r=5.29055 //w=0.35 //l=0.17 //layer=li \
 //thickness=0.1 //x=15.46 //y=7.585 //x2=15.29 //y2=7.585
r492 (  203 293 ) resistor r=2.87058 //w=0.35 //l=0.085 //layer=li \
 //thickness=0.1 //x=15.995 //y=7.585 //x2=16.08 //y2=7.585
r493 (  203 204 ) resistor r=18.6594 //w=0.367 //l=0.535 //layer=li \
 //thickness=0.1 //x=15.995 //y=7.585 //x2=15.46 //y2=7.585
r494 (  200 290 ) resistor r=2.87058 //w=0.35 //l=0.085 //layer=li \
 //thickness=0.1 //x=14.595 //y=7.585 //x2=14.51 //y2=7.585
r495 (  199 291 ) resistor r=5.29055 //w=0.35 //l=0.17 //layer=li \
 //thickness=0.1 //x=15.12 //y=7.585 //x2=15.29 //y2=7.585
r496 (  199 200 ) resistor r=18.3106 //w=0.367 //l=0.525 //layer=li \
 //thickness=0.1 //x=15.12 //y=7.585 //x2=14.595 //y2=7.585
r497 (  193 290 ) resistor r=4.23183 //w=0.7 //l=0.175 //layer=li \
 //thickness=0.1 //x=14.51 //y=7.41 //x2=14.51 //y2=7.585
r498 (  193 312 ) resistor r=33.1979 //w=0.187 //l=0.485 //layer=li \
 //thickness=0.1 //x=14.51 //y=7.41 //x2=14.51 //y2=6.925
r499 (  192 288 ) resistor r=2.87058 //w=0.35 //l=0.085 //layer=li \
 //thickness=0.1 //x=13.715 //y=7.585 //x2=13.63 //y2=7.585
r500 (  191 290 ) resistor r=2.87058 //w=0.35 //l=0.085 //layer=li \
 //thickness=0.1 //x=14.425 //y=7.585 //x2=14.51 //y2=7.585
r501 (  191 192 ) resistor r=24.7629 //w=0.367 //l=0.71 //layer=li \
 //thickness=0.1 //x=14.425 //y=7.585 //x2=13.715 //y2=7.585
r502 (  185 288 ) resistor r=4.23183 //w=0.7 //l=0.175 //layer=li \
 //thickness=0.1 //x=13.63 //y=7.41 //x2=13.63 //y2=7.585
r503 (  185 311 ) resistor r=33.1979 //w=0.187 //l=0.485 //layer=li \
 //thickness=0.1 //x=13.63 //y=7.41 //x2=13.63 //y2=6.925
r504 (  182 287 ) resistor r=2.87058 //w=0.35 //l=0.085 //layer=li \
 //thickness=0.1 //x=12.835 //y=7.585 //x2=12.75 //y2=7.585
r505 (  182 184 ) resistor r=21.1008 //w=0.367 //l=0.605 //layer=li \
 //thickness=0.1 //x=12.835 //y=7.585 //x2=13.44 //y2=7.585
r506 (  181 288 ) resistor r=2.87058 //w=0.35 //l=0.085 //layer=li \
 //thickness=0.1 //x=13.545 //y=7.585 //x2=13.63 //y2=7.585
r507 (  181 184 ) resistor r=3.66213 //w=0.367 //l=0.105 //layer=li \
 //thickness=0.1 //x=13.545 //y=7.585 //x2=13.44 //y2=7.585
r508 (  173 287 ) resistor r=4.23183 //w=0.7 //l=0.175 //layer=li \
 //thickness=0.1 //x=12.75 //y=7.41 //x2=12.75 //y2=7.585
r509 (  173 310 ) resistor r=56.4706 //w=0.187 //l=0.825 //layer=li \
 //thickness=0.1 //x=12.75 //y=7.41 //x2=12.75 //y2=6.585
r510 (  170 286 ) resistor r=5.29055 //w=0.35 //l=0.17 //layer=li \
 //thickness=0.1 //x=12.13 //y=7.585 //x2=11.96 //y2=7.585
r511 (  170 172 ) resistor r=6.97548 //w=0.367 //l=0.2 //layer=li \
 //thickness=0.1 //x=12.13 //y=7.585 //x2=12.33 //y2=7.585
r512 (  169 287 ) resistor r=2.87058 //w=0.35 //l=0.085 //layer=li \
 //thickness=0.1 //x=12.665 //y=7.585 //x2=12.75 //y2=7.585
r513 (  169 172 ) resistor r=11.6839 //w=0.367 //l=0.335 //layer=li \
 //thickness=0.1 //x=12.665 //y=7.585 //x2=12.33 //y2=7.585
r514 (  166 285 ) resistor r=2.87058 //w=0.35 //l=0.085 //layer=li \
 //thickness=0.1 //x=11.265 //y=7.585 //x2=11.18 //y2=7.585
r515 (  165 286 ) resistor r=5.29055 //w=0.35 //l=0.17 //layer=li \
 //thickness=0.1 //x=11.79 //y=7.585 //x2=11.96 //y2=7.585
r516 (  165 166 ) resistor r=18.3106 //w=0.367 //l=0.525 //layer=li \
 //thickness=0.1 //x=11.79 //y=7.585 //x2=11.265 //y2=7.585
r517 (  159 285 ) resistor r=4.23183 //w=0.7 //l=0.175 //layer=li \
 //thickness=0.1 //x=11.18 //y=7.41 //x2=11.18 //y2=7.585
r518 (  159 309 ) resistor r=33.1979 //w=0.187 //l=0.485 //layer=li \
 //thickness=0.1 //x=11.18 //y=7.41 //x2=11.18 //y2=6.925
r519 (  156 284 ) resistor r=2.87058 //w=0.35 //l=0.085 //layer=li \
 //thickness=0.1 //x=10.385 //y=7.585 //x2=10.3 //y2=7.585
r520 (  156 158 ) resistor r=16.218 //w=0.367 //l=0.465 //layer=li \
 //thickness=0.1 //x=10.385 //y=7.585 //x2=10.85 //y2=7.585
r521 (  155 285 ) resistor r=2.87058 //w=0.35 //l=0.085 //layer=li \
 //thickness=0.1 //x=11.095 //y=7.585 //x2=11.18 //y2=7.585
r522 (  155 158 ) resistor r=8.54496 //w=0.367 //l=0.245 //layer=li \
 //thickness=0.1 //x=11.095 //y=7.585 //x2=10.85 //y2=7.585
r523 (  149 284 ) resistor r=4.23183 //w=0.7 //l=0.175 //layer=li \
 //thickness=0.1 //x=10.3 //y=7.41 //x2=10.3 //y2=7.585
r524 (  149 308 ) resistor r=33.1979 //w=0.187 //l=0.485 //layer=li \
 //thickness=0.1 //x=10.3 //y=7.41 //x2=10.3 //y2=6.925
r525 (  146 283 ) resistor r=2.87058 //w=0.35 //l=0.085 //layer=li \
 //thickness=0.1 //x=9.505 //y=7.585 //x2=9.42 //y2=7.585
r526 (  146 148 ) resistor r=8.19619 //w=0.367 //l=0.235 //layer=li \
 //thickness=0.1 //x=9.505 //y=7.585 //x2=9.74 //y2=7.585
r527 (  145 284 ) resistor r=2.87058 //w=0.35 //l=0.085 //layer=li \
 //thickness=0.1 //x=10.215 //y=7.585 //x2=10.3 //y2=7.585
r528 (  145 148 ) resistor r=16.5668 //w=0.367 //l=0.475 //layer=li \
 //thickness=0.1 //x=10.215 //y=7.585 //x2=9.74 //y2=7.585
r529 (  137 283 ) resistor r=4.23183 //w=0.7 //l=0.175 //layer=li \
 //thickness=0.1 //x=9.42 //y=7.41 //x2=9.42 //y2=7.585
r530 (  137 307 ) resistor r=56.4706 //w=0.187 //l=0.825 //layer=li \
 //thickness=0.1 //x=9.42 //y=7.41 //x2=9.42 //y2=6.585
r531 (  136 282 ) resistor r=5.29055 //w=0.35 //l=0.17 //layer=li \
 //thickness=0.1 //x=8.8 //y=7.585 //x2=8.63 //y2=7.585
r532 (  135 283 ) resistor r=2.87058 //w=0.35 //l=0.085 //layer=li \
 //thickness=0.1 //x=9.335 //y=7.585 //x2=9.42 //y2=7.585
r533 (  135 136 ) resistor r=18.6594 //w=0.367 //l=0.535 //layer=li \
 //thickness=0.1 //x=9.335 //y=7.585 //x2=8.8 //y2=7.585
r534 (  130 281 ) resistor r=2.87058 //w=0.35 //l=0.085 //layer=li \
 //thickness=0.1 //x=7.935 //y=7.585 //x2=7.85 //y2=7.585
r535 (  130 132 ) resistor r=11.3351 //w=0.367 //l=0.325 //layer=li \
 //thickness=0.1 //x=7.935 //y=7.585 //x2=8.26 //y2=7.585
r536 (  129 282 ) resistor r=5.29055 //w=0.35 //l=0.17 //layer=li \
 //thickness=0.1 //x=8.46 //y=7.585 //x2=8.63 //y2=7.585
r537 (  129 132 ) resistor r=6.97548 //w=0.367 //l=0.2 //layer=li \
 //thickness=0.1 //x=8.46 //y=7.585 //x2=8.26 //y2=7.585
r538 (  123 281 ) resistor r=4.23183 //w=0.7 //l=0.175 //layer=li \
 //thickness=0.1 //x=7.85 //y=7.41 //x2=7.85 //y2=7.585
r539 (  123 306 ) resistor r=33.1979 //w=0.187 //l=0.485 //layer=li \
 //thickness=0.1 //x=7.85 //y=7.41 //x2=7.85 //y2=6.925
r540 (  120 280 ) resistor r=2.87058 //w=0.35 //l=0.085 //layer=li \
 //thickness=0.1 //x=7.055 //y=7.585 //x2=6.97 //y2=7.585
r541 (  120 122 ) resistor r=3.31335 //w=0.367 //l=0.095 //layer=li \
 //thickness=0.1 //x=7.055 //y=7.585 //x2=7.15 //y2=7.585
r542 (  119 281 ) resistor r=2.87058 //w=0.35 //l=0.085 //layer=li \
 //thickness=0.1 //x=7.765 //y=7.585 //x2=7.85 //y2=7.585
r543 (  119 122 ) resistor r=21.4496 //w=0.367 //l=0.615 //layer=li \
 //thickness=0.1 //x=7.765 //y=7.585 //x2=7.15 //y2=7.585
r544 (  113 280 ) resistor r=4.23183 //w=0.7 //l=0.175 //layer=li \
 //thickness=0.1 //x=6.97 //y=7.41 //x2=6.97 //y2=7.585
r545 (  113 305 ) resistor r=33.1979 //w=0.187 //l=0.485 //layer=li \
 //thickness=0.1 //x=6.97 //y=7.41 //x2=6.97 //y2=6.925
r546 (  112 279 ) resistor r=2.87058 //w=0.35 //l=0.085 //layer=li \
 //thickness=0.1 //x=6.175 //y=7.585 //x2=6.09 //y2=7.585
r547 (  111 280 ) resistor r=2.87058 //w=0.35 //l=0.085 //layer=li \
 //thickness=0.1 //x=6.885 //y=7.585 //x2=6.97 //y2=7.585
r548 (  111 112 ) resistor r=24.7629 //w=0.367 //l=0.71 //layer=li \
 //thickness=0.1 //x=6.885 //y=7.585 //x2=6.175 //y2=7.585
r549 (  103 279 ) resistor r=4.23183 //w=0.7 //l=0.175 //layer=li \
 //thickness=0.1 //x=6.09 //y=7.41 //x2=6.09 //y2=7.585
r550 (  103 304 ) resistor r=56.4706 //w=0.187 //l=0.825 //layer=li \
 //thickness=0.1 //x=6.09 //y=7.41 //x2=6.09 //y2=6.585
r551 (  102 277 ) resistor r=5.29055 //w=0.35 //l=0.17 //layer=li \
 //thickness=0.1 //x=5.47 //y=7.585 //x2=5.3 //y2=7.585
r552 (  101 279 ) resistor r=2.87058 //w=0.35 //l=0.085 //layer=li \
 //thickness=0.1 //x=6.005 //y=7.585 //x2=6.09 //y2=7.585
r553 (  101 102 ) resistor r=18.6594 //w=0.367 //l=0.535 //layer=li \
 //thickness=0.1 //x=6.005 //y=7.585 //x2=5.47 //y2=7.585
r554 (  96 276 ) resistor r=2.87058 //w=0.35 //l=0.085 //layer=li \
 //thickness=0.1 //x=4.305 //y=7.585 //x2=4.22 //y2=7.585
r555 (  96 98 ) resistor r=8.89373 //w=0.367 //l=0.255 //layer=li \
 //thickness=0.1 //x=4.305 //y=7.585 //x2=4.56 //y2=7.585
r556 (  95 277 ) resistor r=5.29055 //w=0.35 //l=0.17 //layer=li \
 //thickness=0.1 //x=5.13 //y=7.585 //x2=5.3 //y2=7.585
r557 (  95 98 ) resistor r=19.8801 //w=0.367 //l=0.57 //layer=li \
 //thickness=0.1 //x=5.13 //y=7.585 //x2=4.56 //y2=7.585
r558 (  89 276 ) resistor r=4.23183 //w=0.7 //l=0.175 //layer=li \
 //thickness=0.1 //x=4.22 //y=7.41 //x2=4.22 //y2=7.585
r559 (  89 303 ) resistor r=33.1979 //w=0.187 //l=0.485 //layer=li \
 //thickness=0.1 //x=4.22 //y=7.41 //x2=4.22 //y2=6.925
r560 (  86 275 ) resistor r=2.87058 //w=0.35 //l=0.085 //layer=li \
 //thickness=0.1 //x=3.425 //y=7.585 //x2=3.34 //y2=7.585
r561 (  86 88 ) resistor r=0.871935 //w=0.367 //l=0.025 //layer=li \
 //thickness=0.1 //x=3.425 //y=7.585 //x2=3.45 //y2=7.585
r562 (  85 276 ) resistor r=2.87058 //w=0.35 //l=0.085 //layer=li \
 //thickness=0.1 //x=4.135 //y=7.585 //x2=4.22 //y2=7.585
r563 (  85 88 ) resistor r=23.891 //w=0.367 //l=0.685 //layer=li \
 //thickness=0.1 //x=4.135 //y=7.585 //x2=3.45 //y2=7.585
r564 (  79 275 ) resistor r=4.23183 //w=0.7 //l=0.175 //layer=li \
 //thickness=0.1 //x=3.34 //y=7.41 //x2=3.34 //y2=7.585
r565 (  79 302 ) resistor r=33.1979 //w=0.187 //l=0.485 //layer=li \
 //thickness=0.1 //x=3.34 //y=7.41 //x2=3.34 //y2=6.925
r566 (  78 274 ) resistor r=2.87058 //w=0.35 //l=0.085 //layer=li \
 //thickness=0.1 //x=2.545 //y=7.585 //x2=2.46 //y2=7.585
r567 (  77 275 ) resistor r=2.87058 //w=0.35 //l=0.085 //layer=li \
 //thickness=0.1 //x=3.255 //y=7.585 //x2=3.34 //y2=7.585
r568 (  77 78 ) resistor r=24.7629 //w=0.367 //l=0.71 //layer=li \
 //thickness=0.1 //x=3.255 //y=7.585 //x2=2.545 //y2=7.585
r569 (  71 274 ) resistor r=4.23183 //w=0.7 //l=0.175 //layer=li \
 //thickness=0.1 //x=2.46 //y=7.41 //x2=2.46 //y2=7.585
r570 (  71 301 ) resistor r=33.1979 //w=0.187 //l=0.485 //layer=li \
 //thickness=0.1 //x=2.46 //y=7.41 //x2=2.46 //y2=6.925
r571 (  68 273 ) resistor r=2.87058 //w=0.35 //l=0.085 //layer=li \
 //thickness=0.1 //x=1.665 //y=7.585 //x2=1.58 //y2=7.585
r572 (  68 70 ) resistor r=23.5422 //w=0.367 //l=0.675 //layer=li \
 //thickness=0.1 //x=1.665 //y=7.585 //x2=2.34 //y2=7.585
r573 (  67 274 ) resistor r=2.87058 //w=0.35 //l=0.085 //layer=li \
 //thickness=0.1 //x=2.375 //y=7.585 //x2=2.46 //y2=7.585
r574 (  67 70 ) resistor r=1.22071 //w=0.367 //l=0.035 //layer=li \
 //thickness=0.1 //x=2.375 //y=7.585 //x2=2.34 //y2=7.585
r575 (  59 273 ) resistor r=4.23183 //w=0.7 //l=0.175 //layer=li \
 //thickness=0.1 //x=1.58 //y=7.41 //x2=1.58 //y2=7.585
r576 (  59 300 ) resistor r=56.4706 //w=0.187 //l=0.825 //layer=li \
 //thickness=0.1 //x=1.58 //y=7.41 //x2=1.58 //y2=6.585
r577 (  55 273 ) resistor r=2.87058 //w=0.35 //l=0.085 //layer=li \
 //thickness=0.1 //x=1.495 //y=7.585 //x2=1.58 //y2=7.585
r578 (  55 58 ) resistor r=9.24251 //w=0.367 //l=0.265 //layer=li \
 //thickness=0.1 //x=1.495 //y=7.585 //x2=1.23 //y2=7.585
r579 (  39 270 ) resistor r=9.3 //w=0.17 //l=0.17 //layer=mcon //count=1 \
 //x=21.58 //y=7.58 //x2=21.58 //y2=7.58
r580 (  37 260 ) resistor r=3.1 //w=0.17 //l=0.51 //layer=mcon //count=3 \
 //x=20.84 //y=7.58 //x2=20.84 //y2=7.58
r581 (  37 39 ) resistor r=0.297428 //w=0.311 //l=0.74 //layer=m1 \
 //thickness=0.36 //x=20.84 //y=7.585 //x2=21.58 //y2=7.585
r582 (  35 250 ) resistor r=3.1 //w=0.17 //l=0.51 //layer=mcon //count=3 \
 //x=19.73 //y=7.58 //x2=19.73 //y2=7.58
r583 (  35 37 ) resistor r=0.446141 //w=0.311 //l=1.11 //layer=m1 \
 //thickness=0.36 //x=19.73 //y=7.585 //x2=20.84 //y2=7.585
r584 (  33 234 ) resistor r=3.1 //w=0.17 //l=0.51 //layer=mcon //count=3 \
 //x=18.25 //y=7.58 //x2=18.25 //y2=7.58
r585 (  33 35 ) resistor r=0.594855 //w=0.311 //l=1.48 //layer=m1 \
 //thickness=0.36 //x=18.25 //y=7.585 //x2=19.73 //y2=7.585
r586 (  31 224 ) resistor r=3.1 //w=0.17 //l=0.51 //layer=mcon //count=3 \
 //x=17.14 //y=7.58 //x2=17.14 //y2=7.58
r587 (  31 33 ) resistor r=0.446141 //w=0.311 //l=1.11 //layer=m1 \
 //thickness=0.36 //x=17.14 //y=7.585 //x2=18.25 //y2=7.585
r588 (  29 293 ) resistor r=3.1 //w=0.17 //l=0.51 //layer=mcon //count=3 \
 //x=16.03 //y=7.58 //x2=16.03 //y2=7.58
r589 (  29 31 ) resistor r=0.446141 //w=0.311 //l=1.11 //layer=m1 \
 //thickness=0.36 //x=16.03 //y=7.585 //x2=17.14 //y2=7.585
r590 (  27 290 ) resistor r=3.1 //w=0.17 //l=0.51 //layer=mcon //count=3 \
 //x=14.55 //y=7.58 //x2=14.55 //y2=7.58
r591 (  27 29 ) resistor r=0.594855 //w=0.311 //l=1.48 //layer=m1 \
 //thickness=0.36 //x=14.55 //y=7.585 //x2=16.03 //y2=7.585
r592 (  25 184 ) resistor r=3.1 //w=0.17 //l=0.51 //layer=mcon //count=3 \
 //x=13.44 //y=7.58 //x2=13.44 //y2=7.58
r593 (  25 27 ) resistor r=0.446141 //w=0.311 //l=1.11 //layer=m1 \
 //thickness=0.36 //x=13.44 //y=7.585 //x2=14.55 //y2=7.585
r594 (  23 172 ) resistor r=3.1 //w=0.17 //l=0.51 //layer=mcon //count=3 \
 //x=12.33 //y=7.58 //x2=12.33 //y2=7.58
r595 (  23 25 ) resistor r=0.446141 //w=0.311 //l=1.11 //layer=m1 \
 //thickness=0.36 //x=12.33 //y=7.585 //x2=13.44 //y2=7.585
r596 (  20 158 ) resistor r=3.1 //w=0.17 //l=0.51 //layer=mcon //count=3 \
 //x=10.85 //y=7.58 //x2=10.85 //y2=7.58
r597 (  18 148 ) resistor r=3.1 //w=0.17 //l=0.51 //layer=mcon //count=3 \
 //x=9.74 //y=7.58 //x2=9.74 //y2=7.58
r598 (  18 20 ) resistor r=0.446141 //w=0.311 //l=1.11 //layer=m1 \
 //thickness=0.36 //x=9.74 //y=7.585 //x2=10.85 //y2=7.585
r599 (  16 132 ) resistor r=3.1 //w=0.17 //l=0.51 //layer=mcon //count=3 \
 //x=8.26 //y=7.58 //x2=8.26 //y2=7.58
r600 (  16 18 ) resistor r=0.594855 //w=0.311 //l=1.48 //layer=m1 \
 //thickness=0.36 //x=8.26 //y=7.585 //x2=9.74 //y2=7.585
r601 (  14 122 ) resistor r=3.1 //w=0.17 //l=0.51 //layer=mcon //count=3 \
 //x=7.15 //y=7.58 //x2=7.15 //y2=7.58
r602 (  14 16 ) resistor r=0.446141 //w=0.311 //l=1.11 //layer=m1 \
 //thickness=0.36 //x=7.15 //y=7.585 //x2=8.26 //y2=7.585
r603 (  12 279 ) resistor r=3.1 //w=0.17 //l=0.51 //layer=mcon //count=3 \
 //x=6.04 //y=7.58 //x2=6.04 //y2=7.58
r604 (  12 14 ) resistor r=0.446141 //w=0.311 //l=1.11 //layer=m1 \
 //thickness=0.36 //x=6.04 //y=7.585 //x2=7.15 //y2=7.585
r605 (  10 98 ) resistor r=3.1 //w=0.17 //l=0.51 //layer=mcon //count=3 \
 //x=4.56 //y=7.58 //x2=4.56 //y2=7.58
r606 (  10 12 ) resistor r=0.594855 //w=0.311 //l=1.48 //layer=m1 \
 //thickness=0.36 //x=4.56 //y=7.585 //x2=6.04 //y2=7.585
r607 (  8 88 ) resistor r=3.1 //w=0.17 //l=0.51 //layer=mcon //count=3 \
 //x=3.45 //y=7.58 //x2=3.45 //y2=7.58
r608 (  8 10 ) resistor r=0.446141 //w=0.311 //l=1.11 //layer=m1 \
 //thickness=0.36 //x=3.45 //y=7.585 //x2=4.56 //y2=7.585
r609 (  6 70 ) resistor r=3.1 //w=0.17 //l=0.51 //layer=mcon //count=3 \
 //x=2.34 //y=7.58 //x2=2.34 //y2=7.58
r610 (  6 8 ) resistor r=0.446141 //w=0.311 //l=1.11 //layer=m1 \
 //thickness=0.36 //x=2.34 //y=7.585 //x2=3.45 //y2=7.585
r611 (  3 58 ) resistor r=3.1 //w=0.17 //l=0.51 //layer=mcon //count=3 \
 //x=1.23 //y=7.58 //x2=1.23 //y2=7.58
r612 (  3 6 ) resistor r=0.446141 //w=0.311 //l=1.11 //layer=m1 \
 //thickness=0.36 //x=1.23 //y=7.585 //x2=2.34 //y2=7.585
r613 (  1 23 ) resistor r=0.446141 //w=0.311 //l=1.11 //layer=m1 \
 //thickness=0.36 //x=11.22 //y=7.585 //x2=12.33 //y2=7.585
r614 (  1 20 ) resistor r=0.148714 //w=0.311 //l=0.37 //layer=m1 \
 //thickness=0.36 //x=11.22 //y=7.585 //x2=10.85 //y2=7.585
ends PM_DFFQNX1\%VDD

subckt PM_DFFQNX1\%noxref_9 ( 5 7 15 19 30 33 34 )
c64 ( 34 0 ) capacitor c=0.0486635f //x=3.455 //y=0.555
c65 ( 33 0 ) capacitor c=0.0198746f //x=2.35 //y=1.09
c66 ( 30 0 ) capacitor c=0.00141302f //x=3.59 //y=1.175
c67 ( 19 0 ) capacitor c=0.00695768f //x=4.56 //y=0.805
c68 ( 15 0 ) capacitor c=0.0154966f //x=4.475 //y=0.72
c69 ( 7 0 ) capacitor c=0.00689476f //x=3.59 //y=0.805
c70 ( 5 0 ) capacitor c=0.0290436f //x=3.505 //y=1.175
r71 (  19 34 ) resistor r=3.57586 //w=0.17 //l=0.125 //layer=li \
 //thickness=0.1 //x=4.56 //y=0.805 //x2=4.56 //y2=0.68
r72 (  19 34 ) resistor r=18.139 //w=0.187 //l=0.265 //layer=li \
 //thickness=0.1 //x=4.56 //y=0.805 //x2=4.56 //y2=1.07
r73 (  16 34 ) resistor r=3.57586 //w=0.17 //l=0.103078 //layer=li \
 //thickness=0.1 //x=3.675 //y=0.72 //x2=3.59 //y2=0.68
r74 (  16 34 ) resistor r=27.3797 //w=0.187 //l=0.4 //layer=li //thickness=0.1 \
 //x=3.675 //y=0.72 //x2=4.075 //y2=0.72
r75 (  15 34 ) resistor r=3.57586 //w=0.17 //l=0.103078 //layer=li \
 //thickness=0.1 //x=4.475 //y=0.72 //x2=4.56 //y2=0.68
r76 (  15 34 ) resistor r=27.3797 //w=0.187 //l=0.4 //layer=li //thickness=0.1 \
 //x=4.475 //y=0.72 //x2=4.075 //y2=0.72
r77 (  11 30 ) resistor r=5.4201 //w=0.17 //l=0.085 //layer=li //thickness=0.1 \
 //x=3.59 //y=1.26 //x2=3.59 //y2=1.175
r78 (  11 34 ) resistor r=10.2674 //w=0.187 //l=0.15 //layer=li \
 //thickness=0.1 //x=3.59 //y=1.26 //x2=3.59 //y2=1.41
r79 (  8 30 ) resistor r=5.4201 //w=0.17 //l=0.085 //layer=li //thickness=0.1 \
 //x=3.59 //y=1.09 //x2=3.59 //y2=1.175
r80 (  8 34 ) resistor r=1.36898 //w=0.187 //l=0.02 //layer=li //thickness=0.1 \
 //x=3.59 //y=1.09 //x2=3.59 //y2=1.07
r81 (  7 34 ) resistor r=3.57586 //w=0.17 //l=0.125 //layer=li //thickness=0.1 \
 //x=3.59 //y=0.805 //x2=3.59 //y2=0.68
r82 (  7 34 ) resistor r=18.139 //w=0.187 //l=0.265 //layer=li //thickness=0.1 \
 //x=3.59 //y=0.805 //x2=3.59 //y2=1.07
r83 (  6 33 ) resistor r=0.751729 //w=0.17 //l=0.085 //layer=li \
 //thickness=0.1 //x=2.625 //y=1.175 //x2=2.54 //y2=1.175
r84 (  5 30 ) resistor r=1.40859 //w=0.34 //l=0.085 //layer=li //thickness=0.1 \
 //x=3.505 //y=1.175 //x2=3.59 //y2=1.175
r85 (  5 6 ) resistor r=60.2353 //w=0.187 //l=0.88 //layer=li //thickness=0.1 \
 //x=3.505 //y=1.175 //x2=2.625 //y2=1.175
ends PM_DFFQNX1\%noxref_9

subckt PM_DFFQNX1\%D ( 1 2 4 8 14 19 23 24 25 26 27 28 33 35 37 43 44 46 47 50 )
c115 ( 50 0 ) capacitor c=0.0393541f //x=7.18 //y=4.88
c116 ( 47 0 ) capacitor c=0.0284095f //x=7.15 //y=2.095
c117 ( 46 0 ) capacitor c=0.0476356f //x=7.15 //y=2.26
c118 ( 44 0 ) capacitor c=0.0439708f //x=7.715 //y=1.43
c119 ( 43 0 ) capacitor c=0.0192582f //x=7.715 //y=1.085
c120 ( 37 0 ) capacitor c=0.0162526f //x=7.56 //y=1.585
c121 ( 35 0 ) capacitor c=0.0157807f //x=7.56 //y=0.93
c122 ( 33 0 ) capacitor c=0.0372668f //x=7.555 //y=4.97
c123 ( 28 0 ) capacitor c=0.0210762f //x=7.185 //y=1.74
c124 ( 27 0 ) capacitor c=0.0168511f //x=7.185 //y=1.43
c125 ( 26 0 ) capacitor c=0.0175485f //x=7.185 //y=1.085
c126 ( 25 0 ) capacitor c=0.155269f //x=7.63 //y=6.2
c127 ( 24 0 ) capacitor c=0.110375f //x=7.19 //y=6.2
c128 ( 19 0 ) capacitor c=8.90417e-19 //x=7.18 //y=4.88
c129 ( 14 0 ) capacitor c=7.72439e-19 //x=7.15 //y=2.26
c130 ( 8 0 ) capacitor c=0.00706019f //x=7.15 //y=2.26
c131 ( 4 0 ) capacitor c=0.00487504f //x=7.15 //y=4.735
c132 ( 1 0 ) capacitor c=0.0504672f //x=7.15 //y=2.77
r133 (  52 53 ) resistor r=32.4568 //w=0.214 //l=0.075 //layer=ply \
 //thickness=0.18 //x=7.18 //y=4.97 //x2=7.18 //y2=5.045
r134 (  50 52 ) resistor r=20.271 //w=0.214 //l=0.09 //layer=ply \
 //thickness=0.18 //x=7.18 //y=4.88 //x2=7.18 //y2=4.97
r135 (  46 47 ) resistor r=52.7279 //w=0.214 //l=0.165 //layer=ply \
 //thickness=0.18 //x=7.15 //y=2.26 //x2=7.15 //y2=2.095
r136 (  44 57 ) resistor r=45.1352 //w=0.168 //l=0.173853 //layer=ply \
 //thickness=0.18 //x=7.715 //y=1.43 //x2=7.675 //y2=1.585
r137 (  43 56 ) resistor r=45.1352 //w=0.168 //l=0.173853 //layer=ply \
 //thickness=0.18 //x=7.715 //y=1.085 //x2=7.675 //y2=0.93
r138 (  43 44 ) resistor r=176.904 //w=0.094 //l=0.345 //layer=ply \
 //thickness=0.18 //x=7.715 //y=1.085 //x2=7.715 //y2=1.43
r139 (  38 55 ) resistor r=10.701 //w=0.21 //l=0.115 //layer=ply \
 //thickness=0.18 //x=7.34 //y=1.585 //x2=7.225 //y2=1.585
r140 (  37 57 ) resistor r=5.52526 //w=0.168 //l=0.115 //layer=ply \
 //thickness=0.18 //x=7.56 //y=1.585 //x2=7.675 //y2=1.585
r141 (  36 54 ) resistor r=5.52526 //w=0.168 //l=0.115 //layer=ply \
 //thickness=0.18 //x=7.34 //y=0.93 //x2=7.225 //y2=0.93
r142 (  35 56 ) resistor r=5.52526 //w=0.168 //l=0.115 //layer=ply \
 //thickness=0.18 //x=7.56 //y=0.93 //x2=7.675 //y2=0.93
r143 (  35 36 ) resistor r=112.809 //w=0.094 //l=0.22 //layer=ply \
 //thickness=0.18 //x=7.56 //y=0.93 //x2=7.34 //y2=0.93
r144 (  34 52 ) resistor r=16.5046 //w=0.27 //l=0.135 //layer=ply \
 //thickness=0.18 //x=7.315 //y=4.97 //x2=7.18 //y2=4.97
r145 (  33 40 ) resistor r=26.9307 //w=0.15 //l=0.106066 //layer=ply \
 //thickness=0.18 //x=7.555 //y=4.97 //x2=7.63 //y2=5.045
r146 (  33 34 ) resistor r=123.064 //w=0.094 //l=0.24 //layer=ply \
 //thickness=0.18 //x=7.555 //y=4.97 //x2=7.315 //y2=4.97
r147 (  28 55 ) resistor r=39.5823 //w=0.21 //l=0.173853 //layer=ply \
 //thickness=0.18 //x=7.185 //y=1.74 //x2=7.225 //y2=1.585
r148 (  28 47 ) resistor r=182.032 //w=0.094 //l=0.355 //layer=ply \
 //thickness=0.18 //x=7.185 //y=1.74 //x2=7.185 //y2=2.095
r149 (  27 55 ) resistor r=39.5823 //w=0.21 //l=0.173853 //layer=ply \
 //thickness=0.18 //x=7.185 //y=1.43 //x2=7.225 //y2=1.585
r150 (  26 54 ) resistor r=45.1352 //w=0.168 //l=0.173853 //layer=ply \
 //thickness=0.18 //x=7.185 //y=1.085 //x2=7.225 //y2=0.93
r151 (  26 27 ) resistor r=176.904 //w=0.094 //l=0.345 //layer=ply \
 //thickness=0.18 //x=7.185 //y=1.085 //x2=7.185 //y2=1.43
r152 (  25 40 ) resistor r=592.245 //w=0.094 //l=1.155 //layer=ply \
 //thickness=0.18 //x=7.63 //y=6.2 //x2=7.63 //y2=5.045
r153 (  24 53 ) resistor r=592.245 //w=0.094 //l=1.155 //layer=ply \
 //thickness=0.18 //x=7.19 //y=6.2 //x2=7.19 //y2=5.045
r154 (  23 37 ) resistor r=56.4043 //w=0.094 //l=0.11 //layer=ply \
 //thickness=0.18 //x=7.45 //y=1.585 //x2=7.56 //y2=1.585
r155 (  23 38 ) resistor r=56.4043 //w=0.094 //l=0.11 //layer=ply \
 //thickness=0.18 //x=7.45 //y=1.585 //x2=7.34 //y2=1.585
r156 (  19 50 ) resistor r=152 //w=0.17 //l=0.17 //layer=licon //count=1 \
 //x=7.18 //y=4.88 //x2=7.18 //y2=4.88
r157 (  14 46 ) resistor r=152 //w=0.17 //l=0.17 //layer=licon //count=1 \
 //x=7.15 //y=2.26 //x2=7.15 //y2=2.26
r158 (  12 19 ) resistor r=9.3 //w=0.17 //l=0.17 //layer=mcon //count=1 \
 //x=7.18 //y=4.88 //x2=7.18 //y2=4.88
r159 (  8 14 ) resistor r=9.3 //w=0.17 //l=0.17 //layer=mcon //count=1 \
 //x=7.15 //y=2.26 //x2=7.15 //y2=2.26
r160 (  8 10 ) resistor r=0.0936408 //w=0.196 //l=0.125 //layer=m1 \
 //thickness=0.36 //x=7.152 //y=2.26 //x2=7.152 //y2=2.385
r161 (  4 12 ) resistor r=0.0878548 //w=0.228 //l=0.159295 //layer=m1 \
 //thickness=0.36 //x=7.15 //y=4.735 //x2=7.18 //y2=4.88
r162 (  2 4 ) resistor r=1.52195 //w=0.131 //l=1.595 //layer=m1 \
 //thickness=0.36 //x=7.15 //y=3.14 //x2=7.15 //y2=4.735
r163 (  1 2 ) resistor r=0.353053 //w=0.131 //l=0.37 //layer=m1 \
 //thickness=0.36 //x=7.15 //y=2.77 //x2=7.15 //y2=3.14
r164 (  1 10 ) resistor r=0.367366 //w=0.131 //l=0.385 //layer=m1 \
 //thickness=0.36 //x=7.15 //y=2.77 //x2=7.15 //y2=2.385
ends PM_DFFQNX1\%D

subckt PM_DFFQNX1\%GND ( 1 2 6 7 19 27 36 46 58 61 65 66 70 71 76 77 81 82 86 \
 87 93 96 110 125 138 153 175 183 184 185 186 187 188 189 190 191 192 193 )
c424 ( 193 0 ) capacitor c=0.00843555f //x=19.61 //y=1.045
c425 ( 192 0 ) capacitor c=0.00843555f //x=16.28 //y=1.045
c426 ( 191 0 ) capacitor c=0.00843555f //x=12.95 //y=1.045
c427 ( 190 0 ) capacitor c=0.00843555f //x=9.62 //y=1.045
c428 ( 189 0 ) capacitor c=0.00843555f //x=6.29 //y=1.045
c429 ( 188 0 ) capacitor c=0.00840423f //x=1.375 //y=1.055
c430 ( 187 0 ) capacitor c=0.117691f //x=18.62 //y=0.175
c431 ( 186 0 ) capacitor c=0.11793f //x=15.29 //y=0.175
c432 ( 185 0 ) capacitor c=0.117691f //x=11.96 //y=0.175
c433 ( 184 0 ) capacitor c=0.117691f //x=8.63 //y=0.175
c434 ( 183 0 ) capacitor c=0.118861f //x=5.3 //y=0.175
c435 ( 175 0 ) capacitor c=0.335444f //x=21.58 //y=0.18
c436 ( 153 0 ) capacitor c=0.125256f //x=18.45 //y=0.175
c437 ( 138 0 ) capacitor c=0.126434f //x=15.12 //y=0.175
c438 ( 125 0 ) capacitor c=0.125256f //x=11.79 //y=0.175
c439 ( 110 0 ) capacitor c=0.126356f //x=8.46 //y=0.175
c440 ( 96 0 ) capacitor c=0.197064f //x=1.23 //y=0.18
c441 ( 93 0 ) capacitor c=0.181445f //x=5.13 //y=0.175
c442 ( 90 0 ) capacitor c=0.00509083f //x=19.73 //y=0.18
c443 ( 87 0 ) capacitor c=0.0232551f //x=19.797 //y=1.005
c444 ( 86 0 ) capacitor c=0.0129519f //x=19.8 //y=1.135
c445 ( 84 0 ) capacitor c=0.00509083f //x=16.47 //y=0.175
c446 ( 82 0 ) capacitor c=0.0188922f //x=16.467 //y=1.005
c447 ( 81 0 ) capacitor c=0.0127521f //x=16.47 //y=1.135
c448 ( 79 0 ) capacitor c=0.00509083f //x=13.14 //y=0.175
c449 ( 77 0 ) capacitor c=0.0188922f //x=13.137 //y=1.005
c450 ( 76 0 ) capacitor c=0.0127968f //x=13.14 //y=1.135
c451 ( 74 0 ) capacitor c=0.00509083f //x=9.74 //y=0.18
c452 ( 71 0 ) capacitor c=0.0188922f //x=9.807 //y=1.005
c453 ( 70 0 ) capacitor c=0.0127973f //x=9.81 //y=1.135
c454 ( 68 0 ) capacitor c=0.00509083f //x=6.48 //y=0.175
c455 ( 66 0 ) capacitor c=0.0235363f //x=6.477 //y=1.005
c456 ( 65 0 ) capacitor c=0.0138363f //x=6.48 //y=1.135
c457 ( 63 0 ) capacitor c=0.00509414f //x=1.565 //y=0.175
c458 ( 61 0 ) capacitor c=0.017081f //x=1.565 //y=1.145
c459 ( 58 0 ) capacitor c=0.102221f //x=21.58 //y=0.18
c460 ( 46 0 ) capacitor c=0.110954f //x=19.715 //y=0.175
c461 ( 36 0 ) capacitor c=0.112419f //x=16.385 //y=0.175
c462 ( 27 0 ) capacitor c=0.110896f //x=13.055 //y=0.175
c463 ( 19 0 ) capacitor c=0.112292f //x=9.725 //y=0.175
c464 ( 7 0 ) capacitor c=0.154867f //x=6.395 //y=0.175
c465 ( 6 0 ) capacitor c=0.0302305f //x=1.565 //y=1.015
c466 ( 2 0 ) capacitor c=0.0710427f //x=1.48 //y=0.175
r467 (  173 175 ) resistor r=25.8093 //w=0.367 //l=0.74 //layer=li \
 //thickness=0.1 //x=20.84 //y=0.175 //x2=21.58 //y2=0.175
r468 (  171 173 ) resistor r=38.7139 //w=0.367 //l=1.11 //layer=li \
 //thickness=0.1 //x=19.73 //y=0.175 //x2=20.84 //y2=0.175
r469 (  169 187 ) resistor r=5.29055 //w=0.35 //l=0.17 //layer=li \
 //thickness=0.1 //x=18.79 //y=0.175 //x2=18.62 //y2=0.175
r470 (  169 171 ) resistor r=32.7847 //w=0.367 //l=0.94 //layer=li \
 //thickness=0.1 //x=18.79 //y=0.175 //x2=19.73 //y2=0.175
r471 (  158 160 ) resistor r=38.7139 //w=0.367 //l=1.11 //layer=li \
 //thickness=0.1 //x=17.14 //y=0.175 //x2=18.25 //y2=0.175
r472 (  156 158 ) resistor r=38.7139 //w=0.367 //l=1.11 //layer=li \
 //thickness=0.1 //x=16.03 //y=0.175 //x2=17.14 //y2=0.175
r473 (  154 186 ) resistor r=5.29055 //w=0.35 //l=0.17 //layer=li \
 //thickness=0.1 //x=15.46 //y=0.175 //x2=15.29 //y2=0.175
r474 (  154 156 ) resistor r=19.8801 //w=0.367 //l=0.57 //layer=li \
 //thickness=0.1 //x=15.46 //y=0.175 //x2=16.03 //y2=0.175
r475 (  153 187 ) resistor r=5.29055 //w=0.35 //l=0.17 //layer=li \
 //thickness=0.1 //x=18.45 //y=0.175 //x2=18.62 //y2=0.175
r476 (  153 160 ) resistor r=6.97548 //w=0.367 //l=0.2 //layer=li \
 //thickness=0.1 //x=18.45 //y=0.175 //x2=18.25 //y2=0.175
r477 (  143 145 ) resistor r=38.7139 //w=0.367 //l=1.11 //layer=li \
 //thickness=0.1 //x=13.44 //y=0.175 //x2=14.55 //y2=0.175
r478 (  141 143 ) resistor r=38.7139 //w=0.367 //l=1.11 //layer=li \
 //thickness=0.1 //x=12.33 //y=0.175 //x2=13.44 //y2=0.175
r479 (  139 185 ) resistor r=5.29055 //w=0.35 //l=0.17 //layer=li \
 //thickness=0.1 //x=12.13 //y=0.175 //x2=11.96 //y2=0.175
r480 (  139 141 ) resistor r=6.97548 //w=0.367 //l=0.2 //layer=li \
 //thickness=0.1 //x=12.13 //y=0.175 //x2=12.33 //y2=0.175
r481 (  138 186 ) resistor r=5.29055 //w=0.35 //l=0.17 //layer=li \
 //thickness=0.1 //x=15.12 //y=0.175 //x2=15.29 //y2=0.175
r482 (  138 145 ) resistor r=19.8801 //w=0.367 //l=0.57 //layer=li \
 //thickness=0.1 //x=15.12 //y=0.175 //x2=14.55 //y2=0.175
r483 (  128 130 ) resistor r=38.7139 //w=0.367 //l=1.11 //layer=li \
 //thickness=0.1 //x=9.74 //y=0.175 //x2=10.85 //y2=0.175
r484 (  126 184 ) resistor r=5.29055 //w=0.35 //l=0.17 //layer=li \
 //thickness=0.1 //x=8.8 //y=0.175 //x2=8.63 //y2=0.175
r485 (  126 128 ) resistor r=32.7847 //w=0.367 //l=0.94 //layer=li \
 //thickness=0.1 //x=8.8 //y=0.175 //x2=9.74 //y2=0.175
r486 (  125 185 ) resistor r=5.29055 //w=0.35 //l=0.17 //layer=li \
 //thickness=0.1 //x=11.79 //y=0.175 //x2=11.96 //y2=0.175
r487 (  125 130 ) resistor r=32.7847 //w=0.367 //l=0.94 //layer=li \
 //thickness=0.1 //x=11.79 //y=0.175 //x2=10.85 //y2=0.175
r488 (  115 117 ) resistor r=38.7139 //w=0.367 //l=1.11 //layer=li \
 //thickness=0.1 //x=7.15 //y=0.175 //x2=8.26 //y2=0.175
r489 (  113 115 ) resistor r=38.7139 //w=0.367 //l=1.11 //layer=li \
 //thickness=0.1 //x=6.04 //y=0.175 //x2=7.15 //y2=0.175
r490 (  111 183 ) resistor r=5.29055 //w=0.35 //l=0.17 //layer=li \
 //thickness=0.1 //x=5.47 //y=0.175 //x2=5.3 //y2=0.175
r491 (  111 113 ) resistor r=19.8801 //w=0.367 //l=0.57 //layer=li \
 //thickness=0.1 //x=5.47 //y=0.175 //x2=6.04 //y2=0.175
r492 (  110 184 ) resistor r=5.29055 //w=0.35 //l=0.17 //layer=li \
 //thickness=0.1 //x=8.46 //y=0.175 //x2=8.63 //y2=0.175
r493 (  110 117 ) resistor r=6.97548 //w=0.367 //l=0.2 //layer=li \
 //thickness=0.1 //x=8.46 //y=0.175 //x2=8.26 //y2=0.175
r494 (  100 102 ) resistor r=38.7139 //w=0.367 //l=1.11 //layer=li \
 //thickness=0.1 //x=3.45 //y=0.175 //x2=4.56 //y2=0.175
r495 (  98 100 ) resistor r=38.7139 //w=0.367 //l=1.11 //layer=li \
 //thickness=0.1 //x=2.34 //y=0.175 //x2=3.45 //y2=0.175
r496 (  96 98 ) resistor r=38.7139 //w=0.367 //l=1.11 //layer=li \
 //thickness=0.1 //x=1.23 //y=0.175 //x2=2.34 //y2=0.175
r497 (  93 183 ) resistor r=5.29055 //w=0.35 //l=0.17 //layer=li \
 //thickness=0.1 //x=5.13 //y=0.175 //x2=5.3 //y2=0.175
r498 (  93 102 ) resistor r=19.8801 //w=0.367 //l=0.57 //layer=li \
 //thickness=0.1 //x=5.13 //y=0.175 //x2=4.56 //y2=0.175
r499 (  90 171 ) resistor r=3.1 //w=0.17 //l=0.51 //layer=mcon //count=3 \
 //x=19.73 //y=0.18 //x2=19.73 //y2=0.18
r500 (  86 193 ) resistor r=9.3 //w=0.17 //l=0.17 //layer=mcon //count=1 \
 //x=19.8 //y=1.135 //x2=19.8 //y2=1.135
r501 (  86 87 ) resistor r=0.0939994 //w=0.226 //l=0.13 //layer=m1 \
 //thickness=0.36 //x=19.797 //y=1.135 //x2=19.797 //y2=1.005
r502 (  81 192 ) resistor r=9.3 //w=0.17 //l=0.17 //layer=mcon //count=1 \
 //x=16.47 //y=1.135 //x2=16.47 //y2=1.135
r503 (  81 82 ) resistor r=0.0939994 //w=0.226 //l=0.13 //layer=m1 \
 //thickness=0.36 //x=16.467 //y=1.135 //x2=16.467 //y2=1.005
r504 (  76 191 ) resistor r=9.3 //w=0.17 //l=0.17 //layer=mcon //count=1 \
 //x=13.14 //y=1.135 //x2=13.14 //y2=1.135
r505 (  76 77 ) resistor r=0.0939994 //w=0.226 //l=0.13 //layer=m1 \
 //thickness=0.36 //x=13.137 //y=1.135 //x2=13.137 //y2=1.005
r506 (  74 128 ) resistor r=3.1 //w=0.17 //l=0.51 //layer=mcon //count=3 \
 //x=9.74 //y=0.18 //x2=9.74 //y2=0.18
r507 (  70 190 ) resistor r=9.3 //w=0.17 //l=0.17 //layer=mcon //count=1 \
 //x=9.81 //y=1.135 //x2=9.81 //y2=1.135
r508 (  70 71 ) resistor r=0.0939994 //w=0.226 //l=0.13 //layer=m1 \
 //thickness=0.36 //x=9.807 //y=1.135 //x2=9.807 //y2=1.005
r509 (  65 189 ) resistor r=9.3 //w=0.17 //l=0.17 //layer=mcon //count=1 \
 //x=6.48 //y=1.135 //x2=6.48 //y2=1.135
r510 (  65 66 ) resistor r=0.0939994 //w=0.226 //l=0.13 //layer=m1 \
 //thickness=0.36 //x=6.477 //y=1.135 //x2=6.477 //y2=1.005
r511 (  61 188 ) resistor r=9.3 //w=0.17 //l=0.17 //layer=mcon //count=1 \
 //x=1.565 //y=1.145 //x2=1.565 //y2=1.145
r512 (  58 175 ) resistor r=9.3 //w=0.17 //l=0.17 //layer=mcon //count=1 \
 //x=21.58 //y=0.18 //x2=21.58 //y2=0.18
r513 (  56 173 ) resistor r=3.1 //w=0.17 //l=0.51 //layer=mcon //count=3 \
 //x=20.84 //y=0.18 //x2=20.84 //y2=0.18
r514 (  56 58 ) resistor r=0.297428 //w=0.311 //l=0.74 //layer=m1 \
 //thickness=0.36 //x=20.84 //y=0.175 //x2=21.58 //y2=0.175
r515 (  54 90 ) resistor r=0.028033 //w=0.35 //l=0.085 //layer=m1 \
 //thickness=0.36 //x=19.885 //y=0.175 //x2=19.8 //y2=0.175
r516 (  54 56 ) resistor r=0.383842 //w=0.311 //l=0.955 //layer=m1 \
 //thickness=0.36 //x=19.885 //y=0.175 //x2=20.84 //y2=0.175
r517 (  52 90 ) resistor r=0.0413265 //w=0.7 //l=0.175 //layer=m1 \
 //thickness=0.36 //x=19.8 //y=0.35 //x2=19.8 //y2=0.175
r518 (  52 87 ) resistor r=0.625 //w=0.131 //l=0.655 //layer=m1 \
 //thickness=0.36 //x=19.8 //y=0.35 //x2=19.8 //y2=1.005
r519 (  51 160 ) resistor r=3.1 //w=0.17 //l=0.51 //layer=mcon //count=3 \
 //x=18.25 //y=0.18 //x2=18.25 //y2=0.18
r520 (  49 158 ) resistor r=3.1 //w=0.17 //l=0.51 //layer=mcon //count=3 \
 //x=17.14 //y=0.18 //x2=17.14 //y2=0.18
r521 (  49 51 ) resistor r=0.446141 //w=0.311 //l=1.11 //layer=m1 \
 //thickness=0.36 //x=17.14 //y=0.175 //x2=18.25 //y2=0.175
r522 (  47 84 ) resistor r=0.028033 //w=0.35 //l=0.085 //layer=m1 \
 //thickness=0.36 //x=16.555 //y=0.175 //x2=16.47 //y2=0.175
r523 (  47 49 ) resistor r=0.235129 //w=0.311 //l=0.585 //layer=m1 \
 //thickness=0.36 //x=16.555 //y=0.175 //x2=17.14 //y2=0.175
r524 (  46 90 ) resistor r=0.028033 //w=0.35 //l=0.085 //layer=m1 \
 //thickness=0.36 //x=19.715 //y=0.175 //x2=19.8 //y2=0.175
r525 (  46 51 ) resistor r=0.588826 //w=0.311 //l=1.465 //layer=m1 \
 //thickness=0.36 //x=19.715 //y=0.175 //x2=18.25 //y2=0.175
r526 (  44 84 ) resistor r=0.0413265 //w=0.7 //l=0.175 //layer=m1 \
 //thickness=0.36 //x=16.47 //y=0.35 //x2=16.47 //y2=0.175
r527 (  44 82 ) resistor r=0.625 //w=0.131 //l=0.655 //layer=m1 \
 //thickness=0.36 //x=16.47 //y=0.35 //x2=16.47 //y2=1.005
r528 (  43 156 ) resistor r=3.1 //w=0.17 //l=0.51 //layer=mcon //count=3 \
 //x=16.03 //y=0.18 //x2=16.03 //y2=0.18
r529 (  41 145 ) resistor r=3.1 //w=0.17 //l=0.51 //layer=mcon //count=3 \
 //x=14.55 //y=0.18 //x2=14.55 //y2=0.18
r530 (  41 43 ) resistor r=0.594855 //w=0.311 //l=1.48 //layer=m1 \
 //thickness=0.36 //x=14.55 //y=0.175 //x2=16.03 //y2=0.175
r531 (  39 143 ) resistor r=3.1 //w=0.17 //l=0.51 //layer=mcon //count=3 \
 //x=13.44 //y=0.18 //x2=13.44 //y2=0.18
r532 (  39 41 ) resistor r=0.446141 //w=0.311 //l=1.11 //layer=m1 \
 //thickness=0.36 //x=13.44 //y=0.175 //x2=14.55 //y2=0.175
r533 (  37 79 ) resistor r=0.028033 //w=0.35 //l=0.085 //layer=m1 \
 //thickness=0.36 //x=13.225 //y=0.175 //x2=13.14 //y2=0.175
r534 (  37 39 ) resistor r=0.0864148 //w=0.311 //l=0.215 //layer=m1 \
 //thickness=0.36 //x=13.225 //y=0.175 //x2=13.44 //y2=0.175
r535 (  36 84 ) resistor r=0.028033 //w=0.35 //l=0.085 //layer=m1 \
 //thickness=0.36 //x=16.385 //y=0.175 //x2=16.47 //y2=0.175
r536 (  36 43 ) resistor r=0.142685 //w=0.311 //l=0.355 //layer=m1 \
 //thickness=0.36 //x=16.385 //y=0.175 //x2=16.03 //y2=0.175
r537 (  34 79 ) resistor r=0.0413265 //w=0.7 //l=0.175 //layer=m1 \
 //thickness=0.36 //x=13.14 //y=0.35 //x2=13.14 //y2=0.175
r538 (  34 77 ) resistor r=0.625 //w=0.131 //l=0.655 //layer=m1 \
 //thickness=0.36 //x=13.14 //y=0.35 //x2=13.14 //y2=1.005
r539 (  33 141 ) resistor r=3.1 //w=0.17 //l=0.51 //layer=mcon //count=3 \
 //x=12.33 //y=0.18 //x2=12.33 //y2=0.18
r540 (  30 130 ) resistor r=3.1 //w=0.17 //l=0.51 //layer=mcon //count=3 \
 //x=10.85 //y=0.18 //x2=10.85 //y2=0.18
r541 (  28 74 ) resistor r=0.028033 //w=0.35 //l=0.085 //layer=m1 \
 //thickness=0.36 //x=9.895 //y=0.175 //x2=9.81 //y2=0.175
r542 (  28 30 ) resistor r=0.383842 //w=0.311 //l=0.955 //layer=m1 \
 //thickness=0.36 //x=9.895 //y=0.175 //x2=10.85 //y2=0.175
r543 (  27 79 ) resistor r=0.028033 //w=0.35 //l=0.085 //layer=m1 \
 //thickness=0.36 //x=13.055 //y=0.175 //x2=13.14 //y2=0.175
r544 (  27 33 ) resistor r=0.291399 //w=0.311 //l=0.725 //layer=m1 \
 //thickness=0.36 //x=13.055 //y=0.175 //x2=12.33 //y2=0.175
r545 (  25 74 ) resistor r=0.0413265 //w=0.7 //l=0.175 //layer=m1 \
 //thickness=0.36 //x=9.81 //y=0.35 //x2=9.81 //y2=0.175
r546 (  25 71 ) resistor r=0.625 //w=0.131 //l=0.655 //layer=m1 \
 //thickness=0.36 //x=9.81 //y=0.35 //x2=9.81 //y2=1.005
r547 (  24 117 ) resistor r=3.1 //w=0.17 //l=0.51 //layer=mcon //count=3 \
 //x=8.26 //y=0.18 //x2=8.26 //y2=0.18
r548 (  22 115 ) resistor r=3.1 //w=0.17 //l=0.51 //layer=mcon //count=3 \
 //x=7.15 //y=0.18 //x2=7.15 //y2=0.18
r549 (  22 24 ) resistor r=0.446141 //w=0.311 //l=1.11 //layer=m1 \
 //thickness=0.36 //x=7.15 //y=0.175 //x2=8.26 //y2=0.175
r550 (  20 68 ) resistor r=0.028033 //w=0.35 //l=0.085 //layer=m1 \
 //thickness=0.36 //x=6.565 //y=0.175 //x2=6.48 //y2=0.175
r551 (  20 22 ) resistor r=0.235129 //w=0.311 //l=0.585 //layer=m1 \
 //thickness=0.36 //x=6.565 //y=0.175 //x2=7.15 //y2=0.175
r552 (  19 74 ) resistor r=0.028033 //w=0.35 //l=0.085 //layer=m1 \
 //thickness=0.36 //x=9.725 //y=0.175 //x2=9.81 //y2=0.175
r553 (  19 24 ) resistor r=0.588826 //w=0.311 //l=1.465 //layer=m1 \
 //thickness=0.36 //x=9.725 //y=0.175 //x2=8.26 //y2=0.175
r554 (  17 68 ) resistor r=0.0413265 //w=0.7 //l=0.175 //layer=m1 \
 //thickness=0.36 //x=6.48 //y=0.35 //x2=6.48 //y2=0.175
r555 (  17 66 ) resistor r=0.625 //w=0.131 //l=0.655 //layer=m1 \
 //thickness=0.36 //x=6.48 //y=0.35 //x2=6.48 //y2=1.005
r556 (  16 113 ) resistor r=3.1 //w=0.17 //l=0.51 //layer=mcon //count=3 \
 //x=6.04 //y=0.18 //x2=6.04 //y2=0.18
r557 (  14 102 ) resistor r=3.1 //w=0.17 //l=0.51 //layer=mcon //count=3 \
 //x=4.56 //y=0.18 //x2=4.56 //y2=0.18
r558 (  14 16 ) resistor r=0.594855 //w=0.311 //l=1.48 //layer=m1 \
 //thickness=0.36 //x=4.56 //y=0.175 //x2=6.04 //y2=0.175
r559 (  12 100 ) resistor r=3.1 //w=0.17 //l=0.51 //layer=mcon //count=3 \
 //x=3.45 //y=0.18 //x2=3.45 //y2=0.18
r560 (  12 14 ) resistor r=0.446141 //w=0.311 //l=1.11 //layer=m1 \
 //thickness=0.36 //x=3.45 //y=0.175 //x2=4.56 //y2=0.175
r561 (  10 98 ) resistor r=3.1 //w=0.17 //l=0.51 //layer=mcon //count=3 \
 //x=2.34 //y=0.18 //x2=2.34 //y2=0.18
r562 (  10 12 ) resistor r=0.446141 //w=0.311 //l=1.11 //layer=m1 \
 //thickness=0.36 //x=2.34 //y=0.175 //x2=3.45 //y2=0.175
r563 (  8 63 ) resistor r=0.028033 //w=0.35 //l=0.085 //layer=m1 \
 //thickness=0.36 //x=1.65 //y=0.175 //x2=1.565 //y2=0.175
r564 (  8 10 ) resistor r=0.277331 //w=0.311 //l=0.69 //layer=m1 \
 //thickness=0.36 //x=1.65 //y=0.175 //x2=2.34 //y2=0.175
r565 (  7 68 ) resistor r=0.028033 //w=0.35 //l=0.085 //layer=m1 \
 //thickness=0.36 //x=6.395 //y=0.175 //x2=6.48 //y2=0.175
r566 (  7 16 ) resistor r=0.142685 //w=0.311 //l=0.355 //layer=m1 \
 //thickness=0.36 //x=6.395 //y=0.175 //x2=6.04 //y2=0.175
r567 (  6 61 ) resistor r=0.0942778 //w=0.221 //l=0.13 //layer=m1 \
 //thickness=0.36 //x=1.565 //y=1.015 //x2=1.565 //y2=1.145
r568 (  5 63 ) resistor r=0.0413265 //w=0.7 //l=0.175 //layer=m1 \
 //thickness=0.36 //x=1.565 //y=0.35 //x2=1.565 //y2=0.175
r569 (  5 6 ) resistor r=0.634542 //w=0.131 //l=0.665 //layer=m1 \
 //thickness=0.36 //x=1.565 //y=0.35 //x2=1.565 //y2=1.015
r570 (  4 96 ) resistor r=3.1 //w=0.17 //l=0.51 //layer=mcon //count=3 \
 //x=1.23 //y=0.18 //x2=1.23 //y2=0.18
r571 (  2 63 ) resistor r=0.028033 //w=0.35 //l=0.085 //layer=m1 \
 //thickness=0.36 //x=1.48 //y=0.175 //x2=1.565 //y2=0.175
r572 (  2 4 ) resistor r=0.0892857 //w=0.35 //l=0.25 //layer=m1 \
 //thickness=0.36 //x=1.48 //y=0.175 //x2=1.23 //y2=0.175
r573 (  1 33 ) resistor r=0.446141 //w=0.311 //l=1.11 //layer=m1 \
 //thickness=0.36 //x=11.22 //y=0.175 //x2=12.33 //y2=0.175
r574 (  1 30 ) resistor r=0.148714 //w=0.311 //l=0.37 //layer=m1 \
 //thickness=0.36 //x=11.22 //y=0.175 //x2=10.85 //y2=0.175
ends PM_DFFQNX1\%GND

subckt PM_DFFQNX1\%noxref_12 ( 1 5 9 13 17 35 )
c52 ( 35 0 ) capacitor c=0.076261f //x=0.945 //y=0.555
c53 ( 17 0 ) capacitor c=0.0259769f //x=2.935 //y=1.77
c54 ( 13 0 ) capacitor c=0.0153941f //x=2.935 //y=0.72
c55 ( 9 0 ) capacitor c=0.00772076f //x=2.05 //y=0.805
c56 ( 5 0 ) capacitor c=0.0211674f //x=1.965 //y=1.77
c57 ( 1 0 ) capacitor c=0.0109947f //x=1.08 //y=1.685
r58 (  18 35 ) resistor r=5.4201 //w=0.17 //l=0.103078 //layer=li \
 //thickness=0.1 //x=2.135 //y=1.77 //x2=2.05 //y2=1.81
r59 (  18 35 ) resistor r=27.3797 //w=0.187 //l=0.4 //layer=li //thickness=0.1 \
 //x=2.135 //y=1.77 //x2=2.535 //y2=1.77
r60 (  17 35 ) resistor r=0.751729 //w=0.17 //l=0.085 //layer=li \
 //thickness=0.1 //x=2.935 //y=1.77 //x2=3.02 //y2=1.77
r61 (  17 35 ) resistor r=27.3797 //w=0.187 //l=0.4 //layer=li //thickness=0.1 \
 //x=2.935 //y=1.77 //x2=2.535 //y2=1.77
r62 (  14 35 ) resistor r=3.57586 //w=0.17 //l=0.103078 //layer=li \
 //thickness=0.1 //x=2.135 //y=0.72 //x2=2.05 //y2=0.68
r63 (  14 35 ) resistor r=27.3797 //w=0.187 //l=0.4 //layer=li //thickness=0.1 \
 //x=2.135 //y=0.72 //x2=2.535 //y2=0.72
r64 (  13 35 ) resistor r=0.751729 //w=0.17 //l=0.085 //layer=li \
 //thickness=0.1 //x=2.935 //y=0.72 //x2=3.02 //y2=0.72
r65 (  13 35 ) resistor r=27.3797 //w=0.187 //l=0.4 //layer=li //thickness=0.1 \
 //x=2.935 //y=0.72 //x2=2.535 //y2=0.72
r66 (  10 35 ) resistor r=1.40859 //w=0.34 //l=0.125 //layer=li \
 //thickness=0.1 //x=2.05 //y=1.685 //x2=2.05 //y2=1.81
r67 (  10 35 ) resistor r=42.0963 //w=0.187 //l=0.615 //layer=li \
 //thickness=0.1 //x=2.05 //y=1.685 //x2=2.05 //y2=1.07
r68 (  9 35 ) resistor r=3.57586 //w=0.17 //l=0.125 //layer=li //thickness=0.1 \
 //x=2.05 //y=0.805 //x2=2.05 //y2=0.68
r69 (  9 35 ) resistor r=18.139 //w=0.187 //l=0.265 //layer=li //thickness=0.1 \
 //x=2.05 //y=0.805 //x2=2.05 //y2=1.07
r70 (  6 35 ) resistor r=3.57586 //w=0.17 //l=0.103078 //layer=li \
 //thickness=0.1 //x=1.165 //y=1.77 //x2=1.08 //y2=1.81
r71 (  6 35 ) resistor r=27.3797 //w=0.187 //l=0.4 //layer=li //thickness=0.1 \
 //x=1.165 //y=1.77 //x2=1.565 //y2=1.77
r72 (  5 35 ) resistor r=5.4201 //w=0.17 //l=0.103078 //layer=li \
 //thickness=0.1 //x=1.965 //y=1.77 //x2=2.05 //y2=1.81
r73 (  5 35 ) resistor r=27.3797 //w=0.187 //l=0.4 //layer=li //thickness=0.1 \
 //x=1.965 //y=1.77 //x2=1.565 //y2=1.77
r74 (  1 35 ) resistor r=3.57586 //w=0.17 //l=0.125 //layer=li //thickness=0.1 \
 //x=1.08 //y=1.685 //x2=1.08 //y2=1.81
r75 (  1 35 ) resistor r=42.0963 //w=0.187 //l=0.615 //layer=li \
 //thickness=0.1 //x=1.08 //y=1.685 //x2=1.08 //y2=1.07
ends PM_DFFQNX1\%noxref_12

subckt PM_DFFQNX1\%noxref_13 ( 1 5 9 10 13 17 29 )
c66 ( 29 0 ) capacitor c=0.0671084f //x=5.86 //y=0.545
c67 ( 17 0 ) capacitor c=0.0067865f //x=7.935 //y=0.795
c68 ( 13 0 ) capacitor c=0.0157877f //x=7.85 //y=0.71
c69 ( 10 0 ) capacitor c=0.00724577f //x=6.965 //y=1.675
c70 ( 9 0 ) capacitor c=0.00770028f //x=6.965 //y=0.795
c71 ( 5 0 ) capacitor c=0.0193892f //x=6.88 //y=1.76
c72 ( 1 0 ) capacitor c=0.00822695f //x=5.995 //y=1.675
r73 (  17 29 ) resistor r=3.57586 //w=0.17 //l=0.125 //layer=li \
 //thickness=0.1 //x=7.935 //y=0.795 //x2=7.935 //y2=0.67
r74 (  17 29 ) resistor r=18.139 //w=0.187 //l=0.265 //layer=li \
 //thickness=0.1 //x=7.935 //y=0.795 //x2=7.935 //y2=1.06
r75 (  14 29 ) resistor r=3.57586 //w=0.17 //l=0.103078 //layer=li \
 //thickness=0.1 //x=7.05 //y=0.71 //x2=6.965 //y2=0.67
r76 (  14 29 ) resistor r=27.3797 //w=0.187 //l=0.4 //layer=li //thickness=0.1 \
 //x=7.05 //y=0.71 //x2=7.45 //y2=0.71
r77 (  13 29 ) resistor r=3.57586 //w=0.17 //l=0.103078 //layer=li \
 //thickness=0.1 //x=7.85 //y=0.71 //x2=7.935 //y2=0.67
r78 (  13 29 ) resistor r=27.3797 //w=0.187 //l=0.4 //layer=li //thickness=0.1 \
 //x=7.85 //y=0.71 //x2=7.45 //y2=0.71
r79 (  10 29 ) resistor r=3.57586 //w=0.17 //l=0.125 //layer=li \
 //thickness=0.1 //x=6.965 //y=1.675 //x2=6.965 //y2=1.8
r80 (  10 29 ) resistor r=42.0963 //w=0.187 //l=0.615 //layer=li \
 //thickness=0.1 //x=6.965 //y=1.675 //x2=6.965 //y2=1.06
r81 (  9 29 ) resistor r=3.57586 //w=0.17 //l=0.125 //layer=li //thickness=0.1 \
 //x=6.965 //y=0.795 //x2=6.965 //y2=0.67
r82 (  9 29 ) resistor r=18.139 //w=0.187 //l=0.265 //layer=li //thickness=0.1 \
 //x=6.965 //y=0.795 //x2=6.965 //y2=1.06
r83 (  6 29 ) resistor r=3.57586 //w=0.17 //l=0.103078 //layer=li \
 //thickness=0.1 //x=6.08 //y=1.76 //x2=5.995 //y2=1.8
r84 (  6 29 ) resistor r=27.3797 //w=0.187 //l=0.4 //layer=li //thickness=0.1 \
 //x=6.08 //y=1.76 //x2=6.48 //y2=1.76
r85 (  5 29 ) resistor r=3.57586 //w=0.17 //l=0.103078 //layer=li \
 //thickness=0.1 //x=6.88 //y=1.76 //x2=6.965 //y2=1.8
r86 (  5 29 ) resistor r=27.3797 //w=0.187 //l=0.4 //layer=li //thickness=0.1 \
 //x=6.88 //y=1.76 //x2=6.48 //y2=1.76
r87 (  1 29 ) resistor r=3.57586 //w=0.17 //l=0.125 //layer=li //thickness=0.1 \
 //x=5.995 //y=1.675 //x2=5.995 //y2=1.8
r88 (  1 29 ) resistor r=42.0963 //w=0.187 //l=0.615 //layer=li \
 //thickness=0.1 //x=5.995 //y=1.675 //x2=5.995 //y2=1.06
ends PM_DFFQNX1\%noxref_13

subckt PM_DFFQNX1\%noxref_14 ( 1 5 9 10 13 17 29 )
c68 ( 29 0 ) capacitor c=0.0668051f //x=9.19 //y=0.545
c69 ( 17 0 ) capacitor c=0.0067865f //x=11.265 //y=0.795
c70 ( 13 0 ) capacitor c=0.0157426f //x=11.18 //y=0.71
c71 ( 10 0 ) capacitor c=0.00742952f //x=10.295 //y=1.675
c72 ( 9 0 ) capacitor c=0.00770028f //x=10.295 //y=0.795
c73 ( 5 0 ) capacitor c=0.0197708f //x=10.21 //y=1.76
c74 ( 1 0 ) capacitor c=0.00821716f //x=9.325 //y=1.675
r75 (  17 29 ) resistor r=3.57586 //w=0.17 //l=0.125 //layer=li \
 //thickness=0.1 //x=11.265 //y=0.795 //x2=11.265 //y2=0.67
r76 (  17 29 ) resistor r=18.139 //w=0.187 //l=0.265 //layer=li \
 //thickness=0.1 //x=11.265 //y=0.795 //x2=11.265 //y2=1.06
r77 (  14 29 ) resistor r=3.57586 //w=0.17 //l=0.103078 //layer=li \
 //thickness=0.1 //x=10.38 //y=0.71 //x2=10.295 //y2=0.67
r78 (  14 29 ) resistor r=27.3797 //w=0.187 //l=0.4 //layer=li //thickness=0.1 \
 //x=10.38 //y=0.71 //x2=10.78 //y2=0.71
r79 (  13 29 ) resistor r=3.57586 //w=0.17 //l=0.103078 //layer=li \
 //thickness=0.1 //x=11.18 //y=0.71 //x2=11.265 //y2=0.67
r80 (  13 29 ) resistor r=27.3797 //w=0.187 //l=0.4 //layer=li //thickness=0.1 \
 //x=11.18 //y=0.71 //x2=10.78 //y2=0.71
r81 (  10 29 ) resistor r=3.57586 //w=0.17 //l=0.125 //layer=li \
 //thickness=0.1 //x=10.295 //y=1.675 //x2=10.295 //y2=1.8
r82 (  10 29 ) resistor r=42.0963 //w=0.187 //l=0.615 //layer=li \
 //thickness=0.1 //x=10.295 //y=1.675 //x2=10.295 //y2=1.06
r83 (  9 29 ) resistor r=3.57586 //w=0.17 //l=0.125 //layer=li //thickness=0.1 \
 //x=10.295 //y=0.795 //x2=10.295 //y2=0.67
r84 (  9 29 ) resistor r=18.139 //w=0.187 //l=0.265 //layer=li //thickness=0.1 \
 //x=10.295 //y=0.795 //x2=10.295 //y2=1.06
r85 (  6 29 ) resistor r=3.57586 //w=0.17 //l=0.103078 //layer=li \
 //thickness=0.1 //x=9.41 //y=1.76 //x2=9.325 //y2=1.8
r86 (  6 29 ) resistor r=27.3797 //w=0.187 //l=0.4 //layer=li //thickness=0.1 \
 //x=9.41 //y=1.76 //x2=9.81 //y2=1.76
r87 (  5 29 ) resistor r=3.57586 //w=0.17 //l=0.103078 //layer=li \
 //thickness=0.1 //x=10.21 //y=1.76 //x2=10.295 //y2=1.8
r88 (  5 29 ) resistor r=27.3797 //w=0.187 //l=0.4 //layer=li //thickness=0.1 \
 //x=10.21 //y=1.76 //x2=9.81 //y2=1.76
r89 (  1 29 ) resistor r=3.57586 //w=0.17 //l=0.125 //layer=li //thickness=0.1 \
 //x=9.325 //y=1.675 //x2=9.325 //y2=1.8
r90 (  1 29 ) resistor r=42.0963 //w=0.187 //l=0.615 //layer=li \
 //thickness=0.1 //x=9.325 //y=1.675 //x2=9.325 //y2=1.06
ends PM_DFFQNX1\%noxref_14

subckt PM_DFFQNX1\%noxref_15 ( 1 5 9 10 13 17 29 )
c66 ( 29 0 ) capacitor c=0.0675014f //x=12.52 //y=0.545
c67 ( 17 0 ) capacitor c=0.0067865f //x=14.595 //y=0.795
c68 ( 13 0 ) capacitor c=0.0157877f //x=14.51 //y=0.71
c69 ( 10 0 ) capacitor c=0.00753446f //x=13.625 //y=1.675
c70 ( 9 0 ) capacitor c=0.00770028f //x=13.625 //y=0.795
c71 ( 5 0 ) capacitor c=0.0197745f //x=13.54 //y=1.76
c72 ( 1 0 ) capacitor c=0.00821716f //x=12.655 //y=1.675
r73 (  17 29 ) resistor r=3.57586 //w=0.17 //l=0.125 //layer=li \
 //thickness=0.1 //x=14.595 //y=0.795 //x2=14.595 //y2=0.67
r74 (  17 29 ) resistor r=18.139 //w=0.187 //l=0.265 //layer=li \
 //thickness=0.1 //x=14.595 //y=0.795 //x2=14.595 //y2=1.06
r75 (  14 29 ) resistor r=3.57586 //w=0.17 //l=0.103078 //layer=li \
 //thickness=0.1 //x=13.71 //y=0.71 //x2=13.625 //y2=0.67
r76 (  14 29 ) resistor r=27.3797 //w=0.187 //l=0.4 //layer=li //thickness=0.1 \
 //x=13.71 //y=0.71 //x2=14.11 //y2=0.71
r77 (  13 29 ) resistor r=3.57586 //w=0.17 //l=0.103078 //layer=li \
 //thickness=0.1 //x=14.51 //y=0.71 //x2=14.595 //y2=0.67
r78 (  13 29 ) resistor r=27.3797 //w=0.187 //l=0.4 //layer=li //thickness=0.1 \
 //x=14.51 //y=0.71 //x2=14.11 //y2=0.71
r79 (  10 29 ) resistor r=3.57586 //w=0.17 //l=0.125 //layer=li \
 //thickness=0.1 //x=13.625 //y=1.675 //x2=13.625 //y2=1.8
r80 (  10 29 ) resistor r=42.0963 //w=0.187 //l=0.615 //layer=li \
 //thickness=0.1 //x=13.625 //y=1.675 //x2=13.625 //y2=1.06
r81 (  9 29 ) resistor r=3.57586 //w=0.17 //l=0.125 //layer=li //thickness=0.1 \
 //x=13.625 //y=0.795 //x2=13.625 //y2=0.67
r82 (  9 29 ) resistor r=18.139 //w=0.187 //l=0.265 //layer=li //thickness=0.1 \
 //x=13.625 //y=0.795 //x2=13.625 //y2=1.06
r83 (  6 29 ) resistor r=3.57586 //w=0.17 //l=0.103078 //layer=li \
 //thickness=0.1 //x=12.74 //y=1.76 //x2=12.655 //y2=1.8
r84 (  6 29 ) resistor r=27.3797 //w=0.187 //l=0.4 //layer=li //thickness=0.1 \
 //x=12.74 //y=1.76 //x2=13.14 //y2=1.76
r85 (  5 29 ) resistor r=3.57586 //w=0.17 //l=0.103078 //layer=li \
 //thickness=0.1 //x=13.54 //y=1.76 //x2=13.625 //y2=1.8
r86 (  5 29 ) resistor r=27.3797 //w=0.187 //l=0.4 //layer=li //thickness=0.1 \
 //x=13.54 //y=1.76 //x2=13.14 //y2=1.76
r87 (  1 29 ) resistor r=3.57586 //w=0.17 //l=0.125 //layer=li //thickness=0.1 \
 //x=12.655 //y=1.675 //x2=12.655 //y2=1.8
r88 (  1 29 ) resistor r=42.0963 //w=0.187 //l=0.615 //layer=li \
 //thickness=0.1 //x=12.655 //y=1.675 //x2=12.655 //y2=1.06
ends PM_DFFQNX1\%noxref_15

subckt PM_DFFQNX1\%noxref_16 ( 1 5 9 10 13 17 29 )
c66 ( 29 0 ) capacitor c=0.0668023f //x=15.85 //y=0.545
c67 ( 17 0 ) capacitor c=0.0067865f //x=17.925 //y=0.795
c68 ( 13 0 ) capacitor c=0.0157377f //x=17.84 //y=0.71
c69 ( 10 0 ) capacitor c=0.00911004f //x=16.955 //y=1.675
c70 ( 9 0 ) capacitor c=0.00770028f //x=16.955 //y=0.795
c71 ( 5 0 ) capacitor c=0.0232545f //x=16.87 //y=1.76
c72 ( 1 0 ) capacitor c=0.00844422f //x=15.985 //y=1.675
r73 (  17 29 ) resistor r=3.57586 //w=0.17 //l=0.125 //layer=li \
 //thickness=0.1 //x=17.925 //y=0.795 //x2=17.925 //y2=0.67
r74 (  17 29 ) resistor r=18.139 //w=0.187 //l=0.265 //layer=li \
 //thickness=0.1 //x=17.925 //y=0.795 //x2=17.925 //y2=1.06
r75 (  14 29 ) resistor r=3.57586 //w=0.17 //l=0.103078 //layer=li \
 //thickness=0.1 //x=17.04 //y=0.71 //x2=16.955 //y2=0.67
r76 (  14 29 ) resistor r=27.3797 //w=0.187 //l=0.4 //layer=li //thickness=0.1 \
 //x=17.04 //y=0.71 //x2=17.44 //y2=0.71
r77 (  13 29 ) resistor r=3.57586 //w=0.17 //l=0.103078 //layer=li \
 //thickness=0.1 //x=17.84 //y=0.71 //x2=17.925 //y2=0.67
r78 (  13 29 ) resistor r=27.3797 //w=0.187 //l=0.4 //layer=li //thickness=0.1 \
 //x=17.84 //y=0.71 //x2=17.44 //y2=0.71
r79 (  10 29 ) resistor r=3.57586 //w=0.17 //l=0.125 //layer=li \
 //thickness=0.1 //x=16.955 //y=1.675 //x2=16.955 //y2=1.8
r80 (  10 29 ) resistor r=42.0963 //w=0.187 //l=0.615 //layer=li \
 //thickness=0.1 //x=16.955 //y=1.675 //x2=16.955 //y2=1.06
r81 (  9 29 ) resistor r=3.57586 //w=0.17 //l=0.125 //layer=li //thickness=0.1 \
 //x=16.955 //y=0.795 //x2=16.955 //y2=0.67
r82 (  9 29 ) resistor r=18.139 //w=0.187 //l=0.265 //layer=li //thickness=0.1 \
 //x=16.955 //y=0.795 //x2=16.955 //y2=1.06
r83 (  6 29 ) resistor r=3.57586 //w=0.17 //l=0.103078 //layer=li \
 //thickness=0.1 //x=16.07 //y=1.76 //x2=15.985 //y2=1.8
r84 (  6 29 ) resistor r=27.3797 //w=0.187 //l=0.4 //layer=li //thickness=0.1 \
 //x=16.07 //y=1.76 //x2=16.47 //y2=1.76
r85 (  5 29 ) resistor r=3.57586 //w=0.17 //l=0.103078 //layer=li \
 //thickness=0.1 //x=16.87 //y=1.76 //x2=16.955 //y2=1.8
r86 (  5 29 ) resistor r=27.3797 //w=0.187 //l=0.4 //layer=li //thickness=0.1 \
 //x=16.87 //y=1.76 //x2=16.47 //y2=1.76
r87 (  1 29 ) resistor r=3.57586 //w=0.17 //l=0.125 //layer=li //thickness=0.1 \
 //x=15.985 //y=1.675 //x2=15.985 //y2=1.8
r88 (  1 29 ) resistor r=42.0963 //w=0.187 //l=0.615 //layer=li \
 //thickness=0.1 //x=15.985 //y=1.675 //x2=15.985 //y2=1.06
ends PM_DFFQNX1\%noxref_16

subckt PM_DFFQNX1\%noxref_17 ( 1 5 9 10 13 17 29 )
c61 ( 29 0 ) capacitor c=0.0678344f //x=19.18 //y=0.545
c62 ( 17 0 ) capacitor c=0.00709791f //x=21.255 //y=0.795
c63 ( 13 0 ) capacitor c=0.0157477f //x=21.17 //y=0.71
c64 ( 10 0 ) capacitor c=0.00742703f //x=20.285 //y=1.675
c65 ( 9 0 ) capacitor c=0.00770028f //x=20.285 //y=0.795
c66 ( 5 0 ) capacitor c=0.0196427f //x=20.2 //y=1.76
c67 ( 1 0 ) capacitor c=0.00821716f //x=19.315 //y=1.675
r68 (  17 29 ) resistor r=3.57586 //w=0.17 //l=0.125 //layer=li \
 //thickness=0.1 //x=21.255 //y=0.795 //x2=21.255 //y2=0.67
r69 (  17 29 ) resistor r=18.139 //w=0.187 //l=0.265 //layer=li \
 //thickness=0.1 //x=21.255 //y=0.795 //x2=21.255 //y2=1.06
r70 (  14 29 ) resistor r=3.57586 //w=0.17 //l=0.103078 //layer=li \
 //thickness=0.1 //x=20.37 //y=0.71 //x2=20.285 //y2=0.67
r71 (  14 29 ) resistor r=27.3797 //w=0.187 //l=0.4 //layer=li //thickness=0.1 \
 //x=20.37 //y=0.71 //x2=20.77 //y2=0.71
r72 (  13 29 ) resistor r=3.57586 //w=0.17 //l=0.103078 //layer=li \
 //thickness=0.1 //x=21.17 //y=0.71 //x2=21.255 //y2=0.67
r73 (  13 29 ) resistor r=27.3797 //w=0.187 //l=0.4 //layer=li //thickness=0.1 \
 //x=21.17 //y=0.71 //x2=20.77 //y2=0.71
r74 (  10 29 ) resistor r=3.57586 //w=0.17 //l=0.125 //layer=li \
 //thickness=0.1 //x=20.285 //y=1.675 //x2=20.285 //y2=1.8
r75 (  10 29 ) resistor r=42.0963 //w=0.187 //l=0.615 //layer=li \
 //thickness=0.1 //x=20.285 //y=1.675 //x2=20.285 //y2=1.06
r76 (  9 29 ) resistor r=3.57586 //w=0.17 //l=0.125 //layer=li //thickness=0.1 \
 //x=20.285 //y=0.795 //x2=20.285 //y2=0.67
r77 (  9 29 ) resistor r=18.139 //w=0.187 //l=0.265 //layer=li //thickness=0.1 \
 //x=20.285 //y=0.795 //x2=20.285 //y2=1.06
r78 (  6 29 ) resistor r=3.57586 //w=0.17 //l=0.103078 //layer=li \
 //thickness=0.1 //x=19.4 //y=1.76 //x2=19.315 //y2=1.8
r79 (  6 29 ) resistor r=27.3797 //w=0.187 //l=0.4 //layer=li //thickness=0.1 \
 //x=19.4 //y=1.76 //x2=19.8 //y2=1.76
r80 (  5 29 ) resistor r=3.57586 //w=0.17 //l=0.103078 //layer=li \
 //thickness=0.1 //x=20.2 //y=1.76 //x2=20.285 //y2=1.8
r81 (  5 29 ) resistor r=27.3797 //w=0.187 //l=0.4 //layer=li //thickness=0.1 \
 //x=20.2 //y=1.76 //x2=19.8 //y2=1.76
r82 (  1 29 ) resistor r=3.57586 //w=0.17 //l=0.125 //layer=li //thickness=0.1 \
 //x=19.315 //y=1.675 //x2=19.315 //y2=1.8
r83 (  1 29 ) resistor r=42.0963 //w=0.187 //l=0.615 //layer=li \
 //thickness=0.1 //x=19.315 //y=1.675 //x2=19.315 //y2=1.06
ends PM_DFFQNX1\%noxref_17
