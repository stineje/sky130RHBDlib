// File: dffrnx1_pcell.spi.pex
// Created: Sun Mar 15 12:48:49 2026
// Program "Calibre xRC"
// Version "v2023.2_27.15"
// Nominal Temperature: 30C
// Circuit Temperature: 30C
//
simulator lang=spectre
subckt PM_DFFRNX1_PCELL\%noxref_1 ( 1 2 3 4 5 7 10 11 13 14 15 16 18 19 20 22 \
 23 30 32 35 38 44 47 50 53 54 56 57 58 60 62 64 65 72 75 84 89 97 105 122 131 \
 135 136 137 138 139 140 144 145 146 151 153 156 157 158 159 160 161 165 167 \
 170 171 176 177 182 191 194 196 197 198 )
c429 ( 194 0 ) capacitor c=0.00885916f //x=8.205 //y=0.915
c430 ( 191 0 ) capacitor c=0.0682508f //x=10.73 //y=4.7
c431 ( 182 0 ) capacitor c=0.0710579f //x=3.33 //y=4.7
c432 ( 177 0 ) capacitor c=0.0278202f //x=3.33 //y=1.915
c433 ( 176 0 ) capacitor c=0.0479324f //x=3.33 //y=2.08
c434 ( 171 0 ) capacitor c=0.0318956f //x=11.065 //y=1.21
c435 ( 170 0 ) capacitor c=0.0186809f //x=11.065 //y=0.865
c436 ( 167 0 ) capacitor c=0.0141821f //x=10.91 //y=1.365
c437 ( 165 0 ) capacitor c=0.0158553f //x=10.91 //y=0.71
c438 ( 161 0 ) capacitor c=0.0854195f //x=10.535 //y=1.915
c439 ( 160 0 ) capacitor c=0.0229235f //x=10.535 //y=1.52
c440 ( 159 0 ) capacitor c=0.0234359f //x=10.535 //y=1.21
c441 ( 158 0 ) capacitor c=0.0198759f //x=10.535 //y=0.865
c442 ( 157 0 ) capacitor c=0.0443175f //x=3.85 //y=1.26
c443 ( 156 0 ) capacitor c=0.0199703f //x=3.85 //y=0.915
c444 ( 153 0 ) capacitor c=0.0162526f //x=3.695 //y=1.415
c445 ( 151 0 ) capacitor c=0.0157807f //x=3.695 //y=0.76
c446 ( 146 0 ) capacitor c=0.0220935f //x=3.32 //y=1.57
c447 ( 145 0 ) capacitor c=0.0207489f //x=3.32 //y=1.26
c448 ( 144 0 ) capacitor c=0.0194091f //x=3.32 //y=0.915
c449 ( 140 0 ) capacitor c=0.110369f //x=11.07 //y=6.02
c450 ( 139 0 ) capacitor c=0.154619f //x=10.63 //y=6.02
c451 ( 138 0 ) capacitor c=0.159671f //x=3.51 //y=6.02
c452 ( 137 0 ) capacitor c=0.110208f //x=3.07 //y=6.02
c453 ( 131 0 ) capacitor c=8.13451e-19 //x=10.73 //y=4.7
c454 ( 122 0 ) capacitor c=7.85889e-19 //x=10.73 //y=2.08
c455 ( 105 0 ) capacitor c=0.0292634f //x=8.1 //y=5.38
c456 ( 97 0 ) capacitor c=0.029137f //x=7.22 //y=5.38
c457 ( 89 0 ) capacitor c=0.0278099f //x=6.34 //y=5.38
c458 ( 84 0 ) capacitor c=7.74199e-19 //x=3.33 //y=4.7
c459 ( 75 0 ) capacitor c=0.00101179f //x=3.33 //y=2.08
c460 ( 72 0 ) capacitor c=5.96651e-19 //x=10.73 //y=3.33
c461 ( 65 0 ) capacitor c=0.057578f //x=9.045 //y=3.33
c462 ( 64 0 ) capacitor c=0.0258251f //x=10.57 //y=3.33
c463 ( 62 0 ) capacitor c=0.00710937f //x=6.14 //y=3.315
c464 ( 60 0 ) capacitor c=0.0381622f //x=5.54 //y=3.33
c465 ( 58 0 ) capacitor c=0.0188644f //x=4.29 //y=3.32
c466 ( 57 0 ) capacitor c=0.00331832f //x=3.49 //y=3.33
c467 ( 56 0 ) capacitor c=0.00718343f //x=3.69 //y=3.33
c468 ( 54 0 ) capacitor c=0.0268056f //x=10.732 //y=4.56
c469 ( 53 0 ) capacitor c=0.00611114f //x=10.73 //y=4.7
c470 ( 50 0 ) capacitor c=0.00463527f //x=10.73 //y=2.08
c471 ( 47 0 ) capacitor c=0.0161834f //x=10.73 //y=3.33
c472 ( 44 0 ) capacitor c=0.0170515f //x=8.88 //y=3.33
c473 ( 38 0 ) capacitor c=0.00112339f //x=8.1 //y=5.155
c474 ( 35 0 ) capacitor c=0.00824259f //x=7.22 //y=5.155
c475 ( 32 0 ) capacitor c=0.0111234f //x=6.342 //y=5.155
c476 ( 30 0 ) capacitor c=0.0148558f //x=3.33 //y=3.33
c477 ( 23 0 ) capacitor c=0.0133354f //x=10.73 //y=3.49
c478 ( 22 0 ) capacitor c=0.0282347f //x=10.73 //y=3.17
c479 ( 20 0 ) capacitor c=0.0423878f //x=8.88 //y=5.07
c480 ( 19 0 ) capacitor c=0.0130115f //x=8.88 //y=3.49
c481 ( 18 0 ) capacitor c=0.0411393f //x=8.88 //y=3.17
c482 ( 16 0 ) capacitor c=0.00493487f //x=8.48 //y=1.665
c483 ( 15 0 ) capacitor c=0.012936f //x=8.795 //y=1.665
c484 ( 14 0 ) capacitor c=0.0136149f //x=8.395 //y=1.58
c485 ( 13 0 ) capacitor c=0.0112307f //x=8.395 //y=1.125
c486 ( 11 0 ) capacitor c=0.023884f //x=8.795 //y=5.155
c487 ( 10 0 ) capacitor c=0.00906713f //x=8.1 //y=5.38
c488 ( 7 0 ) capacitor c=0.019596f //x=7.985 //y=5.155
c489 ( 5 0 ) capacitor c=0.0153086f //x=7.1 //y=5.155
c490 ( 4 0 ) capacitor c=0.0286297f //x=3.33 //y=4.57
c491 ( 3 0 ) capacitor c=0.0128762f //x=3.33 //y=3.49
c492 ( 2 0 ) capacitor c=0.0274817f //x=3.33 //y=3.17
c493 ( 1 0 ) capacitor c=0.00685053f //x=3.33 //y=2.195
r494 (  189 191 ) resistor r=20.6867 //w=0.233 //l=0.1 //layer=ply \
 //thickness=0.18 //x=10.63 //y=4.7 //x2=10.73 //y2=4.7
r495 (  176 177 ) resistor r=52.7279 //w=0.214 //l=0.165 //layer=ply \
 //thickness=0.18 //x=3.33 //y=2.08 //x2=3.33 //y2=1.915
r496 (  172 191 ) resistor r=70.3348 //w=0.233 //l=0.414367 //layer=ply \
 //thickness=0.18 //x=11.07 //y=4.865 //x2=10.73 //y2=4.7
r497 (  171 193 ) resistor r=45.1352 //w=0.168 //l=0.173853 //layer=ply \
 //thickness=0.18 //x=11.065 //y=1.21 //x2=11.025 //y2=1.365
r498 (  170 192 ) resistor r=45.1352 //w=0.168 //l=0.173853 //layer=ply \
 //thickness=0.18 //x=11.065 //y=0.865 //x2=11.025 //y2=0.71
r499 (  170 171 ) resistor r=176.904 //w=0.094 //l=0.345 //layer=ply \
 //thickness=0.18 //x=11.065 //y=0.865 //x2=11.065 //y2=1.21
r500 (  168 188 ) resistor r=10.701 //w=0.21 //l=0.115 //layer=ply \
 //thickness=0.18 //x=10.69 //y=1.365 //x2=10.575 //y2=1.365
r501 (  167 193 ) resistor r=5.52526 //w=0.168 //l=0.115 //layer=ply \
 //thickness=0.18 //x=10.91 //y=1.365 //x2=11.025 //y2=1.365
r502 (  166 187 ) resistor r=5.52526 //w=0.168 //l=0.115 //layer=ply \
 //thickness=0.18 //x=10.69 //y=0.71 //x2=10.575 //y2=0.71
r503 (  165 192 ) resistor r=5.52526 //w=0.168 //l=0.115 //layer=ply \
 //thickness=0.18 //x=10.91 //y=0.71 //x2=11.025 //y2=0.71
r504 (  165 166 ) resistor r=112.809 //w=0.094 //l=0.22 //layer=ply \
 //thickness=0.18 //x=10.91 //y=0.71 //x2=10.69 //y2=0.71
r505 (  162 189 ) resistor r=13.0941 //w=0.233 //l=0.165 //layer=ply \
 //thickness=0.18 //x=10.63 //y=4.865 //x2=10.63 //y2=4.7
r506 (  161 186 ) resistor r=34.8111 //w=0.27 //l=0.264953 //layer=ply \
 //thickness=0.18 //x=10.535 //y=1.915 //x2=10.73 //y2=2.08
r507 (  160 188 ) resistor r=39.5823 //w=0.21 //l=0.173853 //layer=ply \
 //thickness=0.18 //x=10.535 //y=1.52 //x2=10.575 //y2=1.365
r508 (  160 161 ) resistor r=202.543 //w=0.094 //l=0.395 //layer=ply \
 //thickness=0.18 //x=10.535 //y=1.52 //x2=10.535 //y2=1.915
r509 (  159 188 ) resistor r=39.5823 //w=0.21 //l=0.173853 //layer=ply \
 //thickness=0.18 //x=10.535 //y=1.21 //x2=10.575 //y2=1.365
r510 (  158 187 ) resistor r=45.1352 //w=0.168 //l=0.173853 //layer=ply \
 //thickness=0.18 //x=10.535 //y=0.865 //x2=10.575 //y2=0.71
r511 (  158 159 ) resistor r=176.904 //w=0.094 //l=0.345 //layer=ply \
 //thickness=0.18 //x=10.535 //y=0.865 //x2=10.535 //y2=1.21
r512 (  157 184 ) resistor r=45.1352 //w=0.168 //l=0.173853 //layer=ply \
 //thickness=0.18 //x=3.85 //y=1.26 //x2=3.81 //y2=1.415
r513 (  156 183 ) resistor r=45.1352 //w=0.168 //l=0.173853 //layer=ply \
 //thickness=0.18 //x=3.85 //y=0.915 //x2=3.81 //y2=0.76
r514 (  156 157 ) resistor r=176.904 //w=0.094 //l=0.345 //layer=ply \
 //thickness=0.18 //x=3.85 //y=0.915 //x2=3.85 //y2=1.26
r515 (  154 180 ) resistor r=10.701 //w=0.21 //l=0.115 //layer=ply \
 //thickness=0.18 //x=3.475 //y=1.415 //x2=3.36 //y2=1.415
r516 (  153 184 ) resistor r=5.52526 //w=0.168 //l=0.115 //layer=ply \
 //thickness=0.18 //x=3.695 //y=1.415 //x2=3.81 //y2=1.415
r517 (  152 179 ) resistor r=5.52526 //w=0.168 //l=0.115 //layer=ply \
 //thickness=0.18 //x=3.475 //y=0.76 //x2=3.36 //y2=0.76
r518 (  151 183 ) resistor r=5.52526 //w=0.168 //l=0.115 //layer=ply \
 //thickness=0.18 //x=3.695 //y=0.76 //x2=3.81 //y2=0.76
r519 (  151 152 ) resistor r=112.809 //w=0.094 //l=0.22 //layer=ply \
 //thickness=0.18 //x=3.695 //y=0.76 //x2=3.475 //y2=0.76
r520 (  148 182 ) resistor r=37.236 //w=0.233 //l=0.249199 //layer=ply \
 //thickness=0.18 //x=3.51 //y=4.865 //x2=3.33 //y2=4.7
r521 (  146 180 ) resistor r=39.5823 //w=0.21 //l=0.173853 //layer=ply \
 //thickness=0.18 //x=3.32 //y=1.57 //x2=3.36 //y2=1.415
r522 (  146 177 ) resistor r=176.904 //w=0.094 //l=0.345 //layer=ply \
 //thickness=0.18 //x=3.32 //y=1.57 //x2=3.32 //y2=1.915
r523 (  145 180 ) resistor r=39.5823 //w=0.21 //l=0.173853 //layer=ply \
 //thickness=0.18 //x=3.32 //y=1.26 //x2=3.36 //y2=1.415
r524 (  144 179 ) resistor r=45.1352 //w=0.168 //l=0.173853 //layer=ply \
 //thickness=0.18 //x=3.32 //y=0.915 //x2=3.36 //y2=0.76
r525 (  144 145 ) resistor r=176.904 //w=0.094 //l=0.345 //layer=ply \
 //thickness=0.18 //x=3.32 //y=0.915 //x2=3.32 //y2=1.26
r526 (  141 182 ) resistor r=53.7854 //w=0.233 //l=0.332415 //layer=ply \
 //thickness=0.18 //x=3.07 //y=4.865 //x2=3.33 //y2=4.7
r527 (  140 172 ) resistor r=592.245 //w=0.094 //l=1.155 //layer=ply \
 //thickness=0.18 //x=11.07 //y=6.02 //x2=11.07 //y2=4.865
r528 (  139 162 ) resistor r=592.245 //w=0.094 //l=1.155 //layer=ply \
 //thickness=0.18 //x=10.63 //y=6.02 //x2=10.63 //y2=4.865
r529 (  138 148 ) resistor r=592.245 //w=0.094 //l=1.155 //layer=ply \
 //thickness=0.18 //x=3.51 //y=6.02 //x2=3.51 //y2=4.865
r530 (  137 141 ) resistor r=592.245 //w=0.094 //l=1.155 //layer=ply \
 //thickness=0.18 //x=3.07 //y=6.02 //x2=3.07 //y2=4.865
r531 (  136 167 ) resistor r=56.4043 //w=0.094 //l=0.11 //layer=ply \
 //thickness=0.18 //x=10.8 //y=1.365 //x2=10.91 //y2=1.365
r532 (  136 168 ) resistor r=56.4043 //w=0.094 //l=0.11 //layer=ply \
 //thickness=0.18 //x=10.8 //y=1.365 //x2=10.69 //y2=1.365
r533 (  135 153 ) resistor r=56.4043 //w=0.094 //l=0.11 //layer=ply \
 //thickness=0.18 //x=3.585 //y=1.415 //x2=3.695 //y2=1.415
r534 (  135 154 ) resistor r=56.4043 //w=0.094 //l=0.11 //layer=ply \
 //thickness=0.18 //x=3.585 //y=1.415 //x2=3.475 //y2=1.415
r535 (  131 191 ) resistor r=152 //w=0.17 //l=0.17 //layer=licon //count=1 \
 //x=10.73 //y=4.7 //x2=10.73 //y2=4.7
r536 (  122 186 ) resistor r=152 //w=0.17 //l=0.17 //layer=licon //count=1 \
 //x=10.73 //y=2.08 //x2=10.73 //y2=2.08
r537 (  105 198 ) resistor r=23.615 //w=0.187 //l=0.345 //layer=li \
 //thickness=0.1 //x=8.1 //y=5.38 //x2=8.1 //y2=5.725
r538 (  97 197 ) resistor r=23.615 //w=0.187 //l=0.345 //layer=li \
 //thickness=0.1 //x=7.22 //y=5.38 //x2=7.22 //y2=5.725
r539 (  89 196 ) resistor r=23.615 //w=0.187 //l=0.345 //layer=li \
 //thickness=0.1 //x=6.34 //y=5.38 //x2=6.34 //y2=5.725
r540 (  84 182 ) resistor r=152 //w=0.17 //l=0.17 //layer=licon //count=1 \
 //x=3.33 //y=4.7 //x2=3.33 //y2=4.7
r541 (  75 176 ) resistor r=152 //w=0.17 //l=0.17 //layer=licon //count=1 \
 //x=3.33 //y=2.08 //x2=3.33 //y2=2.08
r542 (  65 70 ) resistor r=0.108234 //w=0.187 //l=0.16 //layer=m2 \
 //thickness=0.36 //x=9.045 //y=3.33 //x2=8.885 //y2=3.33
r543 (  64 72 ) resistor r=0.10734 //w=0.281 //l=0.16 //layer=m2 \
 //thickness=0.36 //x=10.57 //y=3.33 //x2=10.73 //y2=3.33
r544 (  64 65 ) resistor r=1.45515 //w=0.131 //l=1.525 //layer=m2 \
 //thickness=0.36 //x=10.57 //y=3.33 //x2=9.045 //y2=3.33
r545 (  62 70 ) resistor r=1.83617 //w=0.187 //l=2.75249 //layer=m2 \
 //thickness=0.36 //x=6.14 //y=3.315 //x2=8.885 //y2=3.33
r546 (  62 63 ) resistor r=0.410305 //w=0.131 //l=0.43 //layer=m2 \
 //thickness=0.36 //x=6.14 //y=3.315 //x2=5.71 //y2=3.315
r547 (  60 63 ) resistor r=0.125 //w=0.17 //l=0.177341 //layer=m2 \
 //thickness=0.36 //x=5.54 //y=3.33 //x2=5.71 //y2=3.315
r548 (  60 61 ) resistor r=0.949427 //w=0.131 //l=0.995 //layer=m2 \
 //thickness=0.36 //x=5.54 //y=3.33 //x2=4.545 //y2=3.33
r549 (  58 61 ) resistor r=0.1875 //w=0.17 //l=0.259952 //layer=m2 \
 //thickness=0.36 //x=4.29 //y=3.32 //x2=4.545 //y2=3.33
r550 (  58 59 ) resistor r=0.410305 //w=0.131 //l=0.43 //layer=m2 \
 //thickness=0.36 //x=4.29 //y=3.32 //x2=3.86 //y2=3.32
r551 (  57 67 ) resistor r=0.10734 //w=0.281 //l=0.16 //layer=m2 \
 //thickness=0.36 //x=3.49 //y=3.33 //x2=3.33 //y2=3.33
r552 (  56 59 ) resistor r=0.125 //w=0.17 //l=0.174929 //layer=m2 \
 //thickness=0.36 //x=3.69 //y=3.33 //x2=3.86 //y2=3.32
r553 (  56 57 ) resistor r=0.19084 //w=0.131 //l=0.2 //layer=m2 \
 //thickness=0.36 //x=3.69 //y=3.33 //x2=3.49 //y2=3.33
r554 (  53 131 ) resistor r=9.3 //w=0.17 //l=0.17 //layer=mcon //count=1 \
 //x=10.73 //y=4.7 //x2=10.73 //y2=4.7
r555 (  53 54 ) resistor r=0.103207 //w=0.196 //l=0.14 //layer=m1 \
 //thickness=0.36 //x=10.732 //y=4.7 //x2=10.732 //y2=4.56
r556 (  50 122 ) resistor r=9.3 //w=0.17 //l=0.17 //layer=mcon //count=1 \
 //x=10.73 //y=2.08 //x2=10.73 //y2=2.08
r557 (  47 72 ) resistor r=4.5 //w=0.15 //l=0.15 //layer=via1 //count=1 \
 //x=10.73 //y=3.33 //x2=10.73 //y2=3.33
r558 (  44 70 ) resistor r=4.5 //w=0.15 //l=0.15 //layer=via1 //count=1 \
 //x=8.885 //y=3.33 //x2=8.885 //y2=3.33
r559 (  42 194 ) resistor r=9.3 //w=0.17 //l=0.17 //layer=mcon //count=1 \
 //x=8.395 //y=1.01 //x2=8.395 //y2=1.01
r560 (  40 105 ) resistor r=9.3 //w=0.17 //l=0.17 //layer=mcon //count=1 \
 //x=8.1 //y=5.38 //x2=8.1 //y2=5.38
r561 (  37 97 ) resistor r=9.3 //w=0.17 //l=0.17 //layer=mcon //count=1 \
 //x=7.22 //y=5.38 //x2=7.22 //y2=5.38
r562 (  35 37 ) resistor r=0.121228 //w=0.232 //l=0.225 //layer=m1 \
 //thickness=0.36 //x=7.22 //y=5.155 //x2=7.22 //y2=5.38
r563 (  34 89 ) resistor r=9.3 //w=0.17 //l=0.17 //layer=mcon //count=1 \
 //x=6.34 //y=5.38 //x2=6.34 //y2=5.38
r564 (  32 34 ) resistor r=0.129608 //w=0.217 //l=0.225 //layer=m1 \
 //thickness=0.36 //x=6.342 //y=5.155 //x2=6.342 //y2=5.38
r565 (  30 67 ) resistor r=4.5 //w=0.15 //l=0.15 //layer=via1 //count=1 \
 //x=3.33 //y=3.33 //x2=3.33 //y2=3.33
r566 (  28 84 ) resistor r=9.3 //w=0.17 //l=0.17 //layer=mcon //count=1 \
 //x=3.33 //y=4.7 //x2=3.33 //y2=4.7
r567 (  26 75 ) resistor r=9.3 //w=0.17 //l=0.17 //layer=mcon //count=1 \
 //x=3.33 //y=2.08 //x2=3.33 //y2=2.08
r568 (  23 47 ) resistor r=0.0911593 //w=0.376 //l=0.184608 //layer=m1 \
 //thickness=0.36 //x=10.73 //y=3.49 //x2=10.677 //y2=3.33
r569 (  23 54 ) resistor r=1.02099 //w=0.131 //l=1.07 //layer=m1 \
 //thickness=0.36 //x=10.73 //y=3.49 //x2=10.73 //y2=4.56
r570 (  22 47 ) resistor r=0.0911593 //w=0.376 //l=0.184608 //layer=m1 \
 //thickness=0.36 //x=10.73 //y=3.17 //x2=10.677 //y2=3.33
r571 (  21 50 ) resistor r=0.0933015 //w=0.201 //l=0.125 //layer=m1 \
 //thickness=0.36 //x=10.73 //y=2.205 //x2=10.73 //y2=2.08
r572 (  21 22 ) resistor r=0.920802 //w=0.131 //l=0.965 //layer=m1 \
 //thickness=0.36 //x=10.73 //y=2.205 //x2=10.73 //y2=3.17
r573 (  19 44 ) resistor r=0.0910802 //w=0.374 //l=0.185472 //layer=m1 \
 //thickness=0.36 //x=8.88 //y=3.49 //x2=8.935 //y2=3.33
r574 (  19 20 ) resistor r=1.50763 //w=0.131 //l=1.58 //layer=m1 \
 //thickness=0.36 //x=8.88 //y=3.49 //x2=8.88 //y2=5.07
r575 (  18 44 ) resistor r=0.0910802 //w=0.374 //l=0.185472 //layer=m1 \
 //thickness=0.36 //x=8.88 //y=3.17 //x2=8.935 //y2=3.33
r576 (  17 18 ) resistor r=1.35496 //w=0.131 //l=1.42 //layer=m1 \
 //thickness=0.36 //x=8.88 //y=1.75 //x2=8.88 //y2=3.17
r577 (  15 17 ) resistor r=0.0698411 //w=0.17 //l=0.120208 //layer=m1 \
 //thickness=0.36 //x=8.795 //y=1.665 //x2=8.88 //y2=1.75
r578 (  15 16 ) resistor r=0.300573 //w=0.131 //l=0.315 //layer=m1 \
 //thickness=0.36 //x=8.795 //y=1.665 //x2=8.48 //y2=1.665
r579 (  14 16 ) resistor r=0.0698411 //w=0.17 //l=0.120208 //layer=m1 \
 //thickness=0.36 //x=8.395 //y=1.58 //x2=8.48 //y2=1.665
r580 (  13 42 ) resistor r=0.0717383 //w=0.224 //l=0.115 //layer=m1 \
 //thickness=0.36 //x=8.395 //y=1.125 //x2=8.395 //y2=1.01
r581 (  13 14 ) resistor r=0.43416 //w=0.131 //l=0.455 //layer=m1 \
 //thickness=0.36 //x=8.395 //y=1.125 //x2=8.395 //y2=1.58
r582 (  12 38 ) resistor r=0.0675342 //w=0.23 //l=0.115 //layer=m1 \
 //thickness=0.36 //x=8.215 //y=5.155 //x2=8.1 //y2=5.155
r583 (  11 20 ) resistor r=0.0698411 //w=0.17 //l=0.120208 //layer=m1 \
 //thickness=0.36 //x=8.795 //y=5.155 //x2=8.88 //y2=5.07
r584 (  11 12 ) resistor r=0.553435 //w=0.131 //l=0.58 //layer=m1 \
 //thickness=0.36 //x=8.795 //y=5.155 //x2=8.215 //y2=5.155
r585 (  10 40 ) resistor r=0.00118313 //w=0.23 //layer=m1 //thickness=0.36 \
 //x=8.1 //y=5.38 //x2=8.1 //y2=5.38
r586 (  9 38 ) resistor r=0.002872 //w=0.34 //l=0.085 //layer=m1 \
 //thickness=0.36 //x=8.1 //y=5.24 //x2=8.1 //y2=5.155
r587 (  9 10 ) resistor r=0.091623 //w=0.191 //l=0.14 //layer=m1 \
 //thickness=0.36 //x=8.1 //y=5.24 //x2=8.1 //y2=5.38
r588 (  8 35 ) resistor r=0.0262263 //w=0.232 //l=0.12 //layer=m1 \
 //thickness=0.36 //x=7.34 //y=5.155 //x2=7.22 //y2=5.155
r589 (  7 38 ) resistor r=0.0675342 //w=0.23 //l=0.115 //layer=m1 \
 //thickness=0.36 //x=7.985 //y=5.155 //x2=8.1 //y2=5.155
r590 (  7 8 ) resistor r=0.615458 //w=0.131 //l=0.645 //layer=m1 \
 //thickness=0.36 //x=7.985 //y=5.155 //x2=7.34 //y2=5.155
r591 (  6 32 ) resistor r=0.0222262 //w=0.217 //l=0.118 //layer=m1 \
 //thickness=0.36 //x=6.46 //y=5.155 //x2=6.342 //y2=5.155
r592 (  5 35 ) resistor r=0.0262263 //w=0.232 //l=0.12 //layer=m1 \
 //thickness=0.36 //x=7.1 //y=5.155 //x2=7.22 //y2=5.155
r593 (  5 6 ) resistor r=0.610687 //w=0.131 //l=0.64 //layer=m1 \
 //thickness=0.36 //x=7.1 //y=5.155 //x2=6.46 //y2=5.155
r594 (  4 28 ) resistor r=0.0801089 //w=0.224 //l=0.13 //layer=m1 \
 //thickness=0.36 //x=3.33 //y=4.57 //x2=3.33 //y2=4.7
r595 (  3 30 ) resistor r=0.0911593 //w=0.376 //l=0.184174 //layer=m1 \
 //thickness=0.36 //x=3.33 //y=3.49 //x2=3.382 //y2=3.33
r596 (  3 4 ) resistor r=1.03053 //w=0.131 //l=1.08 //layer=m1 \
 //thickness=0.36 //x=3.33 //y=3.49 //x2=3.33 //y2=4.57
r597 (  2 30 ) resistor r=0.0911593 //w=0.376 //l=0.184174 //layer=m1 \
 //thickness=0.36 //x=3.33 //y=3.17 //x2=3.382 //y2=3.33
r598 (  1 26 ) resistor r=0.0719237 //w=0.222 //l=0.115 //layer=m1 \
 //thickness=0.36 //x=3.33 //y=2.195 //x2=3.33 //y2=2.08
r599 (  1 2 ) resistor r=0.930344 //w=0.131 //l=0.975 //layer=m1 \
 //thickness=0.36 //x=3.33 //y=2.195 //x2=3.33 //y2=3.17
ends PM_DFFRNX1_PCELL\%noxref_1

subckt PM_DFFRNX1_PCELL\%noxref_2 ( 3 8 9 11 12 14 15 16 17 18 19 20 23 24 27 \
 29 32 36 48 50 51 54 62 79 88 92 93 94 95 96 97 98 99 101 107 108 109 110 122 \
 124 125 )
c272 ( 122 0 ) capacitor c=0.00878249f //x=11.58 //y=0.905
c273 ( 110 0 ) capacitor c=0.0612936f //x=14.335 //y=4.79
c274 ( 109 0 ) capacitor c=0.0376642f //x=14.625 //y=4.79
c275 ( 108 0 ) capacitor c=0.0346489f //x=14.29 //y=1.22
c276 ( 107 0 ) capacitor c=0.018692f //x=14.29 //y=0.875
c277 ( 101 0 ) capacitor c=0.0137077f //x=14.135 //y=1.375
c278 ( 99 0 ) capacitor c=0.0158585f //x=14.135 //y=0.72
c279 ( 98 0 ) capacitor c=0.101012f //x=13.76 //y=1.915
c280 ( 97 0 ) capacitor c=0.0229444f //x=13.76 //y=1.53
c281 ( 96 0 ) capacitor c=0.0234359f //x=13.76 //y=1.22
c282 ( 95 0 ) capacitor c=0.019815f //x=13.76 //y=0.875
c283 ( 94 0 ) capacitor c=0.110208f //x=14.7 //y=6.02
c284 ( 93 0 ) capacitor c=0.158957f //x=14.26 //y=6.02
c285 ( 88 0 ) capacitor c=0.0014751f //x=14.06 //y=4.7
c286 ( 79 0 ) capacitor c=0.0012618f //x=14.06 //y=2.08
c287 ( 62 0 ) capacitor c=0.0322017f //x=11.73 //y=5.38
c288 ( 54 0 ) capacitor c=0.0291938f //x=10.85 //y=5.38
c289 ( 51 0 ) capacitor c=0.0259909f //x=13.905 //y=3.335
c290 ( 50 0 ) capacitor c=6.22456e-19 //x=14.065 //y=3.335
c291 ( 48 0 ) capacitor c=9.69366e-19 //x=12.37 //y=3.335
c292 ( 36 0 ) capacitor c=0.0170693f //x=14.06 //y=3.33
c293 ( 32 0 ) capacitor c=0.016938f //x=12.21 //y=3.33
c294 ( 29 0 ) capacitor c=0.0112415f //x=11.77 //y=1
c295 ( 27 0 ) capacitor c=5.78613e-19 //x=11.73 //y=5.38
c296 ( 24 0 ) capacitor c=0.010659f //x=11.73 //y=5.2
c297 ( 23 0 ) capacitor c=0.00926978f //x=10.85 //y=5.38
c298 ( 20 0 ) capacitor c=0.0382067f //x=14.06 //y=4.575
c299 ( 19 0 ) capacitor c=0.0145934f //x=14.06 //y=3.495
c300 ( 18 0 ) capacitor c=0.0328082f //x=14.06 //y=3.175
c301 ( 17 0 ) capacitor c=0.00495287f //x=14.06 //y=2.195
c302 ( 16 0 ) capacitor c=0.0418029f //x=12.21 //y=5.115
c303 ( 15 0 ) capacitor c=0.0134342f //x=12.21 //y=3.495
c304 ( 14 0 ) capacitor c=0.0413556f //x=12.21 //y=3.175
c305 ( 12 0 ) capacitor c=0.00466468f //x=11.855 //y=1.655
c306 ( 11 0 ) capacitor c=0.0120653f //x=12.125 //y=1.655
c307 ( 9 0 ) capacitor c=0.0116495f //x=12.125 //y=5.2
c308 ( 8 0 ) capacitor c=0.0134844f //x=11.77 //y=1.57
c309 ( 3 0 ) capacitor c=0.013452f //x=11.615 //y=5.2
r310 (  109 111 ) resistor r=26.9307 //w=0.15 //l=0.106066 //layer=ply \
 //thickness=0.18 //x=14.625 //y=4.79 //x2=14.7 //y2=4.865
r311 (  109 110 ) resistor r=148.702 //w=0.094 //l=0.29 //layer=ply \
 //thickness=0.18 //x=14.625 //y=4.79 //x2=14.335 //y2=4.79
r312 (  108 121 ) resistor r=45.1352 //w=0.168 //l=0.173853 //layer=ply \
 //thickness=0.18 //x=14.29 //y=1.22 //x2=14.25 //y2=1.375
r313 (  107 120 ) resistor r=45.1352 //w=0.168 //l=0.173853 //layer=ply \
 //thickness=0.18 //x=14.29 //y=0.875 //x2=14.25 //y2=0.72
r314 (  107 108 ) resistor r=176.904 //w=0.094 //l=0.345 //layer=ply \
 //thickness=0.18 //x=14.29 //y=0.875 //x2=14.29 //y2=1.22
r315 (  104 110 ) resistor r=22.7971 //w=0.269 //l=0.106066 //layer=ply \
 //thickness=0.18 //x=14.26 //y=4.865 //x2=14.335 //y2=4.79
r316 (  104 119 ) resistor r=35.8364 //w=0.269 //l=0.270185 //layer=ply \
 //thickness=0.18 //x=14.26 //y=4.865 //x2=14.06 //y2=4.7
r317 (  102 115 ) resistor r=10.701 //w=0.21 //l=0.115 //layer=ply \
 //thickness=0.18 //x=13.915 //y=1.375 //x2=13.8 //y2=1.375
r318 (  101 121 ) resistor r=5.52526 //w=0.168 //l=0.115 //layer=ply \
 //thickness=0.18 //x=14.135 //y=1.375 //x2=14.25 //y2=1.375
r319 (  100 114 ) resistor r=5.52526 //w=0.168 //l=0.115 //layer=ply \
 //thickness=0.18 //x=13.915 //y=0.72 //x2=13.8 //y2=0.72
r320 (  99 120 ) resistor r=5.52526 //w=0.168 //l=0.115 //layer=ply \
 //thickness=0.18 //x=14.135 //y=0.72 //x2=14.25 //y2=0.72
r321 (  99 100 ) resistor r=112.809 //w=0.094 //l=0.22 //layer=ply \
 //thickness=0.18 //x=14.135 //y=0.72 //x2=13.915 //y2=0.72
r322 (  98 117 ) resistor r=58.7805 //w=0.246 //l=0.373497 //layer=ply \
 //thickness=0.18 //x=13.76 //y=1.915 //x2=14.06 //y2=2.08
r323 (  97 115 ) resistor r=39.5823 //w=0.21 //l=0.173853 //layer=ply \
 //thickness=0.18 //x=13.76 //y=1.53 //x2=13.8 //y2=1.375
r324 (  97 98 ) resistor r=197.415 //w=0.094 //l=0.385 //layer=ply \
 //thickness=0.18 //x=13.76 //y=1.53 //x2=13.76 //y2=1.915
r325 (  96 115 ) resistor r=39.5823 //w=0.21 //l=0.173853 //layer=ply \
 //thickness=0.18 //x=13.76 //y=1.22 //x2=13.8 //y2=1.375
r326 (  95 114 ) resistor r=45.1352 //w=0.168 //l=0.173853 //layer=ply \
 //thickness=0.18 //x=13.76 //y=0.875 //x2=13.8 //y2=0.72
r327 (  95 96 ) resistor r=176.904 //w=0.094 //l=0.345 //layer=ply \
 //thickness=0.18 //x=13.76 //y=0.875 //x2=13.76 //y2=1.22
r328 (  94 111 ) resistor r=592.245 //w=0.094 //l=1.155 //layer=ply \
 //thickness=0.18 //x=14.7 //y=6.02 //x2=14.7 //y2=4.865
r329 (  93 104 ) resistor r=592.245 //w=0.094 //l=1.155 //layer=ply \
 //thickness=0.18 //x=14.26 //y=6.02 //x2=14.26 //y2=4.865
r330 (  92 101 ) resistor r=56.4043 //w=0.094 //l=0.11 //layer=ply \
 //thickness=0.18 //x=14.025 //y=1.375 //x2=14.135 //y2=1.375
r331 (  92 102 ) resistor r=56.4043 //w=0.094 //l=0.11 //layer=ply \
 //thickness=0.18 //x=14.025 //y=1.375 //x2=13.915 //y2=1.375
r332 (  88 119 ) resistor r=152 //w=0.17 //l=0.17 //layer=licon //count=1 \
 //x=14.06 //y=4.7 //x2=14.06 //y2=4.7
r333 (  79 117 ) resistor r=152 //w=0.17 //l=0.17 //layer=licon //count=1 \
 //x=14.06 //y=2.08 //x2=14.06 //y2=2.08
r334 (  62 125 ) resistor r=23.615 //w=0.187 //l=0.345 //layer=li \
 //thickness=0.1 //x=11.73 //y=5.38 //x2=11.73 //y2=5.725
r335 (  54 124 ) resistor r=23.615 //w=0.187 //l=0.345 //layer=li \
 //thickness=0.1 //x=10.85 //y=5.38 //x2=10.85 //y2=5.725
r336 (  50 51 ) resistor r=0.10734 //w=0.281 //l=0.16 //layer=m2 \
 //thickness=0.36 //x=14.065 //y=3.335 //x2=13.905 //y2=3.335
r337 (  48 51 ) resistor r=1.46469 //w=0.131 //l=1.535 //layer=m2 \
 //thickness=0.36 //x=12.37 //y=3.33 //x2=13.905 //y2=3.33
r338 (  46 48 ) resistor r=0.10734 //w=0.281 //l=0.16 //layer=m2 \
 //thickness=0.36 //x=12.21 //y=3.335 //x2=12.37 //y2=3.335
r339 (  42 88 ) resistor r=9.3 //w=0.17 //l=0.17 //layer=mcon //count=1 \
 //x=14.06 //y=4.7 //x2=14.06 //y2=4.7
r340 (  40 79 ) resistor r=9.3 //w=0.17 //l=0.17 //layer=mcon //count=1 \
 //x=14.06 //y=2.08 //x2=14.06 //y2=2.08
r341 (  38 50 ) resistor r=4.5 //w=0.15 //l=0.15 //layer=via1 //count=1 \
 //x=14.065 //y=3.335 //x2=14.065 //y2=3.335
r342 (  36 38 ) resistor r=0.00164908 //w=0.379 //l=0.005 //layer=m1 \
 //thickness=0.36 //x=14.01 //y=3.33 //x2=14.01 //y2=3.335
r343 (  34 46 ) resistor r=4.5 //w=0.15 //l=0.15 //layer=via1 //count=1 \
 //x=12.21 //y=3.335 //x2=12.21 //y2=3.335
r344 (  32 34 ) resistor r=0.00166223 //w=0.376 //l=0.005 //layer=m1 \
 //thickness=0.36 //x=12.262 //y=3.33 //x2=12.262 //y2=3.335
r345 (  29 122 ) resistor r=9.3 //w=0.17 //l=0.17 //layer=mcon //count=1 \
 //x=11.77 //y=1 //x2=11.77 //y2=1
r346 (  27 62 ) resistor r=9.3 //w=0.17 //l=0.17 //layer=mcon //count=1 \
 //x=11.73 //y=5.38 //x2=11.73 //y2=5.38
r347 (  24 27 ) resistor r=0.117801 //w=0.191 //l=0.18 //layer=m1 \
 //thickness=0.36 //x=11.73 //y=5.2 //x2=11.73 //y2=5.38
r348 (  23 54 ) resistor r=9.3 //w=0.17 //l=0.17 //layer=mcon //count=1 \
 //x=10.85 //y=5.38 //x2=10.85 //y2=5.38
r349 (  21 23 ) resistor r=0.10274 //w=0.219 //l=0.18 //layer=m1 \
 //thickness=0.36 //x=10.85 //y=5.2 //x2=10.85 //y2=5.38
r350 (  20 42 ) resistor r=0.0760407 //w=0.238 //l=0.125 //layer=m1 \
 //thickness=0.36 //x=14.06 //y=4.575 //x2=14.06 //y2=4.7
r351 (  19 38 ) resistor r=0.0912814 //w=0.379 //l=0.183303 //layer=m1 \
 //thickness=0.36 //x=14.06 //y=3.495 //x2=14.01 //y2=3.335
r352 (  19 20 ) resistor r=1.03053 //w=0.131 //l=1.08 //layer=m1 \
 //thickness=0.36 //x=14.06 //y=3.495 //x2=14.06 //y2=4.575
r353 (  18 36 ) resistor r=0.0896323 //w=0.379 //l=0.178255 //layer=m1 \
 //thickness=0.36 //x=14.06 //y=3.175 //x2=14.01 //y2=3.33
r354 (  17 40 ) resistor r=0.0719237 //w=0.222 //l=0.115 //layer=m1 \
 //thickness=0.36 //x=14.06 //y=2.195 //x2=14.06 //y2=2.08
r355 (  17 18 ) resistor r=0.935115 //w=0.131 //l=0.98 //layer=m1 \
 //thickness=0.36 //x=14.06 //y=2.195 //x2=14.06 //y2=3.175
r356 (  15 34 ) resistor r=0.0911593 //w=0.376 //l=0.184174 //layer=m1 \
 //thickness=0.36 //x=12.21 //y=3.495 //x2=12.262 //y2=3.335
r357 (  15 16 ) resistor r=1.5458 //w=0.131 //l=1.62 //layer=m1 \
 //thickness=0.36 //x=12.21 //y=3.495 //x2=12.21 //y2=5.115
r358 (  14 32 ) resistor r=0.0894971 //w=0.376 //l=0.179123 //layer=m1 \
 //thickness=0.36 //x=12.21 //y=3.175 //x2=12.262 //y2=3.33
r359 (  13 14 ) resistor r=1.36927 //w=0.131 //l=1.435 //layer=m1 \
 //thickness=0.36 //x=12.21 //y=1.74 //x2=12.21 //y2=3.175
r360 (  11 13 ) resistor r=0.0698411 //w=0.17 //l=0.120208 //layer=m1 \
 //thickness=0.36 //x=12.125 //y=1.655 //x2=12.21 //y2=1.74
r361 (  11 12 ) resistor r=0.257634 //w=0.131 //l=0.27 //layer=m1 \
 //thickness=0.36 //x=12.125 //y=1.655 //x2=11.855 //y2=1.655
r362 (  10 24 ) resistor r=0.0257089 //w=0.23 //l=0.115 //layer=m1 \
 //thickness=0.36 //x=11.845 //y=5.2 //x2=11.73 //y2=5.2
r363 (  9 16 ) resistor r=0.0698411 //w=0.17 //l=0.120208 //layer=m1 \
 //thickness=0.36 //x=12.125 //y=5.2 //x2=12.21 //y2=5.115
r364 (  9 10 ) resistor r=0.267176 //w=0.131 //l=0.28 //layer=m1 \
 //thickness=0.36 //x=12.125 //y=5.2 //x2=11.845 //y2=5.2
r365 (  8 12 ) resistor r=0.0698411 //w=0.17 //l=0.120208 //layer=m1 \
 //thickness=0.36 //x=11.77 //y=1.57 //x2=11.855 //y2=1.655
r366 (  7 29 ) resistor r=0.0913624 //w=0.191 //l=0.12 //layer=m1 \
 //thickness=0.36 //x=11.77 //y=1.12 //x2=11.77 //y2=1
r367 (  7 8 ) resistor r=0.429389 //w=0.131 //l=0.45 //layer=m1 \
 //thickness=0.36 //x=11.77 //y=1.12 //x2=11.77 //y2=1.57
r368 (  4 21 ) resistor r=0.0227762 //w=0.219 //l=0.115 //layer=m1 \
 //thickness=0.36 //x=10.965 //y=5.2 //x2=10.85 //y2=5.2
r369 (  3 24 ) resistor r=0.0257089 //w=0.23 //l=0.115 //layer=m1 \
 //thickness=0.36 //x=11.615 //y=5.2 //x2=11.73 //y2=5.2
r370 (  3 4 ) resistor r=0.620229 //w=0.131 //l=0.65 //layer=m1 \
 //thickness=0.36 //x=11.615 //y=5.2 //x2=10.965 //y2=5.2
ends PM_DFFRNX1_PCELL\%noxref_2

subckt PM_DFFRNX1_PCELL\%noxref_3 ( 1 2 3 4 8 14 17 19 21 27 32 37 42 46 47 48 \
 49 50 51 52 53 54 56 62 63 64 65 66 71 72 73 75 81 82 83 84 85 93 104 )
c294 ( 104 0 ) capacitor c=0.0356502f //x=15.17 //y=4.7
c295 ( 93 0 ) capacitor c=0.0356344f //x=2.22 //y=4.7
c296 ( 85 0 ) capacitor c=0.0306876f //x=15.505 //y=4.79
c297 ( 84 0 ) capacitor c=0.0863671f //x=15.26 //y=1.915
c298 ( 83 0 ) capacitor c=0.0170266f //x=15.26 //y=1.45
c299 ( 82 0 ) capacitor c=0.018609f //x=15.26 //y=1.22
c300 ( 81 0 ) capacitor c=0.0186599f //x=15.26 //y=0.91
c301 ( 75 0 ) capacitor c=0.0146988f //x=15.105 //y=1.375
c302 ( 73 0 ) capacitor c=0.0148531f //x=15.105 //y=0.755
c303 ( 72 0 ) capacitor c=0.0334406f //x=14.735 //y=1.22
c304 ( 71 0 ) capacitor c=0.0173191f //x=14.735 //y=0.91
c305 ( 66 0 ) capacitor c=0.0306608f //x=2.555 //y=4.79
c306 ( 65 0 ) capacitor c=0.0863671f //x=2.31 //y=1.915
c307 ( 64 0 ) capacitor c=0.0170266f //x=2.31 //y=1.45
c308 ( 63 0 ) capacitor c=0.018609f //x=2.31 //y=1.22
c309 ( 62 0 ) capacitor c=0.0186599f //x=2.31 //y=0.91
c310 ( 56 0 ) capacitor c=0.0146988f //x=2.155 //y=1.375
c311 ( 54 0 ) capacitor c=0.0148531f //x=2.155 //y=0.755
c312 ( 53 0 ) capacitor c=0.0334406f //x=1.785 //y=1.22
c313 ( 52 0 ) capacitor c=0.0173191f //x=1.785 //y=0.91
c314 ( 51 0 ) capacitor c=0.110208f //x=15.58 //y=6.02
c315 ( 50 0 ) capacitor c=0.110214f //x=15.14 //y=6.02
c316 ( 49 0 ) capacitor c=0.110208f //x=2.63 //y=6.02
c317 ( 48 0 ) capacitor c=0.110214f //x=2.19 //y=6.02
c318 ( 42 0 ) capacitor c=0.00129934f //x=15.17 //y=4.7
c319 ( 37 0 ) capacitor c=0.00121786f //x=15.17 //y=2.08
c320 ( 32 0 ) capacitor c=0.00129934f //x=2.22 //y=4.7
c321 ( 27 0 ) capacitor c=0.00121786f //x=2.22 //y=2.08
c322 ( 21 0 ) capacitor c=0.0045011f //x=2.215 //y=4.44
c323 ( 19 0 ) capacitor c=0.0999657f //x=11.69 //y=4.455
c324 ( 17 0 ) capacitor c=0.218639f //x=11.09 //y=4.44
c325 ( 14 0 ) capacitor c=0.0115855f //x=15.165 //y=4.515
c326 ( 8 0 ) capacitor c=0.00785241f //x=2.215 //y=4.655
c327 ( 4 0 ) capacitor c=0.0633406f //x=15.17 //y=4.355
c328 ( 3 0 ) capacitor c=0.00382585f //x=15.17 //y=2.195
c329 ( 2 0 ) capacitor c=0.0668824f //x=2.22 //y=4.495
c330 ( 1 0 ) capacitor c=0.0056477f //x=2.22 //y=2.195
r331 (  106 107 ) resistor r=32.4568 //w=0.214 //l=0.075 //layer=ply \
 //thickness=0.18 //x=15.17 //y=4.79 //x2=15.17 //y2=4.865
r332 (  104 106 ) resistor r=20.271 //w=0.214 //l=0.09 //layer=ply \
 //thickness=0.18 //x=15.17 //y=4.7 //x2=15.17 //y2=4.79
r333 (  95 96 ) resistor r=32.4568 //w=0.214 //l=0.075 //layer=ply \
 //thickness=0.18 //x=2.22 //y=4.79 //x2=2.22 //y2=4.865
r334 (  93 95 ) resistor r=20.271 //w=0.214 //l=0.09 //layer=ply \
 //thickness=0.18 //x=2.22 //y=4.7 //x2=2.22 //y2=4.79
r335 (  86 106 ) resistor r=16.5046 //w=0.27 //l=0.135 //layer=ply \
 //thickness=0.18 //x=15.305 //y=4.79 //x2=15.17 //y2=4.79
r336 (  85 87 ) resistor r=26.9307 //w=0.15 //l=0.106066 //layer=ply \
 //thickness=0.18 //x=15.505 //y=4.79 //x2=15.58 //y2=4.865
r337 (  85 86 ) resistor r=102.553 //w=0.094 //l=0.2 //layer=ply \
 //thickness=0.18 //x=15.505 //y=4.79 //x2=15.305 //y2=4.79
r338 (  84 111 ) resistor r=38.6777 //w=0.284 //l=0.198997 //layer=ply \
 //thickness=0.18 //x=15.26 //y=1.915 //x2=15.185 //y2=2.08
r339 (  83 109 ) resistor r=21.2976 //w=0.217 //l=0.0928709 //layer=ply \
 //thickness=0.18 //x=15.26 //y=1.45 //x2=15.22 //y2=1.375
r340 (  83 84 ) resistor r=238.436 //w=0.094 //l=0.465 //layer=ply \
 //thickness=0.18 //x=15.26 //y=1.45 //x2=15.26 //y2=1.915
r341 (  82 109 ) resistor r=39.0671 //w=0.217 //l=0.173853 //layer=ply \
 //thickness=0.18 //x=15.26 //y=1.22 //x2=15.22 //y2=1.375
r342 (  81 108 ) resistor r=45.1352 //w=0.168 //l=0.173853 //layer=ply \
 //thickness=0.18 //x=15.26 //y=0.91 //x2=15.22 //y2=0.755
r343 (  81 82 ) resistor r=158.957 //w=0.094 //l=0.31 //layer=ply \
 //thickness=0.18 //x=15.26 //y=0.91 //x2=15.26 //y2=1.22
r344 (  76 102 ) resistor r=5.52526 //w=0.168 //l=0.115 //layer=ply \
 //thickness=0.18 //x=14.89 //y=1.375 //x2=14.775 //y2=1.375
r345 (  75 109 ) resistor r=11.4558 //w=0.217 //l=0.115 //layer=ply \
 //thickness=0.18 //x=15.105 //y=1.375 //x2=15.22 //y2=1.375
r346 (  74 101 ) resistor r=5.52526 //w=0.168 //l=0.115 //layer=ply \
 //thickness=0.18 //x=14.89 //y=0.755 //x2=14.775 //y2=0.755
r347 (  73 108 ) resistor r=5.52526 //w=0.168 //l=0.115 //layer=ply \
 //thickness=0.18 //x=15.105 //y=0.755 //x2=15.22 //y2=0.755
r348 (  73 74 ) resistor r=110.245 //w=0.094 //l=0.215 //layer=ply \
 //thickness=0.18 //x=15.105 //y=0.755 //x2=14.89 //y2=0.755
r349 (  72 102 ) resistor r=45.1352 //w=0.168 //l=0.173853 //layer=ply \
 //thickness=0.18 //x=14.735 //y=1.22 //x2=14.775 //y2=1.375
r350 (  71 101 ) resistor r=45.1352 //w=0.168 //l=0.173853 //layer=ply \
 //thickness=0.18 //x=14.735 //y=0.91 //x2=14.775 //y2=0.755
r351 (  71 72 ) resistor r=158.957 //w=0.094 //l=0.31 //layer=ply \
 //thickness=0.18 //x=14.735 //y=0.91 //x2=14.735 //y2=1.22
r352 (  67 95 ) resistor r=16.5046 //w=0.27 //l=0.135 //layer=ply \
 //thickness=0.18 //x=2.355 //y=4.79 //x2=2.22 //y2=4.79
r353 (  66 68 ) resistor r=26.9307 //w=0.15 //l=0.106066 //layer=ply \
 //thickness=0.18 //x=2.555 //y=4.79 //x2=2.63 //y2=4.865
r354 (  66 67 ) resistor r=102.553 //w=0.094 //l=0.2 //layer=ply \
 //thickness=0.18 //x=2.555 //y=4.79 //x2=2.355 //y2=4.79
r355 (  65 100 ) resistor r=38.6777 //w=0.284 //l=0.198997 //layer=ply \
 //thickness=0.18 //x=2.31 //y=1.915 //x2=2.235 //y2=2.08
r356 (  64 98 ) resistor r=21.2976 //w=0.217 //l=0.0928709 //layer=ply \
 //thickness=0.18 //x=2.31 //y=1.45 //x2=2.27 //y2=1.375
r357 (  64 65 ) resistor r=238.436 //w=0.094 //l=0.465 //layer=ply \
 //thickness=0.18 //x=2.31 //y=1.45 //x2=2.31 //y2=1.915
r358 (  63 98 ) resistor r=39.0671 //w=0.217 //l=0.173853 //layer=ply \
 //thickness=0.18 //x=2.31 //y=1.22 //x2=2.27 //y2=1.375
r359 (  62 97 ) resistor r=45.1352 //w=0.168 //l=0.173853 //layer=ply \
 //thickness=0.18 //x=2.31 //y=0.91 //x2=2.27 //y2=0.755
r360 (  62 63 ) resistor r=158.957 //w=0.094 //l=0.31 //layer=ply \
 //thickness=0.18 //x=2.31 //y=0.91 //x2=2.31 //y2=1.22
r361 (  57 91 ) resistor r=5.52526 //w=0.168 //l=0.115 //layer=ply \
 //thickness=0.18 //x=1.94 //y=1.375 //x2=1.825 //y2=1.375
r362 (  56 98 ) resistor r=11.4558 //w=0.217 //l=0.115 //layer=ply \
 //thickness=0.18 //x=2.155 //y=1.375 //x2=2.27 //y2=1.375
r363 (  55 90 ) resistor r=5.52526 //w=0.168 //l=0.115 //layer=ply \
 //thickness=0.18 //x=1.94 //y=0.755 //x2=1.825 //y2=0.755
r364 (  54 97 ) resistor r=5.52526 //w=0.168 //l=0.115 //layer=ply \
 //thickness=0.18 //x=2.155 //y=0.755 //x2=2.27 //y2=0.755
r365 (  54 55 ) resistor r=110.245 //w=0.094 //l=0.215 //layer=ply \
 //thickness=0.18 //x=2.155 //y=0.755 //x2=1.94 //y2=0.755
r366 (  53 91 ) resistor r=45.1352 //w=0.168 //l=0.173853 //layer=ply \
 //thickness=0.18 //x=1.785 //y=1.22 //x2=1.825 //y2=1.375
r367 (  52 90 ) resistor r=45.1352 //w=0.168 //l=0.173853 //layer=ply \
 //thickness=0.18 //x=1.785 //y=0.91 //x2=1.825 //y2=0.755
r368 (  52 53 ) resistor r=158.957 //w=0.094 //l=0.31 //layer=ply \
 //thickness=0.18 //x=1.785 //y=0.91 //x2=1.785 //y2=1.22
r369 (  51 87 ) resistor r=592.245 //w=0.094 //l=1.155 //layer=ply \
 //thickness=0.18 //x=15.58 //y=6.02 //x2=15.58 //y2=4.865
r370 (  50 107 ) resistor r=592.245 //w=0.094 //l=1.155 //layer=ply \
 //thickness=0.18 //x=15.14 //y=6.02 //x2=15.14 //y2=4.865
r371 (  49 68 ) resistor r=592.245 //w=0.094 //l=1.155 //layer=ply \
 //thickness=0.18 //x=2.63 //y=6.02 //x2=2.63 //y2=4.865
r372 (  48 96 ) resistor r=592.245 //w=0.094 //l=1.155 //layer=ply \
 //thickness=0.18 //x=2.19 //y=6.02 //x2=2.19 //y2=4.865
r373 (  47 75 ) resistor r=55.3787 //w=0.094 //l=0.108 //layer=ply \
 //thickness=0.18 //x=14.997 //y=1.375 //x2=15.105 //y2=1.375
r374 (  47 76 ) resistor r=54.866 //w=0.094 //l=0.107 //layer=ply \
 //thickness=0.18 //x=14.997 //y=1.375 //x2=14.89 //y2=1.375
r375 (  46 56 ) resistor r=55.3787 //w=0.094 //l=0.108 //layer=ply \
 //thickness=0.18 //x=2.047 //y=1.375 //x2=2.155 //y2=1.375
r376 (  46 57 ) resistor r=54.866 //w=0.094 //l=0.107 //layer=ply \
 //thickness=0.18 //x=2.047 //y=1.375 //x2=1.94 //y2=1.375
r377 (  42 104 ) resistor r=152 //w=0.17 //l=0.17 //layer=licon //count=1 \
 //x=15.17 //y=4.7 //x2=15.17 //y2=4.7
r378 (  37 111 ) resistor r=152 //w=0.17 //l=0.17 //layer=licon //count=1 \
 //x=15.17 //y=2.08 //x2=15.17 //y2=2.08
r379 (  32 93 ) resistor r=152 //w=0.17 //l=0.17 //layer=licon //count=1 \
 //x=2.22 //y=4.7 //x2=2.22 //y2=4.7
r380 (  27 100 ) resistor r=152 //w=0.17 //l=0.17 //layer=licon //count=1 \
 //x=2.22 //y=2.08 //x2=2.22 //y2=2.08
r381 (  21 23 ) resistor r=0.0904882 //w=0.297 //l=0.215 //layer=m2 \
 //thickness=0.36 //x=2.215 //y=4.44 //x2=2.215 //y2=4.655
r382 (  19 25 ) resistor r=2.36166 //w=0.184 //l=3.50487 //layer=m2 \
 //thickness=0.36 //x=11.69 //y=4.455 //x2=15.165 //y2=4.515
r383 (  19 20 ) resistor r=0.329198 //w=0.131 //l=0.345 //layer=m2 \
 //thickness=0.36 //x=11.69 //y=4.455 //x2=11.345 //y2=4.455
r384 (  18 21 ) resistor r=0.0410036 //w=0.297 //l=0.16 //layer=m2 \
 //thickness=0.36 //x=2.375 //y=4.44 //x2=2.215 //y2=4.44
r385 (  17 20 ) resistor r=0.1875 //w=0.17 //l=0.262393 //layer=m2 \
 //thickness=0.36 //x=11.09 //y=4.44 //x2=11.345 //y2=4.455
r386 (  17 18 ) resistor r=8.31584 //w=0.131 //l=8.715 //layer=m2 \
 //thickness=0.36 //x=11.09 //y=4.44 //x2=2.375 //y2=4.44
r387 (  16 42 ) resistor r=9.3 //w=0.17 //l=0.17 //layer=mcon //count=1 \
 //x=15.17 //y=4.7 //x2=15.17 //y2=4.7
r388 (  14 25 ) resistor r=4.5 //w=0.15 //l=0.15 //layer=via1 //count=1 \
 //x=15.165 //y=4.515 //x2=15.165 //y2=4.515
r389 (  14 16 ) resistor r=0.0808566 //w=0.286 //l=0.185 //layer=m1 \
 //thickness=0.36 //x=15.165 //y=4.515 //x2=15.165 //y2=4.7
r390 (  12 37 ) resistor r=9.3 //w=0.17 //l=0.17 //layer=mcon //count=1 \
 //x=15.17 //y=2.08 //x2=15.17 //y2=2.08
r391 (  10 32 ) resistor r=9.3 //w=0.17 //l=0.17 //layer=mcon //count=1 \
 //x=2.22 //y=4.7 //x2=2.22 //y2=4.7
r392 (  8 23 ) resistor r=4.5 //w=0.15 //l=0.15 //layer=via1 //count=1 \
 //x=2.215 //y=4.655 //x2=2.215 //y2=4.655
r393 (  8 10 ) resistor r=0.018263 //w=0.308 //l=0.045 //layer=m1 \
 //thickness=0.36 //x=2.215 //y=4.655 //x2=2.215 //y2=4.7
r394 (  6 27 ) resistor r=9.3 //w=0.17 //l=0.17 //layer=mcon //count=1 \
 //x=2.22 //y=2.08 //x2=2.22 //y2=2.08
r395 (  4 14 ) resistor r=0.0903281 //w=0.286 //l=0.162481 //layer=m1 \
 //thickness=0.36 //x=15.17 //y=4.355 //x2=15.165 //y2=4.515
r396 (  3 12 ) resistor r=0.0715665 //w=0.226 //l=0.115996 //layer=m1 \
 //thickness=0.36 //x=15.17 //y=2.195 //x2=15.172 //y2=2.08
r397 (  3 4 ) resistor r=2.06107 //w=0.131 //l=2.16 //layer=m1 \
 //thickness=0.36 //x=15.17 //y=2.195 //x2=15.17 //y2=4.355
r398 (  2 8 ) resistor r=0.0898396 //w=0.308 //l=0.162481 //layer=m1 \
 //thickness=0.36 //x=2.22 //y=4.495 //x2=2.215 //y2=4.655
r399 (  1 6 ) resistor r=0.0715665 //w=0.226 //l=0.115996 //layer=m1 \
 //thickness=0.36 //x=2.22 //y=2.195 //x2=2.222 //y2=2.08
r400 (  1 2 ) resistor r=2.19466 //w=0.131 //l=2.3 //layer=m1 //thickness=0.36 \
 //x=2.22 //y=2.195 //x2=2.22 //y2=4.495
ends PM_DFFRNX1_PCELL\%noxref_3

subckt PM_DFFRNX1_PCELL\%noxref_4 ( 1 3 6 7 9 10 11 12 14 15 16 17 18 19 20 21 \
 22 23 24 25 28 31 37 45 48 54 56 57 58 60 62 64 66 68 70 72 77 83 91 99 116 \
 125 130 139 143 144 145 146 147 148 149 150 151 152 153 155 161 162 163 164 \
 168 169 170 171 172 174 180 181 182 183 203 205 206 207 )
c457 ( 203 0 ) capacitor c=0.00885916f //x=3.395 //y=0.915
c458 ( 183 0 ) capacitor c=0.0583399f //x=19.145 //y=4.79
c459 ( 182 0 ) capacitor c=0.0376642f //x=19.435 //y=4.79
c460 ( 181 0 ) capacitor c=0.0346489f //x=19.1 //y=1.22
c461 ( 180 0 ) capacitor c=0.018692f //x=19.1 //y=0.875
c462 ( 174 0 ) capacitor c=0.0137077f //x=18.945 //y=1.375
c463 ( 172 0 ) capacitor c=0.0158585f //x=18.945 //y=0.72
c464 ( 171 0 ) capacitor c=0.103534f //x=18.57 //y=1.915
c465 ( 170 0 ) capacitor c=0.0229444f //x=18.57 //y=1.53
c466 ( 169 0 ) capacitor c=0.0234359f //x=18.57 //y=1.22
c467 ( 168 0 ) capacitor c=0.019815f //x=18.57 //y=0.875
c468 ( 164 0 ) capacitor c=0.0564069f //x=6.195 //y=4.79
c469 ( 163 0 ) capacitor c=0.0376642f //x=6.485 //y=4.79
c470 ( 162 0 ) capacitor c=0.0346489f //x=6.15 //y=1.22
c471 ( 161 0 ) capacitor c=0.018692f //x=6.15 //y=0.875
c472 ( 155 0 ) capacitor c=0.0137077f //x=5.995 //y=1.375
c473 ( 153 0 ) capacitor c=0.0158585f //x=5.995 //y=0.72
c474 ( 152 0 ) capacitor c=0.103534f //x=5.62 //y=1.915
c475 ( 151 0 ) capacitor c=0.0229444f //x=5.62 //y=1.53
c476 ( 150 0 ) capacitor c=0.0234359f //x=5.62 //y=1.22
c477 ( 149 0 ) capacitor c=0.019815f //x=5.62 //y=0.875
c478 ( 148 0 ) capacitor c=0.110208f //x=19.51 //y=6.02
c479 ( 147 0 ) capacitor c=0.158957f //x=19.07 //y=6.02
c480 ( 146 0 ) capacitor c=0.110208f //x=6.56 //y=6.02
c481 ( 145 0 ) capacitor c=0.158957f //x=6.12 //y=6.02
c482 ( 139 0 ) capacitor c=0.0014751f //x=18.87 //y=4.7
c483 ( 130 0 ) capacitor c=0.0012618f //x=18.87 //y=2.08
c484 ( 125 0 ) capacitor c=0.0014751f //x=5.92 //y=4.7
c485 ( 116 0 ) capacitor c=0.0012618f //x=5.92 //y=2.08
c486 ( 99 0 ) capacitor c=0.0293561f //x=3.29 //y=5.38
c487 ( 91 0 ) capacitor c=0.029137f //x=2.41 //y=5.38
c488 ( 83 0 ) capacitor c=0.0278099f //x=1.53 //y=5.38
c489 ( 77 0 ) capacitor c=7.36606e-19 //x=4.235 //y=3.705
c490 ( 72 0 ) capacitor c=0.0356523f //x=17.24 //y=3.69
c491 ( 70 0 ) capacitor c=0.0338299f //x=16.64 //y=3.7
c492 ( 68 0 ) capacitor c=0.00527642f //x=14.28 //y=3.72
c493 ( 66 0 ) capacitor c=0.018225f //x=13.68 //y=3.7
c494 ( 64 0 ) capacitor c=0.00410098f //x=12.425 //y=3.72
c495 ( 62 0 ) capacitor c=0.0100086f //x=11.69 //y=3.685
c496 ( 60 0 ) capacitor c=0.00684159f //x=10.945 //y=3.715
c497 ( 58 0 ) capacitor c=0.0174986f //x=10.345 //y=3.7
c498 ( 57 0 ) capacitor c=0.0248309f //x=8.755 //y=3.715
c499 ( 56 0 ) capacitor c=0.00423161f //x=9.1 //y=3.715
c500 ( 54 0 ) capacitor c=0.0209003f //x=5.765 //y=3.7
c501 ( 48 0 ) capacitor c=0.0152841f //x=18.86 //y=3.7
c502 ( 45 0 ) capacitor c=0.0167936f //x=5.92 //y=3.7
c503 ( 37 0 ) capacitor c=0.0172565f //x=4.07 //y=3.7
c504 ( 31 0 ) capacitor c=9.55882e-19 //x=3.29 //y=5.155
c505 ( 28 0 ) capacitor c=0.00740623f //x=2.41 //y=5.155
c506 ( 25 0 ) capacitor c=0.0123281f //x=1.532 //y=5.155
c507 ( 24 0 ) capacitor c=0.0267104f //x=18.87 //y=4.575
c508 ( 23 0 ) capacitor c=0.0136306f //x=18.87 //y=3.86
c509 ( 22 0 ) capacitor c=0.0484215f //x=18.87 //y=3.54
c510 ( 21 0 ) capacitor c=0.00489532f //x=18.87 //y=2.195
c511 ( 20 0 ) capacitor c=0.0266324f //x=5.92 //y=4.575
c512 ( 19 0 ) capacitor c=0.0127337f //x=5.92 //y=3.86
c513 ( 18 0 ) capacitor c=0.0455792f //x=5.92 //y=3.54
c514 ( 17 0 ) capacitor c=0.00670383f //x=5.92 //y=2.195
c515 ( 16 0 ) capacitor c=0.0325919f //x=4.07 //y=5.07
c516 ( 15 0 ) capacitor c=0.0131885f //x=4.07 //y=3.865
c517 ( 14 0 ) capacitor c=0.052475f //x=4.07 //y=3.545
c518 ( 12 0 ) capacitor c=0.00686157f //x=3.67 //y=1.665
c519 ( 11 0 ) capacitor c=0.0163455f //x=3.985 //y=1.665
c520 ( 10 0 ) capacitor c=0.0167992f //x=3.585 //y=1.58
c521 ( 9 0 ) capacitor c=0.0113317f //x=3.585 //y=1.125
c522 ( 7 0 ) capacitor c=0.0229543f //x=3.985 //y=5.155
c523 ( 6 0 ) capacitor c=0.00933983f //x=3.29 //y=5.38
c524 ( 3 0 ) capacitor c=0.019444f //x=3.175 //y=5.155
c525 ( 1 0 ) capacitor c=0.0149475f //x=2.29 //y=5.155
r526 (  182 184 ) resistor r=26.9307 //w=0.15 //l=0.106066 //layer=ply \
 //thickness=0.18 //x=19.435 //y=4.79 //x2=19.51 //y2=4.865
r527 (  182 183 ) resistor r=148.702 //w=0.094 //l=0.29 //layer=ply \
 //thickness=0.18 //x=19.435 //y=4.79 //x2=19.145 //y2=4.79
r528 (  181 202 ) resistor r=45.1352 //w=0.168 //l=0.173853 //layer=ply \
 //thickness=0.18 //x=19.1 //y=1.22 //x2=19.06 //y2=1.375
r529 (  180 201 ) resistor r=45.1352 //w=0.168 //l=0.173853 //layer=ply \
 //thickness=0.18 //x=19.1 //y=0.875 //x2=19.06 //y2=0.72
r530 (  180 181 ) resistor r=176.904 //w=0.094 //l=0.345 //layer=ply \
 //thickness=0.18 //x=19.1 //y=0.875 //x2=19.1 //y2=1.22
r531 (  177 183 ) resistor r=22.7971 //w=0.269 //l=0.106066 //layer=ply \
 //thickness=0.18 //x=19.07 //y=4.865 //x2=19.145 //y2=4.79
r532 (  177 200 ) resistor r=35.8364 //w=0.269 //l=0.270185 //layer=ply \
 //thickness=0.18 //x=19.07 //y=4.865 //x2=18.87 //y2=4.7
r533 (  175 196 ) resistor r=10.701 //w=0.21 //l=0.115 //layer=ply \
 //thickness=0.18 //x=18.725 //y=1.375 //x2=18.61 //y2=1.375
r534 (  174 202 ) resistor r=5.52526 //w=0.168 //l=0.115 //layer=ply \
 //thickness=0.18 //x=18.945 //y=1.375 //x2=19.06 //y2=1.375
r535 (  173 195 ) resistor r=5.52526 //w=0.168 //l=0.115 //layer=ply \
 //thickness=0.18 //x=18.725 //y=0.72 //x2=18.61 //y2=0.72
r536 (  172 201 ) resistor r=5.52526 //w=0.168 //l=0.115 //layer=ply \
 //thickness=0.18 //x=18.945 //y=0.72 //x2=19.06 //y2=0.72
r537 (  172 173 ) resistor r=112.809 //w=0.094 //l=0.22 //layer=ply \
 //thickness=0.18 //x=18.945 //y=0.72 //x2=18.725 //y2=0.72
r538 (  171 198 ) resistor r=58.7805 //w=0.246 //l=0.373497 //layer=ply \
 //thickness=0.18 //x=18.57 //y=1.915 //x2=18.87 //y2=2.08
r539 (  170 196 ) resistor r=39.5823 //w=0.21 //l=0.173853 //layer=ply \
 //thickness=0.18 //x=18.57 //y=1.53 //x2=18.61 //y2=1.375
r540 (  170 171 ) resistor r=197.415 //w=0.094 //l=0.385 //layer=ply \
 //thickness=0.18 //x=18.57 //y=1.53 //x2=18.57 //y2=1.915
r541 (  169 196 ) resistor r=39.5823 //w=0.21 //l=0.173853 //layer=ply \
 //thickness=0.18 //x=18.57 //y=1.22 //x2=18.61 //y2=1.375
r542 (  168 195 ) resistor r=45.1352 //w=0.168 //l=0.173853 //layer=ply \
 //thickness=0.18 //x=18.57 //y=0.875 //x2=18.61 //y2=0.72
r543 (  168 169 ) resistor r=176.904 //w=0.094 //l=0.345 //layer=ply \
 //thickness=0.18 //x=18.57 //y=0.875 //x2=18.57 //y2=1.22
r544 (  163 165 ) resistor r=26.9307 //w=0.15 //l=0.106066 //layer=ply \
 //thickness=0.18 //x=6.485 //y=4.79 //x2=6.56 //y2=4.865
r545 (  163 164 ) resistor r=148.702 //w=0.094 //l=0.29 //layer=ply \
 //thickness=0.18 //x=6.485 //y=4.79 //x2=6.195 //y2=4.79
r546 (  162 194 ) resistor r=45.1352 //w=0.168 //l=0.173853 //layer=ply \
 //thickness=0.18 //x=6.15 //y=1.22 //x2=6.11 //y2=1.375
r547 (  161 193 ) resistor r=45.1352 //w=0.168 //l=0.173853 //layer=ply \
 //thickness=0.18 //x=6.15 //y=0.875 //x2=6.11 //y2=0.72
r548 (  161 162 ) resistor r=176.904 //w=0.094 //l=0.345 //layer=ply \
 //thickness=0.18 //x=6.15 //y=0.875 //x2=6.15 //y2=1.22
r549 (  158 164 ) resistor r=22.7971 //w=0.269 //l=0.106066 //layer=ply \
 //thickness=0.18 //x=6.12 //y=4.865 //x2=6.195 //y2=4.79
r550 (  158 192 ) resistor r=35.8364 //w=0.269 //l=0.270185 //layer=ply \
 //thickness=0.18 //x=6.12 //y=4.865 //x2=5.92 //y2=4.7
r551 (  156 188 ) resistor r=10.701 //w=0.21 //l=0.115 //layer=ply \
 //thickness=0.18 //x=5.775 //y=1.375 //x2=5.66 //y2=1.375
r552 (  155 194 ) resistor r=5.52526 //w=0.168 //l=0.115 //layer=ply \
 //thickness=0.18 //x=5.995 //y=1.375 //x2=6.11 //y2=1.375
r553 (  154 187 ) resistor r=5.52526 //w=0.168 //l=0.115 //layer=ply \
 //thickness=0.18 //x=5.775 //y=0.72 //x2=5.66 //y2=0.72
r554 (  153 193 ) resistor r=5.52526 //w=0.168 //l=0.115 //layer=ply \
 //thickness=0.18 //x=5.995 //y=0.72 //x2=6.11 //y2=0.72
r555 (  153 154 ) resistor r=112.809 //w=0.094 //l=0.22 //layer=ply \
 //thickness=0.18 //x=5.995 //y=0.72 //x2=5.775 //y2=0.72
r556 (  152 190 ) resistor r=58.7805 //w=0.246 //l=0.373497 //layer=ply \
 //thickness=0.18 //x=5.62 //y=1.915 //x2=5.92 //y2=2.08
r557 (  151 188 ) resistor r=39.5823 //w=0.21 //l=0.173853 //layer=ply \
 //thickness=0.18 //x=5.62 //y=1.53 //x2=5.66 //y2=1.375
r558 (  151 152 ) resistor r=197.415 //w=0.094 //l=0.385 //layer=ply \
 //thickness=0.18 //x=5.62 //y=1.53 //x2=5.62 //y2=1.915
r559 (  150 188 ) resistor r=39.5823 //w=0.21 //l=0.173853 //layer=ply \
 //thickness=0.18 //x=5.62 //y=1.22 //x2=5.66 //y2=1.375
r560 (  149 187 ) resistor r=45.1352 //w=0.168 //l=0.173853 //layer=ply \
 //thickness=0.18 //x=5.62 //y=0.875 //x2=5.66 //y2=0.72
r561 (  149 150 ) resistor r=176.904 //w=0.094 //l=0.345 //layer=ply \
 //thickness=0.18 //x=5.62 //y=0.875 //x2=5.62 //y2=1.22
r562 (  148 184 ) resistor r=592.245 //w=0.094 //l=1.155 //layer=ply \
 //thickness=0.18 //x=19.51 //y=6.02 //x2=19.51 //y2=4.865
r563 (  147 177 ) resistor r=592.245 //w=0.094 //l=1.155 //layer=ply \
 //thickness=0.18 //x=19.07 //y=6.02 //x2=19.07 //y2=4.865
r564 (  146 165 ) resistor r=592.245 //w=0.094 //l=1.155 //layer=ply \
 //thickness=0.18 //x=6.56 //y=6.02 //x2=6.56 //y2=4.865
r565 (  145 158 ) resistor r=592.245 //w=0.094 //l=1.155 //layer=ply \
 //thickness=0.18 //x=6.12 //y=6.02 //x2=6.12 //y2=4.865
r566 (  144 174 ) resistor r=56.4043 //w=0.094 //l=0.11 //layer=ply \
 //thickness=0.18 //x=18.835 //y=1.375 //x2=18.945 //y2=1.375
r567 (  144 175 ) resistor r=56.4043 //w=0.094 //l=0.11 //layer=ply \
 //thickness=0.18 //x=18.835 //y=1.375 //x2=18.725 //y2=1.375
r568 (  143 155 ) resistor r=56.4043 //w=0.094 //l=0.11 //layer=ply \
 //thickness=0.18 //x=5.885 //y=1.375 //x2=5.995 //y2=1.375
r569 (  143 156 ) resistor r=56.4043 //w=0.094 //l=0.11 //layer=ply \
 //thickness=0.18 //x=5.885 //y=1.375 //x2=5.775 //y2=1.375
r570 (  139 200 ) resistor r=152 //w=0.17 //l=0.17 //layer=licon //count=1 \
 //x=18.87 //y=4.7 //x2=18.87 //y2=4.7
r571 (  130 198 ) resistor r=152 //w=0.17 //l=0.17 //layer=licon //count=1 \
 //x=18.87 //y=2.08 //x2=18.87 //y2=2.08
r572 (  125 192 ) resistor r=152 //w=0.17 //l=0.17 //layer=licon //count=1 \
 //x=5.92 //y=4.7 //x2=5.92 //y2=4.7
r573 (  116 190 ) resistor r=152 //w=0.17 //l=0.17 //layer=licon //count=1 \
 //x=5.92 //y=2.08 //x2=5.92 //y2=2.08
r574 (  99 207 ) resistor r=23.615 //w=0.187 //l=0.345 //layer=li \
 //thickness=0.1 //x=3.29 //y=5.38 //x2=3.29 //y2=5.725
r575 (  91 206 ) resistor r=23.615 //w=0.187 //l=0.345 //layer=li \
 //thickness=0.1 //x=2.41 //y=5.38 //x2=2.41 //y2=5.725
r576 (  83 205 ) resistor r=23.615 //w=0.187 //l=0.345 //layer=li \
 //thickness=0.1 //x=1.53 //y=5.38 //x2=1.53 //y2=5.725
r577 (  75 77 ) resistor r=0.10734 //w=0.281 //l=0.16 //layer=m2 \
 //thickness=0.36 //x=4.075 //y=3.705 //x2=4.235 //y2=3.705
r578 (  72 81 ) resistor r=1.03061 //w=0.197 //l=1.62499 //layer=m2 \
 //thickness=0.36 //x=17.24 //y=3.69 //x2=18.86 //y2=3.7
r579 (  72 73 ) resistor r=0.410305 //w=0.131 //l=0.43 //layer=m2 \
 //thickness=0.36 //x=17.24 //y=3.69 //x2=16.81 //y2=3.69
r580 (  70 73 ) resistor r=0.125 //w=0.17 //l=0.174929 //layer=m2 \
 //thickness=0.36 //x=16.64 //y=3.7 //x2=16.81 //y2=3.69
r581 (  70 71 ) resistor r=2.08969 //w=0.131 //l=2.19 //layer=m2 \
 //thickness=0.36 //x=16.64 //y=3.7 //x2=14.45 //y2=3.7
r582 (  68 71 ) resistor r=0.125 //w=0.17 //l=0.179722 //layer=m2 \
 //thickness=0.36 //x=14.28 //y=3.72 //x2=14.45 //y2=3.7
r583 (  68 69 ) resistor r=0.329198 //w=0.131 //l=0.345 //layer=m2 \
 //thickness=0.36 //x=14.28 //y=3.72 //x2=13.935 //y2=3.72
r584 (  66 69 ) resistor r=0.1875 //w=0.17 //l=0.264811 //layer=m2 \
 //thickness=0.36 //x=13.68 //y=3.7 //x2=13.935 //y2=3.72
r585 (  66 67 ) resistor r=1.03531 //w=0.131 //l=1.085 //layer=m2 \
 //thickness=0.36 //x=13.68 //y=3.7 //x2=12.595 //y2=3.7
r586 (  64 67 ) resistor r=0.125 //w=0.17 //l=0.179722 //layer=m2 \
 //thickness=0.36 //x=12.425 //y=3.72 //x2=12.595 //y2=3.7
r587 (  64 65 ) resistor r=0.329198 //w=0.131 //l=0.345 //layer=m2 \
 //thickness=0.36 //x=12.425 //y=3.72 //x2=12.08 //y2=3.72
r588 (  62 65 ) resistor r=0.286765 //w=0.17 //l=0.407124 //layer=m2 \
 //thickness=0.36 //x=11.69 //y=3.685 //x2=12.08 //y2=3.72
r589 (  62 63 ) resistor r=0.410305 //w=0.131 //l=0.43 //layer=m2 \
 //thickness=0.36 //x=11.69 //y=3.685 //x2=11.26 //y2=3.685
r590 (  60 63 ) resistor r=0.231618 //w=0.17 //l=0.329659 //layer=m2 \
 //thickness=0.36 //x=10.945 //y=3.715 //x2=11.26 //y2=3.685
r591 (  60 61 ) resistor r=0.329198 //w=0.131 //l=0.345 //layer=m2 \
 //thickness=0.36 //x=10.945 //y=3.715 //x2=10.6 //y2=3.715
r592 (  58 61 ) resistor r=0.1875 //w=0.17 //l=0.262393 //layer=m2 \
 //thickness=0.36 //x=10.345 //y=3.7 //x2=10.6 //y2=3.715
r593 (  58 59 ) resistor r=1.02576 //w=0.131 //l=1.075 //layer=m2 \
 //thickness=0.36 //x=10.345 //y=3.7 //x2=9.27 //y2=3.7
r594 (  57 79 ) resistor r=1.89299 //w=0.187 //l=2.83749 //layer=m2 \
 //thickness=0.36 //x=8.755 //y=3.715 //x2=5.925 //y2=3.7
r595 (  56 59 ) resistor r=0.125 //w=0.17 //l=0.177341 //layer=m2 \
 //thickness=0.36 //x=9.1 //y=3.715 //x2=9.27 //y2=3.7
r596 (  56 57 ) resistor r=0.329198 //w=0.131 //l=0.345 //layer=m2 \
 //thickness=0.36 //x=9.1 //y=3.715 //x2=8.755 //y2=3.715
r597 (  54 79 ) resistor r=0.108234 //w=0.187 //l=0.16 //layer=m2 \
 //thickness=0.36 //x=5.765 //y=3.7 //x2=5.925 //y2=3.7
r598 (  54 77 ) resistor r=1.45992 //w=0.131 //l=1.53 //layer=m2 \
 //thickness=0.36 //x=5.765 //y=3.7 //x2=4.235 //y2=3.7
r599 (  53 139 ) resistor r=9.3 //w=0.17 //l=0.17 //layer=mcon //count=1 \
 //x=18.87 //y=4.7 //x2=18.87 //y2=4.7
r600 (  51 130 ) resistor r=9.3 //w=0.17 //l=0.17 //layer=mcon //count=1 \
 //x=18.87 //y=2.08 //x2=18.87 //y2=2.08
r601 (  48 81 ) resistor r=4.5 //w=0.15 //l=0.15 //layer=via1 //count=1 \
 //x=18.86 //y=3.7 //x2=18.86 //y2=3.7
r602 (  45 79 ) resistor r=4.5 //w=0.15 //l=0.15 //layer=via1 //count=1 \
 //x=5.925 //y=3.7 //x2=5.925 //y2=3.7
r603 (  43 125 ) resistor r=9.3 //w=0.17 //l=0.17 //layer=mcon //count=1 \
 //x=5.92 //y=4.7 //x2=5.92 //y2=4.7
r604 (  41 116 ) resistor r=9.3 //w=0.17 //l=0.17 //layer=mcon //count=1 \
 //x=5.92 //y=2.08 //x2=5.92 //y2=2.08
r605 (  39 75 ) resistor r=4.5 //w=0.15 //l=0.15 //layer=via1 //count=1 \
 //x=4.075 //y=3.705 //x2=4.075 //y2=3.705
r606 (  37 39 ) resistor r=0.00167112 //w=0.374 //l=0.005 //layer=m1 \
 //thickness=0.36 //x=4.125 //y=3.7 //x2=4.125 //y2=3.705
r607 (  35 203 ) resistor r=9.3 //w=0.17 //l=0.17 //layer=mcon //count=1 \
 //x=3.585 //y=1.01 //x2=3.585 //y2=1.01
r608 (  33 99 ) resistor r=9.3 //w=0.17 //l=0.17 //layer=mcon //count=1 \
 //x=3.29 //y=5.38 //x2=3.29 //y2=5.38
r609 (  30 91 ) resistor r=9.3 //w=0.17 //l=0.17 //layer=mcon //count=1 \
 //x=2.41 //y=5.38 //x2=2.41 //y2=5.38
r610 (  28 30 ) resistor r=0.121228 //w=0.232 //l=0.225 //layer=m1 \
 //thickness=0.36 //x=2.41 //y=5.155 //x2=2.41 //y2=5.38
r611 (  27 83 ) resistor r=9.3 //w=0.17 //l=0.17 //layer=mcon //count=1 \
 //x=1.53 //y=5.38 //x2=1.53 //y2=5.38
r612 (  25 27 ) resistor r=0.129608 //w=0.217 //l=0.225 //layer=m1 \
 //thickness=0.36 //x=1.532 //y=5.155 //x2=1.532 //y2=5.38
r613 (  24 53 ) resistor r=0.0760407 //w=0.238 //l=0.125 //layer=m1 \
 //thickness=0.36 //x=18.87 //y=4.575 //x2=18.87 //y2=4.7
r614 (  23 48 ) resistor r=0.0909648 //w=0.371 //l=0.186762 //layer=m1 \
 //thickness=0.36 //x=18.87 //y=3.86 //x2=18.812 //y2=3.7
r615 (  23 24 ) resistor r=0.682252 //w=0.131 //l=0.715 //layer=m1 \
 //thickness=0.36 //x=18.87 //y=3.86 //x2=18.87 //y2=4.575
r616 (  22 48 ) resistor r=0.0909648 //w=0.371 //l=0.186762 //layer=m1 \
 //thickness=0.36 //x=18.87 //y=3.54 //x2=18.812 //y2=3.7
r617 (  21 51 ) resistor r=0.0719237 //w=0.222 //l=0.115 //layer=m1 \
 //thickness=0.36 //x=18.87 //y=2.195 //x2=18.87 //y2=2.08
r618 (  21 22 ) resistor r=1.2834 //w=0.131 //l=1.345 //layer=m1 \
 //thickness=0.36 //x=18.87 //y=2.195 //x2=18.87 //y2=3.54
r619 (  20 43 ) resistor r=0.0760407 //w=0.238 //l=0.125 //layer=m1 \
 //thickness=0.36 //x=5.92 //y=4.575 //x2=5.92 //y2=4.7
r620 (  19 45 ) resistor r=0.0910802 //w=0.374 //l=0.185472 //layer=m1 \
 //thickness=0.36 //x=5.92 //y=3.86 //x2=5.975 //y2=3.7
r621 (  19 20 ) resistor r=0.682252 //w=0.131 //l=0.715 //layer=m1 \
 //thickness=0.36 //x=5.92 //y=3.86 //x2=5.92 //y2=4.575
r622 (  18 45 ) resistor r=0.0910802 //w=0.374 //l=0.185472 //layer=m1 \
 //thickness=0.36 //x=5.92 //y=3.54 //x2=5.975 //y2=3.7
r623 (  17 41 ) resistor r=0.0719237 //w=0.222 //l=0.115 //layer=m1 \
 //thickness=0.36 //x=5.92 //y=2.195 //x2=5.92 //y2=2.08
r624 (  17 18 ) resistor r=1.2834 //w=0.131 //l=1.345 //layer=m1 \
 //thickness=0.36 //x=5.92 //y=2.195 //x2=5.92 //y2=3.54
r625 (  15 39 ) resistor r=0.0910802 //w=0.374 //l=0.185472 //layer=m1 \
 //thickness=0.36 //x=4.07 //y=3.865 //x2=4.125 //y2=3.705
r626 (  15 16 ) resistor r=1.14981 //w=0.131 //l=1.205 //layer=m1 \
 //thickness=0.36 //x=4.07 //y=3.865 //x2=4.07 //y2=5.07
r627 (  14 37 ) resistor r=0.089409 //w=0.374 //l=0.180416 //layer=m1 \
 //thickness=0.36 //x=4.07 //y=3.545 //x2=4.125 //y2=3.7
r628 (  13 14 ) resistor r=1.71279 //w=0.131 //l=1.795 //layer=m1 \
 //thickness=0.36 //x=4.07 //y=1.75 //x2=4.07 //y2=3.545
r629 (  11 13 ) resistor r=0.0698411 //w=0.17 //l=0.120208 //layer=m1 \
 //thickness=0.36 //x=3.985 //y=1.665 //x2=4.07 //y2=1.75
r630 (  11 12 ) resistor r=0.300573 //w=0.131 //l=0.315 //layer=m1 \
 //thickness=0.36 //x=3.985 //y=1.665 //x2=3.67 //y2=1.665
r631 (  10 12 ) resistor r=0.0698411 //w=0.17 //l=0.120208 //layer=m1 \
 //thickness=0.36 //x=3.585 //y=1.58 //x2=3.67 //y2=1.665
r632 (  9 35 ) resistor r=0.0717383 //w=0.224 //l=0.115 //layer=m1 \
 //thickness=0.36 //x=3.585 //y=1.125 //x2=3.585 //y2=1.01
r633 (  9 10 ) resistor r=0.43416 //w=0.131 //l=0.455 //layer=m1 \
 //thickness=0.36 //x=3.585 //y=1.125 //x2=3.585 //y2=1.58
r634 (  8 31 ) resistor r=0.0675342 //w=0.23 //l=0.115 //layer=m1 \
 //thickness=0.36 //x=3.405 //y=5.155 //x2=3.29 //y2=5.155
r635 (  7 16 ) resistor r=0.0698411 //w=0.17 //l=0.120208 //layer=m1 \
 //thickness=0.36 //x=3.985 //y=5.155 //x2=4.07 //y2=5.07
r636 (  7 8 ) resistor r=0.553435 //w=0.131 //l=0.58 //layer=m1 \
 //thickness=0.36 //x=3.985 //y=5.155 //x2=3.405 //y2=5.155
r637 (  6 33 ) resistor r=0.00118313 //w=0.23 //layer=m1 //thickness=0.36 \
 //x=3.29 //y=5.38 //x2=3.29 //y2=5.38
r638 (  5 31 ) resistor r=0.002872 //w=0.34 //l=0.085 //layer=m1 \
 //thickness=0.36 //x=3.29 //y=5.24 //x2=3.29 //y2=5.155
r639 (  5 6 ) resistor r=0.091623 //w=0.191 //l=0.14 //layer=m1 \
 //thickness=0.36 //x=3.29 //y=5.24 //x2=3.29 //y2=5.38
r640 (  4 28 ) resistor r=0.0262263 //w=0.232 //l=0.12 //layer=m1 \
 //thickness=0.36 //x=2.53 //y=5.155 //x2=2.41 //y2=5.155
r641 (  3 31 ) resistor r=0.0675342 //w=0.23 //l=0.115 //layer=m1 \
 //thickness=0.36 //x=3.175 //y=5.155 //x2=3.29 //y2=5.155
r642 (  3 4 ) resistor r=0.615458 //w=0.131 //l=0.645 //layer=m1 \
 //thickness=0.36 //x=3.175 //y=5.155 //x2=2.53 //y2=5.155
r643 (  2 25 ) resistor r=0.0222262 //w=0.217 //l=0.118 //layer=m1 \
 //thickness=0.36 //x=1.65 //y=5.155 //x2=1.532 //y2=5.155
r644 (  1 28 ) resistor r=0.0262263 //w=0.232 //l=0.12 //layer=m1 \
 //thickness=0.36 //x=2.29 //y=5.155 //x2=2.41 //y2=5.155
r645 (  1 2 ) resistor r=0.610687 //w=0.131 //l=0.64 //layer=m1 \
 //thickness=0.36 //x=2.29 //y=5.155 //x2=1.65 //y2=5.155
ends PM_DFFRNX1_PCELL\%noxref_4

subckt PM_DFFRNX1_PCELL\%noxref_5 ( 1 2 3 4 5 6 30 34 35 37 38 41 46 51 56 61 \
 66 70 71 72 73 74 75 76 77 78 82 83 84 89 91 94 95 99 100 101 106 108 111 112 \
 113 114 115 117 123 124 125 126 127 133 134 139 143 144 149 155 )
c409 ( 155 0 ) capacitor c=0.0369044f //x=19.98 //y=4.7
c410 ( 149 0 ) capacitor c=0.0710579f //x=16.28 //y=4.7
c411 ( 144 0 ) capacitor c=0.0278202f //x=16.28 //y=1.915
c412 ( 143 0 ) capacitor c=0.0490597f //x=16.28 //y=2.08
c413 ( 139 0 ) capacitor c=0.0710579f //x=8.14 //y=4.7
c414 ( 134 0 ) capacitor c=0.0278202f //x=8.14 //y=1.915
c415 ( 133 0 ) capacitor c=0.0490597f //x=8.14 //y=2.08
c416 ( 127 0 ) capacitor c=0.0309248f //x=20.315 //y=4.79
c417 ( 126 0 ) capacitor c=0.0852528f //x=20.07 //y=1.915
c418 ( 125 0 ) capacitor c=0.0170266f //x=20.07 //y=1.45
c419 ( 124 0 ) capacitor c=0.018609f //x=20.07 //y=1.22
c420 ( 123 0 ) capacitor c=0.0186599f //x=20.07 //y=0.91
c421 ( 117 0 ) capacitor c=0.0146988f //x=19.915 //y=1.375
c422 ( 115 0 ) capacitor c=0.0148531f //x=19.915 //y=0.755
c423 ( 114 0 ) capacitor c=0.0334406f //x=19.545 //y=1.22
c424 ( 113 0 ) capacitor c=0.0173191f //x=19.545 //y=0.91
c425 ( 112 0 ) capacitor c=0.0443175f //x=16.8 //y=1.26
c426 ( 111 0 ) capacitor c=0.0199703f //x=16.8 //y=0.915
c427 ( 108 0 ) capacitor c=0.0160331f //x=16.645 //y=1.415
c428 ( 106 0 ) capacitor c=0.0157807f //x=16.645 //y=0.76
c429 ( 101 0 ) capacitor c=0.0219045f //x=16.27 //y=1.57
c430 ( 100 0 ) capacitor c=0.0207489f //x=16.27 //y=1.26
c431 ( 99 0 ) capacitor c=0.0194091f //x=16.27 //y=0.915
c432 ( 95 0 ) capacitor c=0.0443175f //x=8.66 //y=1.26
c433 ( 94 0 ) capacitor c=0.0199703f //x=8.66 //y=0.915
c434 ( 91 0 ) capacitor c=0.0160331f //x=8.505 //y=1.415
c435 ( 89 0 ) capacitor c=0.0157807f //x=8.505 //y=0.76
c436 ( 84 0 ) capacitor c=0.0219045f //x=8.13 //y=1.57
c437 ( 83 0 ) capacitor c=0.0207489f //x=8.13 //y=1.26
c438 ( 82 0 ) capacitor c=0.0194091f //x=8.13 //y=0.915
c439 ( 78 0 ) capacitor c=0.110208f //x=20.39 //y=6.02
c440 ( 77 0 ) capacitor c=0.110214f //x=19.95 //y=6.02
c441 ( 76 0 ) capacitor c=0.159671f //x=16.46 //y=6.02
c442 ( 75 0 ) capacitor c=0.110208f //x=16.02 //y=6.02
c443 ( 74 0 ) capacitor c=0.159671f //x=8.32 //y=6.02
c444 ( 73 0 ) capacitor c=0.110208f //x=7.88 //y=6.02
c445 ( 66 0 ) capacitor c=0.00129934f //x=19.98 //y=4.7
c446 ( 61 0 ) capacitor c=0.00121786f //x=19.98 //y=2.08
c447 ( 56 0 ) capacitor c=7.74199e-19 //x=16.28 //y=4.7
c448 ( 51 0 ) capacitor c=0.00118671f //x=16.28 //y=2.08
c449 ( 46 0 ) capacitor c=7.74199e-19 //x=8.14 //y=4.7
c450 ( 41 0 ) capacitor c=0.00118671f //x=8.14 //y=2.08
c451 ( 38 0 ) capacitor c=0.0960316f //x=19.775 //y=2.175
c452 ( 37 0 ) capacitor c=0.00565742f //x=19.935 //y=2.175
c453 ( 35 0 ) capacitor c=0.0061184f //x=16.445 //y=2.135
c454 ( 34 0 ) capacitor c=0.212759f //x=16.125 //y=2.135
c455 ( 30 0 ) capacitor c=0.00623589f //x=8.145 //y=2.125
c456 ( 6 0 ) capacitor c=0.0757449f //x=19.98 //y=4.585
c457 ( 5 0 ) capacitor c=0.00939356f //x=19.98 //y=2.335
c458 ( 4 0 ) capacitor c=0.0645818f //x=16.28 //y=4.57
c459 ( 3 0 ) capacitor c=0.0110146f //x=16.28 //y=2.285
c460 ( 2 0 ) capacitor c=0.0633999f //x=8.14 //y=4.57
c461 ( 1 0 ) capacitor c=0.0111887f //x=8.14 //y=2.285
r462 (  157 158 ) resistor r=32.4568 //w=0.214 //l=0.075 //layer=ply \
 //thickness=0.18 //x=19.98 //y=4.79 //x2=19.98 //y2=4.865
r463 (  155 157 ) resistor r=20.271 //w=0.214 //l=0.09 //layer=ply \
 //thickness=0.18 //x=19.98 //y=4.7 //x2=19.98 //y2=4.79
r464 (  143 144 ) resistor r=52.7279 //w=0.214 //l=0.165 //layer=ply \
 //thickness=0.18 //x=16.28 //y=2.08 //x2=16.28 //y2=1.915
r465 (  133 134 ) resistor r=52.7279 //w=0.214 //l=0.165 //layer=ply \
 //thickness=0.18 //x=8.14 //y=2.08 //x2=8.14 //y2=1.915
r466 (  128 157 ) resistor r=16.5046 //w=0.27 //l=0.135 //layer=ply \
 //thickness=0.18 //x=20.115 //y=4.79 //x2=19.98 //y2=4.79
r467 (  127 129 ) resistor r=26.9307 //w=0.15 //l=0.106066 //layer=ply \
 //thickness=0.18 //x=20.315 //y=4.79 //x2=20.39 //y2=4.865
r468 (  127 128 ) resistor r=102.553 //w=0.094 //l=0.2 //layer=ply \
 //thickness=0.18 //x=20.315 //y=4.79 //x2=20.115 //y2=4.79
r469 (  126 162 ) resistor r=38.6777 //w=0.284 //l=0.198997 //layer=ply \
 //thickness=0.18 //x=20.07 //y=1.915 //x2=19.995 //y2=2.08
r470 (  125 160 ) resistor r=21.2976 //w=0.217 //l=0.0928709 //layer=ply \
 //thickness=0.18 //x=20.07 //y=1.45 //x2=20.03 //y2=1.375
r471 (  125 126 ) resistor r=238.436 //w=0.094 //l=0.465 //layer=ply \
 //thickness=0.18 //x=20.07 //y=1.45 //x2=20.07 //y2=1.915
r472 (  124 160 ) resistor r=39.0671 //w=0.217 //l=0.173853 //layer=ply \
 //thickness=0.18 //x=20.07 //y=1.22 //x2=20.03 //y2=1.375
r473 (  123 159 ) resistor r=45.1352 //w=0.168 //l=0.173853 //layer=ply \
 //thickness=0.18 //x=20.07 //y=0.91 //x2=20.03 //y2=0.755
r474 (  123 124 ) resistor r=158.957 //w=0.094 //l=0.31 //layer=ply \
 //thickness=0.18 //x=20.07 //y=0.91 //x2=20.07 //y2=1.22
r475 (  118 153 ) resistor r=5.52526 //w=0.168 //l=0.115 //layer=ply \
 //thickness=0.18 //x=19.7 //y=1.375 //x2=19.585 //y2=1.375
r476 (  117 160 ) resistor r=11.4558 //w=0.217 //l=0.115 //layer=ply \
 //thickness=0.18 //x=19.915 //y=1.375 //x2=20.03 //y2=1.375
r477 (  116 152 ) resistor r=5.52526 //w=0.168 //l=0.115 //layer=ply \
 //thickness=0.18 //x=19.7 //y=0.755 //x2=19.585 //y2=0.755
r478 (  115 159 ) resistor r=5.52526 //w=0.168 //l=0.115 //layer=ply \
 //thickness=0.18 //x=19.915 //y=0.755 //x2=20.03 //y2=0.755
r479 (  115 116 ) resistor r=110.245 //w=0.094 //l=0.215 //layer=ply \
 //thickness=0.18 //x=19.915 //y=0.755 //x2=19.7 //y2=0.755
r480 (  114 153 ) resistor r=45.1352 //w=0.168 //l=0.173853 //layer=ply \
 //thickness=0.18 //x=19.545 //y=1.22 //x2=19.585 //y2=1.375
r481 (  113 152 ) resistor r=45.1352 //w=0.168 //l=0.173853 //layer=ply \
 //thickness=0.18 //x=19.545 //y=0.91 //x2=19.585 //y2=0.755
r482 (  113 114 ) resistor r=158.957 //w=0.094 //l=0.31 //layer=ply \
 //thickness=0.18 //x=19.545 //y=0.91 //x2=19.545 //y2=1.22
r483 (  112 151 ) resistor r=45.1352 //w=0.168 //l=0.173853 //layer=ply \
 //thickness=0.18 //x=16.8 //y=1.26 //x2=16.76 //y2=1.415
r484 (  111 150 ) resistor r=45.1352 //w=0.168 //l=0.173853 //layer=ply \
 //thickness=0.18 //x=16.8 //y=0.915 //x2=16.76 //y2=0.76
r485 (  111 112 ) resistor r=176.904 //w=0.094 //l=0.345 //layer=ply \
 //thickness=0.18 //x=16.8 //y=0.915 //x2=16.8 //y2=1.26
r486 (  109 147 ) resistor r=10.701 //w=0.21 //l=0.115 //layer=ply \
 //thickness=0.18 //x=16.425 //y=1.415 //x2=16.31 //y2=1.415
r487 (  108 151 ) resistor r=5.52526 //w=0.168 //l=0.115 //layer=ply \
 //thickness=0.18 //x=16.645 //y=1.415 //x2=16.76 //y2=1.415
r488 (  107 146 ) resistor r=5.52526 //w=0.168 //l=0.115 //layer=ply \
 //thickness=0.18 //x=16.425 //y=0.76 //x2=16.31 //y2=0.76
r489 (  106 150 ) resistor r=5.52526 //w=0.168 //l=0.115 //layer=ply \
 //thickness=0.18 //x=16.645 //y=0.76 //x2=16.76 //y2=0.76
r490 (  106 107 ) resistor r=112.809 //w=0.094 //l=0.22 //layer=ply \
 //thickness=0.18 //x=16.645 //y=0.76 //x2=16.425 //y2=0.76
r491 (  103 149 ) resistor r=37.236 //w=0.233 //l=0.249199 //layer=ply \
 //thickness=0.18 //x=16.46 //y=4.865 //x2=16.28 //y2=4.7
r492 (  101 147 ) resistor r=39.5823 //w=0.21 //l=0.173853 //layer=ply \
 //thickness=0.18 //x=16.27 //y=1.57 //x2=16.31 //y2=1.415
r493 (  101 144 ) resistor r=176.904 //w=0.094 //l=0.345 //layer=ply \
 //thickness=0.18 //x=16.27 //y=1.57 //x2=16.27 //y2=1.915
r494 (  100 147 ) resistor r=39.5823 //w=0.21 //l=0.173853 //layer=ply \
 //thickness=0.18 //x=16.27 //y=1.26 //x2=16.31 //y2=1.415
r495 (  99 146 ) resistor r=45.1352 //w=0.168 //l=0.173853 //layer=ply \
 //thickness=0.18 //x=16.27 //y=0.915 //x2=16.31 //y2=0.76
r496 (  99 100 ) resistor r=176.904 //w=0.094 //l=0.345 //layer=ply \
 //thickness=0.18 //x=16.27 //y=0.915 //x2=16.27 //y2=1.26
r497 (  96 149 ) resistor r=53.7854 //w=0.233 //l=0.332415 //layer=ply \
 //thickness=0.18 //x=16.02 //y=4.865 //x2=16.28 //y2=4.7
r498 (  95 141 ) resistor r=45.1352 //w=0.168 //l=0.173853 //layer=ply \
 //thickness=0.18 //x=8.66 //y=1.26 //x2=8.62 //y2=1.415
r499 (  94 140 ) resistor r=45.1352 //w=0.168 //l=0.173853 //layer=ply \
 //thickness=0.18 //x=8.66 //y=0.915 //x2=8.62 //y2=0.76
r500 (  94 95 ) resistor r=176.904 //w=0.094 //l=0.345 //layer=ply \
 //thickness=0.18 //x=8.66 //y=0.915 //x2=8.66 //y2=1.26
r501 (  92 137 ) resistor r=10.701 //w=0.21 //l=0.115 //layer=ply \
 //thickness=0.18 //x=8.285 //y=1.415 //x2=8.17 //y2=1.415
r502 (  91 141 ) resistor r=5.52526 //w=0.168 //l=0.115 //layer=ply \
 //thickness=0.18 //x=8.505 //y=1.415 //x2=8.62 //y2=1.415
r503 (  90 136 ) resistor r=5.52526 //w=0.168 //l=0.115 //layer=ply \
 //thickness=0.18 //x=8.285 //y=0.76 //x2=8.17 //y2=0.76
r504 (  89 140 ) resistor r=5.52526 //w=0.168 //l=0.115 //layer=ply \
 //thickness=0.18 //x=8.505 //y=0.76 //x2=8.62 //y2=0.76
r505 (  89 90 ) resistor r=112.809 //w=0.094 //l=0.22 //layer=ply \
 //thickness=0.18 //x=8.505 //y=0.76 //x2=8.285 //y2=0.76
r506 (  86 139 ) resistor r=37.236 //w=0.233 //l=0.249199 //layer=ply \
 //thickness=0.18 //x=8.32 //y=4.865 //x2=8.14 //y2=4.7
r507 (  84 137 ) resistor r=39.5823 //w=0.21 //l=0.173853 //layer=ply \
 //thickness=0.18 //x=8.13 //y=1.57 //x2=8.17 //y2=1.415
r508 (  84 134 ) resistor r=176.904 //w=0.094 //l=0.345 //layer=ply \
 //thickness=0.18 //x=8.13 //y=1.57 //x2=8.13 //y2=1.915
r509 (  83 137 ) resistor r=39.5823 //w=0.21 //l=0.173853 //layer=ply \
 //thickness=0.18 //x=8.13 //y=1.26 //x2=8.17 //y2=1.415
r510 (  82 136 ) resistor r=45.1352 //w=0.168 //l=0.173853 //layer=ply \
 //thickness=0.18 //x=8.13 //y=0.915 //x2=8.17 //y2=0.76
r511 (  82 83 ) resistor r=176.904 //w=0.094 //l=0.345 //layer=ply \
 //thickness=0.18 //x=8.13 //y=0.915 //x2=8.13 //y2=1.26
r512 (  79 139 ) resistor r=53.7854 //w=0.233 //l=0.332415 //layer=ply \
 //thickness=0.18 //x=7.88 //y=4.865 //x2=8.14 //y2=4.7
r513 (  78 129 ) resistor r=592.245 //w=0.094 //l=1.155 //layer=ply \
 //thickness=0.18 //x=20.39 //y=6.02 //x2=20.39 //y2=4.865
r514 (  77 158 ) resistor r=592.245 //w=0.094 //l=1.155 //layer=ply \
 //thickness=0.18 //x=19.95 //y=6.02 //x2=19.95 //y2=4.865
r515 (  76 103 ) resistor r=592.245 //w=0.094 //l=1.155 //layer=ply \
 //thickness=0.18 //x=16.46 //y=6.02 //x2=16.46 //y2=4.865
r516 (  75 96 ) resistor r=592.245 //w=0.094 //l=1.155 //layer=ply \
 //thickness=0.18 //x=16.02 //y=6.02 //x2=16.02 //y2=4.865
r517 (  74 86 ) resistor r=592.245 //w=0.094 //l=1.155 //layer=ply \
 //thickness=0.18 //x=8.32 //y=6.02 //x2=8.32 //y2=4.865
r518 (  73 79 ) resistor r=592.245 //w=0.094 //l=1.155 //layer=ply \
 //thickness=0.18 //x=7.88 //y=6.02 //x2=7.88 //y2=4.865
r519 (  72 117 ) resistor r=55.3787 //w=0.094 //l=0.108 //layer=ply \
 //thickness=0.18 //x=19.807 //y=1.375 //x2=19.915 //y2=1.375
r520 (  72 118 ) resistor r=54.866 //w=0.094 //l=0.107 //layer=ply \
 //thickness=0.18 //x=19.807 //y=1.375 //x2=19.7 //y2=1.375
r521 (  71 108 ) resistor r=56.4043 //w=0.094 //l=0.11 //layer=ply \
 //thickness=0.18 //x=16.535 //y=1.415 //x2=16.645 //y2=1.415
r522 (  71 109 ) resistor r=56.4043 //w=0.094 //l=0.11 //layer=ply \
 //thickness=0.18 //x=16.535 //y=1.415 //x2=16.425 //y2=1.415
r523 (  70 91 ) resistor r=56.4043 //w=0.094 //l=0.11 //layer=ply \
 //thickness=0.18 //x=8.395 //y=1.415 //x2=8.505 //y2=1.415
r524 (  70 92 ) resistor r=56.4043 //w=0.094 //l=0.11 //layer=ply \
 //thickness=0.18 //x=8.395 //y=1.415 //x2=8.285 //y2=1.415
r525 (  66 155 ) resistor r=152 //w=0.17 //l=0.17 //layer=licon //count=1 \
 //x=19.98 //y=4.7 //x2=19.98 //y2=4.7
r526 (  61 162 ) resistor r=152 //w=0.17 //l=0.17 //layer=licon //count=1 \
 //x=19.98 //y=2.08 //x2=19.98 //y2=2.08
r527 (  56 149 ) resistor r=152 //w=0.17 //l=0.17 //layer=licon //count=1 \
 //x=16.28 //y=4.7 //x2=16.28 //y2=4.7
r528 (  51 143 ) resistor r=152 //w=0.17 //l=0.17 //layer=licon //count=1 \
 //x=16.28 //y=2.08 //x2=16.28 //y2=2.08
r529 (  46 139 ) resistor r=152 //w=0.17 //l=0.17 //layer=licon //count=1 \
 //x=8.14 //y=4.7 //x2=8.14 //y2=4.7
r530 (  41 133 ) resistor r=152 //w=0.17 //l=0.17 //layer=licon //count=1 \
 //x=8.14 //y=2.08 //x2=8.14 //y2=2.08
r531 (  37 38 ) resistor r=0.10734 //w=0.281 //l=0.16 //layer=m2 \
 //thickness=0.36 //x=19.935 //y=2.175 //x2=19.775 //y2=2.175
r532 (  35 38 ) resistor r=3.17748 //w=0.131 //l=3.33 //layer=m2 \
 //thickness=0.36 //x=16.445 //y=2.22 //x2=19.775 //y2=2.22
r533 (  33 35 ) resistor r=0.107331 //w=0.301 //l=0.16 //layer=m2 \
 //thickness=0.36 //x=16.285 //y=2.135 //x2=16.445 //y2=2.135
r534 (  33 34 ) resistor r=0.107331 //w=0.301 //l=0.16 //layer=m2 \
 //thickness=0.36 //x=16.285 //y=2.135 //x2=16.125 //y2=2.135
r535 (  30 31 ) resistor r=0.0373428 //w=0.318 //l=0.095 //layer=m2 \
 //thickness=0.36 //x=8.145 //y=2.125 //x2=8.145 //y2=2.22
r536 (  26 31 ) resistor r=0.0451273 //w=0.318 //l=0.16 //layer=m2 \
 //thickness=0.36 //x=8.305 //y=2.22 //x2=8.145 //y2=2.22
r537 (  26 34 ) resistor r=7.46183 //w=0.131 //l=7.82 //layer=m2 \
 //thickness=0.36 //x=8.305 //y=2.22 //x2=16.125 //y2=2.22
r538 (  24 37 ) resistor r=4.5 //w=0.15 //l=0.15 //layer=via1 //count=1 \
 //x=19.935 //y=2.175 //x2=19.935 //y2=2.175
r539 (  22 61 ) resistor r=9.3 //w=0.17 //l=0.17 //layer=mcon //count=1 \
 //x=19.98 //y=2.08 //x2=19.98 //y2=2.08
r540 (  22 24 ) resistor r=0.0401182 //w=0.296 //l=0.095 //layer=m1 \
 //thickness=0.36 //x=19.937 //y=2.08 //x2=19.937 //y2=2.175
r541 (  20 66 ) resistor r=9.3 //w=0.17 //l=0.17 //layer=mcon //count=1 \
 //x=19.98 //y=4.7 //x2=19.98 //y2=4.7
r542 (  18 33 ) resistor r=4.5 //w=0.15 //l=0.15 //layer=via1 //count=1 \
 //x=16.285 //y=2.125 //x2=16.285 //y2=2.125
r543 (  16 51 ) resistor r=9.3 //w=0.17 //l=0.17 //layer=mcon //count=1 \
 //x=16.28 //y=2.08 //x2=16.28 //y2=2.08
r544 (  16 18 ) resistor r=0.0186258 //w=0.302 //l=0.045 //layer=m1 \
 //thickness=0.36 //x=16.285 //y=2.08 //x2=16.285 //y2=2.125
r545 (  14 56 ) resistor r=9.3 //w=0.17 //l=0.17 //layer=mcon //count=1 \
 //x=16.28 //y=4.7 //x2=16.28 //y2=4.7
r546 (  12 30 ) resistor r=4.5 //w=0.15 //l=0.15 //layer=via1 //count=1 \
 //x=8.145 //y=2.125 //x2=8.145 //y2=2.125
r547 (  10 41 ) resistor r=9.3 //w=0.17 //l=0.17 //layer=mcon //count=1 \
 //x=8.14 //y=2.08 //x2=8.14 //y2=2.08
r548 (  10 12 ) resistor r=0.0186258 //w=0.302 //l=0.045 //layer=m1 \
 //thickness=0.36 //x=8.145 //y=2.08 //x2=8.145 //y2=2.125
r549 (  8 46 ) resistor r=9.3 //w=0.17 //l=0.17 //layer=mcon //count=1 \
 //x=8.14 //y=4.7 //x2=8.14 //y2=4.7
r550 (  6 20 ) resistor r=0.0717383 //w=0.224 //l=0.115 //layer=m1 \
 //thickness=0.36 //x=19.98 //y=4.585 //x2=19.98 //y2=4.7
r551 (  5 24 ) resistor r=0.0900276 //w=0.296 //l=0.180222 //layer=m1 \
 //thickness=0.36 //x=19.98 //y=2.335 //x2=19.937 //y2=2.175
r552 (  5 6 ) resistor r=2.14695 //w=0.131 //l=2.25 //layer=m1 \
 //thickness=0.36 //x=19.98 //y=2.335 //x2=19.98 //y2=4.585
r553 (  4 14 ) resistor r=0.0801089 //w=0.224 //l=0.13 //layer=m1 \
 //thickness=0.36 //x=16.28 //y=4.57 //x2=16.28 //y2=4.7
r554 (  3 18 ) resistor r=0.0899119 //w=0.302 //l=0.162481 //layer=m1 \
 //thickness=0.36 //x=16.28 //y=2.285 //x2=16.285 //y2=2.125
r555 (  3 4 ) resistor r=2.18034 //w=0.131 //l=2.285 //layer=m1 \
 //thickness=0.36 //x=16.28 //y=2.285 //x2=16.28 //y2=4.57
r556 (  2 8 ) resistor r=0.0801089 //w=0.224 //l=0.13 //layer=m1 \
 //thickness=0.36 //x=8.14 //y=4.57 //x2=8.14 //y2=4.7
r557 (  1 12 ) resistor r=0.0899119 //w=0.302 //l=0.162481 //layer=m1 \
 //thickness=0.36 //x=8.14 //y=2.285 //x2=8.145 //y2=2.125
r558 (  1 2 ) resistor r=2.18034 //w=0.131 //l=2.285 //layer=m1 \
 //thickness=0.36 //x=8.14 //y=2.285 //x2=8.14 //y2=4.57
ends PM_DFFRNX1_PCELL\%noxref_5

subckt PM_DFFRNX1_PCELL\%noxref_6 ( 1 2 3 4 6 7 8 9 11 14 15 17 18 19 20 22 23 \
 24 26 27 28 34 38 41 46 49 52 58 62 66 71 73 75 77 79 80 81 82 86 94 103 108 \
 117 122 130 138 155 164 168 169 170 171 172 173 174 175 176 177 178 179 180 \
 181 183 189 190 191 192 196 197 198 203 205 207 213 214 215 216 217 222 224 \
 226 232 233 243 244 247 256 257 260 268 270 271 272 )
c589 ( 268 0 ) capacitor c=0.00885916f //x=16.345 //y=0.915
c590 ( 260 0 ) capacitor c=0.0358148f //x=24.45 //y=4.7
c591 ( 257 0 ) capacitor c=0.0303735f //x=24.42 //y=1.915
c592 ( 256 0 ) capacitor c=0.0476996f //x=24.42 //y=2.08
c593 ( 247 0 ) capacitor c=0.0354929f //x=11.5 //y=4.7
c594 ( 244 0 ) capacitor c=0.0284095f //x=11.47 //y=1.915
c595 ( 243 0 ) capacitor c=0.0476356f //x=11.47 //y=2.08
c596 ( 233 0 ) capacitor c=0.0439708f //x=24.985 //y=1.25
c597 ( 232 0 ) capacitor c=0.0192582f //x=24.985 //y=0.905
c598 ( 226 0 ) capacitor c=0.0162526f //x=24.83 //y=1.405
c599 ( 224 0 ) capacitor c=0.0157807f //x=24.83 //y=0.75
c600 ( 222 0 ) capacitor c=0.0372668f //x=24.825 //y=4.79
c601 ( 217 0 ) capacitor c=0.0210762f //x=24.455 //y=1.56
c602 ( 216 0 ) capacitor c=0.0168511f //x=24.455 //y=1.25
c603 ( 215 0 ) capacitor c=0.0175485f //x=24.455 //y=0.905
c604 ( 214 0 ) capacitor c=0.0439708f //x=12.035 //y=1.25
c605 ( 213 0 ) capacitor c=0.0192582f //x=12.035 //y=0.905
c606 ( 207 0 ) capacitor c=0.0162526f //x=11.88 //y=1.405
c607 ( 205 0 ) capacitor c=0.0157807f //x=11.88 //y=0.75
c608 ( 203 0 ) capacitor c=0.0372668f //x=11.875 //y=4.79
c609 ( 198 0 ) capacitor c=0.0210762f //x=11.505 //y=1.56
c610 ( 197 0 ) capacitor c=0.0168511f //x=11.505 //y=1.25
c611 ( 196 0 ) capacitor c=0.0175485f //x=11.505 //y=0.905
c612 ( 192 0 ) capacitor c=0.0551642f //x=1.385 //y=4.79
c613 ( 191 0 ) capacitor c=0.0376642f //x=1.675 //y=4.79
c614 ( 190 0 ) capacitor c=0.0346489f //x=1.34 //y=1.22
c615 ( 189 0 ) capacitor c=0.018692f //x=1.34 //y=0.875
c616 ( 183 0 ) capacitor c=0.0137077f //x=1.185 //y=1.375
c617 ( 181 0 ) capacitor c=0.0158585f //x=1.185 //y=0.72
c618 ( 180 0 ) capacitor c=0.103534f //x=0.81 //y=1.915
c619 ( 179 0 ) capacitor c=0.0229444f //x=0.81 //y=1.53
c620 ( 178 0 ) capacitor c=0.0234359f //x=0.81 //y=1.22
c621 ( 177 0 ) capacitor c=0.019815f //x=0.81 //y=0.875
c622 ( 176 0 ) capacitor c=0.155269f //x=24.9 //y=6.02
c623 ( 175 0 ) capacitor c=0.110375f //x=24.46 //y=6.02
c624 ( 174 0 ) capacitor c=0.155269f //x=11.95 //y=6.02
c625 ( 173 0 ) capacitor c=0.110375f //x=11.51 //y=6.02
c626 ( 172 0 ) capacitor c=0.110208f //x=1.75 //y=6.02
c627 ( 171 0 ) capacitor c=0.158957f //x=1.31 //y=6.02
c628 ( 164 0 ) capacitor c=5.80955e-19 //x=24.45 //y=4.7
c629 ( 155 0 ) capacitor c=5.78095e-19 //x=24.42 //y=2.08
c630 ( 138 0 ) capacitor c=0.0293124f //x=16.24 //y=5.38
c631 ( 130 0 ) capacitor c=0.029137f //x=15.36 //y=5.38
c632 ( 122 0 ) capacitor c=0.0277605f //x=14.48 //y=5.38
c633 ( 117 0 ) capacitor c=5.80955e-19 //x=11.5 //y=4.7
c634 ( 108 0 ) capacitor c=5.78095e-19 //x=11.47 //y=2.08
c635 ( 103 0 ) capacitor c=0.00120653f //x=1.11 //y=4.7
c636 ( 94 0 ) capacitor c=0.0012618f //x=1.11 //y=2.08
c637 ( 86 0 ) capacitor c=0.0109595f //x=1.27 //y=4.08
c638 ( 82 0 ) capacitor c=0.0547f //x=18.73 //y=4.085
c639 ( 81 0 ) capacitor c=0.236687f //x=19.075 //y=4.085
c640 ( 80 0 ) capacitor c=0.0519986f //x=11.635 //y=4.07
c641 ( 79 0 ) capacitor c=0.0706046f //x=16.865 //y=4.07
c642 ( 77 0 ) capacitor c=0.00150627f //x=6.14 //y=4.085
c643 ( 75 0 ) capacitor c=0.0170341f //x=5.54 //y=4.07
c644 ( 73 0 ) capacitor c=0.00487194f //x=4.325 //y=4.09
c645 ( 71 0 ) capacitor c=0.0809012f //x=3.685 //y=4.07
c646 ( 66 0 ) capacitor c=0.00661943f //x=24.42 //y=2.08
c647 ( 62 0 ) capacitor c=0.0143744f //x=24.42 //y=4.07
c648 ( 58 0 ) capacitor c=0.0152034f //x=17.02 //y=4.07
c649 ( 52 0 ) capacitor c=0.00118259f //x=16.24 //y=5.155
c650 ( 49 0 ) capacitor c=0.00758117f //x=15.36 //y=5.155
c651 ( 46 0 ) capacitor c=0.0112819f //x=14.482 //y=5.155
c652 ( 41 0 ) capacitor c=0.00504845f //x=11.47 //y=2.08
c653 ( 38 0 ) capacitor c=0.0141348f //x=11.47 //y=4.07
c654 ( 34 0 ) capacitor c=0.0160313f //x=1.11 //y=4.07
c655 ( 28 0 ) capacitor c=0.00983657f //x=24.42 //y=4.555
c656 ( 27 0 ) capacitor c=0.00928723f //x=24.42 //y=4.235
c657 ( 26 0 ) capacitor c=0.0454395f //x=24.42 //y=3.915
c658 ( 24 0 ) capacitor c=0.0221841f //x=17.02 //y=5.07
c659 ( 23 0 ) capacitor c=0.0126981f //x=17.02 //y=4.235
c660 ( 22 0 ) capacitor c=0.0663769f //x=17.02 //y=3.915
c661 ( 20 0 ) capacitor c=0.00493487f //x=16.62 //y=1.665
c662 ( 19 0 ) capacitor c=0.0134344f //x=16.935 //y=1.665
c663 ( 18 0 ) capacitor c=0.0167333f //x=16.535 //y=1.58
c664 ( 17 0 ) capacitor c=0.0111392f //x=16.535 //y=1.125
c665 ( 15 0 ) capacitor c=0.0240505f //x=16.935 //y=5.155
c666 ( 14 0 ) capacitor c=0.00933983f //x=16.24 //y=5.38
c667 ( 11 0 ) capacitor c=0.0200404f //x=16.125 //y=5.155
c668 ( 9 0 ) capacitor c=0.0147103f //x=15.24 //y=5.155
c669 ( 8 0 ) capacitor c=0.00917813f //x=11.47 //y=4.555
c670 ( 7 0 ) capacitor c=0.00994896f //x=11.47 //y=4.23
c671 ( 6 0 ) capacitor c=0.0360742f //x=11.47 //y=3.91
c672 ( 4 0 ) capacitor c=0.0226003f //x=1.11 //y=4.575
c673 ( 3 0 ) capacitor c=0.0130233f //x=1.11 //y=4.24
c674 ( 2 0 ) capacitor c=0.0864232f //x=1.11 //y=3.92
c675 ( 1 0 ) capacitor c=0.011342f //x=1.11 //y=2.195
r676 (  262 263 ) resistor r=32.4568 //w=0.214 //l=0.075 //layer=ply \
 //thickness=0.18 //x=24.45 //y=4.79 //x2=24.45 //y2=4.865
r677 (  260 262 ) resistor r=20.271 //w=0.214 //l=0.09 //layer=ply \
 //thickness=0.18 //x=24.45 //y=4.7 //x2=24.45 //y2=4.79
r678 (  256 257 ) resistor r=52.7279 //w=0.214 //l=0.165 //layer=ply \
 //thickness=0.18 //x=24.42 //y=2.08 //x2=24.42 //y2=1.915
r679 (  249 250 ) resistor r=32.4568 //w=0.214 //l=0.075 //layer=ply \
 //thickness=0.18 //x=11.5 //y=4.79 //x2=11.5 //y2=4.865
r680 (  247 249 ) resistor r=20.271 //w=0.214 //l=0.09 //layer=ply \
 //thickness=0.18 //x=11.5 //y=4.7 //x2=11.5 //y2=4.79
r681 (  243 244 ) resistor r=52.7279 //w=0.214 //l=0.165 //layer=ply \
 //thickness=0.18 //x=11.47 //y=2.08 //x2=11.47 //y2=1.915
r682 (  233 267 ) resistor r=45.1352 //w=0.168 //l=0.173853 //layer=ply \
 //thickness=0.18 //x=24.985 //y=1.25 //x2=24.945 //y2=1.405
r683 (  232 266 ) resistor r=45.1352 //w=0.168 //l=0.173853 //layer=ply \
 //thickness=0.18 //x=24.985 //y=0.905 //x2=24.945 //y2=0.75
r684 (  232 233 ) resistor r=176.904 //w=0.094 //l=0.345 //layer=ply \
 //thickness=0.18 //x=24.985 //y=0.905 //x2=24.985 //y2=1.25
r685 (  227 265 ) resistor r=10.701 //w=0.21 //l=0.115 //layer=ply \
 //thickness=0.18 //x=24.61 //y=1.405 //x2=24.495 //y2=1.405
r686 (  226 267 ) resistor r=5.52526 //w=0.168 //l=0.115 //layer=ply \
 //thickness=0.18 //x=24.83 //y=1.405 //x2=24.945 //y2=1.405
r687 (  225 264 ) resistor r=5.52526 //w=0.168 //l=0.115 //layer=ply \
 //thickness=0.18 //x=24.61 //y=0.75 //x2=24.495 //y2=0.75
r688 (  224 266 ) resistor r=5.52526 //w=0.168 //l=0.115 //layer=ply \
 //thickness=0.18 //x=24.83 //y=0.75 //x2=24.945 //y2=0.75
r689 (  224 225 ) resistor r=112.809 //w=0.094 //l=0.22 //layer=ply \
 //thickness=0.18 //x=24.83 //y=0.75 //x2=24.61 //y2=0.75
r690 (  223 262 ) resistor r=16.5046 //w=0.27 //l=0.135 //layer=ply \
 //thickness=0.18 //x=24.585 //y=4.79 //x2=24.45 //y2=4.79
r691 (  222 229 ) resistor r=26.9307 //w=0.15 //l=0.106066 //layer=ply \
 //thickness=0.18 //x=24.825 //y=4.79 //x2=24.9 //y2=4.865
r692 (  222 223 ) resistor r=123.064 //w=0.094 //l=0.24 //layer=ply \
 //thickness=0.18 //x=24.825 //y=4.79 //x2=24.585 //y2=4.79
r693 (  217 265 ) resistor r=39.5823 //w=0.21 //l=0.173853 //layer=ply \
 //thickness=0.18 //x=24.455 //y=1.56 //x2=24.495 //y2=1.405
r694 (  217 257 ) resistor r=182.032 //w=0.094 //l=0.355 //layer=ply \
 //thickness=0.18 //x=24.455 //y=1.56 //x2=24.455 //y2=1.915
r695 (  216 265 ) resistor r=39.5823 //w=0.21 //l=0.173853 //layer=ply \
 //thickness=0.18 //x=24.455 //y=1.25 //x2=24.495 //y2=1.405
r696 (  215 264 ) resistor r=45.1352 //w=0.168 //l=0.173853 //layer=ply \
 //thickness=0.18 //x=24.455 //y=0.905 //x2=24.495 //y2=0.75
r697 (  215 216 ) resistor r=176.904 //w=0.094 //l=0.345 //layer=ply \
 //thickness=0.18 //x=24.455 //y=0.905 //x2=24.455 //y2=1.25
r698 (  214 254 ) resistor r=45.1352 //w=0.168 //l=0.173853 //layer=ply \
 //thickness=0.18 //x=12.035 //y=1.25 //x2=11.995 //y2=1.405
r699 (  213 253 ) resistor r=45.1352 //w=0.168 //l=0.173853 //layer=ply \
 //thickness=0.18 //x=12.035 //y=0.905 //x2=11.995 //y2=0.75
r700 (  213 214 ) resistor r=176.904 //w=0.094 //l=0.345 //layer=ply \
 //thickness=0.18 //x=12.035 //y=0.905 //x2=12.035 //y2=1.25
r701 (  208 252 ) resistor r=10.701 //w=0.21 //l=0.115 //layer=ply \
 //thickness=0.18 //x=11.66 //y=1.405 //x2=11.545 //y2=1.405
r702 (  207 254 ) resistor r=5.52526 //w=0.168 //l=0.115 //layer=ply \
 //thickness=0.18 //x=11.88 //y=1.405 //x2=11.995 //y2=1.405
r703 (  206 251 ) resistor r=5.52526 //w=0.168 //l=0.115 //layer=ply \
 //thickness=0.18 //x=11.66 //y=0.75 //x2=11.545 //y2=0.75
r704 (  205 253 ) resistor r=5.52526 //w=0.168 //l=0.115 //layer=ply \
 //thickness=0.18 //x=11.88 //y=0.75 //x2=11.995 //y2=0.75
r705 (  205 206 ) resistor r=112.809 //w=0.094 //l=0.22 //layer=ply \
 //thickness=0.18 //x=11.88 //y=0.75 //x2=11.66 //y2=0.75
r706 (  204 249 ) resistor r=16.5046 //w=0.27 //l=0.135 //layer=ply \
 //thickness=0.18 //x=11.635 //y=4.79 //x2=11.5 //y2=4.79
r707 (  203 210 ) resistor r=26.9307 //w=0.15 //l=0.106066 //layer=ply \
 //thickness=0.18 //x=11.875 //y=4.79 //x2=11.95 //y2=4.865
r708 (  203 204 ) resistor r=123.064 //w=0.094 //l=0.24 //layer=ply \
 //thickness=0.18 //x=11.875 //y=4.79 //x2=11.635 //y2=4.79
r709 (  198 252 ) resistor r=39.5823 //w=0.21 //l=0.173853 //layer=ply \
 //thickness=0.18 //x=11.505 //y=1.56 //x2=11.545 //y2=1.405
r710 (  198 244 ) resistor r=182.032 //w=0.094 //l=0.355 //layer=ply \
 //thickness=0.18 //x=11.505 //y=1.56 //x2=11.505 //y2=1.915
r711 (  197 252 ) resistor r=39.5823 //w=0.21 //l=0.173853 //layer=ply \
 //thickness=0.18 //x=11.505 //y=1.25 //x2=11.545 //y2=1.405
r712 (  196 251 ) resistor r=45.1352 //w=0.168 //l=0.173853 //layer=ply \
 //thickness=0.18 //x=11.505 //y=0.905 //x2=11.545 //y2=0.75
r713 (  196 197 ) resistor r=176.904 //w=0.094 //l=0.345 //layer=ply \
 //thickness=0.18 //x=11.505 //y=0.905 //x2=11.505 //y2=1.25
r714 (  191 193 ) resistor r=26.9307 //w=0.15 //l=0.106066 //layer=ply \
 //thickness=0.18 //x=1.675 //y=4.79 //x2=1.75 //y2=4.865
r715 (  191 192 ) resistor r=148.702 //w=0.094 //l=0.29 //layer=ply \
 //thickness=0.18 //x=1.675 //y=4.79 //x2=1.385 //y2=4.79
r716 (  190 241 ) resistor r=45.1352 //w=0.168 //l=0.173853 //layer=ply \
 //thickness=0.18 //x=1.34 //y=1.22 //x2=1.3 //y2=1.375
r717 (  189 240 ) resistor r=45.1352 //w=0.168 //l=0.173853 //layer=ply \
 //thickness=0.18 //x=1.34 //y=0.875 //x2=1.3 //y2=0.72
r718 (  189 190 ) resistor r=176.904 //w=0.094 //l=0.345 //layer=ply \
 //thickness=0.18 //x=1.34 //y=0.875 //x2=1.34 //y2=1.22
r719 (  186 192 ) resistor r=22.7971 //w=0.269 //l=0.106066 //layer=ply \
 //thickness=0.18 //x=1.31 //y=4.865 //x2=1.385 //y2=4.79
r720 (  186 239 ) resistor r=35.8364 //w=0.269 //l=0.270185 //layer=ply \
 //thickness=0.18 //x=1.31 //y=4.865 //x2=1.11 //y2=4.7
r721 (  184 235 ) resistor r=10.701 //w=0.21 //l=0.115 //layer=ply \
 //thickness=0.18 //x=0.965 //y=1.375 //x2=0.85 //y2=1.375
r722 (  183 241 ) resistor r=5.52526 //w=0.168 //l=0.115 //layer=ply \
 //thickness=0.18 //x=1.185 //y=1.375 //x2=1.3 //y2=1.375
r723 (  182 234 ) resistor r=5.52526 //w=0.168 //l=0.115 //layer=ply \
 //thickness=0.18 //x=0.965 //y=0.72 //x2=0.85 //y2=0.72
r724 (  181 240 ) resistor r=5.52526 //w=0.168 //l=0.115 //layer=ply \
 //thickness=0.18 //x=1.185 //y=0.72 //x2=1.3 //y2=0.72
r725 (  181 182 ) resistor r=112.809 //w=0.094 //l=0.22 //layer=ply \
 //thickness=0.18 //x=1.185 //y=0.72 //x2=0.965 //y2=0.72
r726 (  180 237 ) resistor r=58.7805 //w=0.246 //l=0.373497 //layer=ply \
 //thickness=0.18 //x=0.81 //y=1.915 //x2=1.11 //y2=2.08
r727 (  179 235 ) resistor r=39.5823 //w=0.21 //l=0.173853 //layer=ply \
 //thickness=0.18 //x=0.81 //y=1.53 //x2=0.85 //y2=1.375
r728 (  179 180 ) resistor r=197.415 //w=0.094 //l=0.385 //layer=ply \
 //thickness=0.18 //x=0.81 //y=1.53 //x2=0.81 //y2=1.915
r729 (  178 235 ) resistor r=39.5823 //w=0.21 //l=0.173853 //layer=ply \
 //thickness=0.18 //x=0.81 //y=1.22 //x2=0.85 //y2=1.375
r730 (  177 234 ) resistor r=45.1352 //w=0.168 //l=0.173853 //layer=ply \
 //thickness=0.18 //x=0.81 //y=0.875 //x2=0.85 //y2=0.72
r731 (  177 178 ) resistor r=176.904 //w=0.094 //l=0.345 //layer=ply \
 //thickness=0.18 //x=0.81 //y=0.875 //x2=0.81 //y2=1.22
r732 (  176 229 ) resistor r=592.245 //w=0.094 //l=1.155 //layer=ply \
 //thickness=0.18 //x=24.9 //y=6.02 //x2=24.9 //y2=4.865
r733 (  175 263 ) resistor r=592.245 //w=0.094 //l=1.155 //layer=ply \
 //thickness=0.18 //x=24.46 //y=6.02 //x2=24.46 //y2=4.865
r734 (  174 210 ) resistor r=592.245 //w=0.094 //l=1.155 //layer=ply \
 //thickness=0.18 //x=11.95 //y=6.02 //x2=11.95 //y2=4.865
r735 (  173 250 ) resistor r=592.245 //w=0.094 //l=1.155 //layer=ply \
 //thickness=0.18 //x=11.51 //y=6.02 //x2=11.51 //y2=4.865
r736 (  172 193 ) resistor r=592.245 //w=0.094 //l=1.155 //layer=ply \
 //thickness=0.18 //x=1.75 //y=6.02 //x2=1.75 //y2=4.865
r737 (  171 186 ) resistor r=592.245 //w=0.094 //l=1.155 //layer=ply \
 //thickness=0.18 //x=1.31 //y=6.02 //x2=1.31 //y2=4.865
r738 (  170 226 ) resistor r=56.4043 //w=0.094 //l=0.11 //layer=ply \
 //thickness=0.18 //x=24.72 //y=1.405 //x2=24.83 //y2=1.405
r739 (  170 227 ) resistor r=56.4043 //w=0.094 //l=0.11 //layer=ply \
 //thickness=0.18 //x=24.72 //y=1.405 //x2=24.61 //y2=1.405
r740 (  169 207 ) resistor r=56.4043 //w=0.094 //l=0.11 //layer=ply \
 //thickness=0.18 //x=11.77 //y=1.405 //x2=11.88 //y2=1.405
r741 (  169 208 ) resistor r=56.4043 //w=0.094 //l=0.11 //layer=ply \
 //thickness=0.18 //x=11.77 //y=1.405 //x2=11.66 //y2=1.405
r742 (  168 183 ) resistor r=56.4043 //w=0.094 //l=0.11 //layer=ply \
 //thickness=0.18 //x=1.075 //y=1.375 //x2=1.185 //y2=1.375
r743 (  168 184 ) resistor r=56.4043 //w=0.094 //l=0.11 //layer=ply \
 //thickness=0.18 //x=1.075 //y=1.375 //x2=0.965 //y2=1.375
r744 (  164 260 ) resistor r=152 //w=0.17 //l=0.17 //layer=licon //count=1 \
 //x=24.45 //y=4.7 //x2=24.45 //y2=4.7
r745 (  155 256 ) resistor r=152 //w=0.17 //l=0.17 //layer=licon //count=1 \
 //x=24.42 //y=2.08 //x2=24.42 //y2=2.08
r746 (  138 272 ) resistor r=23.615 //w=0.187 //l=0.345 //layer=li \
 //thickness=0.1 //x=16.24 //y=5.38 //x2=16.24 //y2=5.725
r747 (  130 271 ) resistor r=23.615 //w=0.187 //l=0.345 //layer=li \
 //thickness=0.1 //x=15.36 //y=5.38 //x2=15.36 //y2=5.725
r748 (  122 270 ) resistor r=23.615 //w=0.187 //l=0.345 //layer=li \
 //thickness=0.1 //x=14.48 //y=5.38 //x2=14.48 //y2=5.725
r749 (  117 247 ) resistor r=152 //w=0.17 //l=0.17 //layer=licon //count=1 \
 //x=11.5 //y=4.7 //x2=11.5 //y2=4.7
r750 (  108 243 ) resistor r=152 //w=0.17 //l=0.17 //layer=licon //count=1 \
 //x=11.47 //y=2.08 //x2=11.47 //y2=2.08
r751 (  103 239 ) resistor r=152 //w=0.17 //l=0.17 //layer=licon //count=1 \
 //x=1.11 //y=4.7 //x2=1.11 //y2=4.7
r752 (  94 237 ) resistor r=152 //w=0.17 //l=0.17 //layer=licon //count=1 \
 //x=1.11 //y=2.08 //x2=1.11 //y2=2.08
r753 (  84 86 ) resistor r=0.10734 //w=0.281 //l=0.16 //layer=m2 \
 //thickness=0.36 //x=1.11 //y=4.08 //x2=1.27 //y2=4.08
r754 (  82 90 ) resistor r=1.08991 //w=0.196 //l=1.70999 //layer=m2 \
 //thickness=0.36 //x=18.73 //y=4.085 //x2=17.025 //y2=4.075
r755 (  81 92 ) resistor r=3.726 //w=0.179 //l=5.34 //layer=m2 \
 //thickness=0.36 //x=19.075 //y=4.085 //x2=24.41 //y2=4.075
r756 (  81 82 ) resistor r=0.329198 //w=0.131 //l=0.345 //layer=m2 \
 //thickness=0.36 //x=19.075 //y=4.085 //x2=18.73 //y2=4.085
r757 (  80 88 ) resistor r=0.112172 //w=0.179 //l=0.16 //layer=m2 \
 //thickness=0.36 //x=11.635 //y=4.07 //x2=11.475 //y2=4.07
r758 (  79 90 ) resistor r=0.104578 //w=0.196 //l=0.162481 //layer=m2 \
 //thickness=0.36 //x=16.865 //y=4.07 //x2=17.025 //y2=4.075
r759 (  79 80 ) resistor r=4.99046 //w=0.131 //l=5.23 //layer=m2 \
 //thickness=0.36 //x=16.865 //y=4.07 //x2=11.635 //y2=4.07
r760 (  77 88 ) resistor r=3.726 //w=0.179 //l=5.34249 //layer=m2 \
 //thickness=0.36 //x=6.14 //y=4.085 //x2=11.475 //y2=4.07
r761 (  77 78 ) resistor r=0.329198 //w=0.131 //l=0.345 //layer=m2 \
 //thickness=0.36 //x=6.14 //y=4.085 //x2=5.795 //y2=4.085
r762 (  75 78 ) resistor r=0.1875 //w=0.17 //l=0.262393 //layer=m2 \
 //thickness=0.36 //x=5.54 //y=4.07 //x2=5.795 //y2=4.085
r763 (  75 76 ) resistor r=0.997137 //w=0.131 //l=1.045 //layer=m2 \
 //thickness=0.36 //x=5.54 //y=4.07 //x2=4.495 //y2=4.07
r764 (  73 76 ) resistor r=0.125 //w=0.17 //l=0.179722 //layer=m2 \
 //thickness=0.36 //x=4.325 //y=4.09 //x2=4.495 //y2=4.07
r765 (  73 74 ) resistor r=0.367366 //w=0.131 //l=0.385 //layer=m2 \
 //thickness=0.36 //x=4.325 //y=4.09 //x2=3.94 //y2=4.09
r766 (  71 74 ) resistor r=0.1875 //w=0.17 //l=0.264811 //layer=m2 \
 //thickness=0.36 //x=3.685 //y=4.07 //x2=3.94 //y2=4.09
r767 (  71 86 ) resistor r=2.30439 //w=0.131 //l=2.415 //layer=m2 \
 //thickness=0.36 //x=3.685 //y=4.07 //x2=1.27 //y2=4.07
r768 (  70 164 ) resistor r=9.3 //w=0.17 //l=0.17 //layer=mcon //count=1 \
 //x=24.45 //y=4.7 //x2=24.45 //y2=4.7
r769 (  66 155 ) resistor r=9.3 //w=0.17 //l=0.17 //layer=mcon //count=1 \
 //x=24.42 //y=2.08 //x2=24.42 //y2=2.08
r770 (  66 68 ) resistor r=0.0936408 //w=0.196 //l=0.125 //layer=m1 \
 //thickness=0.36 //x=24.422 //y=2.08 //x2=24.422 //y2=2.205
r771 (  64 92 ) resistor r=4.5 //w=0.15 //l=0.15 //layer=via1 //count=1 \
 //x=24.41 //y=4.075 //x2=24.41 //y2=4.075
r772 (  62 64 ) resistor r=0.00168464 //w=0.371 //l=0.005 //layer=m1 \
 //thickness=0.36 //x=24.362 //y=4.07 //x2=24.362 //y2=4.075
r773 (  60 90 ) resistor r=4.5 //w=0.15 //l=0.15 //layer=via1 //count=1 \
 //x=17.025 //y=4.075 //x2=17.025 //y2=4.075
r774 (  58 60 ) resistor r=0.00164908 //w=0.379 //l=0.005 //layer=m1 \
 //thickness=0.36 //x=16.97 //y=4.07 //x2=16.97 //y2=4.075
r775 (  56 268 ) resistor r=9.3 //w=0.17 //l=0.17 //layer=mcon //count=1 \
 //x=16.535 //y=1.01 //x2=16.535 //y2=1.01
r776 (  54 138 ) resistor r=9.3 //w=0.17 //l=0.17 //layer=mcon //count=1 \
 //x=16.24 //y=5.38 //x2=16.24 //y2=5.38
r777 (  51 130 ) resistor r=9.3 //w=0.17 //l=0.17 //layer=mcon //count=1 \
 //x=15.36 //y=5.38 //x2=15.36 //y2=5.38
r778 (  49 51 ) resistor r=0.121228 //w=0.232 //l=0.225 //layer=m1 \
 //thickness=0.36 //x=15.36 //y=5.155 //x2=15.36 //y2=5.38
r779 (  48 122 ) resistor r=9.3 //w=0.17 //l=0.17 //layer=mcon //count=1 \
 //x=14.48 //y=5.38 //x2=14.48 //y2=5.38
r780 (  46 48 ) resistor r=0.129608 //w=0.217 //l=0.225 //layer=m1 \
 //thickness=0.36 //x=14.482 //y=5.155 //x2=14.482 //y2=5.38
r781 (  45 117 ) resistor r=9.3 //w=0.17 //l=0.17 //layer=mcon //count=1 \
 //x=11.5 //y=4.7 //x2=11.5 //y2=4.7
r782 (  41 108 ) resistor r=9.3 //w=0.17 //l=0.17 //layer=mcon //count=1 \
 //x=11.47 //y=2.08 //x2=11.47 //y2=2.08
r783 (  41 43 ) resistor r=0.0936408 //w=0.196 //l=0.125 //layer=m1 \
 //thickness=0.36 //x=11.472 //y=2.08 //x2=11.472 //y2=2.205
r784 (  38 88 ) resistor r=4.5 //w=0.15 //l=0.15 //layer=via1 //count=1 \
 //x=11.475 //y=4.07 //x2=11.475 //y2=4.07
r785 (  36 84 ) resistor r=4.5 //w=0.15 //l=0.15 //layer=via1 //count=1 \
 //x=1.11 //y=4.08 //x2=1.11 //y2=4.08
r786 (  34 36 ) resistor r=0.00332447 //w=0.376 //l=0.01 //layer=m1 \
 //thickness=0.36 //x=1.162 //y=4.07 //x2=1.162 //y2=4.08
r787 (  32 103 ) resistor r=9.3 //w=0.17 //l=0.17 //layer=mcon //count=1 \
 //x=1.11 //y=4.7 //x2=1.11 //y2=4.7
r788 (  30 94 ) resistor r=9.3 //w=0.17 //l=0.17 //layer=mcon //count=1 \
 //x=1.11 //y=2.08 //x2=1.11 //y2=2.08
r789 (  28 70 ) resistor r=0.0878548 //w=0.228 //l=0.159295 //layer=m1 \
 //thickness=0.36 //x=24.42 //y=4.555 //x2=24.45 //y2=4.7
r790 (  27 64 ) resistor r=0.0909648 //w=0.371 //l=0.186762 //layer=m1 \
 //thickness=0.36 //x=24.42 //y=4.235 //x2=24.362 //y2=4.075
r791 (  27 28 ) resistor r=0.305344 //w=0.131 //l=0.32 //layer=m1 \
 //thickness=0.36 //x=24.42 //y=4.235 //x2=24.42 //y2=4.555
r792 (  26 62 ) resistor r=0.0892801 //w=0.371 //l=0.1817 //layer=m1 \
 //thickness=0.36 //x=24.42 //y=3.915 //x2=24.362 //y2=4.07
r793 (  26 68 ) resistor r=1.63168 //w=0.131 //l=1.71 //layer=m1 \
 //thickness=0.36 //x=24.42 //y=3.915 //x2=24.42 //y2=2.205
r794 (  23 60 ) resistor r=0.0912814 //w=0.379 //l=0.183303 //layer=m1 \
 //thickness=0.36 //x=17.02 //y=4.235 //x2=16.97 //y2=4.075
r795 (  23 24 ) resistor r=0.796756 //w=0.131 //l=0.835 //layer=m1 \
 //thickness=0.36 //x=17.02 //y=4.235 //x2=17.02 //y2=5.07
r796 (  22 58 ) resistor r=0.0896323 //w=0.379 //l=0.178255 //layer=m1 \
 //thickness=0.36 //x=17.02 //y=3.915 //x2=16.97 //y2=4.07
r797 (  21 22 ) resistor r=2.06584 //w=0.131 //l=2.165 //layer=m1 \
 //thickness=0.36 //x=17.02 //y=1.75 //x2=17.02 //y2=3.915
r798 (  19 21 ) resistor r=0.0698411 //w=0.17 //l=0.120208 //layer=m1 \
 //thickness=0.36 //x=16.935 //y=1.665 //x2=17.02 //y2=1.75
r799 (  19 20 ) resistor r=0.300573 //w=0.131 //l=0.315 //layer=m1 \
 //thickness=0.36 //x=16.935 //y=1.665 //x2=16.62 //y2=1.665
r800 (  18 20 ) resistor r=0.0698411 //w=0.17 //l=0.120208 //layer=m1 \
 //thickness=0.36 //x=16.535 //y=1.58 //x2=16.62 //y2=1.665
r801 (  17 56 ) resistor r=0.0717383 //w=0.224 //l=0.115 //layer=m1 \
 //thickness=0.36 //x=16.535 //y=1.125 //x2=16.535 //y2=1.01
r802 (  17 18 ) resistor r=0.43416 //w=0.131 //l=0.455 //layer=m1 \
 //thickness=0.36 //x=16.535 //y=1.125 //x2=16.535 //y2=1.58
r803 (  16 52 ) resistor r=0.0675342 //w=0.23 //l=0.115 //layer=m1 \
 //thickness=0.36 //x=16.355 //y=5.155 //x2=16.24 //y2=5.155
r804 (  15 24 ) resistor r=0.0698411 //w=0.17 //l=0.120208 //layer=m1 \
 //thickness=0.36 //x=16.935 //y=5.155 //x2=17.02 //y2=5.07
r805 (  15 16 ) resistor r=0.553435 //w=0.131 //l=0.58 //layer=m1 \
 //thickness=0.36 //x=16.935 //y=5.155 //x2=16.355 //y2=5.155
r806 (  14 54 ) resistor r=0.00118313 //w=0.23 //layer=m1 //thickness=0.36 \
 //x=16.24 //y=5.38 //x2=16.24 //y2=5.38
r807 (  13 52 ) resistor r=0.002872 //w=0.34 //l=0.085 //layer=m1 \
 //thickness=0.36 //x=16.24 //y=5.24 //x2=16.24 //y2=5.155
r808 (  13 14 ) resistor r=0.091623 //w=0.191 //l=0.14 //layer=m1 \
 //thickness=0.36 //x=16.24 //y=5.24 //x2=16.24 //y2=5.38
r809 (  12 49 ) resistor r=0.0262263 //w=0.232 //l=0.12 //layer=m1 \
 //thickness=0.36 //x=15.48 //y=5.155 //x2=15.36 //y2=5.155
r810 (  11 52 ) resistor r=0.0675342 //w=0.23 //l=0.115 //layer=m1 \
 //thickness=0.36 //x=16.125 //y=5.155 //x2=16.24 //y2=5.155
r811 (  11 12 ) resistor r=0.615458 //w=0.131 //l=0.645 //layer=m1 \
 //thickness=0.36 //x=16.125 //y=5.155 //x2=15.48 //y2=5.155
r812 (  10 46 ) resistor r=0.0222262 //w=0.217 //l=0.118 //layer=m1 \
 //thickness=0.36 //x=14.6 //y=5.155 //x2=14.482 //y2=5.155
r813 (  9 49 ) resistor r=0.0262263 //w=0.232 //l=0.12 //layer=m1 \
 //thickness=0.36 //x=15.24 //y=5.155 //x2=15.36 //y2=5.155
r814 (  9 10 ) resistor r=0.610687 //w=0.131 //l=0.64 //layer=m1 \
 //thickness=0.36 //x=15.24 //y=5.155 //x2=14.6 //y2=5.155
r815 (  8 45 ) resistor r=0.0878548 //w=0.228 //l=0.159295 //layer=m1 \
 //thickness=0.36 //x=11.47 //y=4.555 //x2=11.5 //y2=4.7
r816 (  7 38 ) resistor r=0.0912814 //w=0.379 //l=0.183303 //layer=m1 \
 //thickness=0.36 //x=11.47 //y=4.23 //x2=11.42 //y2=4.07
r817 (  7 8 ) resistor r=0.310115 //w=0.131 //l=0.325 //layer=m1 \
 //thickness=0.36 //x=11.47 //y=4.23 //x2=11.47 //y2=4.555
r818 (  6 38 ) resistor r=0.0912814 //w=0.379 //l=0.183303 //layer=m1 \
 //thickness=0.36 //x=11.47 //y=3.91 //x2=11.42 //y2=4.07
r819 (  6 43 ) resistor r=1.62691 //w=0.131 //l=1.705 //layer=m1 \
 //thickness=0.36 //x=11.47 //y=3.91 //x2=11.47 //y2=2.205
r820 (  4 32 ) resistor r=0.0760407 //w=0.238 //l=0.125 //layer=m1 \
 //thickness=0.36 //x=1.11 //y=4.575 //x2=1.11 //y2=4.7
r821 (  3 36 ) resistor r=0.0911593 //w=0.376 //l=0.184174 //layer=m1 \
 //thickness=0.36 //x=1.11 //y=4.24 //x2=1.162 //y2=4.08
r822 (  3 4 ) resistor r=0.319656 //w=0.131 //l=0.335 //layer=m1 \
 //thickness=0.36 //x=1.11 //y=4.24 //x2=1.11 //y2=4.575
r823 (  2 34 ) resistor r=0.0878349 //w=0.376 //l=0.174069 //layer=m1 \
 //thickness=0.36 //x=1.11 //y=3.92 //x2=1.162 //y2=4.07
r824 (  1 30 ) resistor r=0.0719237 //w=0.222 //l=0.115 //layer=m1 \
 //thickness=0.36 //x=1.11 //y=2.195 //x2=1.11 //y2=2.08
r825 (  1 2 ) resistor r=1.64599 //w=0.131 //l=1.725 //layer=m1 \
 //thickness=0.36 //x=1.11 //y=2.195 //x2=1.11 //y2=3.92
ends PM_DFFRNX1_PCELL\%noxref_6

subckt PM_DFFRNX1_PCELL\%noxref_7 ( 45 64 73 83 91 101 119 129 137 147 163 171 \
 197 205 215 225 241 249 259 269 285 295 308 315 320 325 331 337 341 342 343 \
 344 345 346 347 348 349 350 351 352 353 354 355 356 357 358 359 360 361 362 )
c393 ( 362 0 ) capacitor c=0.039252f //x=24.975 //y=5.02
c394 ( 361 0 ) capacitor c=0.0248171f //x=24.095 //y=5.02
c395 ( 360 0 ) capacitor c=0.0630862f //x=23.225 //y=5.02
c396 ( 359 0 ) capacitor c=0.0466888f //x=21.345 //y=5.02
c397 ( 358 0 ) capacitor c=0.0255832f //x=20.465 //y=5.02
c398 ( 357 0 ) capacitor c=0.0256111f //x=19.585 //y=5.02
c399 ( 356 0 ) capacitor c=0.0676553f //x=18.715 //y=5.02
c400 ( 355 0 ) capacitor c=0.0466888f //x=16.535 //y=5.02
c401 ( 354 0 ) capacitor c=0.0256166f //x=15.655 //y=5.02
c402 ( 353 0 ) capacitor c=0.0255774f //x=14.775 //y=5.02
c403 ( 352 0 ) capacitor c=0.0674698f //x=13.905 //y=5.02
c404 ( 351 0 ) capacitor c=0.0395436f //x=12.025 //y=5.02
c405 ( 350 0 ) capacitor c=0.0248171f //x=11.145 //y=5.02
c406 ( 349 0 ) capacitor c=0.0628111f //x=10.275 //y=5.02
c407 ( 348 0 ) capacitor c=0.0466888f //x=8.395 //y=5.02
c408 ( 347 0 ) capacitor c=0.0255832f //x=7.515 //y=5.02
c409 ( 346 0 ) capacitor c=0.0256111f //x=6.635 //y=5.02
c410 ( 345 0 ) capacitor c=0.0675755f //x=5.765 //y=5.02
c411 ( 344 0 ) capacitor c=0.0466888f //x=3.585 //y=5.02
c412 ( 343 0 ) capacitor c=0.0256166f //x=2.705 //y=5.02
c413 ( 342 0 ) capacitor c=0.0256111f //x=1.825 //y=5.02
c414 ( 341 0 ) capacitor c=0.0693232f //x=0.955 //y=5.02
c415 ( 340 0 ) capacitor c=0.00591168f //x=25.12 //y=7.4
c416 ( 339 0 ) capacitor c=0.00591168f //x=24.24 //y=7.4
c417 ( 338 0 ) capacitor c=0.00591168f //x=23.36 //y=7.4
c418 ( 337 0 ) capacitor c=0.14636f //x=22.57 //y=7.4
c419 ( 336 0 ) capacitor c=0.00591168f //x=21.49 //y=7.4
c420 ( 335 0 ) capacitor c=0.00591168f //x=20.61 //y=7.4
c421 ( 334 0 ) capacitor c=0.00591168f //x=19.73 //y=7.4
c422 ( 333 0 ) capacitor c=0.00591168f //x=18.87 //y=7.4
c423 ( 331 0 ) capacitor c=0.161937f //x=17.76 //y=7.4
c424 ( 330 0 ) capacitor c=0.00591168f //x=16.68 //y=7.4
c425 ( 329 0 ) capacitor c=0.00591168f //x=15.8 //y=7.4
c426 ( 328 0 ) capacitor c=0.00591168f //x=14.92 //y=7.4
c427 ( 327 0 ) capacitor c=0.00591168f //x=14.06 //y=7.4
c428 ( 325 0 ) capacitor c=0.144309f //x=12.95 //y=7.4
c429 ( 324 0 ) capacitor c=0.00591168f //x=12.17 //y=7.4
c430 ( 323 0 ) capacitor c=0.00591168f //x=11.29 //y=7.4
c431 ( 322 0 ) capacitor c=0.00591168f //x=10.36 //y=7.4
c432 ( 320 0 ) capacitor c=0.14503f //x=9.62 //y=7.4
c433 ( 319 0 ) capacitor c=0.00591168f //x=8.54 //y=7.4
c434 ( 318 0 ) capacitor c=0.00591168f //x=7.66 //y=7.4
c435 ( 317 0 ) capacitor c=0.00591168f //x=6.78 //y=7.4
c436 ( 316 0 ) capacitor c=0.00591168f //x=5.9 //y=7.4
c437 ( 315 0 ) capacitor c=0.163218f //x=4.81 //y=7.4
c438 ( 314 0 ) capacitor c=0.00591168f //x=3.73 //y=7.4
c439 ( 313 0 ) capacitor c=0.00591168f //x=2.85 //y=7.4
c440 ( 312 0 ) capacitor c=0.00591168f //x=1.97 //y=7.4
c441 ( 311 0 ) capacitor c=0.00591168f //x=1.09 //y=7.4
c442 ( 308 0 ) capacitor c=0.243082f //x=25.53 //y=7.4
c443 ( 295 0 ) capacitor c=0.0284688f //x=25.035 //y=7.4
c444 ( 285 0 ) capacitor c=0.0288404f //x=24.155 //y=7.4
c445 ( 275 0 ) capacitor c=0.0281468f //x=23.275 //y=7.4
c446 ( 269 0 ) capacitor c=0.0419403f //x=22.4 //y=7.4
c447 ( 259 0 ) capacitor c=0.0286174f //x=21.405 //y=7.4
c448 ( 249 0 ) capacitor c=0.0286648f //x=20.525 //y=7.4
c449 ( 241 0 ) capacitor c=0.0287602f //x=19.645 //y=7.4
c450 ( 231 0 ) capacitor c=0.0452081f //x=18.765 //y=7.4
c451 ( 225 0 ) capacitor c=0.0424625f //x=17.59 //y=7.4
c452 ( 215 0 ) capacitor c=0.0286174f //x=16.595 //y=7.4
c453 ( 205 0 ) capacitor c=0.0286648f //x=15.715 //y=7.4
c454 ( 197 0 ) capacitor c=0.0287602f //x=14.835 //y=7.4
c455 ( 187 0 ) capacitor c=0.0452081f //x=13.955 //y=7.4
c456 ( 181 0 ) capacitor c=0.0275781f //x=12.78 //y=7.4
c457 ( 171 0 ) capacitor c=0.0284688f //x=12.085 //y=7.4
c458 ( 163 0 ) capacitor c=0.0288404f //x=11.205 //y=7.4
c459 ( 153 0 ) capacitor c=0.0281468f //x=10.325 //y=7.4
c460 ( 147 0 ) capacitor c=0.0419403f //x=9.45 //y=7.4
c461 ( 137 0 ) capacitor c=0.0286174f //x=8.455 //y=7.4
c462 ( 129 0 ) capacitor c=0.0286648f //x=7.575 //y=7.4
c463 ( 119 0 ) capacitor c=0.0287602f //x=6.695 //y=7.4
c464 ( 107 0 ) capacitor c=0.0452081f //x=5.815 //y=7.4
c465 ( 101 0 ) capacitor c=0.0419403f //x=4.64 //y=7.4
c466 ( 91 0 ) capacitor c=0.0286174f //x=3.645 //y=7.4
c467 ( 83 0 ) capacitor c=0.0286648f //x=2.765 //y=7.4
c468 ( 73 0 ) capacitor c=0.0287137f //x=1.885 //y=7.4
c469 ( 64 0 ) capacitor c=0.234862f //x=0.74 //y=7.4
c470 ( 61 0 ) capacitor c=0.045173f //x=1.005 //y=7.4
c471 ( 45 0 ) capacitor c=0.947974f //x=25.53 //y=7.4
r472 (  306 340 ) resistor r=2.94794 //w=0.34 //l=0.085 //layer=li \
 //thickness=0.1 //x=25.205 //y=7.4 //x2=25.12 //y2=7.4
r473 (  306 308 ) resistor r=11.6527 //w=0.357 //l=0.325 //layer=li \
 //thickness=0.1 //x=25.205 //y=7.4 //x2=25.53 //y2=7.4
r474 (  299 340 ) resistor r=4.11603 //w=0.68 //l=0.17 //layer=li \
 //thickness=0.1 //x=25.12 //y=7.23 //x2=25.12 //y2=7.4
r475 (  299 362 ) resistor r=33.1979 //w=0.187 //l=0.485 //layer=li \
 //thickness=0.1 //x=25.12 //y=7.23 //x2=25.12 //y2=6.745
r476 (  296 339 ) resistor r=2.94794 //w=0.34 //l=0.085 //layer=li \
 //thickness=0.1 //x=24.325 //y=7.4 //x2=24.24 //y2=7.4
r477 (  296 298 ) resistor r=16.6723 //w=0.357 //l=0.465 //layer=li \
 //thickness=0.1 //x=24.325 //y=7.4 //x2=24.79 //y2=7.4
r478 (  295 340 ) resistor r=2.94794 //w=0.34 //l=0.085 //layer=li \
 //thickness=0.1 //x=25.035 //y=7.4 //x2=25.12 //y2=7.4
r479 (  295 298 ) resistor r=8.78431 //w=0.357 //l=0.245 //layer=li \
 //thickness=0.1 //x=25.035 //y=7.4 //x2=24.79 //y2=7.4
r480 (  289 339 ) resistor r=4.11603 //w=0.68 //l=0.17 //layer=li \
 //thickness=0.1 //x=24.24 //y=7.23 //x2=24.24 //y2=7.4
r481 (  289 361 ) resistor r=33.1979 //w=0.187 //l=0.485 //layer=li \
 //thickness=0.1 //x=24.24 //y=7.23 //x2=24.24 //y2=6.745
r482 (  286 338 ) resistor r=2.94794 //w=0.34 //l=0.085 //layer=li \
 //thickness=0.1 //x=23.445 //y=7.4 //x2=23.36 //y2=7.4
r483 (  286 288 ) resistor r=8.42577 //w=0.357 //l=0.235 //layer=li \
 //thickness=0.1 //x=23.445 //y=7.4 //x2=23.68 //y2=7.4
r484 (  285 339 ) resistor r=2.94794 //w=0.34 //l=0.085 //layer=li \
 //thickness=0.1 //x=24.155 //y=7.4 //x2=24.24 //y2=7.4
r485 (  285 288 ) resistor r=17.0308 //w=0.357 //l=0.475 //layer=li \
 //thickness=0.1 //x=24.155 //y=7.4 //x2=23.68 //y2=7.4
r486 (  277 338 ) resistor r=4.11603 //w=0.68 //l=0.17 //layer=li \
 //thickness=0.1 //x=23.36 //y=7.23 //x2=23.36 //y2=7.4
r487 (  277 360 ) resistor r=56.4706 //w=0.187 //l=0.825 //layer=li \
 //thickness=0.1 //x=23.36 //y=7.23 //x2=23.36 //y2=6.405
r488 (  276 337 ) resistor r=5.4201 //w=0.34 //l=0.17 //layer=li \
 //thickness=0.1 //x=22.74 //y=7.4 //x2=22.57 //y2=7.4
r489 (  275 338 ) resistor r=2.94794 //w=0.34 //l=0.085 //layer=li \
 //thickness=0.1 //x=23.275 //y=7.4 //x2=23.36 //y2=7.4
r490 (  275 276 ) resistor r=19.1821 //w=0.357 //l=0.535 //layer=li \
 //thickness=0.1 //x=23.275 //y=7.4 //x2=22.74 //y2=7.4
r491 (  270 336 ) resistor r=2.94794 //w=0.34 //l=0.085 //layer=li \
 //thickness=0.1 //x=21.575 //y=7.4 //x2=21.49 //y2=7.4
r492 (  270 272 ) resistor r=22.409 //w=0.357 //l=0.625 //layer=li \
 //thickness=0.1 //x=21.575 //y=7.4 //x2=22.2 //y2=7.4
r493 (  269 337 ) resistor r=5.4201 //w=0.34 //l=0.17 //layer=li \
 //thickness=0.1 //x=22.4 //y=7.4 //x2=22.57 //y2=7.4
r494 (  269 272 ) resistor r=7.17087 //w=0.357 //l=0.2 //layer=li \
 //thickness=0.1 //x=22.4 //y=7.4 //x2=22.2 //y2=7.4
r495 (  263 336 ) resistor r=4.11603 //w=0.68 //l=0.17 //layer=li \
 //thickness=0.1 //x=21.49 //y=7.23 //x2=21.49 //y2=7.4
r496 (  263 359 ) resistor r=33.1979 //w=0.187 //l=0.485 //layer=li \
 //thickness=0.1 //x=21.49 //y=7.23 //x2=21.49 //y2=6.745
r497 (  260 335 ) resistor r=2.94794 //w=0.34 //l=0.085 //layer=li \
 //thickness=0.1 //x=20.695 //y=7.4 //x2=20.61 //y2=7.4
r498 (  260 262 ) resistor r=14.1625 //w=0.357 //l=0.395 //layer=li \
 //thickness=0.1 //x=20.695 //y=7.4 //x2=21.09 //y2=7.4
r499 (  259 336 ) resistor r=2.94794 //w=0.34 //l=0.085 //layer=li \
 //thickness=0.1 //x=21.405 //y=7.4 //x2=21.49 //y2=7.4
r500 (  259 262 ) resistor r=11.2941 //w=0.357 //l=0.315 //layer=li \
 //thickness=0.1 //x=21.405 //y=7.4 //x2=21.09 //y2=7.4
r501 (  253 335 ) resistor r=4.11603 //w=0.68 //l=0.17 //layer=li \
 //thickness=0.1 //x=20.61 //y=7.23 //x2=20.61 //y2=7.4
r502 (  253 358 ) resistor r=33.1979 //w=0.187 //l=0.485 //layer=li \
 //thickness=0.1 //x=20.61 //y=7.23 //x2=20.61 //y2=6.745
r503 (  250 334 ) resistor r=2.94794 //w=0.34 //l=0.085 //layer=li \
 //thickness=0.1 //x=19.815 //y=7.4 //x2=19.73 //y2=7.4
r504 (  250 252 ) resistor r=5.91597 //w=0.357 //l=0.165 //layer=li \
 //thickness=0.1 //x=19.815 //y=7.4 //x2=19.98 //y2=7.4
r505 (  249 335 ) resistor r=2.94794 //w=0.34 //l=0.085 //layer=li \
 //thickness=0.1 //x=20.525 //y=7.4 //x2=20.61 //y2=7.4
r506 (  249 252 ) resistor r=19.5406 //w=0.357 //l=0.545 //layer=li \
 //thickness=0.1 //x=20.525 //y=7.4 //x2=19.98 //y2=7.4
r507 (  243 334 ) resistor r=4.11603 //w=0.68 //l=0.17 //layer=li \
 //thickness=0.1 //x=19.73 //y=7.23 //x2=19.73 //y2=7.4
r508 (  243 357 ) resistor r=33.1979 //w=0.187 //l=0.485 //layer=li \
 //thickness=0.1 //x=19.73 //y=7.23 //x2=19.73 //y2=6.745
r509 (  242 333 ) resistor r=2.94794 //w=0.34 //l=0.085 //layer=li \
 //thickness=0.1 //x=18.935 //y=7.4 //x2=18.85 //y2=7.4
r510 (  241 334 ) resistor r=2.94794 //w=0.34 //l=0.085 //layer=li \
 //thickness=0.1 //x=19.645 //y=7.4 //x2=19.73 //y2=7.4
r511 (  241 242 ) resistor r=25.4566 //w=0.357 //l=0.71 //layer=li \
 //thickness=0.1 //x=19.645 //y=7.4 //x2=18.935 //y2=7.4
r512 (  233 333 ) resistor r=4.11603 //w=0.68 //l=0.17 //layer=li \
 //thickness=0.1 //x=18.85 //y=7.23 //x2=18.85 //y2=7.4
r513 (  233 356 ) resistor r=56.4706 //w=0.187 //l=0.825 //layer=li \
 //thickness=0.1 //x=18.85 //y=7.23 //x2=18.85 //y2=6.405
r514 (  232 331 ) resistor r=5.4201 //w=0.34 //l=0.17 //layer=li \
 //thickness=0.1 //x=17.93 //y=7.4 //x2=17.76 //y2=7.4
r515 (  231 333 ) resistor r=2.94794 //w=0.34 //l=0.085 //layer=li \
 //thickness=0.1 //x=18.765 //y=7.4 //x2=18.85 //y2=7.4
r516 (  231 232 ) resistor r=29.9384 //w=0.357 //l=0.835 //layer=li \
 //thickness=0.1 //x=18.765 //y=7.4 //x2=17.93 //y2=7.4
r517 (  226 330 ) resistor r=2.94794 //w=0.34 //l=0.085 //layer=li \
 //thickness=0.1 //x=16.765 //y=7.4 //x2=16.68 //y2=7.4
r518 (  226 228 ) resistor r=22.409 //w=0.357 //l=0.625 //layer=li \
 //thickness=0.1 //x=16.765 //y=7.4 //x2=17.39 //y2=7.4
r519 (  225 331 ) resistor r=5.4201 //w=0.34 //l=0.17 //layer=li \
 //thickness=0.1 //x=17.59 //y=7.4 //x2=17.76 //y2=7.4
r520 (  225 228 ) resistor r=7.17087 //w=0.357 //l=0.2 //layer=li \
 //thickness=0.1 //x=17.59 //y=7.4 //x2=17.39 //y2=7.4
r521 (  219 330 ) resistor r=4.11603 //w=0.68 //l=0.17 //layer=li \
 //thickness=0.1 //x=16.68 //y=7.23 //x2=16.68 //y2=7.4
r522 (  219 355 ) resistor r=33.1979 //w=0.187 //l=0.485 //layer=li \
 //thickness=0.1 //x=16.68 //y=7.23 //x2=16.68 //y2=6.745
r523 (  216 329 ) resistor r=2.94794 //w=0.34 //l=0.085 //layer=li \
 //thickness=0.1 //x=15.885 //y=7.4 //x2=15.8 //y2=7.4
r524 (  216 218 ) resistor r=14.1625 //w=0.357 //l=0.395 //layer=li \
 //thickness=0.1 //x=15.885 //y=7.4 //x2=16.28 //y2=7.4
r525 (  215 330 ) resistor r=2.94794 //w=0.34 //l=0.085 //layer=li \
 //thickness=0.1 //x=16.595 //y=7.4 //x2=16.68 //y2=7.4
r526 (  215 218 ) resistor r=11.2941 //w=0.357 //l=0.315 //layer=li \
 //thickness=0.1 //x=16.595 //y=7.4 //x2=16.28 //y2=7.4
r527 (  209 329 ) resistor r=4.11603 //w=0.68 //l=0.17 //layer=li \
 //thickness=0.1 //x=15.8 //y=7.23 //x2=15.8 //y2=7.4
r528 (  209 354 ) resistor r=33.1979 //w=0.187 //l=0.485 //layer=li \
 //thickness=0.1 //x=15.8 //y=7.23 //x2=15.8 //y2=6.745
r529 (  206 328 ) resistor r=2.94794 //w=0.34 //l=0.085 //layer=li \
 //thickness=0.1 //x=15.005 //y=7.4 //x2=14.92 //y2=7.4
r530 (  206 208 ) resistor r=5.91597 //w=0.357 //l=0.165 //layer=li \
 //thickness=0.1 //x=15.005 //y=7.4 //x2=15.17 //y2=7.4
r531 (  205 329 ) resistor r=2.94794 //w=0.34 //l=0.085 //layer=li \
 //thickness=0.1 //x=15.715 //y=7.4 //x2=15.8 //y2=7.4
r532 (  205 208 ) resistor r=19.5406 //w=0.357 //l=0.545 //layer=li \
 //thickness=0.1 //x=15.715 //y=7.4 //x2=15.17 //y2=7.4
r533 (  199 328 ) resistor r=4.11603 //w=0.68 //l=0.17 //layer=li \
 //thickness=0.1 //x=14.92 //y=7.23 //x2=14.92 //y2=7.4
r534 (  199 353 ) resistor r=33.1979 //w=0.187 //l=0.485 //layer=li \
 //thickness=0.1 //x=14.92 //y=7.23 //x2=14.92 //y2=6.745
r535 (  198 327 ) resistor r=2.94794 //w=0.34 //l=0.085 //layer=li \
 //thickness=0.1 //x=14.125 //y=7.4 //x2=14.04 //y2=7.4
r536 (  197 328 ) resistor r=2.94794 //w=0.34 //l=0.085 //layer=li \
 //thickness=0.1 //x=14.835 //y=7.4 //x2=14.92 //y2=7.4
r537 (  197 198 ) resistor r=25.4566 //w=0.357 //l=0.71 //layer=li \
 //thickness=0.1 //x=14.835 //y=7.4 //x2=14.125 //y2=7.4
r538 (  189 327 ) resistor r=4.11603 //w=0.68 //l=0.17 //layer=li \
 //thickness=0.1 //x=14.04 //y=7.23 //x2=14.04 //y2=7.4
r539 (  189 352 ) resistor r=56.4706 //w=0.187 //l=0.825 //layer=li \
 //thickness=0.1 //x=14.04 //y=7.23 //x2=14.04 //y2=6.405
r540 (  188 325 ) resistor r=5.4201 //w=0.34 //l=0.17 //layer=li \
 //thickness=0.1 //x=13.12 //y=7.4 //x2=12.95 //y2=7.4
r541 (  187 327 ) resistor r=2.94794 //w=0.34 //l=0.085 //layer=li \
 //thickness=0.1 //x=13.955 //y=7.4 //x2=14.04 //y2=7.4
r542 (  187 188 ) resistor r=29.9384 //w=0.357 //l=0.835 //layer=li \
 //thickness=0.1 //x=13.955 //y=7.4 //x2=13.12 //y2=7.4
r543 (  182 324 ) resistor r=2.94794 //w=0.34 //l=0.085 //layer=li \
 //thickness=0.1 //x=12.255 //y=7.4 //x2=12.17 //y2=7.4
r544 (  182 184 ) resistor r=11.6527 //w=0.357 //l=0.325 //layer=li \
 //thickness=0.1 //x=12.255 //y=7.4 //x2=12.58 //y2=7.4
r545 (  181 325 ) resistor r=5.4201 //w=0.34 //l=0.17 //layer=li \
 //thickness=0.1 //x=12.78 //y=7.4 //x2=12.95 //y2=7.4
r546 (  181 184 ) resistor r=7.17087 //w=0.357 //l=0.2 //layer=li \
 //thickness=0.1 //x=12.78 //y=7.4 //x2=12.58 //y2=7.4
r547 (  175 324 ) resistor r=4.11603 //w=0.68 //l=0.17 //layer=li \
 //thickness=0.1 //x=12.17 //y=7.23 //x2=12.17 //y2=7.4
r548 (  175 351 ) resistor r=33.1979 //w=0.187 //l=0.485 //layer=li \
 //thickness=0.1 //x=12.17 //y=7.23 //x2=12.17 //y2=6.745
r549 (  172 323 ) resistor r=2.94794 //w=0.34 //l=0.085 //layer=li \
 //thickness=0.1 //x=11.375 //y=7.4 //x2=11.29 //y2=7.4
r550 (  172 174 ) resistor r=3.40616 //w=0.357 //l=0.095 //layer=li \
 //thickness=0.1 //x=11.375 //y=7.4 //x2=11.47 //y2=7.4
r551 (  171 324 ) resistor r=2.94794 //w=0.34 //l=0.085 //layer=li \
 //thickness=0.1 //x=12.085 //y=7.4 //x2=12.17 //y2=7.4
r552 (  171 174 ) resistor r=22.0504 //w=0.357 //l=0.615 //layer=li \
 //thickness=0.1 //x=12.085 //y=7.4 //x2=11.47 //y2=7.4
r553 (  165 323 ) resistor r=4.11603 //w=0.68 //l=0.17 //layer=li \
 //thickness=0.1 //x=11.29 //y=7.23 //x2=11.29 //y2=7.4
r554 (  165 350 ) resistor r=33.1979 //w=0.187 //l=0.485 //layer=li \
 //thickness=0.1 //x=11.29 //y=7.23 //x2=11.29 //y2=6.745
r555 (  164 322 ) resistor r=2.94794 //w=0.34 //l=0.085 //layer=li \
 //thickness=0.1 //x=10.495 //y=7.4 //x2=10.41 //y2=7.4
r556 (  163 323 ) resistor r=2.94794 //w=0.34 //l=0.085 //layer=li \
 //thickness=0.1 //x=11.205 //y=7.4 //x2=11.29 //y2=7.4
r557 (  163 164 ) resistor r=25.4566 //w=0.357 //l=0.71 //layer=li \
 //thickness=0.1 //x=11.205 //y=7.4 //x2=10.495 //y2=7.4
r558 (  155 322 ) resistor r=4.11603 //w=0.68 //l=0.17 //layer=li \
 //thickness=0.1 //x=10.41 //y=7.23 //x2=10.41 //y2=7.4
r559 (  155 349 ) resistor r=56.4706 //w=0.187 //l=0.825 //layer=li \
 //thickness=0.1 //x=10.41 //y=7.23 //x2=10.41 //y2=6.405
r560 (  154 320 ) resistor r=5.4201 //w=0.34 //l=0.17 //layer=li \
 //thickness=0.1 //x=9.79 //y=7.4 //x2=9.62 //y2=7.4
r561 (  153 322 ) resistor r=2.94794 //w=0.34 //l=0.085 //layer=li \
 //thickness=0.1 //x=10.325 //y=7.4 //x2=10.41 //y2=7.4
r562 (  153 154 ) resistor r=19.1821 //w=0.357 //l=0.535 //layer=li \
 //thickness=0.1 //x=10.325 //y=7.4 //x2=9.79 //y2=7.4
r563 (  148 319 ) resistor r=2.94794 //w=0.34 //l=0.085 //layer=li \
 //thickness=0.1 //x=8.625 //y=7.4 //x2=8.54 //y2=7.4
r564 (  148 150 ) resistor r=9.14286 //w=0.357 //l=0.255 //layer=li \
 //thickness=0.1 //x=8.625 //y=7.4 //x2=8.88 //y2=7.4
r565 (  147 320 ) resistor r=5.4201 //w=0.34 //l=0.17 //layer=li \
 //thickness=0.1 //x=9.45 //y=7.4 //x2=9.62 //y2=7.4
r566 (  147 150 ) resistor r=20.437 //w=0.357 //l=0.57 //layer=li \
 //thickness=0.1 //x=9.45 //y=7.4 //x2=8.88 //y2=7.4
r567 (  141 319 ) resistor r=4.11603 //w=0.68 //l=0.17 //layer=li \
 //thickness=0.1 //x=8.54 //y=7.23 //x2=8.54 //y2=7.4
r568 (  141 348 ) resistor r=33.1979 //w=0.187 //l=0.485 //layer=li \
 //thickness=0.1 //x=8.54 //y=7.23 //x2=8.54 //y2=6.745
r569 (  138 318 ) resistor r=2.94794 //w=0.34 //l=0.085 //layer=li \
 //thickness=0.1 //x=7.745 //y=7.4 //x2=7.66 //y2=7.4
r570 (  138 140 ) resistor r=0.896359 //w=0.357 //l=0.025 //layer=li \
 //thickness=0.1 //x=7.745 //y=7.4 //x2=7.77 //y2=7.4
r571 (  137 319 ) resistor r=2.94794 //w=0.34 //l=0.085 //layer=li \
 //thickness=0.1 //x=8.455 //y=7.4 //x2=8.54 //y2=7.4
r572 (  137 140 ) resistor r=24.5602 //w=0.357 //l=0.685 //layer=li \
 //thickness=0.1 //x=8.455 //y=7.4 //x2=7.77 //y2=7.4
r573 (  131 318 ) resistor r=4.11603 //w=0.68 //l=0.17 //layer=li \
 //thickness=0.1 //x=7.66 //y=7.23 //x2=7.66 //y2=7.4
r574 (  131 347 ) resistor r=33.1979 //w=0.187 //l=0.485 //layer=li \
 //thickness=0.1 //x=7.66 //y=7.23 //x2=7.66 //y2=6.745
r575 (  130 317 ) resistor r=2.94794 //w=0.34 //l=0.085 //layer=li \
 //thickness=0.1 //x=6.865 //y=7.4 //x2=6.78 //y2=7.4
r576 (  129 318 ) resistor r=2.94794 //w=0.34 //l=0.085 //layer=li \
 //thickness=0.1 //x=7.575 //y=7.4 //x2=7.66 //y2=7.4
r577 (  129 130 ) resistor r=25.4566 //w=0.357 //l=0.71 //layer=li \
 //thickness=0.1 //x=7.575 //y=7.4 //x2=6.865 //y2=7.4
r578 (  123 317 ) resistor r=4.11603 //w=0.68 //l=0.17 //layer=li \
 //thickness=0.1 //x=6.78 //y=7.23 //x2=6.78 //y2=7.4
r579 (  123 346 ) resistor r=33.1979 //w=0.187 //l=0.485 //layer=li \
 //thickness=0.1 //x=6.78 //y=7.23 //x2=6.78 //y2=6.745
r580 (  120 316 ) resistor r=2.94794 //w=0.34 //l=0.085 //layer=li \
 //thickness=0.1 //x=5.985 //y=7.4 //x2=5.9 //y2=7.4
r581 (  120 122 ) resistor r=24.2017 //w=0.357 //l=0.675 //layer=li \
 //thickness=0.1 //x=5.985 //y=7.4 //x2=6.66 //y2=7.4
r582 (  119 317 ) resistor r=2.94794 //w=0.34 //l=0.085 //layer=li \
 //thickness=0.1 //x=6.695 //y=7.4 //x2=6.78 //y2=7.4
r583 (  119 122 ) resistor r=1.2549 //w=0.357 //l=0.035 //layer=li \
 //thickness=0.1 //x=6.695 //y=7.4 //x2=6.66 //y2=7.4
r584 (  111 316 ) resistor r=4.11603 //w=0.68 //l=0.17 //layer=li \
 //thickness=0.1 //x=5.9 //y=7.23 //x2=5.9 //y2=7.4
r585 (  111 345 ) resistor r=56.4706 //w=0.187 //l=0.825 //layer=li \
 //thickness=0.1 //x=5.9 //y=7.23 //x2=5.9 //y2=6.405
r586 (  108 315 ) resistor r=5.4201 //w=0.34 //l=0.17 //layer=li \
 //thickness=0.1 //x=4.98 //y=7.4 //x2=4.81 //y2=7.4
r587 (  108 110 ) resistor r=20.437 //w=0.357 //l=0.57 //layer=li \
 //thickness=0.1 //x=4.98 //y=7.4 //x2=5.55 //y2=7.4
r588 (  107 316 ) resistor r=2.94794 //w=0.34 //l=0.085 //layer=li \
 //thickness=0.1 //x=5.815 //y=7.4 //x2=5.9 //y2=7.4
r589 (  107 110 ) resistor r=9.5014 //w=0.357 //l=0.265 //layer=li \
 //thickness=0.1 //x=5.815 //y=7.4 //x2=5.55 //y2=7.4
r590 (  102 314 ) resistor r=2.94794 //w=0.34 //l=0.085 //layer=li \
 //thickness=0.1 //x=3.815 //y=7.4 //x2=3.73 //y2=7.4
r591 (  102 104 ) resistor r=9.14286 //w=0.357 //l=0.255 //layer=li \
 //thickness=0.1 //x=3.815 //y=7.4 //x2=4.07 //y2=7.4
r592 (  101 315 ) resistor r=5.4201 //w=0.34 //l=0.17 //layer=li \
 //thickness=0.1 //x=4.64 //y=7.4 //x2=4.81 //y2=7.4
r593 (  101 104 ) resistor r=20.437 //w=0.357 //l=0.57 //layer=li \
 //thickness=0.1 //x=4.64 //y=7.4 //x2=4.07 //y2=7.4
r594 (  95 314 ) resistor r=4.11603 //w=0.68 //l=0.17 //layer=li \
 //thickness=0.1 //x=3.73 //y=7.23 //x2=3.73 //y2=7.4
r595 (  95 344 ) resistor r=33.1979 //w=0.187 //l=0.485 //layer=li \
 //thickness=0.1 //x=3.73 //y=7.23 //x2=3.73 //y2=6.745
r596 (  92 313 ) resistor r=2.94794 //w=0.34 //l=0.085 //layer=li \
 //thickness=0.1 //x=2.935 //y=7.4 //x2=2.85 //y2=7.4
r597 (  92 94 ) resistor r=0.896359 //w=0.357 //l=0.025 //layer=li \
 //thickness=0.1 //x=2.935 //y=7.4 //x2=2.96 //y2=7.4
r598 (  91 314 ) resistor r=2.94794 //w=0.34 //l=0.085 //layer=li \
 //thickness=0.1 //x=3.645 //y=7.4 //x2=3.73 //y2=7.4
r599 (  91 94 ) resistor r=24.5602 //w=0.357 //l=0.685 //layer=li \
 //thickness=0.1 //x=3.645 //y=7.4 //x2=2.96 //y2=7.4
r600 (  85 313 ) resistor r=4.11603 //w=0.68 //l=0.17 //layer=li \
 //thickness=0.1 //x=2.85 //y=7.23 //x2=2.85 //y2=7.4
r601 (  85 343 ) resistor r=33.1979 //w=0.187 //l=0.485 //layer=li \
 //thickness=0.1 //x=2.85 //y=7.23 //x2=2.85 //y2=6.745
r602 (  84 312 ) resistor r=2.94794 //w=0.34 //l=0.085 //layer=li \
 //thickness=0.1 //x=2.055 //y=7.4 //x2=1.97 //y2=7.4
r603 (  83 313 ) resistor r=2.94794 //w=0.34 //l=0.085 //layer=li \
 //thickness=0.1 //x=2.765 //y=7.4 //x2=2.85 //y2=7.4
r604 (  83 84 ) resistor r=25.4566 //w=0.357 //l=0.71 //layer=li \
 //thickness=0.1 //x=2.765 //y=7.4 //x2=2.055 //y2=7.4
r605 (  77 312 ) resistor r=4.11603 //w=0.68 //l=0.17 //layer=li \
 //thickness=0.1 //x=1.97 //y=7.23 //x2=1.97 //y2=7.4
r606 (  77 342 ) resistor r=33.1979 //w=0.187 //l=0.485 //layer=li \
 //thickness=0.1 //x=1.97 //y=7.23 //x2=1.97 //y2=6.745
r607 (  74 311 ) resistor r=2.94794 //w=0.34 //l=0.085 //layer=li \
 //thickness=0.1 //x=1.175 //y=7.4 //x2=1.09 //y2=7.4
r608 (  74 76 ) resistor r=24.2017 //w=0.357 //l=0.675 //layer=li \
 //thickness=0.1 //x=1.175 //y=7.4 //x2=1.85 //y2=7.4
r609 (  73 312 ) resistor r=2.94794 //w=0.34 //l=0.085 //layer=li \
 //thickness=0.1 //x=1.885 //y=7.4 //x2=1.97 //y2=7.4
r610 (  73 76 ) resistor r=1.2549 //w=0.357 //l=0.035 //layer=li \
 //thickness=0.1 //x=1.885 //y=7.4 //x2=1.85 //y2=7.4
r611 (  65 311 ) resistor r=4.11603 //w=0.68 //l=0.17 //layer=li \
 //thickness=0.1 //x=1.09 //y=7.23 //x2=1.09 //y2=7.4
r612 (  65 341 ) resistor r=56.4706 //w=0.187 //l=0.825 //layer=li \
 //thickness=0.1 //x=1.09 //y=7.23 //x2=1.09 //y2=6.405
r613 (  61 311 ) resistor r=2.94794 //w=0.34 //l=0.085 //layer=li \
 //thickness=0.1 //x=1.005 //y=7.4 //x2=1.09 //y2=7.4
r614 (  61 64 ) resistor r=9.5014 //w=0.357 //l=0.265 //layer=li \
 //thickness=0.1 //x=1.005 //y=7.4 //x2=0.74 //y2=7.4
r615 (  45 308 ) resistor r=9.3 //w=0.17 //l=0.17 //layer=mcon //count=1 \
 //x=25.53 //y=7.4 //x2=25.53 //y2=7.4
r616 (  43 298 ) resistor r=3.1 //w=0.17 //l=0.51 //layer=mcon //count=3 \
 //x=24.79 //y=7.4 //x2=24.79 //y2=7.4
r617 (  43 45 ) resistor r=0.307309 //w=0.301 //l=0.74 //layer=m1 \
 //thickness=0.36 //x=24.79 //y=7.4 //x2=25.53 //y2=7.4
r618 (  41 288 ) resistor r=3.1 //w=0.17 //l=0.51 //layer=mcon //count=3 \
 //x=23.68 //y=7.4 //x2=23.68 //y2=7.4
r619 (  41 43 ) resistor r=0.460963 //w=0.301 //l=1.11 //layer=m1 \
 //thickness=0.36 //x=23.68 //y=7.4 //x2=24.79 //y2=7.4
r620 (  39 272 ) resistor r=3.1 //w=0.17 //l=0.51 //layer=mcon //count=3 \
 //x=22.2 //y=7.4 //x2=22.2 //y2=7.4
r621 (  39 41 ) resistor r=0.614618 //w=0.301 //l=1.48 //layer=m1 \
 //thickness=0.36 //x=22.2 //y=7.4 //x2=23.68 //y2=7.4
r622 (  37 262 ) resistor r=3.1 //w=0.17 //l=0.51 //layer=mcon //count=3 \
 //x=21.09 //y=7.4 //x2=21.09 //y2=7.4
r623 (  37 39 ) resistor r=0.460963 //w=0.301 //l=1.11 //layer=m1 \
 //thickness=0.36 //x=21.09 //y=7.4 //x2=22.2 //y2=7.4
r624 (  35 252 ) resistor r=3.1 //w=0.17 //l=0.51 //layer=mcon //count=3 \
 //x=19.98 //y=7.4 //x2=19.98 //y2=7.4
r625 (  35 37 ) resistor r=0.460963 //w=0.301 //l=1.11 //layer=m1 \
 //thickness=0.36 //x=19.98 //y=7.4 //x2=21.09 //y2=7.4
r626 (  33 333 ) resistor r=3.1 //w=0.17 //l=0.51 //layer=mcon //count=3 \
 //x=18.87 //y=7.4 //x2=18.87 //y2=7.4
r627 (  33 35 ) resistor r=0.460963 //w=0.301 //l=1.11 //layer=m1 \
 //thickness=0.36 //x=18.87 //y=7.4 //x2=19.98 //y2=7.4
r628 (  31 228 ) resistor r=3.1 //w=0.17 //l=0.51 //layer=mcon //count=3 \
 //x=17.39 //y=7.4 //x2=17.39 //y2=7.4
r629 (  31 33 ) resistor r=0.614618 //w=0.301 //l=1.48 //layer=m1 \
 //thickness=0.36 //x=17.39 //y=7.4 //x2=18.87 //y2=7.4
r630 (  29 218 ) resistor r=3.1 //w=0.17 //l=0.51 //layer=mcon //count=3 \
 //x=16.28 //y=7.4 //x2=16.28 //y2=7.4
r631 (  29 31 ) resistor r=0.460963 //w=0.301 //l=1.11 //layer=m1 \
 //thickness=0.36 //x=16.28 //y=7.4 //x2=17.39 //y2=7.4
r632 (  27 208 ) resistor r=3.1 //w=0.17 //l=0.51 //layer=mcon //count=3 \
 //x=15.17 //y=7.4 //x2=15.17 //y2=7.4
r633 (  27 29 ) resistor r=0.460963 //w=0.301 //l=1.11 //layer=m1 \
 //thickness=0.36 //x=15.17 //y=7.4 //x2=16.28 //y2=7.4
r634 (  25 327 ) resistor r=3.1 //w=0.17 //l=0.51 //layer=mcon //count=3 \
 //x=14.06 //y=7.4 //x2=14.06 //y2=7.4
r635 (  25 27 ) resistor r=0.460963 //w=0.301 //l=1.11 //layer=m1 \
 //thickness=0.36 //x=14.06 //y=7.4 //x2=15.17 //y2=7.4
r636 (  23 184 ) resistor r=3.1 //w=0.17 //l=0.51 //layer=mcon //count=3 \
 //x=12.58 //y=7.4 //x2=12.58 //y2=7.4
r637 (  23 25 ) resistor r=0.614618 //w=0.301 //l=1.48 //layer=m1 \
 //thickness=0.36 //x=12.58 //y=7.4 //x2=14.06 //y2=7.4
r638 (  21 174 ) resistor r=3.1 //w=0.17 //l=0.51 //layer=mcon //count=3 \
 //x=11.47 //y=7.4 //x2=11.47 //y2=7.4
r639 (  21 23 ) resistor r=0.460963 //w=0.301 //l=1.11 //layer=m1 \
 //thickness=0.36 //x=11.47 //y=7.4 //x2=12.58 //y2=7.4
r640 (  19 322 ) resistor r=3.1 //w=0.17 //l=0.51 //layer=mcon //count=3 \
 //x=10.36 //y=7.4 //x2=10.36 //y2=7.4
r641 (  19 21 ) resistor r=0.460963 //w=0.301 //l=1.11 //layer=m1 \
 //thickness=0.36 //x=10.36 //y=7.4 //x2=11.47 //y2=7.4
r642 (  17 150 ) resistor r=3.1 //w=0.17 //l=0.51 //layer=mcon //count=3 \
 //x=8.88 //y=7.4 //x2=8.88 //y2=7.4
r643 (  17 19 ) resistor r=0.614618 //w=0.301 //l=1.48 //layer=m1 \
 //thickness=0.36 //x=8.88 //y=7.4 //x2=10.36 //y2=7.4
r644 (  15 140 ) resistor r=3.1 //w=0.17 //l=0.51 //layer=mcon //count=3 \
 //x=7.77 //y=7.4 //x2=7.77 //y2=7.4
r645 (  15 17 ) resistor r=0.460963 //w=0.301 //l=1.11 //layer=m1 \
 //thickness=0.36 //x=7.77 //y=7.4 //x2=8.88 //y2=7.4
r646 (  13 122 ) resistor r=3.1 //w=0.17 //l=0.51 //layer=mcon //count=3 \
 //x=6.66 //y=7.4 //x2=6.66 //y2=7.4
r647 (  13 15 ) resistor r=0.460963 //w=0.301 //l=1.11 //layer=m1 \
 //thickness=0.36 //x=6.66 //y=7.4 //x2=7.77 //y2=7.4
r648 (  11 110 ) resistor r=3.1 //w=0.17 //l=0.51 //layer=mcon //count=3 \
 //x=5.55 //y=7.4 //x2=5.55 //y2=7.4
r649 (  11 13 ) resistor r=0.460963 //w=0.301 //l=1.11 //layer=m1 \
 //thickness=0.36 //x=5.55 //y=7.4 //x2=6.66 //y2=7.4
r650 (  9 104 ) resistor r=3.1 //w=0.17 //l=0.51 //layer=mcon //count=3 \
 //x=4.07 //y=7.4 //x2=4.07 //y2=7.4
r651 (  9 11 ) resistor r=0.614618 //w=0.301 //l=1.48 //layer=m1 \
 //thickness=0.36 //x=4.07 //y=7.4 //x2=5.55 //y2=7.4
r652 (  7 94 ) resistor r=3.1 //w=0.17 //l=0.51 //layer=mcon //count=3 \
 //x=2.96 //y=7.4 //x2=2.96 //y2=7.4
r653 (  7 9 ) resistor r=0.460963 //w=0.301 //l=1.11 //layer=m1 \
 //thickness=0.36 //x=2.96 //y=7.4 //x2=4.07 //y2=7.4
r654 (  5 76 ) resistor r=3.1 //w=0.17 //l=0.51 //layer=mcon //count=3 \
 //x=1.85 //y=7.4 //x2=1.85 //y2=7.4
r655 (  5 7 ) resistor r=0.460963 //w=0.301 //l=1.11 //layer=m1 \
 //thickness=0.36 //x=1.85 //y=7.4 //x2=2.96 //y2=7.4
r656 (  2 64 ) resistor r=3.1 //w=0.17 //l=0.51 //layer=mcon //count=3 \
 //x=0.74 //y=7.4 //x2=0.74 //y2=7.4
r657 (  2 5 ) resistor r=0.460963 //w=0.301 //l=1.11 //layer=m1 \
 //thickness=0.36 //x=0.74 //y=7.4 //x2=1.85 //y2=7.4
ends PM_DFFRNX1_PCELL\%noxref_7

subckt PM_DFFRNX1_PCELL\%noxref_8 ( 5 7 15 19 30 33 34 )
c64 ( 34 0 ) capacitor c=0.0487212f //x=2.965 //y=0.375
c65 ( 33 0 ) capacitor c=0.0198861f //x=1.86 //y=0.91
c66 ( 30 0 ) capacitor c=0.00141302f //x=3.1 //y=0.995
c67 ( 19 0 ) capacitor c=0.00692795f //x=4.07 //y=0.625
c68 ( 15 0 ) capacitor c=0.0154966f //x=3.985 //y=0.54
c69 ( 7 0 ) capacitor c=0.00689459f //x=3.1 //y=0.625
c70 ( 5 0 ) capacitor c=0.0290436f //x=3.015 //y=0.995
r71 (  19 34 ) resistor r=3.57586 //w=0.17 //l=0.125 //layer=li \
 //thickness=0.1 //x=4.07 //y=0.625 //x2=4.07 //y2=0.5
r72 (  19 34 ) resistor r=18.139 //w=0.187 //l=0.265 //layer=li \
 //thickness=0.1 //x=4.07 //y=0.625 //x2=4.07 //y2=0.89
r73 (  16 34 ) resistor r=3.57586 //w=0.17 //l=0.103078 //layer=li \
 //thickness=0.1 //x=3.185 //y=0.54 //x2=3.1 //y2=0.5
r74 (  16 34 ) resistor r=27.3797 //w=0.187 //l=0.4 //layer=li //thickness=0.1 \
 //x=3.185 //y=0.54 //x2=3.585 //y2=0.54
r75 (  15 34 ) resistor r=3.57586 //w=0.17 //l=0.103078 //layer=li \
 //thickness=0.1 //x=3.985 //y=0.54 //x2=4.07 //y2=0.5
r76 (  15 34 ) resistor r=27.3797 //w=0.187 //l=0.4 //layer=li //thickness=0.1 \
 //x=3.985 //y=0.54 //x2=3.585 //y2=0.54
r77 (  11 30 ) resistor r=5.4201 //w=0.17 //l=0.085 //layer=li //thickness=0.1 \
 //x=3.1 //y=1.08 //x2=3.1 //y2=0.995
r78 (  11 34 ) resistor r=10.2674 //w=0.187 //l=0.15 //layer=li \
 //thickness=0.1 //x=3.1 //y=1.08 //x2=3.1 //y2=1.23
r79 (  8 30 ) resistor r=5.4201 //w=0.17 //l=0.085 //layer=li //thickness=0.1 \
 //x=3.1 //y=0.91 //x2=3.1 //y2=0.995
r80 (  8 34 ) resistor r=1.36898 //w=0.187 //l=0.02 //layer=li //thickness=0.1 \
 //x=3.1 //y=0.91 //x2=3.1 //y2=0.89
r81 (  7 34 ) resistor r=3.57586 //w=0.17 //l=0.125 //layer=li //thickness=0.1 \
 //x=3.1 //y=0.625 //x2=3.1 //y2=0.5
r82 (  7 34 ) resistor r=18.139 //w=0.187 //l=0.265 //layer=li //thickness=0.1 \
 //x=3.1 //y=0.625 //x2=3.1 //y2=0.89
r83 (  6 33 ) resistor r=0.751729 //w=0.17 //l=0.085 //layer=li \
 //thickness=0.1 //x=2.135 //y=0.995 //x2=2.05 //y2=0.995
r84 (  5 30 ) resistor r=1.40859 //w=0.34 //l=0.085 //layer=li //thickness=0.1 \
 //x=3.015 //y=0.995 //x2=3.1 //y2=0.995
r85 (  5 6 ) resistor r=60.2353 //w=0.187 //l=0.88 //layer=li //thickness=0.1 \
 //x=3.015 //y=0.995 //x2=2.135 //y2=0.995
ends PM_DFFRNX1_PCELL\%noxref_8

subckt PM_DFFRNX1_PCELL\%noxref_9 ( 5 7 15 19 30 33 34 )
c67 ( 34 0 ) capacitor c=0.0454839f //x=7.775 //y=0.375
c68 ( 33 0 ) capacitor c=0.0198007f //x=6.67 //y=0.91
c69 ( 30 0 ) capacitor c=0.00141302f //x=7.91 //y=0.995
c70 ( 19 0 ) capacitor c=0.00695768f //x=8.88 //y=0.625
c71 ( 15 0 ) capacitor c=0.0153419f //x=8.795 //y=0.54
c72 ( 7 0 ) capacitor c=0.00689476f //x=7.91 //y=0.625
c73 ( 5 0 ) capacitor c=0.0290436f //x=7.825 //y=0.995
r74 (  19 34 ) resistor r=3.57586 //w=0.17 //l=0.125 //layer=li \
 //thickness=0.1 //x=8.88 //y=0.625 //x2=8.88 //y2=0.5
r75 (  19 34 ) resistor r=18.139 //w=0.187 //l=0.265 //layer=li \
 //thickness=0.1 //x=8.88 //y=0.625 //x2=8.88 //y2=0.89
r76 (  16 34 ) resistor r=3.57586 //w=0.17 //l=0.103078 //layer=li \
 //thickness=0.1 //x=7.995 //y=0.54 //x2=7.91 //y2=0.5
r77 (  16 34 ) resistor r=27.3797 //w=0.187 //l=0.4 //layer=li //thickness=0.1 \
 //x=7.995 //y=0.54 //x2=8.395 //y2=0.54
r78 (  15 34 ) resistor r=3.57586 //w=0.17 //l=0.103078 //layer=li \
 //thickness=0.1 //x=8.795 //y=0.54 //x2=8.88 //y2=0.5
r79 (  15 34 ) resistor r=27.3797 //w=0.187 //l=0.4 //layer=li //thickness=0.1 \
 //x=8.795 //y=0.54 //x2=8.395 //y2=0.54
r80 (  11 30 ) resistor r=5.4201 //w=0.17 //l=0.085 //layer=li //thickness=0.1 \
 //x=7.91 //y=1.08 //x2=7.91 //y2=0.995
r81 (  11 34 ) resistor r=10.2674 //w=0.187 //l=0.15 //layer=li \
 //thickness=0.1 //x=7.91 //y=1.08 //x2=7.91 //y2=1.23
r82 (  8 30 ) resistor r=5.4201 //w=0.17 //l=0.085 //layer=li //thickness=0.1 \
 //x=7.91 //y=0.91 //x2=7.91 //y2=0.995
r83 (  8 34 ) resistor r=1.36898 //w=0.187 //l=0.02 //layer=li //thickness=0.1 \
 //x=7.91 //y=0.91 //x2=7.91 //y2=0.89
r84 (  7 34 ) resistor r=3.57586 //w=0.17 //l=0.125 //layer=li //thickness=0.1 \
 //x=7.91 //y=0.625 //x2=7.91 //y2=0.5
r85 (  7 34 ) resistor r=18.139 //w=0.187 //l=0.265 //layer=li //thickness=0.1 \
 //x=7.91 //y=0.625 //x2=7.91 //y2=0.89
r86 (  6 33 ) resistor r=0.751729 //w=0.17 //l=0.085 //layer=li \
 //thickness=0.1 //x=6.945 //y=0.995 //x2=6.86 //y2=0.995
r87 (  5 30 ) resistor r=1.40859 //w=0.34 //l=0.085 //layer=li //thickness=0.1 \
 //x=7.825 //y=0.995 //x2=7.91 //y2=0.995
r88 (  5 6 ) resistor r=60.2353 //w=0.187 //l=0.88 //layer=li //thickness=0.1 \
 //x=7.825 //y=0.995 //x2=6.945 //y2=0.995
ends PM_DFFRNX1_PCELL\%noxref_9

subckt PM_DFFRNX1_PCELL\%noxref_10 ( 1 2 8 13 17 18 19 20 21 22 24 30 31 32 33 \
 34 42 )
c117 ( 42 0 ) capacitor c=0.0369044f //x=7.03 //y=4.7
c118 ( 34 0 ) capacitor c=0.0309248f //x=7.365 //y=4.79
c119 ( 33 0 ) capacitor c=0.0863671f //x=7.12 //y=1.915
c120 ( 32 0 ) capacitor c=0.0170266f //x=7.12 //y=1.45
c121 ( 31 0 ) capacitor c=0.018609f //x=7.12 //y=1.22
c122 ( 30 0 ) capacitor c=0.0186599f //x=7.12 //y=0.91
c123 ( 24 0 ) capacitor c=0.0146988f //x=6.965 //y=1.375
c124 ( 22 0 ) capacitor c=0.0148531f //x=6.965 //y=0.755
c125 ( 21 0 ) capacitor c=0.0334406f //x=6.595 //y=1.22
c126 ( 20 0 ) capacitor c=0.0173191f //x=6.595 //y=0.91
c127 ( 19 0 ) capacitor c=0.110208f //x=7.44 //y=6.02
c128 ( 18 0 ) capacitor c=0.110214f //x=7 //y=6.02
c129 ( 13 0 ) capacitor c=0.00129934f //x=7.03 //y=4.7
c130 ( 8 0 ) capacitor c=0.00121786f //x=7.03 //y=2.08
c131 ( 2 0 ) capacitor c=0.0728176f //x=7.03 //y=4.585
c132 ( 1 0 ) capacitor c=0.00586341f //x=7.03 //y=2.195
r133 (  44 45 ) resistor r=32.4568 //w=0.214 //l=0.075 //layer=ply \
 //thickness=0.18 //x=7.03 //y=4.79 //x2=7.03 //y2=4.865
r134 (  42 44 ) resistor r=20.271 //w=0.214 //l=0.09 //layer=ply \
 //thickness=0.18 //x=7.03 //y=4.7 //x2=7.03 //y2=4.79
r135 (  35 44 ) resistor r=16.5046 //w=0.27 //l=0.135 //layer=ply \
 //thickness=0.18 //x=7.165 //y=4.79 //x2=7.03 //y2=4.79
r136 (  34 36 ) resistor r=26.9307 //w=0.15 //l=0.106066 //layer=ply \
 //thickness=0.18 //x=7.365 //y=4.79 //x2=7.44 //y2=4.865
r137 (  34 35 ) resistor r=102.553 //w=0.094 //l=0.2 //layer=ply \
 //thickness=0.18 //x=7.365 //y=4.79 //x2=7.165 //y2=4.79
r138 (  33 49 ) resistor r=38.6777 //w=0.284 //l=0.198997 //layer=ply \
 //thickness=0.18 //x=7.12 //y=1.915 //x2=7.045 //y2=2.08
r139 (  32 47 ) resistor r=21.2976 //w=0.217 //l=0.0928709 //layer=ply \
 //thickness=0.18 //x=7.12 //y=1.45 //x2=7.08 //y2=1.375
r140 (  32 33 ) resistor r=238.436 //w=0.094 //l=0.465 //layer=ply \
 //thickness=0.18 //x=7.12 //y=1.45 //x2=7.12 //y2=1.915
r141 (  31 47 ) resistor r=39.0671 //w=0.217 //l=0.173853 //layer=ply \
 //thickness=0.18 //x=7.12 //y=1.22 //x2=7.08 //y2=1.375
r142 (  30 46 ) resistor r=45.1352 //w=0.168 //l=0.173853 //layer=ply \
 //thickness=0.18 //x=7.12 //y=0.91 //x2=7.08 //y2=0.755
r143 (  30 31 ) resistor r=158.957 //w=0.094 //l=0.31 //layer=ply \
 //thickness=0.18 //x=7.12 //y=0.91 //x2=7.12 //y2=1.22
r144 (  25 40 ) resistor r=5.52526 //w=0.168 //l=0.115 //layer=ply \
 //thickness=0.18 //x=6.75 //y=1.375 //x2=6.635 //y2=1.375
r145 (  24 47 ) resistor r=11.4558 //w=0.217 //l=0.115 //layer=ply \
 //thickness=0.18 //x=6.965 //y=1.375 //x2=7.08 //y2=1.375
r146 (  23 39 ) resistor r=5.52526 //w=0.168 //l=0.115 //layer=ply \
 //thickness=0.18 //x=6.75 //y=0.755 //x2=6.635 //y2=0.755
r147 (  22 46 ) resistor r=5.52526 //w=0.168 //l=0.115 //layer=ply \
 //thickness=0.18 //x=6.965 //y=0.755 //x2=7.08 //y2=0.755
r148 (  22 23 ) resistor r=110.245 //w=0.094 //l=0.215 //layer=ply \
 //thickness=0.18 //x=6.965 //y=0.755 //x2=6.75 //y2=0.755
r149 (  21 40 ) resistor r=45.1352 //w=0.168 //l=0.173853 //layer=ply \
 //thickness=0.18 //x=6.595 //y=1.22 //x2=6.635 //y2=1.375
r150 (  20 39 ) resistor r=45.1352 //w=0.168 //l=0.173853 //layer=ply \
 //thickness=0.18 //x=6.595 //y=0.91 //x2=6.635 //y2=0.755
r151 (  20 21 ) resistor r=158.957 //w=0.094 //l=0.31 //layer=ply \
 //thickness=0.18 //x=6.595 //y=0.91 //x2=6.595 //y2=1.22
r152 (  19 36 ) resistor r=592.245 //w=0.094 //l=1.155 //layer=ply \
 //thickness=0.18 //x=7.44 //y=6.02 //x2=7.44 //y2=4.865
r153 (  18 45 ) resistor r=592.245 //w=0.094 //l=1.155 //layer=ply \
 //thickness=0.18 //x=7 //y=6.02 //x2=7 //y2=4.865
r154 (  17 24 ) resistor r=55.3787 //w=0.094 //l=0.108 //layer=ply \
 //thickness=0.18 //x=6.857 //y=1.375 //x2=6.965 //y2=1.375
r155 (  17 25 ) resistor r=54.866 //w=0.094 //l=0.107 //layer=ply \
 //thickness=0.18 //x=6.857 //y=1.375 //x2=6.75 //y2=1.375
r156 (  13 42 ) resistor r=152 //w=0.17 //l=0.17 //layer=licon //count=1 \
 //x=7.03 //y=4.7 //x2=7.03 //y2=4.7
r157 (  8 49 ) resistor r=152 //w=0.17 //l=0.17 //layer=licon //count=1 \
 //x=7.03 //y=2.08 //x2=7.03 //y2=2.08
r158 (  6 13 ) resistor r=9.3 //w=0.17 //l=0.17 //layer=mcon //count=1 \
 //x=7.03 //y=4.7 //x2=7.03 //y2=4.7
r159 (  4 8 ) resistor r=9.3 //w=0.17 //l=0.17 //layer=mcon //count=1 //x=7.03 \
 //y=2.08 //x2=7.03 //y2=2.08
r160 (  2 6 ) resistor r=0.0717383 //w=0.224 //l=0.115 //layer=m1 \
 //thickness=0.36 //x=7.03 //y=4.585 //x2=7.03 //y2=4.7
r161 (  1 4 ) resistor r=0.0715665 //w=0.226 //l=0.115996 //layer=m1 \
 //thickness=0.36 //x=7.03 //y=2.195 //x2=7.032 //y2=2.08
r162 (  1 2 ) resistor r=2.28053 //w=0.131 //l=2.39 //layer=m1 \
 //thickness=0.36 //x=7.03 //y=2.195 //x2=7.03 //y2=4.585
ends PM_DFFRNX1_PCELL\%noxref_10

subckt PM_DFFRNX1_PCELL\%noxref_11 ( 5 7 15 19 30 33 34 )
c69 ( 34 0 ) capacitor c=0.0455032f //x=15.915 //y=0.375
c70 ( 33 0 ) capacitor c=0.019478f //x=14.81 //y=0.91
c71 ( 30 0 ) capacitor c=0.00141302f //x=16.05 //y=0.995
c72 ( 19 0 ) capacitor c=0.00692795f //x=17.02 //y=0.625
c73 ( 15 0 ) capacitor c=0.0153419f //x=16.935 //y=0.54
c74 ( 7 0 ) capacitor c=0.00689459f //x=16.05 //y=0.625
c75 ( 5 0 ) capacitor c=0.0237752f //x=15.965 //y=0.995
r76 (  19 34 ) resistor r=3.57586 //w=0.17 //l=0.125 //layer=li \
 //thickness=0.1 //x=17.02 //y=0.625 //x2=17.02 //y2=0.5
r77 (  19 34 ) resistor r=18.139 //w=0.187 //l=0.265 //layer=li \
 //thickness=0.1 //x=17.02 //y=0.625 //x2=17.02 //y2=0.89
r78 (  16 34 ) resistor r=3.57586 //w=0.17 //l=0.103078 //layer=li \
 //thickness=0.1 //x=16.135 //y=0.54 //x2=16.05 //y2=0.5
r79 (  16 34 ) resistor r=27.3797 //w=0.187 //l=0.4 //layer=li //thickness=0.1 \
 //x=16.135 //y=0.54 //x2=16.535 //y2=0.54
r80 (  15 34 ) resistor r=3.57586 //w=0.17 //l=0.103078 //layer=li \
 //thickness=0.1 //x=16.935 //y=0.54 //x2=17.02 //y2=0.5
r81 (  15 34 ) resistor r=27.3797 //w=0.187 //l=0.4 //layer=li //thickness=0.1 \
 //x=16.935 //y=0.54 //x2=16.535 //y2=0.54
r82 (  11 30 ) resistor r=5.4201 //w=0.17 //l=0.085 //layer=li //thickness=0.1 \
 //x=16.05 //y=1.08 //x2=16.05 //y2=0.995
r83 (  11 34 ) resistor r=10.2674 //w=0.187 //l=0.15 //layer=li \
 //thickness=0.1 //x=16.05 //y=1.08 //x2=16.05 //y2=1.23
r84 (  8 30 ) resistor r=5.4201 //w=0.17 //l=0.085 //layer=li //thickness=0.1 \
 //x=16.05 //y=0.91 //x2=16.05 //y2=0.995
r85 (  8 34 ) resistor r=1.36898 //w=0.187 //l=0.02 //layer=li //thickness=0.1 \
 //x=16.05 //y=0.91 //x2=16.05 //y2=0.89
r86 (  7 34 ) resistor r=3.57586 //w=0.17 //l=0.125 //layer=li //thickness=0.1 \
 //x=16.05 //y=0.625 //x2=16.05 //y2=0.5
r87 (  7 34 ) resistor r=18.139 //w=0.187 //l=0.265 //layer=li //thickness=0.1 \
 //x=16.05 //y=0.625 //x2=16.05 //y2=0.89
r88 (  6 33 ) resistor r=0.751729 //w=0.17 //l=0.085 //layer=li \
 //thickness=0.1 //x=15.085 //y=0.995 //x2=15 //y2=0.995
r89 (  5 30 ) resistor r=1.40859 //w=0.34 //l=0.085 //layer=li //thickness=0.1 \
 //x=15.965 //y=0.995 //x2=16.05 //y2=0.995
r90 (  5 6 ) resistor r=60.2353 //w=0.187 //l=0.88 //layer=li //thickness=0.1 \
 //x=15.965 //y=0.995 //x2=15.085 //y2=0.995
ends PM_DFFRNX1_PCELL\%noxref_11

subckt PM_DFFRNX1_PCELL\%noxref_12 ( 5 7 15 19 30 33 34 )
c66 ( 34 0 ) capacitor c=0.0482234f //x=20.725 //y=0.375
c67 ( 33 0 ) capacitor c=0.0186047f //x=19.62 //y=0.91
c68 ( 30 0 ) capacitor c=0.00141302f //x=20.86 //y=0.995
c69 ( 19 0 ) capacitor c=0.00695768f //x=21.83 //y=0.625
c70 ( 15 0 ) capacitor c=0.0155041f //x=21.745 //y=0.54
c71 ( 7 0 ) capacitor c=0.00689476f //x=20.86 //y=0.625
c72 ( 5 0 ) capacitor c=0.0290436f //x=20.775 //y=0.995
r73 (  19 34 ) resistor r=3.57586 //w=0.17 //l=0.125 //layer=li \
 //thickness=0.1 //x=21.83 //y=0.625 //x2=21.83 //y2=0.5
r74 (  19 34 ) resistor r=18.139 //w=0.187 //l=0.265 //layer=li \
 //thickness=0.1 //x=21.83 //y=0.625 //x2=21.83 //y2=0.89
r75 (  16 34 ) resistor r=3.57586 //w=0.17 //l=0.103078 //layer=li \
 //thickness=0.1 //x=20.945 //y=0.54 //x2=20.86 //y2=0.5
r76 (  16 34 ) resistor r=27.3797 //w=0.187 //l=0.4 //layer=li //thickness=0.1 \
 //x=20.945 //y=0.54 //x2=21.345 //y2=0.54
r77 (  15 34 ) resistor r=3.57586 //w=0.17 //l=0.103078 //layer=li \
 //thickness=0.1 //x=21.745 //y=0.54 //x2=21.83 //y2=0.5
r78 (  15 34 ) resistor r=27.3797 //w=0.187 //l=0.4 //layer=li //thickness=0.1 \
 //x=21.745 //y=0.54 //x2=21.345 //y2=0.54
r79 (  11 30 ) resistor r=5.4201 //w=0.17 //l=0.085 //layer=li //thickness=0.1 \
 //x=20.86 //y=1.08 //x2=20.86 //y2=0.995
r80 (  11 34 ) resistor r=10.2674 //w=0.187 //l=0.15 //layer=li \
 //thickness=0.1 //x=20.86 //y=1.08 //x2=20.86 //y2=1.23
r81 (  8 30 ) resistor r=5.4201 //w=0.17 //l=0.085 //layer=li //thickness=0.1 \
 //x=20.86 //y=0.91 //x2=20.86 //y2=0.995
r82 (  8 34 ) resistor r=1.36898 //w=0.187 //l=0.02 //layer=li //thickness=0.1 \
 //x=20.86 //y=0.91 //x2=20.86 //y2=0.89
r83 (  7 34 ) resistor r=3.57586 //w=0.17 //l=0.125 //layer=li //thickness=0.1 \
 //x=20.86 //y=0.625 //x2=20.86 //y2=0.5
r84 (  7 34 ) resistor r=18.139 //w=0.187 //l=0.265 //layer=li //thickness=0.1 \
 //x=20.86 //y=0.625 //x2=20.86 //y2=0.89
r85 (  6 33 ) resistor r=0.751729 //w=0.17 //l=0.085 //layer=li \
 //thickness=0.1 //x=19.895 //y=0.995 //x2=19.81 //y2=0.995
r86 (  5 30 ) resistor r=1.40859 //w=0.34 //l=0.085 //layer=li //thickness=0.1 \
 //x=20.775 //y=0.995 //x2=20.86 //y2=0.995
r87 (  5 6 ) resistor r=60.2353 //w=0.187 //l=0.88 //layer=li //thickness=0.1 \
 //x=20.775 //y=0.995 //x2=19.895 //y2=0.995
ends PM_DFFRNX1_PCELL\%noxref_12

subckt PM_DFFRNX1_PCELL\%noxref_13 ( 1 2 8 13 17 18 19 23 24 25 30 32 35 36 38 \
 39 44 )
c94 ( 44 0 ) capacitor c=0.0710579f //x=21.09 //y=4.7
c95 ( 39 0 ) capacitor c=0.0296417f //x=21.09 //y=1.915
c96 ( 38 0 ) capacitor c=0.0504691f //x=21.09 //y=2.08
c97 ( 36 0 ) capacitor c=0.0443175f //x=21.61 //y=1.26
c98 ( 35 0 ) capacitor c=0.0199703f //x=21.61 //y=0.915
c99 ( 32 0 ) capacitor c=0.0162526f //x=21.455 //y=1.415
c100 ( 30 0 ) capacitor c=0.0157807f //x=21.455 //y=0.76
c101 ( 25 0 ) capacitor c=0.0220935f //x=21.08 //y=1.57
c102 ( 24 0 ) capacitor c=0.0207489f //x=21.08 //y=1.26
c103 ( 23 0 ) capacitor c=0.0194091f //x=21.08 //y=0.915
c104 ( 19 0 ) capacitor c=0.161796f //x=21.27 //y=6.02
c105 ( 18 0 ) capacitor c=0.110208f //x=20.83 //y=6.02
c106 ( 13 0 ) capacitor c=7.74199e-19 //x=21.09 //y=4.7
c107 ( 8 0 ) capacitor c=0.00101179f //x=21.09 //y=2.08
c108 ( 2 0 ) capacitor c=0.0708768f //x=21.09 //y=4.57
c109 ( 1 0 ) capacitor c=0.00746766f //x=21.09 //y=2.195
r110 (  38 39 ) resistor r=52.7279 //w=0.214 //l=0.165 //layer=ply \
 //thickness=0.18 //x=21.09 //y=2.08 //x2=21.09 //y2=1.915
r111 (  36 46 ) resistor r=45.1352 //w=0.168 //l=0.173853 //layer=ply \
 //thickness=0.18 //x=21.61 //y=1.26 //x2=21.57 //y2=1.415
r112 (  35 45 ) resistor r=45.1352 //w=0.168 //l=0.173853 //layer=ply \
 //thickness=0.18 //x=21.61 //y=0.915 //x2=21.57 //y2=0.76
r113 (  35 36 ) resistor r=176.904 //w=0.094 //l=0.345 //layer=ply \
 //thickness=0.18 //x=21.61 //y=0.915 //x2=21.61 //y2=1.26
r114 (  33 42 ) resistor r=10.701 //w=0.21 //l=0.115 //layer=ply \
 //thickness=0.18 //x=21.235 //y=1.415 //x2=21.12 //y2=1.415
r115 (  32 46 ) resistor r=5.52526 //w=0.168 //l=0.115 //layer=ply \
 //thickness=0.18 //x=21.455 //y=1.415 //x2=21.57 //y2=1.415
r116 (  31 41 ) resistor r=5.52526 //w=0.168 //l=0.115 //layer=ply \
 //thickness=0.18 //x=21.235 //y=0.76 //x2=21.12 //y2=0.76
r117 (  30 45 ) resistor r=5.52526 //w=0.168 //l=0.115 //layer=ply \
 //thickness=0.18 //x=21.455 //y=0.76 //x2=21.57 //y2=0.76
r118 (  30 31 ) resistor r=112.809 //w=0.094 //l=0.22 //layer=ply \
 //thickness=0.18 //x=21.455 //y=0.76 //x2=21.235 //y2=0.76
r119 (  27 44 ) resistor r=37.236 //w=0.233 //l=0.249199 //layer=ply \
 //thickness=0.18 //x=21.27 //y=4.865 //x2=21.09 //y2=4.7
r120 (  25 42 ) resistor r=39.5823 //w=0.21 //l=0.173853 //layer=ply \
 //thickness=0.18 //x=21.08 //y=1.57 //x2=21.12 //y2=1.415
r121 (  25 39 ) resistor r=176.904 //w=0.094 //l=0.345 //layer=ply \
 //thickness=0.18 //x=21.08 //y=1.57 //x2=21.08 //y2=1.915
r122 (  24 42 ) resistor r=39.5823 //w=0.21 //l=0.173853 //layer=ply \
 //thickness=0.18 //x=21.08 //y=1.26 //x2=21.12 //y2=1.415
r123 (  23 41 ) resistor r=45.1352 //w=0.168 //l=0.173853 //layer=ply \
 //thickness=0.18 //x=21.08 //y=0.915 //x2=21.12 //y2=0.76
r124 (  23 24 ) resistor r=176.904 //w=0.094 //l=0.345 //layer=ply \
 //thickness=0.18 //x=21.08 //y=0.915 //x2=21.08 //y2=1.26
r125 (  20 44 ) resistor r=53.7854 //w=0.233 //l=0.332415 //layer=ply \
 //thickness=0.18 //x=20.83 //y=4.865 //x2=21.09 //y2=4.7
r126 (  19 27 ) resistor r=592.245 //w=0.094 //l=1.155 //layer=ply \
 //thickness=0.18 //x=21.27 //y=6.02 //x2=21.27 //y2=4.865
r127 (  18 20 ) resistor r=592.245 //w=0.094 //l=1.155 //layer=ply \
 //thickness=0.18 //x=20.83 //y=6.02 //x2=20.83 //y2=4.865
r128 (  17 32 ) resistor r=56.4043 //w=0.094 //l=0.11 //layer=ply \
 //thickness=0.18 //x=21.345 //y=1.415 //x2=21.455 //y2=1.415
r129 (  17 33 ) resistor r=56.4043 //w=0.094 //l=0.11 //layer=ply \
 //thickness=0.18 //x=21.345 //y=1.415 //x2=21.235 //y2=1.415
r130 (  13 44 ) resistor r=152 //w=0.17 //l=0.17 //layer=licon //count=1 \
 //x=21.09 //y=4.7 //x2=21.09 //y2=4.7
r131 (  8 38 ) resistor r=152 //w=0.17 //l=0.17 //layer=licon //count=1 \
 //x=21.09 //y=2.08 //x2=21.09 //y2=2.08
r132 (  6 13 ) resistor r=9.3 //w=0.17 //l=0.17 //layer=mcon //count=1 \
 //x=21.09 //y=4.7 //x2=21.09 //y2=4.7
r133 (  4 8 ) resistor r=9.3 //w=0.17 //l=0.17 //layer=mcon //count=1 \
 //x=21.09 //y=2.08 //x2=21.09 //y2=2.08
r134 (  2 6 ) resistor r=0.0801089 //w=0.224 //l=0.13 //layer=m1 \
 //thickness=0.36 //x=21.09 //y=4.57 //x2=21.09 //y2=4.7
r135 (  1 4 ) resistor r=0.0719237 //w=0.222 //l=0.115 //layer=m1 \
 //thickness=0.36 //x=21.09 //y=2.195 //x2=21.09 //y2=2.08
r136 (  1 2 ) resistor r=2.26622 //w=0.131 //l=2.375 //layer=m1 \
 //thickness=0.36 //x=21.09 //y=2.195 //x2=21.09 //y2=4.57
ends PM_DFFRNX1_PCELL\%noxref_13

subckt PM_DFFRNX1_PCELL\%noxref_14 ( 1 3 6 7 9 10 11 12 14 15 18 21 27 35 43 \
 55 57 58 59 )
c136 ( 55 0 ) capacitor c=0.00885916f //x=21.155 //y=0.915
c137 ( 43 0 ) capacitor c=0.0292634f //x=21.05 //y=5.38
c138 ( 35 0 ) capacitor c=0.029137f //x=20.17 //y=5.38
c139 ( 27 0 ) capacitor c=0.0278099f //x=19.29 //y=5.38
c140 ( 21 0 ) capacitor c=0.00127215f //x=21.05 //y=5.155
c141 ( 18 0 ) capacitor c=0.00825613f //x=20.17 //y=5.155
c142 ( 15 0 ) capacitor c=0.0113499f //x=19.292 //y=5.155
c143 ( 14 0 ) capacitor c=0.0948958f //x=21.83 //y=5.07
c144 ( 12 0 ) capacitor c=0.00722566f //x=21.43 //y=1.665
c145 ( 11 0 ) capacitor c=0.0172255f //x=21.745 //y=1.665
c146 ( 10 0 ) capacitor c=0.0136149f //x=21.345 //y=1.58
c147 ( 9 0 ) capacitor c=0.0114373f //x=21.345 //y=1.125
c148 ( 7 0 ) capacitor c=0.0261414f //x=21.745 //y=5.155
c149 ( 6 0 ) capacitor c=0.00906713f //x=21.05 //y=5.38
c150 ( 3 0 ) capacitor c=0.0200404f //x=20.935 //y=5.155
c151 ( 1 0 ) capacitor c=0.0154206f //x=20.05 //y=5.155
r152 (  43 59 ) resistor r=23.615 //w=0.187 //l=0.345 //layer=li \
 //thickness=0.1 //x=21.05 //y=5.38 //x2=21.05 //y2=5.725
r153 (  35 58 ) resistor r=23.615 //w=0.187 //l=0.345 //layer=li \
 //thickness=0.1 //x=20.17 //y=5.38 //x2=20.17 //y2=5.725
r154 (  27 57 ) resistor r=23.615 //w=0.187 //l=0.345 //layer=li \
 //thickness=0.1 //x=19.29 //y=5.38 //x2=19.29 //y2=5.725
r155 (  25 55 ) resistor r=9.3 //w=0.17 //l=0.17 //layer=mcon //count=1 \
 //x=21.345 //y=1.01 //x2=21.345 //y2=1.01
r156 (  23 43 ) resistor r=9.3 //w=0.17 //l=0.17 //layer=mcon //count=1 \
 //x=21.05 //y=5.38 //x2=21.05 //y2=5.38
r157 (  20 35 ) resistor r=9.3 //w=0.17 //l=0.17 //layer=mcon //count=1 \
 //x=20.17 //y=5.38 //x2=20.17 //y2=5.38
r158 (  18 20 ) resistor r=0.121228 //w=0.232 //l=0.225 //layer=m1 \
 //thickness=0.36 //x=20.17 //y=5.155 //x2=20.17 //y2=5.38
r159 (  17 27 ) resistor r=9.3 //w=0.17 //l=0.17 //layer=mcon //count=1 \
 //x=19.29 //y=5.38 //x2=19.29 //y2=5.38
r160 (  15 17 ) resistor r=0.129608 //w=0.217 //l=0.225 //layer=m1 \
 //thickness=0.36 //x=19.292 //y=5.155 //x2=19.292 //y2=5.38
r161 (  13 14 ) resistor r=3.16794 //w=0.131 //l=3.32 //layer=m1 \
 //thickness=0.36 //x=21.83 //y=1.75 //x2=21.83 //y2=5.07
r162 (  11 13 ) resistor r=0.0698411 //w=0.17 //l=0.120208 //layer=m1 \
 //thickness=0.36 //x=21.745 //y=1.665 //x2=21.83 //y2=1.75
r163 (  11 12 ) resistor r=0.300573 //w=0.131 //l=0.315 //layer=m1 \
 //thickness=0.36 //x=21.745 //y=1.665 //x2=21.43 //y2=1.665
r164 (  10 12 ) resistor r=0.0698411 //w=0.17 //l=0.120208 //layer=m1 \
 //thickness=0.36 //x=21.345 //y=1.58 //x2=21.43 //y2=1.665
r165 (  9 25 ) resistor r=0.0717383 //w=0.224 //l=0.115 //layer=m1 \
 //thickness=0.36 //x=21.345 //y=1.125 //x2=21.345 //y2=1.01
r166 (  9 10 ) resistor r=0.43416 //w=0.131 //l=0.455 //layer=m1 \
 //thickness=0.36 //x=21.345 //y=1.125 //x2=21.345 //y2=1.58
r167 (  8 21 ) resistor r=0.0675342 //w=0.23 //l=0.115 //layer=m1 \
 //thickness=0.36 //x=21.165 //y=5.155 //x2=21.05 //y2=5.155
r168 (  7 14 ) resistor r=0.0698411 //w=0.17 //l=0.120208 //layer=m1 \
 //thickness=0.36 //x=21.745 //y=5.155 //x2=21.83 //y2=5.07
r169 (  7 8 ) resistor r=0.553435 //w=0.131 //l=0.58 //layer=m1 \
 //thickness=0.36 //x=21.745 //y=5.155 //x2=21.165 //y2=5.155
r170 (  6 23 ) resistor r=0.00118313 //w=0.23 //layer=m1 //thickness=0.36 \
 //x=21.05 //y=5.38 //x2=21.05 //y2=5.38
r171 (  5 21 ) resistor r=0.002872 //w=0.34 //l=0.085 //layer=m1 \
 //thickness=0.36 //x=21.05 //y=5.24 //x2=21.05 //y2=5.155
r172 (  5 6 ) resistor r=0.091623 //w=0.191 //l=0.14 //layer=m1 \
 //thickness=0.36 //x=21.05 //y=5.24 //x2=21.05 //y2=5.38
r173 (  4 18 ) resistor r=0.0262263 //w=0.232 //l=0.12 //layer=m1 \
 //thickness=0.36 //x=20.29 //y=5.155 //x2=20.17 //y2=5.155
r174 (  3 21 ) resistor r=0.0675342 //w=0.23 //l=0.115 //layer=m1 \
 //thickness=0.36 //x=20.935 //y=5.155 //x2=21.05 //y2=5.155
r175 (  3 4 ) resistor r=0.615458 //w=0.131 //l=0.645 //layer=m1 \
 //thickness=0.36 //x=20.935 //y=5.155 //x2=20.29 //y2=5.155
r176 (  2 15 ) resistor r=0.0222262 //w=0.217 //l=0.118 //layer=m1 \
 //thickness=0.36 //x=19.41 //y=5.155 //x2=19.292 //y2=5.155
r177 (  1 18 ) resistor r=0.0262263 //w=0.232 //l=0.12 //layer=m1 \
 //thickness=0.36 //x=20.05 //y=5.155 //x2=20.17 //y2=5.155
r178 (  1 2 ) resistor r=0.610687 //w=0.131 //l=0.64 //layer=m1 \
 //thickness=0.36 //x=20.05 //y=5.155 //x2=19.41 //y2=5.155
ends PM_DFFRNX1_PCELL\%noxref_14

subckt PM_DFFRNX1_PCELL\%noxref_15 ( 4 7 8 11 16 20 21 22 23 24 25 26 30 32 35 \
 36 46 )
c103 ( 46 0 ) capacitor c=0.0682508f //x=23.68 //y=4.7
c104 ( 36 0 ) capacitor c=0.0318956f //x=24.015 //y=1.21
c105 ( 35 0 ) capacitor c=0.0186809f //x=24.015 //y=0.865
c106 ( 32 0 ) capacitor c=0.0141821f //x=23.86 //y=1.365
c107 ( 30 0 ) capacitor c=0.0158553f //x=23.86 //y=0.71
c108 ( 26 0 ) capacitor c=0.088055f //x=23.485 //y=1.915
c109 ( 25 0 ) capacitor c=0.0229235f //x=23.485 //y=1.52
c110 ( 24 0 ) capacitor c=0.0234359f //x=23.485 //y=1.21
c111 ( 23 0 ) capacitor c=0.0198759f //x=23.485 //y=0.865
c112 ( 22 0 ) capacitor c=0.110369f //x=24.02 //y=6.02
c113 ( 21 0 ) capacitor c=0.154619f //x=23.58 //y=6.02
c114 ( 16 0 ) capacitor c=8.13451e-19 //x=23.68 //y=4.7
c115 ( 11 0 ) capacitor c=7.85889e-19 //x=23.68 //y=2.08
c116 ( 8 0 ) capacitor c=0.073411f //x=23.682 //y=4.56
c117 ( 7 0 ) capacitor c=0.0065088f //x=23.68 //y=4.7
c118 ( 4 0 ) capacitor c=0.00694018f //x=23.68 //y=2.08
r119 (  44 46 ) resistor r=20.6867 //w=0.233 //l=0.1 //layer=ply \
 //thickness=0.18 //x=23.58 //y=4.7 //x2=23.68 //y2=4.7
r120 (  37 46 ) resistor r=70.3348 //w=0.233 //l=0.414367 //layer=ply \
 //thickness=0.18 //x=24.02 //y=4.865 //x2=23.68 //y2=4.7
r121 (  36 48 ) resistor r=45.1352 //w=0.168 //l=0.173853 //layer=ply \
 //thickness=0.18 //x=24.015 //y=1.21 //x2=23.975 //y2=1.365
r122 (  35 47 ) resistor r=45.1352 //w=0.168 //l=0.173853 //layer=ply \
 //thickness=0.18 //x=24.015 //y=0.865 //x2=23.975 //y2=0.71
r123 (  35 36 ) resistor r=176.904 //w=0.094 //l=0.345 //layer=ply \
 //thickness=0.18 //x=24.015 //y=0.865 //x2=24.015 //y2=1.21
r124 (  33 43 ) resistor r=10.701 //w=0.21 //l=0.115 //layer=ply \
 //thickness=0.18 //x=23.64 //y=1.365 //x2=23.525 //y2=1.365
r125 (  32 48 ) resistor r=5.52526 //w=0.168 //l=0.115 //layer=ply \
 //thickness=0.18 //x=23.86 //y=1.365 //x2=23.975 //y2=1.365
r126 (  31 42 ) resistor r=5.52526 //w=0.168 //l=0.115 //layer=ply \
 //thickness=0.18 //x=23.64 //y=0.71 //x2=23.525 //y2=0.71
r127 (  30 47 ) resistor r=5.52526 //w=0.168 //l=0.115 //layer=ply \
 //thickness=0.18 //x=23.86 //y=0.71 //x2=23.975 //y2=0.71
r128 (  30 31 ) resistor r=112.809 //w=0.094 //l=0.22 //layer=ply \
 //thickness=0.18 //x=23.86 //y=0.71 //x2=23.64 //y2=0.71
r129 (  27 44 ) resistor r=13.0941 //w=0.233 //l=0.165 //layer=ply \
 //thickness=0.18 //x=23.58 //y=4.865 //x2=23.58 //y2=4.7
r130 (  26 41 ) resistor r=34.8111 //w=0.27 //l=0.264953 //layer=ply \
 //thickness=0.18 //x=23.485 //y=1.915 //x2=23.68 //y2=2.08
r131 (  25 43 ) resistor r=39.5823 //w=0.21 //l=0.173853 //layer=ply \
 //thickness=0.18 //x=23.485 //y=1.52 //x2=23.525 //y2=1.365
r132 (  25 26 ) resistor r=202.543 //w=0.094 //l=0.395 //layer=ply \
 //thickness=0.18 //x=23.485 //y=1.52 //x2=23.485 //y2=1.915
r133 (  24 43 ) resistor r=39.5823 //w=0.21 //l=0.173853 //layer=ply \
 //thickness=0.18 //x=23.485 //y=1.21 //x2=23.525 //y2=1.365
r134 (  23 42 ) resistor r=45.1352 //w=0.168 //l=0.173853 //layer=ply \
 //thickness=0.18 //x=23.485 //y=0.865 //x2=23.525 //y2=0.71
r135 (  23 24 ) resistor r=176.904 //w=0.094 //l=0.345 //layer=ply \
 //thickness=0.18 //x=23.485 //y=0.865 //x2=23.485 //y2=1.21
r136 (  22 37 ) resistor r=592.245 //w=0.094 //l=1.155 //layer=ply \
 //thickness=0.18 //x=24.02 //y=6.02 //x2=24.02 //y2=4.865
r137 (  21 27 ) resistor r=592.245 //w=0.094 //l=1.155 //layer=ply \
 //thickness=0.18 //x=23.58 //y=6.02 //x2=23.58 //y2=4.865
r138 (  20 32 ) resistor r=56.4043 //w=0.094 //l=0.11 //layer=ply \
 //thickness=0.18 //x=23.75 //y=1.365 //x2=23.86 //y2=1.365
r139 (  20 33 ) resistor r=56.4043 //w=0.094 //l=0.11 //layer=ply \
 //thickness=0.18 //x=23.75 //y=1.365 //x2=23.64 //y2=1.365
r140 (  16 46 ) resistor r=152 //w=0.17 //l=0.17 //layer=licon //count=1 \
 //x=23.68 //y=4.7 //x2=23.68 //y2=4.7
r141 (  11 41 ) resistor r=152 //w=0.17 //l=0.17 //layer=licon //count=1 \
 //x=23.68 //y=2.08 //x2=23.68 //y2=2.08
r142 (  7 16 ) resistor r=9.3 //w=0.17 //l=0.17 //layer=mcon //count=1 \
 //x=23.68 //y=4.7 //x2=23.68 //y2=4.7
r143 (  7 8 ) resistor r=0.103207 //w=0.196 //l=0.14 //layer=m1 \
 //thickness=0.36 //x=23.682 //y=4.7 //x2=23.682 //y2=4.56
r144 (  4 11 ) resistor r=9.3 //w=0.17 //l=0.17 //layer=mcon //count=1 \
 //x=23.68 //y=2.08 //x2=23.68 //y2=2.08
r145 (  1 4 ) resistor r=0.0933015 //w=0.201 //l=0.125 //layer=m1 \
 //thickness=0.36 //x=23.68 //y=2.205 //x2=23.68 //y2=2.08
r146 (  1 8 ) resistor r=2.24714 //w=0.131 //l=2.355 //layer=m1 \
 //thickness=0.36 //x=23.68 //y=2.205 //x2=23.68 //y2=4.56
ends PM_DFFRNX1_PCELL\%noxref_15

subckt PM_DFFRNX1_PCELL\%noxref_16 ( 1 6 7 18 19 31 38 39 48 49 63 66 70 74 75 \
 79 84 89 90 96 99 113 130 145 162 186 194 195 196 197 198 199 200 201 202 203 \
 204 )
c455 ( 204 0 ) capacitor c=0.00843555f //x=23.56 //y=0.865
c456 ( 203 0 ) capacitor c=0.00840423f //x=18.645 //y=0.875
c457 ( 202 0 ) capacitor c=0.00840423f //x=13.835 //y=0.875
c458 ( 201 0 ) capacitor c=0.00843555f //x=10.61 //y=0.865
c459 ( 200 0 ) capacitor c=0.00840423f //x=5.695 //y=0.875
c460 ( 199 0 ) capacitor c=0.00840423f //x=0.885 //y=0.875
c461 ( 198 0 ) capacitor c=0.119248f //x=22.57 //y=0
c462 ( 197 0 ) capacitor c=0.114444f //x=17.76 //y=0
c463 ( 196 0 ) capacitor c=0.112884f //x=12.95 //y=0
c464 ( 195 0 ) capacitor c=0.119029f //x=9.62 //y=0
c465 ( 194 0 ) capacitor c=0.11359f //x=4.81 //y=0
c466 ( 186 0 ) capacitor c=0.316233f //x=25.53 //y=0
c467 ( 162 0 ) capacitor c=0.176388f //x=22.4 //y=0
c468 ( 145 0 ) capacitor c=0.174307f //x=17.59 //y=0
c469 ( 130 0 ) capacitor c=0.117553f //x=12.78 //y=0
c470 ( 113 0 ) capacitor c=0.175263f //x=9.45 //y=0
c471 ( 99 0 ) capacitor c=0.178393f //x=0.74 //y=0
c472 ( 96 0 ) capacitor c=0.179326f //x=4.64 //y=0
c473 ( 93 0 ) capacitor c=0.0050875f //x=23.68 //y=0
c474 ( 90 0 ) capacitor c=0.0278993f //x=23.747 //y=0.825
c475 ( 89 0 ) capacitor c=0.0139611f //x=23.75 //y=0.955
c476 ( 87 0 ) capacitor c=0.00509083f //x=18.87 //y=0
c477 ( 84 0 ) capacitor c=0.0140966f //x=18.835 //y=0.965
c478 ( 82 0 ) capacitor c=0.00509083f //x=14.06 //y=0
c479 ( 79 0 ) capacitor c=0.013104f //x=14.025 //y=0.965
c480 ( 77 0 ) capacitor c=0.0050875f //x=10.8 //y=0
c481 ( 75 0 ) capacitor c=0.0234055f //x=10.797 //y=0.825
c482 ( 74 0 ) capacitor c=0.01353f //x=10.8 //y=0.955
c483 ( 72 0 ) capacitor c=0.00509083f //x=5.885 //y=0
c484 ( 70 0 ) capacitor c=0.0143507f //x=5.885 //y=0.965
c485 ( 68 0 ) capacitor c=0.00509083f //x=1.075 //y=0
c486 ( 66 0 ) capacitor c=0.0170404f //x=1.075 //y=0.965
c487 ( 63 0 ) capacitor c=0.0847673f //x=25.53 //y=0
c488 ( 49 0 ) capacitor c=0.155947f //x=23.665 //y=0
c489 ( 48 0 ) capacitor c=0.0302305f //x=18.835 //y=0.835
c490 ( 39 0 ) capacitor c=0.149928f //x=18.75 //y=0
c491 ( 38 0 ) capacitor c=0.0253397f //x=14.025 //y=0.835
c492 ( 31 0 ) capacitor c=0.105195f //x=13.94 //y=0
c493 ( 19 0 ) capacitor c=0.154047f //x=10.715 //y=0
c494 ( 18 0 ) capacitor c=0.0302305f //x=5.885 //y=0.835
c495 ( 7 0 ) capacitor c=0.149034f //x=5.8 //y=0
c496 ( 6 0 ) capacitor c=0.0302305f //x=1.075 //y=0.835
c497 ( 1 0 ) capacitor c=0.0533996f //x=0.99 //y=0
r498 (  184 186 ) resistor r=26.5322 //w=0.357 //l=0.74 //layer=li \
 //thickness=0.1 //x=24.79 //y=0 //x2=25.53 //y2=0
r499 (  182 184 ) resistor r=39.7983 //w=0.357 //l=1.11 //layer=li \
 //thickness=0.1 //x=23.68 //y=0 //x2=24.79 //y2=0
r500 (  180 198 ) resistor r=5.4201 //w=0.34 //l=0.17 //layer=li \
 //thickness=0.1 //x=22.74 //y=0 //x2=22.57 //y2=0
r501 (  180 182 ) resistor r=33.7031 //w=0.357 //l=0.94 //layer=li \
 //thickness=0.1 //x=22.74 //y=0 //x2=23.68 //y2=0
r502 (  169 171 ) resistor r=39.7983 //w=0.357 //l=1.11 //layer=li \
 //thickness=0.1 //x=21.09 //y=0 //x2=22.2 //y2=0
r503 (  167 169 ) resistor r=39.7983 //w=0.357 //l=1.11 //layer=li \
 //thickness=0.1 //x=19.98 //y=0 //x2=21.09 //y2=0
r504 (  165 167 ) resistor r=39.7983 //w=0.357 //l=1.11 //layer=li \
 //thickness=0.1 //x=18.87 //y=0 //x2=19.98 //y2=0
r505 (  163 197 ) resistor r=5.4201 //w=0.34 //l=0.17 //layer=li \
 //thickness=0.1 //x=17.93 //y=0 //x2=17.76 //y2=0
r506 (  163 165 ) resistor r=33.7031 //w=0.357 //l=0.94 //layer=li \
 //thickness=0.1 //x=17.93 //y=0 //x2=18.87 //y2=0
r507 (  162 198 ) resistor r=5.4201 //w=0.34 //l=0.17 //layer=li \
 //thickness=0.1 //x=22.4 //y=0 //x2=22.57 //y2=0
r508 (  162 171 ) resistor r=7.17087 //w=0.357 //l=0.2 //layer=li \
 //thickness=0.1 //x=22.4 //y=0 //x2=22.2 //y2=0
r509 (  152 154 ) resistor r=39.7983 //w=0.357 //l=1.11 //layer=li \
 //thickness=0.1 //x=16.28 //y=0 //x2=17.39 //y2=0
r510 (  150 152 ) resistor r=39.7983 //w=0.357 //l=1.11 //layer=li \
 //thickness=0.1 //x=15.17 //y=0 //x2=16.28 //y2=0
r511 (  148 150 ) resistor r=39.7983 //w=0.357 //l=1.11 //layer=li \
 //thickness=0.1 //x=14.06 //y=0 //x2=15.17 //y2=0
r512 (  146 196 ) resistor r=5.4201 //w=0.34 //l=0.17 //layer=li \
 //thickness=0.1 //x=13.12 //y=0 //x2=12.95 //y2=0
r513 (  146 148 ) resistor r=33.7031 //w=0.357 //l=0.94 //layer=li \
 //thickness=0.1 //x=13.12 //y=0 //x2=14.06 //y2=0
r514 (  145 197 ) resistor r=5.4201 //w=0.34 //l=0.17 //layer=li \
 //thickness=0.1 //x=17.59 //y=0 //x2=17.76 //y2=0
r515 (  145 154 ) resistor r=7.17087 //w=0.357 //l=0.2 //layer=li \
 //thickness=0.1 //x=17.59 //y=0 //x2=17.39 //y2=0
r516 (  135 137 ) resistor r=39.7983 //w=0.357 //l=1.11 //layer=li \
 //thickness=0.1 //x=11.47 //y=0 //x2=12.58 //y2=0
r517 (  133 135 ) resistor r=39.7983 //w=0.357 //l=1.11 //layer=li \
 //thickness=0.1 //x=10.36 //y=0 //x2=11.47 //y2=0
r518 (  131 195 ) resistor r=5.4201 //w=0.34 //l=0.17 //layer=li \
 //thickness=0.1 //x=9.79 //y=0 //x2=9.62 //y2=0
r519 (  131 133 ) resistor r=20.437 //w=0.357 //l=0.57 //layer=li \
 //thickness=0.1 //x=9.79 //y=0 //x2=10.36 //y2=0
r520 (  130 196 ) resistor r=5.4201 //w=0.34 //l=0.17 //layer=li \
 //thickness=0.1 //x=12.78 //y=0 //x2=12.95 //y2=0
r521 (  130 137 ) resistor r=7.17087 //w=0.357 //l=0.2 //layer=li \
 //thickness=0.1 //x=12.78 //y=0 //x2=12.58 //y2=0
r522 (  120 122 ) resistor r=39.7983 //w=0.357 //l=1.11 //layer=li \
 //thickness=0.1 //x=7.77 //y=0 //x2=8.88 //y2=0
r523 (  118 120 ) resistor r=39.7983 //w=0.357 //l=1.11 //layer=li \
 //thickness=0.1 //x=6.66 //y=0 //x2=7.77 //y2=0
r524 (  116 118 ) resistor r=39.7983 //w=0.357 //l=1.11 //layer=li \
 //thickness=0.1 //x=5.55 //y=0 //x2=6.66 //y2=0
r525 (  114 194 ) resistor r=5.4201 //w=0.34 //l=0.17 //layer=li \
 //thickness=0.1 //x=4.98 //y=0 //x2=4.81 //y2=0
r526 (  114 116 ) resistor r=20.437 //w=0.357 //l=0.57 //layer=li \
 //thickness=0.1 //x=4.98 //y=0 //x2=5.55 //y2=0
r527 (  113 195 ) resistor r=5.4201 //w=0.34 //l=0.17 //layer=li \
 //thickness=0.1 //x=9.45 //y=0 //x2=9.62 //y2=0
r528 (  113 122 ) resistor r=20.437 //w=0.357 //l=0.57 //layer=li \
 //thickness=0.1 //x=9.45 //y=0 //x2=8.88 //y2=0
r529 (  103 105 ) resistor r=39.7983 //w=0.357 //l=1.11 //layer=li \
 //thickness=0.1 //x=2.96 //y=0 //x2=4.07 //y2=0
r530 (  101 103 ) resistor r=39.7983 //w=0.357 //l=1.11 //layer=li \
 //thickness=0.1 //x=1.85 //y=0 //x2=2.96 //y2=0
r531 (  99 101 ) resistor r=39.7983 //w=0.357 //l=1.11 //layer=li \
 //thickness=0.1 //x=0.74 //y=0 //x2=1.85 //y2=0
r532 (  96 194 ) resistor r=5.4201 //w=0.34 //l=0.17 //layer=li \
 //thickness=0.1 //x=4.64 //y=0 //x2=4.81 //y2=0
r533 (  96 105 ) resistor r=20.437 //w=0.357 //l=0.57 //layer=li \
 //thickness=0.1 //x=4.64 //y=0 //x2=4.07 //y2=0
r534 (  93 182 ) resistor r=3.1 //w=0.17 //l=0.51 //layer=mcon //count=3 \
 //x=23.68 //y=0 //x2=23.68 //y2=0
r535 (  89 204 ) resistor r=9.3 //w=0.17 //l=0.17 //layer=mcon //count=1 \
 //x=23.75 //y=0.955 //x2=23.75 //y2=0.955
r536 (  89 90 ) resistor r=0.0939994 //w=0.226 //l=0.13 //layer=m1 \
 //thickness=0.36 //x=23.747 //y=0.955 //x2=23.747 //y2=0.825
r537 (  87 165 ) resistor r=3.1 //w=0.17 //l=0.51 //layer=mcon //count=3 \
 //x=18.87 //y=0 //x2=18.87 //y2=0
r538 (  84 203 ) resistor r=9.3 //w=0.17 //l=0.17 //layer=mcon //count=1 \
 //x=18.835 //y=0.965 //x2=18.835 //y2=0.965
r539 (  82 148 ) resistor r=3.1 //w=0.17 //l=0.51 //layer=mcon //count=3 \
 //x=14.06 //y=0 //x2=14.06 //y2=0
r540 (  79 202 ) resistor r=9.3 //w=0.17 //l=0.17 //layer=mcon //count=1 \
 //x=14.025 //y=0.965 //x2=14.025 //y2=0.965
r541 (  74 201 ) resistor r=9.3 //w=0.17 //l=0.17 //layer=mcon //count=1 \
 //x=10.8 //y=0.955 //x2=10.8 //y2=0.955
r542 (  74 75 ) resistor r=0.0939994 //w=0.226 //l=0.13 //layer=m1 \
 //thickness=0.36 //x=10.797 //y=0.955 //x2=10.797 //y2=0.825
r543 (  70 200 ) resistor r=9.3 //w=0.17 //l=0.17 //layer=mcon //count=1 \
 //x=5.885 //y=0.965 //x2=5.885 //y2=0.965
r544 (  66 199 ) resistor r=9.3 //w=0.17 //l=0.17 //layer=mcon //count=1 \
 //x=1.075 //y=0.965 //x2=1.075 //y2=0.965
r545 (  63 186 ) resistor r=9.3 //w=0.17 //l=0.17 //layer=mcon //count=1 \
 //x=25.53 //y=0 //x2=25.53 //y2=0
r546 (  61 184 ) resistor r=3.1 //w=0.17 //l=0.51 //layer=mcon //count=3 \
 //x=24.79 //y=0 //x2=24.79 //y2=0
r547 (  61 63 ) resistor r=0.307309 //w=0.301 //l=0.74 //layer=m1 \
 //thickness=0.36 //x=24.79 //y=0 //x2=25.53 //y2=0
r548 (  59 93 ) resistor r=0.0287885 //w=0.34 //l=0.085 //layer=m1 \
 //thickness=0.36 //x=23.835 //y=0 //x2=23.75 //y2=0
r549 (  59 61 ) resistor r=0.396595 //w=0.301 //l=0.955 //layer=m1 \
 //thickness=0.36 //x=23.835 //y=0 //x2=24.79 //y2=0
r550 (  57 93 ) resistor r=0.0401957 //w=0.68 //l=0.17 //layer=m1 \
 //thickness=0.36 //x=23.75 //y=0.17 //x2=23.75 //y2=0
r551 (  57 90 ) resistor r=0.625 //w=0.131 //l=0.655 //layer=m1 \
 //thickness=0.36 //x=23.75 //y=0.17 //x2=23.75 //y2=0.825
r552 (  56 171 ) resistor r=3.1 //w=0.17 //l=0.51 //layer=mcon //count=3 \
 //x=22.2 //y=0 //x2=22.2 //y2=0
r553 (  54 169 ) resistor r=3.1 //w=0.17 //l=0.51 //layer=mcon //count=3 \
 //x=21.09 //y=0 //x2=21.09 //y2=0
r554 (  54 56 ) resistor r=0.460963 //w=0.301 //l=1.11 //layer=m1 \
 //thickness=0.36 //x=21.09 //y=0 //x2=22.2 //y2=0
r555 (  52 167 ) resistor r=3.1 //w=0.17 //l=0.51 //layer=mcon //count=3 \
 //x=19.98 //y=0 //x2=19.98 //y2=0
r556 (  52 54 ) resistor r=0.460963 //w=0.301 //l=1.11 //layer=m1 \
 //thickness=0.36 //x=19.98 //y=0 //x2=21.09 //y2=0
r557 (  50 87 ) resistor r=0.0287885 //w=0.34 //l=0.085 //layer=m1 \
 //thickness=0.36 //x=18.92 //y=0 //x2=18.835 //y2=0
r558 (  50 52 ) resistor r=0.440199 //w=0.301 //l=1.06 //layer=m1 \
 //thickness=0.36 //x=18.92 //y=0 //x2=19.98 //y2=0
r559 (  49 93 ) resistor r=0.0287885 //w=0.34 //l=0.085 //layer=m1 \
 //thickness=0.36 //x=23.665 //y=0 //x2=23.75 //y2=0
r560 (  49 56 ) resistor r=0.608389 //w=0.301 //l=1.465 //layer=m1 \
 //thickness=0.36 //x=23.665 //y=0 //x2=22.2 //y2=0
r561 (  48 84 ) resistor r=0.0942778 //w=0.221 //l=0.13 //layer=m1 \
 //thickness=0.36 //x=18.835 //y=0.835 //x2=18.835 //y2=0.965
r562 (  47 87 ) resistor r=0.0401957 //w=0.68 //l=0.17 //layer=m1 \
 //thickness=0.36 //x=18.835 //y=0.17 //x2=18.835 //y2=0
r563 (  47 48 ) resistor r=0.634542 //w=0.131 //l=0.665 //layer=m1 \
 //thickness=0.36 //x=18.835 //y=0.17 //x2=18.835 //y2=0.835
r564 (  46 154 ) resistor r=3.1 //w=0.17 //l=0.51 //layer=mcon //count=3 \
 //x=17.39 //y=0 //x2=17.39 //y2=0
r565 (  44 152 ) resistor r=3.1 //w=0.17 //l=0.51 //layer=mcon //count=3 \
 //x=16.28 //y=0 //x2=16.28 //y2=0
r566 (  44 46 ) resistor r=0.460963 //w=0.301 //l=1.11 //layer=m1 \
 //thickness=0.36 //x=16.28 //y=0 //x2=17.39 //y2=0
r567 (  42 150 ) resistor r=3.1 //w=0.17 //l=0.51 //layer=mcon //count=3 \
 //x=15.17 //y=0 //x2=15.17 //y2=0
r568 (  42 44 ) resistor r=0.460963 //w=0.301 //l=1.11 //layer=m1 \
 //thickness=0.36 //x=15.17 //y=0 //x2=16.28 //y2=0
r569 (  40 82 ) resistor r=0.0287885 //w=0.34 //l=0.085 //layer=m1 \
 //thickness=0.36 //x=14.11 //y=0 //x2=14.025 //y2=0
r570 (  40 42 ) resistor r=0.440199 //w=0.301 //l=1.06 //layer=m1 \
 //thickness=0.36 //x=14.11 //y=0 //x2=15.17 //y2=0
r571 (  39 87 ) resistor r=0.0287885 //w=0.34 //l=0.085 //layer=m1 \
 //thickness=0.36 //x=18.75 //y=0 //x2=18.835 //y2=0
r572 (  39 46 ) resistor r=0.564784 //w=0.301 //l=1.36 //layer=m1 \
 //thickness=0.36 //x=18.75 //y=0 //x2=17.39 //y2=0
r573 (  38 79 ) resistor r=0.0942778 //w=0.221 //l=0.13 //layer=m1 \
 //thickness=0.36 //x=14.025 //y=0.835 //x2=14.025 //y2=0.965
r574 (  37 82 ) resistor r=0.0401957 //w=0.68 //l=0.17 //layer=m1 \
 //thickness=0.36 //x=14.025 //y=0.17 //x2=14.025 //y2=0
r575 (  37 38 ) resistor r=0.634542 //w=0.131 //l=0.665 //layer=m1 \
 //thickness=0.36 //x=14.025 //y=0.17 //x2=14.025 //y2=0.835
r576 (  36 137 ) resistor r=3.1 //w=0.17 //l=0.51 //layer=mcon //count=3 \
 //x=12.58 //y=0 //x2=12.58 //y2=0
r577 (  34 135 ) resistor r=3.1 //w=0.17 //l=0.51 //layer=mcon //count=3 \
 //x=11.47 //y=0 //x2=11.47 //y2=0
r578 (  34 36 ) resistor r=0.460963 //w=0.301 //l=1.11 //layer=m1 \
 //thickness=0.36 //x=11.47 //y=0 //x2=12.58 //y2=0
r579 (  32 77 ) resistor r=0.0287885 //w=0.34 //l=0.085 //layer=m1 \
 //thickness=0.36 //x=10.885 //y=0 //x2=10.8 //y2=0
r580 (  32 34 ) resistor r=0.24294 //w=0.301 //l=0.585 //layer=m1 \
 //thickness=0.36 //x=10.885 //y=0 //x2=11.47 //y2=0
r581 (  31 82 ) resistor r=0.0287885 //w=0.34 //l=0.085 //layer=m1 \
 //thickness=0.36 //x=13.94 //y=0 //x2=14.025 //y2=0
r582 (  31 36 ) resistor r=0.564784 //w=0.301 //l=1.36 //layer=m1 \
 //thickness=0.36 //x=13.94 //y=0 //x2=12.58 //y2=0
r583 (  29 77 ) resistor r=0.0401957 //w=0.68 //l=0.17 //layer=m1 \
 //thickness=0.36 //x=10.8 //y=0.17 //x2=10.8 //y2=0
r584 (  29 75 ) resistor r=0.625 //w=0.131 //l=0.655 //layer=m1 \
 //thickness=0.36 //x=10.8 //y=0.17 //x2=10.8 //y2=0.825
r585 (  28 133 ) resistor r=3.1 //w=0.17 //l=0.51 //layer=mcon //count=3 \
 //x=10.36 //y=0 //x2=10.36 //y2=0
r586 (  26 122 ) resistor r=3.1 //w=0.17 //l=0.51 //layer=mcon //count=3 \
 //x=8.88 //y=0 //x2=8.88 //y2=0
r587 (  26 28 ) resistor r=0.614618 //w=0.301 //l=1.48 //layer=m1 \
 //thickness=0.36 //x=8.88 //y=0 //x2=10.36 //y2=0
r588 (  24 120 ) resistor r=3.1 //w=0.17 //l=0.51 //layer=mcon //count=3 \
 //x=7.77 //y=0 //x2=7.77 //y2=0
r589 (  24 26 ) resistor r=0.460963 //w=0.301 //l=1.11 //layer=m1 \
 //thickness=0.36 //x=7.77 //y=0 //x2=8.88 //y2=0
r590 (  22 118 ) resistor r=3.1 //w=0.17 //l=0.51 //layer=mcon //count=3 \
 //x=6.66 //y=0 //x2=6.66 //y2=0
r591 (  22 24 ) resistor r=0.460963 //w=0.301 //l=1.11 //layer=m1 \
 //thickness=0.36 //x=6.66 //y=0 //x2=7.77 //y2=0
r592 (  20 72 ) resistor r=0.0287885 //w=0.34 //l=0.085 //layer=m1 \
 //thickness=0.36 //x=5.97 //y=0 //x2=5.885 //y2=0
r593 (  20 22 ) resistor r=0.286545 //w=0.301 //l=0.69 //layer=m1 \
 //thickness=0.36 //x=5.97 //y=0 //x2=6.66 //y2=0
r594 (  19 77 ) resistor r=0.0287885 //w=0.34 //l=0.085 //layer=m1 \
 //thickness=0.36 //x=10.715 //y=0 //x2=10.8 //y2=0
r595 (  19 28 ) resistor r=0.147425 //w=0.301 //l=0.355 //layer=m1 \
 //thickness=0.36 //x=10.715 //y=0 //x2=10.36 //y2=0
r596 (  18 70 ) resistor r=0.0942778 //w=0.221 //l=0.13 //layer=m1 \
 //thickness=0.36 //x=5.885 //y=0.835 //x2=5.885 //y2=0.965
r597 (  17 72 ) resistor r=0.0401957 //w=0.68 //l=0.17 //layer=m1 \
 //thickness=0.36 //x=5.885 //y=0.17 //x2=5.885 //y2=0
r598 (  17 18 ) resistor r=0.634542 //w=0.131 //l=0.665 //layer=m1 \
 //thickness=0.36 //x=5.885 //y=0.17 //x2=5.885 //y2=0.835
r599 (  16 116 ) resistor r=3.1 //w=0.17 //l=0.51 //layer=mcon //count=3 \
 //x=5.55 //y=0 //x2=5.55 //y2=0
r600 (  14 105 ) resistor r=3.1 //w=0.17 //l=0.51 //layer=mcon //count=3 \
 //x=4.07 //y=0 //x2=4.07 //y2=0
r601 (  14 16 ) resistor r=0.614618 //w=0.301 //l=1.48 //layer=m1 \
 //thickness=0.36 //x=4.07 //y=0 //x2=5.55 //y2=0
r602 (  12 103 ) resistor r=3.1 //w=0.17 //l=0.51 //layer=mcon //count=3 \
 //x=2.96 //y=0 //x2=2.96 //y2=0
r603 (  12 14 ) resistor r=0.460963 //w=0.301 //l=1.11 //layer=m1 \
 //thickness=0.36 //x=2.96 //y=0 //x2=4.07 //y2=0
r604 (  10 101 ) resistor r=3.1 //w=0.17 //l=0.51 //layer=mcon //count=3 \
 //x=1.85 //y=0 //x2=1.85 //y2=0
r605 (  10 12 ) resistor r=0.460963 //w=0.301 //l=1.11 //layer=m1 \
 //thickness=0.36 //x=1.85 //y=0 //x2=2.96 //y2=0
r606 (  8 68 ) resistor r=0.0287885 //w=0.34 //l=0.085 //layer=m1 \
 //thickness=0.36 //x=1.16 //y=0 //x2=1.075 //y2=0
r607 (  8 10 ) resistor r=0.286545 //w=0.301 //l=0.69 //layer=m1 \
 //thickness=0.36 //x=1.16 //y=0 //x2=1.85 //y2=0
r608 (  7 72 ) resistor r=0.0287885 //w=0.34 //l=0.085 //layer=m1 \
 //thickness=0.36 //x=5.8 //y=0 //x2=5.885 //y2=0
r609 (  7 16 ) resistor r=0.103821 //w=0.301 //l=0.25 //layer=m1 \
 //thickness=0.36 //x=5.8 //y=0 //x2=5.55 //y2=0
r610 (  6 66 ) resistor r=0.0942778 //w=0.221 //l=0.13 //layer=m1 \
 //thickness=0.36 //x=1.075 //y=0.835 //x2=1.075 //y2=0.965
r611 (  5 68 ) resistor r=0.0401957 //w=0.68 //l=0.17 //layer=m1 \
 //thickness=0.36 //x=1.075 //y=0.17 //x2=1.075 //y2=0
r612 (  5 6 ) resistor r=0.634542 //w=0.131 //l=0.665 //layer=m1 \
 //thickness=0.36 //x=1.075 //y=0.17 //x2=1.075 //y2=0.835
r613 (  3 99 ) resistor r=3.1 //w=0.17 //l=0.51 //layer=mcon //count=3 \
 //x=0.74 //y=0 //x2=0.74 //y2=0
r614 (  1 68 ) resistor r=0.0287885 //w=0.34 //l=0.085 //layer=m1 \
 //thickness=0.36 //x=0.99 //y=0 //x2=1.075 //y2=0
r615 (  1 3 ) resistor r=0.103821 //w=0.301 //l=0.25 //layer=m1 \
 //thickness=0.36 //x=0.99 //y=0 //x2=0.74 //y2=0
ends PM_DFFRNX1_PCELL\%noxref_16

subckt PM_DFFRNX1_PCELL\%noxref_17 ( 3 8 9 11 12 14 17 18 21 23 26 34 46 48 49 )
c113 ( 46 0 ) capacitor c=0.00878249f //x=24.53 //y=0.905
c114 ( 34 0 ) capacitor c=0.0326476f //x=24.68 //y=5.38
c115 ( 26 0 ) capacitor c=0.0290186f //x=23.8 //y=5.38
c116 ( 23 0 ) capacitor c=0.0148964f //x=24.72 //y=1
c117 ( 21 0 ) capacitor c=5.78613e-19 //x=24.68 //y=5.38
c118 ( 18 0 ) capacitor c=0.0159026f //x=24.68 //y=5.2
c119 ( 17 0 ) capacitor c=0.00955402f //x=23.8 //y=5.38
c120 ( 14 0 ) capacitor c=0.132395f //x=25.16 //y=5.115
c121 ( 12 0 ) capacitor c=0.00696879f //x=24.805 //y=1.655
c122 ( 11 0 ) capacitor c=0.0165738f //x=25.075 //y=1.655
c123 ( 9 0 ) capacitor c=0.0143926f //x=25.075 //y=5.2
c124 ( 8 0 ) capacitor c=0.0134844f //x=24.72 //y=1.57
c125 ( 3 0 ) capacitor c=0.0136546f //x=24.565 //y=5.2
r126 (  34 49 ) resistor r=23.615 //w=0.187 //l=0.345 //layer=li \
 //thickness=0.1 //x=24.68 //y=5.38 //x2=24.68 //y2=5.725
r127 (  26 48 ) resistor r=23.615 //w=0.187 //l=0.345 //layer=li \
 //thickness=0.1 //x=23.8 //y=5.38 //x2=23.8 //y2=5.725
r128 (  23 46 ) resistor r=9.3 //w=0.17 //l=0.17 //layer=mcon //count=1 \
 //x=24.72 //y=1 //x2=24.72 //y2=1
r129 (  21 34 ) resistor r=9.3 //w=0.17 //l=0.17 //layer=mcon //count=1 \
 //x=24.68 //y=5.38 //x2=24.68 //y2=5.38
r130 (  18 21 ) resistor r=0.117801 //w=0.191 //l=0.18 //layer=m1 \
 //thickness=0.36 //x=24.68 //y=5.2 //x2=24.68 //y2=5.38
r131 (  17 26 ) resistor r=9.3 //w=0.17 //l=0.17 //layer=mcon //count=1 \
 //x=23.8 //y=5.38 //x2=23.8 //y2=5.38
r132 (  15 17 ) resistor r=0.10274 //w=0.219 //l=0.18 //layer=m1 \
 //thickness=0.36 //x=23.8 //y=5.2 //x2=23.8 //y2=5.38
r133 (  13 14 ) resistor r=3.22042 //w=0.131 //l=3.375 //layer=m1 \
 //thickness=0.36 //x=25.16 //y=1.74 //x2=25.16 //y2=5.115
r134 (  11 13 ) resistor r=0.0698411 //w=0.17 //l=0.120208 //layer=m1 \
 //thickness=0.36 //x=25.075 //y=1.655 //x2=25.16 //y2=1.74
r135 (  11 12 ) resistor r=0.257634 //w=0.131 //l=0.27 //layer=m1 \
 //thickness=0.36 //x=25.075 //y=1.655 //x2=24.805 //y2=1.655
r136 (  10 18 ) resistor r=0.0257089 //w=0.23 //l=0.115 //layer=m1 \
 //thickness=0.36 //x=24.795 //y=5.2 //x2=24.68 //y2=5.2
r137 (  9 14 ) resistor r=0.0698411 //w=0.17 //l=0.120208 //layer=m1 \
 //thickness=0.36 //x=25.075 //y=5.2 //x2=25.16 //y2=5.115
r138 (  9 10 ) resistor r=0.267176 //w=0.131 //l=0.28 //layer=m1 \
 //thickness=0.36 //x=25.075 //y=5.2 //x2=24.795 //y2=5.2
r139 (  8 12 ) resistor r=0.0698411 //w=0.17 //l=0.120208 //layer=m1 \
 //thickness=0.36 //x=24.72 //y=1.57 //x2=24.805 //y2=1.655
r140 (  7 23 ) resistor r=0.0913624 //w=0.191 //l=0.12 //layer=m1 \
 //thickness=0.36 //x=24.72 //y=1.12 //x2=24.72 //y2=1
r141 (  7 8 ) resistor r=0.429389 //w=0.131 //l=0.45 //layer=m1 \
 //thickness=0.36 //x=24.72 //y=1.12 //x2=24.72 //y2=1.57
r142 (  4 15 ) resistor r=0.0227762 //w=0.219 //l=0.115 //layer=m1 \
 //thickness=0.36 //x=23.915 //y=5.2 //x2=23.8 //y2=5.2
r143 (  3 18 ) resistor r=0.0257089 //w=0.23 //l=0.115 //layer=m1 \
 //thickness=0.36 //x=24.565 //y=5.2 //x2=24.68 //y2=5.2
r144 (  3 4 ) resistor r=0.620229 //w=0.131 //l=0.65 //layer=m1 \
 //thickness=0.36 //x=24.565 //y=5.2 //x2=23.915 //y2=5.2
ends PM_DFFRNX1_PCELL\%noxref_17

subckt PM_DFFRNX1_PCELL\%noxref_18 ( 1 5 9 13 17 35 )
c52 ( 35 0 ) capacitor c=0.0762518f //x=0.455 //y=0.375
c53 ( 17 0 ) capacitor c=0.0259374f //x=2.445 //y=1.59
c54 ( 13 0 ) capacitor c=0.0153941f //x=2.445 //y=0.54
c55 ( 9 0 ) capacitor c=0.00772076f //x=1.56 //y=0.625
c56 ( 5 0 ) capacitor c=0.0211487f //x=1.475 //y=1.59
c57 ( 1 0 ) capacitor c=0.0109947f //x=0.59 //y=1.505
r58 (  18 35 ) resistor r=5.4201 //w=0.17 //l=0.103078 //layer=li \
 //thickness=0.1 //x=1.645 //y=1.59 //x2=1.56 //y2=1.63
r59 (  18 35 ) resistor r=27.3797 //w=0.187 //l=0.4 //layer=li //thickness=0.1 \
 //x=1.645 //y=1.59 //x2=2.045 //y2=1.59
r60 (  17 35 ) resistor r=0.751729 //w=0.17 //l=0.085 //layer=li \
 //thickness=0.1 //x=2.445 //y=1.59 //x2=2.53 //y2=1.59
r61 (  17 35 ) resistor r=27.3797 //w=0.187 //l=0.4 //layer=li //thickness=0.1 \
 //x=2.445 //y=1.59 //x2=2.045 //y2=1.59
r62 (  14 35 ) resistor r=3.57586 //w=0.17 //l=0.103078 //layer=li \
 //thickness=0.1 //x=1.645 //y=0.54 //x2=1.56 //y2=0.5
r63 (  14 35 ) resistor r=27.3797 //w=0.187 //l=0.4 //layer=li //thickness=0.1 \
 //x=1.645 //y=0.54 //x2=2.045 //y2=0.54
r64 (  13 35 ) resistor r=0.751729 //w=0.17 //l=0.085 //layer=li \
 //thickness=0.1 //x=2.445 //y=0.54 //x2=2.53 //y2=0.54
r65 (  13 35 ) resistor r=27.3797 //w=0.187 //l=0.4 //layer=li //thickness=0.1 \
 //x=2.445 //y=0.54 //x2=2.045 //y2=0.54
r66 (  10 35 ) resistor r=1.40859 //w=0.34 //l=0.125 //layer=li \
 //thickness=0.1 //x=1.56 //y=1.505 //x2=1.56 //y2=1.63
r67 (  10 35 ) resistor r=42.0963 //w=0.187 //l=0.615 //layer=li \
 //thickness=0.1 //x=1.56 //y=1.505 //x2=1.56 //y2=0.89
r68 (  9 35 ) resistor r=3.57586 //w=0.17 //l=0.125 //layer=li //thickness=0.1 \
 //x=1.56 //y=0.625 //x2=1.56 //y2=0.5
r69 (  9 35 ) resistor r=18.139 //w=0.187 //l=0.265 //layer=li //thickness=0.1 \
 //x=1.56 //y=0.625 //x2=1.56 //y2=0.89
r70 (  6 35 ) resistor r=3.57586 //w=0.17 //l=0.103078 //layer=li \
 //thickness=0.1 //x=0.675 //y=1.59 //x2=0.59 //y2=1.63
r71 (  6 35 ) resistor r=27.3797 //w=0.187 //l=0.4 //layer=li //thickness=0.1 \
 //x=0.675 //y=1.59 //x2=1.075 //y2=1.59
r72 (  5 35 ) resistor r=5.4201 //w=0.17 //l=0.103078 //layer=li \
 //thickness=0.1 //x=1.475 //y=1.59 //x2=1.56 //y2=1.63
r73 (  5 35 ) resistor r=27.3797 //w=0.187 //l=0.4 //layer=li //thickness=0.1 \
 //x=1.475 //y=1.59 //x2=1.075 //y2=1.59
r74 (  1 35 ) resistor r=3.57586 //w=0.17 //l=0.125 //layer=li //thickness=0.1 \
 //x=0.59 //y=1.505 //x2=0.59 //y2=1.63
r75 (  1 35 ) resistor r=42.0963 //w=0.187 //l=0.615 //layer=li \
 //thickness=0.1 //x=0.59 //y=1.505 //x2=0.59 //y2=0.89
ends PM_DFFRNX1_PCELL\%noxref_18

subckt PM_DFFRNX1_PCELL\%noxref_19 ( 1 5 9 13 17 35 )
c58 ( 35 0 ) capacitor c=0.0704927f //x=5.265 //y=0.375
c59 ( 17 0 ) capacitor c=0.0208678f //x=7.255 //y=1.59
c60 ( 13 0 ) capacitor c=0.0153941f //x=7.255 //y=0.54
c61 ( 9 0 ) capacitor c=0.00772076f //x=6.37 //y=0.625
c62 ( 5 0 ) capacitor c=0.0180187f //x=6.285 //y=1.59
c63 ( 1 0 ) capacitor c=0.00771772f //x=5.4 //y=1.505
r64 (  18 35 ) resistor r=5.4201 //w=0.17 //l=0.103078 //layer=li \
 //thickness=0.1 //x=6.455 //y=1.59 //x2=6.37 //y2=1.63
r65 (  18 35 ) resistor r=27.3797 //w=0.187 //l=0.4 //layer=li //thickness=0.1 \
 //x=6.455 //y=1.59 //x2=6.855 //y2=1.59
r66 (  17 35 ) resistor r=0.751729 //w=0.17 //l=0.085 //layer=li \
 //thickness=0.1 //x=7.255 //y=1.59 //x2=7.34 //y2=1.59
r67 (  17 35 ) resistor r=27.3797 //w=0.187 //l=0.4 //layer=li //thickness=0.1 \
 //x=7.255 //y=1.59 //x2=6.855 //y2=1.59
r68 (  14 35 ) resistor r=3.57586 //w=0.17 //l=0.103078 //layer=li \
 //thickness=0.1 //x=6.455 //y=0.54 //x2=6.37 //y2=0.5
r69 (  14 35 ) resistor r=27.3797 //w=0.187 //l=0.4 //layer=li //thickness=0.1 \
 //x=6.455 //y=0.54 //x2=6.855 //y2=0.54
r70 (  13 35 ) resistor r=0.751729 //w=0.17 //l=0.085 //layer=li \
 //thickness=0.1 //x=7.255 //y=0.54 //x2=7.34 //y2=0.54
r71 (  13 35 ) resistor r=27.3797 //w=0.187 //l=0.4 //layer=li //thickness=0.1 \
 //x=7.255 //y=0.54 //x2=6.855 //y2=0.54
r72 (  10 35 ) resistor r=1.40859 //w=0.34 //l=0.125 //layer=li \
 //thickness=0.1 //x=6.37 //y=1.505 //x2=6.37 //y2=1.63
r73 (  10 35 ) resistor r=42.0963 //w=0.187 //l=0.615 //layer=li \
 //thickness=0.1 //x=6.37 //y=1.505 //x2=6.37 //y2=0.89
r74 (  9 35 ) resistor r=3.57586 //w=0.17 //l=0.125 //layer=li //thickness=0.1 \
 //x=6.37 //y=0.625 //x2=6.37 //y2=0.5
r75 (  9 35 ) resistor r=18.139 //w=0.187 //l=0.265 //layer=li //thickness=0.1 \
 //x=6.37 //y=0.625 //x2=6.37 //y2=0.89
r76 (  6 35 ) resistor r=3.57586 //w=0.17 //l=0.103078 //layer=li \
 //thickness=0.1 //x=5.485 //y=1.59 //x2=5.4 //y2=1.63
r77 (  6 35 ) resistor r=27.3797 //w=0.187 //l=0.4 //layer=li //thickness=0.1 \
 //x=5.485 //y=1.59 //x2=5.885 //y2=1.59
r78 (  5 35 ) resistor r=5.4201 //w=0.17 //l=0.103078 //layer=li \
 //thickness=0.1 //x=6.285 //y=1.59 //x2=6.37 //y2=1.63
r79 (  5 35 ) resistor r=27.3797 //w=0.187 //l=0.4 //layer=li //thickness=0.1 \
 //x=6.285 //y=1.59 //x2=5.885 //y2=1.59
r80 (  1 35 ) resistor r=3.57586 //w=0.17 //l=0.125 //layer=li //thickness=0.1 \
 //x=5.4 //y=1.505 //x2=5.4 //y2=1.63
r81 (  1 35 ) resistor r=42.0963 //w=0.187 //l=0.615 //layer=li \
 //thickness=0.1 //x=5.4 //y=1.505 //x2=5.4 //y2=0.89
ends PM_DFFRNX1_PCELL\%noxref_19

subckt PM_DFFRNX1_PCELL\%noxref_20 ( 1 5 9 10 13 17 29 )
c68 ( 29 0 ) capacitor c=0.067062f //x=10.18 //y=0.365
c69 ( 17 0 ) capacitor c=0.00675704f //x=12.255 //y=0.615
c70 ( 13 0 ) capacitor c=0.0156329f //x=12.17 //y=0.53
c71 ( 10 0 ) capacitor c=0.00673372f //x=11.285 //y=1.495
c72 ( 9 0 ) capacitor c=0.00770028f //x=11.285 //y=0.615
c73 ( 5 0 ) capacitor c=0.0179513f //x=11.2 //y=1.58
c74 ( 1 0 ) capacitor c=0.00761099f //x=10.315 //y=1.495
r75 (  17 29 ) resistor r=3.57586 //w=0.17 //l=0.125 //layer=li \
 //thickness=0.1 //x=12.255 //y=0.615 //x2=12.255 //y2=0.49
r76 (  17 29 ) resistor r=18.139 //w=0.187 //l=0.265 //layer=li \
 //thickness=0.1 //x=12.255 //y=0.615 //x2=12.255 //y2=0.88
r77 (  14 29 ) resistor r=3.57586 //w=0.17 //l=0.103078 //layer=li \
 //thickness=0.1 //x=11.37 //y=0.53 //x2=11.285 //y2=0.49
r78 (  14 29 ) resistor r=27.3797 //w=0.187 //l=0.4 //layer=li //thickness=0.1 \
 //x=11.37 //y=0.53 //x2=11.77 //y2=0.53
r79 (  13 29 ) resistor r=3.57586 //w=0.17 //l=0.103078 //layer=li \
 //thickness=0.1 //x=12.17 //y=0.53 //x2=12.255 //y2=0.49
r80 (  13 29 ) resistor r=27.3797 //w=0.187 //l=0.4 //layer=li //thickness=0.1 \
 //x=12.17 //y=0.53 //x2=11.77 //y2=0.53
r81 (  10 29 ) resistor r=3.57586 //w=0.17 //l=0.125 //layer=li \
 //thickness=0.1 //x=11.285 //y=1.495 //x2=11.285 //y2=1.62
r82 (  10 29 ) resistor r=42.0963 //w=0.187 //l=0.615 //layer=li \
 //thickness=0.1 //x=11.285 //y=1.495 //x2=11.285 //y2=0.88
r83 (  9 29 ) resistor r=3.57586 //w=0.17 //l=0.125 //layer=li //thickness=0.1 \
 //x=11.285 //y=0.615 //x2=11.285 //y2=0.49
r84 (  9 29 ) resistor r=18.139 //w=0.187 //l=0.265 //layer=li //thickness=0.1 \
 //x=11.285 //y=0.615 //x2=11.285 //y2=0.88
r85 (  6 29 ) resistor r=3.57586 //w=0.17 //l=0.103078 //layer=li \
 //thickness=0.1 //x=10.4 //y=1.58 //x2=10.315 //y2=1.62
r86 (  6 29 ) resistor r=27.3797 //w=0.187 //l=0.4 //layer=li //thickness=0.1 \
 //x=10.4 //y=1.58 //x2=10.8 //y2=1.58
r87 (  5 29 ) resistor r=3.57586 //w=0.17 //l=0.103078 //layer=li \
 //thickness=0.1 //x=11.2 //y=1.58 //x2=11.285 //y2=1.62
r88 (  5 29 ) resistor r=27.3797 //w=0.187 //l=0.4 //layer=li //thickness=0.1 \
 //x=11.2 //y=1.58 //x2=10.8 //y2=1.58
r89 (  1 29 ) resistor r=3.57586 //w=0.17 //l=0.125 //layer=li //thickness=0.1 \
 //x=10.315 //y=1.495 //x2=10.315 //y2=1.62
r90 (  1 29 ) resistor r=42.0963 //w=0.187 //l=0.615 //layer=li \
 //thickness=0.1 //x=10.315 //y=1.495 //x2=10.315 //y2=0.88
ends PM_DFFRNX1_PCELL\%noxref_20

subckt PM_DFFRNX1_PCELL\%noxref_21 ( 1 5 9 13 17 35 )
c59 ( 35 0 ) capacitor c=0.068832f //x=13.405 //y=0.375
c60 ( 17 0 ) capacitor c=0.0190725f //x=15.395 //y=1.59
c61 ( 13 0 ) capacitor c=0.015325f //x=15.395 //y=0.54
c62 ( 9 0 ) capacitor c=0.00772076f //x=14.51 //y=0.625
c63 ( 5 0 ) capacitor c=0.0168501f //x=14.425 //y=1.59
c64 ( 1 0 ) capacitor c=0.00709556f //x=13.54 //y=1.505
r65 (  18 35 ) resistor r=5.4201 //w=0.17 //l=0.103078 //layer=li \
 //thickness=0.1 //x=14.595 //y=1.59 //x2=14.51 //y2=1.63
r66 (  18 35 ) resistor r=27.3797 //w=0.187 //l=0.4 //layer=li //thickness=0.1 \
 //x=14.595 //y=1.59 //x2=14.995 //y2=1.59
r67 (  17 35 ) resistor r=0.751729 //w=0.17 //l=0.085 //layer=li \
 //thickness=0.1 //x=15.395 //y=1.59 //x2=15.48 //y2=1.59
r68 (  17 35 ) resistor r=27.3797 //w=0.187 //l=0.4 //layer=li //thickness=0.1 \
 //x=15.395 //y=1.59 //x2=14.995 //y2=1.59
r69 (  14 35 ) resistor r=3.57586 //w=0.17 //l=0.103078 //layer=li \
 //thickness=0.1 //x=14.595 //y=0.54 //x2=14.51 //y2=0.5
r70 (  14 35 ) resistor r=27.3797 //w=0.187 //l=0.4 //layer=li //thickness=0.1 \
 //x=14.595 //y=0.54 //x2=14.995 //y2=0.54
r71 (  13 35 ) resistor r=0.751729 //w=0.17 //l=0.085 //layer=li \
 //thickness=0.1 //x=15.395 //y=0.54 //x2=15.48 //y2=0.54
r72 (  13 35 ) resistor r=27.3797 //w=0.187 //l=0.4 //layer=li //thickness=0.1 \
 //x=15.395 //y=0.54 //x2=14.995 //y2=0.54
r73 (  10 35 ) resistor r=1.40859 //w=0.34 //l=0.125 //layer=li \
 //thickness=0.1 //x=14.51 //y=1.505 //x2=14.51 //y2=1.63
r74 (  10 35 ) resistor r=42.0963 //w=0.187 //l=0.615 //layer=li \
 //thickness=0.1 //x=14.51 //y=1.505 //x2=14.51 //y2=0.89
r75 (  9 35 ) resistor r=3.57586 //w=0.17 //l=0.125 //layer=li //thickness=0.1 \
 //x=14.51 //y=0.625 //x2=14.51 //y2=0.5
r76 (  9 35 ) resistor r=18.139 //w=0.187 //l=0.265 //layer=li //thickness=0.1 \
 //x=14.51 //y=0.625 //x2=14.51 //y2=0.89
r77 (  6 35 ) resistor r=3.57586 //w=0.17 //l=0.103078 //layer=li \
 //thickness=0.1 //x=13.625 //y=1.59 //x2=13.54 //y2=1.63
r78 (  6 35 ) resistor r=27.3797 //w=0.187 //l=0.4 //layer=li //thickness=0.1 \
 //x=13.625 //y=1.59 //x2=14.025 //y2=1.59
r79 (  5 35 ) resistor r=5.4201 //w=0.17 //l=0.103078 //layer=li \
 //thickness=0.1 //x=14.425 //y=1.59 //x2=14.51 //y2=1.63
r80 (  5 35 ) resistor r=27.3797 //w=0.187 //l=0.4 //layer=li //thickness=0.1 \
 //x=14.425 //y=1.59 //x2=14.025 //y2=1.59
r81 (  1 35 ) resistor r=3.57586 //w=0.17 //l=0.125 //layer=li //thickness=0.1 \
 //x=13.54 //y=1.505 //x2=13.54 //y2=1.63
r82 (  1 35 ) resistor r=42.0963 //w=0.187 //l=0.615 //layer=li \
 //thickness=0.1 //x=13.54 //y=1.505 //x2=13.54 //y2=0.89
ends PM_DFFRNX1_PCELL\%noxref_21

subckt PM_DFFRNX1_PCELL\%noxref_22 ( 1 5 9 13 17 35 )
c57 ( 35 0 ) capacitor c=0.0720299f //x=18.215 //y=0.375
c58 ( 17 0 ) capacitor c=0.0196483f //x=20.205 //y=1.59
c59 ( 13 0 ) capacitor c=0.015394f //x=20.205 //y=0.54
c60 ( 9 0 ) capacitor c=0.00772076f //x=19.32 //y=0.625
c61 ( 5 0 ) capacitor c=0.0168501f //x=19.235 //y=1.59
c62 ( 1 0 ) capacitor c=0.00710458f //x=18.35 //y=1.505
r63 (  18 35 ) resistor r=5.4201 //w=0.17 //l=0.103078 //layer=li \
 //thickness=0.1 //x=19.405 //y=1.59 //x2=19.32 //y2=1.63
r64 (  18 35 ) resistor r=27.3797 //w=0.187 //l=0.4 //layer=li //thickness=0.1 \
 //x=19.405 //y=1.59 //x2=19.805 //y2=1.59
r65 (  17 35 ) resistor r=0.751729 //w=0.17 //l=0.085 //layer=li \
 //thickness=0.1 //x=20.205 //y=1.59 //x2=20.29 //y2=1.59
r66 (  17 35 ) resistor r=27.3797 //w=0.187 //l=0.4 //layer=li //thickness=0.1 \
 //x=20.205 //y=1.59 //x2=19.805 //y2=1.59
r67 (  14 35 ) resistor r=3.57586 //w=0.17 //l=0.103078 //layer=li \
 //thickness=0.1 //x=19.405 //y=0.54 //x2=19.32 //y2=0.5
r68 (  14 35 ) resistor r=27.3797 //w=0.187 //l=0.4 //layer=li //thickness=0.1 \
 //x=19.405 //y=0.54 //x2=19.805 //y2=0.54
r69 (  13 35 ) resistor r=0.751729 //w=0.17 //l=0.085 //layer=li \
 //thickness=0.1 //x=20.205 //y=0.54 //x2=20.29 //y2=0.54
r70 (  13 35 ) resistor r=27.3797 //w=0.187 //l=0.4 //layer=li //thickness=0.1 \
 //x=20.205 //y=0.54 //x2=19.805 //y2=0.54
r71 (  10 35 ) resistor r=1.40859 //w=0.34 //l=0.125 //layer=li \
 //thickness=0.1 //x=19.32 //y=1.505 //x2=19.32 //y2=1.63
r72 (  10 35 ) resistor r=42.0963 //w=0.187 //l=0.615 //layer=li \
 //thickness=0.1 //x=19.32 //y=1.505 //x2=19.32 //y2=0.89
r73 (  9 35 ) resistor r=3.57586 //w=0.17 //l=0.125 //layer=li //thickness=0.1 \
 //x=19.32 //y=0.625 //x2=19.32 //y2=0.5
r74 (  9 35 ) resistor r=18.139 //w=0.187 //l=0.265 //layer=li //thickness=0.1 \
 //x=19.32 //y=0.625 //x2=19.32 //y2=0.89
r75 (  6 35 ) resistor r=3.57586 //w=0.17 //l=0.103078 //layer=li \
 //thickness=0.1 //x=18.435 //y=1.59 //x2=18.35 //y2=1.63
r76 (  6 35 ) resistor r=27.3797 //w=0.187 //l=0.4 //layer=li //thickness=0.1 \
 //x=18.435 //y=1.59 //x2=18.835 //y2=1.59
r77 (  5 35 ) resistor r=5.4201 //w=0.17 //l=0.103078 //layer=li \
 //thickness=0.1 //x=19.235 //y=1.59 //x2=19.32 //y2=1.63
r78 (  5 35 ) resistor r=27.3797 //w=0.187 //l=0.4 //layer=li //thickness=0.1 \
 //x=19.235 //y=1.59 //x2=18.835 //y2=1.59
r79 (  1 35 ) resistor r=3.57586 //w=0.17 //l=0.125 //layer=li //thickness=0.1 \
 //x=18.35 //y=1.505 //x2=18.35 //y2=1.63
r80 (  1 35 ) resistor r=42.0963 //w=0.187 //l=0.615 //layer=li \
 //thickness=0.1 //x=18.35 //y=1.505 //x2=18.35 //y2=0.89
ends PM_DFFRNX1_PCELL\%noxref_22

subckt PM_DFFRNX1_PCELL\%noxref_23 ( 1 5 9 10 13 17 29 )
c53 ( 29 0 ) capacitor c=0.0684731f //x=23.13 //y=0.365
c54 ( 17 0 ) capacitor c=0.00709791f //x=25.205 //y=0.615
c55 ( 13 0 ) capacitor c=0.0157577f //x=25.12 //y=0.53
c56 ( 10 0 ) capacitor c=0.00751696f //x=24.235 //y=1.495
c57 ( 9 0 ) capacitor c=0.00770028f //x=24.235 //y=0.615
c58 ( 5 0 ) capacitor c=0.0245319f //x=24.15 //y=1.58
c59 ( 1 0 ) capacitor c=0.0111029f //x=23.265 //y=1.495
r60 (  17 29 ) resistor r=3.57586 //w=0.17 //l=0.125 //layer=li \
 //thickness=0.1 //x=25.205 //y=0.615 //x2=25.205 //y2=0.49
r61 (  17 29 ) resistor r=18.139 //w=0.187 //l=0.265 //layer=li \
 //thickness=0.1 //x=25.205 //y=0.615 //x2=25.205 //y2=0.88
r62 (  14 29 ) resistor r=3.57586 //w=0.17 //l=0.103078 //layer=li \
 //thickness=0.1 //x=24.32 //y=0.53 //x2=24.235 //y2=0.49
r63 (  14 29 ) resistor r=27.3797 //w=0.187 //l=0.4 //layer=li //thickness=0.1 \
 //x=24.32 //y=0.53 //x2=24.72 //y2=0.53
r64 (  13 29 ) resistor r=3.57586 //w=0.17 //l=0.103078 //layer=li \
 //thickness=0.1 //x=25.12 //y=0.53 //x2=25.205 //y2=0.49
r65 (  13 29 ) resistor r=27.3797 //w=0.187 //l=0.4 //layer=li //thickness=0.1 \
 //x=25.12 //y=0.53 //x2=24.72 //y2=0.53
r66 (  10 29 ) resistor r=3.57586 //w=0.17 //l=0.125 //layer=li \
 //thickness=0.1 //x=24.235 //y=1.495 //x2=24.235 //y2=1.62
r67 (  10 29 ) resistor r=42.0963 //w=0.187 //l=0.615 //layer=li \
 //thickness=0.1 //x=24.235 //y=1.495 //x2=24.235 //y2=0.88
r68 (  9 29 ) resistor r=3.57586 //w=0.17 //l=0.125 //layer=li //thickness=0.1 \
 //x=24.235 //y=0.615 //x2=24.235 //y2=0.49
r69 (  9 29 ) resistor r=18.139 //w=0.187 //l=0.265 //layer=li //thickness=0.1 \
 //x=24.235 //y=0.615 //x2=24.235 //y2=0.88
r70 (  6 29 ) resistor r=3.57586 //w=0.17 //l=0.103078 //layer=li \
 //thickness=0.1 //x=23.35 //y=1.58 //x2=23.265 //y2=1.62
r71 (  6 29 ) resistor r=27.3797 //w=0.187 //l=0.4 //layer=li //thickness=0.1 \
 //x=23.35 //y=1.58 //x2=23.75 //y2=1.58
r72 (  5 29 ) resistor r=3.57586 //w=0.17 //l=0.103078 //layer=li \
 //thickness=0.1 //x=24.15 //y=1.58 //x2=24.235 //y2=1.62
r73 (  5 29 ) resistor r=27.3797 //w=0.187 //l=0.4 //layer=li //thickness=0.1 \
 //x=24.15 //y=1.58 //x2=23.75 //y2=1.58
r74 (  1 29 ) resistor r=3.57586 //w=0.17 //l=0.125 //layer=li //thickness=0.1 \
 //x=23.265 //y=1.495 //x2=23.265 //y2=1.62
r75 (  1 29 ) resistor r=42.0963 //w=0.187 //l=0.615 //layer=li \
 //thickness=0.1 //x=23.265 //y=1.495 //x2=23.265 //y2=0.88
ends PM_DFFRNX1_PCELL\%noxref_23
