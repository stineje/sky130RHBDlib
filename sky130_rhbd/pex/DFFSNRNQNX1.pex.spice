// File: DFFSNRNQNX1.spi.pex
// Created: Sun Mar 15 12:41:09 2026
// Program "Calibre xRC"
// Version "v2023.2_27.15"
// Nominal Temperature: 30C
// Circuit Temperature: 30C
//
simulator lang=spectre
subckt PM_DFFSNRNQNX1\%noxref_1 ( 1 3 6 7 9 10 11 12 14 15 16 17 18 19 20 21 \
 22 23 24 25 28 31 37 46 50 55 56 57 58 67 75 83 100 109 114 123 127 128 129 \
 130 131 132 133 134 135 136 137 139 145 146 147 148 152 153 154 155 156 158 \
 164 165 166 167 187 189 190 191 )
c414 ( 187 0 ) capacitor c=0.00885916f //x=3.885 //y=1.095
c415 ( 167 0 ) capacitor c=0.0612936f //x=11.495 //y=4.97
c416 ( 166 0 ) capacitor c=0.0376642f //x=11.785 //y=4.97
c417 ( 165 0 ) capacitor c=0.0346489f //x=11.45 //y=1.4
c418 ( 164 0 ) capacitor c=0.018692f //x=11.45 //y=1.055
c419 ( 158 0 ) capacitor c=0.0137077f //x=11.295 //y=1.555
c420 ( 156 0 ) capacitor c=0.0158585f //x=11.295 //y=0.9
c421 ( 155 0 ) capacitor c=0.0982643f //x=10.92 //y=2.095
c422 ( 154 0 ) capacitor c=0.0229444f //x=10.92 //y=1.71
c423 ( 153 0 ) capacitor c=0.0234359f //x=10.92 //y=1.4
c424 ( 152 0 ) capacitor c=0.019815f //x=10.92 //y=1.055
c425 ( 148 0 ) capacitor c=0.0612936f //x=6.685 //y=4.97
c426 ( 147 0 ) capacitor c=0.0376642f //x=6.975 //y=4.97
c427 ( 146 0 ) capacitor c=0.0346489f //x=6.64 //y=1.4
c428 ( 145 0 ) capacitor c=0.018692f //x=6.64 //y=1.055
c429 ( 139 0 ) capacitor c=0.0137077f //x=6.485 //y=1.555
c430 ( 137 0 ) capacitor c=0.0158585f //x=6.485 //y=0.9
c431 ( 136 0 ) capacitor c=0.0996994f //x=6.11 //y=2.095
c432 ( 135 0 ) capacitor c=0.0229444f //x=6.11 //y=1.71
c433 ( 134 0 ) capacitor c=0.0234359f //x=6.11 //y=1.4
c434 ( 133 0 ) capacitor c=0.019815f //x=6.11 //y=1.055
c435 ( 132 0 ) capacitor c=0.110208f //x=11.86 //y=6.2
c436 ( 131 0 ) capacitor c=0.158957f //x=11.42 //y=6.2
c437 ( 130 0 ) capacitor c=0.110208f //x=7.05 //y=6.2
c438 ( 129 0 ) capacitor c=0.158957f //x=6.61 //y=6.2
c439 ( 123 0 ) capacitor c=0.0014751f //x=11.22 //y=4.88
c440 ( 114 0 ) capacitor c=9.93222e-19 //x=11.22 //y=2.26
c441 ( 109 0 ) capacitor c=0.0014751f //x=6.41 //y=4.88
c442 ( 100 0 ) capacitor c=9.93222e-19 //x=6.41 //y=2.26
c443 ( 83 0 ) capacitor c=0.0293716f //x=3.78 //y=5.56
c444 ( 75 0 ) capacitor c=0.029137f //x=2.9 //y=5.56
c445 ( 67 0 ) capacitor c=0.0282179f //x=2.02 //y=5.56
c446 ( 58 0 ) capacitor c=0.0195699f //x=7.305 //y=3.13
c447 ( 57 0 ) capacitor c=0.0966636f //x=7.735 //y=3.13
c448 ( 56 0 ) capacitor c=0.00328122f //x=4.72 //y=3.145
c449 ( 55 0 ) capacitor c=0.0543617f //x=6.25 //y=3.145
c450 ( 50 0 ) capacitor c=0.0166814f //x=11.22 //y=3.145
c451 ( 46 0 ) capacitor c=0.0165575f //x=6.41 //y=3.145
c452 ( 37 0 ) capacitor c=0.0169946f //x=4.56 //y=3.145
c453 ( 31 0 ) capacitor c=8.85533e-19 //x=3.78 //y=5.335
c454 ( 28 0 ) capacitor c=0.00741792f //x=2.9 //y=5.335
c455 ( 25 0 ) capacitor c=0.0155037f //x=2.022 //y=5.335
c456 ( 24 0 ) capacitor c=0.0488105f //x=11.22 //y=4.755
c457 ( 23 0 ) capacitor c=0.0145483f //x=11.22 //y=3.3
c458 ( 22 0 ) capacitor c=0.0151832f //x=11.22 //y=2.98
c459 ( 21 0 ) capacitor c=0.00647434f //x=11.22 //y=2.375
c460 ( 20 0 ) capacitor c=0.0501887f //x=6.41 //y=4.755
c461 ( 19 0 ) capacitor c=0.0146407f //x=6.41 //y=3.3
c462 ( 18 0 ) capacitor c=0.0190895f //x=6.41 //y=2.98
c463 ( 17 0 ) capacitor c=0.00647434f //x=6.41 //y=2.375
c464 ( 16 0 ) capacitor c=0.0579287f //x=4.56 //y=5.25
c465 ( 15 0 ) capacitor c=0.0139267f //x=4.56 //y=3.305
c466 ( 14 0 ) capacitor c=0.0287727f //x=4.56 //y=2.985
c467 ( 12 0 ) capacitor c=0.0071803f //x=4.16 //y=1.845
c468 ( 11 0 ) capacitor c=0.0161494f //x=4.475 //y=1.845
c469 ( 10 0 ) capacitor c=0.0167992f //x=4.075 //y=1.76
c470 ( 9 0 ) capacitor c=0.0112558f //x=4.075 //y=1.305
c471 ( 7 0 ) capacitor c=0.0229128f //x=4.475 //y=5.335
c472 ( 6 0 ) capacitor c=0.00933983f //x=3.78 //y=5.56
c473 ( 3 0 ) capacitor c=0.019444f //x=3.665 //y=5.335
c474 ( 1 0 ) capacitor c=0.0181135f //x=2.78 //y=5.335
r475 (  166 168 ) resistor r=26.9307 //w=0.15 //l=0.106066 //layer=ply \
 //thickness=0.18 //x=11.785 //y=4.97 //x2=11.86 //y2=5.045
r476 (  166 167 ) resistor r=148.702 //w=0.094 //l=0.29 //layer=ply \
 //thickness=0.18 //x=11.785 //y=4.97 //x2=11.495 //y2=4.97
r477 (  165 186 ) resistor r=45.1352 //w=0.168 //l=0.173853 //layer=ply \
 //thickness=0.18 //x=11.45 //y=1.4 //x2=11.41 //y2=1.555
r478 (  164 185 ) resistor r=45.1352 //w=0.168 //l=0.173853 //layer=ply \
 //thickness=0.18 //x=11.45 //y=1.055 //x2=11.41 //y2=0.9
r479 (  164 165 ) resistor r=176.904 //w=0.094 //l=0.345 //layer=ply \
 //thickness=0.18 //x=11.45 //y=1.055 //x2=11.45 //y2=1.4
r480 (  161 167 ) resistor r=22.7971 //w=0.269 //l=0.106066 //layer=ply \
 //thickness=0.18 //x=11.42 //y=5.045 //x2=11.495 //y2=4.97
r481 (  161 184 ) resistor r=35.8364 //w=0.269 //l=0.270185 //layer=ply \
 //thickness=0.18 //x=11.42 //y=5.045 //x2=11.22 //y2=4.88
r482 (  159 180 ) resistor r=10.701 //w=0.21 //l=0.115 //layer=ply \
 //thickness=0.18 //x=11.075 //y=1.555 //x2=10.96 //y2=1.555
r483 (  158 186 ) resistor r=5.52526 //w=0.168 //l=0.115 //layer=ply \
 //thickness=0.18 //x=11.295 //y=1.555 //x2=11.41 //y2=1.555
r484 (  157 179 ) resistor r=5.52526 //w=0.168 //l=0.115 //layer=ply \
 //thickness=0.18 //x=11.075 //y=0.9 //x2=10.96 //y2=0.9
r485 (  156 185 ) resistor r=5.52526 //w=0.168 //l=0.115 //layer=ply \
 //thickness=0.18 //x=11.295 //y=0.9 //x2=11.41 //y2=0.9
r486 (  156 157 ) resistor r=112.809 //w=0.094 //l=0.22 //layer=ply \
 //thickness=0.18 //x=11.295 //y=0.9 //x2=11.075 //y2=0.9
r487 (  155 182 ) resistor r=58.7805 //w=0.246 //l=0.373497 //layer=ply \
 //thickness=0.18 //x=10.92 //y=2.095 //x2=11.22 //y2=2.26
r488 (  154 180 ) resistor r=39.5823 //w=0.21 //l=0.173853 //layer=ply \
 //thickness=0.18 //x=10.92 //y=1.71 //x2=10.96 //y2=1.555
r489 (  154 155 ) resistor r=197.415 //w=0.094 //l=0.385 //layer=ply \
 //thickness=0.18 //x=10.92 //y=1.71 //x2=10.92 //y2=2.095
r490 (  153 180 ) resistor r=39.5823 //w=0.21 //l=0.173853 //layer=ply \
 //thickness=0.18 //x=10.92 //y=1.4 //x2=10.96 //y2=1.555
r491 (  152 179 ) resistor r=45.1352 //w=0.168 //l=0.173853 //layer=ply \
 //thickness=0.18 //x=10.92 //y=1.055 //x2=10.96 //y2=0.9
r492 (  152 153 ) resistor r=176.904 //w=0.094 //l=0.345 //layer=ply \
 //thickness=0.18 //x=10.92 //y=1.055 //x2=10.92 //y2=1.4
r493 (  147 149 ) resistor r=26.9307 //w=0.15 //l=0.106066 //layer=ply \
 //thickness=0.18 //x=6.975 //y=4.97 //x2=7.05 //y2=5.045
r494 (  147 148 ) resistor r=148.702 //w=0.094 //l=0.29 //layer=ply \
 //thickness=0.18 //x=6.975 //y=4.97 //x2=6.685 //y2=4.97
r495 (  146 178 ) resistor r=45.1352 //w=0.168 //l=0.173853 //layer=ply \
 //thickness=0.18 //x=6.64 //y=1.4 //x2=6.6 //y2=1.555
r496 (  145 177 ) resistor r=45.1352 //w=0.168 //l=0.173853 //layer=ply \
 //thickness=0.18 //x=6.64 //y=1.055 //x2=6.6 //y2=0.9
r497 (  145 146 ) resistor r=176.904 //w=0.094 //l=0.345 //layer=ply \
 //thickness=0.18 //x=6.64 //y=1.055 //x2=6.64 //y2=1.4
r498 (  142 148 ) resistor r=22.7971 //w=0.269 //l=0.106066 //layer=ply \
 //thickness=0.18 //x=6.61 //y=5.045 //x2=6.685 //y2=4.97
r499 (  142 176 ) resistor r=35.8364 //w=0.269 //l=0.270185 //layer=ply \
 //thickness=0.18 //x=6.61 //y=5.045 //x2=6.41 //y2=4.88
r500 (  140 172 ) resistor r=10.701 //w=0.21 //l=0.115 //layer=ply \
 //thickness=0.18 //x=6.265 //y=1.555 //x2=6.15 //y2=1.555
r501 (  139 178 ) resistor r=5.52526 //w=0.168 //l=0.115 //layer=ply \
 //thickness=0.18 //x=6.485 //y=1.555 //x2=6.6 //y2=1.555
r502 (  138 171 ) resistor r=5.52526 //w=0.168 //l=0.115 //layer=ply \
 //thickness=0.18 //x=6.265 //y=0.9 //x2=6.15 //y2=0.9
r503 (  137 177 ) resistor r=5.52526 //w=0.168 //l=0.115 //layer=ply \
 //thickness=0.18 //x=6.485 //y=0.9 //x2=6.6 //y2=0.9
r504 (  137 138 ) resistor r=112.809 //w=0.094 //l=0.22 //layer=ply \
 //thickness=0.18 //x=6.485 //y=0.9 //x2=6.265 //y2=0.9
r505 (  136 174 ) resistor r=58.7805 //w=0.246 //l=0.373497 //layer=ply \
 //thickness=0.18 //x=6.11 //y=2.095 //x2=6.41 //y2=2.26
r506 (  135 172 ) resistor r=39.5823 //w=0.21 //l=0.173853 //layer=ply \
 //thickness=0.18 //x=6.11 //y=1.71 //x2=6.15 //y2=1.555
r507 (  135 136 ) resistor r=197.415 //w=0.094 //l=0.385 //layer=ply \
 //thickness=0.18 //x=6.11 //y=1.71 //x2=6.11 //y2=2.095
r508 (  134 172 ) resistor r=39.5823 //w=0.21 //l=0.173853 //layer=ply \
 //thickness=0.18 //x=6.11 //y=1.4 //x2=6.15 //y2=1.555
r509 (  133 171 ) resistor r=45.1352 //w=0.168 //l=0.173853 //layer=ply \
 //thickness=0.18 //x=6.11 //y=1.055 //x2=6.15 //y2=0.9
r510 (  133 134 ) resistor r=176.904 //w=0.094 //l=0.345 //layer=ply \
 //thickness=0.18 //x=6.11 //y=1.055 //x2=6.11 //y2=1.4
r511 (  132 168 ) resistor r=592.245 //w=0.094 //l=1.155 //layer=ply \
 //thickness=0.18 //x=11.86 //y=6.2 //x2=11.86 //y2=5.045
r512 (  131 161 ) resistor r=592.245 //w=0.094 //l=1.155 //layer=ply \
 //thickness=0.18 //x=11.42 //y=6.2 //x2=11.42 //y2=5.045
r513 (  130 149 ) resistor r=592.245 //w=0.094 //l=1.155 //layer=ply \
 //thickness=0.18 //x=7.05 //y=6.2 //x2=7.05 //y2=5.045
r514 (  129 142 ) resistor r=592.245 //w=0.094 //l=1.155 //layer=ply \
 //thickness=0.18 //x=6.61 //y=6.2 //x2=6.61 //y2=5.045
r515 (  128 158 ) resistor r=56.4043 //w=0.094 //l=0.11 //layer=ply \
 //thickness=0.18 //x=11.185 //y=1.555 //x2=11.295 //y2=1.555
r516 (  128 159 ) resistor r=56.4043 //w=0.094 //l=0.11 //layer=ply \
 //thickness=0.18 //x=11.185 //y=1.555 //x2=11.075 //y2=1.555
r517 (  127 139 ) resistor r=56.4043 //w=0.094 //l=0.11 //layer=ply \
 //thickness=0.18 //x=6.375 //y=1.555 //x2=6.485 //y2=1.555
r518 (  127 140 ) resistor r=56.4043 //w=0.094 //l=0.11 //layer=ply \
 //thickness=0.18 //x=6.375 //y=1.555 //x2=6.265 //y2=1.555
r519 (  123 184 ) resistor r=152 //w=0.17 //l=0.17 //layer=licon //count=1 \
 //x=11.22 //y=4.88 //x2=11.22 //y2=4.88
r520 (  114 182 ) resistor r=152 //w=0.17 //l=0.17 //layer=licon //count=1 \
 //x=11.22 //y=2.26 //x2=11.22 //y2=2.26
r521 (  109 176 ) resistor r=152 //w=0.17 //l=0.17 //layer=licon //count=1 \
 //x=6.41 //y=4.88 //x2=6.41 //y2=4.88
r522 (  100 174 ) resistor r=152 //w=0.17 //l=0.17 //layer=licon //count=1 \
 //x=6.41 //y=2.26 //x2=6.41 //y2=2.26
r523 (  83 191 ) resistor r=23.615 //w=0.187 //l=0.345 //layer=li \
 //thickness=0.1 //x=3.78 //y=5.56 //x2=3.78 //y2=5.905
r524 (  75 190 ) resistor r=23.615 //w=0.187 //l=0.345 //layer=li \
 //thickness=0.1 //x=2.9 //y=5.56 //x2=2.9 //y2=5.905
r525 (  67 189 ) resistor r=23.615 //w=0.187 //l=0.345 //layer=li \
 //thickness=0.1 //x=2.02 //y=5.56 //x2=2.02 //y2=5.905
r526 (  58 63 ) resistor r=0.523955 //w=0.216 //l=0.899986 //layer=m2 \
 //thickness=0.36 //x=7.305 //y=3.13 //x2=6.41 //y2=3.14
r527 (  57 65 ) resistor r=2.36846 //w=0.184 //l=3.49 //layer=m2 \
 //thickness=0.36 //x=7.735 //y=3.13 //x2=11.22 //y2=3.14
r528 (  57 58 ) resistor r=0.410305 //w=0.131 //l=0.43 //layer=m2 \
 //thickness=0.36 //x=7.735 //y=3.13 //x2=7.305 //y2=3.13
r529 (  56 60 ) resistor r=0.10734 //w=0.281 //l=0.16 //layer=m2 \
 //thickness=0.36 //x=4.72 //y=3.145 //x2=4.56 //y2=3.145
r530 (  55 63 ) resistor r=0.0986081 //w=0.216 //l=0.162481 //layer=m2 \
 //thickness=0.36 //x=6.25 //y=3.145 //x2=6.41 //y2=3.14
r531 (  55 56 ) resistor r=1.45992 //w=0.131 //l=1.53 //layer=m2 \
 //thickness=0.36 //x=6.25 //y=3.145 //x2=4.72 //y2=3.145
r532 (  54 123 ) resistor r=9.3 //w=0.17 //l=0.17 //layer=mcon //count=1 \
 //x=11.22 //y=4.88 //x2=11.22 //y2=4.88
r533 (  52 114 ) resistor r=9.3 //w=0.17 //l=0.17 //layer=mcon //count=1 \
 //x=11.22 //y=2.26 //x2=11.22 //y2=2.26
r534 (  48 65 ) resistor r=4.5 //w=0.15 //l=0.15 //layer=via1 //count=1 \
 //x=11.22 //y=3.14 //x2=11.22 //y2=3.14
r535 (  48 50 ) resistor r=0.00166223 //w=0.376 //l=0.005 //layer=m1 \
 //thickness=0.36 //x=11.167 //y=3.14 //x2=11.167 //y2=3.145
r536 (  44 63 ) resistor r=4.5 //w=0.15 //l=0.15 //layer=via1 //count=1 \
 //x=6.41 //y=3.14 //x2=6.41 //y2=3.14
r537 (  44 46 ) resistor r=0.00166223 //w=0.376 //l=0.005 //layer=m1 \
 //thickness=0.36 //x=6.462 //y=3.14 //x2=6.462 //y2=3.145
r538 (  42 109 ) resistor r=9.3 //w=0.17 //l=0.17 //layer=mcon //count=1 \
 //x=6.41 //y=4.88 //x2=6.41 //y2=4.88
r539 (  40 100 ) resistor r=9.3 //w=0.17 //l=0.17 //layer=mcon //count=1 \
 //x=6.41 //y=2.26 //x2=6.41 //y2=2.26
r540 (  37 60 ) resistor r=4.5 //w=0.15 //l=0.15 //layer=via1 //count=1 \
 //x=4.56 //y=3.145 //x2=4.56 //y2=3.145
r541 (  35 187 ) resistor r=9.3 //w=0.17 //l=0.17 //layer=mcon //count=1 \
 //x=4.075 //y=1.19 //x2=4.075 //y2=1.19
r542 (  33 83 ) resistor r=9.3 //w=0.17 //l=0.17 //layer=mcon //count=1 \
 //x=3.78 //y=5.56 //x2=3.78 //y2=5.56
r543 (  30 75 ) resistor r=9.3 //w=0.17 //l=0.17 //layer=mcon //count=1 \
 //x=2.9 //y=5.56 //x2=2.9 //y2=5.56
r544 (  28 30 ) resistor r=0.121228 //w=0.232 //l=0.225 //layer=m1 \
 //thickness=0.36 //x=2.9 //y=5.335 //x2=2.9 //y2=5.56
r545 (  27 67 ) resistor r=9.3 //w=0.17 //l=0.17 //layer=mcon //count=1 \
 //x=2.02 //y=5.56 //x2=2.02 //y2=5.56
r546 (  25 27 ) resistor r=0.129608 //w=0.217 //l=0.225 //layer=m1 \
 //thickness=0.36 //x=2.022 //y=5.335 //x2=2.022 //y2=5.56
r547 (  24 54 ) resistor r=0.0760407 //w=0.238 //l=0.125 //layer=m1 \
 //thickness=0.36 //x=11.22 //y=4.755 //x2=11.22 //y2=4.88
r548 (  23 50 ) resistor r=0.0894971 //w=0.376 //l=0.179555 //layer=m1 \
 //thickness=0.36 //x=11.22 //y=3.3 //x2=11.167 //y2=3.145
r549 (  23 24 ) resistor r=1.38836 //w=0.131 //l=1.455 //layer=m1 \
 //thickness=0.36 //x=11.22 //y=3.3 //x2=11.22 //y2=4.755
r550 (  22 48 ) resistor r=0.0911593 //w=0.376 //l=0.184608 //layer=m1 \
 //thickness=0.36 //x=11.22 //y=2.98 //x2=11.167 //y2=3.14
r551 (  21 52 ) resistor r=0.0719237 //w=0.222 //l=0.115 //layer=m1 \
 //thickness=0.36 //x=11.22 //y=2.375 //x2=11.22 //y2=2.26
r552 (  21 22 ) resistor r=0.57729 //w=0.131 //l=0.605 //layer=m1 \
 //thickness=0.36 //x=11.22 //y=2.375 //x2=11.22 //y2=2.98
r553 (  20 42 ) resistor r=0.0760407 //w=0.238 //l=0.125 //layer=m1 \
 //thickness=0.36 //x=6.41 //y=4.755 //x2=6.41 //y2=4.88
r554 (  19 46 ) resistor r=0.0894971 //w=0.376 //l=0.179123 //layer=m1 \
 //thickness=0.36 //x=6.41 //y=3.3 //x2=6.462 //y2=3.145
r555 (  19 20 ) resistor r=1.38836 //w=0.131 //l=1.455 //layer=m1 \
 //thickness=0.36 //x=6.41 //y=3.3 //x2=6.41 //y2=4.755
r556 (  18 44 ) resistor r=0.0911593 //w=0.376 //l=0.184174 //layer=m1 \
 //thickness=0.36 //x=6.41 //y=2.98 //x2=6.462 //y2=3.14
r557 (  17 40 ) resistor r=0.0719237 //w=0.222 //l=0.115 //layer=m1 \
 //thickness=0.36 //x=6.41 //y=2.375 //x2=6.41 //y2=2.26
r558 (  17 18 ) resistor r=0.57729 //w=0.131 //l=0.605 //layer=m1 \
 //thickness=0.36 //x=6.41 //y=2.375 //x2=6.41 //y2=2.98
r559 (  15 37 ) resistor r=0.0911593 //w=0.376 //l=0.184174 //layer=m1 \
 //thickness=0.36 //x=4.56 //y=3.305 //x2=4.612 //y2=3.145
r560 (  15 16 ) resistor r=1.85592 //w=0.131 //l=1.945 //layer=m1 \
 //thickness=0.36 //x=4.56 //y=3.305 //x2=4.56 //y2=5.25
r561 (  14 37 ) resistor r=0.0911593 //w=0.376 //l=0.184174 //layer=m1 \
 //thickness=0.36 //x=4.56 //y=2.985 //x2=4.612 //y2=3.145
r562 (  13 14 ) resistor r=1.00668 //w=0.131 //l=1.055 //layer=m1 \
 //thickness=0.36 //x=4.56 //y=1.93 //x2=4.56 //y2=2.985
r563 (  11 13 ) resistor r=0.0698411 //w=0.17 //l=0.120208 //layer=m1 \
 //thickness=0.36 //x=4.475 //y=1.845 //x2=4.56 //y2=1.93
r564 (  11 12 ) resistor r=0.300573 //w=0.131 //l=0.315 //layer=m1 \
 //thickness=0.36 //x=4.475 //y=1.845 //x2=4.16 //y2=1.845
r565 (  10 12 ) resistor r=0.0698411 //w=0.17 //l=0.120208 //layer=m1 \
 //thickness=0.36 //x=4.075 //y=1.76 //x2=4.16 //y2=1.845
r566 (  9 35 ) resistor r=0.0717383 //w=0.224 //l=0.115 //layer=m1 \
 //thickness=0.36 //x=4.075 //y=1.305 //x2=4.075 //y2=1.19
r567 (  9 10 ) resistor r=0.43416 //w=0.131 //l=0.455 //layer=m1 \
 //thickness=0.36 //x=4.075 //y=1.305 //x2=4.075 //y2=1.76
r568 (  8 31 ) resistor r=0.0675342 //w=0.23 //l=0.115 //layer=m1 \
 //thickness=0.36 //x=3.895 //y=5.335 //x2=3.78 //y2=5.335
r569 (  7 16 ) resistor r=0.0698411 //w=0.17 //l=0.120208 //layer=m1 \
 //thickness=0.36 //x=4.475 //y=5.335 //x2=4.56 //y2=5.25
r570 (  7 8 ) resistor r=0.553435 //w=0.131 //l=0.58 //layer=m1 \
 //thickness=0.36 //x=4.475 //y=5.335 //x2=3.895 //y2=5.335
r571 (  6 33 ) resistor r=0.00118313 //w=0.23 //layer=m1 //thickness=0.36 \
 //x=3.78 //y=5.56 //x2=3.78 //y2=5.56
r572 (  5 31 ) resistor r=0.002872 //w=0.34 //l=0.085 //layer=m1 \
 //thickness=0.36 //x=3.78 //y=5.42 //x2=3.78 //y2=5.335
r573 (  5 6 ) resistor r=0.091623 //w=0.191 //l=0.14 //layer=m1 \
 //thickness=0.36 //x=3.78 //y=5.42 //x2=3.78 //y2=5.56
r574 (  4 28 ) resistor r=0.0262263 //w=0.232 //l=0.12 //layer=m1 \
 //thickness=0.36 //x=3.02 //y=5.335 //x2=2.9 //y2=5.335
r575 (  3 31 ) resistor r=0.0675342 //w=0.23 //l=0.115 //layer=m1 \
 //thickness=0.36 //x=3.665 //y=5.335 //x2=3.78 //y2=5.335
r576 (  3 4 ) resistor r=0.615458 //w=0.131 //l=0.645 //layer=m1 \
 //thickness=0.36 //x=3.665 //y=5.335 //x2=3.02 //y2=5.335
r577 (  2 25 ) resistor r=0.0222262 //w=0.217 //l=0.118 //layer=m1 \
 //thickness=0.36 //x=2.14 //y=5.335 //x2=2.022 //y2=5.335
r578 (  1 28 ) resistor r=0.0262263 //w=0.232 //l=0.12 //layer=m1 \
 //thickness=0.36 //x=2.78 //y=5.335 //x2=2.9 //y2=5.335
r579 (  1 2 ) resistor r=0.610687 //w=0.131 //l=0.64 //layer=m1 \
 //thickness=0.36 //x=2.78 //y=5.335 //x2=2.14 //y2=5.335
ends PM_DFFSNRNQNX1\%noxref_1

subckt PM_DFFSNRNQNX1\%noxref_2 ( 1 3 6 7 9 10 11 12 14 15 16 17 18 19 20 21 \
 24 27 33 37 43 48 50 53 61 69 86 95 99 100 101 102 103 104 105 106 108 114 \
 115 116 117 129 131 132 133 )
c293 ( 129 0 ) capacitor c=0.00885916f //x=13.505 //y=1.095
c294 ( 117 0 ) capacitor c=0.0612936f //x=16.305 //y=4.97
c295 ( 116 0 ) capacitor c=0.0376642f //x=16.595 //y=4.97
c296 ( 115 0 ) capacitor c=0.0346489f //x=16.26 //y=1.4
c297 ( 114 0 ) capacitor c=0.018692f //x=16.26 //y=1.055
c298 ( 108 0 ) capacitor c=0.0137077f //x=16.105 //y=1.555
c299 ( 106 0 ) capacitor c=0.0158585f //x=16.105 //y=0.9
c300 ( 105 0 ) capacitor c=0.0982618f //x=15.73 //y=2.095
c301 ( 104 0 ) capacitor c=0.0229444f //x=15.73 //y=1.71
c302 ( 103 0 ) capacitor c=0.0234359f //x=15.73 //y=1.4
c303 ( 102 0 ) capacitor c=0.019815f //x=15.73 //y=1.055
c304 ( 101 0 ) capacitor c=0.110208f //x=16.67 //y=6.2
c305 ( 100 0 ) capacitor c=0.158957f //x=16.23 //y=6.2
c306 ( 95 0 ) capacitor c=0.0014751f //x=16.03 //y=4.88
c307 ( 86 0 ) capacitor c=9.93222e-19 //x=16.03 //y=2.26
c308 ( 69 0 ) capacitor c=0.0293373f //x=13.4 //y=5.56
c309 ( 61 0 ) capacitor c=0.029137f //x=12.52 //y=5.56
c310 ( 53 0 ) capacitor c=0.0278099f //x=11.64 //y=5.56
c311 ( 50 0 ) capacitor c=5.93935e-19 //x=16.03 //y=3.14
c312 ( 48 0 ) capacitor c=6.08897e-19 //x=14.335 //y=3.145
c313 ( 43 0 ) capacitor c=0.0192937f //x=15.87 //y=3.14
c314 ( 37 0 ) capacitor c=0.0164004f //x=16.03 //y=3.14
c315 ( 33 0 ) capacitor c=0.0176392f //x=14.18 //y=3.14
c316 ( 27 0 ) capacitor c=8.01953e-19 //x=13.4 //y=5.335
c317 ( 24 0 ) capacitor c=0.00738593f //x=12.52 //y=5.335
c318 ( 21 0 ) capacitor c=0.0111234f //x=11.642 //y=5.335
c319 ( 20 0 ) capacitor c=0.0493367f //x=16.03 //y=4.755
c320 ( 19 0 ) capacitor c=0.0142536f //x=16.03 //y=3.3
c321 ( 18 0 ) capacitor c=0.0173618f //x=16.03 //y=2.98
c322 ( 17 0 ) capacitor c=0.00647434f //x=16.03 //y=2.375
c323 ( 16 0 ) capacitor c=0.0537319f //x=14.18 //y=5.25
c324 ( 15 0 ) capacitor c=0.013926f //x=14.18 //y=3.305
c325 ( 14 0 ) capacitor c=0.0272198f //x=14.18 //y=2.985
c326 ( 12 0 ) capacitor c=0.0058857f //x=13.78 //y=1.845
c327 ( 11 0 ) capacitor c=0.0145298f //x=14.095 //y=1.845
c328 ( 10 0 ) capacitor c=0.0167992f //x=13.695 //y=1.76
c329 ( 9 0 ) capacitor c=0.0113107f //x=13.695 //y=1.305
c330 ( 7 0 ) capacitor c=0.0235636f //x=14.095 //y=5.335
c331 ( 6 0 ) capacitor c=0.00933983f //x=13.4 //y=5.56
c332 ( 3 0 ) capacitor c=0.0179079f //x=13.285 //y=5.335
c333 ( 1 0 ) capacitor c=0.0151752f //x=12.4 //y=5.335
r334 (  116 118 ) resistor r=26.9307 //w=0.15 //l=0.106066 //layer=ply \
 //thickness=0.18 //x=16.595 //y=4.97 //x2=16.67 //y2=5.045
r335 (  116 117 ) resistor r=148.702 //w=0.094 //l=0.29 //layer=ply \
 //thickness=0.18 //x=16.595 //y=4.97 //x2=16.305 //y2=4.97
r336 (  115 128 ) resistor r=45.1352 //w=0.168 //l=0.173853 //layer=ply \
 //thickness=0.18 //x=16.26 //y=1.4 //x2=16.22 //y2=1.555
r337 (  114 127 ) resistor r=45.1352 //w=0.168 //l=0.173853 //layer=ply \
 //thickness=0.18 //x=16.26 //y=1.055 //x2=16.22 //y2=0.9
r338 (  114 115 ) resistor r=176.904 //w=0.094 //l=0.345 //layer=ply \
 //thickness=0.18 //x=16.26 //y=1.055 //x2=16.26 //y2=1.4
r339 (  111 117 ) resistor r=22.7971 //w=0.269 //l=0.106066 //layer=ply \
 //thickness=0.18 //x=16.23 //y=5.045 //x2=16.305 //y2=4.97
r340 (  111 126 ) resistor r=35.8364 //w=0.269 //l=0.270185 //layer=ply \
 //thickness=0.18 //x=16.23 //y=5.045 //x2=16.03 //y2=4.88
r341 (  109 122 ) resistor r=10.701 //w=0.21 //l=0.115 //layer=ply \
 //thickness=0.18 //x=15.885 //y=1.555 //x2=15.77 //y2=1.555
r342 (  108 128 ) resistor r=5.52526 //w=0.168 //l=0.115 //layer=ply \
 //thickness=0.18 //x=16.105 //y=1.555 //x2=16.22 //y2=1.555
r343 (  107 121 ) resistor r=5.52526 //w=0.168 //l=0.115 //layer=ply \
 //thickness=0.18 //x=15.885 //y=0.9 //x2=15.77 //y2=0.9
r344 (  106 127 ) resistor r=5.52526 //w=0.168 //l=0.115 //layer=ply \
 //thickness=0.18 //x=16.105 //y=0.9 //x2=16.22 //y2=0.9
r345 (  106 107 ) resistor r=112.809 //w=0.094 //l=0.22 //layer=ply \
 //thickness=0.18 //x=16.105 //y=0.9 //x2=15.885 //y2=0.9
r346 (  105 124 ) resistor r=58.7805 //w=0.246 //l=0.373497 //layer=ply \
 //thickness=0.18 //x=15.73 //y=2.095 //x2=16.03 //y2=2.26
r347 (  104 122 ) resistor r=39.5823 //w=0.21 //l=0.173853 //layer=ply \
 //thickness=0.18 //x=15.73 //y=1.71 //x2=15.77 //y2=1.555
r348 (  104 105 ) resistor r=197.415 //w=0.094 //l=0.385 //layer=ply \
 //thickness=0.18 //x=15.73 //y=1.71 //x2=15.73 //y2=2.095
r349 (  103 122 ) resistor r=39.5823 //w=0.21 //l=0.173853 //layer=ply \
 //thickness=0.18 //x=15.73 //y=1.4 //x2=15.77 //y2=1.555
r350 (  102 121 ) resistor r=45.1352 //w=0.168 //l=0.173853 //layer=ply \
 //thickness=0.18 //x=15.73 //y=1.055 //x2=15.77 //y2=0.9
r351 (  102 103 ) resistor r=176.904 //w=0.094 //l=0.345 //layer=ply \
 //thickness=0.18 //x=15.73 //y=1.055 //x2=15.73 //y2=1.4
r352 (  101 118 ) resistor r=592.245 //w=0.094 //l=1.155 //layer=ply \
 //thickness=0.18 //x=16.67 //y=6.2 //x2=16.67 //y2=5.045
r353 (  100 111 ) resistor r=592.245 //w=0.094 //l=1.155 //layer=ply \
 //thickness=0.18 //x=16.23 //y=6.2 //x2=16.23 //y2=5.045
r354 (  99 108 ) resistor r=56.4043 //w=0.094 //l=0.11 //layer=ply \
 //thickness=0.18 //x=15.995 //y=1.555 //x2=16.105 //y2=1.555
r355 (  99 109 ) resistor r=56.4043 //w=0.094 //l=0.11 //layer=ply \
 //thickness=0.18 //x=15.995 //y=1.555 //x2=15.885 //y2=1.555
r356 (  95 126 ) resistor r=152 //w=0.17 //l=0.17 //layer=licon //count=1 \
 //x=16.03 //y=4.88 //x2=16.03 //y2=4.88
r357 (  86 124 ) resistor r=152 //w=0.17 //l=0.17 //layer=licon //count=1 \
 //x=16.03 //y=2.26 //x2=16.03 //y2=2.26
r358 (  69 133 ) resistor r=23.615 //w=0.187 //l=0.345 //layer=li \
 //thickness=0.1 //x=13.4 //y=5.56 //x2=13.4 //y2=5.905
r359 (  61 132 ) resistor r=23.615 //w=0.187 //l=0.345 //layer=li \
 //thickness=0.1 //x=12.52 //y=5.56 //x2=12.52 //y2=5.905
r360 (  53 131 ) resistor r=23.615 //w=0.187 //l=0.345 //layer=li \
 //thickness=0.1 //x=11.64 //y=5.56 //x2=11.64 //y2=5.905
r361 (  46 48 ) resistor r=0.10734 //w=0.281 //l=0.16 //layer=m2 \
 //thickness=0.36 //x=14.175 //y=3.145 //x2=14.335 //y2=3.145
r362 (  43 50 ) resistor r=0.10734 //w=0.281 //l=0.16 //layer=m2 \
 //thickness=0.36 //x=15.87 //y=3.14 //x2=16.03 //y2=3.14
r363 (  43 48 ) resistor r=1.46469 //w=0.131 //l=1.535 //layer=m2 \
 //thickness=0.36 //x=15.87 //y=3.14 //x2=14.335 //y2=3.14
r364 (  42 95 ) resistor r=9.3 //w=0.17 //l=0.17 //layer=mcon //count=1 \
 //x=16.03 //y=4.88 //x2=16.03 //y2=4.88
r365 (  40 86 ) resistor r=9.3 //w=0.17 //l=0.17 //layer=mcon //count=1 \
 //x=16.03 //y=2.26 //x2=16.03 //y2=2.26
r366 (  37 50 ) resistor r=4.5 //w=0.15 //l=0.15 //layer=via1 //count=1 \
 //x=16.03 //y=3.14 //x2=16.03 //y2=3.14
r367 (  35 46 ) resistor r=4.5 //w=0.15 //l=0.15 //layer=via1 //count=1 \
 //x=14.175 //y=3.145 //x2=14.175 //y2=3.145
r368 (  33 35 ) resistor r=0.00164908 //w=0.379 //l=0.005 //layer=m1 \
 //thickness=0.36 //x=14.23 //y=3.14 //x2=14.23 //y2=3.145
r369 (  31 129 ) resistor r=9.3 //w=0.17 //l=0.17 //layer=mcon //count=1 \
 //x=13.695 //y=1.19 //x2=13.695 //y2=1.19
r370 (  29 69 ) resistor r=9.3 //w=0.17 //l=0.17 //layer=mcon //count=1 \
 //x=13.4 //y=5.56 //x2=13.4 //y2=5.56
r371 (  26 61 ) resistor r=9.3 //w=0.17 //l=0.17 //layer=mcon //count=1 \
 //x=12.52 //y=5.56 //x2=12.52 //y2=5.56
r372 (  24 26 ) resistor r=0.121228 //w=0.232 //l=0.225 //layer=m1 \
 //thickness=0.36 //x=12.52 //y=5.335 //x2=12.52 //y2=5.56
r373 (  23 53 ) resistor r=9.3 //w=0.17 //l=0.17 //layer=mcon //count=1 \
 //x=11.64 //y=5.56 //x2=11.64 //y2=5.56
r374 (  21 23 ) resistor r=0.129608 //w=0.217 //l=0.225 //layer=m1 \
 //thickness=0.36 //x=11.642 //y=5.335 //x2=11.642 //y2=5.56
r375 (  20 42 ) resistor r=0.0760407 //w=0.238 //l=0.125 //layer=m1 \
 //thickness=0.36 //x=16.03 //y=4.755 //x2=16.03 //y2=4.88
r376 (  19 37 ) resistor r=0.0911593 //w=0.376 //l=0.184608 //layer=m1 \
 //thickness=0.36 //x=16.03 //y=3.3 //x2=15.977 //y2=3.14
r377 (  19 20 ) resistor r=1.38836 //w=0.131 //l=1.455 //layer=m1 \
 //thickness=0.36 //x=16.03 //y=3.3 //x2=16.03 //y2=4.755
r378 (  18 37 ) resistor r=0.0911593 //w=0.376 //l=0.184608 //layer=m1 \
 //thickness=0.36 //x=16.03 //y=2.98 //x2=15.977 //y2=3.14
r379 (  17 40 ) resistor r=0.0719237 //w=0.222 //l=0.115 //layer=m1 \
 //thickness=0.36 //x=16.03 //y=2.375 //x2=16.03 //y2=2.26
r380 (  17 18 ) resistor r=0.57729 //w=0.131 //l=0.605 //layer=m1 \
 //thickness=0.36 //x=16.03 //y=2.375 //x2=16.03 //y2=2.98
r381 (  15 35 ) resistor r=0.0912814 //w=0.379 //l=0.183303 //layer=m1 \
 //thickness=0.36 //x=14.18 //y=3.305 //x2=14.23 //y2=3.145
r382 (  15 16 ) resistor r=1.85592 //w=0.131 //l=1.945 //layer=m1 \
 //thickness=0.36 //x=14.18 //y=3.305 //x2=14.18 //y2=5.25
r383 (  14 33 ) resistor r=0.0896323 //w=0.379 //l=0.178255 //layer=m1 \
 //thickness=0.36 //x=14.18 //y=2.985 //x2=14.23 //y2=3.14
r384 (  13 14 ) resistor r=1.00668 //w=0.131 //l=1.055 //layer=m1 \
 //thickness=0.36 //x=14.18 //y=1.93 //x2=14.18 //y2=2.985
r385 (  11 13 ) resistor r=0.0698411 //w=0.17 //l=0.120208 //layer=m1 \
 //thickness=0.36 //x=14.095 //y=1.845 //x2=14.18 //y2=1.93
r386 (  11 12 ) resistor r=0.300573 //w=0.131 //l=0.315 //layer=m1 \
 //thickness=0.36 //x=14.095 //y=1.845 //x2=13.78 //y2=1.845
r387 (  10 12 ) resistor r=0.0698411 //w=0.17 //l=0.120208 //layer=m1 \
 //thickness=0.36 //x=13.695 //y=1.76 //x2=13.78 //y2=1.845
r388 (  9 31 ) resistor r=0.0717383 //w=0.224 //l=0.115 //layer=m1 \
 //thickness=0.36 //x=13.695 //y=1.305 //x2=13.695 //y2=1.19
r389 (  9 10 ) resistor r=0.43416 //w=0.131 //l=0.455 //layer=m1 \
 //thickness=0.36 //x=13.695 //y=1.305 //x2=13.695 //y2=1.76
r390 (  8 27 ) resistor r=0.0675342 //w=0.23 //l=0.115 //layer=m1 \
 //thickness=0.36 //x=13.515 //y=5.335 //x2=13.4 //y2=5.335
r391 (  7 16 ) resistor r=0.0698411 //w=0.17 //l=0.120208 //layer=m1 \
 //thickness=0.36 //x=14.095 //y=5.335 //x2=14.18 //y2=5.25
r392 (  7 8 ) resistor r=0.553435 //w=0.131 //l=0.58 //layer=m1 \
 //thickness=0.36 //x=14.095 //y=5.335 //x2=13.515 //y2=5.335
r393 (  6 29 ) resistor r=0.00118313 //w=0.23 //layer=m1 //thickness=0.36 \
 //x=13.4 //y=5.56 //x2=13.4 //y2=5.56
r394 (  5 27 ) resistor r=0.002872 //w=0.34 //l=0.085 //layer=m1 \
 //thickness=0.36 //x=13.4 //y=5.42 //x2=13.4 //y2=5.335
r395 (  5 6 ) resistor r=0.091623 //w=0.191 //l=0.14 //layer=m1 \
 //thickness=0.36 //x=13.4 //y=5.42 //x2=13.4 //y2=5.56
r396 (  4 24 ) resistor r=0.0262263 //w=0.232 //l=0.12 //layer=m1 \
 //thickness=0.36 //x=12.64 //y=5.335 //x2=12.52 //y2=5.335
r397 (  3 27 ) resistor r=0.0675342 //w=0.23 //l=0.115 //layer=m1 \
 //thickness=0.36 //x=13.285 //y=5.335 //x2=13.4 //y2=5.335
r398 (  3 4 ) resistor r=0.615458 //w=0.131 //l=0.645 //layer=m1 \
 //thickness=0.36 //x=13.285 //y=5.335 //x2=12.64 //y2=5.335
r399 (  2 21 ) resistor r=0.0222262 //w=0.217 //l=0.118 //layer=m1 \
 //thickness=0.36 //x=11.76 //y=5.335 //x2=11.642 //y2=5.335
r400 (  1 24 ) resistor r=0.0262263 //w=0.232 //l=0.12 //layer=m1 \
 //thickness=0.36 //x=12.4 //y=5.335 //x2=12.52 //y2=5.335
r401 (  1 2 ) resistor r=0.610687 //w=0.131 //l=0.64 //layer=m1 \
 //thickness=0.36 //x=12.4 //y=5.335 //x2=11.76 //y2=5.335
ends PM_DFFSNRNQNX1\%noxref_2

subckt PM_DFFSNRNQNX1\%CLK ( 1 2 3 4 5 6 9 10 12 15 16 33 35 37 39 41 43 45 47 \
 52 56 65 70 79 83 84 85 86 87 88 89 90 91 93 99 100 101 102 103 108 109 110 \
 112 118 119 120 121 122 130 141 )
c338 ( 141 0 ) capacitor c=0.0369044f //x=17.14 //y=4.88
c339 ( 130 0 ) capacitor c=0.0369044f //x=7.52 //y=4.88
c340 ( 122 0 ) capacitor c=0.0309248f //x=17.475 //y=4.97
c341 ( 121 0 ) capacitor c=0.0835408f //x=17.23 //y=2.095
c342 ( 120 0 ) capacitor c=0.0170266f //x=17.23 //y=1.63
c343 ( 119 0 ) capacitor c=0.018609f //x=17.23 //y=1.4
c344 ( 118 0 ) capacitor c=0.0186599f //x=17.23 //y=1.09
c345 ( 112 0 ) capacitor c=0.0146988f //x=17.075 //y=1.555
c346 ( 110 0 ) capacitor c=0.0148531f //x=17.075 //y=0.935
c347 ( 109 0 ) capacitor c=0.0334406f //x=16.705 //y=1.4
c348 ( 108 0 ) capacitor c=0.0173191f //x=16.705 //y=1.09
c349 ( 103 0 ) capacitor c=0.0309248f //x=7.855 //y=4.97
c350 ( 102 0 ) capacitor c=0.0835458f //x=7.61 //y=2.095
c351 ( 101 0 ) capacitor c=0.0170266f //x=7.61 //y=1.63
c352 ( 100 0 ) capacitor c=0.018609f //x=7.61 //y=1.4
c353 ( 99 0 ) capacitor c=0.0186599f //x=7.61 //y=1.09
c354 ( 93 0 ) capacitor c=0.0146988f //x=7.455 //y=1.555
c355 ( 91 0 ) capacitor c=0.0148531f //x=7.455 //y=0.935
c356 ( 90 0 ) capacitor c=0.0334406f //x=7.085 //y=1.4
c357 ( 89 0 ) capacitor c=0.0173191f //x=7.085 //y=1.09
c358 ( 88 0 ) capacitor c=0.110208f //x=17.55 //y=6.2
c359 ( 87 0 ) capacitor c=0.110214f //x=17.11 //y=6.2
c360 ( 86 0 ) capacitor c=0.110208f //x=7.93 //y=6.2
c361 ( 85 0 ) capacitor c=0.110214f //x=7.49 //y=6.2
c362 ( 79 0 ) capacitor c=0.00129935f //x=17.14 //y=4.88
c363 ( 70 0 ) capacitor c=0.00121786f //x=17.14 //y=2.26
c364 ( 65 0 ) capacitor c=0.00129935f //x=7.52 //y=4.88
c365 ( 56 0 ) capacitor c=0.00121786f //x=7.52 //y=2.26
c366 ( 52 0 ) capacitor c=3.20756e-19 //x=7.68 //y=3.515
c367 ( 47 0 ) capacitor c=0.00996893f //x=16.245 //y=3.525
c368 ( 45 0 ) capacitor c=0.0179407f //x=15.645 //y=3.51
c369 ( 43 0 ) capacitor c=0.00431719f //x=14.39 //y=3.53
c370 ( 41 0 ) capacitor c=0.0343307f //x=13.79 //y=3.51
c371 ( 39 0 ) capacitor c=0.00737138f //x=11.435 //y=3.525
c372 ( 37 0 ) capacitor c=0.0170368f //x=10.835 //y=3.51
c373 ( 35 0 ) capacitor c=0.00614268f //x=9.575 //y=3.5
c374 ( 33 0 ) capacitor c=0.0124159f //x=8.975 //y=3.51
c375 ( 16 0 ) capacitor c=0.0332548f //x=17.14 //y=4.765
c376 ( 15 0 ) capacitor c=0.0128818f //x=17.14 //y=3.665
c377 ( 12 0 ) capacitor c=0.00523683f //x=17.14 //y=2.375
c378 ( 10 0 ) capacitor c=0.00473127f //x=7.52 //y=4.765
c379 ( 9 0 ) capacitor c=0.0126734f //x=7.52 //y=3.675
c380 ( 6 0 ) capacitor c=0.00524024f //x=7.52 //y=2.375
c381 ( 5 0 ) capacitor c=0.0155574f //x=17.14 //y=3.51
c382 ( 4 0 ) capacitor c=0.0155574f //x=7.52 //y=3.51
c383 ( 3 0 ) capacitor c=0.0259898f //x=17.14 //y=3.14
c384 ( 2 0 ) capacitor c=0.02735f //x=7.52 //y=4.25
c385 ( 1 0 ) capacitor c=0.0266178f //x=7.52 //y=2.77
r386 (  143 144 ) resistor r=32.4568 //w=0.214 //l=0.075 //layer=ply \
 //thickness=0.18 //x=17.14 //y=4.97 //x2=17.14 //y2=5.045
r387 (  141 143 ) resistor r=20.271 //w=0.214 //l=0.09 //layer=ply \
 //thickness=0.18 //x=17.14 //y=4.88 //x2=17.14 //y2=4.97
r388 (  132 133 ) resistor r=32.4568 //w=0.214 //l=0.075 //layer=ply \
 //thickness=0.18 //x=7.52 //y=4.97 //x2=7.52 //y2=5.045
r389 (  130 132 ) resistor r=20.271 //w=0.214 //l=0.09 //layer=ply \
 //thickness=0.18 //x=7.52 //y=4.88 //x2=7.52 //y2=4.97
r390 (  123 143 ) resistor r=16.5046 //w=0.27 //l=0.135 //layer=ply \
 //thickness=0.18 //x=17.275 //y=4.97 //x2=17.14 //y2=4.97
r391 (  122 124 ) resistor r=26.9307 //w=0.15 //l=0.106066 //layer=ply \
 //thickness=0.18 //x=17.475 //y=4.97 //x2=17.55 //y2=5.045
r392 (  122 123 ) resistor r=102.553 //w=0.094 //l=0.2 //layer=ply \
 //thickness=0.18 //x=17.475 //y=4.97 //x2=17.275 //y2=4.97
r393 (  121 148 ) resistor r=38.6777 //w=0.284 //l=0.198997 //layer=ply \
 //thickness=0.18 //x=17.23 //y=2.095 //x2=17.155 //y2=2.26
r394 (  120 146 ) resistor r=21.2976 //w=0.217 //l=0.0928709 //layer=ply \
 //thickness=0.18 //x=17.23 //y=1.63 //x2=17.19 //y2=1.555
r395 (  120 121 ) resistor r=238.436 //w=0.094 //l=0.465 //layer=ply \
 //thickness=0.18 //x=17.23 //y=1.63 //x2=17.23 //y2=2.095
r396 (  119 146 ) resistor r=39.0671 //w=0.217 //l=0.173853 //layer=ply \
 //thickness=0.18 //x=17.23 //y=1.4 //x2=17.19 //y2=1.555
r397 (  118 145 ) resistor r=45.1352 //w=0.168 //l=0.173853 //layer=ply \
 //thickness=0.18 //x=17.23 //y=1.09 //x2=17.19 //y2=0.935
r398 (  118 119 ) resistor r=158.957 //w=0.094 //l=0.31 //layer=ply \
 //thickness=0.18 //x=17.23 //y=1.09 //x2=17.23 //y2=1.4
r399 (  113 139 ) resistor r=5.52526 //w=0.168 //l=0.115 //layer=ply \
 //thickness=0.18 //x=16.86 //y=1.555 //x2=16.745 //y2=1.555
r400 (  112 146 ) resistor r=11.4558 //w=0.217 //l=0.115 //layer=ply \
 //thickness=0.18 //x=17.075 //y=1.555 //x2=17.19 //y2=1.555
r401 (  111 138 ) resistor r=5.52526 //w=0.168 //l=0.115 //layer=ply \
 //thickness=0.18 //x=16.86 //y=0.935 //x2=16.745 //y2=0.935
r402 (  110 145 ) resistor r=5.52526 //w=0.168 //l=0.115 //layer=ply \
 //thickness=0.18 //x=17.075 //y=0.935 //x2=17.19 //y2=0.935
r403 (  110 111 ) resistor r=110.245 //w=0.094 //l=0.215 //layer=ply \
 //thickness=0.18 //x=17.075 //y=0.935 //x2=16.86 //y2=0.935
r404 (  109 139 ) resistor r=45.1352 //w=0.168 //l=0.173853 //layer=ply \
 //thickness=0.18 //x=16.705 //y=1.4 //x2=16.745 //y2=1.555
r405 (  108 138 ) resistor r=45.1352 //w=0.168 //l=0.173853 //layer=ply \
 //thickness=0.18 //x=16.705 //y=1.09 //x2=16.745 //y2=0.935
r406 (  108 109 ) resistor r=158.957 //w=0.094 //l=0.31 //layer=ply \
 //thickness=0.18 //x=16.705 //y=1.09 //x2=16.705 //y2=1.4
r407 (  104 132 ) resistor r=16.5046 //w=0.27 //l=0.135 //layer=ply \
 //thickness=0.18 //x=7.655 //y=4.97 //x2=7.52 //y2=4.97
r408 (  103 105 ) resistor r=26.9307 //w=0.15 //l=0.106066 //layer=ply \
 //thickness=0.18 //x=7.855 //y=4.97 //x2=7.93 //y2=5.045
r409 (  103 104 ) resistor r=102.553 //w=0.094 //l=0.2 //layer=ply \
 //thickness=0.18 //x=7.855 //y=4.97 //x2=7.655 //y2=4.97
r410 (  102 137 ) resistor r=38.6777 //w=0.284 //l=0.198997 //layer=ply \
 //thickness=0.18 //x=7.61 //y=2.095 //x2=7.535 //y2=2.26
r411 (  101 135 ) resistor r=21.2976 //w=0.217 //l=0.0928709 //layer=ply \
 //thickness=0.18 //x=7.61 //y=1.63 //x2=7.57 //y2=1.555
r412 (  101 102 ) resistor r=238.436 //w=0.094 //l=0.465 //layer=ply \
 //thickness=0.18 //x=7.61 //y=1.63 //x2=7.61 //y2=2.095
r413 (  100 135 ) resistor r=39.0671 //w=0.217 //l=0.173853 //layer=ply \
 //thickness=0.18 //x=7.61 //y=1.4 //x2=7.57 //y2=1.555
r414 (  99 134 ) resistor r=45.1352 //w=0.168 //l=0.173853 //layer=ply \
 //thickness=0.18 //x=7.61 //y=1.09 //x2=7.57 //y2=0.935
r415 (  99 100 ) resistor r=158.957 //w=0.094 //l=0.31 //layer=ply \
 //thickness=0.18 //x=7.61 //y=1.09 //x2=7.61 //y2=1.4
r416 (  94 128 ) resistor r=5.52526 //w=0.168 //l=0.115 //layer=ply \
 //thickness=0.18 //x=7.24 //y=1.555 //x2=7.125 //y2=1.555
r417 (  93 135 ) resistor r=11.4558 //w=0.217 //l=0.115 //layer=ply \
 //thickness=0.18 //x=7.455 //y=1.555 //x2=7.57 //y2=1.555
r418 (  92 127 ) resistor r=5.52526 //w=0.168 //l=0.115 //layer=ply \
 //thickness=0.18 //x=7.24 //y=0.935 //x2=7.125 //y2=0.935
r419 (  91 134 ) resistor r=5.52526 //w=0.168 //l=0.115 //layer=ply \
 //thickness=0.18 //x=7.455 //y=0.935 //x2=7.57 //y2=0.935
r420 (  91 92 ) resistor r=110.245 //w=0.094 //l=0.215 //layer=ply \
 //thickness=0.18 //x=7.455 //y=0.935 //x2=7.24 //y2=0.935
r421 (  90 128 ) resistor r=45.1352 //w=0.168 //l=0.173853 //layer=ply \
 //thickness=0.18 //x=7.085 //y=1.4 //x2=7.125 //y2=1.555
r422 (  89 127 ) resistor r=45.1352 //w=0.168 //l=0.173853 //layer=ply \
 //thickness=0.18 //x=7.085 //y=1.09 //x2=7.125 //y2=0.935
r423 (  89 90 ) resistor r=158.957 //w=0.094 //l=0.31 //layer=ply \
 //thickness=0.18 //x=7.085 //y=1.09 //x2=7.085 //y2=1.4
r424 (  88 124 ) resistor r=592.245 //w=0.094 //l=1.155 //layer=ply \
 //thickness=0.18 //x=17.55 //y=6.2 //x2=17.55 //y2=5.045
r425 (  87 144 ) resistor r=592.245 //w=0.094 //l=1.155 //layer=ply \
 //thickness=0.18 //x=17.11 //y=6.2 //x2=17.11 //y2=5.045
r426 (  86 105 ) resistor r=592.245 //w=0.094 //l=1.155 //layer=ply \
 //thickness=0.18 //x=7.93 //y=6.2 //x2=7.93 //y2=5.045
r427 (  85 133 ) resistor r=592.245 //w=0.094 //l=1.155 //layer=ply \
 //thickness=0.18 //x=7.49 //y=6.2 //x2=7.49 //y2=5.045
r428 (  84 112 ) resistor r=55.3787 //w=0.094 //l=0.108 //layer=ply \
 //thickness=0.18 //x=16.967 //y=1.555 //x2=17.075 //y2=1.555
r429 (  84 113 ) resistor r=54.866 //w=0.094 //l=0.107 //layer=ply \
 //thickness=0.18 //x=16.967 //y=1.555 //x2=16.86 //y2=1.555
r430 (  83 93 ) resistor r=55.3787 //w=0.094 //l=0.108 //layer=ply \
 //thickness=0.18 //x=7.347 //y=1.555 //x2=7.455 //y2=1.555
r431 (  83 94 ) resistor r=54.866 //w=0.094 //l=0.107 //layer=ply \
 //thickness=0.18 //x=7.347 //y=1.555 //x2=7.24 //y2=1.555
r432 (  79 141 ) resistor r=152 //w=0.17 //l=0.17 //layer=licon //count=1 \
 //x=17.14 //y=4.88 //x2=17.14 //y2=4.88
r433 (  70 148 ) resistor r=152 //w=0.17 //l=0.17 //layer=licon //count=1 \
 //x=17.14 //y=2.26 //x2=17.14 //y2=2.26
r434 (  65 130 ) resistor r=152 //w=0.17 //l=0.17 //layer=licon //count=1 \
 //x=7.52 //y=4.88 //x2=7.52 //y2=4.88
r435 (  56 137 ) resistor r=152 //w=0.17 //l=0.17 //layer=licon //count=1 \
 //x=7.52 //y=2.26 //x2=7.52 //y2=2.26
r436 (  50 52 ) resistor r=0.10734 //w=0.281 //l=0.16 //layer=m2 \
 //thickness=0.36 //x=7.52 //y=3.515 //x2=7.68 //y2=3.515
r437 (  47 54 ) resistor r=0.523955 //w=0.216 //l=0.904945 //layer=m2 \
 //thickness=0.36 //x=16.245 //y=3.525 //x2=17.14 //y2=3.505
r438 (  47 48 ) resistor r=0.329198 //w=0.131 //l=0.345 //layer=m2 \
 //thickness=0.36 //x=16.245 //y=3.525 //x2=15.9 //y2=3.525
r439 (  45 48 ) resistor r=0.1875 //w=0.17 //l=0.262393 //layer=m2 \
 //thickness=0.36 //x=15.645 //y=3.51 //x2=15.9 //y2=3.525
r440 (  45 46 ) resistor r=1.03531 //w=0.131 //l=1.085 //layer=m2 \
 //thickness=0.36 //x=15.645 //y=3.51 //x2=14.56 //y2=3.51
r441 (  43 46 ) resistor r=0.125 //w=0.17 //l=0.179722 //layer=m2 \
 //thickness=0.36 //x=14.39 //y=3.53 //x2=14.56 //y2=3.51
r442 (  43 44 ) resistor r=0.329198 //w=0.131 //l=0.345 //layer=m2 \
 //thickness=0.36 //x=14.39 //y=3.53 //x2=14.045 //y2=3.53
r443 (  41 44 ) resistor r=0.1875 //w=0.17 //l=0.264811 //layer=m2 \
 //thickness=0.36 //x=13.79 //y=3.51 //x2=14.045 //y2=3.53
r444 (  41 42 ) resistor r=2.08492 //w=0.131 //l=2.185 //layer=m2 \
 //thickness=0.36 //x=13.79 //y=3.51 //x2=11.605 //y2=3.51
r445 (  39 42 ) resistor r=0.125 //w=0.17 //l=0.177341 //layer=m2 \
 //thickness=0.36 //x=11.435 //y=3.525 //x2=11.605 //y2=3.51
r446 (  39 40 ) resistor r=0.329198 //w=0.131 //l=0.345 //layer=m2 \
 //thickness=0.36 //x=11.435 //y=3.525 //x2=11.09 //y2=3.525
r447 (  37 40 ) resistor r=0.1875 //w=0.17 //l=0.262393 //layer=m2 \
 //thickness=0.36 //x=10.835 //y=3.51 //x2=11.09 //y2=3.525
r448 (  37 38 ) resistor r=0.958969 //w=0.131 //l=1.005 //layer=m2 \
 //thickness=0.36 //x=10.835 //y=3.51 //x2=9.83 //y2=3.51
r449 (  35 38 ) resistor r=0.1875 //w=0.17 //l=0.259952 //layer=m2 \
 //thickness=0.36 //x=9.575 //y=3.5 //x2=9.83 //y2=3.51
r450 (  35 36 ) resistor r=0.410305 //w=0.131 //l=0.43 //layer=m2 \
 //thickness=0.36 //x=9.575 //y=3.5 //x2=9.145 //y2=3.5
r451 (  33 36 ) resistor r=0.125 //w=0.17 //l=0.174929 //layer=m2 \
 //thickness=0.36 //x=8.975 //y=3.51 //x2=9.145 //y2=3.5
r452 (  33 52 ) resistor r=1.23569 //w=0.131 //l=1.295 //layer=m2 \
 //thickness=0.36 //x=8.975 //y=3.51 //x2=7.68 //y2=3.51
r453 (  32 79 ) resistor r=9.3 //w=0.17 //l=0.17 //layer=mcon //count=1 \
 //x=17.14 //y=4.88 //x2=17.14 //y2=4.88
r454 (  30 70 ) resistor r=9.3 //w=0.17 //l=0.17 //layer=mcon //count=1 \
 //x=17.14 //y=2.26 //x2=17.14 //y2=2.26
r455 (  26 54 ) resistor r=4.5 //w=0.15 //l=0.15 //layer=via1 //count=1 \
 //x=17.14 //y=3.505 //x2=17.14 //y2=3.505
r456 (  24 50 ) resistor r=4.5 //w=0.15 //l=0.15 //layer=via1 //count=1 \
 //x=7.52 //y=3.515 //x2=7.52 //y2=3.515
r457 (  20 65 ) resistor r=9.3 //w=0.17 //l=0.17 //layer=mcon //count=1 \
 //x=7.52 //y=4.88 //x2=7.52 //y2=4.88
r458 (  18 56 ) resistor r=9.3 //w=0.17 //l=0.17 //layer=mcon //count=1 \
 //x=7.52 //y=2.26 //x2=7.52 //y2=2.26
r459 (  16 32 ) resistor r=0.0717383 //w=0.224 //l=0.115 //layer=m1 \
 //thickness=0.36 //x=17.14 //y=4.765 //x2=17.14 //y2=4.88
r460 (  15 16 ) resistor r=1.04962 //w=0.131 //l=1.1 //layer=m1 \
 //thickness=0.36 //x=17.14 //y=3.665 //x2=17.14 //y2=4.765
r461 (  13 26 ) resistor r=0.0911593 //w=0.376 //l=0.184608 //layer=m1 \
 //thickness=0.36 //x=17.14 //y=3.345 //x2=17.087 //y2=3.505
r462 (  12 30 ) resistor r=0.0715665 //w=0.226 //l=0.115996 //layer=m1 \
 //thickness=0.36 //x=17.14 //y=2.375 //x2=17.142 //y2=2.26
r463 (  10 20 ) resistor r=0.0717383 //w=0.224 //l=0.115 //layer=m1 \
 //thickness=0.36 //x=7.52 //y=4.765 //x2=7.52 //y2=4.88
r464 (  9 24 ) resistor r=0.0911593 //w=0.376 //l=0.184174 //layer=m1 \
 //thickness=0.36 //x=7.52 //y=3.675 //x2=7.572 //y2=3.515
r465 (  6 18 ) resistor r=0.0715665 //w=0.226 //l=0.115996 //layer=m1 \
 //thickness=0.36 //x=7.52 //y=2.375 //x2=7.522 //y2=2.26
r466 (  5 15 ) resistor r=0.0894971 //w=0.376 //l=0.179555 //layer=m1 \
 //thickness=0.36 //x=17.087 //y=3.51 //x2=17.14 //y2=3.665
r467 (  5 26 ) resistor r=0.00166223 //w=0.376 //l=0.005 //layer=m1 \
 //thickness=0.36 //x=17.087 //y=3.51 //x2=17.087 //y2=3.505
r468 (  4 24 ) resistor r=0.00166223 //w=0.376 //l=0.005 //layer=m1 \
 //thickness=0.36 //x=7.572 //y=3.51 //x2=7.572 //y2=3.515
r469 (  4 7 ) resistor r=0.0894971 //w=0.376 //l=0.179123 //layer=m1 \
 //thickness=0.36 //x=7.572 //y=3.51 //x2=7.52 //y2=3.355
r470 (  3 13 ) resistor r=0.195611 //w=0.131 //l=0.205 //layer=m1 \
 //thickness=0.36 //x=17.14 //y=3.14 //x2=17.14 //y2=3.345
r471 (  3 12 ) resistor r=0.729962 //w=0.131 //l=0.765 //layer=m1 \
 //thickness=0.36 //x=17.14 //y=3.14 //x2=17.14 //y2=2.375
r472 (  2 10 ) resistor r=0.491412 //w=0.131 //l=0.515 //layer=m1 \
 //thickness=0.36 //x=7.52 //y=4.25 //x2=7.52 //y2=4.765
r473 (  2 9 ) resistor r=0.548664 //w=0.131 //l=0.575 //layer=m1 \
 //thickness=0.36 //x=7.52 //y=4.25 //x2=7.52 //y2=3.675
r474 (  1 7 ) resistor r=0.558206 //w=0.131 //l=0.585 //layer=m1 \
 //thickness=0.36 //x=7.52 //y=2.77 //x2=7.52 //y2=3.355
r475 (  1 6 ) resistor r=0.376908 //w=0.131 //l=0.395 //layer=m1 \
 //thickness=0.36 //x=7.52 //y=2.77 //x2=7.52 //y2=2.375
ends PM_DFFSNRNQNX1\%CLK

subckt PM_DFFSNRNQNX1\%noxref_4 ( 1 2 3 4 5 7 10 11 13 14 15 16 18 19 20 21 22 \
 23 24 30 32 35 38 44 48 54 55 56 58 60 62 63 64 66 68 70 80 89 94 102 110 127 \
 136 140 141 142 143 144 145 149 150 151 156 158 161 162 163 164 165 166 167 \
 169 175 176 177 178 183 184 189 200 202 203 204 )
c486 ( 200 0 ) capacitor c=0.00885916f //x=8.695 //y=1.095
c487 ( 189 0 ) capacitor c=0.0653715f //x=3.82 //y=4.88
c488 ( 184 0 ) capacitor c=0.0278202f //x=3.82 //y=2.095
c489 ( 183 0 ) capacitor c=0.0503043f //x=3.82 //y=2.26
c490 ( 178 0 ) capacitor c=0.0582543f //x=21.115 //y=4.97
c491 ( 177 0 ) capacitor c=0.0376642f //x=21.405 //y=4.97
c492 ( 176 0 ) capacitor c=0.0346489f //x=21.07 //y=1.4
c493 ( 175 0 ) capacitor c=0.018692f //x=21.07 //y=1.055
c494 ( 169 0 ) capacitor c=0.0137077f //x=20.915 //y=1.555
c495 ( 167 0 ) capacitor c=0.0158585f //x=20.915 //y=0.9
c496 ( 166 0 ) capacitor c=0.103534f //x=20.54 //y=2.095
c497 ( 165 0 ) capacitor c=0.0229444f //x=20.54 //y=1.71
c498 ( 164 0 ) capacitor c=0.0234359f //x=20.54 //y=1.4
c499 ( 163 0 ) capacitor c=0.019815f //x=20.54 //y=1.055
c500 ( 162 0 ) capacitor c=0.0443175f //x=4.34 //y=1.44
c501 ( 161 0 ) capacitor c=0.0199703f //x=4.34 //y=1.095
c502 ( 158 0 ) capacitor c=0.0162526f //x=4.185 //y=1.595
c503 ( 156 0 ) capacitor c=0.0157807f //x=4.185 //y=0.94
c504 ( 151 0 ) capacitor c=0.0220935f //x=3.81 //y=1.75
c505 ( 150 0 ) capacitor c=0.0207489f //x=3.81 //y=1.44
c506 ( 149 0 ) capacitor c=0.0194091f //x=3.81 //y=1.095
c507 ( 145 0 ) capacitor c=0.110208f //x=21.48 //y=6.2
c508 ( 144 0 ) capacitor c=0.158957f //x=21.04 //y=6.2
c509 ( 143 0 ) capacitor c=0.159671f //x=4 //y=6.2
c510 ( 142 0 ) capacitor c=0.110208f //x=3.56 //y=6.2
c511 ( 136 0 ) capacitor c=0.0014751f //x=20.84 //y=4.88
c512 ( 127 0 ) capacitor c=0.0012618f //x=20.84 //y=2.26
c513 ( 110 0 ) capacitor c=0.0293013f //x=8.59 //y=5.56
c514 ( 102 0 ) capacitor c=0.029137f //x=7.71 //y=5.56
c515 ( 94 0 ) capacitor c=0.0278099f //x=6.83 //y=5.56
c516 ( 89 0 ) capacitor c=7.7417e-19 //x=3.82 //y=4.88
c517 ( 80 0 ) capacitor c=0.00101179f //x=3.82 //y=2.26
c518 ( 70 0 ) capacitor c=0.0318509f //x=19.205 //y=3.86
c519 ( 68 0 ) capacitor c=0.0173629f //x=18.605 //y=3.88
c520 ( 66 0 ) capacitor c=0.00423268f //x=17.36 //y=3.89
c521 ( 64 0 ) capacitor c=0.0337429f //x=16.755 //y=3.88
c522 ( 63 0 ) capacitor c=0.0442834f //x=13.225 //y=3.865
c523 ( 62 0 ) capacitor c=0.00495606f //x=13.655 //y=3.865
c524 ( 60 0 ) capacitor c=0.00249254f //x=8.835 //y=3.87
c525 ( 58 0 ) capacitor c=0.00660213f //x=8.235 //y=3.88
c526 ( 56 0 ) capacitor c=0.00353382f //x=7.735 //y=3.9
c527 ( 55 0 ) capacitor c=0.00333427f //x=3.98 //y=3.88
c528 ( 54 0 ) capacitor c=0.055533f //x=7.135 //y=3.88
c529 ( 48 0 ) capacitor c=0.0168323f //x=20.835 //y=3.88
c530 ( 44 0 ) capacitor c=0.0158086f //x=9.37 //y=3.88
c531 ( 38 0 ) capacitor c=8.0019e-19 //x=8.59 //y=5.335
c532 ( 35 0 ) capacitor c=0.00710957f //x=7.71 //y=5.335
c533 ( 32 0 ) capacitor c=0.0111234f //x=6.832 //y=5.335
c534 ( 30 0 ) capacitor c=0.0147319f //x=3.82 //y=3.88
c535 ( 24 0 ) capacitor c=0.0250594f //x=20.84 //y=4.755
c536 ( 23 0 ) capacitor c=0.0138225f //x=20.84 //y=4.04
c537 ( 22 0 ) capacitor c=0.0479975f //x=20.84 //y=3.72
c538 ( 21 0 ) capacitor c=0.00670383f //x=20.84 //y=2.375
c539 ( 20 0 ) capacitor c=0.0313869f //x=9.37 //y=5.25
c540 ( 19 0 ) capacitor c=0.0139814f //x=9.37 //y=4.045
c541 ( 18 0 ) capacitor c=0.0487392f //x=9.37 //y=3.725
c542 ( 16 0 ) capacitor c=0.00588337f //x=8.97 //y=1.845
c543 ( 15 0 ) capacitor c=0.0157922f //x=9.285 //y=1.845
c544 ( 14 0 ) capacitor c=0.0167992f //x=8.885 //y=1.76
c545 ( 13 0 ) capacitor c=0.0113528f //x=8.885 //y=1.305
c546 ( 11 0 ) capacitor c=0.0224425f //x=9.285 //y=5.335
c547 ( 10 0 ) capacitor c=0.00933983f //x=8.59 //y=5.56
c548 ( 7 0 ) capacitor c=0.0194516f //x=8.475 //y=5.335
c549 ( 5 0 ) capacitor c=0.0150788f //x=7.59 //y=5.335
c550 ( 4 0 ) capacitor c=0.0217407f //x=3.82 //y=4.75
c551 ( 3 0 ) capacitor c=0.0111063f //x=3.82 //y=4.04
c552 ( 2 0 ) capacitor c=0.0367665f //x=3.82 //y=3.72
c553 ( 1 0 ) capacitor c=0.00696542f //x=3.82 //y=2.375
r554 (  183 184 ) resistor r=52.7279 //w=0.214 //l=0.165 //layer=ply \
 //thickness=0.18 //x=3.82 //y=2.26 //x2=3.82 //y2=2.095
r555 (  177 179 ) resistor r=26.9307 //w=0.15 //l=0.106066 //layer=ply \
 //thickness=0.18 //x=21.405 //y=4.97 //x2=21.48 //y2=5.045
r556 (  177 178 ) resistor r=148.702 //w=0.094 //l=0.29 //layer=ply \
 //thickness=0.18 //x=21.405 //y=4.97 //x2=21.115 //y2=4.97
r557 (  176 199 ) resistor r=45.1352 //w=0.168 //l=0.173853 //layer=ply \
 //thickness=0.18 //x=21.07 //y=1.4 //x2=21.03 //y2=1.555
r558 (  175 198 ) resistor r=45.1352 //w=0.168 //l=0.173853 //layer=ply \
 //thickness=0.18 //x=21.07 //y=1.055 //x2=21.03 //y2=0.9
r559 (  175 176 ) resistor r=176.904 //w=0.094 //l=0.345 //layer=ply \
 //thickness=0.18 //x=21.07 //y=1.055 //x2=21.07 //y2=1.4
r560 (  172 178 ) resistor r=22.7971 //w=0.269 //l=0.106066 //layer=ply \
 //thickness=0.18 //x=21.04 //y=5.045 //x2=21.115 //y2=4.97
r561 (  172 197 ) resistor r=35.8364 //w=0.269 //l=0.270185 //layer=ply \
 //thickness=0.18 //x=21.04 //y=5.045 //x2=20.84 //y2=4.88
r562 (  170 193 ) resistor r=10.701 //w=0.21 //l=0.115 //layer=ply \
 //thickness=0.18 //x=20.695 //y=1.555 //x2=20.58 //y2=1.555
r563 (  169 199 ) resistor r=5.52526 //w=0.168 //l=0.115 //layer=ply \
 //thickness=0.18 //x=20.915 //y=1.555 //x2=21.03 //y2=1.555
r564 (  168 192 ) resistor r=5.52526 //w=0.168 //l=0.115 //layer=ply \
 //thickness=0.18 //x=20.695 //y=0.9 //x2=20.58 //y2=0.9
r565 (  167 198 ) resistor r=5.52526 //w=0.168 //l=0.115 //layer=ply \
 //thickness=0.18 //x=20.915 //y=0.9 //x2=21.03 //y2=0.9
r566 (  167 168 ) resistor r=112.809 //w=0.094 //l=0.22 //layer=ply \
 //thickness=0.18 //x=20.915 //y=0.9 //x2=20.695 //y2=0.9
r567 (  166 195 ) resistor r=58.7805 //w=0.246 //l=0.373497 //layer=ply \
 //thickness=0.18 //x=20.54 //y=2.095 //x2=20.84 //y2=2.26
r568 (  165 193 ) resistor r=39.5823 //w=0.21 //l=0.173853 //layer=ply \
 //thickness=0.18 //x=20.54 //y=1.71 //x2=20.58 //y2=1.555
r569 (  165 166 ) resistor r=197.415 //w=0.094 //l=0.385 //layer=ply \
 //thickness=0.18 //x=20.54 //y=1.71 //x2=20.54 //y2=2.095
r570 (  164 193 ) resistor r=39.5823 //w=0.21 //l=0.173853 //layer=ply \
 //thickness=0.18 //x=20.54 //y=1.4 //x2=20.58 //y2=1.555
r571 (  163 192 ) resistor r=45.1352 //w=0.168 //l=0.173853 //layer=ply \
 //thickness=0.18 //x=20.54 //y=1.055 //x2=20.58 //y2=0.9
r572 (  163 164 ) resistor r=176.904 //w=0.094 //l=0.345 //layer=ply \
 //thickness=0.18 //x=20.54 //y=1.055 //x2=20.54 //y2=1.4
r573 (  162 191 ) resistor r=45.1352 //w=0.168 //l=0.173853 //layer=ply \
 //thickness=0.18 //x=4.34 //y=1.44 //x2=4.3 //y2=1.595
r574 (  161 190 ) resistor r=45.1352 //w=0.168 //l=0.173853 //layer=ply \
 //thickness=0.18 //x=4.34 //y=1.095 //x2=4.3 //y2=0.94
r575 (  161 162 ) resistor r=176.904 //w=0.094 //l=0.345 //layer=ply \
 //thickness=0.18 //x=4.34 //y=1.095 //x2=4.34 //y2=1.44
r576 (  159 187 ) resistor r=10.701 //w=0.21 //l=0.115 //layer=ply \
 //thickness=0.18 //x=3.965 //y=1.595 //x2=3.85 //y2=1.595
r577 (  158 191 ) resistor r=5.52526 //w=0.168 //l=0.115 //layer=ply \
 //thickness=0.18 //x=4.185 //y=1.595 //x2=4.3 //y2=1.595
r578 (  157 186 ) resistor r=5.52526 //w=0.168 //l=0.115 //layer=ply \
 //thickness=0.18 //x=3.965 //y=0.94 //x2=3.85 //y2=0.94
r579 (  156 190 ) resistor r=5.52526 //w=0.168 //l=0.115 //layer=ply \
 //thickness=0.18 //x=4.185 //y=0.94 //x2=4.3 //y2=0.94
r580 (  156 157 ) resistor r=112.809 //w=0.094 //l=0.22 //layer=ply \
 //thickness=0.18 //x=4.185 //y=0.94 //x2=3.965 //y2=0.94
r581 (  153 189 ) resistor r=37.236 //w=0.233 //l=0.249199 //layer=ply \
 //thickness=0.18 //x=4 //y=5.045 //x2=3.82 //y2=4.88
r582 (  151 187 ) resistor r=39.5823 //w=0.21 //l=0.173853 //layer=ply \
 //thickness=0.18 //x=3.81 //y=1.75 //x2=3.85 //y2=1.595
r583 (  151 184 ) resistor r=176.904 //w=0.094 //l=0.345 //layer=ply \
 //thickness=0.18 //x=3.81 //y=1.75 //x2=3.81 //y2=2.095
r584 (  150 187 ) resistor r=39.5823 //w=0.21 //l=0.173853 //layer=ply \
 //thickness=0.18 //x=3.81 //y=1.44 //x2=3.85 //y2=1.595
r585 (  149 186 ) resistor r=45.1352 //w=0.168 //l=0.173853 //layer=ply \
 //thickness=0.18 //x=3.81 //y=1.095 //x2=3.85 //y2=0.94
r586 (  149 150 ) resistor r=176.904 //w=0.094 //l=0.345 //layer=ply \
 //thickness=0.18 //x=3.81 //y=1.095 //x2=3.81 //y2=1.44
r587 (  146 189 ) resistor r=53.7854 //w=0.233 //l=0.332415 //layer=ply \
 //thickness=0.18 //x=3.56 //y=5.045 //x2=3.82 //y2=4.88
r588 (  145 179 ) resistor r=592.245 //w=0.094 //l=1.155 //layer=ply \
 //thickness=0.18 //x=21.48 //y=6.2 //x2=21.48 //y2=5.045
r589 (  144 172 ) resistor r=592.245 //w=0.094 //l=1.155 //layer=ply \
 //thickness=0.18 //x=21.04 //y=6.2 //x2=21.04 //y2=5.045
r590 (  143 153 ) resistor r=592.245 //w=0.094 //l=1.155 //layer=ply \
 //thickness=0.18 //x=4 //y=6.2 //x2=4 //y2=5.045
r591 (  142 146 ) resistor r=592.245 //w=0.094 //l=1.155 //layer=ply \
 //thickness=0.18 //x=3.56 //y=6.2 //x2=3.56 //y2=5.045
r592 (  141 169 ) resistor r=56.4043 //w=0.094 //l=0.11 //layer=ply \
 //thickness=0.18 //x=20.805 //y=1.555 //x2=20.915 //y2=1.555
r593 (  141 170 ) resistor r=56.4043 //w=0.094 //l=0.11 //layer=ply \
 //thickness=0.18 //x=20.805 //y=1.555 //x2=20.695 //y2=1.555
r594 (  140 158 ) resistor r=56.4043 //w=0.094 //l=0.11 //layer=ply \
 //thickness=0.18 //x=4.075 //y=1.595 //x2=4.185 //y2=1.595
r595 (  140 159 ) resistor r=56.4043 //w=0.094 //l=0.11 //layer=ply \
 //thickness=0.18 //x=4.075 //y=1.595 //x2=3.965 //y2=1.595
r596 (  136 197 ) resistor r=152 //w=0.17 //l=0.17 //layer=licon //count=1 \
 //x=20.84 //y=4.88 //x2=20.84 //y2=4.88
r597 (  127 195 ) resistor r=152 //w=0.17 //l=0.17 //layer=licon //count=1 \
 //x=20.84 //y=2.26 //x2=20.84 //y2=2.26
r598 (  110 204 ) resistor r=23.615 //w=0.187 //l=0.345 //layer=li \
 //thickness=0.1 //x=8.59 //y=5.56 //x2=8.59 //y2=5.905
r599 (  102 203 ) resistor r=23.615 //w=0.187 //l=0.345 //layer=li \
 //thickness=0.1 //x=7.71 //y=5.56 //x2=7.71 //y2=5.905
r600 (  94 202 ) resistor r=23.615 //w=0.187 //l=0.345 //layer=li \
 //thickness=0.1 //x=6.83 //y=5.56 //x2=6.83 //y2=5.905
r601 (  89 189 ) resistor r=152 //w=0.17 //l=0.17 //layer=licon //count=1 \
 //x=3.82 //y=4.88 //x2=3.82 //y2=4.88
r602 (  80 183 ) resistor r=152 //w=0.17 //l=0.17 //layer=licon //count=1 \
 //x=3.82 //y=2.26 //x2=3.82 //y2=2.26
r603 (  70 78 ) resistor r=1.03696 //w=0.197 //l=1.63997 //layer=m2 \
 //thickness=0.36 //x=19.205 //y=3.86 //x2=20.835 //y2=3.88
r604 (  70 71 ) resistor r=0.410305 //w=0.131 //l=0.43 //layer=m2 \
 //thickness=0.36 //x=19.205 //y=3.86 //x2=18.775 //y2=3.86
r605 (  68 71 ) resistor r=0.125 //w=0.17 //l=0.179722 //layer=m2 \
 //thickness=0.36 //x=18.605 //y=3.88 //x2=18.775 //y2=3.86
r606 (  68 69 ) resistor r=1.02576 //w=0.131 //l=1.075 //layer=m2 \
 //thickness=0.36 //x=18.605 //y=3.88 //x2=17.53 //y2=3.88
r607 (  66 69 ) resistor r=0.125 //w=0.17 //l=0.174929 //layer=m2 \
 //thickness=0.36 //x=17.36 //y=3.89 //x2=17.53 //y2=3.88
r608 (  66 67 ) resistor r=0.333969 //w=0.131 //l=0.35 //layer=m2 \
 //thickness=0.36 //x=17.36 //y=3.89 //x2=17.01 //y2=3.89
r609 (  64 67 ) resistor r=0.1875 //w=0.17 //l=0.259952 //layer=m2 \
 //thickness=0.36 //x=16.755 //y=3.88 //x2=17.01 //y2=3.89
r610 (  64 65 ) resistor r=2.71469 //w=0.131 //l=2.845 //layer=m2 \
 //thickness=0.36 //x=16.755 //y=3.88 //x2=13.91 //y2=3.88
r611 (  63 76 ) resistor r=2.66982 //w=0.181 //l=3.87499 //layer=m2 \
 //thickness=0.36 //x=13.225 //y=3.865 //x2=9.36 //y2=3.885
r612 (  62 65 ) resistor r=0.1875 //w=0.17 //l=0.262393 //layer=m2 \
 //thickness=0.36 //x=13.655 //y=3.865 //x2=13.91 //y2=3.88
r613 (  62 63 ) resistor r=0.410305 //w=0.131 //l=0.43 //layer=m2 \
 //thickness=0.36 //x=13.655 //y=3.865 //x2=13.225 //y2=3.865
r614 (  60 76 ) resistor r=0.363189 //w=0.181 //l=0.532447 //layer=m2 \
 //thickness=0.36 //x=8.835 //y=3.87 //x2=9.36 //y2=3.885
r615 (  60 61 ) resistor r=0.410305 //w=0.131 //l=0.43 //layer=m2 \
 //thickness=0.36 //x=8.835 //y=3.87 //x2=8.405 //y2=3.87
r616 (  58 61 ) resistor r=0.125 //w=0.17 //l=0.174929 //layer=m2 \
 //thickness=0.36 //x=8.235 //y=3.88 //x2=8.405 //y2=3.87
r617 (  58 59 ) resistor r=0.314885 //w=0.131 //l=0.33 //layer=m2 \
 //thickness=0.36 //x=8.235 //y=3.88 //x2=7.905 //y2=3.88
r618 (  56 59 ) resistor r=0.125 //w=0.17 //l=0.179722 //layer=m2 \
 //thickness=0.36 //x=7.735 //y=3.9 //x2=7.905 //y2=3.88
r619 (  56 57 ) resistor r=0.329198 //w=0.131 //l=0.345 //layer=m2 \
 //thickness=0.36 //x=7.735 //y=3.9 //x2=7.39 //y2=3.9
r620 (  55 73 ) resistor r=0.10734 //w=0.281 //l=0.16 //layer=m2 \
 //thickness=0.36 //x=3.98 //y=3.88 //x2=3.82 //y2=3.88
r621 (  54 57 ) resistor r=0.1875 //w=0.17 //l=0.264811 //layer=m2 \
 //thickness=0.36 //x=7.135 //y=3.88 //x2=7.39 //y2=3.9
r622 (  54 55 ) resistor r=3.0105 //w=0.131 //l=3.155 //layer=m2 \
 //thickness=0.36 //x=7.135 //y=3.88 //x2=3.98 //y2=3.88
r623 (  53 136 ) resistor r=9.3 //w=0.17 //l=0.17 //layer=mcon //count=1 \
 //x=20.84 //y=4.88 //x2=20.84 //y2=4.88
r624 (  51 127 ) resistor r=9.3 //w=0.17 //l=0.17 //layer=mcon //count=1 \
 //x=20.84 //y=2.26 //x2=20.84 //y2=2.26
r625 (  48 78 ) resistor r=4.5 //w=0.15 //l=0.15 //layer=via1 //count=1 \
 //x=20.835 //y=3.88 //x2=20.835 //y2=3.88
r626 (  46 76 ) resistor r=4.5 //w=0.15 //l=0.15 //layer=via1 //count=1 \
 //x=9.36 //y=3.885 //x2=9.36 //y2=3.885
r627 (  44 46 ) resistor r=0.00163613 //w=0.382 //l=0.005 //layer=m1 \
 //thickness=0.36 //x=9.417 //y=3.88 //x2=9.417 //y2=3.885
r628 (  42 200 ) resistor r=9.3 //w=0.17 //l=0.17 //layer=mcon //count=1 \
 //x=8.885 //y=1.19 //x2=8.885 //y2=1.19
r629 (  40 110 ) resistor r=9.3 //w=0.17 //l=0.17 //layer=mcon //count=1 \
 //x=8.59 //y=5.56 //x2=8.59 //y2=5.56
r630 (  37 102 ) resistor r=9.3 //w=0.17 //l=0.17 //layer=mcon //count=1 \
 //x=7.71 //y=5.56 //x2=7.71 //y2=5.56
r631 (  35 37 ) resistor r=0.121228 //w=0.232 //l=0.225 //layer=m1 \
 //thickness=0.36 //x=7.71 //y=5.335 //x2=7.71 //y2=5.56
r632 (  34 94 ) resistor r=9.3 //w=0.17 //l=0.17 //layer=mcon //count=1 \
 //x=6.83 //y=5.56 //x2=6.83 //y2=5.56
r633 (  32 34 ) resistor r=0.129608 //w=0.217 //l=0.225 //layer=m1 \
 //thickness=0.36 //x=6.832 //y=5.335 //x2=6.832 //y2=5.56
r634 (  30 73 ) resistor r=4.5 //w=0.15 //l=0.15 //layer=via1 //count=1 \
 //x=3.82 //y=3.88 //x2=3.82 //y2=3.88
r635 (  28 89 ) resistor r=9.3 //w=0.17 //l=0.17 //layer=mcon //count=1 \
 //x=3.82 //y=4.88 //x2=3.82 //y2=4.88
r636 (  26 80 ) resistor r=9.3 //w=0.17 //l=0.17 //layer=mcon //count=1 \
 //x=3.82 //y=2.26 //x2=3.82 //y2=2.26
r637 (  24 53 ) resistor r=0.0760407 //w=0.238 //l=0.125 //layer=m1 \
 //thickness=0.36 //x=20.84 //y=4.755 //x2=20.84 //y2=4.88
r638 (  23 48 ) resistor r=0.0910802 //w=0.374 //l=0.185472 //layer=m1 \
 //thickness=0.36 //x=20.84 //y=4.04 //x2=20.785 //y2=3.88
r639 (  23 24 ) resistor r=0.682252 //w=0.131 //l=0.715 //layer=m1 \
 //thickness=0.36 //x=20.84 //y=4.04 //x2=20.84 //y2=4.755
r640 (  22 48 ) resistor r=0.0910802 //w=0.374 //l=0.185472 //layer=m1 \
 //thickness=0.36 //x=20.84 //y=3.72 //x2=20.785 //y2=3.88
r641 (  21 51 ) resistor r=0.0719237 //w=0.222 //l=0.115 //layer=m1 \
 //thickness=0.36 //x=20.84 //y=2.375 //x2=20.84 //y2=2.26
r642 (  21 22 ) resistor r=1.2834 //w=0.131 //l=1.345 //layer=m1 \
 //thickness=0.36 //x=20.84 //y=2.375 //x2=20.84 //y2=3.72
r643 (  19 46 ) resistor r=0.0914072 //w=0.382 //l=0.181989 //layer=m1 \
 //thickness=0.36 //x=9.37 //y=4.045 //x2=9.417 //y2=3.885
r644 (  19 20 ) resistor r=1.14981 //w=0.131 //l=1.205 //layer=m1 \
 //thickness=0.36 //x=9.37 //y=4.045 //x2=9.37 //y2=5.25
r645 (  18 44 ) resistor r=0.0897711 //w=0.382 //l=0.176946 //layer=m1 \
 //thickness=0.36 //x=9.37 //y=3.725 //x2=9.417 //y2=3.88
r646 (  17 18 ) resistor r=1.71279 //w=0.131 //l=1.795 //layer=m1 \
 //thickness=0.36 //x=9.37 //y=1.93 //x2=9.37 //y2=3.725
r647 (  15 17 ) resistor r=0.0698411 //w=0.17 //l=0.120208 //layer=m1 \
 //thickness=0.36 //x=9.285 //y=1.845 //x2=9.37 //y2=1.93
r648 (  15 16 ) resistor r=0.300573 //w=0.131 //l=0.315 //layer=m1 \
 //thickness=0.36 //x=9.285 //y=1.845 //x2=8.97 //y2=1.845
r649 (  14 16 ) resistor r=0.0698411 //w=0.17 //l=0.120208 //layer=m1 \
 //thickness=0.36 //x=8.885 //y=1.76 //x2=8.97 //y2=1.845
r650 (  13 42 ) resistor r=0.0717383 //w=0.224 //l=0.115 //layer=m1 \
 //thickness=0.36 //x=8.885 //y=1.305 //x2=8.885 //y2=1.19
r651 (  13 14 ) resistor r=0.43416 //w=0.131 //l=0.455 //layer=m1 \
 //thickness=0.36 //x=8.885 //y=1.305 //x2=8.885 //y2=1.76
r652 (  12 38 ) resistor r=0.0675342 //w=0.23 //l=0.115 //layer=m1 \
 //thickness=0.36 //x=8.705 //y=5.335 //x2=8.59 //y2=5.335
r653 (  11 20 ) resistor r=0.0698411 //w=0.17 //l=0.120208 //layer=m1 \
 //thickness=0.36 //x=9.285 //y=5.335 //x2=9.37 //y2=5.25
r654 (  11 12 ) resistor r=0.553435 //w=0.131 //l=0.58 //layer=m1 \
 //thickness=0.36 //x=9.285 //y=5.335 //x2=8.705 //y2=5.335
r655 (  10 40 ) resistor r=0.00118313 //w=0.23 //layer=m1 //thickness=0.36 \
 //x=8.59 //y=5.56 //x2=8.59 //y2=5.56
r656 (  9 38 ) resistor r=0.002872 //w=0.34 //l=0.085 //layer=m1 \
 //thickness=0.36 //x=8.59 //y=5.42 //x2=8.59 //y2=5.335
r657 (  9 10 ) resistor r=0.091623 //w=0.191 //l=0.14 //layer=m1 \
 //thickness=0.36 //x=8.59 //y=5.42 //x2=8.59 //y2=5.56
r658 (  8 35 ) resistor r=0.0262263 //w=0.232 //l=0.12 //layer=m1 \
 //thickness=0.36 //x=7.83 //y=5.335 //x2=7.71 //y2=5.335
r659 (  7 38 ) resistor r=0.0675342 //w=0.23 //l=0.115 //layer=m1 \
 //thickness=0.36 //x=8.475 //y=5.335 //x2=8.59 //y2=5.335
r660 (  7 8 ) resistor r=0.615458 //w=0.131 //l=0.645 //layer=m1 \
 //thickness=0.36 //x=8.475 //y=5.335 //x2=7.83 //y2=5.335
r661 (  6 32 ) resistor r=0.0222262 //w=0.217 //l=0.118 //layer=m1 \
 //thickness=0.36 //x=6.95 //y=5.335 //x2=6.832 //y2=5.335
r662 (  5 35 ) resistor r=0.0262263 //w=0.232 //l=0.12 //layer=m1 \
 //thickness=0.36 //x=7.59 //y=5.335 //x2=7.71 //y2=5.335
r663 (  5 6 ) resistor r=0.610687 //w=0.131 //l=0.64 //layer=m1 \
 //thickness=0.36 //x=7.59 //y=5.335 //x2=6.95 //y2=5.335
r664 (  4 28 ) resistor r=0.0801089 //w=0.224 //l=0.13 //layer=m1 \
 //thickness=0.36 //x=3.82 //y=4.75 //x2=3.82 //y2=4.88
r665 (  3 30 ) resistor r=0.0911593 //w=0.376 //l=0.184174 //layer=m1 \
 //thickness=0.36 //x=3.82 //y=4.04 //x2=3.872 //y2=3.88
r666 (  3 4 ) resistor r=0.677481 //w=0.131 //l=0.71 //layer=m1 \
 //thickness=0.36 //x=3.82 //y=4.04 //x2=3.82 //y2=4.75
r667 (  2 30 ) resistor r=0.0911593 //w=0.376 //l=0.184174 //layer=m1 \
 //thickness=0.36 //x=3.82 //y=3.72 //x2=3.872 //y2=3.88
r668 (  1 26 ) resistor r=0.0719237 //w=0.222 //l=0.115 //layer=m1 \
 //thickness=0.36 //x=3.82 //y=2.375 //x2=3.82 //y2=2.26
r669 (  1 2 ) resistor r=1.2834 //w=0.131 //l=1.345 //layer=m1 \
 //thickness=0.36 //x=3.82 //y=2.375 //x2=3.82 //y2=3.72
ends PM_DFFSNRNQNX1\%noxref_4

subckt PM_DFFSNRNQNX1\%RN ( 1 2 3 4 5 6 7 8 9 10 11 12 13 14 21 25 34 41 50 52 \
 54 56 58 59 63 69 74 79 84 89 94 98 99 100 101 102 103 104 105 106 107 108 \
 109 111 117 118 119 120 121 129 130 131 136 138 141 142 143 144 145 147 153 \
 154 155 156 157 165 174 175 180 186 )
c436 ( 186 0 ) capacitor c=0.0358165f //x=21.95 //y=4.88
c437 ( 180 0 ) capacitor c=0.0679418f //x=18.25 //y=4.88
c438 ( 175 0 ) capacitor c=0.0278202f //x=18.25 //y=2.095
c439 ( 174 0 ) capacitor c=0.0503043f //x=18.25 //y=2.26
c440 ( 165 0 ) capacitor c=0.0354006f //x=2.71 //y=4.88
c441 ( 157 0 ) capacitor c=0.0306608f //x=22.285 //y=4.97
c442 ( 156 0 ) capacitor c=0.0863671f //x=22.04 //y=2.095
c443 ( 155 0 ) capacitor c=0.0170266f //x=22.04 //y=1.63
c444 ( 154 0 ) capacitor c=0.018609f //x=22.04 //y=1.4
c445 ( 153 0 ) capacitor c=0.0186599f //x=22.04 //y=1.09
c446 ( 147 0 ) capacitor c=0.0146988f //x=21.885 //y=1.555
c447 ( 145 0 ) capacitor c=0.0148531f //x=21.885 //y=0.935
c448 ( 144 0 ) capacitor c=0.0334406f //x=21.515 //y=1.4
c449 ( 143 0 ) capacitor c=0.0173191f //x=21.515 //y=1.09
c450 ( 142 0 ) capacitor c=0.0443175f //x=18.77 //y=1.44
c451 ( 141 0 ) capacitor c=0.0199703f //x=18.77 //y=1.095
c452 ( 138 0 ) capacitor c=0.0162526f //x=18.615 //y=1.595
c453 ( 136 0 ) capacitor c=0.0157807f //x=18.615 //y=0.94
c454 ( 131 0 ) capacitor c=0.0220935f //x=18.24 //y=1.75
c455 ( 130 0 ) capacitor c=0.0207489f //x=18.24 //y=1.44
c456 ( 129 0 ) capacitor c=0.0194091f //x=18.24 //y=1.095
c457 ( 121 0 ) capacitor c=0.0306261f //x=3.045 //y=4.97
c458 ( 120 0 ) capacitor c=0.0863671f //x=2.8 //y=2.095
c459 ( 119 0 ) capacitor c=0.0170266f //x=2.8 //y=1.63
c460 ( 118 0 ) capacitor c=0.018609f //x=2.8 //y=1.4
c461 ( 117 0 ) capacitor c=0.0186599f //x=2.8 //y=1.09
c462 ( 111 0 ) capacitor c=0.0146988f //x=2.645 //y=1.555
c463 ( 109 0 ) capacitor c=0.0148531f //x=2.645 //y=0.935
c464 ( 108 0 ) capacitor c=0.0334406f //x=2.275 //y=1.4
c465 ( 107 0 ) capacitor c=0.0173191f //x=2.275 //y=1.09
c466 ( 106 0 ) capacitor c=0.110208f //x=22.36 //y=6.2
c467 ( 105 0 ) capacitor c=0.110214f //x=21.92 //y=6.2
c468 ( 104 0 ) capacitor c=0.159671f //x=18.43 //y=6.2
c469 ( 103 0 ) capacitor c=0.110208f //x=17.99 //y=6.2
c470 ( 102 0 ) capacitor c=0.110208f //x=3.12 //y=6.2
c471 ( 101 0 ) capacitor c=0.110214f //x=2.68 //y=6.2
c472 ( 94 0 ) capacitor c=0.00129935f //x=21.95 //y=4.88
c473 ( 89 0 ) capacitor c=0.00121786f //x=21.95 //y=2.26
c474 ( 84 0 ) capacitor c=7.7417e-19 //x=18.25 //y=4.88
c475 ( 79 0 ) capacitor c=0.00101179f //x=18.25 //y=2.26
c476 ( 74 0 ) capacitor c=0.00129935f //x=2.71 //y=4.88
c477 ( 69 0 ) capacitor c=0.00121786f //x=2.71 //y=2.26
c478 ( 63 0 ) capacitor c=0.00715713f //x=2.87 //y=4.635
c479 ( 59 0 ) capacitor c=0.128504f //x=18.86 //y=4.63
c480 ( 58 0 ) capacitor c=0.0875088f //x=19.205 //y=4.63
c481 ( 56 0 ) capacitor c=0.00549429f //x=13.655 //y=4.635
c482 ( 54 0 ) capacitor c=0.109089f //x=13.055 //y=4.62
c483 ( 52 0 ) capacitor c=0.00908907f //x=8.835 //y=4.64
c484 ( 50 0 ) capacitor c=0.171059f //x=8.235 //y=4.62
c485 ( 41 0 ) capacitor c=0.0105683f //x=18.245 //y=4.725
c486 ( 34 0 ) capacitor c=0.0131101f //x=2.71 //y=4.635
c487 ( 25 0 ) capacitor c=0.00562082f //x=21.95 //y=2.375
c488 ( 21 0 ) capacitor c=0.0072009f //x=18.25 //y=2.375
c489 ( 14 0 ) capacitor c=0.00559325f //x=2.71 //y=2.375
c490 ( 13 0 ) capacitor c=0.0105311f //x=21.95 //y=4.88
c491 ( 8 0 ) capacitor c=0.0614093f //x=21.95 //y=3.14
c492 ( 6 0 ) capacitor c=0.0540555f //x=18.25 //y=3.14
c493 ( 1 0 ) capacitor c=0.0660066f //x=2.71 //y=2.77
r494 (  188 189 ) resistor r=32.4568 //w=0.214 //l=0.075 //layer=ply \
 //thickness=0.18 //x=21.95 //y=4.97 //x2=21.95 //y2=5.045
r495 (  186 188 ) resistor r=20.271 //w=0.214 //l=0.09 //layer=ply \
 //thickness=0.18 //x=21.95 //y=4.88 //x2=21.95 //y2=4.97
r496 (  174 175 ) resistor r=52.7279 //w=0.214 //l=0.165 //layer=ply \
 //thickness=0.18 //x=18.25 //y=2.26 //x2=18.25 //y2=2.095
r497 (  167 168 ) resistor r=32.4568 //w=0.214 //l=0.075 //layer=ply \
 //thickness=0.18 //x=2.71 //y=4.97 //x2=2.71 //y2=5.045
r498 (  165 167 ) resistor r=20.271 //w=0.214 //l=0.09 //layer=ply \
 //thickness=0.18 //x=2.71 //y=4.88 //x2=2.71 //y2=4.97
r499 (  158 188 ) resistor r=16.5046 //w=0.27 //l=0.135 //layer=ply \
 //thickness=0.18 //x=22.085 //y=4.97 //x2=21.95 //y2=4.97
r500 (  157 159 ) resistor r=26.9307 //w=0.15 //l=0.106066 //layer=ply \
 //thickness=0.18 //x=22.285 //y=4.97 //x2=22.36 //y2=5.045
r501 (  157 158 ) resistor r=102.553 //w=0.094 //l=0.2 //layer=ply \
 //thickness=0.18 //x=22.285 //y=4.97 //x2=22.085 //y2=4.97
r502 (  156 193 ) resistor r=38.6777 //w=0.284 //l=0.198997 //layer=ply \
 //thickness=0.18 //x=22.04 //y=2.095 //x2=21.965 //y2=2.26
r503 (  155 191 ) resistor r=21.2976 //w=0.217 //l=0.0928709 //layer=ply \
 //thickness=0.18 //x=22.04 //y=1.63 //x2=22 //y2=1.555
r504 (  155 156 ) resistor r=238.436 //w=0.094 //l=0.465 //layer=ply \
 //thickness=0.18 //x=22.04 //y=1.63 //x2=22.04 //y2=2.095
r505 (  154 191 ) resistor r=39.0671 //w=0.217 //l=0.173853 //layer=ply \
 //thickness=0.18 //x=22.04 //y=1.4 //x2=22 //y2=1.555
r506 (  153 190 ) resistor r=45.1352 //w=0.168 //l=0.173853 //layer=ply \
 //thickness=0.18 //x=22.04 //y=1.09 //x2=22 //y2=0.935
r507 (  153 154 ) resistor r=158.957 //w=0.094 //l=0.31 //layer=ply \
 //thickness=0.18 //x=22.04 //y=1.09 //x2=22.04 //y2=1.4
r508 (  148 184 ) resistor r=5.52526 //w=0.168 //l=0.115 //layer=ply \
 //thickness=0.18 //x=21.67 //y=1.555 //x2=21.555 //y2=1.555
r509 (  147 191 ) resistor r=11.4558 //w=0.217 //l=0.115 //layer=ply \
 //thickness=0.18 //x=21.885 //y=1.555 //x2=22 //y2=1.555
r510 (  146 183 ) resistor r=5.52526 //w=0.168 //l=0.115 //layer=ply \
 //thickness=0.18 //x=21.67 //y=0.935 //x2=21.555 //y2=0.935
r511 (  145 190 ) resistor r=5.52526 //w=0.168 //l=0.115 //layer=ply \
 //thickness=0.18 //x=21.885 //y=0.935 //x2=22 //y2=0.935
r512 (  145 146 ) resistor r=110.245 //w=0.094 //l=0.215 //layer=ply \
 //thickness=0.18 //x=21.885 //y=0.935 //x2=21.67 //y2=0.935
r513 (  144 184 ) resistor r=45.1352 //w=0.168 //l=0.173853 //layer=ply \
 //thickness=0.18 //x=21.515 //y=1.4 //x2=21.555 //y2=1.555
r514 (  143 183 ) resistor r=45.1352 //w=0.168 //l=0.173853 //layer=ply \
 //thickness=0.18 //x=21.515 //y=1.09 //x2=21.555 //y2=0.935
r515 (  143 144 ) resistor r=158.957 //w=0.094 //l=0.31 //layer=ply \
 //thickness=0.18 //x=21.515 //y=1.09 //x2=21.515 //y2=1.4
r516 (  142 182 ) resistor r=45.1352 //w=0.168 //l=0.173853 //layer=ply \
 //thickness=0.18 //x=18.77 //y=1.44 //x2=18.73 //y2=1.595
r517 (  141 181 ) resistor r=45.1352 //w=0.168 //l=0.173853 //layer=ply \
 //thickness=0.18 //x=18.77 //y=1.095 //x2=18.73 //y2=0.94
r518 (  141 142 ) resistor r=176.904 //w=0.094 //l=0.345 //layer=ply \
 //thickness=0.18 //x=18.77 //y=1.095 //x2=18.77 //y2=1.44
r519 (  139 178 ) resistor r=10.701 //w=0.21 //l=0.115 //layer=ply \
 //thickness=0.18 //x=18.395 //y=1.595 //x2=18.28 //y2=1.595
r520 (  138 182 ) resistor r=5.52526 //w=0.168 //l=0.115 //layer=ply \
 //thickness=0.18 //x=18.615 //y=1.595 //x2=18.73 //y2=1.595
r521 (  137 177 ) resistor r=5.52526 //w=0.168 //l=0.115 //layer=ply \
 //thickness=0.18 //x=18.395 //y=0.94 //x2=18.28 //y2=0.94
r522 (  136 181 ) resistor r=5.52526 //w=0.168 //l=0.115 //layer=ply \
 //thickness=0.18 //x=18.615 //y=0.94 //x2=18.73 //y2=0.94
r523 (  136 137 ) resistor r=112.809 //w=0.094 //l=0.22 //layer=ply \
 //thickness=0.18 //x=18.615 //y=0.94 //x2=18.395 //y2=0.94
r524 (  133 180 ) resistor r=37.236 //w=0.233 //l=0.249199 //layer=ply \
 //thickness=0.18 //x=18.43 //y=5.045 //x2=18.25 //y2=4.88
r525 (  131 178 ) resistor r=39.5823 //w=0.21 //l=0.173853 //layer=ply \
 //thickness=0.18 //x=18.24 //y=1.75 //x2=18.28 //y2=1.595
r526 (  131 175 ) resistor r=176.904 //w=0.094 //l=0.345 //layer=ply \
 //thickness=0.18 //x=18.24 //y=1.75 //x2=18.24 //y2=2.095
r527 (  130 178 ) resistor r=39.5823 //w=0.21 //l=0.173853 //layer=ply \
 //thickness=0.18 //x=18.24 //y=1.44 //x2=18.28 //y2=1.595
r528 (  129 177 ) resistor r=45.1352 //w=0.168 //l=0.173853 //layer=ply \
 //thickness=0.18 //x=18.24 //y=1.095 //x2=18.28 //y2=0.94
r529 (  129 130 ) resistor r=176.904 //w=0.094 //l=0.345 //layer=ply \
 //thickness=0.18 //x=18.24 //y=1.095 //x2=18.24 //y2=1.44
r530 (  126 180 ) resistor r=53.7854 //w=0.233 //l=0.332415 //layer=ply \
 //thickness=0.18 //x=17.99 //y=5.045 //x2=18.25 //y2=4.88
r531 (  122 167 ) resistor r=16.5046 //w=0.27 //l=0.135 //layer=ply \
 //thickness=0.18 //x=2.845 //y=4.97 //x2=2.71 //y2=4.97
r532 (  121 123 ) resistor r=26.9307 //w=0.15 //l=0.106066 //layer=ply \
 //thickness=0.18 //x=3.045 //y=4.97 //x2=3.12 //y2=5.045
r533 (  121 122 ) resistor r=102.553 //w=0.094 //l=0.2 //layer=ply \
 //thickness=0.18 //x=3.045 //y=4.97 //x2=2.845 //y2=4.97
r534 (  120 172 ) resistor r=38.6777 //w=0.284 //l=0.198997 //layer=ply \
 //thickness=0.18 //x=2.8 //y=2.095 //x2=2.725 //y2=2.26
r535 (  119 170 ) resistor r=21.2976 //w=0.217 //l=0.0928709 //layer=ply \
 //thickness=0.18 //x=2.8 //y=1.63 //x2=2.76 //y2=1.555
r536 (  119 120 ) resistor r=238.436 //w=0.094 //l=0.465 //layer=ply \
 //thickness=0.18 //x=2.8 //y=1.63 //x2=2.8 //y2=2.095
r537 (  118 170 ) resistor r=39.0671 //w=0.217 //l=0.173853 //layer=ply \
 //thickness=0.18 //x=2.8 //y=1.4 //x2=2.76 //y2=1.555
r538 (  117 169 ) resistor r=45.1352 //w=0.168 //l=0.173853 //layer=ply \
 //thickness=0.18 //x=2.8 //y=1.09 //x2=2.76 //y2=0.935
r539 (  117 118 ) resistor r=158.957 //w=0.094 //l=0.31 //layer=ply \
 //thickness=0.18 //x=2.8 //y=1.09 //x2=2.8 //y2=1.4
r540 (  112 163 ) resistor r=5.52526 //w=0.168 //l=0.115 //layer=ply \
 //thickness=0.18 //x=2.43 //y=1.555 //x2=2.315 //y2=1.555
r541 (  111 170 ) resistor r=11.4558 //w=0.217 //l=0.115 //layer=ply \
 //thickness=0.18 //x=2.645 //y=1.555 //x2=2.76 //y2=1.555
r542 (  110 162 ) resistor r=5.52526 //w=0.168 //l=0.115 //layer=ply \
 //thickness=0.18 //x=2.43 //y=0.935 //x2=2.315 //y2=0.935
r543 (  109 169 ) resistor r=5.52526 //w=0.168 //l=0.115 //layer=ply \
 //thickness=0.18 //x=2.645 //y=0.935 //x2=2.76 //y2=0.935
r544 (  109 110 ) resistor r=110.245 //w=0.094 //l=0.215 //layer=ply \
 //thickness=0.18 //x=2.645 //y=0.935 //x2=2.43 //y2=0.935
r545 (  108 163 ) resistor r=45.1352 //w=0.168 //l=0.173853 //layer=ply \
 //thickness=0.18 //x=2.275 //y=1.4 //x2=2.315 //y2=1.555
r546 (  107 162 ) resistor r=45.1352 //w=0.168 //l=0.173853 //layer=ply \
 //thickness=0.18 //x=2.275 //y=1.09 //x2=2.315 //y2=0.935
r547 (  107 108 ) resistor r=158.957 //w=0.094 //l=0.31 //layer=ply \
 //thickness=0.18 //x=2.275 //y=1.09 //x2=2.275 //y2=1.4
r548 (  106 159 ) resistor r=592.245 //w=0.094 //l=1.155 //layer=ply \
 //thickness=0.18 //x=22.36 //y=6.2 //x2=22.36 //y2=5.045
r549 (  105 189 ) resistor r=592.245 //w=0.094 //l=1.155 //layer=ply \
 //thickness=0.18 //x=21.92 //y=6.2 //x2=21.92 //y2=5.045
r550 (  104 133 ) resistor r=592.245 //w=0.094 //l=1.155 //layer=ply \
 //thickness=0.18 //x=18.43 //y=6.2 //x2=18.43 //y2=5.045
r551 (  103 126 ) resistor r=592.245 //w=0.094 //l=1.155 //layer=ply \
 //thickness=0.18 //x=17.99 //y=6.2 //x2=17.99 //y2=5.045
r552 (  102 123 ) resistor r=592.245 //w=0.094 //l=1.155 //layer=ply \
 //thickness=0.18 //x=3.12 //y=6.2 //x2=3.12 //y2=5.045
r553 (  101 168 ) resistor r=592.245 //w=0.094 //l=1.155 //layer=ply \
 //thickness=0.18 //x=2.68 //y=6.2 //x2=2.68 //y2=5.045
r554 (  100 147 ) resistor r=55.3787 //w=0.094 //l=0.108 //layer=ply \
 //thickness=0.18 //x=21.777 //y=1.555 //x2=21.885 //y2=1.555
r555 (  100 148 ) resistor r=54.866 //w=0.094 //l=0.107 //layer=ply \
 //thickness=0.18 //x=21.777 //y=1.555 //x2=21.67 //y2=1.555
r556 (  99 138 ) resistor r=56.4043 //w=0.094 //l=0.11 //layer=ply \
 //thickness=0.18 //x=18.505 //y=1.595 //x2=18.615 //y2=1.595
r557 (  99 139 ) resistor r=56.4043 //w=0.094 //l=0.11 //layer=ply \
 //thickness=0.18 //x=18.505 //y=1.595 //x2=18.395 //y2=1.595
r558 (  98 111 ) resistor r=55.3787 //w=0.094 //l=0.108 //layer=ply \
 //thickness=0.18 //x=2.537 //y=1.555 //x2=2.645 //y2=1.555
r559 (  98 112 ) resistor r=54.866 //w=0.094 //l=0.107 //layer=ply \
 //thickness=0.18 //x=2.537 //y=1.555 //x2=2.43 //y2=1.555
r560 (  94 186 ) resistor r=152 //w=0.17 //l=0.17 //layer=licon //count=1 \
 //x=21.95 //y=4.88 //x2=21.95 //y2=4.88
r561 (  89 193 ) resistor r=152 //w=0.17 //l=0.17 //layer=licon //count=1 \
 //x=21.95 //y=2.26 //x2=21.95 //y2=2.26
r562 (  84 180 ) resistor r=152 //w=0.17 //l=0.17 //layer=licon //count=1 \
 //x=18.25 //y=4.88 //x2=18.25 //y2=4.88
r563 (  79 174 ) resistor r=152 //w=0.17 //l=0.17 //layer=licon //count=1 \
 //x=18.25 //y=2.26 //x2=18.25 //y2=2.26
r564 (  74 165 ) resistor r=152 //w=0.17 //l=0.17 //layer=licon //count=1 \
 //x=2.71 //y=4.88 //x2=2.71 //y2=4.88
r565 (  69 172 ) resistor r=152 //w=0.17 //l=0.17 //layer=licon //count=1 \
 //x=2.71 //y=2.26 //x2=2.71 //y2=2.26
r566 (  61 63 ) resistor r=0.10734 //w=0.281 //l=0.16 //layer=m2 \
 //thickness=0.36 //x=2.71 //y=4.635 //x2=2.87 //y2=4.635
r567 (  59 65 ) resistor r=0.423108 //w=0.182 //l=0.651422 //layer=m2 \
 //thickness=0.36 //x=18.86 //y=4.63 //x2=18.245 //y2=4.705
r568 (  58 67 ) resistor r=1.795 //w=0.191 //l=2.77725 //layer=m2 \
 //thickness=0.36 //x=19.205 //y=4.63 //x2=21.945 //y2=4.705
r569 (  58 59 ) resistor r=0.329198 //w=0.131 //l=0.345 //layer=m2 \
 //thickness=0.36 //x=19.205 //y=4.63 //x2=18.86 //y2=4.63
r570 (  56 65 ) resistor r=3.15319 //w=0.182 //l=4.62487 //layer=m2 \
 //thickness=0.36 //x=13.655 //y=4.635 //x2=18.245 //y2=4.705
r571 (  56 57 ) resistor r=0.329198 //w=0.131 //l=0.345 //layer=m2 \
 //thickness=0.36 //x=13.655 //y=4.635 //x2=13.31 //y2=4.635
r572 (  54 57 ) resistor r=0.1875 //w=0.17 //l=0.262393 //layer=m2 \
 //thickness=0.36 //x=13.055 //y=4.62 //x2=13.31 //y2=4.635
r573 (  54 55 ) resistor r=3.8645 //w=0.131 //l=4.05 //layer=m2 \
 //thickness=0.36 //x=13.055 //y=4.62 //x2=9.005 //y2=4.62
r574 (  52 55 ) resistor r=0.125 //w=0.17 //l=0.179722 //layer=m2 \
 //thickness=0.36 //x=8.835 //y=4.64 //x2=9.005 //y2=4.62
r575 (  52 53 ) resistor r=0.329198 //w=0.131 //l=0.345 //layer=m2 \
 //thickness=0.36 //x=8.835 //y=4.64 //x2=8.49 //y2=4.64
r576 (  50 53 ) resistor r=0.1875 //w=0.17 //l=0.264811 //layer=m2 \
 //thickness=0.36 //x=8.235 //y=4.62 //x2=8.49 //y2=4.64
r577 (  50 63 ) resistor r=5.11927 //w=0.131 //l=5.365 //layer=m2 \
 //thickness=0.36 //x=8.235 //y=4.62 //x2=2.87 //y2=4.62
r578 (  47 67 ) resistor r=4.5 //w=0.15 //l=0.15 //layer=via1 //count=1 \
 //x=21.945 //y=4.735 //x2=21.945 //y2=4.735
r579 (  45 89 ) resistor r=9.3 //w=0.17 //l=0.17 //layer=mcon //count=1 \
 //x=21.95 //y=2.26 //x2=21.95 //y2=2.26
r580 (  43 84 ) resistor r=9.3 //w=0.17 //l=0.17 //layer=mcon //count=1 \
 //x=18.25 //y=4.88 //x2=18.25 //y2=4.88
r581 (  41 65 ) resistor r=4.5 //w=0.15 //l=0.15 //layer=via1 //count=1 \
 //x=18.245 //y=4.725 //x2=18.245 //y2=4.725
r582 (  41 43 ) resistor r=0.0670415 //w=0.289 //l=0.155 //layer=m1 \
 //thickness=0.36 //x=18.245 //y=4.725 //x2=18.245 //y2=4.88
r583 (  38 79 ) resistor r=9.3 //w=0.17 //l=0.17 //layer=mcon //count=1 \
 //x=18.25 //y=2.26 //x2=18.25 //y2=2.26
r584 (  36 74 ) resistor r=9.3 //w=0.17 //l=0.17 //layer=mcon //count=1 \
 //x=2.71 //y=4.88 //x2=2.71 //y2=4.88
r585 (  34 61 ) resistor r=4.5 //w=0.15 //l=0.15 //layer=via1 //count=1 \
 //x=2.71 //y=4.635 //x2=2.71 //y2=4.635
r586 (  34 36 ) resistor r=0.109375 //w=0.28 //l=0.245 //layer=m1 \
 //thickness=0.36 //x=2.71 //y=4.635 //x2=2.71 //y2=4.88
r587 (  31 69 ) resistor r=9.3 //w=0.17 //l=0.17 //layer=mcon //count=1 \
 //x=2.71 //y=2.26 //x2=2.71 //y2=2.26
r588 (  26 47 ) resistor r=0.0901908 //w=0.29 //l=0.162481 //layer=m1 \
 //thickness=0.36 //x=21.95 //y=4.575 //x2=21.945 //y2=4.735
r589 (  25 45 ) resistor r=0.0715665 //w=0.226 //l=0.115996 //layer=m1 \
 //thickness=0.36 //x=21.95 //y=2.375 //x2=21.952 //y2=2.26
r590 (  21 38 ) resistor r=0.0719237 //w=0.222 //l=0.115 //layer=m1 \
 //thickness=0.36 //x=18.25 //y=2.375 //x2=18.25 //y2=2.26
r591 (  14 31 ) resistor r=0.0715665 //w=0.226 //l=0.115996 //layer=m1 \
 //thickness=0.36 //x=2.71 //y=2.375 //x2=2.712 //y2=2.26
r592 (  13 94 ) resistor r=9.3 //w=0.17 //l=0.17 //layer=mcon //count=1 \
 //x=21.95 //y=4.88 //x2=21.95 //y2=4.88
r593 (  13 47 ) resistor r=0.0625 //w=0.29 //l=0.145 //layer=m1 \
 //thickness=0.36 //x=21.945 //y=4.88 //x2=21.945 //y2=4.735
r594 (  12 41 ) resistor r=0.0108131 //w=0.289 //l=0.025 //layer=m1 \
 //thickness=0.36 //x=18.245 //y=4.7 //x2=18.245 //y2=4.725
r595 (  12 22 ) resistor r=0.0794097 //w=0.289 //l=0.137477 //layer=m1 \
 //thickness=0.36 //x=18.245 //y=4.7 //x2=18.25 //y2=4.565
r596 (  11 34 ) resistor r=0.00669643 //w=0.28 //l=0.015 //layer=m1 \
 //thickness=0.36 //x=2.71 //y=4.62 //x2=2.71 //y2=4.635
r597 (  11 15 ) resistor r=0.0838839 //w=0.28 //l=0.145 //layer=m1 \
 //thickness=0.36 //x=2.71 //y=4.62 //x2=2.71 //y2=4.475
r598 (  10 26 ) resistor r=0.663168 //w=0.131 //l=0.695 //layer=m1 \
 //thickness=0.36 //x=21.95 //y=3.88 //x2=21.95 //y2=4.575
r599 (  9 10 ) resistor r=0.353053 //w=0.131 //l=0.37 //layer=m1 \
 //thickness=0.36 //x=21.95 //y=3.51 //x2=21.95 //y2=3.88
r600 (  8 9 ) resistor r=0.353053 //w=0.131 //l=0.37 //layer=m1 \
 //thickness=0.36 //x=21.95 //y=3.14 //x2=21.95 //y2=3.51
r601 (  8 25 ) resistor r=0.729962 //w=0.131 //l=0.765 //layer=m1 \
 //thickness=0.36 //x=21.95 //y=3.14 //x2=21.95 //y2=2.375
r602 (  7 22 ) resistor r=1.00668 //w=0.131 //l=1.055 //layer=m1 \
 //thickness=0.36 //x=18.25 //y=3.51 //x2=18.25 //y2=4.565
r603 (  6 7 ) resistor r=0.353053 //w=0.131 //l=0.37 //layer=m1 \
 //thickness=0.36 //x=18.25 //y=3.14 //x2=18.25 //y2=3.51
r604 (  6 21 ) resistor r=0.729962 //w=0.131 //l=0.765 //layer=m1 \
 //thickness=0.36 //x=18.25 //y=3.14 //x2=18.25 //y2=2.375
r605 (  5 15 ) resistor r=0.214695 //w=0.131 //l=0.225 //layer=m1 \
 //thickness=0.36 //x=2.71 //y=4.25 //x2=2.71 //y2=4.475
r606 (  4 5 ) resistor r=0.353053 //w=0.131 //l=0.37 //layer=m1 \
 //thickness=0.36 //x=2.71 //y=3.88 //x2=2.71 //y2=4.25
r607 (  3 4 ) resistor r=0.353053 //w=0.131 //l=0.37 //layer=m1 \
 //thickness=0.36 //x=2.71 //y=3.51 //x2=2.71 //y2=3.88
r608 (  2 3 ) resistor r=0.353053 //w=0.131 //l=0.37 //layer=m1 \
 //thickness=0.36 //x=2.71 //y=3.14 //x2=2.71 //y2=3.51
r609 (  1 2 ) resistor r=0.353053 //w=0.131 //l=0.37 //layer=m1 \
 //thickness=0.36 //x=2.71 //y=2.77 //x2=2.71 //y2=3.14
r610 (  1 14 ) resistor r=0.376908 //w=0.131 //l=0.395 //layer=m1 \
 //thickness=0.36 //x=2.71 //y=2.77 //x2=2.71 //y2=2.375
ends PM_DFFSNRNQNX1\%RN

subckt PM_DFFSNRNQNX1\%QN ( 1 2 3 4 5 6 7 8 9 10 12 15 16 18 19 20 21 26 30 33 \
 34 35 38 41 57 62 64 67 75 83 100 109 113 114 115 116 117 118 119 120 122 128 \
 129 130 131 143 145 146 147 )
c288 ( 143 0 ) capacitor c=0.00885916f //x=23.125 //y=1.095
c289 ( 131 0 ) capacitor c=0.0612936f //x=25.925 //y=4.97
c290 ( 130 0 ) capacitor c=0.0376642f //x=26.215 //y=4.97
c291 ( 129 0 ) capacitor c=0.0346489f //x=25.88 //y=1.4
c292 ( 128 0 ) capacitor c=0.018692f //x=25.88 //y=1.055
c293 ( 122 0 ) capacitor c=0.0137077f //x=25.725 //y=1.555
c294 ( 120 0 ) capacitor c=0.0158585f //x=25.725 //y=0.9
c295 ( 119 0 ) capacitor c=0.10101f //x=25.35 //y=2.095
c296 ( 118 0 ) capacitor c=0.0229444f //x=25.35 //y=1.71
c297 ( 117 0 ) capacitor c=0.0234359f //x=25.35 //y=1.4
c298 ( 116 0 ) capacitor c=0.019815f //x=25.35 //y=1.055
c299 ( 115 0 ) capacitor c=0.110208f //x=26.29 //y=6.2
c300 ( 114 0 ) capacitor c=0.158957f //x=25.85 //y=6.2
c301 ( 109 0 ) capacitor c=0.0014751f //x=25.65 //y=4.88
c302 ( 100 0 ) capacitor c=0.0012618f //x=25.65 //y=2.26
c303 ( 83 0 ) capacitor c=0.0293719f //x=23.02 //y=5.56
c304 ( 75 0 ) capacitor c=0.029137f //x=22.14 //y=5.56
c305 ( 67 0 ) capacitor c=0.0278099f //x=21.26 //y=5.56
c306 ( 64 0 ) capacitor c=5.60248e-19 //x=25.65 //y=3.51
c307 ( 62 0 ) capacitor c=8.43895e-19 //x=23.96 //y=3.515
c308 ( 57 0 ) capacitor c=0.0230734f //x=25.49 //y=3.51
c309 ( 41 0 ) capacitor c=9.28645e-19 //x=23.02 //y=5.335
c310 ( 38 0 ) capacitor c=0.0075703f //x=22.14 //y=5.335
c311 ( 35 0 ) capacitor c=0.0111234f //x=21.262 //y=5.335
c312 ( 34 0 ) capacitor c=0.0321974f //x=25.65 //y=4.755
c313 ( 33 0 ) capacitor c=0.014419f //x=25.65 //y=3.67
c314 ( 30 0 ) capacitor c=0.00641616f //x=25.65 //y=2.375
c315 ( 26 0 ) capacitor c=0.0131678f //x=23.8 //y=3.675
c316 ( 21 0 ) capacitor c=0.00537187f //x=23.4 //y=1.845
c317 ( 20 0 ) capacitor c=0.014775f //x=23.715 //y=1.845
c318 ( 19 0 ) capacitor c=0.0167992f //x=23.315 //y=1.76
c319 ( 18 0 ) capacitor c=0.0111307f //x=23.315 //y=1.305
c320 ( 16 0 ) capacitor c=0.0244293f //x=23.715 //y=5.335
c321 ( 15 0 ) capacitor c=0.00933983f //x=23.02 //y=5.56
c322 ( 12 0 ) capacitor c=0.0198815f //x=22.905 //y=5.335
c323 ( 10 0 ) capacitor c=0.0146976f //x=22.02 //y=5.335
c324 ( 9 0 ) capacitor c=0.0064705f //x=25.65 //y=4.88
c325 ( 8 0 ) capacitor c=0.0169181f //x=25.65 //y=3.51
c326 ( 6 0 ) capacitor c=0.0172033f //x=23.8 //y=3.51
c327 ( 5 0 ) capacitor c=0.0309383f //x=25.65 //y=3.14
c328 ( 3 0 ) capacitor c=0.0423155f //x=23.8 //y=4.62
c329 ( 1 0 ) capacitor c=0.0419499f //x=23.8 //y=2.4
r330 (  130 132 ) resistor r=26.9307 //w=0.15 //l=0.106066 //layer=ply \
 //thickness=0.18 //x=26.215 //y=4.97 //x2=26.29 //y2=5.045
r331 (  130 131 ) resistor r=148.702 //w=0.094 //l=0.29 //layer=ply \
 //thickness=0.18 //x=26.215 //y=4.97 //x2=25.925 //y2=4.97
r332 (  129 142 ) resistor r=45.1352 //w=0.168 //l=0.173853 //layer=ply \
 //thickness=0.18 //x=25.88 //y=1.4 //x2=25.84 //y2=1.555
r333 (  128 141 ) resistor r=45.1352 //w=0.168 //l=0.173853 //layer=ply \
 //thickness=0.18 //x=25.88 //y=1.055 //x2=25.84 //y2=0.9
r334 (  128 129 ) resistor r=176.904 //w=0.094 //l=0.345 //layer=ply \
 //thickness=0.18 //x=25.88 //y=1.055 //x2=25.88 //y2=1.4
r335 (  125 131 ) resistor r=22.7971 //w=0.269 //l=0.106066 //layer=ply \
 //thickness=0.18 //x=25.85 //y=5.045 //x2=25.925 //y2=4.97
r336 (  125 140 ) resistor r=35.8364 //w=0.269 //l=0.270185 //layer=ply \
 //thickness=0.18 //x=25.85 //y=5.045 //x2=25.65 //y2=4.88
r337 (  123 136 ) resistor r=10.701 //w=0.21 //l=0.115 //layer=ply \
 //thickness=0.18 //x=25.505 //y=1.555 //x2=25.39 //y2=1.555
r338 (  122 142 ) resistor r=5.52526 //w=0.168 //l=0.115 //layer=ply \
 //thickness=0.18 //x=25.725 //y=1.555 //x2=25.84 //y2=1.555
r339 (  121 135 ) resistor r=5.52526 //w=0.168 //l=0.115 //layer=ply \
 //thickness=0.18 //x=25.505 //y=0.9 //x2=25.39 //y2=0.9
r340 (  120 141 ) resistor r=5.52526 //w=0.168 //l=0.115 //layer=ply \
 //thickness=0.18 //x=25.725 //y=0.9 //x2=25.84 //y2=0.9
r341 (  120 121 ) resistor r=112.809 //w=0.094 //l=0.22 //layer=ply \
 //thickness=0.18 //x=25.725 //y=0.9 //x2=25.505 //y2=0.9
r342 (  119 138 ) resistor r=58.7805 //w=0.246 //l=0.373497 //layer=ply \
 //thickness=0.18 //x=25.35 //y=2.095 //x2=25.65 //y2=2.26
r343 (  118 136 ) resistor r=39.5823 //w=0.21 //l=0.173853 //layer=ply \
 //thickness=0.18 //x=25.35 //y=1.71 //x2=25.39 //y2=1.555
r344 (  118 119 ) resistor r=197.415 //w=0.094 //l=0.385 //layer=ply \
 //thickness=0.18 //x=25.35 //y=1.71 //x2=25.35 //y2=2.095
r345 (  117 136 ) resistor r=39.5823 //w=0.21 //l=0.173853 //layer=ply \
 //thickness=0.18 //x=25.35 //y=1.4 //x2=25.39 //y2=1.555
r346 (  116 135 ) resistor r=45.1352 //w=0.168 //l=0.173853 //layer=ply \
 //thickness=0.18 //x=25.35 //y=1.055 //x2=25.39 //y2=0.9
r347 (  116 117 ) resistor r=176.904 //w=0.094 //l=0.345 //layer=ply \
 //thickness=0.18 //x=25.35 //y=1.055 //x2=25.35 //y2=1.4
r348 (  115 132 ) resistor r=592.245 //w=0.094 //l=1.155 //layer=ply \
 //thickness=0.18 //x=26.29 //y=6.2 //x2=26.29 //y2=5.045
r349 (  114 125 ) resistor r=592.245 //w=0.094 //l=1.155 //layer=ply \
 //thickness=0.18 //x=25.85 //y=6.2 //x2=25.85 //y2=5.045
r350 (  113 122 ) resistor r=56.4043 //w=0.094 //l=0.11 //layer=ply \
 //thickness=0.18 //x=25.615 //y=1.555 //x2=25.725 //y2=1.555
r351 (  113 123 ) resistor r=56.4043 //w=0.094 //l=0.11 //layer=ply \
 //thickness=0.18 //x=25.615 //y=1.555 //x2=25.505 //y2=1.555
r352 (  109 140 ) resistor r=152 //w=0.17 //l=0.17 //layer=licon //count=1 \
 //x=25.65 //y=4.88 //x2=25.65 //y2=4.88
r353 (  100 138 ) resistor r=152 //w=0.17 //l=0.17 //layer=licon //count=1 \
 //x=25.65 //y=2.26 //x2=25.65 //y2=2.26
r354 (  83 147 ) resistor r=23.615 //w=0.187 //l=0.345 //layer=li \
 //thickness=0.1 //x=23.02 //y=5.56 //x2=23.02 //y2=5.905
r355 (  75 146 ) resistor r=23.615 //w=0.187 //l=0.345 //layer=li \
 //thickness=0.1 //x=22.14 //y=5.56 //x2=22.14 //y2=5.905
r356 (  67 145 ) resistor r=23.615 //w=0.187 //l=0.345 //layer=li \
 //thickness=0.1 //x=21.26 //y=5.56 //x2=21.26 //y2=5.905
r357 (  60 62 ) resistor r=0.10734 //w=0.281 //l=0.16 //layer=m2 \
 //thickness=0.36 //x=23.8 //y=3.515 //x2=23.96 //y2=3.515
r358 (  57 64 ) resistor r=0.10734 //w=0.281 //l=0.16 //layer=m2 \
 //thickness=0.36 //x=25.49 //y=3.51 //x2=25.65 //y2=3.51
r359 (  57 62 ) resistor r=1.45992 //w=0.131 //l=1.53 //layer=m2 \
 //thickness=0.36 //x=25.49 //y=3.51 //x2=23.96 //y2=3.51
r360 (  49 60 ) resistor r=4.5 //w=0.15 //l=0.15 //layer=via1 //count=1 \
 //x=23.8 //y=3.515 //x2=23.8 //y2=3.515
r361 (  45 143 ) resistor r=9.3 //w=0.17 //l=0.17 //layer=mcon //count=1 \
 //x=23.315 //y=1.19 //x2=23.315 //y2=1.19
r362 (  43 83 ) resistor r=9.3 //w=0.17 //l=0.17 //layer=mcon //count=1 \
 //x=23.02 //y=5.56 //x2=23.02 //y2=5.56
r363 (  40 75 ) resistor r=9.3 //w=0.17 //l=0.17 //layer=mcon //count=1 \
 //x=22.14 //y=5.56 //x2=22.14 //y2=5.56
r364 (  38 40 ) resistor r=0.121228 //w=0.232 //l=0.225 //layer=m1 \
 //thickness=0.36 //x=22.14 //y=5.335 //x2=22.14 //y2=5.56
r365 (  37 67 ) resistor r=9.3 //w=0.17 //l=0.17 //layer=mcon //count=1 \
 //x=21.26 //y=5.56 //x2=21.26 //y2=5.56
r366 (  35 37 ) resistor r=0.129608 //w=0.217 //l=0.225 //layer=m1 \
 //thickness=0.36 //x=21.262 //y=5.335 //x2=21.262 //y2=5.56
r367 (  33 34 ) resistor r=1.03531 //w=0.131 //l=1.085 //layer=m1 \
 //thickness=0.36 //x=25.65 //y=3.67 //x2=25.65 //y2=4.755
r368 (  26 49 ) resistor r=0.0911593 //w=0.376 //l=0.184174 //layer=m1 \
 //thickness=0.36 //x=23.8 //y=3.675 //x2=23.852 //y2=3.515
r369 (  20 22 ) resistor r=0.0698411 //w=0.17 //l=0.120208 //layer=m1 \
 //thickness=0.36 //x=23.715 //y=1.845 //x2=23.8 //y2=1.93
r370 (  20 21 ) resistor r=0.300573 //w=0.131 //l=0.315 //layer=m1 \
 //thickness=0.36 //x=23.715 //y=1.845 //x2=23.4 //y2=1.845
r371 (  19 21 ) resistor r=0.0698411 //w=0.17 //l=0.120208 //layer=m1 \
 //thickness=0.36 //x=23.315 //y=1.76 //x2=23.4 //y2=1.845
r372 (  18 45 ) resistor r=0.0717383 //w=0.224 //l=0.115 //layer=m1 \
 //thickness=0.36 //x=23.315 //y=1.305 //x2=23.315 //y2=1.19
r373 (  18 19 ) resistor r=0.43416 //w=0.131 //l=0.455 //layer=m1 \
 //thickness=0.36 //x=23.315 //y=1.305 //x2=23.315 //y2=1.76
r374 (  17 41 ) resistor r=0.0675342 //w=0.23 //l=0.115 //layer=m1 \
 //thickness=0.36 //x=23.135 //y=5.335 //x2=23.02 //y2=5.335
r375 (  16 27 ) resistor r=0.0698411 //w=0.17 //l=0.120208 //layer=m1 \
 //thickness=0.36 //x=23.715 //y=5.335 //x2=23.8 //y2=5.25
r376 (  16 17 ) resistor r=0.553435 //w=0.131 //l=0.58 //layer=m1 \
 //thickness=0.36 //x=23.715 //y=5.335 //x2=23.135 //y2=5.335
r377 (  15 43 ) resistor r=0.00118313 //w=0.23 //layer=m1 //thickness=0.36 \
 //x=23.02 //y=5.56 //x2=23.02 //y2=5.56
r378 (  14 41 ) resistor r=0.002872 //w=0.34 //l=0.085 //layer=m1 \
 //thickness=0.36 //x=23.02 //y=5.42 //x2=23.02 //y2=5.335
r379 (  14 15 ) resistor r=0.091623 //w=0.191 //l=0.14 //layer=m1 \
 //thickness=0.36 //x=23.02 //y=5.42 //x2=23.02 //y2=5.56
r380 (  13 38 ) resistor r=0.0262263 //w=0.232 //l=0.12 //layer=m1 \
 //thickness=0.36 //x=22.26 //y=5.335 //x2=22.14 //y2=5.335
r381 (  12 41 ) resistor r=0.0675342 //w=0.23 //l=0.115 //layer=m1 \
 //thickness=0.36 //x=22.905 //y=5.335 //x2=23.02 //y2=5.335
r382 (  12 13 ) resistor r=0.615458 //w=0.131 //l=0.645 //layer=m1 \
 //thickness=0.36 //x=22.905 //y=5.335 //x2=22.26 //y2=5.335
r383 (  11 35 ) resistor r=0.0222262 //w=0.217 //l=0.118 //layer=m1 \
 //thickness=0.36 //x=21.38 //y=5.335 //x2=21.262 //y2=5.335
r384 (  10 38 ) resistor r=0.0262263 //w=0.232 //l=0.12 //layer=m1 \
 //thickness=0.36 //x=22.02 //y=5.335 //x2=22.14 //y2=5.335
r385 (  10 11 ) resistor r=0.610687 //w=0.131 //l=0.64 //layer=m1 \
 //thickness=0.36 //x=22.02 //y=5.335 //x2=21.38 //y2=5.335
r386 (  9 109 ) resistor r=9.3 //w=0.17 //l=0.17 //layer=mcon //count=1 \
 //x=25.65 //y=4.88 //x2=25.65 //y2=4.88
r387 (  9 34 ) resistor r=0.0760407 //w=0.238 //l=0.125 //layer=m1 \
 //thickness=0.36 //x=25.65 //y=4.88 //x2=25.65 //y2=4.755
r388 (  8 64 ) resistor r=4.5 //w=0.15 //l=0.15 //layer=via1 //count=1 \
 //x=25.65 //y=3.51 //x2=25.65 //y2=3.51
r389 (  8 33 ) resistor r=0.0911593 //w=0.376 //l=0.184608 //layer=m1 \
 //thickness=0.36 //x=25.597 //y=3.51 //x2=25.65 //y2=3.67
r390 (  8 31 ) resistor r=0.0911593 //w=0.376 //l=0.184608 //layer=m1 \
 //thickness=0.36 //x=25.597 //y=3.51 //x2=25.65 //y2=3.35
r391 (  7 100 ) resistor r=9.3 //w=0.17 //l=0.17 //layer=mcon //count=1 \
 //x=25.65 //y=2.26 //x2=25.65 //y2=2.26
r392 (  7 30 ) resistor r=0.0719237 //w=0.222 //l=0.115 //layer=m1 \
 //thickness=0.36 //x=25.65 //y=2.26 //x2=25.65 //y2=2.375
r393 (  6 49 ) resistor r=0.00166223 //w=0.376 //l=0.005 //layer=m1 \
 //thickness=0.36 //x=23.852 //y=3.51 //x2=23.852 //y2=3.515
r394 (  6 23 ) resistor r=0.0894971 //w=0.376 //l=0.179123 //layer=m1 \
 //thickness=0.36 //x=23.852 //y=3.51 //x2=23.8 //y2=3.355
r395 (  5 31 ) resistor r=0.200382 //w=0.131 //l=0.21 //layer=m1 \
 //thickness=0.36 //x=25.65 //y=3.14 //x2=25.65 //y2=3.35
r396 (  5 30 ) resistor r=0.729962 //w=0.131 //l=0.765 //layer=m1 \
 //thickness=0.36 //x=25.65 //y=3.14 //x2=25.65 //y2=2.375
r397 (  4 27 ) resistor r=0.248092 //w=0.131 //l=0.26 //layer=m1 \
 //thickness=0.36 //x=23.8 //y=4.99 //x2=23.8 //y2=5.25
r398 (  3 4 ) resistor r=0.353053 //w=0.131 //l=0.37 //layer=m1 \
 //thickness=0.36 //x=23.8 //y=4.62 //x2=23.8 //y2=4.99
r399 (  3 26 ) resistor r=0.901718 //w=0.131 //l=0.945 //layer=m1 \
 //thickness=0.36 //x=23.8 //y=4.62 //x2=23.8 //y2=3.675
r400 (  2 23 ) resistor r=0.205153 //w=0.131 //l=0.215 //layer=m1 \
 //thickness=0.36 //x=23.8 //y=3.14 //x2=23.8 //y2=3.355
r401 (  1 2 ) resistor r=0.706107 //w=0.131 //l=0.74 //layer=m1 \
 //thickness=0.36 //x=23.8 //y=2.4 //x2=23.8 //y2=3.14
r402 (  1 22 ) resistor r=0.448473 //w=0.131 //l=0.47 //layer=m1 \
 //thickness=0.36 //x=23.8 //y=2.4 //x2=23.8 //y2=1.93
ends PM_DFFSNRNQNX1\%QN

subckt PM_DFFSNRNQNX1\%SN ( 1 2 3 4 5 6 7 8 9 10 11 12 22 31 33 35 37 42 46 55 \
 60 69 73 74 75 76 77 78 79 80 81 83 89 90 91 92 93 98 99 100 102 108 109 110 \
 111 112 120 131 )
c383 ( 131 0 ) capacitor c=0.0369044f //x=26.76 //y=4.88
c384 ( 120 0 ) capacitor c=0.0369044f //x=12.33 //y=4.88
c385 ( 112 0 ) capacitor c=0.0309248f //x=27.095 //y=4.97
c386 ( 111 0 ) capacitor c=0.0818437f //x=26.85 //y=2.095
c387 ( 110 0 ) capacitor c=0.0170266f //x=26.85 //y=1.63
c388 ( 109 0 ) capacitor c=0.018609f //x=26.85 //y=1.4
c389 ( 108 0 ) capacitor c=0.0186599f //x=26.85 //y=1.09
c390 ( 102 0 ) capacitor c=0.0146988f //x=26.695 //y=1.555
c391 ( 100 0 ) capacitor c=0.0148531f //x=26.695 //y=0.935
c392 ( 99 0 ) capacitor c=0.0334406f //x=26.325 //y=1.4
c393 ( 98 0 ) capacitor c=0.0173191f //x=26.325 //y=1.09
c394 ( 93 0 ) capacitor c=0.0309248f //x=12.665 //y=4.97
c395 ( 92 0 ) capacitor c=0.0817395f //x=12.42 //y=2.095
c396 ( 91 0 ) capacitor c=0.0170266f //x=12.42 //y=1.63
c397 ( 90 0 ) capacitor c=0.018609f //x=12.42 //y=1.4
c398 ( 89 0 ) capacitor c=0.0186599f //x=12.42 //y=1.09
c399 ( 83 0 ) capacitor c=0.0146988f //x=12.265 //y=1.555
c400 ( 81 0 ) capacitor c=0.0148531f //x=12.265 //y=0.935
c401 ( 80 0 ) capacitor c=0.0334406f //x=11.895 //y=1.4
c402 ( 79 0 ) capacitor c=0.0173191f //x=11.895 //y=1.09
c403 ( 78 0 ) capacitor c=0.110208f //x=27.17 //y=6.2
c404 ( 77 0 ) capacitor c=0.110214f //x=26.73 //y=6.2
c405 ( 76 0 ) capacitor c=0.110208f //x=12.74 //y=6.2
c406 ( 75 0 ) capacitor c=0.110214f //x=12.3 //y=6.2
c407 ( 69 0 ) capacitor c=0.00129935f //x=26.76 //y=4.88
c408 ( 60 0 ) capacitor c=9.49278e-19 //x=26.76 //y=2.26
c409 ( 55 0 ) capacitor c=0.00129935f //x=12.33 //y=4.88
c410 ( 46 0 ) capacitor c=9.49278e-19 //x=12.33 //y=2.26
c411 ( 42 0 ) capacitor c=0.00256675f //x=12.49 //y=2.775
c412 ( 37 0 ) capacitor c=0.304276f //x=16.245 //y=2.755
c413 ( 35 0 ) capacitor c=0.030006f //x=15.645 //y=2.77
c414 ( 33 0 ) capacitor c=0.0188858f //x=14.39 //y=2.76
c415 ( 31 0 ) capacitor c=0.0362725f //x=13.79 //y=2.77
c416 ( 22 0 ) capacitor c=0.0159739f //x=12.33 //y=2.775
c417 ( 12 0 ) capacitor c=0.0125556f //x=26.76 //y=2.93
c418 ( 11 0 ) capacitor c=0.00544556f //x=26.76 //y=2.61
c419 ( 10 0 ) capacitor c=0.00502229f //x=26.76 //y=2.375
c420 ( 9 0 ) capacitor c=0.051253f //x=12.33 //y=4.765
c421 ( 8 0 ) capacitor c=0.0122694f //x=12.33 //y=2.935
c422 ( 7 0 ) capacitor c=0.00557487f //x=12.33 //y=2.615
c423 ( 6 0 ) capacitor c=0.0050228f //x=12.33 //y=2.375
c424 ( 5 0 ) capacitor c=0.00495197f //x=26.76 //y=4.88
c425 ( 4 0 ) capacitor c=0.0159924f //x=26.76 //y=2.77
c426 ( 1 0 ) capacitor c=0.0521641f //x=26.76 //y=3.14
r427 (  133 134 ) resistor r=32.4568 //w=0.214 //l=0.075 //layer=ply \
 //thickness=0.18 //x=26.76 //y=4.97 //x2=26.76 //y2=5.045
r428 (  131 133 ) resistor r=20.271 //w=0.214 //l=0.09 //layer=ply \
 //thickness=0.18 //x=26.76 //y=4.88 //x2=26.76 //y2=4.97
r429 (  122 123 ) resistor r=32.4568 //w=0.214 //l=0.075 //layer=ply \
 //thickness=0.18 //x=12.33 //y=4.97 //x2=12.33 //y2=5.045
r430 (  120 122 ) resistor r=20.271 //w=0.214 //l=0.09 //layer=ply \
 //thickness=0.18 //x=12.33 //y=4.88 //x2=12.33 //y2=4.97
r431 (  113 133 ) resistor r=16.5046 //w=0.27 //l=0.135 //layer=ply \
 //thickness=0.18 //x=26.895 //y=4.97 //x2=26.76 //y2=4.97
r432 (  112 114 ) resistor r=26.9307 //w=0.15 //l=0.106066 //layer=ply \
 //thickness=0.18 //x=27.095 //y=4.97 //x2=27.17 //y2=5.045
r433 (  112 113 ) resistor r=102.553 //w=0.094 //l=0.2 //layer=ply \
 //thickness=0.18 //x=27.095 //y=4.97 //x2=26.895 //y2=4.97
r434 (  111 138 ) resistor r=38.6777 //w=0.284 //l=0.198997 //layer=ply \
 //thickness=0.18 //x=26.85 //y=2.095 //x2=26.775 //y2=2.26
r435 (  110 136 ) resistor r=21.2976 //w=0.217 //l=0.0928709 //layer=ply \
 //thickness=0.18 //x=26.85 //y=1.63 //x2=26.81 //y2=1.555
r436 (  110 111 ) resistor r=238.436 //w=0.094 //l=0.465 //layer=ply \
 //thickness=0.18 //x=26.85 //y=1.63 //x2=26.85 //y2=2.095
r437 (  109 136 ) resistor r=39.0671 //w=0.217 //l=0.173853 //layer=ply \
 //thickness=0.18 //x=26.85 //y=1.4 //x2=26.81 //y2=1.555
r438 (  108 135 ) resistor r=45.1352 //w=0.168 //l=0.173853 //layer=ply \
 //thickness=0.18 //x=26.85 //y=1.09 //x2=26.81 //y2=0.935
r439 (  108 109 ) resistor r=158.957 //w=0.094 //l=0.31 //layer=ply \
 //thickness=0.18 //x=26.85 //y=1.09 //x2=26.85 //y2=1.4
r440 (  103 129 ) resistor r=5.52526 //w=0.168 //l=0.115 //layer=ply \
 //thickness=0.18 //x=26.48 //y=1.555 //x2=26.365 //y2=1.555
r441 (  102 136 ) resistor r=11.4558 //w=0.217 //l=0.115 //layer=ply \
 //thickness=0.18 //x=26.695 //y=1.555 //x2=26.81 //y2=1.555
r442 (  101 128 ) resistor r=5.52526 //w=0.168 //l=0.115 //layer=ply \
 //thickness=0.18 //x=26.48 //y=0.935 //x2=26.365 //y2=0.935
r443 (  100 135 ) resistor r=5.52526 //w=0.168 //l=0.115 //layer=ply \
 //thickness=0.18 //x=26.695 //y=0.935 //x2=26.81 //y2=0.935
r444 (  100 101 ) resistor r=110.245 //w=0.094 //l=0.215 //layer=ply \
 //thickness=0.18 //x=26.695 //y=0.935 //x2=26.48 //y2=0.935
r445 (  99 129 ) resistor r=45.1352 //w=0.168 //l=0.173853 //layer=ply \
 //thickness=0.18 //x=26.325 //y=1.4 //x2=26.365 //y2=1.555
r446 (  98 128 ) resistor r=45.1352 //w=0.168 //l=0.173853 //layer=ply \
 //thickness=0.18 //x=26.325 //y=1.09 //x2=26.365 //y2=0.935
r447 (  98 99 ) resistor r=158.957 //w=0.094 //l=0.31 //layer=ply \
 //thickness=0.18 //x=26.325 //y=1.09 //x2=26.325 //y2=1.4
r448 (  94 122 ) resistor r=16.5046 //w=0.27 //l=0.135 //layer=ply \
 //thickness=0.18 //x=12.465 //y=4.97 //x2=12.33 //y2=4.97
r449 (  93 95 ) resistor r=26.9307 //w=0.15 //l=0.106066 //layer=ply \
 //thickness=0.18 //x=12.665 //y=4.97 //x2=12.74 //y2=5.045
r450 (  93 94 ) resistor r=102.553 //w=0.094 //l=0.2 //layer=ply \
 //thickness=0.18 //x=12.665 //y=4.97 //x2=12.465 //y2=4.97
r451 (  92 127 ) resistor r=38.6777 //w=0.284 //l=0.198997 //layer=ply \
 //thickness=0.18 //x=12.42 //y=2.095 //x2=12.345 //y2=2.26
r452 (  91 125 ) resistor r=21.2976 //w=0.217 //l=0.0928709 //layer=ply \
 //thickness=0.18 //x=12.42 //y=1.63 //x2=12.38 //y2=1.555
r453 (  91 92 ) resistor r=238.436 //w=0.094 //l=0.465 //layer=ply \
 //thickness=0.18 //x=12.42 //y=1.63 //x2=12.42 //y2=2.095
r454 (  90 125 ) resistor r=39.0671 //w=0.217 //l=0.173853 //layer=ply \
 //thickness=0.18 //x=12.42 //y=1.4 //x2=12.38 //y2=1.555
r455 (  89 124 ) resistor r=45.1352 //w=0.168 //l=0.173853 //layer=ply \
 //thickness=0.18 //x=12.42 //y=1.09 //x2=12.38 //y2=0.935
r456 (  89 90 ) resistor r=158.957 //w=0.094 //l=0.31 //layer=ply \
 //thickness=0.18 //x=12.42 //y=1.09 //x2=12.42 //y2=1.4
r457 (  84 118 ) resistor r=5.52526 //w=0.168 //l=0.115 //layer=ply \
 //thickness=0.18 //x=12.05 //y=1.555 //x2=11.935 //y2=1.555
r458 (  83 125 ) resistor r=11.4558 //w=0.217 //l=0.115 //layer=ply \
 //thickness=0.18 //x=12.265 //y=1.555 //x2=12.38 //y2=1.555
r459 (  82 117 ) resistor r=5.52526 //w=0.168 //l=0.115 //layer=ply \
 //thickness=0.18 //x=12.05 //y=0.935 //x2=11.935 //y2=0.935
r460 (  81 124 ) resistor r=5.52526 //w=0.168 //l=0.115 //layer=ply \
 //thickness=0.18 //x=12.265 //y=0.935 //x2=12.38 //y2=0.935
r461 (  81 82 ) resistor r=110.245 //w=0.094 //l=0.215 //layer=ply \
 //thickness=0.18 //x=12.265 //y=0.935 //x2=12.05 //y2=0.935
r462 (  80 118 ) resistor r=45.1352 //w=0.168 //l=0.173853 //layer=ply \
 //thickness=0.18 //x=11.895 //y=1.4 //x2=11.935 //y2=1.555
r463 (  79 117 ) resistor r=45.1352 //w=0.168 //l=0.173853 //layer=ply \
 //thickness=0.18 //x=11.895 //y=1.09 //x2=11.935 //y2=0.935
r464 (  79 80 ) resistor r=158.957 //w=0.094 //l=0.31 //layer=ply \
 //thickness=0.18 //x=11.895 //y=1.09 //x2=11.895 //y2=1.4
r465 (  78 114 ) resistor r=592.245 //w=0.094 //l=1.155 //layer=ply \
 //thickness=0.18 //x=27.17 //y=6.2 //x2=27.17 //y2=5.045
r466 (  77 134 ) resistor r=592.245 //w=0.094 //l=1.155 //layer=ply \
 //thickness=0.18 //x=26.73 //y=6.2 //x2=26.73 //y2=5.045
r467 (  76 95 ) resistor r=592.245 //w=0.094 //l=1.155 //layer=ply \
 //thickness=0.18 //x=12.74 //y=6.2 //x2=12.74 //y2=5.045
r468 (  75 123 ) resistor r=592.245 //w=0.094 //l=1.155 //layer=ply \
 //thickness=0.18 //x=12.3 //y=6.2 //x2=12.3 //y2=5.045
r469 (  74 102 ) resistor r=55.3787 //w=0.094 //l=0.108 //layer=ply \
 //thickness=0.18 //x=26.587 //y=1.555 //x2=26.695 //y2=1.555
r470 (  74 103 ) resistor r=54.866 //w=0.094 //l=0.107 //layer=ply \
 //thickness=0.18 //x=26.587 //y=1.555 //x2=26.48 //y2=1.555
r471 (  73 83 ) resistor r=55.3787 //w=0.094 //l=0.108 //layer=ply \
 //thickness=0.18 //x=12.157 //y=1.555 //x2=12.265 //y2=1.555
r472 (  73 84 ) resistor r=54.866 //w=0.094 //l=0.107 //layer=ply \
 //thickness=0.18 //x=12.157 //y=1.555 //x2=12.05 //y2=1.555
r473 (  69 131 ) resistor r=152 //w=0.17 //l=0.17 //layer=licon //count=1 \
 //x=26.76 //y=4.88 //x2=26.76 //y2=4.88
r474 (  60 138 ) resistor r=152 //w=0.17 //l=0.17 //layer=licon //count=1 \
 //x=26.76 //y=2.26 //x2=26.76 //y2=2.26
r475 (  55 120 ) resistor r=152 //w=0.17 //l=0.17 //layer=licon //count=1 \
 //x=12.33 //y=4.88 //x2=12.33 //y2=4.88
r476 (  46 127 ) resistor r=152 //w=0.17 //l=0.17 //layer=licon //count=1 \
 //x=12.33 //y=2.26 //x2=12.33 //y2=2.26
r477 (  40 42 ) resistor r=0.10734 //w=0.281 //l=0.16 //layer=m2 \
 //thickness=0.36 //x=12.33 //y=2.775 //x2=12.49 //y2=2.775
r478 (  37 44 ) resistor r=7.51071 //w=0.175 //l=10.5225 //layer=m2 \
 //thickness=0.36 //x=16.245 //y=2.755 //x2=26.76 //y2=2.77
r479 (  37 38 ) resistor r=0.410305 //w=0.131 //l=0.43 //layer=m2 \
 //thickness=0.36 //x=16.245 //y=2.755 //x2=15.815 //y2=2.755
r480 (  35 38 ) resistor r=0.125 //w=0.17 //l=0.177341 //layer=m2 \
 //thickness=0.36 //x=15.645 //y=2.77 //x2=15.815 //y2=2.755
r481 (  35 36 ) resistor r=0.954198 //w=0.131 //l=1 //layer=m2 \
 //thickness=0.36 //x=15.645 //y=2.77 //x2=14.645 //y2=2.77
r482 (  33 36 ) resistor r=0.1875 //w=0.17 //l=0.259952 //layer=m2 \
 //thickness=0.36 //x=14.39 //y=2.76 //x2=14.645 //y2=2.77
r483 (  33 34 ) resistor r=0.410305 //w=0.131 //l=0.43 //layer=m2 \
 //thickness=0.36 //x=14.39 //y=2.76 //x2=13.96 //y2=2.76
r484 (  31 34 ) resistor r=0.125 //w=0.17 //l=0.174929 //layer=m2 \
 //thickness=0.36 //x=13.79 //y=2.77 //x2=13.96 //y2=2.76
r485 (  31 42 ) resistor r=1.24046 //w=0.131 //l=1.3 //layer=m2 \
 //thickness=0.36 //x=13.79 //y=2.77 //x2=12.49 //y2=2.77
r486 (  28 60 ) resistor r=9.3 //w=0.17 //l=0.17 //layer=mcon //count=1 \
 //x=26.76 //y=2.26 //x2=26.76 //y2=2.26
r487 (  22 40 ) resistor r=4.5 //w=0.15 //l=0.15 //layer=via1 //count=1 \
 //x=12.33 //y=2.775 //x2=12.33 //y2=2.775
r488 (  19 55 ) resistor r=9.3 //w=0.17 //l=0.17 //layer=mcon //count=1 \
 //x=12.33 //y=4.88 //x2=12.33 //y2=4.88
r489 (  17 46 ) resistor r=9.3 //w=0.17 //l=0.17 //layer=mcon //count=1 \
 //x=12.33 //y=2.26 //x2=12.33 //y2=2.26
r490 (  10 28 ) resistor r=0.0715665 //w=0.226 //l=0.115996 //layer=m1 \
 //thickness=0.36 //x=26.76 //y=2.375 //x2=26.762 //y2=2.26
r491 (  10 11 ) resistor r=0.224237 //w=0.131 //l=0.235 //layer=m1 \
 //thickness=0.36 //x=26.76 //y=2.375 //x2=26.76 //y2=2.61
r492 (  9 19 ) resistor r=0.0717383 //w=0.224 //l=0.115 //layer=m1 \
 //thickness=0.36 //x=12.33 //y=4.765 //x2=12.33 //y2=4.88
r493 (  8 22 ) resistor r=0.0911593 //w=0.376 //l=0.184174 //layer=m1 \
 //thickness=0.36 //x=12.33 //y=2.935 //x2=12.382 //y2=2.775
r494 (  8 9 ) resistor r=1.74618 //w=0.131 //l=1.83 //layer=m1 \
 //thickness=0.36 //x=12.33 //y=2.935 //x2=12.33 //y2=4.765
r495 (  6 17 ) resistor r=0.0715665 //w=0.226 //l=0.115996 //layer=m1 \
 //thickness=0.36 //x=12.33 //y=2.375 //x2=12.332 //y2=2.26
r496 (  6 7 ) resistor r=0.229008 //w=0.131 //l=0.24 //layer=m1 \
 //thickness=0.36 //x=12.33 //y=2.375 //x2=12.33 //y2=2.615
r497 (  5 69 ) resistor r=9.3 //w=0.17 //l=0.17 //layer=mcon //count=1 \
 //x=26.76 //y=4.88 //x2=26.76 //y2=4.88
r498 (  5 13 ) resistor r=0.0717383 //w=0.224 //l=0.115 //layer=m1 \
 //thickness=0.36 //x=26.76 //y=4.88 //x2=26.76 //y2=4.765
r499 (  4 44 ) resistor r=4.5 //w=0.15 //l=0.15 //layer=via1 //count=1 \
 //x=26.76 //y=2.77 //x2=26.76 //y2=2.77
r500 (  4 12 ) resistor r=0.0911593 //w=0.376 //l=0.184608 //layer=m1 \
 //thickness=0.36 //x=26.707 //y=2.77 //x2=26.76 //y2=2.93
r501 (  4 11 ) resistor r=0.0911593 //w=0.376 //l=0.184608 //layer=m1 \
 //thickness=0.36 //x=26.707 //y=2.77 //x2=26.76 //y2=2.61
r502 (  3 22 ) resistor r=0.00166223 //w=0.376 //l=0.005 //layer=m1 \
 //thickness=0.36 //x=12.382 //y=2.77 //x2=12.382 //y2=2.775
r503 (  3 7 ) resistor r=0.0894971 //w=0.376 //l=0.179123 //layer=m1 \
 //thickness=0.36 //x=12.382 //y=2.77 //x2=12.33 //y2=2.615
r504 (  2 13 ) resistor r=1.19752 //w=0.131 //l=1.255 //layer=m1 \
 //thickness=0.36 //x=26.76 //y=3.51 //x2=26.76 //y2=4.765
r505 (  1 2 ) resistor r=0.353053 //w=0.131 //l=0.37 //layer=m1 \
 //thickness=0.36 //x=26.76 //y=3.14 //x2=26.76 //y2=3.51
r506 (  1 12 ) resistor r=0.200382 //w=0.131 //l=0.21 //layer=m1 \
 //thickness=0.36 //x=26.76 //y=3.14 //x2=26.76 //y2=2.93
ends PM_DFFSNRNQNX1\%SN

subckt PM_DFFSNRNQNX1\%noxref_8 ( 1 2 3 4 5 6 7 8 9 11 14 15 17 18 19 20 22 23 \
 24 25 26 27 28 34 38 44 47 50 58 62 67 69 71 72 73 74 75 77 82 94 99 104 113 \
 118 126 134 151 160 164 165 166 167 168 169 170 171 172 176 177 178 183 185 \
 188 189 193 194 195 200 202 205 206 210 211 212 217 219 222 223 225 226 231 \
 235 236 241 245 246 251 254 256 257 258 )
c628 ( 254 0 ) capacitor c=0.00885916f //x=18.315 //y=1.095
c629 ( 251 0 ) capacitor c=0.0638647f //x=27.87 //y=4.88
c630 ( 246 0 ) capacitor c=0.0278202f //x=27.87 //y=2.095
c631 ( 245 0 ) capacitor c=0.0503043f //x=27.87 //y=2.26
c632 ( 241 0 ) capacitor c=0.0638624f //x=13.44 //y=4.88
c633 ( 236 0 ) capacitor c=0.0278202f //x=13.44 //y=2.095
c634 ( 235 0 ) capacitor c=0.0503043f //x=13.44 //y=2.26
c635 ( 231 0 ) capacitor c=0.0638746f //x=8.63 //y=4.88
c636 ( 226 0 ) capacitor c=0.0278202f //x=8.63 //y=2.095
c637 ( 225 0 ) capacitor c=0.0503043f //x=8.63 //y=2.26
c638 ( 223 0 ) capacitor c=0.0443175f //x=28.39 //y=1.44
c639 ( 222 0 ) capacitor c=0.0199703f //x=28.39 //y=1.095
c640 ( 219 0 ) capacitor c=0.0162526f //x=28.235 //y=1.595
c641 ( 217 0 ) capacitor c=0.0157807f //x=28.235 //y=0.94
c642 ( 212 0 ) capacitor c=0.0220935f //x=27.86 //y=1.75
c643 ( 211 0 ) capacitor c=0.0207489f //x=27.86 //y=1.44
c644 ( 210 0 ) capacitor c=0.0194091f //x=27.86 //y=1.095
c645 ( 206 0 ) capacitor c=0.0443175f //x=13.96 //y=1.44
c646 ( 205 0 ) capacitor c=0.0199703f //x=13.96 //y=1.095
c647 ( 202 0 ) capacitor c=0.0162526f //x=13.805 //y=1.595
c648 ( 200 0 ) capacitor c=0.0157807f //x=13.805 //y=0.94
c649 ( 195 0 ) capacitor c=0.0220935f //x=13.43 //y=1.75
c650 ( 194 0 ) capacitor c=0.0207489f //x=13.43 //y=1.44
c651 ( 193 0 ) capacitor c=0.0194091f //x=13.43 //y=1.095
c652 ( 189 0 ) capacitor c=0.0443175f //x=9.15 //y=1.44
c653 ( 188 0 ) capacitor c=0.0199703f //x=9.15 //y=1.095
c654 ( 185 0 ) capacitor c=0.0162526f //x=8.995 //y=1.595
c655 ( 183 0 ) capacitor c=0.0157807f //x=8.995 //y=0.94
c656 ( 178 0 ) capacitor c=0.0220935f //x=8.62 //y=1.75
c657 ( 177 0 ) capacitor c=0.0207489f //x=8.62 //y=1.44
c658 ( 176 0 ) capacitor c=0.0194091f //x=8.62 //y=1.095
c659 ( 172 0 ) capacitor c=0.159671f //x=28.05 //y=6.2
c660 ( 171 0 ) capacitor c=0.110208f //x=27.61 //y=6.2
c661 ( 170 0 ) capacitor c=0.159671f //x=13.62 //y=6.2
c662 ( 169 0 ) capacitor c=0.110208f //x=13.18 //y=6.2
c663 ( 168 0 ) capacitor c=0.159671f //x=8.81 //y=6.2
c664 ( 167 0 ) capacitor c=0.110208f //x=8.37 //y=6.2
c665 ( 160 0 ) capacitor c=5.05592e-19 //x=27.87 //y=4.88
c666 ( 151 0 ) capacitor c=0.00101179f //x=27.87 //y=2.26
c667 ( 134 0 ) capacitor c=0.0293124f //x=18.21 //y=5.56
c668 ( 126 0 ) capacitor c=0.029329f //x=17.33 //y=5.56
c669 ( 118 0 ) capacitor c=0.0278099f //x=16.45 //y=5.56
c670 ( 113 0 ) capacitor c=5.2216e-19 //x=13.44 //y=4.88
c671 ( 104 0 ) capacitor c=0.00101179f //x=13.44 //y=2.26
c672 ( 99 0 ) capacitor c=5.39221e-19 //x=8.63 //y=4.88
c673 ( 94 0 ) capacitor c=0.00101179f //x=8.63 //y=2.26
c674 ( 82 0 ) capacitor c=6.81422e-19 //x=8.78 //y=4.255
c675 ( 77 0 ) capacitor c=0.120577f //x=23.275 //y=4.27
c676 ( 75 0 ) capacitor c=0.0409785f //x=22.675 //y=4.25
c677 ( 74 0 ) capacitor c=0.0200015f //x=20.705 //y=4.265
c678 ( 73 0 ) capacitor c=0.00609347f //x=21.05 //y=4.265
c679 ( 72 0 ) capacitor c=0.0408137f //x=13.6 //y=4.25
c680 ( 71 0 ) capacitor c=0.0536518f //x=18.83 //y=4.25
c681 ( 69 0 ) capacitor c=0.0015766f //x=9.575 //y=4.27
c682 ( 67 0 ) capacitor c=0.00400084f //x=8.975 //y=4.25
c683 ( 62 0 ) capacitor c=0.0147218f //x=27.87 //y=4.25
c684 ( 58 0 ) capacitor c=0.0151236f //x=18.99 //y=4.25
c685 ( 50 0 ) capacitor c=6.61608e-19 //x=18.21 //y=5.335
c686 ( 47 0 ) capacitor c=0.00763653f //x=17.33 //y=5.335
c687 ( 44 0 ) capacitor c=0.0111234f //x=16.452 //y=5.335
c688 ( 38 0 ) capacitor c=0.0144764f //x=13.44 //y=4.25
c689 ( 34 0 ) capacitor c=0.0148013f //x=8.625 //y=4.25
c690 ( 28 0 ) capacitor c=0.0116157f //x=27.87 //y=4.75
c691 ( 27 0 ) capacitor c=0.0108716f //x=27.87 //y=4.405
c692 ( 26 0 ) capacitor c=0.0430026f //x=27.87 //y=4.085
c693 ( 25 0 ) capacitor c=0.00707253f //x=27.87 //y=2.375
c694 ( 24 0 ) capacitor c=0.0221279f //x=18.99 //y=5.25
c695 ( 23 0 ) capacitor c=0.0130572f //x=18.99 //y=4.405
c696 ( 22 0 ) capacitor c=0.0636187f //x=18.99 //y=4.085
c697 ( 20 0 ) capacitor c=0.0058857f //x=18.59 //y=1.845
c698 ( 19 0 ) capacitor c=0.014982f //x=18.905 //y=1.845
c699 ( 18 0 ) capacitor c=0.0167992f //x=18.505 //y=1.76
c700 ( 17 0 ) capacitor c=0.0113053f //x=18.505 //y=1.305
c701 ( 15 0 ) capacitor c=0.0230241f //x=18.905 //y=5.335
c702 ( 14 0 ) capacitor c=0.00933983f //x=18.21 //y=5.56
c703 ( 11 0 ) capacitor c=0.0194761f //x=18.095 //y=5.335
c704 ( 9 0 ) capacitor c=0.0144424f //x=17.21 //y=5.335
c705 ( 8 0 ) capacitor c=0.0103259f //x=13.44 //y=4.75
c706 ( 7 0 ) capacitor c=0.0108895f //x=13.44 //y=4.41
c707 ( 6 0 ) capacitor c=0.0394184f //x=13.44 //y=4.09
c708 ( 5 0 ) capacitor c=0.00707394f //x=13.44 //y=2.375
c709 ( 4 0 ) capacitor c=0.0102184f //x=8.63 //y=4.75
c710 ( 3 0 ) capacitor c=0.0115006f //x=8.63 //y=4.415
c711 ( 2 0 ) capacitor c=0.0405702f //x=8.63 //y=4.095
c712 ( 1 0 ) capacitor c=0.00707535f //x=8.63 //y=2.375
r713 (  245 246 ) resistor r=52.7279 //w=0.214 //l=0.165 //layer=ply \
 //thickness=0.18 //x=27.87 //y=2.26 //x2=27.87 //y2=2.095
r714 (  235 236 ) resistor r=52.7279 //w=0.214 //l=0.165 //layer=ply \
 //thickness=0.18 //x=13.44 //y=2.26 //x2=13.44 //y2=2.095
r715 (  225 226 ) resistor r=52.7279 //w=0.214 //l=0.165 //layer=ply \
 //thickness=0.18 //x=8.63 //y=2.26 //x2=8.63 //y2=2.095
r716 (  223 253 ) resistor r=45.1352 //w=0.168 //l=0.173853 //layer=ply \
 //thickness=0.18 //x=28.39 //y=1.44 //x2=28.35 //y2=1.595
r717 (  222 252 ) resistor r=45.1352 //w=0.168 //l=0.173853 //layer=ply \
 //thickness=0.18 //x=28.39 //y=1.095 //x2=28.35 //y2=0.94
r718 (  222 223 ) resistor r=176.904 //w=0.094 //l=0.345 //layer=ply \
 //thickness=0.18 //x=28.39 //y=1.095 //x2=28.39 //y2=1.44
r719 (  220 249 ) resistor r=10.701 //w=0.21 //l=0.115 //layer=ply \
 //thickness=0.18 //x=28.015 //y=1.595 //x2=27.9 //y2=1.595
r720 (  219 253 ) resistor r=5.52526 //w=0.168 //l=0.115 //layer=ply \
 //thickness=0.18 //x=28.235 //y=1.595 //x2=28.35 //y2=1.595
r721 (  218 248 ) resistor r=5.52526 //w=0.168 //l=0.115 //layer=ply \
 //thickness=0.18 //x=28.015 //y=0.94 //x2=27.9 //y2=0.94
r722 (  217 252 ) resistor r=5.52526 //w=0.168 //l=0.115 //layer=ply \
 //thickness=0.18 //x=28.235 //y=0.94 //x2=28.35 //y2=0.94
r723 (  217 218 ) resistor r=112.809 //w=0.094 //l=0.22 //layer=ply \
 //thickness=0.18 //x=28.235 //y=0.94 //x2=28.015 //y2=0.94
r724 (  214 251 ) resistor r=37.236 //w=0.233 //l=0.249199 //layer=ply \
 //thickness=0.18 //x=28.05 //y=5.045 //x2=27.87 //y2=4.88
r725 (  212 249 ) resistor r=39.5823 //w=0.21 //l=0.173853 //layer=ply \
 //thickness=0.18 //x=27.86 //y=1.75 //x2=27.9 //y2=1.595
r726 (  212 246 ) resistor r=176.904 //w=0.094 //l=0.345 //layer=ply \
 //thickness=0.18 //x=27.86 //y=1.75 //x2=27.86 //y2=2.095
r727 (  211 249 ) resistor r=39.5823 //w=0.21 //l=0.173853 //layer=ply \
 //thickness=0.18 //x=27.86 //y=1.44 //x2=27.9 //y2=1.595
r728 (  210 248 ) resistor r=45.1352 //w=0.168 //l=0.173853 //layer=ply \
 //thickness=0.18 //x=27.86 //y=1.095 //x2=27.9 //y2=0.94
r729 (  210 211 ) resistor r=176.904 //w=0.094 //l=0.345 //layer=ply \
 //thickness=0.18 //x=27.86 //y=1.095 //x2=27.86 //y2=1.44
r730 (  207 251 ) resistor r=53.7854 //w=0.233 //l=0.332415 //layer=ply \
 //thickness=0.18 //x=27.61 //y=5.045 //x2=27.87 //y2=4.88
r731 (  206 243 ) resistor r=45.1352 //w=0.168 //l=0.173853 //layer=ply \
 //thickness=0.18 //x=13.96 //y=1.44 //x2=13.92 //y2=1.595
r732 (  205 242 ) resistor r=45.1352 //w=0.168 //l=0.173853 //layer=ply \
 //thickness=0.18 //x=13.96 //y=1.095 //x2=13.92 //y2=0.94
r733 (  205 206 ) resistor r=176.904 //w=0.094 //l=0.345 //layer=ply \
 //thickness=0.18 //x=13.96 //y=1.095 //x2=13.96 //y2=1.44
r734 (  203 239 ) resistor r=10.701 //w=0.21 //l=0.115 //layer=ply \
 //thickness=0.18 //x=13.585 //y=1.595 //x2=13.47 //y2=1.595
r735 (  202 243 ) resistor r=5.52526 //w=0.168 //l=0.115 //layer=ply \
 //thickness=0.18 //x=13.805 //y=1.595 //x2=13.92 //y2=1.595
r736 (  201 238 ) resistor r=5.52526 //w=0.168 //l=0.115 //layer=ply \
 //thickness=0.18 //x=13.585 //y=0.94 //x2=13.47 //y2=0.94
r737 (  200 242 ) resistor r=5.52526 //w=0.168 //l=0.115 //layer=ply \
 //thickness=0.18 //x=13.805 //y=0.94 //x2=13.92 //y2=0.94
r738 (  200 201 ) resistor r=112.809 //w=0.094 //l=0.22 //layer=ply \
 //thickness=0.18 //x=13.805 //y=0.94 //x2=13.585 //y2=0.94
r739 (  197 241 ) resistor r=37.236 //w=0.233 //l=0.249199 //layer=ply \
 //thickness=0.18 //x=13.62 //y=5.045 //x2=13.44 //y2=4.88
r740 (  195 239 ) resistor r=39.5823 //w=0.21 //l=0.173853 //layer=ply \
 //thickness=0.18 //x=13.43 //y=1.75 //x2=13.47 //y2=1.595
r741 (  195 236 ) resistor r=176.904 //w=0.094 //l=0.345 //layer=ply \
 //thickness=0.18 //x=13.43 //y=1.75 //x2=13.43 //y2=2.095
r742 (  194 239 ) resistor r=39.5823 //w=0.21 //l=0.173853 //layer=ply \
 //thickness=0.18 //x=13.43 //y=1.44 //x2=13.47 //y2=1.595
r743 (  193 238 ) resistor r=45.1352 //w=0.168 //l=0.173853 //layer=ply \
 //thickness=0.18 //x=13.43 //y=1.095 //x2=13.47 //y2=0.94
r744 (  193 194 ) resistor r=176.904 //w=0.094 //l=0.345 //layer=ply \
 //thickness=0.18 //x=13.43 //y=1.095 //x2=13.43 //y2=1.44
r745 (  190 241 ) resistor r=53.7854 //w=0.233 //l=0.332415 //layer=ply \
 //thickness=0.18 //x=13.18 //y=5.045 //x2=13.44 //y2=4.88
r746 (  189 233 ) resistor r=45.1352 //w=0.168 //l=0.173853 //layer=ply \
 //thickness=0.18 //x=9.15 //y=1.44 //x2=9.11 //y2=1.595
r747 (  188 232 ) resistor r=45.1352 //w=0.168 //l=0.173853 //layer=ply \
 //thickness=0.18 //x=9.15 //y=1.095 //x2=9.11 //y2=0.94
r748 (  188 189 ) resistor r=176.904 //w=0.094 //l=0.345 //layer=ply \
 //thickness=0.18 //x=9.15 //y=1.095 //x2=9.15 //y2=1.44
r749 (  186 229 ) resistor r=10.701 //w=0.21 //l=0.115 //layer=ply \
 //thickness=0.18 //x=8.775 //y=1.595 //x2=8.66 //y2=1.595
r750 (  185 233 ) resistor r=5.52526 //w=0.168 //l=0.115 //layer=ply \
 //thickness=0.18 //x=8.995 //y=1.595 //x2=9.11 //y2=1.595
r751 (  184 228 ) resistor r=5.52526 //w=0.168 //l=0.115 //layer=ply \
 //thickness=0.18 //x=8.775 //y=0.94 //x2=8.66 //y2=0.94
r752 (  183 232 ) resistor r=5.52526 //w=0.168 //l=0.115 //layer=ply \
 //thickness=0.18 //x=8.995 //y=0.94 //x2=9.11 //y2=0.94
r753 (  183 184 ) resistor r=112.809 //w=0.094 //l=0.22 //layer=ply \
 //thickness=0.18 //x=8.995 //y=0.94 //x2=8.775 //y2=0.94
r754 (  180 231 ) resistor r=37.236 //w=0.233 //l=0.249199 //layer=ply \
 //thickness=0.18 //x=8.81 //y=5.045 //x2=8.63 //y2=4.88
r755 (  178 229 ) resistor r=39.5823 //w=0.21 //l=0.173853 //layer=ply \
 //thickness=0.18 //x=8.62 //y=1.75 //x2=8.66 //y2=1.595
r756 (  178 226 ) resistor r=176.904 //w=0.094 //l=0.345 //layer=ply \
 //thickness=0.18 //x=8.62 //y=1.75 //x2=8.62 //y2=2.095
r757 (  177 229 ) resistor r=39.5823 //w=0.21 //l=0.173853 //layer=ply \
 //thickness=0.18 //x=8.62 //y=1.44 //x2=8.66 //y2=1.595
r758 (  176 228 ) resistor r=45.1352 //w=0.168 //l=0.173853 //layer=ply \
 //thickness=0.18 //x=8.62 //y=1.095 //x2=8.66 //y2=0.94
r759 (  176 177 ) resistor r=176.904 //w=0.094 //l=0.345 //layer=ply \
 //thickness=0.18 //x=8.62 //y=1.095 //x2=8.62 //y2=1.44
r760 (  173 231 ) resistor r=53.7854 //w=0.233 //l=0.332415 //layer=ply \
 //thickness=0.18 //x=8.37 //y=5.045 //x2=8.63 //y2=4.88
r761 (  172 214 ) resistor r=592.245 //w=0.094 //l=1.155 //layer=ply \
 //thickness=0.18 //x=28.05 //y=6.2 //x2=28.05 //y2=5.045
r762 (  171 207 ) resistor r=592.245 //w=0.094 //l=1.155 //layer=ply \
 //thickness=0.18 //x=27.61 //y=6.2 //x2=27.61 //y2=5.045
r763 (  170 197 ) resistor r=592.245 //w=0.094 //l=1.155 //layer=ply \
 //thickness=0.18 //x=13.62 //y=6.2 //x2=13.62 //y2=5.045
r764 (  169 190 ) resistor r=592.245 //w=0.094 //l=1.155 //layer=ply \
 //thickness=0.18 //x=13.18 //y=6.2 //x2=13.18 //y2=5.045
r765 (  168 180 ) resistor r=592.245 //w=0.094 //l=1.155 //layer=ply \
 //thickness=0.18 //x=8.81 //y=6.2 //x2=8.81 //y2=5.045
r766 (  167 173 ) resistor r=592.245 //w=0.094 //l=1.155 //layer=ply \
 //thickness=0.18 //x=8.37 //y=6.2 //x2=8.37 //y2=5.045
r767 (  166 219 ) resistor r=56.4043 //w=0.094 //l=0.11 //layer=ply \
 //thickness=0.18 //x=28.125 //y=1.595 //x2=28.235 //y2=1.595
r768 (  166 220 ) resistor r=56.4043 //w=0.094 //l=0.11 //layer=ply \
 //thickness=0.18 //x=28.125 //y=1.595 //x2=28.015 //y2=1.595
r769 (  165 202 ) resistor r=56.4043 //w=0.094 //l=0.11 //layer=ply \
 //thickness=0.18 //x=13.695 //y=1.595 //x2=13.805 //y2=1.595
r770 (  165 203 ) resistor r=56.4043 //w=0.094 //l=0.11 //layer=ply \
 //thickness=0.18 //x=13.695 //y=1.595 //x2=13.585 //y2=1.595
r771 (  164 185 ) resistor r=56.4043 //w=0.094 //l=0.11 //layer=ply \
 //thickness=0.18 //x=8.885 //y=1.595 //x2=8.995 //y2=1.595
r772 (  164 186 ) resistor r=56.4043 //w=0.094 //l=0.11 //layer=ply \
 //thickness=0.18 //x=8.885 //y=1.595 //x2=8.775 //y2=1.595
r773 (  160 251 ) resistor r=152 //w=0.17 //l=0.17 //layer=licon //count=1 \
 //x=27.87 //y=4.88 //x2=27.87 //y2=4.88
r774 (  151 245 ) resistor r=152 //w=0.17 //l=0.17 //layer=licon //count=1 \
 //x=27.87 //y=2.26 //x2=27.87 //y2=2.26
r775 (  134 258 ) resistor r=23.615 //w=0.187 //l=0.345 //layer=li \
 //thickness=0.1 //x=18.21 //y=5.56 //x2=18.21 //y2=5.905
r776 (  126 257 ) resistor r=23.615 //w=0.187 //l=0.345 //layer=li \
 //thickness=0.1 //x=17.33 //y=5.56 //x2=17.33 //y2=5.905
r777 (  118 256 ) resistor r=23.615 //w=0.187 //l=0.345 //layer=li \
 //thickness=0.1 //x=16.45 //y=5.56 //x2=16.45 //y2=5.905
r778 (  113 241 ) resistor r=152 //w=0.17 //l=0.17 //layer=licon //count=1 \
 //x=13.44 //y=4.88 //x2=13.44 //y2=4.88
r779 (  104 235 ) resistor r=152 //w=0.17 //l=0.17 //layer=licon //count=1 \
 //x=13.44 //y=2.26 //x2=13.44 //y2=2.26
r780 (  99 231 ) resistor r=152 //w=0.17 //l=0.17 //layer=licon //count=1 \
 //x=8.63 //y=4.88 //x2=8.63 //y2=4.88
r781 (  94 225 ) resistor r=152 //w=0.17 //l=0.17 //layer=licon //count=1 \
 //x=8.63 //y=2.26 //x2=8.63 //y2=2.26
r782 (  80 82 ) resistor r=0.10734 //w=0.281 //l=0.16 //layer=m2 \
 //thickness=0.36 //x=8.62 //y=4.255 //x2=8.78 //y2=4.255
r783 (  77 88 ) resistor r=3.17396 //w=0.181 //l=4.60748 //layer=m2 \
 //thickness=0.36 //x=23.275 //y=4.27 //x2=27.87 //y2=4.245
r784 (  77 78 ) resistor r=0.329198 //w=0.131 //l=0.345 //layer=m2 \
 //thickness=0.36 //x=23.275 //y=4.27 //x2=22.93 //y2=4.27
r785 (  75 78 ) resistor r=0.1875 //w=0.17 //l=0.264811 //layer=m2 \
 //thickness=0.36 //x=22.675 //y=4.25 //x2=22.93 //y2=4.27
r786 (  75 76 ) resistor r=1.38836 //w=0.131 //l=1.455 //layer=m2 \
 //thickness=0.36 //x=22.675 //y=4.25 //x2=21.22 //y2=4.25
r787 (  74 86 ) resistor r=1.09629 //w=0.196 //l=1.72497 //layer=m2 \
 //thickness=0.36 //x=20.705 //y=4.265 //x2=18.99 //y2=4.245
r788 (  73 76 ) resistor r=0.125 //w=0.17 //l=0.177341 //layer=m2 \
 //thickness=0.36 //x=21.05 //y=4.265 //x2=21.22 //y2=4.25
r789 (  73 74 ) resistor r=0.329198 //w=0.131 //l=0.345 //layer=m2 \
 //thickness=0.36 //x=21.05 //y=4.265 //x2=20.705 //y2=4.265
r790 (  72 84 ) resistor r=0.110608 //w=0.182 //l=0.16 //layer=m2 \
 //thickness=0.36 //x=13.6 //y=4.25 //x2=13.44 //y2=4.25
r791 (  71 86 ) resistor r=0.104578 //w=0.196 //l=0.162481 //layer=m2 \
 //thickness=0.36 //x=18.83 //y=4.25 //x2=18.99 //y2=4.245
r792 (  71 72 ) resistor r=4.99046 //w=0.131 //l=5.23 //layer=m2 \
 //thickness=0.36 //x=18.83 //y=4.25 //x2=13.6 //y2=4.25
r793 (  69 84 ) resistor r=2.65525 //w=0.182 //l=3.87499 //layer=m2 \
 //thickness=0.36 //x=9.575 //y=4.27 //x2=13.44 //y2=4.25
r794 (  69 70 ) resistor r=0.329198 //w=0.131 //l=0.345 //layer=m2 \
 //thickness=0.36 //x=9.575 //y=4.27 //x2=9.23 //y2=4.27
r795 (  67 70 ) resistor r=0.1875 //w=0.17 //l=0.264811 //layer=m2 \
 //thickness=0.36 //x=8.975 //y=4.25 //x2=9.23 //y2=4.27
r796 (  67 82 ) resistor r=0.186069 //w=0.131 //l=0.195 //layer=m2 \
 //thickness=0.36 //x=8.975 //y=4.25 //x2=8.78 //y2=4.25
r797 (  66 160 ) resistor r=9.3 //w=0.17 //l=0.17 //layer=mcon //count=1 \
 //x=27.87 //y=4.88 //x2=27.87 //y2=4.88
r798 (  64 151 ) resistor r=9.3 //w=0.17 //l=0.17 //layer=mcon //count=1 \
 //x=27.87 //y=2.26 //x2=27.87 //y2=2.26
r799 (  60 88 ) resistor r=4.5 //w=0.15 //l=0.15 //layer=via1 //count=1 \
 //x=27.87 //y=4.245 //x2=27.87 //y2=4.245
r800 (  60 62 ) resistor r=0.00166223 //w=0.376 //l=0.005 //layer=m1 \
 //thickness=0.36 //x=27.817 //y=4.245 //x2=27.817 //y2=4.25
r801 (  56 86 ) resistor r=4.5 //w=0.15 //l=0.15 //layer=via1 //count=1 \
 //x=18.99 //y=4.245 //x2=18.99 //y2=4.245
r802 (  56 58 ) resistor r=0.00166223 //w=0.376 //l=0.005 //layer=m1 \
 //thickness=0.36 //x=19.042 //y=4.245 //x2=19.042 //y2=4.25
r803 (  54 254 ) resistor r=9.3 //w=0.17 //l=0.17 //layer=mcon //count=1 \
 //x=18.505 //y=1.19 //x2=18.505 //y2=1.19
r804 (  52 134 ) resistor r=9.3 //w=0.17 //l=0.17 //layer=mcon //count=1 \
 //x=18.21 //y=5.56 //x2=18.21 //y2=5.56
r805 (  49 126 ) resistor r=9.3 //w=0.17 //l=0.17 //layer=mcon //count=1 \
 //x=17.33 //y=5.56 //x2=17.33 //y2=5.56
r806 (  47 49 ) resistor r=0.121228 //w=0.232 //l=0.225 //layer=m1 \
 //thickness=0.36 //x=17.33 //y=5.335 //x2=17.33 //y2=5.56
r807 (  46 118 ) resistor r=9.3 //w=0.17 //l=0.17 //layer=mcon //count=1 \
 //x=16.45 //y=5.56 //x2=16.45 //y2=5.56
r808 (  44 46 ) resistor r=0.129608 //w=0.217 //l=0.225 //layer=m1 \
 //thickness=0.36 //x=16.452 //y=5.335 //x2=16.452 //y2=5.56
r809 (  43 113 ) resistor r=9.3 //w=0.17 //l=0.17 //layer=mcon //count=1 \
 //x=13.44 //y=4.88 //x2=13.44 //y2=4.88
r810 (  41 104 ) resistor r=9.3 //w=0.17 //l=0.17 //layer=mcon //count=1 \
 //x=13.44 //y=2.26 //x2=13.44 //y2=2.26
r811 (  38 84 ) resistor r=4.5 //w=0.15 //l=0.15 //layer=via1 //count=1 \
 //x=13.44 //y=4.25 //x2=13.44 //y2=4.25
r812 (  36 80 ) resistor r=4.5 //w=0.15 //l=0.15 //layer=via1 //count=1 \
 //x=8.62 //y=4.255 //x2=8.62 //y2=4.255
r813 (  34 36 ) resistor r=0.00164908 //w=0.379 //l=0.005 //layer=m1 \
 //thickness=0.36 //x=8.675 //y=4.25 //x2=8.675 //y2=4.255
r814 (  32 99 ) resistor r=9.3 //w=0.17 //l=0.17 //layer=mcon //count=1 \
 //x=8.63 //y=4.88 //x2=8.63 //y2=4.88
r815 (  30 94 ) resistor r=9.3 //w=0.17 //l=0.17 //layer=mcon //count=1 \
 //x=8.63 //y=2.26 //x2=8.63 //y2=2.26
r816 (  28 66 ) resistor r=0.0801089 //w=0.224 //l=0.13 //layer=m1 \
 //thickness=0.36 //x=27.87 //y=4.75 //x2=27.87 //y2=4.88
r817 (  27 62 ) resistor r=0.0894971 //w=0.376 //l=0.179555 //layer=m1 \
 //thickness=0.36 //x=27.87 //y=4.405 //x2=27.817 //y2=4.25
r818 (  27 28 ) resistor r=0.329198 //w=0.131 //l=0.345 //layer=m1 \
 //thickness=0.36 //x=27.87 //y=4.405 //x2=27.87 //y2=4.75
r819 (  26 60 ) resistor r=0.0911593 //w=0.376 //l=0.184608 //layer=m1 \
 //thickness=0.36 //x=27.87 //y=4.085 //x2=27.817 //y2=4.245
r820 (  25 64 ) resistor r=0.0719237 //w=0.222 //l=0.115 //layer=m1 \
 //thickness=0.36 //x=27.87 //y=2.375 //x2=27.87 //y2=2.26
r821 (  25 26 ) resistor r=1.63168 //w=0.131 //l=1.71 //layer=m1 \
 //thickness=0.36 //x=27.87 //y=2.375 //x2=27.87 //y2=4.085
r822 (  23 58 ) resistor r=0.0894971 //w=0.376 //l=0.179123 //layer=m1 \
 //thickness=0.36 //x=18.99 //y=4.405 //x2=19.042 //y2=4.25
r823 (  23 24 ) resistor r=0.806298 //w=0.131 //l=0.845 //layer=m1 \
 //thickness=0.36 //x=18.99 //y=4.405 //x2=18.99 //y2=5.25
r824 (  22 56 ) resistor r=0.0911593 //w=0.376 //l=0.184174 //layer=m1 \
 //thickness=0.36 //x=18.99 //y=4.085 //x2=19.042 //y2=4.245
r825 (  21 22 ) resistor r=2.0563 //w=0.131 //l=2.155 //layer=m1 \
 //thickness=0.36 //x=18.99 //y=1.93 //x2=18.99 //y2=4.085
r826 (  19 21 ) resistor r=0.0698411 //w=0.17 //l=0.120208 //layer=m1 \
 //thickness=0.36 //x=18.905 //y=1.845 //x2=18.99 //y2=1.93
r827 (  19 20 ) resistor r=0.300573 //w=0.131 //l=0.315 //layer=m1 \
 //thickness=0.36 //x=18.905 //y=1.845 //x2=18.59 //y2=1.845
r828 (  18 20 ) resistor r=0.0698411 //w=0.17 //l=0.120208 //layer=m1 \
 //thickness=0.36 //x=18.505 //y=1.76 //x2=18.59 //y2=1.845
r829 (  17 54 ) resistor r=0.0717383 //w=0.224 //l=0.115 //layer=m1 \
 //thickness=0.36 //x=18.505 //y=1.305 //x2=18.505 //y2=1.19
r830 (  17 18 ) resistor r=0.43416 //w=0.131 //l=0.455 //layer=m1 \
 //thickness=0.36 //x=18.505 //y=1.305 //x2=18.505 //y2=1.76
r831 (  16 50 ) resistor r=0.0675342 //w=0.23 //l=0.115 //layer=m1 \
 //thickness=0.36 //x=18.325 //y=5.335 //x2=18.21 //y2=5.335
r832 (  15 24 ) resistor r=0.0698411 //w=0.17 //l=0.120208 //layer=m1 \
 //thickness=0.36 //x=18.905 //y=5.335 //x2=18.99 //y2=5.25
r833 (  15 16 ) resistor r=0.553435 //w=0.131 //l=0.58 //layer=m1 \
 //thickness=0.36 //x=18.905 //y=5.335 //x2=18.325 //y2=5.335
r834 (  14 52 ) resistor r=0.00118313 //w=0.23 //layer=m1 //thickness=0.36 \
 //x=18.21 //y=5.56 //x2=18.21 //y2=5.56
r835 (  13 50 ) resistor r=0.002872 //w=0.34 //l=0.085 //layer=m1 \
 //thickness=0.36 //x=18.21 //y=5.42 //x2=18.21 //y2=5.335
r836 (  13 14 ) resistor r=0.091623 //w=0.191 //l=0.14 //layer=m1 \
 //thickness=0.36 //x=18.21 //y=5.42 //x2=18.21 //y2=5.56
r837 (  12 47 ) resistor r=0.0262263 //w=0.232 //l=0.12 //layer=m1 \
 //thickness=0.36 //x=17.45 //y=5.335 //x2=17.33 //y2=5.335
r838 (  11 50 ) resistor r=0.0675342 //w=0.23 //l=0.115 //layer=m1 \
 //thickness=0.36 //x=18.095 //y=5.335 //x2=18.21 //y2=5.335
r839 (  11 12 ) resistor r=0.615458 //w=0.131 //l=0.645 //layer=m1 \
 //thickness=0.36 //x=18.095 //y=5.335 //x2=17.45 //y2=5.335
r840 (  10 44 ) resistor r=0.0222262 //w=0.217 //l=0.118 //layer=m1 \
 //thickness=0.36 //x=16.57 //y=5.335 //x2=16.452 //y2=5.335
r841 (  9 47 ) resistor r=0.0262263 //w=0.232 //l=0.12 //layer=m1 \
 //thickness=0.36 //x=17.21 //y=5.335 //x2=17.33 //y2=5.335
r842 (  9 10 ) resistor r=0.610687 //w=0.131 //l=0.64 //layer=m1 \
 //thickness=0.36 //x=17.21 //y=5.335 //x2=16.57 //y2=5.335
r843 (  8 43 ) resistor r=0.0801089 //w=0.224 //l=0.13 //layer=m1 \
 //thickness=0.36 //x=13.44 //y=4.75 //x2=13.44 //y2=4.88
r844 (  7 38 ) resistor r=0.0911593 //w=0.376 //l=0.184608 //layer=m1 \
 //thickness=0.36 //x=13.44 //y=4.41 //x2=13.387 //y2=4.25
r845 (  7 8 ) resistor r=0.324427 //w=0.131 //l=0.34 //layer=m1 \
 //thickness=0.36 //x=13.44 //y=4.41 //x2=13.44 //y2=4.75
r846 (  6 38 ) resistor r=0.0911593 //w=0.376 //l=0.184608 //layer=m1 \
 //thickness=0.36 //x=13.44 //y=4.09 //x2=13.387 //y2=4.25
r847 (  5 41 ) resistor r=0.0719237 //w=0.222 //l=0.115 //layer=m1 \
 //thickness=0.36 //x=13.44 //y=2.375 //x2=13.44 //y2=2.26
r848 (  5 6 ) resistor r=1.63645 //w=0.131 //l=1.715 //layer=m1 \
 //thickness=0.36 //x=13.44 //y=2.375 //x2=13.44 //y2=4.09
r849 (  4 32 ) resistor r=0.0801089 //w=0.224 //l=0.13 //layer=m1 \
 //thickness=0.36 //x=8.63 //y=4.75 //x2=8.63 //y2=4.88
r850 (  3 36 ) resistor r=0.0912814 //w=0.379 //l=0.181108 //layer=m1 \
 //thickness=0.36 //x=8.63 //y=4.415 //x2=8.675 //y2=4.255
r851 (  3 4 ) resistor r=0.319656 //w=0.131 //l=0.335 //layer=m1 \
 //thickness=0.36 //x=8.63 //y=4.415 //x2=8.63 //y2=4.75
r852 (  2 34 ) resistor r=0.0896323 //w=0.379 //l=0.176068 //layer=m1 \
 //thickness=0.36 //x=8.63 //y=4.095 //x2=8.675 //y2=4.25
r853 (  1 30 ) resistor r=0.0719237 //w=0.222 //l=0.115 //layer=m1 \
 //thickness=0.36 //x=8.63 //y=2.375 //x2=8.63 //y2=2.26
r854 (  1 2 ) resistor r=1.64122 //w=0.131 //l=1.72 //layer=m1 \
 //thickness=0.36 //x=8.63 //y=2.375 //x2=8.63 //y2=4.095
ends PM_DFFSNRNQNX1\%noxref_8

subckt PM_DFFSNRNQNX1\%noxref_9 ( 1 2 3 4 5 7 10 11 13 14 15 16 18 19 20 26 29 \
 32 35 41 43 45 47 49 51 53 58 62 71 76 84 92 108 109 110 114 115 116 121 123 \
 126 127 129 130 135 138 140 141 142 )
c291 ( 138 0 ) capacitor c=0.00885916f //x=27.935 //y=1.095
c292 ( 135 0 ) capacitor c=0.065368f //x=23.06 //y=4.88
c293 ( 130 0 ) capacitor c=0.0278202f //x=23.06 //y=2.095
c294 ( 129 0 ) capacitor c=0.0503043f //x=23.06 //y=2.26
c295 ( 127 0 ) capacitor c=0.0443175f //x=23.58 //y=1.44
c296 ( 126 0 ) capacitor c=0.0199703f //x=23.58 //y=1.095
c297 ( 123 0 ) capacitor c=0.0162526f //x=23.425 //y=1.595
c298 ( 121 0 ) capacitor c=0.0157807f //x=23.425 //y=0.94
c299 ( 116 0 ) capacitor c=0.0220935f //x=23.05 //y=1.75
c300 ( 115 0 ) capacitor c=0.0207489f //x=23.05 //y=1.44
c301 ( 114 0 ) capacitor c=0.0194091f //x=23.05 //y=1.095
c302 ( 110 0 ) capacitor c=0.159671f //x=23.24 //y=6.2
c303 ( 109 0 ) capacitor c=0.110208f //x=22.8 //y=6.2
c304 ( 92 0 ) capacitor c=0.0293408f //x=27.83 //y=5.56
c305 ( 84 0 ) capacitor c=0.0292575f //x=26.95 //y=5.56
c306 ( 76 0 ) capacitor c=0.0278099f //x=26.07 //y=5.56
c307 ( 71 0 ) capacitor c=7.7417e-19 //x=23.06 //y=4.88
c308 ( 62 0 ) capacitor c=0.00101179f //x=23.06 //y=2.26
c309 ( 58 0 ) capacitor c=9.2699e-19 //x=23.22 //y=3.885
c310 ( 53 0 ) capacitor c=0.032195f //x=28.085 //y=3.86
c311 ( 51 0 ) capacitor c=0.033475f //x=27.485 //y=3.88
c312 ( 49 0 ) capacitor c=0.00485151f //x=25.865 //y=3.895
c313 ( 47 0 ) capacitor c=0.0181115f //x=25.265 //y=3.88
c314 ( 45 0 ) capacitor c=0.0042428f //x=24.015 //y=3.9
c315 ( 43 0 ) capacitor c=0.00436906f //x=23.415 //y=3.88
c316 ( 41 0 ) capacitor c=0.0182145f //x=28.61 //y=3.88
c317 ( 35 0 ) capacitor c=8.39376e-19 //x=27.83 //y=5.335
c318 ( 32 0 ) capacitor c=0.00790382f //x=26.95 //y=5.335
c319 ( 29 0 ) capacitor c=0.0113499f //x=26.072 //y=5.335
c320 ( 26 0 ) capacitor c=0.0164304f //x=23.06 //y=3.88
c321 ( 20 0 ) capacitor c=0.0441535f //x=28.61 //y=5.25
c322 ( 19 0 ) capacitor c=0.0129748f //x=28.61 //y=4.04
c323 ( 18 0 ) capacitor c=0.0750098f //x=28.61 //y=3.72
c324 ( 16 0 ) capacitor c=0.00698723f //x=28.21 //y=1.845
c325 ( 15 0 ) capacitor c=0.0168995f //x=28.525 //y=1.845
c326 ( 14 0 ) capacitor c=0.0167992f //x=28.125 //y=1.76
c327 ( 13 0 ) capacitor c=0.0143773f //x=28.125 //y=1.305
c328 ( 11 0 ) capacitor c=0.0263792f //x=28.525 //y=5.335
c329 ( 10 0 ) capacitor c=0.0124512f //x=27.83 //y=5.56
c330 ( 7 0 ) capacitor c=0.0183278f //x=27.715 //y=5.335
c331 ( 5 0 ) capacitor c=0.0151111f //x=26.83 //y=5.335
c332 ( 4 0 ) capacitor c=0.0201833f //x=23.06 //y=4.75
c333 ( 3 0 ) capacitor c=0.0117618f //x=23.06 //y=4.045
c334 ( 2 0 ) capacitor c=0.0358511f //x=23.06 //y=3.725
c335 ( 1 0 ) capacitor c=0.00696694f //x=23.06 //y=2.375
r336 (  129 130 ) resistor r=52.7279 //w=0.214 //l=0.165 //layer=ply \
 //thickness=0.18 //x=23.06 //y=2.26 //x2=23.06 //y2=2.095
r337 (  127 137 ) resistor r=45.1352 //w=0.168 //l=0.173853 //layer=ply \
 //thickness=0.18 //x=23.58 //y=1.44 //x2=23.54 //y2=1.595
r338 (  126 136 ) resistor r=45.1352 //w=0.168 //l=0.173853 //layer=ply \
 //thickness=0.18 //x=23.58 //y=1.095 //x2=23.54 //y2=0.94
r339 (  126 127 ) resistor r=176.904 //w=0.094 //l=0.345 //layer=ply \
 //thickness=0.18 //x=23.58 //y=1.095 //x2=23.58 //y2=1.44
r340 (  124 133 ) resistor r=10.701 //w=0.21 //l=0.115 //layer=ply \
 //thickness=0.18 //x=23.205 //y=1.595 //x2=23.09 //y2=1.595
r341 (  123 137 ) resistor r=5.52526 //w=0.168 //l=0.115 //layer=ply \
 //thickness=0.18 //x=23.425 //y=1.595 //x2=23.54 //y2=1.595
r342 (  122 132 ) resistor r=5.52526 //w=0.168 //l=0.115 //layer=ply \
 //thickness=0.18 //x=23.205 //y=0.94 //x2=23.09 //y2=0.94
r343 (  121 136 ) resistor r=5.52526 //w=0.168 //l=0.115 //layer=ply \
 //thickness=0.18 //x=23.425 //y=0.94 //x2=23.54 //y2=0.94
r344 (  121 122 ) resistor r=112.809 //w=0.094 //l=0.22 //layer=ply \
 //thickness=0.18 //x=23.425 //y=0.94 //x2=23.205 //y2=0.94
r345 (  118 135 ) resistor r=37.236 //w=0.233 //l=0.249199 //layer=ply \
 //thickness=0.18 //x=23.24 //y=5.045 //x2=23.06 //y2=4.88
r346 (  116 133 ) resistor r=39.5823 //w=0.21 //l=0.173853 //layer=ply \
 //thickness=0.18 //x=23.05 //y=1.75 //x2=23.09 //y2=1.595
r347 (  116 130 ) resistor r=176.904 //w=0.094 //l=0.345 //layer=ply \
 //thickness=0.18 //x=23.05 //y=1.75 //x2=23.05 //y2=2.095
r348 (  115 133 ) resistor r=39.5823 //w=0.21 //l=0.173853 //layer=ply \
 //thickness=0.18 //x=23.05 //y=1.44 //x2=23.09 //y2=1.595
r349 (  114 132 ) resistor r=45.1352 //w=0.168 //l=0.173853 //layer=ply \
 //thickness=0.18 //x=23.05 //y=1.095 //x2=23.09 //y2=0.94
r350 (  114 115 ) resistor r=176.904 //w=0.094 //l=0.345 //layer=ply \
 //thickness=0.18 //x=23.05 //y=1.095 //x2=23.05 //y2=1.44
r351 (  111 135 ) resistor r=53.7854 //w=0.233 //l=0.332415 //layer=ply \
 //thickness=0.18 //x=22.8 //y=5.045 //x2=23.06 //y2=4.88
r352 (  110 118 ) resistor r=592.245 //w=0.094 //l=1.155 //layer=ply \
 //thickness=0.18 //x=23.24 //y=6.2 //x2=23.24 //y2=5.045
r353 (  109 111 ) resistor r=592.245 //w=0.094 //l=1.155 //layer=ply \
 //thickness=0.18 //x=22.8 //y=6.2 //x2=22.8 //y2=5.045
r354 (  108 123 ) resistor r=56.4043 //w=0.094 //l=0.11 //layer=ply \
 //thickness=0.18 //x=23.315 //y=1.595 //x2=23.425 //y2=1.595
r355 (  108 124 ) resistor r=56.4043 //w=0.094 //l=0.11 //layer=ply \
 //thickness=0.18 //x=23.315 //y=1.595 //x2=23.205 //y2=1.595
r356 (  92 142 ) resistor r=23.615 //w=0.187 //l=0.345 //layer=li \
 //thickness=0.1 //x=27.83 //y=5.56 //x2=27.83 //y2=5.905
r357 (  84 141 ) resistor r=23.615 //w=0.187 //l=0.345 //layer=li \
 //thickness=0.1 //x=26.95 //y=5.56 //x2=26.95 //y2=5.905
r358 (  76 140 ) resistor r=23.615 //w=0.187 //l=0.345 //layer=li \
 //thickness=0.1 //x=26.07 //y=5.56 //x2=26.07 //y2=5.905
r359 (  71 135 ) resistor r=152 //w=0.17 //l=0.17 //layer=licon //count=1 \
 //x=23.06 //y=4.88 //x2=23.06 //y2=4.88
r360 (  62 129 ) resistor r=152 //w=0.17 //l=0.17 //layer=licon //count=1 \
 //x=23.06 //y=2.26 //x2=23.06 //y2=2.26
r361 (  56 58 ) resistor r=0.10734 //w=0.281 //l=0.16 //layer=m2 \
 //thickness=0.36 //x=23.06 //y=3.885 //x2=23.22 //y2=3.885
r362 (  53 60 ) resistor r=0.28331 //w=0.241 //l=0.534907 //layer=m2 \
 //thickness=0.36 //x=28.085 //y=3.86 //x2=28.61 //y2=3.88
r363 (  53 54 ) resistor r=0.410305 //w=0.131 //l=0.43 //layer=m2 \
 //thickness=0.36 //x=28.085 //y=3.86 //x2=27.655 //y2=3.86
r364 (  51 54 ) resistor r=0.125 //w=0.17 //l=0.179722 //layer=m2 \
 //thickness=0.36 //x=27.485 //y=3.88 //x2=27.655 //y2=3.86
r365 (  51 52 ) resistor r=1.38359 //w=0.131 //l=1.45 //layer=m2 \
 //thickness=0.36 //x=27.485 //y=3.88 //x2=26.035 //y2=3.88
r366 (  49 52 ) resistor r=0.125 //w=0.17 //l=0.177341 //layer=m2 \
 //thickness=0.36 //x=25.865 //y=3.895 //x2=26.035 //y2=3.88
r367 (  49 50 ) resistor r=0.329198 //w=0.131 //l=0.345 //layer=m2 \
 //thickness=0.36 //x=25.865 //y=3.895 //x2=25.52 //y2=3.895
r368 (  47 50 ) resistor r=0.1875 //w=0.17 //l=0.262393 //layer=m2 \
 //thickness=0.36 //x=25.265 //y=3.88 //x2=25.52 //y2=3.895
r369 (  47 48 ) resistor r=1.03053 //w=0.131 //l=1.08 //layer=m2 \
 //thickness=0.36 //x=25.265 //y=3.88 //x2=24.185 //y2=3.88
r370 (  45 48 ) resistor r=0.125 //w=0.17 //l=0.179722 //layer=m2 \
 //thickness=0.36 //x=24.015 //y=3.9 //x2=24.185 //y2=3.88
r371 (  45 46 ) resistor r=0.329198 //w=0.131 //l=0.345 //layer=m2 \
 //thickness=0.36 //x=24.015 //y=3.9 //x2=23.67 //y2=3.9
r372 (  43 46 ) resistor r=0.1875 //w=0.17 //l=0.264811 //layer=m2 \
 //thickness=0.36 //x=23.415 //y=3.88 //x2=23.67 //y2=3.9
r373 (  43 58 ) resistor r=0.186069 //w=0.131 //l=0.195 //layer=m2 \
 //thickness=0.36 //x=23.415 //y=3.88 //x2=23.22 //y2=3.88
r374 (  41 60 ) resistor r=4.5 //w=0.15 //l=0.15 //layer=via1 //count=1 \
 //x=28.61 //y=3.88 //x2=28.61 //y2=3.88
r375 (  39 138 ) resistor r=9.3 //w=0.17 //l=0.17 //layer=mcon //count=1 \
 //x=28.125 //y=1.19 //x2=28.125 //y2=1.19
r376 (  37 92 ) resistor r=9.3 //w=0.17 //l=0.17 //layer=mcon //count=1 \
 //x=27.83 //y=5.56 //x2=27.83 //y2=5.56
r377 (  34 84 ) resistor r=9.3 //w=0.17 //l=0.17 //layer=mcon //count=1 \
 //x=26.95 //y=5.56 //x2=26.95 //y2=5.56
r378 (  32 34 ) resistor r=0.121228 //w=0.232 //l=0.225 //layer=m1 \
 //thickness=0.36 //x=26.95 //y=5.335 //x2=26.95 //y2=5.56
r379 (  31 76 ) resistor r=9.3 //w=0.17 //l=0.17 //layer=mcon //count=1 \
 //x=26.07 //y=5.56 //x2=26.07 //y2=5.56
r380 (  29 31 ) resistor r=0.129608 //w=0.217 //l=0.225 //layer=m1 \
 //thickness=0.36 //x=26.072 //y=5.335 //x2=26.072 //y2=5.56
r381 (  28 56 ) resistor r=4.5 //w=0.15 //l=0.15 //layer=via1 //count=1 \
 //x=23.06 //y=3.885 //x2=23.06 //y2=3.885
r382 (  26 28 ) resistor r=0.00166223 //w=0.376 //l=0.005 //layer=m1 \
 //thickness=0.36 //x=23.112 //y=3.88 //x2=23.112 //y2=3.885
r383 (  24 71 ) resistor r=9.3 //w=0.17 //l=0.17 //layer=mcon //count=1 \
 //x=23.06 //y=4.88 //x2=23.06 //y2=4.88
r384 (  22 62 ) resistor r=9.3 //w=0.17 //l=0.17 //layer=mcon //count=1 \
 //x=23.06 //y=2.26 //x2=23.06 //y2=2.26
r385 (  19 41 ) resistor r=0.0911593 //w=0.376 //l=0.184608 //layer=m1 \
 //thickness=0.36 //x=28.61 //y=4.04 //x2=28.557 //y2=3.88
r386 (  19 20 ) resistor r=1.15458 //w=0.131 //l=1.21 //layer=m1 \
 //thickness=0.36 //x=28.61 //y=4.04 //x2=28.61 //y2=5.25
r387 (  18 41 ) resistor r=0.0911593 //w=0.376 //l=0.184608 //layer=m1 \
 //thickness=0.36 //x=28.61 //y=3.72 //x2=28.557 //y2=3.88
r388 (  17 18 ) resistor r=1.70802 //w=0.131 //l=1.79 //layer=m1 \
 //thickness=0.36 //x=28.61 //y=1.93 //x2=28.61 //y2=3.72
r389 (  15 17 ) resistor r=0.0698411 //w=0.17 //l=0.120208 //layer=m1 \
 //thickness=0.36 //x=28.525 //y=1.845 //x2=28.61 //y2=1.93
r390 (  15 16 ) resistor r=0.300573 //w=0.131 //l=0.315 //layer=m1 \
 //thickness=0.36 //x=28.525 //y=1.845 //x2=28.21 //y2=1.845
r391 (  14 16 ) resistor r=0.0698411 //w=0.17 //l=0.120208 //layer=m1 \
 //thickness=0.36 //x=28.125 //y=1.76 //x2=28.21 //y2=1.845
r392 (  13 39 ) resistor r=0.0717383 //w=0.224 //l=0.115 //layer=m1 \
 //thickness=0.36 //x=28.125 //y=1.305 //x2=28.125 //y2=1.19
r393 (  13 14 ) resistor r=0.43416 //w=0.131 //l=0.455 //layer=m1 \
 //thickness=0.36 //x=28.125 //y=1.305 //x2=28.125 //y2=1.76
r394 (  12 35 ) resistor r=0.0675342 //w=0.23 //l=0.115 //layer=m1 \
 //thickness=0.36 //x=27.945 //y=5.335 //x2=27.83 //y2=5.335
r395 (  11 20 ) resistor r=0.0698411 //w=0.17 //l=0.120208 //layer=m1 \
 //thickness=0.36 //x=28.525 //y=5.335 //x2=28.61 //y2=5.25
r396 (  11 12 ) resistor r=0.553435 //w=0.131 //l=0.58 //layer=m1 \
 //thickness=0.36 //x=28.525 //y=5.335 //x2=27.945 //y2=5.335
r397 (  10 37 ) resistor r=0.00118313 //w=0.23 //layer=m1 //thickness=0.36 \
 //x=27.83 //y=5.56 //x2=27.83 //y2=5.56
r398 (  9 35 ) resistor r=0.002872 //w=0.34 //l=0.085 //layer=m1 \
 //thickness=0.36 //x=27.83 //y=5.42 //x2=27.83 //y2=5.335
r399 (  9 10 ) resistor r=0.091623 //w=0.191 //l=0.14 //layer=m1 \
 //thickness=0.36 //x=27.83 //y=5.42 //x2=27.83 //y2=5.56
r400 (  8 32 ) resistor r=0.0262263 //w=0.232 //l=0.12 //layer=m1 \
 //thickness=0.36 //x=27.07 //y=5.335 //x2=26.95 //y2=5.335
r401 (  7 35 ) resistor r=0.0675342 //w=0.23 //l=0.115 //layer=m1 \
 //thickness=0.36 //x=27.715 //y=5.335 //x2=27.83 //y2=5.335
r402 (  7 8 ) resistor r=0.615458 //w=0.131 //l=0.645 //layer=m1 \
 //thickness=0.36 //x=27.715 //y=5.335 //x2=27.07 //y2=5.335
r403 (  6 29 ) resistor r=0.0222262 //w=0.217 //l=0.118 //layer=m1 \
 //thickness=0.36 //x=26.19 //y=5.335 //x2=26.072 //y2=5.335
r404 (  5 32 ) resistor r=0.0262263 //w=0.232 //l=0.12 //layer=m1 \
 //thickness=0.36 //x=26.83 //y=5.335 //x2=26.95 //y2=5.335
r405 (  5 6 ) resistor r=0.610687 //w=0.131 //l=0.64 //layer=m1 \
 //thickness=0.36 //x=26.83 //y=5.335 //x2=26.19 //y2=5.335
r406 (  4 24 ) resistor r=0.0801089 //w=0.224 //l=0.13 //layer=m1 \
 //thickness=0.36 //x=23.06 //y=4.75 //x2=23.06 //y2=4.88
r407 (  3 28 ) resistor r=0.0911593 //w=0.376 //l=0.184174 //layer=m1 \
 //thickness=0.36 //x=23.06 //y=4.045 //x2=23.112 //y2=3.885
r408 (  3 4 ) resistor r=0.67271 //w=0.131 //l=0.705 //layer=m1 \
 //thickness=0.36 //x=23.06 //y=4.045 //x2=23.06 //y2=4.75
r409 (  2 26 ) resistor r=0.0894971 //w=0.376 //l=0.179123 //layer=m1 \
 //thickness=0.36 //x=23.06 //y=3.725 //x2=23.112 //y2=3.88
r410 (  1 22 ) resistor r=0.0719237 //w=0.222 //l=0.115 //layer=m1 \
 //thickness=0.36 //x=23.06 //y=2.375 //x2=23.06 //y2=2.26
r411 (  1 2 ) resistor r=1.28817 //w=0.131 //l=1.35 //layer=m1 \
 //thickness=0.36 //x=23.06 //y=2.375 //x2=23.06 //y2=3.725
ends PM_DFFSNRNQNX1\%noxref_9

subckt PM_DFFSNRNQNX1\%VDD ( 1 51 70 79 89 97 107 125 135 143 153 171 181 189 \
 199 217 227 235 245 263 273 281 291 309 319 327 340 347 352 357 362 367 372 \
 373 374 375 376 377 378 379 380 381 382 383 384 385 386 387 388 389 390 391 \
 392 393 394 395 )
c406 ( 395 0 ) capacitor c=0.0466891f //x=28.125 //y=5.2
c407 ( 394 0 ) capacitor c=0.0256194f //x=27.245 //y=5.2
c408 ( 393 0 ) capacitor c=0.0256114f //x=26.365 //y=5.2
c409 ( 392 0 ) capacitor c=0.0676818f //x=25.495 //y=5.2
c410 ( 391 0 ) capacitor c=0.0466891f //x=23.315 //y=5.2
c411 ( 390 0 ) capacitor c=0.025617f //x=22.435 //y=5.2
c412 ( 389 0 ) capacitor c=0.0256114f //x=21.555 //y=5.2
c413 ( 388 0 ) capacitor c=0.0676326f //x=20.685 //y=5.2
c414 ( 387 0 ) capacitor c=0.0466891f //x=18.505 //y=5.2
c415 ( 386 0 ) capacitor c=0.025617f //x=17.625 //y=5.2
c416 ( 385 0 ) capacitor c=0.0256114f //x=16.745 //y=5.2
c417 ( 384 0 ) capacitor c=0.0676293f //x=15.875 //y=5.2
c418 ( 383 0 ) capacitor c=0.0466891f //x=13.695 //y=5.2
c419 ( 382 0 ) capacitor c=0.025617f //x=12.815 //y=5.2
c420 ( 381 0 ) capacitor c=0.0256114f //x=11.935 //y=5.2
c421 ( 380 0 ) capacitor c=0.0676882f //x=11.065 //y=5.2
c422 ( 379 0 ) capacitor c=0.0466891f //x=8.885 //y=5.2
c423 ( 378 0 ) capacitor c=0.025617f //x=8.005 //y=5.2
c424 ( 377 0 ) capacitor c=0.0256114f //x=7.125 //y=5.2
c425 ( 376 0 ) capacitor c=0.0677481f //x=6.255 //y=5.2
c426 ( 375 0 ) capacitor c=0.0466891f //x=4.075 //y=5.2
c427 ( 374 0 ) capacitor c=0.025617f //x=3.195 //y=5.2
c428 ( 373 0 ) capacitor c=0.0256114f //x=2.315 //y=5.2
c429 ( 372 0 ) capacitor c=0.0696958f //x=1.445 //y=5.2
c430 ( 371 0 ) capacitor c=0.00597439f //x=28.27 //y=7.585
c431 ( 370 0 ) capacitor c=0.00597439f //x=27.39 //y=7.585
c432 ( 369 0 ) capacitor c=0.00597439f //x=26.51 //y=7.585
c433 ( 368 0 ) capacitor c=0.00597439f //x=25.63 //y=7.585
c434 ( 367 0 ) capacitor c=0.163661f //x=24.54 //y=7.585
c435 ( 366 0 ) capacitor c=0.00597439f //x=23.46 //y=7.585
c436 ( 365 0 ) capacitor c=0.00597439f //x=22.58 //y=7.585
c437 ( 364 0 ) capacitor c=0.00597439f //x=21.7 //y=7.585
c438 ( 363 0 ) capacitor c=0.00597439f //x=20.82 //y=7.585
c439 ( 362 0 ) capacitor c=0.162193f //x=19.73 //y=7.585
c440 ( 361 0 ) capacitor c=0.00597439f //x=18.65 //y=7.585
c441 ( 360 0 ) capacitor c=0.00597439f //x=17.77 //y=7.585
c442 ( 359 0 ) capacitor c=0.00597439f //x=16.89 //y=7.585
c443 ( 358 0 ) capacitor c=0.00597439f //x=16.01 //y=7.585
c444 ( 357 0 ) capacitor c=0.162973f //x=14.92 //y=7.585
c445 ( 356 0 ) capacitor c=0.00597439f //x=13.84 //y=7.585
c446 ( 355 0 ) capacitor c=0.00597439f //x=12.96 //y=7.585
c447 ( 354 0 ) capacitor c=0.00597439f //x=12.08 //y=7.585
c448 ( 353 0 ) capacitor c=0.00597439f //x=11.2 //y=7.585
c449 ( 352 0 ) capacitor c=0.163427f //x=10.11 //y=7.585
c450 ( 351 0 ) capacitor c=0.00597439f //x=9.03 //y=7.585
c451 ( 350 0 ) capacitor c=0.00597439f //x=8.15 //y=7.585
c452 ( 349 0 ) capacitor c=0.00597439f //x=7.27 //y=7.585
c453 ( 348 0 ) capacitor c=0.00597439f //x=6.39 //y=7.585
c454 ( 347 0 ) capacitor c=0.16557f //x=5.3 //y=7.585
c455 ( 346 0 ) capacitor c=0.00597439f //x=4.22 //y=7.585
c456 ( 345 0 ) capacitor c=0.00597439f //x=3.34 //y=7.585
c457 ( 344 0 ) capacitor c=0.00597439f //x=2.46 //y=7.585
c458 ( 343 0 ) capacitor c=0.00597439f //x=1.58 //y=7.585
c459 ( 340 0 ) capacitor c=0.294524f //x=28.61 //y=7.58
c460 ( 327 0 ) capacitor c=0.0288858f //x=28.185 //y=7.585
c461 ( 319 0 ) capacitor c=0.0289326f //x=27.305 //y=7.585
c462 ( 309 0 ) capacitor c=0.0290299f //x=26.425 //y=7.585
c463 ( 297 0 ) capacitor c=0.0455283f //x=25.545 //y=7.585
c464 ( 291 0 ) capacitor c=0.042257f //x=24.37 //y=7.585
c465 ( 281 0 ) capacitor c=0.0288858f //x=23.375 //y=7.585
c466 ( 273 0 ) capacitor c=0.0289326f //x=22.495 //y=7.585
c467 ( 263 0 ) capacitor c=0.0290299f //x=21.615 //y=7.585
c468 ( 251 0 ) capacitor c=0.0455283f //x=20.735 //y=7.585
c469 ( 245 0 ) capacitor c=0.0416617f //x=19.56 //y=7.585
c470 ( 235 0 ) capacitor c=0.0288858f //x=18.565 //y=7.585
c471 ( 227 0 ) capacitor c=0.0289326f //x=17.685 //y=7.585
c472 ( 217 0 ) capacitor c=0.0290299f //x=16.805 //y=7.585
c473 ( 205 0 ) capacitor c=0.0455283f //x=15.925 //y=7.585
c474 ( 199 0 ) capacitor c=0.042257f //x=14.75 //y=7.585
c475 ( 189 0 ) capacitor c=0.0288858f //x=13.755 //y=7.585
c476 ( 181 0 ) capacitor c=0.0289326f //x=12.875 //y=7.585
c477 ( 171 0 ) capacitor c=0.0290299f //x=11.995 //y=7.585
c478 ( 159 0 ) capacitor c=0.0455283f //x=11.115 //y=7.585
c479 ( 153 0 ) capacitor c=0.042257f //x=9.94 //y=7.585
c480 ( 143 0 ) capacitor c=0.0288858f //x=8.945 //y=7.585
c481 ( 135 0 ) capacitor c=0.0289326f //x=8.065 //y=7.585
c482 ( 125 0 ) capacitor c=0.0290299f //x=7.185 //y=7.585
c483 ( 113 0 ) capacitor c=0.0455283f //x=6.305 //y=7.585
c484 ( 107 0 ) capacitor c=0.042257f //x=5.13 //y=7.585
c485 ( 97 0 ) capacitor c=0.0288858f //x=4.135 //y=7.585
c486 ( 89 0 ) capacitor c=0.0288437f //x=3.255 //y=7.585
c487 ( 79 0 ) capacitor c=0.0290299f //x=2.375 //y=7.585
c488 ( 70 0 ) capacitor c=0.254267f //x=1.23 //y=7.58
c489 ( 67 0 ) capacitor c=0.0455283f //x=1.495 //y=7.585
c490 ( 51 0 ) capacitor c=1.08837f //x=28.61 //y=7.58
r491 (  338 371 ) resistor r=2.87058 //w=0.35 //l=0.085 //layer=li \
 //thickness=0.1 //x=28.355 //y=7.585 //x2=28.27 //y2=7.585
r492 (  338 340 ) resistor r=8.89373 //w=0.367 //l=0.255 //layer=li \
 //thickness=0.1 //x=28.355 //y=7.585 //x2=28.61 //y2=7.585
r493 (  331 371 ) resistor r=4.23183 //w=0.7 //l=0.175 //layer=li \
 //thickness=0.1 //x=28.27 //y=7.41 //x2=28.27 //y2=7.585
r494 (  331 395 ) resistor r=33.1979 //w=0.187 //l=0.485 //layer=li \
 //thickness=0.1 //x=28.27 //y=7.41 //x2=28.27 //y2=6.925
r495 (  328 370 ) resistor r=2.87058 //w=0.35 //l=0.085 //layer=li \
 //thickness=0.1 //x=27.475 //y=7.585 //x2=27.39 //y2=7.585
r496 (  328 330 ) resistor r=0.871935 //w=0.367 //l=0.025 //layer=li \
 //thickness=0.1 //x=27.475 //y=7.585 //x2=27.5 //y2=7.585
r497 (  327 371 ) resistor r=2.87058 //w=0.35 //l=0.085 //layer=li \
 //thickness=0.1 //x=28.185 //y=7.585 //x2=28.27 //y2=7.585
r498 (  327 330 ) resistor r=23.891 //w=0.367 //l=0.685 //layer=li \
 //thickness=0.1 //x=28.185 //y=7.585 //x2=27.5 //y2=7.585
r499 (  321 370 ) resistor r=4.23183 //w=0.7 //l=0.175 //layer=li \
 //thickness=0.1 //x=27.39 //y=7.41 //x2=27.39 //y2=7.585
r500 (  321 394 ) resistor r=33.1979 //w=0.187 //l=0.485 //layer=li \
 //thickness=0.1 //x=27.39 //y=7.41 //x2=27.39 //y2=6.925
r501 (  320 369 ) resistor r=2.87058 //w=0.35 //l=0.085 //layer=li \
 //thickness=0.1 //x=26.595 //y=7.585 //x2=26.51 //y2=7.585
r502 (  319 370 ) resistor r=2.87058 //w=0.35 //l=0.085 //layer=li \
 //thickness=0.1 //x=27.305 //y=7.585 //x2=27.39 //y2=7.585
r503 (  319 320 ) resistor r=24.7629 //w=0.367 //l=0.71 //layer=li \
 //thickness=0.1 //x=27.305 //y=7.585 //x2=26.595 //y2=7.585
r504 (  313 369 ) resistor r=4.23183 //w=0.7 //l=0.175 //layer=li \
 //thickness=0.1 //x=26.51 //y=7.41 //x2=26.51 //y2=7.585
r505 (  313 393 ) resistor r=33.1979 //w=0.187 //l=0.485 //layer=li \
 //thickness=0.1 //x=26.51 //y=7.41 //x2=26.51 //y2=6.925
r506 (  310 368 ) resistor r=2.87058 //w=0.35 //l=0.085 //layer=li \
 //thickness=0.1 //x=25.715 //y=7.585 //x2=25.63 //y2=7.585
r507 (  310 312 ) resistor r=23.5422 //w=0.367 //l=0.675 //layer=li \
 //thickness=0.1 //x=25.715 //y=7.585 //x2=26.39 //y2=7.585
r508 (  309 369 ) resistor r=2.87058 //w=0.35 //l=0.085 //layer=li \
 //thickness=0.1 //x=26.425 //y=7.585 //x2=26.51 //y2=7.585
r509 (  309 312 ) resistor r=1.22071 //w=0.367 //l=0.035 //layer=li \
 //thickness=0.1 //x=26.425 //y=7.585 //x2=26.39 //y2=7.585
r510 (  301 368 ) resistor r=4.23183 //w=0.7 //l=0.175 //layer=li \
 //thickness=0.1 //x=25.63 //y=7.41 //x2=25.63 //y2=7.585
r511 (  301 392 ) resistor r=56.4706 //w=0.187 //l=0.825 //layer=li \
 //thickness=0.1 //x=25.63 //y=7.41 //x2=25.63 //y2=6.585
r512 (  298 367 ) resistor r=5.29055 //w=0.35 //l=0.17 //layer=li \
 //thickness=0.1 //x=24.71 //y=7.585 //x2=24.54 //y2=7.585
r513 (  298 300 ) resistor r=19.8801 //w=0.367 //l=0.57 //layer=li \
 //thickness=0.1 //x=24.71 //y=7.585 //x2=25.28 //y2=7.585
r514 (  297 368 ) resistor r=2.87058 //w=0.35 //l=0.085 //layer=li \
 //thickness=0.1 //x=25.545 //y=7.585 //x2=25.63 //y2=7.585
r515 (  297 300 ) resistor r=9.24251 //w=0.367 //l=0.265 //layer=li \
 //thickness=0.1 //x=25.545 //y=7.585 //x2=25.28 //y2=7.585
r516 (  292 366 ) resistor r=2.87058 //w=0.35 //l=0.085 //layer=li \
 //thickness=0.1 //x=23.545 //y=7.585 //x2=23.46 //y2=7.585
r517 (  292 294 ) resistor r=8.89373 //w=0.367 //l=0.255 //layer=li \
 //thickness=0.1 //x=23.545 //y=7.585 //x2=23.8 //y2=7.585
r518 (  291 367 ) resistor r=5.29055 //w=0.35 //l=0.17 //layer=li \
 //thickness=0.1 //x=24.37 //y=7.585 //x2=24.54 //y2=7.585
r519 (  291 294 ) resistor r=19.8801 //w=0.367 //l=0.57 //layer=li \
 //thickness=0.1 //x=24.37 //y=7.585 //x2=23.8 //y2=7.585
r520 (  285 366 ) resistor r=4.23183 //w=0.7 //l=0.175 //layer=li \
 //thickness=0.1 //x=23.46 //y=7.41 //x2=23.46 //y2=7.585
r521 (  285 391 ) resistor r=33.1979 //w=0.187 //l=0.485 //layer=li \
 //thickness=0.1 //x=23.46 //y=7.41 //x2=23.46 //y2=6.925
r522 (  282 365 ) resistor r=2.87058 //w=0.35 //l=0.085 //layer=li \
 //thickness=0.1 //x=22.665 //y=7.585 //x2=22.58 //y2=7.585
r523 (  282 284 ) resistor r=0.871935 //w=0.367 //l=0.025 //layer=li \
 //thickness=0.1 //x=22.665 //y=7.585 //x2=22.69 //y2=7.585
r524 (  281 366 ) resistor r=2.87058 //w=0.35 //l=0.085 //layer=li \
 //thickness=0.1 //x=23.375 //y=7.585 //x2=23.46 //y2=7.585
r525 (  281 284 ) resistor r=23.891 //w=0.367 //l=0.685 //layer=li \
 //thickness=0.1 //x=23.375 //y=7.585 //x2=22.69 //y2=7.585
r526 (  275 365 ) resistor r=4.23183 //w=0.7 //l=0.175 //layer=li \
 //thickness=0.1 //x=22.58 //y=7.41 //x2=22.58 //y2=7.585
r527 (  275 390 ) resistor r=33.1979 //w=0.187 //l=0.485 //layer=li \
 //thickness=0.1 //x=22.58 //y=7.41 //x2=22.58 //y2=6.925
r528 (  274 364 ) resistor r=2.87058 //w=0.35 //l=0.085 //layer=li \
 //thickness=0.1 //x=21.785 //y=7.585 //x2=21.7 //y2=7.585
r529 (  273 365 ) resistor r=2.87058 //w=0.35 //l=0.085 //layer=li \
 //thickness=0.1 //x=22.495 //y=7.585 //x2=22.58 //y2=7.585
r530 (  273 274 ) resistor r=24.7629 //w=0.367 //l=0.71 //layer=li \
 //thickness=0.1 //x=22.495 //y=7.585 //x2=21.785 //y2=7.585
r531 (  267 364 ) resistor r=4.23183 //w=0.7 //l=0.175 //layer=li \
 //thickness=0.1 //x=21.7 //y=7.41 //x2=21.7 //y2=7.585
r532 (  267 389 ) resistor r=33.1979 //w=0.187 //l=0.485 //layer=li \
 //thickness=0.1 //x=21.7 //y=7.41 //x2=21.7 //y2=6.925
r533 (  264 363 ) resistor r=2.87058 //w=0.35 //l=0.085 //layer=li \
 //thickness=0.1 //x=20.905 //y=7.585 //x2=20.82 //y2=7.585
r534 (  264 266 ) resistor r=23.5422 //w=0.367 //l=0.675 //layer=li \
 //thickness=0.1 //x=20.905 //y=7.585 //x2=21.58 //y2=7.585
r535 (  263 364 ) resistor r=2.87058 //w=0.35 //l=0.085 //layer=li \
 //thickness=0.1 //x=21.615 //y=7.585 //x2=21.7 //y2=7.585
r536 (  263 266 ) resistor r=1.22071 //w=0.367 //l=0.035 //layer=li \
 //thickness=0.1 //x=21.615 //y=7.585 //x2=21.58 //y2=7.585
r537 (  255 363 ) resistor r=4.23183 //w=0.7 //l=0.175 //layer=li \
 //thickness=0.1 //x=20.82 //y=7.41 //x2=20.82 //y2=7.585
r538 (  255 388 ) resistor r=56.4706 //w=0.187 //l=0.825 //layer=li \
 //thickness=0.1 //x=20.82 //y=7.41 //x2=20.82 //y2=6.585
r539 (  252 362 ) resistor r=5.29055 //w=0.35 //l=0.17 //layer=li \
 //thickness=0.1 //x=19.9 //y=7.585 //x2=19.73 //y2=7.585
r540 (  252 254 ) resistor r=19.8801 //w=0.367 //l=0.57 //layer=li \
 //thickness=0.1 //x=19.9 //y=7.585 //x2=20.47 //y2=7.585
r541 (  251 363 ) resistor r=2.87058 //w=0.35 //l=0.085 //layer=li \
 //thickness=0.1 //x=20.735 //y=7.585 //x2=20.82 //y2=7.585
r542 (  251 254 ) resistor r=9.24251 //w=0.367 //l=0.265 //layer=li \
 //thickness=0.1 //x=20.735 //y=7.585 //x2=20.47 //y2=7.585
r543 (  246 361 ) resistor r=2.87058 //w=0.35 //l=0.085 //layer=li \
 //thickness=0.1 //x=18.735 //y=7.585 //x2=18.65 //y2=7.585
r544 (  246 248 ) resistor r=8.89373 //w=0.367 //l=0.255 //layer=li \
 //thickness=0.1 //x=18.735 //y=7.585 //x2=18.99 //y2=7.585
r545 (  245 362 ) resistor r=5.29055 //w=0.35 //l=0.17 //layer=li \
 //thickness=0.1 //x=19.56 //y=7.585 //x2=19.73 //y2=7.585
r546 (  245 248 ) resistor r=19.8801 //w=0.367 //l=0.57 //layer=li \
 //thickness=0.1 //x=19.56 //y=7.585 //x2=18.99 //y2=7.585
r547 (  239 361 ) resistor r=4.23183 //w=0.7 //l=0.175 //layer=li \
 //thickness=0.1 //x=18.65 //y=7.41 //x2=18.65 //y2=7.585
r548 (  239 387 ) resistor r=33.1979 //w=0.187 //l=0.485 //layer=li \
 //thickness=0.1 //x=18.65 //y=7.41 //x2=18.65 //y2=6.925
r549 (  236 360 ) resistor r=2.87058 //w=0.35 //l=0.085 //layer=li \
 //thickness=0.1 //x=17.855 //y=7.585 //x2=17.77 //y2=7.585
r550 (  236 238 ) resistor r=0.871935 //w=0.367 //l=0.025 //layer=li \
 //thickness=0.1 //x=17.855 //y=7.585 //x2=17.88 //y2=7.585
r551 (  235 361 ) resistor r=2.87058 //w=0.35 //l=0.085 //layer=li \
 //thickness=0.1 //x=18.565 //y=7.585 //x2=18.65 //y2=7.585
r552 (  235 238 ) resistor r=23.891 //w=0.367 //l=0.685 //layer=li \
 //thickness=0.1 //x=18.565 //y=7.585 //x2=17.88 //y2=7.585
r553 (  229 360 ) resistor r=4.23183 //w=0.7 //l=0.175 //layer=li \
 //thickness=0.1 //x=17.77 //y=7.41 //x2=17.77 //y2=7.585
r554 (  229 386 ) resistor r=33.1979 //w=0.187 //l=0.485 //layer=li \
 //thickness=0.1 //x=17.77 //y=7.41 //x2=17.77 //y2=6.925
r555 (  228 359 ) resistor r=2.87058 //w=0.35 //l=0.085 //layer=li \
 //thickness=0.1 //x=16.975 //y=7.585 //x2=16.89 //y2=7.585
r556 (  227 360 ) resistor r=2.87058 //w=0.35 //l=0.085 //layer=li \
 //thickness=0.1 //x=17.685 //y=7.585 //x2=17.77 //y2=7.585
r557 (  227 228 ) resistor r=24.7629 //w=0.367 //l=0.71 //layer=li \
 //thickness=0.1 //x=17.685 //y=7.585 //x2=16.975 //y2=7.585
r558 (  221 359 ) resistor r=4.23183 //w=0.7 //l=0.175 //layer=li \
 //thickness=0.1 //x=16.89 //y=7.41 //x2=16.89 //y2=7.585
r559 (  221 385 ) resistor r=33.1979 //w=0.187 //l=0.485 //layer=li \
 //thickness=0.1 //x=16.89 //y=7.41 //x2=16.89 //y2=6.925
r560 (  218 358 ) resistor r=2.87058 //w=0.35 //l=0.085 //layer=li \
 //thickness=0.1 //x=16.095 //y=7.585 //x2=16.01 //y2=7.585
r561 (  218 220 ) resistor r=23.5422 //w=0.367 //l=0.675 //layer=li \
 //thickness=0.1 //x=16.095 //y=7.585 //x2=16.77 //y2=7.585
r562 (  217 359 ) resistor r=2.87058 //w=0.35 //l=0.085 //layer=li \
 //thickness=0.1 //x=16.805 //y=7.585 //x2=16.89 //y2=7.585
r563 (  217 220 ) resistor r=1.22071 //w=0.367 //l=0.035 //layer=li \
 //thickness=0.1 //x=16.805 //y=7.585 //x2=16.77 //y2=7.585
r564 (  209 358 ) resistor r=4.23183 //w=0.7 //l=0.175 //layer=li \
 //thickness=0.1 //x=16.01 //y=7.41 //x2=16.01 //y2=7.585
r565 (  209 384 ) resistor r=56.4706 //w=0.187 //l=0.825 //layer=li \
 //thickness=0.1 //x=16.01 //y=7.41 //x2=16.01 //y2=6.585
r566 (  206 357 ) resistor r=5.29055 //w=0.35 //l=0.17 //layer=li \
 //thickness=0.1 //x=15.09 //y=7.585 //x2=14.92 //y2=7.585
r567 (  206 208 ) resistor r=19.8801 //w=0.367 //l=0.57 //layer=li \
 //thickness=0.1 //x=15.09 //y=7.585 //x2=15.66 //y2=7.585
r568 (  205 358 ) resistor r=2.87058 //w=0.35 //l=0.085 //layer=li \
 //thickness=0.1 //x=15.925 //y=7.585 //x2=16.01 //y2=7.585
r569 (  205 208 ) resistor r=9.24251 //w=0.367 //l=0.265 //layer=li \
 //thickness=0.1 //x=15.925 //y=7.585 //x2=15.66 //y2=7.585
r570 (  200 356 ) resistor r=2.87058 //w=0.35 //l=0.085 //layer=li \
 //thickness=0.1 //x=13.925 //y=7.585 //x2=13.84 //y2=7.585
r571 (  200 202 ) resistor r=8.89373 //w=0.367 //l=0.255 //layer=li \
 //thickness=0.1 //x=13.925 //y=7.585 //x2=14.18 //y2=7.585
r572 (  199 357 ) resistor r=5.29055 //w=0.35 //l=0.17 //layer=li \
 //thickness=0.1 //x=14.75 //y=7.585 //x2=14.92 //y2=7.585
r573 (  199 202 ) resistor r=19.8801 //w=0.367 //l=0.57 //layer=li \
 //thickness=0.1 //x=14.75 //y=7.585 //x2=14.18 //y2=7.585
r574 (  193 356 ) resistor r=4.23183 //w=0.7 //l=0.175 //layer=li \
 //thickness=0.1 //x=13.84 //y=7.41 //x2=13.84 //y2=7.585
r575 (  193 383 ) resistor r=33.1979 //w=0.187 //l=0.485 //layer=li \
 //thickness=0.1 //x=13.84 //y=7.41 //x2=13.84 //y2=6.925
r576 (  190 355 ) resistor r=2.87058 //w=0.35 //l=0.085 //layer=li \
 //thickness=0.1 //x=13.045 //y=7.585 //x2=12.96 //y2=7.585
r577 (  190 192 ) resistor r=0.871935 //w=0.367 //l=0.025 //layer=li \
 //thickness=0.1 //x=13.045 //y=7.585 //x2=13.07 //y2=7.585
r578 (  189 356 ) resistor r=2.87058 //w=0.35 //l=0.085 //layer=li \
 //thickness=0.1 //x=13.755 //y=7.585 //x2=13.84 //y2=7.585
r579 (  189 192 ) resistor r=23.891 //w=0.367 //l=0.685 //layer=li \
 //thickness=0.1 //x=13.755 //y=7.585 //x2=13.07 //y2=7.585
r580 (  183 355 ) resistor r=4.23183 //w=0.7 //l=0.175 //layer=li \
 //thickness=0.1 //x=12.96 //y=7.41 //x2=12.96 //y2=7.585
r581 (  183 382 ) resistor r=33.1979 //w=0.187 //l=0.485 //layer=li \
 //thickness=0.1 //x=12.96 //y=7.41 //x2=12.96 //y2=6.925
r582 (  182 354 ) resistor r=2.87058 //w=0.35 //l=0.085 //layer=li \
 //thickness=0.1 //x=12.165 //y=7.585 //x2=12.08 //y2=7.585
r583 (  181 355 ) resistor r=2.87058 //w=0.35 //l=0.085 //layer=li \
 //thickness=0.1 //x=12.875 //y=7.585 //x2=12.96 //y2=7.585
r584 (  181 182 ) resistor r=24.7629 //w=0.367 //l=0.71 //layer=li \
 //thickness=0.1 //x=12.875 //y=7.585 //x2=12.165 //y2=7.585
r585 (  175 354 ) resistor r=4.23183 //w=0.7 //l=0.175 //layer=li \
 //thickness=0.1 //x=12.08 //y=7.41 //x2=12.08 //y2=7.585
r586 (  175 381 ) resistor r=33.1979 //w=0.187 //l=0.485 //layer=li \
 //thickness=0.1 //x=12.08 //y=7.41 //x2=12.08 //y2=6.925
r587 (  172 353 ) resistor r=2.87058 //w=0.35 //l=0.085 //layer=li \
 //thickness=0.1 //x=11.285 //y=7.585 //x2=11.2 //y2=7.585
r588 (  172 174 ) resistor r=23.5422 //w=0.367 //l=0.675 //layer=li \
 //thickness=0.1 //x=11.285 //y=7.585 //x2=11.96 //y2=7.585
r589 (  171 354 ) resistor r=2.87058 //w=0.35 //l=0.085 //layer=li \
 //thickness=0.1 //x=11.995 //y=7.585 //x2=12.08 //y2=7.585
r590 (  171 174 ) resistor r=1.22071 //w=0.367 //l=0.035 //layer=li \
 //thickness=0.1 //x=11.995 //y=7.585 //x2=11.96 //y2=7.585
r591 (  163 353 ) resistor r=4.23183 //w=0.7 //l=0.175 //layer=li \
 //thickness=0.1 //x=11.2 //y=7.41 //x2=11.2 //y2=7.585
r592 (  163 380 ) resistor r=56.4706 //w=0.187 //l=0.825 //layer=li \
 //thickness=0.1 //x=11.2 //y=7.41 //x2=11.2 //y2=6.585
r593 (  160 352 ) resistor r=5.29055 //w=0.35 //l=0.17 //layer=li \
 //thickness=0.1 //x=10.28 //y=7.585 //x2=10.11 //y2=7.585
r594 (  160 162 ) resistor r=19.8801 //w=0.367 //l=0.57 //layer=li \
 //thickness=0.1 //x=10.28 //y=7.585 //x2=10.85 //y2=7.585
r595 (  159 353 ) resistor r=2.87058 //w=0.35 //l=0.085 //layer=li \
 //thickness=0.1 //x=11.115 //y=7.585 //x2=11.2 //y2=7.585
r596 (  159 162 ) resistor r=9.24251 //w=0.367 //l=0.265 //layer=li \
 //thickness=0.1 //x=11.115 //y=7.585 //x2=10.85 //y2=7.585
r597 (  154 351 ) resistor r=2.87058 //w=0.35 //l=0.085 //layer=li \
 //thickness=0.1 //x=9.115 //y=7.585 //x2=9.03 //y2=7.585
r598 (  154 156 ) resistor r=8.89373 //w=0.367 //l=0.255 //layer=li \
 //thickness=0.1 //x=9.115 //y=7.585 //x2=9.37 //y2=7.585
r599 (  153 352 ) resistor r=5.29055 //w=0.35 //l=0.17 //layer=li \
 //thickness=0.1 //x=9.94 //y=7.585 //x2=10.11 //y2=7.585
r600 (  153 156 ) resistor r=19.8801 //w=0.367 //l=0.57 //layer=li \
 //thickness=0.1 //x=9.94 //y=7.585 //x2=9.37 //y2=7.585
r601 (  147 351 ) resistor r=4.23183 //w=0.7 //l=0.175 //layer=li \
 //thickness=0.1 //x=9.03 //y=7.41 //x2=9.03 //y2=7.585
r602 (  147 379 ) resistor r=33.1979 //w=0.187 //l=0.485 //layer=li \
 //thickness=0.1 //x=9.03 //y=7.41 //x2=9.03 //y2=6.925
r603 (  144 350 ) resistor r=2.87058 //w=0.35 //l=0.085 //layer=li \
 //thickness=0.1 //x=8.235 //y=7.585 //x2=8.15 //y2=7.585
r604 (  144 146 ) resistor r=0.871935 //w=0.367 //l=0.025 //layer=li \
 //thickness=0.1 //x=8.235 //y=7.585 //x2=8.26 //y2=7.585
r605 (  143 351 ) resistor r=2.87058 //w=0.35 //l=0.085 //layer=li \
 //thickness=0.1 //x=8.945 //y=7.585 //x2=9.03 //y2=7.585
r606 (  143 146 ) resistor r=23.891 //w=0.367 //l=0.685 //layer=li \
 //thickness=0.1 //x=8.945 //y=7.585 //x2=8.26 //y2=7.585
r607 (  137 350 ) resistor r=4.23183 //w=0.7 //l=0.175 //layer=li \
 //thickness=0.1 //x=8.15 //y=7.41 //x2=8.15 //y2=7.585
r608 (  137 378 ) resistor r=33.1979 //w=0.187 //l=0.485 //layer=li \
 //thickness=0.1 //x=8.15 //y=7.41 //x2=8.15 //y2=6.925
r609 (  136 349 ) resistor r=2.87058 //w=0.35 //l=0.085 //layer=li \
 //thickness=0.1 //x=7.355 //y=7.585 //x2=7.27 //y2=7.585
r610 (  135 350 ) resistor r=2.87058 //w=0.35 //l=0.085 //layer=li \
 //thickness=0.1 //x=8.065 //y=7.585 //x2=8.15 //y2=7.585
r611 (  135 136 ) resistor r=24.7629 //w=0.367 //l=0.71 //layer=li \
 //thickness=0.1 //x=8.065 //y=7.585 //x2=7.355 //y2=7.585
r612 (  129 349 ) resistor r=4.23183 //w=0.7 //l=0.175 //layer=li \
 //thickness=0.1 //x=7.27 //y=7.41 //x2=7.27 //y2=7.585
r613 (  129 377 ) resistor r=33.1979 //w=0.187 //l=0.485 //layer=li \
 //thickness=0.1 //x=7.27 //y=7.41 //x2=7.27 //y2=6.925
r614 (  126 348 ) resistor r=2.87058 //w=0.35 //l=0.085 //layer=li \
 //thickness=0.1 //x=6.475 //y=7.585 //x2=6.39 //y2=7.585
r615 (  126 128 ) resistor r=23.5422 //w=0.367 //l=0.675 //layer=li \
 //thickness=0.1 //x=6.475 //y=7.585 //x2=7.15 //y2=7.585
r616 (  125 349 ) resistor r=2.87058 //w=0.35 //l=0.085 //layer=li \
 //thickness=0.1 //x=7.185 //y=7.585 //x2=7.27 //y2=7.585
r617 (  125 128 ) resistor r=1.22071 //w=0.367 //l=0.035 //layer=li \
 //thickness=0.1 //x=7.185 //y=7.585 //x2=7.15 //y2=7.585
r618 (  117 348 ) resistor r=4.23183 //w=0.7 //l=0.175 //layer=li \
 //thickness=0.1 //x=6.39 //y=7.41 //x2=6.39 //y2=7.585
r619 (  117 376 ) resistor r=56.4706 //w=0.187 //l=0.825 //layer=li \
 //thickness=0.1 //x=6.39 //y=7.41 //x2=6.39 //y2=6.585
r620 (  114 347 ) resistor r=5.29055 //w=0.35 //l=0.17 //layer=li \
 //thickness=0.1 //x=5.47 //y=7.585 //x2=5.3 //y2=7.585
r621 (  114 116 ) resistor r=19.8801 //w=0.367 //l=0.57 //layer=li \
 //thickness=0.1 //x=5.47 //y=7.585 //x2=6.04 //y2=7.585
r622 (  113 348 ) resistor r=2.87058 //w=0.35 //l=0.085 //layer=li \
 //thickness=0.1 //x=6.305 //y=7.585 //x2=6.39 //y2=7.585
r623 (  113 116 ) resistor r=9.24251 //w=0.367 //l=0.265 //layer=li \
 //thickness=0.1 //x=6.305 //y=7.585 //x2=6.04 //y2=7.585
r624 (  108 346 ) resistor r=2.87058 //w=0.35 //l=0.085 //layer=li \
 //thickness=0.1 //x=4.305 //y=7.585 //x2=4.22 //y2=7.585
r625 (  108 110 ) resistor r=8.89373 //w=0.367 //l=0.255 //layer=li \
 //thickness=0.1 //x=4.305 //y=7.585 //x2=4.56 //y2=7.585
r626 (  107 347 ) resistor r=5.29055 //w=0.35 //l=0.17 //layer=li \
 //thickness=0.1 //x=5.13 //y=7.585 //x2=5.3 //y2=7.585
r627 (  107 110 ) resistor r=19.8801 //w=0.367 //l=0.57 //layer=li \
 //thickness=0.1 //x=5.13 //y=7.585 //x2=4.56 //y2=7.585
r628 (  101 346 ) resistor r=4.23183 //w=0.7 //l=0.175 //layer=li \
 //thickness=0.1 //x=4.22 //y=7.41 //x2=4.22 //y2=7.585
r629 (  101 375 ) resistor r=33.1979 //w=0.187 //l=0.485 //layer=li \
 //thickness=0.1 //x=4.22 //y=7.41 //x2=4.22 //y2=6.925
r630 (  98 345 ) resistor r=2.87058 //w=0.35 //l=0.085 //layer=li \
 //thickness=0.1 //x=3.425 //y=7.585 //x2=3.34 //y2=7.585
r631 (  98 100 ) resistor r=0.871935 //w=0.367 //l=0.025 //layer=li \
 //thickness=0.1 //x=3.425 //y=7.585 //x2=3.45 //y2=7.585
r632 (  97 346 ) resistor r=2.87058 //w=0.35 //l=0.085 //layer=li \
 //thickness=0.1 //x=4.135 //y=7.585 //x2=4.22 //y2=7.585
r633 (  97 100 ) resistor r=23.891 //w=0.367 //l=0.685 //layer=li \
 //thickness=0.1 //x=4.135 //y=7.585 //x2=3.45 //y2=7.585
r634 (  91 345 ) resistor r=4.23183 //w=0.7 //l=0.175 //layer=li \
 //thickness=0.1 //x=3.34 //y=7.41 //x2=3.34 //y2=7.585
r635 (  91 374 ) resistor r=33.1979 //w=0.187 //l=0.485 //layer=li \
 //thickness=0.1 //x=3.34 //y=7.41 //x2=3.34 //y2=6.925
r636 (  90 344 ) resistor r=2.87058 //w=0.35 //l=0.085 //layer=li \
 //thickness=0.1 //x=2.545 //y=7.585 //x2=2.46 //y2=7.585
r637 (  89 345 ) resistor r=2.87058 //w=0.35 //l=0.085 //layer=li \
 //thickness=0.1 //x=3.255 //y=7.585 //x2=3.34 //y2=7.585
r638 (  89 90 ) resistor r=24.7629 //w=0.367 //l=0.71 //layer=li \
 //thickness=0.1 //x=3.255 //y=7.585 //x2=2.545 //y2=7.585
r639 (  83 344 ) resistor r=4.23183 //w=0.7 //l=0.175 //layer=li \
 //thickness=0.1 //x=2.46 //y=7.41 //x2=2.46 //y2=7.585
r640 (  83 373 ) resistor r=33.1979 //w=0.187 //l=0.485 //layer=li \
 //thickness=0.1 //x=2.46 //y=7.41 //x2=2.46 //y2=6.925
r641 (  80 343 ) resistor r=2.87058 //w=0.35 //l=0.085 //layer=li \
 //thickness=0.1 //x=1.665 //y=7.585 //x2=1.58 //y2=7.585
r642 (  80 82 ) resistor r=23.5422 //w=0.367 //l=0.675 //layer=li \
 //thickness=0.1 //x=1.665 //y=7.585 //x2=2.34 //y2=7.585
r643 (  79 344 ) resistor r=2.87058 //w=0.35 //l=0.085 //layer=li \
 //thickness=0.1 //x=2.375 //y=7.585 //x2=2.46 //y2=7.585
r644 (  79 82 ) resistor r=1.22071 //w=0.367 //l=0.035 //layer=li \
 //thickness=0.1 //x=2.375 //y=7.585 //x2=2.34 //y2=7.585
r645 (  71 343 ) resistor r=4.23183 //w=0.7 //l=0.175 //layer=li \
 //thickness=0.1 //x=1.58 //y=7.41 //x2=1.58 //y2=7.585
r646 (  71 372 ) resistor r=56.4706 //w=0.187 //l=0.825 //layer=li \
 //thickness=0.1 //x=1.58 //y=7.41 //x2=1.58 //y2=6.585
r647 (  67 343 ) resistor r=2.87058 //w=0.35 //l=0.085 //layer=li \
 //thickness=0.1 //x=1.495 //y=7.585 //x2=1.58 //y2=7.585
r648 (  67 70 ) resistor r=9.24251 //w=0.367 //l=0.265 //layer=li \
 //thickness=0.1 //x=1.495 //y=7.585 //x2=1.23 //y2=7.585
r649 (  51 340 ) resistor r=3.1 //w=0.17 //l=0.51 //layer=mcon //count=3 \
 //x=28.61 //y=7.58 //x2=28.61 //y2=7.58
r650 (  49 330 ) resistor r=3.1 //w=0.17 //l=0.51 //layer=mcon //count=3 \
 //x=27.5 //y=7.58 //x2=27.5 //y2=7.58
r651 (  49 51 ) resistor r=0.446141 //w=0.311 //l=1.11 //layer=m1 \
 //thickness=0.36 //x=27.5 //y=7.585 //x2=28.61 //y2=7.585
r652 (  47 312 ) resistor r=3.1 //w=0.17 //l=0.51 //layer=mcon //count=3 \
 //x=26.39 //y=7.58 //x2=26.39 //y2=7.58
r653 (  47 49 ) resistor r=0.446141 //w=0.311 //l=1.11 //layer=m1 \
 //thickness=0.36 //x=26.39 //y=7.585 //x2=27.5 //y2=7.585
r654 (  45 300 ) resistor r=3.1 //w=0.17 //l=0.51 //layer=mcon //count=3 \
 //x=25.28 //y=7.58 //x2=25.28 //y2=7.58
r655 (  45 47 ) resistor r=0.446141 //w=0.311 //l=1.11 //layer=m1 \
 //thickness=0.36 //x=25.28 //y=7.585 //x2=26.39 //y2=7.585
r656 (  43 294 ) resistor r=3.1 //w=0.17 //l=0.51 //layer=mcon //count=3 \
 //x=23.8 //y=7.58 //x2=23.8 //y2=7.58
r657 (  43 45 ) resistor r=0.594855 //w=0.311 //l=1.48 //layer=m1 \
 //thickness=0.36 //x=23.8 //y=7.585 //x2=25.28 //y2=7.585
r658 (  41 284 ) resistor r=3.1 //w=0.17 //l=0.51 //layer=mcon //count=3 \
 //x=22.69 //y=7.58 //x2=22.69 //y2=7.58
r659 (  41 43 ) resistor r=0.446141 //w=0.311 //l=1.11 //layer=m1 \
 //thickness=0.36 //x=22.69 //y=7.585 //x2=23.8 //y2=7.585
r660 (  39 266 ) resistor r=3.1 //w=0.17 //l=0.51 //layer=mcon //count=3 \
 //x=21.58 //y=7.58 //x2=21.58 //y2=7.58
r661 (  39 41 ) resistor r=0.446141 //w=0.311 //l=1.11 //layer=m1 \
 //thickness=0.36 //x=21.58 //y=7.585 //x2=22.69 //y2=7.585
r662 (  37 254 ) resistor r=3.1 //w=0.17 //l=0.51 //layer=mcon //count=3 \
 //x=20.47 //y=7.58 //x2=20.47 //y2=7.58
r663 (  37 39 ) resistor r=0.446141 //w=0.311 //l=1.11 //layer=m1 \
 //thickness=0.36 //x=20.47 //y=7.585 //x2=21.58 //y2=7.585
r664 (  35 248 ) resistor r=3.1 //w=0.17 //l=0.51 //layer=mcon //count=3 \
 //x=18.99 //y=7.58 //x2=18.99 //y2=7.58
r665 (  35 37 ) resistor r=0.594855 //w=0.311 //l=1.48 //layer=m1 \
 //thickness=0.36 //x=18.99 //y=7.585 //x2=20.47 //y2=7.585
r666 (  33 238 ) resistor r=3.1 //w=0.17 //l=0.51 //layer=mcon //count=3 \
 //x=17.88 //y=7.58 //x2=17.88 //y2=7.58
r667 (  33 35 ) resistor r=0.446141 //w=0.311 //l=1.11 //layer=m1 \
 //thickness=0.36 //x=17.88 //y=7.585 //x2=18.99 //y2=7.585
r668 (  31 220 ) resistor r=3.1 //w=0.17 //l=0.51 //layer=mcon //count=3 \
 //x=16.77 //y=7.58 //x2=16.77 //y2=7.58
r669 (  31 33 ) resistor r=0.446141 //w=0.311 //l=1.11 //layer=m1 \
 //thickness=0.36 //x=16.77 //y=7.585 //x2=17.88 //y2=7.585
r670 (  29 208 ) resistor r=3.1 //w=0.17 //l=0.51 //layer=mcon //count=3 \
 //x=15.66 //y=7.58 //x2=15.66 //y2=7.58
r671 (  29 31 ) resistor r=0.446141 //w=0.311 //l=1.11 //layer=m1 \
 //thickness=0.36 //x=15.66 //y=7.585 //x2=16.77 //y2=7.585
r672 (  26 202 ) resistor r=3.1 //w=0.17 //l=0.51 //layer=mcon //count=3 \
 //x=14.18 //y=7.58 //x2=14.18 //y2=7.58
r673 (  24 192 ) resistor r=3.1 //w=0.17 //l=0.51 //layer=mcon //count=3 \
 //x=13.07 //y=7.58 //x2=13.07 //y2=7.58
r674 (  24 26 ) resistor r=0.446141 //w=0.311 //l=1.11 //layer=m1 \
 //thickness=0.36 //x=13.07 //y=7.585 //x2=14.18 //y2=7.585
r675 (  22 174 ) resistor r=3.1 //w=0.17 //l=0.51 //layer=mcon //count=3 \
 //x=11.96 //y=7.58 //x2=11.96 //y2=7.58
r676 (  22 24 ) resistor r=0.446141 //w=0.311 //l=1.11 //layer=m1 \
 //thickness=0.36 //x=11.96 //y=7.585 //x2=13.07 //y2=7.585
r677 (  20 162 ) resistor r=3.1 //w=0.17 //l=0.51 //layer=mcon //count=3 \
 //x=10.85 //y=7.58 //x2=10.85 //y2=7.58
r678 (  20 22 ) resistor r=0.446141 //w=0.311 //l=1.11 //layer=m1 \
 //thickness=0.36 //x=10.85 //y=7.585 //x2=11.96 //y2=7.585
r679 (  18 156 ) resistor r=3.1 //w=0.17 //l=0.51 //layer=mcon //count=3 \
 //x=9.37 //y=7.58 //x2=9.37 //y2=7.58
r680 (  18 20 ) resistor r=0.594855 //w=0.311 //l=1.48 //layer=m1 \
 //thickness=0.36 //x=9.37 //y=7.585 //x2=10.85 //y2=7.585
r681 (  16 146 ) resistor r=3.1 //w=0.17 //l=0.51 //layer=mcon //count=3 \
 //x=8.26 //y=7.58 //x2=8.26 //y2=7.58
r682 (  16 18 ) resistor r=0.446141 //w=0.311 //l=1.11 //layer=m1 \
 //thickness=0.36 //x=8.26 //y=7.585 //x2=9.37 //y2=7.585
r683 (  14 128 ) resistor r=3.1 //w=0.17 //l=0.51 //layer=mcon //count=3 \
 //x=7.15 //y=7.58 //x2=7.15 //y2=7.58
r684 (  14 16 ) resistor r=0.446141 //w=0.311 //l=1.11 //layer=m1 \
 //thickness=0.36 //x=7.15 //y=7.585 //x2=8.26 //y2=7.585
r685 (  12 116 ) resistor r=3.1 //w=0.17 //l=0.51 //layer=mcon //count=3 \
 //x=6.04 //y=7.58 //x2=6.04 //y2=7.58
r686 (  12 14 ) resistor r=0.446141 //w=0.311 //l=1.11 //layer=m1 \
 //thickness=0.36 //x=6.04 //y=7.585 //x2=7.15 //y2=7.585
r687 (  10 110 ) resistor r=3.1 //w=0.17 //l=0.51 //layer=mcon //count=3 \
 //x=4.56 //y=7.58 //x2=4.56 //y2=7.58
r688 (  10 12 ) resistor r=0.594855 //w=0.311 //l=1.48 //layer=m1 \
 //thickness=0.36 //x=4.56 //y=7.585 //x2=6.04 //y2=7.585
r689 (  8 100 ) resistor r=3.1 //w=0.17 //l=0.51 //layer=mcon //count=3 \
 //x=3.45 //y=7.58 //x2=3.45 //y2=7.58
r690 (  8 10 ) resistor r=0.446141 //w=0.311 //l=1.11 //layer=m1 \
 //thickness=0.36 //x=3.45 //y=7.585 //x2=4.56 //y2=7.585
r691 (  6 82 ) resistor r=3.1 //w=0.17 //l=0.51 //layer=mcon //count=3 \
 //x=2.34 //y=7.58 //x2=2.34 //y2=7.58
r692 (  6 8 ) resistor r=0.446141 //w=0.311 //l=1.11 //layer=m1 \
 //thickness=0.36 //x=2.34 //y=7.585 //x2=3.45 //y2=7.585
r693 (  3 70 ) resistor r=3.1 //w=0.17 //l=0.51 //layer=mcon //count=3 \
 //x=1.23 //y=7.58 //x2=1.23 //y2=7.58
r694 (  3 6 ) resistor r=0.446141 //w=0.311 //l=1.11 //layer=m1 \
 //thickness=0.36 //x=1.23 //y=7.585 //x2=2.34 //y2=7.585
r695 (  1 29 ) resistor r=0.297428 //w=0.311 //l=0.74 //layer=m1 \
 //thickness=0.36 //x=14.92 //y=7.585 //x2=15.66 //y2=7.585
r696 (  1 26 ) resistor r=0.297428 //w=0.311 //l=0.74 //layer=m1 \
 //thickness=0.36 //x=14.92 //y=7.585 //x2=14.18 //y2=7.585
ends PM_DFFSNRNQNX1\%VDD

subckt PM_DFFSNRNQNX1\%D ( 1 2 3 4 5 6 7 8 20 25 29 30 31 32 33 34 35 36 38 44 \
 45 46 47 )
c96 ( 47 0 ) capacitor c=0.0612936f //x=1.875 //y=4.97
c97 ( 46 0 ) capacitor c=0.0376642f //x=2.165 //y=4.97
c98 ( 45 0 ) capacitor c=0.0346489f //x=1.83 //y=1.4
c99 ( 44 0 ) capacitor c=0.018692f //x=1.83 //y=1.055
c100 ( 38 0 ) capacitor c=0.0137077f //x=1.675 //y=1.555
c101 ( 36 0 ) capacitor c=0.0158585f //x=1.675 //y=0.9
c102 ( 35 0 ) capacitor c=0.103534f //x=1.3 //y=2.095
c103 ( 34 0 ) capacitor c=0.0229444f //x=1.3 //y=1.71
c104 ( 33 0 ) capacitor c=0.0234359f //x=1.3 //y=1.4
c105 ( 32 0 ) capacitor c=0.019815f //x=1.3 //y=1.055
c106 ( 31 0 ) capacitor c=0.110208f //x=2.24 //y=6.2
c107 ( 30 0 ) capacitor c=0.158957f //x=1.8 //y=6.2
c108 ( 25 0 ) capacitor c=0.0014751f //x=1.6 //y=4.88
c109 ( 20 0 ) capacitor c=0.0012618f //x=1.6 //y=2.26
c110 ( 8 0 ) capacitor c=0.0117153f //x=1.6 //y=4.755
c111 ( 7 0 ) capacitor c=0.0115129f //x=1.6 //y=2.375
c112 ( 1 0 ) capacitor c=0.115378f //x=1.6 //y=2.77
r113 (  46 48 ) resistor r=26.9307 //w=0.15 //l=0.106066 //layer=ply \
 //thickness=0.18 //x=2.165 //y=4.97 //x2=2.24 //y2=5.045
r114 (  46 47 ) resistor r=148.702 //w=0.094 //l=0.29 //layer=ply \
 //thickness=0.18 //x=2.165 //y=4.97 //x2=1.875 //y2=4.97
r115 (  45 58 ) resistor r=45.1352 //w=0.168 //l=0.173853 //layer=ply \
 //thickness=0.18 //x=1.83 //y=1.4 //x2=1.79 //y2=1.555
r116 (  44 57 ) resistor r=45.1352 //w=0.168 //l=0.173853 //layer=ply \
 //thickness=0.18 //x=1.83 //y=1.055 //x2=1.79 //y2=0.9
r117 (  44 45 ) resistor r=176.904 //w=0.094 //l=0.345 //layer=ply \
 //thickness=0.18 //x=1.83 //y=1.055 //x2=1.83 //y2=1.4
r118 (  41 47 ) resistor r=22.7971 //w=0.269 //l=0.106066 //layer=ply \
 //thickness=0.18 //x=1.8 //y=5.045 //x2=1.875 //y2=4.97
r119 (  41 56 ) resistor r=35.8364 //w=0.269 //l=0.270185 //layer=ply \
 //thickness=0.18 //x=1.8 //y=5.045 //x2=1.6 //y2=4.88
r120 (  39 52 ) resistor r=10.701 //w=0.21 //l=0.115 //layer=ply \
 //thickness=0.18 //x=1.455 //y=1.555 //x2=1.34 //y2=1.555
r121 (  38 58 ) resistor r=5.52526 //w=0.168 //l=0.115 //layer=ply \
 //thickness=0.18 //x=1.675 //y=1.555 //x2=1.79 //y2=1.555
r122 (  37 51 ) resistor r=5.52526 //w=0.168 //l=0.115 //layer=ply \
 //thickness=0.18 //x=1.455 //y=0.9 //x2=1.34 //y2=0.9
r123 (  36 57 ) resistor r=5.52526 //w=0.168 //l=0.115 //layer=ply \
 //thickness=0.18 //x=1.675 //y=0.9 //x2=1.79 //y2=0.9
r124 (  36 37 ) resistor r=112.809 //w=0.094 //l=0.22 //layer=ply \
 //thickness=0.18 //x=1.675 //y=0.9 //x2=1.455 //y2=0.9
r125 (  35 54 ) resistor r=58.7805 //w=0.246 //l=0.373497 //layer=ply \
 //thickness=0.18 //x=1.3 //y=2.095 //x2=1.6 //y2=2.26
r126 (  34 52 ) resistor r=39.5823 //w=0.21 //l=0.173853 //layer=ply \
 //thickness=0.18 //x=1.3 //y=1.71 //x2=1.34 //y2=1.555
r127 (  34 35 ) resistor r=197.415 //w=0.094 //l=0.385 //layer=ply \
 //thickness=0.18 //x=1.3 //y=1.71 //x2=1.3 //y2=2.095
r128 (  33 52 ) resistor r=39.5823 //w=0.21 //l=0.173853 //layer=ply \
 //thickness=0.18 //x=1.3 //y=1.4 //x2=1.34 //y2=1.555
r129 (  32 51 ) resistor r=45.1352 //w=0.168 //l=0.173853 //layer=ply \
 //thickness=0.18 //x=1.3 //y=1.055 //x2=1.34 //y2=0.9
r130 (  32 33 ) resistor r=176.904 //w=0.094 //l=0.345 //layer=ply \
 //thickness=0.18 //x=1.3 //y=1.055 //x2=1.3 //y2=1.4
r131 (  31 48 ) resistor r=592.245 //w=0.094 //l=1.155 //layer=ply \
 //thickness=0.18 //x=2.24 //y=6.2 //x2=2.24 //y2=5.045
r132 (  30 41 ) resistor r=592.245 //w=0.094 //l=1.155 //layer=ply \
 //thickness=0.18 //x=1.8 //y=6.2 //x2=1.8 //y2=5.045
r133 (  29 38 ) resistor r=56.4043 //w=0.094 //l=0.11 //layer=ply \
 //thickness=0.18 //x=1.565 //y=1.555 //x2=1.675 //y2=1.555
r134 (  29 39 ) resistor r=56.4043 //w=0.094 //l=0.11 //layer=ply \
 //thickness=0.18 //x=1.565 //y=1.555 //x2=1.455 //y2=1.555
r135 (  25 56 ) resistor r=152 //w=0.17 //l=0.17 //layer=licon //count=1 \
 //x=1.6 //y=4.88 //x2=1.6 //y2=4.88
r136 (  20 54 ) resistor r=152 //w=0.17 //l=0.17 //layer=licon //count=1 \
 //x=1.6 //y=2.26 //x2=1.6 //y2=2.26
r137 (  18 25 ) resistor r=9.3 //w=0.17 //l=0.17 //layer=mcon //count=1 \
 //x=1.6 //y=4.88 //x2=1.6 //y2=4.88
r138 (  16 20 ) resistor r=9.3 //w=0.17 //l=0.17 //layer=mcon //count=1 \
 //x=1.6 //y=2.26 //x2=1.6 //y2=2.26
r139 (  8 18 ) resistor r=0.0760407 //w=0.238 //l=0.125 //layer=m1 \
 //thickness=0.36 //x=1.6 //y=4.755 //x2=1.6 //y2=4.88
r140 (  7 16 ) resistor r=0.0719237 //w=0.222 //l=0.115 //layer=m1 \
 //thickness=0.36 //x=1.6 //y=2.375 //x2=1.6 //y2=2.26
r141 (  6 8 ) resistor r=0.128817 //w=0.131 //l=0.135 //layer=m1 \
 //thickness=0.36 //x=1.6 //y=4.62 //x2=1.6 //y2=4.755
r142 (  5 6 ) resistor r=0.353053 //w=0.131 //l=0.37 //layer=m1 \
 //thickness=0.36 //x=1.6 //y=4.25 //x2=1.6 //y2=4.62
r143 (  4 5 ) resistor r=0.353053 //w=0.131 //l=0.37 //layer=m1 \
 //thickness=0.36 //x=1.6 //y=3.88 //x2=1.6 //y2=4.25
r144 (  3 4 ) resistor r=0.353053 //w=0.131 //l=0.37 //layer=m1 \
 //thickness=0.36 //x=1.6 //y=3.51 //x2=1.6 //y2=3.88
r145 (  2 3 ) resistor r=0.353053 //w=0.131 //l=0.37 //layer=m1 \
 //thickness=0.36 //x=1.6 //y=3.14 //x2=1.6 //y2=3.51
r146 (  1 2 ) resistor r=0.353053 //w=0.131 //l=0.37 //layer=m1 \
 //thickness=0.36 //x=1.6 //y=2.77 //x2=1.6 //y2=3.14
r147 (  1 7 ) resistor r=0.376908 //w=0.131 //l=0.395 //layer=m1 \
 //thickness=0.36 //x=1.6 //y=2.77 //x2=1.6 //y2=2.375
ends PM_DFFSNRNQNX1\%D

subckt PM_DFFSNRNQNX1\%noxref_12 ( 5 7 15 19 30 33 34 )
c65 ( 34 0 ) capacitor c=0.0480863f //x=3.455 //y=0.555
c66 ( 33 0 ) capacitor c=0.0198665f //x=2.35 //y=1.09
c67 ( 30 0 ) capacitor c=0.00141302f //x=3.59 //y=1.175
c68 ( 19 0 ) capacitor c=0.00692795f //x=4.56 //y=0.805
c69 ( 15 0 ) capacitor c=0.0154871f //x=4.475 //y=0.72
c70 ( 7 0 ) capacitor c=0.00689459f //x=3.59 //y=0.805
c71 ( 5 0 ) capacitor c=0.0288646f //x=3.505 //y=1.175
r72 (  19 34 ) resistor r=3.57586 //w=0.17 //l=0.125 //layer=li \
 //thickness=0.1 //x=4.56 //y=0.805 //x2=4.56 //y2=0.68
r73 (  19 34 ) resistor r=18.139 //w=0.187 //l=0.265 //layer=li \
 //thickness=0.1 //x=4.56 //y=0.805 //x2=4.56 //y2=1.07
r74 (  16 34 ) resistor r=3.57586 //w=0.17 //l=0.103078 //layer=li \
 //thickness=0.1 //x=3.675 //y=0.72 //x2=3.59 //y2=0.68
r75 (  16 34 ) resistor r=27.3797 //w=0.187 //l=0.4 //layer=li //thickness=0.1 \
 //x=3.675 //y=0.72 //x2=4.075 //y2=0.72
r76 (  15 34 ) resistor r=3.57586 //w=0.17 //l=0.103078 //layer=li \
 //thickness=0.1 //x=4.475 //y=0.72 //x2=4.56 //y2=0.68
r77 (  15 34 ) resistor r=27.3797 //w=0.187 //l=0.4 //layer=li //thickness=0.1 \
 //x=4.475 //y=0.72 //x2=4.075 //y2=0.72
r78 (  11 30 ) resistor r=5.4201 //w=0.17 //l=0.085 //layer=li //thickness=0.1 \
 //x=3.59 //y=1.26 //x2=3.59 //y2=1.175
r79 (  11 34 ) resistor r=10.2674 //w=0.187 //l=0.15 //layer=li \
 //thickness=0.1 //x=3.59 //y=1.26 //x2=3.59 //y2=1.41
r80 (  8 30 ) resistor r=5.4201 //w=0.17 //l=0.085 //layer=li //thickness=0.1 \
 //x=3.59 //y=1.09 //x2=3.59 //y2=1.175
r81 (  8 34 ) resistor r=1.36898 //w=0.187 //l=0.02 //layer=li //thickness=0.1 \
 //x=3.59 //y=1.09 //x2=3.59 //y2=1.07
r82 (  7 34 ) resistor r=3.57586 //w=0.17 //l=0.125 //layer=li //thickness=0.1 \
 //x=3.59 //y=0.805 //x2=3.59 //y2=0.68
r83 (  7 34 ) resistor r=18.139 //w=0.187 //l=0.265 //layer=li //thickness=0.1 \
 //x=3.59 //y=0.805 //x2=3.59 //y2=1.07
r84 (  6 33 ) resistor r=0.751729 //w=0.17 //l=0.085 //layer=li \
 //thickness=0.1 //x=2.625 //y=1.175 //x2=2.54 //y2=1.175
r85 (  5 30 ) resistor r=1.40859 //w=0.34 //l=0.085 //layer=li //thickness=0.1 \
 //x=3.505 //y=1.175 //x2=3.59 //y2=1.175
r86 (  5 6 ) resistor r=60.2353 //w=0.187 //l=0.88 //layer=li //thickness=0.1 \
 //x=3.505 //y=1.175 //x2=2.625 //y2=1.175
ends PM_DFFSNRNQNX1\%noxref_12

subckt PM_DFFSNRNQNX1\%noxref_13 ( 5 7 15 19 30 33 34 )
c69 ( 34 0 ) capacitor c=0.0458754f //x=8.265 //y=0.555
c70 ( 33 0 ) capacitor c=0.0194364f //x=7.16 //y=1.09
c71 ( 30 0 ) capacitor c=0.00141302f //x=8.4 //y=1.175
c72 ( 19 0 ) capacitor c=0.00692795f //x=9.37 //y=0.805
c73 ( 15 0 ) capacitor c=0.0155241f //x=9.285 //y=0.72
c74 ( 7 0 ) capacitor c=0.00689459f //x=8.4 //y=0.805
c75 ( 5 0 ) capacitor c=0.0247697f //x=8.315 //y=1.175
r76 (  19 34 ) resistor r=3.57586 //w=0.17 //l=0.125 //layer=li \
 //thickness=0.1 //x=9.37 //y=0.805 //x2=9.37 //y2=0.68
r77 (  19 34 ) resistor r=18.139 //w=0.187 //l=0.265 //layer=li \
 //thickness=0.1 //x=9.37 //y=0.805 //x2=9.37 //y2=1.07
r78 (  16 34 ) resistor r=3.57586 //w=0.17 //l=0.103078 //layer=li \
 //thickness=0.1 //x=8.485 //y=0.72 //x2=8.4 //y2=0.68
r79 (  16 34 ) resistor r=27.3797 //w=0.187 //l=0.4 //layer=li //thickness=0.1 \
 //x=8.485 //y=0.72 //x2=8.885 //y2=0.72
r80 (  15 34 ) resistor r=3.57586 //w=0.17 //l=0.103078 //layer=li \
 //thickness=0.1 //x=9.285 //y=0.72 //x2=9.37 //y2=0.68
r81 (  15 34 ) resistor r=27.3797 //w=0.187 //l=0.4 //layer=li //thickness=0.1 \
 //x=9.285 //y=0.72 //x2=8.885 //y2=0.72
r82 (  11 30 ) resistor r=5.4201 //w=0.17 //l=0.085 //layer=li //thickness=0.1 \
 //x=8.4 //y=1.26 //x2=8.4 //y2=1.175
r83 (  11 34 ) resistor r=10.2674 //w=0.187 //l=0.15 //layer=li \
 //thickness=0.1 //x=8.4 //y=1.26 //x2=8.4 //y2=1.41
r84 (  8 30 ) resistor r=5.4201 //w=0.17 //l=0.085 //layer=li //thickness=0.1 \
 //x=8.4 //y=1.09 //x2=8.4 //y2=1.175
r85 (  8 34 ) resistor r=1.36898 //w=0.187 //l=0.02 //layer=li //thickness=0.1 \
 //x=8.4 //y=1.09 //x2=8.4 //y2=1.07
r86 (  7 34 ) resistor r=3.57586 //w=0.17 //l=0.125 //layer=li //thickness=0.1 \
 //x=8.4 //y=0.805 //x2=8.4 //y2=0.68
r87 (  7 34 ) resistor r=18.139 //w=0.187 //l=0.265 //layer=li //thickness=0.1 \
 //x=8.4 //y=0.805 //x2=8.4 //y2=1.07
r88 (  6 33 ) resistor r=0.751729 //w=0.17 //l=0.085 //layer=li \
 //thickness=0.1 //x=7.435 //y=1.175 //x2=7.35 //y2=1.175
r89 (  5 30 ) resistor r=1.40859 //w=0.34 //l=0.085 //layer=li //thickness=0.1 \
 //x=8.315 //y=1.175 //x2=8.4 //y2=1.175
r90 (  5 6 ) resistor r=60.2353 //w=0.187 //l=0.88 //layer=li //thickness=0.1 \
 //x=8.315 //y=1.175 //x2=7.435 //y2=1.175
ends PM_DFFSNRNQNX1\%noxref_13

subckt PM_DFFSNRNQNX1\%noxref_14 ( 5 7 15 19 30 33 34 )
c72 ( 34 0 ) capacitor c=0.0448619f //x=13.075 //y=0.555
c73 ( 33 0 ) capacitor c=0.0195274f //x=11.97 //y=1.09
c74 ( 30 0 ) capacitor c=0.00141302f //x=13.21 //y=1.175
c75 ( 19 0 ) capacitor c=0.00692795f //x=14.18 //y=0.805
c76 ( 15 0 ) capacitor c=0.0154779f //x=14.095 //y=0.72
c77 ( 7 0 ) capacitor c=0.00689459f //x=13.21 //y=0.805
c78 ( 5 0 ) capacitor c=0.024158f //x=13.125 //y=1.175
r79 (  19 34 ) resistor r=3.57586 //w=0.17 //l=0.125 //layer=li \
 //thickness=0.1 //x=14.18 //y=0.805 //x2=14.18 //y2=0.68
r80 (  19 34 ) resistor r=18.139 //w=0.187 //l=0.265 //layer=li \
 //thickness=0.1 //x=14.18 //y=0.805 //x2=14.18 //y2=1.07
r81 (  16 34 ) resistor r=3.57586 //w=0.17 //l=0.103078 //layer=li \
 //thickness=0.1 //x=13.295 //y=0.72 //x2=13.21 //y2=0.68
r82 (  16 34 ) resistor r=27.3797 //w=0.187 //l=0.4 //layer=li //thickness=0.1 \
 //x=13.295 //y=0.72 //x2=13.695 //y2=0.72
r83 (  15 34 ) resistor r=3.57586 //w=0.17 //l=0.103078 //layer=li \
 //thickness=0.1 //x=14.095 //y=0.72 //x2=14.18 //y2=0.68
r84 (  15 34 ) resistor r=27.3797 //w=0.187 //l=0.4 //layer=li //thickness=0.1 \
 //x=14.095 //y=0.72 //x2=13.695 //y2=0.72
r85 (  11 30 ) resistor r=5.4201 //w=0.17 //l=0.085 //layer=li //thickness=0.1 \
 //x=13.21 //y=1.26 //x2=13.21 //y2=1.175
r86 (  11 34 ) resistor r=10.2674 //w=0.187 //l=0.15 //layer=li \
 //thickness=0.1 //x=13.21 //y=1.26 //x2=13.21 //y2=1.41
r87 (  8 30 ) resistor r=5.4201 //w=0.17 //l=0.085 //layer=li //thickness=0.1 \
 //x=13.21 //y=1.09 //x2=13.21 //y2=1.175
r88 (  8 34 ) resistor r=1.36898 //w=0.187 //l=0.02 //layer=li //thickness=0.1 \
 //x=13.21 //y=1.09 //x2=13.21 //y2=1.07
r89 (  7 34 ) resistor r=3.57586 //w=0.17 //l=0.125 //layer=li //thickness=0.1 \
 //x=13.21 //y=0.805 //x2=13.21 //y2=0.68
r90 (  7 34 ) resistor r=18.139 //w=0.187 //l=0.265 //layer=li //thickness=0.1 \
 //x=13.21 //y=0.805 //x2=13.21 //y2=1.07
r91 (  6 33 ) resistor r=0.751729 //w=0.17 //l=0.085 //layer=li \
 //thickness=0.1 //x=12.245 //y=1.175 //x2=12.16 //y2=1.175
r92 (  5 30 ) resistor r=1.40859 //w=0.34 //l=0.085 //layer=li //thickness=0.1 \
 //x=13.125 //y=1.175 //x2=13.21 //y2=1.175
r93 (  5 6 ) resistor r=60.2353 //w=0.187 //l=0.88 //layer=li //thickness=0.1 \
 //x=13.125 //y=1.175 //x2=12.245 //y2=1.175
ends PM_DFFSNRNQNX1\%noxref_14

subckt PM_DFFSNRNQNX1\%noxref_15 ( 5 7 15 19 30 33 34 )
c71 ( 34 0 ) capacitor c=0.0458165f //x=17.885 //y=0.555
c72 ( 33 0 ) capacitor c=0.0188075f //x=16.78 //y=1.09
c73 ( 30 0 ) capacitor c=0.00141302f //x=18.02 //y=1.175
c74 ( 19 0 ) capacitor c=0.00692795f //x=18.99 //y=0.805
c75 ( 15 0 ) capacitor c=0.0154025f //x=18.905 //y=0.72
c76 ( 7 0 ) capacitor c=0.00689459f //x=18.02 //y=0.805
c77 ( 5 0 ) capacitor c=0.0241875f //x=17.935 //y=1.175
r78 (  19 34 ) resistor r=3.57586 //w=0.17 //l=0.125 //layer=li \
 //thickness=0.1 //x=18.99 //y=0.805 //x2=18.99 //y2=0.68
r79 (  19 34 ) resistor r=18.139 //w=0.187 //l=0.265 //layer=li \
 //thickness=0.1 //x=18.99 //y=0.805 //x2=18.99 //y2=1.07
r80 (  16 34 ) resistor r=3.57586 //w=0.17 //l=0.103078 //layer=li \
 //thickness=0.1 //x=18.105 //y=0.72 //x2=18.02 //y2=0.68
r81 (  16 34 ) resistor r=27.3797 //w=0.187 //l=0.4 //layer=li //thickness=0.1 \
 //x=18.105 //y=0.72 //x2=18.505 //y2=0.72
r82 (  15 34 ) resistor r=3.57586 //w=0.17 //l=0.103078 //layer=li \
 //thickness=0.1 //x=18.905 //y=0.72 //x2=18.99 //y2=0.68
r83 (  15 34 ) resistor r=27.3797 //w=0.187 //l=0.4 //layer=li //thickness=0.1 \
 //x=18.905 //y=0.72 //x2=18.505 //y2=0.72
r84 (  11 30 ) resistor r=5.4201 //w=0.17 //l=0.085 //layer=li //thickness=0.1 \
 //x=18.02 //y=1.26 //x2=18.02 //y2=1.175
r85 (  11 34 ) resistor r=10.2674 //w=0.187 //l=0.15 //layer=li \
 //thickness=0.1 //x=18.02 //y=1.26 //x2=18.02 //y2=1.41
r86 (  8 30 ) resistor r=5.4201 //w=0.17 //l=0.085 //layer=li //thickness=0.1 \
 //x=18.02 //y=1.09 //x2=18.02 //y2=1.175
r87 (  8 34 ) resistor r=1.36898 //w=0.187 //l=0.02 //layer=li //thickness=0.1 \
 //x=18.02 //y=1.09 //x2=18.02 //y2=1.07
r88 (  7 34 ) resistor r=3.57586 //w=0.17 //l=0.125 //layer=li //thickness=0.1 \
 //x=18.02 //y=0.805 //x2=18.02 //y2=0.68
r89 (  7 34 ) resistor r=18.139 //w=0.187 //l=0.265 //layer=li //thickness=0.1 \
 //x=18.02 //y=0.805 //x2=18.02 //y2=1.07
r90 (  6 33 ) resistor r=0.751729 //w=0.17 //l=0.085 //layer=li \
 //thickness=0.1 //x=17.055 //y=1.175 //x2=16.97 //y2=1.175
r91 (  5 30 ) resistor r=1.40859 //w=0.34 //l=0.085 //layer=li //thickness=0.1 \
 //x=17.935 //y=1.175 //x2=18.02 //y2=1.175
r92 (  5 6 ) resistor r=60.2353 //w=0.187 //l=0.88 //layer=li //thickness=0.1 \
 //x=17.935 //y=1.175 //x2=17.055 //y2=1.175
ends PM_DFFSNRNQNX1\%noxref_15

subckt PM_DFFSNRNQNX1\%noxref_16 ( 5 7 15 19 30 33 34 )
c70 ( 34 0 ) capacitor c=0.0453394f //x=22.695 //y=0.555
c71 ( 33 0 ) capacitor c=0.0195149f //x=21.59 //y=1.09
c72 ( 30 0 ) capacitor c=0.00141302f //x=22.83 //y=1.175
c73 ( 19 0 ) capacitor c=0.00692795f //x=23.8 //y=0.805
c74 ( 15 0 ) capacitor c=0.0154975f //x=23.715 //y=0.72
c75 ( 7 0 ) capacitor c=0.00689459f //x=22.83 //y=0.805
c76 ( 5 0 ) capacitor c=0.0241875f //x=22.745 //y=1.175
r77 (  19 34 ) resistor r=3.57586 //w=0.17 //l=0.125 //layer=li \
 //thickness=0.1 //x=23.8 //y=0.805 //x2=23.8 //y2=0.68
r78 (  19 34 ) resistor r=18.139 //w=0.187 //l=0.265 //layer=li \
 //thickness=0.1 //x=23.8 //y=0.805 //x2=23.8 //y2=1.07
r79 (  16 34 ) resistor r=3.57586 //w=0.17 //l=0.103078 //layer=li \
 //thickness=0.1 //x=22.915 //y=0.72 //x2=22.83 //y2=0.68
r80 (  16 34 ) resistor r=27.3797 //w=0.187 //l=0.4 //layer=li //thickness=0.1 \
 //x=22.915 //y=0.72 //x2=23.315 //y2=0.72
r81 (  15 34 ) resistor r=3.57586 //w=0.17 //l=0.103078 //layer=li \
 //thickness=0.1 //x=23.715 //y=0.72 //x2=23.8 //y2=0.68
r82 (  15 34 ) resistor r=27.3797 //w=0.187 //l=0.4 //layer=li //thickness=0.1 \
 //x=23.715 //y=0.72 //x2=23.315 //y2=0.72
r83 (  11 30 ) resistor r=5.4201 //w=0.17 //l=0.085 //layer=li //thickness=0.1 \
 //x=22.83 //y=1.26 //x2=22.83 //y2=1.175
r84 (  11 34 ) resistor r=10.2674 //w=0.187 //l=0.15 //layer=li \
 //thickness=0.1 //x=22.83 //y=1.26 //x2=22.83 //y2=1.41
r85 (  8 30 ) resistor r=5.4201 //w=0.17 //l=0.085 //layer=li //thickness=0.1 \
 //x=22.83 //y=1.09 //x2=22.83 //y2=1.175
r86 (  8 34 ) resistor r=1.36898 //w=0.187 //l=0.02 //layer=li //thickness=0.1 \
 //x=22.83 //y=1.09 //x2=22.83 //y2=1.07
r87 (  7 34 ) resistor r=3.57586 //w=0.17 //l=0.125 //layer=li //thickness=0.1 \
 //x=22.83 //y=0.805 //x2=22.83 //y2=0.68
r88 (  7 34 ) resistor r=18.139 //w=0.187 //l=0.265 //layer=li //thickness=0.1 \
 //x=22.83 //y=0.805 //x2=22.83 //y2=1.07
r89 (  6 33 ) resistor r=0.751729 //w=0.17 //l=0.085 //layer=li \
 //thickness=0.1 //x=21.865 //y=1.175 //x2=21.78 //y2=1.175
r90 (  5 30 ) resistor r=1.40859 //w=0.34 //l=0.085 //layer=li //thickness=0.1 \
 //x=22.745 //y=1.175 //x2=22.83 //y2=1.175
r91 (  5 6 ) resistor r=60.2353 //w=0.187 //l=0.88 //layer=li //thickness=0.1 \
 //x=22.745 //y=1.175 //x2=21.865 //y2=1.175
ends PM_DFFSNRNQNX1\%noxref_16

subckt PM_DFFSNRNQNX1\%GND ( 1 2 6 7 18 19 30 31 43 44 55 56 67 74 77 81 85 89 \
 93 97 102 105 119 136 153 170 196 204 205 206 207 208 209 210 211 212 213 214 )
c484 ( 214 0 ) capacitor c=0.00840423f //x=25.425 //y=1.055
c485 ( 213 0 ) capacitor c=0.00840423f //x=20.615 //y=1.055
c486 ( 212 0 ) capacitor c=0.00840423f //x=15.805 //y=1.055
c487 ( 211 0 ) capacitor c=0.00840423f //x=10.995 //y=1.055
c488 ( 210 0 ) capacitor c=0.00840423f //x=6.185 //y=1.055
c489 ( 209 0 ) capacitor c=0.00840423f //x=1.375 //y=1.055
c490 ( 208 0 ) capacitor c=0.113796f //x=24.54 //y=0.175
c491 ( 207 0 ) capacitor c=0.114085f //x=19.73 //y=0.175
c492 ( 206 0 ) capacitor c=0.113933f //x=14.92 //y=0.175
c493 ( 205 0 ) capacitor c=0.114059f //x=10.11 //y=0.175
c494 ( 204 0 ) capacitor c=0.113562f //x=5.3 //y=0.175
c495 ( 196 0 ) capacitor c=0.392589f //x=28.61 //y=0.18
c496 ( 170 0 ) capacitor c=0.179669f //x=24.37 //y=0.175
c497 ( 153 0 ) capacitor c=0.181344f //x=19.56 //y=0.175
c498 ( 136 0 ) capacitor c=0.179844f //x=14.75 //y=0.175
c499 ( 119 0 ) capacitor c=0.181534f //x=9.94 //y=0.175
c500 ( 105 0 ) capacitor c=0.197064f //x=1.23 //y=0.18
c501 ( 102 0 ) capacitor c=0.179669f //x=5.13 //y=0.175
c502 ( 99 0 ) capacitor c=0.00509414f //x=25.615 //y=0.175
c503 ( 97 0 ) capacitor c=0.0134587f //x=25.615 //y=1.145
c504 ( 95 0 ) capacitor c=0.00509414f //x=20.805 //y=0.175
c505 ( 93 0 ) capacitor c=0.0141128f //x=20.805 //y=1.145
c506 ( 91 0 ) capacitor c=0.00509414f //x=15.995 //y=0.175
c507 ( 89 0 ) capacitor c=0.0140023f //x=15.995 //y=1.145
c508 ( 87 0 ) capacitor c=0.00509414f //x=11.185 //y=0.175
c509 ( 85 0 ) capacitor c=0.0140762f //x=11.185 //y=1.145
c510 ( 83 0 ) capacitor c=0.00509414f //x=6.375 //y=0.175
c511 ( 81 0 ) capacitor c=0.0142365f //x=6.375 //y=1.145
c512 ( 79 0 ) capacitor c=0.00509414f //x=1.565 //y=0.175
c513 ( 77 0 ) capacitor c=0.0171724f //x=1.565 //y=1.145
c514 ( 74 0 ) capacitor c=0.146372f //x=28.61 //y=0.18
c515 ( 67 0 ) capacitor c=0.0302305f //x=25.615 //y=1.015
c516 ( 56 0 ) capacitor c=0.149114f //x=25.53 //y=0.175
c517 ( 55 0 ) capacitor c=0.0302305f //x=20.805 //y=1.015
c518 ( 44 0 ) capacitor c=0.149461f //x=20.72 //y=0.175
c519 ( 43 0 ) capacitor c=0.0302305f //x=15.995 //y=1.015
c520 ( 31 0 ) capacitor c=0.148742f //x=15.91 //y=0.175
c521 ( 30 0 ) capacitor c=0.0302305f //x=11.185 //y=1.015
c522 ( 19 0 ) capacitor c=0.149342f //x=11.1 //y=0.175
c523 ( 18 0 ) capacitor c=0.0302305f //x=6.375 //y=1.015
c524 ( 7 0 ) capacitor c=0.148913f //x=6.29 //y=0.175
c525 ( 6 0 ) capacitor c=0.0302305f //x=1.565 //y=1.015
c526 ( 2 0 ) capacitor c=0.0710427f //x=1.48 //y=0.175
r527 (  194 196 ) resistor r=38.7139 //w=0.367 //l=1.11 //layer=li \
 //thickness=0.1 //x=27.5 //y=0.175 //x2=28.61 //y2=0.175
r528 (  192 194 ) resistor r=38.7139 //w=0.367 //l=1.11 //layer=li \
 //thickness=0.1 //x=26.39 //y=0.175 //x2=27.5 //y2=0.175
r529 (  190 192 ) resistor r=38.7139 //w=0.367 //l=1.11 //layer=li \
 //thickness=0.1 //x=25.28 //y=0.175 //x2=26.39 //y2=0.175
r530 (  188 208 ) resistor r=5.29055 //w=0.35 //l=0.17 //layer=li \
 //thickness=0.1 //x=24.71 //y=0.175 //x2=24.54 //y2=0.175
r531 (  188 190 ) resistor r=19.8801 //w=0.367 //l=0.57 //layer=li \
 //thickness=0.1 //x=24.71 //y=0.175 //x2=25.28 //y2=0.175
r532 (  177 179 ) resistor r=38.7139 //w=0.367 //l=1.11 //layer=li \
 //thickness=0.1 //x=22.69 //y=0.175 //x2=23.8 //y2=0.175
r533 (  175 177 ) resistor r=38.7139 //w=0.367 //l=1.11 //layer=li \
 //thickness=0.1 //x=21.58 //y=0.175 //x2=22.69 //y2=0.175
r534 (  173 175 ) resistor r=38.7139 //w=0.367 //l=1.11 //layer=li \
 //thickness=0.1 //x=20.47 //y=0.175 //x2=21.58 //y2=0.175
r535 (  171 207 ) resistor r=5.29055 //w=0.35 //l=0.17 //layer=li \
 //thickness=0.1 //x=19.9 //y=0.175 //x2=19.73 //y2=0.175
r536 (  171 173 ) resistor r=19.8801 //w=0.367 //l=0.57 //layer=li \
 //thickness=0.1 //x=19.9 //y=0.175 //x2=20.47 //y2=0.175
r537 (  170 208 ) resistor r=5.29055 //w=0.35 //l=0.17 //layer=li \
 //thickness=0.1 //x=24.37 //y=0.175 //x2=24.54 //y2=0.175
r538 (  170 179 ) resistor r=19.8801 //w=0.367 //l=0.57 //layer=li \
 //thickness=0.1 //x=24.37 //y=0.175 //x2=23.8 //y2=0.175
r539 (  160 162 ) resistor r=38.7139 //w=0.367 //l=1.11 //layer=li \
 //thickness=0.1 //x=17.88 //y=0.175 //x2=18.99 //y2=0.175
r540 (  158 160 ) resistor r=38.7139 //w=0.367 //l=1.11 //layer=li \
 //thickness=0.1 //x=16.77 //y=0.175 //x2=17.88 //y2=0.175
r541 (  156 158 ) resistor r=38.7139 //w=0.367 //l=1.11 //layer=li \
 //thickness=0.1 //x=15.66 //y=0.175 //x2=16.77 //y2=0.175
r542 (  154 206 ) resistor r=5.29055 //w=0.35 //l=0.17 //layer=li \
 //thickness=0.1 //x=15.09 //y=0.175 //x2=14.92 //y2=0.175
r543 (  154 156 ) resistor r=19.8801 //w=0.367 //l=0.57 //layer=li \
 //thickness=0.1 //x=15.09 //y=0.175 //x2=15.66 //y2=0.175
r544 (  153 207 ) resistor r=5.29055 //w=0.35 //l=0.17 //layer=li \
 //thickness=0.1 //x=19.56 //y=0.175 //x2=19.73 //y2=0.175
r545 (  153 162 ) resistor r=19.8801 //w=0.367 //l=0.57 //layer=li \
 //thickness=0.1 //x=19.56 //y=0.175 //x2=18.99 //y2=0.175
r546 (  143 145 ) resistor r=38.7139 //w=0.367 //l=1.11 //layer=li \
 //thickness=0.1 //x=13.07 //y=0.175 //x2=14.18 //y2=0.175
r547 (  141 143 ) resistor r=38.7139 //w=0.367 //l=1.11 //layer=li \
 //thickness=0.1 //x=11.96 //y=0.175 //x2=13.07 //y2=0.175
r548 (  139 141 ) resistor r=38.7139 //w=0.367 //l=1.11 //layer=li \
 //thickness=0.1 //x=10.85 //y=0.175 //x2=11.96 //y2=0.175
r549 (  137 205 ) resistor r=5.29055 //w=0.35 //l=0.17 //layer=li \
 //thickness=0.1 //x=10.28 //y=0.175 //x2=10.11 //y2=0.175
r550 (  137 139 ) resistor r=19.8801 //w=0.367 //l=0.57 //layer=li \
 //thickness=0.1 //x=10.28 //y=0.175 //x2=10.85 //y2=0.175
r551 (  136 206 ) resistor r=5.29055 //w=0.35 //l=0.17 //layer=li \
 //thickness=0.1 //x=14.75 //y=0.175 //x2=14.92 //y2=0.175
r552 (  136 145 ) resistor r=19.8801 //w=0.367 //l=0.57 //layer=li \
 //thickness=0.1 //x=14.75 //y=0.175 //x2=14.18 //y2=0.175
r553 (  126 128 ) resistor r=38.7139 //w=0.367 //l=1.11 //layer=li \
 //thickness=0.1 //x=8.26 //y=0.175 //x2=9.37 //y2=0.175
r554 (  124 126 ) resistor r=38.7139 //w=0.367 //l=1.11 //layer=li \
 //thickness=0.1 //x=7.15 //y=0.175 //x2=8.26 //y2=0.175
r555 (  122 124 ) resistor r=38.7139 //w=0.367 //l=1.11 //layer=li \
 //thickness=0.1 //x=6.04 //y=0.175 //x2=7.15 //y2=0.175
r556 (  120 204 ) resistor r=5.29055 //w=0.35 //l=0.17 //layer=li \
 //thickness=0.1 //x=5.47 //y=0.175 //x2=5.3 //y2=0.175
r557 (  120 122 ) resistor r=19.8801 //w=0.367 //l=0.57 //layer=li \
 //thickness=0.1 //x=5.47 //y=0.175 //x2=6.04 //y2=0.175
r558 (  119 205 ) resistor r=5.29055 //w=0.35 //l=0.17 //layer=li \
 //thickness=0.1 //x=9.94 //y=0.175 //x2=10.11 //y2=0.175
r559 (  119 128 ) resistor r=19.8801 //w=0.367 //l=0.57 //layer=li \
 //thickness=0.1 //x=9.94 //y=0.175 //x2=9.37 //y2=0.175
r560 (  109 111 ) resistor r=38.7139 //w=0.367 //l=1.11 //layer=li \
 //thickness=0.1 //x=3.45 //y=0.175 //x2=4.56 //y2=0.175
r561 (  107 109 ) resistor r=38.7139 //w=0.367 //l=1.11 //layer=li \
 //thickness=0.1 //x=2.34 //y=0.175 //x2=3.45 //y2=0.175
r562 (  105 107 ) resistor r=38.7139 //w=0.367 //l=1.11 //layer=li \
 //thickness=0.1 //x=1.23 //y=0.175 //x2=2.34 //y2=0.175
r563 (  102 204 ) resistor r=5.29055 //w=0.35 //l=0.17 //layer=li \
 //thickness=0.1 //x=5.13 //y=0.175 //x2=5.3 //y2=0.175
r564 (  102 111 ) resistor r=19.8801 //w=0.367 //l=0.57 //layer=li \
 //thickness=0.1 //x=5.13 //y=0.175 //x2=4.56 //y2=0.175
r565 (  97 214 ) resistor r=9.3 //w=0.17 //l=0.17 //layer=mcon //count=1 \
 //x=25.615 //y=1.145 //x2=25.615 //y2=1.145
r566 (  93 213 ) resistor r=9.3 //w=0.17 //l=0.17 //layer=mcon //count=1 \
 //x=20.805 //y=1.145 //x2=20.805 //y2=1.145
r567 (  89 212 ) resistor r=9.3 //w=0.17 //l=0.17 //layer=mcon //count=1 \
 //x=15.995 //y=1.145 //x2=15.995 //y2=1.145
r568 (  85 211 ) resistor r=9.3 //w=0.17 //l=0.17 //layer=mcon //count=1 \
 //x=11.185 //y=1.145 //x2=11.185 //y2=1.145
r569 (  81 210 ) resistor r=9.3 //w=0.17 //l=0.17 //layer=mcon //count=1 \
 //x=6.375 //y=1.145 //x2=6.375 //y2=1.145
r570 (  77 209 ) resistor r=9.3 //w=0.17 //l=0.17 //layer=mcon //count=1 \
 //x=1.565 //y=1.145 //x2=1.565 //y2=1.145
r571 (  74 196 ) resistor r=3.1 //w=0.17 //l=0.51 //layer=mcon //count=3 \
 //x=28.61 //y=0.18 //x2=28.61 //y2=0.18
r572 (  72 194 ) resistor r=3.1 //w=0.17 //l=0.51 //layer=mcon //count=3 \
 //x=27.5 //y=0.18 //x2=27.5 //y2=0.18
r573 (  72 74 ) resistor r=0.446141 //w=0.311 //l=1.11 //layer=m1 \
 //thickness=0.36 //x=27.5 //y=0.175 //x2=28.61 //y2=0.175
r574 (  70 192 ) resistor r=3.1 //w=0.17 //l=0.51 //layer=mcon //count=3 \
 //x=26.39 //y=0.18 //x2=26.39 //y2=0.18
r575 (  70 72 ) resistor r=0.446141 //w=0.311 //l=1.11 //layer=m1 \
 //thickness=0.36 //x=26.39 //y=0.175 //x2=27.5 //y2=0.175
r576 (  68 99 ) resistor r=0.028033 //w=0.35 //l=0.085 //layer=m1 \
 //thickness=0.36 //x=25.7 //y=0.175 //x2=25.615 //y2=0.175
r577 (  68 70 ) resistor r=0.277331 //w=0.311 //l=0.69 //layer=m1 \
 //thickness=0.36 //x=25.7 //y=0.175 //x2=26.39 //y2=0.175
r578 (  67 97 ) resistor r=0.0942778 //w=0.221 //l=0.13 //layer=m1 \
 //thickness=0.36 //x=25.615 //y=1.015 //x2=25.615 //y2=1.145
r579 (  66 99 ) resistor r=0.0413265 //w=0.7 //l=0.175 //layer=m1 \
 //thickness=0.36 //x=25.615 //y=0.35 //x2=25.615 //y2=0.175
r580 (  66 67 ) resistor r=0.634542 //w=0.131 //l=0.665 //layer=m1 \
 //thickness=0.36 //x=25.615 //y=0.35 //x2=25.615 //y2=1.015
r581 (  65 190 ) resistor r=3.1 //w=0.17 //l=0.51 //layer=mcon //count=3 \
 //x=25.28 //y=0.18 //x2=25.28 //y2=0.18
r582 (  63 179 ) resistor r=3.1 //w=0.17 //l=0.51 //layer=mcon //count=3 \
 //x=23.8 //y=0.18 //x2=23.8 //y2=0.18
r583 (  63 65 ) resistor r=0.594855 //w=0.311 //l=1.48 //layer=m1 \
 //thickness=0.36 //x=23.8 //y=0.175 //x2=25.28 //y2=0.175
r584 (  61 177 ) resistor r=3.1 //w=0.17 //l=0.51 //layer=mcon //count=3 \
 //x=22.69 //y=0.18 //x2=22.69 //y2=0.18
r585 (  61 63 ) resistor r=0.446141 //w=0.311 //l=1.11 //layer=m1 \
 //thickness=0.36 //x=22.69 //y=0.175 //x2=23.8 //y2=0.175
r586 (  59 175 ) resistor r=3.1 //w=0.17 //l=0.51 //layer=mcon //count=3 \
 //x=21.58 //y=0.18 //x2=21.58 //y2=0.18
r587 (  59 61 ) resistor r=0.446141 //w=0.311 //l=1.11 //layer=m1 \
 //thickness=0.36 //x=21.58 //y=0.175 //x2=22.69 //y2=0.175
r588 (  57 95 ) resistor r=0.028033 //w=0.35 //l=0.085 //layer=m1 \
 //thickness=0.36 //x=20.89 //y=0.175 //x2=20.805 //y2=0.175
r589 (  57 59 ) resistor r=0.277331 //w=0.311 //l=0.69 //layer=m1 \
 //thickness=0.36 //x=20.89 //y=0.175 //x2=21.58 //y2=0.175
r590 (  56 99 ) resistor r=0.028033 //w=0.35 //l=0.085 //layer=m1 \
 //thickness=0.36 //x=25.53 //y=0.175 //x2=25.615 //y2=0.175
r591 (  56 65 ) resistor r=0.100482 //w=0.311 //l=0.25 //layer=m1 \
 //thickness=0.36 //x=25.53 //y=0.175 //x2=25.28 //y2=0.175
r592 (  55 93 ) resistor r=0.0942778 //w=0.221 //l=0.13 //layer=m1 \
 //thickness=0.36 //x=20.805 //y=1.015 //x2=20.805 //y2=1.145
r593 (  54 95 ) resistor r=0.0413265 //w=0.7 //l=0.175 //layer=m1 \
 //thickness=0.36 //x=20.805 //y=0.35 //x2=20.805 //y2=0.175
r594 (  54 55 ) resistor r=0.634542 //w=0.131 //l=0.665 //layer=m1 \
 //thickness=0.36 //x=20.805 //y=0.35 //x2=20.805 //y2=1.015
r595 (  53 173 ) resistor r=3.1 //w=0.17 //l=0.51 //layer=mcon //count=3 \
 //x=20.47 //y=0.18 //x2=20.47 //y2=0.18
r596 (  51 162 ) resistor r=3.1 //w=0.17 //l=0.51 //layer=mcon //count=3 \
 //x=18.99 //y=0.18 //x2=18.99 //y2=0.18
r597 (  51 53 ) resistor r=0.594855 //w=0.311 //l=1.48 //layer=m1 \
 //thickness=0.36 //x=18.99 //y=0.175 //x2=20.47 //y2=0.175
r598 (  49 160 ) resistor r=3.1 //w=0.17 //l=0.51 //layer=mcon //count=3 \
 //x=17.88 //y=0.18 //x2=17.88 //y2=0.18
r599 (  49 51 ) resistor r=0.446141 //w=0.311 //l=1.11 //layer=m1 \
 //thickness=0.36 //x=17.88 //y=0.175 //x2=18.99 //y2=0.175
r600 (  47 158 ) resistor r=3.1 //w=0.17 //l=0.51 //layer=mcon //count=3 \
 //x=16.77 //y=0.18 //x2=16.77 //y2=0.18
r601 (  47 49 ) resistor r=0.446141 //w=0.311 //l=1.11 //layer=m1 \
 //thickness=0.36 //x=16.77 //y=0.175 //x2=17.88 //y2=0.175
r602 (  45 91 ) resistor r=0.028033 //w=0.35 //l=0.085 //layer=m1 \
 //thickness=0.36 //x=16.08 //y=0.175 //x2=15.995 //y2=0.175
r603 (  45 47 ) resistor r=0.277331 //w=0.311 //l=0.69 //layer=m1 \
 //thickness=0.36 //x=16.08 //y=0.175 //x2=16.77 //y2=0.175
r604 (  44 95 ) resistor r=0.028033 //w=0.35 //l=0.085 //layer=m1 \
 //thickness=0.36 //x=20.72 //y=0.175 //x2=20.805 //y2=0.175
r605 (  44 53 ) resistor r=0.100482 //w=0.311 //l=0.25 //layer=m1 \
 //thickness=0.36 //x=20.72 //y=0.175 //x2=20.47 //y2=0.175
r606 (  43 89 ) resistor r=0.0942778 //w=0.221 //l=0.13 //layer=m1 \
 //thickness=0.36 //x=15.995 //y=1.015 //x2=15.995 //y2=1.145
r607 (  42 91 ) resistor r=0.0413265 //w=0.7 //l=0.175 //layer=m1 \
 //thickness=0.36 //x=15.995 //y=0.35 //x2=15.995 //y2=0.175
r608 (  42 43 ) resistor r=0.634542 //w=0.131 //l=0.665 //layer=m1 \
 //thickness=0.36 //x=15.995 //y=0.35 //x2=15.995 //y2=1.015
r609 (  41 156 ) resistor r=3.1 //w=0.17 //l=0.51 //layer=mcon //count=3 \
 //x=15.66 //y=0.18 //x2=15.66 //y2=0.18
r610 (  38 145 ) resistor r=3.1 //w=0.17 //l=0.51 //layer=mcon //count=3 \
 //x=14.18 //y=0.18 //x2=14.18 //y2=0.18
r611 (  36 143 ) resistor r=3.1 //w=0.17 //l=0.51 //layer=mcon //count=3 \
 //x=13.07 //y=0.18 //x2=13.07 //y2=0.18
r612 (  36 38 ) resistor r=0.446141 //w=0.311 //l=1.11 //layer=m1 \
 //thickness=0.36 //x=13.07 //y=0.175 //x2=14.18 //y2=0.175
r613 (  34 141 ) resistor r=3.1 //w=0.17 //l=0.51 //layer=mcon //count=3 \
 //x=11.96 //y=0.18 //x2=11.96 //y2=0.18
r614 (  34 36 ) resistor r=0.446141 //w=0.311 //l=1.11 //layer=m1 \
 //thickness=0.36 //x=11.96 //y=0.175 //x2=13.07 //y2=0.175
r615 (  32 87 ) resistor r=0.028033 //w=0.35 //l=0.085 //layer=m1 \
 //thickness=0.36 //x=11.27 //y=0.175 //x2=11.185 //y2=0.175
r616 (  32 34 ) resistor r=0.277331 //w=0.311 //l=0.69 //layer=m1 \
 //thickness=0.36 //x=11.27 //y=0.175 //x2=11.96 //y2=0.175
r617 (  31 91 ) resistor r=0.028033 //w=0.35 //l=0.085 //layer=m1 \
 //thickness=0.36 //x=15.91 //y=0.175 //x2=15.995 //y2=0.175
r618 (  31 41 ) resistor r=0.100482 //w=0.311 //l=0.25 //layer=m1 \
 //thickness=0.36 //x=15.91 //y=0.175 //x2=15.66 //y2=0.175
r619 (  30 85 ) resistor r=0.0942778 //w=0.221 //l=0.13 //layer=m1 \
 //thickness=0.36 //x=11.185 //y=1.015 //x2=11.185 //y2=1.145
r620 (  29 87 ) resistor r=0.0413265 //w=0.7 //l=0.175 //layer=m1 \
 //thickness=0.36 //x=11.185 //y=0.35 //x2=11.185 //y2=0.175
r621 (  29 30 ) resistor r=0.634542 //w=0.131 //l=0.665 //layer=m1 \
 //thickness=0.36 //x=11.185 //y=0.35 //x2=11.185 //y2=1.015
r622 (  28 139 ) resistor r=3.1 //w=0.17 //l=0.51 //layer=mcon //count=3 \
 //x=10.85 //y=0.18 //x2=10.85 //y2=0.18
r623 (  26 128 ) resistor r=3.1 //w=0.17 //l=0.51 //layer=mcon //count=3 \
 //x=9.37 //y=0.18 //x2=9.37 //y2=0.18
r624 (  26 28 ) resistor r=0.594855 //w=0.311 //l=1.48 //layer=m1 \
 //thickness=0.36 //x=9.37 //y=0.175 //x2=10.85 //y2=0.175
r625 (  24 126 ) resistor r=3.1 //w=0.17 //l=0.51 //layer=mcon //count=3 \
 //x=8.26 //y=0.18 //x2=8.26 //y2=0.18
r626 (  24 26 ) resistor r=0.446141 //w=0.311 //l=1.11 //layer=m1 \
 //thickness=0.36 //x=8.26 //y=0.175 //x2=9.37 //y2=0.175
r627 (  22 124 ) resistor r=3.1 //w=0.17 //l=0.51 //layer=mcon //count=3 \
 //x=7.15 //y=0.18 //x2=7.15 //y2=0.18
r628 (  22 24 ) resistor r=0.446141 //w=0.311 //l=1.11 //layer=m1 \
 //thickness=0.36 //x=7.15 //y=0.175 //x2=8.26 //y2=0.175
r629 (  20 83 ) resistor r=0.028033 //w=0.35 //l=0.085 //layer=m1 \
 //thickness=0.36 //x=6.46 //y=0.175 //x2=6.375 //y2=0.175
r630 (  20 22 ) resistor r=0.277331 //w=0.311 //l=0.69 //layer=m1 \
 //thickness=0.36 //x=6.46 //y=0.175 //x2=7.15 //y2=0.175
r631 (  19 87 ) resistor r=0.028033 //w=0.35 //l=0.085 //layer=m1 \
 //thickness=0.36 //x=11.1 //y=0.175 //x2=11.185 //y2=0.175
r632 (  19 28 ) resistor r=0.100482 //w=0.311 //l=0.25 //layer=m1 \
 //thickness=0.36 //x=11.1 //y=0.175 //x2=10.85 //y2=0.175
r633 (  18 81 ) resistor r=0.0942778 //w=0.221 //l=0.13 //layer=m1 \
 //thickness=0.36 //x=6.375 //y=1.015 //x2=6.375 //y2=1.145
r634 (  17 83 ) resistor r=0.0413265 //w=0.7 //l=0.175 //layer=m1 \
 //thickness=0.36 //x=6.375 //y=0.35 //x2=6.375 //y2=0.175
r635 (  17 18 ) resistor r=0.634542 //w=0.131 //l=0.665 //layer=m1 \
 //thickness=0.36 //x=6.375 //y=0.35 //x2=6.375 //y2=1.015
r636 (  16 122 ) resistor r=3.1 //w=0.17 //l=0.51 //layer=mcon //count=3 \
 //x=6.04 //y=0.18 //x2=6.04 //y2=0.18
r637 (  14 111 ) resistor r=3.1 //w=0.17 //l=0.51 //layer=mcon //count=3 \
 //x=4.56 //y=0.18 //x2=4.56 //y2=0.18
r638 (  14 16 ) resistor r=0.594855 //w=0.311 //l=1.48 //layer=m1 \
 //thickness=0.36 //x=4.56 //y=0.175 //x2=6.04 //y2=0.175
r639 (  12 109 ) resistor r=3.1 //w=0.17 //l=0.51 //layer=mcon //count=3 \
 //x=3.45 //y=0.18 //x2=3.45 //y2=0.18
r640 (  12 14 ) resistor r=0.446141 //w=0.311 //l=1.11 //layer=m1 \
 //thickness=0.36 //x=3.45 //y=0.175 //x2=4.56 //y2=0.175
r641 (  10 107 ) resistor r=3.1 //w=0.17 //l=0.51 //layer=mcon //count=3 \
 //x=2.34 //y=0.18 //x2=2.34 //y2=0.18
r642 (  10 12 ) resistor r=0.446141 //w=0.311 //l=1.11 //layer=m1 \
 //thickness=0.36 //x=2.34 //y=0.175 //x2=3.45 //y2=0.175
r643 (  8 79 ) resistor r=0.028033 //w=0.35 //l=0.085 //layer=m1 \
 //thickness=0.36 //x=1.65 //y=0.175 //x2=1.565 //y2=0.175
r644 (  8 10 ) resistor r=0.277331 //w=0.311 //l=0.69 //layer=m1 \
 //thickness=0.36 //x=1.65 //y=0.175 //x2=2.34 //y2=0.175
r645 (  7 83 ) resistor r=0.028033 //w=0.35 //l=0.085 //layer=m1 \
 //thickness=0.36 //x=6.29 //y=0.175 //x2=6.375 //y2=0.175
r646 (  7 16 ) resistor r=0.100482 //w=0.311 //l=0.25 //layer=m1 \
 //thickness=0.36 //x=6.29 //y=0.175 //x2=6.04 //y2=0.175
r647 (  6 77 ) resistor r=0.0942778 //w=0.221 //l=0.13 //layer=m1 \
 //thickness=0.36 //x=1.565 //y=1.015 //x2=1.565 //y2=1.145
r648 (  5 79 ) resistor r=0.0413265 //w=0.7 //l=0.175 //layer=m1 \
 //thickness=0.36 //x=1.565 //y=0.35 //x2=1.565 //y2=0.175
r649 (  5 6 ) resistor r=0.634542 //w=0.131 //l=0.665 //layer=m1 \
 //thickness=0.36 //x=1.565 //y=0.35 //x2=1.565 //y2=1.015
r650 (  4 105 ) resistor r=3.1 //w=0.17 //l=0.51 //layer=mcon //count=3 \
 //x=1.23 //y=0.18 //x2=1.23 //y2=0.18
r651 (  2 79 ) resistor r=0.028033 //w=0.35 //l=0.085 //layer=m1 \
 //thickness=0.36 //x=1.48 //y=0.175 //x2=1.565 //y2=0.175
r652 (  2 4 ) resistor r=0.0892857 //w=0.35 //l=0.25 //layer=m1 \
 //thickness=0.36 //x=1.48 //y=0.175 //x2=1.23 //y2=0.175
r653 (  1 41 ) resistor r=0.297428 //w=0.311 //l=0.74 //layer=m1 \
 //thickness=0.36 //x=14.92 //y=0.175 //x2=15.66 //y2=0.175
r654 (  1 38 ) resistor r=0.297428 //w=0.311 //l=0.74 //layer=m1 \
 //thickness=0.36 //x=14.92 //y=0.175 //x2=14.18 //y2=0.175
ends PM_DFFSNRNQNX1\%GND

subckt PM_DFFSNRNQNX1\%noxref_18 ( 5 7 15 19 30 33 34 )
c64 ( 34 0 ) capacitor c=0.0468134f //x=27.505 //y=0.555
c65 ( 33 0 ) capacitor c=0.018446f //x=26.4 //y=1.09
c66 ( 30 0 ) capacitor c=0.00141302f //x=27.64 //y=1.175
c67 ( 19 0 ) capacitor c=0.00745448f //x=28.61 //y=0.805
c68 ( 15 0 ) capacitor c=0.0154792f //x=28.525 //y=0.72
c69 ( 7 0 ) capacitor c=0.00681713f //x=27.64 //y=0.805
c70 ( 5 0 ) capacitor c=0.0288646f //x=27.555 //y=1.175
r71 (  19 34 ) resistor r=3.57586 //w=0.17 //l=0.125 //layer=li \
 //thickness=0.1 //x=28.61 //y=0.805 //x2=28.61 //y2=0.68
r72 (  19 34 ) resistor r=18.139 //w=0.187 //l=0.265 //layer=li \
 //thickness=0.1 //x=28.61 //y=0.805 //x2=28.61 //y2=1.07
r73 (  16 34 ) resistor r=3.57586 //w=0.17 //l=0.103078 //layer=li \
 //thickness=0.1 //x=27.725 //y=0.72 //x2=27.64 //y2=0.68
r74 (  16 34 ) resistor r=27.3797 //w=0.187 //l=0.4 //layer=li //thickness=0.1 \
 //x=27.725 //y=0.72 //x2=28.125 //y2=0.72
r75 (  15 34 ) resistor r=3.57586 //w=0.17 //l=0.103078 //layer=li \
 //thickness=0.1 //x=28.525 //y=0.72 //x2=28.61 //y2=0.68
r76 (  15 34 ) resistor r=27.3797 //w=0.187 //l=0.4 //layer=li //thickness=0.1 \
 //x=28.525 //y=0.72 //x2=28.125 //y2=0.72
r77 (  11 30 ) resistor r=5.4201 //w=0.17 //l=0.085 //layer=li //thickness=0.1 \
 //x=27.64 //y=1.26 //x2=27.64 //y2=1.175
r78 (  11 34 ) resistor r=10.2674 //w=0.187 //l=0.15 //layer=li \
 //thickness=0.1 //x=27.64 //y=1.26 //x2=27.64 //y2=1.41
r79 (  8 30 ) resistor r=5.4201 //w=0.17 //l=0.085 //layer=li //thickness=0.1 \
 //x=27.64 //y=1.09 //x2=27.64 //y2=1.175
r80 (  8 34 ) resistor r=1.36898 //w=0.187 //l=0.02 //layer=li //thickness=0.1 \
 //x=27.64 //y=1.09 //x2=27.64 //y2=1.07
r81 (  7 34 ) resistor r=3.57586 //w=0.17 //l=0.125 //layer=li //thickness=0.1 \
 //x=27.64 //y=0.805 //x2=27.64 //y2=0.68
r82 (  7 34 ) resistor r=18.139 //w=0.187 //l=0.265 //layer=li //thickness=0.1 \
 //x=27.64 //y=0.805 //x2=27.64 //y2=1.07
r83 (  6 33 ) resistor r=0.751729 //w=0.17 //l=0.085 //layer=li \
 //thickness=0.1 //x=26.675 //y=1.175 //x2=26.59 //y2=1.175
r84 (  5 30 ) resistor r=1.40859 //w=0.34 //l=0.085 //layer=li //thickness=0.1 \
 //x=27.555 //y=1.175 //x2=27.64 //y2=1.175
r85 (  5 6 ) resistor r=60.2353 //w=0.187 //l=0.88 //layer=li //thickness=0.1 \
 //x=27.555 //y=1.175 //x2=26.675 //y2=1.175
ends PM_DFFSNRNQNX1\%noxref_18

subckt PM_DFFSNRNQNX1\%noxref_19 ( 1 5 9 13 17 35 )
c52 ( 35 0 ) capacitor c=0.0762518f //x=0.945 //y=0.555
c53 ( 17 0 ) capacitor c=0.0259527f //x=2.935 //y=1.77
c54 ( 13 0 ) capacitor c=0.0153941f //x=2.935 //y=0.72
c55 ( 9 0 ) capacitor c=0.00772076f //x=2.05 //y=0.805
c56 ( 5 0 ) capacitor c=0.0225187f //x=1.965 //y=1.77
c57 ( 1 0 ) capacitor c=0.0109947f //x=1.08 //y=1.685
r58 (  18 35 ) resistor r=5.4201 //w=0.17 //l=0.103078 //layer=li \
 //thickness=0.1 //x=2.135 //y=1.77 //x2=2.05 //y2=1.81
r59 (  18 35 ) resistor r=27.3797 //w=0.187 //l=0.4 //layer=li //thickness=0.1 \
 //x=2.135 //y=1.77 //x2=2.535 //y2=1.77
r60 (  17 35 ) resistor r=0.751729 //w=0.17 //l=0.085 //layer=li \
 //thickness=0.1 //x=2.935 //y=1.77 //x2=3.02 //y2=1.77
r61 (  17 35 ) resistor r=27.3797 //w=0.187 //l=0.4 //layer=li //thickness=0.1 \
 //x=2.935 //y=1.77 //x2=2.535 //y2=1.77
r62 (  14 35 ) resistor r=3.57586 //w=0.17 //l=0.103078 //layer=li \
 //thickness=0.1 //x=2.135 //y=0.72 //x2=2.05 //y2=0.68
r63 (  14 35 ) resistor r=27.3797 //w=0.187 //l=0.4 //layer=li //thickness=0.1 \
 //x=2.135 //y=0.72 //x2=2.535 //y2=0.72
r64 (  13 35 ) resistor r=0.751729 //w=0.17 //l=0.085 //layer=li \
 //thickness=0.1 //x=2.935 //y=0.72 //x2=3.02 //y2=0.72
r65 (  13 35 ) resistor r=27.3797 //w=0.187 //l=0.4 //layer=li //thickness=0.1 \
 //x=2.935 //y=0.72 //x2=2.535 //y2=0.72
r66 (  10 35 ) resistor r=1.40859 //w=0.34 //l=0.125 //layer=li \
 //thickness=0.1 //x=2.05 //y=1.685 //x2=2.05 //y2=1.81
r67 (  10 35 ) resistor r=42.0963 //w=0.187 //l=0.615 //layer=li \
 //thickness=0.1 //x=2.05 //y=1.685 //x2=2.05 //y2=1.07
r68 (  9 35 ) resistor r=3.57586 //w=0.17 //l=0.125 //layer=li //thickness=0.1 \
 //x=2.05 //y=0.805 //x2=2.05 //y2=0.68
r69 (  9 35 ) resistor r=18.139 //w=0.187 //l=0.265 //layer=li //thickness=0.1 \
 //x=2.05 //y=0.805 //x2=2.05 //y2=1.07
r70 (  6 35 ) resistor r=3.57586 //w=0.17 //l=0.103078 //layer=li \
 //thickness=0.1 //x=1.165 //y=1.77 //x2=1.08 //y2=1.81
r71 (  6 35 ) resistor r=27.3797 //w=0.187 //l=0.4 //layer=li //thickness=0.1 \
 //x=1.165 //y=1.77 //x2=1.565 //y2=1.77
r72 (  5 35 ) resistor r=5.4201 //w=0.17 //l=0.103078 //layer=li \
 //thickness=0.1 //x=1.965 //y=1.77 //x2=2.05 //y2=1.81
r73 (  5 35 ) resistor r=27.3797 //w=0.187 //l=0.4 //layer=li //thickness=0.1 \
 //x=1.965 //y=1.77 //x2=1.565 //y2=1.77
r74 (  1 35 ) resistor r=3.57586 //w=0.17 //l=0.125 //layer=li //thickness=0.1 \
 //x=1.08 //y=1.685 //x2=1.08 //y2=1.81
r75 (  1 35 ) resistor r=42.0963 //w=0.187 //l=0.615 //layer=li \
 //thickness=0.1 //x=1.08 //y=1.685 //x2=1.08 //y2=1.07
ends PM_DFFSNRNQNX1\%noxref_19

subckt PM_DFFSNRNQNX1\%noxref_20 ( 1 5 9 13 17 35 )
c61 ( 35 0 ) capacitor c=0.0700138f //x=5.755 //y=0.555
c62 ( 17 0 ) capacitor c=0.0202098f //x=7.745 //y=1.77
c63 ( 13 0 ) capacitor c=0.015361f //x=7.745 //y=0.72
c64 ( 9 0 ) capacitor c=0.00772076f //x=6.86 //y=0.805
c65 ( 5 0 ) capacitor c=0.0173771f //x=6.775 //y=1.77
c66 ( 1 0 ) capacitor c=0.00749005f //x=5.89 //y=1.685
r67 (  18 35 ) resistor r=5.4201 //w=0.17 //l=0.103078 //layer=li \
 //thickness=0.1 //x=6.945 //y=1.77 //x2=6.86 //y2=1.81
r68 (  18 35 ) resistor r=27.3797 //w=0.187 //l=0.4 //layer=li //thickness=0.1 \
 //x=6.945 //y=1.77 //x2=7.345 //y2=1.77
r69 (  17 35 ) resistor r=0.751729 //w=0.17 //l=0.085 //layer=li \
 //thickness=0.1 //x=7.745 //y=1.77 //x2=7.83 //y2=1.77
r70 (  17 35 ) resistor r=27.3797 //w=0.187 //l=0.4 //layer=li //thickness=0.1 \
 //x=7.745 //y=1.77 //x2=7.345 //y2=1.77
r71 (  14 35 ) resistor r=3.57586 //w=0.17 //l=0.103078 //layer=li \
 //thickness=0.1 //x=6.945 //y=0.72 //x2=6.86 //y2=0.68
r72 (  14 35 ) resistor r=27.3797 //w=0.187 //l=0.4 //layer=li //thickness=0.1 \
 //x=6.945 //y=0.72 //x2=7.345 //y2=0.72
r73 (  13 35 ) resistor r=0.751729 //w=0.17 //l=0.085 //layer=li \
 //thickness=0.1 //x=7.745 //y=0.72 //x2=7.83 //y2=0.72
r74 (  13 35 ) resistor r=27.3797 //w=0.187 //l=0.4 //layer=li //thickness=0.1 \
 //x=7.745 //y=0.72 //x2=7.345 //y2=0.72
r75 (  10 35 ) resistor r=1.40859 //w=0.34 //l=0.125 //layer=li \
 //thickness=0.1 //x=6.86 //y=1.685 //x2=6.86 //y2=1.81
r76 (  10 35 ) resistor r=42.0963 //w=0.187 //l=0.615 //layer=li \
 //thickness=0.1 //x=6.86 //y=1.685 //x2=6.86 //y2=1.07
r77 (  9 35 ) resistor r=3.57586 //w=0.17 //l=0.125 //layer=li //thickness=0.1 \
 //x=6.86 //y=0.805 //x2=6.86 //y2=0.68
r78 (  9 35 ) resistor r=18.139 //w=0.187 //l=0.265 //layer=li //thickness=0.1 \
 //x=6.86 //y=0.805 //x2=6.86 //y2=1.07
r79 (  6 35 ) resistor r=3.57586 //w=0.17 //l=0.103078 //layer=li \
 //thickness=0.1 //x=5.975 //y=1.77 //x2=5.89 //y2=1.81
r80 (  6 35 ) resistor r=27.3797 //w=0.187 //l=0.4 //layer=li //thickness=0.1 \
 //x=5.975 //y=1.77 //x2=6.375 //y2=1.77
r81 (  5 35 ) resistor r=5.4201 //w=0.17 //l=0.103078 //layer=li \
 //thickness=0.1 //x=6.775 //y=1.77 //x2=6.86 //y2=1.81
r82 (  5 35 ) resistor r=27.3797 //w=0.187 //l=0.4 //layer=li //thickness=0.1 \
 //x=6.775 //y=1.77 //x2=6.375 //y2=1.77
r83 (  1 35 ) resistor r=3.57586 //w=0.17 //l=0.125 //layer=li //thickness=0.1 \
 //x=5.89 //y=1.685 //x2=5.89 //y2=1.81
r84 (  1 35 ) resistor r=42.0963 //w=0.187 //l=0.615 //layer=li \
 //thickness=0.1 //x=5.89 //y=1.685 //x2=5.89 //y2=1.07
ends PM_DFFSNRNQNX1\%noxref_20

subckt PM_DFFSNRNQNX1\%noxref_21 ( 1 5 9 13 17 35 )
c61 ( 35 0 ) capacitor c=0.0698431f //x=10.565 //y=0.555
c62 ( 17 0 ) capacitor c=0.0204501f //x=12.555 //y=1.77
c63 ( 13 0 ) capacitor c=0.0153314f //x=12.555 //y=0.72
c64 ( 9 0 ) capacitor c=0.00772076f //x=11.67 //y=0.805
c65 ( 5 0 ) capacitor c=0.0177764f //x=11.585 //y=1.77
c66 ( 1 0 ) capacitor c=0.00749005f //x=10.7 //y=1.685
r67 (  18 35 ) resistor r=5.4201 //w=0.17 //l=0.103078 //layer=li \
 //thickness=0.1 //x=11.755 //y=1.77 //x2=11.67 //y2=1.81
r68 (  18 35 ) resistor r=27.3797 //w=0.187 //l=0.4 //layer=li //thickness=0.1 \
 //x=11.755 //y=1.77 //x2=12.155 //y2=1.77
r69 (  17 35 ) resistor r=0.751729 //w=0.17 //l=0.085 //layer=li \
 //thickness=0.1 //x=12.555 //y=1.77 //x2=12.64 //y2=1.77
r70 (  17 35 ) resistor r=27.3797 //w=0.187 //l=0.4 //layer=li //thickness=0.1 \
 //x=12.555 //y=1.77 //x2=12.155 //y2=1.77
r71 (  14 35 ) resistor r=3.57586 //w=0.17 //l=0.103078 //layer=li \
 //thickness=0.1 //x=11.755 //y=0.72 //x2=11.67 //y2=0.68
r72 (  14 35 ) resistor r=27.3797 //w=0.187 //l=0.4 //layer=li //thickness=0.1 \
 //x=11.755 //y=0.72 //x2=12.155 //y2=0.72
r73 (  13 35 ) resistor r=0.751729 //w=0.17 //l=0.085 //layer=li \
 //thickness=0.1 //x=12.555 //y=0.72 //x2=12.64 //y2=0.72
r74 (  13 35 ) resistor r=27.3797 //w=0.187 //l=0.4 //layer=li //thickness=0.1 \
 //x=12.555 //y=0.72 //x2=12.155 //y2=0.72
r75 (  10 35 ) resistor r=1.40859 //w=0.34 //l=0.125 //layer=li \
 //thickness=0.1 //x=11.67 //y=1.685 //x2=11.67 //y2=1.81
r76 (  10 35 ) resistor r=42.0963 //w=0.187 //l=0.615 //layer=li \
 //thickness=0.1 //x=11.67 //y=1.685 //x2=11.67 //y2=1.07
r77 (  9 35 ) resistor r=3.57586 //w=0.17 //l=0.125 //layer=li //thickness=0.1 \
 //x=11.67 //y=0.805 //x2=11.67 //y2=0.68
r78 (  9 35 ) resistor r=18.139 //w=0.187 //l=0.265 //layer=li //thickness=0.1 \
 //x=11.67 //y=0.805 //x2=11.67 //y2=1.07
r79 (  6 35 ) resistor r=3.57586 //w=0.17 //l=0.103078 //layer=li \
 //thickness=0.1 //x=10.785 //y=1.77 //x2=10.7 //y2=1.81
r80 (  6 35 ) resistor r=27.3797 //w=0.187 //l=0.4 //layer=li //thickness=0.1 \
 //x=10.785 //y=1.77 //x2=11.185 //y2=1.77
r81 (  5 35 ) resistor r=5.4201 //w=0.17 //l=0.103078 //layer=li \
 //thickness=0.1 //x=11.585 //y=1.77 //x2=11.67 //y2=1.81
r82 (  5 35 ) resistor r=27.3797 //w=0.187 //l=0.4 //layer=li //thickness=0.1 \
 //x=11.585 //y=1.77 //x2=11.185 //y2=1.77
r83 (  1 35 ) resistor r=3.57586 //w=0.17 //l=0.125 //layer=li //thickness=0.1 \
 //x=10.7 //y=1.685 //x2=10.7 //y2=1.81
r84 (  1 35 ) resistor r=42.0963 //w=0.187 //l=0.615 //layer=li \
 //thickness=0.1 //x=10.7 //y=1.685 //x2=10.7 //y2=1.07
ends PM_DFFSNRNQNX1\%noxref_21

subckt PM_DFFSNRNQNX1\%noxref_22 ( 1 5 9 13 17 35 )
c59 ( 35 0 ) capacitor c=0.0694864f //x=15.375 //y=0.555
c60 ( 17 0 ) capacitor c=0.0195855f //x=17.365 //y=1.77
c61 ( 13 0 ) capacitor c=0.015342f //x=17.365 //y=0.72
c62 ( 9 0 ) capacitor c=0.00772076f //x=16.48 //y=0.805
c63 ( 5 0 ) capacitor c=0.0171549f //x=16.395 //y=1.77
c64 ( 1 0 ) capacitor c=0.00727095f //x=15.51 //y=1.685
r65 (  18 35 ) resistor r=5.4201 //w=0.17 //l=0.103078 //layer=li \
 //thickness=0.1 //x=16.565 //y=1.77 //x2=16.48 //y2=1.81
r66 (  18 35 ) resistor r=27.3797 //w=0.187 //l=0.4 //layer=li //thickness=0.1 \
 //x=16.565 //y=1.77 //x2=16.965 //y2=1.77
r67 (  17 35 ) resistor r=0.751729 //w=0.17 //l=0.085 //layer=li \
 //thickness=0.1 //x=17.365 //y=1.77 //x2=17.45 //y2=1.77
r68 (  17 35 ) resistor r=27.3797 //w=0.187 //l=0.4 //layer=li //thickness=0.1 \
 //x=17.365 //y=1.77 //x2=16.965 //y2=1.77
r69 (  14 35 ) resistor r=3.57586 //w=0.17 //l=0.103078 //layer=li \
 //thickness=0.1 //x=16.565 //y=0.72 //x2=16.48 //y2=0.68
r70 (  14 35 ) resistor r=27.3797 //w=0.187 //l=0.4 //layer=li //thickness=0.1 \
 //x=16.565 //y=0.72 //x2=16.965 //y2=0.72
r71 (  13 35 ) resistor r=0.751729 //w=0.17 //l=0.085 //layer=li \
 //thickness=0.1 //x=17.365 //y=0.72 //x2=17.45 //y2=0.72
r72 (  13 35 ) resistor r=27.3797 //w=0.187 //l=0.4 //layer=li //thickness=0.1 \
 //x=17.365 //y=0.72 //x2=16.965 //y2=0.72
r73 (  10 35 ) resistor r=1.40859 //w=0.34 //l=0.125 //layer=li \
 //thickness=0.1 //x=16.48 //y=1.685 //x2=16.48 //y2=1.81
r74 (  10 35 ) resistor r=42.0963 //w=0.187 //l=0.615 //layer=li \
 //thickness=0.1 //x=16.48 //y=1.685 //x2=16.48 //y2=1.07
r75 (  9 35 ) resistor r=3.57586 //w=0.17 //l=0.125 //layer=li //thickness=0.1 \
 //x=16.48 //y=0.805 //x2=16.48 //y2=0.68
r76 (  9 35 ) resistor r=18.139 //w=0.187 //l=0.265 //layer=li //thickness=0.1 \
 //x=16.48 //y=0.805 //x2=16.48 //y2=1.07
r77 (  6 35 ) resistor r=3.57586 //w=0.17 //l=0.103078 //layer=li \
 //thickness=0.1 //x=15.595 //y=1.77 //x2=15.51 //y2=1.81
r78 (  6 35 ) resistor r=27.3797 //w=0.187 //l=0.4 //layer=li //thickness=0.1 \
 //x=15.595 //y=1.77 //x2=15.995 //y2=1.77
r79 (  5 35 ) resistor r=5.4201 //w=0.17 //l=0.103078 //layer=li \
 //thickness=0.1 //x=16.395 //y=1.77 //x2=16.48 //y2=1.81
r80 (  5 35 ) resistor r=27.3797 //w=0.187 //l=0.4 //layer=li //thickness=0.1 \
 //x=16.395 //y=1.77 //x2=15.995 //y2=1.77
r81 (  1 35 ) resistor r=3.57586 //w=0.17 //l=0.125 //layer=li //thickness=0.1 \
 //x=15.51 //y=1.685 //x2=15.51 //y2=1.81
r82 (  1 35 ) resistor r=42.0963 //w=0.187 //l=0.615 //layer=li \
 //thickness=0.1 //x=15.51 //y=1.685 //x2=15.51 //y2=1.07
ends PM_DFFSNRNQNX1\%noxref_22

subckt PM_DFFSNRNQNX1\%noxref_23 ( 1 5 9 13 17 35 )
c58 ( 35 0 ) capacitor c=0.0694864f //x=20.185 //y=0.555
c59 ( 17 0 ) capacitor c=0.0195855f //x=22.175 //y=1.77
c60 ( 13 0 ) capacitor c=0.015342f //x=22.175 //y=0.72
c61 ( 9 0 ) capacitor c=0.00772076f //x=21.29 //y=0.805
c62 ( 5 0 ) capacitor c=0.0171871f //x=21.205 //y=1.77
c63 ( 1 0 ) capacitor c=0.00727095f //x=20.32 //y=1.685
r64 (  18 35 ) resistor r=5.4201 //w=0.17 //l=0.103078 //layer=li \
 //thickness=0.1 //x=21.375 //y=1.77 //x2=21.29 //y2=1.81
r65 (  18 35 ) resistor r=27.3797 //w=0.187 //l=0.4 //layer=li //thickness=0.1 \
 //x=21.375 //y=1.77 //x2=21.775 //y2=1.77
r66 (  17 35 ) resistor r=0.751729 //w=0.17 //l=0.085 //layer=li \
 //thickness=0.1 //x=22.175 //y=1.77 //x2=22.26 //y2=1.77
r67 (  17 35 ) resistor r=27.3797 //w=0.187 //l=0.4 //layer=li //thickness=0.1 \
 //x=22.175 //y=1.77 //x2=21.775 //y2=1.77
r68 (  14 35 ) resistor r=3.57586 //w=0.17 //l=0.103078 //layer=li \
 //thickness=0.1 //x=21.375 //y=0.72 //x2=21.29 //y2=0.68
r69 (  14 35 ) resistor r=27.3797 //w=0.187 //l=0.4 //layer=li //thickness=0.1 \
 //x=21.375 //y=0.72 //x2=21.775 //y2=0.72
r70 (  13 35 ) resistor r=0.751729 //w=0.17 //l=0.085 //layer=li \
 //thickness=0.1 //x=22.175 //y=0.72 //x2=22.26 //y2=0.72
r71 (  13 35 ) resistor r=27.3797 //w=0.187 //l=0.4 //layer=li //thickness=0.1 \
 //x=22.175 //y=0.72 //x2=21.775 //y2=0.72
r72 (  10 35 ) resistor r=1.40859 //w=0.34 //l=0.125 //layer=li \
 //thickness=0.1 //x=21.29 //y=1.685 //x2=21.29 //y2=1.81
r73 (  10 35 ) resistor r=42.0963 //w=0.187 //l=0.615 //layer=li \
 //thickness=0.1 //x=21.29 //y=1.685 //x2=21.29 //y2=1.07
r74 (  9 35 ) resistor r=3.57586 //w=0.17 //l=0.125 //layer=li //thickness=0.1 \
 //x=21.29 //y=0.805 //x2=21.29 //y2=0.68
r75 (  9 35 ) resistor r=18.139 //w=0.187 //l=0.265 //layer=li //thickness=0.1 \
 //x=21.29 //y=0.805 //x2=21.29 //y2=1.07
r76 (  6 35 ) resistor r=3.57586 //w=0.17 //l=0.103078 //layer=li \
 //thickness=0.1 //x=20.405 //y=1.77 //x2=20.32 //y2=1.81
r77 (  6 35 ) resistor r=27.3797 //w=0.187 //l=0.4 //layer=li //thickness=0.1 \
 //x=20.405 //y=1.77 //x2=20.805 //y2=1.77
r78 (  5 35 ) resistor r=5.4201 //w=0.17 //l=0.103078 //layer=li \
 //thickness=0.1 //x=21.205 //y=1.77 //x2=21.29 //y2=1.81
r79 (  5 35 ) resistor r=27.3797 //w=0.187 //l=0.4 //layer=li //thickness=0.1 \
 //x=21.205 //y=1.77 //x2=20.805 //y2=1.77
r80 (  1 35 ) resistor r=3.57586 //w=0.17 //l=0.125 //layer=li //thickness=0.1 \
 //x=20.32 //y=1.685 //x2=20.32 //y2=1.81
r81 (  1 35 ) resistor r=42.0963 //w=0.187 //l=0.615 //layer=li \
 //thickness=0.1 //x=20.32 //y=1.685 //x2=20.32 //y2=1.07
ends PM_DFFSNRNQNX1\%noxref_23

subckt PM_DFFSNRNQNX1\%noxref_24 ( 1 5 9 13 17 35 )
c57 ( 35 0 ) capacitor c=0.0705444f //x=24.995 //y=0.555
c58 ( 17 0 ) capacitor c=0.0195309f //x=26.985 //y=1.77
c59 ( 13 0 ) capacitor c=0.0153839f //x=26.985 //y=0.72
c60 ( 9 0 ) capacitor c=0.00772076f //x=26.1 //y=0.805
c61 ( 5 0 ) capacitor c=0.0170793f //x=26.015 //y=1.77
c62 ( 1 0 ) capacitor c=0.00727095f //x=25.13 //y=1.685
r63 (  18 35 ) resistor r=5.4201 //w=0.17 //l=0.103078 //layer=li \
 //thickness=0.1 //x=26.185 //y=1.77 //x2=26.1 //y2=1.81
r64 (  18 35 ) resistor r=27.3797 //w=0.187 //l=0.4 //layer=li //thickness=0.1 \
 //x=26.185 //y=1.77 //x2=26.585 //y2=1.77
r65 (  17 35 ) resistor r=0.751729 //w=0.17 //l=0.085 //layer=li \
 //thickness=0.1 //x=26.985 //y=1.77 //x2=27.07 //y2=1.77
r66 (  17 35 ) resistor r=27.3797 //w=0.187 //l=0.4 //layer=li //thickness=0.1 \
 //x=26.985 //y=1.77 //x2=26.585 //y2=1.77
r67 (  14 35 ) resistor r=3.57586 //w=0.17 //l=0.103078 //layer=li \
 //thickness=0.1 //x=26.185 //y=0.72 //x2=26.1 //y2=0.68
r68 (  14 35 ) resistor r=27.3797 //w=0.187 //l=0.4 //layer=li //thickness=0.1 \
 //x=26.185 //y=0.72 //x2=26.585 //y2=0.72
r69 (  13 35 ) resistor r=0.751729 //w=0.17 //l=0.085 //layer=li \
 //thickness=0.1 //x=26.985 //y=0.72 //x2=27.07 //y2=0.72
r70 (  13 35 ) resistor r=27.3797 //w=0.187 //l=0.4 //layer=li //thickness=0.1 \
 //x=26.985 //y=0.72 //x2=26.585 //y2=0.72
r71 (  10 35 ) resistor r=1.40859 //w=0.34 //l=0.125 //layer=li \
 //thickness=0.1 //x=26.1 //y=1.685 //x2=26.1 //y2=1.81
r72 (  10 35 ) resistor r=42.0963 //w=0.187 //l=0.615 //layer=li \
 //thickness=0.1 //x=26.1 //y=1.685 //x2=26.1 //y2=1.07
r73 (  9 35 ) resistor r=3.57586 //w=0.17 //l=0.125 //layer=li //thickness=0.1 \
 //x=26.1 //y=0.805 //x2=26.1 //y2=0.68
r74 (  9 35 ) resistor r=18.139 //w=0.187 //l=0.265 //layer=li //thickness=0.1 \
 //x=26.1 //y=0.805 //x2=26.1 //y2=1.07
r75 (  6 35 ) resistor r=3.57586 //w=0.17 //l=0.103078 //layer=li \
 //thickness=0.1 //x=25.215 //y=1.77 //x2=25.13 //y2=1.81
r76 (  6 35 ) resistor r=27.3797 //w=0.187 //l=0.4 //layer=li //thickness=0.1 \
 //x=25.215 //y=1.77 //x2=25.615 //y2=1.77
r77 (  5 35 ) resistor r=5.4201 //w=0.17 //l=0.103078 //layer=li \
 //thickness=0.1 //x=26.015 //y=1.77 //x2=26.1 //y2=1.81
r78 (  5 35 ) resistor r=27.3797 //w=0.187 //l=0.4 //layer=li //thickness=0.1 \
 //x=26.015 //y=1.77 //x2=25.615 //y2=1.77
r79 (  1 35 ) resistor r=3.57586 //w=0.17 //l=0.125 //layer=li //thickness=0.1 \
 //x=25.13 //y=1.685 //x2=25.13 //y2=1.81
r80 (  1 35 ) resistor r=42.0963 //w=0.187 //l=0.615 //layer=li \
 //thickness=0.1 //x=25.13 //y=1.685 //x2=25.13 //y2=1.07
ends PM_DFFSNRNQNX1\%noxref_24
