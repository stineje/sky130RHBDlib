// File: TMRDFFSNQNX1.spi.pex
// Created: Sun Apr 12 08:36:56 2026
// Program "Calibre xRC"
// Version "v2023.2_27.15"
// Nominal Temperature: 30C
// Circuit Temperature: 30C
//
simulator lang=spectre
subckt PM_TMRDFFSNQNX1\%noxref_1 ( 3 8 9 11 12 14 15 16 17 18 19 20 21 22 23 \
 24 27 28 31 33 36 43 47 54 55 57 64 65 68 76 93 102 107 116 120 121 122 123 \
 124 125 126 127 128 129 130 132 138 139 140 141 145 146 147 148 149 151 157 \
 158 159 160 180 182 183 )
c413 ( 180 0 ) capacitor c=0.00878249f //x=2.45 //y=1.085
c414 ( 160 0 ) capacitor c=0.0612936f //x=10.015 //y=4.97
c415 ( 159 0 ) capacitor c=0.0376642f //x=10.305 //y=4.97
c416 ( 158 0 ) capacitor c=0.0346489f //x=9.97 //y=1.4
c417 ( 157 0 ) capacitor c=0.018692f //x=9.97 //y=1.055
c418 ( 151 0 ) capacitor c=0.0137077f //x=9.815 //y=1.555
c419 ( 149 0 ) capacitor c=0.0158585f //x=9.815 //y=0.9
c420 ( 148 0 ) capacitor c=0.0979511f //x=9.44 //y=2.095
c421 ( 147 0 ) capacitor c=0.0229444f //x=9.44 //y=1.71
c422 ( 146 0 ) capacitor c=0.0234359f //x=9.44 //y=1.4
c423 ( 145 0 ) capacitor c=0.019815f //x=9.44 //y=1.055
c424 ( 141 0 ) capacitor c=0.0612936f //x=5.205 //y=4.97
c425 ( 140 0 ) capacitor c=0.0376642f //x=5.495 //y=4.97
c426 ( 139 0 ) capacitor c=0.0346489f //x=5.16 //y=1.4
c427 ( 138 0 ) capacitor c=0.018692f //x=5.16 //y=1.055
c428 ( 132 0 ) capacitor c=0.0137077f //x=5.005 //y=1.555
c429 ( 130 0 ) capacitor c=0.0158585f //x=5.005 //y=0.9
c430 ( 129 0 ) capacitor c=0.099553f //x=4.63 //y=2.095
c431 ( 128 0 ) capacitor c=0.0229444f //x=4.63 //y=1.71
c432 ( 127 0 ) capacitor c=0.0234359f //x=4.63 //y=1.4
c433 ( 126 0 ) capacitor c=0.019815f //x=4.63 //y=1.055
c434 ( 125 0 ) capacitor c=0.110208f //x=10.38 //y=6.2
c435 ( 124 0 ) capacitor c=0.158957f //x=9.94 //y=6.2
c436 ( 123 0 ) capacitor c=0.110208f //x=5.57 //y=6.2
c437 ( 122 0 ) capacitor c=0.158957f //x=5.13 //y=6.2
c438 ( 116 0 ) capacitor c=0.0014751f //x=9.74 //y=4.88
c439 ( 107 0 ) capacitor c=9.93222e-19 //x=9.74 //y=2.26
c440 ( 102 0 ) capacitor c=0.0014751f //x=4.93 //y=4.88
c441 ( 93 0 ) capacitor c=9.93222e-19 //x=4.93 //y=2.26
c442 ( 76 0 ) capacitor c=0.0322017f //x=2.6 //y=5.56
c443 ( 68 0 ) capacitor c=0.0291338f //x=1.72 //y=5.56
c444 ( 65 0 ) capacitor c=0.0936548f //x=9.58 //y=2.775
c445 ( 64 0 ) capacitor c=0.00250142f //x=9.74 //y=2.775
c446 ( 57 0 ) capacitor c=0.0025105f //x=5.09 //y=2.77
c447 ( 55 0 ) capacitor c=0.00278714f //x=3.24 //y=2.77
c448 ( 54 0 ) capacitor c=0.0351844f //x=4.77 //y=2.77
c449 ( 47 0 ) capacitor c=0.0154699f //x=9.74 //y=2.77
c450 ( 43 0 ) capacitor c=0.0146914f //x=4.93 //y=2.765
c451 ( 36 0 ) capacitor c=0.0146635f //x=3.08 //y=2.77
c452 ( 33 0 ) capacitor c=0.0115709f //x=2.64 //y=1.18
c453 ( 31 0 ) capacitor c=5.78613e-19 //x=2.6 //y=5.56
c454 ( 28 0 ) capacitor c=0.0112565f //x=2.6 //y=5.38
c455 ( 27 0 ) capacitor c=0.00938035f //x=1.72 //y=5.56
c456 ( 24 0 ) capacitor c=0.0642737f //x=9.74 //y=4.755
c457 ( 23 0 ) capacitor c=0.0130124f //x=9.74 //y=2.935
c458 ( 22 0 ) capacitor c=0.0052305f //x=9.74 //y=2.615
c459 ( 21 0 ) capacitor c=0.00635496f //x=9.74 //y=2.375
c460 ( 20 0 ) capacitor c=0.0669671f //x=4.93 //y=4.755
c461 ( 19 0 ) capacitor c=0.0130093f //x=4.93 //y=2.93
c462 ( 18 0 ) capacitor c=0.00604005f //x=4.93 //y=2.61
c463 ( 17 0 ) capacitor c=0.00638932f //x=4.93 //y=2.375
c464 ( 16 0 ) capacitor c=0.0706561f //x=3.08 //y=5.295
c465 ( 15 0 ) capacitor c=0.0120692f //x=3.08 //y=2.93
c466 ( 14 0 ) capacitor c=0.0182566f //x=3.08 //y=2.61
c467 ( 12 0 ) capacitor c=0.00727246f //x=2.725 //y=1.835
c468 ( 11 0 ) capacitor c=0.0135366f //x=2.995 //y=1.835
c469 ( 9 0 ) capacitor c=0.0122194f //x=2.995 //y=5.38
c470 ( 8 0 ) capacitor c=0.0167748f //x=2.64 //y=1.75
c471 ( 3 0 ) capacitor c=0.015247f //x=2.485 //y=5.38
r472 (  159 161 ) resistor r=26.9307 //w=0.15 //l=0.106066 //layer=ply \
 //thickness=0.18 //x=10.305 //y=4.97 //x2=10.38 //y2=5.045
r473 (  159 160 ) resistor r=148.702 //w=0.094 //l=0.29 //layer=ply \
 //thickness=0.18 //x=10.305 //y=4.97 //x2=10.015 //y2=4.97
r474 (  158 179 ) resistor r=45.1352 //w=0.168 //l=0.173853 //layer=ply \
 //thickness=0.18 //x=9.97 //y=1.4 //x2=9.93 //y2=1.555
r475 (  157 178 ) resistor r=45.1352 //w=0.168 //l=0.173853 //layer=ply \
 //thickness=0.18 //x=9.97 //y=1.055 //x2=9.93 //y2=0.9
r476 (  157 158 ) resistor r=176.904 //w=0.094 //l=0.345 //layer=ply \
 //thickness=0.18 //x=9.97 //y=1.055 //x2=9.97 //y2=1.4
r477 (  154 160 ) resistor r=22.7971 //w=0.269 //l=0.106066 //layer=ply \
 //thickness=0.18 //x=9.94 //y=5.045 //x2=10.015 //y2=4.97
r478 (  154 177 ) resistor r=35.8364 //w=0.269 //l=0.270185 //layer=ply \
 //thickness=0.18 //x=9.94 //y=5.045 //x2=9.74 //y2=4.88
r479 (  152 173 ) resistor r=10.701 //w=0.21 //l=0.115 //layer=ply \
 //thickness=0.18 //x=9.595 //y=1.555 //x2=9.48 //y2=1.555
r480 (  151 179 ) resistor r=5.52526 //w=0.168 //l=0.115 //layer=ply \
 //thickness=0.18 //x=9.815 //y=1.555 //x2=9.93 //y2=1.555
r481 (  150 172 ) resistor r=5.52526 //w=0.168 //l=0.115 //layer=ply \
 //thickness=0.18 //x=9.595 //y=0.9 //x2=9.48 //y2=0.9
r482 (  149 178 ) resistor r=5.52526 //w=0.168 //l=0.115 //layer=ply \
 //thickness=0.18 //x=9.815 //y=0.9 //x2=9.93 //y2=0.9
r483 (  149 150 ) resistor r=112.809 //w=0.094 //l=0.22 //layer=ply \
 //thickness=0.18 //x=9.815 //y=0.9 //x2=9.595 //y2=0.9
r484 (  148 175 ) resistor r=58.7805 //w=0.246 //l=0.373497 //layer=ply \
 //thickness=0.18 //x=9.44 //y=2.095 //x2=9.74 //y2=2.26
r485 (  147 173 ) resistor r=39.5823 //w=0.21 //l=0.173853 //layer=ply \
 //thickness=0.18 //x=9.44 //y=1.71 //x2=9.48 //y2=1.555
r486 (  147 148 ) resistor r=197.415 //w=0.094 //l=0.385 //layer=ply \
 //thickness=0.18 //x=9.44 //y=1.71 //x2=9.44 //y2=2.095
r487 (  146 173 ) resistor r=39.5823 //w=0.21 //l=0.173853 //layer=ply \
 //thickness=0.18 //x=9.44 //y=1.4 //x2=9.48 //y2=1.555
r488 (  145 172 ) resistor r=45.1352 //w=0.168 //l=0.173853 //layer=ply \
 //thickness=0.18 //x=9.44 //y=1.055 //x2=9.48 //y2=0.9
r489 (  145 146 ) resistor r=176.904 //w=0.094 //l=0.345 //layer=ply \
 //thickness=0.18 //x=9.44 //y=1.055 //x2=9.44 //y2=1.4
r490 (  140 142 ) resistor r=26.9307 //w=0.15 //l=0.106066 //layer=ply \
 //thickness=0.18 //x=5.495 //y=4.97 //x2=5.57 //y2=5.045
r491 (  140 141 ) resistor r=148.702 //w=0.094 //l=0.29 //layer=ply \
 //thickness=0.18 //x=5.495 //y=4.97 //x2=5.205 //y2=4.97
r492 (  139 171 ) resistor r=45.1352 //w=0.168 //l=0.173853 //layer=ply \
 //thickness=0.18 //x=5.16 //y=1.4 //x2=5.12 //y2=1.555
r493 (  138 170 ) resistor r=45.1352 //w=0.168 //l=0.173853 //layer=ply \
 //thickness=0.18 //x=5.16 //y=1.055 //x2=5.12 //y2=0.9
r494 (  138 139 ) resistor r=176.904 //w=0.094 //l=0.345 //layer=ply \
 //thickness=0.18 //x=5.16 //y=1.055 //x2=5.16 //y2=1.4
r495 (  135 141 ) resistor r=22.7971 //w=0.269 //l=0.106066 //layer=ply \
 //thickness=0.18 //x=5.13 //y=5.045 //x2=5.205 //y2=4.97
r496 (  135 169 ) resistor r=35.8364 //w=0.269 //l=0.270185 //layer=ply \
 //thickness=0.18 //x=5.13 //y=5.045 //x2=4.93 //y2=4.88
r497 (  133 165 ) resistor r=10.701 //w=0.21 //l=0.115 //layer=ply \
 //thickness=0.18 //x=4.785 //y=1.555 //x2=4.67 //y2=1.555
r498 (  132 171 ) resistor r=5.52526 //w=0.168 //l=0.115 //layer=ply \
 //thickness=0.18 //x=5.005 //y=1.555 //x2=5.12 //y2=1.555
r499 (  131 164 ) resistor r=5.52526 //w=0.168 //l=0.115 //layer=ply \
 //thickness=0.18 //x=4.785 //y=0.9 //x2=4.67 //y2=0.9
r500 (  130 170 ) resistor r=5.52526 //w=0.168 //l=0.115 //layer=ply \
 //thickness=0.18 //x=5.005 //y=0.9 //x2=5.12 //y2=0.9
r501 (  130 131 ) resistor r=112.809 //w=0.094 //l=0.22 //layer=ply \
 //thickness=0.18 //x=5.005 //y=0.9 //x2=4.785 //y2=0.9
r502 (  129 167 ) resistor r=58.7805 //w=0.246 //l=0.373497 //layer=ply \
 //thickness=0.18 //x=4.63 //y=2.095 //x2=4.93 //y2=2.26
r503 (  128 165 ) resistor r=39.5823 //w=0.21 //l=0.173853 //layer=ply \
 //thickness=0.18 //x=4.63 //y=1.71 //x2=4.67 //y2=1.555
r504 (  128 129 ) resistor r=197.415 //w=0.094 //l=0.385 //layer=ply \
 //thickness=0.18 //x=4.63 //y=1.71 //x2=4.63 //y2=2.095
r505 (  127 165 ) resistor r=39.5823 //w=0.21 //l=0.173853 //layer=ply \
 //thickness=0.18 //x=4.63 //y=1.4 //x2=4.67 //y2=1.555
r506 (  126 164 ) resistor r=45.1352 //w=0.168 //l=0.173853 //layer=ply \
 //thickness=0.18 //x=4.63 //y=1.055 //x2=4.67 //y2=0.9
r507 (  126 127 ) resistor r=176.904 //w=0.094 //l=0.345 //layer=ply \
 //thickness=0.18 //x=4.63 //y=1.055 //x2=4.63 //y2=1.4
r508 (  125 161 ) resistor r=592.245 //w=0.094 //l=1.155 //layer=ply \
 //thickness=0.18 //x=10.38 //y=6.2 //x2=10.38 //y2=5.045
r509 (  124 154 ) resistor r=592.245 //w=0.094 //l=1.155 //layer=ply \
 //thickness=0.18 //x=9.94 //y=6.2 //x2=9.94 //y2=5.045
r510 (  123 142 ) resistor r=592.245 //w=0.094 //l=1.155 //layer=ply \
 //thickness=0.18 //x=5.57 //y=6.2 //x2=5.57 //y2=5.045
r511 (  122 135 ) resistor r=592.245 //w=0.094 //l=1.155 //layer=ply \
 //thickness=0.18 //x=5.13 //y=6.2 //x2=5.13 //y2=5.045
r512 (  121 151 ) resistor r=56.4043 //w=0.094 //l=0.11 //layer=ply \
 //thickness=0.18 //x=9.705 //y=1.555 //x2=9.815 //y2=1.555
r513 (  121 152 ) resistor r=56.4043 //w=0.094 //l=0.11 //layer=ply \
 //thickness=0.18 //x=9.705 //y=1.555 //x2=9.595 //y2=1.555
r514 (  120 132 ) resistor r=56.4043 //w=0.094 //l=0.11 //layer=ply \
 //thickness=0.18 //x=4.895 //y=1.555 //x2=5.005 //y2=1.555
r515 (  120 133 ) resistor r=56.4043 //w=0.094 //l=0.11 //layer=ply \
 //thickness=0.18 //x=4.895 //y=1.555 //x2=4.785 //y2=1.555
r516 (  116 177 ) resistor r=152 //w=0.17 //l=0.17 //layer=licon //count=1 \
 //x=9.74 //y=4.88 //x2=9.74 //y2=4.88
r517 (  107 175 ) resistor r=152 //w=0.17 //l=0.17 //layer=licon //count=1 \
 //x=9.74 //y=2.26 //x2=9.74 //y2=2.26
r518 (  102 169 ) resistor r=152 //w=0.17 //l=0.17 //layer=licon //count=1 \
 //x=4.93 //y=4.88 //x2=4.93 //y2=4.88
r519 (  93 167 ) resistor r=152 //w=0.17 //l=0.17 //layer=licon //count=1 \
 //x=4.93 //y=2.26 //x2=4.93 //y2=2.26
r520 (  76 183 ) resistor r=23.615 //w=0.187 //l=0.345 //layer=li \
 //thickness=0.1 //x=2.6 //y=5.56 //x2=2.6 //y2=5.905
r521 (  68 182 ) resistor r=23.615 //w=0.187 //l=0.345 //layer=li \
 //thickness=0.1 //x=1.72 //y=5.56 //x2=1.72 //y2=5.905
r522 (  64 65 ) resistor r=0.10734 //w=0.281 //l=0.16 //layer=m2 \
 //thickness=0.36 //x=9.74 //y=2.775 //x2=9.58 //y2=2.775
r523 (  57 62 ) resistor r=0.10734 //w=0.281 //l=0.16 //layer=m2 \
 //thickness=0.36 //x=5.09 //y=2.77 //x2=4.93 //y2=2.77
r524 (  57 65 ) resistor r=4.28435 //w=0.131 //l=4.49 //layer=m2 \
 //thickness=0.36 //x=5.09 //y=2.77 //x2=9.58 //y2=2.77
r525 (  55 59 ) resistor r=0.10734 //w=0.281 //l=0.16 //layer=m2 \
 //thickness=0.36 //x=3.24 //y=2.77 //x2=3.08 //y2=2.77
r526 (  54 62 ) resistor r=0.10734 //w=0.281 //l=0.16 //layer=m2 \
 //thickness=0.36 //x=4.77 //y=2.77 //x2=4.93 //y2=2.77
r527 (  54 55 ) resistor r=1.45992 //w=0.131 //l=1.53 //layer=m2 \
 //thickness=0.36 //x=4.77 //y=2.77 //x2=3.24 //y2=2.77
r528 (  53 116 ) resistor r=9.3 //w=0.17 //l=0.17 //layer=mcon //count=1 \
 //x=9.74 //y=4.88 //x2=9.74 //y2=4.88
r529 (  51 107 ) resistor r=9.3 //w=0.17 //l=0.17 //layer=mcon //count=1 \
 //x=9.74 //y=2.26 //x2=9.74 //y2=2.26
r530 (  49 64 ) resistor r=4.5 //w=0.15 //l=0.15 //layer=via1 //count=1 \
 //x=9.74 //y=2.775 //x2=9.74 //y2=2.775
r531 (  47 49 ) resistor r=0.00166223 //w=0.376 //l=0.005 //layer=m1 \
 //thickness=0.36 //x=9.687 //y=2.77 //x2=9.687 //y2=2.775
r532 (  45 62 ) resistor r=4.5 //w=0.15 //l=0.15 //layer=via1 //count=1 \
 //x=4.93 //y=2.77 //x2=4.93 //y2=2.77
r533 (  43 45 ) resistor r=0.00166223 //w=0.376 //l=0.005 //layer=m1 \
 //thickness=0.36 //x=4.982 //y=2.765 //x2=4.982 //y2=2.77
r534 (  41 102 ) resistor r=9.3 //w=0.17 //l=0.17 //layer=mcon //count=1 \
 //x=4.93 //y=4.88 //x2=4.93 //y2=4.88
r535 (  39 93 ) resistor r=9.3 //w=0.17 //l=0.17 //layer=mcon //count=1 \
 //x=4.93 //y=2.26 //x2=4.93 //y2=2.26
r536 (  36 59 ) resistor r=4.5 //w=0.15 //l=0.15 //layer=via1 //count=1 \
 //x=3.08 //y=2.77 //x2=3.08 //y2=2.77
r537 (  33 180 ) resistor r=9.3 //w=0.17 //l=0.17 //layer=mcon //count=1 \
 //x=2.64 //y=1.18 //x2=2.64 //y2=1.18
r538 (  31 76 ) resistor r=9.3 //w=0.17 //l=0.17 //layer=mcon //count=1 \
 //x=2.6 //y=5.56 //x2=2.6 //y2=5.56
r539 (  28 31 ) resistor r=0.117801 //w=0.191 //l=0.18 //layer=m1 \
 //thickness=0.36 //x=2.6 //y=5.38 //x2=2.6 //y2=5.56
r540 (  27 68 ) resistor r=9.3 //w=0.17 //l=0.17 //layer=mcon //count=1 \
 //x=1.72 //y=5.56 //x2=1.72 //y2=5.56
r541 (  25 27 ) resistor r=0.10274 //w=0.219 //l=0.18 //layer=m1 \
 //thickness=0.36 //x=1.72 //y=5.38 //x2=1.72 //y2=5.56
r542 (  24 53 ) resistor r=0.0760407 //w=0.238 //l=0.125 //layer=m1 \
 //thickness=0.36 //x=9.74 //y=4.755 //x2=9.74 //y2=4.88
r543 (  23 49 ) resistor r=0.0911593 //w=0.376 //l=0.184608 //layer=m1 \
 //thickness=0.36 //x=9.74 //y=2.935 //x2=9.687 //y2=2.775
r544 (  23 24 ) resistor r=1.73664 //w=0.131 //l=1.82 //layer=m1 \
 //thickness=0.36 //x=9.74 //y=2.935 //x2=9.74 //y2=4.755
r545 (  22 47 ) resistor r=0.0894971 //w=0.376 //l=0.179555 //layer=m1 \
 //thickness=0.36 //x=9.74 //y=2.615 //x2=9.687 //y2=2.77
r546 (  21 51 ) resistor r=0.0719237 //w=0.222 //l=0.115 //layer=m1 \
 //thickness=0.36 //x=9.74 //y=2.375 //x2=9.74 //y2=2.26
r547 (  21 22 ) resistor r=0.229008 //w=0.131 //l=0.24 //layer=m1 \
 //thickness=0.36 //x=9.74 //y=2.375 //x2=9.74 //y2=2.615
r548 (  20 41 ) resistor r=0.0760407 //w=0.238 //l=0.125 //layer=m1 \
 //thickness=0.36 //x=4.93 //y=4.755 //x2=4.93 //y2=4.88
r549 (  19 45 ) resistor r=0.0911593 //w=0.376 //l=0.184174 //layer=m1 \
 //thickness=0.36 //x=4.93 //y=2.93 //x2=4.982 //y2=2.77
r550 (  19 20 ) resistor r=1.74141 //w=0.131 //l=1.825 //layer=m1 \
 //thickness=0.36 //x=4.93 //y=2.93 //x2=4.93 //y2=4.755
r551 (  18 43 ) resistor r=0.0894971 //w=0.376 //l=0.179123 //layer=m1 \
 //thickness=0.36 //x=4.93 //y=2.61 //x2=4.982 //y2=2.765
r552 (  17 39 ) resistor r=0.0719237 //w=0.222 //l=0.115 //layer=m1 \
 //thickness=0.36 //x=4.93 //y=2.375 //x2=4.93 //y2=2.26
r553 (  17 18 ) resistor r=0.224237 //w=0.131 //l=0.235 //layer=m1 \
 //thickness=0.36 //x=4.93 //y=2.375 //x2=4.93 //y2=2.61
r554 (  15 36 ) resistor r=0.0911593 //w=0.376 //l=0.184174 //layer=m1 \
 //thickness=0.36 //x=3.08 //y=2.93 //x2=3.132 //y2=2.77
r555 (  15 16 ) resistor r=2.25668 //w=0.131 //l=2.365 //layer=m1 \
 //thickness=0.36 //x=3.08 //y=2.93 //x2=3.08 //y2=5.295
r556 (  14 36 ) resistor r=0.0911593 //w=0.376 //l=0.184174 //layer=m1 \
 //thickness=0.36 //x=3.08 //y=2.61 //x2=3.132 //y2=2.77
r557 (  13 14 ) resistor r=0.658397 //w=0.131 //l=0.69 //layer=m1 \
 //thickness=0.36 //x=3.08 //y=1.92 //x2=3.08 //y2=2.61
r558 (  11 13 ) resistor r=0.0698411 //w=0.17 //l=0.120208 //layer=m1 \
 //thickness=0.36 //x=2.995 //y=1.835 //x2=3.08 //y2=1.92
r559 (  11 12 ) resistor r=0.257634 //w=0.131 //l=0.27 //layer=m1 \
 //thickness=0.36 //x=2.995 //y=1.835 //x2=2.725 //y2=1.835
r560 (  10 28 ) resistor r=0.0257089 //w=0.23 //l=0.115 //layer=m1 \
 //thickness=0.36 //x=2.715 //y=5.38 //x2=2.6 //y2=5.38
r561 (  9 16 ) resistor r=0.0698411 //w=0.17 //l=0.120208 //layer=m1 \
 //thickness=0.36 //x=2.995 //y=5.38 //x2=3.08 //y2=5.295
r562 (  9 10 ) resistor r=0.267176 //w=0.131 //l=0.28 //layer=m1 \
 //thickness=0.36 //x=2.995 //y=5.38 //x2=2.715 //y2=5.38
r563 (  8 12 ) resistor r=0.0698411 //w=0.17 //l=0.120208 //layer=m1 \
 //thickness=0.36 //x=2.64 //y=1.75 //x2=2.725 //y2=1.835
r564 (  7 33 ) resistor r=0.0913624 //w=0.191 //l=0.12 //layer=m1 \
 //thickness=0.36 //x=2.64 //y=1.3 //x2=2.64 //y2=1.18
r565 (  7 8 ) resistor r=0.429389 //w=0.131 //l=0.45 //layer=m1 \
 //thickness=0.36 //x=2.64 //y=1.3 //x2=2.64 //y2=1.75
r566 (  4 25 ) resistor r=0.0227762 //w=0.219 //l=0.115 //layer=m1 \
 //thickness=0.36 //x=1.835 //y=5.38 //x2=1.72 //y2=5.38
r567 (  3 28 ) resistor r=0.0257089 //w=0.23 //l=0.115 //layer=m1 \
 //thickness=0.36 //x=2.485 //y=5.38 //x2=2.6 //y2=5.38
r568 (  3 4 ) resistor r=0.620229 //w=0.131 //l=0.65 //layer=m1 \
 //thickness=0.36 //x=2.485 //y=5.38 //x2=1.835 //y2=5.38
ends PM_TMRDFFSNQNX1\%noxref_1

subckt PM_TMRDFFSNQNX1\%noxref_2 ( 1 3 6 7 9 10 11 12 14 15 16 18 19 21 24 27 \
 33 37 41 44 45 52 54 55 58 66 74 91 100 104 105 106 107 108 109 110 114 116 \
 119 120 130 133 135 136 137 )
c297 ( 133 0 ) capacitor c=0.00885916f //x=12.025 //y=1.095
c298 ( 130 0 ) capacitor c=0.0682508f //x=14.55 //y=4.88
c299 ( 120 0 ) capacitor c=0.0318956f //x=14.885 //y=1.39
c300 ( 119 0 ) capacitor c=0.0186809f //x=14.885 //y=1.045
c301 ( 116 0 ) capacitor c=0.0141821f //x=14.73 //y=1.545
c302 ( 114 0 ) capacitor c=0.0158553f //x=14.73 //y=0.89
c303 ( 110 0 ) capacitor c=0.0815114f //x=14.355 //y=2.095
c304 ( 109 0 ) capacitor c=0.0229235f //x=14.355 //y=1.7
c305 ( 108 0 ) capacitor c=0.0234359f //x=14.355 //y=1.39
c306 ( 107 0 ) capacitor c=0.0198759f //x=14.355 //y=1.045
c307 ( 106 0 ) capacitor c=0.110369f //x=14.89 //y=6.2
c308 ( 105 0 ) capacitor c=0.154619f //x=14.45 //y=6.2
c309 ( 100 0 ) capacitor c=8.13425e-19 //x=14.55 //y=4.88
c310 ( 91 0 ) capacitor c=5.17312e-19 //x=14.55 //y=2.26
c311 ( 74 0 ) capacitor c=0.0293219f //x=11.92 //y=5.56
c312 ( 66 0 ) capacitor c=0.029137f //x=11.04 //y=5.56
c313 ( 58 0 ) capacitor c=0.0278099f //x=10.16 //y=5.56
c314 ( 55 0 ) capacitor c=0.0156383f //x=14.385 //y=2.785
c315 ( 54 0 ) capacitor c=6.75833e-19 //x=14.545 //y=2.785
c316 ( 52 0 ) capacitor c=9.41304e-19 //x=12.86 //y=2.785
c317 ( 45 0 ) capacitor c=0.0515599f //x=14.552 //y=4.74
c318 ( 44 0 ) capacitor c=0.00631721f //x=14.55 //y=4.88
c319 ( 41 0 ) capacitor c=0.00463527f //x=14.55 //y=2.26
c320 ( 37 0 ) capacitor c=0.0145985f //x=14.55 //y=2.77
c321 ( 33 0 ) capacitor c=0.0149529f //x=12.7 //y=2.77
c322 ( 27 0 ) capacitor c=8.88597e-19 //x=11.92 //y=5.335
c323 ( 24 0 ) capacitor c=0.00796615f //x=11.04 //y=5.335
c324 ( 21 0 ) capacitor c=0.0111234f //x=10.162 //y=5.335
c325 ( 19 0 ) capacitor c=0.0120345f //x=14.55 //y=2.945
c326 ( 18 0 ) capacitor c=0.00384658f //x=14.55 //y=2.625
c327 ( 16 0 ) capacitor c=0.0658347f //x=12.7 //y=5.25
c328 ( 15 0 ) capacitor c=0.0123676f //x=12.7 //y=2.945
c329 ( 14 0 ) capacitor c=0.0168574f //x=12.7 //y=2.625
c330 ( 12 0 ) capacitor c=0.00493487f //x=12.3 //y=1.845
c331 ( 11 0 ) capacitor c=0.0126211f //x=12.615 //y=1.845
c332 ( 10 0 ) capacitor c=0.0136149f //x=12.215 //y=1.76
c333 ( 9 0 ) capacitor c=0.0113786f //x=12.215 //y=1.305
c334 ( 7 0 ) capacitor c=0.0235567f //x=12.615 //y=5.335
c335 ( 6 0 ) capacitor c=0.00906713f //x=11.92 //y=5.56
c336 ( 3 0 ) capacitor c=0.0180822f //x=11.805 //y=5.335
c337 ( 1 0 ) capacitor c=0.0152149f //x=10.92 //y=5.335
r338 (  128 130 ) resistor r=20.6867 //w=0.233 //l=0.1 //layer=ply \
 //thickness=0.18 //x=14.45 //y=4.88 //x2=14.55 //y2=4.88
r339 (  121 130 ) resistor r=70.3348 //w=0.233 //l=0.414367 //layer=ply \
 //thickness=0.18 //x=14.89 //y=5.045 //x2=14.55 //y2=4.88
r340 (  120 132 ) resistor r=45.1352 //w=0.168 //l=0.173853 //layer=ply \
 //thickness=0.18 //x=14.885 //y=1.39 //x2=14.845 //y2=1.545
r341 (  119 131 ) resistor r=45.1352 //w=0.168 //l=0.173853 //layer=ply \
 //thickness=0.18 //x=14.885 //y=1.045 //x2=14.845 //y2=0.89
r342 (  119 120 ) resistor r=176.904 //w=0.094 //l=0.345 //layer=ply \
 //thickness=0.18 //x=14.885 //y=1.045 //x2=14.885 //y2=1.39
r343 (  117 127 ) resistor r=10.701 //w=0.21 //l=0.115 //layer=ply \
 //thickness=0.18 //x=14.51 //y=1.545 //x2=14.395 //y2=1.545
r344 (  116 132 ) resistor r=5.52526 //w=0.168 //l=0.115 //layer=ply \
 //thickness=0.18 //x=14.73 //y=1.545 //x2=14.845 //y2=1.545
r345 (  115 126 ) resistor r=5.52526 //w=0.168 //l=0.115 //layer=ply \
 //thickness=0.18 //x=14.51 //y=0.89 //x2=14.395 //y2=0.89
r346 (  114 131 ) resistor r=5.52526 //w=0.168 //l=0.115 //layer=ply \
 //thickness=0.18 //x=14.73 //y=0.89 //x2=14.845 //y2=0.89
r347 (  114 115 ) resistor r=112.809 //w=0.094 //l=0.22 //layer=ply \
 //thickness=0.18 //x=14.73 //y=0.89 //x2=14.51 //y2=0.89
r348 (  111 128 ) resistor r=13.0941 //w=0.233 //l=0.165 //layer=ply \
 //thickness=0.18 //x=14.45 //y=5.045 //x2=14.45 //y2=4.88
r349 (  110 125 ) resistor r=34.8111 //w=0.27 //l=0.264953 //layer=ply \
 //thickness=0.18 //x=14.355 //y=2.095 //x2=14.55 //y2=2.26
r350 (  109 127 ) resistor r=39.5823 //w=0.21 //l=0.173853 //layer=ply \
 //thickness=0.18 //x=14.355 //y=1.7 //x2=14.395 //y2=1.545
r351 (  109 110 ) resistor r=202.543 //w=0.094 //l=0.395 //layer=ply \
 //thickness=0.18 //x=14.355 //y=1.7 //x2=14.355 //y2=2.095
r352 (  108 127 ) resistor r=39.5823 //w=0.21 //l=0.173853 //layer=ply \
 //thickness=0.18 //x=14.355 //y=1.39 //x2=14.395 //y2=1.545
r353 (  107 126 ) resistor r=45.1352 //w=0.168 //l=0.173853 //layer=ply \
 //thickness=0.18 //x=14.355 //y=1.045 //x2=14.395 //y2=0.89
r354 (  107 108 ) resistor r=176.904 //w=0.094 //l=0.345 //layer=ply \
 //thickness=0.18 //x=14.355 //y=1.045 //x2=14.355 //y2=1.39
r355 (  106 121 ) resistor r=592.245 //w=0.094 //l=1.155 //layer=ply \
 //thickness=0.18 //x=14.89 //y=6.2 //x2=14.89 //y2=5.045
r356 (  105 111 ) resistor r=592.245 //w=0.094 //l=1.155 //layer=ply \
 //thickness=0.18 //x=14.45 //y=6.2 //x2=14.45 //y2=5.045
r357 (  104 116 ) resistor r=56.4043 //w=0.094 //l=0.11 //layer=ply \
 //thickness=0.18 //x=14.62 //y=1.545 //x2=14.73 //y2=1.545
r358 (  104 117 ) resistor r=56.4043 //w=0.094 //l=0.11 //layer=ply \
 //thickness=0.18 //x=14.62 //y=1.545 //x2=14.51 //y2=1.545
r359 (  100 130 ) resistor r=152 //w=0.17 //l=0.17 //layer=licon //count=1 \
 //x=14.55 //y=4.88 //x2=14.55 //y2=4.88
r360 (  91 125 ) resistor r=152 //w=0.17 //l=0.17 //layer=licon //count=1 \
 //x=14.55 //y=2.26 //x2=14.55 //y2=2.26
r361 (  74 137 ) resistor r=23.615 //w=0.187 //l=0.345 //layer=li \
 //thickness=0.1 //x=11.92 //y=5.56 //x2=11.92 //y2=5.905
r362 (  66 136 ) resistor r=23.615 //w=0.187 //l=0.345 //layer=li \
 //thickness=0.1 //x=11.04 //y=5.56 //x2=11.04 //y2=5.905
r363 (  58 135 ) resistor r=23.615 //w=0.187 //l=0.345 //layer=li \
 //thickness=0.1 //x=10.16 //y=5.56 //x2=10.16 //y2=5.905
r364 (  54 55 ) resistor r=0.10734 //w=0.281 //l=0.16 //layer=m2 \
 //thickness=0.36 //x=14.545 //y=2.785 //x2=14.385 //y2=2.785
r365 (  52 55 ) resistor r=1.45515 //w=0.131 //l=1.525 //layer=m2 \
 //thickness=0.36 //x=12.86 //y=2.77 //x2=14.385 //y2=2.77
r366 (  50 52 ) resistor r=0.10734 //w=0.281 //l=0.16 //layer=m2 \
 //thickness=0.36 //x=12.7 //y=2.785 //x2=12.86 //y2=2.785
r367 (  44 100 ) resistor r=9.3 //w=0.17 //l=0.17 //layer=mcon //count=1 \
 //x=14.55 //y=4.88 //x2=14.55 //y2=4.88
r368 (  44 45 ) resistor r=0.103207 //w=0.196 //l=0.14 //layer=m1 \
 //thickness=0.36 //x=14.552 //y=4.88 //x2=14.552 //y2=4.74
r369 (  41 91 ) resistor r=9.3 //w=0.17 //l=0.17 //layer=mcon //count=1 \
 //x=14.55 //y=2.26 //x2=14.55 //y2=2.26
r370 (  39 54 ) resistor r=4.5 //w=0.15 //l=0.15 //layer=via1 //count=1 \
 //x=14.545 //y=2.785 //x2=14.545 //y2=2.785
r371 (  37 39 ) resistor r=0.00501337 //w=0.374 //l=0.015 //layer=m1 \
 //thickness=0.36 //x=14.495 //y=2.77 //x2=14.495 //y2=2.785
r372 (  35 50 ) resistor r=4.5 //w=0.15 //l=0.15 //layer=via1 //count=1 \
 //x=12.7 //y=2.785 //x2=12.7 //y2=2.785
r373 (  33 35 ) resistor r=0.0049867 //w=0.376 //l=0.015 //layer=m1 \
 //thickness=0.36 //x=12.752 //y=2.77 //x2=12.752 //y2=2.785
r374 (  31 133 ) resistor r=9.3 //w=0.17 //l=0.17 //layer=mcon //count=1 \
 //x=12.215 //y=1.19 //x2=12.215 //y2=1.19
r375 (  29 74 ) resistor r=9.3 //w=0.17 //l=0.17 //layer=mcon //count=1 \
 //x=11.92 //y=5.56 //x2=11.92 //y2=5.56
r376 (  26 66 ) resistor r=9.3 //w=0.17 //l=0.17 //layer=mcon //count=1 \
 //x=11.04 //y=5.56 //x2=11.04 //y2=5.56
r377 (  24 26 ) resistor r=0.121228 //w=0.232 //l=0.225 //layer=m1 \
 //thickness=0.36 //x=11.04 //y=5.335 //x2=11.04 //y2=5.56
r378 (  23 58 ) resistor r=9.3 //w=0.17 //l=0.17 //layer=mcon //count=1 \
 //x=10.16 //y=5.56 //x2=10.16 //y2=5.56
r379 (  21 23 ) resistor r=0.129608 //w=0.217 //l=0.225 //layer=m1 \
 //thickness=0.36 //x=10.162 //y=5.335 //x2=10.162 //y2=5.56
r380 (  19 39 ) resistor r=0.0910802 //w=0.374 //l=0.185472 //layer=m1 \
 //thickness=0.36 //x=14.55 //y=2.945 //x2=14.495 //y2=2.785
r381 (  19 45 ) resistor r=1.71279 //w=0.131 //l=1.795 //layer=m1 \
 //thickness=0.36 //x=14.55 //y=2.945 //x2=14.55 //y2=4.74
r382 (  18 37 ) resistor r=0.0860668 //w=0.374 //l=0.170294 //layer=m1 \
 //thickness=0.36 //x=14.55 //y=2.625 //x2=14.495 //y2=2.77
r383 (  17 41 ) resistor r=0.0933015 //w=0.201 //l=0.125 //layer=m1 \
 //thickness=0.36 //x=14.55 //y=2.385 //x2=14.55 //y2=2.26
r384 (  17 18 ) resistor r=0.229008 //w=0.131 //l=0.24 //layer=m1 \
 //thickness=0.36 //x=14.55 //y=2.385 //x2=14.55 //y2=2.625
r385 (  15 35 ) resistor r=0.0911593 //w=0.376 //l=0.184174 //layer=m1 \
 //thickness=0.36 //x=12.7 //y=2.945 //x2=12.752 //y2=2.785
r386 (  15 16 ) resistor r=2.19943 //w=0.131 //l=2.305 //layer=m1 \
 //thickness=0.36 //x=12.7 //y=2.945 //x2=12.7 //y2=5.25
r387 (  14 33 ) resistor r=0.0861726 //w=0.376 //l=0.169012 //layer=m1 \
 //thickness=0.36 //x=12.7 //y=2.625 //x2=12.752 //y2=2.77
r388 (  13 14 ) resistor r=0.663168 //w=0.131 //l=0.695 //layer=m1 \
 //thickness=0.36 //x=12.7 //y=1.93 //x2=12.7 //y2=2.625
r389 (  11 13 ) resistor r=0.0698411 //w=0.17 //l=0.120208 //layer=m1 \
 //thickness=0.36 //x=12.615 //y=1.845 //x2=12.7 //y2=1.93
r390 (  11 12 ) resistor r=0.300573 //w=0.131 //l=0.315 //layer=m1 \
 //thickness=0.36 //x=12.615 //y=1.845 //x2=12.3 //y2=1.845
r391 (  10 12 ) resistor r=0.0698411 //w=0.17 //l=0.120208 //layer=m1 \
 //thickness=0.36 //x=12.215 //y=1.76 //x2=12.3 //y2=1.845
r392 (  9 31 ) resistor r=0.0717383 //w=0.224 //l=0.115 //layer=m1 \
 //thickness=0.36 //x=12.215 //y=1.305 //x2=12.215 //y2=1.19
r393 (  9 10 ) resistor r=0.43416 //w=0.131 //l=0.455 //layer=m1 \
 //thickness=0.36 //x=12.215 //y=1.305 //x2=12.215 //y2=1.76
r394 (  8 27 ) resistor r=0.0675342 //w=0.23 //l=0.115 //layer=m1 \
 //thickness=0.36 //x=12.035 //y=5.335 //x2=11.92 //y2=5.335
r395 (  7 16 ) resistor r=0.0698411 //w=0.17 //l=0.120208 //layer=m1 \
 //thickness=0.36 //x=12.615 //y=5.335 //x2=12.7 //y2=5.25
r396 (  7 8 ) resistor r=0.553435 //w=0.131 //l=0.58 //layer=m1 \
 //thickness=0.36 //x=12.615 //y=5.335 //x2=12.035 //y2=5.335
r397 (  6 29 ) resistor r=0.00118313 //w=0.23 //layer=m1 //thickness=0.36 \
 //x=11.92 //y=5.56 //x2=11.92 //y2=5.56
r398 (  5 27 ) resistor r=0.002872 //w=0.34 //l=0.085 //layer=m1 \
 //thickness=0.36 //x=11.92 //y=5.42 //x2=11.92 //y2=5.335
r399 (  5 6 ) resistor r=0.091623 //w=0.191 //l=0.14 //layer=m1 \
 //thickness=0.36 //x=11.92 //y=5.42 //x2=11.92 //y2=5.56
r400 (  4 24 ) resistor r=0.0262263 //w=0.232 //l=0.12 //layer=m1 \
 //thickness=0.36 //x=11.16 //y=5.335 //x2=11.04 //y2=5.335
r401 (  3 27 ) resistor r=0.0675342 //w=0.23 //l=0.115 //layer=m1 \
 //thickness=0.36 //x=11.805 //y=5.335 //x2=11.92 //y2=5.335
r402 (  3 4 ) resistor r=0.615458 //w=0.131 //l=0.645 //layer=m1 \
 //thickness=0.36 //x=11.805 //y=5.335 //x2=11.16 //y2=5.335
r403 (  2 21 ) resistor r=0.0222262 //w=0.217 //l=0.118 //layer=m1 \
 //thickness=0.36 //x=10.28 //y=5.335 //x2=10.162 //y2=5.335
r404 (  1 24 ) resistor r=0.0262263 //w=0.232 //l=0.12 //layer=m1 \
 //thickness=0.36 //x=10.92 //y=5.335 //x2=11.04 //y2=5.335
r405 (  1 2 ) resistor r=0.610687 //w=0.131 //l=0.64 //layer=m1 \
 //thickness=0.36 //x=10.92 //y=5.335 //x2=10.28 //y2=5.335
ends PM_TMRDFFSNQNX1\%noxref_2

subckt PM_TMRDFFSNQNX1\%noxref_3 ( 2 3 4 5 7 10 11 13 14 15 16 18 19 20 22 23 \
 26 34 35 38 41 47 50 54 57 58 60 63 67 71 72 75 84 89 97 105 122 131 135 136 \
 137 138 139 140 141 142 143 148 150 152 158 159 160 161 162 163 167 169 172 \
 173 178 179 182 196 199 201 202 203 )
c486 ( 199 0 ) capacitor c=0.00885916f //x=7.215 //y=1.095
c487 ( 196 0 ) capacitor c=0.0634117f //x=17.88 //y=4.88
c488 ( 182 0 ) capacitor c=0.0354953f //x=2.37 //y=4.88
c489 ( 179 0 ) capacitor c=0.0284095f //x=2.34 //y=2.095
c490 ( 178 0 ) capacitor c=0.0476356f //x=2.34 //y=2.26
c491 ( 173 0 ) capacitor c=0.0318956f //x=18.215 //y=1.39
c492 ( 172 0 ) capacitor c=0.0186809f //x=18.215 //y=1.045
c493 ( 169 0 ) capacitor c=0.0141821f //x=18.06 //y=1.545
c494 ( 167 0 ) capacitor c=0.0158553f //x=18.06 //y=0.89
c495 ( 163 0 ) capacitor c=0.088055f //x=17.685 //y=2.095
c496 ( 162 0 ) capacitor c=0.0229235f //x=17.685 //y=1.7
c497 ( 161 0 ) capacitor c=0.0234359f //x=17.685 //y=1.39
c498 ( 160 0 ) capacitor c=0.0198759f //x=17.685 //y=1.045
c499 ( 159 0 ) capacitor c=0.0439708f //x=2.905 //y=1.43
c500 ( 158 0 ) capacitor c=0.0192582f //x=2.905 //y=1.085
c501 ( 152 0 ) capacitor c=0.0162526f //x=2.75 //y=1.585
c502 ( 150 0 ) capacitor c=0.0157807f //x=2.75 //y=0.93
c503 ( 148 0 ) capacitor c=0.0357885f //x=2.745 //y=4.97
c504 ( 143 0 ) capacitor c=0.0210762f //x=2.375 //y=1.74
c505 ( 142 0 ) capacitor c=0.0168511f //x=2.375 //y=1.43
c506 ( 141 0 ) capacitor c=0.0175485f //x=2.375 //y=1.085
c507 ( 140 0 ) capacitor c=0.110369f //x=18.22 //y=6.2
c508 ( 139 0 ) capacitor c=0.154619f //x=17.78 //y=6.2
c509 ( 138 0 ) capacitor c=0.155269f //x=2.82 //y=6.2
c510 ( 137 0 ) capacitor c=0.110375f //x=2.38 //y=6.2
c511 ( 131 0 ) capacitor c=6.19917e-19 //x=17.88 //y=4.88
c512 ( 122 0 ) capacitor c=7.85889e-19 //x=17.88 //y=2.26
c513 ( 105 0 ) capacitor c=0.0293709f //x=7.11 //y=5.56
c514 ( 97 0 ) capacitor c=0.029137f //x=6.23 //y=5.56
c515 ( 89 0 ) capacitor c=0.0277605f //x=5.35 //y=5.56
c516 ( 84 0 ) capacitor c=5.80994e-19 //x=2.37 //y=4.88
c517 ( 75 0 ) capacitor c=5.78095e-19 //x=2.34 //y=2.26
c518 ( 72 0 ) capacitor c=0.0941234f //x=17.72 //y=4.265
c519 ( 71 0 ) capacitor c=7.98142e-19 //x=17.88 //y=4.265
c520 ( 67 0 ) capacitor c=0.00262261f //x=2.5 //y=4.245
c521 ( 63 0 ) capacitor c=9.81648e-19 //x=8.045 //y=4.25
c522 ( 60 0 ) capacitor c=0.122114f //x=7.725 //y=4.25
c523 ( 58 0 ) capacitor c=0.00571667f //x=17.882 //y=4.74
c524 ( 57 0 ) capacitor c=0.00511243f //x=17.88 //y=4.88
c525 ( 54 0 ) capacitor c=0.00463527f //x=17.88 //y=2.26
c526 ( 50 0 ) capacitor c=0.0134746f //x=17.88 //y=4.25
c527 ( 47 0 ) capacitor c=0.0149922f //x=7.885 //y=4.25
c528 ( 41 0 ) capacitor c=8.88597e-19 //x=7.11 //y=5.335
c529 ( 38 0 ) capacitor c=0.0073827f //x=6.23 //y=5.335
c530 ( 35 0 ) capacitor c=0.0115084f //x=5.352 //y=5.335
c531 ( 34 0 ) capacitor c=0.0143718f //x=2.34 //y=4.25
c532 ( 26 0 ) capacitor c=0.00662206f //x=2.34 //y=2.26
c533 ( 23 0 ) capacitor c=0.0119701f //x=17.88 //y=4.425
c534 ( 22 0 ) capacitor c=0.0479951f //x=17.88 //y=4.105
c535 ( 20 0 ) capacitor c=0.0222419f //x=7.89 //y=5.25
c536 ( 19 0 ) capacitor c=0.0128722f //x=7.89 //y=4.41
c537 ( 18 0 ) capacitor c=0.0622725f //x=7.89 //y=4.09
c538 ( 16 0 ) capacitor c=0.00537187f //x=7.49 //y=1.845
c539 ( 15 0 ) capacitor c=0.0148432f //x=7.805 //y=1.845
c540 ( 14 0 ) capacitor c=0.0167333f //x=7.405 //y=1.76
c541 ( 13 0 ) capacitor c=0.0111291f //x=7.405 //y=1.305
c542 ( 11 0 ) capacitor c=0.0223199f //x=7.805 //y=5.335
c543 ( 10 0 ) capacitor c=0.00933983f //x=7.11 //y=5.56
c544 ( 7 0 ) capacitor c=0.019596f //x=6.995 //y=5.335
c545 ( 5 0 ) capacitor c=0.0150448f //x=6.11 //y=5.335
c546 ( 4 0 ) capacitor c=0.00990813f //x=2.34 //y=4.735
c547 ( 3 0 ) capacitor c=0.0102989f //x=2.34 //y=4.405
c548 ( 2 0 ) capacitor c=0.0396155f //x=2.34 //y=4.085
r549 (  194 196 ) resistor r=20.6867 //w=0.233 //l=0.1 //layer=ply \
 //thickness=0.18 //x=17.78 //y=4.88 //x2=17.88 //y2=4.88
r550 (  184 185 ) resistor r=32.4568 //w=0.214 //l=0.075 //layer=ply \
 //thickness=0.18 //x=2.37 //y=4.97 //x2=2.37 //y2=5.045
r551 (  182 184 ) resistor r=20.271 //w=0.214 //l=0.09 //layer=ply \
 //thickness=0.18 //x=2.37 //y=4.88 //x2=2.37 //y2=4.97
r552 (  178 179 ) resistor r=52.7279 //w=0.214 //l=0.165 //layer=ply \
 //thickness=0.18 //x=2.34 //y=2.26 //x2=2.34 //y2=2.095
r553 (  174 196 ) resistor r=70.3348 //w=0.233 //l=0.414367 //layer=ply \
 //thickness=0.18 //x=18.22 //y=5.045 //x2=17.88 //y2=4.88
r554 (  173 198 ) resistor r=45.1352 //w=0.168 //l=0.173853 //layer=ply \
 //thickness=0.18 //x=18.215 //y=1.39 //x2=18.175 //y2=1.545
r555 (  172 197 ) resistor r=45.1352 //w=0.168 //l=0.173853 //layer=ply \
 //thickness=0.18 //x=18.215 //y=1.045 //x2=18.175 //y2=0.89
r556 (  172 173 ) resistor r=176.904 //w=0.094 //l=0.345 //layer=ply \
 //thickness=0.18 //x=18.215 //y=1.045 //x2=18.215 //y2=1.39
r557 (  170 193 ) resistor r=10.701 //w=0.21 //l=0.115 //layer=ply \
 //thickness=0.18 //x=17.84 //y=1.545 //x2=17.725 //y2=1.545
r558 (  169 198 ) resistor r=5.52526 //w=0.168 //l=0.115 //layer=ply \
 //thickness=0.18 //x=18.06 //y=1.545 //x2=18.175 //y2=1.545
r559 (  168 192 ) resistor r=5.52526 //w=0.168 //l=0.115 //layer=ply \
 //thickness=0.18 //x=17.84 //y=0.89 //x2=17.725 //y2=0.89
r560 (  167 197 ) resistor r=5.52526 //w=0.168 //l=0.115 //layer=ply \
 //thickness=0.18 //x=18.06 //y=0.89 //x2=18.175 //y2=0.89
r561 (  167 168 ) resistor r=112.809 //w=0.094 //l=0.22 //layer=ply \
 //thickness=0.18 //x=18.06 //y=0.89 //x2=17.84 //y2=0.89
r562 (  164 194 ) resistor r=13.0941 //w=0.233 //l=0.165 //layer=ply \
 //thickness=0.18 //x=17.78 //y=5.045 //x2=17.78 //y2=4.88
r563 (  163 191 ) resistor r=34.8111 //w=0.27 //l=0.264953 //layer=ply \
 //thickness=0.18 //x=17.685 //y=2.095 //x2=17.88 //y2=2.26
r564 (  162 193 ) resistor r=39.5823 //w=0.21 //l=0.173853 //layer=ply \
 //thickness=0.18 //x=17.685 //y=1.7 //x2=17.725 //y2=1.545
r565 (  162 163 ) resistor r=202.543 //w=0.094 //l=0.395 //layer=ply \
 //thickness=0.18 //x=17.685 //y=1.7 //x2=17.685 //y2=2.095
r566 (  161 193 ) resistor r=39.5823 //w=0.21 //l=0.173853 //layer=ply \
 //thickness=0.18 //x=17.685 //y=1.39 //x2=17.725 //y2=1.545
r567 (  160 192 ) resistor r=45.1352 //w=0.168 //l=0.173853 //layer=ply \
 //thickness=0.18 //x=17.685 //y=1.045 //x2=17.725 //y2=0.89
r568 (  160 161 ) resistor r=176.904 //w=0.094 //l=0.345 //layer=ply \
 //thickness=0.18 //x=17.685 //y=1.045 //x2=17.685 //y2=1.39
r569 (  159 189 ) resistor r=45.1352 //w=0.168 //l=0.173853 //layer=ply \
 //thickness=0.18 //x=2.905 //y=1.43 //x2=2.865 //y2=1.585
r570 (  158 188 ) resistor r=45.1352 //w=0.168 //l=0.173853 //layer=ply \
 //thickness=0.18 //x=2.905 //y=1.085 //x2=2.865 //y2=0.93
r571 (  158 159 ) resistor r=176.904 //w=0.094 //l=0.345 //layer=ply \
 //thickness=0.18 //x=2.905 //y=1.085 //x2=2.905 //y2=1.43
r572 (  153 187 ) resistor r=10.701 //w=0.21 //l=0.115 //layer=ply \
 //thickness=0.18 //x=2.53 //y=1.585 //x2=2.415 //y2=1.585
r573 (  152 189 ) resistor r=5.52526 //w=0.168 //l=0.115 //layer=ply \
 //thickness=0.18 //x=2.75 //y=1.585 //x2=2.865 //y2=1.585
r574 (  151 186 ) resistor r=5.52526 //w=0.168 //l=0.115 //layer=ply \
 //thickness=0.18 //x=2.53 //y=0.93 //x2=2.415 //y2=0.93
r575 (  150 188 ) resistor r=5.52526 //w=0.168 //l=0.115 //layer=ply \
 //thickness=0.18 //x=2.75 //y=0.93 //x2=2.865 //y2=0.93
r576 (  150 151 ) resistor r=112.809 //w=0.094 //l=0.22 //layer=ply \
 //thickness=0.18 //x=2.75 //y=0.93 //x2=2.53 //y2=0.93
r577 (  149 184 ) resistor r=16.5046 //w=0.27 //l=0.135 //layer=ply \
 //thickness=0.18 //x=2.505 //y=4.97 //x2=2.37 //y2=4.97
r578 (  148 155 ) resistor r=26.9307 //w=0.15 //l=0.106066 //layer=ply \
 //thickness=0.18 //x=2.745 //y=4.97 //x2=2.82 //y2=5.045
r579 (  148 149 ) resistor r=123.064 //w=0.094 //l=0.24 //layer=ply \
 //thickness=0.18 //x=2.745 //y=4.97 //x2=2.505 //y2=4.97
r580 (  143 187 ) resistor r=39.5823 //w=0.21 //l=0.173853 //layer=ply \
 //thickness=0.18 //x=2.375 //y=1.74 //x2=2.415 //y2=1.585
r581 (  143 179 ) resistor r=182.032 //w=0.094 //l=0.355 //layer=ply \
 //thickness=0.18 //x=2.375 //y=1.74 //x2=2.375 //y2=2.095
r582 (  142 187 ) resistor r=39.5823 //w=0.21 //l=0.173853 //layer=ply \
 //thickness=0.18 //x=2.375 //y=1.43 //x2=2.415 //y2=1.585
r583 (  141 186 ) resistor r=45.1352 //w=0.168 //l=0.173853 //layer=ply \
 //thickness=0.18 //x=2.375 //y=1.085 //x2=2.415 //y2=0.93
r584 (  141 142 ) resistor r=176.904 //w=0.094 //l=0.345 //layer=ply \
 //thickness=0.18 //x=2.375 //y=1.085 //x2=2.375 //y2=1.43
r585 (  140 174 ) resistor r=592.245 //w=0.094 //l=1.155 //layer=ply \
 //thickness=0.18 //x=18.22 //y=6.2 //x2=18.22 //y2=5.045
r586 (  139 164 ) resistor r=592.245 //w=0.094 //l=1.155 //layer=ply \
 //thickness=0.18 //x=17.78 //y=6.2 //x2=17.78 //y2=5.045
r587 (  138 155 ) resistor r=592.245 //w=0.094 //l=1.155 //layer=ply \
 //thickness=0.18 //x=2.82 //y=6.2 //x2=2.82 //y2=5.045
r588 (  137 185 ) resistor r=592.245 //w=0.094 //l=1.155 //layer=ply \
 //thickness=0.18 //x=2.38 //y=6.2 //x2=2.38 //y2=5.045
r589 (  136 169 ) resistor r=56.4043 //w=0.094 //l=0.11 //layer=ply \
 //thickness=0.18 //x=17.95 //y=1.545 //x2=18.06 //y2=1.545
r590 (  136 170 ) resistor r=56.4043 //w=0.094 //l=0.11 //layer=ply \
 //thickness=0.18 //x=17.95 //y=1.545 //x2=17.84 //y2=1.545
r591 (  135 152 ) resistor r=56.4043 //w=0.094 //l=0.11 //layer=ply \
 //thickness=0.18 //x=2.64 //y=1.585 //x2=2.75 //y2=1.585
r592 (  135 153 ) resistor r=56.4043 //w=0.094 //l=0.11 //layer=ply \
 //thickness=0.18 //x=2.64 //y=1.585 //x2=2.53 //y2=1.585
r593 (  131 196 ) resistor r=152 //w=0.17 //l=0.17 //layer=licon //count=1 \
 //x=17.88 //y=4.88 //x2=17.88 //y2=4.88
r594 (  122 191 ) resistor r=152 //w=0.17 //l=0.17 //layer=licon //count=1 \
 //x=17.88 //y=2.26 //x2=17.88 //y2=2.26
r595 (  105 203 ) resistor r=23.615 //w=0.187 //l=0.345 //layer=li \
 //thickness=0.1 //x=7.11 //y=5.56 //x2=7.11 //y2=5.905
r596 (  97 202 ) resistor r=23.615 //w=0.187 //l=0.345 //layer=li \
 //thickness=0.1 //x=6.23 //y=5.56 //x2=6.23 //y2=5.905
r597 (  89 201 ) resistor r=23.615 //w=0.187 //l=0.345 //layer=li \
 //thickness=0.1 //x=5.35 //y=5.56 //x2=5.35 //y2=5.905
r598 (  84 182 ) resistor r=152 //w=0.17 //l=0.17 //layer=licon //count=1 \
 //x=2.37 //y=4.88 //x2=2.37 //y2=4.88
r599 (  75 178 ) resistor r=152 //w=0.17 //l=0.17 //layer=licon //count=1 \
 //x=2.34 //y=2.26 //x2=2.34 //y2=2.26
r600 (  71 72 ) resistor r=0.10734 //w=0.281 //l=0.16 //layer=m2 \
 //thickness=0.36 //x=17.88 //y=4.265 //x2=17.72 //y2=4.265
r601 (  65 67 ) resistor r=0.10734 //w=0.281 //l=0.16 //layer=m2 \
 //thickness=0.36 //x=2.34 //y=4.245 //x2=2.5 //y2=4.245
r602 (  63 69 ) resistor r=0.10734 //w=0.281 //l=0.16 //layer=m2 \
 //thickness=0.36 //x=8.045 //y=4.25 //x2=7.885 //y2=4.25
r603 (  63 72 ) resistor r=9.23187 //w=0.131 //l=9.675 //layer=m2 \
 //thickness=0.36 //x=8.045 //y=4.25 //x2=17.72 //y2=4.25
r604 (  60 69 ) resistor r=0.10734 //w=0.281 //l=0.16 //layer=m2 \
 //thickness=0.36 //x=7.725 //y=4.25 //x2=7.885 //y2=4.25
r605 (  60 67 ) resistor r=4.98569 //w=0.131 //l=5.225 //layer=m2 \
 //thickness=0.36 //x=7.725 //y=4.25 //x2=2.5 //y2=4.25
r606 (  57 131 ) resistor r=9.3 //w=0.17 //l=0.17 //layer=mcon //count=1 \
 //x=17.88 //y=4.88 //x2=17.88 //y2=4.88
r607 (  57 58 ) resistor r=0.103207 //w=0.196 //l=0.14 //layer=m1 \
 //thickness=0.36 //x=17.882 //y=4.88 //x2=17.882 //y2=4.74
r608 (  54 122 ) resistor r=9.3 //w=0.17 //l=0.17 //layer=mcon //count=1 \
 //x=17.88 //y=2.26 //x2=17.88 //y2=2.26
r609 (  52 71 ) resistor r=4.5 //w=0.15 //l=0.15 //layer=via1 //count=1 \
 //x=17.88 //y=4.265 //x2=17.88 //y2=4.265
r610 (  50 52 ) resistor r=0.0049867 //w=0.376 //l=0.015 //layer=m1 \
 //thickness=0.36 //x=17.827 //y=4.25 //x2=17.827 //y2=4.265
r611 (  47 69 ) resistor r=4.5 //w=0.15 //l=0.15 //layer=via1 //count=1 \
 //x=7.885 //y=4.25 //x2=7.885 //y2=4.25
r612 (  45 199 ) resistor r=9.3 //w=0.17 //l=0.17 //layer=mcon //count=1 \
 //x=7.405 //y=1.19 //x2=7.405 //y2=1.19
r613 (  43 105 ) resistor r=9.3 //w=0.17 //l=0.17 //layer=mcon //count=1 \
 //x=7.11 //y=5.56 //x2=7.11 //y2=5.56
r614 (  40 97 ) resistor r=9.3 //w=0.17 //l=0.17 //layer=mcon //count=1 \
 //x=6.23 //y=5.56 //x2=6.23 //y2=5.56
r615 (  38 40 ) resistor r=0.121228 //w=0.232 //l=0.225 //layer=m1 \
 //thickness=0.36 //x=6.23 //y=5.335 //x2=6.23 //y2=5.56
r616 (  37 89 ) resistor r=9.3 //w=0.17 //l=0.17 //layer=mcon //count=1 \
 //x=5.35 //y=5.56 //x2=5.35 //y2=5.56
r617 (  35 37 ) resistor r=0.129608 //w=0.217 //l=0.225 //layer=m1 \
 //thickness=0.36 //x=5.352 //y=5.335 //x2=5.352 //y2=5.56
r618 (  32 65 ) resistor r=4.5 //w=0.15 //l=0.15 //layer=via1 //count=1 \
 //x=2.34 //y=4.245 //x2=2.34 //y2=4.245
r619 (  32 34 ) resistor r=0.00166223 //w=0.376 //l=0.005 //layer=m1 \
 //thickness=0.36 //x=2.392 //y=4.245 //x2=2.392 //y2=4.25
r620 (  30 84 ) resistor r=9.3 //w=0.17 //l=0.17 //layer=mcon //count=1 \
 //x=2.37 //y=4.88 //x2=2.37 //y2=4.88
r621 (  26 75 ) resistor r=9.3 //w=0.17 //l=0.17 //layer=mcon //count=1 \
 //x=2.34 //y=2.26 //x2=2.34 //y2=2.26
r622 (  26 28 ) resistor r=0.0936408 //w=0.196 //l=0.125 //layer=m1 \
 //thickness=0.36 //x=2.342 //y=2.26 //x2=2.342 //y2=2.385
r623 (  23 52 ) resistor r=0.0911593 //w=0.376 //l=0.184608 //layer=m1 \
 //thickness=0.36 //x=17.88 //y=4.425 //x2=17.827 //y2=4.265
r624 (  23 58 ) resistor r=0.300573 //w=0.131 //l=0.315 //layer=m1 \
 //thickness=0.36 //x=17.88 //y=4.425 //x2=17.88 //y2=4.74
r625 (  22 50 ) resistor r=0.0861726 //w=0.376 //l=0.16944 //layer=m1 \
 //thickness=0.36 //x=17.88 //y=4.105 //x2=17.827 //y2=4.25
r626 (  21 54 ) resistor r=0.0933015 //w=0.201 //l=0.125 //layer=m1 \
 //thickness=0.36 //x=17.88 //y=2.385 //x2=17.88 //y2=2.26
r627 (  21 22 ) resistor r=1.64122 //w=0.131 //l=1.72 //layer=m1 \
 //thickness=0.36 //x=17.88 //y=2.385 //x2=17.88 //y2=4.105
r628 (  19 47 ) resistor r=0.0911593 //w=0.376 //l=0.181989 //layer=m1 \
 //thickness=0.36 //x=7.89 //y=4.41 //x2=7.937 //y2=4.25
r629 (  19 20 ) resistor r=0.801527 //w=0.131 //l=0.84 //layer=m1 \
 //thickness=0.36 //x=7.89 //y=4.41 //x2=7.89 //y2=5.25
r630 (  18 47 ) resistor r=0.0911593 //w=0.376 //l=0.181989 //layer=m1 \
 //thickness=0.36 //x=7.89 //y=4.09 //x2=7.937 //y2=4.25
r631 (  17 18 ) resistor r=2.06107 //w=0.131 //l=2.16 //layer=m1 \
 //thickness=0.36 //x=7.89 //y=1.93 //x2=7.89 //y2=4.09
r632 (  15 17 ) resistor r=0.0698411 //w=0.17 //l=0.120208 //layer=m1 \
 //thickness=0.36 //x=7.805 //y=1.845 //x2=7.89 //y2=1.93
r633 (  15 16 ) resistor r=0.300573 //w=0.131 //l=0.315 //layer=m1 \
 //thickness=0.36 //x=7.805 //y=1.845 //x2=7.49 //y2=1.845
r634 (  14 16 ) resistor r=0.0698411 //w=0.17 //l=0.120208 //layer=m1 \
 //thickness=0.36 //x=7.405 //y=1.76 //x2=7.49 //y2=1.845
r635 (  13 45 ) resistor r=0.0717383 //w=0.224 //l=0.115 //layer=m1 \
 //thickness=0.36 //x=7.405 //y=1.305 //x2=7.405 //y2=1.19
r636 (  13 14 ) resistor r=0.43416 //w=0.131 //l=0.455 //layer=m1 \
 //thickness=0.36 //x=7.405 //y=1.305 //x2=7.405 //y2=1.76
r637 (  12 41 ) resistor r=0.0675342 //w=0.23 //l=0.115 //layer=m1 \
 //thickness=0.36 //x=7.225 //y=5.335 //x2=7.11 //y2=5.335
r638 (  11 20 ) resistor r=0.0698411 //w=0.17 //l=0.120208 //layer=m1 \
 //thickness=0.36 //x=7.805 //y=5.335 //x2=7.89 //y2=5.25
r639 (  11 12 ) resistor r=0.553435 //w=0.131 //l=0.58 //layer=m1 \
 //thickness=0.36 //x=7.805 //y=5.335 //x2=7.225 //y2=5.335
r640 (  10 43 ) resistor r=0.00118313 //w=0.23 //layer=m1 //thickness=0.36 \
 //x=7.11 //y=5.56 //x2=7.11 //y2=5.56
r641 (  9 41 ) resistor r=0.002872 //w=0.34 //l=0.085 //layer=m1 \
 //thickness=0.36 //x=7.11 //y=5.42 //x2=7.11 //y2=5.335
r642 (  9 10 ) resistor r=0.091623 //w=0.191 //l=0.14 //layer=m1 \
 //thickness=0.36 //x=7.11 //y=5.42 //x2=7.11 //y2=5.56
r643 (  8 38 ) resistor r=0.0262263 //w=0.232 //l=0.12 //layer=m1 \
 //thickness=0.36 //x=6.35 //y=5.335 //x2=6.23 //y2=5.335
r644 (  7 41 ) resistor r=0.0675342 //w=0.23 //l=0.115 //layer=m1 \
 //thickness=0.36 //x=6.995 //y=5.335 //x2=7.11 //y2=5.335
r645 (  7 8 ) resistor r=0.615458 //w=0.131 //l=0.645 //layer=m1 \
 //thickness=0.36 //x=6.995 //y=5.335 //x2=6.35 //y2=5.335
r646 (  6 35 ) resistor r=0.0222262 //w=0.217 //l=0.118 //layer=m1 \
 //thickness=0.36 //x=5.47 //y=5.335 //x2=5.352 //y2=5.335
r647 (  5 38 ) resistor r=0.0262263 //w=0.232 //l=0.12 //layer=m1 \
 //thickness=0.36 //x=6.11 //y=5.335 //x2=6.23 //y2=5.335
r648 (  5 6 ) resistor r=0.610687 //w=0.131 //l=0.64 //layer=m1 \
 //thickness=0.36 //x=6.11 //y=5.335 //x2=5.47 //y2=5.335
r649 (  4 30 ) resistor r=0.0878548 //w=0.228 //l=0.159295 //layer=m1 \
 //thickness=0.36 //x=2.34 //y=4.735 //x2=2.37 //y2=4.88
r650 (  3 34 ) resistor r=0.0894971 //w=0.376 //l=0.179123 //layer=m1 \
 //thickness=0.36 //x=2.34 //y=4.405 //x2=2.392 //y2=4.25
r651 (  3 4 ) resistor r=0.314885 //w=0.131 //l=0.33 //layer=m1 \
 //thickness=0.36 //x=2.34 //y=4.405 //x2=2.34 //y2=4.735
r652 (  2 32 ) resistor r=0.0911593 //w=0.376 //l=0.184174 //layer=m1 \
 //thickness=0.36 //x=2.34 //y=4.085 //x2=2.392 //y2=4.245
r653 (  2 28 ) resistor r=1.62214 //w=0.131 //l=1.7 //layer=m1 \
 //thickness=0.36 //x=2.34 //y=4.085 //x2=2.34 //y2=2.385
ends PM_TMRDFFSNQNX1\%noxref_3

subckt PM_TMRDFFSNQNX1\%noxref_4 ( 1 2 3 4 5 6 7 8 11 16 17 19 20 22 23 24 25 \
 26 27 28 36 40 47 48 51 53 58 60 67 69 72 78 83 84 86 87 90 99 104 113 118 \
 126 143 152 156 157 158 159 160 161 162 163 164 168 169 170 175 177 180 181 \
 185 186 187 192 194 197 198 202 203 204 209 211 214 215 217 218 223 227 228 \
 233 237 238 243 246 248 249 )
c578 ( 246 0 ) capacitor c=0.00878249f //x=15.4 //y=1.085
c579 ( 243 0 ) capacitor c=0.0651477f //x=23.43 //y=4.88
c580 ( 238 0 ) capacitor c=0.0278202f //x=23.43 //y=2.095
c581 ( 237 0 ) capacitor c=0.0503043f //x=23.43 //y=2.26
c582 ( 233 0 ) capacitor c=0.0651619f //x=11.96 //y=4.88
c583 ( 228 0 ) capacitor c=0.0278202f //x=11.96 //y=2.095
c584 ( 227 0 ) capacitor c=0.0503043f //x=11.96 //y=2.26
c585 ( 223 0 ) capacitor c=0.0654765f //x=7.15 //y=4.88
c586 ( 218 0 ) capacitor c=0.0278202f //x=7.15 //y=2.095
c587 ( 217 0 ) capacitor c=0.0503043f //x=7.15 //y=2.26
c588 ( 215 0 ) capacitor c=0.0443175f //x=23.95 //y=1.44
c589 ( 214 0 ) capacitor c=0.0199703f //x=23.95 //y=1.095
c590 ( 211 0 ) capacitor c=0.0162526f //x=23.795 //y=1.595
c591 ( 209 0 ) capacitor c=0.0157807f //x=23.795 //y=0.94
c592 ( 204 0 ) capacitor c=0.0220935f //x=23.42 //y=1.75
c593 ( 203 0 ) capacitor c=0.0207489f //x=23.42 //y=1.44
c594 ( 202 0 ) capacitor c=0.0194091f //x=23.42 //y=1.095
c595 ( 198 0 ) capacitor c=0.0443175f //x=12.48 //y=1.44
c596 ( 197 0 ) capacitor c=0.0199703f //x=12.48 //y=1.095
c597 ( 194 0 ) capacitor c=0.0162526f //x=12.325 //y=1.595
c598 ( 192 0 ) capacitor c=0.0157807f //x=12.325 //y=0.94
c599 ( 187 0 ) capacitor c=0.0220935f //x=11.95 //y=1.75
c600 ( 186 0 ) capacitor c=0.0207489f //x=11.95 //y=1.44
c601 ( 185 0 ) capacitor c=0.0194091f //x=11.95 //y=1.095
c602 ( 181 0 ) capacitor c=0.0443175f //x=7.67 //y=1.44
c603 ( 180 0 ) capacitor c=0.0199703f //x=7.67 //y=1.095
c604 ( 177 0 ) capacitor c=0.0162526f //x=7.515 //y=1.595
c605 ( 175 0 ) capacitor c=0.0157807f //x=7.515 //y=0.94
c606 ( 170 0 ) capacitor c=0.0220935f //x=7.14 //y=1.75
c607 ( 169 0 ) capacitor c=0.0207489f //x=7.14 //y=1.44
c608 ( 168 0 ) capacitor c=0.0194091f //x=7.14 //y=1.095
c609 ( 164 0 ) capacitor c=0.159671f //x=23.61 //y=6.2
c610 ( 163 0 ) capacitor c=0.110208f //x=23.17 //y=6.2
c611 ( 162 0 ) capacitor c=0.159671f //x=12.14 //y=6.2
c612 ( 161 0 ) capacitor c=0.110208f //x=11.7 //y=6.2
c613 ( 160 0 ) capacitor c=0.159671f //x=7.33 //y=6.2
c614 ( 159 0 ) capacitor c=0.110208f //x=6.89 //y=6.2
c615 ( 152 0 ) capacitor c=7.7417e-19 //x=23.43 //y=4.88
c616 ( 143 0 ) capacitor c=0.00101179f //x=23.43 //y=2.26
c617 ( 126 0 ) capacitor c=0.0319332f //x=15.55 //y=5.56
c618 ( 118 0 ) capacitor c=0.0290186f //x=14.67 //y=5.56
c619 ( 113 0 ) capacitor c=7.7417e-19 //x=11.96 //y=4.88
c620 ( 104 0 ) capacitor c=0.00101179f //x=11.96 //y=2.26
c621 ( 99 0 ) capacitor c=7.7417e-19 //x=7.15 //y=4.88
c622 ( 90 0 ) capacitor c=0.00101179f //x=7.15 //y=2.26
c623 ( 87 0 ) capacitor c=0.0802696f //x=23.27 //y=3.885
c624 ( 86 0 ) capacitor c=6.15393e-19 //x=23.43 //y=3.885
c625 ( 84 0 ) capacitor c=7.85706e-19 //x=16.185 //y=3.865
c626 ( 83 0 ) capacitor c=0.0445493f //x=15.865 //y=3.865
c627 ( 78 0 ) capacitor c=7.70073e-19 //x=7.315 //y=3.865
c628 ( 72 0 ) capacitor c=0.0499276f //x=12.12 //y=3.88
c629 ( 69 0 ) capacitor c=0.00318287f //x=8.1 //y=3.865
c630 ( 67 0 ) capacitor c=0.00289159f //x=7.5 //y=3.88
c631 ( 60 0 ) capacitor c=0.0149589f //x=23.43 //y=3.88
c632 ( 58 0 ) capacitor c=0.0158493f //x=16.03 //y=3.88
c633 ( 53 0 ) capacitor c=0.0113632f //x=15.59 //y=1.18
c634 ( 51 0 ) capacitor c=5.78613e-19 //x=15.55 //y=5.56
c635 ( 48 0 ) capacitor c=0.00996089f //x=15.55 //y=5.38
c636 ( 47 0 ) capacitor c=0.00947836f //x=14.67 //y=5.56
c637 ( 40 0 ) capacitor c=0.0149589f //x=11.96 //y=3.88
c638 ( 36 0 ) capacitor c=0.0149589f //x=7.15 //y=3.88
c639 ( 28 0 ) capacitor c=0.0188294f //x=23.43 //y=4.75
c640 ( 27 0 ) capacitor c=0.0114437f //x=23.43 //y=4.045
c641 ( 26 0 ) capacitor c=0.0321374f //x=23.43 //y=3.725
c642 ( 25 0 ) capacitor c=0.0055474f //x=23.43 //y=2.375
c643 ( 24 0 ) capacitor c=0.0292688f //x=16.03 //y=5.295
c644 ( 23 0 ) capacitor c=0.0126782f //x=16.03 //y=4.025
c645 ( 22 0 ) capacitor c=0.0491572f //x=16.03 //y=3.705
c646 ( 20 0 ) capacitor c=0.00466468f //x=15.675 //y=1.835
c647 ( 19 0 ) capacitor c=0.0118534f //x=15.945 //y=1.835
c648 ( 17 0 ) capacitor c=0.0105341f //x=15.945 //y=5.38
c649 ( 16 0 ) capacitor c=0.0102514f //x=15.59 //y=1.75
c650 ( 11 0 ) capacitor c=0.0144196f //x=15.435 //y=5.38
c651 ( 8 0 ) capacitor c=0.0205242f //x=11.96 //y=4.75
c652 ( 7 0 ) capacitor c=0.0115579f //x=11.96 //y=4.025
c653 ( 6 0 ) capacitor c=0.0322912f //x=11.96 //y=3.705
c654 ( 5 0 ) capacitor c=0.00554287f //x=11.96 //y=2.375
c655 ( 4 0 ) capacitor c=0.0190807f //x=7.15 //y=4.75
c656 ( 3 0 ) capacitor c=0.0113742f //x=7.15 //y=4.025
c657 ( 2 0 ) capacitor c=0.0350104f //x=7.15 //y=3.705
c658 ( 1 0 ) capacitor c=0.00696087f //x=7.15 //y=2.375
r659 (  237 238 ) resistor r=52.7279 //w=0.214 //l=0.165 //layer=ply \
 //thickness=0.18 //x=23.43 //y=2.26 //x2=23.43 //y2=2.095
r660 (  227 228 ) resistor r=52.7279 //w=0.214 //l=0.165 //layer=ply \
 //thickness=0.18 //x=11.96 //y=2.26 //x2=11.96 //y2=2.095
r661 (  217 218 ) resistor r=52.7279 //w=0.214 //l=0.165 //layer=ply \
 //thickness=0.18 //x=7.15 //y=2.26 //x2=7.15 //y2=2.095
r662 (  215 245 ) resistor r=45.1352 //w=0.168 //l=0.173853 //layer=ply \
 //thickness=0.18 //x=23.95 //y=1.44 //x2=23.91 //y2=1.595
r663 (  214 244 ) resistor r=45.1352 //w=0.168 //l=0.173853 //layer=ply \
 //thickness=0.18 //x=23.95 //y=1.095 //x2=23.91 //y2=0.94
r664 (  214 215 ) resistor r=176.904 //w=0.094 //l=0.345 //layer=ply \
 //thickness=0.18 //x=23.95 //y=1.095 //x2=23.95 //y2=1.44
r665 (  212 241 ) resistor r=10.701 //w=0.21 //l=0.115 //layer=ply \
 //thickness=0.18 //x=23.575 //y=1.595 //x2=23.46 //y2=1.595
r666 (  211 245 ) resistor r=5.52526 //w=0.168 //l=0.115 //layer=ply \
 //thickness=0.18 //x=23.795 //y=1.595 //x2=23.91 //y2=1.595
r667 (  210 240 ) resistor r=5.52526 //w=0.168 //l=0.115 //layer=ply \
 //thickness=0.18 //x=23.575 //y=0.94 //x2=23.46 //y2=0.94
r668 (  209 244 ) resistor r=5.52526 //w=0.168 //l=0.115 //layer=ply \
 //thickness=0.18 //x=23.795 //y=0.94 //x2=23.91 //y2=0.94
r669 (  209 210 ) resistor r=112.809 //w=0.094 //l=0.22 //layer=ply \
 //thickness=0.18 //x=23.795 //y=0.94 //x2=23.575 //y2=0.94
r670 (  206 243 ) resistor r=37.236 //w=0.233 //l=0.249199 //layer=ply \
 //thickness=0.18 //x=23.61 //y=5.045 //x2=23.43 //y2=4.88
r671 (  204 241 ) resistor r=39.5823 //w=0.21 //l=0.173853 //layer=ply \
 //thickness=0.18 //x=23.42 //y=1.75 //x2=23.46 //y2=1.595
r672 (  204 238 ) resistor r=176.904 //w=0.094 //l=0.345 //layer=ply \
 //thickness=0.18 //x=23.42 //y=1.75 //x2=23.42 //y2=2.095
r673 (  203 241 ) resistor r=39.5823 //w=0.21 //l=0.173853 //layer=ply \
 //thickness=0.18 //x=23.42 //y=1.44 //x2=23.46 //y2=1.595
r674 (  202 240 ) resistor r=45.1352 //w=0.168 //l=0.173853 //layer=ply \
 //thickness=0.18 //x=23.42 //y=1.095 //x2=23.46 //y2=0.94
r675 (  202 203 ) resistor r=176.904 //w=0.094 //l=0.345 //layer=ply \
 //thickness=0.18 //x=23.42 //y=1.095 //x2=23.42 //y2=1.44
r676 (  199 243 ) resistor r=53.7854 //w=0.233 //l=0.332415 //layer=ply \
 //thickness=0.18 //x=23.17 //y=5.045 //x2=23.43 //y2=4.88
r677 (  198 235 ) resistor r=45.1352 //w=0.168 //l=0.173853 //layer=ply \
 //thickness=0.18 //x=12.48 //y=1.44 //x2=12.44 //y2=1.595
r678 (  197 234 ) resistor r=45.1352 //w=0.168 //l=0.173853 //layer=ply \
 //thickness=0.18 //x=12.48 //y=1.095 //x2=12.44 //y2=0.94
r679 (  197 198 ) resistor r=176.904 //w=0.094 //l=0.345 //layer=ply \
 //thickness=0.18 //x=12.48 //y=1.095 //x2=12.48 //y2=1.44
r680 (  195 231 ) resistor r=10.701 //w=0.21 //l=0.115 //layer=ply \
 //thickness=0.18 //x=12.105 //y=1.595 //x2=11.99 //y2=1.595
r681 (  194 235 ) resistor r=5.52526 //w=0.168 //l=0.115 //layer=ply \
 //thickness=0.18 //x=12.325 //y=1.595 //x2=12.44 //y2=1.595
r682 (  193 230 ) resistor r=5.52526 //w=0.168 //l=0.115 //layer=ply \
 //thickness=0.18 //x=12.105 //y=0.94 //x2=11.99 //y2=0.94
r683 (  192 234 ) resistor r=5.52526 //w=0.168 //l=0.115 //layer=ply \
 //thickness=0.18 //x=12.325 //y=0.94 //x2=12.44 //y2=0.94
r684 (  192 193 ) resistor r=112.809 //w=0.094 //l=0.22 //layer=ply \
 //thickness=0.18 //x=12.325 //y=0.94 //x2=12.105 //y2=0.94
r685 (  189 233 ) resistor r=37.236 //w=0.233 //l=0.249199 //layer=ply \
 //thickness=0.18 //x=12.14 //y=5.045 //x2=11.96 //y2=4.88
r686 (  187 231 ) resistor r=39.5823 //w=0.21 //l=0.173853 //layer=ply \
 //thickness=0.18 //x=11.95 //y=1.75 //x2=11.99 //y2=1.595
r687 (  187 228 ) resistor r=176.904 //w=0.094 //l=0.345 //layer=ply \
 //thickness=0.18 //x=11.95 //y=1.75 //x2=11.95 //y2=2.095
r688 (  186 231 ) resistor r=39.5823 //w=0.21 //l=0.173853 //layer=ply \
 //thickness=0.18 //x=11.95 //y=1.44 //x2=11.99 //y2=1.595
r689 (  185 230 ) resistor r=45.1352 //w=0.168 //l=0.173853 //layer=ply \
 //thickness=0.18 //x=11.95 //y=1.095 //x2=11.99 //y2=0.94
r690 (  185 186 ) resistor r=176.904 //w=0.094 //l=0.345 //layer=ply \
 //thickness=0.18 //x=11.95 //y=1.095 //x2=11.95 //y2=1.44
r691 (  182 233 ) resistor r=53.7854 //w=0.233 //l=0.332415 //layer=ply \
 //thickness=0.18 //x=11.7 //y=5.045 //x2=11.96 //y2=4.88
r692 (  181 225 ) resistor r=45.1352 //w=0.168 //l=0.173853 //layer=ply \
 //thickness=0.18 //x=7.67 //y=1.44 //x2=7.63 //y2=1.595
r693 (  180 224 ) resistor r=45.1352 //w=0.168 //l=0.173853 //layer=ply \
 //thickness=0.18 //x=7.67 //y=1.095 //x2=7.63 //y2=0.94
r694 (  180 181 ) resistor r=176.904 //w=0.094 //l=0.345 //layer=ply \
 //thickness=0.18 //x=7.67 //y=1.095 //x2=7.67 //y2=1.44
r695 (  178 221 ) resistor r=10.701 //w=0.21 //l=0.115 //layer=ply \
 //thickness=0.18 //x=7.295 //y=1.595 //x2=7.18 //y2=1.595
r696 (  177 225 ) resistor r=5.52526 //w=0.168 //l=0.115 //layer=ply \
 //thickness=0.18 //x=7.515 //y=1.595 //x2=7.63 //y2=1.595
r697 (  176 220 ) resistor r=5.52526 //w=0.168 //l=0.115 //layer=ply \
 //thickness=0.18 //x=7.295 //y=0.94 //x2=7.18 //y2=0.94
r698 (  175 224 ) resistor r=5.52526 //w=0.168 //l=0.115 //layer=ply \
 //thickness=0.18 //x=7.515 //y=0.94 //x2=7.63 //y2=0.94
r699 (  175 176 ) resistor r=112.809 //w=0.094 //l=0.22 //layer=ply \
 //thickness=0.18 //x=7.515 //y=0.94 //x2=7.295 //y2=0.94
r700 (  172 223 ) resistor r=37.236 //w=0.233 //l=0.249199 //layer=ply \
 //thickness=0.18 //x=7.33 //y=5.045 //x2=7.15 //y2=4.88
r701 (  170 221 ) resistor r=39.5823 //w=0.21 //l=0.173853 //layer=ply \
 //thickness=0.18 //x=7.14 //y=1.75 //x2=7.18 //y2=1.595
r702 (  170 218 ) resistor r=176.904 //w=0.094 //l=0.345 //layer=ply \
 //thickness=0.18 //x=7.14 //y=1.75 //x2=7.14 //y2=2.095
r703 (  169 221 ) resistor r=39.5823 //w=0.21 //l=0.173853 //layer=ply \
 //thickness=0.18 //x=7.14 //y=1.44 //x2=7.18 //y2=1.595
r704 (  168 220 ) resistor r=45.1352 //w=0.168 //l=0.173853 //layer=ply \
 //thickness=0.18 //x=7.14 //y=1.095 //x2=7.18 //y2=0.94
r705 (  168 169 ) resistor r=176.904 //w=0.094 //l=0.345 //layer=ply \
 //thickness=0.18 //x=7.14 //y=1.095 //x2=7.14 //y2=1.44
r706 (  165 223 ) resistor r=53.7854 //w=0.233 //l=0.332415 //layer=ply \
 //thickness=0.18 //x=6.89 //y=5.045 //x2=7.15 //y2=4.88
r707 (  164 206 ) resistor r=592.245 //w=0.094 //l=1.155 //layer=ply \
 //thickness=0.18 //x=23.61 //y=6.2 //x2=23.61 //y2=5.045
r708 (  163 199 ) resistor r=592.245 //w=0.094 //l=1.155 //layer=ply \
 //thickness=0.18 //x=23.17 //y=6.2 //x2=23.17 //y2=5.045
r709 (  162 189 ) resistor r=592.245 //w=0.094 //l=1.155 //layer=ply \
 //thickness=0.18 //x=12.14 //y=6.2 //x2=12.14 //y2=5.045
r710 (  161 182 ) resistor r=592.245 //w=0.094 //l=1.155 //layer=ply \
 //thickness=0.18 //x=11.7 //y=6.2 //x2=11.7 //y2=5.045
r711 (  160 172 ) resistor r=592.245 //w=0.094 //l=1.155 //layer=ply \
 //thickness=0.18 //x=7.33 //y=6.2 //x2=7.33 //y2=5.045
r712 (  159 165 ) resistor r=592.245 //w=0.094 //l=1.155 //layer=ply \
 //thickness=0.18 //x=6.89 //y=6.2 //x2=6.89 //y2=5.045
r713 (  158 211 ) resistor r=56.4043 //w=0.094 //l=0.11 //layer=ply \
 //thickness=0.18 //x=23.685 //y=1.595 //x2=23.795 //y2=1.595
r714 (  158 212 ) resistor r=56.4043 //w=0.094 //l=0.11 //layer=ply \
 //thickness=0.18 //x=23.685 //y=1.595 //x2=23.575 //y2=1.595
r715 (  157 194 ) resistor r=56.4043 //w=0.094 //l=0.11 //layer=ply \
 //thickness=0.18 //x=12.215 //y=1.595 //x2=12.325 //y2=1.595
r716 (  157 195 ) resistor r=56.4043 //w=0.094 //l=0.11 //layer=ply \
 //thickness=0.18 //x=12.215 //y=1.595 //x2=12.105 //y2=1.595
r717 (  156 177 ) resistor r=56.4043 //w=0.094 //l=0.11 //layer=ply \
 //thickness=0.18 //x=7.405 //y=1.595 //x2=7.515 //y2=1.595
r718 (  156 178 ) resistor r=56.4043 //w=0.094 //l=0.11 //layer=ply \
 //thickness=0.18 //x=7.405 //y=1.595 //x2=7.295 //y2=1.595
r719 (  152 243 ) resistor r=152 //w=0.17 //l=0.17 //layer=licon //count=1 \
 //x=23.43 //y=4.88 //x2=23.43 //y2=4.88
r720 (  143 237 ) resistor r=152 //w=0.17 //l=0.17 //layer=licon //count=1 \
 //x=23.43 //y=2.26 //x2=23.43 //y2=2.26
r721 (  126 249 ) resistor r=23.615 //w=0.187 //l=0.345 //layer=li \
 //thickness=0.1 //x=15.55 //y=5.56 //x2=15.55 //y2=5.905
r722 (  118 248 ) resistor r=23.615 //w=0.187 //l=0.345 //layer=li \
 //thickness=0.1 //x=14.67 //y=5.56 //x2=14.67 //y2=5.905
r723 (  113 233 ) resistor r=152 //w=0.17 //l=0.17 //layer=licon //count=1 \
 //x=11.96 //y=4.88 //x2=11.96 //y2=4.88
r724 (  104 227 ) resistor r=152 //w=0.17 //l=0.17 //layer=licon //count=1 \
 //x=11.96 //y=2.26 //x2=11.96 //y2=2.26
r725 (  99 223 ) resistor r=152 //w=0.17 //l=0.17 //layer=licon //count=1 \
 //x=7.15 //y=4.88 //x2=7.15 //y2=4.88
r726 (  90 217 ) resistor r=152 //w=0.17 //l=0.17 //layer=licon //count=1 \
 //x=7.15 //y=2.26 //x2=7.15 //y2=2.26
r727 (  86 87 ) resistor r=0.10734 //w=0.281 //l=0.16 //layer=m2 \
 //thickness=0.36 //x=23.43 //y=3.885 //x2=23.27 //y2=3.885
r728 (  84 87 ) resistor r=6.7605 //w=0.131 //l=7.085 //layer=m2 \
 //thickness=0.36 //x=16.185 //y=3.88 //x2=23.27 //y2=3.88
r729 (  82 84 ) resistor r=0.10734 //w=0.281 //l=0.16 //layer=m2 \
 //thickness=0.36 //x=16.025 //y=3.865 //x2=16.185 //y2=3.865
r730 (  82 83 ) resistor r=0.10734 //w=0.281 //l=0.16 //layer=m2 \
 //thickness=0.36 //x=16.025 //y=3.865 //x2=15.865 //y2=3.865
r731 (  76 78 ) resistor r=0.10734 //w=0.281 //l=0.16 //layer=m2 \
 //thickness=0.36 //x=7.155 //y=3.865 //x2=7.315 //y2=3.865
r732 (  72 80 ) resistor r=0.110608 //w=0.182 //l=0.167332 //layer=m2 \
 //thickness=0.36 //x=12.12 //y=3.88 //x2=11.96 //y2=3.865
r733 (  72 83 ) resistor r=3.57347 //w=0.131 //l=3.745 //layer=m2 \
 //thickness=0.36 //x=12.12 //y=3.88 //x2=15.865 //y2=3.88
r734 (  69 80 ) resistor r=2.65182 //w=0.182 //l=3.86 //layer=m2 \
 //thickness=0.36 //x=8.1 //y=3.865 //x2=11.96 //y2=3.865
r735 (  69 70 ) resistor r=0.410305 //w=0.131 //l=0.43 //layer=m2 \
 //thickness=0.36 //x=8.1 //y=3.865 //x2=7.67 //y2=3.865
r736 (  67 70 ) resistor r=0.125 //w=0.17 //l=0.177341 //layer=m2 \
 //thickness=0.36 //x=7.5 //y=3.88 //x2=7.67 //y2=3.865
r737 (  67 78 ) resistor r=0.176527 //w=0.131 //l=0.185 //layer=m2 \
 //thickness=0.36 //x=7.5 //y=3.88 //x2=7.315 //y2=3.88
r738 (  66 152 ) resistor r=9.3 //w=0.17 //l=0.17 //layer=mcon //count=1 \
 //x=23.43 //y=4.88 //x2=23.43 //y2=4.88
r739 (  64 143 ) resistor r=9.3 //w=0.17 //l=0.17 //layer=mcon //count=1 \
 //x=23.43 //y=2.26 //x2=23.43 //y2=2.26
r740 (  62 86 ) resistor r=4.5 //w=0.15 //l=0.15 //layer=via1 //count=1 \
 //x=23.43 //y=3.885 //x2=23.43 //y2=3.885
r741 (  60 62 ) resistor r=0.00166223 //w=0.376 //l=0.005 //layer=m1 \
 //thickness=0.36 //x=23.377 //y=3.88 //x2=23.377 //y2=3.885
r742 (  56 82 ) resistor r=4.5 //w=0.15 //l=0.15 //layer=via1 //count=1 \
 //x=16.025 //y=3.865 //x2=16.025 //y2=3.865
r743 (  56 58 ) resistor r=0.00501337 //w=0.374 //l=0.015 //layer=m1 \
 //thickness=0.36 //x=15.975 //y=3.865 //x2=15.975 //y2=3.88
r744 (  53 246 ) resistor r=9.3 //w=0.17 //l=0.17 //layer=mcon //count=1 \
 //x=15.59 //y=1.18 //x2=15.59 //y2=1.18
r745 (  51 126 ) resistor r=9.3 //w=0.17 //l=0.17 //layer=mcon //count=1 \
 //x=15.55 //y=5.56 //x2=15.55 //y2=5.56
r746 (  48 51 ) resistor r=0.117801 //w=0.191 //l=0.18 //layer=m1 \
 //thickness=0.36 //x=15.55 //y=5.38 //x2=15.55 //y2=5.56
r747 (  47 118 ) resistor r=9.3 //w=0.17 //l=0.17 //layer=mcon //count=1 \
 //x=14.67 //y=5.56 //x2=14.67 //y2=5.56
r748 (  45 47 ) resistor r=0.10274 //w=0.219 //l=0.18 //layer=m1 \
 //thickness=0.36 //x=14.67 //y=5.38 //x2=14.67 //y2=5.56
r749 (  44 113 ) resistor r=9.3 //w=0.17 //l=0.17 //layer=mcon //count=1 \
 //x=11.96 //y=4.88 //x2=11.96 //y2=4.88
r750 (  42 104 ) resistor r=9.3 //w=0.17 //l=0.17 //layer=mcon //count=1 \
 //x=11.96 //y=2.26 //x2=11.96 //y2=2.26
r751 (  38 80 ) resistor r=4.5 //w=0.15 //l=0.15 //layer=via1 //count=1 \
 //x=11.96 //y=3.865 //x2=11.96 //y2=3.865
r752 (  38 40 ) resistor r=0.0049867 //w=0.376 //l=0.015 //layer=m1 \
 //thickness=0.36 //x=11.907 //y=3.865 //x2=11.907 //y2=3.88
r753 (  34 76 ) resistor r=4.5 //w=0.15 //l=0.15 //layer=via1 //count=1 \
 //x=7.155 //y=3.865 //x2=7.155 //y2=3.865
r754 (  34 36 ) resistor r=0.00501337 //w=0.374 //l=0.015 //layer=m1 \
 //thickness=0.36 //x=7.205 //y=3.865 //x2=7.205 //y2=3.88
r755 (  32 99 ) resistor r=9.3 //w=0.17 //l=0.17 //layer=mcon //count=1 \
 //x=7.15 //y=4.88 //x2=7.15 //y2=4.88
r756 (  30 90 ) resistor r=9.3 //w=0.17 //l=0.17 //layer=mcon //count=1 \
 //x=7.15 //y=2.26 //x2=7.15 //y2=2.26
r757 (  28 66 ) resistor r=0.0801089 //w=0.224 //l=0.13 //layer=m1 \
 //thickness=0.36 //x=23.43 //y=4.75 //x2=23.43 //y2=4.88
r758 (  27 62 ) resistor r=0.0911593 //w=0.376 //l=0.184608 //layer=m1 \
 //thickness=0.36 //x=23.43 //y=4.045 //x2=23.377 //y2=3.885
r759 (  27 28 ) resistor r=0.67271 //w=0.131 //l=0.705 //layer=m1 \
 //thickness=0.36 //x=23.43 //y=4.045 //x2=23.43 //y2=4.75
r760 (  26 60 ) resistor r=0.0894971 //w=0.376 //l=0.179555 //layer=m1 \
 //thickness=0.36 //x=23.43 //y=3.725 //x2=23.377 //y2=3.88
r761 (  25 64 ) resistor r=0.0719237 //w=0.222 //l=0.115 //layer=m1 \
 //thickness=0.36 //x=23.43 //y=2.375 //x2=23.43 //y2=2.26
r762 (  25 26 ) resistor r=1.28817 //w=0.131 //l=1.35 //layer=m1 \
 //thickness=0.36 //x=23.43 //y=2.375 //x2=23.43 //y2=3.725
r763 (  23 58 ) resistor r=0.0860668 //w=0.374 //l=0.170294 //layer=m1 \
 //thickness=0.36 //x=16.03 //y=4.025 //x2=15.975 //y2=3.88
r764 (  23 24 ) resistor r=1.21183 //w=0.131 //l=1.27 //layer=m1 \
 //thickness=0.36 //x=16.03 //y=4.025 //x2=16.03 //y2=5.295
r765 (  22 56 ) resistor r=0.0910802 //w=0.374 //l=0.185472 //layer=m1 \
 //thickness=0.36 //x=16.03 //y=3.705 //x2=15.975 //y2=3.865
r766 (  21 22 ) resistor r=1.70324 //w=0.131 //l=1.785 //layer=m1 \
 //thickness=0.36 //x=16.03 //y=1.92 //x2=16.03 //y2=3.705
r767 (  19 21 ) resistor r=0.0698411 //w=0.17 //l=0.120208 //layer=m1 \
 //thickness=0.36 //x=15.945 //y=1.835 //x2=16.03 //y2=1.92
r768 (  19 20 ) resistor r=0.257634 //w=0.131 //l=0.27 //layer=m1 \
 //thickness=0.36 //x=15.945 //y=1.835 //x2=15.675 //y2=1.835
r769 (  18 48 ) resistor r=0.0257089 //w=0.23 //l=0.115 //layer=m1 \
 //thickness=0.36 //x=15.665 //y=5.38 //x2=15.55 //y2=5.38
r770 (  17 24 ) resistor r=0.0698411 //w=0.17 //l=0.120208 //layer=m1 \
 //thickness=0.36 //x=15.945 //y=5.38 //x2=16.03 //y2=5.295
r771 (  17 18 ) resistor r=0.267176 //w=0.131 //l=0.28 //layer=m1 \
 //thickness=0.36 //x=15.945 //y=5.38 //x2=15.665 //y2=5.38
r772 (  16 20 ) resistor r=0.0698411 //w=0.17 //l=0.120208 //layer=m1 \
 //thickness=0.36 //x=15.59 //y=1.75 //x2=15.675 //y2=1.835
r773 (  15 53 ) resistor r=0.0913624 //w=0.191 //l=0.12 //layer=m1 \
 //thickness=0.36 //x=15.59 //y=1.3 //x2=15.59 //y2=1.18
r774 (  15 16 ) resistor r=0.429389 //w=0.131 //l=0.45 //layer=m1 \
 //thickness=0.36 //x=15.59 //y=1.3 //x2=15.59 //y2=1.75
r775 (  12 45 ) resistor r=0.0227762 //w=0.219 //l=0.115 //layer=m1 \
 //thickness=0.36 //x=14.785 //y=5.38 //x2=14.67 //y2=5.38
r776 (  11 48 ) resistor r=0.0257089 //w=0.23 //l=0.115 //layer=m1 \
 //thickness=0.36 //x=15.435 //y=5.38 //x2=15.55 //y2=5.38
r777 (  11 12 ) resistor r=0.620229 //w=0.131 //l=0.65 //layer=m1 \
 //thickness=0.36 //x=15.435 //y=5.38 //x2=14.785 //y2=5.38
r778 (  8 44 ) resistor r=0.0801089 //w=0.224 //l=0.13 //layer=m1 \
 //thickness=0.36 //x=11.96 //y=4.75 //x2=11.96 //y2=4.88
r779 (  7 40 ) resistor r=0.0861726 //w=0.376 //l=0.16944 //layer=m1 \
 //thickness=0.36 //x=11.96 //y=4.025 //x2=11.907 //y2=3.88
r780 (  7 8 ) resistor r=0.691794 //w=0.131 //l=0.725 //layer=m1 \
 //thickness=0.36 //x=11.96 //y=4.025 //x2=11.96 //y2=4.75
r781 (  6 38 ) resistor r=0.0911593 //w=0.376 //l=0.184608 //layer=m1 \
 //thickness=0.36 //x=11.96 //y=3.705 //x2=11.907 //y2=3.865
r782 (  5 42 ) resistor r=0.0719237 //w=0.222 //l=0.115 //layer=m1 \
 //thickness=0.36 //x=11.96 //y=2.375 //x2=11.96 //y2=2.26
r783 (  5 6 ) resistor r=1.26908 //w=0.131 //l=1.33 //layer=m1 \
 //thickness=0.36 //x=11.96 //y=2.375 //x2=11.96 //y2=3.705
r784 (  4 32 ) resistor r=0.0801089 //w=0.224 //l=0.13 //layer=m1 \
 //thickness=0.36 //x=7.15 //y=4.75 //x2=7.15 //y2=4.88
r785 (  3 36 ) resistor r=0.0860668 //w=0.374 //l=0.170294 //layer=m1 \
 //thickness=0.36 //x=7.15 //y=4.025 //x2=7.205 //y2=3.88
r786 (  3 4 ) resistor r=0.691794 //w=0.131 //l=0.725 //layer=m1 \
 //thickness=0.36 //x=7.15 //y=4.025 //x2=7.15 //y2=4.75
r787 (  2 34 ) resistor r=0.0910802 //w=0.374 //l=0.185472 //layer=m1 \
 //thickness=0.36 //x=7.15 //y=3.705 //x2=7.205 //y2=3.865
r788 (  1 30 ) resistor r=0.0719237 //w=0.222 //l=0.115 //layer=m1 \
 //thickness=0.36 //x=7.15 //y=2.375 //x2=7.15 //y2=2.26
r789 (  1 2 ) resistor r=1.26908 //w=0.131 //l=1.33 //layer=m1 \
 //thickness=0.36 //x=7.15 //y=2.375 //x2=7.15 //y2=3.705
ends PM_TMRDFFSNQNX1\%noxref_4

subckt PM_TMRDFFSNQNX1\%noxref_5 ( 2 3 4 5 7 10 11 13 14 15 16 18 19 20 22 28 \
 31 34 37 45 46 48 53 57 66 71 79 87 103 104 105 106 107 108 113 115 117 123 \
 124 126 127 130 138 140 141 142 )
c323 ( 138 0 ) capacitor c=0.00885916f //x=23.495 //y=1.095
c324 ( 130 0 ) capacitor c=0.0354916f //x=18.65 //y=4.88
c325 ( 127 0 ) capacitor c=0.0284095f //x=18.62 //y=2.095
c326 ( 126 0 ) capacitor c=0.0476356f //x=18.62 //y=2.26
c327 ( 124 0 ) capacitor c=0.0439708f //x=19.185 //y=1.43
c328 ( 123 0 ) capacitor c=0.0192582f //x=19.185 //y=1.085
c329 ( 117 0 ) capacitor c=0.0162526f //x=19.03 //y=1.585
c330 ( 115 0 ) capacitor c=0.0157807f //x=19.03 //y=0.93
c331 ( 113 0 ) capacitor c=0.0357885f //x=19.025 //y=4.97
c332 ( 108 0 ) capacitor c=0.0210762f //x=18.655 //y=1.74
c333 ( 107 0 ) capacitor c=0.0168511f //x=18.655 //y=1.43
c334 ( 106 0 ) capacitor c=0.0175485f //x=18.655 //y=1.085
c335 ( 105 0 ) capacitor c=0.155269f //x=19.1 //y=6.2
c336 ( 104 0 ) capacitor c=0.110375f //x=18.66 //y=6.2
c337 ( 87 0 ) capacitor c=0.0293228f //x=23.39 //y=5.56
c338 ( 79 0 ) capacitor c=0.029137f //x=22.51 //y=5.56
c339 ( 71 0 ) capacitor c=0.0277605f //x=21.63 //y=5.56
c340 ( 66 0 ) capacitor c=5.80994e-19 //x=18.65 //y=4.88
c341 ( 57 0 ) capacitor c=5.78095e-19 //x=18.62 //y=2.26
c342 ( 53 0 ) capacitor c=6.56309e-19 //x=18.775 //y=4.265
c343 ( 48 0 ) capacitor c=0.00820049f //x=23.645 //y=4.27
c344 ( 46 0 ) capacitor c=0.0437269f //x=23.045 //y=4.25
c345 ( 45 0 ) capacitor c=0.0163405f //x=24.17 //y=4.25
c346 ( 37 0 ) capacitor c=8.84507e-19 //x=23.39 //y=5.335
c347 ( 34 0 ) capacitor c=0.00799482f //x=22.51 //y=5.335
c348 ( 31 0 ) capacitor c=0.0112819f //x=21.632 //y=5.335
c349 ( 28 0 ) capacitor c=0.0133657f //x=18.62 //y=4.25
c350 ( 22 0 ) capacitor c=0.00504845f //x=18.62 //y=2.26
c351 ( 20 0 ) capacitor c=0.0210243f //x=24.17 //y=5.25
c352 ( 19 0 ) capacitor c=0.0152889f //x=24.17 //y=4.395
c353 ( 18 0 ) capacitor c=0.0591845f //x=24.17 //y=4.075
c354 ( 16 0 ) capacitor c=0.00493487f //x=23.77 //y=1.845
c355 ( 15 0 ) capacitor c=0.0130102f //x=24.085 //y=1.845
c356 ( 14 0 ) capacitor c=0.013549f //x=23.685 //y=1.76
c357 ( 13 0 ) capacitor c=0.0113783f //x=23.685 //y=1.305
c358 ( 11 0 ) capacitor c=0.0231085f //x=24.085 //y=5.335
c359 ( 10 0 ) capacitor c=0.00906713f //x=23.39 //y=5.56
c360 ( 7 0 ) capacitor c=0.0180822f //x=23.275 //y=5.335
c361 ( 5 0 ) capacitor c=0.0151888f //x=22.39 //y=5.335
c362 ( 4 0 ) capacitor c=0.00859003f //x=18.62 //y=4.735
c363 ( 3 0 ) capacitor c=0.0105809f //x=18.62 //y=4.425
c364 ( 2 0 ) capacitor c=0.036971f //x=18.62 //y=4.105
r365 (  132 133 ) resistor r=32.4568 //w=0.214 //l=0.075 //layer=ply \
 //thickness=0.18 //x=18.65 //y=4.97 //x2=18.65 //y2=5.045
r366 (  130 132 ) resistor r=20.271 //w=0.214 //l=0.09 //layer=ply \
 //thickness=0.18 //x=18.65 //y=4.88 //x2=18.65 //y2=4.97
r367 (  126 127 ) resistor r=52.7279 //w=0.214 //l=0.165 //layer=ply \
 //thickness=0.18 //x=18.62 //y=2.26 //x2=18.62 //y2=2.095
r368 (  124 137 ) resistor r=45.1352 //w=0.168 //l=0.173853 //layer=ply \
 //thickness=0.18 //x=19.185 //y=1.43 //x2=19.145 //y2=1.585
r369 (  123 136 ) resistor r=45.1352 //w=0.168 //l=0.173853 //layer=ply \
 //thickness=0.18 //x=19.185 //y=1.085 //x2=19.145 //y2=0.93
r370 (  123 124 ) resistor r=176.904 //w=0.094 //l=0.345 //layer=ply \
 //thickness=0.18 //x=19.185 //y=1.085 //x2=19.185 //y2=1.43
r371 (  118 135 ) resistor r=10.701 //w=0.21 //l=0.115 //layer=ply \
 //thickness=0.18 //x=18.81 //y=1.585 //x2=18.695 //y2=1.585
r372 (  117 137 ) resistor r=5.52526 //w=0.168 //l=0.115 //layer=ply \
 //thickness=0.18 //x=19.03 //y=1.585 //x2=19.145 //y2=1.585
r373 (  116 134 ) resistor r=5.52526 //w=0.168 //l=0.115 //layer=ply \
 //thickness=0.18 //x=18.81 //y=0.93 //x2=18.695 //y2=0.93
r374 (  115 136 ) resistor r=5.52526 //w=0.168 //l=0.115 //layer=ply \
 //thickness=0.18 //x=19.03 //y=0.93 //x2=19.145 //y2=0.93
r375 (  115 116 ) resistor r=112.809 //w=0.094 //l=0.22 //layer=ply \
 //thickness=0.18 //x=19.03 //y=0.93 //x2=18.81 //y2=0.93
r376 (  114 132 ) resistor r=16.5046 //w=0.27 //l=0.135 //layer=ply \
 //thickness=0.18 //x=18.785 //y=4.97 //x2=18.65 //y2=4.97
r377 (  113 120 ) resistor r=26.9307 //w=0.15 //l=0.106066 //layer=ply \
 //thickness=0.18 //x=19.025 //y=4.97 //x2=19.1 //y2=5.045
r378 (  113 114 ) resistor r=123.064 //w=0.094 //l=0.24 //layer=ply \
 //thickness=0.18 //x=19.025 //y=4.97 //x2=18.785 //y2=4.97
r379 (  108 135 ) resistor r=39.5823 //w=0.21 //l=0.173853 //layer=ply \
 //thickness=0.18 //x=18.655 //y=1.74 //x2=18.695 //y2=1.585
r380 (  108 127 ) resistor r=182.032 //w=0.094 //l=0.355 //layer=ply \
 //thickness=0.18 //x=18.655 //y=1.74 //x2=18.655 //y2=2.095
r381 (  107 135 ) resistor r=39.5823 //w=0.21 //l=0.173853 //layer=ply \
 //thickness=0.18 //x=18.655 //y=1.43 //x2=18.695 //y2=1.585
r382 (  106 134 ) resistor r=45.1352 //w=0.168 //l=0.173853 //layer=ply \
 //thickness=0.18 //x=18.655 //y=1.085 //x2=18.695 //y2=0.93
r383 (  106 107 ) resistor r=176.904 //w=0.094 //l=0.345 //layer=ply \
 //thickness=0.18 //x=18.655 //y=1.085 //x2=18.655 //y2=1.43
r384 (  105 120 ) resistor r=592.245 //w=0.094 //l=1.155 //layer=ply \
 //thickness=0.18 //x=19.1 //y=6.2 //x2=19.1 //y2=5.045
r385 (  104 133 ) resistor r=592.245 //w=0.094 //l=1.155 //layer=ply \
 //thickness=0.18 //x=18.66 //y=6.2 //x2=18.66 //y2=5.045
r386 (  103 117 ) resistor r=56.4043 //w=0.094 //l=0.11 //layer=ply \
 //thickness=0.18 //x=18.92 //y=1.585 //x2=19.03 //y2=1.585
r387 (  103 118 ) resistor r=56.4043 //w=0.094 //l=0.11 //layer=ply \
 //thickness=0.18 //x=18.92 //y=1.585 //x2=18.81 //y2=1.585
r388 (  87 142 ) resistor r=23.615 //w=0.187 //l=0.345 //layer=li \
 //thickness=0.1 //x=23.39 //y=5.56 //x2=23.39 //y2=5.905
r389 (  79 141 ) resistor r=23.615 //w=0.187 //l=0.345 //layer=li \
 //thickness=0.1 //x=22.51 //y=5.56 //x2=22.51 //y2=5.905
r390 (  71 140 ) resistor r=23.615 //w=0.187 //l=0.345 //layer=li \
 //thickness=0.1 //x=21.63 //y=5.56 //x2=21.63 //y2=5.905
r391 (  66 130 ) resistor r=152 //w=0.17 //l=0.17 //layer=licon //count=1 \
 //x=18.65 //y=4.88 //x2=18.65 //y2=4.88
r392 (  57 126 ) resistor r=152 //w=0.17 //l=0.17 //layer=licon //count=1 \
 //x=18.62 //y=2.26 //x2=18.62 //y2=2.26
r393 (  51 53 ) resistor r=0.10734 //w=0.281 //l=0.16 //layer=m2 \
 //thickness=0.36 //x=18.615 //y=4.265 //x2=18.775 //y2=4.265
r394 (  48 55 ) resistor r=0.280717 //w=0.241 //l=0.537215 //layer=m2 \
 //thickness=0.36 //x=23.645 //y=4.27 //x2=24.165 //y2=4.235
r395 (  48 49 ) resistor r=0.329198 //w=0.131 //l=0.345 //layer=m2 \
 //thickness=0.36 //x=23.645 //y=4.27 //x2=23.3 //y2=4.27
r396 (  46 49 ) resistor r=0.1875 //w=0.17 //l=0.264811 //layer=m2 \
 //thickness=0.36 //x=23.045 //y=4.25 //x2=23.3 //y2=4.27
r397 (  46 53 ) resistor r=4.07443 //w=0.131 //l=4.27 //layer=m2 \
 //thickness=0.36 //x=23.045 //y=4.25 //x2=18.775 //y2=4.25
r398 (  43 55 ) resistor r=4.5 //w=0.15 //l=0.15 //layer=via1 //count=1 \
 //x=24.165 //y=4.235 //x2=24.165 //y2=4.235
r399 (  43 45 ) resistor r=0.00494723 //w=0.379 //l=0.015 //layer=m1 \
 //thickness=0.36 //x=24.22 //y=4.235 //x2=24.22 //y2=4.25
r400 (  41 138 ) resistor r=9.3 //w=0.17 //l=0.17 //layer=mcon //count=1 \
 //x=23.685 //y=1.19 //x2=23.685 //y2=1.19
r401 (  39 87 ) resistor r=9.3 //w=0.17 //l=0.17 //layer=mcon //count=1 \
 //x=23.39 //y=5.56 //x2=23.39 //y2=5.56
r402 (  36 79 ) resistor r=9.3 //w=0.17 //l=0.17 //layer=mcon //count=1 \
 //x=22.51 //y=5.56 //x2=22.51 //y2=5.56
r403 (  34 36 ) resistor r=0.121228 //w=0.232 //l=0.225 //layer=m1 \
 //thickness=0.36 //x=22.51 //y=5.335 //x2=22.51 //y2=5.56
r404 (  33 71 ) resistor r=9.3 //w=0.17 //l=0.17 //layer=mcon //count=1 \
 //x=21.63 //y=5.56 //x2=21.63 //y2=5.56
r405 (  31 33 ) resistor r=0.129608 //w=0.217 //l=0.225 //layer=m1 \
 //thickness=0.36 //x=21.632 //y=5.335 //x2=21.632 //y2=5.56
r406 (  30 51 ) resistor r=4.5 //w=0.15 //l=0.15 //layer=via1 //count=1 \
 //x=18.615 //y=4.265 //x2=18.615 //y2=4.265
r407 (  28 30 ) resistor r=0.00494723 //w=0.379 //l=0.015 //layer=m1 \
 //thickness=0.36 //x=18.67 //y=4.25 //x2=18.67 //y2=4.265
r408 (  26 66 ) resistor r=9.3 //w=0.17 //l=0.17 //layer=mcon //count=1 \
 //x=18.65 //y=4.88 //x2=18.65 //y2=4.88
r409 (  22 57 ) resistor r=9.3 //w=0.17 //l=0.17 //layer=mcon //count=1 \
 //x=18.62 //y=2.26 //x2=18.62 //y2=2.26
r410 (  22 24 ) resistor r=0.0936408 //w=0.196 //l=0.125 //layer=m1 \
 //thickness=0.36 //x=18.622 //y=2.26 //x2=18.622 //y2=2.385
r411 (  19 45 ) resistor r=0.0863342 //w=0.379 //l=0.168152 //layer=m1 \
 //thickness=0.36 //x=24.17 //y=4.395 //x2=24.22 //y2=4.25
r412 (  19 20 ) resistor r=0.81584 //w=0.131 //l=0.855 //layer=m1 \
 //thickness=0.36 //x=24.17 //y=4.395 //x2=24.17 //y2=5.25
r413 (  18 43 ) resistor r=0.0912814 //w=0.379 //l=0.183303 //layer=m1 \
 //thickness=0.36 //x=24.17 //y=4.075 //x2=24.22 //y2=4.235
r414 (  17 18 ) resistor r=2.04676 //w=0.131 //l=2.145 //layer=m1 \
 //thickness=0.36 //x=24.17 //y=1.93 //x2=24.17 //y2=4.075
r415 (  15 17 ) resistor r=0.0698411 //w=0.17 //l=0.120208 //layer=m1 \
 //thickness=0.36 //x=24.085 //y=1.845 //x2=24.17 //y2=1.93
r416 (  15 16 ) resistor r=0.300573 //w=0.131 //l=0.315 //layer=m1 \
 //thickness=0.36 //x=24.085 //y=1.845 //x2=23.77 //y2=1.845
r417 (  14 16 ) resistor r=0.0698411 //w=0.17 //l=0.120208 //layer=m1 \
 //thickness=0.36 //x=23.685 //y=1.76 //x2=23.77 //y2=1.845
r418 (  13 41 ) resistor r=0.0717383 //w=0.224 //l=0.115 //layer=m1 \
 //thickness=0.36 //x=23.685 //y=1.305 //x2=23.685 //y2=1.19
r419 (  13 14 ) resistor r=0.43416 //w=0.131 //l=0.455 //layer=m1 \
 //thickness=0.36 //x=23.685 //y=1.305 //x2=23.685 //y2=1.76
r420 (  12 37 ) resistor r=0.0675342 //w=0.23 //l=0.115 //layer=m1 \
 //thickness=0.36 //x=23.505 //y=5.335 //x2=23.39 //y2=5.335
r421 (  11 20 ) resistor r=0.0698411 //w=0.17 //l=0.120208 //layer=m1 \
 //thickness=0.36 //x=24.085 //y=5.335 //x2=24.17 //y2=5.25
r422 (  11 12 ) resistor r=0.553435 //w=0.131 //l=0.58 //layer=m1 \
 //thickness=0.36 //x=24.085 //y=5.335 //x2=23.505 //y2=5.335
r423 (  10 39 ) resistor r=0.00118313 //w=0.23 //layer=m1 //thickness=0.36 \
 //x=23.39 //y=5.56 //x2=23.39 //y2=5.56
r424 (  9 37 ) resistor r=0.002872 //w=0.34 //l=0.085 //layer=m1 \
 //thickness=0.36 //x=23.39 //y=5.42 //x2=23.39 //y2=5.335
r425 (  9 10 ) resistor r=0.091623 //w=0.191 //l=0.14 //layer=m1 \
 //thickness=0.36 //x=23.39 //y=5.42 //x2=23.39 //y2=5.56
r426 (  8 34 ) resistor r=0.0262263 //w=0.232 //l=0.12 //layer=m1 \
 //thickness=0.36 //x=22.63 //y=5.335 //x2=22.51 //y2=5.335
r427 (  7 37 ) resistor r=0.0675342 //w=0.23 //l=0.115 //layer=m1 \
 //thickness=0.36 //x=23.275 //y=5.335 //x2=23.39 //y2=5.335
r428 (  7 8 ) resistor r=0.615458 //w=0.131 //l=0.645 //layer=m1 \
 //thickness=0.36 //x=23.275 //y=5.335 //x2=22.63 //y2=5.335
r429 (  6 31 ) resistor r=0.0222262 //w=0.217 //l=0.118 //layer=m1 \
 //thickness=0.36 //x=21.75 //y=5.335 //x2=21.632 //y2=5.335
r430 (  5 34 ) resistor r=0.0262263 //w=0.232 //l=0.12 //layer=m1 \
 //thickness=0.36 //x=22.39 //y=5.335 //x2=22.51 //y2=5.335
r431 (  5 6 ) resistor r=0.610687 //w=0.131 //l=0.64 //layer=m1 \
 //thickness=0.36 //x=22.39 //y=5.335 //x2=21.75 //y2=5.335
r432 (  4 26 ) resistor r=0.0878548 //w=0.228 //l=0.159295 //layer=m1 \
 //thickness=0.36 //x=18.62 //y=4.735 //x2=18.65 //y2=4.88
r433 (  3 30 ) resistor r=0.0912814 //w=0.379 //l=0.183303 //layer=m1 \
 //thickness=0.36 //x=18.62 //y=4.425 //x2=18.67 //y2=4.265
r434 (  3 4 ) resistor r=0.295802 //w=0.131 //l=0.31 //layer=m1 \
 //thickness=0.36 //x=18.62 //y=4.425 //x2=18.62 //y2=4.735
r435 (  2 28 ) resistor r=0.0863342 //w=0.379 //l=0.168152 //layer=m1 \
 //thickness=0.36 //x=18.62 //y=4.105 //x2=18.67 //y2=4.25
r436 (  2 24 ) resistor r=1.64122 //w=0.131 //l=1.72 //layer=m1 \
 //thickness=0.36 //x=18.62 //y=4.105 //x2=18.62 //y2=2.385
ends PM_TMRDFFSNQNX1\%noxref_5

subckt PM_TMRDFFSNQNX1\%noxref_6 ( 3 8 9 11 12 14 15 16 17 18 19 20 21 22 23 \
 24 27 28 31 33 36 43 47 54 55 57 64 65 68 76 93 102 107 116 120 121 122 123 \
 124 125 126 127 128 129 130 132 138 139 140 141 145 146 147 148 149 151 157 \
 158 159 160 180 182 183 )
c425 ( 180 0 ) capacitor c=0.00878249f //x=26.87 //y=1.085
c426 ( 160 0 ) capacitor c=0.0612936f //x=34.435 //y=4.97
c427 ( 159 0 ) capacitor c=0.0376642f //x=34.725 //y=4.97
c428 ( 158 0 ) capacitor c=0.0346489f //x=34.39 //y=1.4
c429 ( 157 0 ) capacitor c=0.018692f //x=34.39 //y=1.055
c430 ( 151 0 ) capacitor c=0.0137077f //x=34.235 //y=1.555
c431 ( 149 0 ) capacitor c=0.0158585f //x=34.235 //y=0.9
c432 ( 148 0 ) capacitor c=0.0979511f //x=33.86 //y=2.095
c433 ( 147 0 ) capacitor c=0.0229444f //x=33.86 //y=1.71
c434 ( 146 0 ) capacitor c=0.0234359f //x=33.86 //y=1.4
c435 ( 145 0 ) capacitor c=0.019815f //x=33.86 //y=1.055
c436 ( 141 0 ) capacitor c=0.0612936f //x=29.625 //y=4.97
c437 ( 140 0 ) capacitor c=0.0376642f //x=29.915 //y=4.97
c438 ( 139 0 ) capacitor c=0.0346489f //x=29.58 //y=1.4
c439 ( 138 0 ) capacitor c=0.018692f //x=29.58 //y=1.055
c440 ( 132 0 ) capacitor c=0.0137077f //x=29.425 //y=1.555
c441 ( 130 0 ) capacitor c=0.0158585f //x=29.425 //y=0.9
c442 ( 129 0 ) capacitor c=0.099553f //x=29.05 //y=2.095
c443 ( 128 0 ) capacitor c=0.0229444f //x=29.05 //y=1.71
c444 ( 127 0 ) capacitor c=0.0234359f //x=29.05 //y=1.4
c445 ( 126 0 ) capacitor c=0.019815f //x=29.05 //y=1.055
c446 ( 125 0 ) capacitor c=0.110208f //x=34.8 //y=6.2
c447 ( 124 0 ) capacitor c=0.158957f //x=34.36 //y=6.2
c448 ( 123 0 ) capacitor c=0.110208f //x=29.99 //y=6.2
c449 ( 122 0 ) capacitor c=0.158957f //x=29.55 //y=6.2
c450 ( 116 0 ) capacitor c=0.0014751f //x=34.16 //y=4.88
c451 ( 107 0 ) capacitor c=9.93222e-19 //x=34.16 //y=2.26
c452 ( 102 0 ) capacitor c=0.0014751f //x=29.35 //y=4.88
c453 ( 93 0 ) capacitor c=9.93222e-19 //x=29.35 //y=2.26
c454 ( 76 0 ) capacitor c=0.0322017f //x=27.02 //y=5.56
c455 ( 68 0 ) capacitor c=0.0291338f //x=26.14 //y=5.56
c456 ( 65 0 ) capacitor c=0.0398037f //x=34 //y=2.775
c457 ( 64 0 ) capacitor c=6.56496e-19 //x=34.16 //y=2.775
c458 ( 57 0 ) capacitor c=6.57651e-19 //x=29.51 //y=2.77
c459 ( 55 0 ) capacitor c=8.02114e-19 //x=27.66 //y=2.77
c460 ( 54 0 ) capacitor c=0.0166477f //x=29.19 //y=2.77
c461 ( 47 0 ) capacitor c=0.0154699f //x=34.16 //y=2.77
c462 ( 43 0 ) capacitor c=0.0146914f //x=29.35 //y=2.765
c463 ( 36 0 ) capacitor c=0.0146635f //x=27.5 //y=2.77
c464 ( 33 0 ) capacitor c=0.011349f //x=27.06 //y=1.18
c465 ( 31 0 ) capacitor c=5.78613e-19 //x=27.02 //y=5.56
c466 ( 28 0 ) capacitor c=0.0108509f //x=27.02 //y=5.38
c467 ( 27 0 ) capacitor c=0.00911958f //x=26.14 //y=5.56
c468 ( 24 0 ) capacitor c=0.0606246f //x=34.16 //y=4.755
c469 ( 23 0 ) capacitor c=0.0130119f //x=34.16 //y=2.935
c470 ( 22 0 ) capacitor c=0.00415551f //x=34.16 //y=2.615
c471 ( 21 0 ) capacitor c=0.00474211f //x=34.16 //y=2.375
c472 ( 20 0 ) capacitor c=0.0635686f //x=29.35 //y=4.755
c473 ( 19 0 ) capacitor c=0.0130033f //x=29.35 //y=2.93
c474 ( 18 0 ) capacitor c=0.00452361f //x=29.35 //y=2.61
c475 ( 17 0 ) capacitor c=0.00485545f //x=29.35 //y=2.375
c476 ( 16 0 ) capacitor c=0.0661493f //x=27.5 //y=5.295
c477 ( 15 0 ) capacitor c=0.0120687f //x=27.5 //y=2.93
c478 ( 14 0 ) capacitor c=0.0175872f //x=27.5 //y=2.61
c479 ( 12 0 ) capacitor c=0.0046997f //x=27.145 //y=1.835
c480 ( 11 0 ) capacitor c=0.0117163f //x=27.415 //y=1.835
c481 ( 9 0 ) capacitor c=0.011753f //x=27.415 //y=5.38
c482 ( 8 0 ) capacitor c=0.0134844f //x=27.06 //y=1.75
c483 ( 3 0 ) capacitor c=0.0143226f //x=26.905 //y=5.38
r484 (  159 161 ) resistor r=26.9307 //w=0.15 //l=0.106066 //layer=ply \
 //thickness=0.18 //x=34.725 //y=4.97 //x2=34.8 //y2=5.045
r485 (  159 160 ) resistor r=148.702 //w=0.094 //l=0.29 //layer=ply \
 //thickness=0.18 //x=34.725 //y=4.97 //x2=34.435 //y2=4.97
r486 (  158 179 ) resistor r=45.1352 //w=0.168 //l=0.173853 //layer=ply \
 //thickness=0.18 //x=34.39 //y=1.4 //x2=34.35 //y2=1.555
r487 (  157 178 ) resistor r=45.1352 //w=0.168 //l=0.173853 //layer=ply \
 //thickness=0.18 //x=34.39 //y=1.055 //x2=34.35 //y2=0.9
r488 (  157 158 ) resistor r=176.904 //w=0.094 //l=0.345 //layer=ply \
 //thickness=0.18 //x=34.39 //y=1.055 //x2=34.39 //y2=1.4
r489 (  154 160 ) resistor r=22.7971 //w=0.269 //l=0.106066 //layer=ply \
 //thickness=0.18 //x=34.36 //y=5.045 //x2=34.435 //y2=4.97
r490 (  154 177 ) resistor r=35.8364 //w=0.269 //l=0.270185 //layer=ply \
 //thickness=0.18 //x=34.36 //y=5.045 //x2=34.16 //y2=4.88
r491 (  152 173 ) resistor r=10.701 //w=0.21 //l=0.115 //layer=ply \
 //thickness=0.18 //x=34.015 //y=1.555 //x2=33.9 //y2=1.555
r492 (  151 179 ) resistor r=5.52526 //w=0.168 //l=0.115 //layer=ply \
 //thickness=0.18 //x=34.235 //y=1.555 //x2=34.35 //y2=1.555
r493 (  150 172 ) resistor r=5.52526 //w=0.168 //l=0.115 //layer=ply \
 //thickness=0.18 //x=34.015 //y=0.9 //x2=33.9 //y2=0.9
r494 (  149 178 ) resistor r=5.52526 //w=0.168 //l=0.115 //layer=ply \
 //thickness=0.18 //x=34.235 //y=0.9 //x2=34.35 //y2=0.9
r495 (  149 150 ) resistor r=112.809 //w=0.094 //l=0.22 //layer=ply \
 //thickness=0.18 //x=34.235 //y=0.9 //x2=34.015 //y2=0.9
r496 (  148 175 ) resistor r=58.7805 //w=0.246 //l=0.373497 //layer=ply \
 //thickness=0.18 //x=33.86 //y=2.095 //x2=34.16 //y2=2.26
r497 (  147 173 ) resistor r=39.5823 //w=0.21 //l=0.173853 //layer=ply \
 //thickness=0.18 //x=33.86 //y=1.71 //x2=33.9 //y2=1.555
r498 (  147 148 ) resistor r=197.415 //w=0.094 //l=0.385 //layer=ply \
 //thickness=0.18 //x=33.86 //y=1.71 //x2=33.86 //y2=2.095
r499 (  146 173 ) resistor r=39.5823 //w=0.21 //l=0.173853 //layer=ply \
 //thickness=0.18 //x=33.86 //y=1.4 //x2=33.9 //y2=1.555
r500 (  145 172 ) resistor r=45.1352 //w=0.168 //l=0.173853 //layer=ply \
 //thickness=0.18 //x=33.86 //y=1.055 //x2=33.9 //y2=0.9
r501 (  145 146 ) resistor r=176.904 //w=0.094 //l=0.345 //layer=ply \
 //thickness=0.18 //x=33.86 //y=1.055 //x2=33.86 //y2=1.4
r502 (  140 142 ) resistor r=26.9307 //w=0.15 //l=0.106066 //layer=ply \
 //thickness=0.18 //x=29.915 //y=4.97 //x2=29.99 //y2=5.045
r503 (  140 141 ) resistor r=148.702 //w=0.094 //l=0.29 //layer=ply \
 //thickness=0.18 //x=29.915 //y=4.97 //x2=29.625 //y2=4.97
r504 (  139 171 ) resistor r=45.1352 //w=0.168 //l=0.173853 //layer=ply \
 //thickness=0.18 //x=29.58 //y=1.4 //x2=29.54 //y2=1.555
r505 (  138 170 ) resistor r=45.1352 //w=0.168 //l=0.173853 //layer=ply \
 //thickness=0.18 //x=29.58 //y=1.055 //x2=29.54 //y2=0.9
r506 (  138 139 ) resistor r=176.904 //w=0.094 //l=0.345 //layer=ply \
 //thickness=0.18 //x=29.58 //y=1.055 //x2=29.58 //y2=1.4
r507 (  135 141 ) resistor r=22.7971 //w=0.269 //l=0.106066 //layer=ply \
 //thickness=0.18 //x=29.55 //y=5.045 //x2=29.625 //y2=4.97
r508 (  135 169 ) resistor r=35.8364 //w=0.269 //l=0.270185 //layer=ply \
 //thickness=0.18 //x=29.55 //y=5.045 //x2=29.35 //y2=4.88
r509 (  133 165 ) resistor r=10.701 //w=0.21 //l=0.115 //layer=ply \
 //thickness=0.18 //x=29.205 //y=1.555 //x2=29.09 //y2=1.555
r510 (  132 171 ) resistor r=5.52526 //w=0.168 //l=0.115 //layer=ply \
 //thickness=0.18 //x=29.425 //y=1.555 //x2=29.54 //y2=1.555
r511 (  131 164 ) resistor r=5.52526 //w=0.168 //l=0.115 //layer=ply \
 //thickness=0.18 //x=29.205 //y=0.9 //x2=29.09 //y2=0.9
r512 (  130 170 ) resistor r=5.52526 //w=0.168 //l=0.115 //layer=ply \
 //thickness=0.18 //x=29.425 //y=0.9 //x2=29.54 //y2=0.9
r513 (  130 131 ) resistor r=112.809 //w=0.094 //l=0.22 //layer=ply \
 //thickness=0.18 //x=29.425 //y=0.9 //x2=29.205 //y2=0.9
r514 (  129 167 ) resistor r=58.7805 //w=0.246 //l=0.373497 //layer=ply \
 //thickness=0.18 //x=29.05 //y=2.095 //x2=29.35 //y2=2.26
r515 (  128 165 ) resistor r=39.5823 //w=0.21 //l=0.173853 //layer=ply \
 //thickness=0.18 //x=29.05 //y=1.71 //x2=29.09 //y2=1.555
r516 (  128 129 ) resistor r=197.415 //w=0.094 //l=0.385 //layer=ply \
 //thickness=0.18 //x=29.05 //y=1.71 //x2=29.05 //y2=2.095
r517 (  127 165 ) resistor r=39.5823 //w=0.21 //l=0.173853 //layer=ply \
 //thickness=0.18 //x=29.05 //y=1.4 //x2=29.09 //y2=1.555
r518 (  126 164 ) resistor r=45.1352 //w=0.168 //l=0.173853 //layer=ply \
 //thickness=0.18 //x=29.05 //y=1.055 //x2=29.09 //y2=0.9
r519 (  126 127 ) resistor r=176.904 //w=0.094 //l=0.345 //layer=ply \
 //thickness=0.18 //x=29.05 //y=1.055 //x2=29.05 //y2=1.4
r520 (  125 161 ) resistor r=592.245 //w=0.094 //l=1.155 //layer=ply \
 //thickness=0.18 //x=34.8 //y=6.2 //x2=34.8 //y2=5.045
r521 (  124 154 ) resistor r=592.245 //w=0.094 //l=1.155 //layer=ply \
 //thickness=0.18 //x=34.36 //y=6.2 //x2=34.36 //y2=5.045
r522 (  123 142 ) resistor r=592.245 //w=0.094 //l=1.155 //layer=ply \
 //thickness=0.18 //x=29.99 //y=6.2 //x2=29.99 //y2=5.045
r523 (  122 135 ) resistor r=592.245 //w=0.094 //l=1.155 //layer=ply \
 //thickness=0.18 //x=29.55 //y=6.2 //x2=29.55 //y2=5.045
r524 (  121 151 ) resistor r=56.4043 //w=0.094 //l=0.11 //layer=ply \
 //thickness=0.18 //x=34.125 //y=1.555 //x2=34.235 //y2=1.555
r525 (  121 152 ) resistor r=56.4043 //w=0.094 //l=0.11 //layer=ply \
 //thickness=0.18 //x=34.125 //y=1.555 //x2=34.015 //y2=1.555
r526 (  120 132 ) resistor r=56.4043 //w=0.094 //l=0.11 //layer=ply \
 //thickness=0.18 //x=29.315 //y=1.555 //x2=29.425 //y2=1.555
r527 (  120 133 ) resistor r=56.4043 //w=0.094 //l=0.11 //layer=ply \
 //thickness=0.18 //x=29.315 //y=1.555 //x2=29.205 //y2=1.555
r528 (  116 177 ) resistor r=152 //w=0.17 //l=0.17 //layer=licon //count=1 \
 //x=34.16 //y=4.88 //x2=34.16 //y2=4.88
r529 (  107 175 ) resistor r=152 //w=0.17 //l=0.17 //layer=licon //count=1 \
 //x=34.16 //y=2.26 //x2=34.16 //y2=2.26
r530 (  102 169 ) resistor r=152 //w=0.17 //l=0.17 //layer=licon //count=1 \
 //x=29.35 //y=4.88 //x2=29.35 //y2=4.88
r531 (  93 167 ) resistor r=152 //w=0.17 //l=0.17 //layer=licon //count=1 \
 //x=29.35 //y=2.26 //x2=29.35 //y2=2.26
r532 (  76 183 ) resistor r=23.615 //w=0.187 //l=0.345 //layer=li \
 //thickness=0.1 //x=27.02 //y=5.56 //x2=27.02 //y2=5.905
r533 (  68 182 ) resistor r=23.615 //w=0.187 //l=0.345 //layer=li \
 //thickness=0.1 //x=26.14 //y=5.56 //x2=26.14 //y2=5.905
r534 (  64 65 ) resistor r=0.10734 //w=0.281 //l=0.16 //layer=m2 \
 //thickness=0.36 //x=34.16 //y=2.775 //x2=34 //y2=2.775
r535 (  57 62 ) resistor r=0.10734 //w=0.281 //l=0.16 //layer=m2 \
 //thickness=0.36 //x=29.51 //y=2.77 //x2=29.35 //y2=2.77
r536 (  57 65 ) resistor r=4.28435 //w=0.131 //l=4.49 //layer=m2 \
 //thickness=0.36 //x=29.51 //y=2.77 //x2=34 //y2=2.77
r537 (  55 59 ) resistor r=0.10734 //w=0.281 //l=0.16 //layer=m2 \
 //thickness=0.36 //x=27.66 //y=2.77 //x2=27.5 //y2=2.77
r538 (  54 62 ) resistor r=0.10734 //w=0.281 //l=0.16 //layer=m2 \
 //thickness=0.36 //x=29.19 //y=2.77 //x2=29.35 //y2=2.77
r539 (  54 55 ) resistor r=1.45992 //w=0.131 //l=1.53 //layer=m2 \
 //thickness=0.36 //x=29.19 //y=2.77 //x2=27.66 //y2=2.77
r540 (  53 116 ) resistor r=9.3 //w=0.17 //l=0.17 //layer=mcon //count=1 \
 //x=34.16 //y=4.88 //x2=34.16 //y2=4.88
r541 (  51 107 ) resistor r=9.3 //w=0.17 //l=0.17 //layer=mcon //count=1 \
 //x=34.16 //y=2.26 //x2=34.16 //y2=2.26
r542 (  49 64 ) resistor r=4.5 //w=0.15 //l=0.15 //layer=via1 //count=1 \
 //x=34.16 //y=2.775 //x2=34.16 //y2=2.775
r543 (  47 49 ) resistor r=0.00166223 //w=0.376 //l=0.005 //layer=m1 \
 //thickness=0.36 //x=34.107 //y=2.77 //x2=34.107 //y2=2.775
r544 (  45 62 ) resistor r=4.5 //w=0.15 //l=0.15 //layer=via1 //count=1 \
 //x=29.35 //y=2.77 //x2=29.35 //y2=2.77
r545 (  43 45 ) resistor r=0.00166223 //w=0.376 //l=0.005 //layer=m1 \
 //thickness=0.36 //x=29.402 //y=2.765 //x2=29.402 //y2=2.77
r546 (  41 102 ) resistor r=9.3 //w=0.17 //l=0.17 //layer=mcon //count=1 \
 //x=29.35 //y=4.88 //x2=29.35 //y2=4.88
r547 (  39 93 ) resistor r=9.3 //w=0.17 //l=0.17 //layer=mcon //count=1 \
 //x=29.35 //y=2.26 //x2=29.35 //y2=2.26
r548 (  36 59 ) resistor r=4.5 //w=0.15 //l=0.15 //layer=via1 //count=1 \
 //x=27.5 //y=2.77 //x2=27.5 //y2=2.77
r549 (  33 180 ) resistor r=9.3 //w=0.17 //l=0.17 //layer=mcon //count=1 \
 //x=27.06 //y=1.18 //x2=27.06 //y2=1.18
r550 (  31 76 ) resistor r=9.3 //w=0.17 //l=0.17 //layer=mcon //count=1 \
 //x=27.02 //y=5.56 //x2=27.02 //y2=5.56
r551 (  28 31 ) resistor r=0.117801 //w=0.191 //l=0.18 //layer=m1 \
 //thickness=0.36 //x=27.02 //y=5.38 //x2=27.02 //y2=5.56
r552 (  27 68 ) resistor r=9.3 //w=0.17 //l=0.17 //layer=mcon //count=1 \
 //x=26.14 //y=5.56 //x2=26.14 //y2=5.56
r553 (  25 27 ) resistor r=0.10274 //w=0.219 //l=0.18 //layer=m1 \
 //thickness=0.36 //x=26.14 //y=5.38 //x2=26.14 //y2=5.56
r554 (  24 53 ) resistor r=0.0760407 //w=0.238 //l=0.125 //layer=m1 \
 //thickness=0.36 //x=34.16 //y=4.755 //x2=34.16 //y2=4.88
r555 (  23 49 ) resistor r=0.0911593 //w=0.376 //l=0.184608 //layer=m1 \
 //thickness=0.36 //x=34.16 //y=2.935 //x2=34.107 //y2=2.775
r556 (  23 24 ) resistor r=1.73664 //w=0.131 //l=1.82 //layer=m1 \
 //thickness=0.36 //x=34.16 //y=2.935 //x2=34.16 //y2=4.755
r557 (  22 47 ) resistor r=0.0894971 //w=0.376 //l=0.179555 //layer=m1 \
 //thickness=0.36 //x=34.16 //y=2.615 //x2=34.107 //y2=2.77
r558 (  21 51 ) resistor r=0.0719237 //w=0.222 //l=0.115 //layer=m1 \
 //thickness=0.36 //x=34.16 //y=2.375 //x2=34.16 //y2=2.26
r559 (  21 22 ) resistor r=0.229008 //w=0.131 //l=0.24 //layer=m1 \
 //thickness=0.36 //x=34.16 //y=2.375 //x2=34.16 //y2=2.615
r560 (  20 41 ) resistor r=0.0760407 //w=0.238 //l=0.125 //layer=m1 \
 //thickness=0.36 //x=29.35 //y=4.755 //x2=29.35 //y2=4.88
r561 (  19 45 ) resistor r=0.0911593 //w=0.376 //l=0.184174 //layer=m1 \
 //thickness=0.36 //x=29.35 //y=2.93 //x2=29.402 //y2=2.77
r562 (  19 20 ) resistor r=1.74141 //w=0.131 //l=1.825 //layer=m1 \
 //thickness=0.36 //x=29.35 //y=2.93 //x2=29.35 //y2=4.755
r563 (  18 43 ) resistor r=0.0894971 //w=0.376 //l=0.179123 //layer=m1 \
 //thickness=0.36 //x=29.35 //y=2.61 //x2=29.402 //y2=2.765
r564 (  17 39 ) resistor r=0.0719237 //w=0.222 //l=0.115 //layer=m1 \
 //thickness=0.36 //x=29.35 //y=2.375 //x2=29.35 //y2=2.26
r565 (  17 18 ) resistor r=0.224237 //w=0.131 //l=0.235 //layer=m1 \
 //thickness=0.36 //x=29.35 //y=2.375 //x2=29.35 //y2=2.61
r566 (  15 36 ) resistor r=0.0911593 //w=0.376 //l=0.184174 //layer=m1 \
 //thickness=0.36 //x=27.5 //y=2.93 //x2=27.552 //y2=2.77
r567 (  15 16 ) resistor r=2.25668 //w=0.131 //l=2.365 //layer=m1 \
 //thickness=0.36 //x=27.5 //y=2.93 //x2=27.5 //y2=5.295
r568 (  14 36 ) resistor r=0.0911593 //w=0.376 //l=0.184174 //layer=m1 \
 //thickness=0.36 //x=27.5 //y=2.61 //x2=27.552 //y2=2.77
r569 (  13 14 ) resistor r=0.658397 //w=0.131 //l=0.69 //layer=m1 \
 //thickness=0.36 //x=27.5 //y=1.92 //x2=27.5 //y2=2.61
r570 (  11 13 ) resistor r=0.0698411 //w=0.17 //l=0.120208 //layer=m1 \
 //thickness=0.36 //x=27.415 //y=1.835 //x2=27.5 //y2=1.92
r571 (  11 12 ) resistor r=0.257634 //w=0.131 //l=0.27 //layer=m1 \
 //thickness=0.36 //x=27.415 //y=1.835 //x2=27.145 //y2=1.835
r572 (  10 28 ) resistor r=0.0257089 //w=0.23 //l=0.115 //layer=m1 \
 //thickness=0.36 //x=27.135 //y=5.38 //x2=27.02 //y2=5.38
r573 (  9 16 ) resistor r=0.0698411 //w=0.17 //l=0.120208 //layer=m1 \
 //thickness=0.36 //x=27.415 //y=5.38 //x2=27.5 //y2=5.295
r574 (  9 10 ) resistor r=0.267176 //w=0.131 //l=0.28 //layer=m1 \
 //thickness=0.36 //x=27.415 //y=5.38 //x2=27.135 //y2=5.38
r575 (  8 12 ) resistor r=0.0698411 //w=0.17 //l=0.120208 //layer=m1 \
 //thickness=0.36 //x=27.06 //y=1.75 //x2=27.145 //y2=1.835
r576 (  7 33 ) resistor r=0.0913624 //w=0.191 //l=0.12 //layer=m1 \
 //thickness=0.36 //x=27.06 //y=1.3 //x2=27.06 //y2=1.18
r577 (  7 8 ) resistor r=0.429389 //w=0.131 //l=0.45 //layer=m1 \
 //thickness=0.36 //x=27.06 //y=1.3 //x2=27.06 //y2=1.75
r578 (  4 25 ) resistor r=0.0227762 //w=0.219 //l=0.115 //layer=m1 \
 //thickness=0.36 //x=26.255 //y=5.38 //x2=26.14 //y2=5.38
r579 (  3 28 ) resistor r=0.0257089 //w=0.23 //l=0.115 //layer=m1 \
 //thickness=0.36 //x=26.905 //y=5.38 //x2=27.02 //y2=5.38
r580 (  3 4 ) resistor r=0.620229 //w=0.131 //l=0.65 //layer=m1 \
 //thickness=0.36 //x=26.905 //y=5.38 //x2=26.255 //y2=5.38
ends PM_TMRDFFSNQNX1\%noxref_6

subckt PM_TMRDFFSNQNX1\%noxref_7 ( 1 3 6 7 9 10 11 12 14 15 16 18 19 21 24 27 \
 33 37 41 44 45 52 54 55 58 66 74 91 100 104 105 106 107 108 109 110 114 116 \
 119 120 130 133 135 136 137 )
c300 ( 133 0 ) capacitor c=0.00885916f //x=36.445 //y=1.095
c301 ( 130 0 ) capacitor c=0.0682508f //x=38.97 //y=4.88
c302 ( 120 0 ) capacitor c=0.0318956f //x=39.305 //y=1.39
c303 ( 119 0 ) capacitor c=0.0186809f //x=39.305 //y=1.045
c304 ( 116 0 ) capacitor c=0.0141821f //x=39.15 //y=1.545
c305 ( 114 0 ) capacitor c=0.0158553f //x=39.15 //y=0.89
c306 ( 110 0 ) capacitor c=0.0815114f //x=38.775 //y=2.095
c307 ( 109 0 ) capacitor c=0.0229235f //x=38.775 //y=1.7
c308 ( 108 0 ) capacitor c=0.0234359f //x=38.775 //y=1.39
c309 ( 107 0 ) capacitor c=0.0198759f //x=38.775 //y=1.045
c310 ( 106 0 ) capacitor c=0.110369f //x=39.31 //y=6.2
c311 ( 105 0 ) capacitor c=0.154619f //x=38.87 //y=6.2
c312 ( 100 0 ) capacitor c=8.13425e-19 //x=38.97 //y=4.88
c313 ( 91 0 ) capacitor c=5.17312e-19 //x=38.97 //y=2.26
c314 ( 74 0 ) capacitor c=0.0293219f //x=36.34 //y=5.56
c315 ( 66 0 ) capacitor c=0.029137f //x=35.46 //y=5.56
c316 ( 58 0 ) capacitor c=0.0278099f //x=34.58 //y=5.56
c317 ( 55 0 ) capacitor c=0.0156383f //x=38.805 //y=2.785
c318 ( 54 0 ) capacitor c=6.75833e-19 //x=38.965 //y=2.785
c319 ( 52 0 ) capacitor c=9.41304e-19 //x=37.28 //y=2.785
c320 ( 45 0 ) capacitor c=0.0487054f //x=38.972 //y=4.74
c321 ( 44 0 ) capacitor c=0.00631721f //x=38.97 //y=4.88
c322 ( 41 0 ) capacitor c=0.00463527f //x=38.97 //y=2.26
c323 ( 37 0 ) capacitor c=0.0145985f //x=38.97 //y=2.77
c324 ( 33 0 ) capacitor c=0.0149529f //x=37.12 //y=2.77
c325 ( 27 0 ) capacitor c=8.88597e-19 //x=36.34 //y=5.335
c326 ( 24 0 ) capacitor c=0.00796615f //x=35.46 //y=5.335
c327 ( 21 0 ) capacitor c=0.0111234f //x=34.582 //y=5.335
c328 ( 19 0 ) capacitor c=0.0120345f //x=38.97 //y=2.945
c329 ( 18 0 ) capacitor c=0.00384658f //x=38.97 //y=2.625
c330 ( 16 0 ) capacitor c=0.0629347f //x=37.12 //y=5.25
c331 ( 15 0 ) capacitor c=0.0123676f //x=37.12 //y=2.945
c332 ( 14 0 ) capacitor c=0.0168574f //x=37.12 //y=2.625
c333 ( 12 0 ) capacitor c=0.00493487f //x=36.72 //y=1.845
c334 ( 11 0 ) capacitor c=0.0126211f //x=37.035 //y=1.845
c335 ( 10 0 ) capacitor c=0.0136149f //x=36.635 //y=1.76
c336 ( 9 0 ) capacitor c=0.0113786f //x=36.635 //y=1.305
c337 ( 7 0 ) capacitor c=0.0235567f //x=37.035 //y=5.335
c338 ( 6 0 ) capacitor c=0.00906713f //x=36.34 //y=5.56
c339 ( 3 0 ) capacitor c=0.0180822f //x=36.225 //y=5.335
c340 ( 1 0 ) capacitor c=0.0152149f //x=35.34 //y=5.335
r341 (  128 130 ) resistor r=20.6867 //w=0.233 //l=0.1 //layer=ply \
 //thickness=0.18 //x=38.87 //y=4.88 //x2=38.97 //y2=4.88
r342 (  121 130 ) resistor r=70.3348 //w=0.233 //l=0.414367 //layer=ply \
 //thickness=0.18 //x=39.31 //y=5.045 //x2=38.97 //y2=4.88
r343 (  120 132 ) resistor r=45.1352 //w=0.168 //l=0.173853 //layer=ply \
 //thickness=0.18 //x=39.305 //y=1.39 //x2=39.265 //y2=1.545
r344 (  119 131 ) resistor r=45.1352 //w=0.168 //l=0.173853 //layer=ply \
 //thickness=0.18 //x=39.305 //y=1.045 //x2=39.265 //y2=0.89
r345 (  119 120 ) resistor r=176.904 //w=0.094 //l=0.345 //layer=ply \
 //thickness=0.18 //x=39.305 //y=1.045 //x2=39.305 //y2=1.39
r346 (  117 127 ) resistor r=10.701 //w=0.21 //l=0.115 //layer=ply \
 //thickness=0.18 //x=38.93 //y=1.545 //x2=38.815 //y2=1.545
r347 (  116 132 ) resistor r=5.52526 //w=0.168 //l=0.115 //layer=ply \
 //thickness=0.18 //x=39.15 //y=1.545 //x2=39.265 //y2=1.545
r348 (  115 126 ) resistor r=5.52526 //w=0.168 //l=0.115 //layer=ply \
 //thickness=0.18 //x=38.93 //y=0.89 //x2=38.815 //y2=0.89
r349 (  114 131 ) resistor r=5.52526 //w=0.168 //l=0.115 //layer=ply \
 //thickness=0.18 //x=39.15 //y=0.89 //x2=39.265 //y2=0.89
r350 (  114 115 ) resistor r=112.809 //w=0.094 //l=0.22 //layer=ply \
 //thickness=0.18 //x=39.15 //y=0.89 //x2=38.93 //y2=0.89
r351 (  111 128 ) resistor r=13.0941 //w=0.233 //l=0.165 //layer=ply \
 //thickness=0.18 //x=38.87 //y=5.045 //x2=38.87 //y2=4.88
r352 (  110 125 ) resistor r=34.8111 //w=0.27 //l=0.264953 //layer=ply \
 //thickness=0.18 //x=38.775 //y=2.095 //x2=38.97 //y2=2.26
r353 (  109 127 ) resistor r=39.5823 //w=0.21 //l=0.173853 //layer=ply \
 //thickness=0.18 //x=38.775 //y=1.7 //x2=38.815 //y2=1.545
r354 (  109 110 ) resistor r=202.543 //w=0.094 //l=0.395 //layer=ply \
 //thickness=0.18 //x=38.775 //y=1.7 //x2=38.775 //y2=2.095
r355 (  108 127 ) resistor r=39.5823 //w=0.21 //l=0.173853 //layer=ply \
 //thickness=0.18 //x=38.775 //y=1.39 //x2=38.815 //y2=1.545
r356 (  107 126 ) resistor r=45.1352 //w=0.168 //l=0.173853 //layer=ply \
 //thickness=0.18 //x=38.775 //y=1.045 //x2=38.815 //y2=0.89
r357 (  107 108 ) resistor r=176.904 //w=0.094 //l=0.345 //layer=ply \
 //thickness=0.18 //x=38.775 //y=1.045 //x2=38.775 //y2=1.39
r358 (  106 121 ) resistor r=592.245 //w=0.094 //l=1.155 //layer=ply \
 //thickness=0.18 //x=39.31 //y=6.2 //x2=39.31 //y2=5.045
r359 (  105 111 ) resistor r=592.245 //w=0.094 //l=1.155 //layer=ply \
 //thickness=0.18 //x=38.87 //y=6.2 //x2=38.87 //y2=5.045
r360 (  104 116 ) resistor r=56.4043 //w=0.094 //l=0.11 //layer=ply \
 //thickness=0.18 //x=39.04 //y=1.545 //x2=39.15 //y2=1.545
r361 (  104 117 ) resistor r=56.4043 //w=0.094 //l=0.11 //layer=ply \
 //thickness=0.18 //x=39.04 //y=1.545 //x2=38.93 //y2=1.545
r362 (  100 130 ) resistor r=152 //w=0.17 //l=0.17 //layer=licon //count=1 \
 //x=38.97 //y=4.88 //x2=38.97 //y2=4.88
r363 (  91 125 ) resistor r=152 //w=0.17 //l=0.17 //layer=licon //count=1 \
 //x=38.97 //y=2.26 //x2=38.97 //y2=2.26
r364 (  74 137 ) resistor r=23.615 //w=0.187 //l=0.345 //layer=li \
 //thickness=0.1 //x=36.34 //y=5.56 //x2=36.34 //y2=5.905
r365 (  66 136 ) resistor r=23.615 //w=0.187 //l=0.345 //layer=li \
 //thickness=0.1 //x=35.46 //y=5.56 //x2=35.46 //y2=5.905
r366 (  58 135 ) resistor r=23.615 //w=0.187 //l=0.345 //layer=li \
 //thickness=0.1 //x=34.58 //y=5.56 //x2=34.58 //y2=5.905
r367 (  54 55 ) resistor r=0.10734 //w=0.281 //l=0.16 //layer=m2 \
 //thickness=0.36 //x=38.965 //y=2.785 //x2=38.805 //y2=2.785
r368 (  52 55 ) resistor r=1.45515 //w=0.131 //l=1.525 //layer=m2 \
 //thickness=0.36 //x=37.28 //y=2.77 //x2=38.805 //y2=2.77
r369 (  50 52 ) resistor r=0.10734 //w=0.281 //l=0.16 //layer=m2 \
 //thickness=0.36 //x=37.12 //y=2.785 //x2=37.28 //y2=2.785
r370 (  44 100 ) resistor r=9.3 //w=0.17 //l=0.17 //layer=mcon //count=1 \
 //x=38.97 //y=4.88 //x2=38.97 //y2=4.88
r371 (  44 45 ) resistor r=0.103207 //w=0.196 //l=0.14 //layer=m1 \
 //thickness=0.36 //x=38.972 //y=4.88 //x2=38.972 //y2=4.74
r372 (  41 91 ) resistor r=9.3 //w=0.17 //l=0.17 //layer=mcon //count=1 \
 //x=38.97 //y=2.26 //x2=38.97 //y2=2.26
r373 (  39 54 ) resistor r=4.5 //w=0.15 //l=0.15 //layer=via1 //count=1 \
 //x=38.965 //y=2.785 //x2=38.965 //y2=2.785
r374 (  37 39 ) resistor r=0.00501337 //w=0.374 //l=0.015 //layer=m1 \
 //thickness=0.36 //x=38.915 //y=2.77 //x2=38.915 //y2=2.785
r375 (  35 50 ) resistor r=4.5 //w=0.15 //l=0.15 //layer=via1 //count=1 \
 //x=37.12 //y=2.785 //x2=37.12 //y2=2.785
r376 (  33 35 ) resistor r=0.0049867 //w=0.376 //l=0.015 //layer=m1 \
 //thickness=0.36 //x=37.172 //y=2.77 //x2=37.172 //y2=2.785
r377 (  31 133 ) resistor r=9.3 //w=0.17 //l=0.17 //layer=mcon //count=1 \
 //x=36.635 //y=1.19 //x2=36.635 //y2=1.19
r378 (  29 74 ) resistor r=9.3 //w=0.17 //l=0.17 //layer=mcon //count=1 \
 //x=36.34 //y=5.56 //x2=36.34 //y2=5.56
r379 (  26 66 ) resistor r=9.3 //w=0.17 //l=0.17 //layer=mcon //count=1 \
 //x=35.46 //y=5.56 //x2=35.46 //y2=5.56
r380 (  24 26 ) resistor r=0.121228 //w=0.232 //l=0.225 //layer=m1 \
 //thickness=0.36 //x=35.46 //y=5.335 //x2=35.46 //y2=5.56
r381 (  23 58 ) resistor r=9.3 //w=0.17 //l=0.17 //layer=mcon //count=1 \
 //x=34.58 //y=5.56 //x2=34.58 //y2=5.56
r382 (  21 23 ) resistor r=0.129608 //w=0.217 //l=0.225 //layer=m1 \
 //thickness=0.36 //x=34.582 //y=5.335 //x2=34.582 //y2=5.56
r383 (  19 39 ) resistor r=0.0910802 //w=0.374 //l=0.185472 //layer=m1 \
 //thickness=0.36 //x=38.97 //y=2.945 //x2=38.915 //y2=2.785
r384 (  19 45 ) resistor r=1.71279 //w=0.131 //l=1.795 //layer=m1 \
 //thickness=0.36 //x=38.97 //y=2.945 //x2=38.97 //y2=4.74
r385 (  18 37 ) resistor r=0.0860668 //w=0.374 //l=0.170294 //layer=m1 \
 //thickness=0.36 //x=38.97 //y=2.625 //x2=38.915 //y2=2.77
r386 (  17 41 ) resistor r=0.0933015 //w=0.201 //l=0.125 //layer=m1 \
 //thickness=0.36 //x=38.97 //y=2.385 //x2=38.97 //y2=2.26
r387 (  17 18 ) resistor r=0.229008 //w=0.131 //l=0.24 //layer=m1 \
 //thickness=0.36 //x=38.97 //y=2.385 //x2=38.97 //y2=2.625
r388 (  15 35 ) resistor r=0.0911593 //w=0.376 //l=0.184174 //layer=m1 \
 //thickness=0.36 //x=37.12 //y=2.945 //x2=37.172 //y2=2.785
r389 (  15 16 ) resistor r=2.19943 //w=0.131 //l=2.305 //layer=m1 \
 //thickness=0.36 //x=37.12 //y=2.945 //x2=37.12 //y2=5.25
r390 (  14 33 ) resistor r=0.0861726 //w=0.376 //l=0.169012 //layer=m1 \
 //thickness=0.36 //x=37.12 //y=2.625 //x2=37.172 //y2=2.77
r391 (  13 14 ) resistor r=0.663168 //w=0.131 //l=0.695 //layer=m1 \
 //thickness=0.36 //x=37.12 //y=1.93 //x2=37.12 //y2=2.625
r392 (  11 13 ) resistor r=0.0698411 //w=0.17 //l=0.120208 //layer=m1 \
 //thickness=0.36 //x=37.035 //y=1.845 //x2=37.12 //y2=1.93
r393 (  11 12 ) resistor r=0.300573 //w=0.131 //l=0.315 //layer=m1 \
 //thickness=0.36 //x=37.035 //y=1.845 //x2=36.72 //y2=1.845
r394 (  10 12 ) resistor r=0.0698411 //w=0.17 //l=0.120208 //layer=m1 \
 //thickness=0.36 //x=36.635 //y=1.76 //x2=36.72 //y2=1.845
r395 (  9 31 ) resistor r=0.0717383 //w=0.224 //l=0.115 //layer=m1 \
 //thickness=0.36 //x=36.635 //y=1.305 //x2=36.635 //y2=1.19
r396 (  9 10 ) resistor r=0.43416 //w=0.131 //l=0.455 //layer=m1 \
 //thickness=0.36 //x=36.635 //y=1.305 //x2=36.635 //y2=1.76
r397 (  8 27 ) resistor r=0.0675342 //w=0.23 //l=0.115 //layer=m1 \
 //thickness=0.36 //x=36.455 //y=5.335 //x2=36.34 //y2=5.335
r398 (  7 16 ) resistor r=0.0698411 //w=0.17 //l=0.120208 //layer=m1 \
 //thickness=0.36 //x=37.035 //y=5.335 //x2=37.12 //y2=5.25
r399 (  7 8 ) resistor r=0.553435 //w=0.131 //l=0.58 //layer=m1 \
 //thickness=0.36 //x=37.035 //y=5.335 //x2=36.455 //y2=5.335
r400 (  6 29 ) resistor r=0.00118313 //w=0.23 //layer=m1 //thickness=0.36 \
 //x=36.34 //y=5.56 //x2=36.34 //y2=5.56
r401 (  5 27 ) resistor r=0.002872 //w=0.34 //l=0.085 //layer=m1 \
 //thickness=0.36 //x=36.34 //y=5.42 //x2=36.34 //y2=5.335
r402 (  5 6 ) resistor r=0.091623 //w=0.191 //l=0.14 //layer=m1 \
 //thickness=0.36 //x=36.34 //y=5.42 //x2=36.34 //y2=5.56
r403 (  4 24 ) resistor r=0.0262263 //w=0.232 //l=0.12 //layer=m1 \
 //thickness=0.36 //x=35.58 //y=5.335 //x2=35.46 //y2=5.335
r404 (  3 27 ) resistor r=0.0675342 //w=0.23 //l=0.115 //layer=m1 \
 //thickness=0.36 //x=36.225 //y=5.335 //x2=36.34 //y2=5.335
r405 (  3 4 ) resistor r=0.615458 //w=0.131 //l=0.645 //layer=m1 \
 //thickness=0.36 //x=36.225 //y=5.335 //x2=35.58 //y2=5.335
r406 (  2 21 ) resistor r=0.0222262 //w=0.217 //l=0.118 //layer=m1 \
 //thickness=0.36 //x=34.7 //y=5.335 //x2=34.582 //y2=5.335
r407 (  1 24 ) resistor r=0.0262263 //w=0.232 //l=0.12 //layer=m1 \
 //thickness=0.36 //x=35.34 //y=5.335 //x2=35.46 //y2=5.335
r408 (  1 2 ) resistor r=0.610687 //w=0.131 //l=0.64 //layer=m1 \
 //thickness=0.36 //x=35.34 //y=5.335 //x2=34.7 //y2=5.335
ends PM_TMRDFFSNQNX1\%noxref_7

subckt PM_TMRDFFSNQNX1\%noxref_8 ( 2 3 4 5 7 10 11 13 14 15 16 18 19 20 22 23 \
 26 34 35 38 41 47 50 54 57 58 60 63 67 71 72 75 84 89 97 105 122 131 135 136 \
 137 138 139 140 141 142 143 148 150 152 158 159 160 161 162 163 167 169 172 \
 173 178 179 182 196 199 201 202 203 )
c497 ( 199 0 ) capacitor c=0.00885916f //x=31.635 //y=1.095
c498 ( 196 0 ) capacitor c=0.0634117f //x=42.3 //y=4.88
c499 ( 182 0 ) capacitor c=0.0354953f //x=26.79 //y=4.88
c500 ( 179 0 ) capacitor c=0.0284095f //x=26.76 //y=2.095
c501 ( 178 0 ) capacitor c=0.0476356f //x=26.76 //y=2.26
c502 ( 173 0 ) capacitor c=0.0318956f //x=42.635 //y=1.39
c503 ( 172 0 ) capacitor c=0.0186809f //x=42.635 //y=1.045
c504 ( 169 0 ) capacitor c=0.0141821f //x=42.48 //y=1.545
c505 ( 167 0 ) capacitor c=0.0158553f //x=42.48 //y=0.89
c506 ( 163 0 ) capacitor c=0.088055f //x=42.105 //y=2.095
c507 ( 162 0 ) capacitor c=0.0229235f //x=42.105 //y=1.7
c508 ( 161 0 ) capacitor c=0.0234359f //x=42.105 //y=1.39
c509 ( 160 0 ) capacitor c=0.0198759f //x=42.105 //y=1.045
c510 ( 159 0 ) capacitor c=0.0439708f //x=27.325 //y=1.43
c511 ( 158 0 ) capacitor c=0.0192582f //x=27.325 //y=1.085
c512 ( 152 0 ) capacitor c=0.0162526f //x=27.17 //y=1.585
c513 ( 150 0 ) capacitor c=0.0157807f //x=27.17 //y=0.93
c514 ( 148 0 ) capacitor c=0.0357885f //x=27.165 //y=4.97
c515 ( 143 0 ) capacitor c=0.0210762f //x=26.795 //y=1.74
c516 ( 142 0 ) capacitor c=0.0168511f //x=26.795 //y=1.43
c517 ( 141 0 ) capacitor c=0.0175485f //x=26.795 //y=1.085
c518 ( 140 0 ) capacitor c=0.110369f //x=42.64 //y=6.2
c519 ( 139 0 ) capacitor c=0.154619f //x=42.2 //y=6.2
c520 ( 138 0 ) capacitor c=0.155269f //x=27.24 //y=6.2
c521 ( 137 0 ) capacitor c=0.110375f //x=26.8 //y=6.2
c522 ( 131 0 ) capacitor c=6.19917e-19 //x=42.3 //y=4.88
c523 ( 122 0 ) capacitor c=7.85889e-19 //x=42.3 //y=2.26
c524 ( 105 0 ) capacitor c=0.0293709f //x=31.53 //y=5.56
c525 ( 97 0 ) capacitor c=0.029137f //x=30.65 //y=5.56
c526 ( 89 0 ) capacitor c=0.0277605f //x=29.77 //y=5.56
c527 ( 84 0 ) capacitor c=5.80994e-19 //x=26.79 //y=4.88
c528 ( 75 0 ) capacitor c=5.78095e-19 //x=26.76 //y=2.26
c529 ( 72 0 ) capacitor c=0.0941234f //x=42.14 //y=4.265
c530 ( 71 0 ) capacitor c=7.98142e-19 //x=42.3 //y=4.265
c531 ( 67 0 ) capacitor c=7.93125e-19 //x=26.92 //y=4.245
c532 ( 63 0 ) capacitor c=9.81648e-19 //x=32.465 //y=4.25
c533 ( 60 0 ) capacitor c=0.0589422f //x=32.145 //y=4.25
c534 ( 58 0 ) capacitor c=0.00571667f //x=42.302 //y=4.74
c535 ( 57 0 ) capacitor c=0.00511243f //x=42.3 //y=4.88
c536 ( 54 0 ) capacitor c=0.00463527f //x=42.3 //y=2.26
c537 ( 50 0 ) capacitor c=0.0134746f //x=42.3 //y=4.25
c538 ( 47 0 ) capacitor c=0.0149922f //x=32.305 //y=4.25
c539 ( 41 0 ) capacitor c=8.88597e-19 //x=31.53 //y=5.335
c540 ( 38 0 ) capacitor c=0.0073827f //x=30.65 //y=5.335
c541 ( 35 0 ) capacitor c=0.0112819f //x=29.772 //y=5.335
c542 ( 34 0 ) capacitor c=0.0152963f //x=26.76 //y=4.25
c543 ( 26 0 ) capacitor c=0.00504845f //x=26.76 //y=2.26
c544 ( 23 0 ) capacitor c=0.0119701f //x=42.3 //y=4.425
c545 ( 22 0 ) capacitor c=0.0457453f //x=42.3 //y=4.105
c546 ( 20 0 ) capacitor c=0.0222419f //x=32.31 //y=5.25
c547 ( 19 0 ) capacitor c=0.0128722f //x=32.31 //y=4.41
c548 ( 18 0 ) capacitor c=0.0593722f //x=32.31 //y=4.09
c549 ( 16 0 ) capacitor c=0.0048771f //x=31.91 //y=1.845
c550 ( 15 0 ) capacitor c=0.0132264f //x=32.225 //y=1.845
c551 ( 14 0 ) capacitor c=0.0167333f //x=31.825 //y=1.76
c552 ( 13 0 ) capacitor c=0.0111164f //x=31.825 //y=1.305
c553 ( 11 0 ) capacitor c=0.0223199f //x=32.225 //y=5.335
c554 ( 10 0 ) capacitor c=0.00933983f //x=31.53 //y=5.56
c555 ( 7 0 ) capacitor c=0.019596f //x=31.415 //y=5.335
c556 ( 5 0 ) capacitor c=0.0147581f //x=30.53 //y=5.335
c557 ( 4 0 ) capacitor c=0.00931067f //x=26.76 //y=4.735
c558 ( 3 0 ) capacitor c=0.0102157f //x=26.76 //y=4.405
c559 ( 2 0 ) capacitor c=0.0364749f //x=26.76 //y=4.085
r560 (  194 196 ) resistor r=20.6867 //w=0.233 //l=0.1 //layer=ply \
 //thickness=0.18 //x=42.2 //y=4.88 //x2=42.3 //y2=4.88
r561 (  184 185 ) resistor r=32.4568 //w=0.214 //l=0.075 //layer=ply \
 //thickness=0.18 //x=26.79 //y=4.97 //x2=26.79 //y2=5.045
r562 (  182 184 ) resistor r=20.271 //w=0.214 //l=0.09 //layer=ply \
 //thickness=0.18 //x=26.79 //y=4.88 //x2=26.79 //y2=4.97
r563 (  178 179 ) resistor r=52.7279 //w=0.214 //l=0.165 //layer=ply \
 //thickness=0.18 //x=26.76 //y=2.26 //x2=26.76 //y2=2.095
r564 (  174 196 ) resistor r=70.3348 //w=0.233 //l=0.414367 //layer=ply \
 //thickness=0.18 //x=42.64 //y=5.045 //x2=42.3 //y2=4.88
r565 (  173 198 ) resistor r=45.1352 //w=0.168 //l=0.173853 //layer=ply \
 //thickness=0.18 //x=42.635 //y=1.39 //x2=42.595 //y2=1.545
r566 (  172 197 ) resistor r=45.1352 //w=0.168 //l=0.173853 //layer=ply \
 //thickness=0.18 //x=42.635 //y=1.045 //x2=42.595 //y2=0.89
r567 (  172 173 ) resistor r=176.904 //w=0.094 //l=0.345 //layer=ply \
 //thickness=0.18 //x=42.635 //y=1.045 //x2=42.635 //y2=1.39
r568 (  170 193 ) resistor r=10.701 //w=0.21 //l=0.115 //layer=ply \
 //thickness=0.18 //x=42.26 //y=1.545 //x2=42.145 //y2=1.545
r569 (  169 198 ) resistor r=5.52526 //w=0.168 //l=0.115 //layer=ply \
 //thickness=0.18 //x=42.48 //y=1.545 //x2=42.595 //y2=1.545
r570 (  168 192 ) resistor r=5.52526 //w=0.168 //l=0.115 //layer=ply \
 //thickness=0.18 //x=42.26 //y=0.89 //x2=42.145 //y2=0.89
r571 (  167 197 ) resistor r=5.52526 //w=0.168 //l=0.115 //layer=ply \
 //thickness=0.18 //x=42.48 //y=0.89 //x2=42.595 //y2=0.89
r572 (  167 168 ) resistor r=112.809 //w=0.094 //l=0.22 //layer=ply \
 //thickness=0.18 //x=42.48 //y=0.89 //x2=42.26 //y2=0.89
r573 (  164 194 ) resistor r=13.0941 //w=0.233 //l=0.165 //layer=ply \
 //thickness=0.18 //x=42.2 //y=5.045 //x2=42.2 //y2=4.88
r574 (  163 191 ) resistor r=34.8111 //w=0.27 //l=0.264953 //layer=ply \
 //thickness=0.18 //x=42.105 //y=2.095 //x2=42.3 //y2=2.26
r575 (  162 193 ) resistor r=39.5823 //w=0.21 //l=0.173853 //layer=ply \
 //thickness=0.18 //x=42.105 //y=1.7 //x2=42.145 //y2=1.545
r576 (  162 163 ) resistor r=202.543 //w=0.094 //l=0.395 //layer=ply \
 //thickness=0.18 //x=42.105 //y=1.7 //x2=42.105 //y2=2.095
r577 (  161 193 ) resistor r=39.5823 //w=0.21 //l=0.173853 //layer=ply \
 //thickness=0.18 //x=42.105 //y=1.39 //x2=42.145 //y2=1.545
r578 (  160 192 ) resistor r=45.1352 //w=0.168 //l=0.173853 //layer=ply \
 //thickness=0.18 //x=42.105 //y=1.045 //x2=42.145 //y2=0.89
r579 (  160 161 ) resistor r=176.904 //w=0.094 //l=0.345 //layer=ply \
 //thickness=0.18 //x=42.105 //y=1.045 //x2=42.105 //y2=1.39
r580 (  159 189 ) resistor r=45.1352 //w=0.168 //l=0.173853 //layer=ply \
 //thickness=0.18 //x=27.325 //y=1.43 //x2=27.285 //y2=1.585
r581 (  158 188 ) resistor r=45.1352 //w=0.168 //l=0.173853 //layer=ply \
 //thickness=0.18 //x=27.325 //y=1.085 //x2=27.285 //y2=0.93
r582 (  158 159 ) resistor r=176.904 //w=0.094 //l=0.345 //layer=ply \
 //thickness=0.18 //x=27.325 //y=1.085 //x2=27.325 //y2=1.43
r583 (  153 187 ) resistor r=10.701 //w=0.21 //l=0.115 //layer=ply \
 //thickness=0.18 //x=26.95 //y=1.585 //x2=26.835 //y2=1.585
r584 (  152 189 ) resistor r=5.52526 //w=0.168 //l=0.115 //layer=ply \
 //thickness=0.18 //x=27.17 //y=1.585 //x2=27.285 //y2=1.585
r585 (  151 186 ) resistor r=5.52526 //w=0.168 //l=0.115 //layer=ply \
 //thickness=0.18 //x=26.95 //y=0.93 //x2=26.835 //y2=0.93
r586 (  150 188 ) resistor r=5.52526 //w=0.168 //l=0.115 //layer=ply \
 //thickness=0.18 //x=27.17 //y=0.93 //x2=27.285 //y2=0.93
r587 (  150 151 ) resistor r=112.809 //w=0.094 //l=0.22 //layer=ply \
 //thickness=0.18 //x=27.17 //y=0.93 //x2=26.95 //y2=0.93
r588 (  149 184 ) resistor r=16.5046 //w=0.27 //l=0.135 //layer=ply \
 //thickness=0.18 //x=26.925 //y=4.97 //x2=26.79 //y2=4.97
r589 (  148 155 ) resistor r=26.9307 //w=0.15 //l=0.106066 //layer=ply \
 //thickness=0.18 //x=27.165 //y=4.97 //x2=27.24 //y2=5.045
r590 (  148 149 ) resistor r=123.064 //w=0.094 //l=0.24 //layer=ply \
 //thickness=0.18 //x=27.165 //y=4.97 //x2=26.925 //y2=4.97
r591 (  143 187 ) resistor r=39.5823 //w=0.21 //l=0.173853 //layer=ply \
 //thickness=0.18 //x=26.795 //y=1.74 //x2=26.835 //y2=1.585
r592 (  143 179 ) resistor r=182.032 //w=0.094 //l=0.355 //layer=ply \
 //thickness=0.18 //x=26.795 //y=1.74 //x2=26.795 //y2=2.095
r593 (  142 187 ) resistor r=39.5823 //w=0.21 //l=0.173853 //layer=ply \
 //thickness=0.18 //x=26.795 //y=1.43 //x2=26.835 //y2=1.585
r594 (  141 186 ) resistor r=45.1352 //w=0.168 //l=0.173853 //layer=ply \
 //thickness=0.18 //x=26.795 //y=1.085 //x2=26.835 //y2=0.93
r595 (  141 142 ) resistor r=176.904 //w=0.094 //l=0.345 //layer=ply \
 //thickness=0.18 //x=26.795 //y=1.085 //x2=26.795 //y2=1.43
r596 (  140 174 ) resistor r=592.245 //w=0.094 //l=1.155 //layer=ply \
 //thickness=0.18 //x=42.64 //y=6.2 //x2=42.64 //y2=5.045
r597 (  139 164 ) resistor r=592.245 //w=0.094 //l=1.155 //layer=ply \
 //thickness=0.18 //x=42.2 //y=6.2 //x2=42.2 //y2=5.045
r598 (  138 155 ) resistor r=592.245 //w=0.094 //l=1.155 //layer=ply \
 //thickness=0.18 //x=27.24 //y=6.2 //x2=27.24 //y2=5.045
r599 (  137 185 ) resistor r=592.245 //w=0.094 //l=1.155 //layer=ply \
 //thickness=0.18 //x=26.8 //y=6.2 //x2=26.8 //y2=5.045
r600 (  136 169 ) resistor r=56.4043 //w=0.094 //l=0.11 //layer=ply \
 //thickness=0.18 //x=42.37 //y=1.545 //x2=42.48 //y2=1.545
r601 (  136 170 ) resistor r=56.4043 //w=0.094 //l=0.11 //layer=ply \
 //thickness=0.18 //x=42.37 //y=1.545 //x2=42.26 //y2=1.545
r602 (  135 152 ) resistor r=56.4043 //w=0.094 //l=0.11 //layer=ply \
 //thickness=0.18 //x=27.06 //y=1.585 //x2=27.17 //y2=1.585
r603 (  135 153 ) resistor r=56.4043 //w=0.094 //l=0.11 //layer=ply \
 //thickness=0.18 //x=27.06 //y=1.585 //x2=26.95 //y2=1.585
r604 (  131 196 ) resistor r=152 //w=0.17 //l=0.17 //layer=licon //count=1 \
 //x=42.3 //y=4.88 //x2=42.3 //y2=4.88
r605 (  122 191 ) resistor r=152 //w=0.17 //l=0.17 //layer=licon //count=1 \
 //x=42.3 //y=2.26 //x2=42.3 //y2=2.26
r606 (  105 203 ) resistor r=23.615 //w=0.187 //l=0.345 //layer=li \
 //thickness=0.1 //x=31.53 //y=5.56 //x2=31.53 //y2=5.905
r607 (  97 202 ) resistor r=23.615 //w=0.187 //l=0.345 //layer=li \
 //thickness=0.1 //x=30.65 //y=5.56 //x2=30.65 //y2=5.905
r608 (  89 201 ) resistor r=23.615 //w=0.187 //l=0.345 //layer=li \
 //thickness=0.1 //x=29.77 //y=5.56 //x2=29.77 //y2=5.905
r609 (  84 182 ) resistor r=152 //w=0.17 //l=0.17 //layer=licon //count=1 \
 //x=26.79 //y=4.88 //x2=26.79 //y2=4.88
r610 (  75 178 ) resistor r=152 //w=0.17 //l=0.17 //layer=licon //count=1 \
 //x=26.76 //y=2.26 //x2=26.76 //y2=2.26
r611 (  71 72 ) resistor r=0.10734 //w=0.281 //l=0.16 //layer=m2 \
 //thickness=0.36 //x=42.3 //y=4.265 //x2=42.14 //y2=4.265
r612 (  65 67 ) resistor r=0.10734 //w=0.281 //l=0.16 //layer=m2 \
 //thickness=0.36 //x=26.76 //y=4.245 //x2=26.92 //y2=4.245
r613 (  63 69 ) resistor r=0.10734 //w=0.281 //l=0.16 //layer=m2 \
 //thickness=0.36 //x=32.465 //y=4.25 //x2=32.305 //y2=4.25
r614 (  63 72 ) resistor r=9.23187 //w=0.131 //l=9.675 //layer=m2 \
 //thickness=0.36 //x=32.465 //y=4.25 //x2=42.14 //y2=4.25
r615 (  60 69 ) resistor r=0.10734 //w=0.281 //l=0.16 //layer=m2 \
 //thickness=0.36 //x=32.145 //y=4.25 //x2=32.305 //y2=4.25
r616 (  60 67 ) resistor r=4.98569 //w=0.131 //l=5.225 //layer=m2 \
 //thickness=0.36 //x=32.145 //y=4.25 //x2=26.92 //y2=4.25
r617 (  57 131 ) resistor r=9.3 //w=0.17 //l=0.17 //layer=mcon //count=1 \
 //x=42.3 //y=4.88 //x2=42.3 //y2=4.88
r618 (  57 58 ) resistor r=0.103207 //w=0.196 //l=0.14 //layer=m1 \
 //thickness=0.36 //x=42.302 //y=4.88 //x2=42.302 //y2=4.74
r619 (  54 122 ) resistor r=9.3 //w=0.17 //l=0.17 //layer=mcon //count=1 \
 //x=42.3 //y=2.26 //x2=42.3 //y2=2.26
r620 (  52 71 ) resistor r=4.5 //w=0.15 //l=0.15 //layer=via1 //count=1 \
 //x=42.3 //y=4.265 //x2=42.3 //y2=4.265
r621 (  50 52 ) resistor r=0.0049867 //w=0.376 //l=0.015 //layer=m1 \
 //thickness=0.36 //x=42.247 //y=4.25 //x2=42.247 //y2=4.265
r622 (  47 69 ) resistor r=4.5 //w=0.15 //l=0.15 //layer=via1 //count=1 \
 //x=32.305 //y=4.25 //x2=32.305 //y2=4.25
r623 (  45 199 ) resistor r=9.3 //w=0.17 //l=0.17 //layer=mcon //count=1 \
 //x=31.825 //y=1.19 //x2=31.825 //y2=1.19
r624 (  43 105 ) resistor r=9.3 //w=0.17 //l=0.17 //layer=mcon //count=1 \
 //x=31.53 //y=5.56 //x2=31.53 //y2=5.56
r625 (  40 97 ) resistor r=9.3 //w=0.17 //l=0.17 //layer=mcon //count=1 \
 //x=30.65 //y=5.56 //x2=30.65 //y2=5.56
r626 (  38 40 ) resistor r=0.121228 //w=0.232 //l=0.225 //layer=m1 \
 //thickness=0.36 //x=30.65 //y=5.335 //x2=30.65 //y2=5.56
r627 (  37 89 ) resistor r=9.3 //w=0.17 //l=0.17 //layer=mcon //count=1 \
 //x=29.77 //y=5.56 //x2=29.77 //y2=5.56
r628 (  35 37 ) resistor r=0.129608 //w=0.217 //l=0.225 //layer=m1 \
 //thickness=0.36 //x=29.772 //y=5.335 //x2=29.772 //y2=5.56
r629 (  32 65 ) resistor r=4.5 //w=0.15 //l=0.15 //layer=via1 //count=1 \
 //x=26.76 //y=4.245 //x2=26.76 //y2=4.245
r630 (  32 34 ) resistor r=0.00166223 //w=0.376 //l=0.005 //layer=m1 \
 //thickness=0.36 //x=26.812 //y=4.245 //x2=26.812 //y2=4.25
r631 (  30 84 ) resistor r=9.3 //w=0.17 //l=0.17 //layer=mcon //count=1 \
 //x=26.79 //y=4.88 //x2=26.79 //y2=4.88
r632 (  26 75 ) resistor r=9.3 //w=0.17 //l=0.17 //layer=mcon //count=1 \
 //x=26.76 //y=2.26 //x2=26.76 //y2=2.26
r633 (  26 28 ) resistor r=0.0936408 //w=0.196 //l=0.125 //layer=m1 \
 //thickness=0.36 //x=26.762 //y=2.26 //x2=26.762 //y2=2.385
r634 (  23 52 ) resistor r=0.0911593 //w=0.376 //l=0.184608 //layer=m1 \
 //thickness=0.36 //x=42.3 //y=4.425 //x2=42.247 //y2=4.265
r635 (  23 58 ) resistor r=0.300573 //w=0.131 //l=0.315 //layer=m1 \
 //thickness=0.36 //x=42.3 //y=4.425 //x2=42.3 //y2=4.74
r636 (  22 50 ) resistor r=0.0861726 //w=0.376 //l=0.16944 //layer=m1 \
 //thickness=0.36 //x=42.3 //y=4.105 //x2=42.247 //y2=4.25
r637 (  21 54 ) resistor r=0.0933015 //w=0.201 //l=0.125 //layer=m1 \
 //thickness=0.36 //x=42.3 //y=2.385 //x2=42.3 //y2=2.26
r638 (  21 22 ) resistor r=1.64122 //w=0.131 //l=1.72 //layer=m1 \
 //thickness=0.36 //x=42.3 //y=2.385 //x2=42.3 //y2=4.105
r639 (  19 47 ) resistor r=0.0911593 //w=0.376 //l=0.181989 //layer=m1 \
 //thickness=0.36 //x=32.31 //y=4.41 //x2=32.357 //y2=4.25
r640 (  19 20 ) resistor r=0.801527 //w=0.131 //l=0.84 //layer=m1 \
 //thickness=0.36 //x=32.31 //y=4.41 //x2=32.31 //y2=5.25
r641 (  18 47 ) resistor r=0.0911593 //w=0.376 //l=0.181989 //layer=m1 \
 //thickness=0.36 //x=32.31 //y=4.09 //x2=32.357 //y2=4.25
r642 (  17 18 ) resistor r=2.06107 //w=0.131 //l=2.16 //layer=m1 \
 //thickness=0.36 //x=32.31 //y=1.93 //x2=32.31 //y2=4.09
r643 (  15 17 ) resistor r=0.0698411 //w=0.17 //l=0.120208 //layer=m1 \
 //thickness=0.36 //x=32.225 //y=1.845 //x2=32.31 //y2=1.93
r644 (  15 16 ) resistor r=0.300573 //w=0.131 //l=0.315 //layer=m1 \
 //thickness=0.36 //x=32.225 //y=1.845 //x2=31.91 //y2=1.845
r645 (  14 16 ) resistor r=0.0698411 //w=0.17 //l=0.120208 //layer=m1 \
 //thickness=0.36 //x=31.825 //y=1.76 //x2=31.91 //y2=1.845
r646 (  13 45 ) resistor r=0.0717383 //w=0.224 //l=0.115 //layer=m1 \
 //thickness=0.36 //x=31.825 //y=1.305 //x2=31.825 //y2=1.19
r647 (  13 14 ) resistor r=0.43416 //w=0.131 //l=0.455 //layer=m1 \
 //thickness=0.36 //x=31.825 //y=1.305 //x2=31.825 //y2=1.76
r648 (  12 41 ) resistor r=0.0675342 //w=0.23 //l=0.115 //layer=m1 \
 //thickness=0.36 //x=31.645 //y=5.335 //x2=31.53 //y2=5.335
r649 (  11 20 ) resistor r=0.0698411 //w=0.17 //l=0.120208 //layer=m1 \
 //thickness=0.36 //x=32.225 //y=5.335 //x2=32.31 //y2=5.25
r650 (  11 12 ) resistor r=0.553435 //w=0.131 //l=0.58 //layer=m1 \
 //thickness=0.36 //x=32.225 //y=5.335 //x2=31.645 //y2=5.335
r651 (  10 43 ) resistor r=0.00118313 //w=0.23 //layer=m1 //thickness=0.36 \
 //x=31.53 //y=5.56 //x2=31.53 //y2=5.56
r652 (  9 41 ) resistor r=0.002872 //w=0.34 //l=0.085 //layer=m1 \
 //thickness=0.36 //x=31.53 //y=5.42 //x2=31.53 //y2=5.335
r653 (  9 10 ) resistor r=0.091623 //w=0.191 //l=0.14 //layer=m1 \
 //thickness=0.36 //x=31.53 //y=5.42 //x2=31.53 //y2=5.56
r654 (  8 38 ) resistor r=0.0262263 //w=0.232 //l=0.12 //layer=m1 \
 //thickness=0.36 //x=30.77 //y=5.335 //x2=30.65 //y2=5.335
r655 (  7 41 ) resistor r=0.0675342 //w=0.23 //l=0.115 //layer=m1 \
 //thickness=0.36 //x=31.415 //y=5.335 //x2=31.53 //y2=5.335
r656 (  7 8 ) resistor r=0.615458 //w=0.131 //l=0.645 //layer=m1 \
 //thickness=0.36 //x=31.415 //y=5.335 //x2=30.77 //y2=5.335
r657 (  6 35 ) resistor r=0.0222262 //w=0.217 //l=0.118 //layer=m1 \
 //thickness=0.36 //x=29.89 //y=5.335 //x2=29.772 //y2=5.335
r658 (  5 38 ) resistor r=0.0262263 //w=0.232 //l=0.12 //layer=m1 \
 //thickness=0.36 //x=30.53 //y=5.335 //x2=30.65 //y2=5.335
r659 (  5 6 ) resistor r=0.610687 //w=0.131 //l=0.64 //layer=m1 \
 //thickness=0.36 //x=30.53 //y=5.335 //x2=29.89 //y2=5.335
r660 (  4 30 ) resistor r=0.0878548 //w=0.228 //l=0.159295 //layer=m1 \
 //thickness=0.36 //x=26.76 //y=4.735 //x2=26.79 //y2=4.88
r661 (  3 34 ) resistor r=0.0894971 //w=0.376 //l=0.179123 //layer=m1 \
 //thickness=0.36 //x=26.76 //y=4.405 //x2=26.812 //y2=4.25
r662 (  3 4 ) resistor r=0.314885 //w=0.131 //l=0.33 //layer=m1 \
 //thickness=0.36 //x=26.76 //y=4.405 //x2=26.76 //y2=4.735
r663 (  2 32 ) resistor r=0.0911593 //w=0.376 //l=0.184174 //layer=m1 \
 //thickness=0.36 //x=26.76 //y=4.085 //x2=26.812 //y2=4.245
r664 (  2 28 ) resistor r=1.62214 //w=0.131 //l=1.7 //layer=m1 \
 //thickness=0.36 //x=26.76 //y=4.085 //x2=26.76 //y2=2.385
ends PM_TMRDFFSNQNX1\%noxref_8

subckt PM_TMRDFFSNQNX1\%noxref_9 ( 1 2 3 4 5 6 7 8 11 16 17 19 20 22 23 24 25 \
 26 27 28 36 40 47 48 51 53 58 60 67 69 72 78 83 84 86 87 90 99 104 113 118 \
 126 143 152 156 157 158 159 160 161 162 163 164 168 169 170 175 177 180 181 \
 185 186 187 192 194 197 198 202 203 204 209 211 214 215 217 218 223 227 228 \
 233 237 238 243 246 248 249 )
c587 ( 246 0 ) capacitor c=0.00878249f //x=39.82 //y=1.085
c588 ( 243 0 ) capacitor c=0.0651477f //x=47.85 //y=4.88
c589 ( 238 0 ) capacitor c=0.0278202f //x=47.85 //y=2.095
c590 ( 237 0 ) capacitor c=0.0503043f //x=47.85 //y=2.26
c591 ( 233 0 ) capacitor c=0.0651619f //x=36.38 //y=4.88
c592 ( 228 0 ) capacitor c=0.0278202f //x=36.38 //y=2.095
c593 ( 227 0 ) capacitor c=0.0503043f //x=36.38 //y=2.26
c594 ( 223 0 ) capacitor c=0.0654765f //x=31.57 //y=4.88
c595 ( 218 0 ) capacitor c=0.0278202f //x=31.57 //y=2.095
c596 ( 217 0 ) capacitor c=0.0503043f //x=31.57 //y=2.26
c597 ( 215 0 ) capacitor c=0.0443175f //x=48.37 //y=1.44
c598 ( 214 0 ) capacitor c=0.0199703f //x=48.37 //y=1.095
c599 ( 211 0 ) capacitor c=0.0162526f //x=48.215 //y=1.595
c600 ( 209 0 ) capacitor c=0.0157807f //x=48.215 //y=0.94
c601 ( 204 0 ) capacitor c=0.0220935f //x=47.84 //y=1.75
c602 ( 203 0 ) capacitor c=0.0207489f //x=47.84 //y=1.44
c603 ( 202 0 ) capacitor c=0.0194091f //x=47.84 //y=1.095
c604 ( 198 0 ) capacitor c=0.0443175f //x=36.9 //y=1.44
c605 ( 197 0 ) capacitor c=0.0199703f //x=36.9 //y=1.095
c606 ( 194 0 ) capacitor c=0.0162526f //x=36.745 //y=1.595
c607 ( 192 0 ) capacitor c=0.0157807f //x=36.745 //y=0.94
c608 ( 187 0 ) capacitor c=0.0220935f //x=36.37 //y=1.75
c609 ( 186 0 ) capacitor c=0.0207489f //x=36.37 //y=1.44
c610 ( 185 0 ) capacitor c=0.0194091f //x=36.37 //y=1.095
c611 ( 181 0 ) capacitor c=0.0443175f //x=32.09 //y=1.44
c612 ( 180 0 ) capacitor c=0.0199703f //x=32.09 //y=1.095
c613 ( 177 0 ) capacitor c=0.0162526f //x=31.935 //y=1.595
c614 ( 175 0 ) capacitor c=0.0157807f //x=31.935 //y=0.94
c615 ( 170 0 ) capacitor c=0.0220935f //x=31.56 //y=1.75
c616 ( 169 0 ) capacitor c=0.0207489f //x=31.56 //y=1.44
c617 ( 168 0 ) capacitor c=0.0194091f //x=31.56 //y=1.095
c618 ( 164 0 ) capacitor c=0.159671f //x=48.03 //y=6.2
c619 ( 163 0 ) capacitor c=0.110208f //x=47.59 //y=6.2
c620 ( 162 0 ) capacitor c=0.159671f //x=36.56 //y=6.2
c621 ( 161 0 ) capacitor c=0.110208f //x=36.12 //y=6.2
c622 ( 160 0 ) capacitor c=0.159671f //x=31.75 //y=6.2
c623 ( 159 0 ) capacitor c=0.110208f //x=31.31 //y=6.2
c624 ( 152 0 ) capacitor c=7.7417e-19 //x=47.85 //y=4.88
c625 ( 143 0 ) capacitor c=0.00101179f //x=47.85 //y=2.26
c626 ( 126 0 ) capacitor c=0.0319332f //x=39.97 //y=5.56
c627 ( 118 0 ) capacitor c=0.0290186f //x=39.09 //y=5.56
c628 ( 113 0 ) capacitor c=7.7417e-19 //x=36.38 //y=4.88
c629 ( 104 0 ) capacitor c=0.00101179f //x=36.38 //y=2.26
c630 ( 99 0 ) capacitor c=7.7417e-19 //x=31.57 //y=4.88
c631 ( 90 0 ) capacitor c=0.00101179f //x=31.57 //y=2.26
c632 ( 87 0 ) capacitor c=0.0754404f //x=47.69 //y=3.885
c633 ( 86 0 ) capacitor c=6.15393e-19 //x=47.85 //y=3.885
c634 ( 84 0 ) capacitor c=6.78139e-19 //x=40.605 //y=3.865
c635 ( 83 0 ) capacitor c=0.0371901f //x=40.285 //y=3.865
c636 ( 78 0 ) capacitor c=6.291e-19 //x=31.735 //y=3.865
c637 ( 72 0 ) capacitor c=0.0413374f //x=36.54 //y=3.88
c638 ( 69 0 ) capacitor c=0.00240665f //x=32.52 //y=3.865
c639 ( 67 0 ) capacitor c=0.00239648f //x=31.92 //y=3.88
c640 ( 60 0 ) capacitor c=0.0149589f //x=47.85 //y=3.88
c641 ( 58 0 ) capacitor c=0.0158493f //x=40.45 //y=3.88
c642 ( 53 0 ) capacitor c=0.0113632f //x=40.01 //y=1.18
c643 ( 51 0 ) capacitor c=5.78613e-19 //x=39.97 //y=5.56
c644 ( 48 0 ) capacitor c=0.00996089f //x=39.97 //y=5.38
c645 ( 47 0 ) capacitor c=0.00947836f //x=39.09 //y=5.56
c646 ( 40 0 ) capacitor c=0.0149589f //x=36.38 //y=3.88
c647 ( 36 0 ) capacitor c=0.0149589f //x=31.57 //y=3.88
c648 ( 28 0 ) capacitor c=0.018686f //x=47.85 //y=4.75
c649 ( 27 0 ) capacitor c=0.0114437f //x=47.85 //y=4.045
c650 ( 26 0 ) capacitor c=0.0312765f //x=47.85 //y=3.725
c651 ( 25 0 ) capacitor c=0.0055474f //x=47.85 //y=2.375
c652 ( 24 0 ) capacitor c=0.0292688f //x=40.45 //y=5.295
c653 ( 23 0 ) capacitor c=0.0126608f //x=40.45 //y=4.025
c654 ( 22 0 ) capacitor c=0.0461152f //x=40.45 //y=3.705
c655 ( 20 0 ) capacitor c=0.00466468f //x=40.095 //y=1.835
c656 ( 19 0 ) capacitor c=0.0118534f //x=40.365 //y=1.835
c657 ( 17 0 ) capacitor c=0.0105341f //x=40.365 //y=5.38
c658 ( 16 0 ) capacitor c=0.0102514f //x=40.01 //y=1.75
c659 ( 11 0 ) capacitor c=0.0144196f //x=39.855 //y=5.38
c660 ( 8 0 ) capacitor c=0.0205242f //x=36.38 //y=4.75
c661 ( 7 0 ) capacitor c=0.0115377f //x=36.38 //y=4.025
c662 ( 6 0 ) capacitor c=0.0292543f //x=36.38 //y=3.705
c663 ( 5 0 ) capacitor c=0.00554287f //x=36.38 //y=2.375
c664 ( 4 0 ) capacitor c=0.0190807f //x=31.57 //y=4.75
c665 ( 3 0 ) capacitor c=0.01135f //x=31.57 //y=4.025
c666 ( 2 0 ) capacitor c=0.0309098f //x=31.57 //y=3.705
c667 ( 1 0 ) capacitor c=0.00556102f //x=31.57 //y=2.375
r668 (  237 238 ) resistor r=52.7279 //w=0.214 //l=0.165 //layer=ply \
 //thickness=0.18 //x=47.85 //y=2.26 //x2=47.85 //y2=2.095
r669 (  227 228 ) resistor r=52.7279 //w=0.214 //l=0.165 //layer=ply \
 //thickness=0.18 //x=36.38 //y=2.26 //x2=36.38 //y2=2.095
r670 (  217 218 ) resistor r=52.7279 //w=0.214 //l=0.165 //layer=ply \
 //thickness=0.18 //x=31.57 //y=2.26 //x2=31.57 //y2=2.095
r671 (  215 245 ) resistor r=45.1352 //w=0.168 //l=0.173853 //layer=ply \
 //thickness=0.18 //x=48.37 //y=1.44 //x2=48.33 //y2=1.595
r672 (  214 244 ) resistor r=45.1352 //w=0.168 //l=0.173853 //layer=ply \
 //thickness=0.18 //x=48.37 //y=1.095 //x2=48.33 //y2=0.94
r673 (  214 215 ) resistor r=176.904 //w=0.094 //l=0.345 //layer=ply \
 //thickness=0.18 //x=48.37 //y=1.095 //x2=48.37 //y2=1.44
r674 (  212 241 ) resistor r=10.701 //w=0.21 //l=0.115 //layer=ply \
 //thickness=0.18 //x=47.995 //y=1.595 //x2=47.88 //y2=1.595
r675 (  211 245 ) resistor r=5.52526 //w=0.168 //l=0.115 //layer=ply \
 //thickness=0.18 //x=48.215 //y=1.595 //x2=48.33 //y2=1.595
r676 (  210 240 ) resistor r=5.52526 //w=0.168 //l=0.115 //layer=ply \
 //thickness=0.18 //x=47.995 //y=0.94 //x2=47.88 //y2=0.94
r677 (  209 244 ) resistor r=5.52526 //w=0.168 //l=0.115 //layer=ply \
 //thickness=0.18 //x=48.215 //y=0.94 //x2=48.33 //y2=0.94
r678 (  209 210 ) resistor r=112.809 //w=0.094 //l=0.22 //layer=ply \
 //thickness=0.18 //x=48.215 //y=0.94 //x2=47.995 //y2=0.94
r679 (  206 243 ) resistor r=37.236 //w=0.233 //l=0.249199 //layer=ply \
 //thickness=0.18 //x=48.03 //y=5.045 //x2=47.85 //y2=4.88
r680 (  204 241 ) resistor r=39.5823 //w=0.21 //l=0.173853 //layer=ply \
 //thickness=0.18 //x=47.84 //y=1.75 //x2=47.88 //y2=1.595
r681 (  204 238 ) resistor r=176.904 //w=0.094 //l=0.345 //layer=ply \
 //thickness=0.18 //x=47.84 //y=1.75 //x2=47.84 //y2=2.095
r682 (  203 241 ) resistor r=39.5823 //w=0.21 //l=0.173853 //layer=ply \
 //thickness=0.18 //x=47.84 //y=1.44 //x2=47.88 //y2=1.595
r683 (  202 240 ) resistor r=45.1352 //w=0.168 //l=0.173853 //layer=ply \
 //thickness=0.18 //x=47.84 //y=1.095 //x2=47.88 //y2=0.94
r684 (  202 203 ) resistor r=176.904 //w=0.094 //l=0.345 //layer=ply \
 //thickness=0.18 //x=47.84 //y=1.095 //x2=47.84 //y2=1.44
r685 (  199 243 ) resistor r=53.7854 //w=0.233 //l=0.332415 //layer=ply \
 //thickness=0.18 //x=47.59 //y=5.045 //x2=47.85 //y2=4.88
r686 (  198 235 ) resistor r=45.1352 //w=0.168 //l=0.173853 //layer=ply \
 //thickness=0.18 //x=36.9 //y=1.44 //x2=36.86 //y2=1.595
r687 (  197 234 ) resistor r=45.1352 //w=0.168 //l=0.173853 //layer=ply \
 //thickness=0.18 //x=36.9 //y=1.095 //x2=36.86 //y2=0.94
r688 (  197 198 ) resistor r=176.904 //w=0.094 //l=0.345 //layer=ply \
 //thickness=0.18 //x=36.9 //y=1.095 //x2=36.9 //y2=1.44
r689 (  195 231 ) resistor r=10.701 //w=0.21 //l=0.115 //layer=ply \
 //thickness=0.18 //x=36.525 //y=1.595 //x2=36.41 //y2=1.595
r690 (  194 235 ) resistor r=5.52526 //w=0.168 //l=0.115 //layer=ply \
 //thickness=0.18 //x=36.745 //y=1.595 //x2=36.86 //y2=1.595
r691 (  193 230 ) resistor r=5.52526 //w=0.168 //l=0.115 //layer=ply \
 //thickness=0.18 //x=36.525 //y=0.94 //x2=36.41 //y2=0.94
r692 (  192 234 ) resistor r=5.52526 //w=0.168 //l=0.115 //layer=ply \
 //thickness=0.18 //x=36.745 //y=0.94 //x2=36.86 //y2=0.94
r693 (  192 193 ) resistor r=112.809 //w=0.094 //l=0.22 //layer=ply \
 //thickness=0.18 //x=36.745 //y=0.94 //x2=36.525 //y2=0.94
r694 (  189 233 ) resistor r=37.236 //w=0.233 //l=0.249199 //layer=ply \
 //thickness=0.18 //x=36.56 //y=5.045 //x2=36.38 //y2=4.88
r695 (  187 231 ) resistor r=39.5823 //w=0.21 //l=0.173853 //layer=ply \
 //thickness=0.18 //x=36.37 //y=1.75 //x2=36.41 //y2=1.595
r696 (  187 228 ) resistor r=176.904 //w=0.094 //l=0.345 //layer=ply \
 //thickness=0.18 //x=36.37 //y=1.75 //x2=36.37 //y2=2.095
r697 (  186 231 ) resistor r=39.5823 //w=0.21 //l=0.173853 //layer=ply \
 //thickness=0.18 //x=36.37 //y=1.44 //x2=36.41 //y2=1.595
r698 (  185 230 ) resistor r=45.1352 //w=0.168 //l=0.173853 //layer=ply \
 //thickness=0.18 //x=36.37 //y=1.095 //x2=36.41 //y2=0.94
r699 (  185 186 ) resistor r=176.904 //w=0.094 //l=0.345 //layer=ply \
 //thickness=0.18 //x=36.37 //y=1.095 //x2=36.37 //y2=1.44
r700 (  182 233 ) resistor r=53.7854 //w=0.233 //l=0.332415 //layer=ply \
 //thickness=0.18 //x=36.12 //y=5.045 //x2=36.38 //y2=4.88
r701 (  181 225 ) resistor r=45.1352 //w=0.168 //l=0.173853 //layer=ply \
 //thickness=0.18 //x=32.09 //y=1.44 //x2=32.05 //y2=1.595
r702 (  180 224 ) resistor r=45.1352 //w=0.168 //l=0.173853 //layer=ply \
 //thickness=0.18 //x=32.09 //y=1.095 //x2=32.05 //y2=0.94
r703 (  180 181 ) resistor r=176.904 //w=0.094 //l=0.345 //layer=ply \
 //thickness=0.18 //x=32.09 //y=1.095 //x2=32.09 //y2=1.44
r704 (  178 221 ) resistor r=10.701 //w=0.21 //l=0.115 //layer=ply \
 //thickness=0.18 //x=31.715 //y=1.595 //x2=31.6 //y2=1.595
r705 (  177 225 ) resistor r=5.52526 //w=0.168 //l=0.115 //layer=ply \
 //thickness=0.18 //x=31.935 //y=1.595 //x2=32.05 //y2=1.595
r706 (  176 220 ) resistor r=5.52526 //w=0.168 //l=0.115 //layer=ply \
 //thickness=0.18 //x=31.715 //y=0.94 //x2=31.6 //y2=0.94
r707 (  175 224 ) resistor r=5.52526 //w=0.168 //l=0.115 //layer=ply \
 //thickness=0.18 //x=31.935 //y=0.94 //x2=32.05 //y2=0.94
r708 (  175 176 ) resistor r=112.809 //w=0.094 //l=0.22 //layer=ply \
 //thickness=0.18 //x=31.935 //y=0.94 //x2=31.715 //y2=0.94
r709 (  172 223 ) resistor r=37.236 //w=0.233 //l=0.249199 //layer=ply \
 //thickness=0.18 //x=31.75 //y=5.045 //x2=31.57 //y2=4.88
r710 (  170 221 ) resistor r=39.5823 //w=0.21 //l=0.173853 //layer=ply \
 //thickness=0.18 //x=31.56 //y=1.75 //x2=31.6 //y2=1.595
r711 (  170 218 ) resistor r=176.904 //w=0.094 //l=0.345 //layer=ply \
 //thickness=0.18 //x=31.56 //y=1.75 //x2=31.56 //y2=2.095
r712 (  169 221 ) resistor r=39.5823 //w=0.21 //l=0.173853 //layer=ply \
 //thickness=0.18 //x=31.56 //y=1.44 //x2=31.6 //y2=1.595
r713 (  168 220 ) resistor r=45.1352 //w=0.168 //l=0.173853 //layer=ply \
 //thickness=0.18 //x=31.56 //y=1.095 //x2=31.6 //y2=0.94
r714 (  168 169 ) resistor r=176.904 //w=0.094 //l=0.345 //layer=ply \
 //thickness=0.18 //x=31.56 //y=1.095 //x2=31.56 //y2=1.44
r715 (  165 223 ) resistor r=53.7854 //w=0.233 //l=0.332415 //layer=ply \
 //thickness=0.18 //x=31.31 //y=5.045 //x2=31.57 //y2=4.88
r716 (  164 206 ) resistor r=592.245 //w=0.094 //l=1.155 //layer=ply \
 //thickness=0.18 //x=48.03 //y=6.2 //x2=48.03 //y2=5.045
r717 (  163 199 ) resistor r=592.245 //w=0.094 //l=1.155 //layer=ply \
 //thickness=0.18 //x=47.59 //y=6.2 //x2=47.59 //y2=5.045
r718 (  162 189 ) resistor r=592.245 //w=0.094 //l=1.155 //layer=ply \
 //thickness=0.18 //x=36.56 //y=6.2 //x2=36.56 //y2=5.045
r719 (  161 182 ) resistor r=592.245 //w=0.094 //l=1.155 //layer=ply \
 //thickness=0.18 //x=36.12 //y=6.2 //x2=36.12 //y2=5.045
r720 (  160 172 ) resistor r=592.245 //w=0.094 //l=1.155 //layer=ply \
 //thickness=0.18 //x=31.75 //y=6.2 //x2=31.75 //y2=5.045
r721 (  159 165 ) resistor r=592.245 //w=0.094 //l=1.155 //layer=ply \
 //thickness=0.18 //x=31.31 //y=6.2 //x2=31.31 //y2=5.045
r722 (  158 211 ) resistor r=56.4043 //w=0.094 //l=0.11 //layer=ply \
 //thickness=0.18 //x=48.105 //y=1.595 //x2=48.215 //y2=1.595
r723 (  158 212 ) resistor r=56.4043 //w=0.094 //l=0.11 //layer=ply \
 //thickness=0.18 //x=48.105 //y=1.595 //x2=47.995 //y2=1.595
r724 (  157 194 ) resistor r=56.4043 //w=0.094 //l=0.11 //layer=ply \
 //thickness=0.18 //x=36.635 //y=1.595 //x2=36.745 //y2=1.595
r725 (  157 195 ) resistor r=56.4043 //w=0.094 //l=0.11 //layer=ply \
 //thickness=0.18 //x=36.635 //y=1.595 //x2=36.525 //y2=1.595
r726 (  156 177 ) resistor r=56.4043 //w=0.094 //l=0.11 //layer=ply \
 //thickness=0.18 //x=31.825 //y=1.595 //x2=31.935 //y2=1.595
r727 (  156 178 ) resistor r=56.4043 //w=0.094 //l=0.11 //layer=ply \
 //thickness=0.18 //x=31.825 //y=1.595 //x2=31.715 //y2=1.595
r728 (  152 243 ) resistor r=152 //w=0.17 //l=0.17 //layer=licon //count=1 \
 //x=47.85 //y=4.88 //x2=47.85 //y2=4.88
r729 (  143 237 ) resistor r=152 //w=0.17 //l=0.17 //layer=licon //count=1 \
 //x=47.85 //y=2.26 //x2=47.85 //y2=2.26
r730 (  126 249 ) resistor r=23.615 //w=0.187 //l=0.345 //layer=li \
 //thickness=0.1 //x=39.97 //y=5.56 //x2=39.97 //y2=5.905
r731 (  118 248 ) resistor r=23.615 //w=0.187 //l=0.345 //layer=li \
 //thickness=0.1 //x=39.09 //y=5.56 //x2=39.09 //y2=5.905
r732 (  113 233 ) resistor r=152 //w=0.17 //l=0.17 //layer=licon //count=1 \
 //x=36.38 //y=4.88 //x2=36.38 //y2=4.88
r733 (  104 227 ) resistor r=152 //w=0.17 //l=0.17 //layer=licon //count=1 \
 //x=36.38 //y=2.26 //x2=36.38 //y2=2.26
r734 (  99 223 ) resistor r=152 //w=0.17 //l=0.17 //layer=licon //count=1 \
 //x=31.57 //y=4.88 //x2=31.57 //y2=4.88
r735 (  90 217 ) resistor r=152 //w=0.17 //l=0.17 //layer=licon //count=1 \
 //x=31.57 //y=2.26 //x2=31.57 //y2=2.26
r736 (  86 87 ) resistor r=0.10734 //w=0.281 //l=0.16 //layer=m2 \
 //thickness=0.36 //x=47.85 //y=3.885 //x2=47.69 //y2=3.885
r737 (  84 87 ) resistor r=6.7605 //w=0.131 //l=7.085 //layer=m2 \
 //thickness=0.36 //x=40.605 //y=3.88 //x2=47.69 //y2=3.88
r738 (  82 84 ) resistor r=0.10734 //w=0.281 //l=0.16 //layer=m2 \
 //thickness=0.36 //x=40.445 //y=3.865 //x2=40.605 //y2=3.865
r739 (  82 83 ) resistor r=0.10734 //w=0.281 //l=0.16 //layer=m2 \
 //thickness=0.36 //x=40.445 //y=3.865 //x2=40.285 //y2=3.865
r740 (  76 78 ) resistor r=0.10734 //w=0.281 //l=0.16 //layer=m2 \
 //thickness=0.36 //x=31.575 //y=3.865 //x2=31.735 //y2=3.865
r741 (  72 80 ) resistor r=0.110608 //w=0.182 //l=0.167332 //layer=m2 \
 //thickness=0.36 //x=36.54 //y=3.88 //x2=36.38 //y2=3.865
r742 (  72 83 ) resistor r=3.57347 //w=0.131 //l=3.745 //layer=m2 \
 //thickness=0.36 //x=36.54 //y=3.88 //x2=40.285 //y2=3.88
r743 (  69 80 ) resistor r=2.65182 //w=0.182 //l=3.86 //layer=m2 \
 //thickness=0.36 //x=32.52 //y=3.865 //x2=36.38 //y2=3.865
r744 (  69 70 ) resistor r=0.410305 //w=0.131 //l=0.43 //layer=m2 \
 //thickness=0.36 //x=32.52 //y=3.865 //x2=32.09 //y2=3.865
r745 (  67 70 ) resistor r=0.125 //w=0.17 //l=0.177341 //layer=m2 \
 //thickness=0.36 //x=31.92 //y=3.88 //x2=32.09 //y2=3.865
r746 (  67 78 ) resistor r=0.176527 //w=0.131 //l=0.185 //layer=m2 \
 //thickness=0.36 //x=31.92 //y=3.88 //x2=31.735 //y2=3.88
r747 (  66 152 ) resistor r=9.3 //w=0.17 //l=0.17 //layer=mcon //count=1 \
 //x=47.85 //y=4.88 //x2=47.85 //y2=4.88
r748 (  64 143 ) resistor r=9.3 //w=0.17 //l=0.17 //layer=mcon //count=1 \
 //x=47.85 //y=2.26 //x2=47.85 //y2=2.26
r749 (  62 86 ) resistor r=4.5 //w=0.15 //l=0.15 //layer=via1 //count=1 \
 //x=47.85 //y=3.885 //x2=47.85 //y2=3.885
r750 (  60 62 ) resistor r=0.00166223 //w=0.376 //l=0.005 //layer=m1 \
 //thickness=0.36 //x=47.797 //y=3.88 //x2=47.797 //y2=3.885
r751 (  56 82 ) resistor r=4.5 //w=0.15 //l=0.15 //layer=via1 //count=1 \
 //x=40.445 //y=3.865 //x2=40.445 //y2=3.865
r752 (  56 58 ) resistor r=0.00501337 //w=0.374 //l=0.015 //layer=m1 \
 //thickness=0.36 //x=40.395 //y=3.865 //x2=40.395 //y2=3.88
r753 (  53 246 ) resistor r=9.3 //w=0.17 //l=0.17 //layer=mcon //count=1 \
 //x=40.01 //y=1.18 //x2=40.01 //y2=1.18
r754 (  51 126 ) resistor r=9.3 //w=0.17 //l=0.17 //layer=mcon //count=1 \
 //x=39.97 //y=5.56 //x2=39.97 //y2=5.56
r755 (  48 51 ) resistor r=0.117801 //w=0.191 //l=0.18 //layer=m1 \
 //thickness=0.36 //x=39.97 //y=5.38 //x2=39.97 //y2=5.56
r756 (  47 118 ) resistor r=9.3 //w=0.17 //l=0.17 //layer=mcon //count=1 \
 //x=39.09 //y=5.56 //x2=39.09 //y2=5.56
r757 (  45 47 ) resistor r=0.10274 //w=0.219 //l=0.18 //layer=m1 \
 //thickness=0.36 //x=39.09 //y=5.38 //x2=39.09 //y2=5.56
r758 (  44 113 ) resistor r=9.3 //w=0.17 //l=0.17 //layer=mcon //count=1 \
 //x=36.38 //y=4.88 //x2=36.38 //y2=4.88
r759 (  42 104 ) resistor r=9.3 //w=0.17 //l=0.17 //layer=mcon //count=1 \
 //x=36.38 //y=2.26 //x2=36.38 //y2=2.26
r760 (  38 80 ) resistor r=4.5 //w=0.15 //l=0.15 //layer=via1 //count=1 \
 //x=36.38 //y=3.865 //x2=36.38 //y2=3.865
r761 (  38 40 ) resistor r=0.0049867 //w=0.376 //l=0.015 //layer=m1 \
 //thickness=0.36 //x=36.327 //y=3.865 //x2=36.327 //y2=3.88
r762 (  34 76 ) resistor r=4.5 //w=0.15 //l=0.15 //layer=via1 //count=1 \
 //x=31.575 //y=3.865 //x2=31.575 //y2=3.865
r763 (  34 36 ) resistor r=0.00501337 //w=0.374 //l=0.015 //layer=m1 \
 //thickness=0.36 //x=31.625 //y=3.865 //x2=31.625 //y2=3.88
r764 (  32 99 ) resistor r=9.3 //w=0.17 //l=0.17 //layer=mcon //count=1 \
 //x=31.57 //y=4.88 //x2=31.57 //y2=4.88
r765 (  30 90 ) resistor r=9.3 //w=0.17 //l=0.17 //layer=mcon //count=1 \
 //x=31.57 //y=2.26 //x2=31.57 //y2=2.26
r766 (  28 66 ) resistor r=0.0801089 //w=0.224 //l=0.13 //layer=m1 \
 //thickness=0.36 //x=47.85 //y=4.75 //x2=47.85 //y2=4.88
r767 (  27 62 ) resistor r=0.0911593 //w=0.376 //l=0.184608 //layer=m1 \
 //thickness=0.36 //x=47.85 //y=4.045 //x2=47.797 //y2=3.885
r768 (  27 28 ) resistor r=0.67271 //w=0.131 //l=0.705 //layer=m1 \
 //thickness=0.36 //x=47.85 //y=4.045 //x2=47.85 //y2=4.75
r769 (  26 60 ) resistor r=0.0894971 //w=0.376 //l=0.179555 //layer=m1 \
 //thickness=0.36 //x=47.85 //y=3.725 //x2=47.797 //y2=3.88
r770 (  25 64 ) resistor r=0.0719237 //w=0.222 //l=0.115 //layer=m1 \
 //thickness=0.36 //x=47.85 //y=2.375 //x2=47.85 //y2=2.26
r771 (  25 26 ) resistor r=1.28817 //w=0.131 //l=1.35 //layer=m1 \
 //thickness=0.36 //x=47.85 //y=2.375 //x2=47.85 //y2=3.725
r772 (  23 58 ) resistor r=0.0860668 //w=0.374 //l=0.170294 //layer=m1 \
 //thickness=0.36 //x=40.45 //y=4.025 //x2=40.395 //y2=3.88
r773 (  23 24 ) resistor r=1.21183 //w=0.131 //l=1.27 //layer=m1 \
 //thickness=0.36 //x=40.45 //y=4.025 //x2=40.45 //y2=5.295
r774 (  22 56 ) resistor r=0.0910802 //w=0.374 //l=0.185472 //layer=m1 \
 //thickness=0.36 //x=40.45 //y=3.705 //x2=40.395 //y2=3.865
r775 (  21 22 ) resistor r=1.70324 //w=0.131 //l=1.785 //layer=m1 \
 //thickness=0.36 //x=40.45 //y=1.92 //x2=40.45 //y2=3.705
r776 (  19 21 ) resistor r=0.0698411 //w=0.17 //l=0.120208 //layer=m1 \
 //thickness=0.36 //x=40.365 //y=1.835 //x2=40.45 //y2=1.92
r777 (  19 20 ) resistor r=0.257634 //w=0.131 //l=0.27 //layer=m1 \
 //thickness=0.36 //x=40.365 //y=1.835 //x2=40.095 //y2=1.835
r778 (  18 48 ) resistor r=0.0257089 //w=0.23 //l=0.115 //layer=m1 \
 //thickness=0.36 //x=40.085 //y=5.38 //x2=39.97 //y2=5.38
r779 (  17 24 ) resistor r=0.0698411 //w=0.17 //l=0.120208 //layer=m1 \
 //thickness=0.36 //x=40.365 //y=5.38 //x2=40.45 //y2=5.295
r780 (  17 18 ) resistor r=0.267176 //w=0.131 //l=0.28 //layer=m1 \
 //thickness=0.36 //x=40.365 //y=5.38 //x2=40.085 //y2=5.38
r781 (  16 20 ) resistor r=0.0698411 //w=0.17 //l=0.120208 //layer=m1 \
 //thickness=0.36 //x=40.01 //y=1.75 //x2=40.095 //y2=1.835
r782 (  15 53 ) resistor r=0.0913624 //w=0.191 //l=0.12 //layer=m1 \
 //thickness=0.36 //x=40.01 //y=1.3 //x2=40.01 //y2=1.18
r783 (  15 16 ) resistor r=0.429389 //w=0.131 //l=0.45 //layer=m1 \
 //thickness=0.36 //x=40.01 //y=1.3 //x2=40.01 //y2=1.75
r784 (  12 45 ) resistor r=0.0227762 //w=0.219 //l=0.115 //layer=m1 \
 //thickness=0.36 //x=39.205 //y=5.38 //x2=39.09 //y2=5.38
r785 (  11 48 ) resistor r=0.0257089 //w=0.23 //l=0.115 //layer=m1 \
 //thickness=0.36 //x=39.855 //y=5.38 //x2=39.97 //y2=5.38
r786 (  11 12 ) resistor r=0.620229 //w=0.131 //l=0.65 //layer=m1 \
 //thickness=0.36 //x=39.855 //y=5.38 //x2=39.205 //y2=5.38
r787 (  8 44 ) resistor r=0.0801089 //w=0.224 //l=0.13 //layer=m1 \
 //thickness=0.36 //x=36.38 //y=4.75 //x2=36.38 //y2=4.88
r788 (  7 40 ) resistor r=0.0861726 //w=0.376 //l=0.16944 //layer=m1 \
 //thickness=0.36 //x=36.38 //y=4.025 //x2=36.327 //y2=3.88
r789 (  7 8 ) resistor r=0.691794 //w=0.131 //l=0.725 //layer=m1 \
 //thickness=0.36 //x=36.38 //y=4.025 //x2=36.38 //y2=4.75
r790 (  6 38 ) resistor r=0.0911593 //w=0.376 //l=0.184608 //layer=m1 \
 //thickness=0.36 //x=36.38 //y=3.705 //x2=36.327 //y2=3.865
r791 (  5 42 ) resistor r=0.0719237 //w=0.222 //l=0.115 //layer=m1 \
 //thickness=0.36 //x=36.38 //y=2.375 //x2=36.38 //y2=2.26
r792 (  5 6 ) resistor r=1.26908 //w=0.131 //l=1.33 //layer=m1 \
 //thickness=0.36 //x=36.38 //y=2.375 //x2=36.38 //y2=3.705
r793 (  4 32 ) resistor r=0.0801089 //w=0.224 //l=0.13 //layer=m1 \
 //thickness=0.36 //x=31.57 //y=4.75 //x2=31.57 //y2=4.88
r794 (  3 36 ) resistor r=0.0860668 //w=0.374 //l=0.170294 //layer=m1 \
 //thickness=0.36 //x=31.57 //y=4.025 //x2=31.625 //y2=3.88
r795 (  3 4 ) resistor r=0.691794 //w=0.131 //l=0.725 //layer=m1 \
 //thickness=0.36 //x=31.57 //y=4.025 //x2=31.57 //y2=4.75
r796 (  2 34 ) resistor r=0.0910802 //w=0.374 //l=0.185472 //layer=m1 \
 //thickness=0.36 //x=31.57 //y=3.705 //x2=31.625 //y2=3.865
r797 (  1 30 ) resistor r=0.0719237 //w=0.222 //l=0.115 //layer=m1 \
 //thickness=0.36 //x=31.57 //y=2.375 //x2=31.57 //y2=2.26
r798 (  1 2 ) resistor r=1.26908 //w=0.131 //l=1.33 //layer=m1 \
 //thickness=0.36 //x=31.57 //y=2.375 //x2=31.57 //y2=3.705
ends PM_TMRDFFSNQNX1\%noxref_9

subckt PM_TMRDFFSNQNX1\%noxref_10 ( 2 3 4 5 7 10 11 13 14 15 16 18 19 20 22 28 \
 31 34 37 45 46 48 53 57 66 71 79 87 103 104 105 106 107 108 113 115 117 123 \
 124 126 127 130 138 140 141 142 )
c323 ( 138 0 ) capacitor c=0.00885916f //x=47.915 //y=1.095
c324 ( 130 0 ) capacitor c=0.0354916f //x=43.07 //y=4.88
c325 ( 127 0 ) capacitor c=0.0284095f //x=43.04 //y=2.095
c326 ( 126 0 ) capacitor c=0.0476356f //x=43.04 //y=2.26
c327 ( 124 0 ) capacitor c=0.0439708f //x=43.605 //y=1.43
c328 ( 123 0 ) capacitor c=0.0192582f //x=43.605 //y=1.085
c329 ( 117 0 ) capacitor c=0.0162526f //x=43.45 //y=1.585
c330 ( 115 0 ) capacitor c=0.0157807f //x=43.45 //y=0.93
c331 ( 113 0 ) capacitor c=0.0357885f //x=43.445 //y=4.97
c332 ( 108 0 ) capacitor c=0.0210762f //x=43.075 //y=1.74
c333 ( 107 0 ) capacitor c=0.0168511f //x=43.075 //y=1.43
c334 ( 106 0 ) capacitor c=0.0175485f //x=43.075 //y=1.085
c335 ( 105 0 ) capacitor c=0.155269f //x=43.52 //y=6.2
c336 ( 104 0 ) capacitor c=0.110375f //x=43.08 //y=6.2
c337 ( 87 0 ) capacitor c=0.0293228f //x=47.81 //y=5.56
c338 ( 79 0 ) capacitor c=0.029137f //x=46.93 //y=5.56
c339 ( 71 0 ) capacitor c=0.0277605f //x=46.05 //y=5.56
c340 ( 66 0 ) capacitor c=5.80994e-19 //x=43.07 //y=4.88
c341 ( 57 0 ) capacitor c=5.78095e-19 //x=43.04 //y=2.26
c342 ( 53 0 ) capacitor c=6.56309e-19 //x=43.195 //y=4.265
c343 ( 48 0 ) capacitor c=0.00617801f //x=48.065 //y=4.27
c344 ( 46 0 ) capacitor c=0.0444785f //x=47.465 //y=4.25
c345 ( 45 0 ) capacitor c=0.0163405f //x=48.59 //y=4.25
c346 ( 37 0 ) capacitor c=8.84507e-19 //x=47.81 //y=5.335
c347 ( 34 0 ) capacitor c=0.00799482f //x=46.93 //y=5.335
c348 ( 31 0 ) capacitor c=0.0112819f //x=46.052 //y=5.335
c349 ( 28 0 ) capacitor c=0.0133657f //x=43.04 //y=4.25
c350 ( 22 0 ) capacitor c=0.00504845f //x=43.04 //y=2.26
c351 ( 20 0 ) capacitor c=0.0210243f //x=48.59 //y=5.25
c352 ( 19 0 ) capacitor c=0.0130748f //x=48.59 //y=4.395
c353 ( 18 0 ) capacitor c=0.0578319f //x=48.59 //y=4.075
c354 ( 16 0 ) capacitor c=0.00493487f //x=48.19 //y=1.845
c355 ( 15 0 ) capacitor c=0.0130981f //x=48.505 //y=1.845
c356 ( 14 0 ) capacitor c=0.013549f //x=48.105 //y=1.76
c357 ( 13 0 ) capacitor c=0.0113783f //x=48.105 //y=1.305
c358 ( 11 0 ) capacitor c=0.0226401f //x=48.505 //y=5.335
c359 ( 10 0 ) capacitor c=0.00906713f //x=47.81 //y=5.56
c360 ( 7 0 ) capacitor c=0.0180822f //x=47.695 //y=5.335
c361 ( 5 0 ) capacitor c=0.0151888f //x=46.81 //y=5.335
c362 ( 4 0 ) capacitor c=0.00859003f //x=43.04 //y=4.735
c363 ( 3 0 ) capacitor c=0.0105809f //x=43.04 //y=4.425
c364 ( 2 0 ) capacitor c=0.0361678f //x=43.04 //y=4.105
r365 (  132 133 ) resistor r=32.4568 //w=0.214 //l=0.075 //layer=ply \
 //thickness=0.18 //x=43.07 //y=4.97 //x2=43.07 //y2=5.045
r366 (  130 132 ) resistor r=20.271 //w=0.214 //l=0.09 //layer=ply \
 //thickness=0.18 //x=43.07 //y=4.88 //x2=43.07 //y2=4.97
r367 (  126 127 ) resistor r=52.7279 //w=0.214 //l=0.165 //layer=ply \
 //thickness=0.18 //x=43.04 //y=2.26 //x2=43.04 //y2=2.095
r368 (  124 137 ) resistor r=45.1352 //w=0.168 //l=0.173853 //layer=ply \
 //thickness=0.18 //x=43.605 //y=1.43 //x2=43.565 //y2=1.585
r369 (  123 136 ) resistor r=45.1352 //w=0.168 //l=0.173853 //layer=ply \
 //thickness=0.18 //x=43.605 //y=1.085 //x2=43.565 //y2=0.93
r370 (  123 124 ) resistor r=176.904 //w=0.094 //l=0.345 //layer=ply \
 //thickness=0.18 //x=43.605 //y=1.085 //x2=43.605 //y2=1.43
r371 (  118 135 ) resistor r=10.701 //w=0.21 //l=0.115 //layer=ply \
 //thickness=0.18 //x=43.23 //y=1.585 //x2=43.115 //y2=1.585
r372 (  117 137 ) resistor r=5.52526 //w=0.168 //l=0.115 //layer=ply \
 //thickness=0.18 //x=43.45 //y=1.585 //x2=43.565 //y2=1.585
r373 (  116 134 ) resistor r=5.52526 //w=0.168 //l=0.115 //layer=ply \
 //thickness=0.18 //x=43.23 //y=0.93 //x2=43.115 //y2=0.93
r374 (  115 136 ) resistor r=5.52526 //w=0.168 //l=0.115 //layer=ply \
 //thickness=0.18 //x=43.45 //y=0.93 //x2=43.565 //y2=0.93
r375 (  115 116 ) resistor r=112.809 //w=0.094 //l=0.22 //layer=ply \
 //thickness=0.18 //x=43.45 //y=0.93 //x2=43.23 //y2=0.93
r376 (  114 132 ) resistor r=16.5046 //w=0.27 //l=0.135 //layer=ply \
 //thickness=0.18 //x=43.205 //y=4.97 //x2=43.07 //y2=4.97
r377 (  113 120 ) resistor r=26.9307 //w=0.15 //l=0.106066 //layer=ply \
 //thickness=0.18 //x=43.445 //y=4.97 //x2=43.52 //y2=5.045
r378 (  113 114 ) resistor r=123.064 //w=0.094 //l=0.24 //layer=ply \
 //thickness=0.18 //x=43.445 //y=4.97 //x2=43.205 //y2=4.97
r379 (  108 135 ) resistor r=39.5823 //w=0.21 //l=0.173853 //layer=ply \
 //thickness=0.18 //x=43.075 //y=1.74 //x2=43.115 //y2=1.585
r380 (  108 127 ) resistor r=182.032 //w=0.094 //l=0.355 //layer=ply \
 //thickness=0.18 //x=43.075 //y=1.74 //x2=43.075 //y2=2.095
r381 (  107 135 ) resistor r=39.5823 //w=0.21 //l=0.173853 //layer=ply \
 //thickness=0.18 //x=43.075 //y=1.43 //x2=43.115 //y2=1.585
r382 (  106 134 ) resistor r=45.1352 //w=0.168 //l=0.173853 //layer=ply \
 //thickness=0.18 //x=43.075 //y=1.085 //x2=43.115 //y2=0.93
r383 (  106 107 ) resistor r=176.904 //w=0.094 //l=0.345 //layer=ply \
 //thickness=0.18 //x=43.075 //y=1.085 //x2=43.075 //y2=1.43
r384 (  105 120 ) resistor r=592.245 //w=0.094 //l=1.155 //layer=ply \
 //thickness=0.18 //x=43.52 //y=6.2 //x2=43.52 //y2=5.045
r385 (  104 133 ) resistor r=592.245 //w=0.094 //l=1.155 //layer=ply \
 //thickness=0.18 //x=43.08 //y=6.2 //x2=43.08 //y2=5.045
r386 (  103 117 ) resistor r=56.4043 //w=0.094 //l=0.11 //layer=ply \
 //thickness=0.18 //x=43.34 //y=1.585 //x2=43.45 //y2=1.585
r387 (  103 118 ) resistor r=56.4043 //w=0.094 //l=0.11 //layer=ply \
 //thickness=0.18 //x=43.34 //y=1.585 //x2=43.23 //y2=1.585
r388 (  87 142 ) resistor r=23.615 //w=0.187 //l=0.345 //layer=li \
 //thickness=0.1 //x=47.81 //y=5.56 //x2=47.81 //y2=5.905
r389 (  79 141 ) resistor r=23.615 //w=0.187 //l=0.345 //layer=li \
 //thickness=0.1 //x=46.93 //y=5.56 //x2=46.93 //y2=5.905
r390 (  71 140 ) resistor r=23.615 //w=0.187 //l=0.345 //layer=li \
 //thickness=0.1 //x=46.05 //y=5.56 //x2=46.05 //y2=5.905
r391 (  66 130 ) resistor r=152 //w=0.17 //l=0.17 //layer=licon //count=1 \
 //x=43.07 //y=4.88 //x2=43.07 //y2=4.88
r392 (  57 126 ) resistor r=152 //w=0.17 //l=0.17 //layer=licon //count=1 \
 //x=43.04 //y=2.26 //x2=43.04 //y2=2.26
r393 (  51 53 ) resistor r=0.10734 //w=0.281 //l=0.16 //layer=m2 \
 //thickness=0.36 //x=43.035 //y=4.265 //x2=43.195 //y2=4.265
r394 (  48 55 ) resistor r=0.28331 //w=0.241 //l=0.542218 //layer=m2 \
 //thickness=0.36 //x=48.065 //y=4.27 //x2=48.59 //y2=4.235
r395 (  48 49 ) resistor r=0.329198 //w=0.131 //l=0.345 //layer=m2 \
 //thickness=0.36 //x=48.065 //y=4.27 //x2=47.72 //y2=4.27
r396 (  46 49 ) resistor r=0.1875 //w=0.17 //l=0.264811 //layer=m2 \
 //thickness=0.36 //x=47.465 //y=4.25 //x2=47.72 //y2=4.27
r397 (  46 53 ) resistor r=4.07443 //w=0.131 //l=4.27 //layer=m2 \
 //thickness=0.36 //x=47.465 //y=4.25 //x2=43.195 //y2=4.25
r398 (  43 55 ) resistor r=4.5 //w=0.15 //l=0.15 //layer=via1 //count=1 \
 //x=48.59 //y=4.235 //x2=48.59 //y2=4.235
r399 (  43 45 ) resistor r=0.0049867 //w=0.376 //l=0.015 //layer=m1 \
 //thickness=0.36 //x=48.537 //y=4.235 //x2=48.537 //y2=4.25
r400 (  41 138 ) resistor r=9.3 //w=0.17 //l=0.17 //layer=mcon //count=1 \
 //x=48.105 //y=1.19 //x2=48.105 //y2=1.19
r401 (  39 87 ) resistor r=9.3 //w=0.17 //l=0.17 //layer=mcon //count=1 \
 //x=47.81 //y=5.56 //x2=47.81 //y2=5.56
r402 (  36 79 ) resistor r=9.3 //w=0.17 //l=0.17 //layer=mcon //count=1 \
 //x=46.93 //y=5.56 //x2=46.93 //y2=5.56
r403 (  34 36 ) resistor r=0.121228 //w=0.232 //l=0.225 //layer=m1 \
 //thickness=0.36 //x=46.93 //y=5.335 //x2=46.93 //y2=5.56
r404 (  33 71 ) resistor r=9.3 //w=0.17 //l=0.17 //layer=mcon //count=1 \
 //x=46.05 //y=5.56 //x2=46.05 //y2=5.56
r405 (  31 33 ) resistor r=0.129608 //w=0.217 //l=0.225 //layer=m1 \
 //thickness=0.36 //x=46.052 //y=5.335 //x2=46.052 //y2=5.56
r406 (  30 51 ) resistor r=4.5 //w=0.15 //l=0.15 //layer=via1 //count=1 \
 //x=43.035 //y=4.265 //x2=43.035 //y2=4.265
r407 (  28 30 ) resistor r=0.00494723 //w=0.379 //l=0.015 //layer=m1 \
 //thickness=0.36 //x=43.09 //y=4.25 //x2=43.09 //y2=4.265
r408 (  26 66 ) resistor r=9.3 //w=0.17 //l=0.17 //layer=mcon //count=1 \
 //x=43.07 //y=4.88 //x2=43.07 //y2=4.88
r409 (  22 57 ) resistor r=9.3 //w=0.17 //l=0.17 //layer=mcon //count=1 \
 //x=43.04 //y=2.26 //x2=43.04 //y2=2.26
r410 (  22 24 ) resistor r=0.0936408 //w=0.196 //l=0.125 //layer=m1 \
 //thickness=0.36 //x=43.042 //y=2.26 //x2=43.042 //y2=2.385
r411 (  19 45 ) resistor r=0.0861726 //w=0.376 //l=0.16944 //layer=m1 \
 //thickness=0.36 //x=48.59 //y=4.395 //x2=48.537 //y2=4.25
r412 (  19 20 ) resistor r=0.81584 //w=0.131 //l=0.855 //layer=m1 \
 //thickness=0.36 //x=48.59 //y=4.395 //x2=48.59 //y2=5.25
r413 (  18 43 ) resistor r=0.0911593 //w=0.376 //l=0.184608 //layer=m1 \
 //thickness=0.36 //x=48.59 //y=4.075 //x2=48.537 //y2=4.235
r414 (  17 18 ) resistor r=2.04676 //w=0.131 //l=2.145 //layer=m1 \
 //thickness=0.36 //x=48.59 //y=1.93 //x2=48.59 //y2=4.075
r415 (  15 17 ) resistor r=0.0698411 //w=0.17 //l=0.120208 //layer=m1 \
 //thickness=0.36 //x=48.505 //y=1.845 //x2=48.59 //y2=1.93
r416 (  15 16 ) resistor r=0.300573 //w=0.131 //l=0.315 //layer=m1 \
 //thickness=0.36 //x=48.505 //y=1.845 //x2=48.19 //y2=1.845
r417 (  14 16 ) resistor r=0.0698411 //w=0.17 //l=0.120208 //layer=m1 \
 //thickness=0.36 //x=48.105 //y=1.76 //x2=48.19 //y2=1.845
r418 (  13 41 ) resistor r=0.0717383 //w=0.224 //l=0.115 //layer=m1 \
 //thickness=0.36 //x=48.105 //y=1.305 //x2=48.105 //y2=1.19
r419 (  13 14 ) resistor r=0.43416 //w=0.131 //l=0.455 //layer=m1 \
 //thickness=0.36 //x=48.105 //y=1.305 //x2=48.105 //y2=1.76
r420 (  12 37 ) resistor r=0.0675342 //w=0.23 //l=0.115 //layer=m1 \
 //thickness=0.36 //x=47.925 //y=5.335 //x2=47.81 //y2=5.335
r421 (  11 20 ) resistor r=0.0698411 //w=0.17 //l=0.120208 //layer=m1 \
 //thickness=0.36 //x=48.505 //y=5.335 //x2=48.59 //y2=5.25
r422 (  11 12 ) resistor r=0.553435 //w=0.131 //l=0.58 //layer=m1 \
 //thickness=0.36 //x=48.505 //y=5.335 //x2=47.925 //y2=5.335
r423 (  10 39 ) resistor r=0.00118313 //w=0.23 //layer=m1 //thickness=0.36 \
 //x=47.81 //y=5.56 //x2=47.81 //y2=5.56
r424 (  9 37 ) resistor r=0.002872 //w=0.34 //l=0.085 //layer=m1 \
 //thickness=0.36 //x=47.81 //y=5.42 //x2=47.81 //y2=5.335
r425 (  9 10 ) resistor r=0.091623 //w=0.191 //l=0.14 //layer=m1 \
 //thickness=0.36 //x=47.81 //y=5.42 //x2=47.81 //y2=5.56
r426 (  8 34 ) resistor r=0.0262263 //w=0.232 //l=0.12 //layer=m1 \
 //thickness=0.36 //x=47.05 //y=5.335 //x2=46.93 //y2=5.335
r427 (  7 37 ) resistor r=0.0675342 //w=0.23 //l=0.115 //layer=m1 \
 //thickness=0.36 //x=47.695 //y=5.335 //x2=47.81 //y2=5.335
r428 (  7 8 ) resistor r=0.615458 //w=0.131 //l=0.645 //layer=m1 \
 //thickness=0.36 //x=47.695 //y=5.335 //x2=47.05 //y2=5.335
r429 (  6 31 ) resistor r=0.0222262 //w=0.217 //l=0.118 //layer=m1 \
 //thickness=0.36 //x=46.17 //y=5.335 //x2=46.052 //y2=5.335
r430 (  5 34 ) resistor r=0.0262263 //w=0.232 //l=0.12 //layer=m1 \
 //thickness=0.36 //x=46.81 //y=5.335 //x2=46.93 //y2=5.335
r431 (  5 6 ) resistor r=0.610687 //w=0.131 //l=0.64 //layer=m1 \
 //thickness=0.36 //x=46.81 //y=5.335 //x2=46.17 //y2=5.335
r432 (  4 26 ) resistor r=0.0878548 //w=0.228 //l=0.159295 //layer=m1 \
 //thickness=0.36 //x=43.04 //y=4.735 //x2=43.07 //y2=4.88
r433 (  3 30 ) resistor r=0.0912814 //w=0.379 //l=0.183303 //layer=m1 \
 //thickness=0.36 //x=43.04 //y=4.425 //x2=43.09 //y2=4.265
r434 (  3 4 ) resistor r=0.295802 //w=0.131 //l=0.31 //layer=m1 \
 //thickness=0.36 //x=43.04 //y=4.425 //x2=43.04 //y2=4.735
r435 (  2 28 ) resistor r=0.0863342 //w=0.379 //l=0.168152 //layer=m1 \
 //thickness=0.36 //x=43.04 //y=4.105 //x2=43.09 //y2=4.25
r436 (  2 24 ) resistor r=1.64122 //w=0.131 //l=1.72 //layer=m1 \
 //thickness=0.36 //x=43.04 //y=4.105 //x2=43.04 //y2=2.385
ends PM_TMRDFFSNQNX1\%noxref_10

subckt PM_TMRDFFSNQNX1\%D ( 1 2 3 4 5 6 7 8 9 10 11 12 13 17 26 31 32 37 40 48 \
 51 62 65 68 70 72 74 76 78 80 82 84 86 88 90 92 94 96 97 98 100 102 104 106 \
 108 110 112 114 116 118 120 125 131 140 145 154 159 168 172 173 174 175 176 \
 177 178 179 180 181 182 183 184 188 190 193 194 198 199 200 201 205 207 210 \
 211 215 216 217 218 222 224 227 228 238 247 256 )
c630 ( 256 0 ) capacitor c=0.0682508f //x=50.44 //y=4.88
c631 ( 247 0 ) capacitor c=0.0682508f //x=26.02 //y=4.88
c632 ( 238 0 ) capacitor c=0.0682508f //x=1.6 //y=4.88
c633 ( 228 0 ) capacitor c=0.0318956f //x=50.775 //y=1.39
c634 ( 227 0 ) capacitor c=0.0186809f //x=50.775 //y=1.045
c635 ( 224 0 ) capacitor c=0.0141821f //x=50.62 //y=1.545
c636 ( 222 0 ) capacitor c=0.0158553f //x=50.62 //y=0.89
c637 ( 218 0 ) capacitor c=0.0818299f //x=50.245 //y=2.095
c638 ( 217 0 ) capacitor c=0.0229235f //x=50.245 //y=1.7
c639 ( 216 0 ) capacitor c=0.0234359f //x=50.245 //y=1.39
c640 ( 215 0 ) capacitor c=0.0198759f //x=50.245 //y=1.045
c641 ( 211 0 ) capacitor c=0.0318956f //x=26.355 //y=1.39
c642 ( 210 0 ) capacitor c=0.0186809f //x=26.355 //y=1.045
c643 ( 207 0 ) capacitor c=0.0141821f //x=26.2 //y=1.545
c644 ( 205 0 ) capacitor c=0.0158553f //x=26.2 //y=0.89
c645 ( 201 0 ) capacitor c=0.0839659f //x=25.825 //y=2.095
c646 ( 200 0 ) capacitor c=0.0229235f //x=25.825 //y=1.7
c647 ( 199 0 ) capacitor c=0.0234359f //x=25.825 //y=1.39
c648 ( 198 0 ) capacitor c=0.0198759f //x=25.825 //y=1.045
c649 ( 194 0 ) capacitor c=0.0318956f //x=1.935 //y=1.39
c650 ( 193 0 ) capacitor c=0.0186809f //x=1.935 //y=1.045
c651 ( 190 0 ) capacitor c=0.0141821f //x=1.78 //y=1.545
c652 ( 188 0 ) capacitor c=0.0158553f //x=1.78 //y=0.89
c653 ( 184 0 ) capacitor c=0.0839759f //x=1.405 //y=2.095
c654 ( 183 0 ) capacitor c=0.0229235f //x=1.405 //y=1.7
c655 ( 182 0 ) capacitor c=0.0234359f //x=1.405 //y=1.39
c656 ( 181 0 ) capacitor c=0.0198759f //x=1.405 //y=1.045
c657 ( 180 0 ) capacitor c=0.110369f //x=50.78 //y=6.2
c658 ( 179 0 ) capacitor c=0.154619f //x=50.34 //y=6.2
c659 ( 178 0 ) capacitor c=0.110369f //x=26.36 //y=6.2
c660 ( 177 0 ) capacitor c=0.154619f //x=25.92 //y=6.2
c661 ( 176 0 ) capacitor c=0.110369f //x=1.94 //y=6.2
c662 ( 175 0 ) capacitor c=0.154619f //x=1.5 //y=6.2
c663 ( 168 0 ) capacitor c=8.13425e-19 //x=50.44 //y=4.88
c664 ( 159 0 ) capacitor c=5.17312e-19 //x=50.44 //y=2.26
c665 ( 154 0 ) capacitor c=8.13425e-19 //x=26.02 //y=4.88
c666 ( 145 0 ) capacitor c=5.17312e-19 //x=26.02 //y=2.26
c667 ( 140 0 ) capacitor c=8.13425e-19 //x=1.6 //y=4.88
c668 ( 131 0 ) capacitor c=5.17312e-19 //x=1.6 //y=2.26
c669 ( 125 0 ) capacitor c=0.0124948f //x=1.765 //y=3.145
c670 ( 120 0 ) capacitor c=0.0480646f //x=45.835 //y=3.17
c671 ( 118 0 ) capacitor c=0.0178477f //x=45.235 //y=3.14
c672 ( 116 0 ) capacitor c=0.00425342f //x=43.995 //y=3.17
c673 ( 114 0 ) capacitor c=0.0496763f //x=43.395 //y=3.14
c674 ( 112 0 ) capacitor c=0.00416317f //x=39.18 //y=3.17
c675 ( 110 0 ) capacitor c=0.0177421f //x=38.58 //y=3.14
c676 ( 108 0 ) capacitor c=0.00425641f //x=37.335 //y=3.17
c677 ( 106 0 ) capacitor c=0.0252286f //x=36.735 //y=3.14
c678 ( 104 0 ) capacitor c=0.00429096f //x=34.375 //y=3.16
c679 ( 102 0 ) capacitor c=0.0439077f //x=33.775 //y=3.14
c680 ( 100 0 ) capacitor c=0.00368608f //x=29.565 //y=3.155
c681 ( 98 0 ) capacitor c=0.0184713f //x=28.965 //y=3.14
c682 ( 97 0 ) capacitor c=0.0667142f //x=27.37 //y=3.155
c683 ( 96 0 ) capacitor c=0.00413336f //x=27.715 //y=3.155
c684 ( 94 0 ) capacitor c=0.00270184f //x=21.42 //y=3.11
c685 ( 92 0 ) capacitor c=0.0187627f //x=20.82 //y=3.14
c686 ( 90 0 ) capacitor c=0.00768878f //x=19.565 //y=3.11
c687 ( 88 0 ) capacitor c=0.0572827f //x=18.965 //y=3.14
c688 ( 86 0 ) capacitor c=0.00493425f //x=14.76 //y=3.17
c689 ( 84 0 ) capacitor c=0.0216919f //x=14.16 //y=3.14
c690 ( 82 0 ) capacitor c=0.00552914f //x=12.915 //y=3.17
c691 ( 80 0 ) capacitor c=0.036695f //x=12.315 //y=3.14
c692 ( 78 0 ) capacitor c=0.0081917f //x=9.955 //y=3.16
c693 ( 76 0 ) capacitor c=0.0560227f //x=9.355 //y=3.14
c694 ( 74 0 ) capacitor c=0.00556621f //x=5.145 //y=3.155
c695 ( 72 0 ) capacitor c=0.0259961f //x=4.545 //y=3.14
c696 ( 70 0 ) capacitor c=0.00631336f //x=3.295 //y=3.155
c697 ( 68 0 ) capacitor c=0.0314162f //x=2.695 //y=3.14
c698 ( 65 0 ) capacitor c=0.00623622f //x=50.44 //y=4.88
c699 ( 62 0 ) capacitor c=0.00463527f //x=50.44 //y=2.26
c700 ( 51 0 ) capacitor c=0.00624114f //x=26.02 //y=4.88
c701 ( 48 0 ) capacitor c=0.00463527f //x=26.02 //y=2.26
c702 ( 40 0 ) capacitor c=0.0111203f //x=1.6 //y=4.88
c703 ( 37 0 ) capacitor c=0.0101947f //x=1.6 //y=2.26
c704 ( 32 0 ) capacitor c=0.0155069f //x=50.44 //y=3.3
c705 ( 31 0 ) capacitor c=0.012456f //x=50.44 //y=2.98
c706 ( 26 0 ) capacitor c=0.0127747f //x=26.02 //y=3.285
c707 ( 17 0 ) capacitor c=0.0123502f //x=1.6 //y=3.305
c708 ( 13 0 ) capacitor c=0.0144067f //x=50.44 //y=3.14
c709 ( 12 0 ) capacitor c=0.0147327f //x=26.02 //y=3.14
c710 ( 11 0 ) capacitor c=0.0173037f //x=1.6 //y=3.14
c711 ( 9 0 ) capacitor c=0.0372494f //x=50.44 //y=3.88
c712 ( 7 0 ) capacitor c=0.0377342f //x=26.02 //y=3.88
c713 ( 6 0 ) capacitor c=0.0123253f //x=26.02 //y=2.77
c714 ( 2 0 ) capacitor c=0.0651614f //x=1.6 //y=3.51
c715 ( 1 0 ) capacitor c=0.0201611f //x=1.6 //y=2.77
r716 (  254 256 ) resistor r=20.6867 //w=0.233 //l=0.1 //layer=ply \
 //thickness=0.18 //x=50.34 //y=4.88 //x2=50.44 //y2=4.88
r717 (  245 247 ) resistor r=20.6867 //w=0.233 //l=0.1 //layer=ply \
 //thickness=0.18 //x=25.92 //y=4.88 //x2=26.02 //y2=4.88
r718 (  236 238 ) resistor r=20.6867 //w=0.233 //l=0.1 //layer=ply \
 //thickness=0.18 //x=1.5 //y=4.88 //x2=1.6 //y2=4.88
r719 (  229 256 ) resistor r=70.3348 //w=0.233 //l=0.414367 //layer=ply \
 //thickness=0.18 //x=50.78 //y=5.045 //x2=50.44 //y2=4.88
r720 (  228 258 ) resistor r=45.1352 //w=0.168 //l=0.173853 //layer=ply \
 //thickness=0.18 //x=50.775 //y=1.39 //x2=50.735 //y2=1.545
r721 (  227 257 ) resistor r=45.1352 //w=0.168 //l=0.173853 //layer=ply \
 //thickness=0.18 //x=50.775 //y=1.045 //x2=50.735 //y2=0.89
r722 (  227 228 ) resistor r=176.904 //w=0.094 //l=0.345 //layer=ply \
 //thickness=0.18 //x=50.775 //y=1.045 //x2=50.775 //y2=1.39
r723 (  225 253 ) resistor r=10.701 //w=0.21 //l=0.115 //layer=ply \
 //thickness=0.18 //x=50.4 //y=1.545 //x2=50.285 //y2=1.545
r724 (  224 258 ) resistor r=5.52526 //w=0.168 //l=0.115 //layer=ply \
 //thickness=0.18 //x=50.62 //y=1.545 //x2=50.735 //y2=1.545
r725 (  223 252 ) resistor r=5.52526 //w=0.168 //l=0.115 //layer=ply \
 //thickness=0.18 //x=50.4 //y=0.89 //x2=50.285 //y2=0.89
r726 (  222 257 ) resistor r=5.52526 //w=0.168 //l=0.115 //layer=ply \
 //thickness=0.18 //x=50.62 //y=0.89 //x2=50.735 //y2=0.89
r727 (  222 223 ) resistor r=112.809 //w=0.094 //l=0.22 //layer=ply \
 //thickness=0.18 //x=50.62 //y=0.89 //x2=50.4 //y2=0.89
r728 (  219 254 ) resistor r=13.0941 //w=0.233 //l=0.165 //layer=ply \
 //thickness=0.18 //x=50.34 //y=5.045 //x2=50.34 //y2=4.88
r729 (  218 251 ) resistor r=34.8111 //w=0.27 //l=0.264953 //layer=ply \
 //thickness=0.18 //x=50.245 //y=2.095 //x2=50.44 //y2=2.26
r730 (  217 253 ) resistor r=39.5823 //w=0.21 //l=0.173853 //layer=ply \
 //thickness=0.18 //x=50.245 //y=1.7 //x2=50.285 //y2=1.545
r731 (  217 218 ) resistor r=202.543 //w=0.094 //l=0.395 //layer=ply \
 //thickness=0.18 //x=50.245 //y=1.7 //x2=50.245 //y2=2.095
r732 (  216 253 ) resistor r=39.5823 //w=0.21 //l=0.173853 //layer=ply \
 //thickness=0.18 //x=50.245 //y=1.39 //x2=50.285 //y2=1.545
r733 (  215 252 ) resistor r=45.1352 //w=0.168 //l=0.173853 //layer=ply \
 //thickness=0.18 //x=50.245 //y=1.045 //x2=50.285 //y2=0.89
r734 (  215 216 ) resistor r=176.904 //w=0.094 //l=0.345 //layer=ply \
 //thickness=0.18 //x=50.245 //y=1.045 //x2=50.245 //y2=1.39
r735 (  212 247 ) resistor r=70.3348 //w=0.233 //l=0.414367 //layer=ply \
 //thickness=0.18 //x=26.36 //y=5.045 //x2=26.02 //y2=4.88
r736 (  211 249 ) resistor r=45.1352 //w=0.168 //l=0.173853 //layer=ply \
 //thickness=0.18 //x=26.355 //y=1.39 //x2=26.315 //y2=1.545
r737 (  210 248 ) resistor r=45.1352 //w=0.168 //l=0.173853 //layer=ply \
 //thickness=0.18 //x=26.355 //y=1.045 //x2=26.315 //y2=0.89
r738 (  210 211 ) resistor r=176.904 //w=0.094 //l=0.345 //layer=ply \
 //thickness=0.18 //x=26.355 //y=1.045 //x2=26.355 //y2=1.39
r739 (  208 244 ) resistor r=10.701 //w=0.21 //l=0.115 //layer=ply \
 //thickness=0.18 //x=25.98 //y=1.545 //x2=25.865 //y2=1.545
r740 (  207 249 ) resistor r=5.52526 //w=0.168 //l=0.115 //layer=ply \
 //thickness=0.18 //x=26.2 //y=1.545 //x2=26.315 //y2=1.545
r741 (  206 243 ) resistor r=5.52526 //w=0.168 //l=0.115 //layer=ply \
 //thickness=0.18 //x=25.98 //y=0.89 //x2=25.865 //y2=0.89
r742 (  205 248 ) resistor r=5.52526 //w=0.168 //l=0.115 //layer=ply \
 //thickness=0.18 //x=26.2 //y=0.89 //x2=26.315 //y2=0.89
r743 (  205 206 ) resistor r=112.809 //w=0.094 //l=0.22 //layer=ply \
 //thickness=0.18 //x=26.2 //y=0.89 //x2=25.98 //y2=0.89
r744 (  202 245 ) resistor r=13.0941 //w=0.233 //l=0.165 //layer=ply \
 //thickness=0.18 //x=25.92 //y=5.045 //x2=25.92 //y2=4.88
r745 (  201 242 ) resistor r=34.8111 //w=0.27 //l=0.264953 //layer=ply \
 //thickness=0.18 //x=25.825 //y=2.095 //x2=26.02 //y2=2.26
r746 (  200 244 ) resistor r=39.5823 //w=0.21 //l=0.173853 //layer=ply \
 //thickness=0.18 //x=25.825 //y=1.7 //x2=25.865 //y2=1.545
r747 (  200 201 ) resistor r=202.543 //w=0.094 //l=0.395 //layer=ply \
 //thickness=0.18 //x=25.825 //y=1.7 //x2=25.825 //y2=2.095
r748 (  199 244 ) resistor r=39.5823 //w=0.21 //l=0.173853 //layer=ply \
 //thickness=0.18 //x=25.825 //y=1.39 //x2=25.865 //y2=1.545
r749 (  198 243 ) resistor r=45.1352 //w=0.168 //l=0.173853 //layer=ply \
 //thickness=0.18 //x=25.825 //y=1.045 //x2=25.865 //y2=0.89
r750 (  198 199 ) resistor r=176.904 //w=0.094 //l=0.345 //layer=ply \
 //thickness=0.18 //x=25.825 //y=1.045 //x2=25.825 //y2=1.39
r751 (  195 238 ) resistor r=70.3348 //w=0.233 //l=0.414367 //layer=ply \
 //thickness=0.18 //x=1.94 //y=5.045 //x2=1.6 //y2=4.88
r752 (  194 240 ) resistor r=45.1352 //w=0.168 //l=0.173853 //layer=ply \
 //thickness=0.18 //x=1.935 //y=1.39 //x2=1.895 //y2=1.545
r753 (  193 239 ) resistor r=45.1352 //w=0.168 //l=0.173853 //layer=ply \
 //thickness=0.18 //x=1.935 //y=1.045 //x2=1.895 //y2=0.89
r754 (  193 194 ) resistor r=176.904 //w=0.094 //l=0.345 //layer=ply \
 //thickness=0.18 //x=1.935 //y=1.045 //x2=1.935 //y2=1.39
r755 (  191 235 ) resistor r=10.701 //w=0.21 //l=0.115 //layer=ply \
 //thickness=0.18 //x=1.56 //y=1.545 //x2=1.445 //y2=1.545
r756 (  190 240 ) resistor r=5.52526 //w=0.168 //l=0.115 //layer=ply \
 //thickness=0.18 //x=1.78 //y=1.545 //x2=1.895 //y2=1.545
r757 (  189 234 ) resistor r=5.52526 //w=0.168 //l=0.115 //layer=ply \
 //thickness=0.18 //x=1.56 //y=0.89 //x2=1.445 //y2=0.89
r758 (  188 239 ) resistor r=5.52526 //w=0.168 //l=0.115 //layer=ply \
 //thickness=0.18 //x=1.78 //y=0.89 //x2=1.895 //y2=0.89
r759 (  188 189 ) resistor r=112.809 //w=0.094 //l=0.22 //layer=ply \
 //thickness=0.18 //x=1.78 //y=0.89 //x2=1.56 //y2=0.89
r760 (  185 236 ) resistor r=13.0941 //w=0.233 //l=0.165 //layer=ply \
 //thickness=0.18 //x=1.5 //y=5.045 //x2=1.5 //y2=4.88
r761 (  184 233 ) resistor r=34.8111 //w=0.27 //l=0.264953 //layer=ply \
 //thickness=0.18 //x=1.405 //y=2.095 //x2=1.6 //y2=2.26
r762 (  183 235 ) resistor r=39.5823 //w=0.21 //l=0.173853 //layer=ply \
 //thickness=0.18 //x=1.405 //y=1.7 //x2=1.445 //y2=1.545
r763 (  183 184 ) resistor r=202.543 //w=0.094 //l=0.395 //layer=ply \
 //thickness=0.18 //x=1.405 //y=1.7 //x2=1.405 //y2=2.095
r764 (  182 235 ) resistor r=39.5823 //w=0.21 //l=0.173853 //layer=ply \
 //thickness=0.18 //x=1.405 //y=1.39 //x2=1.445 //y2=1.545
r765 (  181 234 ) resistor r=45.1352 //w=0.168 //l=0.173853 //layer=ply \
 //thickness=0.18 //x=1.405 //y=1.045 //x2=1.445 //y2=0.89
r766 (  181 182 ) resistor r=176.904 //w=0.094 //l=0.345 //layer=ply \
 //thickness=0.18 //x=1.405 //y=1.045 //x2=1.405 //y2=1.39
r767 (  180 229 ) resistor r=592.245 //w=0.094 //l=1.155 //layer=ply \
 //thickness=0.18 //x=50.78 //y=6.2 //x2=50.78 //y2=5.045
r768 (  179 219 ) resistor r=592.245 //w=0.094 //l=1.155 //layer=ply \
 //thickness=0.18 //x=50.34 //y=6.2 //x2=50.34 //y2=5.045
r769 (  178 212 ) resistor r=592.245 //w=0.094 //l=1.155 //layer=ply \
 //thickness=0.18 //x=26.36 //y=6.2 //x2=26.36 //y2=5.045
r770 (  177 202 ) resistor r=592.245 //w=0.094 //l=1.155 //layer=ply \
 //thickness=0.18 //x=25.92 //y=6.2 //x2=25.92 //y2=5.045
r771 (  176 195 ) resistor r=592.245 //w=0.094 //l=1.155 //layer=ply \
 //thickness=0.18 //x=1.94 //y=6.2 //x2=1.94 //y2=5.045
r772 (  175 185 ) resistor r=592.245 //w=0.094 //l=1.155 //layer=ply \
 //thickness=0.18 //x=1.5 //y=6.2 //x2=1.5 //y2=5.045
r773 (  174 224 ) resistor r=56.4043 //w=0.094 //l=0.11 //layer=ply \
 //thickness=0.18 //x=50.51 //y=1.545 //x2=50.62 //y2=1.545
r774 (  174 225 ) resistor r=56.4043 //w=0.094 //l=0.11 //layer=ply \
 //thickness=0.18 //x=50.51 //y=1.545 //x2=50.4 //y2=1.545
r775 (  173 207 ) resistor r=56.4043 //w=0.094 //l=0.11 //layer=ply \
 //thickness=0.18 //x=26.09 //y=1.545 //x2=26.2 //y2=1.545
r776 (  173 208 ) resistor r=56.4043 //w=0.094 //l=0.11 //layer=ply \
 //thickness=0.18 //x=26.09 //y=1.545 //x2=25.98 //y2=1.545
r777 (  172 190 ) resistor r=56.4043 //w=0.094 //l=0.11 //layer=ply \
 //thickness=0.18 //x=1.67 //y=1.545 //x2=1.78 //y2=1.545
r778 (  172 191 ) resistor r=56.4043 //w=0.094 //l=0.11 //layer=ply \
 //thickness=0.18 //x=1.67 //y=1.545 //x2=1.56 //y2=1.545
r779 (  168 256 ) resistor r=152 //w=0.17 //l=0.17 //layer=licon //count=1 \
 //x=50.44 //y=4.88 //x2=50.44 //y2=4.88
r780 (  159 251 ) resistor r=152 //w=0.17 //l=0.17 //layer=licon //count=1 \
 //x=50.44 //y=2.26 //x2=50.44 //y2=2.26
r781 (  154 247 ) resistor r=152 //w=0.17 //l=0.17 //layer=licon //count=1 \
 //x=26.02 //y=4.88 //x2=26.02 //y2=4.88
r782 (  145 242 ) resistor r=152 //w=0.17 //l=0.17 //layer=licon //count=1 \
 //x=26.02 //y=2.26 //x2=26.02 //y2=2.26
r783 (  140 238 ) resistor r=152 //w=0.17 //l=0.17 //layer=licon //count=1 \
 //x=1.6 //y=4.88 //x2=1.6 //y2=4.88
r784 (  131 233 ) resistor r=152 //w=0.17 //l=0.17 //layer=licon //count=1 \
 //x=1.6 //y=2.26 //x2=1.6 //y2=2.26
r785 (  123 125 ) resistor r=0.10734 //w=0.281 //l=0.16 //layer=m2 \
 //thickness=0.36 //x=1.605 //y=3.145 //x2=1.765 //y2=3.145
r786 (  120 129 ) resistor r=3.18087 //w=0.181 //l=4.61998 //layer=m2 \
 //thickness=0.36 //x=45.835 //y=3.17 //x2=50.44 //y2=3.14
r787 (  120 121 ) resistor r=0.329198 //w=0.131 //l=0.345 //layer=m2 \
 //thickness=0.36 //x=45.835 //y=3.17 //x2=45.49 //y2=3.17
r788 (  118 121 ) resistor r=0.1875 //w=0.17 //l=0.269583 //layer=m2 \
 //thickness=0.36 //x=45.235 //y=3.14 //x2=45.49 //y2=3.17
r789 (  118 119 ) resistor r=1.02099 //w=0.131 //l=1.07 //layer=m2 \
 //thickness=0.36 //x=45.235 //y=3.14 //x2=44.165 //y2=3.14
r790 (  116 119 ) resistor r=0.125 //w=0.17 //l=0.184391 //layer=m2 \
 //thickness=0.36 //x=43.995 //y=3.17 //x2=44.165 //y2=3.14
r791 (  116 117 ) resistor r=0.329198 //w=0.131 //l=0.345 //layer=m2 \
 //thickness=0.36 //x=43.995 //y=3.17 //x2=43.65 //y2=3.17
r792 (  114 117 ) resistor r=0.1875 //w=0.17 //l=0.269583 //layer=m2 \
 //thickness=0.36 //x=43.395 //y=3.14 //x2=43.65 //y2=3.17
r793 (  114 115 ) resistor r=3.85973 //w=0.131 //l=4.045 //layer=m2 \
 //thickness=0.36 //x=43.395 //y=3.14 //x2=39.35 //y2=3.14
r794 (  112 115 ) resistor r=0.125 //w=0.17 //l=0.184391 //layer=m2 \
 //thickness=0.36 //x=39.18 //y=3.17 //x2=39.35 //y2=3.14
r795 (  112 113 ) resistor r=0.329198 //w=0.131 //l=0.345 //layer=m2 \
 //thickness=0.36 //x=39.18 //y=3.17 //x2=38.835 //y2=3.17
r796 (  110 113 ) resistor r=0.1875 //w=0.17 //l=0.269583 //layer=m2 \
 //thickness=0.36 //x=38.58 //y=3.14 //x2=38.835 //y2=3.17
r797 (  110 111 ) resistor r=1.02576 //w=0.131 //l=1.075 //layer=m2 \
 //thickness=0.36 //x=38.58 //y=3.14 //x2=37.505 //y2=3.14
r798 (  108 111 ) resistor r=0.125 //w=0.17 //l=0.184391 //layer=m2 \
 //thickness=0.36 //x=37.335 //y=3.17 //x2=37.505 //y2=3.14
r799 (  108 109 ) resistor r=0.329198 //w=0.131 //l=0.345 //layer=m2 \
 //thickness=0.36 //x=37.335 //y=3.17 //x2=36.99 //y2=3.17
r800 (  106 109 ) resistor r=0.1875 //w=0.17 //l=0.269583 //layer=m2 \
 //thickness=0.36 //x=36.735 //y=3.14 //x2=36.99 //y2=3.17
r801 (  106 107 ) resistor r=2.08969 //w=0.131 //l=2.19 //layer=m2 \
 //thickness=0.36 //x=36.735 //y=3.14 //x2=34.545 //y2=3.14
r802 (  104 107 ) resistor r=0.125 //w=0.17 //l=0.179722 //layer=m2 \
 //thickness=0.36 //x=34.375 //y=3.16 //x2=34.545 //y2=3.14
r803 (  104 105 ) resistor r=0.329198 //w=0.131 //l=0.345 //layer=m2 \
 //thickness=0.36 //x=34.375 //y=3.16 //x2=34.03 //y2=3.16
r804 (  102 105 ) resistor r=0.1875 //w=0.17 //l=0.264811 //layer=m2 \
 //thickness=0.36 //x=33.775 //y=3.14 //x2=34.03 //y2=3.16
r805 (  102 103 ) resistor r=3.85496 //w=0.131 //l=4.04 //layer=m2 \
 //thickness=0.36 //x=33.775 //y=3.14 //x2=29.735 //y2=3.14
r806 (  100 103 ) resistor r=0.125 //w=0.17 //l=0.177341 //layer=m2 \
 //thickness=0.36 //x=29.565 //y=3.155 //x2=29.735 //y2=3.14
r807 (  100 101 ) resistor r=0.329198 //w=0.131 //l=0.345 //layer=m2 \
 //thickness=0.36 //x=29.565 //y=3.155 //x2=29.22 //y2=3.155
r808 (  98 101 ) resistor r=0.1875 //w=0.17 //l=0.262393 //layer=m2 \
 //thickness=0.36 //x=28.965 //y=3.14 //x2=29.22 //y2=3.155
r809 (  98 99 ) resistor r=1.03053 //w=0.131 //l=1.08 //layer=m2 \
 //thickness=0.36 //x=28.965 //y=3.14 //x2=27.885 //y2=3.14
r810 (  97 127 ) resistor r=0.939686 //w=0.179 //l=1.35992 //layer=m2 \
 //thickness=0.36 //x=27.37 //y=3.155 //x2=26.025 //y2=3.125
r811 (  96 99 ) resistor r=0.125 //w=0.17 //l=0.177341 //layer=m2 \
 //thickness=0.36 //x=27.715 //y=3.155 //x2=27.885 //y2=3.14
r812 (  96 97 ) resistor r=0.329198 //w=0.131 //l=0.345 //layer=m2 \
 //thickness=0.36 //x=27.715 //y=3.155 //x2=27.37 //y2=3.155
r813 (  94 127 ) resistor r=3.21622 //w=0.179 //l=4.61249 //layer=m2 \
 //thickness=0.36 //x=21.42 //y=3.11 //x2=26.025 //y2=3.125
r814 (  94 95 ) resistor r=0.410305 //w=0.131 //l=0.43 //layer=m2 \
 //thickness=0.36 //x=21.42 //y=3.11 //x2=20.99 //y2=3.11
r815 (  92 95 ) resistor r=0.125 //w=0.17 //l=0.184391 //layer=m2 \
 //thickness=0.36 //x=20.82 //y=3.14 //x2=20.99 //y2=3.11
r816 (  92 93 ) resistor r=0.954198 //w=0.131 //l=1 //layer=m2 \
 //thickness=0.36 //x=20.82 //y=3.14 //x2=19.82 //y2=3.14
r817 (  90 93 ) resistor r=0.1875 //w=0.17 //l=0.269583 //layer=m2 \
 //thickness=0.36 //x=19.565 //y=3.11 //x2=19.82 //y2=3.14
r818 (  90 91 ) resistor r=0.410305 //w=0.131 //l=0.43 //layer=m2 \
 //thickness=0.36 //x=19.565 //y=3.11 //x2=19.135 //y2=3.11
r819 (  88 91 ) resistor r=0.125 //w=0.17 //l=0.184391 //layer=m2 \
 //thickness=0.36 //x=18.965 //y=3.14 //x2=19.135 //y2=3.11
r820 (  88 89 ) resistor r=3.85019 //w=0.131 //l=4.035 //layer=m2 \
 //thickness=0.36 //x=18.965 //y=3.14 //x2=14.93 //y2=3.14
r821 (  86 89 ) resistor r=0.125 //w=0.17 //l=0.184391 //layer=m2 \
 //thickness=0.36 //x=14.76 //y=3.17 //x2=14.93 //y2=3.14
r822 (  86 87 ) resistor r=0.329198 //w=0.131 //l=0.345 //layer=m2 \
 //thickness=0.36 //x=14.76 //y=3.17 //x2=14.415 //y2=3.17
r823 (  84 87 ) resistor r=0.1875 //w=0.17 //l=0.269583 //layer=m2 \
 //thickness=0.36 //x=14.16 //y=3.14 //x2=14.415 //y2=3.17
r824 (  84 85 ) resistor r=1.02576 //w=0.131 //l=1.075 //layer=m2 \
 //thickness=0.36 //x=14.16 //y=3.14 //x2=13.085 //y2=3.14
r825 (  82 85 ) resistor r=0.125 //w=0.17 //l=0.184391 //layer=m2 \
 //thickness=0.36 //x=12.915 //y=3.17 //x2=13.085 //y2=3.14
r826 (  82 83 ) resistor r=0.329198 //w=0.131 //l=0.345 //layer=m2 \
 //thickness=0.36 //x=12.915 //y=3.17 //x2=12.57 //y2=3.17
r827 (  80 83 ) resistor r=0.1875 //w=0.17 //l=0.269583 //layer=m2 \
 //thickness=0.36 //x=12.315 //y=3.14 //x2=12.57 //y2=3.17
r828 (  80 81 ) resistor r=2.08969 //w=0.131 //l=2.19 //layer=m2 \
 //thickness=0.36 //x=12.315 //y=3.14 //x2=10.125 //y2=3.14
r829 (  78 81 ) resistor r=0.125 //w=0.17 //l=0.179722 //layer=m2 \
 //thickness=0.36 //x=9.955 //y=3.16 //x2=10.125 //y2=3.14
r830 (  78 79 ) resistor r=0.329198 //w=0.131 //l=0.345 //layer=m2 \
 //thickness=0.36 //x=9.955 //y=3.16 //x2=9.61 //y2=3.16
r831 (  76 79 ) resistor r=0.1875 //w=0.17 //l=0.264811 //layer=m2 \
 //thickness=0.36 //x=9.355 //y=3.14 //x2=9.61 //y2=3.16
r832 (  76 77 ) resistor r=3.85496 //w=0.131 //l=4.04 //layer=m2 \
 //thickness=0.36 //x=9.355 //y=3.14 //x2=5.315 //y2=3.14
r833 (  74 77 ) resistor r=0.125 //w=0.17 //l=0.177341 //layer=m2 \
 //thickness=0.36 //x=5.145 //y=3.155 //x2=5.315 //y2=3.14
r834 (  74 75 ) resistor r=0.329198 //w=0.131 //l=0.345 //layer=m2 \
 //thickness=0.36 //x=5.145 //y=3.155 //x2=4.8 //y2=3.155
r835 (  72 75 ) resistor r=0.1875 //w=0.17 //l=0.262393 //layer=m2 \
 //thickness=0.36 //x=4.545 //y=3.14 //x2=4.8 //y2=3.155
r836 (  72 73 ) resistor r=1.03053 //w=0.131 //l=1.08 //layer=m2 \
 //thickness=0.36 //x=4.545 //y=3.14 //x2=3.465 //y2=3.14
r837 (  70 73 ) resistor r=0.125 //w=0.17 //l=0.177341 //layer=m2 \
 //thickness=0.36 //x=3.295 //y=3.155 //x2=3.465 //y2=3.14
r838 (  70 71 ) resistor r=0.329198 //w=0.131 //l=0.345 //layer=m2 \
 //thickness=0.36 //x=3.295 //y=3.155 //x2=2.95 //y2=3.155
r839 (  68 71 ) resistor r=0.1875 //w=0.17 //l=0.262393 //layer=m2 \
 //thickness=0.36 //x=2.695 //y=3.14 //x2=2.95 //y2=3.155
r840 (  68 125 ) resistor r=0.887405 //w=0.131 //l=0.93 //layer=m2 \
 //thickness=0.36 //x=2.695 //y=3.14 //x2=1.765 //y2=3.14
r841 (  65 168 ) resistor r=9.3 //w=0.17 //l=0.17 //layer=mcon //count=1 \
 //x=50.44 //y=4.88 //x2=50.44 //y2=4.88
r842 (  65 66 ) resistor r=0.103207 //w=0.196 //l=0.14 //layer=m1 \
 //thickness=0.36 //x=50.442 //y=4.88 //x2=50.442 //y2=4.74
r843 (  62 159 ) resistor r=9.3 //w=0.17 //l=0.17 //layer=mcon //count=1 \
 //x=50.44 //y=2.26 //x2=50.44 //y2=2.26
r844 (  55 127 ) resistor r=4.5 //w=0.15 //l=0.15 //layer=via1 //count=1 \
 //x=26.025 //y=3.125 //x2=26.025 //y2=3.125
r845 (  51 154 ) resistor r=9.3 //w=0.17 //l=0.17 //layer=mcon //count=1 \
 //x=26.02 //y=4.88 //x2=26.02 //y2=4.88
r846 (  51 52 ) resistor r=0.103207 //w=0.196 //l=0.14 //layer=m1 \
 //thickness=0.36 //x=26.022 //y=4.88 //x2=26.022 //y2=4.74
r847 (  48 145 ) resistor r=9.3 //w=0.17 //l=0.17 //layer=mcon //count=1 \
 //x=26.02 //y=2.26 //x2=26.02 //y2=2.26
r848 (  46 123 ) resistor r=4.5 //w=0.15 //l=0.15 //layer=via1 //count=1 \
 //x=1.605 //y=3.145 //x2=1.605 //y2=3.145
r849 (  40 140 ) resistor r=9.3 //w=0.17 //l=0.17 //layer=mcon //count=1 \
 //x=1.6 //y=4.88 //x2=1.6 //y2=4.88
r850 (  40 41 ) resistor r=0.103207 //w=0.196 //l=0.14 //layer=m1 \
 //thickness=0.36 //x=1.602 //y=4.88 //x2=1.602 //y2=4.74
r851 (  37 131 ) resistor r=9.3 //w=0.17 //l=0.17 //layer=mcon //count=1 \
 //x=1.6 //y=2.26 //x2=1.6 //y2=2.26
r852 (  30 62 ) resistor r=0.0933015 //w=0.201 //l=0.125 //layer=m1 \
 //thickness=0.36 //x=50.44 //y=2.385 //x2=50.44 //y2=2.26
r853 (  30 31 ) resistor r=0.567748 //w=0.131 //l=0.595 //layer=m1 \
 //thickness=0.36 //x=50.44 //y=2.385 //x2=50.44 //y2=2.98
r854 (  24 55 ) resistor r=0.0910802 //w=0.374 //l=0.185472 //layer=m1 \
 //thickness=0.36 //x=26.02 //y=2.965 //x2=26.075 //y2=3.125
r855 (  23 48 ) resistor r=0.0933015 //w=0.201 //l=0.125 //layer=m1 \
 //thickness=0.36 //x=26.02 //y=2.385 //x2=26.02 //y2=2.26
r856 (  17 46 ) resistor r=0.0910802 //w=0.374 //l=0.185472 //layer=m1 \
 //thickness=0.36 //x=1.6 //y=3.305 //x2=1.655 //y2=3.145
r857 (  14 37 ) resistor r=0.0933015 //w=0.201 //l=0.125 //layer=m1 \
 //thickness=0.36 //x=1.6 //y=2.385 //x2=1.6 //y2=2.26
r858 (  13 129 ) resistor r=4.5 //w=0.15 //l=0.15 //layer=via1 //count=1 \
 //x=50.44 //y=3.14 //x2=50.44 //y2=3.14
r859 (  13 32 ) resistor r=0.0911593 //w=0.376 //l=0.184608 //layer=m1 \
 //thickness=0.36 //x=50.387 //y=3.14 //x2=50.44 //y2=3.3
r860 (  13 31 ) resistor r=0.0911593 //w=0.376 //l=0.184608 //layer=m1 \
 //thickness=0.36 //x=50.387 //y=3.14 //x2=50.44 //y2=2.98
r861 (  12 26 ) resistor r=0.0860668 //w=0.374 //l=0.170294 //layer=m1 \
 //thickness=0.36 //x=26.075 //y=3.14 //x2=26.02 //y2=3.285
r862 (  12 55 ) resistor r=0.00501337 //w=0.374 //l=0.015 //layer=m1 \
 //thickness=0.36 //x=26.075 //y=3.14 //x2=26.075 //y2=3.125
r863 (  11 46 ) resistor r=0.00167112 //w=0.374 //l=0.005 //layer=m1 \
 //thickness=0.36 //x=1.655 //y=3.14 //x2=1.655 //y2=3.145
r864 (  11 15 ) resistor r=0.089409 //w=0.374 //l=0.180416 //layer=m1 \
 //thickness=0.36 //x=1.655 //y=3.14 //x2=1.6 //y2=2.985
r865 (  10 66 ) resistor r=0.467557 //w=0.131 //l=0.49 //layer=m1 \
 //thickness=0.36 //x=50.44 //y=4.25 //x2=50.44 //y2=4.74
r866 (  9 10 ) resistor r=0.353053 //w=0.131 //l=0.37 //layer=m1 \
 //thickness=0.36 //x=50.44 //y=3.88 //x2=50.44 //y2=4.25
r867 (  9 32 ) resistor r=0.553435 //w=0.131 //l=0.58 //layer=m1 \
 //thickness=0.36 //x=50.44 //y=3.88 //x2=50.44 //y2=3.3
r868 (  8 52 ) resistor r=0.467557 //w=0.131 //l=0.49 //layer=m1 \
 //thickness=0.36 //x=26.02 //y=4.25 //x2=26.02 //y2=4.74
r869 (  7 8 ) resistor r=0.353053 //w=0.131 //l=0.37 //layer=m1 \
 //thickness=0.36 //x=26.02 //y=3.88 //x2=26.02 //y2=4.25
r870 (  7 26 ) resistor r=0.567748 //w=0.131 //l=0.595 //layer=m1 \
 //thickness=0.36 //x=26.02 //y=3.88 //x2=26.02 //y2=3.285
r871 (  6 24 ) resistor r=0.186069 //w=0.131 //l=0.195 //layer=m1 \
 //thickness=0.36 //x=26.02 //y=2.77 //x2=26.02 //y2=2.965
r872 (  6 23 ) resistor r=0.367366 //w=0.131 //l=0.385 //layer=m1 \
 //thickness=0.36 //x=26.02 //y=2.77 //x2=26.02 //y2=2.385
r873 (  5 41 ) resistor r=0.114504 //w=0.131 //l=0.12 //layer=m1 \
 //thickness=0.36 //x=1.6 //y=4.62 //x2=1.6 //y2=4.74
r874 (  4 5 ) resistor r=0.353053 //w=0.131 //l=0.37 //layer=m1 \
 //thickness=0.36 //x=1.6 //y=4.25 //x2=1.6 //y2=4.62
r875 (  3 4 ) resistor r=0.353053 //w=0.131 //l=0.37 //layer=m1 \
 //thickness=0.36 //x=1.6 //y=3.88 //x2=1.6 //y2=4.25
r876 (  2 3 ) resistor r=0.353053 //w=0.131 //l=0.37 //layer=m1 \
 //thickness=0.36 //x=1.6 //y=3.51 //x2=1.6 //y2=3.88
r877 (  2 17 ) resistor r=0.195611 //w=0.131 //l=0.205 //layer=m1 \
 //thickness=0.36 //x=1.6 //y=3.51 //x2=1.6 //y2=3.305
r878 (  1 15 ) resistor r=0.205153 //w=0.131 //l=0.215 //layer=m1 \
 //thickness=0.36 //x=1.6 //y=2.77 //x2=1.6 //y2=2.985
r879 (  1 14 ) resistor r=0.367366 //w=0.131 //l=0.385 //layer=m1 \
 //thickness=0.36 //x=1.6 //y=2.77 //x2=1.6 //y2=2.385
ends PM_TMRDFFSNQNX1\%D

subckt PM_TMRDFFSNQNX1\%noxref_12 ( 3 8 9 11 12 14 15 16 17 18 19 20 21 22 23 \
 24 27 28 31 33 36 43 47 54 55 57 64 65 68 76 93 102 107 116 120 121 122 123 \
 124 125 126 127 128 129 130 132 138 139 140 141 145 146 147 148 149 151 157 \
 158 159 160 180 182 183 )
c430 ( 180 0 ) capacitor c=0.00878249f //x=51.29 //y=1.085
c431 ( 160 0 ) capacitor c=0.0612936f //x=58.855 //y=4.97
c432 ( 159 0 ) capacitor c=0.0376642f //x=59.145 //y=4.97
c433 ( 158 0 ) capacitor c=0.0346489f //x=58.81 //y=1.4
c434 ( 157 0 ) capacitor c=0.018692f //x=58.81 //y=1.055
c435 ( 151 0 ) capacitor c=0.0137077f //x=58.655 //y=1.555
c436 ( 149 0 ) capacitor c=0.0158585f //x=58.655 //y=0.9
c437 ( 148 0 ) capacitor c=0.0979511f //x=58.28 //y=2.095
c438 ( 147 0 ) capacitor c=0.0229444f //x=58.28 //y=1.71
c439 ( 146 0 ) capacitor c=0.0234359f //x=58.28 //y=1.4
c440 ( 145 0 ) capacitor c=0.019815f //x=58.28 //y=1.055
c441 ( 141 0 ) capacitor c=0.0612936f //x=54.045 //y=4.97
c442 ( 140 0 ) capacitor c=0.0376642f //x=54.335 //y=4.97
c443 ( 139 0 ) capacitor c=0.0346489f //x=54 //y=1.4
c444 ( 138 0 ) capacitor c=0.018692f //x=54 //y=1.055
c445 ( 132 0 ) capacitor c=0.0137077f //x=53.845 //y=1.555
c446 ( 130 0 ) capacitor c=0.0158585f //x=53.845 //y=0.9
c447 ( 129 0 ) capacitor c=0.099553f //x=53.47 //y=2.095
c448 ( 128 0 ) capacitor c=0.0229444f //x=53.47 //y=1.71
c449 ( 127 0 ) capacitor c=0.0234359f //x=53.47 //y=1.4
c450 ( 126 0 ) capacitor c=0.019815f //x=53.47 //y=1.055
c451 ( 125 0 ) capacitor c=0.110208f //x=59.22 //y=6.2
c452 ( 124 0 ) capacitor c=0.158957f //x=58.78 //y=6.2
c453 ( 123 0 ) capacitor c=0.110208f //x=54.41 //y=6.2
c454 ( 122 0 ) capacitor c=0.158957f //x=53.97 //y=6.2
c455 ( 116 0 ) capacitor c=0.0014751f //x=58.58 //y=4.88
c456 ( 107 0 ) capacitor c=9.93222e-19 //x=58.58 //y=2.26
c457 ( 102 0 ) capacitor c=0.0014751f //x=53.77 //y=4.88
c458 ( 93 0 ) capacitor c=9.93222e-19 //x=53.77 //y=2.26
c459 ( 76 0 ) capacitor c=0.0322017f //x=51.44 //y=5.56
c460 ( 68 0 ) capacitor c=0.0290186f //x=50.56 //y=5.56
c461 ( 65 0 ) capacitor c=0.0398037f //x=58.42 //y=2.775
c462 ( 64 0 ) capacitor c=6.56496e-19 //x=58.58 //y=2.775
c463 ( 57 0 ) capacitor c=6.57651e-19 //x=53.93 //y=2.77
c464 ( 55 0 ) capacitor c=8.02114e-19 //x=52.08 //y=2.77
c465 ( 54 0 ) capacitor c=0.0166477f //x=53.61 //y=2.77
c466 ( 47 0 ) capacitor c=0.0154699f //x=58.58 //y=2.77
c467 ( 43 0 ) capacitor c=0.0146914f //x=53.77 //y=2.765
c468 ( 36 0 ) capacitor c=0.0146635f //x=51.92 //y=2.77
c469 ( 33 0 ) capacitor c=0.011349f //x=51.48 //y=1.18
c470 ( 31 0 ) capacitor c=5.78613e-19 //x=51.44 //y=5.56
c471 ( 28 0 ) capacitor c=0.0108509f //x=51.44 //y=5.38
c472 ( 27 0 ) capacitor c=0.00937287f //x=50.56 //y=5.56
c473 ( 24 0 ) capacitor c=0.0606206f //x=58.58 //y=4.755
c474 ( 23 0 ) capacitor c=0.0130119f //x=58.58 //y=2.935
c475 ( 22 0 ) capacitor c=0.00415551f //x=58.58 //y=2.615
c476 ( 21 0 ) capacitor c=0.00474211f //x=58.58 //y=2.375
c477 ( 20 0 ) capacitor c=0.0635672f //x=53.77 //y=4.755
c478 ( 19 0 ) capacitor c=0.0130033f //x=53.77 //y=2.93
c479 ( 18 0 ) capacitor c=0.00452361f //x=53.77 //y=2.61
c480 ( 17 0 ) capacitor c=0.00485545f //x=53.77 //y=2.375
c481 ( 16 0 ) capacitor c=0.0657698f //x=51.92 //y=5.295
c482 ( 15 0 ) capacitor c=0.0123242f //x=51.92 //y=2.93
c483 ( 14 0 ) capacitor c=0.0175872f //x=51.92 //y=2.61
c484 ( 12 0 ) capacitor c=0.0046997f //x=51.565 //y=1.835
c485 ( 11 0 ) capacitor c=0.0117163f //x=51.835 //y=1.835
c486 ( 9 0 ) capacitor c=0.011753f //x=51.835 //y=5.38
c487 ( 8 0 ) capacitor c=0.0134844f //x=51.48 //y=1.75
c488 ( 3 0 ) capacitor c=0.0144605f //x=51.325 //y=5.38
r489 (  159 161 ) resistor r=26.9307 //w=0.15 //l=0.106066 //layer=ply \
 //thickness=0.18 //x=59.145 //y=4.97 //x2=59.22 //y2=5.045
r490 (  159 160 ) resistor r=148.702 //w=0.094 //l=0.29 //layer=ply \
 //thickness=0.18 //x=59.145 //y=4.97 //x2=58.855 //y2=4.97
r491 (  158 179 ) resistor r=45.1352 //w=0.168 //l=0.173853 //layer=ply \
 //thickness=0.18 //x=58.81 //y=1.4 //x2=58.77 //y2=1.555
r492 (  157 178 ) resistor r=45.1352 //w=0.168 //l=0.173853 //layer=ply \
 //thickness=0.18 //x=58.81 //y=1.055 //x2=58.77 //y2=0.9
r493 (  157 158 ) resistor r=176.904 //w=0.094 //l=0.345 //layer=ply \
 //thickness=0.18 //x=58.81 //y=1.055 //x2=58.81 //y2=1.4
r494 (  154 160 ) resistor r=22.7971 //w=0.269 //l=0.106066 //layer=ply \
 //thickness=0.18 //x=58.78 //y=5.045 //x2=58.855 //y2=4.97
r495 (  154 177 ) resistor r=35.8364 //w=0.269 //l=0.270185 //layer=ply \
 //thickness=0.18 //x=58.78 //y=5.045 //x2=58.58 //y2=4.88
r496 (  152 173 ) resistor r=10.701 //w=0.21 //l=0.115 //layer=ply \
 //thickness=0.18 //x=58.435 //y=1.555 //x2=58.32 //y2=1.555
r497 (  151 179 ) resistor r=5.52526 //w=0.168 //l=0.115 //layer=ply \
 //thickness=0.18 //x=58.655 //y=1.555 //x2=58.77 //y2=1.555
r498 (  150 172 ) resistor r=5.52526 //w=0.168 //l=0.115 //layer=ply \
 //thickness=0.18 //x=58.435 //y=0.9 //x2=58.32 //y2=0.9
r499 (  149 178 ) resistor r=5.52526 //w=0.168 //l=0.115 //layer=ply \
 //thickness=0.18 //x=58.655 //y=0.9 //x2=58.77 //y2=0.9
r500 (  149 150 ) resistor r=112.809 //w=0.094 //l=0.22 //layer=ply \
 //thickness=0.18 //x=58.655 //y=0.9 //x2=58.435 //y2=0.9
r501 (  148 175 ) resistor r=58.7805 //w=0.246 //l=0.373497 //layer=ply \
 //thickness=0.18 //x=58.28 //y=2.095 //x2=58.58 //y2=2.26
r502 (  147 173 ) resistor r=39.5823 //w=0.21 //l=0.173853 //layer=ply \
 //thickness=0.18 //x=58.28 //y=1.71 //x2=58.32 //y2=1.555
r503 (  147 148 ) resistor r=197.415 //w=0.094 //l=0.385 //layer=ply \
 //thickness=0.18 //x=58.28 //y=1.71 //x2=58.28 //y2=2.095
r504 (  146 173 ) resistor r=39.5823 //w=0.21 //l=0.173853 //layer=ply \
 //thickness=0.18 //x=58.28 //y=1.4 //x2=58.32 //y2=1.555
r505 (  145 172 ) resistor r=45.1352 //w=0.168 //l=0.173853 //layer=ply \
 //thickness=0.18 //x=58.28 //y=1.055 //x2=58.32 //y2=0.9
r506 (  145 146 ) resistor r=176.904 //w=0.094 //l=0.345 //layer=ply \
 //thickness=0.18 //x=58.28 //y=1.055 //x2=58.28 //y2=1.4
r507 (  140 142 ) resistor r=26.9307 //w=0.15 //l=0.106066 //layer=ply \
 //thickness=0.18 //x=54.335 //y=4.97 //x2=54.41 //y2=5.045
r508 (  140 141 ) resistor r=148.702 //w=0.094 //l=0.29 //layer=ply \
 //thickness=0.18 //x=54.335 //y=4.97 //x2=54.045 //y2=4.97
r509 (  139 171 ) resistor r=45.1352 //w=0.168 //l=0.173853 //layer=ply \
 //thickness=0.18 //x=54 //y=1.4 //x2=53.96 //y2=1.555
r510 (  138 170 ) resistor r=45.1352 //w=0.168 //l=0.173853 //layer=ply \
 //thickness=0.18 //x=54 //y=1.055 //x2=53.96 //y2=0.9
r511 (  138 139 ) resistor r=176.904 //w=0.094 //l=0.345 //layer=ply \
 //thickness=0.18 //x=54 //y=1.055 //x2=54 //y2=1.4
r512 (  135 141 ) resistor r=22.7971 //w=0.269 //l=0.106066 //layer=ply \
 //thickness=0.18 //x=53.97 //y=5.045 //x2=54.045 //y2=4.97
r513 (  135 169 ) resistor r=35.8364 //w=0.269 //l=0.270185 //layer=ply \
 //thickness=0.18 //x=53.97 //y=5.045 //x2=53.77 //y2=4.88
r514 (  133 165 ) resistor r=10.701 //w=0.21 //l=0.115 //layer=ply \
 //thickness=0.18 //x=53.625 //y=1.555 //x2=53.51 //y2=1.555
r515 (  132 171 ) resistor r=5.52526 //w=0.168 //l=0.115 //layer=ply \
 //thickness=0.18 //x=53.845 //y=1.555 //x2=53.96 //y2=1.555
r516 (  131 164 ) resistor r=5.52526 //w=0.168 //l=0.115 //layer=ply \
 //thickness=0.18 //x=53.625 //y=0.9 //x2=53.51 //y2=0.9
r517 (  130 170 ) resistor r=5.52526 //w=0.168 //l=0.115 //layer=ply \
 //thickness=0.18 //x=53.845 //y=0.9 //x2=53.96 //y2=0.9
r518 (  130 131 ) resistor r=112.809 //w=0.094 //l=0.22 //layer=ply \
 //thickness=0.18 //x=53.845 //y=0.9 //x2=53.625 //y2=0.9
r519 (  129 167 ) resistor r=58.7805 //w=0.246 //l=0.373497 //layer=ply \
 //thickness=0.18 //x=53.47 //y=2.095 //x2=53.77 //y2=2.26
r520 (  128 165 ) resistor r=39.5823 //w=0.21 //l=0.173853 //layer=ply \
 //thickness=0.18 //x=53.47 //y=1.71 //x2=53.51 //y2=1.555
r521 (  128 129 ) resistor r=197.415 //w=0.094 //l=0.385 //layer=ply \
 //thickness=0.18 //x=53.47 //y=1.71 //x2=53.47 //y2=2.095
r522 (  127 165 ) resistor r=39.5823 //w=0.21 //l=0.173853 //layer=ply \
 //thickness=0.18 //x=53.47 //y=1.4 //x2=53.51 //y2=1.555
r523 (  126 164 ) resistor r=45.1352 //w=0.168 //l=0.173853 //layer=ply \
 //thickness=0.18 //x=53.47 //y=1.055 //x2=53.51 //y2=0.9
r524 (  126 127 ) resistor r=176.904 //w=0.094 //l=0.345 //layer=ply \
 //thickness=0.18 //x=53.47 //y=1.055 //x2=53.47 //y2=1.4
r525 (  125 161 ) resistor r=592.245 //w=0.094 //l=1.155 //layer=ply \
 //thickness=0.18 //x=59.22 //y=6.2 //x2=59.22 //y2=5.045
r526 (  124 154 ) resistor r=592.245 //w=0.094 //l=1.155 //layer=ply \
 //thickness=0.18 //x=58.78 //y=6.2 //x2=58.78 //y2=5.045
r527 (  123 142 ) resistor r=592.245 //w=0.094 //l=1.155 //layer=ply \
 //thickness=0.18 //x=54.41 //y=6.2 //x2=54.41 //y2=5.045
r528 (  122 135 ) resistor r=592.245 //w=0.094 //l=1.155 //layer=ply \
 //thickness=0.18 //x=53.97 //y=6.2 //x2=53.97 //y2=5.045
r529 (  121 151 ) resistor r=56.4043 //w=0.094 //l=0.11 //layer=ply \
 //thickness=0.18 //x=58.545 //y=1.555 //x2=58.655 //y2=1.555
r530 (  121 152 ) resistor r=56.4043 //w=0.094 //l=0.11 //layer=ply \
 //thickness=0.18 //x=58.545 //y=1.555 //x2=58.435 //y2=1.555
r531 (  120 132 ) resistor r=56.4043 //w=0.094 //l=0.11 //layer=ply \
 //thickness=0.18 //x=53.735 //y=1.555 //x2=53.845 //y2=1.555
r532 (  120 133 ) resistor r=56.4043 //w=0.094 //l=0.11 //layer=ply \
 //thickness=0.18 //x=53.735 //y=1.555 //x2=53.625 //y2=1.555
r533 (  116 177 ) resistor r=152 //w=0.17 //l=0.17 //layer=licon //count=1 \
 //x=58.58 //y=4.88 //x2=58.58 //y2=4.88
r534 (  107 175 ) resistor r=152 //w=0.17 //l=0.17 //layer=licon //count=1 \
 //x=58.58 //y=2.26 //x2=58.58 //y2=2.26
r535 (  102 169 ) resistor r=152 //w=0.17 //l=0.17 //layer=licon //count=1 \
 //x=53.77 //y=4.88 //x2=53.77 //y2=4.88
r536 (  93 167 ) resistor r=152 //w=0.17 //l=0.17 //layer=licon //count=1 \
 //x=53.77 //y=2.26 //x2=53.77 //y2=2.26
r537 (  76 183 ) resistor r=23.615 //w=0.187 //l=0.345 //layer=li \
 //thickness=0.1 //x=51.44 //y=5.56 //x2=51.44 //y2=5.905
r538 (  68 182 ) resistor r=23.615 //w=0.187 //l=0.345 //layer=li \
 //thickness=0.1 //x=50.56 //y=5.56 //x2=50.56 //y2=5.905
r539 (  64 65 ) resistor r=0.10734 //w=0.281 //l=0.16 //layer=m2 \
 //thickness=0.36 //x=58.58 //y=2.775 //x2=58.42 //y2=2.775
r540 (  57 62 ) resistor r=0.10734 //w=0.281 //l=0.16 //layer=m2 \
 //thickness=0.36 //x=53.93 //y=2.77 //x2=53.77 //y2=2.77
r541 (  57 65 ) resistor r=4.28435 //w=0.131 //l=4.49 //layer=m2 \
 //thickness=0.36 //x=53.93 //y=2.77 //x2=58.42 //y2=2.77
r542 (  55 59 ) resistor r=0.10734 //w=0.281 //l=0.16 //layer=m2 \
 //thickness=0.36 //x=52.08 //y=2.77 //x2=51.92 //y2=2.77
r543 (  54 62 ) resistor r=0.10734 //w=0.281 //l=0.16 //layer=m2 \
 //thickness=0.36 //x=53.61 //y=2.77 //x2=53.77 //y2=2.77
r544 (  54 55 ) resistor r=1.45992 //w=0.131 //l=1.53 //layer=m2 \
 //thickness=0.36 //x=53.61 //y=2.77 //x2=52.08 //y2=2.77
r545 (  53 116 ) resistor r=9.3 //w=0.17 //l=0.17 //layer=mcon //count=1 \
 //x=58.58 //y=4.88 //x2=58.58 //y2=4.88
r546 (  51 107 ) resistor r=9.3 //w=0.17 //l=0.17 //layer=mcon //count=1 \
 //x=58.58 //y=2.26 //x2=58.58 //y2=2.26
r547 (  49 64 ) resistor r=4.5 //w=0.15 //l=0.15 //layer=via1 //count=1 \
 //x=58.58 //y=2.775 //x2=58.58 //y2=2.775
r548 (  47 49 ) resistor r=0.00166223 //w=0.376 //l=0.005 //layer=m1 \
 //thickness=0.36 //x=58.527 //y=2.77 //x2=58.527 //y2=2.775
r549 (  45 62 ) resistor r=4.5 //w=0.15 //l=0.15 //layer=via1 //count=1 \
 //x=53.77 //y=2.77 //x2=53.77 //y2=2.77
r550 (  43 45 ) resistor r=0.00166223 //w=0.376 //l=0.005 //layer=m1 \
 //thickness=0.36 //x=53.822 //y=2.765 //x2=53.822 //y2=2.77
r551 (  41 102 ) resistor r=9.3 //w=0.17 //l=0.17 //layer=mcon //count=1 \
 //x=53.77 //y=4.88 //x2=53.77 //y2=4.88
r552 (  39 93 ) resistor r=9.3 //w=0.17 //l=0.17 //layer=mcon //count=1 \
 //x=53.77 //y=2.26 //x2=53.77 //y2=2.26
r553 (  36 59 ) resistor r=4.5 //w=0.15 //l=0.15 //layer=via1 //count=1 \
 //x=51.92 //y=2.77 //x2=51.92 //y2=2.77
r554 (  33 180 ) resistor r=9.3 //w=0.17 //l=0.17 //layer=mcon //count=1 \
 //x=51.48 //y=1.18 //x2=51.48 //y2=1.18
r555 (  31 76 ) resistor r=9.3 //w=0.17 //l=0.17 //layer=mcon //count=1 \
 //x=51.44 //y=5.56 //x2=51.44 //y2=5.56
r556 (  28 31 ) resistor r=0.117801 //w=0.191 //l=0.18 //layer=m1 \
 //thickness=0.36 //x=51.44 //y=5.38 //x2=51.44 //y2=5.56
r557 (  27 68 ) resistor r=9.3 //w=0.17 //l=0.17 //layer=mcon //count=1 \
 //x=50.56 //y=5.56 //x2=50.56 //y2=5.56
r558 (  25 27 ) resistor r=0.10274 //w=0.219 //l=0.18 //layer=m1 \
 //thickness=0.36 //x=50.56 //y=5.38 //x2=50.56 //y2=5.56
r559 (  24 53 ) resistor r=0.0760407 //w=0.238 //l=0.125 //layer=m1 \
 //thickness=0.36 //x=58.58 //y=4.755 //x2=58.58 //y2=4.88
r560 (  23 49 ) resistor r=0.0911593 //w=0.376 //l=0.184608 //layer=m1 \
 //thickness=0.36 //x=58.58 //y=2.935 //x2=58.527 //y2=2.775
r561 (  23 24 ) resistor r=1.73664 //w=0.131 //l=1.82 //layer=m1 \
 //thickness=0.36 //x=58.58 //y=2.935 //x2=58.58 //y2=4.755
r562 (  22 47 ) resistor r=0.0894971 //w=0.376 //l=0.179555 //layer=m1 \
 //thickness=0.36 //x=58.58 //y=2.615 //x2=58.527 //y2=2.77
r563 (  21 51 ) resistor r=0.0719237 //w=0.222 //l=0.115 //layer=m1 \
 //thickness=0.36 //x=58.58 //y=2.375 //x2=58.58 //y2=2.26
r564 (  21 22 ) resistor r=0.229008 //w=0.131 //l=0.24 //layer=m1 \
 //thickness=0.36 //x=58.58 //y=2.375 //x2=58.58 //y2=2.615
r565 (  20 41 ) resistor r=0.0760407 //w=0.238 //l=0.125 //layer=m1 \
 //thickness=0.36 //x=53.77 //y=4.755 //x2=53.77 //y2=4.88
r566 (  19 45 ) resistor r=0.0911593 //w=0.376 //l=0.184174 //layer=m1 \
 //thickness=0.36 //x=53.77 //y=2.93 //x2=53.822 //y2=2.77
r567 (  19 20 ) resistor r=1.74141 //w=0.131 //l=1.825 //layer=m1 \
 //thickness=0.36 //x=53.77 //y=2.93 //x2=53.77 //y2=4.755
r568 (  18 43 ) resistor r=0.0894971 //w=0.376 //l=0.179123 //layer=m1 \
 //thickness=0.36 //x=53.77 //y=2.61 //x2=53.822 //y2=2.765
r569 (  17 39 ) resistor r=0.0719237 //w=0.222 //l=0.115 //layer=m1 \
 //thickness=0.36 //x=53.77 //y=2.375 //x2=53.77 //y2=2.26
r570 (  17 18 ) resistor r=0.224237 //w=0.131 //l=0.235 //layer=m1 \
 //thickness=0.36 //x=53.77 //y=2.375 //x2=53.77 //y2=2.61
r571 (  15 36 ) resistor r=0.0911593 //w=0.376 //l=0.184174 //layer=m1 \
 //thickness=0.36 //x=51.92 //y=2.93 //x2=51.972 //y2=2.77
r572 (  15 16 ) resistor r=2.25668 //w=0.131 //l=2.365 //layer=m1 \
 //thickness=0.36 //x=51.92 //y=2.93 //x2=51.92 //y2=5.295
r573 (  14 36 ) resistor r=0.0911593 //w=0.376 //l=0.184174 //layer=m1 \
 //thickness=0.36 //x=51.92 //y=2.61 //x2=51.972 //y2=2.77
r574 (  13 14 ) resistor r=0.658397 //w=0.131 //l=0.69 //layer=m1 \
 //thickness=0.36 //x=51.92 //y=1.92 //x2=51.92 //y2=2.61
r575 (  11 13 ) resistor r=0.0698411 //w=0.17 //l=0.120208 //layer=m1 \
 //thickness=0.36 //x=51.835 //y=1.835 //x2=51.92 //y2=1.92
r576 (  11 12 ) resistor r=0.257634 //w=0.131 //l=0.27 //layer=m1 \
 //thickness=0.36 //x=51.835 //y=1.835 //x2=51.565 //y2=1.835
r577 (  10 28 ) resistor r=0.0257089 //w=0.23 //l=0.115 //layer=m1 \
 //thickness=0.36 //x=51.555 //y=5.38 //x2=51.44 //y2=5.38
r578 (  9 16 ) resistor r=0.0698411 //w=0.17 //l=0.120208 //layer=m1 \
 //thickness=0.36 //x=51.835 //y=5.38 //x2=51.92 //y2=5.295
r579 (  9 10 ) resistor r=0.267176 //w=0.131 //l=0.28 //layer=m1 \
 //thickness=0.36 //x=51.835 //y=5.38 //x2=51.555 //y2=5.38
r580 (  8 12 ) resistor r=0.0698411 //w=0.17 //l=0.120208 //layer=m1 \
 //thickness=0.36 //x=51.48 //y=1.75 //x2=51.565 //y2=1.835
r581 (  7 33 ) resistor r=0.0913624 //w=0.191 //l=0.12 //layer=m1 \
 //thickness=0.36 //x=51.48 //y=1.3 //x2=51.48 //y2=1.18
r582 (  7 8 ) resistor r=0.429389 //w=0.131 //l=0.45 //layer=m1 \
 //thickness=0.36 //x=51.48 //y=1.3 //x2=51.48 //y2=1.75
r583 (  4 25 ) resistor r=0.0227762 //w=0.219 //l=0.115 //layer=m1 \
 //thickness=0.36 //x=50.675 //y=5.38 //x2=50.56 //y2=5.38
r584 (  3 28 ) resistor r=0.0257089 //w=0.23 //l=0.115 //layer=m1 \
 //thickness=0.36 //x=51.325 //y=5.38 //x2=51.44 //y2=5.38
r585 (  3 4 ) resistor r=0.620229 //w=0.131 //l=0.65 //layer=m1 \
 //thickness=0.36 //x=51.325 //y=5.38 //x2=50.675 //y2=5.38
ends PM_TMRDFFSNQNX1\%noxref_12

subckt PM_TMRDFFSNQNX1\%noxref_13 ( 1 3 6 7 9 10 11 12 14 15 16 18 19 21 24 27 \
 33 37 41 44 45 52 54 55 58 66 74 91 100 104 105 106 107 108 109 110 114 116 \
 119 120 130 133 135 136 137 )
c300 ( 133 0 ) capacitor c=0.00885916f //x=60.865 //y=1.095
c301 ( 130 0 ) capacitor c=0.0682508f //x=63.39 //y=4.88
c302 ( 120 0 ) capacitor c=0.0318956f //x=63.725 //y=1.39
c303 ( 119 0 ) capacitor c=0.0186809f //x=63.725 //y=1.045
c304 ( 116 0 ) capacitor c=0.0141821f //x=63.57 //y=1.545
c305 ( 114 0 ) capacitor c=0.0158553f //x=63.57 //y=0.89
c306 ( 110 0 ) capacitor c=0.0815114f //x=63.195 //y=2.095
c307 ( 109 0 ) capacitor c=0.0229235f //x=63.195 //y=1.7
c308 ( 108 0 ) capacitor c=0.0234359f //x=63.195 //y=1.39
c309 ( 107 0 ) capacitor c=0.0198759f //x=63.195 //y=1.045
c310 ( 106 0 ) capacitor c=0.110369f //x=63.73 //y=6.2
c311 ( 105 0 ) capacitor c=0.154619f //x=63.29 //y=6.2
c312 ( 100 0 ) capacitor c=8.13425e-19 //x=63.39 //y=4.88
c313 ( 91 0 ) capacitor c=5.17312e-19 //x=63.39 //y=2.26
c314 ( 74 0 ) capacitor c=0.0293219f //x=60.76 //y=5.56
c315 ( 66 0 ) capacitor c=0.029137f //x=59.88 //y=5.56
c316 ( 58 0 ) capacitor c=0.0278099f //x=59 //y=5.56
c317 ( 55 0 ) capacitor c=0.0156383f //x=63.225 //y=2.785
c318 ( 54 0 ) capacitor c=6.75833e-19 //x=63.385 //y=2.785
c319 ( 52 0 ) capacitor c=9.41304e-19 //x=61.7 //y=2.785
c320 ( 45 0 ) capacitor c=0.0487037f //x=63.392 //y=4.74
c321 ( 44 0 ) capacitor c=0.00631721f //x=63.39 //y=4.88
c322 ( 41 0 ) capacitor c=0.00463527f //x=63.39 //y=2.26
c323 ( 37 0 ) capacitor c=0.0145985f //x=63.39 //y=2.77
c324 ( 33 0 ) capacitor c=0.0149529f //x=61.54 //y=2.77
c325 ( 27 0 ) capacitor c=8.88597e-19 //x=60.76 //y=5.335
c326 ( 24 0 ) capacitor c=0.00796615f //x=59.88 //y=5.335
c327 ( 21 0 ) capacitor c=0.0111234f //x=59.002 //y=5.335
c328 ( 19 0 ) capacitor c=0.0120345f //x=63.39 //y=2.945
c329 ( 18 0 ) capacitor c=0.00384658f //x=63.39 //y=2.625
c330 ( 16 0 ) capacitor c=0.0629352f //x=61.54 //y=5.25
c331 ( 15 0 ) capacitor c=0.0123676f //x=61.54 //y=2.945
c332 ( 14 0 ) capacitor c=0.0168574f //x=61.54 //y=2.625
c333 ( 12 0 ) capacitor c=0.00493487f //x=61.14 //y=1.845
c334 ( 11 0 ) capacitor c=0.0126211f //x=61.455 //y=1.845
c335 ( 10 0 ) capacitor c=0.0136149f //x=61.055 //y=1.76
c336 ( 9 0 ) capacitor c=0.0113786f //x=61.055 //y=1.305
c337 ( 7 0 ) capacitor c=0.0235567f //x=61.455 //y=5.335
c338 ( 6 0 ) capacitor c=0.00906713f //x=60.76 //y=5.56
c339 ( 3 0 ) capacitor c=0.0180822f //x=60.645 //y=5.335
c340 ( 1 0 ) capacitor c=0.0152149f //x=59.76 //y=5.335
r341 (  128 130 ) resistor r=20.6867 //w=0.233 //l=0.1 //layer=ply \
 //thickness=0.18 //x=63.29 //y=4.88 //x2=63.39 //y2=4.88
r342 (  121 130 ) resistor r=70.3348 //w=0.233 //l=0.414367 //layer=ply \
 //thickness=0.18 //x=63.73 //y=5.045 //x2=63.39 //y2=4.88
r343 (  120 132 ) resistor r=45.1352 //w=0.168 //l=0.173853 //layer=ply \
 //thickness=0.18 //x=63.725 //y=1.39 //x2=63.685 //y2=1.545
r344 (  119 131 ) resistor r=45.1352 //w=0.168 //l=0.173853 //layer=ply \
 //thickness=0.18 //x=63.725 //y=1.045 //x2=63.685 //y2=0.89
r345 (  119 120 ) resistor r=176.904 //w=0.094 //l=0.345 //layer=ply \
 //thickness=0.18 //x=63.725 //y=1.045 //x2=63.725 //y2=1.39
r346 (  117 127 ) resistor r=10.701 //w=0.21 //l=0.115 //layer=ply \
 //thickness=0.18 //x=63.35 //y=1.545 //x2=63.235 //y2=1.545
r347 (  116 132 ) resistor r=5.52526 //w=0.168 //l=0.115 //layer=ply \
 //thickness=0.18 //x=63.57 //y=1.545 //x2=63.685 //y2=1.545
r348 (  115 126 ) resistor r=5.52526 //w=0.168 //l=0.115 //layer=ply \
 //thickness=0.18 //x=63.35 //y=0.89 //x2=63.235 //y2=0.89
r349 (  114 131 ) resistor r=5.52526 //w=0.168 //l=0.115 //layer=ply \
 //thickness=0.18 //x=63.57 //y=0.89 //x2=63.685 //y2=0.89
r350 (  114 115 ) resistor r=112.809 //w=0.094 //l=0.22 //layer=ply \
 //thickness=0.18 //x=63.57 //y=0.89 //x2=63.35 //y2=0.89
r351 (  111 128 ) resistor r=13.0941 //w=0.233 //l=0.165 //layer=ply \
 //thickness=0.18 //x=63.29 //y=5.045 //x2=63.29 //y2=4.88
r352 (  110 125 ) resistor r=34.8111 //w=0.27 //l=0.264953 //layer=ply \
 //thickness=0.18 //x=63.195 //y=2.095 //x2=63.39 //y2=2.26
r353 (  109 127 ) resistor r=39.5823 //w=0.21 //l=0.173853 //layer=ply \
 //thickness=0.18 //x=63.195 //y=1.7 //x2=63.235 //y2=1.545
r354 (  109 110 ) resistor r=202.543 //w=0.094 //l=0.395 //layer=ply \
 //thickness=0.18 //x=63.195 //y=1.7 //x2=63.195 //y2=2.095
r355 (  108 127 ) resistor r=39.5823 //w=0.21 //l=0.173853 //layer=ply \
 //thickness=0.18 //x=63.195 //y=1.39 //x2=63.235 //y2=1.545
r356 (  107 126 ) resistor r=45.1352 //w=0.168 //l=0.173853 //layer=ply \
 //thickness=0.18 //x=63.195 //y=1.045 //x2=63.235 //y2=0.89
r357 (  107 108 ) resistor r=176.904 //w=0.094 //l=0.345 //layer=ply \
 //thickness=0.18 //x=63.195 //y=1.045 //x2=63.195 //y2=1.39
r358 (  106 121 ) resistor r=592.245 //w=0.094 //l=1.155 //layer=ply \
 //thickness=0.18 //x=63.73 //y=6.2 //x2=63.73 //y2=5.045
r359 (  105 111 ) resistor r=592.245 //w=0.094 //l=1.155 //layer=ply \
 //thickness=0.18 //x=63.29 //y=6.2 //x2=63.29 //y2=5.045
r360 (  104 116 ) resistor r=56.4043 //w=0.094 //l=0.11 //layer=ply \
 //thickness=0.18 //x=63.46 //y=1.545 //x2=63.57 //y2=1.545
r361 (  104 117 ) resistor r=56.4043 //w=0.094 //l=0.11 //layer=ply \
 //thickness=0.18 //x=63.46 //y=1.545 //x2=63.35 //y2=1.545
r362 (  100 130 ) resistor r=152 //w=0.17 //l=0.17 //layer=licon //count=1 \
 //x=63.39 //y=4.88 //x2=63.39 //y2=4.88
r363 (  91 125 ) resistor r=152 //w=0.17 //l=0.17 //layer=licon //count=1 \
 //x=63.39 //y=2.26 //x2=63.39 //y2=2.26
r364 (  74 137 ) resistor r=23.615 //w=0.187 //l=0.345 //layer=li \
 //thickness=0.1 //x=60.76 //y=5.56 //x2=60.76 //y2=5.905
r365 (  66 136 ) resistor r=23.615 //w=0.187 //l=0.345 //layer=li \
 //thickness=0.1 //x=59.88 //y=5.56 //x2=59.88 //y2=5.905
r366 (  58 135 ) resistor r=23.615 //w=0.187 //l=0.345 //layer=li \
 //thickness=0.1 //x=59 //y=5.56 //x2=59 //y2=5.905
r367 (  54 55 ) resistor r=0.10734 //w=0.281 //l=0.16 //layer=m2 \
 //thickness=0.36 //x=63.385 //y=2.785 //x2=63.225 //y2=2.785
r368 (  52 55 ) resistor r=1.45515 //w=0.131 //l=1.525 //layer=m2 \
 //thickness=0.36 //x=61.7 //y=2.77 //x2=63.225 //y2=2.77
r369 (  50 52 ) resistor r=0.10734 //w=0.281 //l=0.16 //layer=m2 \
 //thickness=0.36 //x=61.54 //y=2.785 //x2=61.7 //y2=2.785
r370 (  44 100 ) resistor r=9.3 //w=0.17 //l=0.17 //layer=mcon //count=1 \
 //x=63.39 //y=4.88 //x2=63.39 //y2=4.88
r371 (  44 45 ) resistor r=0.103207 //w=0.196 //l=0.14 //layer=m1 \
 //thickness=0.36 //x=63.392 //y=4.88 //x2=63.392 //y2=4.74
r372 (  41 91 ) resistor r=9.3 //w=0.17 //l=0.17 //layer=mcon //count=1 \
 //x=63.39 //y=2.26 //x2=63.39 //y2=2.26
r373 (  39 54 ) resistor r=4.5 //w=0.15 //l=0.15 //layer=via1 //count=1 \
 //x=63.385 //y=2.785 //x2=63.385 //y2=2.785
r374 (  37 39 ) resistor r=0.00501337 //w=0.374 //l=0.015 //layer=m1 \
 //thickness=0.36 //x=63.335 //y=2.77 //x2=63.335 //y2=2.785
r375 (  35 50 ) resistor r=4.5 //w=0.15 //l=0.15 //layer=via1 //count=1 \
 //x=61.54 //y=2.785 //x2=61.54 //y2=2.785
r376 (  33 35 ) resistor r=0.0049867 //w=0.376 //l=0.015 //layer=m1 \
 //thickness=0.36 //x=61.592 //y=2.77 //x2=61.592 //y2=2.785
r377 (  31 133 ) resistor r=9.3 //w=0.17 //l=0.17 //layer=mcon //count=1 \
 //x=61.055 //y=1.19 //x2=61.055 //y2=1.19
r378 (  29 74 ) resistor r=9.3 //w=0.17 //l=0.17 //layer=mcon //count=1 \
 //x=60.76 //y=5.56 //x2=60.76 //y2=5.56
r379 (  26 66 ) resistor r=9.3 //w=0.17 //l=0.17 //layer=mcon //count=1 \
 //x=59.88 //y=5.56 //x2=59.88 //y2=5.56
r380 (  24 26 ) resistor r=0.121228 //w=0.232 //l=0.225 //layer=m1 \
 //thickness=0.36 //x=59.88 //y=5.335 //x2=59.88 //y2=5.56
r381 (  23 58 ) resistor r=9.3 //w=0.17 //l=0.17 //layer=mcon //count=1 //x=59 \
 //y=5.56 //x2=59 //y2=5.56
r382 (  21 23 ) resistor r=0.129608 //w=0.217 //l=0.225 //layer=m1 \
 //thickness=0.36 //x=59.002 //y=5.335 //x2=59.002 //y2=5.56
r383 (  19 39 ) resistor r=0.0910802 //w=0.374 //l=0.185472 //layer=m1 \
 //thickness=0.36 //x=63.39 //y=2.945 //x2=63.335 //y2=2.785
r384 (  19 45 ) resistor r=1.71279 //w=0.131 //l=1.795 //layer=m1 \
 //thickness=0.36 //x=63.39 //y=2.945 //x2=63.39 //y2=4.74
r385 (  18 37 ) resistor r=0.0860668 //w=0.374 //l=0.170294 //layer=m1 \
 //thickness=0.36 //x=63.39 //y=2.625 //x2=63.335 //y2=2.77
r386 (  17 41 ) resistor r=0.0933015 //w=0.201 //l=0.125 //layer=m1 \
 //thickness=0.36 //x=63.39 //y=2.385 //x2=63.39 //y2=2.26
r387 (  17 18 ) resistor r=0.229008 //w=0.131 //l=0.24 //layer=m1 \
 //thickness=0.36 //x=63.39 //y=2.385 //x2=63.39 //y2=2.625
r388 (  15 35 ) resistor r=0.0911593 //w=0.376 //l=0.184174 //layer=m1 \
 //thickness=0.36 //x=61.54 //y=2.945 //x2=61.592 //y2=2.785
r389 (  15 16 ) resistor r=2.19943 //w=0.131 //l=2.305 //layer=m1 \
 //thickness=0.36 //x=61.54 //y=2.945 //x2=61.54 //y2=5.25
r390 (  14 33 ) resistor r=0.0861726 //w=0.376 //l=0.169012 //layer=m1 \
 //thickness=0.36 //x=61.54 //y=2.625 //x2=61.592 //y2=2.77
r391 (  13 14 ) resistor r=0.663168 //w=0.131 //l=0.695 //layer=m1 \
 //thickness=0.36 //x=61.54 //y=1.93 //x2=61.54 //y2=2.625
r392 (  11 13 ) resistor r=0.0698411 //w=0.17 //l=0.120208 //layer=m1 \
 //thickness=0.36 //x=61.455 //y=1.845 //x2=61.54 //y2=1.93
r393 (  11 12 ) resistor r=0.300573 //w=0.131 //l=0.315 //layer=m1 \
 //thickness=0.36 //x=61.455 //y=1.845 //x2=61.14 //y2=1.845
r394 (  10 12 ) resistor r=0.0698411 //w=0.17 //l=0.120208 //layer=m1 \
 //thickness=0.36 //x=61.055 //y=1.76 //x2=61.14 //y2=1.845
r395 (  9 31 ) resistor r=0.0717383 //w=0.224 //l=0.115 //layer=m1 \
 //thickness=0.36 //x=61.055 //y=1.305 //x2=61.055 //y2=1.19
r396 (  9 10 ) resistor r=0.43416 //w=0.131 //l=0.455 //layer=m1 \
 //thickness=0.36 //x=61.055 //y=1.305 //x2=61.055 //y2=1.76
r397 (  8 27 ) resistor r=0.0675342 //w=0.23 //l=0.115 //layer=m1 \
 //thickness=0.36 //x=60.875 //y=5.335 //x2=60.76 //y2=5.335
r398 (  7 16 ) resistor r=0.0698411 //w=0.17 //l=0.120208 //layer=m1 \
 //thickness=0.36 //x=61.455 //y=5.335 //x2=61.54 //y2=5.25
r399 (  7 8 ) resistor r=0.553435 //w=0.131 //l=0.58 //layer=m1 \
 //thickness=0.36 //x=61.455 //y=5.335 //x2=60.875 //y2=5.335
r400 (  6 29 ) resistor r=0.00118313 //w=0.23 //layer=m1 //thickness=0.36 \
 //x=60.76 //y=5.56 //x2=60.76 //y2=5.56
r401 (  5 27 ) resistor r=0.002872 //w=0.34 //l=0.085 //layer=m1 \
 //thickness=0.36 //x=60.76 //y=5.42 //x2=60.76 //y2=5.335
r402 (  5 6 ) resistor r=0.091623 //w=0.191 //l=0.14 //layer=m1 \
 //thickness=0.36 //x=60.76 //y=5.42 //x2=60.76 //y2=5.56
r403 (  4 24 ) resistor r=0.0262263 //w=0.232 //l=0.12 //layer=m1 \
 //thickness=0.36 //x=60 //y=5.335 //x2=59.88 //y2=5.335
r404 (  3 27 ) resistor r=0.0675342 //w=0.23 //l=0.115 //layer=m1 \
 //thickness=0.36 //x=60.645 //y=5.335 //x2=60.76 //y2=5.335
r405 (  3 4 ) resistor r=0.615458 //w=0.131 //l=0.645 //layer=m1 \
 //thickness=0.36 //x=60.645 //y=5.335 //x2=60 //y2=5.335
r406 (  2 21 ) resistor r=0.0222262 //w=0.217 //l=0.118 //layer=m1 \
 //thickness=0.36 //x=59.12 //y=5.335 //x2=59.002 //y2=5.335
r407 (  1 24 ) resistor r=0.0262263 //w=0.232 //l=0.12 //layer=m1 \
 //thickness=0.36 //x=59.76 //y=5.335 //x2=59.88 //y2=5.335
r408 (  1 2 ) resistor r=0.610687 //w=0.131 //l=0.64 //layer=m1 \
 //thickness=0.36 //x=59.76 //y=5.335 //x2=59.12 //y2=5.335
ends PM_TMRDFFSNQNX1\%noxref_13

subckt PM_TMRDFFSNQNX1\%CLK ( 1 2 3 4 5 6 7 8 9 10 11 12 13 14 15 16 25 31 41 \
 45 50 57 61 66 73 77 82 85 87 89 90 91 93 95 97 98 99 100 101 103 105 107 108 \
 109 123 128 133 138 143 148 153 158 163 168 173 178 182 183 184 185 186 187 \
 188 189 190 191 192 193 194 195 196 197 198 199 200 201 202 204 210 211 212 \
 213 214 219 220 221 226 228 230 236 237 238 239 240 242 248 249 250 251 252 \
 257 258 259 264 266 268 274 275 276 277 278 280 286 287 288 289 290 295 296 \
 297 302 304 306 312 313 317 326 327 330 341 350 351 354 365 374 375 378 )
c980 ( 378 0 ) capacitor c=0.0368618f //x=64.16 //y=4.88
c981 ( 375 0 ) capacitor c=0.0284095f //x=64.13 //y=2.095
c982 ( 374 0 ) capacitor c=0.0476356f //x=64.13 //y=2.26
c983 ( 365 0 ) capacitor c=0.035802f //x=54.88 //y=4.88
c984 ( 354 0 ) capacitor c=0.0368618f //x=39.74 //y=4.88
c985 ( 351 0 ) capacitor c=0.0284095f //x=39.71 //y=2.095
c986 ( 350 0 ) capacitor c=0.0476356f //x=39.71 //y=2.26
c987 ( 341 0 ) capacitor c=0.035802f //x=30.46 //y=4.88
c988 ( 330 0 ) capacitor c=0.0368618f //x=15.32 //y=4.88
c989 ( 327 0 ) capacitor c=0.0284095f //x=15.29 //y=2.095
c990 ( 326 0 ) capacitor c=0.0476356f //x=15.29 //y=2.26
c991 ( 317 0 ) capacitor c=0.035802f //x=6.04 //y=4.88
c992 ( 313 0 ) capacitor c=0.0439708f //x=64.695 //y=1.43
c993 ( 312 0 ) capacitor c=0.0192582f //x=64.695 //y=1.085
c994 ( 306 0 ) capacitor c=0.0162526f //x=64.54 //y=1.585
c995 ( 304 0 ) capacitor c=0.0157807f //x=64.54 //y=0.93
c996 ( 302 0 ) capacitor c=0.0352777f //x=64.535 //y=4.97
c997 ( 297 0 ) capacitor c=0.0210762f //x=64.165 //y=1.74
c998 ( 296 0 ) capacitor c=0.0168511f //x=64.165 //y=1.43
c999 ( 295 0 ) capacitor c=0.0175485f //x=64.165 //y=1.085
c1000 ( 290 0 ) capacitor c=0.0305913f //x=55.215 //y=4.97
c1001 ( 289 0 ) capacitor c=0.0863671f //x=54.97 //y=2.095
c1002 ( 288 0 ) capacitor c=0.0170266f //x=54.97 //y=1.63
c1003 ( 287 0 ) capacitor c=0.018609f //x=54.97 //y=1.4
c1004 ( 286 0 ) capacitor c=0.0186599f //x=54.97 //y=1.09
c1005 ( 280 0 ) capacitor c=0.0146988f //x=54.815 //y=1.555
c1006 ( 278 0 ) capacitor c=0.0148531f //x=54.815 //y=0.935
c1007 ( 277 0 ) capacitor c=0.0334406f //x=54.445 //y=1.4
c1008 ( 276 0 ) capacitor c=0.0173191f //x=54.445 //y=1.09
c1009 ( 275 0 ) capacitor c=0.0439708f //x=40.275 //y=1.43
c1010 ( 274 0 ) capacitor c=0.0192582f //x=40.275 //y=1.085
c1011 ( 268 0 ) capacitor c=0.0162526f //x=40.12 //y=1.585
c1012 ( 266 0 ) capacitor c=0.0157807f //x=40.12 //y=0.93
c1013 ( 264 0 ) capacitor c=0.0352777f //x=40.115 //y=4.97
c1014 ( 259 0 ) capacitor c=0.0210762f //x=39.745 //y=1.74
c1015 ( 258 0 ) capacitor c=0.0168511f //x=39.745 //y=1.43
c1016 ( 257 0 ) capacitor c=0.0175485f //x=39.745 //y=1.085
c1017 ( 252 0 ) capacitor c=0.0305913f //x=30.795 //y=4.97
c1018 ( 251 0 ) capacitor c=0.0863671f //x=30.55 //y=2.095
c1019 ( 250 0 ) capacitor c=0.0170266f //x=30.55 //y=1.63
c1020 ( 249 0 ) capacitor c=0.018609f //x=30.55 //y=1.4
c1021 ( 248 0 ) capacitor c=0.0186599f //x=30.55 //y=1.09
c1022 ( 242 0 ) capacitor c=0.0146988f //x=30.395 //y=1.555
c1023 ( 240 0 ) capacitor c=0.0148531f //x=30.395 //y=0.935
c1024 ( 239 0 ) capacitor c=0.0334406f //x=30.025 //y=1.4
c1025 ( 238 0 ) capacitor c=0.0173191f //x=30.025 //y=1.09
c1026 ( 237 0 ) capacitor c=0.0439708f //x=15.855 //y=1.43
c1027 ( 236 0 ) capacitor c=0.0192582f //x=15.855 //y=1.085
c1028 ( 230 0 ) capacitor c=0.0162526f //x=15.7 //y=1.585
c1029 ( 228 0 ) capacitor c=0.0157807f //x=15.7 //y=0.93
c1030 ( 226 0 ) capacitor c=0.0352777f //x=15.695 //y=4.97
c1031 ( 221 0 ) capacitor c=0.0210762f //x=15.325 //y=1.74
c1032 ( 220 0 ) capacitor c=0.0168511f //x=15.325 //y=1.43
c1033 ( 219 0 ) capacitor c=0.0175485f //x=15.325 //y=1.085
c1034 ( 214 0 ) capacitor c=0.0305913f //x=6.375 //y=4.97
c1035 ( 213 0 ) capacitor c=0.0863671f //x=6.13 //y=2.095
c1036 ( 212 0 ) capacitor c=0.0170266f //x=6.13 //y=1.63
c1037 ( 211 0 ) capacitor c=0.018609f //x=6.13 //y=1.4
c1038 ( 210 0 ) capacitor c=0.0186599f //x=6.13 //y=1.09
c1039 ( 204 0 ) capacitor c=0.0146988f //x=5.975 //y=1.555
c1040 ( 202 0 ) capacitor c=0.0148531f //x=5.975 //y=0.935
c1041 ( 201 0 ) capacitor c=0.0334406f //x=5.605 //y=1.4
c1042 ( 200 0 ) capacitor c=0.0173191f //x=5.605 //y=1.09
c1043 ( 199 0 ) capacitor c=0.155269f //x=64.61 //y=6.2
c1044 ( 198 0 ) capacitor c=0.110375f //x=64.17 //y=6.2
c1045 ( 197 0 ) capacitor c=0.110208f //x=55.29 //y=6.2
c1046 ( 196 0 ) capacitor c=0.110214f //x=54.85 //y=6.2
c1047 ( 195 0 ) capacitor c=0.155269f //x=40.19 //y=6.2
c1048 ( 194 0 ) capacitor c=0.110375f //x=39.75 //y=6.2
c1049 ( 193 0 ) capacitor c=0.110208f //x=30.87 //y=6.2
c1050 ( 192 0 ) capacitor c=0.110214f //x=30.43 //y=6.2
c1051 ( 191 0 ) capacitor c=0.155269f //x=15.77 //y=6.2
c1052 ( 190 0 ) capacitor c=0.110375f //x=15.33 //y=6.2
c1053 ( 189 0 ) capacitor c=0.110208f //x=6.45 //y=6.2
c1054 ( 188 0 ) capacitor c=0.110214f //x=6.01 //y=6.2
c1055 ( 178 0 ) capacitor c=8.63406e-19 //x=64.16 //y=4.88
c1056 ( 173 0 ) capacitor c=7.72439e-19 //x=64.13 //y=2.26
c1057 ( 168 0 ) capacitor c=0.00129935f //x=54.88 //y=4.88
c1058 ( 163 0 ) capacitor c=0.00121786f //x=54.88 //y=2.26
c1059 ( 158 0 ) capacitor c=8.63406e-19 //x=39.74 //y=4.88
c1060 ( 153 0 ) capacitor c=7.72439e-19 //x=39.71 //y=2.26
c1061 ( 148 0 ) capacitor c=0.00129935f //x=30.46 //y=4.88
c1062 ( 143 0 ) capacitor c=0.00121786f //x=30.46 //y=2.26
c1063 ( 138 0 ) capacitor c=8.63406e-19 //x=15.32 //y=4.88
c1064 ( 133 0 ) capacitor c=7.72439e-19 //x=15.29 //y=2.26
c1065 ( 128 0 ) capacitor c=0.00129935f //x=6.04 //y=4.88
c1066 ( 123 0 ) capacitor c=0.00121786f //x=6.04 //y=2.26
c1067 ( 109 0 ) capacitor c=0.00532303f //x=6.04 //y=4.62
c1068 ( 108 0 ) capacitor c=0.128217f //x=56.595 //y=4.635
c1069 ( 107 0 ) capacitor c=0.194051f //x=56.94 //y=4.635
c1070 ( 105 0 ) capacitor c=0.0043561f //x=51.395 //y=4.63
c1071 ( 103 0 ) capacitor c=0.20317f //x=50.795 //y=4.62
c1072 ( 101 0 ) capacitor c=0.0131018f //x=43.25 //y=4.65
c1073 ( 100 0 ) capacitor c=0.185079f //x=39.905 //y=4.62
c1074 ( 99 0 ) capacitor c=0.0723239f //x=41.86 //y=4.62
c1075 ( 98 0 ) capacitor c=0.128217f //x=32.175 //y=4.635
c1076 ( 97 0 ) capacitor c=0.00691742f //x=32.52 //y=4.635
c1077 ( 95 0 ) capacitor c=0.0043561f //x=26.975 //y=4.63
c1078 ( 93 0 ) capacitor c=0.202041f //x=26.375 //y=4.62
c1079 ( 91 0 ) capacitor c=0.0131018f //x=18.83 //y=4.65
c1080 ( 90 0 ) capacitor c=0.185079f //x=15.485 //y=4.62
c1081 ( 89 0 ) capacitor c=0.0723239f //x=17.44 //y=4.62
c1082 ( 87 0 ) capacitor c=0.00691742f //x=8.1 //y=4.635
c1083 ( 85 0 ) capacitor c=0.0322851f //x=7.5 //y=4.62
c1084 ( 82 0 ) capacitor c=0.00896434f //x=64.165 //y=4.75
c1085 ( 77 0 ) capacitor c=0.00504845f //x=64.13 //y=2.26
c1086 ( 73 0 ) capacitor c=0.00985633f //x=54.88 //y=4.755
c1087 ( 66 0 ) capacitor c=0.00896434f //x=39.745 //y=4.75
c1088 ( 61 0 ) capacitor c=0.00504845f //x=39.71 //y=2.26
c1089 ( 57 0 ) capacitor c=0.00985633f //x=30.46 //y=4.755
c1090 ( 50 0 ) capacitor c=0.00896434f //x=15.325 //y=4.75
c1091 ( 45 0 ) capacitor c=0.00504845f //x=15.29 //y=2.26
c1092 ( 41 0 ) capacitor c=0.00986189f //x=6.04 //y=4.755
c1093 ( 31 0 ) capacitor c=0.00380207f //x=54.88 //y=2.375
c1094 ( 25 0 ) capacitor c=0.00380207f //x=30.46 //y=2.375
c1095 ( 16 0 ) capacitor c=0.00562626f //x=6.04 //y=2.375
c1096 ( 9 0 ) capacitor c=0.0447319f //x=64.13 //y=2.77
c1097 ( 8 0 ) capacitor c=0.0592705f //x=54.88 //y=3.88
c1098 ( 7 0 ) capacitor c=0.0447334f //x=39.71 //y=2.77
c1099 ( 6 0 ) capacitor c=0.059271f //x=30.46 //y=3.88
c1100 ( 4 0 ) capacitor c=0.0471209f //x=15.29 //y=2.77
c1101 ( 1 0 ) capacitor c=0.0633852f //x=6.04 //y=2.4
r1102 (  380 381 ) resistor r=32.4568 //w=0.214 //l=0.075 //layer=ply \
 //thickness=0.18 //x=64.16 //y=4.97 //x2=64.16 //y2=5.045
r1103 (  378 380 ) resistor r=20.271 //w=0.214 //l=0.09 //layer=ply \
 //thickness=0.18 //x=64.16 //y=4.88 //x2=64.16 //y2=4.97
r1104 (  374 375 ) resistor r=52.7279 //w=0.214 //l=0.165 //layer=ply \
 //thickness=0.18 //x=64.13 //y=2.26 //x2=64.13 //y2=2.095
r1105 (  367 368 ) resistor r=32.4568 //w=0.214 //l=0.075 //layer=ply \
 //thickness=0.18 //x=54.88 //y=4.97 //x2=54.88 //y2=5.045
r1106 (  365 367 ) resistor r=20.271 //w=0.214 //l=0.09 //layer=ply \
 //thickness=0.18 //x=54.88 //y=4.88 //x2=54.88 //y2=4.97
r1107 (  356 357 ) resistor r=32.4568 //w=0.214 //l=0.075 //layer=ply \
 //thickness=0.18 //x=39.74 //y=4.97 //x2=39.74 //y2=5.045
r1108 (  354 356 ) resistor r=20.271 //w=0.214 //l=0.09 //layer=ply \
 //thickness=0.18 //x=39.74 //y=4.88 //x2=39.74 //y2=4.97
r1109 (  350 351 ) resistor r=52.7279 //w=0.214 //l=0.165 //layer=ply \
 //thickness=0.18 //x=39.71 //y=2.26 //x2=39.71 //y2=2.095
r1110 (  343 344 ) resistor r=32.4568 //w=0.214 //l=0.075 //layer=ply \
 //thickness=0.18 //x=30.46 //y=4.97 //x2=30.46 //y2=5.045
r1111 (  341 343 ) resistor r=20.271 //w=0.214 //l=0.09 //layer=ply \
 //thickness=0.18 //x=30.46 //y=4.88 //x2=30.46 //y2=4.97
r1112 (  332 333 ) resistor r=32.4568 //w=0.214 //l=0.075 //layer=ply \
 //thickness=0.18 //x=15.32 //y=4.97 //x2=15.32 //y2=5.045
r1113 (  330 332 ) resistor r=20.271 //w=0.214 //l=0.09 //layer=ply \
 //thickness=0.18 //x=15.32 //y=4.88 //x2=15.32 //y2=4.97
r1114 (  326 327 ) resistor r=52.7279 //w=0.214 //l=0.165 //layer=ply \
 //thickness=0.18 //x=15.29 //y=2.26 //x2=15.29 //y2=2.095
r1115 (  319 320 ) resistor r=32.4568 //w=0.214 //l=0.075 //layer=ply \
 //thickness=0.18 //x=6.04 //y=4.97 //x2=6.04 //y2=5.045
r1116 (  317 319 ) resistor r=20.271 //w=0.214 //l=0.09 //layer=ply \
 //thickness=0.18 //x=6.04 //y=4.88 //x2=6.04 //y2=4.97
r1117 (  313 385 ) resistor r=45.1352 //w=0.168 //l=0.173853 //layer=ply \
 //thickness=0.18 //x=64.695 //y=1.43 //x2=64.655 //y2=1.585
r1118 (  312 384 ) resistor r=45.1352 //w=0.168 //l=0.173853 //layer=ply \
 //thickness=0.18 //x=64.695 //y=1.085 //x2=64.655 //y2=0.93
r1119 (  312 313 ) resistor r=176.904 //w=0.094 //l=0.345 //layer=ply \
 //thickness=0.18 //x=64.695 //y=1.085 //x2=64.695 //y2=1.43
r1120 (  307 383 ) resistor r=10.701 //w=0.21 //l=0.115 //layer=ply \
 //thickness=0.18 //x=64.32 //y=1.585 //x2=64.205 //y2=1.585
r1121 (  306 385 ) resistor r=5.52526 //w=0.168 //l=0.115 //layer=ply \
 //thickness=0.18 //x=64.54 //y=1.585 //x2=64.655 //y2=1.585
r1122 (  305 382 ) resistor r=5.52526 //w=0.168 //l=0.115 //layer=ply \
 //thickness=0.18 //x=64.32 //y=0.93 //x2=64.205 //y2=0.93
r1123 (  304 384 ) resistor r=5.52526 //w=0.168 //l=0.115 //layer=ply \
 //thickness=0.18 //x=64.54 //y=0.93 //x2=64.655 //y2=0.93
r1124 (  304 305 ) resistor r=112.809 //w=0.094 //l=0.22 //layer=ply \
 //thickness=0.18 //x=64.54 //y=0.93 //x2=64.32 //y2=0.93
r1125 (  303 380 ) resistor r=16.5046 //w=0.27 //l=0.135 //layer=ply \
 //thickness=0.18 //x=64.295 //y=4.97 //x2=64.16 //y2=4.97
r1126 (  302 309 ) resistor r=26.9307 //w=0.15 //l=0.106066 //layer=ply \
 //thickness=0.18 //x=64.535 //y=4.97 //x2=64.61 //y2=5.045
r1127 (  302 303 ) resistor r=123.064 //w=0.094 //l=0.24 //layer=ply \
 //thickness=0.18 //x=64.535 //y=4.97 //x2=64.295 //y2=4.97
r1128 (  297 383 ) resistor r=39.5823 //w=0.21 //l=0.173853 //layer=ply \
 //thickness=0.18 //x=64.165 //y=1.74 //x2=64.205 //y2=1.585
r1129 (  297 375 ) resistor r=182.032 //w=0.094 //l=0.355 //layer=ply \
 //thickness=0.18 //x=64.165 //y=1.74 //x2=64.165 //y2=2.095
r1130 (  296 383 ) resistor r=39.5823 //w=0.21 //l=0.173853 //layer=ply \
 //thickness=0.18 //x=64.165 //y=1.43 //x2=64.205 //y2=1.585
r1131 (  295 382 ) resistor r=45.1352 //w=0.168 //l=0.173853 //layer=ply \
 //thickness=0.18 //x=64.165 //y=1.085 //x2=64.205 //y2=0.93
r1132 (  295 296 ) resistor r=176.904 //w=0.094 //l=0.345 //layer=ply \
 //thickness=0.18 //x=64.165 //y=1.085 //x2=64.165 //y2=1.43
r1133 (  291 367 ) resistor r=16.5046 //w=0.27 //l=0.135 //layer=ply \
 //thickness=0.18 //x=55.015 //y=4.97 //x2=54.88 //y2=4.97
r1134 (  290 292 ) resistor r=26.9307 //w=0.15 //l=0.106066 //layer=ply \
 //thickness=0.18 //x=55.215 //y=4.97 //x2=55.29 //y2=5.045
r1135 (  290 291 ) resistor r=102.553 //w=0.094 //l=0.2 //layer=ply \
 //thickness=0.18 //x=55.215 //y=4.97 //x2=55.015 //y2=4.97
r1136 (  289 372 ) resistor r=38.6777 //w=0.284 //l=0.198997 //layer=ply \
 //thickness=0.18 //x=54.97 //y=2.095 //x2=54.895 //y2=2.26
r1137 (  288 370 ) resistor r=21.2976 //w=0.217 //l=0.0928709 //layer=ply \
 //thickness=0.18 //x=54.97 //y=1.63 //x2=54.93 //y2=1.555
r1138 (  288 289 ) resistor r=238.436 //w=0.094 //l=0.465 //layer=ply \
 //thickness=0.18 //x=54.97 //y=1.63 //x2=54.97 //y2=2.095
r1139 (  287 370 ) resistor r=39.0671 //w=0.217 //l=0.173853 //layer=ply \
 //thickness=0.18 //x=54.97 //y=1.4 //x2=54.93 //y2=1.555
r1140 (  286 369 ) resistor r=45.1352 //w=0.168 //l=0.173853 //layer=ply \
 //thickness=0.18 //x=54.97 //y=1.09 //x2=54.93 //y2=0.935
r1141 (  286 287 ) resistor r=158.957 //w=0.094 //l=0.31 //layer=ply \
 //thickness=0.18 //x=54.97 //y=1.09 //x2=54.97 //y2=1.4
r1142 (  281 363 ) resistor r=5.52526 //w=0.168 //l=0.115 //layer=ply \
 //thickness=0.18 //x=54.6 //y=1.555 //x2=54.485 //y2=1.555
r1143 (  280 370 ) resistor r=11.4558 //w=0.217 //l=0.115 //layer=ply \
 //thickness=0.18 //x=54.815 //y=1.555 //x2=54.93 //y2=1.555
r1144 (  279 362 ) resistor r=5.52526 //w=0.168 //l=0.115 //layer=ply \
 //thickness=0.18 //x=54.6 //y=0.935 //x2=54.485 //y2=0.935
r1145 (  278 369 ) resistor r=5.52526 //w=0.168 //l=0.115 //layer=ply \
 //thickness=0.18 //x=54.815 //y=0.935 //x2=54.93 //y2=0.935
r1146 (  278 279 ) resistor r=110.245 //w=0.094 //l=0.215 //layer=ply \
 //thickness=0.18 //x=54.815 //y=0.935 //x2=54.6 //y2=0.935
r1147 (  277 363 ) resistor r=45.1352 //w=0.168 //l=0.173853 //layer=ply \
 //thickness=0.18 //x=54.445 //y=1.4 //x2=54.485 //y2=1.555
r1148 (  276 362 ) resistor r=45.1352 //w=0.168 //l=0.173853 //layer=ply \
 //thickness=0.18 //x=54.445 //y=1.09 //x2=54.485 //y2=0.935
r1149 (  276 277 ) resistor r=158.957 //w=0.094 //l=0.31 //layer=ply \
 //thickness=0.18 //x=54.445 //y=1.09 //x2=54.445 //y2=1.4
r1150 (  275 361 ) resistor r=45.1352 //w=0.168 //l=0.173853 //layer=ply \
 //thickness=0.18 //x=40.275 //y=1.43 //x2=40.235 //y2=1.585
r1151 (  274 360 ) resistor r=45.1352 //w=0.168 //l=0.173853 //layer=ply \
 //thickness=0.18 //x=40.275 //y=1.085 //x2=40.235 //y2=0.93
r1152 (  274 275 ) resistor r=176.904 //w=0.094 //l=0.345 //layer=ply \
 //thickness=0.18 //x=40.275 //y=1.085 //x2=40.275 //y2=1.43
r1153 (  269 359 ) resistor r=10.701 //w=0.21 //l=0.115 //layer=ply \
 //thickness=0.18 //x=39.9 //y=1.585 //x2=39.785 //y2=1.585
r1154 (  268 361 ) resistor r=5.52526 //w=0.168 //l=0.115 //layer=ply \
 //thickness=0.18 //x=40.12 //y=1.585 //x2=40.235 //y2=1.585
r1155 (  267 358 ) resistor r=5.52526 //w=0.168 //l=0.115 //layer=ply \
 //thickness=0.18 //x=39.9 //y=0.93 //x2=39.785 //y2=0.93
r1156 (  266 360 ) resistor r=5.52526 //w=0.168 //l=0.115 //layer=ply \
 //thickness=0.18 //x=40.12 //y=0.93 //x2=40.235 //y2=0.93
r1157 (  266 267 ) resistor r=112.809 //w=0.094 //l=0.22 //layer=ply \
 //thickness=0.18 //x=40.12 //y=0.93 //x2=39.9 //y2=0.93
r1158 (  265 356 ) resistor r=16.5046 //w=0.27 //l=0.135 //layer=ply \
 //thickness=0.18 //x=39.875 //y=4.97 //x2=39.74 //y2=4.97
r1159 (  264 271 ) resistor r=26.9307 //w=0.15 //l=0.106066 //layer=ply \
 //thickness=0.18 //x=40.115 //y=4.97 //x2=40.19 //y2=5.045
r1160 (  264 265 ) resistor r=123.064 //w=0.094 //l=0.24 //layer=ply \
 //thickness=0.18 //x=40.115 //y=4.97 //x2=39.875 //y2=4.97
r1161 (  259 359 ) resistor r=39.5823 //w=0.21 //l=0.173853 //layer=ply \
 //thickness=0.18 //x=39.745 //y=1.74 //x2=39.785 //y2=1.585
r1162 (  259 351 ) resistor r=182.032 //w=0.094 //l=0.355 //layer=ply \
 //thickness=0.18 //x=39.745 //y=1.74 //x2=39.745 //y2=2.095
r1163 (  258 359 ) resistor r=39.5823 //w=0.21 //l=0.173853 //layer=ply \
 //thickness=0.18 //x=39.745 //y=1.43 //x2=39.785 //y2=1.585
r1164 (  257 358 ) resistor r=45.1352 //w=0.168 //l=0.173853 //layer=ply \
 //thickness=0.18 //x=39.745 //y=1.085 //x2=39.785 //y2=0.93
r1165 (  257 258 ) resistor r=176.904 //w=0.094 //l=0.345 //layer=ply \
 //thickness=0.18 //x=39.745 //y=1.085 //x2=39.745 //y2=1.43
r1166 (  253 343 ) resistor r=16.5046 //w=0.27 //l=0.135 //layer=ply \
 //thickness=0.18 //x=30.595 //y=4.97 //x2=30.46 //y2=4.97
r1167 (  252 254 ) resistor r=26.9307 //w=0.15 //l=0.106066 //layer=ply \
 //thickness=0.18 //x=30.795 //y=4.97 //x2=30.87 //y2=5.045
r1168 (  252 253 ) resistor r=102.553 //w=0.094 //l=0.2 //layer=ply \
 //thickness=0.18 //x=30.795 //y=4.97 //x2=30.595 //y2=4.97
r1169 (  251 348 ) resistor r=38.6777 //w=0.284 //l=0.198997 //layer=ply \
 //thickness=0.18 //x=30.55 //y=2.095 //x2=30.475 //y2=2.26
r1170 (  250 346 ) resistor r=21.2976 //w=0.217 //l=0.0928709 //layer=ply \
 //thickness=0.18 //x=30.55 //y=1.63 //x2=30.51 //y2=1.555
r1171 (  250 251 ) resistor r=238.436 //w=0.094 //l=0.465 //layer=ply \
 //thickness=0.18 //x=30.55 //y=1.63 //x2=30.55 //y2=2.095
r1172 (  249 346 ) resistor r=39.0671 //w=0.217 //l=0.173853 //layer=ply \
 //thickness=0.18 //x=30.55 //y=1.4 //x2=30.51 //y2=1.555
r1173 (  248 345 ) resistor r=45.1352 //w=0.168 //l=0.173853 //layer=ply \
 //thickness=0.18 //x=30.55 //y=1.09 //x2=30.51 //y2=0.935
r1174 (  248 249 ) resistor r=158.957 //w=0.094 //l=0.31 //layer=ply \
 //thickness=0.18 //x=30.55 //y=1.09 //x2=30.55 //y2=1.4
r1175 (  243 339 ) resistor r=5.52526 //w=0.168 //l=0.115 //layer=ply \
 //thickness=0.18 //x=30.18 //y=1.555 //x2=30.065 //y2=1.555
r1176 (  242 346 ) resistor r=11.4558 //w=0.217 //l=0.115 //layer=ply \
 //thickness=0.18 //x=30.395 //y=1.555 //x2=30.51 //y2=1.555
r1177 (  241 338 ) resistor r=5.52526 //w=0.168 //l=0.115 //layer=ply \
 //thickness=0.18 //x=30.18 //y=0.935 //x2=30.065 //y2=0.935
r1178 (  240 345 ) resistor r=5.52526 //w=0.168 //l=0.115 //layer=ply \
 //thickness=0.18 //x=30.395 //y=0.935 //x2=30.51 //y2=0.935
r1179 (  240 241 ) resistor r=110.245 //w=0.094 //l=0.215 //layer=ply \
 //thickness=0.18 //x=30.395 //y=0.935 //x2=30.18 //y2=0.935
r1180 (  239 339 ) resistor r=45.1352 //w=0.168 //l=0.173853 //layer=ply \
 //thickness=0.18 //x=30.025 //y=1.4 //x2=30.065 //y2=1.555
r1181 (  238 338 ) resistor r=45.1352 //w=0.168 //l=0.173853 //layer=ply \
 //thickness=0.18 //x=30.025 //y=1.09 //x2=30.065 //y2=0.935
r1182 (  238 239 ) resistor r=158.957 //w=0.094 //l=0.31 //layer=ply \
 //thickness=0.18 //x=30.025 //y=1.09 //x2=30.025 //y2=1.4
r1183 (  237 337 ) resistor r=45.1352 //w=0.168 //l=0.173853 //layer=ply \
 //thickness=0.18 //x=15.855 //y=1.43 //x2=15.815 //y2=1.585
r1184 (  236 336 ) resistor r=45.1352 //w=0.168 //l=0.173853 //layer=ply \
 //thickness=0.18 //x=15.855 //y=1.085 //x2=15.815 //y2=0.93
r1185 (  236 237 ) resistor r=176.904 //w=0.094 //l=0.345 //layer=ply \
 //thickness=0.18 //x=15.855 //y=1.085 //x2=15.855 //y2=1.43
r1186 (  231 335 ) resistor r=10.701 //w=0.21 //l=0.115 //layer=ply \
 //thickness=0.18 //x=15.48 //y=1.585 //x2=15.365 //y2=1.585
r1187 (  230 337 ) resistor r=5.52526 //w=0.168 //l=0.115 //layer=ply \
 //thickness=0.18 //x=15.7 //y=1.585 //x2=15.815 //y2=1.585
r1188 (  229 334 ) resistor r=5.52526 //w=0.168 //l=0.115 //layer=ply \
 //thickness=0.18 //x=15.48 //y=0.93 //x2=15.365 //y2=0.93
r1189 (  228 336 ) resistor r=5.52526 //w=0.168 //l=0.115 //layer=ply \
 //thickness=0.18 //x=15.7 //y=0.93 //x2=15.815 //y2=0.93
r1190 (  228 229 ) resistor r=112.809 //w=0.094 //l=0.22 //layer=ply \
 //thickness=0.18 //x=15.7 //y=0.93 //x2=15.48 //y2=0.93
r1191 (  227 332 ) resistor r=16.5046 //w=0.27 //l=0.135 //layer=ply \
 //thickness=0.18 //x=15.455 //y=4.97 //x2=15.32 //y2=4.97
r1192 (  226 233 ) resistor r=26.9307 //w=0.15 //l=0.106066 //layer=ply \
 //thickness=0.18 //x=15.695 //y=4.97 //x2=15.77 //y2=5.045
r1193 (  226 227 ) resistor r=123.064 //w=0.094 //l=0.24 //layer=ply \
 //thickness=0.18 //x=15.695 //y=4.97 //x2=15.455 //y2=4.97
r1194 (  221 335 ) resistor r=39.5823 //w=0.21 //l=0.173853 //layer=ply \
 //thickness=0.18 //x=15.325 //y=1.74 //x2=15.365 //y2=1.585
r1195 (  221 327 ) resistor r=182.032 //w=0.094 //l=0.355 //layer=ply \
 //thickness=0.18 //x=15.325 //y=1.74 //x2=15.325 //y2=2.095
r1196 (  220 335 ) resistor r=39.5823 //w=0.21 //l=0.173853 //layer=ply \
 //thickness=0.18 //x=15.325 //y=1.43 //x2=15.365 //y2=1.585
r1197 (  219 334 ) resistor r=45.1352 //w=0.168 //l=0.173853 //layer=ply \
 //thickness=0.18 //x=15.325 //y=1.085 //x2=15.365 //y2=0.93
r1198 (  219 220 ) resistor r=176.904 //w=0.094 //l=0.345 //layer=ply \
 //thickness=0.18 //x=15.325 //y=1.085 //x2=15.325 //y2=1.43
r1199 (  215 319 ) resistor r=16.5046 //w=0.27 //l=0.135 //layer=ply \
 //thickness=0.18 //x=6.175 //y=4.97 //x2=6.04 //y2=4.97
r1200 (  214 216 ) resistor r=26.9307 //w=0.15 //l=0.106066 //layer=ply \
 //thickness=0.18 //x=6.375 //y=4.97 //x2=6.45 //y2=5.045
r1201 (  214 215 ) resistor r=102.553 //w=0.094 //l=0.2 //layer=ply \
 //thickness=0.18 //x=6.375 //y=4.97 //x2=6.175 //y2=4.97
r1202 (  213 324 ) resistor r=38.6777 //w=0.284 //l=0.198997 //layer=ply \
 //thickness=0.18 //x=6.13 //y=2.095 //x2=6.055 //y2=2.26
r1203 (  212 322 ) resistor r=21.2976 //w=0.217 //l=0.0928709 //layer=ply \
 //thickness=0.18 //x=6.13 //y=1.63 //x2=6.09 //y2=1.555
r1204 (  212 213 ) resistor r=238.436 //w=0.094 //l=0.465 //layer=ply \
 //thickness=0.18 //x=6.13 //y=1.63 //x2=6.13 //y2=2.095
r1205 (  211 322 ) resistor r=39.0671 //w=0.217 //l=0.173853 //layer=ply \
 //thickness=0.18 //x=6.13 //y=1.4 //x2=6.09 //y2=1.555
r1206 (  210 321 ) resistor r=45.1352 //w=0.168 //l=0.173853 //layer=ply \
 //thickness=0.18 //x=6.13 //y=1.09 //x2=6.09 //y2=0.935
r1207 (  210 211 ) resistor r=158.957 //w=0.094 //l=0.31 //layer=ply \
 //thickness=0.18 //x=6.13 //y=1.09 //x2=6.13 //y2=1.4
r1208 (  205 315 ) resistor r=5.52526 //w=0.168 //l=0.115 //layer=ply \
 //thickness=0.18 //x=5.76 //y=1.555 //x2=5.645 //y2=1.555
r1209 (  204 322 ) resistor r=11.4558 //w=0.217 //l=0.115 //layer=ply \
 //thickness=0.18 //x=5.975 //y=1.555 //x2=6.09 //y2=1.555
r1210 (  203 314 ) resistor r=5.52526 //w=0.168 //l=0.115 //layer=ply \
 //thickness=0.18 //x=5.76 //y=0.935 //x2=5.645 //y2=0.935
r1211 (  202 321 ) resistor r=5.52526 //w=0.168 //l=0.115 //layer=ply \
 //thickness=0.18 //x=5.975 //y=0.935 //x2=6.09 //y2=0.935
r1212 (  202 203 ) resistor r=110.245 //w=0.094 //l=0.215 //layer=ply \
 //thickness=0.18 //x=5.975 //y=0.935 //x2=5.76 //y2=0.935
r1213 (  201 315 ) resistor r=45.1352 //w=0.168 //l=0.173853 //layer=ply \
 //thickness=0.18 //x=5.605 //y=1.4 //x2=5.645 //y2=1.555
r1214 (  200 314 ) resistor r=45.1352 //w=0.168 //l=0.173853 //layer=ply \
 //thickness=0.18 //x=5.605 //y=1.09 //x2=5.645 //y2=0.935
r1215 (  200 201 ) resistor r=158.957 //w=0.094 //l=0.31 //layer=ply \
 //thickness=0.18 //x=5.605 //y=1.09 //x2=5.605 //y2=1.4
r1216 (  199 309 ) resistor r=592.245 //w=0.094 //l=1.155 //layer=ply \
 //thickness=0.18 //x=64.61 //y=6.2 //x2=64.61 //y2=5.045
r1217 (  198 381 ) resistor r=592.245 //w=0.094 //l=1.155 //layer=ply \
 //thickness=0.18 //x=64.17 //y=6.2 //x2=64.17 //y2=5.045
r1218 (  197 292 ) resistor r=592.245 //w=0.094 //l=1.155 //layer=ply \
 //thickness=0.18 //x=55.29 //y=6.2 //x2=55.29 //y2=5.045
r1219 (  196 368 ) resistor r=592.245 //w=0.094 //l=1.155 //layer=ply \
 //thickness=0.18 //x=54.85 //y=6.2 //x2=54.85 //y2=5.045
r1220 (  195 271 ) resistor r=592.245 //w=0.094 //l=1.155 //layer=ply \
 //thickness=0.18 //x=40.19 //y=6.2 //x2=40.19 //y2=5.045
r1221 (  194 357 ) resistor r=592.245 //w=0.094 //l=1.155 //layer=ply \
 //thickness=0.18 //x=39.75 //y=6.2 //x2=39.75 //y2=5.045
r1222 (  193 254 ) resistor r=592.245 //w=0.094 //l=1.155 //layer=ply \
 //thickness=0.18 //x=30.87 //y=6.2 //x2=30.87 //y2=5.045
r1223 (  192 344 ) resistor r=592.245 //w=0.094 //l=1.155 //layer=ply \
 //thickness=0.18 //x=30.43 //y=6.2 //x2=30.43 //y2=5.045
r1224 (  191 233 ) resistor r=592.245 //w=0.094 //l=1.155 //layer=ply \
 //thickness=0.18 //x=15.77 //y=6.2 //x2=15.77 //y2=5.045
r1225 (  190 333 ) resistor r=592.245 //w=0.094 //l=1.155 //layer=ply \
 //thickness=0.18 //x=15.33 //y=6.2 //x2=15.33 //y2=5.045
r1226 (  189 216 ) resistor r=592.245 //w=0.094 //l=1.155 //layer=ply \
 //thickness=0.18 //x=6.45 //y=6.2 //x2=6.45 //y2=5.045
r1227 (  188 320 ) resistor r=592.245 //w=0.094 //l=1.155 //layer=ply \
 //thickness=0.18 //x=6.01 //y=6.2 //x2=6.01 //y2=5.045
r1228 (  187 306 ) resistor r=56.4043 //w=0.094 //l=0.11 //layer=ply \
 //thickness=0.18 //x=64.43 //y=1.585 //x2=64.54 //y2=1.585
r1229 (  187 307 ) resistor r=56.4043 //w=0.094 //l=0.11 //layer=ply \
 //thickness=0.18 //x=64.43 //y=1.585 //x2=64.32 //y2=1.585
r1230 (  186 280 ) resistor r=55.3787 //w=0.094 //l=0.108 //layer=ply \
 //thickness=0.18 //x=54.707 //y=1.555 //x2=54.815 //y2=1.555
r1231 (  186 281 ) resistor r=54.866 //w=0.094 //l=0.107 //layer=ply \
 //thickness=0.18 //x=54.707 //y=1.555 //x2=54.6 //y2=1.555
r1232 (  185 268 ) resistor r=56.4043 //w=0.094 //l=0.11 //layer=ply \
 //thickness=0.18 //x=40.01 //y=1.585 //x2=40.12 //y2=1.585
r1233 (  185 269 ) resistor r=56.4043 //w=0.094 //l=0.11 //layer=ply \
 //thickness=0.18 //x=40.01 //y=1.585 //x2=39.9 //y2=1.585
r1234 (  184 242 ) resistor r=55.3787 //w=0.094 //l=0.108 //layer=ply \
 //thickness=0.18 //x=30.287 //y=1.555 //x2=30.395 //y2=1.555
r1235 (  184 243 ) resistor r=54.866 //w=0.094 //l=0.107 //layer=ply \
 //thickness=0.18 //x=30.287 //y=1.555 //x2=30.18 //y2=1.555
r1236 (  183 230 ) resistor r=56.4043 //w=0.094 //l=0.11 //layer=ply \
 //thickness=0.18 //x=15.59 //y=1.585 //x2=15.7 //y2=1.585
r1237 (  183 231 ) resistor r=56.4043 //w=0.094 //l=0.11 //layer=ply \
 //thickness=0.18 //x=15.59 //y=1.585 //x2=15.48 //y2=1.585
r1238 (  182 204 ) resistor r=55.3787 //w=0.094 //l=0.108 //layer=ply \
 //thickness=0.18 //x=5.867 //y=1.555 //x2=5.975 //y2=1.555
r1239 (  182 205 ) resistor r=54.866 //w=0.094 //l=0.107 //layer=ply \
 //thickness=0.18 //x=5.867 //y=1.555 //x2=5.76 //y2=1.555
r1240 (  178 378 ) resistor r=152 //w=0.17 //l=0.17 //layer=licon //count=1 \
 //x=64.16 //y=4.88 //x2=64.16 //y2=4.88
r1241 (  173 374 ) resistor r=152 //w=0.17 //l=0.17 //layer=licon //count=1 \
 //x=64.13 //y=2.26 //x2=64.13 //y2=2.26
r1242 (  168 365 ) resistor r=152 //w=0.17 //l=0.17 //layer=licon //count=1 \
 //x=54.88 //y=4.88 //x2=54.88 //y2=4.88
r1243 (  163 372 ) resistor r=152 //w=0.17 //l=0.17 //layer=licon //count=1 \
 //x=54.88 //y=2.26 //x2=54.88 //y2=2.26
r1244 (  158 354 ) resistor r=152 //w=0.17 //l=0.17 //layer=licon //count=1 \
 //x=39.74 //y=4.88 //x2=39.74 //y2=4.88
r1245 (  153 350 ) resistor r=152 //w=0.17 //l=0.17 //layer=licon //count=1 \
 //x=39.71 //y=2.26 //x2=39.71 //y2=2.26
r1246 (  148 341 ) resistor r=152 //w=0.17 //l=0.17 //layer=licon //count=1 \
 //x=30.46 //y=4.88 //x2=30.46 //y2=4.88
r1247 (  143 348 ) resistor r=152 //w=0.17 //l=0.17 //layer=licon //count=1 \
 //x=30.46 //y=2.26 //x2=30.46 //y2=2.26
r1248 (  138 330 ) resistor r=152 //w=0.17 //l=0.17 //layer=licon //count=1 \
 //x=15.32 //y=4.88 //x2=15.32 //y2=4.88
r1249 (  133 326 ) resistor r=152 //w=0.17 //l=0.17 //layer=licon //count=1 \
 //x=15.29 //y=2.26 //x2=15.29 //y2=2.26
r1250 (  128 317 ) resistor r=152 //w=0.17 //l=0.17 //layer=licon //count=1 \
 //x=6.04 //y=4.88 //x2=6.04 //y2=4.88
r1251 (  123 324 ) resistor r=152 //w=0.17 //l=0.17 //layer=licon //count=1 \
 //x=6.04 //y=2.26 //x2=6.04 //y2=2.26
r1252 (  109 111 ) resistor r=0.0546116 //w=0.309 //l=0.135 //layer=m2 \
 //thickness=0.36 //x=6.04 //y=4.62 //x2=6.04 //y2=4.755
r1253 (  108 119 ) resistor r=1.17227 //w=0.183 //l=1.74965 //layer=m2 \
 //thickness=0.36 //x=56.595 //y=4.635 //x2=54.88 //y2=4.705
r1254 (  107 121 ) resistor r=5.04583 //w=0.179 //l=7.25992 //layer=m2 \
 //thickness=0.36 //x=56.94 //y=4.635 //x2=64.165 //y2=4.705
r1255 (  107 108 ) resistor r=0.329198 //w=0.131 //l=0.345 //layer=m2 \
 //thickness=0.36 //x=56.94 //y=4.635 //x2=56.595 //y2=4.635
r1256 (  105 119 ) resistor r=2.38129 //w=0.183 //l=3.5223 //layer=m2 \
 //thickness=0.36 //x=51.395 //y=4.63 //x2=54.88 //y2=4.705
r1257 (  105 106 ) resistor r=0.329198 //w=0.131 //l=0.345 //layer=m2 \
 //thickness=0.36 //x=51.395 //y=4.63 //x2=51.05 //y2=4.63
r1258 (  103 106 ) resistor r=0.1875 //w=0.17 //l=0.259952 //layer=m2 \
 //thickness=0.36 //x=50.795 //y=4.62 //x2=51.05 //y2=4.63
r1259 (  103 104 ) resistor r=7.03721 //w=0.131 //l=7.375 //layer=m2 \
 //thickness=0.36 //x=50.795 //y=4.62 //x2=43.42 //y2=4.62
r1260 (  101 104 ) resistor r=0.125 //w=0.17 //l=0.184391 //layer=m2 \
 //thickness=0.36 //x=43.25 //y=4.65 //x2=43.42 //y2=4.62
r1261 (  101 102 ) resistor r=0.491412 //w=0.131 //l=0.515 //layer=m2 \
 //thickness=0.36 //x=43.25 //y=4.65 //x2=42.735 //y2=4.65
r1262 (  100 117 ) resistor r=0.112172 //w=0.179 //l=0.19799 //layer=m2 \
 //thickness=0.36 //x=39.905 //y=4.62 //x2=39.745 //y2=4.705
r1263 (  99 102 ) resistor r=0.607639 //w=0.18 //l=0.889874 //layer=m2 \
 //thickness=0.36 //x=41.86 //y=4.62 //x2=42.735 //y2=4.65
r1264 (  99 100 ) resistor r=1.86546 //w=0.131 //l=1.955 //layer=m2 \
 //thickness=0.36 //x=41.86 //y=4.62 //x2=39.905 //y2=4.62
r1265 (  98 115 ) resistor r=1.17227 //w=0.183 //l=1.74965 //layer=m2 \
 //thickness=0.36 //x=32.175 //y=4.635 //x2=30.46 //y2=4.705
r1266 (  97 117 ) resistor r=5.04583 //w=0.179 //l=7.25992 //layer=m2 \
 //thickness=0.36 //x=32.52 //y=4.635 //x2=39.745 //y2=4.705
r1267 (  97 98 ) resistor r=0.329198 //w=0.131 //l=0.345 //layer=m2 \
 //thickness=0.36 //x=32.52 //y=4.635 //x2=32.175 //y2=4.635
r1268 (  95 115 ) resistor r=2.38129 //w=0.183 //l=3.5223 //layer=m2 \
 //thickness=0.36 //x=26.975 //y=4.63 //x2=30.46 //y2=4.705
r1269 (  95 96 ) resistor r=0.329198 //w=0.131 //l=0.345 //layer=m2 \
 //thickness=0.36 //x=26.975 //y=4.63 //x2=26.63 //y2=4.63
r1270 (  93 96 ) resistor r=0.1875 //w=0.17 //l=0.259952 //layer=m2 \
 //thickness=0.36 //x=26.375 //y=4.62 //x2=26.63 //y2=4.63
r1271 (  93 94 ) resistor r=7.03721 //w=0.131 //l=7.375 //layer=m2 \
 //thickness=0.36 //x=26.375 //y=4.62 //x2=19 //y2=4.62
r1272 (  91 94 ) resistor r=0.125 //w=0.17 //l=0.184391 //layer=m2 \
 //thickness=0.36 //x=18.83 //y=4.65 //x2=19 //y2=4.62
r1273 (  91 92 ) resistor r=0.491412 //w=0.131 //l=0.515 //layer=m2 \
 //thickness=0.36 //x=18.83 //y=4.65 //x2=18.315 //y2=4.65
r1274 (  90 113 ) resistor r=0.112172 //w=0.179 //l=0.19799 //layer=m2 \
 //thickness=0.36 //x=15.485 //y=4.62 //x2=15.325 //y2=4.705
r1275 (  89 92 ) resistor r=0.607639 //w=0.18 //l=0.889874 //layer=m2 \
 //thickness=0.36 //x=17.44 //y=4.62 //x2=18.315 //y2=4.65
r1276 (  89 90 ) resistor r=1.86546 //w=0.131 //l=1.955 //layer=m2 \
 //thickness=0.36 //x=17.44 //y=4.62 //x2=15.485 //y2=4.62
r1277 (  87 113 ) resistor r=5.04583 //w=0.179 //l=7.25992 //layer=m2 \
 //thickness=0.36 //x=8.1 //y=4.635 //x2=15.325 //y2=4.705
r1278 (  87 88 ) resistor r=0.329198 //w=0.131 //l=0.345 //layer=m2 \
 //thickness=0.36 //x=8.1 //y=4.635 //x2=7.755 //y2=4.635
r1279 (  86 109 ) resistor r=0.0433913 //w=0.309 //l=0.16 //layer=m2 \
 //thickness=0.36 //x=6.2 //y=4.62 //x2=6.04 //y2=4.62
r1280 (  85 88 ) resistor r=0.1875 //w=0.17 //l=0.262393 //layer=m2 \
 //thickness=0.36 //x=7.5 //y=4.62 //x2=7.755 //y2=4.635
r1281 (  85 86 ) resistor r=1.24046 //w=0.131 //l=1.3 //layer=m2 \
 //thickness=0.36 //x=7.5 //y=4.62 //x2=6.2 //y2=4.62
r1282 (  84 178 ) resistor r=9.3 //w=0.17 //l=0.17 //layer=mcon //count=1 \
 //x=64.16 //y=4.88 //x2=64.16 //y2=4.88
r1283 (  82 121 ) resistor r=4.5 //w=0.15 //l=0.15 //layer=via1 //count=1 \
 //x=64.165 //y=4.75 //x2=64.165 //y2=4.75
r1284 (  82 84 ) resistor r=0.0547138 //w=0.297 //l=0.13 //layer=m1 \
 //thickness=0.36 //x=64.165 //y=4.75 //x2=64.165 //y2=4.88
r1285 (  77 173 ) resistor r=9.3 //w=0.17 //l=0.17 //layer=mcon //count=1 \
 //x=64.13 //y=2.26 //x2=64.13 //y2=2.26
r1286 (  77 79 ) resistor r=0.0936408 //w=0.196 //l=0.125 //layer=m1 \
 //thickness=0.36 //x=64.132 //y=2.26 //x2=64.132 //y2=2.385
r1287 (  75 168 ) resistor r=9.3 //w=0.17 //l=0.17 //layer=mcon //count=1 \
 //x=54.88 //y=4.88 //x2=54.88 //y2=4.88
r1288 (  73 119 ) resistor r=4.5 //w=0.15 //l=0.15 //layer=via1 //count=1 \
 //x=54.88 //y=4.755 //x2=54.88 //y2=4.755
r1289 (  73 75 ) resistor r=0.0533276 //w=0.293 //l=0.125 //layer=m1 \
 //thickness=0.36 //x=54.88 //y=4.755 //x2=54.88 //y2=4.88
r1290 (  70 163 ) resistor r=9.3 //w=0.17 //l=0.17 //layer=mcon //count=1 \
 //x=54.88 //y=2.26 //x2=54.88 //y2=2.26
r1291 (  68 158 ) resistor r=9.3 //w=0.17 //l=0.17 //layer=mcon //count=1 \
 //x=39.74 //y=4.88 //x2=39.74 //y2=4.88
r1292 (  66 117 ) resistor r=4.5 //w=0.15 //l=0.15 //layer=via1 //count=1 \
 //x=39.745 //y=4.75 //x2=39.745 //y2=4.75
r1293 (  66 68 ) resistor r=0.0547138 //w=0.297 //l=0.13 //layer=m1 \
 //thickness=0.36 //x=39.745 //y=4.75 //x2=39.745 //y2=4.88
r1294 (  61 153 ) resistor r=9.3 //w=0.17 //l=0.17 //layer=mcon //count=1 \
 //x=39.71 //y=2.26 //x2=39.71 //y2=2.26
r1295 (  61 63 ) resistor r=0.0936408 //w=0.196 //l=0.125 //layer=m1 \
 //thickness=0.36 //x=39.712 //y=2.26 //x2=39.712 //y2=2.385
r1296 (  59 148 ) resistor r=9.3 //w=0.17 //l=0.17 //layer=mcon //count=1 \
 //x=30.46 //y=4.88 //x2=30.46 //y2=4.88
r1297 (  57 115 ) resistor r=4.5 //w=0.15 //l=0.15 //layer=via1 //count=1 \
 //x=30.46 //y=4.755 //x2=30.46 //y2=4.755
r1298 (  57 59 ) resistor r=0.0533276 //w=0.293 //l=0.125 //layer=m1 \
 //thickness=0.36 //x=30.46 //y=4.755 //x2=30.46 //y2=4.88
r1299 (  54 143 ) resistor r=9.3 //w=0.17 //l=0.17 //layer=mcon //count=1 \
 //x=30.46 //y=2.26 //x2=30.46 //y2=2.26
r1300 (  52 138 ) resistor r=9.3 //w=0.17 //l=0.17 //layer=mcon //count=1 \
 //x=15.32 //y=4.88 //x2=15.32 //y2=4.88
r1301 (  50 113 ) resistor r=4.5 //w=0.15 //l=0.15 //layer=via1 //count=1 \
 //x=15.325 //y=4.75 //x2=15.325 //y2=4.75
r1302 (  50 52 ) resistor r=0.0547138 //w=0.297 //l=0.13 //layer=m1 \
 //thickness=0.36 //x=15.325 //y=4.75 //x2=15.325 //y2=4.88
r1303 (  45 133 ) resistor r=9.3 //w=0.17 //l=0.17 //layer=mcon //count=1 \
 //x=15.29 //y=2.26 //x2=15.29 //y2=2.26
r1304 (  45 47 ) resistor r=0.0936408 //w=0.196 //l=0.125 //layer=m1 \
 //thickness=0.36 //x=15.292 //y=2.26 //x2=15.292 //y2=2.385
r1305 (  43 128 ) resistor r=9.3 //w=0.17 //l=0.17 //layer=mcon //count=1 \
 //x=6.04 //y=4.88 //x2=6.04 //y2=4.88
r1306 (  41 111 ) resistor r=4.5 //w=0.15 //l=0.15 //layer=via1 //count=1 \
 //x=6.04 //y=4.755 //x2=6.04 //y2=4.755
r1307 (  41 43 ) resistor r=0.0533276 //w=0.293 //l=0.125 //layer=m1 \
 //thickness=0.36 //x=6.04 //y=4.755 //x2=6.04 //y2=4.88
r1308 (  38 123 ) resistor r=9.3 //w=0.17 //l=0.17 //layer=mcon //count=1 \
 //x=6.04 //y=2.26 //x2=6.04 //y2=2.26
r1309 (  31 70 ) resistor r=0.0715665 //w=0.226 //l=0.115996 //layer=m1 \
 //thickness=0.36 //x=54.88 //y=2.375 //x2=54.882 //y2=2.26
r1310 (  25 54 ) resistor r=0.0715665 //w=0.226 //l=0.115996 //layer=m1 \
 //thickness=0.36 //x=30.46 //y=2.375 //x2=30.462 //y2=2.26
r1311 (  16 38 ) resistor r=0.0715665 //w=0.226 //l=0.115996 //layer=m1 \
 //thickness=0.36 //x=6.04 //y=2.375 //x2=6.042 //y2=2.26
r1312 (  15 82 ) resistor r=0.0547138 //w=0.297 //l=0.13 //layer=m1 \
 //thickness=0.36 //x=64.165 //y=4.62 //x2=64.165 //y2=4.75
r1313 (  15 35 ) resistor r=0.0352913 //w=0.297 //l=0.047697 //layer=m1 \
 //thickness=0.36 //x=64.165 //y=4.62 //x2=64.13 //y2=4.59
r1314 (  14 73 ) resistor r=0.0575939 //w=0.293 //l=0.135 //layer=m1 \
 //thickness=0.36 //x=54.88 //y=4.62 //x2=54.88 //y2=4.755
r1315 (  14 32 ) resistor r=0.0325091 //w=0.293 //l=0.025 //layer=m1 \
 //thickness=0.36 //x=54.88 //y=4.62 //x2=54.88 //y2=4.595
r1316 (  13 66 ) resistor r=0.0547138 //w=0.297 //l=0.13 //layer=m1 \
 //thickness=0.36 //x=39.745 //y=4.62 //x2=39.745 //y2=4.75
r1317 (  13 29 ) resistor r=0.0352913 //w=0.297 //l=0.047697 //layer=m1 \
 //thickness=0.36 //x=39.745 //y=4.62 //x2=39.71 //y2=4.59
r1318 (  12 57 ) resistor r=0.0575939 //w=0.293 //l=0.135 //layer=m1 \
 //thickness=0.36 //x=30.46 //y=4.62 //x2=30.46 //y2=4.755
r1319 (  12 26 ) resistor r=0.0325091 //w=0.293 //l=0.025 //layer=m1 \
 //thickness=0.36 //x=30.46 //y=4.62 //x2=30.46 //y2=4.595
r1320 (  11 50 ) resistor r=0.0547138 //w=0.297 //l=0.13 //layer=m1 \
 //thickness=0.36 //x=15.325 //y=4.62 //x2=15.325 //y2=4.75
r1321 (  11 22 ) resistor r=0.0352913 //w=0.297 //l=0.047697 //layer=m1 \
 //thickness=0.36 //x=15.325 //y=4.62 //x2=15.29 //y2=4.59
r1322 (  10 41 ) resistor r=0.0575939 //w=0.293 //l=0.135 //layer=m1 \
 //thickness=0.36 //x=6.04 //y=4.62 //x2=6.04 //y2=4.755
r1323 (  10 17 ) resistor r=0.0325091 //w=0.293 //l=0.025 //layer=m1 \
 //thickness=0.36 //x=6.04 //y=4.62 //x2=6.04 //y2=4.595
r1324 (  9 35 ) resistor r=1.73664 //w=0.131 //l=1.82 //layer=m1 \
 //thickness=0.36 //x=64.13 //y=2.77 //x2=64.13 //y2=4.59
r1325 (  9 79 ) resistor r=0.367366 //w=0.131 //l=0.385 //layer=m1 \
 //thickness=0.36 //x=64.13 //y=2.77 //x2=64.13 //y2=2.385
r1326 (  8 32 ) resistor r=0.682252 //w=0.131 //l=0.715 //layer=m1 \
 //thickness=0.36 //x=54.88 //y=3.88 //x2=54.88 //y2=4.595
r1327 (  8 31 ) resistor r=1.43607 //w=0.131 //l=1.505 //layer=m1 \
 //thickness=0.36 //x=54.88 //y=3.88 //x2=54.88 //y2=2.375
r1328 (  7 29 ) resistor r=1.73664 //w=0.131 //l=1.82 //layer=m1 \
 //thickness=0.36 //x=39.71 //y=2.77 //x2=39.71 //y2=4.59
r1329 (  7 63 ) resistor r=0.367366 //w=0.131 //l=0.385 //layer=m1 \
 //thickness=0.36 //x=39.71 //y=2.77 //x2=39.71 //y2=2.385
r1330 (  6 26 ) resistor r=0.682252 //w=0.131 //l=0.715 //layer=m1 \
 //thickness=0.36 //x=30.46 //y=3.88 //x2=30.46 //y2=4.595
r1331 (  6 25 ) resistor r=1.43607 //w=0.131 //l=1.505 //layer=m1 \
 //thickness=0.36 //x=30.46 //y=3.88 //x2=30.46 //y2=2.375
r1332 (  5 22 ) resistor r=1.03053 //w=0.131 //l=1.08 //layer=m1 \
 //thickness=0.36 //x=15.29 //y=3.51 //x2=15.29 //y2=4.59
r1333 (  4 5 ) resistor r=0.706107 //w=0.131 //l=0.74 //layer=m1 \
 //thickness=0.36 //x=15.29 //y=2.77 //x2=15.29 //y2=3.51
r1334 (  4 47 ) resistor r=0.367366 //w=0.131 //l=0.385 //layer=m1 \
 //thickness=0.36 //x=15.29 //y=2.77 //x2=15.29 //y2=2.385
r1335 (  3 17 ) resistor r=0.682252 //w=0.131 //l=0.715 //layer=m1 \
 //thickness=0.36 //x=6.04 //y=3.88 //x2=6.04 //y2=4.595
r1336 (  2 3 ) resistor r=0.353053 //w=0.131 //l=0.37 //layer=m1 \
 //thickness=0.36 //x=6.04 //y=3.51 //x2=6.04 //y2=3.88
r1337 (  1 2 ) resistor r=1.05916 //w=0.131 //l=1.11 //layer=m1 \
 //thickness=0.36 //x=6.04 //y=2.4 //x2=6.04 //y2=3.51
r1338 (  1 16 ) resistor r=0.023855 //w=0.131 //l=0.025 //layer=m1 \
 //thickness=0.36 //x=6.04 //y=2.4 //x2=6.04 //y2=2.375
ends PM_TMRDFFSNQNX1\%CLK

subckt PM_TMRDFFSNQNX1\%noxref_15 ( 2 3 4 5 7 10 11 13 14 15 16 18 19 20 22 23 \
 26 34 35 38 41 47 50 54 57 58 60 63 67 71 72 75 84 89 97 105 122 131 135 136 \
 137 138 139 140 141 142 143 148 150 152 158 159 160 161 162 163 167 169 172 \
 173 178 179 182 196 199 201 202 203 )
c495 ( 199 0 ) capacitor c=0.00885916f //x=56.055 //y=1.095
c496 ( 196 0 ) capacitor c=0.0634117f //x=66.72 //y=4.88
c497 ( 182 0 ) capacitor c=0.0354953f //x=51.21 //y=4.88
c498 ( 179 0 ) capacitor c=0.0284095f //x=51.18 //y=2.095
c499 ( 178 0 ) capacitor c=0.0476356f //x=51.18 //y=2.26
c500 ( 173 0 ) capacitor c=0.0318956f //x=67.055 //y=1.39
c501 ( 172 0 ) capacitor c=0.0186809f //x=67.055 //y=1.045
c502 ( 169 0 ) capacitor c=0.0141821f //x=66.9 //y=1.545
c503 ( 167 0 ) capacitor c=0.0158553f //x=66.9 //y=0.89
c504 ( 163 0 ) capacitor c=0.088055f //x=66.525 //y=2.095
c505 ( 162 0 ) capacitor c=0.0229235f //x=66.525 //y=1.7
c506 ( 161 0 ) capacitor c=0.0234359f //x=66.525 //y=1.39
c507 ( 160 0 ) capacitor c=0.0198759f //x=66.525 //y=1.045
c508 ( 159 0 ) capacitor c=0.0439708f //x=51.745 //y=1.43
c509 ( 158 0 ) capacitor c=0.0192582f //x=51.745 //y=1.085
c510 ( 152 0 ) capacitor c=0.0162526f //x=51.59 //y=1.585
c511 ( 150 0 ) capacitor c=0.0157807f //x=51.59 //y=0.93
c512 ( 148 0 ) capacitor c=0.0357885f //x=51.585 //y=4.97
c513 ( 143 0 ) capacitor c=0.0210762f //x=51.215 //y=1.74
c514 ( 142 0 ) capacitor c=0.0168511f //x=51.215 //y=1.43
c515 ( 141 0 ) capacitor c=0.0175485f //x=51.215 //y=1.085
c516 ( 140 0 ) capacitor c=0.110369f //x=67.06 //y=6.2
c517 ( 139 0 ) capacitor c=0.154619f //x=66.62 //y=6.2
c518 ( 138 0 ) capacitor c=0.155269f //x=51.66 //y=6.2
c519 ( 137 0 ) capacitor c=0.110375f //x=51.22 //y=6.2
c520 ( 131 0 ) capacitor c=5.44848e-19 //x=66.72 //y=4.88
c521 ( 122 0 ) capacitor c=7.85889e-19 //x=66.72 //y=2.26
c522 ( 105 0 ) capacitor c=0.0293709f //x=55.95 //y=5.56
c523 ( 97 0 ) capacitor c=0.029137f //x=55.07 //y=5.56
c524 ( 89 0 ) capacitor c=0.0277605f //x=54.19 //y=5.56
c525 ( 84 0 ) capacitor c=5.80994e-19 //x=51.21 //y=4.88
c526 ( 75 0 ) capacitor c=5.78095e-19 //x=51.18 //y=2.26
c527 ( 72 0 ) capacitor c=0.129791f //x=66.56 //y=4.265
c528 ( 71 0 ) capacitor c=0.00334332f //x=66.72 //y=4.265
c529 ( 67 0 ) capacitor c=7.93125e-19 //x=51.34 //y=4.245
c530 ( 63 0 ) capacitor c=9.81648e-19 //x=56.885 //y=4.25
c531 ( 60 0 ) capacitor c=0.0589422f //x=56.565 //y=4.25
c532 ( 58 0 ) capacitor c=0.00539295f //x=66.722 //y=4.74
c533 ( 57 0 ) capacitor c=0.00587099f //x=66.72 //y=4.88
c534 ( 54 0 ) capacitor c=0.00463527f //x=66.72 //y=2.26
c535 ( 50 0 ) capacitor c=0.0134782f //x=66.72 //y=4.25
c536 ( 47 0 ) capacitor c=0.0149922f //x=56.725 //y=4.25
c537 ( 41 0 ) capacitor c=8.88597e-19 //x=55.95 //y=5.335
c538 ( 38 0 ) capacitor c=0.0073827f //x=55.07 //y=5.335
c539 ( 35 0 ) capacitor c=0.0112819f //x=54.192 //y=5.335
c540 ( 34 0 ) capacitor c=0.0152963f //x=51.18 //y=4.25
c541 ( 26 0 ) capacitor c=0.00504845f //x=51.18 //y=2.26
c542 ( 23 0 ) capacitor c=0.011639f //x=66.72 //y=4.425
c543 ( 22 0 ) capacitor c=0.0473477f //x=66.72 //y=4.105
c544 ( 20 0 ) capacitor c=0.0222419f //x=56.73 //y=5.25
c545 ( 19 0 ) capacitor c=0.0128722f //x=56.73 //y=4.41
c546 ( 18 0 ) capacitor c=0.0593697f //x=56.73 //y=4.09
c547 ( 16 0 ) capacitor c=0.0048771f //x=56.33 //y=1.845
c548 ( 15 0 ) capacitor c=0.0132264f //x=56.645 //y=1.845
c549 ( 14 0 ) capacitor c=0.0167333f //x=56.245 //y=1.76
c550 ( 13 0 ) capacitor c=0.0111164f //x=56.245 //y=1.305
c551 ( 11 0 ) capacitor c=0.0223199f //x=56.645 //y=5.335
c552 ( 10 0 ) capacitor c=0.00933983f //x=55.95 //y=5.56
c553 ( 7 0 ) capacitor c=0.019596f //x=55.835 //y=5.335
c554 ( 5 0 ) capacitor c=0.0147581f //x=54.95 //y=5.335
c555 ( 4 0 ) capacitor c=0.00931067f //x=51.18 //y=4.735
c556 ( 3 0 ) capacitor c=0.0102157f //x=51.18 //y=4.405
c557 ( 2 0 ) capacitor c=0.0359248f //x=51.18 //y=4.085
r558 (  194 196 ) resistor r=20.6867 //w=0.233 //l=0.1 //layer=ply \
 //thickness=0.18 //x=66.62 //y=4.88 //x2=66.72 //y2=4.88
r559 (  184 185 ) resistor r=32.4568 //w=0.214 //l=0.075 //layer=ply \
 //thickness=0.18 //x=51.21 //y=4.97 //x2=51.21 //y2=5.045
r560 (  182 184 ) resistor r=20.271 //w=0.214 //l=0.09 //layer=ply \
 //thickness=0.18 //x=51.21 //y=4.88 //x2=51.21 //y2=4.97
r561 (  178 179 ) resistor r=52.7279 //w=0.214 //l=0.165 //layer=ply \
 //thickness=0.18 //x=51.18 //y=2.26 //x2=51.18 //y2=2.095
r562 (  174 196 ) resistor r=70.3348 //w=0.233 //l=0.414367 //layer=ply \
 //thickness=0.18 //x=67.06 //y=5.045 //x2=66.72 //y2=4.88
r563 (  173 198 ) resistor r=45.1352 //w=0.168 //l=0.173853 //layer=ply \
 //thickness=0.18 //x=67.055 //y=1.39 //x2=67.015 //y2=1.545
r564 (  172 197 ) resistor r=45.1352 //w=0.168 //l=0.173853 //layer=ply \
 //thickness=0.18 //x=67.055 //y=1.045 //x2=67.015 //y2=0.89
r565 (  172 173 ) resistor r=176.904 //w=0.094 //l=0.345 //layer=ply \
 //thickness=0.18 //x=67.055 //y=1.045 //x2=67.055 //y2=1.39
r566 (  170 193 ) resistor r=10.701 //w=0.21 //l=0.115 //layer=ply \
 //thickness=0.18 //x=66.68 //y=1.545 //x2=66.565 //y2=1.545
r567 (  169 198 ) resistor r=5.52526 //w=0.168 //l=0.115 //layer=ply \
 //thickness=0.18 //x=66.9 //y=1.545 //x2=67.015 //y2=1.545
r568 (  168 192 ) resistor r=5.52526 //w=0.168 //l=0.115 //layer=ply \
 //thickness=0.18 //x=66.68 //y=0.89 //x2=66.565 //y2=0.89
r569 (  167 197 ) resistor r=5.52526 //w=0.168 //l=0.115 //layer=ply \
 //thickness=0.18 //x=66.9 //y=0.89 //x2=67.015 //y2=0.89
r570 (  167 168 ) resistor r=112.809 //w=0.094 //l=0.22 //layer=ply \
 //thickness=0.18 //x=66.9 //y=0.89 //x2=66.68 //y2=0.89
r571 (  164 194 ) resistor r=13.0941 //w=0.233 //l=0.165 //layer=ply \
 //thickness=0.18 //x=66.62 //y=5.045 //x2=66.62 //y2=4.88
r572 (  163 191 ) resistor r=34.8111 //w=0.27 //l=0.264953 //layer=ply \
 //thickness=0.18 //x=66.525 //y=2.095 //x2=66.72 //y2=2.26
r573 (  162 193 ) resistor r=39.5823 //w=0.21 //l=0.173853 //layer=ply \
 //thickness=0.18 //x=66.525 //y=1.7 //x2=66.565 //y2=1.545
r574 (  162 163 ) resistor r=202.543 //w=0.094 //l=0.395 //layer=ply \
 //thickness=0.18 //x=66.525 //y=1.7 //x2=66.525 //y2=2.095
r575 (  161 193 ) resistor r=39.5823 //w=0.21 //l=0.173853 //layer=ply \
 //thickness=0.18 //x=66.525 //y=1.39 //x2=66.565 //y2=1.545
r576 (  160 192 ) resistor r=45.1352 //w=0.168 //l=0.173853 //layer=ply \
 //thickness=0.18 //x=66.525 //y=1.045 //x2=66.565 //y2=0.89
r577 (  160 161 ) resistor r=176.904 //w=0.094 //l=0.345 //layer=ply \
 //thickness=0.18 //x=66.525 //y=1.045 //x2=66.525 //y2=1.39
r578 (  159 189 ) resistor r=45.1352 //w=0.168 //l=0.173853 //layer=ply \
 //thickness=0.18 //x=51.745 //y=1.43 //x2=51.705 //y2=1.585
r579 (  158 188 ) resistor r=45.1352 //w=0.168 //l=0.173853 //layer=ply \
 //thickness=0.18 //x=51.745 //y=1.085 //x2=51.705 //y2=0.93
r580 (  158 159 ) resistor r=176.904 //w=0.094 //l=0.345 //layer=ply \
 //thickness=0.18 //x=51.745 //y=1.085 //x2=51.745 //y2=1.43
r581 (  153 187 ) resistor r=10.701 //w=0.21 //l=0.115 //layer=ply \
 //thickness=0.18 //x=51.37 //y=1.585 //x2=51.255 //y2=1.585
r582 (  152 189 ) resistor r=5.52526 //w=0.168 //l=0.115 //layer=ply \
 //thickness=0.18 //x=51.59 //y=1.585 //x2=51.705 //y2=1.585
r583 (  151 186 ) resistor r=5.52526 //w=0.168 //l=0.115 //layer=ply \
 //thickness=0.18 //x=51.37 //y=0.93 //x2=51.255 //y2=0.93
r584 (  150 188 ) resistor r=5.52526 //w=0.168 //l=0.115 //layer=ply \
 //thickness=0.18 //x=51.59 //y=0.93 //x2=51.705 //y2=0.93
r585 (  150 151 ) resistor r=112.809 //w=0.094 //l=0.22 //layer=ply \
 //thickness=0.18 //x=51.59 //y=0.93 //x2=51.37 //y2=0.93
r586 (  149 184 ) resistor r=16.5046 //w=0.27 //l=0.135 //layer=ply \
 //thickness=0.18 //x=51.345 //y=4.97 //x2=51.21 //y2=4.97
r587 (  148 155 ) resistor r=26.9307 //w=0.15 //l=0.106066 //layer=ply \
 //thickness=0.18 //x=51.585 //y=4.97 //x2=51.66 //y2=5.045
r588 (  148 149 ) resistor r=123.064 //w=0.094 //l=0.24 //layer=ply \
 //thickness=0.18 //x=51.585 //y=4.97 //x2=51.345 //y2=4.97
r589 (  143 187 ) resistor r=39.5823 //w=0.21 //l=0.173853 //layer=ply \
 //thickness=0.18 //x=51.215 //y=1.74 //x2=51.255 //y2=1.585
r590 (  143 179 ) resistor r=182.032 //w=0.094 //l=0.355 //layer=ply \
 //thickness=0.18 //x=51.215 //y=1.74 //x2=51.215 //y2=2.095
r591 (  142 187 ) resistor r=39.5823 //w=0.21 //l=0.173853 //layer=ply \
 //thickness=0.18 //x=51.215 //y=1.43 //x2=51.255 //y2=1.585
r592 (  141 186 ) resistor r=45.1352 //w=0.168 //l=0.173853 //layer=ply \
 //thickness=0.18 //x=51.215 //y=1.085 //x2=51.255 //y2=0.93
r593 (  141 142 ) resistor r=176.904 //w=0.094 //l=0.345 //layer=ply \
 //thickness=0.18 //x=51.215 //y=1.085 //x2=51.215 //y2=1.43
r594 (  140 174 ) resistor r=592.245 //w=0.094 //l=1.155 //layer=ply \
 //thickness=0.18 //x=67.06 //y=6.2 //x2=67.06 //y2=5.045
r595 (  139 164 ) resistor r=592.245 //w=0.094 //l=1.155 //layer=ply \
 //thickness=0.18 //x=66.62 //y=6.2 //x2=66.62 //y2=5.045
r596 (  138 155 ) resistor r=592.245 //w=0.094 //l=1.155 //layer=ply \
 //thickness=0.18 //x=51.66 //y=6.2 //x2=51.66 //y2=5.045
r597 (  137 185 ) resistor r=592.245 //w=0.094 //l=1.155 //layer=ply \
 //thickness=0.18 //x=51.22 //y=6.2 //x2=51.22 //y2=5.045
r598 (  136 169 ) resistor r=56.4043 //w=0.094 //l=0.11 //layer=ply \
 //thickness=0.18 //x=66.79 //y=1.545 //x2=66.9 //y2=1.545
r599 (  136 170 ) resistor r=56.4043 //w=0.094 //l=0.11 //layer=ply \
 //thickness=0.18 //x=66.79 //y=1.545 //x2=66.68 //y2=1.545
r600 (  135 152 ) resistor r=56.4043 //w=0.094 //l=0.11 //layer=ply \
 //thickness=0.18 //x=51.48 //y=1.585 //x2=51.59 //y2=1.585
r601 (  135 153 ) resistor r=56.4043 //w=0.094 //l=0.11 //layer=ply \
 //thickness=0.18 //x=51.48 //y=1.585 //x2=51.37 //y2=1.585
r602 (  131 196 ) resistor r=152 //w=0.17 //l=0.17 //layer=licon //count=1 \
 //x=66.72 //y=4.88 //x2=66.72 //y2=4.88
r603 (  122 191 ) resistor r=152 //w=0.17 //l=0.17 //layer=licon //count=1 \
 //x=66.72 //y=2.26 //x2=66.72 //y2=2.26
r604 (  105 203 ) resistor r=23.615 //w=0.187 //l=0.345 //layer=li \
 //thickness=0.1 //x=55.95 //y=5.56 //x2=55.95 //y2=5.905
r605 (  97 202 ) resistor r=23.615 //w=0.187 //l=0.345 //layer=li \
 //thickness=0.1 //x=55.07 //y=5.56 //x2=55.07 //y2=5.905
r606 (  89 201 ) resistor r=23.615 //w=0.187 //l=0.345 //layer=li \
 //thickness=0.1 //x=54.19 //y=5.56 //x2=54.19 //y2=5.905
r607 (  84 182 ) resistor r=152 //w=0.17 //l=0.17 //layer=licon //count=1 \
 //x=51.21 //y=4.88 //x2=51.21 //y2=4.88
r608 (  75 178 ) resistor r=152 //w=0.17 //l=0.17 //layer=licon //count=1 \
 //x=51.18 //y=2.26 //x2=51.18 //y2=2.26
r609 (  71 72 ) resistor r=0.10734 //w=0.281 //l=0.16 //layer=m2 \
 //thickness=0.36 //x=66.72 //y=4.265 //x2=66.56 //y2=4.265
r610 (  65 67 ) resistor r=0.10734 //w=0.281 //l=0.16 //layer=m2 \
 //thickness=0.36 //x=51.18 //y=4.245 //x2=51.34 //y2=4.245
r611 (  63 69 ) resistor r=0.10734 //w=0.281 //l=0.16 //layer=m2 \
 //thickness=0.36 //x=56.885 //y=4.25 //x2=56.725 //y2=4.25
r612 (  63 72 ) resistor r=9.23187 //w=0.131 //l=9.675 //layer=m2 \
 //thickness=0.36 //x=56.885 //y=4.25 //x2=66.56 //y2=4.25
r613 (  60 69 ) resistor r=0.10734 //w=0.281 //l=0.16 //layer=m2 \
 //thickness=0.36 //x=56.565 //y=4.25 //x2=56.725 //y2=4.25
r614 (  60 67 ) resistor r=4.98569 //w=0.131 //l=5.225 //layer=m2 \
 //thickness=0.36 //x=56.565 //y=4.25 //x2=51.34 //y2=4.25
r615 (  57 131 ) resistor r=9.3 //w=0.17 //l=0.17 //layer=mcon //count=1 \
 //x=66.72 //y=4.88 //x2=66.72 //y2=4.88
r616 (  57 58 ) resistor r=0.103207 //w=0.196 //l=0.14 //layer=m1 \
 //thickness=0.36 //x=66.722 //y=4.88 //x2=66.722 //y2=4.74
r617 (  54 122 ) resistor r=9.3 //w=0.17 //l=0.17 //layer=mcon //count=1 \
 //x=66.72 //y=2.26 //x2=66.72 //y2=2.26
r618 (  52 71 ) resistor r=4.5 //w=0.15 //l=0.15 //layer=via1 //count=1 \
 //x=66.72 //y=4.265 //x2=66.72 //y2=4.265
r619 (  50 52 ) resistor r=0.0049867 //w=0.376 //l=0.015 //layer=m1 \
 //thickness=0.36 //x=66.667 //y=4.25 //x2=66.667 //y2=4.265
r620 (  47 69 ) resistor r=4.5 //w=0.15 //l=0.15 //layer=via1 //count=1 \
 //x=56.725 //y=4.25 //x2=56.725 //y2=4.25
r621 (  45 199 ) resistor r=9.3 //w=0.17 //l=0.17 //layer=mcon //count=1 \
 //x=56.245 //y=1.19 //x2=56.245 //y2=1.19
r622 (  43 105 ) resistor r=9.3 //w=0.17 //l=0.17 //layer=mcon //count=1 \
 //x=55.95 //y=5.56 //x2=55.95 //y2=5.56
r623 (  40 97 ) resistor r=9.3 //w=0.17 //l=0.17 //layer=mcon //count=1 \
 //x=55.07 //y=5.56 //x2=55.07 //y2=5.56
r624 (  38 40 ) resistor r=0.121228 //w=0.232 //l=0.225 //layer=m1 \
 //thickness=0.36 //x=55.07 //y=5.335 //x2=55.07 //y2=5.56
r625 (  37 89 ) resistor r=9.3 //w=0.17 //l=0.17 //layer=mcon //count=1 \
 //x=54.19 //y=5.56 //x2=54.19 //y2=5.56
r626 (  35 37 ) resistor r=0.129608 //w=0.217 //l=0.225 //layer=m1 \
 //thickness=0.36 //x=54.192 //y=5.335 //x2=54.192 //y2=5.56
r627 (  32 65 ) resistor r=4.5 //w=0.15 //l=0.15 //layer=via1 //count=1 \
 //x=51.18 //y=4.245 //x2=51.18 //y2=4.245
r628 (  32 34 ) resistor r=0.00166223 //w=0.376 //l=0.005 //layer=m1 \
 //thickness=0.36 //x=51.232 //y=4.245 //x2=51.232 //y2=4.25
r629 (  30 84 ) resistor r=9.3 //w=0.17 //l=0.17 //layer=mcon //count=1 \
 //x=51.21 //y=4.88 //x2=51.21 //y2=4.88
r630 (  26 75 ) resistor r=9.3 //w=0.17 //l=0.17 //layer=mcon //count=1 \
 //x=51.18 //y=2.26 //x2=51.18 //y2=2.26
r631 (  26 28 ) resistor r=0.0936408 //w=0.196 //l=0.125 //layer=m1 \
 //thickness=0.36 //x=51.182 //y=2.26 //x2=51.182 //y2=2.385
r632 (  23 52 ) resistor r=0.0911593 //w=0.376 //l=0.184608 //layer=m1 \
 //thickness=0.36 //x=66.72 //y=4.425 //x2=66.667 //y2=4.265
r633 (  23 58 ) resistor r=0.300573 //w=0.131 //l=0.315 //layer=m1 \
 //thickness=0.36 //x=66.72 //y=4.425 //x2=66.72 //y2=4.74
r634 (  22 50 ) resistor r=0.0861726 //w=0.376 //l=0.16944 //layer=m1 \
 //thickness=0.36 //x=66.72 //y=4.105 //x2=66.667 //y2=4.25
r635 (  21 54 ) resistor r=0.0933015 //w=0.201 //l=0.125 //layer=m1 \
 //thickness=0.36 //x=66.72 //y=2.385 //x2=66.72 //y2=2.26
r636 (  21 22 ) resistor r=1.64122 //w=0.131 //l=1.72 //layer=m1 \
 //thickness=0.36 //x=66.72 //y=2.385 //x2=66.72 //y2=4.105
r637 (  19 47 ) resistor r=0.0911593 //w=0.376 //l=0.181989 //layer=m1 \
 //thickness=0.36 //x=56.73 //y=4.41 //x2=56.777 //y2=4.25
r638 (  19 20 ) resistor r=0.801527 //w=0.131 //l=0.84 //layer=m1 \
 //thickness=0.36 //x=56.73 //y=4.41 //x2=56.73 //y2=5.25
r639 (  18 47 ) resistor r=0.0911593 //w=0.376 //l=0.181989 //layer=m1 \
 //thickness=0.36 //x=56.73 //y=4.09 //x2=56.777 //y2=4.25
r640 (  17 18 ) resistor r=2.06107 //w=0.131 //l=2.16 //layer=m1 \
 //thickness=0.36 //x=56.73 //y=1.93 //x2=56.73 //y2=4.09
r641 (  15 17 ) resistor r=0.0698411 //w=0.17 //l=0.120208 //layer=m1 \
 //thickness=0.36 //x=56.645 //y=1.845 //x2=56.73 //y2=1.93
r642 (  15 16 ) resistor r=0.300573 //w=0.131 //l=0.315 //layer=m1 \
 //thickness=0.36 //x=56.645 //y=1.845 //x2=56.33 //y2=1.845
r643 (  14 16 ) resistor r=0.0698411 //w=0.17 //l=0.120208 //layer=m1 \
 //thickness=0.36 //x=56.245 //y=1.76 //x2=56.33 //y2=1.845
r644 (  13 45 ) resistor r=0.0717383 //w=0.224 //l=0.115 //layer=m1 \
 //thickness=0.36 //x=56.245 //y=1.305 //x2=56.245 //y2=1.19
r645 (  13 14 ) resistor r=0.43416 //w=0.131 //l=0.455 //layer=m1 \
 //thickness=0.36 //x=56.245 //y=1.305 //x2=56.245 //y2=1.76
r646 (  12 41 ) resistor r=0.0675342 //w=0.23 //l=0.115 //layer=m1 \
 //thickness=0.36 //x=56.065 //y=5.335 //x2=55.95 //y2=5.335
r647 (  11 20 ) resistor r=0.0698411 //w=0.17 //l=0.120208 //layer=m1 \
 //thickness=0.36 //x=56.645 //y=5.335 //x2=56.73 //y2=5.25
r648 (  11 12 ) resistor r=0.553435 //w=0.131 //l=0.58 //layer=m1 \
 //thickness=0.36 //x=56.645 //y=5.335 //x2=56.065 //y2=5.335
r649 (  10 43 ) resistor r=0.00118313 //w=0.23 //layer=m1 //thickness=0.36 \
 //x=55.95 //y=5.56 //x2=55.95 //y2=5.56
r650 (  9 41 ) resistor r=0.002872 //w=0.34 //l=0.085 //layer=m1 \
 //thickness=0.36 //x=55.95 //y=5.42 //x2=55.95 //y2=5.335
r651 (  9 10 ) resistor r=0.091623 //w=0.191 //l=0.14 //layer=m1 \
 //thickness=0.36 //x=55.95 //y=5.42 //x2=55.95 //y2=5.56
r652 (  8 38 ) resistor r=0.0262263 //w=0.232 //l=0.12 //layer=m1 \
 //thickness=0.36 //x=55.19 //y=5.335 //x2=55.07 //y2=5.335
r653 (  7 41 ) resistor r=0.0675342 //w=0.23 //l=0.115 //layer=m1 \
 //thickness=0.36 //x=55.835 //y=5.335 //x2=55.95 //y2=5.335
r654 (  7 8 ) resistor r=0.615458 //w=0.131 //l=0.645 //layer=m1 \
 //thickness=0.36 //x=55.835 //y=5.335 //x2=55.19 //y2=5.335
r655 (  6 35 ) resistor r=0.0222262 //w=0.217 //l=0.118 //layer=m1 \
 //thickness=0.36 //x=54.31 //y=5.335 //x2=54.192 //y2=5.335
r656 (  5 38 ) resistor r=0.0262263 //w=0.232 //l=0.12 //layer=m1 \
 //thickness=0.36 //x=54.95 //y=5.335 //x2=55.07 //y2=5.335
r657 (  5 6 ) resistor r=0.610687 //w=0.131 //l=0.64 //layer=m1 \
 //thickness=0.36 //x=54.95 //y=5.335 //x2=54.31 //y2=5.335
r658 (  4 30 ) resistor r=0.0878548 //w=0.228 //l=0.159295 //layer=m1 \
 //thickness=0.36 //x=51.18 //y=4.735 //x2=51.21 //y2=4.88
r659 (  3 34 ) resistor r=0.0894971 //w=0.376 //l=0.179123 //layer=m1 \
 //thickness=0.36 //x=51.18 //y=4.405 //x2=51.232 //y2=4.25
r660 (  3 4 ) resistor r=0.314885 //w=0.131 //l=0.33 //layer=m1 \
 //thickness=0.36 //x=51.18 //y=4.405 //x2=51.18 //y2=4.735
r661 (  2 32 ) resistor r=0.0911593 //w=0.376 //l=0.184174 //layer=m1 \
 //thickness=0.36 //x=51.18 //y=4.085 //x2=51.232 //y2=4.245
r662 (  2 28 ) resistor r=1.62214 //w=0.131 //l=1.7 //layer=m1 \
 //thickness=0.36 //x=51.18 //y=4.085 //x2=51.18 //y2=2.385
ends PM_TMRDFFSNQNX1\%noxref_15

subckt PM_TMRDFFSNQNX1\%SN ( 1 2 3 4 5 6 7 8 9 10 11 12 13 14 15 16 19 20 22 \
 23 24 25 26 29 30 72 74 75 76 78 80 82 84 85 86 87 88 90 92 94 97 101 111 112 \
 115 120 125 130 135 140 145 150 155 160 165 170 174 175 176 177 178 179 180 \
 181 182 183 184 185 186 187 188 189 190 191 192 193 194 196 202 203 204 205 \
 206 211 212 213 215 221 222 223 224 225 230 231 232 234 240 241 242 243 244 \
 249 250 251 253 259 260 261 262 263 268 269 270 272 278 279 280 281 282 287 \
 288 289 291 297 298 299 300 301 309 320 331 342 353 364 )
c1234 ( 364 0 ) capacitor c=0.0369044f //x=71.16 //y=4.88
c1235 ( 353 0 ) capacitor c=0.0369044f //x=59.69 //y=4.88
c1236 ( 342 0 ) capacitor c=0.0369044f //x=46.74 //y=4.88
c1237 ( 331 0 ) capacitor c=0.0369044f //x=35.27 //y=4.88
c1238 ( 320 0 ) capacitor c=0.0369044f //x=22.32 //y=4.88
c1239 ( 309 0 ) capacitor c=0.0369044f //x=10.85 //y=4.88
c1240 ( 301 0 ) capacitor c=0.0309248f //x=71.495 //y=4.97
c1241 ( 300 0 ) capacitor c=0.0847377f //x=71.25 //y=2.095
c1242 ( 299 0 ) capacitor c=0.0170266f //x=71.25 //y=1.63
c1243 ( 298 0 ) capacitor c=0.018609f //x=71.25 //y=1.4
c1244 ( 297 0 ) capacitor c=0.0186599f //x=71.25 //y=1.09
c1245 ( 291 0 ) capacitor c=0.0146988f //x=71.095 //y=1.555
c1246 ( 289 0 ) capacitor c=0.0148531f //x=71.095 //y=0.935
c1247 ( 288 0 ) capacitor c=0.0334406f //x=70.725 //y=1.4
c1248 ( 287 0 ) capacitor c=0.0173191f //x=70.725 //y=1.09
c1249 ( 282 0 ) capacitor c=0.0309248f //x=60.025 //y=4.97
c1250 ( 281 0 ) capacitor c=0.0845067f //x=59.78 //y=2.095
c1251 ( 280 0 ) capacitor c=0.0170266f //x=59.78 //y=1.63
c1252 ( 279 0 ) capacitor c=0.018609f //x=59.78 //y=1.4
c1253 ( 278 0 ) capacitor c=0.0186599f //x=59.78 //y=1.09
c1254 ( 272 0 ) capacitor c=0.0146988f //x=59.625 //y=1.555
c1255 ( 270 0 ) capacitor c=0.0148531f //x=59.625 //y=0.935
c1256 ( 269 0 ) capacitor c=0.0334406f //x=59.255 //y=1.4
c1257 ( 268 0 ) capacitor c=0.0173191f //x=59.255 //y=1.09
c1258 ( 263 0 ) capacitor c=0.0309248f //x=47.075 //y=4.97
c1259 ( 262 0 ) capacitor c=0.0847377f //x=46.83 //y=2.095
c1260 ( 261 0 ) capacitor c=0.0170266f //x=46.83 //y=1.63
c1261 ( 260 0 ) capacitor c=0.018609f //x=46.83 //y=1.4
c1262 ( 259 0 ) capacitor c=0.0186599f //x=46.83 //y=1.09
c1263 ( 253 0 ) capacitor c=0.0146988f //x=46.675 //y=1.555
c1264 ( 251 0 ) capacitor c=0.0148531f //x=46.675 //y=0.935
c1265 ( 250 0 ) capacitor c=0.0334406f //x=46.305 //y=1.4
c1266 ( 249 0 ) capacitor c=0.0173191f //x=46.305 //y=1.09
c1267 ( 244 0 ) capacitor c=0.0309248f //x=35.605 //y=4.97
c1268 ( 243 0 ) capacitor c=0.0845067f //x=35.36 //y=2.095
c1269 ( 242 0 ) capacitor c=0.0170266f //x=35.36 //y=1.63
c1270 ( 241 0 ) capacitor c=0.018609f //x=35.36 //y=1.4
c1271 ( 240 0 ) capacitor c=0.0186599f //x=35.36 //y=1.09
c1272 ( 234 0 ) capacitor c=0.0146988f //x=35.205 //y=1.555
c1273 ( 232 0 ) capacitor c=0.0148531f //x=35.205 //y=0.935
c1274 ( 231 0 ) capacitor c=0.0334406f //x=34.835 //y=1.4
c1275 ( 230 0 ) capacitor c=0.0173191f //x=34.835 //y=1.09
c1276 ( 225 0 ) capacitor c=0.0309248f //x=22.655 //y=4.97
c1277 ( 224 0 ) capacitor c=0.0847377f //x=22.41 //y=2.095
c1278 ( 223 0 ) capacitor c=0.0170266f //x=22.41 //y=1.63
c1279 ( 222 0 ) capacitor c=0.018609f //x=22.41 //y=1.4
c1280 ( 221 0 ) capacitor c=0.0186599f //x=22.41 //y=1.09
c1281 ( 215 0 ) capacitor c=0.0146988f //x=22.255 //y=1.555
c1282 ( 213 0 ) capacitor c=0.0148531f //x=22.255 //y=0.935
c1283 ( 212 0 ) capacitor c=0.0334406f //x=21.885 //y=1.4
c1284 ( 211 0 ) capacitor c=0.0173191f //x=21.885 //y=1.09
c1285 ( 206 0 ) capacitor c=0.0309248f //x=11.185 //y=4.97
c1286 ( 205 0 ) capacitor c=0.0845067f //x=10.94 //y=2.095
c1287 ( 204 0 ) capacitor c=0.0170266f //x=10.94 //y=1.63
c1288 ( 203 0 ) capacitor c=0.018609f //x=10.94 //y=1.4
c1289 ( 202 0 ) capacitor c=0.0186599f //x=10.94 //y=1.09
c1290 ( 196 0 ) capacitor c=0.0146988f //x=10.785 //y=1.555
c1291 ( 194 0 ) capacitor c=0.0148531f //x=10.785 //y=0.935
c1292 ( 193 0 ) capacitor c=0.0334406f //x=10.415 //y=1.4
c1293 ( 192 0 ) capacitor c=0.0173191f //x=10.415 //y=1.09
c1294 ( 191 0 ) capacitor c=0.110208f //x=71.57 //y=6.2
c1295 ( 190 0 ) capacitor c=0.110214f //x=71.13 //y=6.2
c1296 ( 189 0 ) capacitor c=0.110208f //x=60.1 //y=6.2
c1297 ( 188 0 ) capacitor c=0.110214f //x=59.66 //y=6.2
c1298 ( 187 0 ) capacitor c=0.110208f //x=47.15 //y=6.2
c1299 ( 186 0 ) capacitor c=0.110214f //x=46.71 //y=6.2
c1300 ( 185 0 ) capacitor c=0.110208f //x=35.68 //y=6.2
c1301 ( 184 0 ) capacitor c=0.110214f //x=35.24 //y=6.2
c1302 ( 183 0 ) capacitor c=0.110208f //x=22.73 //y=6.2
c1303 ( 182 0 ) capacitor c=0.110214f //x=22.29 //y=6.2
c1304 ( 181 0 ) capacitor c=0.110208f //x=11.26 //y=6.2
c1305 ( 180 0 ) capacitor c=0.110214f //x=10.82 //y=6.2
c1306 ( 170 0 ) capacitor c=0.00129935f //x=71.16 //y=4.88
c1307 ( 165 0 ) capacitor c=0.00121786f //x=71.16 //y=2.26
c1308 ( 160 0 ) capacitor c=0.00129935f //x=59.69 //y=4.88
c1309 ( 155 0 ) capacitor c=0.00121786f //x=59.69 //y=2.26
c1310 ( 150 0 ) capacitor c=0.00129935f //x=46.74 //y=4.88
c1311 ( 145 0 ) capacitor c=0.00121786f //x=46.74 //y=2.26
c1312 ( 140 0 ) capacitor c=0.00129935f //x=35.27 //y=4.88
c1313 ( 135 0 ) capacitor c=0.00121786f //x=35.27 //y=2.26
c1314 ( 130 0 ) capacitor c=0.00129935f //x=22.32 //y=4.88
c1315 ( 125 0 ) capacitor c=0.00121786f //x=22.32 //y=2.26
c1316 ( 120 0 ) capacitor c=0.00129935f //x=10.85 //y=4.88
c1317 ( 115 0 ) capacitor c=0.00121786f //x=10.85 //y=2.26
c1318 ( 112 0 ) capacitor c=0.275202f //x=70.99 //y=2.39
c1319 ( 111 0 ) capacitor c=0.00509167f //x=71.15 //y=2.39
c1320 ( 101 0 ) capacitor c=0.00509167f //x=11.01 //y=2.39
c1321 ( 97 0 ) capacitor c=0.0261338f //x=59.85 //y=2.4
c1322 ( 94 0 ) capacitor c=0.008735f //x=58.795 //y=2.39
c1323 ( 92 0 ) capacitor c=0.0938815f //x=58.195 //y=2.4
c1324 ( 90 0 ) capacitor c=0.0147801f //x=53.985 //y=2.385
c1325 ( 88 0 ) capacitor c=0.0269815f //x=53.385 //y=2.4
c1326 ( 87 0 ) capacitor c=0.114927f //x=51.705 //y=2.385
c1327 ( 86 0 ) capacitor c=0.0145823f //x=52.135 //y=2.385
c1328 ( 85 0 ) capacitor c=0.0261338f //x=35.43 //y=2.4
c1329 ( 84 0 ) capacitor c=0.264604f //x=46.57 //y=2.4
c1330 ( 82 0 ) capacitor c=0.008735f //x=34.375 //y=2.39
c1331 ( 80 0 ) capacitor c=0.0938815f //x=33.775 //y=2.4
c1332 ( 78 0 ) capacitor c=0.0147801f //x=29.565 //y=2.385
c1333 ( 76 0 ) capacitor c=0.0269815f //x=28.965 //y=2.4
c1334 ( 75 0 ) capacitor c=0.126542f //x=27.285 //y=2.385
c1335 ( 74 0 ) capacitor c=0.0145823f //x=27.715 //y=2.385
c1336 ( 72 0 ) capacitor c=0.27346f //x=22.15 //y=2.4
c1337 ( 30 0 ) capacitor c=0.0616483f //x=71.16 //y=4.765
c1338 ( 29 0 ) capacitor c=0.0113796f //x=71.16 //y=2.55
c1339 ( 26 0 ) capacitor c=0.0112516f //x=59.69 //y=2.55
c1340 ( 25 0 ) capacitor c=0.0590956f //x=46.74 //y=4.765
c1341 ( 24 0 ) capacitor c=0.0113469f //x=46.74 //y=2.55
c1342 ( 23 0 ) capacitor c=0.0580472f //x=35.27 //y=4.765
c1343 ( 22 0 ) capacitor c=0.0112516f //x=35.27 //y=2.55
c1344 ( 20 0 ) capacitor c=0.00505177f //x=22.32 //y=4.765
c1345 ( 19 0 ) capacitor c=0.0113796f //x=22.32 //y=2.55
c1346 ( 16 0 ) capacitor c=0.00505177f //x=10.85 //y=4.765
c1347 ( 15 0 ) capacitor c=0.0112516f //x=10.85 //y=2.55
c1348 ( 14 0 ) capacitor c=0.00500645f //x=71.16 //y=4.88
c1349 ( 12 0 ) capacitor c=0.00505177f //x=59.69 //y=4.88
c1350 ( 10 0 ) capacitor c=0.00505177f //x=46.74 //y=4.88
c1351 ( 8 0 ) capacitor c=0.00505177f //x=35.27 //y=4.88
c1352 ( 4 0 ) capacitor c=0.0580476f //x=59.69 //y=2.77
c1353 ( 3 0 ) capacitor c=0.0597443f //x=22.32 //y=2.77
c1354 ( 1 0 ) capacitor c=0.0609174f //x=10.85 //y=2.77
r1355 (  366 367 ) resistor r=32.4568 //w=0.214 //l=0.075 //layer=ply \
 //thickness=0.18 //x=71.16 //y=4.97 //x2=71.16 //y2=5.045
r1356 (  364 366 ) resistor r=20.271 //w=0.214 //l=0.09 //layer=ply \
 //thickness=0.18 //x=71.16 //y=4.88 //x2=71.16 //y2=4.97
r1357 (  355 356 ) resistor r=32.4568 //w=0.214 //l=0.075 //layer=ply \
 //thickness=0.18 //x=59.69 //y=4.97 //x2=59.69 //y2=5.045
r1358 (  353 355 ) resistor r=20.271 //w=0.214 //l=0.09 //layer=ply \
 //thickness=0.18 //x=59.69 //y=4.88 //x2=59.69 //y2=4.97
r1359 (  344 345 ) resistor r=32.4568 //w=0.214 //l=0.075 //layer=ply \
 //thickness=0.18 //x=46.74 //y=4.97 //x2=46.74 //y2=5.045
r1360 (  342 344 ) resistor r=20.271 //w=0.214 //l=0.09 //layer=ply \
 //thickness=0.18 //x=46.74 //y=4.88 //x2=46.74 //y2=4.97
r1361 (  333 334 ) resistor r=32.4568 //w=0.214 //l=0.075 //layer=ply \
 //thickness=0.18 //x=35.27 //y=4.97 //x2=35.27 //y2=5.045
r1362 (  331 333 ) resistor r=20.271 //w=0.214 //l=0.09 //layer=ply \
 //thickness=0.18 //x=35.27 //y=4.88 //x2=35.27 //y2=4.97
r1363 (  322 323 ) resistor r=32.4568 //w=0.214 //l=0.075 //layer=ply \
 //thickness=0.18 //x=22.32 //y=4.97 //x2=22.32 //y2=5.045
r1364 (  320 322 ) resistor r=20.271 //w=0.214 //l=0.09 //layer=ply \
 //thickness=0.18 //x=22.32 //y=4.88 //x2=22.32 //y2=4.97
r1365 (  311 312 ) resistor r=32.4568 //w=0.214 //l=0.075 //layer=ply \
 //thickness=0.18 //x=10.85 //y=4.97 //x2=10.85 //y2=5.045
r1366 (  309 311 ) resistor r=20.271 //w=0.214 //l=0.09 //layer=ply \
 //thickness=0.18 //x=10.85 //y=4.88 //x2=10.85 //y2=4.97
r1367 (  302 366 ) resistor r=16.5046 //w=0.27 //l=0.135 //layer=ply \
 //thickness=0.18 //x=71.295 //y=4.97 //x2=71.16 //y2=4.97
r1368 (  301 303 ) resistor r=26.9307 //w=0.15 //l=0.106066 //layer=ply \
 //thickness=0.18 //x=71.495 //y=4.97 //x2=71.57 //y2=5.045
r1369 (  301 302 ) resistor r=102.553 //w=0.094 //l=0.2 //layer=ply \
 //thickness=0.18 //x=71.495 //y=4.97 //x2=71.295 //y2=4.97
r1370 (  300 371 ) resistor r=38.6777 //w=0.284 //l=0.198997 //layer=ply \
 //thickness=0.18 //x=71.25 //y=2.095 //x2=71.175 //y2=2.26
r1371 (  299 369 ) resistor r=21.2976 //w=0.217 //l=0.0928709 //layer=ply \
 //thickness=0.18 //x=71.25 //y=1.63 //x2=71.21 //y2=1.555
r1372 (  299 300 ) resistor r=238.436 //w=0.094 //l=0.465 //layer=ply \
 //thickness=0.18 //x=71.25 //y=1.63 //x2=71.25 //y2=2.095
r1373 (  298 369 ) resistor r=39.0671 //w=0.217 //l=0.173853 //layer=ply \
 //thickness=0.18 //x=71.25 //y=1.4 //x2=71.21 //y2=1.555
r1374 (  297 368 ) resistor r=45.1352 //w=0.168 //l=0.173853 //layer=ply \
 //thickness=0.18 //x=71.25 //y=1.09 //x2=71.21 //y2=0.935
r1375 (  297 298 ) resistor r=158.957 //w=0.094 //l=0.31 //layer=ply \
 //thickness=0.18 //x=71.25 //y=1.09 //x2=71.25 //y2=1.4
r1376 (  292 362 ) resistor r=5.52526 //w=0.168 //l=0.115 //layer=ply \
 //thickness=0.18 //x=70.88 //y=1.555 //x2=70.765 //y2=1.555
r1377 (  291 369 ) resistor r=11.4558 //w=0.217 //l=0.115 //layer=ply \
 //thickness=0.18 //x=71.095 //y=1.555 //x2=71.21 //y2=1.555
r1378 (  290 361 ) resistor r=5.52526 //w=0.168 //l=0.115 //layer=ply \
 //thickness=0.18 //x=70.88 //y=0.935 //x2=70.765 //y2=0.935
r1379 (  289 368 ) resistor r=5.52526 //w=0.168 //l=0.115 //layer=ply \
 //thickness=0.18 //x=71.095 //y=0.935 //x2=71.21 //y2=0.935
r1380 (  289 290 ) resistor r=110.245 //w=0.094 //l=0.215 //layer=ply \
 //thickness=0.18 //x=71.095 //y=0.935 //x2=70.88 //y2=0.935
r1381 (  288 362 ) resistor r=45.1352 //w=0.168 //l=0.173853 //layer=ply \
 //thickness=0.18 //x=70.725 //y=1.4 //x2=70.765 //y2=1.555
r1382 (  287 361 ) resistor r=45.1352 //w=0.168 //l=0.173853 //layer=ply \
 //thickness=0.18 //x=70.725 //y=1.09 //x2=70.765 //y2=0.935
r1383 (  287 288 ) resistor r=158.957 //w=0.094 //l=0.31 //layer=ply \
 //thickness=0.18 //x=70.725 //y=1.09 //x2=70.725 //y2=1.4
r1384 (  283 355 ) resistor r=16.5046 //w=0.27 //l=0.135 //layer=ply \
 //thickness=0.18 //x=59.825 //y=4.97 //x2=59.69 //y2=4.97
r1385 (  282 284 ) resistor r=26.9307 //w=0.15 //l=0.106066 //layer=ply \
 //thickness=0.18 //x=60.025 //y=4.97 //x2=60.1 //y2=5.045
r1386 (  282 283 ) resistor r=102.553 //w=0.094 //l=0.2 //layer=ply \
 //thickness=0.18 //x=60.025 //y=4.97 //x2=59.825 //y2=4.97
r1387 (  281 360 ) resistor r=38.6777 //w=0.284 //l=0.198997 //layer=ply \
 //thickness=0.18 //x=59.78 //y=2.095 //x2=59.705 //y2=2.26
r1388 (  280 358 ) resistor r=21.2976 //w=0.217 //l=0.0928709 //layer=ply \
 //thickness=0.18 //x=59.78 //y=1.63 //x2=59.74 //y2=1.555
r1389 (  280 281 ) resistor r=238.436 //w=0.094 //l=0.465 //layer=ply \
 //thickness=0.18 //x=59.78 //y=1.63 //x2=59.78 //y2=2.095
r1390 (  279 358 ) resistor r=39.0671 //w=0.217 //l=0.173853 //layer=ply \
 //thickness=0.18 //x=59.78 //y=1.4 //x2=59.74 //y2=1.555
r1391 (  278 357 ) resistor r=45.1352 //w=0.168 //l=0.173853 //layer=ply \
 //thickness=0.18 //x=59.78 //y=1.09 //x2=59.74 //y2=0.935
r1392 (  278 279 ) resistor r=158.957 //w=0.094 //l=0.31 //layer=ply \
 //thickness=0.18 //x=59.78 //y=1.09 //x2=59.78 //y2=1.4
r1393 (  273 351 ) resistor r=5.52526 //w=0.168 //l=0.115 //layer=ply \
 //thickness=0.18 //x=59.41 //y=1.555 //x2=59.295 //y2=1.555
r1394 (  272 358 ) resistor r=11.4558 //w=0.217 //l=0.115 //layer=ply \
 //thickness=0.18 //x=59.625 //y=1.555 //x2=59.74 //y2=1.555
r1395 (  271 350 ) resistor r=5.52526 //w=0.168 //l=0.115 //layer=ply \
 //thickness=0.18 //x=59.41 //y=0.935 //x2=59.295 //y2=0.935
r1396 (  270 357 ) resistor r=5.52526 //w=0.168 //l=0.115 //layer=ply \
 //thickness=0.18 //x=59.625 //y=0.935 //x2=59.74 //y2=0.935
r1397 (  270 271 ) resistor r=110.245 //w=0.094 //l=0.215 //layer=ply \
 //thickness=0.18 //x=59.625 //y=0.935 //x2=59.41 //y2=0.935
r1398 (  269 351 ) resistor r=45.1352 //w=0.168 //l=0.173853 //layer=ply \
 //thickness=0.18 //x=59.255 //y=1.4 //x2=59.295 //y2=1.555
r1399 (  268 350 ) resistor r=45.1352 //w=0.168 //l=0.173853 //layer=ply \
 //thickness=0.18 //x=59.255 //y=1.09 //x2=59.295 //y2=0.935
r1400 (  268 269 ) resistor r=158.957 //w=0.094 //l=0.31 //layer=ply \
 //thickness=0.18 //x=59.255 //y=1.09 //x2=59.255 //y2=1.4
r1401 (  264 344 ) resistor r=16.5046 //w=0.27 //l=0.135 //layer=ply \
 //thickness=0.18 //x=46.875 //y=4.97 //x2=46.74 //y2=4.97
r1402 (  263 265 ) resistor r=26.9307 //w=0.15 //l=0.106066 //layer=ply \
 //thickness=0.18 //x=47.075 //y=4.97 //x2=47.15 //y2=5.045
r1403 (  263 264 ) resistor r=102.553 //w=0.094 //l=0.2 //layer=ply \
 //thickness=0.18 //x=47.075 //y=4.97 //x2=46.875 //y2=4.97
r1404 (  262 349 ) resistor r=38.6777 //w=0.284 //l=0.198997 //layer=ply \
 //thickness=0.18 //x=46.83 //y=2.095 //x2=46.755 //y2=2.26
r1405 (  261 347 ) resistor r=21.2976 //w=0.217 //l=0.0928709 //layer=ply \
 //thickness=0.18 //x=46.83 //y=1.63 //x2=46.79 //y2=1.555
r1406 (  261 262 ) resistor r=238.436 //w=0.094 //l=0.465 //layer=ply \
 //thickness=0.18 //x=46.83 //y=1.63 //x2=46.83 //y2=2.095
r1407 (  260 347 ) resistor r=39.0671 //w=0.217 //l=0.173853 //layer=ply \
 //thickness=0.18 //x=46.83 //y=1.4 //x2=46.79 //y2=1.555
r1408 (  259 346 ) resistor r=45.1352 //w=0.168 //l=0.173853 //layer=ply \
 //thickness=0.18 //x=46.83 //y=1.09 //x2=46.79 //y2=0.935
r1409 (  259 260 ) resistor r=158.957 //w=0.094 //l=0.31 //layer=ply \
 //thickness=0.18 //x=46.83 //y=1.09 //x2=46.83 //y2=1.4
r1410 (  254 340 ) resistor r=5.52526 //w=0.168 //l=0.115 //layer=ply \
 //thickness=0.18 //x=46.46 //y=1.555 //x2=46.345 //y2=1.555
r1411 (  253 347 ) resistor r=11.4558 //w=0.217 //l=0.115 //layer=ply \
 //thickness=0.18 //x=46.675 //y=1.555 //x2=46.79 //y2=1.555
r1412 (  252 339 ) resistor r=5.52526 //w=0.168 //l=0.115 //layer=ply \
 //thickness=0.18 //x=46.46 //y=0.935 //x2=46.345 //y2=0.935
r1413 (  251 346 ) resistor r=5.52526 //w=0.168 //l=0.115 //layer=ply \
 //thickness=0.18 //x=46.675 //y=0.935 //x2=46.79 //y2=0.935
r1414 (  251 252 ) resistor r=110.245 //w=0.094 //l=0.215 //layer=ply \
 //thickness=0.18 //x=46.675 //y=0.935 //x2=46.46 //y2=0.935
r1415 (  250 340 ) resistor r=45.1352 //w=0.168 //l=0.173853 //layer=ply \
 //thickness=0.18 //x=46.305 //y=1.4 //x2=46.345 //y2=1.555
r1416 (  249 339 ) resistor r=45.1352 //w=0.168 //l=0.173853 //layer=ply \
 //thickness=0.18 //x=46.305 //y=1.09 //x2=46.345 //y2=0.935
r1417 (  249 250 ) resistor r=158.957 //w=0.094 //l=0.31 //layer=ply \
 //thickness=0.18 //x=46.305 //y=1.09 //x2=46.305 //y2=1.4
r1418 (  245 333 ) resistor r=16.5046 //w=0.27 //l=0.135 //layer=ply \
 //thickness=0.18 //x=35.405 //y=4.97 //x2=35.27 //y2=4.97
r1419 (  244 246 ) resistor r=26.9307 //w=0.15 //l=0.106066 //layer=ply \
 //thickness=0.18 //x=35.605 //y=4.97 //x2=35.68 //y2=5.045
r1420 (  244 245 ) resistor r=102.553 //w=0.094 //l=0.2 //layer=ply \
 //thickness=0.18 //x=35.605 //y=4.97 //x2=35.405 //y2=4.97
r1421 (  243 338 ) resistor r=38.6777 //w=0.284 //l=0.198997 //layer=ply \
 //thickness=0.18 //x=35.36 //y=2.095 //x2=35.285 //y2=2.26
r1422 (  242 336 ) resistor r=21.2976 //w=0.217 //l=0.0928709 //layer=ply \
 //thickness=0.18 //x=35.36 //y=1.63 //x2=35.32 //y2=1.555
r1423 (  242 243 ) resistor r=238.436 //w=0.094 //l=0.465 //layer=ply \
 //thickness=0.18 //x=35.36 //y=1.63 //x2=35.36 //y2=2.095
r1424 (  241 336 ) resistor r=39.0671 //w=0.217 //l=0.173853 //layer=ply \
 //thickness=0.18 //x=35.36 //y=1.4 //x2=35.32 //y2=1.555
r1425 (  240 335 ) resistor r=45.1352 //w=0.168 //l=0.173853 //layer=ply \
 //thickness=0.18 //x=35.36 //y=1.09 //x2=35.32 //y2=0.935
r1426 (  240 241 ) resistor r=158.957 //w=0.094 //l=0.31 //layer=ply \
 //thickness=0.18 //x=35.36 //y=1.09 //x2=35.36 //y2=1.4
r1427 (  235 329 ) resistor r=5.52526 //w=0.168 //l=0.115 //layer=ply \
 //thickness=0.18 //x=34.99 //y=1.555 //x2=34.875 //y2=1.555
r1428 (  234 336 ) resistor r=11.4558 //w=0.217 //l=0.115 //layer=ply \
 //thickness=0.18 //x=35.205 //y=1.555 //x2=35.32 //y2=1.555
r1429 (  233 328 ) resistor r=5.52526 //w=0.168 //l=0.115 //layer=ply \
 //thickness=0.18 //x=34.99 //y=0.935 //x2=34.875 //y2=0.935
r1430 (  232 335 ) resistor r=5.52526 //w=0.168 //l=0.115 //layer=ply \
 //thickness=0.18 //x=35.205 //y=0.935 //x2=35.32 //y2=0.935
r1431 (  232 233 ) resistor r=110.245 //w=0.094 //l=0.215 //layer=ply \
 //thickness=0.18 //x=35.205 //y=0.935 //x2=34.99 //y2=0.935
r1432 (  231 329 ) resistor r=45.1352 //w=0.168 //l=0.173853 //layer=ply \
 //thickness=0.18 //x=34.835 //y=1.4 //x2=34.875 //y2=1.555
r1433 (  230 328 ) resistor r=45.1352 //w=0.168 //l=0.173853 //layer=ply \
 //thickness=0.18 //x=34.835 //y=1.09 //x2=34.875 //y2=0.935
r1434 (  230 231 ) resistor r=158.957 //w=0.094 //l=0.31 //layer=ply \
 //thickness=0.18 //x=34.835 //y=1.09 //x2=34.835 //y2=1.4
r1435 (  226 322 ) resistor r=16.5046 //w=0.27 //l=0.135 //layer=ply \
 //thickness=0.18 //x=22.455 //y=4.97 //x2=22.32 //y2=4.97
r1436 (  225 227 ) resistor r=26.9307 //w=0.15 //l=0.106066 //layer=ply \
 //thickness=0.18 //x=22.655 //y=4.97 //x2=22.73 //y2=5.045
r1437 (  225 226 ) resistor r=102.553 //w=0.094 //l=0.2 //layer=ply \
 //thickness=0.18 //x=22.655 //y=4.97 //x2=22.455 //y2=4.97
r1438 (  224 327 ) resistor r=38.6777 //w=0.284 //l=0.198997 //layer=ply \
 //thickness=0.18 //x=22.41 //y=2.095 //x2=22.335 //y2=2.26
r1439 (  223 325 ) resistor r=21.2976 //w=0.217 //l=0.0928709 //layer=ply \
 //thickness=0.18 //x=22.41 //y=1.63 //x2=22.37 //y2=1.555
r1440 (  223 224 ) resistor r=238.436 //w=0.094 //l=0.465 //layer=ply \
 //thickness=0.18 //x=22.41 //y=1.63 //x2=22.41 //y2=2.095
r1441 (  222 325 ) resistor r=39.0671 //w=0.217 //l=0.173853 //layer=ply \
 //thickness=0.18 //x=22.41 //y=1.4 //x2=22.37 //y2=1.555
r1442 (  221 324 ) resistor r=45.1352 //w=0.168 //l=0.173853 //layer=ply \
 //thickness=0.18 //x=22.41 //y=1.09 //x2=22.37 //y2=0.935
r1443 (  221 222 ) resistor r=158.957 //w=0.094 //l=0.31 //layer=ply \
 //thickness=0.18 //x=22.41 //y=1.09 //x2=22.41 //y2=1.4
r1444 (  216 318 ) resistor r=5.52526 //w=0.168 //l=0.115 //layer=ply \
 //thickness=0.18 //x=22.04 //y=1.555 //x2=21.925 //y2=1.555
r1445 (  215 325 ) resistor r=11.4558 //w=0.217 //l=0.115 //layer=ply \
 //thickness=0.18 //x=22.255 //y=1.555 //x2=22.37 //y2=1.555
r1446 (  214 317 ) resistor r=5.52526 //w=0.168 //l=0.115 //layer=ply \
 //thickness=0.18 //x=22.04 //y=0.935 //x2=21.925 //y2=0.935
r1447 (  213 324 ) resistor r=5.52526 //w=0.168 //l=0.115 //layer=ply \
 //thickness=0.18 //x=22.255 //y=0.935 //x2=22.37 //y2=0.935
r1448 (  213 214 ) resistor r=110.245 //w=0.094 //l=0.215 //layer=ply \
 //thickness=0.18 //x=22.255 //y=0.935 //x2=22.04 //y2=0.935
r1449 (  212 318 ) resistor r=45.1352 //w=0.168 //l=0.173853 //layer=ply \
 //thickness=0.18 //x=21.885 //y=1.4 //x2=21.925 //y2=1.555
r1450 (  211 317 ) resistor r=45.1352 //w=0.168 //l=0.173853 //layer=ply \
 //thickness=0.18 //x=21.885 //y=1.09 //x2=21.925 //y2=0.935
r1451 (  211 212 ) resistor r=158.957 //w=0.094 //l=0.31 //layer=ply \
 //thickness=0.18 //x=21.885 //y=1.09 //x2=21.885 //y2=1.4
r1452 (  207 311 ) resistor r=16.5046 //w=0.27 //l=0.135 //layer=ply \
 //thickness=0.18 //x=10.985 //y=4.97 //x2=10.85 //y2=4.97
r1453 (  206 208 ) resistor r=26.9307 //w=0.15 //l=0.106066 //layer=ply \
 //thickness=0.18 //x=11.185 //y=4.97 //x2=11.26 //y2=5.045
r1454 (  206 207 ) resistor r=102.553 //w=0.094 //l=0.2 //layer=ply \
 //thickness=0.18 //x=11.185 //y=4.97 //x2=10.985 //y2=4.97
r1455 (  205 316 ) resistor r=38.6777 //w=0.284 //l=0.198997 //layer=ply \
 //thickness=0.18 //x=10.94 //y=2.095 //x2=10.865 //y2=2.26
r1456 (  204 314 ) resistor r=21.2976 //w=0.217 //l=0.0928709 //layer=ply \
 //thickness=0.18 //x=10.94 //y=1.63 //x2=10.9 //y2=1.555
r1457 (  204 205 ) resistor r=238.436 //w=0.094 //l=0.465 //layer=ply \
 //thickness=0.18 //x=10.94 //y=1.63 //x2=10.94 //y2=2.095
r1458 (  203 314 ) resistor r=39.0671 //w=0.217 //l=0.173853 //layer=ply \
 //thickness=0.18 //x=10.94 //y=1.4 //x2=10.9 //y2=1.555
r1459 (  202 313 ) resistor r=45.1352 //w=0.168 //l=0.173853 //layer=ply \
 //thickness=0.18 //x=10.94 //y=1.09 //x2=10.9 //y2=0.935
r1460 (  202 203 ) resistor r=158.957 //w=0.094 //l=0.31 //layer=ply \
 //thickness=0.18 //x=10.94 //y=1.09 //x2=10.94 //y2=1.4
r1461 (  197 307 ) resistor r=5.52526 //w=0.168 //l=0.115 //layer=ply \
 //thickness=0.18 //x=10.57 //y=1.555 //x2=10.455 //y2=1.555
r1462 (  196 314 ) resistor r=11.4558 //w=0.217 //l=0.115 //layer=ply \
 //thickness=0.18 //x=10.785 //y=1.555 //x2=10.9 //y2=1.555
r1463 (  195 306 ) resistor r=5.52526 //w=0.168 //l=0.115 //layer=ply \
 //thickness=0.18 //x=10.57 //y=0.935 //x2=10.455 //y2=0.935
r1464 (  194 313 ) resistor r=5.52526 //w=0.168 //l=0.115 //layer=ply \
 //thickness=0.18 //x=10.785 //y=0.935 //x2=10.9 //y2=0.935
r1465 (  194 195 ) resistor r=110.245 //w=0.094 //l=0.215 //layer=ply \
 //thickness=0.18 //x=10.785 //y=0.935 //x2=10.57 //y2=0.935
r1466 (  193 307 ) resistor r=45.1352 //w=0.168 //l=0.173853 //layer=ply \
 //thickness=0.18 //x=10.415 //y=1.4 //x2=10.455 //y2=1.555
r1467 (  192 306 ) resistor r=45.1352 //w=0.168 //l=0.173853 //layer=ply \
 //thickness=0.18 //x=10.415 //y=1.09 //x2=10.455 //y2=0.935
r1468 (  192 193 ) resistor r=158.957 //w=0.094 //l=0.31 //layer=ply \
 //thickness=0.18 //x=10.415 //y=1.09 //x2=10.415 //y2=1.4
r1469 (  191 303 ) resistor r=592.245 //w=0.094 //l=1.155 //layer=ply \
 //thickness=0.18 //x=71.57 //y=6.2 //x2=71.57 //y2=5.045
r1470 (  190 367 ) resistor r=592.245 //w=0.094 //l=1.155 //layer=ply \
 //thickness=0.18 //x=71.13 //y=6.2 //x2=71.13 //y2=5.045
r1471 (  189 284 ) resistor r=592.245 //w=0.094 //l=1.155 //layer=ply \
 //thickness=0.18 //x=60.1 //y=6.2 //x2=60.1 //y2=5.045
r1472 (  188 356 ) resistor r=592.245 //w=0.094 //l=1.155 //layer=ply \
 //thickness=0.18 //x=59.66 //y=6.2 //x2=59.66 //y2=5.045
r1473 (  187 265 ) resistor r=592.245 //w=0.094 //l=1.155 //layer=ply \
 //thickness=0.18 //x=47.15 //y=6.2 //x2=47.15 //y2=5.045
r1474 (  186 345 ) resistor r=592.245 //w=0.094 //l=1.155 //layer=ply \
 //thickness=0.18 //x=46.71 //y=6.2 //x2=46.71 //y2=5.045
r1475 (  185 246 ) resistor r=592.245 //w=0.094 //l=1.155 //layer=ply \
 //thickness=0.18 //x=35.68 //y=6.2 //x2=35.68 //y2=5.045
r1476 (  184 334 ) resistor r=592.245 //w=0.094 //l=1.155 //layer=ply \
 //thickness=0.18 //x=35.24 //y=6.2 //x2=35.24 //y2=5.045
r1477 (  183 227 ) resistor r=592.245 //w=0.094 //l=1.155 //layer=ply \
 //thickness=0.18 //x=22.73 //y=6.2 //x2=22.73 //y2=5.045
r1478 (  182 323 ) resistor r=592.245 //w=0.094 //l=1.155 //layer=ply \
 //thickness=0.18 //x=22.29 //y=6.2 //x2=22.29 //y2=5.045
r1479 (  181 208 ) resistor r=592.245 //w=0.094 //l=1.155 //layer=ply \
 //thickness=0.18 //x=11.26 //y=6.2 //x2=11.26 //y2=5.045
r1480 (  180 312 ) resistor r=592.245 //w=0.094 //l=1.155 //layer=ply \
 //thickness=0.18 //x=10.82 //y=6.2 //x2=10.82 //y2=5.045
r1481 (  179 291 ) resistor r=55.3787 //w=0.094 //l=0.108 //layer=ply \
 //thickness=0.18 //x=70.987 //y=1.555 //x2=71.095 //y2=1.555
r1482 (  179 292 ) resistor r=54.866 //w=0.094 //l=0.107 //layer=ply \
 //thickness=0.18 //x=70.987 //y=1.555 //x2=70.88 //y2=1.555
r1483 (  178 272 ) resistor r=55.3787 //w=0.094 //l=0.108 //layer=ply \
 //thickness=0.18 //x=59.517 //y=1.555 //x2=59.625 //y2=1.555
r1484 (  178 273 ) resistor r=54.866 //w=0.094 //l=0.107 //layer=ply \
 //thickness=0.18 //x=59.517 //y=1.555 //x2=59.41 //y2=1.555
r1485 (  177 253 ) resistor r=55.3787 //w=0.094 //l=0.108 //layer=ply \
 //thickness=0.18 //x=46.567 //y=1.555 //x2=46.675 //y2=1.555
r1486 (  177 254 ) resistor r=54.866 //w=0.094 //l=0.107 //layer=ply \
 //thickness=0.18 //x=46.567 //y=1.555 //x2=46.46 //y2=1.555
r1487 (  176 234 ) resistor r=55.3787 //w=0.094 //l=0.108 //layer=ply \
 //thickness=0.18 //x=35.097 //y=1.555 //x2=35.205 //y2=1.555
r1488 (  176 235 ) resistor r=54.866 //w=0.094 //l=0.107 //layer=ply \
 //thickness=0.18 //x=35.097 //y=1.555 //x2=34.99 //y2=1.555
r1489 (  175 215 ) resistor r=55.3787 //w=0.094 //l=0.108 //layer=ply \
 //thickness=0.18 //x=22.147 //y=1.555 //x2=22.255 //y2=1.555
r1490 (  175 216 ) resistor r=54.866 //w=0.094 //l=0.107 //layer=ply \
 //thickness=0.18 //x=22.147 //y=1.555 //x2=22.04 //y2=1.555
r1491 (  174 196 ) resistor r=55.3787 //w=0.094 //l=0.108 //layer=ply \
 //thickness=0.18 //x=10.677 //y=1.555 //x2=10.785 //y2=1.555
r1492 (  174 197 ) resistor r=54.866 //w=0.094 //l=0.107 //layer=ply \
 //thickness=0.18 //x=10.677 //y=1.555 //x2=10.57 //y2=1.555
r1493 (  170 364 ) resistor r=152 //w=0.17 //l=0.17 //layer=licon //count=1 \
 //x=71.16 //y=4.88 //x2=71.16 //y2=4.88
r1494 (  165 371 ) resistor r=152 //w=0.17 //l=0.17 //layer=licon //count=1 \
 //x=71.16 //y=2.26 //x2=71.16 //y2=2.26
r1495 (  160 353 ) resistor r=152 //w=0.17 //l=0.17 //layer=licon //count=1 \
 //x=59.69 //y=4.88 //x2=59.69 //y2=4.88
r1496 (  155 360 ) resistor r=152 //w=0.17 //l=0.17 //layer=licon //count=1 \
 //x=59.69 //y=2.26 //x2=59.69 //y2=2.26
r1497 (  150 342 ) resistor r=152 //w=0.17 //l=0.17 //layer=licon //count=1 \
 //x=46.74 //y=4.88 //x2=46.74 //y2=4.88
r1498 (  145 349 ) resistor r=152 //w=0.17 //l=0.17 //layer=licon //count=1 \
 //x=46.74 //y=2.26 //x2=46.74 //y2=2.26
r1499 (  140 331 ) resistor r=152 //w=0.17 //l=0.17 //layer=licon //count=1 \
 //x=35.27 //y=4.88 //x2=35.27 //y2=4.88
r1500 (  135 338 ) resistor r=152 //w=0.17 //l=0.17 //layer=licon //count=1 \
 //x=35.27 //y=2.26 //x2=35.27 //y2=2.26
r1501 (  130 320 ) resistor r=152 //w=0.17 //l=0.17 //layer=licon //count=1 \
 //x=22.32 //y=4.88 //x2=22.32 //y2=4.88
r1502 (  125 327 ) resistor r=152 //w=0.17 //l=0.17 //layer=licon //count=1 \
 //x=22.32 //y=2.26 //x2=22.32 //y2=2.26
r1503 (  120 309 ) resistor r=152 //w=0.17 //l=0.17 //layer=licon //count=1 \
 //x=10.85 //y=4.88 //x2=10.85 //y2=4.88
r1504 (  115 316 ) resistor r=152 //w=0.17 //l=0.17 //layer=licon //count=1 \
 //x=10.85 //y=2.26 //x2=10.85 //y2=2.26
r1505 (  111 112 ) resistor r=0.10734 //w=0.281 //l=0.16 //layer=m2 \
 //thickness=0.36 //x=71.15 //y=2.39 //x2=70.99 //y2=2.39
r1506 (  99 101 ) resistor r=0.10734 //w=0.281 //l=0.16 //layer=m2 \
 //thickness=0.36 //x=10.85 //y=2.39 //x2=11.01 //y2=2.39
r1507 (  97 109 ) resistor r=0.0986081 //w=0.216 //l=0.164924 //layer=m2 \
 //thickness=0.36 //x=59.85 //y=2.4 //x2=59.69 //y2=2.39
r1508 (  97 112 ) resistor r=10.6298 //w=0.131 //l=11.14 //layer=m2 \
 //thickness=0.36 //x=59.85 //y=2.4 //x2=70.99 //y2=2.4
r1509 (  94 109 ) resistor r=0.523955 //w=0.216 //l=0.895 //layer=m2 \
 //thickness=0.36 //x=58.795 //y=2.39 //x2=59.69 //y2=2.39
r1510 (  94 95 ) resistor r=0.410305 //w=0.131 //l=0.43 //layer=m2 \
 //thickness=0.36 //x=58.795 //y=2.39 //x2=58.365 //y2=2.39
r1511 (  92 95 ) resistor r=0.125 //w=0.17 //l=0.174929 //layer=m2 \
 //thickness=0.36 //x=58.195 //y=2.4 //x2=58.365 //y2=2.39
r1512 (  92 93 ) resistor r=3.77385 //w=0.131 //l=3.955 //layer=m2 \
 //thickness=0.36 //x=58.195 //y=2.4 //x2=54.24 //y2=2.4
r1513 (  90 93 ) resistor r=0.1875 //w=0.17 //l=0.262393 //layer=m2 \
 //thickness=0.36 //x=53.985 //y=2.385 //x2=54.24 //y2=2.4
r1514 (  90 91 ) resistor r=0.410305 //w=0.131 //l=0.43 //layer=m2 \
 //thickness=0.36 //x=53.985 //y=2.385 //x2=53.555 //y2=2.385
r1515 (  88 91 ) resistor r=0.125 //w=0.17 //l=0.177341 //layer=m2 \
 //thickness=0.36 //x=53.385 //y=2.4 //x2=53.555 //y2=2.385
r1516 (  88 89 ) resistor r=0.949427 //w=0.131 //l=0.995 //layer=m2 \
 //thickness=0.36 //x=53.385 //y=2.4 //x2=52.39 //y2=2.4
r1517 (  87 107 ) resistor r=3.45539 //w=0.18 //l=4.9775 //layer=m2 \
 //thickness=0.36 //x=51.705 //y=2.385 //x2=46.73 //y2=2.39
r1518 (  86 89 ) resistor r=0.1875 //w=0.17 //l=0.262393 //layer=m2 \
 //thickness=0.36 //x=52.135 //y=2.385 //x2=52.39 //y2=2.4
r1519 (  86 87 ) resistor r=0.410305 //w=0.131 //l=0.43 //layer=m2 \
 //thickness=0.36 //x=52.135 //y=2.385 //x2=51.705 //y2=2.385
r1520 (  85 105 ) resistor r=0.0986081 //w=0.216 //l=0.164924 //layer=m2 \
 //thickness=0.36 //x=35.43 //y=2.4 //x2=35.27 //y2=2.39
r1521 (  84 107 ) resistor r=0.111638 //w=0.18 //l=0.164924 //layer=m2 \
 //thickness=0.36 //x=46.57 //y=2.4 //x2=46.73 //y2=2.39
r1522 (  84 85 ) resistor r=10.6298 //w=0.131 //l=11.14 //layer=m2 \
 //thickness=0.36 //x=46.57 //y=2.4 //x2=35.43 //y2=2.4
r1523 (  82 105 ) resistor r=0.523955 //w=0.216 //l=0.895 //layer=m2 \
 //thickness=0.36 //x=34.375 //y=2.39 //x2=35.27 //y2=2.39
r1524 (  82 83 ) resistor r=0.410305 //w=0.131 //l=0.43 //layer=m2 \
 //thickness=0.36 //x=34.375 //y=2.39 //x2=33.945 //y2=2.39
r1525 (  80 83 ) resistor r=0.125 //w=0.17 //l=0.174929 //layer=m2 \
 //thickness=0.36 //x=33.775 //y=2.4 //x2=33.945 //y2=2.39
r1526 (  80 81 ) resistor r=3.77385 //w=0.131 //l=3.955 //layer=m2 \
 //thickness=0.36 //x=33.775 //y=2.4 //x2=29.82 //y2=2.4
r1527 (  78 81 ) resistor r=0.1875 //w=0.17 //l=0.262393 //layer=m2 \
 //thickness=0.36 //x=29.565 //y=2.385 //x2=29.82 //y2=2.4
r1528 (  78 79 ) resistor r=0.410305 //w=0.131 //l=0.43 //layer=m2 \
 //thickness=0.36 //x=29.565 //y=2.385 //x2=29.135 //y2=2.385
r1529 (  76 79 ) resistor r=0.125 //w=0.17 //l=0.177341 //layer=m2 \
 //thickness=0.36 //x=28.965 //y=2.4 //x2=29.135 //y2=2.385
r1530 (  76 77 ) resistor r=0.949427 //w=0.131 //l=0.995 //layer=m2 \
 //thickness=0.36 //x=28.965 //y=2.4 //x2=27.97 //y2=2.4
r1531 (  75 103 ) resistor r=3.45539 //w=0.18 //l=4.9775 //layer=m2 \
 //thickness=0.36 //x=27.285 //y=2.385 //x2=22.31 //y2=2.39
r1532 (  74 77 ) resistor r=0.1875 //w=0.17 //l=0.262393 //layer=m2 \
 //thickness=0.36 //x=27.715 //y=2.385 //x2=27.97 //y2=2.4
r1533 (  74 75 ) resistor r=0.410305 //w=0.131 //l=0.43 //layer=m2 \
 //thickness=0.36 //x=27.715 //y=2.385 //x2=27.285 //y2=2.385
r1534 (  72 103 ) resistor r=0.111638 //w=0.18 //l=0.164924 //layer=m2 \
 //thickness=0.36 //x=22.15 //y=2.4 //x2=22.31 //y2=2.39
r1535 (  72 101 ) resistor r=10.6298 //w=0.131 //l=11.14 //layer=m2 \
 //thickness=0.36 //x=22.15 //y=2.4 //x2=11.01 //y2=2.4
r1536 (  70 111 ) resistor r=4.5 //w=0.15 //l=0.15 //layer=via1 //count=1 \
 //x=71.15 //y=2.39 //x2=71.15 //y2=2.39
r1537 (  68 165 ) resistor r=9.3 //w=0.17 //l=0.17 //layer=mcon //count=1 \
 //x=71.16 //y=2.26 //x2=71.16 //y2=2.26
r1538 (  68 70 ) resistor r=0.0560345 //w=0.29 //l=0.13 //layer=m1 \
 //thickness=0.36 //x=71.15 //y=2.26 //x2=71.15 //y2=2.39
r1539 (  63 109 ) resistor r=4.5 //w=0.15 //l=0.15 //layer=via1 //count=1 \
 //x=59.69 //y=2.39 //x2=59.69 //y2=2.39
r1540 (  61 155 ) resistor r=9.3 //w=0.17 //l=0.17 //layer=mcon //count=1 \
 //x=59.69 //y=2.26 //x2=59.69 //y2=2.26
r1541 (  61 63 ) resistor r=0.0560345 //w=0.29 //l=0.13 //layer=m1 \
 //thickness=0.36 //x=59.69 //y=2.26 //x2=59.69 //y2=2.39
r1542 (  57 107 ) resistor r=4.5 //w=0.15 //l=0.15 //layer=via1 //count=1 \
 //x=46.73 //y=2.39 //x2=46.73 //y2=2.39
r1543 (  50 105 ) resistor r=4.5 //w=0.15 //l=0.15 //layer=via1 //count=1 \
 //x=35.27 //y=2.39 //x2=35.27 //y2=2.39
r1544 (  48 135 ) resistor r=9.3 //w=0.17 //l=0.17 //layer=mcon //count=1 \
 //x=35.27 //y=2.26 //x2=35.27 //y2=2.26
r1545 (  48 50 ) resistor r=0.0560345 //w=0.29 //l=0.13 //layer=m1 \
 //thickness=0.36 //x=35.27 //y=2.26 //x2=35.27 //y2=2.39
r1546 (  43 103 ) resistor r=4.5 //w=0.15 //l=0.15 //layer=via1 //count=1 \
 //x=22.31 //y=2.39 //x2=22.31 //y2=2.39
r1547 (  41 125 ) resistor r=9.3 //w=0.17 //l=0.17 //layer=mcon //count=1 \
 //x=22.32 //y=2.26 //x2=22.32 //y2=2.26
r1548 (  41 43 ) resistor r=0.0560345 //w=0.29 //l=0.13 //layer=m1 \
 //thickness=0.36 //x=22.31 //y=2.26 //x2=22.31 //y2=2.39
r1549 (  39 130 ) resistor r=9.3 //w=0.17 //l=0.17 //layer=mcon //count=1 \
 //x=22.32 //y=4.88 //x2=22.32 //y2=4.88
r1550 (  36 99 ) resistor r=4.5 //w=0.15 //l=0.15 //layer=via1 //count=1 \
 //x=10.85 //y=2.39 //x2=10.85 //y2=2.39
r1551 (  34 115 ) resistor r=9.3 //w=0.17 //l=0.17 //layer=mcon //count=1 \
 //x=10.85 //y=2.26 //x2=10.85 //y2=2.26
r1552 (  34 36 ) resistor r=0.0560345 //w=0.29 //l=0.13 //layer=m1 \
 //thickness=0.36 //x=10.85 //y=2.26 //x2=10.85 //y2=2.39
r1553 (  32 120 ) resistor r=9.3 //w=0.17 //l=0.17 //layer=mcon //count=1 \
 //x=10.85 //y=4.88 //x2=10.85 //y2=4.88
r1554 (  29 30 ) resistor r=2.11355 //w=0.131 //l=2.215 //layer=m1 \
 //thickness=0.36 //x=71.16 //y=2.55 //x2=71.16 //y2=4.765
r1555 (  24 57 ) resistor r=0.0901908 //w=0.29 //l=0.164924 //layer=m1 \
 //thickness=0.36 //x=46.74 //y=2.55 //x2=46.73 //y2=2.39
r1556 (  24 25 ) resistor r=2.11355 //w=0.131 //l=2.215 //layer=m1 \
 //thickness=0.36 //x=46.74 //y=2.55 //x2=46.74 //y2=4.765
r1557 (  22 23 ) resistor r=2.11355 //w=0.131 //l=2.215 //layer=m1 \
 //thickness=0.36 //x=35.27 //y=2.55 //x2=35.27 //y2=4.765
r1558 (  20 39 ) resistor r=0.0717383 //w=0.224 //l=0.115 //layer=m1 \
 //thickness=0.36 //x=22.32 //y=4.765 //x2=22.32 //y2=4.88
r1559 (  16 32 ) resistor r=0.0717383 //w=0.224 //l=0.115 //layer=m1 \
 //thickness=0.36 //x=10.85 //y=4.765 //x2=10.85 //y2=4.88
r1560 (  14 170 ) resistor r=9.3 //w=0.17 //l=0.17 //layer=mcon //count=1 \
 //x=71.16 //y=4.88 //x2=71.16 //y2=4.88
r1561 (  14 30 ) resistor r=0.0717383 //w=0.224 //l=0.115 //layer=m1 \
 //thickness=0.36 //x=71.16 //y=4.88 //x2=71.16 //y2=4.765
r1562 (  13 29 ) resistor r=0.0858804 //w=0.29 //l=0.154919 //layer=m1 \
 //thickness=0.36 //x=71.15 //y=2.4 //x2=71.16 //y2=2.55
r1563 (  13 70 ) resistor r=0.00431034 //w=0.29 //l=0.01 //layer=m1 \
 //thickness=0.36 //x=71.15 //y=2.4 //x2=71.15 //y2=2.39
r1564 (  12 160 ) resistor r=9.3 //w=0.17 //l=0.17 //layer=mcon //count=1 \
 //x=59.69 //y=4.88 //x2=59.69 //y2=4.88
r1565 (  12 27 ) resistor r=0.0717383 //w=0.224 //l=0.115 //layer=m1 \
 //thickness=0.36 //x=59.69 //y=4.88 //x2=59.69 //y2=4.765
r1566 (  11 26 ) resistor r=0.0858804 //w=0.29 //l=0.15 //layer=m1 \
 //thickness=0.36 //x=59.69 //y=2.4 //x2=59.69 //y2=2.55
r1567 (  11 63 ) resistor r=0.00431034 //w=0.29 //l=0.01 //layer=m1 \
 //thickness=0.36 //x=59.69 //y=2.4 //x2=59.69 //y2=2.39
r1568 (  10 150 ) resistor r=9.3 //w=0.17 //l=0.17 //layer=mcon //count=1 \
 //x=46.74 //y=4.88 //x2=46.74 //y2=4.88
r1569 (  10 25 ) resistor r=0.0717383 //w=0.224 //l=0.115 //layer=m1 \
 //thickness=0.36 //x=46.74 //y=4.88 //x2=46.74 //y2=4.765
r1570 (  9 145 ) resistor r=9.3 //w=0.17 //l=0.17 //layer=mcon //count=1 \
 //x=46.74 //y=2.26 //x2=46.74 //y2=2.26
r1571 (  9 57 ) resistor r=0.0560345 //w=0.29 //l=0.13 //layer=m1 \
 //thickness=0.36 //x=46.73 //y=2.26 //x2=46.73 //y2=2.39
r1572 (  8 140 ) resistor r=9.3 //w=0.17 //l=0.17 //layer=mcon //count=1 \
 //x=35.27 //y=4.88 //x2=35.27 //y2=4.88
r1573 (  8 23 ) resistor r=0.0717383 //w=0.224 //l=0.115 //layer=m1 \
 //thickness=0.36 //x=35.27 //y=4.88 //x2=35.27 //y2=4.765
r1574 (  7 22 ) resistor r=0.0858804 //w=0.29 //l=0.15 //layer=m1 \
 //thickness=0.36 //x=35.27 //y=2.4 //x2=35.27 //y2=2.55
r1575 (  7 50 ) resistor r=0.00431034 //w=0.29 //l=0.01 //layer=m1 \
 //thickness=0.36 //x=35.27 //y=2.4 //x2=35.27 //y2=2.39
r1576 (  6 19 ) resistor r=0.0858804 //w=0.29 //l=0.154919 //layer=m1 \
 //thickness=0.36 //x=22.31 //y=2.4 //x2=22.32 //y2=2.55
r1577 (  6 43 ) resistor r=0.00431034 //w=0.29 //l=0.01 //layer=m1 \
 //thickness=0.36 //x=22.31 //y=2.4 //x2=22.31 //y2=2.39
r1578 (  5 15 ) resistor r=0.0858804 //w=0.29 //l=0.15 //layer=m1 \
 //thickness=0.36 //x=10.85 //y=2.4 //x2=10.85 //y2=2.55
r1579 (  5 36 ) resistor r=0.00431034 //w=0.29 //l=0.01 //layer=m1 \
 //thickness=0.36 //x=10.85 //y=2.4 //x2=10.85 //y2=2.39
r1580 (  4 27 ) resistor r=1.90363 //w=0.131 //l=1.995 //layer=m1 \
 //thickness=0.36 //x=59.69 //y=2.77 //x2=59.69 //y2=4.765
r1581 (  4 26 ) resistor r=0.209924 //w=0.131 //l=0.22 //layer=m1 \
 //thickness=0.36 //x=59.69 //y=2.77 //x2=59.69 //y2=2.55
r1582 (  3 20 ) resistor r=1.90363 //w=0.131 //l=1.995 //layer=m1 \
 //thickness=0.36 //x=22.32 //y=2.77 //x2=22.32 //y2=4.765
r1583 (  3 19 ) resistor r=0.209924 //w=0.131 //l=0.22 //layer=m1 \
 //thickness=0.36 //x=22.32 //y=2.77 //x2=22.32 //y2=2.55
r1584 (  2 16 ) resistor r=1.19752 //w=0.131 //l=1.255 //layer=m1 \
 //thickness=0.36 //x=10.85 //y=3.51 //x2=10.85 //y2=4.765
r1585 (  1 2 ) resistor r=0.706107 //w=0.131 //l=0.74 //layer=m1 \
 //thickness=0.36 //x=10.85 //y=2.77 //x2=10.85 //y2=3.51
r1586 (  1 15 ) resistor r=0.209924 //w=0.131 //l=0.22 //layer=m1 \
 //thickness=0.36 //x=10.85 //y=2.77 //x2=10.85 //y2=2.55
ends PM_TMRDFFSNQNX1\%SN

subckt PM_TMRDFFSNQNX1\%noxref_17 ( 1 2 3 4 5 6 7 8 11 16 17 19 20 22 23 24 25 \
 26 27 28 36 40 47 48 51 53 58 60 67 69 72 78 83 84 86 87 90 99 104 113 118 \
 126 143 152 156 157 158 159 160 161 162 163 164 168 169 170 175 177 180 181 \
 185 186 187 192 194 197 198 202 203 204 209 211 214 215 217 218 223 227 228 \
 233 237 238 243 246 248 249 )
c581 ( 246 0 ) capacitor c=0.00878249f //x=64.24 //y=1.085
c582 ( 243 0 ) capacitor c=0.0651477f //x=72.27 //y=4.88
c583 ( 238 0 ) capacitor c=0.0278202f //x=72.27 //y=2.095
c584 ( 237 0 ) capacitor c=0.0503043f //x=72.27 //y=2.26
c585 ( 233 0 ) capacitor c=0.0651619f //x=60.8 //y=4.88
c586 ( 228 0 ) capacitor c=0.0278202f //x=60.8 //y=2.095
c587 ( 227 0 ) capacitor c=0.0503043f //x=60.8 //y=2.26
c588 ( 223 0 ) capacitor c=0.0654765f //x=55.99 //y=4.88
c589 ( 218 0 ) capacitor c=0.0278202f //x=55.99 //y=2.095
c590 ( 217 0 ) capacitor c=0.0503043f //x=55.99 //y=2.26
c591 ( 215 0 ) capacitor c=0.0443175f //x=72.79 //y=1.44
c592 ( 214 0 ) capacitor c=0.0199703f //x=72.79 //y=1.095
c593 ( 211 0 ) capacitor c=0.0162526f //x=72.635 //y=1.595
c594 ( 209 0 ) capacitor c=0.0157807f //x=72.635 //y=0.94
c595 ( 204 0 ) capacitor c=0.0220935f //x=72.26 //y=1.75
c596 ( 203 0 ) capacitor c=0.0207489f //x=72.26 //y=1.44
c597 ( 202 0 ) capacitor c=0.0194091f //x=72.26 //y=1.095
c598 ( 198 0 ) capacitor c=0.0443175f //x=61.32 //y=1.44
c599 ( 197 0 ) capacitor c=0.0199703f //x=61.32 //y=1.095
c600 ( 194 0 ) capacitor c=0.0162526f //x=61.165 //y=1.595
c601 ( 192 0 ) capacitor c=0.0157807f //x=61.165 //y=0.94
c602 ( 187 0 ) capacitor c=0.0220935f //x=60.79 //y=1.75
c603 ( 186 0 ) capacitor c=0.0207489f //x=60.79 //y=1.44
c604 ( 185 0 ) capacitor c=0.0194091f //x=60.79 //y=1.095
c605 ( 181 0 ) capacitor c=0.0443175f //x=56.51 //y=1.44
c606 ( 180 0 ) capacitor c=0.0199703f //x=56.51 //y=1.095
c607 ( 177 0 ) capacitor c=0.0162526f //x=56.355 //y=1.595
c608 ( 175 0 ) capacitor c=0.0157807f //x=56.355 //y=0.94
c609 ( 170 0 ) capacitor c=0.0220935f //x=55.98 //y=1.75
c610 ( 169 0 ) capacitor c=0.0207489f //x=55.98 //y=1.44
c611 ( 168 0 ) capacitor c=0.0194091f //x=55.98 //y=1.095
c612 ( 164 0 ) capacitor c=0.159671f //x=72.45 //y=6.2
c613 ( 163 0 ) capacitor c=0.110208f //x=72.01 //y=6.2
c614 ( 162 0 ) capacitor c=0.159671f //x=60.98 //y=6.2
c615 ( 161 0 ) capacitor c=0.110208f //x=60.54 //y=6.2
c616 ( 160 0 ) capacitor c=0.159671f //x=56.17 //y=6.2
c617 ( 159 0 ) capacitor c=0.110208f //x=55.73 //y=6.2
c618 ( 152 0 ) capacitor c=7.7417e-19 //x=72.27 //y=4.88
c619 ( 143 0 ) capacitor c=0.00101179f //x=72.27 //y=2.26
c620 ( 126 0 ) capacitor c=0.0319332f //x=64.39 //y=5.56
c621 ( 118 0 ) capacitor c=0.0290186f //x=63.51 //y=5.56
c622 ( 113 0 ) capacitor c=7.7417e-19 //x=60.8 //y=4.88
c623 ( 104 0 ) capacitor c=0.00101179f //x=60.8 //y=2.26
c624 ( 99 0 ) capacitor c=7.7417e-19 //x=55.99 //y=4.88
c625 ( 90 0 ) capacitor c=0.00101179f //x=55.99 //y=2.26
c626 ( 87 0 ) capacitor c=0.0805857f //x=72.11 //y=3.885
c627 ( 86 0 ) capacitor c=6.15393e-19 //x=72.27 //y=3.885
c628 ( 84 0 ) capacitor c=6.78139e-19 //x=65.025 //y=3.865
c629 ( 83 0 ) capacitor c=0.0371901f //x=64.705 //y=3.865
c630 ( 78 0 ) capacitor c=6.291e-19 //x=56.155 //y=3.865
c631 ( 72 0 ) capacitor c=0.0413374f //x=60.96 //y=3.88
c632 ( 69 0 ) capacitor c=0.00240665f //x=56.94 //y=3.865
c633 ( 67 0 ) capacitor c=0.00239648f //x=56.34 //y=3.88
c634 ( 60 0 ) capacitor c=0.0149589f //x=72.27 //y=3.88
c635 ( 58 0 ) capacitor c=0.0158493f //x=64.87 //y=3.88
c636 ( 53 0 ) capacitor c=0.0113632f //x=64.43 //y=1.18
c637 ( 51 0 ) capacitor c=5.78613e-19 //x=64.39 //y=5.56
c638 ( 48 0 ) capacitor c=0.0105477f //x=64.39 //y=5.38
c639 ( 47 0 ) capacitor c=0.00947836f //x=63.51 //y=5.56
c640 ( 40 0 ) capacitor c=0.0149589f //x=60.8 //y=3.88
c641 ( 36 0 ) capacitor c=0.0149589f //x=55.99 //y=3.88
c642 ( 28 0 ) capacitor c=0.0184732f //x=72.27 //y=4.75
c643 ( 27 0 ) capacitor c=0.011264f //x=72.27 //y=4.045
c644 ( 26 0 ) capacitor c=0.0344849f //x=72.27 //y=3.725
c645 ( 25 0 ) capacitor c=0.00694371f //x=72.27 //y=2.375
c646 ( 24 0 ) capacitor c=0.0289407f //x=64.87 //y=5.295
c647 ( 23 0 ) capacitor c=0.0126608f //x=64.87 //y=4.025
c648 ( 22 0 ) capacitor c=0.0461888f //x=64.87 //y=3.705
c649 ( 20 0 ) capacitor c=0.00466468f //x=64.515 //y=1.835
c650 ( 19 0 ) capacitor c=0.0118534f //x=64.785 //y=1.835
c651 ( 17 0 ) capacitor c=0.0107481f //x=64.785 //y=5.38
c652 ( 16 0 ) capacitor c=0.0102514f //x=64.43 //y=1.75
c653 ( 11 0 ) capacitor c=0.0144196f //x=64.275 //y=5.38
c654 ( 8 0 ) capacitor c=0.0205242f //x=60.8 //y=4.75
c655 ( 7 0 ) capacitor c=0.0115377f //x=60.8 //y=4.025
c656 ( 6 0 ) capacitor c=0.0292543f //x=60.8 //y=3.705
c657 ( 5 0 ) capacitor c=0.00554287f //x=60.8 //y=2.375
c658 ( 4 0 ) capacitor c=0.0190807f //x=55.99 //y=4.75
c659 ( 3 0 ) capacitor c=0.01135f //x=55.99 //y=4.025
c660 ( 2 0 ) capacitor c=0.0309098f //x=55.99 //y=3.705
c661 ( 1 0 ) capacitor c=0.00556102f //x=55.99 //y=2.375
r662 (  237 238 ) resistor r=52.7279 //w=0.214 //l=0.165 //layer=ply \
 //thickness=0.18 //x=72.27 //y=2.26 //x2=72.27 //y2=2.095
r663 (  227 228 ) resistor r=52.7279 //w=0.214 //l=0.165 //layer=ply \
 //thickness=0.18 //x=60.8 //y=2.26 //x2=60.8 //y2=2.095
r664 (  217 218 ) resistor r=52.7279 //w=0.214 //l=0.165 //layer=ply \
 //thickness=0.18 //x=55.99 //y=2.26 //x2=55.99 //y2=2.095
r665 (  215 245 ) resistor r=45.1352 //w=0.168 //l=0.173853 //layer=ply \
 //thickness=0.18 //x=72.79 //y=1.44 //x2=72.75 //y2=1.595
r666 (  214 244 ) resistor r=45.1352 //w=0.168 //l=0.173853 //layer=ply \
 //thickness=0.18 //x=72.79 //y=1.095 //x2=72.75 //y2=0.94
r667 (  214 215 ) resistor r=176.904 //w=0.094 //l=0.345 //layer=ply \
 //thickness=0.18 //x=72.79 //y=1.095 //x2=72.79 //y2=1.44
r668 (  212 241 ) resistor r=10.701 //w=0.21 //l=0.115 //layer=ply \
 //thickness=0.18 //x=72.415 //y=1.595 //x2=72.3 //y2=1.595
r669 (  211 245 ) resistor r=5.52526 //w=0.168 //l=0.115 //layer=ply \
 //thickness=0.18 //x=72.635 //y=1.595 //x2=72.75 //y2=1.595
r670 (  210 240 ) resistor r=5.52526 //w=0.168 //l=0.115 //layer=ply \
 //thickness=0.18 //x=72.415 //y=0.94 //x2=72.3 //y2=0.94
r671 (  209 244 ) resistor r=5.52526 //w=0.168 //l=0.115 //layer=ply \
 //thickness=0.18 //x=72.635 //y=0.94 //x2=72.75 //y2=0.94
r672 (  209 210 ) resistor r=112.809 //w=0.094 //l=0.22 //layer=ply \
 //thickness=0.18 //x=72.635 //y=0.94 //x2=72.415 //y2=0.94
r673 (  206 243 ) resistor r=37.236 //w=0.233 //l=0.249199 //layer=ply \
 //thickness=0.18 //x=72.45 //y=5.045 //x2=72.27 //y2=4.88
r674 (  204 241 ) resistor r=39.5823 //w=0.21 //l=0.173853 //layer=ply \
 //thickness=0.18 //x=72.26 //y=1.75 //x2=72.3 //y2=1.595
r675 (  204 238 ) resistor r=176.904 //w=0.094 //l=0.345 //layer=ply \
 //thickness=0.18 //x=72.26 //y=1.75 //x2=72.26 //y2=2.095
r676 (  203 241 ) resistor r=39.5823 //w=0.21 //l=0.173853 //layer=ply \
 //thickness=0.18 //x=72.26 //y=1.44 //x2=72.3 //y2=1.595
r677 (  202 240 ) resistor r=45.1352 //w=0.168 //l=0.173853 //layer=ply \
 //thickness=0.18 //x=72.26 //y=1.095 //x2=72.3 //y2=0.94
r678 (  202 203 ) resistor r=176.904 //w=0.094 //l=0.345 //layer=ply \
 //thickness=0.18 //x=72.26 //y=1.095 //x2=72.26 //y2=1.44
r679 (  199 243 ) resistor r=53.7854 //w=0.233 //l=0.332415 //layer=ply \
 //thickness=0.18 //x=72.01 //y=5.045 //x2=72.27 //y2=4.88
r680 (  198 235 ) resistor r=45.1352 //w=0.168 //l=0.173853 //layer=ply \
 //thickness=0.18 //x=61.32 //y=1.44 //x2=61.28 //y2=1.595
r681 (  197 234 ) resistor r=45.1352 //w=0.168 //l=0.173853 //layer=ply \
 //thickness=0.18 //x=61.32 //y=1.095 //x2=61.28 //y2=0.94
r682 (  197 198 ) resistor r=176.904 //w=0.094 //l=0.345 //layer=ply \
 //thickness=0.18 //x=61.32 //y=1.095 //x2=61.32 //y2=1.44
r683 (  195 231 ) resistor r=10.701 //w=0.21 //l=0.115 //layer=ply \
 //thickness=0.18 //x=60.945 //y=1.595 //x2=60.83 //y2=1.595
r684 (  194 235 ) resistor r=5.52526 //w=0.168 //l=0.115 //layer=ply \
 //thickness=0.18 //x=61.165 //y=1.595 //x2=61.28 //y2=1.595
r685 (  193 230 ) resistor r=5.52526 //w=0.168 //l=0.115 //layer=ply \
 //thickness=0.18 //x=60.945 //y=0.94 //x2=60.83 //y2=0.94
r686 (  192 234 ) resistor r=5.52526 //w=0.168 //l=0.115 //layer=ply \
 //thickness=0.18 //x=61.165 //y=0.94 //x2=61.28 //y2=0.94
r687 (  192 193 ) resistor r=112.809 //w=0.094 //l=0.22 //layer=ply \
 //thickness=0.18 //x=61.165 //y=0.94 //x2=60.945 //y2=0.94
r688 (  189 233 ) resistor r=37.236 //w=0.233 //l=0.249199 //layer=ply \
 //thickness=0.18 //x=60.98 //y=5.045 //x2=60.8 //y2=4.88
r689 (  187 231 ) resistor r=39.5823 //w=0.21 //l=0.173853 //layer=ply \
 //thickness=0.18 //x=60.79 //y=1.75 //x2=60.83 //y2=1.595
r690 (  187 228 ) resistor r=176.904 //w=0.094 //l=0.345 //layer=ply \
 //thickness=0.18 //x=60.79 //y=1.75 //x2=60.79 //y2=2.095
r691 (  186 231 ) resistor r=39.5823 //w=0.21 //l=0.173853 //layer=ply \
 //thickness=0.18 //x=60.79 //y=1.44 //x2=60.83 //y2=1.595
r692 (  185 230 ) resistor r=45.1352 //w=0.168 //l=0.173853 //layer=ply \
 //thickness=0.18 //x=60.79 //y=1.095 //x2=60.83 //y2=0.94
r693 (  185 186 ) resistor r=176.904 //w=0.094 //l=0.345 //layer=ply \
 //thickness=0.18 //x=60.79 //y=1.095 //x2=60.79 //y2=1.44
r694 (  182 233 ) resistor r=53.7854 //w=0.233 //l=0.332415 //layer=ply \
 //thickness=0.18 //x=60.54 //y=5.045 //x2=60.8 //y2=4.88
r695 (  181 225 ) resistor r=45.1352 //w=0.168 //l=0.173853 //layer=ply \
 //thickness=0.18 //x=56.51 //y=1.44 //x2=56.47 //y2=1.595
r696 (  180 224 ) resistor r=45.1352 //w=0.168 //l=0.173853 //layer=ply \
 //thickness=0.18 //x=56.51 //y=1.095 //x2=56.47 //y2=0.94
r697 (  180 181 ) resistor r=176.904 //w=0.094 //l=0.345 //layer=ply \
 //thickness=0.18 //x=56.51 //y=1.095 //x2=56.51 //y2=1.44
r698 (  178 221 ) resistor r=10.701 //w=0.21 //l=0.115 //layer=ply \
 //thickness=0.18 //x=56.135 //y=1.595 //x2=56.02 //y2=1.595
r699 (  177 225 ) resistor r=5.52526 //w=0.168 //l=0.115 //layer=ply \
 //thickness=0.18 //x=56.355 //y=1.595 //x2=56.47 //y2=1.595
r700 (  176 220 ) resistor r=5.52526 //w=0.168 //l=0.115 //layer=ply \
 //thickness=0.18 //x=56.135 //y=0.94 //x2=56.02 //y2=0.94
r701 (  175 224 ) resistor r=5.52526 //w=0.168 //l=0.115 //layer=ply \
 //thickness=0.18 //x=56.355 //y=0.94 //x2=56.47 //y2=0.94
r702 (  175 176 ) resistor r=112.809 //w=0.094 //l=0.22 //layer=ply \
 //thickness=0.18 //x=56.355 //y=0.94 //x2=56.135 //y2=0.94
r703 (  172 223 ) resistor r=37.236 //w=0.233 //l=0.249199 //layer=ply \
 //thickness=0.18 //x=56.17 //y=5.045 //x2=55.99 //y2=4.88
r704 (  170 221 ) resistor r=39.5823 //w=0.21 //l=0.173853 //layer=ply \
 //thickness=0.18 //x=55.98 //y=1.75 //x2=56.02 //y2=1.595
r705 (  170 218 ) resistor r=176.904 //w=0.094 //l=0.345 //layer=ply \
 //thickness=0.18 //x=55.98 //y=1.75 //x2=55.98 //y2=2.095
r706 (  169 221 ) resistor r=39.5823 //w=0.21 //l=0.173853 //layer=ply \
 //thickness=0.18 //x=55.98 //y=1.44 //x2=56.02 //y2=1.595
r707 (  168 220 ) resistor r=45.1352 //w=0.168 //l=0.173853 //layer=ply \
 //thickness=0.18 //x=55.98 //y=1.095 //x2=56.02 //y2=0.94
r708 (  168 169 ) resistor r=176.904 //w=0.094 //l=0.345 //layer=ply \
 //thickness=0.18 //x=55.98 //y=1.095 //x2=55.98 //y2=1.44
r709 (  165 223 ) resistor r=53.7854 //w=0.233 //l=0.332415 //layer=ply \
 //thickness=0.18 //x=55.73 //y=5.045 //x2=55.99 //y2=4.88
r710 (  164 206 ) resistor r=592.245 //w=0.094 //l=1.155 //layer=ply \
 //thickness=0.18 //x=72.45 //y=6.2 //x2=72.45 //y2=5.045
r711 (  163 199 ) resistor r=592.245 //w=0.094 //l=1.155 //layer=ply \
 //thickness=0.18 //x=72.01 //y=6.2 //x2=72.01 //y2=5.045
r712 (  162 189 ) resistor r=592.245 //w=0.094 //l=1.155 //layer=ply \
 //thickness=0.18 //x=60.98 //y=6.2 //x2=60.98 //y2=5.045
r713 (  161 182 ) resistor r=592.245 //w=0.094 //l=1.155 //layer=ply \
 //thickness=0.18 //x=60.54 //y=6.2 //x2=60.54 //y2=5.045
r714 (  160 172 ) resistor r=592.245 //w=0.094 //l=1.155 //layer=ply \
 //thickness=0.18 //x=56.17 //y=6.2 //x2=56.17 //y2=5.045
r715 (  159 165 ) resistor r=592.245 //w=0.094 //l=1.155 //layer=ply \
 //thickness=0.18 //x=55.73 //y=6.2 //x2=55.73 //y2=5.045
r716 (  158 211 ) resistor r=56.4043 //w=0.094 //l=0.11 //layer=ply \
 //thickness=0.18 //x=72.525 //y=1.595 //x2=72.635 //y2=1.595
r717 (  158 212 ) resistor r=56.4043 //w=0.094 //l=0.11 //layer=ply \
 //thickness=0.18 //x=72.525 //y=1.595 //x2=72.415 //y2=1.595
r718 (  157 194 ) resistor r=56.4043 //w=0.094 //l=0.11 //layer=ply \
 //thickness=0.18 //x=61.055 //y=1.595 //x2=61.165 //y2=1.595
r719 (  157 195 ) resistor r=56.4043 //w=0.094 //l=0.11 //layer=ply \
 //thickness=0.18 //x=61.055 //y=1.595 //x2=60.945 //y2=1.595
r720 (  156 177 ) resistor r=56.4043 //w=0.094 //l=0.11 //layer=ply \
 //thickness=0.18 //x=56.245 //y=1.595 //x2=56.355 //y2=1.595
r721 (  156 178 ) resistor r=56.4043 //w=0.094 //l=0.11 //layer=ply \
 //thickness=0.18 //x=56.245 //y=1.595 //x2=56.135 //y2=1.595
r722 (  152 243 ) resistor r=152 //w=0.17 //l=0.17 //layer=licon //count=1 \
 //x=72.27 //y=4.88 //x2=72.27 //y2=4.88
r723 (  143 237 ) resistor r=152 //w=0.17 //l=0.17 //layer=licon //count=1 \
 //x=72.27 //y=2.26 //x2=72.27 //y2=2.26
r724 (  126 249 ) resistor r=23.615 //w=0.187 //l=0.345 //layer=li \
 //thickness=0.1 //x=64.39 //y=5.56 //x2=64.39 //y2=5.905
r725 (  118 248 ) resistor r=23.615 //w=0.187 //l=0.345 //layer=li \
 //thickness=0.1 //x=63.51 //y=5.56 //x2=63.51 //y2=5.905
r726 (  113 233 ) resistor r=152 //w=0.17 //l=0.17 //layer=licon //count=1 \
 //x=60.8 //y=4.88 //x2=60.8 //y2=4.88
r727 (  104 227 ) resistor r=152 //w=0.17 //l=0.17 //layer=licon //count=1 \
 //x=60.8 //y=2.26 //x2=60.8 //y2=2.26
r728 (  99 223 ) resistor r=152 //w=0.17 //l=0.17 //layer=licon //count=1 \
 //x=55.99 //y=4.88 //x2=55.99 //y2=4.88
r729 (  90 217 ) resistor r=152 //w=0.17 //l=0.17 //layer=licon //count=1 \
 //x=55.99 //y=2.26 //x2=55.99 //y2=2.26
r730 (  86 87 ) resistor r=0.10734 //w=0.281 //l=0.16 //layer=m2 \
 //thickness=0.36 //x=72.27 //y=3.885 //x2=72.11 //y2=3.885
r731 (  84 87 ) resistor r=6.7605 //w=0.131 //l=7.085 //layer=m2 \
 //thickness=0.36 //x=65.025 //y=3.88 //x2=72.11 //y2=3.88
r732 (  82 84 ) resistor r=0.10734 //w=0.281 //l=0.16 //layer=m2 \
 //thickness=0.36 //x=64.865 //y=3.865 //x2=65.025 //y2=3.865
r733 (  82 83 ) resistor r=0.10734 //w=0.281 //l=0.16 //layer=m2 \
 //thickness=0.36 //x=64.865 //y=3.865 //x2=64.705 //y2=3.865
r734 (  76 78 ) resistor r=0.10734 //w=0.281 //l=0.16 //layer=m2 \
 //thickness=0.36 //x=55.995 //y=3.865 //x2=56.155 //y2=3.865
r735 (  72 80 ) resistor r=0.110608 //w=0.182 //l=0.167332 //layer=m2 \
 //thickness=0.36 //x=60.96 //y=3.88 //x2=60.8 //y2=3.865
r736 (  72 83 ) resistor r=3.57347 //w=0.131 //l=3.745 //layer=m2 \
 //thickness=0.36 //x=60.96 //y=3.88 //x2=64.705 //y2=3.88
r737 (  69 80 ) resistor r=2.65182 //w=0.182 //l=3.86 //layer=m2 \
 //thickness=0.36 //x=56.94 //y=3.865 //x2=60.8 //y2=3.865
r738 (  69 70 ) resistor r=0.410305 //w=0.131 //l=0.43 //layer=m2 \
 //thickness=0.36 //x=56.94 //y=3.865 //x2=56.51 //y2=3.865
r739 (  67 70 ) resistor r=0.125 //w=0.17 //l=0.177341 //layer=m2 \
 //thickness=0.36 //x=56.34 //y=3.88 //x2=56.51 //y2=3.865
r740 (  67 78 ) resistor r=0.176527 //w=0.131 //l=0.185 //layer=m2 \
 //thickness=0.36 //x=56.34 //y=3.88 //x2=56.155 //y2=3.88
r741 (  66 152 ) resistor r=9.3 //w=0.17 //l=0.17 //layer=mcon //count=1 \
 //x=72.27 //y=4.88 //x2=72.27 //y2=4.88
r742 (  64 143 ) resistor r=9.3 //w=0.17 //l=0.17 //layer=mcon //count=1 \
 //x=72.27 //y=2.26 //x2=72.27 //y2=2.26
r743 (  62 86 ) resistor r=4.5 //w=0.15 //l=0.15 //layer=via1 //count=1 \
 //x=72.27 //y=3.885 //x2=72.27 //y2=3.885
r744 (  60 62 ) resistor r=0.00166223 //w=0.376 //l=0.005 //layer=m1 \
 //thickness=0.36 //x=72.217 //y=3.88 //x2=72.217 //y2=3.885
r745 (  56 82 ) resistor r=4.5 //w=0.15 //l=0.15 //layer=via1 //count=1 \
 //x=64.865 //y=3.865 //x2=64.865 //y2=3.865
r746 (  56 58 ) resistor r=0.00501337 //w=0.374 //l=0.015 //layer=m1 \
 //thickness=0.36 //x=64.815 //y=3.865 //x2=64.815 //y2=3.88
r747 (  53 246 ) resistor r=9.3 //w=0.17 //l=0.17 //layer=mcon //count=1 \
 //x=64.43 //y=1.18 //x2=64.43 //y2=1.18
r748 (  51 126 ) resistor r=9.3 //w=0.17 //l=0.17 //layer=mcon //count=1 \
 //x=64.39 //y=5.56 //x2=64.39 //y2=5.56
r749 (  48 51 ) resistor r=0.117801 //w=0.191 //l=0.18 //layer=m1 \
 //thickness=0.36 //x=64.39 //y=5.38 //x2=64.39 //y2=5.56
r750 (  47 118 ) resistor r=9.3 //w=0.17 //l=0.17 //layer=mcon //count=1 \
 //x=63.51 //y=5.56 //x2=63.51 //y2=5.56
r751 (  45 47 ) resistor r=0.10274 //w=0.219 //l=0.18 //layer=m1 \
 //thickness=0.36 //x=63.51 //y=5.38 //x2=63.51 //y2=5.56
r752 (  44 113 ) resistor r=9.3 //w=0.17 //l=0.17 //layer=mcon //count=1 \
 //x=60.8 //y=4.88 //x2=60.8 //y2=4.88
r753 (  42 104 ) resistor r=9.3 //w=0.17 //l=0.17 //layer=mcon //count=1 \
 //x=60.8 //y=2.26 //x2=60.8 //y2=2.26
r754 (  38 80 ) resistor r=4.5 //w=0.15 //l=0.15 //layer=via1 //count=1 \
 //x=60.8 //y=3.865 //x2=60.8 //y2=3.865
r755 (  38 40 ) resistor r=0.0049867 //w=0.376 //l=0.015 //layer=m1 \
 //thickness=0.36 //x=60.747 //y=3.865 //x2=60.747 //y2=3.88
r756 (  34 76 ) resistor r=4.5 //w=0.15 //l=0.15 //layer=via1 //count=1 \
 //x=55.995 //y=3.865 //x2=55.995 //y2=3.865
r757 (  34 36 ) resistor r=0.00501337 //w=0.374 //l=0.015 //layer=m1 \
 //thickness=0.36 //x=56.045 //y=3.865 //x2=56.045 //y2=3.88
r758 (  32 99 ) resistor r=9.3 //w=0.17 //l=0.17 //layer=mcon //count=1 \
 //x=55.99 //y=4.88 //x2=55.99 //y2=4.88
r759 (  30 90 ) resistor r=9.3 //w=0.17 //l=0.17 //layer=mcon //count=1 \
 //x=55.99 //y=2.26 //x2=55.99 //y2=2.26
r760 (  28 66 ) resistor r=0.0801089 //w=0.224 //l=0.13 //layer=m1 \
 //thickness=0.36 //x=72.27 //y=4.75 //x2=72.27 //y2=4.88
r761 (  27 62 ) resistor r=0.0911593 //w=0.376 //l=0.184608 //layer=m1 \
 //thickness=0.36 //x=72.27 //y=4.045 //x2=72.217 //y2=3.885
r762 (  27 28 ) resistor r=0.67271 //w=0.131 //l=0.705 //layer=m1 \
 //thickness=0.36 //x=72.27 //y=4.045 //x2=72.27 //y2=4.75
r763 (  26 60 ) resistor r=0.0894971 //w=0.376 //l=0.179555 //layer=m1 \
 //thickness=0.36 //x=72.27 //y=3.725 //x2=72.217 //y2=3.88
r764 (  25 64 ) resistor r=0.0719237 //w=0.222 //l=0.115 //layer=m1 \
 //thickness=0.36 //x=72.27 //y=2.375 //x2=72.27 //y2=2.26
r765 (  25 26 ) resistor r=1.28817 //w=0.131 //l=1.35 //layer=m1 \
 //thickness=0.36 //x=72.27 //y=2.375 //x2=72.27 //y2=3.725
r766 (  23 58 ) resistor r=0.0860668 //w=0.374 //l=0.170294 //layer=m1 \
 //thickness=0.36 //x=64.87 //y=4.025 //x2=64.815 //y2=3.88
r767 (  23 24 ) resistor r=1.21183 //w=0.131 //l=1.27 //layer=m1 \
 //thickness=0.36 //x=64.87 //y=4.025 //x2=64.87 //y2=5.295
r768 (  22 56 ) resistor r=0.0910802 //w=0.374 //l=0.185472 //layer=m1 \
 //thickness=0.36 //x=64.87 //y=3.705 //x2=64.815 //y2=3.865
r769 (  21 22 ) resistor r=1.70324 //w=0.131 //l=1.785 //layer=m1 \
 //thickness=0.36 //x=64.87 //y=1.92 //x2=64.87 //y2=3.705
r770 (  19 21 ) resistor r=0.0698411 //w=0.17 //l=0.120208 //layer=m1 \
 //thickness=0.36 //x=64.785 //y=1.835 //x2=64.87 //y2=1.92
r771 (  19 20 ) resistor r=0.257634 //w=0.131 //l=0.27 //layer=m1 \
 //thickness=0.36 //x=64.785 //y=1.835 //x2=64.515 //y2=1.835
r772 (  18 48 ) resistor r=0.0257089 //w=0.23 //l=0.115 //layer=m1 \
 //thickness=0.36 //x=64.505 //y=5.38 //x2=64.39 //y2=5.38
r773 (  17 24 ) resistor r=0.0698411 //w=0.17 //l=0.120208 //layer=m1 \
 //thickness=0.36 //x=64.785 //y=5.38 //x2=64.87 //y2=5.295
r774 (  17 18 ) resistor r=0.267176 //w=0.131 //l=0.28 //layer=m1 \
 //thickness=0.36 //x=64.785 //y=5.38 //x2=64.505 //y2=5.38
r775 (  16 20 ) resistor r=0.0698411 //w=0.17 //l=0.120208 //layer=m1 \
 //thickness=0.36 //x=64.43 //y=1.75 //x2=64.515 //y2=1.835
r776 (  15 53 ) resistor r=0.0913624 //w=0.191 //l=0.12 //layer=m1 \
 //thickness=0.36 //x=64.43 //y=1.3 //x2=64.43 //y2=1.18
r777 (  15 16 ) resistor r=0.429389 //w=0.131 //l=0.45 //layer=m1 \
 //thickness=0.36 //x=64.43 //y=1.3 //x2=64.43 //y2=1.75
r778 (  12 45 ) resistor r=0.0227762 //w=0.219 //l=0.115 //layer=m1 \
 //thickness=0.36 //x=63.625 //y=5.38 //x2=63.51 //y2=5.38
r779 (  11 48 ) resistor r=0.0257089 //w=0.23 //l=0.115 //layer=m1 \
 //thickness=0.36 //x=64.275 //y=5.38 //x2=64.39 //y2=5.38
r780 (  11 12 ) resistor r=0.620229 //w=0.131 //l=0.65 //layer=m1 \
 //thickness=0.36 //x=64.275 //y=5.38 //x2=63.625 //y2=5.38
r781 (  8 44 ) resistor r=0.0801089 //w=0.224 //l=0.13 //layer=m1 \
 //thickness=0.36 //x=60.8 //y=4.75 //x2=60.8 //y2=4.88
r782 (  7 40 ) resistor r=0.0861726 //w=0.376 //l=0.16944 //layer=m1 \
 //thickness=0.36 //x=60.8 //y=4.025 //x2=60.747 //y2=3.88
r783 (  7 8 ) resistor r=0.691794 //w=0.131 //l=0.725 //layer=m1 \
 //thickness=0.36 //x=60.8 //y=4.025 //x2=60.8 //y2=4.75
r784 (  6 38 ) resistor r=0.0911593 //w=0.376 //l=0.184608 //layer=m1 \
 //thickness=0.36 //x=60.8 //y=3.705 //x2=60.747 //y2=3.865
r785 (  5 42 ) resistor r=0.0719237 //w=0.222 //l=0.115 //layer=m1 \
 //thickness=0.36 //x=60.8 //y=2.375 //x2=60.8 //y2=2.26
r786 (  5 6 ) resistor r=1.26908 //w=0.131 //l=1.33 //layer=m1 \
 //thickness=0.36 //x=60.8 //y=2.375 //x2=60.8 //y2=3.705
r787 (  4 32 ) resistor r=0.0801089 //w=0.224 //l=0.13 //layer=m1 \
 //thickness=0.36 //x=55.99 //y=4.75 //x2=55.99 //y2=4.88
r788 (  3 36 ) resistor r=0.0860668 //w=0.374 //l=0.170294 //layer=m1 \
 //thickness=0.36 //x=55.99 //y=4.025 //x2=56.045 //y2=3.88
r789 (  3 4 ) resistor r=0.691794 //w=0.131 //l=0.725 //layer=m1 \
 //thickness=0.36 //x=55.99 //y=4.025 //x2=55.99 //y2=4.75
r790 (  2 34 ) resistor r=0.0910802 //w=0.374 //l=0.185472 //layer=m1 \
 //thickness=0.36 //x=55.99 //y=3.705 //x2=56.045 //y2=3.865
r791 (  1 30 ) resistor r=0.0719237 //w=0.222 //l=0.115 //layer=m1 \
 //thickness=0.36 //x=55.99 //y=2.375 //x2=55.99 //y2=2.26
r792 (  1 2 ) resistor r=1.26908 //w=0.131 //l=1.33 //layer=m1 \
 //thickness=0.36 //x=55.99 //y=2.375 //x2=55.99 //y2=3.705
ends PM_TMRDFFSNQNX1\%noxref_17

subckt PM_TMRDFFSNQNX1\%noxref_18 ( 2 3 4 5 7 10 11 13 14 15 16 18 19 20 22 28 \
 31 34 37 45 46 48 53 57 66 71 79 87 103 104 105 106 107 108 113 115 117 123 \
 124 126 127 130 138 140 141 142 )
c319 ( 138 0 ) capacitor c=0.00885916f //x=72.335 //y=1.095
c320 ( 130 0 ) capacitor c=0.0352852f //x=67.49 //y=4.88
c321 ( 127 0 ) capacitor c=0.0284095f //x=67.46 //y=2.095
c322 ( 126 0 ) capacitor c=0.0476356f //x=67.46 //y=2.26
c323 ( 124 0 ) capacitor c=0.0439708f //x=68.025 //y=1.43
c324 ( 123 0 ) capacitor c=0.0192582f //x=68.025 //y=1.085
c325 ( 117 0 ) capacitor c=0.0162526f //x=67.87 //y=1.585
c326 ( 115 0 ) capacitor c=0.0157807f //x=67.87 //y=0.93
c327 ( 113 0 ) capacitor c=0.0357885f //x=67.865 //y=4.97
c328 ( 108 0 ) capacitor c=0.0210762f //x=67.495 //y=1.74
c329 ( 107 0 ) capacitor c=0.0168511f //x=67.495 //y=1.43
c330 ( 106 0 ) capacitor c=0.0175485f //x=67.495 //y=1.085
c331 ( 105 0 ) capacitor c=0.155269f //x=67.94 //y=6.2
c332 ( 104 0 ) capacitor c=0.110375f //x=67.5 //y=6.2
c333 ( 87 0 ) capacitor c=0.0292914f //x=72.23 //y=5.56
c334 ( 79 0 ) capacitor c=0.029098f //x=71.35 //y=5.56
c335 ( 71 0 ) capacitor c=0.0277605f //x=70.47 //y=5.56
c336 ( 66 0 ) capacitor c=7.50799e-19 //x=67.49 //y=4.88
c337 ( 57 0 ) capacitor c=5.78095e-19 //x=67.46 //y=2.26
c338 ( 53 0 ) capacitor c=0.00238271f //x=67.625 //y=4.265
c339 ( 48 0 ) capacitor c=0.00613885f //x=72.485 //y=4.27
c340 ( 46 0 ) capacitor c=0.0478605f //x=71.885 //y=4.25
c341 ( 45 0 ) capacitor c=0.0163347f //x=73.01 //y=4.25
c342 ( 37 0 ) capacitor c=8.84507e-19 //x=72.23 //y=5.335
c343 ( 34 0 ) capacitor c=0.00799521f //x=71.35 //y=5.335
c344 ( 31 0 ) capacitor c=0.0112819f //x=70.472 //y=5.335
c345 ( 28 0 ) capacitor c=0.0133657f //x=67.46 //y=4.25
c346 ( 22 0 ) capacitor c=0.00504845f //x=67.46 //y=2.26
c347 ( 20 0 ) capacitor c=0.0221544f //x=73.01 //y=5.25
c348 ( 19 0 ) capacitor c=0.0128809f //x=73.01 //y=4.395
c349 ( 18 0 ) capacitor c=0.0575266f //x=73.01 //y=4.075
c350 ( 16 0 ) capacitor c=0.00647115f //x=72.61 //y=1.845
c351 ( 15 0 ) capacitor c=0.0166592f //x=72.925 //y=1.845
c352 ( 14 0 ) capacitor c=0.0149757f //x=72.525 //y=1.76
c353 ( 13 0 ) capacitor c=0.0113674f //x=72.525 //y=1.305
c354 ( 11 0 ) capacitor c=0.0227693f //x=72.925 //y=5.335
c355 ( 10 0 ) capacitor c=0.00906283f //x=72.23 //y=5.56
c356 ( 7 0 ) capacitor c=0.0180822f //x=72.115 //y=5.335
c357 ( 5 0 ) capacitor c=0.0151888f //x=71.23 //y=5.335
c358 ( 4 0 ) capacitor c=0.00831531f //x=67.46 //y=4.735
c359 ( 3 0 ) capacitor c=0.0103703f //x=67.46 //y=4.425
c360 ( 2 0 ) capacitor c=0.0381161f //x=67.46 //y=4.105
r361 (  132 133 ) resistor r=32.4568 //w=0.214 //l=0.075 //layer=ply \
 //thickness=0.18 //x=67.49 //y=4.97 //x2=67.49 //y2=5.045
r362 (  130 132 ) resistor r=20.271 //w=0.214 //l=0.09 //layer=ply \
 //thickness=0.18 //x=67.49 //y=4.88 //x2=67.49 //y2=4.97
r363 (  126 127 ) resistor r=52.7279 //w=0.214 //l=0.165 //layer=ply \
 //thickness=0.18 //x=67.46 //y=2.26 //x2=67.46 //y2=2.095
r364 (  124 137 ) resistor r=45.1352 //w=0.168 //l=0.173853 //layer=ply \
 //thickness=0.18 //x=68.025 //y=1.43 //x2=67.985 //y2=1.585
r365 (  123 136 ) resistor r=45.1352 //w=0.168 //l=0.173853 //layer=ply \
 //thickness=0.18 //x=68.025 //y=1.085 //x2=67.985 //y2=0.93
r366 (  123 124 ) resistor r=176.904 //w=0.094 //l=0.345 //layer=ply \
 //thickness=0.18 //x=68.025 //y=1.085 //x2=68.025 //y2=1.43
r367 (  118 135 ) resistor r=10.701 //w=0.21 //l=0.115 //layer=ply \
 //thickness=0.18 //x=67.65 //y=1.585 //x2=67.535 //y2=1.585
r368 (  117 137 ) resistor r=5.52526 //w=0.168 //l=0.115 //layer=ply \
 //thickness=0.18 //x=67.87 //y=1.585 //x2=67.985 //y2=1.585
r369 (  116 134 ) resistor r=5.52526 //w=0.168 //l=0.115 //layer=ply \
 //thickness=0.18 //x=67.65 //y=0.93 //x2=67.535 //y2=0.93
r370 (  115 136 ) resistor r=5.52526 //w=0.168 //l=0.115 //layer=ply \
 //thickness=0.18 //x=67.87 //y=0.93 //x2=67.985 //y2=0.93
r371 (  115 116 ) resistor r=112.809 //w=0.094 //l=0.22 //layer=ply \
 //thickness=0.18 //x=67.87 //y=0.93 //x2=67.65 //y2=0.93
r372 (  114 132 ) resistor r=16.5046 //w=0.27 //l=0.135 //layer=ply \
 //thickness=0.18 //x=67.625 //y=4.97 //x2=67.49 //y2=4.97
r373 (  113 120 ) resistor r=26.9307 //w=0.15 //l=0.106066 //layer=ply \
 //thickness=0.18 //x=67.865 //y=4.97 //x2=67.94 //y2=5.045
r374 (  113 114 ) resistor r=123.064 //w=0.094 //l=0.24 //layer=ply \
 //thickness=0.18 //x=67.865 //y=4.97 //x2=67.625 //y2=4.97
r375 (  108 135 ) resistor r=39.5823 //w=0.21 //l=0.173853 //layer=ply \
 //thickness=0.18 //x=67.495 //y=1.74 //x2=67.535 //y2=1.585
r376 (  108 127 ) resistor r=182.032 //w=0.094 //l=0.355 //layer=ply \
 //thickness=0.18 //x=67.495 //y=1.74 //x2=67.495 //y2=2.095
r377 (  107 135 ) resistor r=39.5823 //w=0.21 //l=0.173853 //layer=ply \
 //thickness=0.18 //x=67.495 //y=1.43 //x2=67.535 //y2=1.585
r378 (  106 134 ) resistor r=45.1352 //w=0.168 //l=0.173853 //layer=ply \
 //thickness=0.18 //x=67.495 //y=1.085 //x2=67.535 //y2=0.93
r379 (  106 107 ) resistor r=176.904 //w=0.094 //l=0.345 //layer=ply \
 //thickness=0.18 //x=67.495 //y=1.085 //x2=67.495 //y2=1.43
r380 (  105 120 ) resistor r=592.245 //w=0.094 //l=1.155 //layer=ply \
 //thickness=0.18 //x=67.94 //y=6.2 //x2=67.94 //y2=5.045
r381 (  104 133 ) resistor r=592.245 //w=0.094 //l=1.155 //layer=ply \
 //thickness=0.18 //x=67.5 //y=6.2 //x2=67.5 //y2=5.045
r382 (  103 117 ) resistor r=56.4043 //w=0.094 //l=0.11 //layer=ply \
 //thickness=0.18 //x=67.76 //y=1.585 //x2=67.87 //y2=1.585
r383 (  103 118 ) resistor r=56.4043 //w=0.094 //l=0.11 //layer=ply \
 //thickness=0.18 //x=67.76 //y=1.585 //x2=67.65 //y2=1.585
r384 (  87 142 ) resistor r=23.615 //w=0.187 //l=0.345 //layer=li \
 //thickness=0.1 //x=72.23 //y=5.56 //x2=72.23 //y2=5.905
r385 (  79 141 ) resistor r=23.615 //w=0.187 //l=0.345 //layer=li \
 //thickness=0.1 //x=71.35 //y=5.56 //x2=71.35 //y2=5.905
r386 (  71 140 ) resistor r=23.615 //w=0.187 //l=0.345 //layer=li \
 //thickness=0.1 //x=70.47 //y=5.56 //x2=70.47 //y2=5.905
r387 (  66 130 ) resistor r=152 //w=0.17 //l=0.17 //layer=licon //count=1 \
 //x=67.49 //y=4.88 //x2=67.49 //y2=4.88
r388 (  57 126 ) resistor r=152 //w=0.17 //l=0.17 //layer=licon //count=1 \
 //x=67.46 //y=2.26 //x2=67.46 //y2=2.26
r389 (  51 53 ) resistor r=0.10734 //w=0.281 //l=0.16 //layer=m2 \
 //thickness=0.36 //x=67.465 //y=4.265 //x2=67.625 //y2=4.265
r390 (  48 55 ) resistor r=0.280717 //w=0.241 //l=0.537215 //layer=m2 \
 //thickness=0.36 //x=72.485 //y=4.27 //x2=73.005 //y2=4.235
r391 (  48 49 ) resistor r=0.329198 //w=0.131 //l=0.345 //layer=m2 \
 //thickness=0.36 //x=72.485 //y=4.27 //x2=72.14 //y2=4.27
r392 (  46 49 ) resistor r=0.1875 //w=0.17 //l=0.264811 //layer=m2 \
 //thickness=0.36 //x=71.885 //y=4.25 //x2=72.14 //y2=4.27
r393 (  46 53 ) resistor r=4.06489 //w=0.131 //l=4.26 //layer=m2 \
 //thickness=0.36 //x=71.885 //y=4.25 //x2=67.625 //y2=4.25
r394 (  43 55 ) resistor r=4.5 //w=0.15 //l=0.15 //layer=via1 //count=1 \
 //x=73.005 //y=4.235 //x2=73.005 //y2=4.235
r395 (  43 45 ) resistor r=0.00501337 //w=0.374 //l=0.015 //layer=m1 \
 //thickness=0.36 //x=72.955 //y=4.235 //x2=72.955 //y2=4.25
r396 (  41 138 ) resistor r=9.3 //w=0.17 //l=0.17 //layer=mcon //count=1 \
 //x=72.525 //y=1.19 //x2=72.525 //y2=1.19
r397 (  39 87 ) resistor r=9.3 //w=0.17 //l=0.17 //layer=mcon //count=1 \
 //x=72.23 //y=5.56 //x2=72.23 //y2=5.56
r398 (  36 79 ) resistor r=9.3 //w=0.17 //l=0.17 //layer=mcon //count=1 \
 //x=71.35 //y=5.56 //x2=71.35 //y2=5.56
r399 (  34 36 ) resistor r=0.121228 //w=0.232 //l=0.225 //layer=m1 \
 //thickness=0.36 //x=71.35 //y=5.335 //x2=71.35 //y2=5.56
r400 (  33 71 ) resistor r=9.3 //w=0.17 //l=0.17 //layer=mcon //count=1 \
 //x=70.47 //y=5.56 //x2=70.47 //y2=5.56
r401 (  31 33 ) resistor r=0.129608 //w=0.217 //l=0.225 //layer=m1 \
 //thickness=0.36 //x=70.472 //y=5.335 //x2=70.472 //y2=5.56
r402 (  30 51 ) resistor r=4.5 //w=0.15 //l=0.15 //layer=via1 //count=1 \
 //x=67.465 //y=4.265 //x2=67.465 //y2=4.265
r403 (  28 30 ) resistor r=0.00501337 //w=0.374 //l=0.015 //layer=m1 \
 //thickness=0.36 //x=67.515 //y=4.25 //x2=67.515 //y2=4.265
r404 (  26 66 ) resistor r=9.3 //w=0.17 //l=0.17 //layer=mcon //count=1 \
 //x=67.49 //y=4.88 //x2=67.49 //y2=4.88
r405 (  22 57 ) resistor r=9.3 //w=0.17 //l=0.17 //layer=mcon //count=1 \
 //x=67.46 //y=2.26 //x2=67.46 //y2=2.26
r406 (  22 24 ) resistor r=0.0936408 //w=0.196 //l=0.125 //layer=m1 \
 //thickness=0.36 //x=67.462 //y=2.26 //x2=67.462 //y2=2.385
r407 (  19 45 ) resistor r=0.0860668 //w=0.374 //l=0.170294 //layer=m1 \
 //thickness=0.36 //x=73.01 //y=4.395 //x2=72.955 //y2=4.25
r408 (  19 20 ) resistor r=0.81584 //w=0.131 //l=0.855 //layer=m1 \
 //thickness=0.36 //x=73.01 //y=4.395 //x2=73.01 //y2=5.25
r409 (  18 43 ) resistor r=0.0910802 //w=0.374 //l=0.185472 //layer=m1 \
 //thickness=0.36 //x=73.01 //y=4.075 //x2=72.955 //y2=4.235
r410 (  17 18 ) resistor r=2.04676 //w=0.131 //l=2.145 //layer=m1 \
 //thickness=0.36 //x=73.01 //y=1.93 //x2=73.01 //y2=4.075
r411 (  15 17 ) resistor r=0.0698411 //w=0.17 //l=0.120208 //layer=m1 \
 //thickness=0.36 //x=72.925 //y=1.845 //x2=73.01 //y2=1.93
r412 (  15 16 ) resistor r=0.300573 //w=0.131 //l=0.315 //layer=m1 \
 //thickness=0.36 //x=72.925 //y=1.845 //x2=72.61 //y2=1.845
r413 (  14 16 ) resistor r=0.0698411 //w=0.17 //l=0.120208 //layer=m1 \
 //thickness=0.36 //x=72.525 //y=1.76 //x2=72.61 //y2=1.845
r414 (  13 41 ) resistor r=0.0717383 //w=0.224 //l=0.115 //layer=m1 \
 //thickness=0.36 //x=72.525 //y=1.305 //x2=72.525 //y2=1.19
r415 (  13 14 ) resistor r=0.43416 //w=0.131 //l=0.455 //layer=m1 \
 //thickness=0.36 //x=72.525 //y=1.305 //x2=72.525 //y2=1.76
r416 (  12 37 ) resistor r=0.0675342 //w=0.23 //l=0.115 //layer=m1 \
 //thickness=0.36 //x=72.345 //y=5.335 //x2=72.23 //y2=5.335
r417 (  11 20 ) resistor r=0.0698411 //w=0.17 //l=0.120208 //layer=m1 \
 //thickness=0.36 //x=72.925 //y=5.335 //x2=73.01 //y2=5.25
r418 (  11 12 ) resistor r=0.553435 //w=0.131 //l=0.58 //layer=m1 \
 //thickness=0.36 //x=72.925 //y=5.335 //x2=72.345 //y2=5.335
r419 (  10 39 ) resistor r=0.00118313 //w=0.23 //layer=m1 //thickness=0.36 \
 //x=72.23 //y=5.56 //x2=72.23 //y2=5.56
r420 (  9 37 ) resistor r=0.002872 //w=0.34 //l=0.085 //layer=m1 \
 //thickness=0.36 //x=72.23 //y=5.42 //x2=72.23 //y2=5.335
r421 (  9 10 ) resistor r=0.091623 //w=0.191 //l=0.14 //layer=m1 \
 //thickness=0.36 //x=72.23 //y=5.42 //x2=72.23 //y2=5.56
r422 (  8 34 ) resistor r=0.0262263 //w=0.232 //l=0.12 //layer=m1 \
 //thickness=0.36 //x=71.47 //y=5.335 //x2=71.35 //y2=5.335
r423 (  7 37 ) resistor r=0.0675342 //w=0.23 //l=0.115 //layer=m1 \
 //thickness=0.36 //x=72.115 //y=5.335 //x2=72.23 //y2=5.335
r424 (  7 8 ) resistor r=0.615458 //w=0.131 //l=0.645 //layer=m1 \
 //thickness=0.36 //x=72.115 //y=5.335 //x2=71.47 //y2=5.335
r425 (  6 31 ) resistor r=0.0222262 //w=0.217 //l=0.118 //layer=m1 \
 //thickness=0.36 //x=70.59 //y=5.335 //x2=70.472 //y2=5.335
r426 (  5 34 ) resistor r=0.0262263 //w=0.232 //l=0.12 //layer=m1 \
 //thickness=0.36 //x=71.23 //y=5.335 //x2=71.35 //y2=5.335
r427 (  5 6 ) resistor r=0.610687 //w=0.131 //l=0.64 //layer=m1 \
 //thickness=0.36 //x=71.23 //y=5.335 //x2=70.59 //y2=5.335
r428 (  4 26 ) resistor r=0.0878548 //w=0.228 //l=0.159295 //layer=m1 \
 //thickness=0.36 //x=67.46 //y=4.735 //x2=67.49 //y2=4.88
r429 (  3 30 ) resistor r=0.0910802 //w=0.374 //l=0.185472 //layer=m1 \
 //thickness=0.36 //x=67.46 //y=4.425 //x2=67.515 //y2=4.265
r430 (  3 4 ) resistor r=0.295802 //w=0.131 //l=0.31 //layer=m1 \
 //thickness=0.36 //x=67.46 //y=4.425 //x2=67.46 //y2=4.735
r431 (  2 28 ) resistor r=0.0860668 //w=0.374 //l=0.170294 //layer=m1 \
 //thickness=0.36 //x=67.46 //y=4.105 //x2=67.515 //y2=4.25
r432 (  2 24 ) resistor r=1.64122 //w=0.131 //l=1.72 //layer=m1 \
 //thickness=0.36 //x=67.46 //y=4.105 //x2=67.46 //y2=2.385
ends PM_TMRDFFSNQNX1\%noxref_18

subckt PM_TMRDFFSNQNX1\%noxref_19 ( 3 8 9 11 12 14 15 16 17 18 19 20 21 22 23 \
 24 25 26 27 28 29 30 33 34 37 39 42 46 56 64 68 73 75 76 77 79 82 83 84 85 87 \
 89 91 93 95 97 99 101 108 117 119 120 123 131 148 157 162 175 180 189 193 194 \
 195 196 197 198 199 200 201 202 203 204 205 206 208 214 215 216 217 221 222 \
 223 228 230 232 238 239 240 241 242 247 249 251 257 258 268 269 272 280 281 \
 284 292 294 295 )
c734 ( 292 0 ) capacitor c=0.00878249f //x=43.15 //y=1.085
c735 ( 284 0 ) capacitor c=0.0370698f //x=82.28 //y=4.885
c736 ( 281 0 ) capacitor c=0.030265f //x=82.26 //y=2.095
c737 ( 280 0 ) capacitor c=0.0512002f //x=82.26 //y=2.26
c738 ( 272 0 ) capacitor c=0.0387879f //x=75.64 //y=4.885
c739 ( 269 0 ) capacitor c=0.0300885f //x=75.6 //y=2.095
c740 ( 268 0 ) capacitor c=0.0518094f //x=75.6 //y=2.26
c741 ( 258 0 ) capacitor c=0.0237734f //x=82.825 //y=1.435
c742 ( 257 0 ) capacitor c=0.0191782f //x=82.825 //y=1.085
c743 ( 251 0 ) capacitor c=0.0361171f //x=82.67 //y=1.585
c744 ( 249 0 ) capacitor c=0.0157803f //x=82.67 //y=0.93
c745 ( 247 0 ) capacitor c=0.0376354f //x=82.665 //y=4.975
c746 ( 242 0 ) capacitor c=0.020493f //x=82.295 //y=1.74
c747 ( 241 0 ) capacitor c=0.0167049f //x=82.295 //y=1.435
c748 ( 240 0 ) capacitor c=0.0174993f //x=82.295 //y=1.085
c749 ( 239 0 ) capacitor c=0.0443648f //x=76.165 //y=1.43
c750 ( 238 0 ) capacitor c=0.0192211f //x=76.165 //y=1.085
c751 ( 232 0 ) capacitor c=0.0186579f //x=76.01 //y=1.585
c752 ( 230 0 ) capacitor c=0.0157795f //x=76.01 //y=0.93
c753 ( 228 0 ) capacitor c=0.0351351f //x=76.005 //y=4.975
c754 ( 223 0 ) capacitor c=0.0209124f //x=75.635 //y=1.74
c755 ( 222 0 ) capacitor c=0.016848f //x=75.635 //y=1.43
c756 ( 221 0 ) capacitor c=0.0174777f //x=75.635 //y=1.085
c757 ( 217 0 ) capacitor c=0.0612936f //x=45.905 //y=4.97
c758 ( 216 0 ) capacitor c=0.0376642f //x=46.195 //y=4.97
c759 ( 215 0 ) capacitor c=0.0346489f //x=45.86 //y=1.4
c760 ( 214 0 ) capacitor c=0.018692f //x=45.86 //y=1.055
c761 ( 208 0 ) capacitor c=0.0137077f //x=45.705 //y=1.555
c762 ( 206 0 ) capacitor c=0.0158585f //x=45.705 //y=0.9
c763 ( 205 0 ) capacitor c=0.0979517f //x=45.33 //y=2.095
c764 ( 204 0 ) capacitor c=0.0229444f //x=45.33 //y=1.71
c765 ( 203 0 ) capacitor c=0.0234359f //x=45.33 //y=1.4
c766 ( 202 0 ) capacitor c=0.019815f //x=45.33 //y=1.055
c767 ( 201 0 ) capacitor c=0.155887f //x=82.74 //y=6.205
c768 ( 200 0 ) capacitor c=0.1106f //x=82.3 //y=6.205
c769 ( 199 0 ) capacitor c=0.154859f //x=76.08 //y=6.205
c770 ( 198 0 ) capacitor c=0.110573f //x=75.64 //y=6.205
c771 ( 197 0 ) capacitor c=0.110208f //x=46.27 //y=6.2
c772 ( 196 0 ) capacitor c=0.158957f //x=45.83 //y=6.2
c773 ( 189 0 ) capacitor c=8.10734e-19 //x=82.28 //y=4.885
c774 ( 180 0 ) capacitor c=0.00105273f //x=82.26 //y=2.26
c775 ( 175 0 ) capacitor c=0.00173056f //x=75.64 //y=4.885
c776 ( 162 0 ) capacitor c=0.0012588f //x=75.6 //y=2.26
c777 ( 157 0 ) capacitor c=0.0014751f //x=45.63 //y=4.88
c778 ( 148 0 ) capacitor c=9.93222e-19 //x=45.63 //y=2.26
c779 ( 131 0 ) capacitor c=0.0322017f //x=43.3 //y=5.56
c780 ( 123 0 ) capacitor c=0.0290435f //x=42.42 //y=5.56
c781 ( 120 0 ) capacitor c=0.138665f //x=82.115 //y=4.21
c782 ( 119 0 ) capacitor c=0.00479868f //x=82.275 //y=4.21
c783 ( 117 0 ) capacitor c=0.00304681f //x=75.76 //y=4.205
c784 ( 108 0 ) capacitor c=7.98824e-19 //x=43.94 //y=2.785
c785 ( 101 0 ) capacitor c=0.210945f //x=63.6 //y=3.17
c786 ( 99 0 ) capacitor c=0.0177421f //x=63 //y=3.14
c787 ( 97 0 ) capacitor c=0.00425641f //x=61.755 //y=3.17
c788 ( 95 0 ) capacitor c=0.025234f //x=61.155 //y=3.14
c789 ( 93 0 ) capacitor c=0.00429096f //x=58.795 //y=3.16
c790 ( 91 0 ) capacitor c=0.043887f //x=58.195 //y=3.14
c791 ( 89 0 ) capacitor c=0.00368608f //x=53.985 //y=3.155
c792 ( 87 0 ) capacitor c=0.0184713f //x=53.385 //y=3.14
c793 ( 85 0 ) capacitor c=0.00413336f //x=52.135 //y=3.155
c794 ( 84 0 ) capacitor c=1.09476e-19 //x=51.265 //y=3.14
c795 ( 83 0 ) capacitor c=0.00544846f //x=51.535 //y=3.14
c796 ( 79 0 ) capacitor c=0.00904084f //x=50.655 //y=2.755
c797 ( 77 0 ) capacitor c=0.0292555f //x=50.055 //y=2.77
c798 ( 76 0 ) capacitor c=0.00917443f //x=46.6 //y=2.775
c799 ( 75 0 ) capacitor c=0.00360945f //x=46.945 //y=2.775
c800 ( 73 0 ) capacitor c=0.0154723f //x=45.46 //y=2.77
c801 ( 68 0 ) capacitor c=0.0148587f //x=82.26 //y=4.25
c802 ( 64 0 ) capacitor c=0.0160193f //x=75.6 //y=4.25
c803 ( 56 0 ) capacitor c=0.0147928f //x=75.6 //y=3.14
c804 ( 46 0 ) capacitor c=0.0148633f //x=45.63 //y=2.77
c805 ( 42 0 ) capacitor c=0.0149023f //x=43.78 //y=2.77
c806 ( 39 0 ) capacitor c=0.0113436f //x=43.34 //y=1.18
c807 ( 37 0 ) capacitor c=5.78613e-19 //x=43.3 //y=5.56
c808 ( 34 0 ) capacitor c=0.0108461f //x=43.3 //y=5.38
c809 ( 33 0 ) capacitor c=0.0090176f //x=42.42 //y=5.56
c810 ( 30 0 ) capacitor c=0.0124358f //x=82.26 //y=4.74
c811 ( 29 0 ) capacitor c=0.0110536f //x=82.26 //y=4.37
c812 ( 28 0 ) capacitor c=0.0479874f //x=82.26 //y=4.05
c813 ( 27 0 ) capacitor c=0.00651439f //x=82.26 //y=2.38
c814 ( 26 0 ) capacitor c=0.0169891f //x=75.6 //y=4.71
c815 ( 25 0 ) capacitor c=0.0124046f //x=75.6 //y=4.365
c816 ( 24 0 ) capacitor c=0.0296262f //x=75.6 //y=4.045
c817 ( 23 0 ) capacitor c=0.0129885f //x=75.6 //y=3.285
c818 ( 22 0 ) capacitor c=0.0188593f //x=75.6 //y=2.965
c819 ( 21 0 ) capacitor c=0.00887451f //x=75.6 //y=2.375
c820 ( 20 0 ) capacitor c=0.0618341f //x=45.63 //y=4.755
c821 ( 19 0 ) capacitor c=0.0128476f //x=45.63 //y=2.945
c822 ( 18 0 ) capacitor c=0.00435263f //x=45.63 //y=2.625
c823 ( 17 0 ) capacitor c=0.00492791f //x=45.63 //y=2.375
c824 ( 16 0 ) capacitor c=0.0635585f //x=43.78 //y=5.295
c825 ( 15 0 ) capacitor c=0.0120975f //x=43.78 //y=2.945
c826 ( 14 0 ) capacitor c=0.0177588f //x=43.78 //y=2.625
c827 ( 12 0 ) capacitor c=0.00469281f //x=43.425 //y=1.835
c828 ( 11 0 ) capacitor c=0.0117659f //x=43.695 //y=1.835
c829 ( 9 0 ) capacitor c=0.0117523f //x=43.695 //y=5.38
c830 ( 8 0 ) capacitor c=0.0133876f //x=43.34 //y=1.75
c831 ( 3 0 ) capacitor c=0.0143818f //x=43.185 //y=5.38
r832 (  286 287 ) resistor r=32.4568 //w=0.214 //l=0.075 //layer=ply \
 //thickness=0.18 //x=82.28 //y=4.975 //x2=82.28 //y2=5.05
r833 (  284 286 ) resistor r=20.271 //w=0.214 //l=0.09 //layer=ply \
 //thickness=0.18 //x=82.28 //y=4.885 //x2=82.28 //y2=4.975
r834 (  280 281 ) resistor r=52.7279 //w=0.214 //l=0.165 //layer=ply \
 //thickness=0.18 //x=82.26 //y=2.26 //x2=82.26 //y2=2.095
r835 (  272 274 ) resistor r=20.271 //w=0.214 //l=0.09 //layer=ply \
 //thickness=0.18 //x=75.64 //y=4.885 //x2=75.64 //y2=4.975
r836 (  268 269 ) resistor r=52.7279 //w=0.214 //l=0.165 //layer=ply \
 //thickness=0.18 //x=75.6 //y=2.26 //x2=75.6 //y2=2.095
r837 (  258 291 ) resistor r=4.95774 //w=0.164 //l=0.112 //layer=ply \
 //thickness=0.18 //x=82.825 //y=1.435 //x2=82.825 //y2=1.547
r838 (  257 290 ) resistor r=45.1352 //w=0.168 //l=0.173853 //layer=ply \
 //thickness=0.18 //x=82.825 //y=1.085 //x2=82.785 //y2=0.93
r839 (  257 258 ) resistor r=179.468 //w=0.094 //l=0.35 //layer=ply \
 //thickness=0.18 //x=82.825 //y=1.085 //x2=82.825 //y2=1.435
r840 (  252 289 ) resistor r=10.8103 //w=0.211 //l=0.115 //layer=ply \
 //thickness=0.18 //x=82.45 //y=1.585 //x2=82.335 //y2=1.585
r841 (  251 291 ) resistor r=45.9962 //w=0.164 //l=0.17296 //layer=ply \
 //thickness=0.18 //x=82.67 //y=1.585 //x2=82.825 //y2=1.547
r842 (  250 288 ) resistor r=5.52526 //w=0.168 //l=0.115 //layer=ply \
 //thickness=0.18 //x=82.45 //y=0.93 //x2=82.335 //y2=0.93
r843 (  249 290 ) resistor r=5.52526 //w=0.168 //l=0.115 //layer=ply \
 //thickness=0.18 //x=82.67 //y=0.93 //x2=82.785 //y2=0.93
r844 (  249 250 ) resistor r=112.809 //w=0.094 //l=0.22 //layer=ply \
 //thickness=0.18 //x=82.67 //y=0.93 //x2=82.45 //y2=0.93
r845 (  248 286 ) resistor r=16.5046 //w=0.27 //l=0.135 //layer=ply \
 //thickness=0.18 //x=82.415 //y=4.975 //x2=82.28 //y2=4.975
r846 (  247 254 ) resistor r=26.9307 //w=0.15 //l=0.106066 //layer=ply \
 //thickness=0.18 //x=82.665 //y=4.975 //x2=82.74 //y2=5.05
r847 (  247 248 ) resistor r=128.191 //w=0.094 //l=0.25 //layer=ply \
 //thickness=0.18 //x=82.665 //y=4.975 //x2=82.415 //y2=4.975
r848 (  242 289 ) resistor r=39.5036 //w=0.211 //l=0.173853 //layer=ply \
 //thickness=0.18 //x=82.295 //y=1.74 //x2=82.335 //y2=1.585
r849 (  242 281 ) resistor r=182.032 //w=0.094 //l=0.355 //layer=ply \
 //thickness=0.18 //x=82.295 //y=1.74 //x2=82.295 //y2=2.095
r850 (  241 289 ) resistor r=38.3614 //w=0.211 //l=0.168819 //layer=ply \
 //thickness=0.18 //x=82.295 //y=1.435 //x2=82.335 //y2=1.585
r851 (  240 288 ) resistor r=45.1352 //w=0.168 //l=0.173853 //layer=ply \
 //thickness=0.18 //x=82.295 //y=1.085 //x2=82.335 //y2=0.93
r852 (  240 241 ) resistor r=179.468 //w=0.094 //l=0.35 //layer=ply \
 //thickness=0.18 //x=82.295 //y=1.085 //x2=82.295 //y2=1.435
r853 (  239 278 ) resistor r=45.1352 //w=0.168 //l=0.173853 //layer=ply \
 //thickness=0.18 //x=76.165 //y=1.43 //x2=76.125 //y2=1.585
r854 (  238 277 ) resistor r=45.1352 //w=0.168 //l=0.173853 //layer=ply \
 //thickness=0.18 //x=76.165 //y=1.085 //x2=76.125 //y2=0.93
r855 (  238 239 ) resistor r=176.904 //w=0.094 //l=0.345 //layer=ply \
 //thickness=0.18 //x=76.165 //y=1.085 //x2=76.165 //y2=1.43
r856 (  233 276 ) resistor r=10.701 //w=0.21 //l=0.115 //layer=ply \
 //thickness=0.18 //x=75.79 //y=1.585 //x2=75.675 //y2=1.585
r857 (  232 278 ) resistor r=5.52526 //w=0.168 //l=0.115 //layer=ply \
 //thickness=0.18 //x=76.01 //y=1.585 //x2=76.125 //y2=1.585
r858 (  231 275 ) resistor r=5.52526 //w=0.168 //l=0.115 //layer=ply \
 //thickness=0.18 //x=75.79 //y=0.93 //x2=75.675 //y2=0.93
r859 (  230 277 ) resistor r=5.52526 //w=0.168 //l=0.115 //layer=ply \
 //thickness=0.18 //x=76.01 //y=0.93 //x2=76.125 //y2=0.93
r860 (  230 231 ) resistor r=112.809 //w=0.094 //l=0.22 //layer=ply \
 //thickness=0.18 //x=76.01 //y=0.93 //x2=75.79 //y2=0.93
r861 (  229 274 ) resistor r=16.5046 //w=0.27 //l=0.135 //layer=ply \
 //thickness=0.18 //x=75.775 //y=4.975 //x2=75.64 //y2=4.975
r862 (  228 235 ) resistor r=26.9307 //w=0.15 //l=0.106066 //layer=ply \
 //thickness=0.18 //x=76.005 //y=4.975 //x2=76.08 //y2=5.05
r863 (  228 229 ) resistor r=117.936 //w=0.094 //l=0.23 //layer=ply \
 //thickness=0.18 //x=76.005 //y=4.975 //x2=75.775 //y2=4.975
r864 (  225 274 ) resistor r=32.4568 //w=0.214 //l=0.075 //layer=ply \
 //thickness=0.18 //x=75.64 //y=5.05 //x2=75.64 //y2=4.975
r865 (  223 276 ) resistor r=39.5823 //w=0.21 //l=0.173853 //layer=ply \
 //thickness=0.18 //x=75.635 //y=1.74 //x2=75.675 //y2=1.585
r866 (  223 269 ) resistor r=182.032 //w=0.094 //l=0.355 //layer=ply \
 //thickness=0.18 //x=75.635 //y=1.74 //x2=75.635 //y2=2.095
r867 (  222 276 ) resistor r=39.5823 //w=0.21 //l=0.173853 //layer=ply \
 //thickness=0.18 //x=75.635 //y=1.43 //x2=75.675 //y2=1.585
r868 (  221 275 ) resistor r=45.1352 //w=0.168 //l=0.173853 //layer=ply \
 //thickness=0.18 //x=75.635 //y=1.085 //x2=75.675 //y2=0.93
r869 (  221 222 ) resistor r=176.904 //w=0.094 //l=0.345 //layer=ply \
 //thickness=0.18 //x=75.635 //y=1.085 //x2=75.635 //y2=1.43
r870 (  216 218 ) resistor r=26.9307 //w=0.15 //l=0.106066 //layer=ply \
 //thickness=0.18 //x=46.195 //y=4.97 //x2=46.27 //y2=5.045
r871 (  216 217 ) resistor r=148.702 //w=0.094 //l=0.29 //layer=ply \
 //thickness=0.18 //x=46.195 //y=4.97 //x2=45.905 //y2=4.97
r872 (  215 266 ) resistor r=45.1352 //w=0.168 //l=0.173853 //layer=ply \
 //thickness=0.18 //x=45.86 //y=1.4 //x2=45.82 //y2=1.555
r873 (  214 265 ) resistor r=45.1352 //w=0.168 //l=0.173853 //layer=ply \
 //thickness=0.18 //x=45.86 //y=1.055 //x2=45.82 //y2=0.9
r874 (  214 215 ) resistor r=176.904 //w=0.094 //l=0.345 //layer=ply \
 //thickness=0.18 //x=45.86 //y=1.055 //x2=45.86 //y2=1.4
r875 (  211 217 ) resistor r=22.7971 //w=0.269 //l=0.106066 //layer=ply \
 //thickness=0.18 //x=45.83 //y=5.045 //x2=45.905 //y2=4.97
r876 (  211 264 ) resistor r=35.8364 //w=0.269 //l=0.270185 //layer=ply \
 //thickness=0.18 //x=45.83 //y=5.045 //x2=45.63 //y2=4.88
r877 (  209 260 ) resistor r=10.701 //w=0.21 //l=0.115 //layer=ply \
 //thickness=0.18 //x=45.485 //y=1.555 //x2=45.37 //y2=1.555
r878 (  208 266 ) resistor r=5.52526 //w=0.168 //l=0.115 //layer=ply \
 //thickness=0.18 //x=45.705 //y=1.555 //x2=45.82 //y2=1.555
r879 (  207 259 ) resistor r=5.52526 //w=0.168 //l=0.115 //layer=ply \
 //thickness=0.18 //x=45.485 //y=0.9 //x2=45.37 //y2=0.9
r880 (  206 265 ) resistor r=5.52526 //w=0.168 //l=0.115 //layer=ply \
 //thickness=0.18 //x=45.705 //y=0.9 //x2=45.82 //y2=0.9
r881 (  206 207 ) resistor r=112.809 //w=0.094 //l=0.22 //layer=ply \
 //thickness=0.18 //x=45.705 //y=0.9 //x2=45.485 //y2=0.9
r882 (  205 262 ) resistor r=58.7805 //w=0.246 //l=0.373497 //layer=ply \
 //thickness=0.18 //x=45.33 //y=2.095 //x2=45.63 //y2=2.26
r883 (  204 260 ) resistor r=39.5823 //w=0.21 //l=0.173853 //layer=ply \
 //thickness=0.18 //x=45.33 //y=1.71 //x2=45.37 //y2=1.555
r884 (  204 205 ) resistor r=197.415 //w=0.094 //l=0.385 //layer=ply \
 //thickness=0.18 //x=45.33 //y=1.71 //x2=45.33 //y2=2.095
r885 (  203 260 ) resistor r=39.5823 //w=0.21 //l=0.173853 //layer=ply \
 //thickness=0.18 //x=45.33 //y=1.4 //x2=45.37 //y2=1.555
r886 (  202 259 ) resistor r=45.1352 //w=0.168 //l=0.173853 //layer=ply \
 //thickness=0.18 //x=45.33 //y=1.055 //x2=45.37 //y2=0.9
r887 (  202 203 ) resistor r=176.904 //w=0.094 //l=0.345 //layer=ply \
 //thickness=0.18 //x=45.33 //y=1.055 //x2=45.33 //y2=1.4
r888 (  201 254 ) resistor r=592.245 //w=0.094 //l=1.155 //layer=ply \
 //thickness=0.18 //x=82.74 //y=6.205 //x2=82.74 //y2=5.05
r889 (  200 287 ) resistor r=592.245 //w=0.094 //l=1.155 //layer=ply \
 //thickness=0.18 //x=82.3 //y=6.205 //x2=82.3 //y2=5.05
r890 (  199 235 ) resistor r=592.245 //w=0.094 //l=1.155 //layer=ply \
 //thickness=0.18 //x=76.08 //y=6.205 //x2=76.08 //y2=5.05
r891 (  198 225 ) resistor r=592.245 //w=0.094 //l=1.155 //layer=ply \
 //thickness=0.18 //x=75.64 //y=6.205 //x2=75.64 //y2=5.05
r892 (  197 218 ) resistor r=592.245 //w=0.094 //l=1.155 //layer=ply \
 //thickness=0.18 //x=46.27 //y=6.2 //x2=46.27 //y2=5.045
r893 (  196 211 ) resistor r=592.245 //w=0.094 //l=1.155 //layer=ply \
 //thickness=0.18 //x=45.83 //y=6.2 //x2=45.83 //y2=5.045
r894 (  195 251 ) resistor r=56.4043 //w=0.094 //l=0.11 //layer=ply \
 //thickness=0.18 //x=82.56 //y=1.585 //x2=82.67 //y2=1.585
r895 (  195 252 ) resistor r=56.4043 //w=0.094 //l=0.11 //layer=ply \
 //thickness=0.18 //x=82.56 //y=1.585 //x2=82.45 //y2=1.585
r896 (  194 232 ) resistor r=56.4043 //w=0.094 //l=0.11 //layer=ply \
 //thickness=0.18 //x=75.9 //y=1.585 //x2=76.01 //y2=1.585
r897 (  194 233 ) resistor r=56.4043 //w=0.094 //l=0.11 //layer=ply \
 //thickness=0.18 //x=75.9 //y=1.585 //x2=75.79 //y2=1.585
r898 (  193 208 ) resistor r=56.4043 //w=0.094 //l=0.11 //layer=ply \
 //thickness=0.18 //x=45.595 //y=1.555 //x2=45.705 //y2=1.555
r899 (  193 209 ) resistor r=56.4043 //w=0.094 //l=0.11 //layer=ply \
 //thickness=0.18 //x=45.595 //y=1.555 //x2=45.485 //y2=1.555
r900 (  189 284 ) resistor r=152 //w=0.17 //l=0.17 //layer=licon //count=1 \
 //x=82.28 //y=4.885 //x2=82.28 //y2=4.885
r901 (  180 280 ) resistor r=152 //w=0.17 //l=0.17 //layer=licon //count=1 \
 //x=82.26 //y=2.26 //x2=82.26 //y2=2.26
r902 (  175 272 ) resistor r=152 //w=0.17 //l=0.17 //layer=licon //count=1 \
 //x=75.64 //y=4.885 //x2=75.64 //y2=4.885
r903 (  162 268 ) resistor r=152 //w=0.17 //l=0.17 //layer=licon //count=1 \
 //x=75.6 //y=2.26 //x2=75.6 //y2=2.26
r904 (  157 264 ) resistor r=152 //w=0.17 //l=0.17 //layer=licon //count=1 \
 //x=45.63 //y=4.88 //x2=45.63 //y2=4.88
r905 (  148 262 ) resistor r=152 //w=0.17 //l=0.17 //layer=licon //count=1 \
 //x=45.63 //y=2.26 //x2=45.63 //y2=2.26
r906 (  131 295 ) resistor r=23.615 //w=0.187 //l=0.345 //layer=li \
 //thickness=0.1 //x=43.3 //y=5.56 //x2=43.3 //y2=5.905
r907 (  123 294 ) resistor r=23.615 //w=0.187 //l=0.345 //layer=li \
 //thickness=0.1 //x=42.42 //y=5.56 //x2=42.42 //y2=5.905
r908 (  119 120 ) resistor r=0.104807 //w=0.281 //l=0.16 //layer=m2 \
 //thickness=0.36 //x=82.275 //y=4.21 //x2=82.115 //y2=4.21
r909 (  117 120 ) resistor r=5.84099 //w=0.136 //l=6.355 //layer=m2 \
 //thickness=0.36 //x=75.76 //y=4.252 //x2=82.115 //y2=4.252
r910 (  115 117 ) resistor r=0.104807 //w=0.281 //l=0.16 //layer=m2 \
 //thickness=0.36 //x=75.6 //y=4.205 //x2=75.76 //y2=4.205
r911 (  106 108 ) resistor r=0.10734 //w=0.281 //l=0.16 //layer=m2 \
 //thickness=0.36 //x=43.78 //y=2.785 //x2=43.94 //y2=2.785
r912 (  101 113 ) resistor r=8.6171 //w=0.174 //l=12.0175 //layer=m2 \
 //thickness=0.36 //x=63.6 //y=3.17 //x2=75.595 //y2=3.125
r913 (  101 102 ) resistor r=0.329198 //w=0.131 //l=0.345 //layer=m2 \
 //thickness=0.36 //x=63.6 //y=3.17 //x2=63.255 //y2=3.17
r914 (  99 102 ) resistor r=0.1875 //w=0.17 //l=0.269583 //layer=m2 \
 //thickness=0.36 //x=63 //y=3.14 //x2=63.255 //y2=3.17
r915 (  99 100 ) resistor r=1.02576 //w=0.131 //l=1.075 //layer=m2 \
 //thickness=0.36 //x=63 //y=3.14 //x2=61.925 //y2=3.14
r916 (  97 100 ) resistor r=0.125 //w=0.17 //l=0.184391 //layer=m2 \
 //thickness=0.36 //x=61.755 //y=3.17 //x2=61.925 //y2=3.14
r917 (  97 98 ) resistor r=0.329198 //w=0.131 //l=0.345 //layer=m2 \
 //thickness=0.36 //x=61.755 //y=3.17 //x2=61.41 //y2=3.17
r918 (  95 98 ) resistor r=0.1875 //w=0.17 //l=0.269583 //layer=m2 \
 //thickness=0.36 //x=61.155 //y=3.14 //x2=61.41 //y2=3.17
r919 (  95 96 ) resistor r=2.08969 //w=0.131 //l=2.19 //layer=m2 \
 //thickness=0.36 //x=61.155 //y=3.14 //x2=58.965 //y2=3.14
r920 (  93 96 ) resistor r=0.125 //w=0.17 //l=0.179722 //layer=m2 \
 //thickness=0.36 //x=58.795 //y=3.16 //x2=58.965 //y2=3.14
r921 (  93 94 ) resistor r=0.329198 //w=0.131 //l=0.345 //layer=m2 \
 //thickness=0.36 //x=58.795 //y=3.16 //x2=58.45 //y2=3.16
r922 (  91 94 ) resistor r=0.1875 //w=0.17 //l=0.264811 //layer=m2 \
 //thickness=0.36 //x=58.195 //y=3.14 //x2=58.45 //y2=3.16
r923 (  91 92 ) resistor r=3.85496 //w=0.131 //l=4.04 //layer=m2 \
 //thickness=0.36 //x=58.195 //y=3.14 //x2=54.155 //y2=3.14
r924 (  89 92 ) resistor r=0.125 //w=0.17 //l=0.177341 //layer=m2 \
 //thickness=0.36 //x=53.985 //y=3.155 //x2=54.155 //y2=3.14
r925 (  89 90 ) resistor r=0.329198 //w=0.131 //l=0.345 //layer=m2 \
 //thickness=0.36 //x=53.985 //y=3.155 //x2=53.64 //y2=3.155
r926 (  87 90 ) resistor r=0.1875 //w=0.17 //l=0.262393 //layer=m2 \
 //thickness=0.36 //x=53.385 //y=3.14 //x2=53.64 //y2=3.155
r927 (  87 88 ) resistor r=1.03053 //w=0.131 //l=1.08 //layer=m2 \
 //thickness=0.36 //x=53.385 //y=3.14 //x2=52.305 //y2=3.14
r928 (  85 88 ) resistor r=0.125 //w=0.17 //l=0.177341 //layer=m2 \
 //thickness=0.36 //x=52.135 //y=3.155 //x2=52.305 //y2=3.14
r929 (  85 86 ) resistor r=0.329198 //w=0.131 //l=0.345 //layer=m2 \
 //thickness=0.36 //x=52.135 //y=3.155 //x2=51.79 //y2=3.155
r930 (  83 86 ) resistor r=0.1875 //w=0.17 //l=0.262393 //layer=m2 \
 //thickness=0.36 //x=51.535 //y=3.14 //x2=51.79 //y2=3.155
r931 (  83 84 ) resistor r=0.257634 //w=0.131 //l=0.27 //layer=m2 \
 //thickness=0.36 //x=51.535 //y=3.14 //x2=51.265 //y2=3.14
r932 (  82 84 ) resistor r=0.0698411 //w=0.17 //l=0.120208 //layer=m2 \
 //thickness=0.36 //x=51.18 //y=3.055 //x2=51.265 //y2=3.14
r933 (  81 111 ) resistor r=0.0073411 //w=0.17 //l=0.093 //layer=m2 \
 //thickness=0.36 //x=51.18 //y=2.855 //x2=51.18 //y2=2.762
r934 (  81 82 ) resistor r=0.19084 //w=0.131 //l=0.2 //layer=m2 \
 //thickness=0.36 //x=51.18 //y=2.855 //x2=51.18 //y2=3.055
r935 (  79 111 ) resistor r=0.386029 //w=0.17 //l=0.528488 //layer=m2 \
 //thickness=0.36 //x=50.655 //y=2.755 //x2=51.18 //y2=2.762
r936 (  79 80 ) resistor r=0.410305 //w=0.131 //l=0.43 //layer=m2 \
 //thickness=0.36 //x=50.655 //y=2.755 //x2=50.225 //y2=2.755
r937 (  77 80 ) resistor r=0.125 //w=0.17 //l=0.177341 //layer=m2 \
 //thickness=0.36 //x=50.055 //y=2.77 //x2=50.225 //y2=2.755
r938 (  77 78 ) resistor r=2.80534 //w=0.131 //l=2.94 //layer=m2 \
 //thickness=0.36 //x=50.055 //y=2.77 //x2=47.115 //y2=2.77
r939 (  76 110 ) resistor r=0.58057 //w=0.213 //l=0.984987 //layer=m2 \
 //thickness=0.36 //x=46.6 //y=2.775 //x2=45.62 //y2=2.785
r940 (  75 78 ) resistor r=0.125 //w=0.17 //l=0.172482 //layer=m2 \
 //thickness=0.36 //x=46.945 //y=2.775 //x2=47.115 //y2=2.77
r941 (  75 76 ) resistor r=0.329198 //w=0.131 //l=0.345 //layer=m2 \
 //thickness=0.36 //x=46.945 //y=2.775 //x2=46.6 //y2=2.775
r942 (  73 110 ) resistor r=0.0993492 //w=0.213 //l=0.167332 //layer=m2 \
 //thickness=0.36 //x=45.46 //y=2.77 //x2=45.62 //y2=2.785
r943 (  73 108 ) resistor r=1.45038 //w=0.131 //l=1.52 //layer=m2 \
 //thickness=0.36 //x=45.46 //y=2.77 //x2=43.94 //y2=2.77
r944 (  72 189 ) resistor r=9.3 //w=0.17 //l=0.17 //layer=mcon //count=1 \
 //x=82.28 //y=4.885 //x2=82.28 //y2=4.885
r945 (  70 180 ) resistor r=9.3 //w=0.17 //l=0.17 //layer=mcon //count=1 \
 //x=82.26 //y=2.26 //x2=82.26 //y2=2.26
r946 (  66 119 ) resistor r=4.5 //w=0.15 //l=0.15 //layer=via1 //count=1 \
 //x=82.275 //y=4.21 //x2=82.275 //y2=4.21
r947 (  66 68 ) resistor r=0.0130208 //w=0.384 //l=0.04 //layer=m1 \
 //thickness=0.36 //x=82.215 //y=4.21 //x2=82.215 //y2=4.25
r948 (  62 115 ) resistor r=4.5 //w=0.15 //l=0.15 //layer=via1 //count=1 \
 //x=75.6 //y=4.205 //x2=75.6 //y2=4.205
r949 (  62 64 ) resistor r=0.0149601 //w=0.376 //l=0.045 //layer=m1 \
 //thickness=0.36 //x=75.652 //y=4.205 //x2=75.652 //y2=4.25
r950 (  60 175 ) resistor r=9.3 //w=0.17 //l=0.17 //layer=mcon //count=1 \
 //x=75.64 //y=4.885 //x2=75.64 //y2=4.885
r951 (  58 162 ) resistor r=9.3 //w=0.17 //l=0.17 //layer=mcon //count=1 \
 //x=75.6 //y=2.26 //x2=75.6 //y2=2.26
r952 (  54 113 ) resistor r=4.5 //w=0.15 //l=0.15 //layer=via1 //count=1 \
 //x=75.595 //y=3.125 //x2=75.595 //y2=3.125
r953 (  54 56 ) resistor r=0.00501337 //w=0.374 //l=0.015 //layer=m1 \
 //thickness=0.36 //x=75.545 //y=3.125 //x2=75.545 //y2=3.14
r954 (  52 157 ) resistor r=9.3 //w=0.17 //l=0.17 //layer=mcon //count=1 \
 //x=45.63 //y=4.88 //x2=45.63 //y2=4.88
r955 (  50 148 ) resistor r=9.3 //w=0.17 //l=0.17 //layer=mcon //count=1 \
 //x=45.63 //y=2.26 //x2=45.63 //y2=2.26
r956 (  48 110 ) resistor r=4.5 //w=0.15 //l=0.15 //layer=via1 //count=1 \
 //x=45.62 //y=2.785 //x2=45.62 //y2=2.785
r957 (  46 48 ) resistor r=0.00505391 //w=0.371 //l=0.015 //layer=m1 \
 //thickness=0.36 //x=45.572 //y=2.77 //x2=45.572 //y2=2.785
r958 (  44 106 ) resistor r=4.5 //w=0.15 //l=0.15 //layer=via1 //count=1 \
 //x=43.78 //y=2.785 //x2=43.78 //y2=2.785
r959 (  42 44 ) resistor r=0.0049867 //w=0.376 //l=0.015 //layer=m1 \
 //thickness=0.36 //x=43.832 //y=2.77 //x2=43.832 //y2=2.785
r960 (  39 292 ) resistor r=9.3 //w=0.17 //l=0.17 //layer=mcon //count=1 \
 //x=43.34 //y=1.18 //x2=43.34 //y2=1.18
r961 (  37 131 ) resistor r=9.3 //w=0.17 //l=0.17 //layer=mcon //count=1 \
 //x=43.3 //y=5.56 //x2=43.3 //y2=5.56
r962 (  34 37 ) resistor r=0.117801 //w=0.191 //l=0.18 //layer=m1 \
 //thickness=0.36 //x=43.3 //y=5.38 //x2=43.3 //y2=5.56
r963 (  33 123 ) resistor r=9.3 //w=0.17 //l=0.17 //layer=mcon //count=1 \
 //x=42.42 //y=5.56 //x2=42.42 //y2=5.56
r964 (  31 33 ) resistor r=0.10274 //w=0.219 //l=0.18 //layer=m1 \
 //thickness=0.36 //x=42.42 //y=5.38 //x2=42.42 //y2=5.56
r965 (  30 72 ) resistor r=0.0893515 //w=0.219 //l=0.154677 //layer=m1 \
 //thickness=0.36 //x=82.26 //y=4.74 //x2=82.28 //y2=4.885
r966 (  29 68 ) resistor r=0.0784723 //w=0.384 //l=0.140712 //layer=m1 \
 //thickness=0.36 //x=82.26 //y=4.37 //x2=82.215 //y2=4.25
r967 (  29 30 ) resistor r=0.353053 //w=0.131 //l=0.37 //layer=m1 \
 //thickness=0.36 //x=82.26 //y=4.37 //x2=82.26 //y2=4.74
r968 (  28 66 ) resistor r=0.0914932 //w=0.384 //l=0.181108 //layer=m1 \
 //thickness=0.36 //x=82.26 //y=4.05 //x2=82.215 //y2=4.21
r969 (  27 70 ) resistor r=0.0744285 //w=0.225 //l=0.12 //layer=m1 \
 //thickness=0.36 //x=82.26 //y=2.38 //x2=82.26 //y2=2.26
r970 (  27 28 ) resistor r=1.59351 //w=0.131 //l=1.67 //layer=m1 \
 //thickness=0.36 //x=82.26 //y=2.38 //x2=82.26 //y2=4.05
r971 (  26 60 ) resistor r=0.100665 //w=0.248 //l=0.193972 //layer=m1 \
 //thickness=0.36 //x=75.6 //y=4.71 //x2=75.64 //y2=4.885
r972 (  25 64 ) resistor r=0.0761992 //w=0.376 //l=0.138582 //layer=m1 \
 //thickness=0.36 //x=75.6 //y=4.365 //x2=75.652 //y2=4.25
r973 (  25 26 ) resistor r=0.329198 //w=0.131 //l=0.345 //layer=m1 \
 //thickness=0.36 //x=75.6 //y=4.365 //x2=75.6 //y2=4.71
r974 (  24 62 ) resistor r=0.0911593 //w=0.376 //l=0.184174 //layer=m1 \
 //thickness=0.36 //x=75.6 //y=4.045 //x2=75.652 //y2=4.205
r975 (  23 56 ) resistor r=0.0860668 //w=0.374 //l=0.170294 //layer=m1 \
 //thickness=0.36 //x=75.6 //y=3.285 //x2=75.545 //y2=3.14
r976 (  23 24 ) resistor r=0.725191 //w=0.131 //l=0.76 //layer=m1 \
 //thickness=0.36 //x=75.6 //y=3.285 //x2=75.6 //y2=4.045
r977 (  22 54 ) resistor r=0.0910802 //w=0.374 //l=0.185472 //layer=m1 \
 //thickness=0.36 //x=75.6 //y=2.965 //x2=75.545 //y2=3.125
r978 (  21 58 ) resistor r=0.0717383 //w=0.224 //l=0.115 //layer=m1 \
 //thickness=0.36 //x=75.6 //y=2.375 //x2=75.6 //y2=2.26
r979 (  21 22 ) resistor r=0.562977 //w=0.131 //l=0.59 //layer=m1 \
 //thickness=0.36 //x=75.6 //y=2.375 //x2=75.6 //y2=2.965
r980 (  20 52 ) resistor r=0.0760407 //w=0.238 //l=0.125 //layer=m1 \
 //thickness=0.36 //x=45.63 //y=4.755 //x2=45.63 //y2=4.88
r981 (  19 48 ) resistor r=0.0909648 //w=0.371 //l=0.186762 //layer=m1 \
 //thickness=0.36 //x=45.63 //y=2.945 //x2=45.572 //y2=2.785
r982 (  19 20 ) resistor r=1.7271 //w=0.131 //l=1.81 //layer=m1 \
 //thickness=0.36 //x=45.63 //y=2.945 //x2=45.63 //y2=4.755
r983 (  18 46 ) resistor r=0.0859108 //w=0.371 //l=0.171566 //layer=m1 \
 //thickness=0.36 //x=45.63 //y=2.625 //x2=45.572 //y2=2.77
r984 (  17 50 ) resistor r=0.0719237 //w=0.222 //l=0.115 //layer=m1 \
 //thickness=0.36 //x=45.63 //y=2.375 //x2=45.63 //y2=2.26
r985 (  17 18 ) resistor r=0.23855 //w=0.131 //l=0.25 //layer=m1 \
 //thickness=0.36 //x=45.63 //y=2.375 //x2=45.63 //y2=2.625
r986 (  15 44 ) resistor r=0.0911593 //w=0.376 //l=0.184174 //layer=m1 \
 //thickness=0.36 //x=43.78 //y=2.945 //x2=43.832 //y2=2.785
r987 (  15 16 ) resistor r=2.24237 //w=0.131 //l=2.35 //layer=m1 \
 //thickness=0.36 //x=43.78 //y=2.945 //x2=43.78 //y2=5.295
r988 (  14 42 ) resistor r=0.0861726 //w=0.376 //l=0.169012 //layer=m1 \
 //thickness=0.36 //x=43.78 //y=2.625 //x2=43.832 //y2=2.77
r989 (  13 14 ) resistor r=0.67271 //w=0.131 //l=0.705 //layer=m1 \
 //thickness=0.36 //x=43.78 //y=1.92 //x2=43.78 //y2=2.625
r990 (  11 13 ) resistor r=0.0698411 //w=0.17 //l=0.120208 //layer=m1 \
 //thickness=0.36 //x=43.695 //y=1.835 //x2=43.78 //y2=1.92
r991 (  11 12 ) resistor r=0.257634 //w=0.131 //l=0.27 //layer=m1 \
 //thickness=0.36 //x=43.695 //y=1.835 //x2=43.425 //y2=1.835
r992 (  10 34 ) resistor r=0.0257089 //w=0.23 //l=0.115 //layer=m1 \
 //thickness=0.36 //x=43.415 //y=5.38 //x2=43.3 //y2=5.38
r993 (  9 16 ) resistor r=0.0698411 //w=0.17 //l=0.120208 //layer=m1 \
 //thickness=0.36 //x=43.695 //y=5.38 //x2=43.78 //y2=5.295
r994 (  9 10 ) resistor r=0.267176 //w=0.131 //l=0.28 //layer=m1 \
 //thickness=0.36 //x=43.695 //y=5.38 //x2=43.415 //y2=5.38
r995 (  8 12 ) resistor r=0.0698411 //w=0.17 //l=0.120208 //layer=m1 \
 //thickness=0.36 //x=43.34 //y=1.75 //x2=43.425 //y2=1.835
r996 (  7 39 ) resistor r=0.0913624 //w=0.191 //l=0.12 //layer=m1 \
 //thickness=0.36 //x=43.34 //y=1.3 //x2=43.34 //y2=1.18
r997 (  7 8 ) resistor r=0.429389 //w=0.131 //l=0.45 //layer=m1 \
 //thickness=0.36 //x=43.34 //y=1.3 //x2=43.34 //y2=1.75
r998 (  4 31 ) resistor r=0.0227762 //w=0.219 //l=0.115 //layer=m1 \
 //thickness=0.36 //x=42.535 //y=5.38 //x2=42.42 //y2=5.38
r999 (  3 34 ) resistor r=0.0257089 //w=0.23 //l=0.115 //layer=m1 \
 //thickness=0.36 //x=43.185 //y=5.38 //x2=43.3 //y2=5.38
r1000 (  3 4 ) resistor r=0.620229 //w=0.131 //l=0.65 //layer=m1 \
 //thickness=0.36 //x=43.185 //y=5.38 //x2=42.535 //y2=5.38
ends PM_TMRDFFSNQNX1\%noxref_19

subckt PM_TMRDFFSNQNX1\%noxref_20 ( 3 8 9 11 12 14 15 16 17 18 19 20 21 22 25 \
 26 29 31 34 40 46 49 54 56 59 63 64 72 73 76 84 101 106 111 116 122 127 132 \
 133 134 135 136 137 138 139 140 141 142 143 144 145 147 153 154 155 156 160 \
 161 162 163 167 169 172 173 174 175 179 180 181 182 186 188 194 195 205 218 \
 221 223 224 )
c548 ( 221 0 ) capacitor c=0.00878249f //x=67.57 //y=1.085
c549 ( 218 0 ) capacitor c=0.0692896f //x=78.19 //y=4.885
c550 ( 205 0 ) capacitor c=0.0603371f //x=74.49 //y=2.26
c551 ( 195 0 ) capacitor c=0.0344584f //x=78.525 //y=1.39
c552 ( 194 0 ) capacitor c=0.0186809f //x=78.525 //y=1.045
c553 ( 188 0 ) capacitor c=0.0141797f //x=78.37 //y=1.545
c554 ( 186 0 ) capacitor c=0.0158553f //x=78.37 //y=0.89
c555 ( 182 0 ) capacitor c=0.103881f //x=77.995 //y=2.095
c556 ( 181 0 ) capacitor c=0.0227978f //x=77.995 //y=1.7
c557 ( 180 0 ) capacitor c=0.0234352f //x=77.995 //y=1.39
c558 ( 179 0 ) capacitor c=0.0198759f //x=77.995 //y=1.045
c559 ( 175 0 ) capacitor c=0.0318956f //x=75.195 //y=1.39
c560 ( 174 0 ) capacitor c=0.0186809f //x=75.195 //y=1.045
c561 ( 173 0 ) capacitor c=0.0624333f //x=74.835 //y=4.975
c562 ( 172 0 ) capacitor c=0.0375163f //x=75.125 //y=4.975
c563 ( 169 0 ) capacitor c=0.0157936f //x=75.04 //y=1.545
c564 ( 167 0 ) capacitor c=0.0158553f //x=75.04 //y=0.89
c565 ( 163 0 ) capacitor c=0.0302441f //x=74.665 //y=2.095
c566 ( 162 0 ) capacitor c=0.0238107f //x=74.665 //y=1.7
c567 ( 161 0 ) capacitor c=0.0234359f //x=74.665 //y=1.39
c568 ( 160 0 ) capacitor c=0.0199332f //x=74.665 //y=1.045
c569 ( 156 0 ) capacitor c=0.0595747f //x=70.325 //y=4.97
c570 ( 155 0 ) capacitor c=0.0376642f //x=70.615 //y=4.97
c571 ( 154 0 ) capacitor c=0.0346489f //x=70.28 //y=1.4
c572 ( 153 0 ) capacitor c=0.018692f //x=70.28 //y=1.055
c573 ( 147 0 ) capacitor c=0.0137077f //x=70.125 //y=1.555
c574 ( 145 0 ) capacitor c=0.0158585f //x=70.125 //y=0.9
c575 ( 144 0 ) capacitor c=0.103534f //x=69.75 //y=2.095
c576 ( 143 0 ) capacitor c=0.0229444f //x=69.75 //y=1.71
c577 ( 142 0 ) capacitor c=0.0234359f //x=69.75 //y=1.4
c578 ( 141 0 ) capacitor c=0.019815f //x=69.75 //y=1.055
c579 ( 140 0 ) capacitor c=0.110525f //x=78.52 //y=6.205
c580 ( 139 0 ) capacitor c=0.154978f //x=78.08 //y=6.205
c581 ( 138 0 ) capacitor c=0.110282f //x=75.2 //y=6.205
c582 ( 137 0 ) capacitor c=0.155219f //x=74.76 //y=6.205
c583 ( 136 0 ) capacitor c=0.110208f //x=70.69 //y=6.2
c584 ( 135 0 ) capacitor c=0.158957f //x=70.25 //y=6.2
c585 ( 127 0 ) capacitor c=0.0156727f //x=78.19 //y=4.62
c586 ( 122 0 ) capacitor c=0.00126053f //x=78.19 //y=2.26
c587 ( 116 0 ) capacitor c=0.0130807f //x=74.49 //y=4.62
c588 ( 111 0 ) capacitor c=8.37642e-19 //x=74.49 //y=2.26
c589 ( 106 0 ) capacitor c=0.0014751f //x=70.05 //y=4.88
c590 ( 101 0 ) capacitor c=0.0012618f //x=70.05 //y=2.26
c591 ( 84 0 ) capacitor c=0.0322017f //x=67.72 //y=5.56
c592 ( 76 0 ) capacitor c=0.0290435f //x=66.84 //y=5.56
c593 ( 73 0 ) capacitor c=0.0723121f //x=78.035 //y=4.64
c594 ( 72 0 ) capacitor c=0.00642399f //x=78.195 //y=4.64
c595 ( 64 0 ) capacitor c=0.00644903f //x=70.05 //y=4.62
c596 ( 63 0 ) capacitor c=0.00390716f //x=68.355 //y=4.635
c597 ( 59 0 ) capacitor c=0.00609426f //x=74.655 //y=4.62
c598 ( 56 0 ) capacitor c=0.104011f //x=74.335 //y=4.62
c599 ( 54 0 ) capacitor c=0.0477518f //x=69.89 //y=4.62
c600 ( 49 0 ) capacitor c=0.0127992f //x=78.19 //y=4.62
c601 ( 46 0 ) capacitor c=0.0138664f //x=74.49 //y=4.62
c602 ( 40 0 ) capacitor c=0.00883171f //x=70.05 //y=4.835
c603 ( 34 0 ) capacitor c=0.0146097f //x=68.2 //y=4.62
c604 ( 31 0 ) capacitor c=0.0113436f //x=67.76 //y=1.18
c605 ( 29 0 ) capacitor c=5.78613e-19 //x=67.72 //y=5.56
c606 ( 26 0 ) capacitor c=0.0112509f //x=67.72 //y=5.38
c607 ( 25 0 ) capacitor c=0.00911838f //x=66.84 //y=5.56
c608 ( 22 0 ) capacitor c=0.0770318f //x=78.19 //y=4.475
c609 ( 21 0 ) capacitor c=0.00888199f //x=78.19 //y=2.385
c610 ( 20 0 ) capacitor c=0.0557599f //x=74.49 //y=4.46
c611 ( 19 0 ) capacitor c=0.00562527f //x=74.49 //y=2.375
c612 ( 18 0 ) capacitor c=0.0704546f //x=70.05 //y=4.675
c613 ( 17 0 ) capacitor c=0.00492791f //x=70.05 //y=2.375
c614 ( 16 0 ) capacitor c=0.0133989f //x=68.2 //y=5.295
c615 ( 15 0 ) capacitor c=0.0133876f //x=68.2 //y=4.795
c616 ( 14 0 ) capacitor c=0.0694782f //x=68.2 //y=4.475
c617 ( 12 0 ) capacitor c=0.00469281f //x=67.845 //y=1.835
c618 ( 11 0 ) capacitor c=0.0121291f //x=68.115 //y=1.835
c619 ( 9 0 ) capacitor c=0.0111758f //x=68.115 //y=5.38
c620 ( 8 0 ) capacitor c=0.0133876f //x=67.76 //y=1.75
c621 ( 3 0 ) capacitor c=0.0150508f //x=67.605 //y=5.38
r622 (  216 218 ) resistor r=22.7554 //w=0.233 //l=0.11 //layer=ply \
 //thickness=0.18 //x=78.08 //y=4.885 //x2=78.19 //y2=4.885
r623 (  195 220 ) resistor r=45.1352 //w=0.168 //l=0.173853 //layer=ply \
 //thickness=0.18 //x=78.525 //y=1.39 //x2=78.485 //y2=1.545
r624 (  194 219 ) resistor r=45.1352 //w=0.168 //l=0.173853 //layer=ply \
 //thickness=0.18 //x=78.525 //y=1.045 //x2=78.485 //y2=0.89
r625 (  194 195 ) resistor r=176.904 //w=0.094 //l=0.345 //layer=ply \
 //thickness=0.18 //x=78.525 //y=1.045 //x2=78.525 //y2=1.39
r626 (  191 218 ) resistor r=68.2661 //w=0.233 //l=0.404166 //layer=ply \
 //thickness=0.18 //x=78.52 //y=5.05 //x2=78.19 //y2=4.885
r627 (  189 215 ) resistor r=10.701 //w=0.21 //l=0.115 //layer=ply \
 //thickness=0.18 //x=78.15 //y=1.545 //x2=78.035 //y2=1.545
r628 (  188 220 ) resistor r=5.52526 //w=0.168 //l=0.115 //layer=ply \
 //thickness=0.18 //x=78.37 //y=1.545 //x2=78.485 //y2=1.545
r629 (  187 214 ) resistor r=5.52526 //w=0.168 //l=0.115 //layer=ply \
 //thickness=0.18 //x=78.15 //y=0.89 //x2=78.035 //y2=0.89
r630 (  186 219 ) resistor r=5.52526 //w=0.168 //l=0.115 //layer=ply \
 //thickness=0.18 //x=78.37 //y=0.89 //x2=78.485 //y2=0.89
r631 (  186 187 ) resistor r=112.809 //w=0.094 //l=0.22 //layer=ply \
 //thickness=0.18 //x=78.37 //y=0.89 //x2=78.15 //y2=0.89
r632 (  183 216 ) resistor r=13.0941 //w=0.233 //l=0.165 //layer=ply \
 //thickness=0.18 //x=78.08 //y=5.05 //x2=78.08 //y2=4.885
r633 (  182 213 ) resistor r=34.8111 //w=0.27 //l=0.264953 //layer=ply \
 //thickness=0.18 //x=77.995 //y=2.095 //x2=78.19 //y2=2.26
r634 (  181 215 ) resistor r=39.5823 //w=0.21 //l=0.173853 //layer=ply \
 //thickness=0.18 //x=77.995 //y=1.7 //x2=78.035 //y2=1.545
r635 (  181 182 ) resistor r=202.543 //w=0.094 //l=0.395 //layer=ply \
 //thickness=0.18 //x=77.995 //y=1.7 //x2=77.995 //y2=2.095
r636 (  180 215 ) resistor r=39.5823 //w=0.21 //l=0.173853 //layer=ply \
 //thickness=0.18 //x=77.995 //y=1.39 //x2=78.035 //y2=1.545
r637 (  179 214 ) resistor r=45.1352 //w=0.168 //l=0.173853 //layer=ply \
 //thickness=0.18 //x=77.995 //y=1.045 //x2=78.035 //y2=0.89
r638 (  179 180 ) resistor r=176.904 //w=0.094 //l=0.345 //layer=ply \
 //thickness=0.18 //x=77.995 //y=1.045 //x2=77.995 //y2=1.39
r639 (  175 211 ) resistor r=45.1352 //w=0.168 //l=0.173853 //layer=ply \
 //thickness=0.18 //x=75.195 //y=1.39 //x2=75.155 //y2=1.545
r640 (  174 210 ) resistor r=45.1352 //w=0.168 //l=0.173853 //layer=ply \
 //thickness=0.18 //x=75.195 //y=1.045 //x2=75.155 //y2=0.89
r641 (  174 175 ) resistor r=176.904 //w=0.094 //l=0.345 //layer=ply \
 //thickness=0.18 //x=75.195 //y=1.045 //x2=75.195 //y2=1.39
r642 (  172 176 ) resistor r=26.9307 //w=0.15 //l=0.106066 //layer=ply \
 //thickness=0.18 //x=75.125 //y=4.975 //x2=75.2 //y2=5.05
r643 (  172 173 ) resistor r=148.702 //w=0.094 //l=0.29 //layer=ply \
 //thickness=0.18 //x=75.125 //y=4.975 //x2=74.835 //y2=4.975
r644 (  170 209 ) resistor r=10.701 //w=0.21 //l=0.115 //layer=ply \
 //thickness=0.18 //x=74.82 //y=1.545 //x2=74.705 //y2=1.545
r645 (  169 211 ) resistor r=5.52526 //w=0.168 //l=0.115 //layer=ply \
 //thickness=0.18 //x=75.04 //y=1.545 //x2=75.155 //y2=1.545
r646 (  168 208 ) resistor r=5.52526 //w=0.168 //l=0.115 //layer=ply \
 //thickness=0.18 //x=74.82 //y=0.89 //x2=74.705 //y2=0.89
r647 (  167 210 ) resistor r=5.52526 //w=0.168 //l=0.115 //layer=ply \
 //thickness=0.18 //x=75.04 //y=0.89 //x2=75.155 //y2=0.89
r648 (  167 168 ) resistor r=112.809 //w=0.094 //l=0.22 //layer=ply \
 //thickness=0.18 //x=75.04 //y=0.89 //x2=74.82 //y2=0.89
r649 (  164 173 ) resistor r=22.1787 //w=0.252 //l=0.106066 //layer=ply \
 //thickness=0.18 //x=74.76 //y=5.05 //x2=74.835 //y2=4.975
r650 (  164 207 ) resistor r=51.6429 //w=0.252 //l=0.34271 //layer=ply \
 //thickness=0.18 //x=74.76 //y=5.05 //x2=74.49 //y2=4.885
r651 (  163 205 ) resistor r=30.4513 //w=0.277 //l=0.243926 //layer=ply \
 //thickness=0.18 //x=74.665 //y=2.095 //x2=74.49 //y2=2.26
r652 (  162 209 ) resistor r=39.5823 //w=0.21 //l=0.173853 //layer=ply \
 //thickness=0.18 //x=74.665 //y=1.7 //x2=74.705 //y2=1.545
r653 (  162 163 ) resistor r=202.543 //w=0.094 //l=0.395 //layer=ply \
 //thickness=0.18 //x=74.665 //y=1.7 //x2=74.665 //y2=2.095
r654 (  161 209 ) resistor r=39.5823 //w=0.21 //l=0.173853 //layer=ply \
 //thickness=0.18 //x=74.665 //y=1.39 //x2=74.705 //y2=1.545
r655 (  160 208 ) resistor r=45.1352 //w=0.168 //l=0.173853 //layer=ply \
 //thickness=0.18 //x=74.665 //y=1.045 //x2=74.705 //y2=0.89
r656 (  160 161 ) resistor r=176.904 //w=0.094 //l=0.345 //layer=ply \
 //thickness=0.18 //x=74.665 //y=1.045 //x2=74.665 //y2=1.39
r657 (  155 157 ) resistor r=26.9307 //w=0.15 //l=0.106066 //layer=ply \
 //thickness=0.18 //x=70.615 //y=4.97 //x2=70.69 //y2=5.045
r658 (  155 156 ) resistor r=148.702 //w=0.094 //l=0.29 //layer=ply \
 //thickness=0.18 //x=70.615 //y=4.97 //x2=70.325 //y2=4.97
r659 (  154 203 ) resistor r=45.1352 //w=0.168 //l=0.173853 //layer=ply \
 //thickness=0.18 //x=70.28 //y=1.4 //x2=70.24 //y2=1.555
r660 (  153 202 ) resistor r=45.1352 //w=0.168 //l=0.173853 //layer=ply \
 //thickness=0.18 //x=70.28 //y=1.055 //x2=70.24 //y2=0.9
r661 (  153 154 ) resistor r=176.904 //w=0.094 //l=0.345 //layer=ply \
 //thickness=0.18 //x=70.28 //y=1.055 //x2=70.28 //y2=1.4
r662 (  150 156 ) resistor r=22.7971 //w=0.269 //l=0.106066 //layer=ply \
 //thickness=0.18 //x=70.25 //y=5.045 //x2=70.325 //y2=4.97
r663 (  150 201 ) resistor r=35.8364 //w=0.269 //l=0.270185 //layer=ply \
 //thickness=0.18 //x=70.25 //y=5.045 //x2=70.05 //y2=4.88
r664 (  148 197 ) resistor r=10.701 //w=0.21 //l=0.115 //layer=ply \
 //thickness=0.18 //x=69.905 //y=1.555 //x2=69.79 //y2=1.555
r665 (  147 203 ) resistor r=5.52526 //w=0.168 //l=0.115 //layer=ply \
 //thickness=0.18 //x=70.125 //y=1.555 //x2=70.24 //y2=1.555
r666 (  146 196 ) resistor r=5.52526 //w=0.168 //l=0.115 //layer=ply \
 //thickness=0.18 //x=69.905 //y=0.9 //x2=69.79 //y2=0.9
r667 (  145 202 ) resistor r=5.52526 //w=0.168 //l=0.115 //layer=ply \
 //thickness=0.18 //x=70.125 //y=0.9 //x2=70.24 //y2=0.9
r668 (  145 146 ) resistor r=112.809 //w=0.094 //l=0.22 //layer=ply \
 //thickness=0.18 //x=70.125 //y=0.9 //x2=69.905 //y2=0.9
r669 (  144 199 ) resistor r=58.7805 //w=0.246 //l=0.373497 //layer=ply \
 //thickness=0.18 //x=69.75 //y=2.095 //x2=70.05 //y2=2.26
r670 (  143 197 ) resistor r=39.5823 //w=0.21 //l=0.173853 //layer=ply \
 //thickness=0.18 //x=69.75 //y=1.71 //x2=69.79 //y2=1.555
r671 (  143 144 ) resistor r=197.415 //w=0.094 //l=0.385 //layer=ply \
 //thickness=0.18 //x=69.75 //y=1.71 //x2=69.75 //y2=2.095
r672 (  142 197 ) resistor r=39.5823 //w=0.21 //l=0.173853 //layer=ply \
 //thickness=0.18 //x=69.75 //y=1.4 //x2=69.79 //y2=1.555
r673 (  141 196 ) resistor r=45.1352 //w=0.168 //l=0.173853 //layer=ply \
 //thickness=0.18 //x=69.75 //y=1.055 //x2=69.79 //y2=0.9
r674 (  141 142 ) resistor r=176.904 //w=0.094 //l=0.345 //layer=ply \
 //thickness=0.18 //x=69.75 //y=1.055 //x2=69.75 //y2=1.4
r675 (  140 191 ) resistor r=592.245 //w=0.094 //l=1.155 //layer=ply \
 //thickness=0.18 //x=78.52 //y=6.205 //x2=78.52 //y2=5.05
r676 (  139 183 ) resistor r=592.245 //w=0.094 //l=1.155 //layer=ply \
 //thickness=0.18 //x=78.08 //y=6.205 //x2=78.08 //y2=5.05
r677 (  138 176 ) resistor r=592.245 //w=0.094 //l=1.155 //layer=ply \
 //thickness=0.18 //x=75.2 //y=6.205 //x2=75.2 //y2=5.05
r678 (  137 164 ) resistor r=592.245 //w=0.094 //l=1.155 //layer=ply \
 //thickness=0.18 //x=74.76 //y=6.205 //x2=74.76 //y2=5.05
r679 (  136 157 ) resistor r=592.245 //w=0.094 //l=1.155 //layer=ply \
 //thickness=0.18 //x=70.69 //y=6.2 //x2=70.69 //y2=5.045
r680 (  135 150 ) resistor r=592.245 //w=0.094 //l=1.155 //layer=ply \
 //thickness=0.18 //x=70.25 //y=6.2 //x2=70.25 //y2=5.045
r681 (  134 188 ) resistor r=56.4043 //w=0.094 //l=0.11 //layer=ply \
 //thickness=0.18 //x=78.26 //y=1.545 //x2=78.37 //y2=1.545
r682 (  134 189 ) resistor r=56.4043 //w=0.094 //l=0.11 //layer=ply \
 //thickness=0.18 //x=78.26 //y=1.545 //x2=78.15 //y2=1.545
r683 (  133 169 ) resistor r=56.4043 //w=0.094 //l=0.11 //layer=ply \
 //thickness=0.18 //x=74.93 //y=1.545 //x2=75.04 //y2=1.545
r684 (  133 170 ) resistor r=56.4043 //w=0.094 //l=0.11 //layer=ply \
 //thickness=0.18 //x=74.93 //y=1.545 //x2=74.82 //y2=1.545
r685 (  132 147 ) resistor r=56.4043 //w=0.094 //l=0.11 //layer=ply \
 //thickness=0.18 //x=70.015 //y=1.555 //x2=70.125 //y2=1.555
r686 (  132 148 ) resistor r=56.4043 //w=0.094 //l=0.11 //layer=ply \
 //thickness=0.18 //x=70.015 //y=1.555 //x2=69.905 //y2=1.555
r687 (  130 218 ) resistor r=152 //w=0.17 //l=0.17 //layer=licon //count=1 \
 //x=78.19 //y=4.885 //x2=78.19 //y2=4.885
r688 (  127 130 ) resistor r=18.139 //w=0.187 //l=0.265 //layer=li \
 //thickness=0.1 //x=78.19 //y=4.62 //x2=78.19 //y2=4.885
r689 (  122 213 ) resistor r=152 //w=0.17 //l=0.17 //layer=licon //count=1 \
 //x=78.19 //y=2.26 //x2=78.19 //y2=2.26
r690 (  119 207 ) resistor r=152 //w=0.17 //l=0.17 //layer=licon //count=1 \
 //x=74.49 //y=4.885 //x2=74.49 //y2=4.885
r691 (  116 119 ) resistor r=18.139 //w=0.187 //l=0.265 //layer=li \
 //thickness=0.1 //x=74.49 //y=4.62 //x2=74.49 //y2=4.885
r692 (  111 205 ) resistor r=152 //w=0.17 //l=0.17 //layer=licon //count=1 \
 //x=74.49 //y=2.26 //x2=74.49 //y2=2.26
r693 (  106 201 ) resistor r=152 //w=0.17 //l=0.17 //layer=licon //count=1 \
 //x=70.05 //y=4.88 //x2=70.05 //y2=4.88
r694 (  101 199 ) resistor r=152 //w=0.17 //l=0.17 //layer=licon //count=1 \
 //x=70.05 //y=2.26 //x2=70.05 //y2=2.26
r695 (  84 224 ) resistor r=23.615 //w=0.187 //l=0.345 //layer=li \
 //thickness=0.1 //x=67.72 //y=5.56 //x2=67.72 //y2=5.905
r696 (  76 223 ) resistor r=23.615 //w=0.187 //l=0.345 //layer=li \
 //thickness=0.1 //x=66.84 //y=5.56 //x2=66.84 //y2=5.905
r697 (  72 73 ) resistor r=0.10734 //w=0.281 //l=0.16 //layer=m2 \
 //thickness=0.36 //x=78.195 //y=4.64 //x2=78.035 //y2=4.64
r698 (  64 67 ) resistor r=0.0956406 //w=0.281 //l=0.215 //layer=m2 \
 //thickness=0.36 //x=70.05 //y=4.62 //x2=70.05 //y2=4.835
r699 (  61 63 ) resistor r=0.10734 //w=0.281 //l=0.16 //layer=m2 \
 //thickness=0.36 //x=68.195 //y=4.635 //x2=68.355 //y2=4.635
r700 (  59 70 ) resistor r=0.10734 //w=0.281 //l=0.16 //layer=m2 \
 //thickness=0.36 //x=74.655 //y=4.62 //x2=74.495 //y2=4.62
r701 (  59 73 ) resistor r=3.22519 //w=0.131 //l=3.38 //layer=m2 \
 //thickness=0.36 //x=74.655 //y=4.62 //x2=78.035 //y2=4.62
r702 (  57 64 ) resistor r=0.0455071 //w=0.32 //l=0.16 //layer=m2 \
 //thickness=0.36 //x=70.21 //y=4.62 //x2=70.05 //y2=4.62
r703 (  56 70 ) resistor r=0.10734 //w=0.281 //l=0.16 //layer=m2 \
 //thickness=0.36 //x=74.335 //y=4.62 //x2=74.495 //y2=4.62
r704 (  56 57 ) resistor r=3.93607 //w=0.131 //l=4.125 //layer=m2 \
 //thickness=0.36 //x=74.335 //y=4.62 //x2=70.21 //y2=4.62
r705 (  54 64 ) resistor r=0.0455071 //w=0.32 //l=0.16 //layer=m2 \
 //thickness=0.36 //x=69.89 //y=4.62 //x2=70.05 //y2=4.62
r706 (  54 63 ) resistor r=1.46469 //w=0.131 //l=1.535 //layer=m2 \
 //thickness=0.36 //x=69.89 //y=4.62 //x2=68.355 //y2=4.62
r707 (  53 122 ) resistor r=9.3 //w=0.17 //l=0.17 //layer=mcon //count=1 \
 //x=78.19 //y=2.26 //x2=78.19 //y2=2.26
r708 (  51 72 ) resistor r=4.5 //w=0.15 //l=0.15 //layer=via1 //count=1 \
 //x=78.195 //y=4.64 //x2=78.195 //y2=4.64
r709 (  49 127 ) resistor r=9.3 //w=0.17 //l=0.17 //layer=mcon //count=1 \
 //x=78.19 //y=4.62 //x2=78.19 //y2=4.62
r710 (  49 51 ) resistor r=0.00659631 //w=0.379 //l=0.02 //layer=m1 \
 //thickness=0.36 //x=78.14 //y=4.62 //x2=78.14 //y2=4.64
r711 (  46 116 ) resistor r=9.3 //w=0.17 //l=0.17 //layer=mcon //count=1 \
 //x=74.49 //y=4.62 //x2=74.49 //y2=4.62
r712 (  46 70 ) resistor r=4.5 //w=0.15 //l=0.15 //layer=via1 //count=1 \
 //x=74.495 //y=4.62 //x2=74.495 //y2=4.62
r713 (  44 111 ) resistor r=9.3 //w=0.17 //l=0.17 //layer=mcon //count=1 \
 //x=74.49 //y=2.26 //x2=74.49 //y2=2.26
r714 (  42 106 ) resistor r=9.3 //w=0.17 //l=0.17 //layer=mcon //count=1 \
 //x=70.05 //y=4.88 //x2=70.05 //y2=4.88
r715 (  40 67 ) resistor r=4.5 //w=0.15 //l=0.15 //layer=via1 //count=1 \
 //x=70.05 //y=4.835 //x2=70.05 //y2=4.835
r716 (  40 42 ) resistor r=0.0180288 //w=0.312 //l=0.045 //layer=m1 \
 //thickness=0.36 //x=70.05 //y=4.835 //x2=70.05 //y2=4.88
r717 (  38 101 ) resistor r=9.3 //w=0.17 //l=0.17 //layer=mcon //count=1 \
 //x=70.05 //y=2.26 //x2=70.05 //y2=2.26
r718 (  36 61 ) resistor r=4.5 //w=0.15 //l=0.15 //layer=via1 //count=1 \
 //x=68.195 //y=4.635 //x2=68.195 //y2=4.635
r719 (  34 36 ) resistor r=0.00494723 //w=0.379 //l=0.015 //layer=m1 \
 //thickness=0.36 //x=68.25 //y=4.62 //x2=68.25 //y2=4.635
r720 (  31 221 ) resistor r=9.3 //w=0.17 //l=0.17 //layer=mcon //count=1 \
 //x=67.76 //y=1.18 //x2=67.76 //y2=1.18
r721 (  29 84 ) resistor r=9.3 //w=0.17 //l=0.17 //layer=mcon //count=1 \
 //x=67.72 //y=5.56 //x2=67.72 //y2=5.56
r722 (  26 29 ) resistor r=0.117801 //w=0.191 //l=0.18 //layer=m1 \
 //thickness=0.36 //x=67.72 //y=5.38 //x2=67.72 //y2=5.56
r723 (  25 76 ) resistor r=9.3 //w=0.17 //l=0.17 //layer=mcon //count=1 \
 //x=66.84 //y=5.56 //x2=66.84 //y2=5.56
r724 (  23 25 ) resistor r=0.10274 //w=0.219 //l=0.18 //layer=m1 \
 //thickness=0.36 //x=66.84 //y=5.38 //x2=66.84 //y2=5.56
r725 (  22 49 ) resistor r=0.0863342 //w=0.379 //l=0.168152 //layer=m1 \
 //thickness=0.36 //x=78.19 //y=4.475 //x2=78.14 //y2=4.62
r726 (  21 53 ) resistor r=0.0761125 //w=0.237 //l=0.126491 //layer=m1 \
 //thickness=0.36 //x=78.19 //y=2.385 //x2=78.187 //y2=2.26
r727 (  21 22 ) resistor r=1.99427 //w=0.131 //l=2.09 //layer=m1 \
 //thickness=0.36 //x=78.19 //y=2.385 //x2=78.19 //y2=4.475
r728 (  20 46 ) resistor r=0.0898201 //w=0.322 //l=0.185472 //layer=m1 \
 //thickness=0.36 //x=74.49 //y=4.46 //x2=74.545 //y2=4.62
r729 (  19 44 ) resistor r=0.0717383 //w=0.224 //l=0.115 //layer=m1 \
 //thickness=0.36 //x=74.49 //y=2.375 //x2=74.49 //y2=2.26
r730 (  19 20 ) resistor r=1.9895 //w=0.131 //l=2.085 //layer=m1 \
 //thickness=0.36 //x=74.49 //y=2.375 //x2=74.49 //y2=4.46
r731 (  18 40 ) resistor r=0.0898137 //w=0.312 //l=0.16 //layer=m1 \
 //thickness=0.36 //x=70.05 //y=4.675 //x2=70.05 //y2=4.835
r732 (  17 38 ) resistor r=0.0719237 //w=0.222 //l=0.115 //layer=m1 \
 //thickness=0.36 //x=70.05 //y=2.375 //x2=70.05 //y2=2.26
r733 (  17 18 ) resistor r=2.19466 //w=0.131 //l=2.3 //layer=m1 \
 //thickness=0.36 //x=70.05 //y=2.375 //x2=70.05 //y2=4.675
r734 (  15 36 ) resistor r=0.0912814 //w=0.379 //l=0.183303 //layer=m1 \
 //thickness=0.36 //x=68.2 //y=4.795 //x2=68.25 //y2=4.635
r735 (  15 16 ) resistor r=0.477099 //w=0.131 //l=0.5 //layer=m1 \
 //thickness=0.36 //x=68.2 //y=4.795 //x2=68.2 //y2=5.295
r736 (  14 34 ) resistor r=0.0863342 //w=0.379 //l=0.168152 //layer=m1 \
 //thickness=0.36 //x=68.2 //y=4.475 //x2=68.25 //y2=4.62
r737 (  13 14 ) resistor r=2.43798 //w=0.131 //l=2.555 //layer=m1 \
 //thickness=0.36 //x=68.2 //y=1.92 //x2=68.2 //y2=4.475
r738 (  11 13 ) resistor r=0.0698411 //w=0.17 //l=0.120208 //layer=m1 \
 //thickness=0.36 //x=68.115 //y=1.835 //x2=68.2 //y2=1.92
r739 (  11 12 ) resistor r=0.257634 //w=0.131 //l=0.27 //layer=m1 \
 //thickness=0.36 //x=68.115 //y=1.835 //x2=67.845 //y2=1.835
r740 (  10 26 ) resistor r=0.0257089 //w=0.23 //l=0.115 //layer=m1 \
 //thickness=0.36 //x=67.835 //y=5.38 //x2=67.72 //y2=5.38
r741 (  9 16 ) resistor r=0.0698411 //w=0.17 //l=0.120208 //layer=m1 \
 //thickness=0.36 //x=68.115 //y=5.38 //x2=68.2 //y2=5.295
r742 (  9 10 ) resistor r=0.267176 //w=0.131 //l=0.28 //layer=m1 \
 //thickness=0.36 //x=68.115 //y=5.38 //x2=67.835 //y2=5.38
r743 (  8 12 ) resistor r=0.0698411 //w=0.17 //l=0.120208 //layer=m1 \
 //thickness=0.36 //x=67.76 //y=1.75 //x2=67.845 //y2=1.835
r744 (  7 31 ) resistor r=0.0913624 //w=0.191 //l=0.12 //layer=m1 \
 //thickness=0.36 //x=67.76 //y=1.3 //x2=67.76 //y2=1.18
r745 (  7 8 ) resistor r=0.429389 //w=0.131 //l=0.45 //layer=m1 \
 //thickness=0.36 //x=67.76 //y=1.3 //x2=67.76 //y2=1.75
r746 (  4 23 ) resistor r=0.0227762 //w=0.219 //l=0.115 //layer=m1 \
 //thickness=0.36 //x=66.955 //y=5.38 //x2=66.84 //y2=5.38
r747 (  3 26 ) resistor r=0.0257089 //w=0.23 //l=0.115 //layer=m1 \
 //thickness=0.36 //x=67.605 //y=5.38 //x2=67.72 //y2=5.38
r748 (  3 4 ) resistor r=0.620229 //w=0.131 //l=0.65 //layer=m1 \
 //thickness=0.36 //x=67.605 //y=5.38 //x2=66.955 //y2=5.38
ends PM_TMRDFFSNQNX1\%noxref_20

subckt PM_TMRDFFSNQNX1\%noxref_21 ( 3 8 9 11 12 14 15 16 17 18 19 20 21 22 23 \
 24 25 26 29 30 33 35 40 44 52 65 67 68 69 71 73 75 77 79 81 83 85 87 89 91 93 \
 95 97 99 106 114 116 117 120 128 145 154 159 168 173 178 182 183 184 185 186 \
 187 188 189 190 191 192 193 194 195 197 203 204 205 206 213 214 215 216 217 \
 219 222 225 226 227 228 229 230 231 232 236 238 241 242 243 244 265 272 274 \
 275 )
c757 ( 272 0 ) capacitor c=0.00878249f //x=18.73 //y=1.085
c758 ( 265 0 ) capacitor c=0.0586737f //x=81.15 //y=2.26
c759 ( 244 0 ) capacitor c=0.0318956f //x=81.855 //y=1.39
c760 ( 243 0 ) capacitor c=0.0186809f //x=81.855 //y=1.045
c761 ( 242 0 ) capacitor c=0.0659968f //x=81.495 //y=4.975
c762 ( 241 0 ) capacitor c=0.0373387f //x=81.785 //y=4.975
c763 ( 238 0 ) capacitor c=0.0157936f //x=81.7 //y=1.545
c764 ( 236 0 ) capacitor c=0.0158553f //x=81.7 //y=0.89
c765 ( 232 0 ) capacitor c=0.0302441f //x=81.325 //y=2.095
c766 ( 231 0 ) capacitor c=0.0238107f //x=81.325 //y=1.7
c767 ( 230 0 ) capacitor c=0.0234359f //x=81.325 //y=1.39
c768 ( 229 0 ) capacitor c=0.0199332f //x=81.325 //y=1.045
c769 ( 228 0 ) capacitor c=0.0955672f //x=79.495 //y=2.095
c770 ( 227 0 ) capacitor c=0.0251353f //x=79.495 //y=1.74
c771 ( 226 0 ) capacitor c=0.0234318f //x=79.495 //y=1.43
c772 ( 225 0 ) capacitor c=0.0192547f //x=79.495 //y=1.085
c773 ( 222 0 ) capacitor c=0.0714656f //x=79.4 //y=5.05
c774 ( 219 0 ) capacitor c=0.0186579f //x=79.34 //y=1.585
c775 ( 217 0 ) capacitor c=0.0157803f //x=79.34 //y=0.93
c776 ( 216 0 ) capacitor c=0.0134011f //x=79.035 //y=4.975
c777 ( 215 0 ) capacitor c=0.0243282f //x=79.325 //y=4.975
c778 ( 214 0 ) capacitor c=0.0364928f //x=78.965 //y=1.43
c779 ( 213 0 ) capacitor c=0.0174823f //x=78.965 //y=1.085
c780 ( 206 0 ) capacitor c=0.0612936f //x=21.485 //y=4.97
c781 ( 205 0 ) capacitor c=0.0376642f //x=21.775 //y=4.97
c782 ( 204 0 ) capacitor c=0.0346489f //x=21.44 //y=1.4
c783 ( 203 0 ) capacitor c=0.018692f //x=21.44 //y=1.055
c784 ( 197 0 ) capacitor c=0.0137077f //x=21.285 //y=1.555
c785 ( 195 0 ) capacitor c=0.0158585f //x=21.285 //y=0.9
c786 ( 194 0 ) capacitor c=0.101002f //x=20.91 //y=2.095
c787 ( 193 0 ) capacitor c=0.0229444f //x=20.91 //y=1.71
c788 ( 192 0 ) capacitor c=0.0234359f //x=20.91 //y=1.4
c789 ( 191 0 ) capacitor c=0.019815f //x=20.91 //y=1.055
c790 ( 190 0 ) capacitor c=0.11081f //x=81.86 //y=6.205
c791 ( 189 0 ) capacitor c=0.154997f //x=81.42 //y=6.205
c792 ( 188 0 ) capacitor c=0.155934f //x=79.4 //y=6.205
c793 ( 187 0 ) capacitor c=0.110593f //x=78.96 //y=6.205
c794 ( 186 0 ) capacitor c=0.110208f //x=21.85 //y=6.2
c795 ( 185 0 ) capacitor c=0.158957f //x=21.41 //y=6.2
c796 ( 178 0 ) capacitor c=7.7962e-19 //x=81.15 //y=4.885
c797 ( 173 0 ) capacitor c=7.89145e-19 //x=81.15 //y=2.26
c798 ( 168 0 ) capacitor c=7.79163e-19 //x=79.67 //y=4.885
c799 ( 159 0 ) capacitor c=7.43216e-19 //x=79.67 //y=2.26
c800 ( 154 0 ) capacitor c=0.0014751f //x=21.21 //y=4.88
c801 ( 145 0 ) capacitor c=0.0012618f //x=21.21 //y=2.26
c802 ( 128 0 ) capacitor c=0.0322017f //x=18.88 //y=5.56
c803 ( 120 0 ) capacitor c=0.0290435f //x=18 //y=5.56
c804 ( 117 0 ) capacitor c=0.0208859f //x=80.985 //y=2.27
c805 ( 116 0 ) capacitor c=0.00241177f //x=81.145 //y=2.27
c806 ( 114 0 ) capacitor c=0.00152439f //x=79.835 //y=2.27
c807 ( 106 0 ) capacitor c=6.30123e-19 //x=19.51 //y=3.495
c808 ( 99 0 ) capacitor c=0.126131f //x=72.485 //y=3.5
c809 ( 97 0 ) capacitor c=0.0706474f //x=71.885 //y=3.51
c810 ( 95 0 ) capacitor c=0.00702126f //x=65.08 //y=3.45
c811 ( 93 0 ) capacitor c=0.0355719f //x=64.42 //y=3.51
c812 ( 91 0 ) capacitor c=0.00501349f //x=61.015 //y=3.45
c813 ( 89 0 ) capacitor c=0.0439945f //x=60.41 //y=3.51
c814 ( 87 0 ) capacitor c=0.00550699f //x=56.21 //y=3.45
c815 ( 85 0 ) capacitor c=0.0676965f //x=50.655 //y=3.525
c816 ( 83 0 ) capacitor c=0.0324688f //x=50.055 //y=3.51
c817 ( 81 0 ) capacitor c=0.00537733f //x=48.065 //y=3.5
c818 ( 79 0 ) capacitor c=0.0703896f //x=47.465 //y=3.51
c819 ( 77 0 ) capacitor c=0.00679364f //x=40.66 //y=3.45
c820 ( 75 0 ) capacitor c=0.0354009f //x=40.035 //y=3.51
c821 ( 73 0 ) capacitor c=0.00519407f //x=36.595 //y=3.45
c822 ( 71 0 ) capacitor c=0.044446f //x=35.98 //y=3.51
c823 ( 69 0 ) capacitor c=0.00511869f //x=31.79 //y=3.45
c824 ( 68 0 ) capacitor c=0.0180548f //x=23.215 //y=3.5
c825 ( 67 0 ) capacitor c=0.103816f //x=23.645 //y=3.5
c826 ( 65 0 ) capacitor c=0.0193955f //x=21.045 //y=3.51
c827 ( 52 0 ) capacitor c=0.0155604f //x=79.67 //y=3.51
c828 ( 44 0 ) capacitor c=0.0171924f //x=21.21 //y=3.51
c829 ( 40 0 ) capacitor c=0.017322f //x=19.36 //y=3.51
c830 ( 35 0 ) capacitor c=0.0113436f //x=18.92 //y=1.18
c831 ( 33 0 ) capacitor c=5.78613e-19 //x=18.88 //y=5.56
c832 ( 30 0 ) capacitor c=0.0108461f //x=18.88 //y=5.38
c833 ( 29 0 ) capacitor c=0.0090176f //x=18 //y=5.56
c834 ( 26 0 ) capacitor c=0.0768092f //x=81.15 //y=4.755
c835 ( 25 0 ) capacitor c=0.00995077f //x=81.15 //y=2.43
c836 ( 24 0 ) capacitor c=0.0411607f //x=79.67 //y=4.76
c837 ( 23 0 ) capacitor c=0.0139275f //x=79.67 //y=3.665
c838 ( 22 0 ) capacitor c=0.0306526f //x=79.67 //y=3.345
c839 ( 21 0 ) capacitor c=0.0101251f //x=79.67 //y=2.43
c840 ( 20 0 ) capacitor c=0.0379175f //x=21.21 //y=4.755
c841 ( 19 0 ) capacitor c=0.0144374f //x=21.21 //y=3.655
c842 ( 18 0 ) capacitor c=0.0286508f //x=21.21 //y=3.335
c843 ( 17 0 ) capacitor c=0.00492791f //x=21.21 //y=2.375
c844 ( 16 0 ) capacitor c=0.0418114f //x=19.36 //y=5.295
c845 ( 15 0 ) capacitor c=0.0138127f //x=19.36 //y=3.655
c846 ( 14 0 ) capacitor c=0.0379957f //x=19.36 //y=3.335
c847 ( 12 0 ) capacitor c=0.00469281f //x=19.005 //y=1.835
c848 ( 11 0 ) capacitor c=0.0120601f //x=19.275 //y=1.835
c849 ( 9 0 ) capacitor c=0.0116449f //x=19.275 //y=5.38
c850 ( 8 0 ) capacitor c=0.0133876f //x=18.92 //y=1.75
c851 ( 3 0 ) capacitor c=0.0143818f //x=18.765 //y=5.38
r852 (  244 271 ) resistor r=45.1352 //w=0.168 //l=0.173853 //layer=ply \
 //thickness=0.18 //x=81.855 //y=1.39 //x2=81.815 //y2=1.545
r853 (  243 270 ) resistor r=45.1352 //w=0.168 //l=0.173853 //layer=ply \
 //thickness=0.18 //x=81.855 //y=1.045 //x2=81.815 //y2=0.89
r854 (  243 244 ) resistor r=176.904 //w=0.094 //l=0.345 //layer=ply \
 //thickness=0.18 //x=81.855 //y=1.045 //x2=81.855 //y2=1.39
r855 (  241 245 ) resistor r=26.9307 //w=0.15 //l=0.106066 //layer=ply \
 //thickness=0.18 //x=81.785 //y=4.975 //x2=81.86 //y2=5.05
r856 (  241 242 ) resistor r=148.702 //w=0.094 //l=0.29 //layer=ply \
 //thickness=0.18 //x=81.785 //y=4.975 //x2=81.495 //y2=4.975
r857 (  239 269 ) resistor r=10.701 //w=0.21 //l=0.115 //layer=ply \
 //thickness=0.18 //x=81.48 //y=1.545 //x2=81.365 //y2=1.545
r858 (  238 271 ) resistor r=5.52526 //w=0.168 //l=0.115 //layer=ply \
 //thickness=0.18 //x=81.7 //y=1.545 //x2=81.815 //y2=1.545
r859 (  237 268 ) resistor r=5.52526 //w=0.168 //l=0.115 //layer=ply \
 //thickness=0.18 //x=81.48 //y=0.89 //x2=81.365 //y2=0.89
r860 (  236 270 ) resistor r=5.52526 //w=0.168 //l=0.115 //layer=ply \
 //thickness=0.18 //x=81.7 //y=0.89 //x2=81.815 //y2=0.89
r861 (  236 237 ) resistor r=112.809 //w=0.094 //l=0.22 //layer=ply \
 //thickness=0.18 //x=81.7 //y=0.89 //x2=81.48 //y2=0.89
r862 (  233 242 ) resistor r=22.1787 //w=0.252 //l=0.106066 //layer=ply \
 //thickness=0.18 //x=81.42 //y=5.05 //x2=81.495 //y2=4.975
r863 (  233 267 ) resistor r=51.6429 //w=0.252 //l=0.34271 //layer=ply \
 //thickness=0.18 //x=81.42 //y=5.05 //x2=81.15 //y2=4.885
r864 (  232 265 ) resistor r=30.4513 //w=0.277 //l=0.243926 //layer=ply \
 //thickness=0.18 //x=81.325 //y=2.095 //x2=81.15 //y2=2.26
r865 (  231 269 ) resistor r=39.5823 //w=0.21 //l=0.173853 //layer=ply \
 //thickness=0.18 //x=81.325 //y=1.7 //x2=81.365 //y2=1.545
r866 (  231 232 ) resistor r=202.543 //w=0.094 //l=0.395 //layer=ply \
 //thickness=0.18 //x=81.325 //y=1.7 //x2=81.325 //y2=2.095
r867 (  230 269 ) resistor r=39.5823 //w=0.21 //l=0.173853 //layer=ply \
 //thickness=0.18 //x=81.325 //y=1.39 //x2=81.365 //y2=1.545
r868 (  229 268 ) resistor r=45.1352 //w=0.168 //l=0.173853 //layer=ply \
 //thickness=0.18 //x=81.325 //y=1.045 //x2=81.365 //y2=0.89
r869 (  229 230 ) resistor r=176.904 //w=0.094 //l=0.345 //layer=ply \
 //thickness=0.18 //x=81.325 //y=1.045 //x2=81.325 //y2=1.39
r870 (  228 261 ) resistor r=30.4513 //w=0.277 //l=0.243926 //layer=ply \
 //thickness=0.18 //x=79.495 //y=2.095 //x2=79.67 //y2=2.26
r871 (  227 259 ) resistor r=39.5823 //w=0.21 //l=0.173853 //layer=ply \
 //thickness=0.18 //x=79.495 //y=1.74 //x2=79.455 //y2=1.585
r872 (  227 228 ) resistor r=182.032 //w=0.094 //l=0.355 //layer=ply \
 //thickness=0.18 //x=79.495 //y=1.74 //x2=79.495 //y2=2.095
r873 (  226 259 ) resistor r=39.5823 //w=0.21 //l=0.173853 //layer=ply \
 //thickness=0.18 //x=79.495 //y=1.43 //x2=79.455 //y2=1.585
r874 (  225 258 ) resistor r=45.1352 //w=0.168 //l=0.173853 //layer=ply \
 //thickness=0.18 //x=79.495 //y=1.085 //x2=79.455 //y2=0.93
r875 (  225 226 ) resistor r=176.904 //w=0.094 //l=0.345 //layer=ply \
 //thickness=0.18 //x=79.495 //y=1.085 //x2=79.495 //y2=1.43
r876 (  222 263 ) resistor r=51.6429 //w=0.252 //l=0.34271 //layer=ply \
 //thickness=0.18 //x=79.4 //y=5.05 //x2=79.67 //y2=4.885
r877 (  220 257 ) resistor r=5.52526 //w=0.168 //l=0.115 //layer=ply \
 //thickness=0.18 //x=79.12 //y=1.585 //x2=79.005 //y2=1.585
r878 (  219 259 ) resistor r=10.701 //w=0.21 //l=0.115 //layer=ply \
 //thickness=0.18 //x=79.34 //y=1.585 //x2=79.455 //y2=1.585
r879 (  218 256 ) resistor r=5.52526 //w=0.168 //l=0.115 //layer=ply \
 //thickness=0.18 //x=79.12 //y=0.93 //x2=79.005 //y2=0.93
r880 (  217 258 ) resistor r=5.52526 //w=0.168 //l=0.115 //layer=ply \
 //thickness=0.18 //x=79.34 //y=0.93 //x2=79.455 //y2=0.93
r881 (  217 218 ) resistor r=112.809 //w=0.094 //l=0.22 //layer=ply \
 //thickness=0.18 //x=79.34 //y=0.93 //x2=79.12 //y2=0.93
r882 (  215 222 ) resistor r=22.1787 //w=0.252 //l=0.106066 //layer=ply \
 //thickness=0.18 //x=79.325 //y=4.975 //x2=79.4 //y2=5.05
r883 (  215 216 ) resistor r=148.702 //w=0.094 //l=0.29 //layer=ply \
 //thickness=0.18 //x=79.325 //y=4.975 //x2=79.035 //y2=4.975
r884 (  214 257 ) resistor r=45.1352 //w=0.168 //l=0.173853 //layer=ply \
 //thickness=0.18 //x=78.965 //y=1.43 //x2=79.005 //y2=1.585
r885 (  213 256 ) resistor r=45.1352 //w=0.168 //l=0.173853 //layer=ply \
 //thickness=0.18 //x=78.965 //y=1.085 //x2=79.005 //y2=0.93
r886 (  213 214 ) resistor r=176.904 //w=0.094 //l=0.345 //layer=ply \
 //thickness=0.18 //x=78.965 //y=1.085 //x2=78.965 //y2=1.43
r887 (  210 216 ) resistor r=26.9307 //w=0.15 //l=0.106066 //layer=ply \
 //thickness=0.18 //x=78.96 //y=5.05 //x2=79.035 //y2=4.975
r888 (  205 207 ) resistor r=26.9307 //w=0.15 //l=0.106066 //layer=ply \
 //thickness=0.18 //x=21.775 //y=4.97 //x2=21.85 //y2=5.045
r889 (  205 206 ) resistor r=148.702 //w=0.094 //l=0.29 //layer=ply \
 //thickness=0.18 //x=21.775 //y=4.97 //x2=21.485 //y2=4.97
r890 (  204 255 ) resistor r=45.1352 //w=0.168 //l=0.173853 //layer=ply \
 //thickness=0.18 //x=21.44 //y=1.4 //x2=21.4 //y2=1.555
r891 (  203 254 ) resistor r=45.1352 //w=0.168 //l=0.173853 //layer=ply \
 //thickness=0.18 //x=21.44 //y=1.055 //x2=21.4 //y2=0.9
r892 (  203 204 ) resistor r=176.904 //w=0.094 //l=0.345 //layer=ply \
 //thickness=0.18 //x=21.44 //y=1.055 //x2=21.44 //y2=1.4
r893 (  200 206 ) resistor r=22.7971 //w=0.269 //l=0.106066 //layer=ply \
 //thickness=0.18 //x=21.41 //y=5.045 //x2=21.485 //y2=4.97
r894 (  200 253 ) resistor r=35.8364 //w=0.269 //l=0.270185 //layer=ply \
 //thickness=0.18 //x=21.41 //y=5.045 //x2=21.21 //y2=4.88
r895 (  198 249 ) resistor r=10.701 //w=0.21 //l=0.115 //layer=ply \
 //thickness=0.18 //x=21.065 //y=1.555 //x2=20.95 //y2=1.555
r896 (  197 255 ) resistor r=5.52526 //w=0.168 //l=0.115 //layer=ply \
 //thickness=0.18 //x=21.285 //y=1.555 //x2=21.4 //y2=1.555
r897 (  196 248 ) resistor r=5.52526 //w=0.168 //l=0.115 //layer=ply \
 //thickness=0.18 //x=21.065 //y=0.9 //x2=20.95 //y2=0.9
r898 (  195 254 ) resistor r=5.52526 //w=0.168 //l=0.115 //layer=ply \
 //thickness=0.18 //x=21.285 //y=0.9 //x2=21.4 //y2=0.9
r899 (  195 196 ) resistor r=112.809 //w=0.094 //l=0.22 //layer=ply \
 //thickness=0.18 //x=21.285 //y=0.9 //x2=21.065 //y2=0.9
r900 (  194 251 ) resistor r=58.7805 //w=0.246 //l=0.373497 //layer=ply \
 //thickness=0.18 //x=20.91 //y=2.095 //x2=21.21 //y2=2.26
r901 (  193 249 ) resistor r=39.5823 //w=0.21 //l=0.173853 //layer=ply \
 //thickness=0.18 //x=20.91 //y=1.71 //x2=20.95 //y2=1.555
r902 (  193 194 ) resistor r=197.415 //w=0.094 //l=0.385 //layer=ply \
 //thickness=0.18 //x=20.91 //y=1.71 //x2=20.91 //y2=2.095
r903 (  192 249 ) resistor r=39.5823 //w=0.21 //l=0.173853 //layer=ply \
 //thickness=0.18 //x=20.91 //y=1.4 //x2=20.95 //y2=1.555
r904 (  191 248 ) resistor r=45.1352 //w=0.168 //l=0.173853 //layer=ply \
 //thickness=0.18 //x=20.91 //y=1.055 //x2=20.95 //y2=0.9
r905 (  191 192 ) resistor r=176.904 //w=0.094 //l=0.345 //layer=ply \
 //thickness=0.18 //x=20.91 //y=1.055 //x2=20.91 //y2=1.4
r906 (  190 245 ) resistor r=592.245 //w=0.094 //l=1.155 //layer=ply \
 //thickness=0.18 //x=81.86 //y=6.205 //x2=81.86 //y2=5.05
r907 (  189 233 ) resistor r=592.245 //w=0.094 //l=1.155 //layer=ply \
 //thickness=0.18 //x=81.42 //y=6.205 //x2=81.42 //y2=5.05
r908 (  188 222 ) resistor r=592.245 //w=0.094 //l=1.155 //layer=ply \
 //thickness=0.18 //x=79.4 //y=6.205 //x2=79.4 //y2=5.05
r909 (  187 210 ) resistor r=592.245 //w=0.094 //l=1.155 //layer=ply \
 //thickness=0.18 //x=78.96 //y=6.205 //x2=78.96 //y2=5.05
r910 (  186 207 ) resistor r=592.245 //w=0.094 //l=1.155 //layer=ply \
 //thickness=0.18 //x=21.85 //y=6.2 //x2=21.85 //y2=5.045
r911 (  185 200 ) resistor r=592.245 //w=0.094 //l=1.155 //layer=ply \
 //thickness=0.18 //x=21.41 //y=6.2 //x2=21.41 //y2=5.045
r912 (  184 238 ) resistor r=56.4043 //w=0.094 //l=0.11 //layer=ply \
 //thickness=0.18 //x=81.59 //y=1.545 //x2=81.7 //y2=1.545
r913 (  184 239 ) resistor r=56.4043 //w=0.094 //l=0.11 //layer=ply \
 //thickness=0.18 //x=81.59 //y=1.545 //x2=81.48 //y2=1.545
r914 (  183 219 ) resistor r=56.4043 //w=0.094 //l=0.11 //layer=ply \
 //thickness=0.18 //x=79.23 //y=1.585 //x2=79.34 //y2=1.585
r915 (  183 220 ) resistor r=56.4043 //w=0.094 //l=0.11 //layer=ply \
 //thickness=0.18 //x=79.23 //y=1.585 //x2=79.12 //y2=1.585
r916 (  182 197 ) resistor r=56.4043 //w=0.094 //l=0.11 //layer=ply \
 //thickness=0.18 //x=21.175 //y=1.555 //x2=21.285 //y2=1.555
r917 (  182 198 ) resistor r=56.4043 //w=0.094 //l=0.11 //layer=ply \
 //thickness=0.18 //x=21.175 //y=1.555 //x2=21.065 //y2=1.555
r918 (  178 267 ) resistor r=152 //w=0.17 //l=0.17 //layer=licon //count=1 \
 //x=81.15 //y=4.885 //x2=81.15 //y2=4.885
r919 (  173 265 ) resistor r=152 //w=0.17 //l=0.17 //layer=licon //count=1 \
 //x=81.15 //y=2.26 //x2=81.15 //y2=2.26
r920 (  168 263 ) resistor r=152 //w=0.17 //l=0.17 //layer=licon //count=1 \
 //x=79.67 //y=4.885 //x2=79.67 //y2=4.885
r921 (  159 261 ) resistor r=152 //w=0.17 //l=0.17 //layer=licon //count=1 \
 //x=79.67 //y=2.26 //x2=79.67 //y2=2.26
r922 (  154 253 ) resistor r=152 //w=0.17 //l=0.17 //layer=licon //count=1 \
 //x=21.21 //y=4.88 //x2=21.21 //y2=4.88
r923 (  145 251 ) resistor r=152 //w=0.17 //l=0.17 //layer=licon //count=1 \
 //x=21.21 //y=2.26 //x2=21.21 //y2=2.26
r924 (  128 275 ) resistor r=23.615 //w=0.187 //l=0.345 //layer=li \
 //thickness=0.1 //x=18.88 //y=5.56 //x2=18.88 //y2=5.905
r925 (  120 274 ) resistor r=23.615 //w=0.187 //l=0.345 //layer=li \
 //thickness=0.1 //x=18 //y=5.56 //x2=18 //y2=5.905
r926 (  116 117 ) resistor r=0.10734 //w=0.281 //l=0.16 //layer=m2 \
 //thickness=0.36 //x=81.145 //y=2.27 //x2=80.985 //y2=2.27
r927 (  114 117 ) resistor r=1.09733 //w=0.131 //l=1.15 //layer=m2 \
 //thickness=0.36 //x=79.835 //y=2.26 //x2=80.985 //y2=2.26
r928 (  112 114 ) resistor r=0.10734 //w=0.281 //l=0.16 //layer=m2 \
 //thickness=0.36 //x=79.675 //y=2.27 //x2=79.835 //y2=2.27
r929 (  104 106 ) resistor r=0.10734 //w=0.281 //l=0.16 //layer=m2 \
 //thickness=0.36 //x=19.35 //y=3.495 //x2=19.51 //y2=3.495
r930 (  99 110 ) resistor r=5.07415 //w=0.177 //l=7.1875 //layer=m2 \
 //thickness=0.36 //x=72.485 //y=3.5 //x2=79.67 //y2=3.505
r931 (  99 100 ) resistor r=0.410305 //w=0.131 //l=0.43 //layer=m2 \
 //thickness=0.36 //x=72.485 //y=3.5 //x2=72.055 //y2=3.5
r932 (  97 100 ) resistor r=0.125 //w=0.17 //l=0.174929 //layer=m2 \
 //thickness=0.36 //x=71.885 //y=3.51 //x2=72.055 //y2=3.5
r933 (  97 98 ) resistor r=6.26908 //w=0.131 //l=6.57 //layer=m2 \
 //thickness=0.36 //x=71.885 //y=3.51 //x2=65.315 //y2=3.51
r934 (  95 98 ) resistor r=0.154605 //w=0.19 //l=0.263296 //layer=m2 \
 //thickness=0.36 //x=65.08 //y=3.45 //x2=65.315 //y2=3.51
r935 (  95 96 ) resistor r=0.410305 //w=0.131 //l=0.43 //layer=m2 \
 //thickness=0.36 //x=65.08 //y=3.45 //x2=64.65 //y2=3.45
r936 (  93 96 ) resistor r=0.148964 //w=0.193 //l=0.258263 //layer=m2 \
 //thickness=0.36 //x=64.42 //y=3.51 //x2=64.65 //y2=3.45
r937 (  93 94 ) resistor r=3.05344 //w=0.131 //l=3.2 //layer=m2 \
 //thickness=0.36 //x=64.42 //y=3.51 //x2=61.22 //y2=3.51
r938 (  91 94 ) resistor r=0.136303 //w=0.188 //l=0.233077 //layer=m2 \
 //thickness=0.36 //x=61.015 //y=3.45 //x2=61.22 //y2=3.51
r939 (  91 92 ) resistor r=0.410305 //w=0.131 //l=0.43 //layer=m2 \
 //thickness=0.36 //x=61.015 //y=3.45 //x2=60.585 //y2=3.45
r940 (  89 92 ) resistor r=0.117608 //w=0.186 //l=0.202793 //layer=m2 \
 //thickness=0.36 //x=60.41 //y=3.51 //x2=60.585 //y2=3.45
r941 (  89 90 ) resistor r=3.75477 //w=0.131 //l=3.935 //layer=m2 \
 //thickness=0.36 //x=60.41 //y=3.51 //x2=56.475 //y2=3.51
r942 (  87 90 ) resistor r=0.167298 //w=0.198 //l=0.293471 //layer=m2 \
 //thickness=0.36 //x=56.21 //y=3.45 //x2=56.475 //y2=3.51
r943 (  87 88 ) resistor r=0.410305 //w=0.131 //l=0.43 //layer=m2 \
 //thickness=0.36 //x=56.21 //y=3.45 //x2=55.78 //y2=3.45
r944 (  85 88 ) resistor r=3.74635 //w=0.171 //l=5.16236 //layer=m2 \
 //thickness=0.36 //x=50.655 //y=3.525 //x2=55.78 //y2=3.45
r945 (  85 86 ) resistor r=0.329198 //w=0.131 //l=0.345 //layer=m2 \
 //thickness=0.36 //x=50.655 //y=3.525 //x2=50.31 //y2=3.525
r946 (  83 86 ) resistor r=0.1875 //w=0.17 //l=0.262393 //layer=m2 \
 //thickness=0.36 //x=50.055 //y=3.51 //x2=50.31 //y2=3.525
r947 (  83 84 ) resistor r=1.65553 //w=0.131 //l=1.735 //layer=m2 \
 //thickness=0.36 //x=50.055 //y=3.51 //x2=48.32 //y2=3.51
r948 (  81 84 ) resistor r=0.1875 //w=0.17 //l=0.259952 //layer=m2 \
 //thickness=0.36 //x=48.065 //y=3.5 //x2=48.32 //y2=3.51
r949 (  81 82 ) resistor r=0.410305 //w=0.131 //l=0.43 //layer=m2 \
 //thickness=0.36 //x=48.065 //y=3.5 //x2=47.635 //y2=3.5
r950 (  79 82 ) resistor r=0.125 //w=0.17 //l=0.174929 //layer=m2 \
 //thickness=0.36 //x=47.465 //y=3.51 //x2=47.635 //y2=3.5
r951 (  79 80 ) resistor r=6.2834 //w=0.131 //l=6.585 //layer=m2 \
 //thickness=0.36 //x=47.465 //y=3.51 //x2=40.88 //y2=3.51
r952 (  77 80 ) resistor r=0.143229 //w=0.192 //l=0.248193 //layer=m2 \
 //thickness=0.36 //x=40.66 //y=3.45 //x2=40.88 //y2=3.51
r953 (  77 78 ) resistor r=0.410305 //w=0.131 //l=0.43 //layer=m2 \
 //thickness=0.36 //x=40.66 //y=3.45 //x2=40.23 //y2=3.45
r954 (  75 78 ) resistor r=0.130348 //w=0.187 //l=0.222991 //layer=m2 \
 //thickness=0.36 //x=40.035 //y=3.51 //x2=40.23 //y2=3.45
r955 (  75 76 ) resistor r=3.06775 //w=0.131 //l=3.215 //layer=m2 \
 //thickness=0.36 //x=40.035 //y=3.51 //x2=36.82 //y2=3.51
r956 (  73 76 ) resistor r=0.14881 //w=0.189 //l=0.253229 //layer=m2 \
 //thickness=0.36 //x=36.595 //y=3.45 //x2=36.82 //y2=3.51
r957 (  73 74 ) resistor r=0.410305 //w=0.131 //l=0.43 //layer=m2 \
 //thickness=0.36 //x=36.595 //y=3.45 //x2=36.165 //y2=3.45
r958 (  71 74 ) resistor r=0.123663 //w=0.187 //l=0.212897 //layer=m2 \
 //thickness=0.36 //x=35.98 //y=3.51 //x2=36.165 //y2=3.45
r959 (  71 72 ) resistor r=3.78817 //w=0.131 //l=3.97 //layer=m2 \
 //thickness=0.36 //x=35.98 //y=3.51 //x2=32.01 //y2=3.51
r960 (  69 72 ) resistor r=0.145503 //w=0.189 //l=0.248193 //layer=m2 \
 //thickness=0.36 //x=31.79 //y=3.45 //x2=32.01 //y2=3.51
r961 (  69 70 ) resistor r=0.410305 //w=0.131 //l=0.43 //layer=m2 \
 //thickness=0.36 //x=31.79 //y=3.45 //x2=31.36 //y2=3.45
r962 (  68 108 ) resistor r=1.3039 //w=0.193 //l=2.0125 //layer=m2 \
 //thickness=0.36 //x=23.215 //y=3.5 //x2=21.205 //y2=3.495
r963 (  67 70 ) resistor r=5.63962 //w=0.171 //l=7.73996 //layer=m2 \
 //thickness=0.36 //x=23.645 //y=3.5 //x2=31.36 //y2=3.45
r964 (  67 68 ) resistor r=0.410305 //w=0.131 //l=0.43 //layer=m2 \
 //thickness=0.36 //x=23.645 //y=3.5 //x2=23.215 //y2=3.5
r965 (  65 108 ) resistor r=0.105717 //w=0.193 //l=0.167332 //layer=m2 \
 //thickness=0.36 //x=21.045 //y=3.51 //x2=21.205 //y2=3.495
r966 (  65 106 ) resistor r=1.46469 //w=0.131 //l=1.535 //layer=m2 \
 //thickness=0.36 //x=21.045 //y=3.51 //x2=19.51 //y2=3.51
r967 (  64 178 ) resistor r=9.3 //w=0.17 //l=0.17 //layer=mcon //count=1 \
 //x=81.15 //y=4.885 //x2=81.15 //y2=4.885
r968 (  62 116 ) resistor r=4.5 //w=0.15 //l=0.15 //layer=via1 //count=1 \
 //x=81.145 //y=2.27 //x2=81.145 //y2=2.27
r969 (  60 173 ) resistor r=9.3 //w=0.17 //l=0.17 //layer=mcon //count=1 \
 //x=81.15 //y=2.26 //x2=81.15 //y2=2.26
r970 (  60 62 ) resistor r=0.00334225 //w=0.374 //l=0.01 //layer=m1 \
 //thickness=0.36 //x=81.095 //y=2.26 //x2=81.095 //y2=2.27
r971 (  58 112 ) resistor r=4.5 //w=0.15 //l=0.15 //layer=via1 //count=1 \
 //x=79.675 //y=2.27 //x2=79.675 //y2=2.27
r972 (  56 159 ) resistor r=9.3 //w=0.17 //l=0.17 //layer=mcon //count=1 \
 //x=79.67 //y=2.26 //x2=79.67 //y2=2.26
r973 (  56 58 ) resistor r=0.00334225 //w=0.374 //l=0.01 //layer=m1 \
 //thickness=0.36 //x=79.725 //y=2.26 //x2=79.725 //y2=2.27
r974 (  54 168 ) resistor r=9.3 //w=0.17 //l=0.17 //layer=mcon //count=1 \
 //x=79.67 //y=4.885 //x2=79.67 //y2=4.885
r975 (  50 110 ) resistor r=4.5 //w=0.15 //l=0.15 //layer=via1 //count=1 \
 //x=79.67 //y=3.505 //x2=79.67 //y2=3.505
r976 (  50 52 ) resistor r=0.00166223 //w=0.376 //l=0.005 //layer=m1 \
 //thickness=0.36 //x=79.617 //y=3.505 //x2=79.617 //y2=3.51
r977 (  48 154 ) resistor r=9.3 //w=0.17 //l=0.17 //layer=mcon //count=1 \
 //x=21.21 //y=4.88 //x2=21.21 //y2=4.88
r978 (  46 145 ) resistor r=9.3 //w=0.17 //l=0.17 //layer=mcon //count=1 \
 //x=21.21 //y=2.26 //x2=21.21 //y2=2.26
r979 (  42 108 ) resistor r=4.5 //w=0.15 //l=0.15 //layer=via1 //count=1 \
 //x=21.205 //y=3.495 //x2=21.205 //y2=3.495
r980 (  42 44 ) resistor r=0.00501337 //w=0.374 //l=0.015 //layer=m1 \
 //thickness=0.36 //x=21.155 //y=3.495 //x2=21.155 //y2=3.51
r981 (  38 104 ) resistor r=4.5 //w=0.15 //l=0.15 //layer=via1 //count=1 \
 //x=19.35 //y=3.495 //x2=19.35 //y2=3.495
r982 (  38 40 ) resistor r=0.00490838 //w=0.382 //l=0.015 //layer=m1 \
 //thickness=0.36 //x=19.407 //y=3.495 //x2=19.407 //y2=3.51
r983 (  35 272 ) resistor r=9.3 //w=0.17 //l=0.17 //layer=mcon //count=1 \
 //x=18.92 //y=1.18 //x2=18.92 //y2=1.18
r984 (  33 128 ) resistor r=9.3 //w=0.17 //l=0.17 //layer=mcon //count=1 \
 //x=18.88 //y=5.56 //x2=18.88 //y2=5.56
r985 (  30 33 ) resistor r=0.117801 //w=0.191 //l=0.18 //layer=m1 \
 //thickness=0.36 //x=18.88 //y=5.38 //x2=18.88 //y2=5.56
r986 (  29 120 ) resistor r=9.3 //w=0.17 //l=0.17 //layer=mcon //count=1 \
 //x=18 //y=5.56 //x2=18 //y2=5.56
r987 (  27 29 ) resistor r=0.10274 //w=0.219 //l=0.18 //layer=m1 \
 //thickness=0.36 //x=18 //y=5.38 //x2=18 //y2=5.56
r988 (  26 64 ) resistor r=0.0777782 //w=0.252 //l=0.131491 //layer=m1 \
 //thickness=0.36 //x=81.15 //y=4.755 //x2=81.147 //y2=4.885
r989 (  25 62 ) resistor r=0.0910802 //w=0.374 //l=0.185472 //layer=m1 \
 //thickness=0.36 //x=81.15 //y=2.43 //x2=81.095 //y2=2.27
r990 (  25 26 ) resistor r=2.21851 //w=0.131 //l=2.325 //layer=m1 \
 //thickness=0.36 //x=81.15 //y=2.43 //x2=81.15 //y2=4.755
r991 (  24 54 ) resistor r=0.075298 //w=0.252 //l=0.125 //layer=m1 \
 //thickness=0.36 //x=79.67 //y=4.76 //x2=79.67 //y2=4.885
r992 (  23 52 ) resistor r=0.0894971 //w=0.376 //l=0.179555 //layer=m1 \
 //thickness=0.36 //x=79.67 //y=3.665 //x2=79.617 //y2=3.51
r993 (  23 24 ) resistor r=1.04485 //w=0.131 //l=1.095 //layer=m1 \
 //thickness=0.36 //x=79.67 //y=3.665 //x2=79.67 //y2=4.76
r994 (  22 50 ) resistor r=0.0911593 //w=0.376 //l=0.184608 //layer=m1 \
 //thickness=0.36 //x=79.67 //y=3.345 //x2=79.617 //y2=3.505
r995 (  21 58 ) resistor r=0.0910802 //w=0.374 //l=0.185472 //layer=m1 \
 //thickness=0.36 //x=79.67 //y=2.43 //x2=79.725 //y2=2.27
r996 (  21 22 ) resistor r=0.873092 //w=0.131 //l=0.915 //layer=m1 \
 //thickness=0.36 //x=79.67 //y=2.43 //x2=79.67 //y2=3.345
r997 (  20 48 ) resistor r=0.0760407 //w=0.238 //l=0.125 //layer=m1 \
 //thickness=0.36 //x=21.21 //y=4.755 //x2=21.21 //y2=4.88
r998 (  19 44 ) resistor r=0.0860668 //w=0.374 //l=0.170294 //layer=m1 \
 //thickness=0.36 //x=21.21 //y=3.655 //x2=21.155 //y2=3.51
r999 (  19 20 ) resistor r=1.04962 //w=0.131 //l=1.1 //layer=m1 \
 //thickness=0.36 //x=21.21 //y=3.655 //x2=21.21 //y2=4.755
r1000 (  18 42 ) resistor r=0.0910802 //w=0.374 //l=0.185472 //layer=m1 \
 //thickness=0.36 //x=21.21 //y=3.335 //x2=21.155 //y2=3.495
r1001 (  17 46 ) resistor r=0.0719237 //w=0.222 //l=0.115 //layer=m1 \
 //thickness=0.36 //x=21.21 //y=2.375 //x2=21.21 //y2=2.26
r1002 (  17 18 ) resistor r=0.916031 //w=0.131 //l=0.96 //layer=m1 \
 //thickness=0.36 //x=21.21 //y=2.375 //x2=21.21 //y2=3.335
r1003 (  15 40 ) resistor r=0.0864989 //w=0.382 //l=0.166853 //layer=m1 \
 //thickness=0.36 //x=19.36 //y=3.655 //x2=19.407 //y2=3.51
r1004 (  15 16 ) resistor r=1.56489 //w=0.131 //l=1.64 //layer=m1 \
 //thickness=0.36 //x=19.36 //y=3.655 //x2=19.36 //y2=5.295
r1005 (  14 38 ) resistor r=0.0914072 //w=0.382 //l=0.181989 //layer=m1 \
 //thickness=0.36 //x=19.36 //y=3.335 //x2=19.407 //y2=3.495
r1006 (  13 14 ) resistor r=1.35019 //w=0.131 //l=1.415 //layer=m1 \
 //thickness=0.36 //x=19.36 //y=1.92 //x2=19.36 //y2=3.335
r1007 (  11 13 ) resistor r=0.0698411 //w=0.17 //l=0.120208 //layer=m1 \
 //thickness=0.36 //x=19.275 //y=1.835 //x2=19.36 //y2=1.92
r1008 (  11 12 ) resistor r=0.257634 //w=0.131 //l=0.27 //layer=m1 \
 //thickness=0.36 //x=19.275 //y=1.835 //x2=19.005 //y2=1.835
r1009 (  10 30 ) resistor r=0.0257089 //w=0.23 //l=0.115 //layer=m1 \
 //thickness=0.36 //x=18.995 //y=5.38 //x2=18.88 //y2=5.38
r1010 (  9 16 ) resistor r=0.0698411 //w=0.17 //l=0.120208 //layer=m1 \
 //thickness=0.36 //x=19.275 //y=5.38 //x2=19.36 //y2=5.295
r1011 (  9 10 ) resistor r=0.267176 //w=0.131 //l=0.28 //layer=m1 \
 //thickness=0.36 //x=19.275 //y=5.38 //x2=18.995 //y2=5.38
r1012 (  8 12 ) resistor r=0.0698411 //w=0.17 //l=0.120208 //layer=m1 \
 //thickness=0.36 //x=18.92 //y=1.75 //x2=19.005 //y2=1.835
r1013 (  7 35 ) resistor r=0.0913624 //w=0.191 //l=0.12 //layer=m1 \
 //thickness=0.36 //x=18.92 //y=1.3 //x2=18.92 //y2=1.18
r1014 (  7 8 ) resistor r=0.429389 //w=0.131 //l=0.45 //layer=m1 \
 //thickness=0.36 //x=18.92 //y=1.3 //x2=18.92 //y2=1.75
r1015 (  4 27 ) resistor r=0.0227762 //w=0.219 //l=0.115 //layer=m1 \
 //thickness=0.36 //x=18.115 //y=5.38 //x2=18 //y2=5.38
r1016 (  3 30 ) resistor r=0.0257089 //w=0.23 //l=0.115 //layer=m1 \
 //thickness=0.36 //x=18.765 //y=5.38 //x2=18.88 //y2=5.38
r1017 (  3 4 ) resistor r=0.620229 //w=0.131 //l=0.65 //layer=m1 \
 //thickness=0.36 //x=18.765 //y=5.38 //x2=18.115 //y2=5.38
ends PM_TMRDFFSNQNX1\%noxref_21

subckt PM_TMRDFFSNQNX1\%QN ( 1 2 3 4 5 6 7 8 10 11 12 14 15 26 30 33 36 50 53 \
 54 56 57 66 74 91 92 93 97 98 )
c214 ( 93 0 ) capacitor c=0.009897f //x=82.37 //y=1.085
c215 ( 92 0 ) capacitor c=0.0108944f //x=79.04 //y=1.085
c216 ( 91 0 ) capacitor c=0.0110396f //x=75.71 //y=1.085
c217 ( 74 0 ) capacitor c=0.0265472f //x=82.52 //y=5.56
c218 ( 66 0 ) capacitor c=0.0232072f //x=81.64 //y=5.56
c219 ( 57 0 ) capacitor c=0.0848427f //x=82.395 //y=1.405
c220 ( 56 0 ) capacitor c=0.0257508f //x=82.555 //y=1.405
c221 ( 54 0 ) capacitor c=0.00767971f //x=79.36 //y=1.405
c222 ( 53 0 ) capacitor c=0.0878164f //x=79.1 //y=1.405
c223 ( 50 0 ) capacitor c=0.00355061f //x=76.065 //y=1.405
c224 ( 36 0 ) capacitor c=0.01557f //x=82.517 //y=5.39
c225 ( 33 0 ) capacitor c=0.0155006f //x=81.64 //y=5.39
c226 ( 30 0 ) capacitor c=0.00905508f //x=79.23 //y=1.36
c227 ( 26 0 ) capacitor c=0.00604998f //x=75.9 //y=1.36
c228 ( 15 0 ) capacitor c=0.00834076f //x=82.645 //y=1.825
c229 ( 14 0 ) capacitor c=0.0162177f //x=82.915 //y=1.825
c230 ( 12 0 ) capacitor c=0.0128896f //x=82.915 //y=5.39
c231 ( 11 0 ) capacitor c=0.00871794f //x=82.56 //y=1.74
c232 ( 10 0 ) capacitor c=0.00698506f //x=82.56 //y=1.535
c233 ( 8 0 ) capacitor c=0.0116295f //x=82.395 //y=5.39
c234 ( 1 0 ) capacitor c=0.132496f //x=83 //y=2.4
r235 (  90 91 ) resistor r=13.3953 //w=0.172 //l=0.18 //layer=li \
 //thickness=0.1 //x=75.897 //y=1.36 //x2=75.897 //y2=1.18
r236 (  85 93 ) resistor r=12.3209 //w=0.187 //l=0.18 //layer=li \
 //thickness=0.1 //x=82.56 //y=1.36 //x2=82.56 //y2=1.18
r237 (  74 98 ) resistor r=23.2727 //w=0.187 //l=0.34 //layer=li \
 //thickness=0.1 //x=82.52 //y=5.56 //x2=82.52 //y2=5.9
r238 (  66 97 ) resistor r=23.2727 //w=0.187 //l=0.34 //layer=li \
 //thickness=0.1 //x=81.64 //y=5.56 //x2=81.64 //y2=5.9
r239 (  63 92 ) resistor r=12.3209 //w=0.187 //l=0.18 //layer=li \
 //thickness=0.1 //x=79.23 //y=1.36 //x2=79.23 //y2=1.18
r240 (  56 57 ) resistor r=0.10734 //w=0.281 //l=0.16 //layer=m2 \
 //thickness=0.36 //x=82.555 //y=1.405 //x2=82.395 //y2=1.405
r241 (  54 57 ) resistor r=2.89599 //w=0.131 //l=3.035 //layer=m2 \
 //thickness=0.36 //x=79.36 //y=1.36 //x2=82.395 //y2=1.36
r242 (  52 54 ) resistor r=0.0942778 //w=0.221 //l=0.13 //layer=m2 \
 //thickness=0.36 //x=79.23 //y=1.405 //x2=79.36 //y2=1.405
r243 (  52 53 ) resistor r=0.0942778 //w=0.221 //l=0.13 //layer=m2 \
 //thickness=0.36 //x=79.23 //y=1.405 //x2=79.1 //y2=1.405
r244 (  50 53 ) resistor r=2.89599 //w=0.131 //l=3.035 //layer=m2 \
 //thickness=0.36 //x=76.065 //y=1.36 //x2=79.1 //y2=1.36
r245 (  48 50 ) resistor r=0.10734 //w=0.281 //l=0.16 //layer=m2 \
 //thickness=0.36 //x=75.905 //y=1.405 //x2=76.065 //y2=1.405
r246 (  42 56 ) resistor r=4.5 //w=0.15 //l=0.15 //layer=via1 //count=1 \
 //x=82.555 //y=1.405 //x2=82.555 //y2=1.405
r247 (  40 85 ) resistor r=9.3 //w=0.17 //l=0.17 //layer=mcon //count=1 \
 //x=82.56 //y=1.36 //x2=82.56 //y2=1.36
r248 (  40 42 ) resistor r=0.0163043 //w=0.345 //l=0.045 //layer=m1 \
 //thickness=0.36 //x=82.5 //y=1.36 //x2=82.5 //y2=1.405
r249 (  38 74 ) resistor r=9.3 //w=0.17 //l=0.17 //layer=mcon //count=1 \
 //x=82.52 //y=5.56 //x2=82.52 //y2=5.56
r250 (  36 38 ) resistor r=0.0944444 //w=0.225 //l=0.17 //layer=m1 \
 //thickness=0.36 //x=82.517 //y=5.39 //x2=82.517 //y2=5.56
r251 (  35 66 ) resistor r=9.3 //w=0.17 //l=0.17 //layer=mcon //count=1 \
 //x=81.64 //y=5.56 //x2=81.64 //y2=5.56
r252 (  33 35 ) resistor r=0.0936123 //w=0.227 //l=0.17 //layer=m1 \
 //thickness=0.36 //x=81.64 //y=5.39 //x2=81.64 //y2=5.56
r253 (  32 52 ) resistor r=4.5 //w=0.15 //l=0.15 //layer=via1 //count=1 \
 //x=79.23 //y=1.405 //x2=79.23 //y2=1.405
r254 (  30 63 ) resistor r=9.3 //w=0.17 //l=0.17 //layer=mcon //count=1 \
 //x=79.23 //y=1.36 //x2=79.23 //y2=1.36
r255 (  30 32 ) resistor r=0.0163043 //w=0.345 //l=0.045 //layer=m1 \
 //thickness=0.36 //x=79.17 //y=1.36 //x2=79.17 //y2=1.405
r256 (  28 48 ) resistor r=4.5 //w=0.15 //l=0.15 //layer=via1 //count=1 \
 //x=75.905 //y=1.405 //x2=75.905 //y2=1.405
r257 (  26 90 ) resistor r=9.3 //w=0.17 //l=0.17 //layer=mcon //count=1 \
 //x=75.9 //y=1.36 //x2=75.9 //y2=1.36
r258 (  26 28 ) resistor r=0.0150401 //w=0.374 //l=0.045 //layer=m1 \
 //thickness=0.36 //x=75.955 //y=1.36 //x2=75.955 //y2=1.405
r259 (  14 16 ) resistor r=0.0698411 //w=0.17 //l=0.120208 //layer=m1 \
 //thickness=0.36 //x=82.915 //y=1.825 //x2=83 //y2=1.91
r260 (  14 15 ) resistor r=0.257634 //w=0.131 //l=0.27 //layer=m1 \
 //thickness=0.36 //x=82.915 //y=1.825 //x2=82.645 //y2=1.825
r261 (  13 36 ) resistor r=0.0243946 //w=0.225 //l=0.123 //layer=m1 \
 //thickness=0.36 //x=82.64 //y=5.39 //x2=82.517 //y2=5.39
r262 (  12 17 ) resistor r=0.0698411 //w=0.17 //l=0.120208 //layer=m1 \
 //thickness=0.36 //x=82.915 //y=5.39 //x2=83 //y2=5.305
r263 (  12 13 ) resistor r=0.262405 //w=0.131 //l=0.275 //layer=m1 \
 //thickness=0.36 //x=82.915 //y=5.39 //x2=82.64 //y2=5.39
r264 (  11 15 ) resistor r=0.0698411 //w=0.17 //l=0.120208 //layer=m1 \
 //thickness=0.36 //x=82.56 //y=1.74 //x2=82.645 //y2=1.825
r265 (  10 42 ) resistor r=0.0792909 //w=0.345 //l=0.157162 //layer=m1 \
 //thickness=0.36 //x=82.56 //y=1.535 //x2=82.5 //y2=1.405
r266 (  10 11 ) resistor r=0.195611 //w=0.131 //l=0.205 //layer=m1 \
 //thickness=0.36 //x=82.56 //y=1.535 //x2=82.56 //y2=1.74
r267 (  9 33 ) resistor r=0.0249239 //w=0.227 //l=0.125 //layer=m1 \
 //thickness=0.36 //x=81.765 //y=5.39 //x2=81.64 //y2=5.39
r268 (  8 36 ) resistor r=0.0243946 //w=0.225 //l=0.122 //layer=m1 \
 //thickness=0.36 //x=82.395 //y=5.39 //x2=82.517 //y2=5.39
r269 (  8 9 ) resistor r=0.601145 //w=0.131 //l=0.63 //layer=m1 \
 //thickness=0.36 //x=82.395 //y=5.39 //x2=81.765 //y2=5.39
r270 (  7 17 ) resistor r=0.653626 //w=0.131 //l=0.685 //layer=m1 \
 //thickness=0.36 //x=83 //y=4.62 //x2=83 //y2=5.305
r271 (  6 7 ) resistor r=0.353053 //w=0.131 //l=0.37 //layer=m1 \
 //thickness=0.36 //x=83 //y=4.25 //x2=83 //y2=4.62
r272 (  5 6 ) resistor r=0.353053 //w=0.131 //l=0.37 //layer=m1 \
 //thickness=0.36 //x=83 //y=3.88 //x2=83 //y2=4.25
r273 (  4 5 ) resistor r=0.353053 //w=0.131 //l=0.37 //layer=m1 \
 //thickness=0.36 //x=83 //y=3.51 //x2=83 //y2=3.88
r274 (  3 4 ) resistor r=0.353053 //w=0.131 //l=0.37 //layer=m1 \
 //thickness=0.36 //x=83 //y=3.14 //x2=83 //y2=3.51
r275 (  2 3 ) resistor r=0.353053 //w=0.131 //l=0.37 //layer=m1 \
 //thickness=0.36 //x=83 //y=2.77 //x2=83 //y2=3.14
r276 (  1 2 ) resistor r=0.353053 //w=0.131 //l=0.37 //layer=m1 \
 //thickness=0.36 //x=83 //y=2.4 //x2=83 //y2=2.77
r277 (  1 16 ) resistor r=0.467557 //w=0.131 //l=0.49 //layer=m1 \
 //thickness=0.36 //x=83 //y=2.4 //x2=83 //y2=1.91
ends PM_TMRDFFSNQNX1\%QN

subckt PM_TMRDFFSNQNX1\%VDD ( 1 2 125 126 127 129 130 131 135 136 149 211 219 \
 245 253 263 273 289 297 307 317 333 343 369 379 403 413 421 431 447 455 481 \
 489 499 509 525 533 543 553 569 579 605 615 639 649 657 667 683 691 717 725 \
 735 745 761 769 779 789 805 815 841 851 859 875 885 893 903 909 944 959 963 \
 966 972 978 982 987 992 997 1003 1009 1013 1018 1023 1028 1034 1040 1044 1049 \
 1054 1055 1056 1057 1058 1059 1060 1061 1062 1063 1064 1065 1066 1067 1068 \
 1069 1070 1071 1072 1073 1074 1075 1076 1077 1078 1079 1080 1081 1082 1083 \
 1084 1085 1086 1087 1088 1089 1090 1091 1092 1093 1094 1095 1096 1097 1098 \
 1099 1100 1101 1102 1103 1104 1105 1106 1107 1108 1109 1110 1111 1112 1113 \
 1114 1115 1116 1117 1118 1119 1120 1121 1122 )
c1358 ( 1122 0 ) capacitor c=0.0424825f //x=76.155 //y=5.205
c1359 ( 1121 0 ) capacitor c=0.0224071f //x=75.275 //y=5.205
c1360 ( 1120 0 ) capacitor c=0.0513776f //x=74.405 //y=5.205
c1361 ( 1119 0 ) capacitor c=0.046689f //x=72.525 //y=5.2
c1362 ( 1118 0 ) capacitor c=0.0255621f //x=71.645 //y=5.2
c1363 ( 1117 0 ) capacitor c=0.0255777f //x=70.765 //y=5.2
c1364 ( 1116 0 ) capacitor c=0.0674421f //x=69.895 //y=5.2
c1365 ( 1115 0 ) capacitor c=0.0386927f //x=68.015 //y=5.2
c1366 ( 1114 0 ) capacitor c=0.0248174f //x=67.135 //y=5.2
c1367 ( 1113 0 ) capacitor c=0.0621883f //x=66.265 //y=5.2
c1368 ( 1112 0 ) capacitor c=0.0393089f //x=64.685 //y=5.2
c1369 ( 1111 0 ) capacitor c=0.0248174f //x=63.805 //y=5.2
c1370 ( 1110 0 ) capacitor c=0.0629527f //x=62.935 //y=5.2
c1371 ( 1109 0 ) capacitor c=0.0466891f //x=61.055 //y=5.2
c1372 ( 1108 0 ) capacitor c=0.0255836f //x=60.175 //y=5.2
c1373 ( 1107 0 ) capacitor c=0.0256114f //x=59.295 //y=5.2
c1374 ( 1106 0 ) capacitor c=0.0677135f //x=58.425 //y=5.2
c1375 ( 1105 0 ) capacitor c=0.0466891f //x=56.245 //y=5.2
c1376 ( 1104 0 ) capacitor c=0.025617f //x=55.365 //y=5.2
c1377 ( 1103 0 ) capacitor c=0.0255777f //x=54.485 //y=5.2
c1378 ( 1102 0 ) capacitor c=0.0675218f //x=53.615 //y=5.2
c1379 ( 1101 0 ) capacitor c=0.0399069f //x=51.735 //y=5.2
c1380 ( 1100 0 ) capacitor c=0.0248174f //x=50.855 //y=5.2
c1381 ( 1099 0 ) capacitor c=0.062891f //x=49.985 //y=5.2
c1382 ( 1098 0 ) capacitor c=0.0466891f //x=48.105 //y=5.2
c1383 ( 1097 0 ) capacitor c=0.0255836f //x=47.225 //y=5.2
c1384 ( 1096 0 ) capacitor c=0.0255777f //x=46.345 //y=5.2
c1385 ( 1095 0 ) capacitor c=0.0675806f //x=45.475 //y=5.2
c1386 ( 1094 0 ) capacitor c=0.0399069f //x=43.595 //y=5.2
c1387 ( 1093 0 ) capacitor c=0.0248174f //x=42.715 //y=5.2
c1388 ( 1092 0 ) capacitor c=0.0619264f //x=41.845 //y=5.2
c1389 ( 1091 0 ) capacitor c=0.0393089f //x=40.265 //y=5.2
c1390 ( 1090 0 ) capacitor c=0.0248174f //x=39.385 //y=5.2
c1391 ( 1089 0 ) capacitor c=0.0629527f //x=38.515 //y=5.2
c1392 ( 1088 0 ) capacitor c=0.0466891f //x=36.635 //y=5.2
c1393 ( 1087 0 ) capacitor c=0.0255836f //x=35.755 //y=5.2
c1394 ( 1086 0 ) capacitor c=0.0256114f //x=34.875 //y=5.2
c1395 ( 1085 0 ) capacitor c=0.0677135f //x=34.005 //y=5.2
c1396 ( 1084 0 ) capacitor c=0.0466891f //x=31.825 //y=5.2
c1397 ( 1083 0 ) capacitor c=0.025617f //x=30.945 //y=5.2
c1398 ( 1082 0 ) capacitor c=0.0255777f //x=30.065 //y=5.2
c1399 ( 1081 0 ) capacitor c=0.0675218f //x=29.195 //y=5.2
c1400 ( 1080 0 ) capacitor c=0.0399069f //x=27.315 //y=5.2
c1401 ( 1079 0 ) capacitor c=0.0248174f //x=26.435 //y=5.2
c1402 ( 1078 0 ) capacitor c=0.0627878f //x=25.565 //y=5.2
c1403 ( 1077 0 ) capacitor c=0.0466891f //x=23.685 //y=5.2
c1404 ( 1076 0 ) capacitor c=0.0255836f //x=22.805 //y=5.2
c1405 ( 1075 0 ) capacitor c=0.0255777f //x=21.925 //y=5.2
c1406 ( 1074 0 ) capacitor c=0.0675312f //x=21.055 //y=5.2
c1407 ( 1073 0 ) capacitor c=0.039544f //x=19.175 //y=5.2
c1408 ( 1072 0 ) capacitor c=0.0248174f //x=18.295 //y=5.2
c1409 ( 1071 0 ) capacitor c=0.0619264f //x=17.425 //y=5.2
c1410 ( 1070 0 ) capacitor c=0.0393089f //x=15.845 //y=5.2
c1411 ( 1069 0 ) capacitor c=0.0248174f //x=14.965 //y=5.2
c1412 ( 1068 0 ) capacitor c=0.0629527f //x=14.095 //y=5.2
c1413 ( 1067 0 ) capacitor c=0.0466891f //x=12.215 //y=5.2
c1414 ( 1066 0 ) capacitor c=0.0255836f //x=11.335 //y=5.2
c1415 ( 1065 0 ) capacitor c=0.0256114f //x=10.455 //y=5.2
c1416 ( 1064 0 ) capacitor c=0.0676542f //x=9.585 //y=5.2
c1417 ( 1063 0 ) capacitor c=0.0466891f //x=7.405 //y=5.2
c1418 ( 1062 0 ) capacitor c=0.025617f //x=6.525 //y=5.2
c1419 ( 1061 0 ) capacitor c=0.0255777f //x=5.645 //y=5.2
c1420 ( 1060 0 ) capacitor c=0.0676078f //x=4.775 //y=5.2
c1421 ( 1059 0 ) capacitor c=0.0399069f //x=2.895 //y=5.2
c1422 ( 1058 0 ) capacitor c=0.0248174f //x=2.015 //y=5.2
c1423 ( 1057 0 ) capacitor c=0.0678368f //x=1.145 //y=5.2
c1424 ( 1056 0 ) capacitor c=0.120833f //x=80.41 //y=7.585
c1425 ( 1055 0 ) capacitor c=0.125805f //x=77.08 //y=7.585
c1426 ( 1054 0 ) capacitor c=0.141457f //x=73.75 //y=7.585
c1427 ( 1053 0 ) capacitor c=0.00597439f //x=72.67 //y=7.585
c1428 ( 1052 0 ) capacitor c=0.00597439f //x=71.79 //y=7.585
c1429 ( 1051 0 ) capacitor c=0.00597439f //x=70.91 //y=7.585
c1430 ( 1050 0 ) capacitor c=0.00597439f //x=70.03 //y=7.585
c1431 ( 1049 0 ) capacitor c=0.141301f //x=68.94 //y=7.585
c1432 ( 1048 0 ) capacitor c=0.00597439f //x=68.2 //y=7.58
c1433 ( 1046 0 ) capacitor c=0.00597439f //x=67.28 //y=7.585
c1434 ( 1045 0 ) capacitor c=0.00597439f //x=66.4 //y=7.585
c1435 ( 1044 0 ) capacitor c=0.126907f //x=65.61 //y=7.585
c1436 ( 1043 0 ) capacitor c=0.00597439f //x=64.83 //y=7.585
c1437 ( 1042 0 ) capacitor c=0.00597439f //x=63.95 //y=7.585
c1438 ( 1041 0 ) capacitor c=0.00597439f //x=63.07 //y=7.585
c1439 ( 1040 0 ) capacitor c=0.145673f //x=62.28 //y=7.585
c1440 ( 1039 0 ) capacitor c=0.00597439f //x=61.2 //y=7.585
c1441 ( 1038 0 ) capacitor c=0.00597439f //x=60.32 //y=7.585
c1442 ( 1037 0 ) capacitor c=0.00597439f //x=59.44 //y=7.585
c1443 ( 1036 0 ) capacitor c=0.00597439f //x=58.58 //y=7.58
c1444 ( 1034 0 ) capacitor c=0.162199f //x=57.47 //y=7.585
c1445 ( 1033 0 ) capacitor c=0.00597439f //x=56.39 //y=7.585
c1446 ( 1032 0 ) capacitor c=0.00597439f //x=55.51 //y=7.585
c1447 ( 1031 0 ) capacitor c=0.00597439f //x=54.63 //y=7.585
c1448 ( 1030 0 ) capacitor c=0.00597439f //x=53.77 //y=7.58
c1449 ( 1028 0 ) capacitor c=0.14448f //x=52.66 //y=7.585
c1450 ( 1027 0 ) capacitor c=0.00597439f //x=51.88 //y=7.585
c1451 ( 1026 0 ) capacitor c=0.00597439f //x=51 //y=7.585
c1452 ( 1025 0 ) capacitor c=0.00597439f //x=50.07 //y=7.58
c1453 ( 1023 0 ) capacitor c=0.14593f //x=49.33 //y=7.585
c1454 ( 1022 0 ) capacitor c=0.00597439f //x=48.25 //y=7.585
c1455 ( 1021 0 ) capacitor c=0.00597439f //x=47.37 //y=7.585
c1456 ( 1020 0 ) capacitor c=0.00597439f //x=46.49 //y=7.585
c1457 ( 1019 0 ) capacitor c=0.00597439f //x=45.61 //y=7.585
c1458 ( 1018 0 ) capacitor c=0.144432f //x=44.52 //y=7.585
c1459 ( 1017 0 ) capacitor c=0.00597439f //x=43.78 //y=7.58
c1460 ( 1015 0 ) capacitor c=0.00597439f //x=42.86 //y=7.585
c1461 ( 1014 0 ) capacitor c=0.00597439f //x=41.98 //y=7.585
c1462 ( 1013 0 ) capacitor c=0.126123f //x=41.19 //y=7.585
c1463 ( 1012 0 ) capacitor c=0.00597439f //x=40.41 //y=7.585
c1464 ( 1011 0 ) capacitor c=0.00597439f //x=39.53 //y=7.585
c1465 ( 1010 0 ) capacitor c=0.00597439f //x=38.65 //y=7.585
c1466 ( 1009 0 ) capacitor c=0.145673f //x=37.86 //y=7.585
c1467 ( 1008 0 ) capacitor c=0.00597439f //x=36.78 //y=7.585
c1468 ( 1007 0 ) capacitor c=0.00597439f //x=35.9 //y=7.585
c1469 ( 1006 0 ) capacitor c=0.00597439f //x=35.02 //y=7.585
c1470 ( 1005 0 ) capacitor c=0.00597439f //x=34.16 //y=7.58
c1471 ( 1003 0 ) capacitor c=0.162199f //x=33.05 //y=7.585
c1472 ( 1002 0 ) capacitor c=0.00597439f //x=31.97 //y=7.585
c1473 ( 1001 0 ) capacitor c=0.00597439f //x=31.09 //y=7.585
c1474 ( 1000 0 ) capacitor c=0.00597439f //x=30.21 //y=7.585
c1475 ( 999 0 ) capacitor c=0.00597439f //x=29.35 //y=7.58
c1476 ( 997 0 ) capacitor c=0.14448f //x=28.24 //y=7.585
c1477 ( 996 0 ) capacitor c=0.00597439f //x=27.46 //y=7.585
c1478 ( 995 0 ) capacitor c=0.00597439f //x=26.58 //y=7.585
c1479 ( 994 0 ) capacitor c=0.00597439f //x=25.65 //y=7.58
c1480 ( 992 0 ) capacitor c=0.145919f //x=24.91 //y=7.585
c1481 ( 991 0 ) capacitor c=0.00597439f //x=23.83 //y=7.585
c1482 ( 990 0 ) capacitor c=0.00597439f //x=22.95 //y=7.585
c1483 ( 989 0 ) capacitor c=0.00597439f //x=22.07 //y=7.585
c1484 ( 988 0 ) capacitor c=0.00597439f //x=21.19 //y=7.585
c1485 ( 987 0 ) capacitor c=0.144432f //x=20.1 //y=7.585
c1486 ( 986 0 ) capacitor c=0.00597439f //x=19.36 //y=7.58
c1487 ( 984 0 ) capacitor c=0.00597439f //x=18.44 //y=7.585
c1488 ( 983 0 ) capacitor c=0.00597439f //x=17.56 //y=7.585
c1489 ( 982 0 ) capacitor c=0.126123f //x=16.77 //y=7.585
c1490 ( 981 0 ) capacitor c=0.00597439f //x=15.99 //y=7.585
c1491 ( 980 0 ) capacitor c=0.00597439f //x=15.11 //y=7.585
c1492 ( 979 0 ) capacitor c=0.00597439f //x=14.23 //y=7.585
c1493 ( 978 0 ) capacitor c=0.145673f //x=13.44 //y=7.585
c1494 ( 977 0 ) capacitor c=0.00597439f //x=12.36 //y=7.585
c1495 ( 976 0 ) capacitor c=0.00597439f //x=11.48 //y=7.585
c1496 ( 975 0 ) capacitor c=0.00597439f //x=10.6 //y=7.585
c1497 ( 974 0 ) capacitor c=0.00597439f //x=9.74 //y=7.58
c1498 ( 972 0 ) capacitor c=0.162199f //x=8.63 //y=7.585
c1499 ( 971 0 ) capacitor c=0.00597439f //x=7.55 //y=7.585
c1500 ( 970 0 ) capacitor c=0.00597439f //x=6.67 //y=7.585
c1501 ( 969 0 ) capacitor c=0.00597439f //x=5.79 //y=7.585
c1502 ( 968 0 ) capacitor c=0.00597439f //x=4.93 //y=7.58
c1503 ( 966 0 ) capacitor c=0.14484f //x=3.82 //y=7.585
c1504 ( 965 0 ) capacitor c=0.00597439f //x=3.04 //y=7.585
c1505 ( 964 0 ) capacitor c=0.00597439f //x=2.16 //y=7.585
c1506 ( 963 0 ) capacitor c=0.27142f //x=1.23 //y=7.58
c1507 ( 959 0 ) capacitor c=0.369119f //x=83 //y=7.58
c1508 ( 944 0 ) capacitor c=0.131873f //x=80.24 //y=7.585
c1509 ( 909 0 ) capacitor c=0.133054f //x=76.91 //y=7.585
c1510 ( 903 0 ) capacitor c=0.0428422f //x=73.58 //y=7.585
c1511 ( 893 0 ) capacitor c=0.0288858f //x=72.585 //y=7.585
c1512 ( 885 0 ) capacitor c=0.0289326f //x=71.705 //y=7.585
c1513 ( 875 0 ) capacitor c=0.0290587f //x=70.825 //y=7.585
c1514 ( 863 0 ) capacitor c=0.0454973f //x=69.945 //y=7.585
c1515 ( 859 0 ) capacitor c=0.0261965f //x=68.77 //y=7.585
c1516 ( 851 0 ) capacitor c=0.0287376f //x=68.075 //y=7.585
c1517 ( 841 0 ) capacitor c=0.0291726f //x=67.195 //y=7.585
c1518 ( 829 0 ) capacitor c=0.0283511f //x=66.315 //y=7.585
c1519 ( 825 0 ) capacitor c=0.0277785f //x=65.44 //y=7.585
c1520 ( 815 0 ) capacitor c=0.0287377f //x=64.745 //y=7.585
c1521 ( 805 0 ) capacitor c=0.0291078f //x=63.865 //y=7.585
c1522 ( 795 0 ) capacitor c=0.0283511f //x=62.985 //y=7.585
c1523 ( 789 0 ) capacitor c=0.042257f //x=62.11 //y=7.585
c1524 ( 779 0 ) capacitor c=0.0288858f //x=61.115 //y=7.585
c1525 ( 769 0 ) capacitor c=0.0289326f //x=60.235 //y=7.585
c1526 ( 761 0 ) capacitor c=0.0290299f //x=59.355 //y=7.585
c1527 ( 751 0 ) capacitor c=0.0455283f //x=58.475 //y=7.585
c1528 ( 745 0 ) capacitor c=0.041708f //x=57.3 //y=7.585
c1529 ( 735 0 ) capacitor c=0.0288858f //x=56.305 //y=7.585
c1530 ( 725 0 ) capacitor c=0.0288437f //x=55.425 //y=7.585
c1531 ( 717 0 ) capacitor c=0.0290299f //x=54.545 //y=7.585
c1532 ( 707 0 ) capacitor c=0.0455283f //x=53.665 //y=7.585
c1533 ( 701 0 ) capacitor c=0.0277785f //x=52.49 //y=7.585
c1534 ( 691 0 ) capacitor c=0.0287376f //x=51.795 //y=7.585
c1535 ( 683 0 ) capacitor c=0.0291078f //x=50.915 //y=7.585
c1536 ( 673 0 ) capacitor c=0.0283511f //x=50.035 //y=7.585
c1537 ( 667 0 ) capacitor c=0.0428069f //x=49.16 //y=7.585
c1538 ( 657 0 ) capacitor c=0.0288858f //x=48.165 //y=7.585
c1539 ( 649 0 ) capacitor c=0.0289326f //x=47.285 //y=7.585
c1540 ( 639 0 ) capacitor c=0.0290299f //x=46.405 //y=7.585
c1541 ( 627 0 ) capacitor c=0.0455283f //x=45.525 //y=7.585
c1542 ( 623 0 ) capacitor c=0.0277785f //x=44.35 //y=7.585
c1543 ( 615 0 ) capacitor c=0.0287376f //x=43.655 //y=7.585
c1544 ( 605 0 ) capacitor c=0.0291726f //x=42.775 //y=7.585
c1545 ( 593 0 ) capacitor c=0.0283511f //x=41.895 //y=7.585
c1546 ( 589 0 ) capacitor c=0.0277785f //x=41.02 //y=7.585
c1547 ( 579 0 ) capacitor c=0.0287377f //x=40.325 //y=7.585
c1548 ( 569 0 ) capacitor c=0.0291078f //x=39.445 //y=7.585
c1549 ( 559 0 ) capacitor c=0.0283511f //x=38.565 //y=7.585
c1550 ( 553 0 ) capacitor c=0.042257f //x=37.69 //y=7.585
c1551 ( 543 0 ) capacitor c=0.0288858f //x=36.695 //y=7.585
c1552 ( 533 0 ) capacitor c=0.0289326f //x=35.815 //y=7.585
c1553 ( 525 0 ) capacitor c=0.0290299f //x=34.935 //y=7.585
c1554 ( 515 0 ) capacitor c=0.0455283f //x=34.055 //y=7.585
c1555 ( 509 0 ) capacitor c=0.041708f //x=32.88 //y=7.585
c1556 ( 499 0 ) capacitor c=0.0288858f //x=31.885 //y=7.585
c1557 ( 489 0 ) capacitor c=0.0288437f //x=31.005 //y=7.585
c1558 ( 481 0 ) capacitor c=0.0290299f //x=30.125 //y=7.585
c1559 ( 471 0 ) capacitor c=0.0455283f //x=29.245 //y=7.585
c1560 ( 465 0 ) capacitor c=0.0277785f //x=28.07 //y=7.585
c1561 ( 455 0 ) capacitor c=0.0287376f //x=27.375 //y=7.585
c1562 ( 447 0 ) capacitor c=0.0291078f //x=26.495 //y=7.585
c1563 ( 437 0 ) capacitor c=0.0283511f //x=25.615 //y=7.585
c1564 ( 431 0 ) capacitor c=0.0416617f //x=24.74 //y=7.585
c1565 ( 421 0 ) capacitor c=0.0288858f //x=23.745 //y=7.585
c1566 ( 413 0 ) capacitor c=0.0289326f //x=22.865 //y=7.585
c1567 ( 403 0 ) capacitor c=0.0290299f //x=21.985 //y=7.585
c1568 ( 391 0 ) capacitor c=0.0455283f //x=21.105 //y=7.585
c1569 ( 387 0 ) capacitor c=0.0277785f //x=19.93 //y=7.585
c1570 ( 379 0 ) capacitor c=0.0287376f //x=19.235 //y=7.585
c1571 ( 369 0 ) capacitor c=0.0291726f //x=18.355 //y=7.585
c1572 ( 357 0 ) capacitor c=0.0283511f //x=17.475 //y=7.585
c1573 ( 353 0 ) capacitor c=0.0277785f //x=16.6 //y=7.585
c1574 ( 343 0 ) capacitor c=0.0287377f //x=15.905 //y=7.585
c1575 ( 333 0 ) capacitor c=0.0291078f //x=15.025 //y=7.585
c1576 ( 323 0 ) capacitor c=0.0283511f //x=14.145 //y=7.585
c1577 ( 317 0 ) capacitor c=0.042257f //x=13.27 //y=7.585
c1578 ( 307 0 ) capacitor c=0.0288858f //x=12.275 //y=7.585
c1579 ( 297 0 ) capacitor c=0.0289326f //x=11.395 //y=7.585
c1580 ( 289 0 ) capacitor c=0.0290299f //x=10.515 //y=7.585
c1581 ( 279 0 ) capacitor c=0.0455283f //x=9.635 //y=7.585
c1582 ( 273 0 ) capacitor c=0.041708f //x=8.46 //y=7.585
c1583 ( 263 0 ) capacitor c=0.0288858f //x=7.465 //y=7.585
c1584 ( 253 0 ) capacitor c=0.0288437f //x=6.585 //y=7.585
c1585 ( 245 0 ) capacitor c=0.0290299f //x=5.705 //y=7.585
c1586 ( 235 0 ) capacitor c=0.0455283f //x=4.825 //y=7.585
c1587 ( 229 0 ) capacitor c=0.0277785f //x=3.65 //y=7.585
c1588 ( 219 0 ) capacitor c=0.0287376f //x=2.955 //y=7.585
c1589 ( 211 0 ) capacitor c=0.0291078f //x=2.075 //y=7.585
c1590 ( 196 0 ) capacitor c=0.00499323f //x=76.3 //y=7.585
c1591 ( 193 0 ) capacitor c=0.00499323f //x=75.42 //y=7.585
c1592 ( 188 0 ) capacitor c=0.00499323f //x=74.49 //y=7.58
c1593 ( 149 0 ) capacitor c=0.270843f //x=83 //y=7.58
c1594 ( 136 0 ) capacitor c=0.00657976f //x=76.3 //y=7.41
c1595 ( 135 0 ) capacitor c=0.00827249f //x=76.3 //y=7.035
c1596 ( 131 0 ) capacitor c=0.0220779f //x=76.215 //y=7.585
c1597 ( 130 0 ) capacitor c=0.00369726f //x=75.42 //y=7.41
c1598 ( 129 0 ) capacitor c=0.00650208f //x=75.42 //y=7.035
c1599 ( 127 0 ) capacitor c=0.02242f //x=75.335 //y=7.585
c1600 ( 126 0 ) capacitor c=0.0090067f //x=74.54 //y=7.41
c1601 ( 125 0 ) capacitor c=0.0125184f //x=74.54 //y=7.035
c1602 ( 2 0 ) capacitor c=2.66174f //x=74.455 //y=7.585
r1603 (  957 959 ) resistor r=38.7139 //w=0.367 //l=1.11 //layer=li \
 //thickness=0.1 //x=81.89 //y=7.585 //x2=83 //y2=7.585
r1604 (  955 957 ) resistor r=38.7139 //w=0.367 //l=1.11 //layer=li \
 //thickness=0.1 //x=80.78 //y=7.585 //x2=81.89 //y2=7.585
r1605 (  953 1056 ) resistor r=5.29055 //w=0.35 //l=0.17 //layer=li \
 //thickness=0.1 //x=80.58 //y=7.585 //x2=80.41 //y2=7.585
r1606 (  953 955 ) resistor r=6.97548 //w=0.367 //l=0.2 //layer=li \
 //thickness=0.1 //x=80.58 //y=7.585 //x2=80.78 //y2=7.585
r1607 (  947 949 ) resistor r=38.7139 //w=0.367 //l=1.11 //layer=li \
 //thickness=0.1 //x=78.19 //y=7.585 //x2=79.3 //y2=7.585
r1608 (  945 1055 ) resistor r=5.29055 //w=0.35 //l=0.17 //layer=li \
 //thickness=0.1 //x=77.25 //y=7.585 //x2=77.08 //y2=7.585
r1609 (  945 947 ) resistor r=32.7847 //w=0.367 //l=0.94 //layer=li \
 //thickness=0.1 //x=77.25 //y=7.585 //x2=78.19 //y2=7.585
r1610 (  944 1056 ) resistor r=5.29055 //w=0.35 //l=0.17 //layer=li \
 //thickness=0.1 //x=80.24 //y=7.585 //x2=80.41 //y2=7.585
r1611 (  944 949 ) resistor r=32.7847 //w=0.367 //l=0.94 //layer=li \
 //thickness=0.1 //x=80.24 //y=7.585 //x2=79.3 //y2=7.585
r1612 (  940 1122 ) resistor r=23.2727 //w=0.187 //l=0.34 //layer=li \
 //thickness=0.1 //x=76.3 //y=6.92 //x2=76.3 //y2=6.58
r1613 (  925 1120 ) resistor r=23.2727 //w=0.187 //l=0.34 //layer=li \
 //thickness=0.1 //x=74.54 //y=6.92 //x2=74.54 //y2=6.58
r1614 (  914 916 ) resistor r=38.7139 //w=0.367 //l=1.11 //layer=li \
 //thickness=0.1 //x=75.6 //y=7.585 //x2=76.71 //y2=7.585
r1615 (  912 914 ) resistor r=38.7139 //w=0.367 //l=1.11 //layer=li \
 //thickness=0.1 //x=74.49 //y=7.585 //x2=75.6 //y2=7.585
r1616 (  910 1054 ) resistor r=5.29055 //w=0.35 //l=0.17 //layer=li \
 //thickness=0.1 //x=73.92 //y=7.585 //x2=73.75 //y2=7.585
r1617 (  910 912 ) resistor r=19.8801 //w=0.367 //l=0.57 //layer=li \
 //thickness=0.1 //x=73.92 //y=7.585 //x2=74.49 //y2=7.585
r1618 (  909 1055 ) resistor r=5.29055 //w=0.35 //l=0.17 //layer=li \
 //thickness=0.1 //x=76.91 //y=7.585 //x2=77.08 //y2=7.585
r1619 (  909 916 ) resistor r=6.97548 //w=0.367 //l=0.2 //layer=li \
 //thickness=0.1 //x=76.91 //y=7.585 //x2=76.71 //y2=7.585
r1620 (  904 1053 ) resistor r=2.87058 //w=0.35 //l=0.085 //layer=li \
 //thickness=0.1 //x=72.755 //y=7.585 //x2=72.67 //y2=7.585
r1621 (  904 906 ) resistor r=8.89373 //w=0.367 //l=0.255 //layer=li \
 //thickness=0.1 //x=72.755 //y=7.585 //x2=73.01 //y2=7.585
r1622 (  903 1054 ) resistor r=5.29055 //w=0.35 //l=0.17 //layer=li \
 //thickness=0.1 //x=73.58 //y=7.585 //x2=73.75 //y2=7.585
r1623 (  903 906 ) resistor r=19.8801 //w=0.367 //l=0.57 //layer=li \
 //thickness=0.1 //x=73.58 //y=7.585 //x2=73.01 //y2=7.585
r1624 (  897 1053 ) resistor r=4.23183 //w=0.7 //l=0.175 //layer=li \
 //thickness=0.1 //x=72.67 //y=7.41 //x2=72.67 //y2=7.585
r1625 (  897 1119 ) resistor r=33.1979 //w=0.187 //l=0.485 //layer=li \
 //thickness=0.1 //x=72.67 //y=7.41 //x2=72.67 //y2=6.925
r1626 (  894 1052 ) resistor r=2.87058 //w=0.35 //l=0.085 //layer=li \
 //thickness=0.1 //x=71.875 //y=7.585 //x2=71.79 //y2=7.585
r1627 (  894 896 ) resistor r=0.871935 //w=0.367 //l=0.025 //layer=li \
 //thickness=0.1 //x=71.875 //y=7.585 //x2=71.9 //y2=7.585
r1628 (  893 1053 ) resistor r=2.87058 //w=0.35 //l=0.085 //layer=li \
 //thickness=0.1 //x=72.585 //y=7.585 //x2=72.67 //y2=7.585
r1629 (  893 896 ) resistor r=23.891 //w=0.367 //l=0.685 //layer=li \
 //thickness=0.1 //x=72.585 //y=7.585 //x2=71.9 //y2=7.585
r1630 (  887 1052 ) resistor r=4.23183 //w=0.7 //l=0.175 //layer=li \
 //thickness=0.1 //x=71.79 //y=7.41 //x2=71.79 //y2=7.585
r1631 (  887 1118 ) resistor r=33.1979 //w=0.187 //l=0.485 //layer=li \
 //thickness=0.1 //x=71.79 //y=7.41 //x2=71.79 //y2=6.925
r1632 (  886 1051 ) resistor r=2.87058 //w=0.35 //l=0.085 //layer=li \
 //thickness=0.1 //x=70.995 //y=7.585 //x2=70.91 //y2=7.585
r1633 (  885 1052 ) resistor r=2.87058 //w=0.35 //l=0.085 //layer=li \
 //thickness=0.1 //x=71.705 //y=7.585 //x2=71.79 //y2=7.585
r1634 (  885 886 ) resistor r=24.7629 //w=0.367 //l=0.71 //layer=li \
 //thickness=0.1 //x=71.705 //y=7.585 //x2=70.995 //y2=7.585
r1635 (  879 1051 ) resistor r=4.23183 //w=0.7 //l=0.175 //layer=li \
 //thickness=0.1 //x=70.91 //y=7.41 //x2=70.91 //y2=7.585
r1636 (  879 1117 ) resistor r=33.1979 //w=0.187 //l=0.485 //layer=li \
 //thickness=0.1 //x=70.91 //y=7.41 //x2=70.91 //y2=6.925
r1637 (  876 1050 ) resistor r=2.87058 //w=0.35 //l=0.085 //layer=li \
 //thickness=0.1 //x=70.115 //y=7.585 //x2=70.03 //y2=7.585
r1638 (  876 878 ) resistor r=23.5422 //w=0.367 //l=0.675 //layer=li \
 //thickness=0.1 //x=70.115 //y=7.585 //x2=70.79 //y2=7.585
r1639 (  875 1051 ) resistor r=2.87058 //w=0.35 //l=0.085 //layer=li \
 //thickness=0.1 //x=70.825 //y=7.585 //x2=70.91 //y2=7.585
r1640 (  875 878 ) resistor r=1.22071 //w=0.367 //l=0.035 //layer=li \
 //thickness=0.1 //x=70.825 //y=7.585 //x2=70.79 //y2=7.585
r1641 (  867 1050 ) resistor r=4.23183 //w=0.7 //l=0.175 //layer=li \
 //thickness=0.1 //x=70.03 //y=7.41 //x2=70.03 //y2=7.585
r1642 (  867 1116 ) resistor r=56.4706 //w=0.187 //l=0.825 //layer=li \
 //thickness=0.1 //x=70.03 //y=7.41 //x2=70.03 //y2=6.585
r1643 (  864 1049 ) resistor r=5.29055 //w=0.35 //l=0.17 //layer=li \
 //thickness=0.1 //x=69.11 //y=7.585 //x2=68.94 //y2=7.585
r1644 (  864 866 ) resistor r=19.8801 //w=0.367 //l=0.57 //layer=li \
 //thickness=0.1 //x=69.11 //y=7.585 //x2=69.68 //y2=7.585
r1645 (  863 1050 ) resistor r=2.87058 //w=0.35 //l=0.085 //layer=li \
 //thickness=0.1 //x=69.945 //y=7.585 //x2=70.03 //y2=7.585
r1646 (  863 866 ) resistor r=9.24251 //w=0.367 //l=0.265 //layer=li \
 //thickness=0.1 //x=69.945 //y=7.585 //x2=69.68 //y2=7.585
r1647 (  860 1048 ) resistor r=2.87058 //w=0.35 //l=0.085 //layer=li \
 //thickness=0.1 //x=68.245 //y=7.585 //x2=68.16 //y2=7.585
r1648 (  859 1049 ) resistor r=5.29055 //w=0.35 //l=0.17 //layer=li \
 //thickness=0.1 //x=68.77 //y=7.585 //x2=68.94 //y2=7.585
r1649 (  859 860 ) resistor r=18.3106 //w=0.367 //l=0.525 //layer=li \
 //thickness=0.1 //x=68.77 //y=7.585 //x2=68.245 //y2=7.585
r1650 (  853 1048 ) resistor r=4.23183 //w=0.7 //l=0.175 //layer=li \
 //thickness=0.1 //x=68.16 //y=7.41 //x2=68.16 //y2=7.585
r1651 (  853 1115 ) resistor r=33.1979 //w=0.187 //l=0.485 //layer=li \
 //thickness=0.1 //x=68.16 //y=7.41 //x2=68.16 //y2=6.925
r1652 (  852 1046 ) resistor r=2.87058 //w=0.35 //l=0.085 //layer=li \
 //thickness=0.1 //x=67.365 //y=7.585 //x2=67.28 //y2=7.585
r1653 (  851 1048 ) resistor r=2.87058 //w=0.35 //l=0.085 //layer=li \
 //thickness=0.1 //x=68.075 //y=7.585 //x2=68.16 //y2=7.585
r1654 (  851 852 ) resistor r=24.7629 //w=0.367 //l=0.71 //layer=li \
 //thickness=0.1 //x=68.075 //y=7.585 //x2=67.365 //y2=7.585
r1655 (  845 1046 ) resistor r=4.23183 //w=0.7 //l=0.175 //layer=li \
 //thickness=0.1 //x=67.28 //y=7.41 //x2=67.28 //y2=7.585
r1656 (  845 1114 ) resistor r=33.1979 //w=0.187 //l=0.485 //layer=li \
 //thickness=0.1 //x=67.28 //y=7.41 //x2=67.28 //y2=6.925
r1657 (  842 1045 ) resistor r=2.87058 //w=0.35 //l=0.085 //layer=li \
 //thickness=0.1 //x=66.485 //y=7.585 //x2=66.4 //y2=7.585
r1658 (  842 844 ) resistor r=21.1008 //w=0.367 //l=0.605 //layer=li \
 //thickness=0.1 //x=66.485 //y=7.585 //x2=67.09 //y2=7.585
r1659 (  841 1046 ) resistor r=2.87058 //w=0.35 //l=0.085 //layer=li \
 //thickness=0.1 //x=67.195 //y=7.585 //x2=67.28 //y2=7.585
r1660 (  841 844 ) resistor r=3.66213 //w=0.367 //l=0.105 //layer=li \
 //thickness=0.1 //x=67.195 //y=7.585 //x2=67.09 //y2=7.585
r1661 (  833 1045 ) resistor r=4.23183 //w=0.7 //l=0.175 //layer=li \
 //thickness=0.1 //x=66.4 //y=7.41 //x2=66.4 //y2=7.585
r1662 (  833 1113 ) resistor r=56.4706 //w=0.187 //l=0.825 //layer=li \
 //thickness=0.1 //x=66.4 //y=7.41 //x2=66.4 //y2=6.585
r1663 (  830 1044 ) resistor r=5.29055 //w=0.35 //l=0.17 //layer=li \
 //thickness=0.1 //x=65.78 //y=7.585 //x2=65.61 //y2=7.585
r1664 (  830 832 ) resistor r=6.97548 //w=0.367 //l=0.2 //layer=li \
 //thickness=0.1 //x=65.78 //y=7.585 //x2=65.98 //y2=7.585
r1665 (  829 1045 ) resistor r=2.87058 //w=0.35 //l=0.085 //layer=li \
 //thickness=0.1 //x=66.315 //y=7.585 //x2=66.4 //y2=7.585
r1666 (  829 832 ) resistor r=11.6839 //w=0.367 //l=0.335 //layer=li \
 //thickness=0.1 //x=66.315 //y=7.585 //x2=65.98 //y2=7.585
r1667 (  826 1043 ) resistor r=2.87058 //w=0.35 //l=0.085 //layer=li \
 //thickness=0.1 //x=64.915 //y=7.585 //x2=64.83 //y2=7.585
r1668 (  825 1044 ) resistor r=5.29055 //w=0.35 //l=0.17 //layer=li \
 //thickness=0.1 //x=65.44 //y=7.585 //x2=65.61 //y2=7.585
r1669 (  825 826 ) resistor r=18.3106 //w=0.367 //l=0.525 //layer=li \
 //thickness=0.1 //x=65.44 //y=7.585 //x2=64.915 //y2=7.585
r1670 (  819 1043 ) resistor r=4.23183 //w=0.7 //l=0.175 //layer=li \
 //thickness=0.1 //x=64.83 //y=7.41 //x2=64.83 //y2=7.585
r1671 (  819 1112 ) resistor r=33.1979 //w=0.187 //l=0.485 //layer=li \
 //thickness=0.1 //x=64.83 //y=7.41 //x2=64.83 //y2=6.925
r1672 (  816 1042 ) resistor r=2.87058 //w=0.35 //l=0.085 //layer=li \
 //thickness=0.1 //x=64.035 //y=7.585 //x2=63.95 //y2=7.585
r1673 (  816 818 ) resistor r=16.218 //w=0.367 //l=0.465 //layer=li \
 //thickness=0.1 //x=64.035 //y=7.585 //x2=64.5 //y2=7.585
r1674 (  815 1043 ) resistor r=2.87058 //w=0.35 //l=0.085 //layer=li \
 //thickness=0.1 //x=64.745 //y=7.585 //x2=64.83 //y2=7.585
r1675 (  815 818 ) resistor r=8.54496 //w=0.367 //l=0.245 //layer=li \
 //thickness=0.1 //x=64.745 //y=7.585 //x2=64.5 //y2=7.585
r1676 (  809 1042 ) resistor r=4.23183 //w=0.7 //l=0.175 //layer=li \
 //thickness=0.1 //x=63.95 //y=7.41 //x2=63.95 //y2=7.585
r1677 (  809 1111 ) resistor r=33.1979 //w=0.187 //l=0.485 //layer=li \
 //thickness=0.1 //x=63.95 //y=7.41 //x2=63.95 //y2=6.925
r1678 (  806 1041 ) resistor r=2.87058 //w=0.35 //l=0.085 //layer=li \
 //thickness=0.1 //x=63.155 //y=7.585 //x2=63.07 //y2=7.585
r1679 (  806 808 ) resistor r=8.19619 //w=0.367 //l=0.235 //layer=li \
 //thickness=0.1 //x=63.155 //y=7.585 //x2=63.39 //y2=7.585
r1680 (  805 1042 ) resistor r=2.87058 //w=0.35 //l=0.085 //layer=li \
 //thickness=0.1 //x=63.865 //y=7.585 //x2=63.95 //y2=7.585
r1681 (  805 808 ) resistor r=16.5668 //w=0.367 //l=0.475 //layer=li \
 //thickness=0.1 //x=63.865 //y=7.585 //x2=63.39 //y2=7.585
r1682 (  797 1041 ) resistor r=4.23183 //w=0.7 //l=0.175 //layer=li \
 //thickness=0.1 //x=63.07 //y=7.41 //x2=63.07 //y2=7.585
r1683 (  797 1110 ) resistor r=56.4706 //w=0.187 //l=0.825 //layer=li \
 //thickness=0.1 //x=63.07 //y=7.41 //x2=63.07 //y2=6.585
r1684 (  796 1040 ) resistor r=5.29055 //w=0.35 //l=0.17 //layer=li \
 //thickness=0.1 //x=62.45 //y=7.585 //x2=62.28 //y2=7.585
r1685 (  795 1041 ) resistor r=2.87058 //w=0.35 //l=0.085 //layer=li \
 //thickness=0.1 //x=62.985 //y=7.585 //x2=63.07 //y2=7.585
r1686 (  795 796 ) resistor r=18.6594 //w=0.367 //l=0.535 //layer=li \
 //thickness=0.1 //x=62.985 //y=7.585 //x2=62.45 //y2=7.585
r1687 (  790 1039 ) resistor r=2.87058 //w=0.35 //l=0.085 //layer=li \
 //thickness=0.1 //x=61.285 //y=7.585 //x2=61.2 //y2=7.585
r1688 (  790 792 ) resistor r=21.7984 //w=0.367 //l=0.625 //layer=li \
 //thickness=0.1 //x=61.285 //y=7.585 //x2=61.91 //y2=7.585
r1689 (  789 1040 ) resistor r=5.29055 //w=0.35 //l=0.17 //layer=li \
 //thickness=0.1 //x=62.11 //y=7.585 //x2=62.28 //y2=7.585
r1690 (  789 792 ) resistor r=6.97548 //w=0.367 //l=0.2 //layer=li \
 //thickness=0.1 //x=62.11 //y=7.585 //x2=61.91 //y2=7.585
r1691 (  783 1039 ) resistor r=4.23183 //w=0.7 //l=0.175 //layer=li \
 //thickness=0.1 //x=61.2 //y=7.41 //x2=61.2 //y2=7.585
r1692 (  783 1109 ) resistor r=33.1979 //w=0.187 //l=0.485 //layer=li \
 //thickness=0.1 //x=61.2 //y=7.41 //x2=61.2 //y2=6.925
r1693 (  780 1038 ) resistor r=2.87058 //w=0.35 //l=0.085 //layer=li \
 //thickness=0.1 //x=60.405 //y=7.585 //x2=60.32 //y2=7.585
r1694 (  780 782 ) resistor r=13.7766 //w=0.367 //l=0.395 //layer=li \
 //thickness=0.1 //x=60.405 //y=7.585 //x2=60.8 //y2=7.585
r1695 (  779 1039 ) resistor r=2.87058 //w=0.35 //l=0.085 //layer=li \
 //thickness=0.1 //x=61.115 //y=7.585 //x2=61.2 //y2=7.585
r1696 (  779 782 ) resistor r=10.9864 //w=0.367 //l=0.315 //layer=li \
 //thickness=0.1 //x=61.115 //y=7.585 //x2=60.8 //y2=7.585
r1697 (  773 1038 ) resistor r=4.23183 //w=0.7 //l=0.175 //layer=li \
 //thickness=0.1 //x=60.32 //y=7.41 //x2=60.32 //y2=7.585
r1698 (  773 1108 ) resistor r=33.1979 //w=0.187 //l=0.485 //layer=li \
 //thickness=0.1 //x=60.32 //y=7.41 //x2=60.32 //y2=6.925
r1699 (  770 1037 ) resistor r=2.87058 //w=0.35 //l=0.085 //layer=li \
 //thickness=0.1 //x=59.525 //y=7.585 //x2=59.44 //y2=7.585
r1700 (  770 772 ) resistor r=5.75477 //w=0.367 //l=0.165 //layer=li \
 //thickness=0.1 //x=59.525 //y=7.585 //x2=59.69 //y2=7.585
r1701 (  769 1038 ) resistor r=2.87058 //w=0.35 //l=0.085 //layer=li \
 //thickness=0.1 //x=60.235 //y=7.585 //x2=60.32 //y2=7.585
r1702 (  769 772 ) resistor r=19.0082 //w=0.367 //l=0.545 //layer=li \
 //thickness=0.1 //x=60.235 //y=7.585 //x2=59.69 //y2=7.585
r1703 (  763 1037 ) resistor r=4.23183 //w=0.7 //l=0.175 //layer=li \
 //thickness=0.1 //x=59.44 //y=7.41 //x2=59.44 //y2=7.585
r1704 (  763 1107 ) resistor r=33.1979 //w=0.187 //l=0.485 //layer=li \
 //thickness=0.1 //x=59.44 //y=7.41 //x2=59.44 //y2=6.925
r1705 (  762 1036 ) resistor r=2.87058 //w=0.35 //l=0.085 //layer=li \
 //thickness=0.1 //x=58.645 //y=7.585 //x2=58.56 //y2=7.585
r1706 (  761 1037 ) resistor r=2.87058 //w=0.35 //l=0.085 //layer=li \
 //thickness=0.1 //x=59.355 //y=7.585 //x2=59.44 //y2=7.585
r1707 (  761 762 ) resistor r=24.7629 //w=0.367 //l=0.71 //layer=li \
 //thickness=0.1 //x=59.355 //y=7.585 //x2=58.645 //y2=7.585
r1708 (  753 1036 ) resistor r=4.23183 //w=0.7 //l=0.175 //layer=li \
 //thickness=0.1 //x=58.56 //y=7.41 //x2=58.56 //y2=7.585
r1709 (  753 1106 ) resistor r=56.4706 //w=0.187 //l=0.825 //layer=li \
 //thickness=0.1 //x=58.56 //y=7.41 //x2=58.56 //y2=6.585
r1710 (  752 1034 ) resistor r=5.29055 //w=0.35 //l=0.17 //layer=li \
 //thickness=0.1 //x=57.64 //y=7.585 //x2=57.47 //y2=7.585
r1711 (  751 1036 ) resistor r=2.87058 //w=0.35 //l=0.085 //layer=li \
 //thickness=0.1 //x=58.475 //y=7.585 //x2=58.56 //y2=7.585
r1712 (  751 752 ) resistor r=29.1226 //w=0.367 //l=0.835 //layer=li \
 //thickness=0.1 //x=58.475 //y=7.585 //x2=57.64 //y2=7.585
r1713 (  746 1033 ) resistor r=2.87058 //w=0.35 //l=0.085 //layer=li \
 //thickness=0.1 //x=56.475 //y=7.585 //x2=56.39 //y2=7.585
r1714 (  746 748 ) resistor r=21.7984 //w=0.367 //l=0.625 //layer=li \
 //thickness=0.1 //x=56.475 //y=7.585 //x2=57.1 //y2=7.585
r1715 (  745 1034 ) resistor r=5.29055 //w=0.35 //l=0.17 //layer=li \
 //thickness=0.1 //x=57.3 //y=7.585 //x2=57.47 //y2=7.585
r1716 (  745 748 ) resistor r=6.97548 //w=0.367 //l=0.2 //layer=li \
 //thickness=0.1 //x=57.3 //y=7.585 //x2=57.1 //y2=7.585
r1717 (  739 1033 ) resistor r=4.23183 //w=0.7 //l=0.175 //layer=li \
 //thickness=0.1 //x=56.39 //y=7.41 //x2=56.39 //y2=7.585
r1718 (  739 1105 ) resistor r=33.1979 //w=0.187 //l=0.485 //layer=li \
 //thickness=0.1 //x=56.39 //y=7.41 //x2=56.39 //y2=6.925
r1719 (  736 1032 ) resistor r=2.87058 //w=0.35 //l=0.085 //layer=li \
 //thickness=0.1 //x=55.595 //y=7.585 //x2=55.51 //y2=7.585
r1720 (  736 738 ) resistor r=13.7766 //w=0.367 //l=0.395 //layer=li \
 //thickness=0.1 //x=55.595 //y=7.585 //x2=55.99 //y2=7.585
r1721 (  735 1033 ) resistor r=2.87058 //w=0.35 //l=0.085 //layer=li \
 //thickness=0.1 //x=56.305 //y=7.585 //x2=56.39 //y2=7.585
r1722 (  735 738 ) resistor r=10.9864 //w=0.367 //l=0.315 //layer=li \
 //thickness=0.1 //x=56.305 //y=7.585 //x2=55.99 //y2=7.585
r1723 (  729 1032 ) resistor r=4.23183 //w=0.7 //l=0.175 //layer=li \
 //thickness=0.1 //x=55.51 //y=7.41 //x2=55.51 //y2=7.585
r1724 (  729 1104 ) resistor r=33.1979 //w=0.187 //l=0.485 //layer=li \
 //thickness=0.1 //x=55.51 //y=7.41 //x2=55.51 //y2=6.925
r1725 (  726 1031 ) resistor r=2.87058 //w=0.35 //l=0.085 //layer=li \
 //thickness=0.1 //x=54.715 //y=7.585 //x2=54.63 //y2=7.585
r1726 (  726 728 ) resistor r=5.75477 //w=0.367 //l=0.165 //layer=li \
 //thickness=0.1 //x=54.715 //y=7.585 //x2=54.88 //y2=7.585
r1727 (  725 1032 ) resistor r=2.87058 //w=0.35 //l=0.085 //layer=li \
 //thickness=0.1 //x=55.425 //y=7.585 //x2=55.51 //y2=7.585
r1728 (  725 728 ) resistor r=19.0082 //w=0.367 //l=0.545 //layer=li \
 //thickness=0.1 //x=55.425 //y=7.585 //x2=54.88 //y2=7.585
r1729 (  719 1031 ) resistor r=4.23183 //w=0.7 //l=0.175 //layer=li \
 //thickness=0.1 //x=54.63 //y=7.41 //x2=54.63 //y2=7.585
r1730 (  719 1103 ) resistor r=33.1979 //w=0.187 //l=0.485 //layer=li \
 //thickness=0.1 //x=54.63 //y=7.41 //x2=54.63 //y2=6.925
r1731 (  718 1030 ) resistor r=2.87058 //w=0.35 //l=0.085 //layer=li \
 //thickness=0.1 //x=53.835 //y=7.585 //x2=53.75 //y2=7.585
r1732 (  717 1031 ) resistor r=2.87058 //w=0.35 //l=0.085 //layer=li \
 //thickness=0.1 //x=54.545 //y=7.585 //x2=54.63 //y2=7.585
r1733 (  717 718 ) resistor r=24.7629 //w=0.367 //l=0.71 //layer=li \
 //thickness=0.1 //x=54.545 //y=7.585 //x2=53.835 //y2=7.585
r1734 (  709 1030 ) resistor r=4.23183 //w=0.7 //l=0.175 //layer=li \
 //thickness=0.1 //x=53.75 //y=7.41 //x2=53.75 //y2=7.585
r1735 (  709 1102 ) resistor r=56.4706 //w=0.187 //l=0.825 //layer=li \
 //thickness=0.1 //x=53.75 //y=7.41 //x2=53.75 //y2=6.585
r1736 (  708 1028 ) resistor r=5.29055 //w=0.35 //l=0.17 //layer=li \
 //thickness=0.1 //x=52.83 //y=7.585 //x2=52.66 //y2=7.585
r1737 (  707 1030 ) resistor r=2.87058 //w=0.35 //l=0.085 //layer=li \
 //thickness=0.1 //x=53.665 //y=7.585 //x2=53.75 //y2=7.585
r1738 (  707 708 ) resistor r=29.1226 //w=0.367 //l=0.835 //layer=li \
 //thickness=0.1 //x=53.665 //y=7.585 //x2=52.83 //y2=7.585
r1739 (  702 1027 ) resistor r=2.87058 //w=0.35 //l=0.085 //layer=li \
 //thickness=0.1 //x=51.965 //y=7.585 //x2=51.88 //y2=7.585
r1740 (  702 704 ) resistor r=11.3351 //w=0.367 //l=0.325 //layer=li \
 //thickness=0.1 //x=51.965 //y=7.585 //x2=52.29 //y2=7.585
r1741 (  701 1028 ) resistor r=5.29055 //w=0.35 //l=0.17 //layer=li \
 //thickness=0.1 //x=52.49 //y=7.585 //x2=52.66 //y2=7.585
r1742 (  701 704 ) resistor r=6.97548 //w=0.367 //l=0.2 //layer=li \
 //thickness=0.1 //x=52.49 //y=7.585 //x2=52.29 //y2=7.585
r1743 (  695 1027 ) resistor r=4.23183 //w=0.7 //l=0.175 //layer=li \
 //thickness=0.1 //x=51.88 //y=7.41 //x2=51.88 //y2=7.585
r1744 (  695 1101 ) resistor r=33.1979 //w=0.187 //l=0.485 //layer=li \
 //thickness=0.1 //x=51.88 //y=7.41 //x2=51.88 //y2=6.925
r1745 (  692 1026 ) resistor r=2.87058 //w=0.35 //l=0.085 //layer=li \
 //thickness=0.1 //x=51.085 //y=7.585 //x2=51 //y2=7.585
r1746 (  692 694 ) resistor r=3.31335 //w=0.367 //l=0.095 //layer=li \
 //thickness=0.1 //x=51.085 //y=7.585 //x2=51.18 //y2=7.585
r1747 (  691 1027 ) resistor r=2.87058 //w=0.35 //l=0.085 //layer=li \
 //thickness=0.1 //x=51.795 //y=7.585 //x2=51.88 //y2=7.585
r1748 (  691 694 ) resistor r=21.4496 //w=0.367 //l=0.615 //layer=li \
 //thickness=0.1 //x=51.795 //y=7.585 //x2=51.18 //y2=7.585
r1749 (  685 1026 ) resistor r=4.23183 //w=0.7 //l=0.175 //layer=li \
 //thickness=0.1 //x=51 //y=7.41 //x2=51 //y2=7.585
r1750 (  685 1100 ) resistor r=33.1979 //w=0.187 //l=0.485 //layer=li \
 //thickness=0.1 //x=51 //y=7.41 //x2=51 //y2=6.925
r1751 (  684 1025 ) resistor r=2.87058 //w=0.35 //l=0.085 //layer=li \
 //thickness=0.1 //x=50.205 //y=7.585 //x2=50.12 //y2=7.585
r1752 (  683 1026 ) resistor r=2.87058 //w=0.35 //l=0.085 //layer=li \
 //thickness=0.1 //x=50.915 //y=7.585 //x2=51 //y2=7.585
r1753 (  683 684 ) resistor r=24.7629 //w=0.367 //l=0.71 //layer=li \
 //thickness=0.1 //x=50.915 //y=7.585 //x2=50.205 //y2=7.585
r1754 (  675 1025 ) resistor r=4.23183 //w=0.7 //l=0.175 //layer=li \
 //thickness=0.1 //x=50.12 //y=7.41 //x2=50.12 //y2=7.585
r1755 (  675 1099 ) resistor r=56.4706 //w=0.187 //l=0.825 //layer=li \
 //thickness=0.1 //x=50.12 //y=7.41 //x2=50.12 //y2=6.585
r1756 (  674 1023 ) resistor r=5.29055 //w=0.35 //l=0.17 //layer=li \
 //thickness=0.1 //x=49.5 //y=7.585 //x2=49.33 //y2=7.585
r1757 (  673 1025 ) resistor r=2.87058 //w=0.35 //l=0.085 //layer=li \
 //thickness=0.1 //x=50.035 //y=7.585 //x2=50.12 //y2=7.585
r1758 (  673 674 ) resistor r=18.6594 //w=0.367 //l=0.535 //layer=li \
 //thickness=0.1 //x=50.035 //y=7.585 //x2=49.5 //y2=7.585
r1759 (  668 1022 ) resistor r=2.87058 //w=0.35 //l=0.085 //layer=li \
 //thickness=0.1 //x=48.335 //y=7.585 //x2=48.25 //y2=7.585
r1760 (  668 670 ) resistor r=8.89373 //w=0.367 //l=0.255 //layer=li \
 //thickness=0.1 //x=48.335 //y=7.585 //x2=48.59 //y2=7.585
r1761 (  667 1023 ) resistor r=5.29055 //w=0.35 //l=0.17 //layer=li \
 //thickness=0.1 //x=49.16 //y=7.585 //x2=49.33 //y2=7.585
r1762 (  667 670 ) resistor r=19.8801 //w=0.367 //l=0.57 //layer=li \
 //thickness=0.1 //x=49.16 //y=7.585 //x2=48.59 //y2=7.585
r1763 (  661 1022 ) resistor r=4.23183 //w=0.7 //l=0.175 //layer=li \
 //thickness=0.1 //x=48.25 //y=7.41 //x2=48.25 //y2=7.585
r1764 (  661 1098 ) resistor r=33.1979 //w=0.187 //l=0.485 //layer=li \
 //thickness=0.1 //x=48.25 //y=7.41 //x2=48.25 //y2=6.925
r1765 (  658 1021 ) resistor r=2.87058 //w=0.35 //l=0.085 //layer=li \
 //thickness=0.1 //x=47.455 //y=7.585 //x2=47.37 //y2=7.585
r1766 (  658 660 ) resistor r=0.871935 //w=0.367 //l=0.025 //layer=li \
 //thickness=0.1 //x=47.455 //y=7.585 //x2=47.48 //y2=7.585
r1767 (  657 1022 ) resistor r=2.87058 //w=0.35 //l=0.085 //layer=li \
 //thickness=0.1 //x=48.165 //y=7.585 //x2=48.25 //y2=7.585
r1768 (  657 660 ) resistor r=23.891 //w=0.367 //l=0.685 //layer=li \
 //thickness=0.1 //x=48.165 //y=7.585 //x2=47.48 //y2=7.585
r1769 (  651 1021 ) resistor r=4.23183 //w=0.7 //l=0.175 //layer=li \
 //thickness=0.1 //x=47.37 //y=7.41 //x2=47.37 //y2=7.585
r1770 (  651 1097 ) resistor r=33.1979 //w=0.187 //l=0.485 //layer=li \
 //thickness=0.1 //x=47.37 //y=7.41 //x2=47.37 //y2=6.925
r1771 (  650 1020 ) resistor r=2.87058 //w=0.35 //l=0.085 //layer=li \
 //thickness=0.1 //x=46.575 //y=7.585 //x2=46.49 //y2=7.585
r1772 (  649 1021 ) resistor r=2.87058 //w=0.35 //l=0.085 //layer=li \
 //thickness=0.1 //x=47.285 //y=7.585 //x2=47.37 //y2=7.585
r1773 (  649 650 ) resistor r=24.7629 //w=0.367 //l=0.71 //layer=li \
 //thickness=0.1 //x=47.285 //y=7.585 //x2=46.575 //y2=7.585
r1774 (  643 1020 ) resistor r=4.23183 //w=0.7 //l=0.175 //layer=li \
 //thickness=0.1 //x=46.49 //y=7.41 //x2=46.49 //y2=7.585
r1775 (  643 1096 ) resistor r=33.1979 //w=0.187 //l=0.485 //layer=li \
 //thickness=0.1 //x=46.49 //y=7.41 //x2=46.49 //y2=6.925
r1776 (  640 1019 ) resistor r=2.87058 //w=0.35 //l=0.085 //layer=li \
 //thickness=0.1 //x=45.695 //y=7.585 //x2=45.61 //y2=7.585
r1777 (  640 642 ) resistor r=23.5422 //w=0.367 //l=0.675 //layer=li \
 //thickness=0.1 //x=45.695 //y=7.585 //x2=46.37 //y2=7.585
r1778 (  639 1020 ) resistor r=2.87058 //w=0.35 //l=0.085 //layer=li \
 //thickness=0.1 //x=46.405 //y=7.585 //x2=46.49 //y2=7.585
r1779 (  639 642 ) resistor r=1.22071 //w=0.367 //l=0.035 //layer=li \
 //thickness=0.1 //x=46.405 //y=7.585 //x2=46.37 //y2=7.585
r1780 (  631 1019 ) resistor r=4.23183 //w=0.7 //l=0.175 //layer=li \
 //thickness=0.1 //x=45.61 //y=7.41 //x2=45.61 //y2=7.585
r1781 (  631 1095 ) resistor r=56.4706 //w=0.187 //l=0.825 //layer=li \
 //thickness=0.1 //x=45.61 //y=7.41 //x2=45.61 //y2=6.585
r1782 (  628 1018 ) resistor r=5.29055 //w=0.35 //l=0.17 //layer=li \
 //thickness=0.1 //x=44.69 //y=7.585 //x2=44.52 //y2=7.585
r1783 (  628 630 ) resistor r=19.8801 //w=0.367 //l=0.57 //layer=li \
 //thickness=0.1 //x=44.69 //y=7.585 //x2=45.26 //y2=7.585
r1784 (  627 1019 ) resistor r=2.87058 //w=0.35 //l=0.085 //layer=li \
 //thickness=0.1 //x=45.525 //y=7.585 //x2=45.61 //y2=7.585
r1785 (  627 630 ) resistor r=9.24251 //w=0.367 //l=0.265 //layer=li \
 //thickness=0.1 //x=45.525 //y=7.585 //x2=45.26 //y2=7.585
r1786 (  624 1017 ) resistor r=2.87058 //w=0.35 //l=0.085 //layer=li \
 //thickness=0.1 //x=43.825 //y=7.585 //x2=43.74 //y2=7.585
r1787 (  623 1018 ) resistor r=5.29055 //w=0.35 //l=0.17 //layer=li \
 //thickness=0.1 //x=44.35 //y=7.585 //x2=44.52 //y2=7.585
r1788 (  623 624 ) resistor r=18.3106 //w=0.367 //l=0.525 //layer=li \
 //thickness=0.1 //x=44.35 //y=7.585 //x2=43.825 //y2=7.585
r1789 (  617 1017 ) resistor r=4.23183 //w=0.7 //l=0.175 //layer=li \
 //thickness=0.1 //x=43.74 //y=7.41 //x2=43.74 //y2=7.585
r1790 (  617 1094 ) resistor r=33.1979 //w=0.187 //l=0.485 //layer=li \
 //thickness=0.1 //x=43.74 //y=7.41 //x2=43.74 //y2=6.925
r1791 (  616 1015 ) resistor r=2.87058 //w=0.35 //l=0.085 //layer=li \
 //thickness=0.1 //x=42.945 //y=7.585 //x2=42.86 //y2=7.585
r1792 (  615 1017 ) resistor r=2.87058 //w=0.35 //l=0.085 //layer=li \
 //thickness=0.1 //x=43.655 //y=7.585 //x2=43.74 //y2=7.585
r1793 (  615 616 ) resistor r=24.7629 //w=0.367 //l=0.71 //layer=li \
 //thickness=0.1 //x=43.655 //y=7.585 //x2=42.945 //y2=7.585
r1794 (  609 1015 ) resistor r=4.23183 //w=0.7 //l=0.175 //layer=li \
 //thickness=0.1 //x=42.86 //y=7.41 //x2=42.86 //y2=7.585
r1795 (  609 1093 ) resistor r=33.1979 //w=0.187 //l=0.485 //layer=li \
 //thickness=0.1 //x=42.86 //y=7.41 //x2=42.86 //y2=6.925
r1796 (  606 1014 ) resistor r=2.87058 //w=0.35 //l=0.085 //layer=li \
 //thickness=0.1 //x=42.065 //y=7.585 //x2=41.98 //y2=7.585
r1797 (  606 608 ) resistor r=21.1008 //w=0.367 //l=0.605 //layer=li \
 //thickness=0.1 //x=42.065 //y=7.585 //x2=42.67 //y2=7.585
r1798 (  605 1015 ) resistor r=2.87058 //w=0.35 //l=0.085 //layer=li \
 //thickness=0.1 //x=42.775 //y=7.585 //x2=42.86 //y2=7.585
r1799 (  605 608 ) resistor r=3.66213 //w=0.367 //l=0.105 //layer=li \
 //thickness=0.1 //x=42.775 //y=7.585 //x2=42.67 //y2=7.585
r1800 (  597 1014 ) resistor r=4.23183 //w=0.7 //l=0.175 //layer=li \
 //thickness=0.1 //x=41.98 //y=7.41 //x2=41.98 //y2=7.585
r1801 (  597 1092 ) resistor r=56.4706 //w=0.187 //l=0.825 //layer=li \
 //thickness=0.1 //x=41.98 //y=7.41 //x2=41.98 //y2=6.585
r1802 (  594 1013 ) resistor r=5.29055 //w=0.35 //l=0.17 //layer=li \
 //thickness=0.1 //x=41.36 //y=7.585 //x2=41.19 //y2=7.585
r1803 (  594 596 ) resistor r=6.97548 //w=0.367 //l=0.2 //layer=li \
 //thickness=0.1 //x=41.36 //y=7.585 //x2=41.56 //y2=7.585
r1804 (  593 1014 ) resistor r=2.87058 //w=0.35 //l=0.085 //layer=li \
 //thickness=0.1 //x=41.895 //y=7.585 //x2=41.98 //y2=7.585
r1805 (  593 596 ) resistor r=11.6839 //w=0.367 //l=0.335 //layer=li \
 //thickness=0.1 //x=41.895 //y=7.585 //x2=41.56 //y2=7.585
r1806 (  590 1012 ) resistor r=2.87058 //w=0.35 //l=0.085 //layer=li \
 //thickness=0.1 //x=40.495 //y=7.585 //x2=40.41 //y2=7.585
r1807 (  589 1013 ) resistor r=5.29055 //w=0.35 //l=0.17 //layer=li \
 //thickness=0.1 //x=41.02 //y=7.585 //x2=41.19 //y2=7.585
r1808 (  589 590 ) resistor r=18.3106 //w=0.367 //l=0.525 //layer=li \
 //thickness=0.1 //x=41.02 //y=7.585 //x2=40.495 //y2=7.585
r1809 (  583 1012 ) resistor r=4.23183 //w=0.7 //l=0.175 //layer=li \
 //thickness=0.1 //x=40.41 //y=7.41 //x2=40.41 //y2=7.585
r1810 (  583 1091 ) resistor r=33.1979 //w=0.187 //l=0.485 //layer=li \
 //thickness=0.1 //x=40.41 //y=7.41 //x2=40.41 //y2=6.925
r1811 (  580 1011 ) resistor r=2.87058 //w=0.35 //l=0.085 //layer=li \
 //thickness=0.1 //x=39.615 //y=7.585 //x2=39.53 //y2=7.585
r1812 (  580 582 ) resistor r=16.218 //w=0.367 //l=0.465 //layer=li \
 //thickness=0.1 //x=39.615 //y=7.585 //x2=40.08 //y2=7.585
r1813 (  579 1012 ) resistor r=2.87058 //w=0.35 //l=0.085 //layer=li \
 //thickness=0.1 //x=40.325 //y=7.585 //x2=40.41 //y2=7.585
r1814 (  579 582 ) resistor r=8.54496 //w=0.367 //l=0.245 //layer=li \
 //thickness=0.1 //x=40.325 //y=7.585 //x2=40.08 //y2=7.585
r1815 (  573 1011 ) resistor r=4.23183 //w=0.7 //l=0.175 //layer=li \
 //thickness=0.1 //x=39.53 //y=7.41 //x2=39.53 //y2=7.585
r1816 (  573 1090 ) resistor r=33.1979 //w=0.187 //l=0.485 //layer=li \
 //thickness=0.1 //x=39.53 //y=7.41 //x2=39.53 //y2=6.925
r1817 (  570 1010 ) resistor r=2.87058 //w=0.35 //l=0.085 //layer=li \
 //thickness=0.1 //x=38.735 //y=7.585 //x2=38.65 //y2=7.585
r1818 (  570 572 ) resistor r=8.19619 //w=0.367 //l=0.235 //layer=li \
 //thickness=0.1 //x=38.735 //y=7.585 //x2=38.97 //y2=7.585
r1819 (  569 1011 ) resistor r=2.87058 //w=0.35 //l=0.085 //layer=li \
 //thickness=0.1 //x=39.445 //y=7.585 //x2=39.53 //y2=7.585
r1820 (  569 572 ) resistor r=16.5668 //w=0.367 //l=0.475 //layer=li \
 //thickness=0.1 //x=39.445 //y=7.585 //x2=38.97 //y2=7.585
r1821 (  561 1010 ) resistor r=4.23183 //w=0.7 //l=0.175 //layer=li \
 //thickness=0.1 //x=38.65 //y=7.41 //x2=38.65 //y2=7.585
r1822 (  561 1089 ) resistor r=56.4706 //w=0.187 //l=0.825 //layer=li \
 //thickness=0.1 //x=38.65 //y=7.41 //x2=38.65 //y2=6.585
r1823 (  560 1009 ) resistor r=5.29055 //w=0.35 //l=0.17 //layer=li \
 //thickness=0.1 //x=38.03 //y=7.585 //x2=37.86 //y2=7.585
r1824 (  559 1010 ) resistor r=2.87058 //w=0.35 //l=0.085 //layer=li \
 //thickness=0.1 //x=38.565 //y=7.585 //x2=38.65 //y2=7.585
r1825 (  559 560 ) resistor r=18.6594 //w=0.367 //l=0.535 //layer=li \
 //thickness=0.1 //x=38.565 //y=7.585 //x2=38.03 //y2=7.585
r1826 (  554 1008 ) resistor r=2.87058 //w=0.35 //l=0.085 //layer=li \
 //thickness=0.1 //x=36.865 //y=7.585 //x2=36.78 //y2=7.585
r1827 (  554 556 ) resistor r=21.7984 //w=0.367 //l=0.625 //layer=li \
 //thickness=0.1 //x=36.865 //y=7.585 //x2=37.49 //y2=7.585
r1828 (  553 1009 ) resistor r=5.29055 //w=0.35 //l=0.17 //layer=li \
 //thickness=0.1 //x=37.69 //y=7.585 //x2=37.86 //y2=7.585
r1829 (  553 556 ) resistor r=6.97548 //w=0.367 //l=0.2 //layer=li \
 //thickness=0.1 //x=37.69 //y=7.585 //x2=37.49 //y2=7.585
r1830 (  547 1008 ) resistor r=4.23183 //w=0.7 //l=0.175 //layer=li \
 //thickness=0.1 //x=36.78 //y=7.41 //x2=36.78 //y2=7.585
r1831 (  547 1088 ) resistor r=33.1979 //w=0.187 //l=0.485 //layer=li \
 //thickness=0.1 //x=36.78 //y=7.41 //x2=36.78 //y2=6.925
r1832 (  544 1007 ) resistor r=2.87058 //w=0.35 //l=0.085 //layer=li \
 //thickness=0.1 //x=35.985 //y=7.585 //x2=35.9 //y2=7.585
r1833 (  544 546 ) resistor r=13.7766 //w=0.367 //l=0.395 //layer=li \
 //thickness=0.1 //x=35.985 //y=7.585 //x2=36.38 //y2=7.585
r1834 (  543 1008 ) resistor r=2.87058 //w=0.35 //l=0.085 //layer=li \
 //thickness=0.1 //x=36.695 //y=7.585 //x2=36.78 //y2=7.585
r1835 (  543 546 ) resistor r=10.9864 //w=0.367 //l=0.315 //layer=li \
 //thickness=0.1 //x=36.695 //y=7.585 //x2=36.38 //y2=7.585
r1836 (  537 1007 ) resistor r=4.23183 //w=0.7 //l=0.175 //layer=li \
 //thickness=0.1 //x=35.9 //y=7.41 //x2=35.9 //y2=7.585
r1837 (  537 1087 ) resistor r=33.1979 //w=0.187 //l=0.485 //layer=li \
 //thickness=0.1 //x=35.9 //y=7.41 //x2=35.9 //y2=6.925
r1838 (  534 1006 ) resistor r=2.87058 //w=0.35 //l=0.085 //layer=li \
 //thickness=0.1 //x=35.105 //y=7.585 //x2=35.02 //y2=7.585
r1839 (  534 536 ) resistor r=5.75477 //w=0.367 //l=0.165 //layer=li \
 //thickness=0.1 //x=35.105 //y=7.585 //x2=35.27 //y2=7.585
r1840 (  533 1007 ) resistor r=2.87058 //w=0.35 //l=0.085 //layer=li \
 //thickness=0.1 //x=35.815 //y=7.585 //x2=35.9 //y2=7.585
r1841 (  533 536 ) resistor r=19.0082 //w=0.367 //l=0.545 //layer=li \
 //thickness=0.1 //x=35.815 //y=7.585 //x2=35.27 //y2=7.585
r1842 (  527 1006 ) resistor r=4.23183 //w=0.7 //l=0.175 //layer=li \
 //thickness=0.1 //x=35.02 //y=7.41 //x2=35.02 //y2=7.585
r1843 (  527 1086 ) resistor r=33.1979 //w=0.187 //l=0.485 //layer=li \
 //thickness=0.1 //x=35.02 //y=7.41 //x2=35.02 //y2=6.925
r1844 (  526 1005 ) resistor r=2.87058 //w=0.35 //l=0.085 //layer=li \
 //thickness=0.1 //x=34.225 //y=7.585 //x2=34.14 //y2=7.585
r1845 (  525 1006 ) resistor r=2.87058 //w=0.35 //l=0.085 //layer=li \
 //thickness=0.1 //x=34.935 //y=7.585 //x2=35.02 //y2=7.585
r1846 (  525 526 ) resistor r=24.7629 //w=0.367 //l=0.71 //layer=li \
 //thickness=0.1 //x=34.935 //y=7.585 //x2=34.225 //y2=7.585
r1847 (  517 1005 ) resistor r=4.23183 //w=0.7 //l=0.175 //layer=li \
 //thickness=0.1 //x=34.14 //y=7.41 //x2=34.14 //y2=7.585
r1848 (  517 1085 ) resistor r=56.4706 //w=0.187 //l=0.825 //layer=li \
 //thickness=0.1 //x=34.14 //y=7.41 //x2=34.14 //y2=6.585
r1849 (  516 1003 ) resistor r=5.29055 //w=0.35 //l=0.17 //layer=li \
 //thickness=0.1 //x=33.22 //y=7.585 //x2=33.05 //y2=7.585
r1850 (  515 1005 ) resistor r=2.87058 //w=0.35 //l=0.085 //layer=li \
 //thickness=0.1 //x=34.055 //y=7.585 //x2=34.14 //y2=7.585
r1851 (  515 516 ) resistor r=29.1226 //w=0.367 //l=0.835 //layer=li \
 //thickness=0.1 //x=34.055 //y=7.585 //x2=33.22 //y2=7.585
r1852 (  510 1002 ) resistor r=2.87058 //w=0.35 //l=0.085 //layer=li \
 //thickness=0.1 //x=32.055 //y=7.585 //x2=31.97 //y2=7.585
r1853 (  510 512 ) resistor r=21.7984 //w=0.367 //l=0.625 //layer=li \
 //thickness=0.1 //x=32.055 //y=7.585 //x2=32.68 //y2=7.585
r1854 (  509 1003 ) resistor r=5.29055 //w=0.35 //l=0.17 //layer=li \
 //thickness=0.1 //x=32.88 //y=7.585 //x2=33.05 //y2=7.585
r1855 (  509 512 ) resistor r=6.97548 //w=0.367 //l=0.2 //layer=li \
 //thickness=0.1 //x=32.88 //y=7.585 //x2=32.68 //y2=7.585
r1856 (  503 1002 ) resistor r=4.23183 //w=0.7 //l=0.175 //layer=li \
 //thickness=0.1 //x=31.97 //y=7.41 //x2=31.97 //y2=7.585
r1857 (  503 1084 ) resistor r=33.1979 //w=0.187 //l=0.485 //layer=li \
 //thickness=0.1 //x=31.97 //y=7.41 //x2=31.97 //y2=6.925
r1858 (  500 1001 ) resistor r=2.87058 //w=0.35 //l=0.085 //layer=li \
 //thickness=0.1 //x=31.175 //y=7.585 //x2=31.09 //y2=7.585
r1859 (  500 502 ) resistor r=13.7766 //w=0.367 //l=0.395 //layer=li \
 //thickness=0.1 //x=31.175 //y=7.585 //x2=31.57 //y2=7.585
r1860 (  499 1002 ) resistor r=2.87058 //w=0.35 //l=0.085 //layer=li \
 //thickness=0.1 //x=31.885 //y=7.585 //x2=31.97 //y2=7.585
r1861 (  499 502 ) resistor r=10.9864 //w=0.367 //l=0.315 //layer=li \
 //thickness=0.1 //x=31.885 //y=7.585 //x2=31.57 //y2=7.585
r1862 (  493 1001 ) resistor r=4.23183 //w=0.7 //l=0.175 //layer=li \
 //thickness=0.1 //x=31.09 //y=7.41 //x2=31.09 //y2=7.585
r1863 (  493 1083 ) resistor r=33.1979 //w=0.187 //l=0.485 //layer=li \
 //thickness=0.1 //x=31.09 //y=7.41 //x2=31.09 //y2=6.925
r1864 (  490 1000 ) resistor r=2.87058 //w=0.35 //l=0.085 //layer=li \
 //thickness=0.1 //x=30.295 //y=7.585 //x2=30.21 //y2=7.585
r1865 (  490 492 ) resistor r=5.75477 //w=0.367 //l=0.165 //layer=li \
 //thickness=0.1 //x=30.295 //y=7.585 //x2=30.46 //y2=7.585
r1866 (  489 1001 ) resistor r=2.87058 //w=0.35 //l=0.085 //layer=li \
 //thickness=0.1 //x=31.005 //y=7.585 //x2=31.09 //y2=7.585
r1867 (  489 492 ) resistor r=19.0082 //w=0.367 //l=0.545 //layer=li \
 //thickness=0.1 //x=31.005 //y=7.585 //x2=30.46 //y2=7.585
r1868 (  483 1000 ) resistor r=4.23183 //w=0.7 //l=0.175 //layer=li \
 //thickness=0.1 //x=30.21 //y=7.41 //x2=30.21 //y2=7.585
r1869 (  483 1082 ) resistor r=33.1979 //w=0.187 //l=0.485 //layer=li \
 //thickness=0.1 //x=30.21 //y=7.41 //x2=30.21 //y2=6.925
r1870 (  482 999 ) resistor r=2.87058 //w=0.35 //l=0.085 //layer=li \
 //thickness=0.1 //x=29.415 //y=7.585 //x2=29.33 //y2=7.585
r1871 (  481 1000 ) resistor r=2.87058 //w=0.35 //l=0.085 //layer=li \
 //thickness=0.1 //x=30.125 //y=7.585 //x2=30.21 //y2=7.585
r1872 (  481 482 ) resistor r=24.7629 //w=0.367 //l=0.71 //layer=li \
 //thickness=0.1 //x=30.125 //y=7.585 //x2=29.415 //y2=7.585
r1873 (  473 999 ) resistor r=4.23183 //w=0.7 //l=0.175 //layer=li \
 //thickness=0.1 //x=29.33 //y=7.41 //x2=29.33 //y2=7.585
r1874 (  473 1081 ) resistor r=56.4706 //w=0.187 //l=0.825 //layer=li \
 //thickness=0.1 //x=29.33 //y=7.41 //x2=29.33 //y2=6.585
r1875 (  472 997 ) resistor r=5.29055 //w=0.35 //l=0.17 //layer=li \
 //thickness=0.1 //x=28.41 //y=7.585 //x2=28.24 //y2=7.585
r1876 (  471 999 ) resistor r=2.87058 //w=0.35 //l=0.085 //layer=li \
 //thickness=0.1 //x=29.245 //y=7.585 //x2=29.33 //y2=7.585
r1877 (  471 472 ) resistor r=29.1226 //w=0.367 //l=0.835 //layer=li \
 //thickness=0.1 //x=29.245 //y=7.585 //x2=28.41 //y2=7.585
r1878 (  466 996 ) resistor r=2.87058 //w=0.35 //l=0.085 //layer=li \
 //thickness=0.1 //x=27.545 //y=7.585 //x2=27.46 //y2=7.585
r1879 (  466 468 ) resistor r=11.3351 //w=0.367 //l=0.325 //layer=li \
 //thickness=0.1 //x=27.545 //y=7.585 //x2=27.87 //y2=7.585
r1880 (  465 997 ) resistor r=5.29055 //w=0.35 //l=0.17 //layer=li \
 //thickness=0.1 //x=28.07 //y=7.585 //x2=28.24 //y2=7.585
r1881 (  465 468 ) resistor r=6.97548 //w=0.367 //l=0.2 //layer=li \
 //thickness=0.1 //x=28.07 //y=7.585 //x2=27.87 //y2=7.585
r1882 (  459 996 ) resistor r=4.23183 //w=0.7 //l=0.175 //layer=li \
 //thickness=0.1 //x=27.46 //y=7.41 //x2=27.46 //y2=7.585
r1883 (  459 1080 ) resistor r=33.1979 //w=0.187 //l=0.485 //layer=li \
 //thickness=0.1 //x=27.46 //y=7.41 //x2=27.46 //y2=6.925
r1884 (  456 995 ) resistor r=2.87058 //w=0.35 //l=0.085 //layer=li \
 //thickness=0.1 //x=26.665 //y=7.585 //x2=26.58 //y2=7.585
r1885 (  456 458 ) resistor r=3.31335 //w=0.367 //l=0.095 //layer=li \
 //thickness=0.1 //x=26.665 //y=7.585 //x2=26.76 //y2=7.585
r1886 (  455 996 ) resistor r=2.87058 //w=0.35 //l=0.085 //layer=li \
 //thickness=0.1 //x=27.375 //y=7.585 //x2=27.46 //y2=7.585
r1887 (  455 458 ) resistor r=21.4496 //w=0.367 //l=0.615 //layer=li \
 //thickness=0.1 //x=27.375 //y=7.585 //x2=26.76 //y2=7.585
r1888 (  449 995 ) resistor r=4.23183 //w=0.7 //l=0.175 //layer=li \
 //thickness=0.1 //x=26.58 //y=7.41 //x2=26.58 //y2=7.585
r1889 (  449 1079 ) resistor r=33.1979 //w=0.187 //l=0.485 //layer=li \
 //thickness=0.1 //x=26.58 //y=7.41 //x2=26.58 //y2=6.925
r1890 (  448 994 ) resistor r=2.87058 //w=0.35 //l=0.085 //layer=li \
 //thickness=0.1 //x=25.785 //y=7.585 //x2=25.7 //y2=7.585
r1891 (  447 995 ) resistor r=2.87058 //w=0.35 //l=0.085 //layer=li \
 //thickness=0.1 //x=26.495 //y=7.585 //x2=26.58 //y2=7.585
r1892 (  447 448 ) resistor r=24.7629 //w=0.367 //l=0.71 //layer=li \
 //thickness=0.1 //x=26.495 //y=7.585 //x2=25.785 //y2=7.585
r1893 (  439 994 ) resistor r=4.23183 //w=0.7 //l=0.175 //layer=li \
 //thickness=0.1 //x=25.7 //y=7.41 //x2=25.7 //y2=7.585
r1894 (  439 1078 ) resistor r=56.4706 //w=0.187 //l=0.825 //layer=li \
 //thickness=0.1 //x=25.7 //y=7.41 //x2=25.7 //y2=6.585
r1895 (  438 992 ) resistor r=5.29055 //w=0.35 //l=0.17 //layer=li \
 //thickness=0.1 //x=25.08 //y=7.585 //x2=24.91 //y2=7.585
r1896 (  437 994 ) resistor r=2.87058 //w=0.35 //l=0.085 //layer=li \
 //thickness=0.1 //x=25.615 //y=7.585 //x2=25.7 //y2=7.585
r1897 (  437 438 ) resistor r=18.6594 //w=0.367 //l=0.535 //layer=li \
 //thickness=0.1 //x=25.615 //y=7.585 //x2=25.08 //y2=7.585
r1898 (  432 991 ) resistor r=2.87058 //w=0.35 //l=0.085 //layer=li \
 //thickness=0.1 //x=23.915 //y=7.585 //x2=23.83 //y2=7.585
r1899 (  432 434 ) resistor r=8.89373 //w=0.367 //l=0.255 //layer=li \
 //thickness=0.1 //x=23.915 //y=7.585 //x2=24.17 //y2=7.585
r1900 (  431 992 ) resistor r=5.29055 //w=0.35 //l=0.17 //layer=li \
 //thickness=0.1 //x=24.74 //y=7.585 //x2=24.91 //y2=7.585
r1901 (  431 434 ) resistor r=19.8801 //w=0.367 //l=0.57 //layer=li \
 //thickness=0.1 //x=24.74 //y=7.585 //x2=24.17 //y2=7.585
r1902 (  425 991 ) resistor r=4.23183 //w=0.7 //l=0.175 //layer=li \
 //thickness=0.1 //x=23.83 //y=7.41 //x2=23.83 //y2=7.585
r1903 (  425 1077 ) resistor r=33.1979 //w=0.187 //l=0.485 //layer=li \
 //thickness=0.1 //x=23.83 //y=7.41 //x2=23.83 //y2=6.925
r1904 (  422 990 ) resistor r=2.87058 //w=0.35 //l=0.085 //layer=li \
 //thickness=0.1 //x=23.035 //y=7.585 //x2=22.95 //y2=7.585
r1905 (  422 424 ) resistor r=0.871935 //w=0.367 //l=0.025 //layer=li \
 //thickness=0.1 //x=23.035 //y=7.585 //x2=23.06 //y2=7.585
r1906 (  421 991 ) resistor r=2.87058 //w=0.35 //l=0.085 //layer=li \
 //thickness=0.1 //x=23.745 //y=7.585 //x2=23.83 //y2=7.585
r1907 (  421 424 ) resistor r=23.891 //w=0.367 //l=0.685 //layer=li \
 //thickness=0.1 //x=23.745 //y=7.585 //x2=23.06 //y2=7.585
r1908 (  415 990 ) resistor r=4.23183 //w=0.7 //l=0.175 //layer=li \
 //thickness=0.1 //x=22.95 //y=7.41 //x2=22.95 //y2=7.585
r1909 (  415 1076 ) resistor r=33.1979 //w=0.187 //l=0.485 //layer=li \
 //thickness=0.1 //x=22.95 //y=7.41 //x2=22.95 //y2=6.925
r1910 (  414 989 ) resistor r=2.87058 //w=0.35 //l=0.085 //layer=li \
 //thickness=0.1 //x=22.155 //y=7.585 //x2=22.07 //y2=7.585
r1911 (  413 990 ) resistor r=2.87058 //w=0.35 //l=0.085 //layer=li \
 //thickness=0.1 //x=22.865 //y=7.585 //x2=22.95 //y2=7.585
r1912 (  413 414 ) resistor r=24.7629 //w=0.367 //l=0.71 //layer=li \
 //thickness=0.1 //x=22.865 //y=7.585 //x2=22.155 //y2=7.585
r1913 (  407 989 ) resistor r=4.23183 //w=0.7 //l=0.175 //layer=li \
 //thickness=0.1 //x=22.07 //y=7.41 //x2=22.07 //y2=7.585
r1914 (  407 1075 ) resistor r=33.1979 //w=0.187 //l=0.485 //layer=li \
 //thickness=0.1 //x=22.07 //y=7.41 //x2=22.07 //y2=6.925
r1915 (  404 988 ) resistor r=2.87058 //w=0.35 //l=0.085 //layer=li \
 //thickness=0.1 //x=21.275 //y=7.585 //x2=21.19 //y2=7.585
r1916 (  404 406 ) resistor r=23.5422 //w=0.367 //l=0.675 //layer=li \
 //thickness=0.1 //x=21.275 //y=7.585 //x2=21.95 //y2=7.585
r1917 (  403 989 ) resistor r=2.87058 //w=0.35 //l=0.085 //layer=li \
 //thickness=0.1 //x=21.985 //y=7.585 //x2=22.07 //y2=7.585
r1918 (  403 406 ) resistor r=1.22071 //w=0.367 //l=0.035 //layer=li \
 //thickness=0.1 //x=21.985 //y=7.585 //x2=21.95 //y2=7.585
r1919 (  395 988 ) resistor r=4.23183 //w=0.7 //l=0.175 //layer=li \
 //thickness=0.1 //x=21.19 //y=7.41 //x2=21.19 //y2=7.585
r1920 (  395 1074 ) resistor r=56.4706 //w=0.187 //l=0.825 //layer=li \
 //thickness=0.1 //x=21.19 //y=7.41 //x2=21.19 //y2=6.585
r1921 (  392 987 ) resistor r=5.29055 //w=0.35 //l=0.17 //layer=li \
 //thickness=0.1 //x=20.27 //y=7.585 //x2=20.1 //y2=7.585
r1922 (  392 394 ) resistor r=19.8801 //w=0.367 //l=0.57 //layer=li \
 //thickness=0.1 //x=20.27 //y=7.585 //x2=20.84 //y2=7.585
r1923 (  391 988 ) resistor r=2.87058 //w=0.35 //l=0.085 //layer=li \
 //thickness=0.1 //x=21.105 //y=7.585 //x2=21.19 //y2=7.585
r1924 (  391 394 ) resistor r=9.24251 //w=0.367 //l=0.265 //layer=li \
 //thickness=0.1 //x=21.105 //y=7.585 //x2=20.84 //y2=7.585
r1925 (  388 986 ) resistor r=2.87058 //w=0.35 //l=0.085 //layer=li \
 //thickness=0.1 //x=19.405 //y=7.585 //x2=19.32 //y2=7.585
r1926 (  387 987 ) resistor r=5.29055 //w=0.35 //l=0.17 //layer=li \
 //thickness=0.1 //x=19.93 //y=7.585 //x2=20.1 //y2=7.585
r1927 (  387 388 ) resistor r=18.3106 //w=0.367 //l=0.525 //layer=li \
 //thickness=0.1 //x=19.93 //y=7.585 //x2=19.405 //y2=7.585
r1928 (  381 986 ) resistor r=4.23183 //w=0.7 //l=0.175 //layer=li \
 //thickness=0.1 //x=19.32 //y=7.41 //x2=19.32 //y2=7.585
r1929 (  381 1073 ) resistor r=33.1979 //w=0.187 //l=0.485 //layer=li \
 //thickness=0.1 //x=19.32 //y=7.41 //x2=19.32 //y2=6.925
r1930 (  380 984 ) resistor r=2.87058 //w=0.35 //l=0.085 //layer=li \
 //thickness=0.1 //x=18.525 //y=7.585 //x2=18.44 //y2=7.585
r1931 (  379 986 ) resistor r=2.87058 //w=0.35 //l=0.085 //layer=li \
 //thickness=0.1 //x=19.235 //y=7.585 //x2=19.32 //y2=7.585
r1932 (  379 380 ) resistor r=24.7629 //w=0.367 //l=0.71 //layer=li \
 //thickness=0.1 //x=19.235 //y=7.585 //x2=18.525 //y2=7.585
r1933 (  373 984 ) resistor r=4.23183 //w=0.7 //l=0.175 //layer=li \
 //thickness=0.1 //x=18.44 //y=7.41 //x2=18.44 //y2=7.585
r1934 (  373 1072 ) resistor r=33.1979 //w=0.187 //l=0.485 //layer=li \
 //thickness=0.1 //x=18.44 //y=7.41 //x2=18.44 //y2=6.925
r1935 (  370 983 ) resistor r=2.87058 //w=0.35 //l=0.085 //layer=li \
 //thickness=0.1 //x=17.645 //y=7.585 //x2=17.56 //y2=7.585
r1936 (  370 372 ) resistor r=21.1008 //w=0.367 //l=0.605 //layer=li \
 //thickness=0.1 //x=17.645 //y=7.585 //x2=18.25 //y2=7.585
r1937 (  369 984 ) resistor r=2.87058 //w=0.35 //l=0.085 //layer=li \
 //thickness=0.1 //x=18.355 //y=7.585 //x2=18.44 //y2=7.585
r1938 (  369 372 ) resistor r=3.66213 //w=0.367 //l=0.105 //layer=li \
 //thickness=0.1 //x=18.355 //y=7.585 //x2=18.25 //y2=7.585
r1939 (  361 983 ) resistor r=4.23183 //w=0.7 //l=0.175 //layer=li \
 //thickness=0.1 //x=17.56 //y=7.41 //x2=17.56 //y2=7.585
r1940 (  361 1071 ) resistor r=56.4706 //w=0.187 //l=0.825 //layer=li \
 //thickness=0.1 //x=17.56 //y=7.41 //x2=17.56 //y2=6.585
r1941 (  358 982 ) resistor r=5.29055 //w=0.35 //l=0.17 //layer=li \
 //thickness=0.1 //x=16.94 //y=7.585 //x2=16.77 //y2=7.585
r1942 (  358 360 ) resistor r=6.97548 //w=0.367 //l=0.2 //layer=li \
 //thickness=0.1 //x=16.94 //y=7.585 //x2=17.14 //y2=7.585
r1943 (  357 983 ) resistor r=2.87058 //w=0.35 //l=0.085 //layer=li \
 //thickness=0.1 //x=17.475 //y=7.585 //x2=17.56 //y2=7.585
r1944 (  357 360 ) resistor r=11.6839 //w=0.367 //l=0.335 //layer=li \
 //thickness=0.1 //x=17.475 //y=7.585 //x2=17.14 //y2=7.585
r1945 (  354 981 ) resistor r=2.87058 //w=0.35 //l=0.085 //layer=li \
 //thickness=0.1 //x=16.075 //y=7.585 //x2=15.99 //y2=7.585
r1946 (  353 982 ) resistor r=5.29055 //w=0.35 //l=0.17 //layer=li \
 //thickness=0.1 //x=16.6 //y=7.585 //x2=16.77 //y2=7.585
r1947 (  353 354 ) resistor r=18.3106 //w=0.367 //l=0.525 //layer=li \
 //thickness=0.1 //x=16.6 //y=7.585 //x2=16.075 //y2=7.585
r1948 (  347 981 ) resistor r=4.23183 //w=0.7 //l=0.175 //layer=li \
 //thickness=0.1 //x=15.99 //y=7.41 //x2=15.99 //y2=7.585
r1949 (  347 1070 ) resistor r=33.1979 //w=0.187 //l=0.485 //layer=li \
 //thickness=0.1 //x=15.99 //y=7.41 //x2=15.99 //y2=6.925
r1950 (  344 980 ) resistor r=2.87058 //w=0.35 //l=0.085 //layer=li \
 //thickness=0.1 //x=15.195 //y=7.585 //x2=15.11 //y2=7.585
r1951 (  344 346 ) resistor r=16.218 //w=0.367 //l=0.465 //layer=li \
 //thickness=0.1 //x=15.195 //y=7.585 //x2=15.66 //y2=7.585
r1952 (  343 981 ) resistor r=2.87058 //w=0.35 //l=0.085 //layer=li \
 //thickness=0.1 //x=15.905 //y=7.585 //x2=15.99 //y2=7.585
r1953 (  343 346 ) resistor r=8.54496 //w=0.367 //l=0.245 //layer=li \
 //thickness=0.1 //x=15.905 //y=7.585 //x2=15.66 //y2=7.585
r1954 (  337 980 ) resistor r=4.23183 //w=0.7 //l=0.175 //layer=li \
 //thickness=0.1 //x=15.11 //y=7.41 //x2=15.11 //y2=7.585
r1955 (  337 1069 ) resistor r=33.1979 //w=0.187 //l=0.485 //layer=li \
 //thickness=0.1 //x=15.11 //y=7.41 //x2=15.11 //y2=6.925
r1956 (  334 979 ) resistor r=2.87058 //w=0.35 //l=0.085 //layer=li \
 //thickness=0.1 //x=14.315 //y=7.585 //x2=14.23 //y2=7.585
r1957 (  334 336 ) resistor r=8.19619 //w=0.367 //l=0.235 //layer=li \
 //thickness=0.1 //x=14.315 //y=7.585 //x2=14.55 //y2=7.585
r1958 (  333 980 ) resistor r=2.87058 //w=0.35 //l=0.085 //layer=li \
 //thickness=0.1 //x=15.025 //y=7.585 //x2=15.11 //y2=7.585
r1959 (  333 336 ) resistor r=16.5668 //w=0.367 //l=0.475 //layer=li \
 //thickness=0.1 //x=15.025 //y=7.585 //x2=14.55 //y2=7.585
r1960 (  325 979 ) resistor r=4.23183 //w=0.7 //l=0.175 //layer=li \
 //thickness=0.1 //x=14.23 //y=7.41 //x2=14.23 //y2=7.585
r1961 (  325 1068 ) resistor r=56.4706 //w=0.187 //l=0.825 //layer=li \
 //thickness=0.1 //x=14.23 //y=7.41 //x2=14.23 //y2=6.585
r1962 (  324 978 ) resistor r=5.29055 //w=0.35 //l=0.17 //layer=li \
 //thickness=0.1 //x=13.61 //y=7.585 //x2=13.44 //y2=7.585
r1963 (  323 979 ) resistor r=2.87058 //w=0.35 //l=0.085 //layer=li \
 //thickness=0.1 //x=14.145 //y=7.585 //x2=14.23 //y2=7.585
r1964 (  323 324 ) resistor r=18.6594 //w=0.367 //l=0.535 //layer=li \
 //thickness=0.1 //x=14.145 //y=7.585 //x2=13.61 //y2=7.585
r1965 (  318 977 ) resistor r=2.87058 //w=0.35 //l=0.085 //layer=li \
 //thickness=0.1 //x=12.445 //y=7.585 //x2=12.36 //y2=7.585
r1966 (  318 320 ) resistor r=21.7984 //w=0.367 //l=0.625 //layer=li \
 //thickness=0.1 //x=12.445 //y=7.585 //x2=13.07 //y2=7.585
r1967 (  317 978 ) resistor r=5.29055 //w=0.35 //l=0.17 //layer=li \
 //thickness=0.1 //x=13.27 //y=7.585 //x2=13.44 //y2=7.585
r1968 (  317 320 ) resistor r=6.97548 //w=0.367 //l=0.2 //layer=li \
 //thickness=0.1 //x=13.27 //y=7.585 //x2=13.07 //y2=7.585
r1969 (  311 977 ) resistor r=4.23183 //w=0.7 //l=0.175 //layer=li \
 //thickness=0.1 //x=12.36 //y=7.41 //x2=12.36 //y2=7.585
r1970 (  311 1067 ) resistor r=33.1979 //w=0.187 //l=0.485 //layer=li \
 //thickness=0.1 //x=12.36 //y=7.41 //x2=12.36 //y2=6.925
r1971 (  308 976 ) resistor r=2.87058 //w=0.35 //l=0.085 //layer=li \
 //thickness=0.1 //x=11.565 //y=7.585 //x2=11.48 //y2=7.585
r1972 (  308 310 ) resistor r=13.7766 //w=0.367 //l=0.395 //layer=li \
 //thickness=0.1 //x=11.565 //y=7.585 //x2=11.96 //y2=7.585
r1973 (  307 977 ) resistor r=2.87058 //w=0.35 //l=0.085 //layer=li \
 //thickness=0.1 //x=12.275 //y=7.585 //x2=12.36 //y2=7.585
r1974 (  307 310 ) resistor r=10.9864 //w=0.367 //l=0.315 //layer=li \
 //thickness=0.1 //x=12.275 //y=7.585 //x2=11.96 //y2=7.585
r1975 (  301 976 ) resistor r=4.23183 //w=0.7 //l=0.175 //layer=li \
 //thickness=0.1 //x=11.48 //y=7.41 //x2=11.48 //y2=7.585
r1976 (  301 1066 ) resistor r=33.1979 //w=0.187 //l=0.485 //layer=li \
 //thickness=0.1 //x=11.48 //y=7.41 //x2=11.48 //y2=6.925
r1977 (  298 975 ) resistor r=2.87058 //w=0.35 //l=0.085 //layer=li \
 //thickness=0.1 //x=10.685 //y=7.585 //x2=10.6 //y2=7.585
r1978 (  298 300 ) resistor r=5.75477 //w=0.367 //l=0.165 //layer=li \
 //thickness=0.1 //x=10.685 //y=7.585 //x2=10.85 //y2=7.585
r1979 (  297 976 ) resistor r=2.87058 //w=0.35 //l=0.085 //layer=li \
 //thickness=0.1 //x=11.395 //y=7.585 //x2=11.48 //y2=7.585
r1980 (  297 300 ) resistor r=19.0082 //w=0.367 //l=0.545 //layer=li \
 //thickness=0.1 //x=11.395 //y=7.585 //x2=10.85 //y2=7.585
r1981 (  291 975 ) resistor r=4.23183 //w=0.7 //l=0.175 //layer=li \
 //thickness=0.1 //x=10.6 //y=7.41 //x2=10.6 //y2=7.585
r1982 (  291 1065 ) resistor r=33.1979 //w=0.187 //l=0.485 //layer=li \
 //thickness=0.1 //x=10.6 //y=7.41 //x2=10.6 //y2=6.925
r1983 (  290 974 ) resistor r=2.87058 //w=0.35 //l=0.085 //layer=li \
 //thickness=0.1 //x=9.805 //y=7.585 //x2=9.72 //y2=7.585
r1984 (  289 975 ) resistor r=2.87058 //w=0.35 //l=0.085 //layer=li \
 //thickness=0.1 //x=10.515 //y=7.585 //x2=10.6 //y2=7.585
r1985 (  289 290 ) resistor r=24.7629 //w=0.367 //l=0.71 //layer=li \
 //thickness=0.1 //x=10.515 //y=7.585 //x2=9.805 //y2=7.585
r1986 (  281 974 ) resistor r=4.23183 //w=0.7 //l=0.175 //layer=li \
 //thickness=0.1 //x=9.72 //y=7.41 //x2=9.72 //y2=7.585
r1987 (  281 1064 ) resistor r=56.4706 //w=0.187 //l=0.825 //layer=li \
 //thickness=0.1 //x=9.72 //y=7.41 //x2=9.72 //y2=6.585
r1988 (  280 972 ) resistor r=5.29055 //w=0.35 //l=0.17 //layer=li \
 //thickness=0.1 //x=8.8 //y=7.585 //x2=8.63 //y2=7.585
r1989 (  279 974 ) resistor r=2.87058 //w=0.35 //l=0.085 //layer=li \
 //thickness=0.1 //x=9.635 //y=7.585 //x2=9.72 //y2=7.585
r1990 (  279 280 ) resistor r=29.1226 //w=0.367 //l=0.835 //layer=li \
 //thickness=0.1 //x=9.635 //y=7.585 //x2=8.8 //y2=7.585
r1991 (  274 971 ) resistor r=2.87058 //w=0.35 //l=0.085 //layer=li \
 //thickness=0.1 //x=7.635 //y=7.585 //x2=7.55 //y2=7.585
r1992 (  274 276 ) resistor r=21.7984 //w=0.367 //l=0.625 //layer=li \
 //thickness=0.1 //x=7.635 //y=7.585 //x2=8.26 //y2=7.585
r1993 (  273 972 ) resistor r=5.29055 //w=0.35 //l=0.17 //layer=li \
 //thickness=0.1 //x=8.46 //y=7.585 //x2=8.63 //y2=7.585
r1994 (  273 276 ) resistor r=6.97548 //w=0.367 //l=0.2 //layer=li \
 //thickness=0.1 //x=8.46 //y=7.585 //x2=8.26 //y2=7.585
r1995 (  267 971 ) resistor r=4.23183 //w=0.7 //l=0.175 //layer=li \
 //thickness=0.1 //x=7.55 //y=7.41 //x2=7.55 //y2=7.585
r1996 (  267 1063 ) resistor r=33.1979 //w=0.187 //l=0.485 //layer=li \
 //thickness=0.1 //x=7.55 //y=7.41 //x2=7.55 //y2=6.925
r1997 (  264 970 ) resistor r=2.87058 //w=0.35 //l=0.085 //layer=li \
 //thickness=0.1 //x=6.755 //y=7.585 //x2=6.67 //y2=7.585
r1998 (  264 266 ) resistor r=13.7766 //w=0.367 //l=0.395 //layer=li \
 //thickness=0.1 //x=6.755 //y=7.585 //x2=7.15 //y2=7.585
r1999 (  263 971 ) resistor r=2.87058 //w=0.35 //l=0.085 //layer=li \
 //thickness=0.1 //x=7.465 //y=7.585 //x2=7.55 //y2=7.585
r2000 (  263 266 ) resistor r=10.9864 //w=0.367 //l=0.315 //layer=li \
 //thickness=0.1 //x=7.465 //y=7.585 //x2=7.15 //y2=7.585
r2001 (  257 970 ) resistor r=4.23183 //w=0.7 //l=0.175 //layer=li \
 //thickness=0.1 //x=6.67 //y=7.41 //x2=6.67 //y2=7.585
r2002 (  257 1062 ) resistor r=33.1979 //w=0.187 //l=0.485 //layer=li \
 //thickness=0.1 //x=6.67 //y=7.41 //x2=6.67 //y2=6.925
r2003 (  254 969 ) resistor r=2.87058 //w=0.35 //l=0.085 //layer=li \
 //thickness=0.1 //x=5.875 //y=7.585 //x2=5.79 //y2=7.585
r2004 (  254 256 ) resistor r=5.75477 //w=0.367 //l=0.165 //layer=li \
 //thickness=0.1 //x=5.875 //y=7.585 //x2=6.04 //y2=7.585
r2005 (  253 970 ) resistor r=2.87058 //w=0.35 //l=0.085 //layer=li \
 //thickness=0.1 //x=6.585 //y=7.585 //x2=6.67 //y2=7.585
r2006 (  253 256 ) resistor r=19.0082 //w=0.367 //l=0.545 //layer=li \
 //thickness=0.1 //x=6.585 //y=7.585 //x2=6.04 //y2=7.585
r2007 (  247 969 ) resistor r=4.23183 //w=0.7 //l=0.175 //layer=li \
 //thickness=0.1 //x=5.79 //y=7.41 //x2=5.79 //y2=7.585
r2008 (  247 1061 ) resistor r=33.1979 //w=0.187 //l=0.485 //layer=li \
 //thickness=0.1 //x=5.79 //y=7.41 //x2=5.79 //y2=6.925
r2009 (  246 968 ) resistor r=2.87058 //w=0.35 //l=0.085 //layer=li \
 //thickness=0.1 //x=4.995 //y=7.585 //x2=4.91 //y2=7.585
r2010 (  245 969 ) resistor r=2.87058 //w=0.35 //l=0.085 //layer=li \
 //thickness=0.1 //x=5.705 //y=7.585 //x2=5.79 //y2=7.585
r2011 (  245 246 ) resistor r=24.7629 //w=0.367 //l=0.71 //layer=li \
 //thickness=0.1 //x=5.705 //y=7.585 //x2=4.995 //y2=7.585
r2012 (  237 968 ) resistor r=4.23183 //w=0.7 //l=0.175 //layer=li \
 //thickness=0.1 //x=4.91 //y=7.41 //x2=4.91 //y2=7.585
r2013 (  237 1060 ) resistor r=56.4706 //w=0.187 //l=0.825 //layer=li \
 //thickness=0.1 //x=4.91 //y=7.41 //x2=4.91 //y2=6.585
r2014 (  236 966 ) resistor r=5.29055 //w=0.35 //l=0.17 //layer=li \
 //thickness=0.1 //x=3.99 //y=7.585 //x2=3.82 //y2=7.585
r2015 (  235 968 ) resistor r=2.87058 //w=0.35 //l=0.085 //layer=li \
 //thickness=0.1 //x=4.825 //y=7.585 //x2=4.91 //y2=7.585
r2016 (  235 236 ) resistor r=29.1226 //w=0.367 //l=0.835 //layer=li \
 //thickness=0.1 //x=4.825 //y=7.585 //x2=3.99 //y2=7.585
r2017 (  230 965 ) resistor r=2.87058 //w=0.35 //l=0.085 //layer=li \
 //thickness=0.1 //x=3.125 //y=7.585 //x2=3.04 //y2=7.585
r2018 (  230 232 ) resistor r=11.3351 //w=0.367 //l=0.325 //layer=li \
 //thickness=0.1 //x=3.125 //y=7.585 //x2=3.45 //y2=7.585
r2019 (  229 966 ) resistor r=5.29055 //w=0.35 //l=0.17 //layer=li \
 //thickness=0.1 //x=3.65 //y=7.585 //x2=3.82 //y2=7.585
r2020 (  229 232 ) resistor r=6.97548 //w=0.367 //l=0.2 //layer=li \
 //thickness=0.1 //x=3.65 //y=7.585 //x2=3.45 //y2=7.585
r2021 (  223 965 ) resistor r=4.23183 //w=0.7 //l=0.175 //layer=li \
 //thickness=0.1 //x=3.04 //y=7.41 //x2=3.04 //y2=7.585
r2022 (  223 1059 ) resistor r=33.1979 //w=0.187 //l=0.485 //layer=li \
 //thickness=0.1 //x=3.04 //y=7.41 //x2=3.04 //y2=6.925
r2023 (  220 964 ) resistor r=2.87058 //w=0.35 //l=0.085 //layer=li \
 //thickness=0.1 //x=2.245 //y=7.585 //x2=2.16 //y2=7.585
r2024 (  220 222 ) resistor r=3.31335 //w=0.367 //l=0.095 //layer=li \
 //thickness=0.1 //x=2.245 //y=7.585 //x2=2.34 //y2=7.585
r2025 (  219 965 ) resistor r=2.87058 //w=0.35 //l=0.085 //layer=li \
 //thickness=0.1 //x=2.955 //y=7.585 //x2=3.04 //y2=7.585
r2026 (  219 222 ) resistor r=21.4496 //w=0.367 //l=0.615 //layer=li \
 //thickness=0.1 //x=2.955 //y=7.585 //x2=2.34 //y2=7.585
r2027 (  213 964 ) resistor r=4.23183 //w=0.7 //l=0.175 //layer=li \
 //thickness=0.1 //x=2.16 //y=7.41 //x2=2.16 //y2=7.585
r2028 (  213 1058 ) resistor r=33.1979 //w=0.187 //l=0.485 //layer=li \
 //thickness=0.1 //x=2.16 //y=7.41 //x2=2.16 //y2=6.925
r2029 (  212 963 ) resistor r=2.87058 //w=0.35 //l=0.085 //layer=li \
 //thickness=0.1 //x=1.365 //y=7.585 //x2=1.28 //y2=7.585
r2030 (  211 964 ) resistor r=2.87058 //w=0.35 //l=0.085 //layer=li \
 //thickness=0.1 //x=2.075 //y=7.585 //x2=2.16 //y2=7.585
r2031 (  211 212 ) resistor r=24.7629 //w=0.367 //l=0.71 //layer=li \
 //thickness=0.1 //x=2.075 //y=7.585 //x2=1.365 //y2=7.585
r2032 (  203 963 ) resistor r=4.23183 //w=0.7 //l=0.175 //layer=li \
 //thickness=0.1 //x=1.28 //y=7.41 //x2=1.28 //y2=7.585
r2033 (  203 1057 ) resistor r=56.4706 //w=0.187 //l=0.825 //layer=li \
 //thickness=0.1 //x=1.28 //y=7.41 //x2=1.28 //y2=6.585
r2034 (  198 940 ) resistor r=9.3 //w=0.17 //l=0.17 //layer=mcon //count=1 \
 //x=76.3 //y=6.92 //x2=76.3 //y2=6.92
r2035 (  195 1121 ) resistor r=9.3 //w=0.17 //l=0.17 //layer=mcon //count=1 \
 //x=75.42 //y=6.92 //x2=75.42 //y2=6.92
r2036 (  192 925 ) resistor r=9.3 //w=0.17 //l=0.17 //layer=mcon //count=1 \
 //x=74.54 //y=6.92 //x2=74.54 //y2=6.92
r2037 (  188 912 ) resistor r=3.1 //w=0.17 //l=0.51 //layer=mcon //count=3 \
 //x=74.49 //y=7.58 //x2=74.49 //y2=7.58
r2038 (  149 959 ) resistor r=3.1 //w=0.17 //l=0.51 //layer=mcon //count=3 \
 //x=83 //y=7.58 //x2=83 //y2=7.58
r2039 (  147 957 ) resistor r=3.1 //w=0.17 //l=0.51 //layer=mcon //count=3 \
 //x=81.89 //y=7.58 //x2=81.89 //y2=7.58
r2040 (  147 149 ) resistor r=0.446141 //w=0.311 //l=1.11 //layer=m1 \
 //thickness=0.36 //x=81.89 //y=7.585 //x2=83 //y2=7.585
r2041 (  145 955 ) resistor r=3.1 //w=0.17 //l=0.51 //layer=mcon //count=3 \
 //x=80.78 //y=7.58 //x2=80.78 //y2=7.58
r2042 (  145 147 ) resistor r=0.446141 //w=0.311 //l=1.11 //layer=m1 \
 //thickness=0.36 //x=80.78 //y=7.585 //x2=81.89 //y2=7.585
r2043 (  143 949 ) resistor r=3.1 //w=0.17 //l=0.51 //layer=mcon //count=3 \
 //x=79.3 //y=7.58 //x2=79.3 //y2=7.58
r2044 (  143 145 ) resistor r=0.594855 //w=0.311 //l=1.48 //layer=m1 \
 //thickness=0.36 //x=79.3 //y=7.585 //x2=80.78 //y2=7.585
r2045 (  141 947 ) resistor r=3.1 //w=0.17 //l=0.51 //layer=mcon //count=3 \
 //x=78.19 //y=7.58 //x2=78.19 //y2=7.58
r2046 (  141 143 ) resistor r=0.446141 //w=0.311 //l=1.11 //layer=m1 \
 //thickness=0.36 //x=78.19 //y=7.585 //x2=79.3 //y2=7.585
r2047 (  139 916 ) resistor r=3.1 //w=0.17 //l=0.51 //layer=mcon //count=3 \
 //x=76.71 //y=7.58 //x2=76.71 //y2=7.58
r2048 (  139 141 ) resistor r=0.594855 //w=0.311 //l=1.48 //layer=m1 \
 //thickness=0.36 //x=76.71 //y=7.585 //x2=78.19 //y2=7.585
r2049 (  137 196 ) resistor r=0.028033 //w=0.35 //l=0.085 //layer=m1 \
 //thickness=0.36 //x=76.385 //y=7.585 //x2=76.3 //y2=7.585
r2050 (  137 139 ) resistor r=0.130627 //w=0.311 //l=0.325 //layer=m1 \
 //thickness=0.36 //x=76.385 //y=7.585 //x2=76.71 //y2=7.585
r2051 (  136 196 ) resistor r=0.0413265 //w=0.7 //l=0.175 //layer=m1 \
 //thickness=0.36 //x=76.3 //y=7.41 //x2=76.3 //y2=7.585
r2052 (  135 198 ) resistor r=0.0715665 //w=0.226 //l=0.115 //layer=m1 \
 //thickness=0.36 //x=76.3 //y=7.035 //x2=76.3 //y2=6.92
r2053 (  135 136 ) resistor r=0.357824 //w=0.131 //l=0.375 //layer=m1 \
 //thickness=0.36 //x=76.3 //y=7.035 //x2=76.3 //y2=7.41
r2054 (  134 914 ) resistor r=3.1 //w=0.17 //l=0.51 //layer=mcon //count=3 \
 //x=75.6 //y=7.58 //x2=75.6 //y2=7.58
r2055 (  132 193 ) resistor r=0.028033 //w=0.35 //l=0.085 //layer=m1 \
 //thickness=0.36 //x=75.505 //y=7.585 //x2=75.42 //y2=7.585
r2056 (  132 134 ) resistor r=0.0381833 //w=0.311 //l=0.095 //layer=m1 \
 //thickness=0.36 //x=75.505 //y=7.585 //x2=75.6 //y2=7.585
r2057 (  131 196 ) resistor r=0.028033 //w=0.35 //l=0.085 //layer=m1 \
 //thickness=0.36 //x=76.215 //y=7.585 //x2=76.3 //y2=7.585
r2058 (  131 134 ) resistor r=0.247186 //w=0.311 //l=0.615 //layer=m1 \
 //thickness=0.36 //x=76.215 //y=7.585 //x2=75.6 //y2=7.585
r2059 (  130 193 ) resistor r=0.0413265 //w=0.7 //l=0.175 //layer=m1 \
 //thickness=0.36 //x=75.42 //y=7.41 //x2=75.42 //y2=7.585
r2060 (  129 195 ) resistor r=0.0715665 //w=0.226 //l=0.117473 //layer=m1 \
 //thickness=0.36 //x=75.42 //y=7.035 //x2=75.425 //y2=6.92
r2061 (  129 130 ) resistor r=0.357824 //w=0.131 //l=0.375 //layer=m1 \
 //thickness=0.36 //x=75.42 //y=7.035 //x2=75.42 //y2=7.41
r2062 (  128 188 ) resistor r=0.028033 //w=0.35 //l=0.085 //layer=m1 \
 //thickness=0.36 //x=74.625 //y=7.585 //x2=74.54 //y2=7.585
r2063 (  127 193 ) resistor r=0.028033 //w=0.35 //l=0.085 //layer=m1 \
 //thickness=0.36 //x=75.335 //y=7.585 //x2=75.42 //y2=7.585
r2064 (  127 128 ) resistor r=0.28537 //w=0.311 //l=0.71 //layer=m1 \
 //thickness=0.36 //x=75.335 //y=7.585 //x2=74.625 //y2=7.585
r2065 (  126 188 ) resistor r=0.0413265 //w=0.7 //l=0.175 //layer=m1 \
 //thickness=0.36 //x=74.54 //y=7.41 //x2=74.54 //y2=7.585
r2066 (  125 192 ) resistor r=0.0712609 //w=0.23 //l=0.11649 //layer=m1 \
 //thickness=0.36 //x=74.54 //y=7.035 //x2=74.537 //y2=6.92
r2067 (  125 126 ) resistor r=0.357824 //w=0.131 //l=0.375 //layer=m1 \
 //thickness=0.36 //x=74.54 //y=7.035 //x2=74.54 //y2=7.41
r2068 (  124 906 ) resistor r=3.1 //w=0.17 //l=0.51 //layer=mcon //count=3 \
 //x=73.01 //y=7.58 //x2=73.01 //y2=7.58
r2069 (  122 896 ) resistor r=3.1 //w=0.17 //l=0.51 //layer=mcon //count=3 \
 //x=71.9 //y=7.58 //x2=71.9 //y2=7.58
r2070 (  122 124 ) resistor r=0.446141 //w=0.311 //l=1.11 //layer=m1 \
 //thickness=0.36 //x=71.9 //y=7.585 //x2=73.01 //y2=7.585
r2071 (  120 878 ) resistor r=3.1 //w=0.17 //l=0.51 //layer=mcon //count=3 \
 //x=70.79 //y=7.58 //x2=70.79 //y2=7.58
r2072 (  120 122 ) resistor r=0.446141 //w=0.311 //l=1.11 //layer=m1 \
 //thickness=0.36 //x=70.79 //y=7.585 //x2=71.9 //y2=7.585
r2073 (  118 866 ) resistor r=3.1 //w=0.17 //l=0.51 //layer=mcon //count=3 \
 //x=69.68 //y=7.58 //x2=69.68 //y2=7.58
r2074 (  118 120 ) resistor r=0.446141 //w=0.311 //l=1.11 //layer=m1 \
 //thickness=0.36 //x=69.68 //y=7.585 //x2=70.79 //y2=7.585
r2075 (  116 1048 ) resistor r=3.1 //w=0.17 //l=0.51 //layer=mcon //count=3 \
 //x=68.2 //y=7.58 //x2=68.2 //y2=7.58
r2076 (  116 118 ) resistor r=0.594855 //w=0.311 //l=1.48 //layer=m1 \
 //thickness=0.36 //x=68.2 //y=7.585 //x2=69.68 //y2=7.585
r2077 (  114 844 ) resistor r=3.1 //w=0.17 //l=0.51 //layer=mcon //count=3 \
 //x=67.09 //y=7.58 //x2=67.09 //y2=7.58
r2078 (  114 116 ) resistor r=0.446141 //w=0.311 //l=1.11 //layer=m1 \
 //thickness=0.36 //x=67.09 //y=7.585 //x2=68.2 //y2=7.585
r2079 (  112 832 ) resistor r=3.1 //w=0.17 //l=0.51 //layer=mcon //count=3 \
 //x=65.98 //y=7.58 //x2=65.98 //y2=7.58
r2080 (  112 114 ) resistor r=0.446141 //w=0.311 //l=1.11 //layer=m1 \
 //thickness=0.36 //x=65.98 //y=7.585 //x2=67.09 //y2=7.585
r2081 (  110 818 ) resistor r=3.1 //w=0.17 //l=0.51 //layer=mcon //count=3 \
 //x=64.5 //y=7.58 //x2=64.5 //y2=7.58
r2082 (  110 112 ) resistor r=0.594855 //w=0.311 //l=1.48 //layer=m1 \
 //thickness=0.36 //x=64.5 //y=7.585 //x2=65.98 //y2=7.585
r2083 (  108 808 ) resistor r=3.1 //w=0.17 //l=0.51 //layer=mcon //count=3 \
 //x=63.39 //y=7.58 //x2=63.39 //y2=7.58
r2084 (  108 110 ) resistor r=0.446141 //w=0.311 //l=1.11 //layer=m1 \
 //thickness=0.36 //x=63.39 //y=7.585 //x2=64.5 //y2=7.585
r2085 (  106 792 ) resistor r=3.1 //w=0.17 //l=0.51 //layer=mcon //count=3 \
 //x=61.91 //y=7.58 //x2=61.91 //y2=7.58
r2086 (  106 108 ) resistor r=0.594855 //w=0.311 //l=1.48 //layer=m1 \
 //thickness=0.36 //x=61.91 //y=7.585 //x2=63.39 //y2=7.585
r2087 (  104 782 ) resistor r=3.1 //w=0.17 //l=0.51 //layer=mcon //count=3 \
 //x=60.8 //y=7.58 //x2=60.8 //y2=7.58
r2088 (  104 106 ) resistor r=0.446141 //w=0.311 //l=1.11 //layer=m1 \
 //thickness=0.36 //x=60.8 //y=7.585 //x2=61.91 //y2=7.585
r2089 (  102 772 ) resistor r=3.1 //w=0.17 //l=0.51 //layer=mcon //count=3 \
 //x=59.69 //y=7.58 //x2=59.69 //y2=7.58
r2090 (  102 104 ) resistor r=0.446141 //w=0.311 //l=1.11 //layer=m1 \
 //thickness=0.36 //x=59.69 //y=7.585 //x2=60.8 //y2=7.585
r2091 (  100 1036 ) resistor r=3.1 //w=0.17 //l=0.51 //layer=mcon //count=3 \
 //x=58.58 //y=7.58 //x2=58.58 //y2=7.58
r2092 (  100 102 ) resistor r=0.446141 //w=0.311 //l=1.11 //layer=m1 \
 //thickness=0.36 //x=58.58 //y=7.585 //x2=59.69 //y2=7.585
r2093 (  98 748 ) resistor r=3.1 //w=0.17 //l=0.51 //layer=mcon //count=3 \
 //x=57.1 //y=7.58 //x2=57.1 //y2=7.58
r2094 (  98 100 ) resistor r=0.594855 //w=0.311 //l=1.48 //layer=m1 \
 //thickness=0.36 //x=57.1 //y=7.585 //x2=58.58 //y2=7.585
r2095 (  96 738 ) resistor r=3.1 //w=0.17 //l=0.51 //layer=mcon //count=3 \
 //x=55.99 //y=7.58 //x2=55.99 //y2=7.58
r2096 (  96 98 ) resistor r=0.446141 //w=0.311 //l=1.11 //layer=m1 \
 //thickness=0.36 //x=55.99 //y=7.585 //x2=57.1 //y2=7.585
r2097 (  94 728 ) resistor r=3.1 //w=0.17 //l=0.51 //layer=mcon //count=3 \
 //x=54.88 //y=7.58 //x2=54.88 //y2=7.58
r2098 (  94 96 ) resistor r=0.446141 //w=0.311 //l=1.11 //layer=m1 \
 //thickness=0.36 //x=54.88 //y=7.585 //x2=55.99 //y2=7.585
r2099 (  92 1030 ) resistor r=3.1 //w=0.17 //l=0.51 //layer=mcon //count=3 \
 //x=53.77 //y=7.58 //x2=53.77 //y2=7.58
r2100 (  92 94 ) resistor r=0.446141 //w=0.311 //l=1.11 //layer=m1 \
 //thickness=0.36 //x=53.77 //y=7.585 //x2=54.88 //y2=7.585
r2101 (  90 704 ) resistor r=3.1 //w=0.17 //l=0.51 //layer=mcon //count=3 \
 //x=52.29 //y=7.58 //x2=52.29 //y2=7.58
r2102 (  90 92 ) resistor r=0.594855 //w=0.311 //l=1.48 //layer=m1 \
 //thickness=0.36 //x=52.29 //y=7.585 //x2=53.77 //y2=7.585
r2103 (  88 694 ) resistor r=3.1 //w=0.17 //l=0.51 //layer=mcon //count=3 \
 //x=51.18 //y=7.58 //x2=51.18 //y2=7.58
r2104 (  88 90 ) resistor r=0.446141 //w=0.311 //l=1.11 //layer=m1 \
 //thickness=0.36 //x=51.18 //y=7.585 //x2=52.29 //y2=7.585
r2105 (  86 1025 ) resistor r=3.1 //w=0.17 //l=0.51 //layer=mcon //count=3 \
 //x=50.07 //y=7.58 //x2=50.07 //y2=7.58
r2106 (  86 88 ) resistor r=0.446141 //w=0.311 //l=1.11 //layer=m1 \
 //thickness=0.36 //x=50.07 //y=7.585 //x2=51.18 //y2=7.585
r2107 (  84 670 ) resistor r=3.1 //w=0.17 //l=0.51 //layer=mcon //count=3 \
 //x=48.59 //y=7.58 //x2=48.59 //y2=7.58
r2108 (  84 86 ) resistor r=0.594855 //w=0.311 //l=1.48 //layer=m1 \
 //thickness=0.36 //x=48.59 //y=7.585 //x2=50.07 //y2=7.585
r2109 (  82 660 ) resistor r=3.1 //w=0.17 //l=0.51 //layer=mcon //count=3 \
 //x=47.48 //y=7.58 //x2=47.48 //y2=7.58
r2110 (  82 84 ) resistor r=0.446141 //w=0.311 //l=1.11 //layer=m1 \
 //thickness=0.36 //x=47.48 //y=7.585 //x2=48.59 //y2=7.585
r2111 (  80 642 ) resistor r=3.1 //w=0.17 //l=0.51 //layer=mcon //count=3 \
 //x=46.37 //y=7.58 //x2=46.37 //y2=7.58
r2112 (  80 82 ) resistor r=0.446141 //w=0.311 //l=1.11 //layer=m1 \
 //thickness=0.36 //x=46.37 //y=7.585 //x2=47.48 //y2=7.585
r2113 (  78 630 ) resistor r=3.1 //w=0.17 //l=0.51 //layer=mcon //count=3 \
 //x=45.26 //y=7.58 //x2=45.26 //y2=7.58
r2114 (  78 80 ) resistor r=0.446141 //w=0.311 //l=1.11 //layer=m1 \
 //thickness=0.36 //x=45.26 //y=7.585 //x2=46.37 //y2=7.585
r2115 (  76 1017 ) resistor r=3.1 //w=0.17 //l=0.51 //layer=mcon //count=3 \
 //x=43.78 //y=7.58 //x2=43.78 //y2=7.58
r2116 (  76 78 ) resistor r=0.594855 //w=0.311 //l=1.48 //layer=m1 \
 //thickness=0.36 //x=43.78 //y=7.585 //x2=45.26 //y2=7.585
r2117 (  74 608 ) resistor r=3.1 //w=0.17 //l=0.51 //layer=mcon //count=3 \
 //x=42.67 //y=7.58 //x2=42.67 //y2=7.58
r2118 (  74 76 ) resistor r=0.446141 //w=0.311 //l=1.11 //layer=m1 \
 //thickness=0.36 //x=42.67 //y=7.585 //x2=43.78 //y2=7.585
r2119 (  71 596 ) resistor r=3.1 //w=0.17 //l=0.51 //layer=mcon //count=3 \
 //x=41.56 //y=7.58 //x2=41.56 //y2=7.58
r2120 (  69 582 ) resistor r=3.1 //w=0.17 //l=0.51 //layer=mcon //count=3 \
 //x=40.08 //y=7.58 //x2=40.08 //y2=7.58
r2121 (  69 71 ) resistor r=0.594855 //w=0.311 //l=1.48 //layer=m1 \
 //thickness=0.36 //x=40.08 //y=7.585 //x2=41.56 //y2=7.585
r2122 (  67 572 ) resistor r=3.1 //w=0.17 //l=0.51 //layer=mcon //count=3 \
 //x=38.97 //y=7.58 //x2=38.97 //y2=7.58
r2123 (  67 69 ) resistor r=0.446141 //w=0.311 //l=1.11 //layer=m1 \
 //thickness=0.36 //x=38.97 //y=7.585 //x2=40.08 //y2=7.585
r2124 (  65 556 ) resistor r=3.1 //w=0.17 //l=0.51 //layer=mcon //count=3 \
 //x=37.49 //y=7.58 //x2=37.49 //y2=7.58
r2125 (  65 67 ) resistor r=0.594855 //w=0.311 //l=1.48 //layer=m1 \
 //thickness=0.36 //x=37.49 //y=7.585 //x2=38.97 //y2=7.585
r2126 (  63 546 ) resistor r=3.1 //w=0.17 //l=0.51 //layer=mcon //count=3 \
 //x=36.38 //y=7.58 //x2=36.38 //y2=7.58
r2127 (  63 65 ) resistor r=0.446141 //w=0.311 //l=1.11 //layer=m1 \
 //thickness=0.36 //x=36.38 //y=7.585 //x2=37.49 //y2=7.585
r2128 (  61 536 ) resistor r=3.1 //w=0.17 //l=0.51 //layer=mcon //count=3 \
 //x=35.27 //y=7.58 //x2=35.27 //y2=7.58
r2129 (  61 63 ) resistor r=0.446141 //w=0.311 //l=1.11 //layer=m1 \
 //thickness=0.36 //x=35.27 //y=7.585 //x2=36.38 //y2=7.585
r2130 (  59 1005 ) resistor r=3.1 //w=0.17 //l=0.51 //layer=mcon //count=3 \
 //x=34.16 //y=7.58 //x2=34.16 //y2=7.58
r2131 (  59 61 ) resistor r=0.446141 //w=0.311 //l=1.11 //layer=m1 \
 //thickness=0.36 //x=34.16 //y=7.585 //x2=35.27 //y2=7.585
r2132 (  57 512 ) resistor r=3.1 //w=0.17 //l=0.51 //layer=mcon //count=3 \
 //x=32.68 //y=7.58 //x2=32.68 //y2=7.58
r2133 (  57 59 ) resistor r=0.594855 //w=0.311 //l=1.48 //layer=m1 \
 //thickness=0.36 //x=32.68 //y=7.585 //x2=34.16 //y2=7.585
r2134 (  55 502 ) resistor r=3.1 //w=0.17 //l=0.51 //layer=mcon //count=3 \
 //x=31.57 //y=7.58 //x2=31.57 //y2=7.58
r2135 (  55 57 ) resistor r=0.446141 //w=0.311 //l=1.11 //layer=m1 \
 //thickness=0.36 //x=31.57 //y=7.585 //x2=32.68 //y2=7.585
r2136 (  53 492 ) resistor r=3.1 //w=0.17 //l=0.51 //layer=mcon //count=3 \
 //x=30.46 //y=7.58 //x2=30.46 //y2=7.58
r2137 (  53 55 ) resistor r=0.446141 //w=0.311 //l=1.11 //layer=m1 \
 //thickness=0.36 //x=30.46 //y=7.585 //x2=31.57 //y2=7.585
r2138 (  51 999 ) resistor r=3.1 //w=0.17 //l=0.51 //layer=mcon //count=3 \
 //x=29.35 //y=7.58 //x2=29.35 //y2=7.58
r2139 (  51 53 ) resistor r=0.446141 //w=0.311 //l=1.11 //layer=m1 \
 //thickness=0.36 //x=29.35 //y=7.585 //x2=30.46 //y2=7.585
r2140 (  49 468 ) resistor r=3.1 //w=0.17 //l=0.51 //layer=mcon //count=3 \
 //x=27.87 //y=7.58 //x2=27.87 //y2=7.58
r2141 (  49 51 ) resistor r=0.594855 //w=0.311 //l=1.48 //layer=m1 \
 //thickness=0.36 //x=27.87 //y=7.585 //x2=29.35 //y2=7.585
r2142 (  47 458 ) resistor r=3.1 //w=0.17 //l=0.51 //layer=mcon //count=3 \
 //x=26.76 //y=7.58 //x2=26.76 //y2=7.58
r2143 (  47 49 ) resistor r=0.446141 //w=0.311 //l=1.11 //layer=m1 \
 //thickness=0.36 //x=26.76 //y=7.585 //x2=27.87 //y2=7.585
r2144 (  45 994 ) resistor r=3.1 //w=0.17 //l=0.51 //layer=mcon //count=3 \
 //x=25.65 //y=7.58 //x2=25.65 //y2=7.58
r2145 (  45 47 ) resistor r=0.446141 //w=0.311 //l=1.11 //layer=m1 \
 //thickness=0.36 //x=25.65 //y=7.585 //x2=26.76 //y2=7.585
r2146 (  43 434 ) resistor r=3.1 //w=0.17 //l=0.51 //layer=mcon //count=3 \
 //x=24.17 //y=7.58 //x2=24.17 //y2=7.58
r2147 (  43 45 ) resistor r=0.594855 //w=0.311 //l=1.48 //layer=m1 \
 //thickness=0.36 //x=24.17 //y=7.585 //x2=25.65 //y2=7.585
r2148 (  41 424 ) resistor r=3.1 //w=0.17 //l=0.51 //layer=mcon //count=3 \
 //x=23.06 //y=7.58 //x2=23.06 //y2=7.58
r2149 (  41 43 ) resistor r=0.446141 //w=0.311 //l=1.11 //layer=m1 \
 //thickness=0.36 //x=23.06 //y=7.585 //x2=24.17 //y2=7.585
r2150 (  39 406 ) resistor r=3.1 //w=0.17 //l=0.51 //layer=mcon //count=3 \
 //x=21.95 //y=7.58 //x2=21.95 //y2=7.58
r2151 (  39 41 ) resistor r=0.446141 //w=0.311 //l=1.11 //layer=m1 \
 //thickness=0.36 //x=21.95 //y=7.585 //x2=23.06 //y2=7.585
r2152 (  37 394 ) resistor r=3.1 //w=0.17 //l=0.51 //layer=mcon //count=3 \
 //x=20.84 //y=7.58 //x2=20.84 //y2=7.58
r2153 (  37 39 ) resistor r=0.446141 //w=0.311 //l=1.11 //layer=m1 \
 //thickness=0.36 //x=20.84 //y=7.585 //x2=21.95 //y2=7.585
r2154 (  35 986 ) resistor r=3.1 //w=0.17 //l=0.51 //layer=mcon //count=3 \
 //x=19.36 //y=7.58 //x2=19.36 //y2=7.58
r2155 (  35 37 ) resistor r=0.594855 //w=0.311 //l=1.48 //layer=m1 \
 //thickness=0.36 //x=19.36 //y=7.585 //x2=20.84 //y2=7.585
r2156 (  33 372 ) resistor r=3.1 //w=0.17 //l=0.51 //layer=mcon //count=3 \
 //x=18.25 //y=7.58 //x2=18.25 //y2=7.58
r2157 (  33 35 ) resistor r=0.446141 //w=0.311 //l=1.11 //layer=m1 \
 //thickness=0.36 //x=18.25 //y=7.585 //x2=19.36 //y2=7.585
r2158 (  31 360 ) resistor r=3.1 //w=0.17 //l=0.51 //layer=mcon //count=3 \
 //x=17.14 //y=7.58 //x2=17.14 //y2=7.58
r2159 (  31 33 ) resistor r=0.446141 //w=0.311 //l=1.11 //layer=m1 \
 //thickness=0.36 //x=17.14 //y=7.585 //x2=18.25 //y2=7.585
r2160 (  29 346 ) resistor r=3.1 //w=0.17 //l=0.51 //layer=mcon //count=3 \
 //x=15.66 //y=7.58 //x2=15.66 //y2=7.58
r2161 (  29 31 ) resistor r=0.594855 //w=0.311 //l=1.48 //layer=m1 \
 //thickness=0.36 //x=15.66 //y=7.585 //x2=17.14 //y2=7.585
r2162 (  27 336 ) resistor r=3.1 //w=0.17 //l=0.51 //layer=mcon //count=3 \
 //x=14.55 //y=7.58 //x2=14.55 //y2=7.58
r2163 (  27 29 ) resistor r=0.446141 //w=0.311 //l=1.11 //layer=m1 \
 //thickness=0.36 //x=14.55 //y=7.585 //x2=15.66 //y2=7.585
r2164 (  25 320 ) resistor r=3.1 //w=0.17 //l=0.51 //layer=mcon //count=3 \
 //x=13.07 //y=7.58 //x2=13.07 //y2=7.58
r2165 (  25 27 ) resistor r=0.594855 //w=0.311 //l=1.48 //layer=m1 \
 //thickness=0.36 //x=13.07 //y=7.585 //x2=14.55 //y2=7.585
r2166 (  23 310 ) resistor r=3.1 //w=0.17 //l=0.51 //layer=mcon //count=3 \
 //x=11.96 //y=7.58 //x2=11.96 //y2=7.58
r2167 (  23 25 ) resistor r=0.446141 //w=0.311 //l=1.11 //layer=m1 \
 //thickness=0.36 //x=11.96 //y=7.585 //x2=13.07 //y2=7.585
r2168 (  21 300 ) resistor r=3.1 //w=0.17 //l=0.51 //layer=mcon //count=3 \
 //x=10.85 //y=7.58 //x2=10.85 //y2=7.58
r2169 (  21 23 ) resistor r=0.446141 //w=0.311 //l=1.11 //layer=m1 \
 //thickness=0.36 //x=10.85 //y=7.585 //x2=11.96 //y2=7.585
r2170 (  19 974 ) resistor r=3.1 //w=0.17 //l=0.51 //layer=mcon //count=3 \
 //x=9.74 //y=7.58 //x2=9.74 //y2=7.58
r2171 (  19 21 ) resistor r=0.446141 //w=0.311 //l=1.11 //layer=m1 \
 //thickness=0.36 //x=9.74 //y=7.585 //x2=10.85 //y2=7.585
r2172 (  17 276 ) resistor r=3.1 //w=0.17 //l=0.51 //layer=mcon //count=3 \
 //x=8.26 //y=7.58 //x2=8.26 //y2=7.58
r2173 (  17 19 ) resistor r=0.594855 //w=0.311 //l=1.48 //layer=m1 \
 //thickness=0.36 //x=8.26 //y=7.585 //x2=9.74 //y2=7.585
r2174 (  15 266 ) resistor r=3.1 //w=0.17 //l=0.51 //layer=mcon //count=3 \
 //x=7.15 //y=7.58 //x2=7.15 //y2=7.58
r2175 (  15 17 ) resistor r=0.446141 //w=0.311 //l=1.11 //layer=m1 \
 //thickness=0.36 //x=7.15 //y=7.585 //x2=8.26 //y2=7.585
r2176 (  13 256 ) resistor r=3.1 //w=0.17 //l=0.51 //layer=mcon //count=3 \
 //x=6.04 //y=7.58 //x2=6.04 //y2=7.58
r2177 (  13 15 ) resistor r=0.446141 //w=0.311 //l=1.11 //layer=m1 \
 //thickness=0.36 //x=6.04 //y=7.585 //x2=7.15 //y2=7.585
r2178 (  11 968 ) resistor r=3.1 //w=0.17 //l=0.51 //layer=mcon //count=3 \
 //x=4.93 //y=7.58 //x2=4.93 //y2=7.58
r2179 (  11 13 ) resistor r=0.446141 //w=0.311 //l=1.11 //layer=m1 \
 //thickness=0.36 //x=4.93 //y=7.585 //x2=6.04 //y2=7.585
r2180 (  9 232 ) resistor r=3.1 //w=0.17 //l=0.51 //layer=mcon //count=3 \
 //x=3.45 //y=7.58 //x2=3.45 //y2=7.58
r2181 (  9 11 ) resistor r=0.594855 //w=0.311 //l=1.48 //layer=m1 \
 //thickness=0.36 //x=3.45 //y=7.585 //x2=4.93 //y2=7.585
r2182 (  7 222 ) resistor r=3.1 //w=0.17 //l=0.51 //layer=mcon //count=3 \
 //x=2.34 //y=7.58 //x2=2.34 //y2=7.58
r2183 (  7 9 ) resistor r=0.446141 //w=0.311 //l=1.11 //layer=m1 \
 //thickness=0.36 //x=2.34 //y=7.585 //x2=3.45 //y2=7.585
r2184 (  4 963 ) resistor r=3.1 //w=0.17 //l=0.51 //layer=mcon //count=3 \
 //x=1.23 //y=7.58 //x2=1.23 //y2=7.58
r2185 (  4 7 ) resistor r=0.446141 //w=0.311 //l=1.11 //layer=m1 \
 //thickness=0.36 //x=1.23 //y=7.585 //x2=2.34 //y2=7.585
r2186 (  2 188 ) resistor r=0.028033 //w=0.35 //l=0.085 //layer=m1 \
 //thickness=0.36 //x=74.455 //y=7.585 //x2=74.54 //y2=7.585
r2187 (  2 124 ) resistor r=0.580788 //w=0.311 //l=1.445 //layer=m1 \
 //thickness=0.36 //x=74.455 //y=7.585 //x2=73.01 //y2=7.585
r2188 (  1 74 ) resistor r=0.223071 //w=0.311 //l=0.555 //layer=m1 \
 //thickness=0.36 //x=42.115 //y=7.585 //x2=42.67 //y2=7.585
r2189 (  1 71 ) resistor r=0.223071 //w=0.311 //l=0.555 //layer=m1 \
 //thickness=0.36 //x=42.115 //y=7.585 //x2=41.56 //y2=7.585
ends PM_TMRDFFSNQNX1\%VDD

subckt PM_TMRDFFSNQNX1\%noxref_24 ( 5 7 15 19 30 33 34 )
c67 ( 34 0 ) capacitor c=0.0457851f //x=6.785 //y=0.555
c68 ( 33 0 ) capacitor c=0.0195185f //x=5.68 //y=1.09
c69 ( 30 0 ) capacitor c=0.00141302f //x=6.92 //y=1.175
c70 ( 19 0 ) capacitor c=0.00692795f //x=7.89 //y=0.805
c71 ( 15 0 ) capacitor c=0.0154984f //x=7.805 //y=0.72
c72 ( 7 0 ) capacitor c=0.00689459f //x=6.92 //y=0.805
c73 ( 5 0 ) capacitor c=0.0241875f //x=6.835 //y=1.175
r74 (  19 34 ) resistor r=3.57586 //w=0.17 //l=0.125 //layer=li \
 //thickness=0.1 //x=7.89 //y=0.805 //x2=7.89 //y2=0.68
r75 (  19 34 ) resistor r=18.139 //w=0.187 //l=0.265 //layer=li \
 //thickness=0.1 //x=7.89 //y=0.805 //x2=7.89 //y2=1.07
r76 (  16 34 ) resistor r=3.57586 //w=0.17 //l=0.103078 //layer=li \
 //thickness=0.1 //x=7.005 //y=0.72 //x2=6.92 //y2=0.68
r77 (  16 34 ) resistor r=27.3797 //w=0.187 //l=0.4 //layer=li //thickness=0.1 \
 //x=7.005 //y=0.72 //x2=7.405 //y2=0.72
r78 (  15 34 ) resistor r=3.57586 //w=0.17 //l=0.103078 //layer=li \
 //thickness=0.1 //x=7.805 //y=0.72 //x2=7.89 //y2=0.68
r79 (  15 34 ) resistor r=27.3797 //w=0.187 //l=0.4 //layer=li //thickness=0.1 \
 //x=7.805 //y=0.72 //x2=7.405 //y2=0.72
r80 (  11 30 ) resistor r=5.4201 //w=0.17 //l=0.085 //layer=li //thickness=0.1 \
 //x=6.92 //y=1.26 //x2=6.92 //y2=1.175
r81 (  11 34 ) resistor r=10.2674 //w=0.187 //l=0.15 //layer=li \
 //thickness=0.1 //x=6.92 //y=1.26 //x2=6.92 //y2=1.41
r82 (  8 30 ) resistor r=5.4201 //w=0.17 //l=0.085 //layer=li //thickness=0.1 \
 //x=6.92 //y=1.09 //x2=6.92 //y2=1.175
r83 (  8 34 ) resistor r=1.36898 //w=0.187 //l=0.02 //layer=li //thickness=0.1 \
 //x=6.92 //y=1.09 //x2=6.92 //y2=1.07
r84 (  7 34 ) resistor r=3.57586 //w=0.17 //l=0.125 //layer=li //thickness=0.1 \
 //x=6.92 //y=0.805 //x2=6.92 //y2=0.68
r85 (  7 34 ) resistor r=18.139 //w=0.187 //l=0.265 //layer=li //thickness=0.1 \
 //x=6.92 //y=0.805 //x2=6.92 //y2=1.07
r86 (  6 33 ) resistor r=0.751729 //w=0.17 //l=0.085 //layer=li \
 //thickness=0.1 //x=5.955 //y=1.175 //x2=5.87 //y2=1.175
r87 (  5 30 ) resistor r=1.40859 //w=0.34 //l=0.085 //layer=li //thickness=0.1 \
 //x=6.835 //y=1.175 //x2=6.92 //y2=1.175
r88 (  5 6 ) resistor r=60.2353 //w=0.187 //l=0.88 //layer=li //thickness=0.1 \
 //x=6.835 //y=1.175 //x2=5.955 //y2=1.175
ends PM_TMRDFFSNQNX1\%noxref_24

subckt PM_TMRDFFSNQNX1\%noxref_25 ( 5 7 15 19 30 33 34 )
c69 ( 34 0 ) capacitor c=0.044206f //x=11.595 //y=0.555
c70 ( 33 0 ) capacitor c=0.0191162f //x=10.49 //y=1.09
c71 ( 30 0 ) capacitor c=0.00141302f //x=11.73 //y=1.175
c72 ( 19 0 ) capacitor c=0.00695768f //x=12.7 //y=0.805
c73 ( 15 0 ) capacitor c=0.0154882f //x=12.615 //y=0.72
c74 ( 7 0 ) capacitor c=0.00689476f //x=11.73 //y=0.805
c75 ( 5 0 ) capacitor c=0.0235962f //x=11.645 //y=1.175
r76 (  19 34 ) resistor r=3.57586 //w=0.17 //l=0.125 //layer=li \
 //thickness=0.1 //x=12.7 //y=0.805 //x2=12.7 //y2=0.68
r77 (  19 34 ) resistor r=18.139 //w=0.187 //l=0.265 //layer=li \
 //thickness=0.1 //x=12.7 //y=0.805 //x2=12.7 //y2=1.07
r78 (  16 34 ) resistor r=3.57586 //w=0.17 //l=0.103078 //layer=li \
 //thickness=0.1 //x=11.815 //y=0.72 //x2=11.73 //y2=0.68
r79 (  16 34 ) resistor r=27.3797 //w=0.187 //l=0.4 //layer=li //thickness=0.1 \
 //x=11.815 //y=0.72 //x2=12.215 //y2=0.72
r80 (  15 34 ) resistor r=3.57586 //w=0.17 //l=0.103078 //layer=li \
 //thickness=0.1 //x=12.615 //y=0.72 //x2=12.7 //y2=0.68
r81 (  15 34 ) resistor r=27.3797 //w=0.187 //l=0.4 //layer=li //thickness=0.1 \
 //x=12.615 //y=0.72 //x2=12.215 //y2=0.72
r82 (  11 30 ) resistor r=5.4201 //w=0.17 //l=0.085 //layer=li //thickness=0.1 \
 //x=11.73 //y=1.26 //x2=11.73 //y2=1.175
r83 (  11 34 ) resistor r=10.2674 //w=0.187 //l=0.15 //layer=li \
 //thickness=0.1 //x=11.73 //y=1.26 //x2=11.73 //y2=1.41
r84 (  8 30 ) resistor r=5.4201 //w=0.17 //l=0.085 //layer=li //thickness=0.1 \
 //x=11.73 //y=1.09 //x2=11.73 //y2=1.175
r85 (  8 34 ) resistor r=1.36898 //w=0.187 //l=0.02 //layer=li //thickness=0.1 \
 //x=11.73 //y=1.09 //x2=11.73 //y2=1.07
r86 (  7 34 ) resistor r=3.57586 //w=0.17 //l=0.125 //layer=li //thickness=0.1 \
 //x=11.73 //y=0.805 //x2=11.73 //y2=0.68
r87 (  7 34 ) resistor r=18.139 //w=0.187 //l=0.265 //layer=li //thickness=0.1 \
 //x=11.73 //y=0.805 //x2=11.73 //y2=1.07
r88 (  6 33 ) resistor r=0.751729 //w=0.17 //l=0.085 //layer=li \
 //thickness=0.1 //x=10.765 //y=1.175 //x2=10.68 //y2=1.175
r89 (  5 30 ) resistor r=1.40859 //w=0.34 //l=0.085 //layer=li //thickness=0.1 \
 //x=11.645 //y=1.175 //x2=11.73 //y2=1.175
r90 (  5 6 ) resistor r=60.2353 //w=0.187 //l=0.88 //layer=li //thickness=0.1 \
 //x=11.645 //y=1.175 //x2=10.765 //y2=1.175
ends PM_TMRDFFSNQNX1\%noxref_25

subckt PM_TMRDFFSNQNX1\%noxref_26 ( 5 7 15 19 30 33 34 )
c69 ( 34 0 ) capacitor c=0.0454561f //x=23.065 //y=0.555
c70 ( 33 0 ) capacitor c=0.0189646f //x=21.96 //y=1.09
c71 ( 30 0 ) capacitor c=0.00141302f //x=23.2 //y=1.175
c72 ( 19 0 ) capacitor c=0.00695768f //x=24.17 //y=0.805
c73 ( 15 0 ) capacitor c=0.0154873f //x=24.085 //y=0.72
c74 ( 7 0 ) capacitor c=0.00689476f //x=23.2 //y=0.805
c75 ( 5 0 ) capacitor c=0.0235962f //x=23.115 //y=1.175
r76 (  19 34 ) resistor r=3.57586 //w=0.17 //l=0.125 //layer=li \
 //thickness=0.1 //x=24.17 //y=0.805 //x2=24.17 //y2=0.68
r77 (  19 34 ) resistor r=18.139 //w=0.187 //l=0.265 //layer=li \
 //thickness=0.1 //x=24.17 //y=0.805 //x2=24.17 //y2=1.07
r78 (  16 34 ) resistor r=3.57586 //w=0.17 //l=0.103078 //layer=li \
 //thickness=0.1 //x=23.285 //y=0.72 //x2=23.2 //y2=0.68
r79 (  16 34 ) resistor r=27.3797 //w=0.187 //l=0.4 //layer=li //thickness=0.1 \
 //x=23.285 //y=0.72 //x2=23.685 //y2=0.72
r80 (  15 34 ) resistor r=3.57586 //w=0.17 //l=0.103078 //layer=li \
 //thickness=0.1 //x=24.085 //y=0.72 //x2=24.17 //y2=0.68
r81 (  15 34 ) resistor r=27.3797 //w=0.187 //l=0.4 //layer=li //thickness=0.1 \
 //x=24.085 //y=0.72 //x2=23.685 //y2=0.72
r82 (  11 30 ) resistor r=5.4201 //w=0.17 //l=0.085 //layer=li //thickness=0.1 \
 //x=23.2 //y=1.26 //x2=23.2 //y2=1.175
r83 (  11 34 ) resistor r=10.2674 //w=0.187 //l=0.15 //layer=li \
 //thickness=0.1 //x=23.2 //y=1.26 //x2=23.2 //y2=1.41
r84 (  8 30 ) resistor r=5.4201 //w=0.17 //l=0.085 //layer=li //thickness=0.1 \
 //x=23.2 //y=1.09 //x2=23.2 //y2=1.175
r85 (  8 34 ) resistor r=1.36898 //w=0.187 //l=0.02 //layer=li //thickness=0.1 \
 //x=23.2 //y=1.09 //x2=23.2 //y2=1.07
r86 (  7 34 ) resistor r=3.57586 //w=0.17 //l=0.125 //layer=li //thickness=0.1 \
 //x=23.2 //y=0.805 //x2=23.2 //y2=0.68
r87 (  7 34 ) resistor r=18.139 //w=0.187 //l=0.265 //layer=li //thickness=0.1 \
 //x=23.2 //y=0.805 //x2=23.2 //y2=1.07
r88 (  6 33 ) resistor r=0.751729 //w=0.17 //l=0.085 //layer=li \
 //thickness=0.1 //x=22.235 //y=1.175 //x2=22.15 //y2=1.175
r89 (  5 30 ) resistor r=1.40859 //w=0.34 //l=0.085 //layer=li //thickness=0.1 \
 //x=23.115 //y=1.175 //x2=23.2 //y2=1.175
r90 (  5 6 ) resistor r=60.2353 //w=0.187 //l=0.88 //layer=li //thickness=0.1 \
 //x=23.115 //y=1.175 //x2=22.235 //y2=1.175
ends PM_TMRDFFSNQNX1\%noxref_26

subckt PM_TMRDFFSNQNX1\%noxref_27 ( 5 7 15 19 30 33 34 )
c67 ( 34 0 ) capacitor c=0.0456187f //x=31.205 //y=0.555
c68 ( 33 0 ) capacitor c=0.0194877f //x=30.1 //y=1.09
c69 ( 30 0 ) capacitor c=0.00141302f //x=31.34 //y=1.175
c70 ( 19 0 ) capacitor c=0.00692795f //x=32.31 //y=0.805
c71 ( 15 0 ) capacitor c=0.0154882f //x=32.225 //y=0.72
c72 ( 7 0 ) capacitor c=0.00689459f //x=31.34 //y=0.805
c73 ( 5 0 ) capacitor c=0.0235962f //x=31.255 //y=1.175
r74 (  19 34 ) resistor r=3.57586 //w=0.17 //l=0.125 //layer=li \
 //thickness=0.1 //x=32.31 //y=0.805 //x2=32.31 //y2=0.68
r75 (  19 34 ) resistor r=18.139 //w=0.187 //l=0.265 //layer=li \
 //thickness=0.1 //x=32.31 //y=0.805 //x2=32.31 //y2=1.07
r76 (  16 34 ) resistor r=3.57586 //w=0.17 //l=0.103078 //layer=li \
 //thickness=0.1 //x=31.425 //y=0.72 //x2=31.34 //y2=0.68
r77 (  16 34 ) resistor r=27.3797 //w=0.187 //l=0.4 //layer=li //thickness=0.1 \
 //x=31.425 //y=0.72 //x2=31.825 //y2=0.72
r78 (  15 34 ) resistor r=3.57586 //w=0.17 //l=0.103078 //layer=li \
 //thickness=0.1 //x=32.225 //y=0.72 //x2=32.31 //y2=0.68
r79 (  15 34 ) resistor r=27.3797 //w=0.187 //l=0.4 //layer=li //thickness=0.1 \
 //x=32.225 //y=0.72 //x2=31.825 //y2=0.72
r80 (  11 30 ) resistor r=5.4201 //w=0.17 //l=0.085 //layer=li //thickness=0.1 \
 //x=31.34 //y=1.26 //x2=31.34 //y2=1.175
r81 (  11 34 ) resistor r=10.2674 //w=0.187 //l=0.15 //layer=li \
 //thickness=0.1 //x=31.34 //y=1.26 //x2=31.34 //y2=1.41
r82 (  8 30 ) resistor r=5.4201 //w=0.17 //l=0.085 //layer=li //thickness=0.1 \
 //x=31.34 //y=1.09 //x2=31.34 //y2=1.175
r83 (  8 34 ) resistor r=1.36898 //w=0.187 //l=0.02 //layer=li //thickness=0.1 \
 //x=31.34 //y=1.09 //x2=31.34 //y2=1.07
r84 (  7 34 ) resistor r=3.57586 //w=0.17 //l=0.125 //layer=li //thickness=0.1 \
 //x=31.34 //y=0.805 //x2=31.34 //y2=0.68
r85 (  7 34 ) resistor r=18.139 //w=0.187 //l=0.265 //layer=li //thickness=0.1 \
 //x=31.34 //y=0.805 //x2=31.34 //y2=1.07
r86 (  6 33 ) resistor r=0.751729 //w=0.17 //l=0.085 //layer=li \
 //thickness=0.1 //x=30.375 //y=1.175 //x2=30.29 //y2=1.175
r87 (  5 30 ) resistor r=1.40859 //w=0.34 //l=0.085 //layer=li //thickness=0.1 \
 //x=31.255 //y=1.175 //x2=31.34 //y2=1.175
r88 (  5 6 ) resistor r=60.2353 //w=0.187 //l=0.88 //layer=li //thickness=0.1 \
 //x=31.255 //y=1.175 //x2=30.375 //y2=1.175
ends PM_TMRDFFSNQNX1\%noxref_27

subckt PM_TMRDFFSNQNX1\%noxref_28 ( 5 7 15 19 30 33 34 )
c68 ( 34 0 ) capacitor c=0.044206f //x=36.015 //y=0.555
c69 ( 33 0 ) capacitor c=0.0190646f //x=34.91 //y=1.09
c70 ( 30 0 ) capacitor c=0.00141302f //x=36.15 //y=1.175
c71 ( 19 0 ) capacitor c=0.00695768f //x=37.12 //y=0.805
c72 ( 15 0 ) capacitor c=0.0154882f //x=37.035 //y=0.72
c73 ( 7 0 ) capacitor c=0.00689476f //x=36.15 //y=0.805
c74 ( 5 0 ) capacitor c=0.0235962f //x=36.065 //y=1.175
r75 (  19 34 ) resistor r=3.57586 //w=0.17 //l=0.125 //layer=li \
 //thickness=0.1 //x=37.12 //y=0.805 //x2=37.12 //y2=0.68
r76 (  19 34 ) resistor r=18.139 //w=0.187 //l=0.265 //layer=li \
 //thickness=0.1 //x=37.12 //y=0.805 //x2=37.12 //y2=1.07
r77 (  16 34 ) resistor r=3.57586 //w=0.17 //l=0.103078 //layer=li \
 //thickness=0.1 //x=36.235 //y=0.72 //x2=36.15 //y2=0.68
r78 (  16 34 ) resistor r=27.3797 //w=0.187 //l=0.4 //layer=li //thickness=0.1 \
 //x=36.235 //y=0.72 //x2=36.635 //y2=0.72
r79 (  15 34 ) resistor r=3.57586 //w=0.17 //l=0.103078 //layer=li \
 //thickness=0.1 //x=37.035 //y=0.72 //x2=37.12 //y2=0.68
r80 (  15 34 ) resistor r=27.3797 //w=0.187 //l=0.4 //layer=li //thickness=0.1 \
 //x=37.035 //y=0.72 //x2=36.635 //y2=0.72
r81 (  11 30 ) resistor r=5.4201 //w=0.17 //l=0.085 //layer=li //thickness=0.1 \
 //x=36.15 //y=1.26 //x2=36.15 //y2=1.175
r82 (  11 34 ) resistor r=10.2674 //w=0.187 //l=0.15 //layer=li \
 //thickness=0.1 //x=36.15 //y=1.26 //x2=36.15 //y2=1.41
r83 (  8 30 ) resistor r=5.4201 //w=0.17 //l=0.085 //layer=li //thickness=0.1 \
 //x=36.15 //y=1.09 //x2=36.15 //y2=1.175
r84 (  8 34 ) resistor r=1.36898 //w=0.187 //l=0.02 //layer=li //thickness=0.1 \
 //x=36.15 //y=1.09 //x2=36.15 //y2=1.07
r85 (  7 34 ) resistor r=3.57586 //w=0.17 //l=0.125 //layer=li //thickness=0.1 \
 //x=36.15 //y=0.805 //x2=36.15 //y2=0.68
r86 (  7 34 ) resistor r=18.139 //w=0.187 //l=0.265 //layer=li //thickness=0.1 \
 //x=36.15 //y=0.805 //x2=36.15 //y2=1.07
r87 (  6 33 ) resistor r=0.751729 //w=0.17 //l=0.085 //layer=li \
 //thickness=0.1 //x=35.185 //y=1.175 //x2=35.1 //y2=1.175
r88 (  5 30 ) resistor r=1.40859 //w=0.34 //l=0.085 //layer=li //thickness=0.1 \
 //x=36.065 //y=1.175 //x2=36.15 //y2=1.175
r89 (  5 6 ) resistor r=60.2353 //w=0.187 //l=0.88 //layer=li //thickness=0.1 \
 //x=36.065 //y=1.175 //x2=35.185 //y2=1.175
ends PM_TMRDFFSNQNX1\%noxref_28

subckt PM_TMRDFFSNQNX1\%noxref_29 ( 5 7 15 19 30 33 34 )
c69 ( 34 0 ) capacitor c=0.0454561f //x=47.485 //y=0.555
c70 ( 33 0 ) capacitor c=0.0189646f //x=46.38 //y=1.09
c71 ( 30 0 ) capacitor c=0.00141302f //x=47.62 //y=1.175
c72 ( 19 0 ) capacitor c=0.00695768f //x=48.59 //y=0.805
c73 ( 15 0 ) capacitor c=0.0154873f //x=48.505 //y=0.72
c74 ( 7 0 ) capacitor c=0.00689476f //x=47.62 //y=0.805
c75 ( 5 0 ) capacitor c=0.0235962f //x=47.535 //y=1.175
r76 (  19 34 ) resistor r=3.57586 //w=0.17 //l=0.125 //layer=li \
 //thickness=0.1 //x=48.59 //y=0.805 //x2=48.59 //y2=0.68
r77 (  19 34 ) resistor r=18.139 //w=0.187 //l=0.265 //layer=li \
 //thickness=0.1 //x=48.59 //y=0.805 //x2=48.59 //y2=1.07
r78 (  16 34 ) resistor r=3.57586 //w=0.17 //l=0.103078 //layer=li \
 //thickness=0.1 //x=47.705 //y=0.72 //x2=47.62 //y2=0.68
r79 (  16 34 ) resistor r=27.3797 //w=0.187 //l=0.4 //layer=li //thickness=0.1 \
 //x=47.705 //y=0.72 //x2=48.105 //y2=0.72
r80 (  15 34 ) resistor r=3.57586 //w=0.17 //l=0.103078 //layer=li \
 //thickness=0.1 //x=48.505 //y=0.72 //x2=48.59 //y2=0.68
r81 (  15 34 ) resistor r=27.3797 //w=0.187 //l=0.4 //layer=li //thickness=0.1 \
 //x=48.505 //y=0.72 //x2=48.105 //y2=0.72
r82 (  11 30 ) resistor r=5.4201 //w=0.17 //l=0.085 //layer=li //thickness=0.1 \
 //x=47.62 //y=1.26 //x2=47.62 //y2=1.175
r83 (  11 34 ) resistor r=10.2674 //w=0.187 //l=0.15 //layer=li \
 //thickness=0.1 //x=47.62 //y=1.26 //x2=47.62 //y2=1.41
r84 (  8 30 ) resistor r=5.4201 //w=0.17 //l=0.085 //layer=li //thickness=0.1 \
 //x=47.62 //y=1.09 //x2=47.62 //y2=1.175
r85 (  8 34 ) resistor r=1.36898 //w=0.187 //l=0.02 //layer=li //thickness=0.1 \
 //x=47.62 //y=1.09 //x2=47.62 //y2=1.07
r86 (  7 34 ) resistor r=3.57586 //w=0.17 //l=0.125 //layer=li //thickness=0.1 \
 //x=47.62 //y=0.805 //x2=47.62 //y2=0.68
r87 (  7 34 ) resistor r=18.139 //w=0.187 //l=0.265 //layer=li //thickness=0.1 \
 //x=47.62 //y=0.805 //x2=47.62 //y2=1.07
r88 (  6 33 ) resistor r=0.751729 //w=0.17 //l=0.085 //layer=li \
 //thickness=0.1 //x=46.655 //y=1.175 //x2=46.57 //y2=1.175
r89 (  5 30 ) resistor r=1.40859 //w=0.34 //l=0.085 //layer=li //thickness=0.1 \
 //x=47.535 //y=1.175 //x2=47.62 //y2=1.175
r90 (  5 6 ) resistor r=60.2353 //w=0.187 //l=0.88 //layer=li //thickness=0.1 \
 //x=47.535 //y=1.175 //x2=46.655 //y2=1.175
ends PM_TMRDFFSNQNX1\%noxref_29

subckt PM_TMRDFFSNQNX1\%noxref_30 ( 5 7 15 19 30 33 34 )
c67 ( 34 0 ) capacitor c=0.0456187f //x=55.625 //y=0.555
c68 ( 33 0 ) capacitor c=0.0194877f //x=54.52 //y=1.09
c69 ( 30 0 ) capacitor c=0.00141302f //x=55.76 //y=1.175
c70 ( 19 0 ) capacitor c=0.00692795f //x=56.73 //y=0.805
c71 ( 15 0 ) capacitor c=0.0154882f //x=56.645 //y=0.72
c72 ( 7 0 ) capacitor c=0.00689459f //x=55.76 //y=0.805
c73 ( 5 0 ) capacitor c=0.0235962f //x=55.675 //y=1.175
r74 (  19 34 ) resistor r=3.57586 //w=0.17 //l=0.125 //layer=li \
 //thickness=0.1 //x=56.73 //y=0.805 //x2=56.73 //y2=0.68
r75 (  19 34 ) resistor r=18.139 //w=0.187 //l=0.265 //layer=li \
 //thickness=0.1 //x=56.73 //y=0.805 //x2=56.73 //y2=1.07
r76 (  16 34 ) resistor r=3.57586 //w=0.17 //l=0.103078 //layer=li \
 //thickness=0.1 //x=55.845 //y=0.72 //x2=55.76 //y2=0.68
r77 (  16 34 ) resistor r=27.3797 //w=0.187 //l=0.4 //layer=li //thickness=0.1 \
 //x=55.845 //y=0.72 //x2=56.245 //y2=0.72
r78 (  15 34 ) resistor r=3.57586 //w=0.17 //l=0.103078 //layer=li \
 //thickness=0.1 //x=56.645 //y=0.72 //x2=56.73 //y2=0.68
r79 (  15 34 ) resistor r=27.3797 //w=0.187 //l=0.4 //layer=li //thickness=0.1 \
 //x=56.645 //y=0.72 //x2=56.245 //y2=0.72
r80 (  11 30 ) resistor r=5.4201 //w=0.17 //l=0.085 //layer=li //thickness=0.1 \
 //x=55.76 //y=1.26 //x2=55.76 //y2=1.175
r81 (  11 34 ) resistor r=10.2674 //w=0.187 //l=0.15 //layer=li \
 //thickness=0.1 //x=55.76 //y=1.26 //x2=55.76 //y2=1.41
r82 (  8 30 ) resistor r=5.4201 //w=0.17 //l=0.085 //layer=li //thickness=0.1 \
 //x=55.76 //y=1.09 //x2=55.76 //y2=1.175
r83 (  8 34 ) resistor r=1.36898 //w=0.187 //l=0.02 //layer=li //thickness=0.1 \
 //x=55.76 //y=1.09 //x2=55.76 //y2=1.07
r84 (  7 34 ) resistor r=3.57586 //w=0.17 //l=0.125 //layer=li //thickness=0.1 \
 //x=55.76 //y=0.805 //x2=55.76 //y2=0.68
r85 (  7 34 ) resistor r=18.139 //w=0.187 //l=0.265 //layer=li //thickness=0.1 \
 //x=55.76 //y=0.805 //x2=55.76 //y2=1.07
r86 (  6 33 ) resistor r=0.751729 //w=0.17 //l=0.085 //layer=li \
 //thickness=0.1 //x=54.795 //y=1.175 //x2=54.71 //y2=1.175
r87 (  5 30 ) resistor r=1.40859 //w=0.34 //l=0.085 //layer=li //thickness=0.1 \
 //x=55.675 //y=1.175 //x2=55.76 //y2=1.175
r88 (  5 6 ) resistor r=60.2353 //w=0.187 //l=0.88 //layer=li //thickness=0.1 \
 //x=55.675 //y=1.175 //x2=54.795 //y2=1.175
ends PM_TMRDFFSNQNX1\%noxref_30

subckt PM_TMRDFFSNQNX1\%noxref_31 ( 5 7 15 19 30 33 34 )
c68 ( 34 0 ) capacitor c=0.044206f //x=60.435 //y=0.555
c69 ( 33 0 ) capacitor c=0.0190646f //x=59.33 //y=1.09
c70 ( 30 0 ) capacitor c=0.00141302f //x=60.57 //y=1.175
c71 ( 19 0 ) capacitor c=0.00695768f //x=61.54 //y=0.805
c72 ( 15 0 ) capacitor c=0.0154882f //x=61.455 //y=0.72
c73 ( 7 0 ) capacitor c=0.00689476f //x=60.57 //y=0.805
c74 ( 5 0 ) capacitor c=0.0235962f //x=60.485 //y=1.175
r75 (  19 34 ) resistor r=3.57586 //w=0.17 //l=0.125 //layer=li \
 //thickness=0.1 //x=61.54 //y=0.805 //x2=61.54 //y2=0.68
r76 (  19 34 ) resistor r=18.139 //w=0.187 //l=0.265 //layer=li \
 //thickness=0.1 //x=61.54 //y=0.805 //x2=61.54 //y2=1.07
r77 (  16 34 ) resistor r=3.57586 //w=0.17 //l=0.103078 //layer=li \
 //thickness=0.1 //x=60.655 //y=0.72 //x2=60.57 //y2=0.68
r78 (  16 34 ) resistor r=27.3797 //w=0.187 //l=0.4 //layer=li //thickness=0.1 \
 //x=60.655 //y=0.72 //x2=61.055 //y2=0.72
r79 (  15 34 ) resistor r=3.57586 //w=0.17 //l=0.103078 //layer=li \
 //thickness=0.1 //x=61.455 //y=0.72 //x2=61.54 //y2=0.68
r80 (  15 34 ) resistor r=27.3797 //w=0.187 //l=0.4 //layer=li //thickness=0.1 \
 //x=61.455 //y=0.72 //x2=61.055 //y2=0.72
r81 (  11 30 ) resistor r=5.4201 //w=0.17 //l=0.085 //layer=li //thickness=0.1 \
 //x=60.57 //y=1.26 //x2=60.57 //y2=1.175
r82 (  11 34 ) resistor r=10.2674 //w=0.187 //l=0.15 //layer=li \
 //thickness=0.1 //x=60.57 //y=1.26 //x2=60.57 //y2=1.41
r83 (  8 30 ) resistor r=5.4201 //w=0.17 //l=0.085 //layer=li //thickness=0.1 \
 //x=60.57 //y=1.09 //x2=60.57 //y2=1.175
r84 (  8 34 ) resistor r=1.36898 //w=0.187 //l=0.02 //layer=li //thickness=0.1 \
 //x=60.57 //y=1.09 //x2=60.57 //y2=1.07
r85 (  7 34 ) resistor r=3.57586 //w=0.17 //l=0.125 //layer=li //thickness=0.1 \
 //x=60.57 //y=0.805 //x2=60.57 //y2=0.68
r86 (  7 34 ) resistor r=18.139 //w=0.187 //l=0.265 //layer=li //thickness=0.1 \
 //x=60.57 //y=0.805 //x2=60.57 //y2=1.07
r87 (  6 33 ) resistor r=0.751729 //w=0.17 //l=0.085 //layer=li \
 //thickness=0.1 //x=59.605 //y=1.175 //x2=59.52 //y2=1.175
r88 (  5 30 ) resistor r=1.40859 //w=0.34 //l=0.085 //layer=li //thickness=0.1 \
 //x=60.485 //y=1.175 //x2=60.57 //y2=1.175
r89 (  5 6 ) resistor r=60.2353 //w=0.187 //l=0.88 //layer=li //thickness=0.1 \
 //x=60.485 //y=1.175 //x2=59.605 //y2=1.175
ends PM_TMRDFFSNQNX1\%noxref_31

subckt PM_TMRDFFSNQNX1\%noxref_32 ( 5 7 15 19 30 33 34 )
c69 ( 34 0 ) capacitor c=0.0458389f //x=71.905 //y=0.555
c70 ( 33 0 ) capacitor c=0.0189604f //x=70.8 //y=1.09
c71 ( 30 0 ) capacitor c=0.00141302f //x=72.04 //y=1.175
c72 ( 19 0 ) capacitor c=0.00695768f //x=73.01 //y=0.805
c73 ( 15 0 ) capacitor c=0.0155071f //x=72.925 //y=0.72
c74 ( 7 0 ) capacitor c=0.00689476f //x=72.04 //y=0.805
c75 ( 5 0 ) capacitor c=0.0247635f //x=71.955 //y=1.175
r76 (  19 34 ) resistor r=3.57586 //w=0.17 //l=0.125 //layer=li \
 //thickness=0.1 //x=73.01 //y=0.805 //x2=73.01 //y2=0.68
r77 (  19 34 ) resistor r=18.139 //w=0.187 //l=0.265 //layer=li \
 //thickness=0.1 //x=73.01 //y=0.805 //x2=73.01 //y2=1.07
r78 (  16 34 ) resistor r=3.57586 //w=0.17 //l=0.103078 //layer=li \
 //thickness=0.1 //x=72.125 //y=0.72 //x2=72.04 //y2=0.68
r79 (  16 34 ) resistor r=27.3797 //w=0.187 //l=0.4 //layer=li //thickness=0.1 \
 //x=72.125 //y=0.72 //x2=72.525 //y2=0.72
r80 (  15 34 ) resistor r=3.57586 //w=0.17 //l=0.103078 //layer=li \
 //thickness=0.1 //x=72.925 //y=0.72 //x2=73.01 //y2=0.68
r81 (  15 34 ) resistor r=27.3797 //w=0.187 //l=0.4 //layer=li //thickness=0.1 \
 //x=72.925 //y=0.72 //x2=72.525 //y2=0.72
r82 (  11 30 ) resistor r=5.4201 //w=0.17 //l=0.085 //layer=li //thickness=0.1 \
 //x=72.04 //y=1.26 //x2=72.04 //y2=1.175
r83 (  11 34 ) resistor r=10.2674 //w=0.187 //l=0.15 //layer=li \
 //thickness=0.1 //x=72.04 //y=1.26 //x2=72.04 //y2=1.41
r84 (  8 30 ) resistor r=5.4201 //w=0.17 //l=0.085 //layer=li //thickness=0.1 \
 //x=72.04 //y=1.09 //x2=72.04 //y2=1.175
r85 (  8 34 ) resistor r=1.36898 //w=0.187 //l=0.02 //layer=li //thickness=0.1 \
 //x=72.04 //y=1.09 //x2=72.04 //y2=1.07
r86 (  7 34 ) resistor r=3.57586 //w=0.17 //l=0.125 //layer=li //thickness=0.1 \
 //x=72.04 //y=0.805 //x2=72.04 //y2=0.68
r87 (  7 34 ) resistor r=18.139 //w=0.187 //l=0.265 //layer=li //thickness=0.1 \
 //x=72.04 //y=0.805 //x2=72.04 //y2=1.07
r88 (  6 33 ) resistor r=0.751729 //w=0.17 //l=0.085 //layer=li \
 //thickness=0.1 //x=71.075 //y=1.175 //x2=70.99 //y2=1.175
r89 (  5 30 ) resistor r=1.40859 //w=0.34 //l=0.085 //layer=li //thickness=0.1 \
 //x=71.955 //y=1.175 //x2=72.04 //y2=1.175
r90 (  5 6 ) resistor r=60.2353 //w=0.187 //l=0.88 //layer=li //thickness=0.1 \
 //x=71.955 //y=1.175 //x2=71.075 //y2=1.175
ends PM_TMRDFFSNQNX1\%noxref_32

subckt PM_TMRDFFSNQNX1\%noxref_33 ( 1 3 4 5 7 9 19 25 27 30 40 49 71 72 73 74 \
 75 )
c161 ( 75 0 ) capacitor c=0.0354016f //x=79.475 //y=5.205
c162 ( 74 0 ) capacitor c=0.0241107f //x=78.595 //y=5.205
c163 ( 72 0 ) capacitor c=0.00544792f //x=75.715 //y=5.205
c164 ( 71 0 ) capacitor c=0.00516996f //x=74.835 //y=5.205
c165 ( 49 0 ) capacitor c=0.0509795f //x=77.86 //y=5.39
c166 ( 40 0 ) capacitor c=0.0363228f //x=75.86 //y=5.39
c167 ( 30 0 ) capacitor c=0.0294643f //x=74.98 //y=5.56
c168 ( 27 0 ) capacitor c=0.00984489f //x=79.62 //y=6.92
c169 ( 25 0 ) capacitor c=0.0059844f //x=78.737 //y=7.09
c170 ( 19 0 ) capacitor c=0.00975753f //x=77.86 //y=6.92
c171 ( 9 0 ) capacitor c=0.014892f //x=74.982 //y=5.39
c172 ( 7 0 ) capacitor c=0.00787288f //x=79.505 //y=7.09
c173 ( 5 0 ) capacitor c=0.00659042f //x=78.62 //y=7.09
c174 ( 4 0 ) capacitor c=0.0054878f //x=75.975 //y=5.39
c175 ( 3 0 ) capacitor c=0.0636102f //x=77.745 //y=5.39
c176 ( 1 0 ) capacitor c=0.0141017f //x=75.745 //y=5.39
r177 (  49 73 ) resistor r=58.1818 //w=0.187 //l=0.85 //layer=li \
 //thickness=0.1 //x=77.86 //y=5.39 //x2=77.86 //y2=6.24
r178 (  40 72 ) resistor r=58.1818 //w=0.187 //l=0.85 //layer=li \
 //thickness=0.1 //x=75.86 //y=5.39 //x2=75.86 //y2=6.24
r179 (  30 71 ) resistor r=23.2727 //w=0.187 //l=0.34 //layer=li \
 //thickness=0.1 //x=74.98 //y=5.56 //x2=74.98 //y2=5.9
r180 (  27 75 ) resistor r=9.3 //w=0.17 //l=0.17 //layer=mcon //count=1 \
 //x=79.62 //y=6.92 //x2=79.62 //y2=6.92
r181 (  27 28 ) resistor r=0.0988372 //w=0.215 //l=0.17 //layer=m1 \
 //thickness=0.36 //x=79.622 //y=6.92 //x2=79.622 //y2=7.09
r182 (  24 74 ) resistor r=9.3 //w=0.17 //l=0.17 //layer=mcon //count=1 \
 //x=78.74 //y=6.92 //x2=78.74 //y2=6.92
r183 (  24 25 ) resistor r=0.0940266 //w=0.226 //l=0.17 //layer=m1 \
 //thickness=0.36 //x=78.737 //y=6.92 //x2=78.737 //y2=7.09
r184 (  22 49 ) resistor r=9.3 //w=0.17 //l=0.17 //layer=mcon //count=1 \
 //x=77.86 //y=5.39 //x2=77.86 //y2=5.39
r185 (  19 73 ) resistor r=9.3 //w=0.17 //l=0.17 //layer=mcon //count=1 \
 //x=77.86 //y=6.92 //x2=77.86 //y2=6.92
r186 (  19 20 ) resistor r=0.0979263 //w=0.217 //l=0.17 //layer=m1 \
 //thickness=0.36 //x=77.862 //y=6.92 //x2=77.862 //y2=7.09
r187 (  15 40 ) resistor r=9.3 //w=0.17 //l=0.17 //layer=mcon //count=1 \
 //x=75.86 //y=5.39 //x2=75.86 //y2=5.39
r188 (  11 30 ) resistor r=9.3 //w=0.17 //l=0.17 //layer=mcon //count=1 \
 //x=74.98 //y=5.56 //x2=74.98 //y2=5.56
r189 (  9 11 ) resistor r=0.0944444 //w=0.225 //l=0.17 //layer=m1 \
 //thickness=0.36 //x=74.982 //y=5.39 //x2=74.982 //y2=5.56
r190 (  8 25 ) resistor r=0.0246599 //w=0.226 //l=0.118 //layer=m1 \
 //thickness=0.36 //x=78.855 //y=7.09 //x2=78.737 //y2=7.09
r191 (  7 28 ) resistor r=0.0216707 //w=0.215 //l=0.117 //layer=m1 \
 //thickness=0.36 //x=79.505 //y=7.09 //x2=79.622 //y2=7.09
r192 (  7 8 ) resistor r=0.620229 //w=0.131 //l=0.65 //layer=m1 \
 //thickness=0.36 //x=79.505 //y=7.09 //x2=78.855 //y2=7.09
r193 (  6 20 ) resistor r=0.0222262 //w=0.217 //l=0.118 //layer=m1 \
 //thickness=0.36 //x=77.98 //y=7.09 //x2=77.862 //y2=7.09
r194 (  5 25 ) resistor r=0.0246599 //w=0.226 //l=0.117 //layer=m1 \
 //thickness=0.36 //x=78.62 //y=7.09 //x2=78.737 //y2=7.09
r195 (  5 6 ) resistor r=0.610687 //w=0.131 //l=0.64 //layer=m1 \
 //thickness=0.36 //x=78.62 //y=7.09 //x2=77.98 //y2=7.09
r196 (  4 15 ) resistor r=0.0880901 //w=0.191 //l=0.115 //layer=m1 \
 //thickness=0.36 //x=75.975 //y=5.39 //x2=75.86 //y2=5.39
r197 (  3 22 ) resistor r=0.0717383 //w=0.224 //l=0.115 //layer=m1 \
 //thickness=0.36 //x=77.745 //y=5.39 //x2=77.86 //y2=5.39
r198 (  3 4 ) resistor r=1.68893 //w=0.131 //l=1.77 //layer=m1 \
 //thickness=0.36 //x=77.745 //y=5.39 //x2=75.975 //y2=5.39
r199 (  2 9 ) resistor r=0.0243946 //w=0.225 //l=0.123 //layer=m1 \
 //thickness=0.36 //x=75.105 //y=5.39 //x2=74.982 //y2=5.39
r200 (  1 15 ) resistor r=0.0880901 //w=0.191 //l=0.115 //layer=m1 \
 //thickness=0.36 //x=75.745 //y=5.39 //x2=75.86 //y2=5.39
r201 (  1 2 ) resistor r=0.610687 //w=0.131 //l=0.64 //layer=m1 \
 //thickness=0.36 //x=75.745 //y=5.39 //x2=75.105 //y2=5.39
ends PM_TMRDFFSNQNX1\%noxref_33

subckt PM_TMRDFFSNQNX1\%noxref_34 ( 1 3 4 5 7 9 15 21 23 26 34 40 62 63 64 65 \
 66 )
c123 ( 66 0 ) capacitor c=0.0346626f //x=82.815 //y=5.205
c124 ( 65 0 ) capacitor c=0.0239063f //x=81.935 //y=5.205
c125 ( 40 0 ) capacitor c=0.0496943f //x=81.2 //y=5.39
c126 ( 34 0 ) capacitor c=0.0324071f //x=79.18 //y=5.39
c127 ( 26 0 ) capacitor c=0.0224248f //x=78.3 //y=5.56
c128 ( 23 0 ) capacitor c=0.0159821f //x=82.96 //y=6.92
c129 ( 21 0 ) capacitor c=0.00566376f //x=82.08 //y=7.09
c130 ( 15 0 ) capacitor c=0.00945187f //x=81.2 //y=6.92
c131 ( 9 0 ) capacitor c=0.0152859f //x=78.3 //y=5.39
c132 ( 7 0 ) capacitor c=0.0068287f //x=82.83 //y=7.09
c133 ( 5 0 ) capacitor c=0.00878908f //x=81.965 //y=7.09
c134 ( 4 0 ) capacitor c=0.00709931f //x=79.295 //y=5.39
c135 ( 3 0 ) capacitor c=0.0562658f //x=81.085 //y=5.39
c136 ( 1 0 ) capacitor c=0.0183137f //x=79.065 //y=5.39
r137 (  40 64 ) resistor r=58.1818 //w=0.187 //l=0.85 //layer=li \
 //thickness=0.1 //x=81.2 //y=5.39 //x2=81.2 //y2=6.24
r138 (  34 63 ) resistor r=58.1818 //w=0.187 //l=0.85 //layer=li \
 //thickness=0.1 //x=79.18 //y=5.39 //x2=79.18 //y2=6.24
r139 (  26 62 ) resistor r=23.2727 //w=0.187 //l=0.34 //layer=li \
 //thickness=0.1 //x=78.3 //y=5.56 //x2=78.3 //y2=5.9
r140 (  23 66 ) resistor r=9.3 //w=0.17 //l=0.17 //layer=mcon //count=1 \
 //x=82.96 //y=6.92 //x2=82.96 //y2=6.92
r141 (  23 24 ) resistor r=0.0923913 //w=0.23 //l=0.17 //layer=m1 \
 //thickness=0.36 //x=82.955 //y=6.92 //x2=82.955 //y2=7.09
r142 (  20 65 ) resistor r=9.3 //w=0.17 //l=0.17 //layer=mcon //count=1 \
 //x=82.08 //y=6.92 //x2=82.08 //y2=6.92
r143 (  20 21 ) resistor r=0.0957207 //w=0.222 //l=0.17 //layer=m1 \
 //thickness=0.36 //x=82.08 //y=6.92 //x2=82.08 //y2=7.09
r144 (  18 40 ) resistor r=9.3 //w=0.17 //l=0.17 //layer=mcon //count=1 \
 //x=81.2 //y=5.39 //x2=81.2 //y2=5.39
r145 (  15 64 ) resistor r=9.3 //w=0.17 //l=0.17 //layer=mcon //count=1 \
 //x=81.2 //y=6.92 //x2=81.2 //y2=6.92
r146 (  15 16 ) resistor r=0.100236 //w=0.212 //l=0.17 //layer=m1 \
 //thickness=0.36 //x=81.2 //y=6.92 //x2=81.2 //y2=7.09
r147 (  13 34 ) resistor r=9.3 //w=0.17 //l=0.17 //layer=mcon //count=1 \
 //x=79.18 //y=5.39 //x2=79.18 //y2=5.39
r148 (  11 26 ) resistor r=9.3 //w=0.17 //l=0.17 //layer=mcon //count=1 \
 //x=78.3 //y=5.56 //x2=78.3 //y2=5.56
r149 (  9 11 ) resistor r=0.100236 //w=0.212 //l=0.17 //layer=m1 \
 //thickness=0.36 //x=78.3 //y=5.39 //x2=78.3 //y2=5.56
r150 (  8 21 ) resistor r=0.0235912 //w=0.222 //l=0.115 //layer=m1 \
 //thickness=0.36 //x=82.195 //y=7.09 //x2=82.08 //y2=7.09
r151 (  7 24 ) resistor r=0.0257089 //w=0.23 //l=0.125 //layer=m1 \
 //thickness=0.36 //x=82.83 //y=7.09 //x2=82.955 //y2=7.09
r152 (  7 8 ) resistor r=0.605916 //w=0.131 //l=0.635 //layer=m1 \
 //thickness=0.36 //x=82.83 //y=7.09 //x2=82.195 //y2=7.09
r153 (  6 16 ) resistor r=0.0208269 //w=0.212 //l=0.115 //layer=m1 \
 //thickness=0.36 //x=81.315 //y=7.09 //x2=81.2 //y2=7.09
r154 (  5 21 ) resistor r=0.0235912 //w=0.222 //l=0.115 //layer=m1 \
 //thickness=0.36 //x=81.965 //y=7.09 //x2=82.08 //y2=7.09
r155 (  5 6 ) resistor r=0.620229 //w=0.131 //l=0.65 //layer=m1 \
 //thickness=0.36 //x=81.965 //y=7.09 //x2=81.315 //y2=7.09
r156 (  4 13 ) resistor r=0.0880901 //w=0.191 //l=0.115 //layer=m1 \
 //thickness=0.36 //x=79.295 //y=5.39 //x2=79.18 //y2=5.39
r157 (  3 18 ) resistor r=0.0717383 //w=0.224 //l=0.115 //layer=m1 \
 //thickness=0.36 //x=81.085 //y=5.39 //x2=81.2 //y2=5.39
r158 (  3 4 ) resistor r=1.70802 //w=0.131 //l=1.79 //layer=m1 \
 //thickness=0.36 //x=81.085 //y=5.39 //x2=79.295 //y2=5.39
r159 (  2 9 ) resistor r=0.0208269 //w=0.212 //l=0.115 //layer=m1 \
 //thickness=0.36 //x=78.415 //y=5.39 //x2=78.3 //y2=5.39
r160 (  1 13 ) resistor r=0.0880901 //w=0.191 //l=0.115 //layer=m1 \
 //thickness=0.36 //x=79.065 //y=5.39 //x2=79.18 //y2=5.39
r161 (  1 2 ) resistor r=0.620229 //w=0.131 //l=0.65 //layer=m1 \
 //thickness=0.36 //x=79.065 //y=5.39 //x2=78.415 //y2=5.39
ends PM_TMRDFFSNQNX1\%noxref_34

subckt PM_TMRDFFSNQNX1\%GND ( 1 2 8 15 16 25 26 36 44 53 54 66 73 74 83 84 94 \
 103 112 113 125 132 133 142 143 153 161 170 171 182 183 190 191 198 203 206 \
 207 211 216 221 222 227 228 232 236 237 241 246 251 252 257 258 262 266 267 \
 271 276 281 282 287 288 292 307 310 322 339 356 369 384 401 416 433 450 463 \
 478 495 510 527 544 557 572 589 604 624 632 633 634 635 636 637 638 639 640 \
 641 642 643 644 645 646 647 648 649 650 651 652 653 654 655 656 657 658 659 \
 660 661 662 663 664 665 666 667 668 669 670 671 672 )
c1604 ( 672 0 ) capacitor c=0.00828027f //x=81.4 //y=1.045
c1605 ( 671 0 ) capacitor c=0.00867576f //x=78.07 //y=1.045
c1606 ( 670 0 ) capacitor c=0.0083251f //x=74.74 //y=1.045
c1607 ( 669 0 ) capacitor c=0.00840423f //x=69.825 //y=1.055
c1608 ( 668 0 ) capacitor c=0.00843555f //x=66.6 //y=1.045
c1609 ( 667 0 ) capacitor c=0.00843555f //x=63.27 //y=1.045
c1610 ( 666 0 ) capacitor c=0.00840423f //x=58.355 //y=1.055
c1611 ( 665 0 ) capacitor c=0.00840423f //x=53.545 //y=1.055
c1612 ( 664 0 ) capacitor c=0.00843555f //x=50.32 //y=1.045
c1613 ( 663 0 ) capacitor c=0.00840423f //x=45.405 //y=1.055
c1614 ( 662 0 ) capacitor c=0.00843555f //x=42.18 //y=1.045
c1615 ( 661 0 ) capacitor c=0.00843555f //x=38.85 //y=1.045
c1616 ( 660 0 ) capacitor c=0.00840423f //x=33.935 //y=1.055
c1617 ( 659 0 ) capacitor c=0.00840423f //x=29.125 //y=1.055
c1618 ( 658 0 ) capacitor c=0.00843555f //x=25.9 //y=1.045
c1619 ( 657 0 ) capacitor c=0.00840423f //x=20.985 //y=1.055
c1620 ( 656 0 ) capacitor c=0.00843555f //x=17.76 //y=1.045
c1621 ( 655 0 ) capacitor c=0.00843555f //x=14.43 //y=1.045
c1622 ( 654 0 ) capacitor c=0.00840423f //x=9.515 //y=1.055
c1623 ( 653 0 ) capacitor c=0.00840423f //x=4.705 //y=1.055
c1624 ( 652 0 ) capacitor c=0.00843555f //x=1.48 //y=1.045
c1625 ( 651 0 ) capacitor c=0.110294f //x=80.41 //y=0.175
c1626 ( 650 0 ) capacitor c=0.123802f //x=77.08 //y=0.175
c1627 ( 649 0 ) capacitor c=0.115672f //x=73.75 //y=0.175
c1628 ( 648 0 ) capacitor c=0.112855f //x=68.94 //y=0.175
c1629 ( 647 0 ) capacitor c=0.117575f //x=65.61 //y=0.175
c1630 ( 646 0 ) capacitor c=0.112938f //x=62.28 //y=0.175
c1631 ( 645 0 ) capacitor c=0.112435f //x=57.47 //y=0.175
c1632 ( 644 0 ) capacitor c=0.10764f //x=52.66 //y=0.175
c1633 ( 643 0 ) capacitor c=0.117926f //x=49.33 //y=0.175
c1634 ( 642 0 ) capacitor c=0.107626f //x=44.52 //y=0.175
c1635 ( 641 0 ) capacitor c=0.117089f //x=41.19 //y=0.175
c1636 ( 640 0 ) capacitor c=0.112938f //x=37.86 //y=0.175
c1637 ( 639 0 ) capacitor c=0.112435f //x=33.05 //y=0.175
c1638 ( 638 0 ) capacitor c=0.10764f //x=28.24 //y=0.175
c1639 ( 637 0 ) capacitor c=0.118515f //x=24.91 //y=0.175
c1640 ( 636 0 ) capacitor c=0.112855f //x=20.1 //y=0.175
c1641 ( 635 0 ) capacitor c=0.117575f //x=16.77 //y=0.175
c1642 ( 634 0 ) capacitor c=0.112938f //x=13.44 //y=0.175
c1643 ( 633 0 ) capacitor c=0.11182f //x=8.63 //y=0.175
c1644 ( 632 0 ) capacitor c=0.107177f //x=3.82 //y=0.175
c1645 ( 624 0 ) capacitor c=0.332864f //x=83 //y=0.18
c1646 ( 604 0 ) capacitor c=0.118812f //x=80.24 //y=0.175
c1647 ( 589 0 ) capacitor c=0.123122f //x=76.91 //y=0.175
c1648 ( 572 0 ) capacitor c=0.178514f //x=73.58 //y=0.175
c1649 ( 557 0 ) capacitor c=0.118923f //x=68.77 //y=0.175
c1650 ( 544 0 ) capacitor c=0.118923f //x=65.44 //y=0.175
c1651 ( 527 0 ) capacitor c=0.176363f //x=62.11 //y=0.175
c1652 ( 510 0 ) capacitor c=0.176363f //x=57.3 //y=0.175
c1653 ( 495 0 ) capacitor c=0.118823f //x=52.49 //y=0.175
c1654 ( 478 0 ) capacitor c=0.176388f //x=49.16 //y=0.175
c1655 ( 463 0 ) capacitor c=0.118923f //x=44.35 //y=0.175
c1656 ( 450 0 ) capacitor c=0.118923f //x=41.02 //y=0.175
c1657 ( 433 0 ) capacitor c=0.176363f //x=37.69 //y=0.175
c1658 ( 416 0 ) capacitor c=0.176363f //x=32.88 //y=0.175
c1659 ( 401 0 ) capacitor c=0.118923f //x=28.07 //y=0.175
c1660 ( 384 0 ) capacitor c=0.176388f //x=24.74 //y=0.175
c1661 ( 369 0 ) capacitor c=0.118923f //x=19.93 //y=0.175
c1662 ( 356 0 ) capacitor c=0.118923f //x=16.6 //y=0.175
c1663 ( 339 0 ) capacitor c=0.176433f //x=13.27 //y=0.175
c1664 ( 322 0 ) capacitor c=0.176513f //x=8.46 //y=0.175
c1665 ( 310 0 ) capacitor c=0.201723f //x=1.23 //y=0.18
c1666 ( 307 0 ) capacitor c=0.122877f //x=3.65 //y=0.175
c1667 ( 302 0 ) capacitor c=0.00509083f //x=81.59 //y=0.175
c1668 ( 299 0 ) capacitor c=0.00510068f //x=78.19 //y=0.18
c1669 ( 295 0 ) capacitor c=0.00509083f //x=74.93 //y=0.175
c1670 ( 294 0 ) capacitor c=0.00509414f //x=70.015 //y=0.175
c1671 ( 292 0 ) capacitor c=0.0133036f //x=70.015 //y=1.145
c1672 ( 290 0 ) capacitor c=0.00509083f //x=66.79 //y=0.175
c1673 ( 288 0 ) capacitor c=0.0187613f //x=66.787 //y=1.005
c1674 ( 287 0 ) capacitor c=0.0124186f //x=66.79 //y=1.135
c1675 ( 285 0 ) capacitor c=0.00509083f //x=63.39 //y=0.18
c1676 ( 282 0 ) capacitor c=0.0235363f //x=63.457 //y=1.005
c1677 ( 281 0 ) capacitor c=0.0134704f //x=63.46 //y=1.135
c1678 ( 279 0 ) capacitor c=0.00509414f //x=58.58 //y=0.18
c1679 ( 276 0 ) capacitor c=0.0140159f //x=58.545 //y=1.145
c1680 ( 274 0 ) capacitor c=0.00509414f //x=53.77 //y=0.18
c1681 ( 271 0 ) capacitor c=0.0130816f //x=53.735 //y=1.145
c1682 ( 269 0 ) capacitor c=0.00509083f //x=50.51 //y=0.175
c1683 ( 267 0 ) capacitor c=0.0234055f //x=50.507 //y=1.005
c1684 ( 266 0 ) capacitor c=0.0133746f //x=50.51 //y=1.135
c1685 ( 264 0 ) capacitor c=0.00509414f //x=45.595 //y=0.175
c1686 ( 262 0 ) capacitor c=0.0131105f //x=45.595 //y=1.145
c1687 ( 260 0 ) capacitor c=0.00509083f //x=42.37 //y=0.175
c1688 ( 258 0 ) capacitor c=0.0187613f //x=42.367 //y=1.005
c1689 ( 257 0 ) capacitor c=0.0124186f //x=42.37 //y=1.135
c1690 ( 255 0 ) capacitor c=0.00509083f //x=38.97 //y=0.18
c1691 ( 252 0 ) capacitor c=0.0235363f //x=39.037 //y=1.005
c1692 ( 251 0 ) capacitor c=0.0134704f //x=39.04 //y=1.135
c1693 ( 249 0 ) capacitor c=0.00509414f //x=34.16 //y=0.18
c1694 ( 246 0 ) capacitor c=0.0140159f //x=34.125 //y=1.145
c1695 ( 244 0 ) capacitor c=0.00509414f //x=29.35 //y=0.18
c1696 ( 241 0 ) capacitor c=0.0130816f //x=29.315 //y=1.145
c1697 ( 239 0 ) capacitor c=0.00509083f //x=26.09 //y=0.175
c1698 ( 237 0 ) capacitor c=0.0234055f //x=26.087 //y=1.005
c1699 ( 236 0 ) capacitor c=0.0135102f //x=26.09 //y=1.135
c1700 ( 234 0 ) capacitor c=0.00509414f //x=21.175 //y=0.175
c1701 ( 232 0 ) capacitor c=0.0131615f //x=21.175 //y=1.145
c1702 ( 230 0 ) capacitor c=0.00509083f //x=17.95 //y=0.175
c1703 ( 228 0 ) capacitor c=0.0187613f //x=17.947 //y=1.005
c1704 ( 227 0 ) capacitor c=0.0124186f //x=17.95 //y=1.135
c1705 ( 225 0 ) capacitor c=0.00509083f //x=14.55 //y=0.18
c1706 ( 222 0 ) capacitor c=0.0235363f //x=14.617 //y=1.005
c1707 ( 221 0 ) capacitor c=0.0134704f //x=14.62 //y=1.135
c1708 ( 219 0 ) capacitor c=0.00509414f //x=9.74 //y=0.18
c1709 ( 216 0 ) capacitor c=0.0140227f //x=9.705 //y=1.145
c1710 ( 214 0 ) capacitor c=0.00509414f //x=4.93 //y=0.18
c1711 ( 211 0 ) capacitor c=0.0132507f //x=4.895 //y=1.145
c1712 ( 209 0 ) capacitor c=0.00509083f //x=1.67 //y=0.175
c1713 ( 207 0 ) capacitor c=0.0234055f //x=1.667 //y=1.005
c1714 ( 206 0 ) capacitor c=0.0159643f //x=1.67 //y=1.135
c1715 ( 203 0 ) capacitor c=0.102594f //x=83 //y=0.18
c1716 ( 198 0 ) capacitor c=0.0371563f //x=81.59 //y=1.02
c1717 ( 191 0 ) capacitor c=0.107469f //x=81.505 //y=0.175
c1718 ( 190 0 ) capacitor c=0.0274205f //x=78.26 //y=1.015
c1719 ( 183 0 ) capacitor c=0.112314f //x=78.175 //y=0.175
c1720 ( 182 0 ) capacitor c=0.0348508f //x=74.93 //y=1.015
c1721 ( 171 0 ) capacitor c=0.155073f //x=74.845 //y=0.175
c1722 ( 170 0 ) capacitor c=0.0253397f //x=70.015 //y=1.015
c1723 ( 161 0 ) capacitor c=0.105726f //x=69.93 //y=0.175
c1724 ( 153 0 ) capacitor c=0.112203f //x=66.705 //y=0.175
c1725 ( 143 0 ) capacitor c=0.154167f //x=63.375 //y=0.175
c1726 ( 142 0 ) capacitor c=0.0302305f //x=58.545 //y=1.015
c1727 ( 133 0 ) capacitor c=0.149464f //x=58.46 //y=0.175
c1728 ( 132 0 ) capacitor c=0.0253397f //x=53.735 //y=1.015
c1729 ( 125 0 ) capacitor c=0.105043f //x=53.65 //y=0.175
c1730 ( 113 0 ) capacitor c=0.156022f //x=50.425 //y=0.175
c1731 ( 112 0 ) capacitor c=0.0253397f //x=45.595 //y=1.015
c1732 ( 103 0 ) capacitor c=0.105054f //x=45.51 //y=0.175
c1733 ( 94 0 ) capacitor c=0.112203f //x=42.285 //y=0.175
c1734 ( 84 0 ) capacitor c=0.154167f //x=38.955 //y=0.175
c1735 ( 83 0 ) capacitor c=0.0302305f //x=34.125 //y=1.015
c1736 ( 74 0 ) capacitor c=0.149464f //x=34.04 //y=0.175
c1737 ( 73 0 ) capacitor c=0.0253397f //x=29.315 //y=1.015
c1738 ( 66 0 ) capacitor c=0.105162f //x=29.23 //y=0.175
c1739 ( 54 0 ) capacitor c=0.154823f //x=26.005 //y=0.175
c1740 ( 53 0 ) capacitor c=0.0253397f //x=21.175 //y=1.015
c1741 ( 44 0 ) capacitor c=0.105367f //x=21.09 //y=0.175
c1742 ( 36 0 ) capacitor c=0.112204f //x=17.865 //y=0.175
c1743 ( 26 0 ) capacitor c=0.154222f //x=14.535 //y=0.175
c1744 ( 25 0 ) capacitor c=0.0302305f //x=9.705 //y=1.015
c1745 ( 16 0 ) capacitor c=0.14953f //x=9.62 //y=0.175
c1746 ( 15 0 ) capacitor c=0.0253397f //x=4.895 //y=1.015
c1747 ( 8 0 ) capacitor c=0.105221f //x=4.81 //y=0.175
c1748 ( 2 0 ) capacitor c=0.0765201f //x=1.585 //y=0.175
r1749 (  622 624 ) resistor r=38.7139 //w=0.367 //l=1.11 //layer=li \
 //thickness=0.1 //x=81.89 //y=0.175 //x2=83 //y2=0.175
r1750 (  620 622 ) resistor r=38.7139 //w=0.367 //l=1.11 //layer=li \
 //thickness=0.1 //x=80.78 //y=0.175 //x2=81.89 //y2=0.175
r1751 (  618 651 ) resistor r=5.29055 //w=0.35 //l=0.17 //layer=li \
 //thickness=0.1 //x=80.58 //y=0.175 //x2=80.41 //y2=0.175
r1752 (  618 620 ) resistor r=6.97548 //w=0.367 //l=0.2 //layer=li \
 //thickness=0.1 //x=80.58 //y=0.175 //x2=80.78 //y2=0.175
r1753 (  607 609 ) resistor r=38.7139 //w=0.367 //l=1.11 //layer=li \
 //thickness=0.1 //x=78.19 //y=0.175 //x2=79.3 //y2=0.175
r1754 (  605 650 ) resistor r=5.29055 //w=0.35 //l=0.17 //layer=li \
 //thickness=0.1 //x=77.25 //y=0.175 //x2=77.08 //y2=0.175
r1755 (  605 607 ) resistor r=32.7847 //w=0.367 //l=0.94 //layer=li \
 //thickness=0.1 //x=77.25 //y=0.175 //x2=78.19 //y2=0.175
r1756 (  604 651 ) resistor r=5.29055 //w=0.35 //l=0.17 //layer=li \
 //thickness=0.1 //x=80.24 //y=0.175 //x2=80.41 //y2=0.175
r1757 (  604 609 ) resistor r=32.7847 //w=0.367 //l=0.94 //layer=li \
 //thickness=0.1 //x=80.24 //y=0.175 //x2=79.3 //y2=0.175
r1758 (  594 596 ) resistor r=38.7139 //w=0.367 //l=1.11 //layer=li \
 //thickness=0.1 //x=75.6 //y=0.175 //x2=76.71 //y2=0.175
r1759 (  592 594 ) resistor r=38.7139 //w=0.367 //l=1.11 //layer=li \
 //thickness=0.1 //x=74.49 //y=0.175 //x2=75.6 //y2=0.175
r1760 (  590 649 ) resistor r=5.29055 //w=0.35 //l=0.17 //layer=li \
 //thickness=0.1 //x=73.92 //y=0.175 //x2=73.75 //y2=0.175
r1761 (  590 592 ) resistor r=19.8801 //w=0.367 //l=0.57 //layer=li \
 //thickness=0.1 //x=73.92 //y=0.175 //x2=74.49 //y2=0.175
r1762 (  589 650 ) resistor r=5.29055 //w=0.35 //l=0.17 //layer=li \
 //thickness=0.1 //x=76.91 //y=0.175 //x2=77.08 //y2=0.175
r1763 (  589 596 ) resistor r=6.97548 //w=0.367 //l=0.2 //layer=li \
 //thickness=0.1 //x=76.91 //y=0.175 //x2=76.71 //y2=0.175
r1764 (  579 581 ) resistor r=38.7139 //w=0.367 //l=1.11 //layer=li \
 //thickness=0.1 //x=71.9 //y=0.175 //x2=73.01 //y2=0.175
r1765 (  577 579 ) resistor r=38.7139 //w=0.367 //l=1.11 //layer=li \
 //thickness=0.1 //x=70.79 //y=0.175 //x2=71.9 //y2=0.175
r1766 (  575 577 ) resistor r=38.7139 //w=0.367 //l=1.11 //layer=li \
 //thickness=0.1 //x=69.68 //y=0.175 //x2=70.79 //y2=0.175
r1767 (  573 648 ) resistor r=5.29055 //w=0.35 //l=0.17 //layer=li \
 //thickness=0.1 //x=69.11 //y=0.175 //x2=68.94 //y2=0.175
r1768 (  573 575 ) resistor r=19.8801 //w=0.367 //l=0.57 //layer=li \
 //thickness=0.1 //x=69.11 //y=0.175 //x2=69.68 //y2=0.175
r1769 (  572 649 ) resistor r=5.29055 //w=0.35 //l=0.17 //layer=li \
 //thickness=0.1 //x=73.58 //y=0.175 //x2=73.75 //y2=0.175
r1770 (  572 581 ) resistor r=19.8801 //w=0.367 //l=0.57 //layer=li \
 //thickness=0.1 //x=73.58 //y=0.175 //x2=73.01 //y2=0.175
r1771 (  562 564 ) resistor r=38.7139 //w=0.367 //l=1.11 //layer=li \
 //thickness=0.1 //x=67.09 //y=0.175 //x2=68.2 //y2=0.175
r1772 (  560 562 ) resistor r=38.7139 //w=0.367 //l=1.11 //layer=li \
 //thickness=0.1 //x=65.98 //y=0.175 //x2=67.09 //y2=0.175
r1773 (  558 647 ) resistor r=5.29055 //w=0.35 //l=0.17 //layer=li \
 //thickness=0.1 //x=65.78 //y=0.175 //x2=65.61 //y2=0.175
r1774 (  558 560 ) resistor r=6.97548 //w=0.367 //l=0.2 //layer=li \
 //thickness=0.1 //x=65.78 //y=0.175 //x2=65.98 //y2=0.175
r1775 (  557 648 ) resistor r=5.29055 //w=0.35 //l=0.17 //layer=li \
 //thickness=0.1 //x=68.77 //y=0.175 //x2=68.94 //y2=0.175
r1776 (  557 564 ) resistor r=19.8801 //w=0.367 //l=0.57 //layer=li \
 //thickness=0.1 //x=68.77 //y=0.175 //x2=68.2 //y2=0.175
r1777 (  547 549 ) resistor r=38.7139 //w=0.367 //l=1.11 //layer=li \
 //thickness=0.1 //x=63.39 //y=0.175 //x2=64.5 //y2=0.175
r1778 (  545 646 ) resistor r=5.29055 //w=0.35 //l=0.17 //layer=li \
 //thickness=0.1 //x=62.45 //y=0.175 //x2=62.28 //y2=0.175
r1779 (  545 547 ) resistor r=32.7847 //w=0.367 //l=0.94 //layer=li \
 //thickness=0.1 //x=62.45 //y=0.175 //x2=63.39 //y2=0.175
r1780 (  544 647 ) resistor r=5.29055 //w=0.35 //l=0.17 //layer=li \
 //thickness=0.1 //x=65.44 //y=0.175 //x2=65.61 //y2=0.175
r1781 (  544 549 ) resistor r=32.7847 //w=0.367 //l=0.94 //layer=li \
 //thickness=0.1 //x=65.44 //y=0.175 //x2=64.5 //y2=0.175
r1782 (  534 536 ) resistor r=38.7139 //w=0.367 //l=1.11 //layer=li \
 //thickness=0.1 //x=60.8 //y=0.175 //x2=61.91 //y2=0.175
r1783 (  532 534 ) resistor r=38.7139 //w=0.367 //l=1.11 //layer=li \
 //thickness=0.1 //x=59.69 //y=0.175 //x2=60.8 //y2=0.175
r1784 (  530 532 ) resistor r=38.7139 //w=0.367 //l=1.11 //layer=li \
 //thickness=0.1 //x=58.58 //y=0.175 //x2=59.69 //y2=0.175
r1785 (  528 645 ) resistor r=5.29055 //w=0.35 //l=0.17 //layer=li \
 //thickness=0.1 //x=57.64 //y=0.175 //x2=57.47 //y2=0.175
r1786 (  528 530 ) resistor r=32.7847 //w=0.367 //l=0.94 //layer=li \
 //thickness=0.1 //x=57.64 //y=0.175 //x2=58.58 //y2=0.175
r1787 (  527 646 ) resistor r=5.29055 //w=0.35 //l=0.17 //layer=li \
 //thickness=0.1 //x=62.11 //y=0.175 //x2=62.28 //y2=0.175
r1788 (  527 536 ) resistor r=6.97548 //w=0.367 //l=0.2 //layer=li \
 //thickness=0.1 //x=62.11 //y=0.175 //x2=61.91 //y2=0.175
r1789 (  517 519 ) resistor r=38.7139 //w=0.367 //l=1.11 //layer=li \
 //thickness=0.1 //x=55.99 //y=0.175 //x2=57.1 //y2=0.175
r1790 (  515 517 ) resistor r=38.7139 //w=0.367 //l=1.11 //layer=li \
 //thickness=0.1 //x=54.88 //y=0.175 //x2=55.99 //y2=0.175
r1791 (  513 515 ) resistor r=38.7139 //w=0.367 //l=1.11 //layer=li \
 //thickness=0.1 //x=53.77 //y=0.175 //x2=54.88 //y2=0.175
r1792 (  511 644 ) resistor r=5.29055 //w=0.35 //l=0.17 //layer=li \
 //thickness=0.1 //x=52.83 //y=0.175 //x2=52.66 //y2=0.175
r1793 (  511 513 ) resistor r=32.7847 //w=0.367 //l=0.94 //layer=li \
 //thickness=0.1 //x=52.83 //y=0.175 //x2=53.77 //y2=0.175
r1794 (  510 645 ) resistor r=5.29055 //w=0.35 //l=0.17 //layer=li \
 //thickness=0.1 //x=57.3 //y=0.175 //x2=57.47 //y2=0.175
r1795 (  510 519 ) resistor r=6.97548 //w=0.367 //l=0.2 //layer=li \
 //thickness=0.1 //x=57.3 //y=0.175 //x2=57.1 //y2=0.175
r1796 (  500 502 ) resistor r=38.7139 //w=0.367 //l=1.11 //layer=li \
 //thickness=0.1 //x=51.18 //y=0.175 //x2=52.29 //y2=0.175
r1797 (  498 500 ) resistor r=38.7139 //w=0.367 //l=1.11 //layer=li \
 //thickness=0.1 //x=50.07 //y=0.175 //x2=51.18 //y2=0.175
r1798 (  496 643 ) resistor r=5.29055 //w=0.35 //l=0.17 //layer=li \
 //thickness=0.1 //x=49.5 //y=0.175 //x2=49.33 //y2=0.175
r1799 (  496 498 ) resistor r=19.8801 //w=0.367 //l=0.57 //layer=li \
 //thickness=0.1 //x=49.5 //y=0.175 //x2=50.07 //y2=0.175
r1800 (  495 644 ) resistor r=5.29055 //w=0.35 //l=0.17 //layer=li \
 //thickness=0.1 //x=52.49 //y=0.175 //x2=52.66 //y2=0.175
r1801 (  495 502 ) resistor r=6.97548 //w=0.367 //l=0.2 //layer=li \
 //thickness=0.1 //x=52.49 //y=0.175 //x2=52.29 //y2=0.175
r1802 (  485 487 ) resistor r=38.7139 //w=0.367 //l=1.11 //layer=li \
 //thickness=0.1 //x=47.48 //y=0.175 //x2=48.59 //y2=0.175
r1803 (  483 485 ) resistor r=38.7139 //w=0.367 //l=1.11 //layer=li \
 //thickness=0.1 //x=46.37 //y=0.175 //x2=47.48 //y2=0.175
r1804 (  481 483 ) resistor r=38.7139 //w=0.367 //l=1.11 //layer=li \
 //thickness=0.1 //x=45.26 //y=0.175 //x2=46.37 //y2=0.175
r1805 (  479 642 ) resistor r=5.29055 //w=0.35 //l=0.17 //layer=li \
 //thickness=0.1 //x=44.69 //y=0.175 //x2=44.52 //y2=0.175
r1806 (  479 481 ) resistor r=19.8801 //w=0.367 //l=0.57 //layer=li \
 //thickness=0.1 //x=44.69 //y=0.175 //x2=45.26 //y2=0.175
r1807 (  478 643 ) resistor r=5.29055 //w=0.35 //l=0.17 //layer=li \
 //thickness=0.1 //x=49.16 //y=0.175 //x2=49.33 //y2=0.175
r1808 (  478 487 ) resistor r=19.8801 //w=0.367 //l=0.57 //layer=li \
 //thickness=0.1 //x=49.16 //y=0.175 //x2=48.59 //y2=0.175
r1809 (  468 470 ) resistor r=38.7139 //w=0.367 //l=1.11 //layer=li \
 //thickness=0.1 //x=42.67 //y=0.175 //x2=43.78 //y2=0.175
r1810 (  466 468 ) resistor r=38.7139 //w=0.367 //l=1.11 //layer=li \
 //thickness=0.1 //x=41.56 //y=0.175 //x2=42.67 //y2=0.175
r1811 (  464 641 ) resistor r=5.29055 //w=0.35 //l=0.17 //layer=li \
 //thickness=0.1 //x=41.36 //y=0.175 //x2=41.19 //y2=0.175
r1812 (  464 466 ) resistor r=6.97548 //w=0.367 //l=0.2 //layer=li \
 //thickness=0.1 //x=41.36 //y=0.175 //x2=41.56 //y2=0.175
r1813 (  463 642 ) resistor r=5.29055 //w=0.35 //l=0.17 //layer=li \
 //thickness=0.1 //x=44.35 //y=0.175 //x2=44.52 //y2=0.175
r1814 (  463 470 ) resistor r=19.8801 //w=0.367 //l=0.57 //layer=li \
 //thickness=0.1 //x=44.35 //y=0.175 //x2=43.78 //y2=0.175
r1815 (  453 455 ) resistor r=38.7139 //w=0.367 //l=1.11 //layer=li \
 //thickness=0.1 //x=38.97 //y=0.175 //x2=40.08 //y2=0.175
r1816 (  451 640 ) resistor r=5.29055 //w=0.35 //l=0.17 //layer=li \
 //thickness=0.1 //x=38.03 //y=0.175 //x2=37.86 //y2=0.175
r1817 (  451 453 ) resistor r=32.7847 //w=0.367 //l=0.94 //layer=li \
 //thickness=0.1 //x=38.03 //y=0.175 //x2=38.97 //y2=0.175
r1818 (  450 641 ) resistor r=5.29055 //w=0.35 //l=0.17 //layer=li \
 //thickness=0.1 //x=41.02 //y=0.175 //x2=41.19 //y2=0.175
r1819 (  450 455 ) resistor r=32.7847 //w=0.367 //l=0.94 //layer=li \
 //thickness=0.1 //x=41.02 //y=0.175 //x2=40.08 //y2=0.175
r1820 (  440 442 ) resistor r=38.7139 //w=0.367 //l=1.11 //layer=li \
 //thickness=0.1 //x=36.38 //y=0.175 //x2=37.49 //y2=0.175
r1821 (  438 440 ) resistor r=38.7139 //w=0.367 //l=1.11 //layer=li \
 //thickness=0.1 //x=35.27 //y=0.175 //x2=36.38 //y2=0.175
r1822 (  436 438 ) resistor r=38.7139 //w=0.367 //l=1.11 //layer=li \
 //thickness=0.1 //x=34.16 //y=0.175 //x2=35.27 //y2=0.175
r1823 (  434 639 ) resistor r=5.29055 //w=0.35 //l=0.17 //layer=li \
 //thickness=0.1 //x=33.22 //y=0.175 //x2=33.05 //y2=0.175
r1824 (  434 436 ) resistor r=32.7847 //w=0.367 //l=0.94 //layer=li \
 //thickness=0.1 //x=33.22 //y=0.175 //x2=34.16 //y2=0.175
r1825 (  433 640 ) resistor r=5.29055 //w=0.35 //l=0.17 //layer=li \
 //thickness=0.1 //x=37.69 //y=0.175 //x2=37.86 //y2=0.175
r1826 (  433 442 ) resistor r=6.97548 //w=0.367 //l=0.2 //layer=li \
 //thickness=0.1 //x=37.69 //y=0.175 //x2=37.49 //y2=0.175
r1827 (  423 425 ) resistor r=38.7139 //w=0.367 //l=1.11 //layer=li \
 //thickness=0.1 //x=31.57 //y=0.175 //x2=32.68 //y2=0.175
r1828 (  421 423 ) resistor r=38.7139 //w=0.367 //l=1.11 //layer=li \
 //thickness=0.1 //x=30.46 //y=0.175 //x2=31.57 //y2=0.175
r1829 (  419 421 ) resistor r=38.7139 //w=0.367 //l=1.11 //layer=li \
 //thickness=0.1 //x=29.35 //y=0.175 //x2=30.46 //y2=0.175
r1830 (  417 638 ) resistor r=5.29055 //w=0.35 //l=0.17 //layer=li \
 //thickness=0.1 //x=28.41 //y=0.175 //x2=28.24 //y2=0.175
r1831 (  417 419 ) resistor r=32.7847 //w=0.367 //l=0.94 //layer=li \
 //thickness=0.1 //x=28.41 //y=0.175 //x2=29.35 //y2=0.175
r1832 (  416 639 ) resistor r=5.29055 //w=0.35 //l=0.17 //layer=li \
 //thickness=0.1 //x=32.88 //y=0.175 //x2=33.05 //y2=0.175
r1833 (  416 425 ) resistor r=6.97548 //w=0.367 //l=0.2 //layer=li \
 //thickness=0.1 //x=32.88 //y=0.175 //x2=32.68 //y2=0.175
r1834 (  406 408 ) resistor r=38.7139 //w=0.367 //l=1.11 //layer=li \
 //thickness=0.1 //x=26.76 //y=0.175 //x2=27.87 //y2=0.175
r1835 (  404 406 ) resistor r=38.7139 //w=0.367 //l=1.11 //layer=li \
 //thickness=0.1 //x=25.65 //y=0.175 //x2=26.76 //y2=0.175
r1836 (  402 637 ) resistor r=5.29055 //w=0.35 //l=0.17 //layer=li \
 //thickness=0.1 //x=25.08 //y=0.175 //x2=24.91 //y2=0.175
r1837 (  402 404 ) resistor r=19.8801 //w=0.367 //l=0.57 //layer=li \
 //thickness=0.1 //x=25.08 //y=0.175 //x2=25.65 //y2=0.175
r1838 (  401 638 ) resistor r=5.29055 //w=0.35 //l=0.17 //layer=li \
 //thickness=0.1 //x=28.07 //y=0.175 //x2=28.24 //y2=0.175
r1839 (  401 408 ) resistor r=6.97548 //w=0.367 //l=0.2 //layer=li \
 //thickness=0.1 //x=28.07 //y=0.175 //x2=27.87 //y2=0.175
r1840 (  391 393 ) resistor r=38.7139 //w=0.367 //l=1.11 //layer=li \
 //thickness=0.1 //x=23.06 //y=0.175 //x2=24.17 //y2=0.175
r1841 (  389 391 ) resistor r=38.7139 //w=0.367 //l=1.11 //layer=li \
 //thickness=0.1 //x=21.95 //y=0.175 //x2=23.06 //y2=0.175
r1842 (  387 389 ) resistor r=38.7139 //w=0.367 //l=1.11 //layer=li \
 //thickness=0.1 //x=20.84 //y=0.175 //x2=21.95 //y2=0.175
r1843 (  385 636 ) resistor r=5.29055 //w=0.35 //l=0.17 //layer=li \
 //thickness=0.1 //x=20.27 //y=0.175 //x2=20.1 //y2=0.175
r1844 (  385 387 ) resistor r=19.8801 //w=0.367 //l=0.57 //layer=li \
 //thickness=0.1 //x=20.27 //y=0.175 //x2=20.84 //y2=0.175
r1845 (  384 637 ) resistor r=5.29055 //w=0.35 //l=0.17 //layer=li \
 //thickness=0.1 //x=24.74 //y=0.175 //x2=24.91 //y2=0.175
r1846 (  384 393 ) resistor r=19.8801 //w=0.367 //l=0.57 //layer=li \
 //thickness=0.1 //x=24.74 //y=0.175 //x2=24.17 //y2=0.175
r1847 (  374 376 ) resistor r=38.7139 //w=0.367 //l=1.11 //layer=li \
 //thickness=0.1 //x=18.25 //y=0.175 //x2=19.36 //y2=0.175
r1848 (  372 374 ) resistor r=38.7139 //w=0.367 //l=1.11 //layer=li \
 //thickness=0.1 //x=17.14 //y=0.175 //x2=18.25 //y2=0.175
r1849 (  370 635 ) resistor r=5.29055 //w=0.35 //l=0.17 //layer=li \
 //thickness=0.1 //x=16.94 //y=0.175 //x2=16.77 //y2=0.175
r1850 (  370 372 ) resistor r=6.97548 //w=0.367 //l=0.2 //layer=li \
 //thickness=0.1 //x=16.94 //y=0.175 //x2=17.14 //y2=0.175
r1851 (  369 636 ) resistor r=5.29055 //w=0.35 //l=0.17 //layer=li \
 //thickness=0.1 //x=19.93 //y=0.175 //x2=20.1 //y2=0.175
r1852 (  369 376 ) resistor r=19.8801 //w=0.367 //l=0.57 //layer=li \
 //thickness=0.1 //x=19.93 //y=0.175 //x2=19.36 //y2=0.175
r1853 (  359 361 ) resistor r=38.7139 //w=0.367 //l=1.11 //layer=li \
 //thickness=0.1 //x=14.55 //y=0.175 //x2=15.66 //y2=0.175
r1854 (  357 634 ) resistor r=5.29055 //w=0.35 //l=0.17 //layer=li \
 //thickness=0.1 //x=13.61 //y=0.175 //x2=13.44 //y2=0.175
r1855 (  357 359 ) resistor r=32.7847 //w=0.367 //l=0.94 //layer=li \
 //thickness=0.1 //x=13.61 //y=0.175 //x2=14.55 //y2=0.175
r1856 (  356 635 ) resistor r=5.29055 //w=0.35 //l=0.17 //layer=li \
 //thickness=0.1 //x=16.6 //y=0.175 //x2=16.77 //y2=0.175
r1857 (  356 361 ) resistor r=32.7847 //w=0.367 //l=0.94 //layer=li \
 //thickness=0.1 //x=16.6 //y=0.175 //x2=15.66 //y2=0.175
r1858 (  346 348 ) resistor r=38.7139 //w=0.367 //l=1.11 //layer=li \
 //thickness=0.1 //x=11.96 //y=0.175 //x2=13.07 //y2=0.175
r1859 (  344 346 ) resistor r=38.7139 //w=0.367 //l=1.11 //layer=li \
 //thickness=0.1 //x=10.85 //y=0.175 //x2=11.96 //y2=0.175
r1860 (  342 344 ) resistor r=38.7139 //w=0.367 //l=1.11 //layer=li \
 //thickness=0.1 //x=9.74 //y=0.175 //x2=10.85 //y2=0.175
r1861 (  340 633 ) resistor r=5.29055 //w=0.35 //l=0.17 //layer=li \
 //thickness=0.1 //x=8.8 //y=0.175 //x2=8.63 //y2=0.175
r1862 (  340 342 ) resistor r=32.7847 //w=0.367 //l=0.94 //layer=li \
 //thickness=0.1 //x=8.8 //y=0.175 //x2=9.74 //y2=0.175
r1863 (  339 634 ) resistor r=5.29055 //w=0.35 //l=0.17 //layer=li \
 //thickness=0.1 //x=13.27 //y=0.175 //x2=13.44 //y2=0.175
r1864 (  339 348 ) resistor r=6.97548 //w=0.367 //l=0.2 //layer=li \
 //thickness=0.1 //x=13.27 //y=0.175 //x2=13.07 //y2=0.175
r1865 (  329 331 ) resistor r=38.7139 //w=0.367 //l=1.11 //layer=li \
 //thickness=0.1 //x=7.15 //y=0.175 //x2=8.26 //y2=0.175
r1866 (  327 329 ) resistor r=38.7139 //w=0.367 //l=1.11 //layer=li \
 //thickness=0.1 //x=6.04 //y=0.175 //x2=7.15 //y2=0.175
r1867 (  325 327 ) resistor r=38.7139 //w=0.367 //l=1.11 //layer=li \
 //thickness=0.1 //x=4.93 //y=0.175 //x2=6.04 //y2=0.175
r1868 (  323 632 ) resistor r=5.29055 //w=0.35 //l=0.17 //layer=li \
 //thickness=0.1 //x=3.99 //y=0.175 //x2=3.82 //y2=0.175
r1869 (  323 325 ) resistor r=32.7847 //w=0.367 //l=0.94 //layer=li \
 //thickness=0.1 //x=3.99 //y=0.175 //x2=4.93 //y2=0.175
r1870 (  322 633 ) resistor r=5.29055 //w=0.35 //l=0.17 //layer=li \
 //thickness=0.1 //x=8.46 //y=0.175 //x2=8.63 //y2=0.175
r1871 (  322 331 ) resistor r=6.97548 //w=0.367 //l=0.2 //layer=li \
 //thickness=0.1 //x=8.46 //y=0.175 //x2=8.26 //y2=0.175
r1872 (  312 314 ) resistor r=38.7139 //w=0.367 //l=1.11 //layer=li \
 //thickness=0.1 //x=2.34 //y=0.175 //x2=3.45 //y2=0.175
r1873 (  310 312 ) resistor r=38.7139 //w=0.367 //l=1.11 //layer=li \
 //thickness=0.1 //x=1.23 //y=0.175 //x2=2.34 //y2=0.175
r1874 (  307 632 ) resistor r=5.29055 //w=0.35 //l=0.17 //layer=li \
 //thickness=0.1 //x=3.65 //y=0.175 //x2=3.82 //y2=0.175
r1875 (  307 314 ) resistor r=6.97548 //w=0.367 //l=0.2 //layer=li \
 //thickness=0.1 //x=3.65 //y=0.175 //x2=3.45 //y2=0.175
r1876 (  304 672 ) resistor r=9.3 //w=0.17 //l=0.17 //layer=mcon //count=1 \
 //x=81.59 //y=1.135 //x2=81.59 //y2=1.135
r1877 (  301 671 ) resistor r=9.3 //w=0.17 //l=0.17 //layer=mcon //count=1 \
 //x=78.26 //y=1.135 //x2=78.26 //y2=1.135
r1878 (  299 607 ) resistor r=3.1 //w=0.17 //l=0.51 //layer=mcon //count=3 \
 //x=78.19 //y=0.18 //x2=78.19 //y2=0.18
r1879 (  297 670 ) resistor r=9.3 //w=0.17 //l=0.17 //layer=mcon //count=1 \
 //x=74.93 //y=1.135 //x2=74.93 //y2=1.135
r1880 (  292 669 ) resistor r=9.3 //w=0.17 //l=0.17 //layer=mcon //count=1 \
 //x=70.015 //y=1.145 //x2=70.015 //y2=1.145
r1881 (  287 668 ) resistor r=9.3 //w=0.17 //l=0.17 //layer=mcon //count=1 \
 //x=66.79 //y=1.135 //x2=66.79 //y2=1.135
r1882 (  287 288 ) resistor r=0.0939994 //w=0.226 //l=0.13 //layer=m1 \
 //thickness=0.36 //x=66.787 //y=1.135 //x2=66.787 //y2=1.005
r1883 (  285 547 ) resistor r=3.1 //w=0.17 //l=0.51 //layer=mcon //count=3 \
 //x=63.39 //y=0.18 //x2=63.39 //y2=0.18
r1884 (  281 667 ) resistor r=9.3 //w=0.17 //l=0.17 //layer=mcon //count=1 \
 //x=63.46 //y=1.135 //x2=63.46 //y2=1.135
r1885 (  281 282 ) resistor r=0.0939994 //w=0.226 //l=0.13 //layer=m1 \
 //thickness=0.36 //x=63.457 //y=1.135 //x2=63.457 //y2=1.005
r1886 (  279 530 ) resistor r=3.1 //w=0.17 //l=0.51 //layer=mcon //count=3 \
 //x=58.58 //y=0.18 //x2=58.58 //y2=0.18
r1887 (  276 666 ) resistor r=9.3 //w=0.17 //l=0.17 //layer=mcon //count=1 \
 //x=58.545 //y=1.145 //x2=58.545 //y2=1.145
r1888 (  274 513 ) resistor r=3.1 //w=0.17 //l=0.51 //layer=mcon //count=3 \
 //x=53.77 //y=0.18 //x2=53.77 //y2=0.18
r1889 (  271 665 ) resistor r=9.3 //w=0.17 //l=0.17 //layer=mcon //count=1 \
 //x=53.735 //y=1.145 //x2=53.735 //y2=1.145
r1890 (  266 664 ) resistor r=9.3 //w=0.17 //l=0.17 //layer=mcon //count=1 \
 //x=50.51 //y=1.135 //x2=50.51 //y2=1.135
r1891 (  266 267 ) resistor r=0.0939994 //w=0.226 //l=0.13 //layer=m1 \
 //thickness=0.36 //x=50.507 //y=1.135 //x2=50.507 //y2=1.005
r1892 (  262 663 ) resistor r=9.3 //w=0.17 //l=0.17 //layer=mcon //count=1 \
 //x=45.595 //y=1.145 //x2=45.595 //y2=1.145
r1893 (  257 662 ) resistor r=9.3 //w=0.17 //l=0.17 //layer=mcon //count=1 \
 //x=42.37 //y=1.135 //x2=42.37 //y2=1.135
r1894 (  257 258 ) resistor r=0.0939994 //w=0.226 //l=0.13 //layer=m1 \
 //thickness=0.36 //x=42.367 //y=1.135 //x2=42.367 //y2=1.005
r1895 (  255 453 ) resistor r=3.1 //w=0.17 //l=0.51 //layer=mcon //count=3 \
 //x=38.97 //y=0.18 //x2=38.97 //y2=0.18
r1896 (  251 661 ) resistor r=9.3 //w=0.17 //l=0.17 //layer=mcon //count=1 \
 //x=39.04 //y=1.135 //x2=39.04 //y2=1.135
r1897 (  251 252 ) resistor r=0.0939994 //w=0.226 //l=0.13 //layer=m1 \
 //thickness=0.36 //x=39.037 //y=1.135 //x2=39.037 //y2=1.005
r1898 (  249 436 ) resistor r=3.1 //w=0.17 //l=0.51 //layer=mcon //count=3 \
 //x=34.16 //y=0.18 //x2=34.16 //y2=0.18
r1899 (  246 660 ) resistor r=9.3 //w=0.17 //l=0.17 //layer=mcon //count=1 \
 //x=34.125 //y=1.145 //x2=34.125 //y2=1.145
r1900 (  244 419 ) resistor r=3.1 //w=0.17 //l=0.51 //layer=mcon //count=3 \
 //x=29.35 //y=0.18 //x2=29.35 //y2=0.18
r1901 (  241 659 ) resistor r=9.3 //w=0.17 //l=0.17 //layer=mcon //count=1 \
 //x=29.315 //y=1.145 //x2=29.315 //y2=1.145
r1902 (  236 658 ) resistor r=9.3 //w=0.17 //l=0.17 //layer=mcon //count=1 \
 //x=26.09 //y=1.135 //x2=26.09 //y2=1.135
r1903 (  236 237 ) resistor r=0.0939994 //w=0.226 //l=0.13 //layer=m1 \
 //thickness=0.36 //x=26.087 //y=1.135 //x2=26.087 //y2=1.005
r1904 (  232 657 ) resistor r=9.3 //w=0.17 //l=0.17 //layer=mcon //count=1 \
 //x=21.175 //y=1.145 //x2=21.175 //y2=1.145
r1905 (  227 656 ) resistor r=9.3 //w=0.17 //l=0.17 //layer=mcon //count=1 \
 //x=17.95 //y=1.135 //x2=17.95 //y2=1.135
r1906 (  227 228 ) resistor r=0.0939994 //w=0.226 //l=0.13 //layer=m1 \
 //thickness=0.36 //x=17.947 //y=1.135 //x2=17.947 //y2=1.005
r1907 (  225 359 ) resistor r=3.1 //w=0.17 //l=0.51 //layer=mcon //count=3 \
 //x=14.55 //y=0.18 //x2=14.55 //y2=0.18
r1908 (  221 655 ) resistor r=9.3 //w=0.17 //l=0.17 //layer=mcon //count=1 \
 //x=14.62 //y=1.135 //x2=14.62 //y2=1.135
r1909 (  221 222 ) resistor r=0.0939994 //w=0.226 //l=0.13 //layer=m1 \
 //thickness=0.36 //x=14.617 //y=1.135 //x2=14.617 //y2=1.005
r1910 (  219 342 ) resistor r=3.1 //w=0.17 //l=0.51 //layer=mcon //count=3 \
 //x=9.74 //y=0.18 //x2=9.74 //y2=0.18
r1911 (  216 654 ) resistor r=9.3 //w=0.17 //l=0.17 //layer=mcon //count=1 \
 //x=9.705 //y=1.145 //x2=9.705 //y2=1.145
r1912 (  214 325 ) resistor r=3.1 //w=0.17 //l=0.51 //layer=mcon //count=3 \
 //x=4.93 //y=0.18 //x2=4.93 //y2=0.18
r1913 (  211 653 ) resistor r=9.3 //w=0.17 //l=0.17 //layer=mcon //count=1 \
 //x=4.895 //y=1.145 //x2=4.895 //y2=1.145
r1914 (  206 652 ) resistor r=9.3 //w=0.17 //l=0.17 //layer=mcon //count=1 \
 //x=1.67 //y=1.135 //x2=1.67 //y2=1.135
r1915 (  206 207 ) resistor r=0.0939994 //w=0.226 //l=0.13 //layer=m1 \
 //thickness=0.36 //x=1.667 //y=1.135 //x2=1.667 //y2=1.005
r1916 (  203 624 ) resistor r=3.1 //w=0.17 //l=0.51 //layer=mcon //count=3 \
 //x=83 //y=0.18 //x2=83 //y2=0.18
r1917 (  201 622 ) resistor r=3.1 //w=0.17 //l=0.51 //layer=mcon //count=3 \
 //x=81.89 //y=0.18 //x2=81.89 //y2=0.18
r1918 (  201 203 ) resistor r=0.446141 //w=0.311 //l=1.11 //layer=m1 \
 //thickness=0.36 //x=81.89 //y=0.175 //x2=83 //y2=0.175
r1919 (  199 302 ) resistor r=0.028033 //w=0.35 //l=0.085 //layer=m1 \
 //thickness=0.36 //x=81.675 //y=0.175 //x2=81.59 //y2=0.175
r1920 (  199 201 ) resistor r=0.0864148 //w=0.311 //l=0.215 //layer=m1 \
 //thickness=0.36 //x=81.675 //y=0.175 //x2=81.89 //y2=0.175
r1921 (  198 304 ) resistor r=0.0703067 //w=0.254 //l=0.11649 //layer=m1 \
 //thickness=0.36 //x=81.59 //y=1.02 //x2=81.587 //y2=1.135
r1922 (  197 302 ) resistor r=0.0413265 //w=0.7 //l=0.175 //layer=m1 \
 //thickness=0.36 //x=81.59 //y=0.35 //x2=81.59 //y2=0.175
r1923 (  197 198 ) resistor r=0.639313 //w=0.131 //l=0.67 //layer=m1 \
 //thickness=0.36 //x=81.59 //y=0.35 //x2=81.59 //y2=1.02
r1924 (  196 620 ) resistor r=3.1 //w=0.17 //l=0.51 //layer=mcon //count=3 \
 //x=80.78 //y=0.18 //x2=80.78 //y2=0.18
r1925 (  194 609 ) resistor r=3.1 //w=0.17 //l=0.51 //layer=mcon //count=3 \
 //x=79.3 //y=0.18 //x2=79.3 //y2=0.18
r1926 (  194 196 ) resistor r=0.594855 //w=0.311 //l=1.48 //layer=m1 \
 //thickness=0.36 //x=79.3 //y=0.175 //x2=80.78 //y2=0.175
r1927 (  192 299 ) resistor r=0.028033 //w=0.35 //l=0.085 //layer=m1 \
 //thickness=0.36 //x=78.345 //y=0.175 //x2=78.26 //y2=0.175
r1928 (  192 194 ) resistor r=0.383842 //w=0.311 //l=0.955 //layer=m1 \
 //thickness=0.36 //x=78.345 //y=0.175 //x2=79.3 //y2=0.175
r1929 (  191 302 ) resistor r=0.028033 //w=0.35 //l=0.085 //layer=m1 \
 //thickness=0.36 //x=81.505 //y=0.175 //x2=81.59 //y2=0.175
r1930 (  191 196 ) resistor r=0.291399 //w=0.311 //l=0.725 //layer=m1 \
 //thickness=0.36 //x=81.505 //y=0.175 //x2=80.78 //y2=0.175
r1931 (  190 301 ) resistor r=0.0738201 //w=0.232 //l=0.121491 //layer=m1 \
 //thickness=0.36 //x=78.26 //y=1.015 //x2=78.257 //y2=1.135
r1932 (  189 299 ) resistor r=0.0413265 //w=0.7 //l=0.175 //layer=m1 \
 //thickness=0.36 //x=78.26 //y=0.35 //x2=78.26 //y2=0.175
r1933 (  189 190 ) resistor r=0.634542 //w=0.131 //l=0.665 //layer=m1 \
 //thickness=0.36 //x=78.26 //y=0.35 //x2=78.26 //y2=1.015
r1934 (  188 596 ) resistor r=3.1 //w=0.17 //l=0.51 //layer=mcon //count=3 \
 //x=76.71 //y=0.18 //x2=76.71 //y2=0.18
r1935 (  186 594 ) resistor r=3.1 //w=0.17 //l=0.51 //layer=mcon //count=3 \
 //x=75.6 //y=0.18 //x2=75.6 //y2=0.18
r1936 (  186 188 ) resistor r=0.446141 //w=0.311 //l=1.11 //layer=m1 \
 //thickness=0.36 //x=75.6 //y=0.175 //x2=76.71 //y2=0.175
r1937 (  184 295 ) resistor r=0.028033 //w=0.35 //l=0.085 //layer=m1 \
 //thickness=0.36 //x=75.015 //y=0.175 //x2=74.93 //y2=0.175
r1938 (  184 186 ) resistor r=0.235129 //w=0.311 //l=0.585 //layer=m1 \
 //thickness=0.36 //x=75.015 //y=0.175 //x2=75.6 //y2=0.175
r1939 (  183 299 ) resistor r=0.028033 //w=0.35 //l=0.085 //layer=m1 \
 //thickness=0.36 //x=78.175 //y=0.175 //x2=78.26 //y2=0.175
r1940 (  183 188 ) resistor r=0.588826 //w=0.311 //l=1.465 //layer=m1 \
 //thickness=0.36 //x=78.175 //y=0.175 //x2=76.71 //y2=0.175
r1941 (  182 297 ) resistor r=0.0729089 //w=0.249 //l=0.120996 //layer=m1 \
 //thickness=0.36 //x=74.93 //y=1.015 //x2=74.932 //y2=1.135
r1942 (  181 295 ) resistor r=0.0413265 //w=0.7 //l=0.175 //layer=m1 \
 //thickness=0.36 //x=74.93 //y=0.35 //x2=74.93 //y2=0.175
r1943 (  181 182 ) resistor r=0.634542 //w=0.131 //l=0.665 //layer=m1 \
 //thickness=0.36 //x=74.93 //y=0.35 //x2=74.93 //y2=1.015
r1944 (  180 592 ) resistor r=3.1 //w=0.17 //l=0.51 //layer=mcon //count=3 \
 //x=74.49 //y=0.18 //x2=74.49 //y2=0.18
r1945 (  178 581 ) resistor r=3.1 //w=0.17 //l=0.51 //layer=mcon //count=3 \
 //x=73.01 //y=0.18 //x2=73.01 //y2=0.18
r1946 (  178 180 ) resistor r=0.594855 //w=0.311 //l=1.48 //layer=m1 \
 //thickness=0.36 //x=73.01 //y=0.175 //x2=74.49 //y2=0.175
r1947 (  176 579 ) resistor r=3.1 //w=0.17 //l=0.51 //layer=mcon //count=3 \
 //x=71.9 //y=0.18 //x2=71.9 //y2=0.18
r1948 (  176 178 ) resistor r=0.446141 //w=0.311 //l=1.11 //layer=m1 \
 //thickness=0.36 //x=71.9 //y=0.175 //x2=73.01 //y2=0.175
r1949 (  174 577 ) resistor r=3.1 //w=0.17 //l=0.51 //layer=mcon //count=3 \
 //x=70.79 //y=0.18 //x2=70.79 //y2=0.18
r1950 (  174 176 ) resistor r=0.446141 //w=0.311 //l=1.11 //layer=m1 \
 //thickness=0.36 //x=70.79 //y=0.175 //x2=71.9 //y2=0.175
r1951 (  172 294 ) resistor r=0.028033 //w=0.35 //l=0.085 //layer=m1 \
 //thickness=0.36 //x=70.1 //y=0.175 //x2=70.015 //y2=0.175
r1952 (  172 174 ) resistor r=0.277331 //w=0.311 //l=0.69 //layer=m1 \
 //thickness=0.36 //x=70.1 //y=0.175 //x2=70.79 //y2=0.175
r1953 (  171 295 ) resistor r=0.028033 //w=0.35 //l=0.085 //layer=m1 \
 //thickness=0.36 //x=74.845 //y=0.175 //x2=74.93 //y2=0.175
r1954 (  171 180 ) resistor r=0.142685 //w=0.311 //l=0.355 //layer=m1 \
 //thickness=0.36 //x=74.845 //y=0.175 //x2=74.49 //y2=0.175
r1955 (  170 292 ) resistor r=0.0942778 //w=0.221 //l=0.13 //layer=m1 \
 //thickness=0.36 //x=70.015 //y=1.015 //x2=70.015 //y2=1.145
r1956 (  169 294 ) resistor r=0.0413265 //w=0.7 //l=0.175 //layer=m1 \
 //thickness=0.36 //x=70.015 //y=0.35 //x2=70.015 //y2=0.175
r1957 (  169 170 ) resistor r=0.634542 //w=0.131 //l=0.665 //layer=m1 \
 //thickness=0.36 //x=70.015 //y=0.35 //x2=70.015 //y2=1.015
r1958 (  168 575 ) resistor r=3.1 //w=0.17 //l=0.51 //layer=mcon //count=3 \
 //x=69.68 //y=0.18 //x2=69.68 //y2=0.18
r1959 (  166 564 ) resistor r=3.1 //w=0.17 //l=0.51 //layer=mcon //count=3 \
 //x=68.2 //y=0.18 //x2=68.2 //y2=0.18
r1960 (  166 168 ) resistor r=0.594855 //w=0.311 //l=1.48 //layer=m1 \
 //thickness=0.36 //x=68.2 //y=0.175 //x2=69.68 //y2=0.175
r1961 (  164 562 ) resistor r=3.1 //w=0.17 //l=0.51 //layer=mcon //count=3 \
 //x=67.09 //y=0.18 //x2=67.09 //y2=0.18
r1962 (  164 166 ) resistor r=0.446141 //w=0.311 //l=1.11 //layer=m1 \
 //thickness=0.36 //x=67.09 //y=0.175 //x2=68.2 //y2=0.175
r1963 (  162 290 ) resistor r=0.028033 //w=0.35 //l=0.085 //layer=m1 \
 //thickness=0.36 //x=66.875 //y=0.175 //x2=66.79 //y2=0.175
r1964 (  162 164 ) resistor r=0.0864148 //w=0.311 //l=0.215 //layer=m1 \
 //thickness=0.36 //x=66.875 //y=0.175 //x2=67.09 //y2=0.175
r1965 (  161 294 ) resistor r=0.028033 //w=0.35 //l=0.085 //layer=m1 \
 //thickness=0.36 //x=69.93 //y=0.175 //x2=70.015 //y2=0.175
r1966 (  161 168 ) resistor r=0.100482 //w=0.311 //l=0.25 //layer=m1 \
 //thickness=0.36 //x=69.93 //y=0.175 //x2=69.68 //y2=0.175
r1967 (  159 290 ) resistor r=0.0413265 //w=0.7 //l=0.175 //layer=m1 \
 //thickness=0.36 //x=66.79 //y=0.35 //x2=66.79 //y2=0.175
r1968 (  159 288 ) resistor r=0.625 //w=0.131 //l=0.655 //layer=m1 \
 //thickness=0.36 //x=66.79 //y=0.35 //x2=66.79 //y2=1.005
r1969 (  158 560 ) resistor r=3.1 //w=0.17 //l=0.51 //layer=mcon //count=3 \
 //x=65.98 //y=0.18 //x2=65.98 //y2=0.18
r1970 (  156 549 ) resistor r=3.1 //w=0.17 //l=0.51 //layer=mcon //count=3 \
 //x=64.5 //y=0.18 //x2=64.5 //y2=0.18
r1971 (  156 158 ) resistor r=0.594855 //w=0.311 //l=1.48 //layer=m1 \
 //thickness=0.36 //x=64.5 //y=0.175 //x2=65.98 //y2=0.175
r1972 (  154 285 ) resistor r=0.028033 //w=0.35 //l=0.085 //layer=m1 \
 //thickness=0.36 //x=63.545 //y=0.175 //x2=63.46 //y2=0.175
r1973 (  154 156 ) resistor r=0.383842 //w=0.311 //l=0.955 //layer=m1 \
 //thickness=0.36 //x=63.545 //y=0.175 //x2=64.5 //y2=0.175
r1974 (  153 290 ) resistor r=0.028033 //w=0.35 //l=0.085 //layer=m1 \
 //thickness=0.36 //x=66.705 //y=0.175 //x2=66.79 //y2=0.175
r1975 (  153 158 ) resistor r=0.291399 //w=0.311 //l=0.725 //layer=m1 \
 //thickness=0.36 //x=66.705 //y=0.175 //x2=65.98 //y2=0.175
r1976 (  151 285 ) resistor r=0.0413265 //w=0.7 //l=0.175 //layer=m1 \
 //thickness=0.36 //x=63.46 //y=0.35 //x2=63.46 //y2=0.175
r1977 (  151 282 ) resistor r=0.625 //w=0.131 //l=0.655 //layer=m1 \
 //thickness=0.36 //x=63.46 //y=0.35 //x2=63.46 //y2=1.005
r1978 (  150 536 ) resistor r=3.1 //w=0.17 //l=0.51 //layer=mcon //count=3 \
 //x=61.91 //y=0.18 //x2=61.91 //y2=0.18
r1979 (  148 534 ) resistor r=3.1 //w=0.17 //l=0.51 //layer=mcon //count=3 \
 //x=60.8 //y=0.18 //x2=60.8 //y2=0.18
r1980 (  148 150 ) resistor r=0.446141 //w=0.311 //l=1.11 //layer=m1 \
 //thickness=0.36 //x=60.8 //y=0.175 //x2=61.91 //y2=0.175
r1981 (  146 532 ) resistor r=3.1 //w=0.17 //l=0.51 //layer=mcon //count=3 \
 //x=59.69 //y=0.18 //x2=59.69 //y2=0.18
r1982 (  146 148 ) resistor r=0.446141 //w=0.311 //l=1.11 //layer=m1 \
 //thickness=0.36 //x=59.69 //y=0.175 //x2=60.8 //y2=0.175
r1983 (  144 279 ) resistor r=0.028033 //w=0.35 //l=0.085 //layer=m1 \
 //thickness=0.36 //x=58.63 //y=0.175 //x2=58.545 //y2=0.175
r1984 (  144 146 ) resistor r=0.426045 //w=0.311 //l=1.06 //layer=m1 \
 //thickness=0.36 //x=58.63 //y=0.175 //x2=59.69 //y2=0.175
r1985 (  143 285 ) resistor r=0.028033 //w=0.35 //l=0.085 //layer=m1 \
 //thickness=0.36 //x=63.375 //y=0.175 //x2=63.46 //y2=0.175
r1986 (  143 150 ) resistor r=0.588826 //w=0.311 //l=1.465 //layer=m1 \
 //thickness=0.36 //x=63.375 //y=0.175 //x2=61.91 //y2=0.175
r1987 (  142 276 ) resistor r=0.0942778 //w=0.221 //l=0.13 //layer=m1 \
 //thickness=0.36 //x=58.545 //y=1.015 //x2=58.545 //y2=1.145
r1988 (  141 279 ) resistor r=0.0413265 //w=0.7 //l=0.175 //layer=m1 \
 //thickness=0.36 //x=58.545 //y=0.35 //x2=58.545 //y2=0.175
r1989 (  141 142 ) resistor r=0.634542 //w=0.131 //l=0.665 //layer=m1 \
 //thickness=0.36 //x=58.545 //y=0.35 //x2=58.545 //y2=1.015
r1990 (  140 519 ) resistor r=3.1 //w=0.17 //l=0.51 //layer=mcon //count=3 \
 //x=57.1 //y=0.18 //x2=57.1 //y2=0.18
r1991 (  138 517 ) resistor r=3.1 //w=0.17 //l=0.51 //layer=mcon //count=3 \
 //x=55.99 //y=0.18 //x2=55.99 //y2=0.18
r1992 (  138 140 ) resistor r=0.446141 //w=0.311 //l=1.11 //layer=m1 \
 //thickness=0.36 //x=55.99 //y=0.175 //x2=57.1 //y2=0.175
r1993 (  136 515 ) resistor r=3.1 //w=0.17 //l=0.51 //layer=mcon //count=3 \
 //x=54.88 //y=0.18 //x2=54.88 //y2=0.18
r1994 (  136 138 ) resistor r=0.446141 //w=0.311 //l=1.11 //layer=m1 \
 //thickness=0.36 //x=54.88 //y=0.175 //x2=55.99 //y2=0.175
r1995 (  134 274 ) resistor r=0.028033 //w=0.35 //l=0.085 //layer=m1 \
 //thickness=0.36 //x=53.82 //y=0.175 //x2=53.735 //y2=0.175
r1996 (  134 136 ) resistor r=0.426045 //w=0.311 //l=1.06 //layer=m1 \
 //thickness=0.36 //x=53.82 //y=0.175 //x2=54.88 //y2=0.175
r1997 (  133 279 ) resistor r=0.028033 //w=0.35 //l=0.085 //layer=m1 \
 //thickness=0.36 //x=58.46 //y=0.175 //x2=58.545 //y2=0.175
r1998 (  133 140 ) resistor r=0.546624 //w=0.311 //l=1.36 //layer=m1 \
 //thickness=0.36 //x=58.46 //y=0.175 //x2=57.1 //y2=0.175
r1999 (  132 271 ) resistor r=0.0942778 //w=0.221 //l=0.13 //layer=m1 \
 //thickness=0.36 //x=53.735 //y=1.015 //x2=53.735 //y2=1.145
r2000 (  131 274 ) resistor r=0.0413265 //w=0.7 //l=0.175 //layer=m1 \
 //thickness=0.36 //x=53.735 //y=0.35 //x2=53.735 //y2=0.175
r2001 (  131 132 ) resistor r=0.634542 //w=0.131 //l=0.665 //layer=m1 \
 //thickness=0.36 //x=53.735 //y=0.35 //x2=53.735 //y2=1.015
r2002 (  130 502 ) resistor r=3.1 //w=0.17 //l=0.51 //layer=mcon //count=3 \
 //x=52.29 //y=0.18 //x2=52.29 //y2=0.18
r2003 (  128 500 ) resistor r=3.1 //w=0.17 //l=0.51 //layer=mcon //count=3 \
 //x=51.18 //y=0.18 //x2=51.18 //y2=0.18
r2004 (  128 130 ) resistor r=0.446141 //w=0.311 //l=1.11 //layer=m1 \
 //thickness=0.36 //x=51.18 //y=0.175 //x2=52.29 //y2=0.175
r2005 (  126 269 ) resistor r=0.028033 //w=0.35 //l=0.085 //layer=m1 \
 //thickness=0.36 //x=50.595 //y=0.175 //x2=50.51 //y2=0.175
r2006 (  126 128 ) resistor r=0.235129 //w=0.311 //l=0.585 //layer=m1 \
 //thickness=0.36 //x=50.595 //y=0.175 //x2=51.18 //y2=0.175
r2007 (  125 274 ) resistor r=0.028033 //w=0.35 //l=0.085 //layer=m1 \
 //thickness=0.36 //x=53.65 //y=0.175 //x2=53.735 //y2=0.175
r2008 (  125 130 ) resistor r=0.546624 //w=0.311 //l=1.36 //layer=m1 \
 //thickness=0.36 //x=53.65 //y=0.175 //x2=52.29 //y2=0.175
r2009 (  123 269 ) resistor r=0.0413265 //w=0.7 //l=0.175 //layer=m1 \
 //thickness=0.36 //x=50.51 //y=0.35 //x2=50.51 //y2=0.175
r2010 (  123 267 ) resistor r=0.625 //w=0.131 //l=0.655 //layer=m1 \
 //thickness=0.36 //x=50.51 //y=0.35 //x2=50.51 //y2=1.005
r2011 (  122 498 ) resistor r=3.1 //w=0.17 //l=0.51 //layer=mcon //count=3 \
 //x=50.07 //y=0.18 //x2=50.07 //y2=0.18
r2012 (  120 487 ) resistor r=3.1 //w=0.17 //l=0.51 //layer=mcon //count=3 \
 //x=48.59 //y=0.18 //x2=48.59 //y2=0.18
r2013 (  120 122 ) resistor r=0.594855 //w=0.311 //l=1.48 //layer=m1 \
 //thickness=0.36 //x=48.59 //y=0.175 //x2=50.07 //y2=0.175
r2014 (  118 485 ) resistor r=3.1 //w=0.17 //l=0.51 //layer=mcon //count=3 \
 //x=47.48 //y=0.18 //x2=47.48 //y2=0.18
r2015 (  118 120 ) resistor r=0.446141 //w=0.311 //l=1.11 //layer=m1 \
 //thickness=0.36 //x=47.48 //y=0.175 //x2=48.59 //y2=0.175
r2016 (  116 483 ) resistor r=3.1 //w=0.17 //l=0.51 //layer=mcon //count=3 \
 //x=46.37 //y=0.18 //x2=46.37 //y2=0.18
r2017 (  116 118 ) resistor r=0.446141 //w=0.311 //l=1.11 //layer=m1 \
 //thickness=0.36 //x=46.37 //y=0.175 //x2=47.48 //y2=0.175
r2018 (  114 264 ) resistor r=0.028033 //w=0.35 //l=0.085 //layer=m1 \
 //thickness=0.36 //x=45.68 //y=0.175 //x2=45.595 //y2=0.175
r2019 (  114 116 ) resistor r=0.277331 //w=0.311 //l=0.69 //layer=m1 \
 //thickness=0.36 //x=45.68 //y=0.175 //x2=46.37 //y2=0.175
r2020 (  113 269 ) resistor r=0.028033 //w=0.35 //l=0.085 //layer=m1 \
 //thickness=0.36 //x=50.425 //y=0.175 //x2=50.51 //y2=0.175
r2021 (  113 122 ) resistor r=0.142685 //w=0.311 //l=0.355 //layer=m1 \
 //thickness=0.36 //x=50.425 //y=0.175 //x2=50.07 //y2=0.175
r2022 (  112 262 ) resistor r=0.0942778 //w=0.221 //l=0.13 //layer=m1 \
 //thickness=0.36 //x=45.595 //y=1.015 //x2=45.595 //y2=1.145
r2023 (  111 264 ) resistor r=0.0413265 //w=0.7 //l=0.175 //layer=m1 \
 //thickness=0.36 //x=45.595 //y=0.35 //x2=45.595 //y2=0.175
r2024 (  111 112 ) resistor r=0.634542 //w=0.131 //l=0.665 //layer=m1 \
 //thickness=0.36 //x=45.595 //y=0.35 //x2=45.595 //y2=1.015
r2025 (  110 481 ) resistor r=3.1 //w=0.17 //l=0.51 //layer=mcon //count=3 \
 //x=45.26 //y=0.18 //x2=45.26 //y2=0.18
r2026 (  108 470 ) resistor r=3.1 //w=0.17 //l=0.51 //layer=mcon //count=3 \
 //x=43.78 //y=0.18 //x2=43.78 //y2=0.18
r2027 (  108 110 ) resistor r=0.594855 //w=0.311 //l=1.48 //layer=m1 \
 //thickness=0.36 //x=43.78 //y=0.175 //x2=45.26 //y2=0.175
r2028 (  106 468 ) resistor r=3.1 //w=0.17 //l=0.51 //layer=mcon //count=3 \
 //x=42.67 //y=0.18 //x2=42.67 //y2=0.18
r2029 (  106 108 ) resistor r=0.446141 //w=0.311 //l=1.11 //layer=m1 \
 //thickness=0.36 //x=42.67 //y=0.175 //x2=43.78 //y2=0.175
r2030 (  104 260 ) resistor r=0.028033 //w=0.35 //l=0.085 //layer=m1 \
 //thickness=0.36 //x=42.455 //y=0.175 //x2=42.37 //y2=0.175
r2031 (  104 106 ) resistor r=0.0864148 //w=0.311 //l=0.215 //layer=m1 \
 //thickness=0.36 //x=42.455 //y=0.175 //x2=42.67 //y2=0.175
r2032 (  103 264 ) resistor r=0.028033 //w=0.35 //l=0.085 //layer=m1 \
 //thickness=0.36 //x=45.51 //y=0.175 //x2=45.595 //y2=0.175
r2033 (  103 110 ) resistor r=0.100482 //w=0.311 //l=0.25 //layer=m1 \
 //thickness=0.36 //x=45.51 //y=0.175 //x2=45.26 //y2=0.175
r2034 (  101 260 ) resistor r=0.0413265 //w=0.7 //l=0.175 //layer=m1 \
 //thickness=0.36 //x=42.37 //y=0.35 //x2=42.37 //y2=0.175
r2035 (  101 258 ) resistor r=0.625 //w=0.131 //l=0.655 //layer=m1 \
 //thickness=0.36 //x=42.37 //y=0.35 //x2=42.37 //y2=1.005
r2036 (  99 466 ) resistor r=3.1 //w=0.17 //l=0.51 //layer=mcon //count=3 \
 //x=41.56 //y=0.18 //x2=41.56 //y2=0.18
r2037 (  97 455 ) resistor r=3.1 //w=0.17 //l=0.51 //layer=mcon //count=3 \
 //x=40.08 //y=0.18 //x2=40.08 //y2=0.18
r2038 (  97 99 ) resistor r=0.594855 //w=0.311 //l=1.48 //layer=m1 \
 //thickness=0.36 //x=40.08 //y=0.175 //x2=41.56 //y2=0.175
r2039 (  95 255 ) resistor r=0.028033 //w=0.35 //l=0.085 //layer=m1 \
 //thickness=0.36 //x=39.125 //y=0.175 //x2=39.04 //y2=0.175
r2040 (  95 97 ) resistor r=0.383842 //w=0.311 //l=0.955 //layer=m1 \
 //thickness=0.36 //x=39.125 //y=0.175 //x2=40.08 //y2=0.175
r2041 (  94 260 ) resistor r=0.028033 //w=0.35 //l=0.085 //layer=m1 \
 //thickness=0.36 //x=42.285 //y=0.175 //x2=42.37 //y2=0.175
r2042 (  92 255 ) resistor r=0.0413265 //w=0.7 //l=0.175 //layer=m1 \
 //thickness=0.36 //x=39.04 //y=0.35 //x2=39.04 //y2=0.175
r2043 (  92 252 ) resistor r=0.625 //w=0.131 //l=0.655 //layer=m1 \
 //thickness=0.36 //x=39.04 //y=0.35 //x2=39.04 //y2=1.005
r2044 (  91 442 ) resistor r=3.1 //w=0.17 //l=0.51 //layer=mcon //count=3 \
 //x=37.49 //y=0.18 //x2=37.49 //y2=0.18
r2045 (  89 440 ) resistor r=3.1 //w=0.17 //l=0.51 //layer=mcon //count=3 \
 //x=36.38 //y=0.18 //x2=36.38 //y2=0.18
r2046 (  89 91 ) resistor r=0.446141 //w=0.311 //l=1.11 //layer=m1 \
 //thickness=0.36 //x=36.38 //y=0.175 //x2=37.49 //y2=0.175
r2047 (  87 438 ) resistor r=3.1 //w=0.17 //l=0.51 //layer=mcon //count=3 \
 //x=35.27 //y=0.18 //x2=35.27 //y2=0.18
r2048 (  87 89 ) resistor r=0.446141 //w=0.311 //l=1.11 //layer=m1 \
 //thickness=0.36 //x=35.27 //y=0.175 //x2=36.38 //y2=0.175
r2049 (  85 249 ) resistor r=0.028033 //w=0.35 //l=0.085 //layer=m1 \
 //thickness=0.36 //x=34.21 //y=0.175 //x2=34.125 //y2=0.175
r2050 (  85 87 ) resistor r=0.426045 //w=0.311 //l=1.06 //layer=m1 \
 //thickness=0.36 //x=34.21 //y=0.175 //x2=35.27 //y2=0.175
r2051 (  84 255 ) resistor r=0.028033 //w=0.35 //l=0.085 //layer=m1 \
 //thickness=0.36 //x=38.955 //y=0.175 //x2=39.04 //y2=0.175
r2052 (  84 91 ) resistor r=0.588826 //w=0.311 //l=1.465 //layer=m1 \
 //thickness=0.36 //x=38.955 //y=0.175 //x2=37.49 //y2=0.175
r2053 (  83 246 ) resistor r=0.0942778 //w=0.221 //l=0.13 //layer=m1 \
 //thickness=0.36 //x=34.125 //y=1.015 //x2=34.125 //y2=1.145
r2054 (  82 249 ) resistor r=0.0413265 //w=0.7 //l=0.175 //layer=m1 \
 //thickness=0.36 //x=34.125 //y=0.35 //x2=34.125 //y2=0.175
r2055 (  82 83 ) resistor r=0.634542 //w=0.131 //l=0.665 //layer=m1 \
 //thickness=0.36 //x=34.125 //y=0.35 //x2=34.125 //y2=1.015
r2056 (  81 425 ) resistor r=3.1 //w=0.17 //l=0.51 //layer=mcon //count=3 \
 //x=32.68 //y=0.18 //x2=32.68 //y2=0.18
r2057 (  79 423 ) resistor r=3.1 //w=0.17 //l=0.51 //layer=mcon //count=3 \
 //x=31.57 //y=0.18 //x2=31.57 //y2=0.18
r2058 (  79 81 ) resistor r=0.446141 //w=0.311 //l=1.11 //layer=m1 \
 //thickness=0.36 //x=31.57 //y=0.175 //x2=32.68 //y2=0.175
r2059 (  77 421 ) resistor r=3.1 //w=0.17 //l=0.51 //layer=mcon //count=3 \
 //x=30.46 //y=0.18 //x2=30.46 //y2=0.18
r2060 (  77 79 ) resistor r=0.446141 //w=0.311 //l=1.11 //layer=m1 \
 //thickness=0.36 //x=30.46 //y=0.175 //x2=31.57 //y2=0.175
r2061 (  75 244 ) resistor r=0.028033 //w=0.35 //l=0.085 //layer=m1 \
 //thickness=0.36 //x=29.4 //y=0.175 //x2=29.315 //y2=0.175
r2062 (  75 77 ) resistor r=0.426045 //w=0.311 //l=1.06 //layer=m1 \
 //thickness=0.36 //x=29.4 //y=0.175 //x2=30.46 //y2=0.175
r2063 (  74 249 ) resistor r=0.028033 //w=0.35 //l=0.085 //layer=m1 \
 //thickness=0.36 //x=34.04 //y=0.175 //x2=34.125 //y2=0.175
r2064 (  74 81 ) resistor r=0.546624 //w=0.311 //l=1.36 //layer=m1 \
 //thickness=0.36 //x=34.04 //y=0.175 //x2=32.68 //y2=0.175
r2065 (  73 241 ) resistor r=0.0942778 //w=0.221 //l=0.13 //layer=m1 \
 //thickness=0.36 //x=29.315 //y=1.015 //x2=29.315 //y2=1.145
r2066 (  72 244 ) resistor r=0.0413265 //w=0.7 //l=0.175 //layer=m1 \
 //thickness=0.36 //x=29.315 //y=0.35 //x2=29.315 //y2=0.175
r2067 (  72 73 ) resistor r=0.634542 //w=0.131 //l=0.665 //layer=m1 \
 //thickness=0.36 //x=29.315 //y=0.35 //x2=29.315 //y2=1.015
r2068 (  71 408 ) resistor r=3.1 //w=0.17 //l=0.51 //layer=mcon //count=3 \
 //x=27.87 //y=0.18 //x2=27.87 //y2=0.18
r2069 (  69 406 ) resistor r=3.1 //w=0.17 //l=0.51 //layer=mcon //count=3 \
 //x=26.76 //y=0.18 //x2=26.76 //y2=0.18
r2070 (  69 71 ) resistor r=0.446141 //w=0.311 //l=1.11 //layer=m1 \
 //thickness=0.36 //x=26.76 //y=0.175 //x2=27.87 //y2=0.175
r2071 (  67 239 ) resistor r=0.028033 //w=0.35 //l=0.085 //layer=m1 \
 //thickness=0.36 //x=26.175 //y=0.175 //x2=26.09 //y2=0.175
r2072 (  67 69 ) resistor r=0.235129 //w=0.311 //l=0.585 //layer=m1 \
 //thickness=0.36 //x=26.175 //y=0.175 //x2=26.76 //y2=0.175
r2073 (  66 244 ) resistor r=0.028033 //w=0.35 //l=0.085 //layer=m1 \
 //thickness=0.36 //x=29.23 //y=0.175 //x2=29.315 //y2=0.175
r2074 (  66 71 ) resistor r=0.546624 //w=0.311 //l=1.36 //layer=m1 \
 //thickness=0.36 //x=29.23 //y=0.175 //x2=27.87 //y2=0.175
r2075 (  64 239 ) resistor r=0.0413265 //w=0.7 //l=0.175 //layer=m1 \
 //thickness=0.36 //x=26.09 //y=0.35 //x2=26.09 //y2=0.175
r2076 (  64 237 ) resistor r=0.625 //w=0.131 //l=0.655 //layer=m1 \
 //thickness=0.36 //x=26.09 //y=0.35 //x2=26.09 //y2=1.005
r2077 (  63 404 ) resistor r=3.1 //w=0.17 //l=0.51 //layer=mcon //count=3 \
 //x=25.65 //y=0.18 //x2=25.65 //y2=0.18
r2078 (  61 393 ) resistor r=3.1 //w=0.17 //l=0.51 //layer=mcon //count=3 \
 //x=24.17 //y=0.18 //x2=24.17 //y2=0.18
r2079 (  61 63 ) resistor r=0.594855 //w=0.311 //l=1.48 //layer=m1 \
 //thickness=0.36 //x=24.17 //y=0.175 //x2=25.65 //y2=0.175
r2080 (  59 391 ) resistor r=3.1 //w=0.17 //l=0.51 //layer=mcon //count=3 \
 //x=23.06 //y=0.18 //x2=23.06 //y2=0.18
r2081 (  59 61 ) resistor r=0.446141 //w=0.311 //l=1.11 //layer=m1 \
 //thickness=0.36 //x=23.06 //y=0.175 //x2=24.17 //y2=0.175
r2082 (  57 389 ) resistor r=3.1 //w=0.17 //l=0.51 //layer=mcon //count=3 \
 //x=21.95 //y=0.18 //x2=21.95 //y2=0.18
r2083 (  57 59 ) resistor r=0.446141 //w=0.311 //l=1.11 //layer=m1 \
 //thickness=0.36 //x=21.95 //y=0.175 //x2=23.06 //y2=0.175
r2084 (  55 234 ) resistor r=0.028033 //w=0.35 //l=0.085 //layer=m1 \
 //thickness=0.36 //x=21.26 //y=0.175 //x2=21.175 //y2=0.175
r2085 (  55 57 ) resistor r=0.277331 //w=0.311 //l=0.69 //layer=m1 \
 //thickness=0.36 //x=21.26 //y=0.175 //x2=21.95 //y2=0.175
r2086 (  54 239 ) resistor r=0.028033 //w=0.35 //l=0.085 //layer=m1 \
 //thickness=0.36 //x=26.005 //y=0.175 //x2=26.09 //y2=0.175
r2087 (  54 63 ) resistor r=0.142685 //w=0.311 //l=0.355 //layer=m1 \
 //thickness=0.36 //x=26.005 //y=0.175 //x2=25.65 //y2=0.175
r2088 (  53 232 ) resistor r=0.0942778 //w=0.221 //l=0.13 //layer=m1 \
 //thickness=0.36 //x=21.175 //y=1.015 //x2=21.175 //y2=1.145
r2089 (  52 234 ) resistor r=0.0413265 //w=0.7 //l=0.175 //layer=m1 \
 //thickness=0.36 //x=21.175 //y=0.35 //x2=21.175 //y2=0.175
r2090 (  52 53 ) resistor r=0.634542 //w=0.131 //l=0.665 //layer=m1 \
 //thickness=0.36 //x=21.175 //y=0.35 //x2=21.175 //y2=1.015
r2091 (  51 387 ) resistor r=3.1 //w=0.17 //l=0.51 //layer=mcon //count=3 \
 //x=20.84 //y=0.18 //x2=20.84 //y2=0.18
r2092 (  49 376 ) resistor r=3.1 //w=0.17 //l=0.51 //layer=mcon //count=3 \
 //x=19.36 //y=0.18 //x2=19.36 //y2=0.18
r2093 (  49 51 ) resistor r=0.594855 //w=0.311 //l=1.48 //layer=m1 \
 //thickness=0.36 //x=19.36 //y=0.175 //x2=20.84 //y2=0.175
r2094 (  47 374 ) resistor r=3.1 //w=0.17 //l=0.51 //layer=mcon //count=3 \
 //x=18.25 //y=0.18 //x2=18.25 //y2=0.18
r2095 (  47 49 ) resistor r=0.446141 //w=0.311 //l=1.11 //layer=m1 \
 //thickness=0.36 //x=18.25 //y=0.175 //x2=19.36 //y2=0.175
r2096 (  45 230 ) resistor r=0.028033 //w=0.35 //l=0.085 //layer=m1 \
 //thickness=0.36 //x=18.035 //y=0.175 //x2=17.95 //y2=0.175
r2097 (  45 47 ) resistor r=0.0864148 //w=0.311 //l=0.215 //layer=m1 \
 //thickness=0.36 //x=18.035 //y=0.175 //x2=18.25 //y2=0.175
r2098 (  44 234 ) resistor r=0.028033 //w=0.35 //l=0.085 //layer=m1 \
 //thickness=0.36 //x=21.09 //y=0.175 //x2=21.175 //y2=0.175
r2099 (  44 51 ) resistor r=0.100482 //w=0.311 //l=0.25 //layer=m1 \
 //thickness=0.36 //x=21.09 //y=0.175 //x2=20.84 //y2=0.175
r2100 (  42 230 ) resistor r=0.0413265 //w=0.7 //l=0.175 //layer=m1 \
 //thickness=0.36 //x=17.95 //y=0.35 //x2=17.95 //y2=0.175
r2101 (  42 228 ) resistor r=0.625 //w=0.131 //l=0.655 //layer=m1 \
 //thickness=0.36 //x=17.95 //y=0.35 //x2=17.95 //y2=1.005
r2102 (  41 372 ) resistor r=3.1 //w=0.17 //l=0.51 //layer=mcon //count=3 \
 //x=17.14 //y=0.18 //x2=17.14 //y2=0.18
r2103 (  39 361 ) resistor r=3.1 //w=0.17 //l=0.51 //layer=mcon //count=3 \
 //x=15.66 //y=0.18 //x2=15.66 //y2=0.18
r2104 (  39 41 ) resistor r=0.594855 //w=0.311 //l=1.48 //layer=m1 \
 //thickness=0.36 //x=15.66 //y=0.175 //x2=17.14 //y2=0.175
r2105 (  37 225 ) resistor r=0.028033 //w=0.35 //l=0.085 //layer=m1 \
 //thickness=0.36 //x=14.705 //y=0.175 //x2=14.62 //y2=0.175
r2106 (  37 39 ) resistor r=0.383842 //w=0.311 //l=0.955 //layer=m1 \
 //thickness=0.36 //x=14.705 //y=0.175 //x2=15.66 //y2=0.175
r2107 (  36 230 ) resistor r=0.028033 //w=0.35 //l=0.085 //layer=m1 \
 //thickness=0.36 //x=17.865 //y=0.175 //x2=17.95 //y2=0.175
r2108 (  36 41 ) resistor r=0.291399 //w=0.311 //l=0.725 //layer=m1 \
 //thickness=0.36 //x=17.865 //y=0.175 //x2=17.14 //y2=0.175
r2109 (  34 225 ) resistor r=0.0413265 //w=0.7 //l=0.175 //layer=m1 \
 //thickness=0.36 //x=14.62 //y=0.35 //x2=14.62 //y2=0.175
r2110 (  34 222 ) resistor r=0.625 //w=0.131 //l=0.655 //layer=m1 \
 //thickness=0.36 //x=14.62 //y=0.35 //x2=14.62 //y2=1.005
r2111 (  33 348 ) resistor r=3.1 //w=0.17 //l=0.51 //layer=mcon //count=3 \
 //x=13.07 //y=0.18 //x2=13.07 //y2=0.18
r2112 (  31 346 ) resistor r=3.1 //w=0.17 //l=0.51 //layer=mcon //count=3 \
 //x=11.96 //y=0.18 //x2=11.96 //y2=0.18
r2113 (  31 33 ) resistor r=0.446141 //w=0.311 //l=1.11 //layer=m1 \
 //thickness=0.36 //x=11.96 //y=0.175 //x2=13.07 //y2=0.175
r2114 (  29 344 ) resistor r=3.1 //w=0.17 //l=0.51 //layer=mcon //count=3 \
 //x=10.85 //y=0.18 //x2=10.85 //y2=0.18
r2115 (  29 31 ) resistor r=0.446141 //w=0.311 //l=1.11 //layer=m1 \
 //thickness=0.36 //x=10.85 //y=0.175 //x2=11.96 //y2=0.175
r2116 (  27 219 ) resistor r=0.028033 //w=0.35 //l=0.085 //layer=m1 \
 //thickness=0.36 //x=9.79 //y=0.175 //x2=9.705 //y2=0.175
r2117 (  27 29 ) resistor r=0.426045 //w=0.311 //l=1.06 //layer=m1 \
 //thickness=0.36 //x=9.79 //y=0.175 //x2=10.85 //y2=0.175
r2118 (  26 225 ) resistor r=0.028033 //w=0.35 //l=0.085 //layer=m1 \
 //thickness=0.36 //x=14.535 //y=0.175 //x2=14.62 //y2=0.175
r2119 (  26 33 ) resistor r=0.588826 //w=0.311 //l=1.465 //layer=m1 \
 //thickness=0.36 //x=14.535 //y=0.175 //x2=13.07 //y2=0.175
r2120 (  25 216 ) resistor r=0.0942778 //w=0.221 //l=0.13 //layer=m1 \
 //thickness=0.36 //x=9.705 //y=1.015 //x2=9.705 //y2=1.145
r2121 (  24 219 ) resistor r=0.0413265 //w=0.7 //l=0.175 //layer=m1 \
 //thickness=0.36 //x=9.705 //y=0.35 //x2=9.705 //y2=0.175
r2122 (  24 25 ) resistor r=0.634542 //w=0.131 //l=0.665 //layer=m1 \
 //thickness=0.36 //x=9.705 //y=0.35 //x2=9.705 //y2=1.015
r2123 (  23 331 ) resistor r=3.1 //w=0.17 //l=0.51 //layer=mcon //count=3 \
 //x=8.26 //y=0.18 //x2=8.26 //y2=0.18
r2124 (  21 329 ) resistor r=3.1 //w=0.17 //l=0.51 //layer=mcon //count=3 \
 //x=7.15 //y=0.18 //x2=7.15 //y2=0.18
r2125 (  21 23 ) resistor r=0.446141 //w=0.311 //l=1.11 //layer=m1 \
 //thickness=0.36 //x=7.15 //y=0.175 //x2=8.26 //y2=0.175
r2126 (  19 327 ) resistor r=3.1 //w=0.17 //l=0.51 //layer=mcon //count=3 \
 //x=6.04 //y=0.18 //x2=6.04 //y2=0.18
r2127 (  19 21 ) resistor r=0.446141 //w=0.311 //l=1.11 //layer=m1 \
 //thickness=0.36 //x=6.04 //y=0.175 //x2=7.15 //y2=0.175
r2128 (  17 214 ) resistor r=0.028033 //w=0.35 //l=0.085 //layer=m1 \
 //thickness=0.36 //x=4.98 //y=0.175 //x2=4.895 //y2=0.175
r2129 (  17 19 ) resistor r=0.426045 //w=0.311 //l=1.06 //layer=m1 \
 //thickness=0.36 //x=4.98 //y=0.175 //x2=6.04 //y2=0.175
r2130 (  16 219 ) resistor r=0.028033 //w=0.35 //l=0.085 //layer=m1 \
 //thickness=0.36 //x=9.62 //y=0.175 //x2=9.705 //y2=0.175
r2131 (  16 23 ) resistor r=0.546624 //w=0.311 //l=1.36 //layer=m1 \
 //thickness=0.36 //x=9.62 //y=0.175 //x2=8.26 //y2=0.175
r2132 (  15 211 ) resistor r=0.0942778 //w=0.221 //l=0.13 //layer=m1 \
 //thickness=0.36 //x=4.895 //y=1.015 //x2=4.895 //y2=1.145
r2133 (  14 214 ) resistor r=0.0413265 //w=0.7 //l=0.175 //layer=m1 \
 //thickness=0.36 //x=4.895 //y=0.35 //x2=4.895 //y2=0.175
r2134 (  14 15 ) resistor r=0.634542 //w=0.131 //l=0.665 //layer=m1 \
 //thickness=0.36 //x=4.895 //y=0.35 //x2=4.895 //y2=1.015
r2135 (  13 314 ) resistor r=3.1 //w=0.17 //l=0.51 //layer=mcon //count=3 \
 //x=3.45 //y=0.18 //x2=3.45 //y2=0.18
r2136 (  11 312 ) resistor r=3.1 //w=0.17 //l=0.51 //layer=mcon //count=3 \
 //x=2.34 //y=0.18 //x2=2.34 //y2=0.18
r2137 (  11 13 ) resistor r=0.446141 //w=0.311 //l=1.11 //layer=m1 \
 //thickness=0.36 //x=2.34 //y=0.175 //x2=3.45 //y2=0.175
r2138 (  9 209 ) resistor r=0.028033 //w=0.35 //l=0.085 //layer=m1 \
 //thickness=0.36 //x=1.755 //y=0.175 //x2=1.67 //y2=0.175
r2139 (  9 11 ) resistor r=0.235129 //w=0.311 //l=0.585 //layer=m1 \
 //thickness=0.36 //x=1.755 //y=0.175 //x2=2.34 //y2=0.175
r2140 (  8 214 ) resistor r=0.028033 //w=0.35 //l=0.085 //layer=m1 \
 //thickness=0.36 //x=4.81 //y=0.175 //x2=4.895 //y2=0.175
r2141 (  8 13 ) resistor r=0.546624 //w=0.311 //l=1.36 //layer=m1 \
 //thickness=0.36 //x=4.81 //y=0.175 //x2=3.45 //y2=0.175
r2142 (  6 209 ) resistor r=0.0413265 //w=0.7 //l=0.175 //layer=m1 \
 //thickness=0.36 //x=1.67 //y=0.35 //x2=1.67 //y2=0.175
r2143 (  6 207 ) resistor r=0.625 //w=0.131 //l=0.655 //layer=m1 \
 //thickness=0.36 //x=1.67 //y=0.35 //x2=1.67 //y2=1.005
r2144 (  4 310 ) resistor r=3.1 //w=0.17 //l=0.51 //layer=mcon //count=3 \
 //x=1.23 //y=0.18 //x2=1.23 //y2=0.18
r2145 (  2 209 ) resistor r=0.028033 //w=0.35 //l=0.085 //layer=m1 \
 //thickness=0.36 //x=1.585 //y=0.175 //x2=1.67 //y2=0.175
r2146 (  2 4 ) resistor r=0.142685 //w=0.311 //l=0.355 //layer=m1 \
 //thickness=0.36 //x=1.585 //y=0.175 //x2=1.23 //y2=0.175
r2147 (  1 94 ) resistor r=0.068328 //w=0.311 //l=0.17 //layer=m1 \
 //thickness=0.36 //x=42.115 //y=0.175 //x2=42.285 //y2=0.175
r2148 (  1 99 ) resistor r=0.223071 //w=0.311 //l=0.555 //layer=m1 \
 //thickness=0.36 //x=42.115 //y=0.175 //x2=41.56 //y2=0.175
ends PM_TMRDFFSNQNX1\%GND

subckt PM_TMRDFFSNQNX1\%noxref_36 ( 1 5 9 10 13 17 29 )
c63 ( 29 0 ) capacitor c=0.0672418f //x=1.05 //y=0.545
c64 ( 17 0 ) capacitor c=0.00675704f //x=3.125 //y=0.795
c65 ( 13 0 ) capacitor c=0.0156697f //x=3.04 //y=0.71
c66 ( 10 0 ) capacitor c=0.007067f //x=2.155 //y=1.675
c67 ( 9 0 ) capacitor c=0.00770028f //x=2.155 //y=0.795
c68 ( 5 0 ) capacitor c=0.019857f //x=2.07 //y=1.76
c69 ( 1 0 ) capacitor c=0.0115037f //x=1.185 //y=1.675
r70 (  17 29 ) resistor r=3.57586 //w=0.17 //l=0.125 //layer=li \
 //thickness=0.1 //x=3.125 //y=0.795 //x2=3.125 //y2=0.67
r71 (  17 29 ) resistor r=18.139 //w=0.187 //l=0.265 //layer=li \
 //thickness=0.1 //x=3.125 //y=0.795 //x2=3.125 //y2=1.06
r72 (  14 29 ) resistor r=3.57586 //w=0.17 //l=0.103078 //layer=li \
 //thickness=0.1 //x=2.24 //y=0.71 //x2=2.155 //y2=0.67
r73 (  14 29 ) resistor r=27.3797 //w=0.187 //l=0.4 //layer=li //thickness=0.1 \
 //x=2.24 //y=0.71 //x2=2.64 //y2=0.71
r74 (  13 29 ) resistor r=3.57586 //w=0.17 //l=0.103078 //layer=li \
 //thickness=0.1 //x=3.04 //y=0.71 //x2=3.125 //y2=0.67
r75 (  13 29 ) resistor r=27.3797 //w=0.187 //l=0.4 //layer=li //thickness=0.1 \
 //x=3.04 //y=0.71 //x2=2.64 //y2=0.71
r76 (  10 29 ) resistor r=3.57586 //w=0.17 //l=0.125 //layer=li \
 //thickness=0.1 //x=2.155 //y=1.675 //x2=2.155 //y2=1.8
r77 (  10 29 ) resistor r=42.0963 //w=0.187 //l=0.615 //layer=li \
 //thickness=0.1 //x=2.155 //y=1.675 //x2=2.155 //y2=1.06
r78 (  9 29 ) resistor r=3.57586 //w=0.17 //l=0.125 //layer=li //thickness=0.1 \
 //x=2.155 //y=0.795 //x2=2.155 //y2=0.67
r79 (  9 29 ) resistor r=18.139 //w=0.187 //l=0.265 //layer=li //thickness=0.1 \
 //x=2.155 //y=0.795 //x2=2.155 //y2=1.06
r80 (  6 29 ) resistor r=3.57586 //w=0.17 //l=0.103078 //layer=li \
 //thickness=0.1 //x=1.27 //y=1.76 //x2=1.185 //y2=1.8
r81 (  6 29 ) resistor r=27.3797 //w=0.187 //l=0.4 //layer=li //thickness=0.1 \
 //x=1.27 //y=1.76 //x2=1.67 //y2=1.76
r82 (  5 29 ) resistor r=3.57586 //w=0.17 //l=0.103078 //layer=li \
 //thickness=0.1 //x=2.07 //y=1.76 //x2=2.155 //y2=1.8
r83 (  5 29 ) resistor r=27.3797 //w=0.187 //l=0.4 //layer=li //thickness=0.1 \
 //x=2.07 //y=1.76 //x2=1.67 //y2=1.76
r84 (  1 29 ) resistor r=3.57586 //w=0.17 //l=0.125 //layer=li //thickness=0.1 \
 //x=1.185 //y=1.675 //x2=1.185 //y2=1.8
r85 (  1 29 ) resistor r=42.0963 //w=0.187 //l=0.615 //layer=li \
 //thickness=0.1 //x=1.185 //y=1.675 //x2=1.185 //y2=1.06
ends PM_TMRDFFSNQNX1\%noxref_36

subckt PM_TMRDFFSNQNX1\%noxref_37 ( 1 5 9 13 17 35 )
c59 ( 35 0 ) capacitor c=0.0691972f //x=4.275 //y=0.555
c60 ( 17 0 ) capacitor c=0.0195855f //x=6.265 //y=1.77
c61 ( 13 0 ) capacitor c=0.015342f //x=6.265 //y=0.72
c62 ( 9 0 ) capacitor c=0.00772076f //x=5.38 //y=0.805
c63 ( 5 0 ) capacitor c=0.0168722f //x=5.295 //y=1.77
c64 ( 1 0 ) capacitor c=0.00726193f //x=4.41 //y=1.685
r65 (  18 35 ) resistor r=5.4201 //w=0.17 //l=0.103078 //layer=li \
 //thickness=0.1 //x=5.465 //y=1.77 //x2=5.38 //y2=1.81
r66 (  18 35 ) resistor r=27.3797 //w=0.187 //l=0.4 //layer=li //thickness=0.1 \
 //x=5.465 //y=1.77 //x2=5.865 //y2=1.77
r67 (  17 35 ) resistor r=0.751729 //w=0.17 //l=0.085 //layer=li \
 //thickness=0.1 //x=6.265 //y=1.77 //x2=6.35 //y2=1.77
r68 (  17 35 ) resistor r=27.3797 //w=0.187 //l=0.4 //layer=li //thickness=0.1 \
 //x=6.265 //y=1.77 //x2=5.865 //y2=1.77
r69 (  14 35 ) resistor r=3.57586 //w=0.17 //l=0.103078 //layer=li \
 //thickness=0.1 //x=5.465 //y=0.72 //x2=5.38 //y2=0.68
r70 (  14 35 ) resistor r=27.3797 //w=0.187 //l=0.4 //layer=li //thickness=0.1 \
 //x=5.465 //y=0.72 //x2=5.865 //y2=0.72
r71 (  13 35 ) resistor r=0.751729 //w=0.17 //l=0.085 //layer=li \
 //thickness=0.1 //x=6.265 //y=0.72 //x2=6.35 //y2=0.72
r72 (  13 35 ) resistor r=27.3797 //w=0.187 //l=0.4 //layer=li //thickness=0.1 \
 //x=6.265 //y=0.72 //x2=5.865 //y2=0.72
r73 (  10 35 ) resistor r=1.40859 //w=0.34 //l=0.125 //layer=li \
 //thickness=0.1 //x=5.38 //y=1.685 //x2=5.38 //y2=1.81
r74 (  10 35 ) resistor r=42.0963 //w=0.187 //l=0.615 //layer=li \
 //thickness=0.1 //x=5.38 //y=1.685 //x2=5.38 //y2=1.07
r75 (  9 35 ) resistor r=3.57586 //w=0.17 //l=0.125 //layer=li //thickness=0.1 \
 //x=5.38 //y=0.805 //x2=5.38 //y2=0.68
r76 (  9 35 ) resistor r=18.139 //w=0.187 //l=0.265 //layer=li //thickness=0.1 \
 //x=5.38 //y=0.805 //x2=5.38 //y2=1.07
r77 (  6 35 ) resistor r=3.57586 //w=0.17 //l=0.103078 //layer=li \
 //thickness=0.1 //x=4.495 //y=1.77 //x2=4.41 //y2=1.81
r78 (  6 35 ) resistor r=27.3797 //w=0.187 //l=0.4 //layer=li //thickness=0.1 \
 //x=4.495 //y=1.77 //x2=4.895 //y2=1.77
r79 (  5 35 ) resistor r=5.4201 //w=0.17 //l=0.103078 //layer=li \
 //thickness=0.1 //x=5.295 //y=1.77 //x2=5.38 //y2=1.81
r80 (  5 35 ) resistor r=27.3797 //w=0.187 //l=0.4 //layer=li //thickness=0.1 \
 //x=5.295 //y=1.77 //x2=4.895 //y2=1.77
r81 (  1 35 ) resistor r=3.57586 //w=0.17 //l=0.125 //layer=li //thickness=0.1 \
 //x=4.41 //y=1.685 //x2=4.41 //y2=1.81
r82 (  1 35 ) resistor r=42.0963 //w=0.187 //l=0.615 //layer=li \
 //thickness=0.1 //x=4.41 //y=1.685 //x2=4.41 //y2=1.07
ends PM_TMRDFFSNQNX1\%noxref_37

subckt PM_TMRDFFSNQNX1\%noxref_38 ( 1 5 9 13 17 35 )
c59 ( 35 0 ) capacitor c=0.0695128f //x=9.085 //y=0.555
c60 ( 17 0 ) capacitor c=0.0199063f //x=11.075 //y=1.77
c61 ( 13 0 ) capacitor c=0.0153215f //x=11.075 //y=0.72
c62 ( 9 0 ) capacitor c=0.00772076f //x=10.19 //y=0.805
c63 ( 5 0 ) capacitor c=0.0173197f //x=10.105 //y=1.77
c64 ( 1 0 ) capacitor c=0.00727095f //x=9.22 //y=1.685
r65 (  18 35 ) resistor r=5.4201 //w=0.17 //l=0.103078 //layer=li \
 //thickness=0.1 //x=10.275 //y=1.77 //x2=10.19 //y2=1.81
r66 (  18 35 ) resistor r=27.3797 //w=0.187 //l=0.4 //layer=li //thickness=0.1 \
 //x=10.275 //y=1.77 //x2=10.675 //y2=1.77
r67 (  17 35 ) resistor r=0.751729 //w=0.17 //l=0.085 //layer=li \
 //thickness=0.1 //x=11.075 //y=1.77 //x2=11.16 //y2=1.77
r68 (  17 35 ) resistor r=27.3797 //w=0.187 //l=0.4 //layer=li //thickness=0.1 \
 //x=11.075 //y=1.77 //x2=10.675 //y2=1.77
r69 (  14 35 ) resistor r=3.57586 //w=0.17 //l=0.103078 //layer=li \
 //thickness=0.1 //x=10.275 //y=0.72 //x2=10.19 //y2=0.68
r70 (  14 35 ) resistor r=27.3797 //w=0.187 //l=0.4 //layer=li //thickness=0.1 \
 //x=10.275 //y=0.72 //x2=10.675 //y2=0.72
r71 (  13 35 ) resistor r=0.751729 //w=0.17 //l=0.085 //layer=li \
 //thickness=0.1 //x=11.075 //y=0.72 //x2=11.16 //y2=0.72
r72 (  13 35 ) resistor r=27.3797 //w=0.187 //l=0.4 //layer=li //thickness=0.1 \
 //x=11.075 //y=0.72 //x2=10.675 //y2=0.72
r73 (  10 35 ) resistor r=1.40859 //w=0.34 //l=0.125 //layer=li \
 //thickness=0.1 //x=10.19 //y=1.685 //x2=10.19 //y2=1.81
r74 (  10 35 ) resistor r=42.0963 //w=0.187 //l=0.615 //layer=li \
 //thickness=0.1 //x=10.19 //y=1.685 //x2=10.19 //y2=1.07
r75 (  9 35 ) resistor r=3.57586 //w=0.17 //l=0.125 //layer=li //thickness=0.1 \
 //x=10.19 //y=0.805 //x2=10.19 //y2=0.68
r76 (  9 35 ) resistor r=18.139 //w=0.187 //l=0.265 //layer=li //thickness=0.1 \
 //x=10.19 //y=0.805 //x2=10.19 //y2=1.07
r77 (  6 35 ) resistor r=3.57586 //w=0.17 //l=0.103078 //layer=li \
 //thickness=0.1 //x=9.305 //y=1.77 //x2=9.22 //y2=1.81
r78 (  6 35 ) resistor r=27.3797 //w=0.187 //l=0.4 //layer=li //thickness=0.1 \
 //x=9.305 //y=1.77 //x2=9.705 //y2=1.77
r79 (  5 35 ) resistor r=5.4201 //w=0.17 //l=0.103078 //layer=li \
 //thickness=0.1 //x=10.105 //y=1.77 //x2=10.19 //y2=1.81
r80 (  5 35 ) resistor r=27.3797 //w=0.187 //l=0.4 //layer=li //thickness=0.1 \
 //x=10.105 //y=1.77 //x2=9.705 //y2=1.77
r81 (  1 35 ) resistor r=3.57586 //w=0.17 //l=0.125 //layer=li //thickness=0.1 \
 //x=9.22 //y=1.685 //x2=9.22 //y2=1.81
r82 (  1 35 ) resistor r=42.0963 //w=0.187 //l=0.615 //layer=li \
 //thickness=0.1 //x=9.22 //y=1.685 //x2=9.22 //y2=1.07
ends PM_TMRDFFSNQNX1\%noxref_38

subckt PM_TMRDFFSNQNX1\%noxref_39 ( 1 5 9 10 13 17 29 )
c66 ( 29 0 ) capacitor c=0.0671873f //x=14 //y=0.545
c67 ( 17 0 ) capacitor c=0.0067865f //x=16.075 //y=0.795
c68 ( 13 0 ) capacitor c=0.0154977f //x=15.99 //y=0.71
c69 ( 10 0 ) capacitor c=0.00678687f //x=15.105 //y=1.675
c70 ( 9 0 ) capacitor c=0.00770028f //x=15.105 //y=0.795
c71 ( 5 0 ) capacitor c=0.0179209f //x=15.02 //y=1.76
c72 ( 1 0 ) capacitor c=0.00761099f //x=14.135 //y=1.675
r73 (  17 29 ) resistor r=3.57586 //w=0.17 //l=0.125 //layer=li \
 //thickness=0.1 //x=16.075 //y=0.795 //x2=16.075 //y2=0.67
r74 (  17 29 ) resistor r=18.139 //w=0.187 //l=0.265 //layer=li \
 //thickness=0.1 //x=16.075 //y=0.795 //x2=16.075 //y2=1.06
r75 (  14 29 ) resistor r=3.57586 //w=0.17 //l=0.103078 //layer=li \
 //thickness=0.1 //x=15.19 //y=0.71 //x2=15.105 //y2=0.67
r76 (  14 29 ) resistor r=27.3797 //w=0.187 //l=0.4 //layer=li //thickness=0.1 \
 //x=15.19 //y=0.71 //x2=15.59 //y2=0.71
r77 (  13 29 ) resistor r=3.57586 //w=0.17 //l=0.103078 //layer=li \
 //thickness=0.1 //x=15.99 //y=0.71 //x2=16.075 //y2=0.67
r78 (  13 29 ) resistor r=27.3797 //w=0.187 //l=0.4 //layer=li //thickness=0.1 \
 //x=15.99 //y=0.71 //x2=15.59 //y2=0.71
r79 (  10 29 ) resistor r=3.57586 //w=0.17 //l=0.125 //layer=li \
 //thickness=0.1 //x=15.105 //y=1.675 //x2=15.105 //y2=1.8
r80 (  10 29 ) resistor r=42.0963 //w=0.187 //l=0.615 //layer=li \
 //thickness=0.1 //x=15.105 //y=1.675 //x2=15.105 //y2=1.06
r81 (  9 29 ) resistor r=3.57586 //w=0.17 //l=0.125 //layer=li //thickness=0.1 \
 //x=15.105 //y=0.795 //x2=15.105 //y2=0.67
r82 (  9 29 ) resistor r=18.139 //w=0.187 //l=0.265 //layer=li //thickness=0.1 \
 //x=15.105 //y=0.795 //x2=15.105 //y2=1.06
r83 (  6 29 ) resistor r=3.57586 //w=0.17 //l=0.103078 //layer=li \
 //thickness=0.1 //x=14.22 //y=1.76 //x2=14.135 //y2=1.8
r84 (  6 29 ) resistor r=27.3797 //w=0.187 //l=0.4 //layer=li //thickness=0.1 \
 //x=14.22 //y=1.76 //x2=14.62 //y2=1.76
r85 (  5 29 ) resistor r=3.57586 //w=0.17 //l=0.103078 //layer=li \
 //thickness=0.1 //x=15.02 //y=1.76 //x2=15.105 //y2=1.8
r86 (  5 29 ) resistor r=27.3797 //w=0.187 //l=0.4 //layer=li //thickness=0.1 \
 //x=15.02 //y=1.76 //x2=14.62 //y2=1.76
r87 (  1 29 ) resistor r=3.57586 //w=0.17 //l=0.125 //layer=li //thickness=0.1 \
 //x=14.135 //y=1.675 //x2=14.135 //y2=1.8
r88 (  1 29 ) resistor r=42.0963 //w=0.187 //l=0.615 //layer=li \
 //thickness=0.1 //x=14.135 //y=1.675 //x2=14.135 //y2=1.06
ends PM_TMRDFFSNQNX1\%noxref_39

subckt PM_TMRDFFSNQNX1\%noxref_40 ( 1 5 9 10 13 17 29 )
c68 ( 29 0 ) capacitor c=0.0667587f //x=17.33 //y=0.545
c69 ( 17 0 ) capacitor c=0.00675704f //x=19.405 //y=0.795
c70 ( 13 0 ) capacitor c=0.0154977f //x=19.32 //y=0.71
c71 ( 10 0 ) capacitor c=0.00673372f //x=18.435 //y=1.675
c72 ( 9 0 ) capacitor c=0.00770028f //x=18.435 //y=0.795
c73 ( 5 0 ) capacitor c=0.0179513f //x=18.35 //y=1.76
c74 ( 1 0 ) capacitor c=0.0076012f //x=17.465 //y=1.675
r75 (  17 29 ) resistor r=3.57586 //w=0.17 //l=0.125 //layer=li \
 //thickness=0.1 //x=19.405 //y=0.795 //x2=19.405 //y2=0.67
r76 (  17 29 ) resistor r=18.139 //w=0.187 //l=0.265 //layer=li \
 //thickness=0.1 //x=19.405 //y=0.795 //x2=19.405 //y2=1.06
r77 (  14 29 ) resistor r=3.57586 //w=0.17 //l=0.103078 //layer=li \
 //thickness=0.1 //x=18.52 //y=0.71 //x2=18.435 //y2=0.67
r78 (  14 29 ) resistor r=27.3797 //w=0.187 //l=0.4 //layer=li //thickness=0.1 \
 //x=18.52 //y=0.71 //x2=18.92 //y2=0.71
r79 (  13 29 ) resistor r=3.57586 //w=0.17 //l=0.103078 //layer=li \
 //thickness=0.1 //x=19.32 //y=0.71 //x2=19.405 //y2=0.67
r80 (  13 29 ) resistor r=27.3797 //w=0.187 //l=0.4 //layer=li //thickness=0.1 \
 //x=19.32 //y=0.71 //x2=18.92 //y2=0.71
r81 (  10 29 ) resistor r=3.57586 //w=0.17 //l=0.125 //layer=li \
 //thickness=0.1 //x=18.435 //y=1.675 //x2=18.435 //y2=1.8
r82 (  10 29 ) resistor r=42.0963 //w=0.187 //l=0.615 //layer=li \
 //thickness=0.1 //x=18.435 //y=1.675 //x2=18.435 //y2=1.06
r83 (  9 29 ) resistor r=3.57586 //w=0.17 //l=0.125 //layer=li //thickness=0.1 \
 //x=18.435 //y=0.795 //x2=18.435 //y2=0.67
r84 (  9 29 ) resistor r=18.139 //w=0.187 //l=0.265 //layer=li //thickness=0.1 \
 //x=18.435 //y=0.795 //x2=18.435 //y2=1.06
r85 (  6 29 ) resistor r=3.57586 //w=0.17 //l=0.103078 //layer=li \
 //thickness=0.1 //x=17.55 //y=1.76 //x2=17.465 //y2=1.8
r86 (  6 29 ) resistor r=27.3797 //w=0.187 //l=0.4 //layer=li //thickness=0.1 \
 //x=17.55 //y=1.76 //x2=17.95 //y2=1.76
r87 (  5 29 ) resistor r=3.57586 //w=0.17 //l=0.103078 //layer=li \
 //thickness=0.1 //x=18.35 //y=1.76 //x2=18.435 //y2=1.8
r88 (  5 29 ) resistor r=27.3797 //w=0.187 //l=0.4 //layer=li //thickness=0.1 \
 //x=18.35 //y=1.76 //x2=17.95 //y2=1.76
r89 (  1 29 ) resistor r=3.57586 //w=0.17 //l=0.125 //layer=li //thickness=0.1 \
 //x=17.465 //y=1.675 //x2=17.465 //y2=1.8
r90 (  1 29 ) resistor r=42.0963 //w=0.187 //l=0.615 //layer=li \
 //thickness=0.1 //x=17.465 //y=1.675 //x2=17.465 //y2=1.06
ends PM_TMRDFFSNQNX1\%noxref_40

subckt PM_TMRDFFSNQNX1\%noxref_41 ( 1 5 9 13 17 35 )
c59 ( 35 0 ) capacitor c=0.0688411f //x=20.555 //y=0.555
c60 ( 17 0 ) capacitor c=0.0189392f //x=22.545 //y=1.77
c61 ( 13 0 ) capacitor c=0.0153224f //x=22.545 //y=0.72
c62 ( 9 0 ) capacitor c=0.00772076f //x=21.66 //y=0.805
c63 ( 5 0 ) capacitor c=0.0168501f //x=21.575 //y=1.77
c64 ( 1 0 ) capacitor c=0.00709556f //x=20.69 //y=1.685
r65 (  18 35 ) resistor r=5.4201 //w=0.17 //l=0.103078 //layer=li \
 //thickness=0.1 //x=21.745 //y=1.77 //x2=21.66 //y2=1.81
r66 (  18 35 ) resistor r=27.3797 //w=0.187 //l=0.4 //layer=li //thickness=0.1 \
 //x=21.745 //y=1.77 //x2=22.145 //y2=1.77
r67 (  17 35 ) resistor r=0.751729 //w=0.17 //l=0.085 //layer=li \
 //thickness=0.1 //x=22.545 //y=1.77 //x2=22.63 //y2=1.77
r68 (  17 35 ) resistor r=27.3797 //w=0.187 //l=0.4 //layer=li //thickness=0.1 \
 //x=22.545 //y=1.77 //x2=22.145 //y2=1.77
r69 (  14 35 ) resistor r=3.57586 //w=0.17 //l=0.103078 //layer=li \
 //thickness=0.1 //x=21.745 //y=0.72 //x2=21.66 //y2=0.68
r70 (  14 35 ) resistor r=27.3797 //w=0.187 //l=0.4 //layer=li //thickness=0.1 \
 //x=21.745 //y=0.72 //x2=22.145 //y2=0.72
r71 (  13 35 ) resistor r=0.751729 //w=0.17 //l=0.085 //layer=li \
 //thickness=0.1 //x=22.545 //y=0.72 //x2=22.63 //y2=0.72
r72 (  13 35 ) resistor r=27.3797 //w=0.187 //l=0.4 //layer=li //thickness=0.1 \
 //x=22.545 //y=0.72 //x2=22.145 //y2=0.72
r73 (  10 35 ) resistor r=1.40859 //w=0.34 //l=0.125 //layer=li \
 //thickness=0.1 //x=21.66 //y=1.685 //x2=21.66 //y2=1.81
r74 (  10 35 ) resistor r=42.0963 //w=0.187 //l=0.615 //layer=li \
 //thickness=0.1 //x=21.66 //y=1.685 //x2=21.66 //y2=1.07
r75 (  9 35 ) resistor r=3.57586 //w=0.17 //l=0.125 //layer=li //thickness=0.1 \
 //x=21.66 //y=0.805 //x2=21.66 //y2=0.68
r76 (  9 35 ) resistor r=18.139 //w=0.187 //l=0.265 //layer=li //thickness=0.1 \
 //x=21.66 //y=0.805 //x2=21.66 //y2=1.07
r77 (  6 35 ) resistor r=3.57586 //w=0.17 //l=0.103078 //layer=li \
 //thickness=0.1 //x=20.775 //y=1.77 //x2=20.69 //y2=1.81
r78 (  6 35 ) resistor r=27.3797 //w=0.187 //l=0.4 //layer=li //thickness=0.1 \
 //x=20.775 //y=1.77 //x2=21.175 //y2=1.77
r79 (  5 35 ) resistor r=5.4201 //w=0.17 //l=0.103078 //layer=li \
 //thickness=0.1 //x=21.575 //y=1.77 //x2=21.66 //y2=1.81
r80 (  5 35 ) resistor r=27.3797 //w=0.187 //l=0.4 //layer=li //thickness=0.1 \
 //x=21.575 //y=1.77 //x2=21.175 //y2=1.77
r81 (  1 35 ) resistor r=3.57586 //w=0.17 //l=0.125 //layer=li //thickness=0.1 \
 //x=20.69 //y=1.685 //x2=20.69 //y2=1.81
r82 (  1 35 ) resistor r=42.0963 //w=0.187 //l=0.615 //layer=li \
 //thickness=0.1 //x=20.69 //y=1.685 //x2=20.69 //y2=1.07
ends PM_TMRDFFSNQNX1\%noxref_41

subckt PM_TMRDFFSNQNX1\%noxref_42 ( 1 5 9 10 13 17 29 )
c67 ( 29 0 ) capacitor c=0.0664911f //x=25.47 //y=0.545
c68 ( 17 0 ) capacitor c=0.00675704f //x=27.545 //y=0.795
c69 ( 13 0 ) capacitor c=0.0156182f //x=27.46 //y=0.71
c70 ( 10 0 ) capacitor c=0.00673372f //x=26.575 //y=1.675
c71 ( 9 0 ) capacitor c=0.00770028f //x=26.575 //y=0.795
c72 ( 5 0 ) capacitor c=0.0179513f //x=26.49 //y=1.76
c73 ( 1 0 ) capacitor c=0.00761099f //x=25.605 //y=1.675
r74 (  17 29 ) resistor r=3.57586 //w=0.17 //l=0.125 //layer=li \
 //thickness=0.1 //x=27.545 //y=0.795 //x2=27.545 //y2=0.67
r75 (  17 29 ) resistor r=18.139 //w=0.187 //l=0.265 //layer=li \
 //thickness=0.1 //x=27.545 //y=0.795 //x2=27.545 //y2=1.06
r76 (  14 29 ) resistor r=3.57586 //w=0.17 //l=0.103078 //layer=li \
 //thickness=0.1 //x=26.66 //y=0.71 //x2=26.575 //y2=0.67
r77 (  14 29 ) resistor r=27.3797 //w=0.187 //l=0.4 //layer=li //thickness=0.1 \
 //x=26.66 //y=0.71 //x2=27.06 //y2=0.71
r78 (  13 29 ) resistor r=3.57586 //w=0.17 //l=0.103078 //layer=li \
 //thickness=0.1 //x=27.46 //y=0.71 //x2=27.545 //y2=0.67
r79 (  13 29 ) resistor r=27.3797 //w=0.187 //l=0.4 //layer=li //thickness=0.1 \
 //x=27.46 //y=0.71 //x2=27.06 //y2=0.71
r80 (  10 29 ) resistor r=3.57586 //w=0.17 //l=0.125 //layer=li \
 //thickness=0.1 //x=26.575 //y=1.675 //x2=26.575 //y2=1.8
r81 (  10 29 ) resistor r=42.0963 //w=0.187 //l=0.615 //layer=li \
 //thickness=0.1 //x=26.575 //y=1.675 //x2=26.575 //y2=1.06
r82 (  9 29 ) resistor r=3.57586 //w=0.17 //l=0.125 //layer=li //thickness=0.1 \
 //x=26.575 //y=0.795 //x2=26.575 //y2=0.67
r83 (  9 29 ) resistor r=18.139 //w=0.187 //l=0.265 //layer=li //thickness=0.1 \
 //x=26.575 //y=0.795 //x2=26.575 //y2=1.06
r84 (  6 29 ) resistor r=3.57586 //w=0.17 //l=0.103078 //layer=li \
 //thickness=0.1 //x=25.69 //y=1.76 //x2=25.605 //y2=1.8
r85 (  6 29 ) resistor r=27.3797 //w=0.187 //l=0.4 //layer=li //thickness=0.1 \
 //x=25.69 //y=1.76 //x2=26.09 //y2=1.76
r86 (  5 29 ) resistor r=3.57586 //w=0.17 //l=0.103078 //layer=li \
 //thickness=0.1 //x=26.49 //y=1.76 //x2=26.575 //y2=1.8
r87 (  5 29 ) resistor r=27.3797 //w=0.187 //l=0.4 //layer=li //thickness=0.1 \
 //x=26.49 //y=1.76 //x2=26.09 //y2=1.76
r88 (  1 29 ) resistor r=3.57586 //w=0.17 //l=0.125 //layer=li //thickness=0.1 \
 //x=25.605 //y=1.675 //x2=25.605 //y2=1.8
r89 (  1 29 ) resistor r=42.0963 //w=0.187 //l=0.615 //layer=li \
 //thickness=0.1 //x=25.605 //y=1.675 //x2=25.605 //y2=1.06
ends PM_TMRDFFSNQNX1\%noxref_42

subckt PM_TMRDFFSNQNX1\%noxref_43 ( 1 5 9 13 17 35 )
c60 ( 35 0 ) capacitor c=0.068832f //x=28.695 //y=0.555
c61 ( 17 0 ) capacitor c=0.0190725f //x=30.685 //y=1.77
c62 ( 13 0 ) capacitor c=0.015325f //x=30.685 //y=0.72
c63 ( 9 0 ) capacitor c=0.00772076f //x=29.8 //y=0.805
c64 ( 5 0 ) capacitor c=0.0166883f //x=29.715 //y=1.77
c65 ( 1 0 ) capacitor c=0.00709556f //x=28.83 //y=1.685
r66 (  18 35 ) resistor r=5.4201 //w=0.17 //l=0.103078 //layer=li \
 //thickness=0.1 //x=29.885 //y=1.77 //x2=29.8 //y2=1.81
r67 (  18 35 ) resistor r=27.3797 //w=0.187 //l=0.4 //layer=li //thickness=0.1 \
 //x=29.885 //y=1.77 //x2=30.285 //y2=1.77
r68 (  17 35 ) resistor r=0.751729 //w=0.17 //l=0.085 //layer=li \
 //thickness=0.1 //x=30.685 //y=1.77 //x2=30.77 //y2=1.77
r69 (  17 35 ) resistor r=27.3797 //w=0.187 //l=0.4 //layer=li //thickness=0.1 \
 //x=30.685 //y=1.77 //x2=30.285 //y2=1.77
r70 (  14 35 ) resistor r=3.57586 //w=0.17 //l=0.103078 //layer=li \
 //thickness=0.1 //x=29.885 //y=0.72 //x2=29.8 //y2=0.68
r71 (  14 35 ) resistor r=27.3797 //w=0.187 //l=0.4 //layer=li //thickness=0.1 \
 //x=29.885 //y=0.72 //x2=30.285 //y2=0.72
r72 (  13 35 ) resistor r=0.751729 //w=0.17 //l=0.085 //layer=li \
 //thickness=0.1 //x=30.685 //y=0.72 //x2=30.77 //y2=0.72
r73 (  13 35 ) resistor r=27.3797 //w=0.187 //l=0.4 //layer=li //thickness=0.1 \
 //x=30.685 //y=0.72 //x2=30.285 //y2=0.72
r74 (  10 35 ) resistor r=1.40859 //w=0.34 //l=0.125 //layer=li \
 //thickness=0.1 //x=29.8 //y=1.685 //x2=29.8 //y2=1.81
r75 (  10 35 ) resistor r=42.0963 //w=0.187 //l=0.615 //layer=li \
 //thickness=0.1 //x=29.8 //y=1.685 //x2=29.8 //y2=1.07
r76 (  9 35 ) resistor r=3.57586 //w=0.17 //l=0.125 //layer=li //thickness=0.1 \
 //x=29.8 //y=0.805 //x2=29.8 //y2=0.68
r77 (  9 35 ) resistor r=18.139 //w=0.187 //l=0.265 //layer=li //thickness=0.1 \
 //x=29.8 //y=0.805 //x2=29.8 //y2=1.07
r78 (  6 35 ) resistor r=3.57586 //w=0.17 //l=0.103078 //layer=li \
 //thickness=0.1 //x=28.915 //y=1.77 //x2=28.83 //y2=1.81
r79 (  6 35 ) resistor r=27.3797 //w=0.187 //l=0.4 //layer=li //thickness=0.1 \
 //x=28.915 //y=1.77 //x2=29.315 //y2=1.77
r80 (  5 35 ) resistor r=5.4201 //w=0.17 //l=0.103078 //layer=li \
 //thickness=0.1 //x=29.715 //y=1.77 //x2=29.8 //y2=1.81
r81 (  5 35 ) resistor r=27.3797 //w=0.187 //l=0.4 //layer=li //thickness=0.1 \
 //x=29.715 //y=1.77 //x2=29.315 //y2=1.77
r82 (  1 35 ) resistor r=3.57586 //w=0.17 //l=0.125 //layer=li //thickness=0.1 \
 //x=28.83 //y=1.685 //x2=28.83 //y2=1.81
r83 (  1 35 ) resistor r=42.0963 //w=0.187 //l=0.615 //layer=li \
 //thickness=0.1 //x=28.83 //y=1.685 //x2=28.83 //y2=1.07
ends PM_TMRDFFSNQNX1\%noxref_43

subckt PM_TMRDFFSNQNX1\%noxref_44 ( 1 5 9 13 17 35 )
c60 ( 35 0 ) capacitor c=0.0691304f //x=33.505 //y=0.555
c61 ( 17 0 ) capacitor c=0.0189711f //x=35.495 //y=1.77
c62 ( 13 0 ) capacitor c=0.0153215f //x=35.495 //y=0.72
c63 ( 9 0 ) capacitor c=0.00772076f //x=34.61 //y=0.805
c64 ( 5 0 ) capacitor c=0.0167734f //x=34.525 //y=1.77
c65 ( 1 0 ) capacitor c=0.00710458f //x=33.64 //y=1.685
r66 (  18 35 ) resistor r=5.4201 //w=0.17 //l=0.103078 //layer=li \
 //thickness=0.1 //x=34.695 //y=1.77 //x2=34.61 //y2=1.81
r67 (  18 35 ) resistor r=27.3797 //w=0.187 //l=0.4 //layer=li //thickness=0.1 \
 //x=34.695 //y=1.77 //x2=35.095 //y2=1.77
r68 (  17 35 ) resistor r=0.751729 //w=0.17 //l=0.085 //layer=li \
 //thickness=0.1 //x=35.495 //y=1.77 //x2=35.58 //y2=1.77
r69 (  17 35 ) resistor r=27.3797 //w=0.187 //l=0.4 //layer=li //thickness=0.1 \
 //x=35.495 //y=1.77 //x2=35.095 //y2=1.77
r70 (  14 35 ) resistor r=3.57586 //w=0.17 //l=0.103078 //layer=li \
 //thickness=0.1 //x=34.695 //y=0.72 //x2=34.61 //y2=0.68
r71 (  14 35 ) resistor r=27.3797 //w=0.187 //l=0.4 //layer=li //thickness=0.1 \
 //x=34.695 //y=0.72 //x2=35.095 //y2=0.72
r72 (  13 35 ) resistor r=0.751729 //w=0.17 //l=0.085 //layer=li \
 //thickness=0.1 //x=35.495 //y=0.72 //x2=35.58 //y2=0.72
r73 (  13 35 ) resistor r=27.3797 //w=0.187 //l=0.4 //layer=li //thickness=0.1 \
 //x=35.495 //y=0.72 //x2=35.095 //y2=0.72
r74 (  10 35 ) resistor r=1.40859 //w=0.34 //l=0.125 //layer=li \
 //thickness=0.1 //x=34.61 //y=1.685 //x2=34.61 //y2=1.81
r75 (  10 35 ) resistor r=42.0963 //w=0.187 //l=0.615 //layer=li \
 //thickness=0.1 //x=34.61 //y=1.685 //x2=34.61 //y2=1.07
r76 (  9 35 ) resistor r=3.57586 //w=0.17 //l=0.125 //layer=li //thickness=0.1 \
 //x=34.61 //y=0.805 //x2=34.61 //y2=0.68
r77 (  9 35 ) resistor r=18.139 //w=0.187 //l=0.265 //layer=li //thickness=0.1 \
 //x=34.61 //y=0.805 //x2=34.61 //y2=1.07
r78 (  6 35 ) resistor r=3.57586 //w=0.17 //l=0.103078 //layer=li \
 //thickness=0.1 //x=33.725 //y=1.77 //x2=33.64 //y2=1.81
r79 (  6 35 ) resistor r=27.3797 //w=0.187 //l=0.4 //layer=li //thickness=0.1 \
 //x=33.725 //y=1.77 //x2=34.125 //y2=1.77
r80 (  5 35 ) resistor r=5.4201 //w=0.17 //l=0.103078 //layer=li \
 //thickness=0.1 //x=34.525 //y=1.77 //x2=34.61 //y2=1.81
r81 (  5 35 ) resistor r=27.3797 //w=0.187 //l=0.4 //layer=li //thickness=0.1 \
 //x=34.525 //y=1.77 //x2=34.125 //y2=1.77
r82 (  1 35 ) resistor r=3.57586 //w=0.17 //l=0.125 //layer=li //thickness=0.1 \
 //x=33.64 //y=1.685 //x2=33.64 //y2=1.81
r83 (  1 35 ) resistor r=42.0963 //w=0.187 //l=0.615 //layer=li \
 //thickness=0.1 //x=33.64 //y=1.685 //x2=33.64 //y2=1.07
ends PM_TMRDFFSNQNX1\%noxref_44

subckt PM_TMRDFFSNQNX1\%noxref_45 ( 1 5 9 10 13 17 29 )
c66 ( 29 0 ) capacitor c=0.0671873f //x=38.42 //y=0.545
c67 ( 17 0 ) capacitor c=0.0067865f //x=40.495 //y=0.795
c68 ( 13 0 ) capacitor c=0.0154977f //x=40.41 //y=0.71
c69 ( 10 0 ) capacitor c=0.00678687f //x=39.525 //y=1.675
c70 ( 9 0 ) capacitor c=0.00770028f //x=39.525 //y=0.795
c71 ( 5 0 ) capacitor c=0.0179209f //x=39.44 //y=1.76
c72 ( 1 0 ) capacitor c=0.00761099f //x=38.555 //y=1.675
r73 (  17 29 ) resistor r=3.57586 //w=0.17 //l=0.125 //layer=li \
 //thickness=0.1 //x=40.495 //y=0.795 //x2=40.495 //y2=0.67
r74 (  17 29 ) resistor r=18.139 //w=0.187 //l=0.265 //layer=li \
 //thickness=0.1 //x=40.495 //y=0.795 //x2=40.495 //y2=1.06
r75 (  14 29 ) resistor r=3.57586 //w=0.17 //l=0.103078 //layer=li \
 //thickness=0.1 //x=39.61 //y=0.71 //x2=39.525 //y2=0.67
r76 (  14 29 ) resistor r=27.3797 //w=0.187 //l=0.4 //layer=li //thickness=0.1 \
 //x=39.61 //y=0.71 //x2=40.01 //y2=0.71
r77 (  13 29 ) resistor r=3.57586 //w=0.17 //l=0.103078 //layer=li \
 //thickness=0.1 //x=40.41 //y=0.71 //x2=40.495 //y2=0.67
r78 (  13 29 ) resistor r=27.3797 //w=0.187 //l=0.4 //layer=li //thickness=0.1 \
 //x=40.41 //y=0.71 //x2=40.01 //y2=0.71
r79 (  10 29 ) resistor r=3.57586 //w=0.17 //l=0.125 //layer=li \
 //thickness=0.1 //x=39.525 //y=1.675 //x2=39.525 //y2=1.8
r80 (  10 29 ) resistor r=42.0963 //w=0.187 //l=0.615 //layer=li \
 //thickness=0.1 //x=39.525 //y=1.675 //x2=39.525 //y2=1.06
r81 (  9 29 ) resistor r=3.57586 //w=0.17 //l=0.125 //layer=li //thickness=0.1 \
 //x=39.525 //y=0.795 //x2=39.525 //y2=0.67
r82 (  9 29 ) resistor r=18.139 //w=0.187 //l=0.265 //layer=li //thickness=0.1 \
 //x=39.525 //y=0.795 //x2=39.525 //y2=1.06
r83 (  6 29 ) resistor r=3.57586 //w=0.17 //l=0.103078 //layer=li \
 //thickness=0.1 //x=38.64 //y=1.76 //x2=38.555 //y2=1.8
r84 (  6 29 ) resistor r=27.3797 //w=0.187 //l=0.4 //layer=li //thickness=0.1 \
 //x=38.64 //y=1.76 //x2=39.04 //y2=1.76
r85 (  5 29 ) resistor r=3.57586 //w=0.17 //l=0.103078 //layer=li \
 //thickness=0.1 //x=39.44 //y=1.76 //x2=39.525 //y2=1.8
r86 (  5 29 ) resistor r=27.3797 //w=0.187 //l=0.4 //layer=li //thickness=0.1 \
 //x=39.44 //y=1.76 //x2=39.04 //y2=1.76
r87 (  1 29 ) resistor r=3.57586 //w=0.17 //l=0.125 //layer=li //thickness=0.1 \
 //x=38.555 //y=1.675 //x2=38.555 //y2=1.8
r88 (  1 29 ) resistor r=42.0963 //w=0.187 //l=0.615 //layer=li \
 //thickness=0.1 //x=38.555 //y=1.675 //x2=38.555 //y2=1.06
ends PM_TMRDFFSNQNX1\%noxref_45

subckt PM_TMRDFFSNQNX1\%noxref_46 ( 1 5 9 10 13 17 29 )
c68 ( 29 0 ) capacitor c=0.0661913f //x=41.75 //y=0.545
c69 ( 17 0 ) capacitor c=0.00675704f //x=43.825 //y=0.795
c70 ( 13 0 ) capacitor c=0.0154977f //x=43.74 //y=0.71
c71 ( 10 0 ) capacitor c=0.00673372f //x=42.855 //y=1.675
c72 ( 9 0 ) capacitor c=0.00770028f //x=42.855 //y=0.795
c73 ( 5 0 ) capacitor c=0.0179513f //x=42.77 //y=1.76
c74 ( 1 0 ) capacitor c=0.0076012f //x=41.885 //y=1.675
r75 (  17 29 ) resistor r=3.57586 //w=0.17 //l=0.125 //layer=li \
 //thickness=0.1 //x=43.825 //y=0.795 //x2=43.825 //y2=0.67
r76 (  17 29 ) resistor r=18.139 //w=0.187 //l=0.265 //layer=li \
 //thickness=0.1 //x=43.825 //y=0.795 //x2=43.825 //y2=1.06
r77 (  14 29 ) resistor r=3.57586 //w=0.17 //l=0.103078 //layer=li \
 //thickness=0.1 //x=42.94 //y=0.71 //x2=42.855 //y2=0.67
r78 (  14 29 ) resistor r=27.3797 //w=0.187 //l=0.4 //layer=li //thickness=0.1 \
 //x=42.94 //y=0.71 //x2=43.34 //y2=0.71
r79 (  13 29 ) resistor r=3.57586 //w=0.17 //l=0.103078 //layer=li \
 //thickness=0.1 //x=43.74 //y=0.71 //x2=43.825 //y2=0.67
r80 (  13 29 ) resistor r=27.3797 //w=0.187 //l=0.4 //layer=li //thickness=0.1 \
 //x=43.74 //y=0.71 //x2=43.34 //y2=0.71
r81 (  10 29 ) resistor r=3.57586 //w=0.17 //l=0.125 //layer=li \
 //thickness=0.1 //x=42.855 //y=1.675 //x2=42.855 //y2=1.8
r82 (  10 29 ) resistor r=42.0963 //w=0.187 //l=0.615 //layer=li \
 //thickness=0.1 //x=42.855 //y=1.675 //x2=42.855 //y2=1.06
r83 (  9 29 ) resistor r=3.57586 //w=0.17 //l=0.125 //layer=li //thickness=0.1 \
 //x=42.855 //y=0.795 //x2=42.855 //y2=0.67
r84 (  9 29 ) resistor r=18.139 //w=0.187 //l=0.265 //layer=li //thickness=0.1 \
 //x=42.855 //y=0.795 //x2=42.855 //y2=1.06
r85 (  6 29 ) resistor r=3.57586 //w=0.17 //l=0.103078 //layer=li \
 //thickness=0.1 //x=41.97 //y=1.76 //x2=41.885 //y2=1.8
r86 (  6 29 ) resistor r=27.3797 //w=0.187 //l=0.4 //layer=li //thickness=0.1 \
 //x=41.97 //y=1.76 //x2=42.37 //y2=1.76
r87 (  5 29 ) resistor r=3.57586 //w=0.17 //l=0.103078 //layer=li \
 //thickness=0.1 //x=42.77 //y=1.76 //x2=42.855 //y2=1.8
r88 (  5 29 ) resistor r=27.3797 //w=0.187 //l=0.4 //layer=li //thickness=0.1 \
 //x=42.77 //y=1.76 //x2=42.37 //y2=1.76
r89 (  1 29 ) resistor r=3.57586 //w=0.17 //l=0.125 //layer=li //thickness=0.1 \
 //x=41.885 //y=1.675 //x2=41.885 //y2=1.8
r90 (  1 29 ) resistor r=42.0963 //w=0.187 //l=0.615 //layer=li \
 //thickness=0.1 //x=41.885 //y=1.675 //x2=41.885 //y2=1.06
ends PM_TMRDFFSNQNX1\%noxref_46

subckt PM_TMRDFFSNQNX1\%noxref_47 ( 1 5 9 13 17 35 )
c59 ( 35 0 ) capacitor c=0.0688411f //x=44.975 //y=0.555
c60 ( 17 0 ) capacitor c=0.0189392f //x=46.965 //y=1.77
c61 ( 13 0 ) capacitor c=0.0153224f //x=46.965 //y=0.72
c62 ( 9 0 ) capacitor c=0.00772076f //x=46.08 //y=0.805
c63 ( 5 0 ) capacitor c=0.0167902f //x=45.995 //y=1.77
c64 ( 1 0 ) capacitor c=0.00709556f //x=45.11 //y=1.685
r65 (  18 35 ) resistor r=5.4201 //w=0.17 //l=0.103078 //layer=li \
 //thickness=0.1 //x=46.165 //y=1.77 //x2=46.08 //y2=1.81
r66 (  18 35 ) resistor r=27.3797 //w=0.187 //l=0.4 //layer=li //thickness=0.1 \
 //x=46.165 //y=1.77 //x2=46.565 //y2=1.77
r67 (  17 35 ) resistor r=0.751729 //w=0.17 //l=0.085 //layer=li \
 //thickness=0.1 //x=46.965 //y=1.77 //x2=47.05 //y2=1.77
r68 (  17 35 ) resistor r=27.3797 //w=0.187 //l=0.4 //layer=li //thickness=0.1 \
 //x=46.965 //y=1.77 //x2=46.565 //y2=1.77
r69 (  14 35 ) resistor r=3.57586 //w=0.17 //l=0.103078 //layer=li \
 //thickness=0.1 //x=46.165 //y=0.72 //x2=46.08 //y2=0.68
r70 (  14 35 ) resistor r=27.3797 //w=0.187 //l=0.4 //layer=li //thickness=0.1 \
 //x=46.165 //y=0.72 //x2=46.565 //y2=0.72
r71 (  13 35 ) resistor r=0.751729 //w=0.17 //l=0.085 //layer=li \
 //thickness=0.1 //x=46.965 //y=0.72 //x2=47.05 //y2=0.72
r72 (  13 35 ) resistor r=27.3797 //w=0.187 //l=0.4 //layer=li //thickness=0.1 \
 //x=46.965 //y=0.72 //x2=46.565 //y2=0.72
r73 (  10 35 ) resistor r=1.40859 //w=0.34 //l=0.125 //layer=li \
 //thickness=0.1 //x=46.08 //y=1.685 //x2=46.08 //y2=1.81
r74 (  10 35 ) resistor r=42.0963 //w=0.187 //l=0.615 //layer=li \
 //thickness=0.1 //x=46.08 //y=1.685 //x2=46.08 //y2=1.07
r75 (  9 35 ) resistor r=3.57586 //w=0.17 //l=0.125 //layer=li //thickness=0.1 \
 //x=46.08 //y=0.805 //x2=46.08 //y2=0.68
r76 (  9 35 ) resistor r=18.139 //w=0.187 //l=0.265 //layer=li //thickness=0.1 \
 //x=46.08 //y=0.805 //x2=46.08 //y2=1.07
r77 (  6 35 ) resistor r=3.57586 //w=0.17 //l=0.103078 //layer=li \
 //thickness=0.1 //x=45.195 //y=1.77 //x2=45.11 //y2=1.81
r78 (  6 35 ) resistor r=27.3797 //w=0.187 //l=0.4 //layer=li //thickness=0.1 \
 //x=45.195 //y=1.77 //x2=45.595 //y2=1.77
r79 (  5 35 ) resistor r=5.4201 //w=0.17 //l=0.103078 //layer=li \
 //thickness=0.1 //x=45.995 //y=1.77 //x2=46.08 //y2=1.81
r80 (  5 35 ) resistor r=27.3797 //w=0.187 //l=0.4 //layer=li //thickness=0.1 \
 //x=45.995 //y=1.77 //x2=45.595 //y2=1.77
r81 (  1 35 ) resistor r=3.57586 //w=0.17 //l=0.125 //layer=li //thickness=0.1 \
 //x=45.11 //y=1.685 //x2=45.11 //y2=1.81
r82 (  1 35 ) resistor r=42.0963 //w=0.187 //l=0.615 //layer=li \
 //thickness=0.1 //x=45.11 //y=1.685 //x2=45.11 //y2=1.07
ends PM_TMRDFFSNQNX1\%noxref_47

subckt PM_TMRDFFSNQNX1\%noxref_48 ( 1 5 9 10 13 17 29 )
c67 ( 29 0 ) capacitor c=0.0664911f //x=49.89 //y=0.545
c68 ( 17 0 ) capacitor c=0.00675704f //x=51.965 //y=0.795
c69 ( 13 0 ) capacitor c=0.0156182f //x=51.88 //y=0.71
c70 ( 10 0 ) capacitor c=0.00673372f //x=50.995 //y=1.675
c71 ( 9 0 ) capacitor c=0.00770028f //x=50.995 //y=0.795
c72 ( 5 0 ) capacitor c=0.0179513f //x=50.91 //y=1.76
c73 ( 1 0 ) capacitor c=0.00761099f //x=50.025 //y=1.675
r74 (  17 29 ) resistor r=3.57586 //w=0.17 //l=0.125 //layer=li \
 //thickness=0.1 //x=51.965 //y=0.795 //x2=51.965 //y2=0.67
r75 (  17 29 ) resistor r=18.139 //w=0.187 //l=0.265 //layer=li \
 //thickness=0.1 //x=51.965 //y=0.795 //x2=51.965 //y2=1.06
r76 (  14 29 ) resistor r=3.57586 //w=0.17 //l=0.103078 //layer=li \
 //thickness=0.1 //x=51.08 //y=0.71 //x2=50.995 //y2=0.67
r77 (  14 29 ) resistor r=27.3797 //w=0.187 //l=0.4 //layer=li //thickness=0.1 \
 //x=51.08 //y=0.71 //x2=51.48 //y2=0.71
r78 (  13 29 ) resistor r=3.57586 //w=0.17 //l=0.103078 //layer=li \
 //thickness=0.1 //x=51.88 //y=0.71 //x2=51.965 //y2=0.67
r79 (  13 29 ) resistor r=27.3797 //w=0.187 //l=0.4 //layer=li //thickness=0.1 \
 //x=51.88 //y=0.71 //x2=51.48 //y2=0.71
r80 (  10 29 ) resistor r=3.57586 //w=0.17 //l=0.125 //layer=li \
 //thickness=0.1 //x=50.995 //y=1.675 //x2=50.995 //y2=1.8
r81 (  10 29 ) resistor r=42.0963 //w=0.187 //l=0.615 //layer=li \
 //thickness=0.1 //x=50.995 //y=1.675 //x2=50.995 //y2=1.06
r82 (  9 29 ) resistor r=3.57586 //w=0.17 //l=0.125 //layer=li //thickness=0.1 \
 //x=50.995 //y=0.795 //x2=50.995 //y2=0.67
r83 (  9 29 ) resistor r=18.139 //w=0.187 //l=0.265 //layer=li //thickness=0.1 \
 //x=50.995 //y=0.795 //x2=50.995 //y2=1.06
r84 (  6 29 ) resistor r=3.57586 //w=0.17 //l=0.103078 //layer=li \
 //thickness=0.1 //x=50.11 //y=1.76 //x2=50.025 //y2=1.8
r85 (  6 29 ) resistor r=27.3797 //w=0.187 //l=0.4 //layer=li //thickness=0.1 \
 //x=50.11 //y=1.76 //x2=50.51 //y2=1.76
r86 (  5 29 ) resistor r=3.57586 //w=0.17 //l=0.103078 //layer=li \
 //thickness=0.1 //x=50.91 //y=1.76 //x2=50.995 //y2=1.8
r87 (  5 29 ) resistor r=27.3797 //w=0.187 //l=0.4 //layer=li //thickness=0.1 \
 //x=50.91 //y=1.76 //x2=50.51 //y2=1.76
r88 (  1 29 ) resistor r=3.57586 //w=0.17 //l=0.125 //layer=li //thickness=0.1 \
 //x=50.025 //y=1.675 //x2=50.025 //y2=1.8
r89 (  1 29 ) resistor r=42.0963 //w=0.187 //l=0.615 //layer=li \
 //thickness=0.1 //x=50.025 //y=1.675 //x2=50.025 //y2=1.06
ends PM_TMRDFFSNQNX1\%noxref_48

subckt PM_TMRDFFSNQNX1\%noxref_49 ( 1 5 9 13 17 35 )
c60 ( 35 0 ) capacitor c=0.068832f //x=53.115 //y=0.555
c61 ( 17 0 ) capacitor c=0.0190725f //x=55.105 //y=1.77
c62 ( 13 0 ) capacitor c=0.015325f //x=55.105 //y=0.72
c63 ( 9 0 ) capacitor c=0.00772076f //x=54.22 //y=0.805
c64 ( 5 0 ) capacitor c=0.0166883f //x=54.135 //y=1.77
c65 ( 1 0 ) capacitor c=0.00709556f //x=53.25 //y=1.685
r66 (  18 35 ) resistor r=5.4201 //w=0.17 //l=0.103078 //layer=li \
 //thickness=0.1 //x=54.305 //y=1.77 //x2=54.22 //y2=1.81
r67 (  18 35 ) resistor r=27.3797 //w=0.187 //l=0.4 //layer=li //thickness=0.1 \
 //x=54.305 //y=1.77 //x2=54.705 //y2=1.77
r68 (  17 35 ) resistor r=0.751729 //w=0.17 //l=0.085 //layer=li \
 //thickness=0.1 //x=55.105 //y=1.77 //x2=55.19 //y2=1.77
r69 (  17 35 ) resistor r=27.3797 //w=0.187 //l=0.4 //layer=li //thickness=0.1 \
 //x=55.105 //y=1.77 //x2=54.705 //y2=1.77
r70 (  14 35 ) resistor r=3.57586 //w=0.17 //l=0.103078 //layer=li \
 //thickness=0.1 //x=54.305 //y=0.72 //x2=54.22 //y2=0.68
r71 (  14 35 ) resistor r=27.3797 //w=0.187 //l=0.4 //layer=li //thickness=0.1 \
 //x=54.305 //y=0.72 //x2=54.705 //y2=0.72
r72 (  13 35 ) resistor r=0.751729 //w=0.17 //l=0.085 //layer=li \
 //thickness=0.1 //x=55.105 //y=0.72 //x2=55.19 //y2=0.72
r73 (  13 35 ) resistor r=27.3797 //w=0.187 //l=0.4 //layer=li //thickness=0.1 \
 //x=55.105 //y=0.72 //x2=54.705 //y2=0.72
r74 (  10 35 ) resistor r=1.40859 //w=0.34 //l=0.125 //layer=li \
 //thickness=0.1 //x=54.22 //y=1.685 //x2=54.22 //y2=1.81
r75 (  10 35 ) resistor r=42.0963 //w=0.187 //l=0.615 //layer=li \
 //thickness=0.1 //x=54.22 //y=1.685 //x2=54.22 //y2=1.07
r76 (  9 35 ) resistor r=3.57586 //w=0.17 //l=0.125 //layer=li //thickness=0.1 \
 //x=54.22 //y=0.805 //x2=54.22 //y2=0.68
r77 (  9 35 ) resistor r=18.139 //w=0.187 //l=0.265 //layer=li //thickness=0.1 \
 //x=54.22 //y=0.805 //x2=54.22 //y2=1.07
r78 (  6 35 ) resistor r=3.57586 //w=0.17 //l=0.103078 //layer=li \
 //thickness=0.1 //x=53.335 //y=1.77 //x2=53.25 //y2=1.81
r79 (  6 35 ) resistor r=27.3797 //w=0.187 //l=0.4 //layer=li //thickness=0.1 \
 //x=53.335 //y=1.77 //x2=53.735 //y2=1.77
r80 (  5 35 ) resistor r=5.4201 //w=0.17 //l=0.103078 //layer=li \
 //thickness=0.1 //x=54.135 //y=1.77 //x2=54.22 //y2=1.81
r81 (  5 35 ) resistor r=27.3797 //w=0.187 //l=0.4 //layer=li //thickness=0.1 \
 //x=54.135 //y=1.77 //x2=53.735 //y2=1.77
r82 (  1 35 ) resistor r=3.57586 //w=0.17 //l=0.125 //layer=li //thickness=0.1 \
 //x=53.25 //y=1.685 //x2=53.25 //y2=1.81
r83 (  1 35 ) resistor r=42.0963 //w=0.187 //l=0.615 //layer=li \
 //thickness=0.1 //x=53.25 //y=1.685 //x2=53.25 //y2=1.07
ends PM_TMRDFFSNQNX1\%noxref_49

subckt PM_TMRDFFSNQNX1\%noxref_50 ( 1 5 9 13 17 35 )
c60 ( 35 0 ) capacitor c=0.0691304f //x=57.925 //y=0.555
c61 ( 17 0 ) capacitor c=0.0189711f //x=59.915 //y=1.77
c62 ( 13 0 ) capacitor c=0.0153215f //x=59.915 //y=0.72
c63 ( 9 0 ) capacitor c=0.00772076f //x=59.03 //y=0.805
c64 ( 5 0 ) capacitor c=0.0167734f //x=58.945 //y=1.77
c65 ( 1 0 ) capacitor c=0.00710458f //x=58.06 //y=1.685
r66 (  18 35 ) resistor r=5.4201 //w=0.17 //l=0.103078 //layer=li \
 //thickness=0.1 //x=59.115 //y=1.77 //x2=59.03 //y2=1.81
r67 (  18 35 ) resistor r=27.3797 //w=0.187 //l=0.4 //layer=li //thickness=0.1 \
 //x=59.115 //y=1.77 //x2=59.515 //y2=1.77
r68 (  17 35 ) resistor r=0.751729 //w=0.17 //l=0.085 //layer=li \
 //thickness=0.1 //x=59.915 //y=1.77 //x2=60 //y2=1.77
r69 (  17 35 ) resistor r=27.3797 //w=0.187 //l=0.4 //layer=li //thickness=0.1 \
 //x=59.915 //y=1.77 //x2=59.515 //y2=1.77
r70 (  14 35 ) resistor r=3.57586 //w=0.17 //l=0.103078 //layer=li \
 //thickness=0.1 //x=59.115 //y=0.72 //x2=59.03 //y2=0.68
r71 (  14 35 ) resistor r=27.3797 //w=0.187 //l=0.4 //layer=li //thickness=0.1 \
 //x=59.115 //y=0.72 //x2=59.515 //y2=0.72
r72 (  13 35 ) resistor r=0.751729 //w=0.17 //l=0.085 //layer=li \
 //thickness=0.1 //x=59.915 //y=0.72 //x2=60 //y2=0.72
r73 (  13 35 ) resistor r=27.3797 //w=0.187 //l=0.4 //layer=li //thickness=0.1 \
 //x=59.915 //y=0.72 //x2=59.515 //y2=0.72
r74 (  10 35 ) resistor r=1.40859 //w=0.34 //l=0.125 //layer=li \
 //thickness=0.1 //x=59.03 //y=1.685 //x2=59.03 //y2=1.81
r75 (  10 35 ) resistor r=42.0963 //w=0.187 //l=0.615 //layer=li \
 //thickness=0.1 //x=59.03 //y=1.685 //x2=59.03 //y2=1.07
r76 (  9 35 ) resistor r=3.57586 //w=0.17 //l=0.125 //layer=li //thickness=0.1 \
 //x=59.03 //y=0.805 //x2=59.03 //y2=0.68
r77 (  9 35 ) resistor r=18.139 //w=0.187 //l=0.265 //layer=li //thickness=0.1 \
 //x=59.03 //y=0.805 //x2=59.03 //y2=1.07
r78 (  6 35 ) resistor r=3.57586 //w=0.17 //l=0.103078 //layer=li \
 //thickness=0.1 //x=58.145 //y=1.77 //x2=58.06 //y2=1.81
r79 (  6 35 ) resistor r=27.3797 //w=0.187 //l=0.4 //layer=li //thickness=0.1 \
 //x=58.145 //y=1.77 //x2=58.545 //y2=1.77
r80 (  5 35 ) resistor r=5.4201 //w=0.17 //l=0.103078 //layer=li \
 //thickness=0.1 //x=58.945 //y=1.77 //x2=59.03 //y2=1.81
r81 (  5 35 ) resistor r=27.3797 //w=0.187 //l=0.4 //layer=li //thickness=0.1 \
 //x=58.945 //y=1.77 //x2=58.545 //y2=1.77
r82 (  1 35 ) resistor r=3.57586 //w=0.17 //l=0.125 //layer=li //thickness=0.1 \
 //x=58.06 //y=1.685 //x2=58.06 //y2=1.81
r83 (  1 35 ) resistor r=42.0963 //w=0.187 //l=0.615 //layer=li \
 //thickness=0.1 //x=58.06 //y=1.685 //x2=58.06 //y2=1.07
ends PM_TMRDFFSNQNX1\%noxref_50

subckt PM_TMRDFFSNQNX1\%noxref_51 ( 1 5 9 10 13 17 29 )
c66 ( 29 0 ) capacitor c=0.0671873f //x=62.84 //y=0.545
c67 ( 17 0 ) capacitor c=0.0067865f //x=64.915 //y=0.795
c68 ( 13 0 ) capacitor c=0.0154977f //x=64.83 //y=0.71
c69 ( 10 0 ) capacitor c=0.00678687f //x=63.945 //y=1.675
c70 ( 9 0 ) capacitor c=0.00770028f //x=63.945 //y=0.795
c71 ( 5 0 ) capacitor c=0.0179209f //x=63.86 //y=1.76
c72 ( 1 0 ) capacitor c=0.00761099f //x=62.975 //y=1.675
r73 (  17 29 ) resistor r=3.57586 //w=0.17 //l=0.125 //layer=li \
 //thickness=0.1 //x=64.915 //y=0.795 //x2=64.915 //y2=0.67
r74 (  17 29 ) resistor r=18.139 //w=0.187 //l=0.265 //layer=li \
 //thickness=0.1 //x=64.915 //y=0.795 //x2=64.915 //y2=1.06
r75 (  14 29 ) resistor r=3.57586 //w=0.17 //l=0.103078 //layer=li \
 //thickness=0.1 //x=64.03 //y=0.71 //x2=63.945 //y2=0.67
r76 (  14 29 ) resistor r=27.3797 //w=0.187 //l=0.4 //layer=li //thickness=0.1 \
 //x=64.03 //y=0.71 //x2=64.43 //y2=0.71
r77 (  13 29 ) resistor r=3.57586 //w=0.17 //l=0.103078 //layer=li \
 //thickness=0.1 //x=64.83 //y=0.71 //x2=64.915 //y2=0.67
r78 (  13 29 ) resistor r=27.3797 //w=0.187 //l=0.4 //layer=li //thickness=0.1 \
 //x=64.83 //y=0.71 //x2=64.43 //y2=0.71
r79 (  10 29 ) resistor r=3.57586 //w=0.17 //l=0.125 //layer=li \
 //thickness=0.1 //x=63.945 //y=1.675 //x2=63.945 //y2=1.8
r80 (  10 29 ) resistor r=42.0963 //w=0.187 //l=0.615 //layer=li \
 //thickness=0.1 //x=63.945 //y=1.675 //x2=63.945 //y2=1.06
r81 (  9 29 ) resistor r=3.57586 //w=0.17 //l=0.125 //layer=li //thickness=0.1 \
 //x=63.945 //y=0.795 //x2=63.945 //y2=0.67
r82 (  9 29 ) resistor r=18.139 //w=0.187 //l=0.265 //layer=li //thickness=0.1 \
 //x=63.945 //y=0.795 //x2=63.945 //y2=1.06
r83 (  6 29 ) resistor r=3.57586 //w=0.17 //l=0.103078 //layer=li \
 //thickness=0.1 //x=63.06 //y=1.76 //x2=62.975 //y2=1.8
r84 (  6 29 ) resistor r=27.3797 //w=0.187 //l=0.4 //layer=li //thickness=0.1 \
 //x=63.06 //y=1.76 //x2=63.46 //y2=1.76
r85 (  5 29 ) resistor r=3.57586 //w=0.17 //l=0.103078 //layer=li \
 //thickness=0.1 //x=63.86 //y=1.76 //x2=63.945 //y2=1.8
r86 (  5 29 ) resistor r=27.3797 //w=0.187 //l=0.4 //layer=li //thickness=0.1 \
 //x=63.86 //y=1.76 //x2=63.46 //y2=1.76
r87 (  1 29 ) resistor r=3.57586 //w=0.17 //l=0.125 //layer=li //thickness=0.1 \
 //x=62.975 //y=1.675 //x2=62.975 //y2=1.8
r88 (  1 29 ) resistor r=42.0963 //w=0.187 //l=0.615 //layer=li \
 //thickness=0.1 //x=62.975 //y=1.675 //x2=62.975 //y2=1.06
ends PM_TMRDFFSNQNX1\%noxref_51

subckt PM_TMRDFFSNQNX1\%noxref_52 ( 1 5 9 10 13 17 29 )
c68 ( 29 0 ) capacitor c=0.0672733f //x=66.17 //y=0.545
c69 ( 17 0 ) capacitor c=0.00675704f //x=68.245 //y=0.795
c70 ( 13 0 ) capacitor c=0.0154977f //x=68.16 //y=0.71
c71 ( 10 0 ) capacitor c=0.00673372f //x=67.275 //y=1.675
c72 ( 9 0 ) capacitor c=0.00770028f //x=67.275 //y=0.795
c73 ( 5 0 ) capacitor c=0.0179513f //x=67.19 //y=1.76
c74 ( 1 0 ) capacitor c=0.0076012f //x=66.305 //y=1.675
r75 (  17 29 ) resistor r=3.57586 //w=0.17 //l=0.125 //layer=li \
 //thickness=0.1 //x=68.245 //y=0.795 //x2=68.245 //y2=0.67
r76 (  17 29 ) resistor r=18.139 //w=0.187 //l=0.265 //layer=li \
 //thickness=0.1 //x=68.245 //y=0.795 //x2=68.245 //y2=1.06
r77 (  14 29 ) resistor r=3.57586 //w=0.17 //l=0.103078 //layer=li \
 //thickness=0.1 //x=67.36 //y=0.71 //x2=67.275 //y2=0.67
r78 (  14 29 ) resistor r=27.3797 //w=0.187 //l=0.4 //layer=li //thickness=0.1 \
 //x=67.36 //y=0.71 //x2=67.76 //y2=0.71
r79 (  13 29 ) resistor r=3.57586 //w=0.17 //l=0.103078 //layer=li \
 //thickness=0.1 //x=68.16 //y=0.71 //x2=68.245 //y2=0.67
r80 (  13 29 ) resistor r=27.3797 //w=0.187 //l=0.4 //layer=li //thickness=0.1 \
 //x=68.16 //y=0.71 //x2=67.76 //y2=0.71
r81 (  10 29 ) resistor r=3.57586 //w=0.17 //l=0.125 //layer=li \
 //thickness=0.1 //x=67.275 //y=1.675 //x2=67.275 //y2=1.8
r82 (  10 29 ) resistor r=42.0963 //w=0.187 //l=0.615 //layer=li \
 //thickness=0.1 //x=67.275 //y=1.675 //x2=67.275 //y2=1.06
r83 (  9 29 ) resistor r=3.57586 //w=0.17 //l=0.125 //layer=li //thickness=0.1 \
 //x=67.275 //y=0.795 //x2=67.275 //y2=0.67
r84 (  9 29 ) resistor r=18.139 //w=0.187 //l=0.265 //layer=li //thickness=0.1 \
 //x=67.275 //y=0.795 //x2=67.275 //y2=1.06
r85 (  6 29 ) resistor r=3.57586 //w=0.17 //l=0.103078 //layer=li \
 //thickness=0.1 //x=66.39 //y=1.76 //x2=66.305 //y2=1.8
r86 (  6 29 ) resistor r=27.3797 //w=0.187 //l=0.4 //layer=li //thickness=0.1 \
 //x=66.39 //y=1.76 //x2=66.79 //y2=1.76
r87 (  5 29 ) resistor r=3.57586 //w=0.17 //l=0.103078 //layer=li \
 //thickness=0.1 //x=67.19 //y=1.76 //x2=67.275 //y2=1.8
r88 (  5 29 ) resistor r=27.3797 //w=0.187 //l=0.4 //layer=li //thickness=0.1 \
 //x=67.19 //y=1.76 //x2=66.79 //y2=1.76
r89 (  1 29 ) resistor r=3.57586 //w=0.17 //l=0.125 //layer=li //thickness=0.1 \
 //x=66.305 //y=1.675 //x2=66.305 //y2=1.8
r90 (  1 29 ) resistor r=42.0963 //w=0.187 //l=0.615 //layer=li \
 //thickness=0.1 //x=66.305 //y=1.675 //x2=66.305 //y2=1.06
ends PM_TMRDFFSNQNX1\%noxref_52

subckt PM_TMRDFFSNQNX1\%noxref_53 ( 1 5 9 13 17 35 )
c59 ( 35 0 ) capacitor c=0.069279f //x=69.395 //y=0.555
c60 ( 17 0 ) capacitor c=0.0190725f //x=71.385 //y=1.77
c61 ( 13 0 ) capacitor c=0.0153491f //x=71.385 //y=0.72
c62 ( 9 0 ) capacitor c=0.00772076f //x=70.5 //y=0.805
c63 ( 5 0 ) capacitor c=0.0168501f //x=70.415 //y=1.77
c64 ( 1 0 ) capacitor c=0.00709556f //x=69.53 //y=1.685
r65 (  18 35 ) resistor r=5.4201 //w=0.17 //l=0.103078 //layer=li \
 //thickness=0.1 //x=70.585 //y=1.77 //x2=70.5 //y2=1.81
r66 (  18 35 ) resistor r=27.3797 //w=0.187 //l=0.4 //layer=li //thickness=0.1 \
 //x=70.585 //y=1.77 //x2=70.985 //y2=1.77
r67 (  17 35 ) resistor r=0.751729 //w=0.17 //l=0.085 //layer=li \
 //thickness=0.1 //x=71.385 //y=1.77 //x2=71.47 //y2=1.77
r68 (  17 35 ) resistor r=27.3797 //w=0.187 //l=0.4 //layer=li //thickness=0.1 \
 //x=71.385 //y=1.77 //x2=70.985 //y2=1.77
r69 (  14 35 ) resistor r=3.57586 //w=0.17 //l=0.103078 //layer=li \
 //thickness=0.1 //x=70.585 //y=0.72 //x2=70.5 //y2=0.68
r70 (  14 35 ) resistor r=27.3797 //w=0.187 //l=0.4 //layer=li //thickness=0.1 \
 //x=70.585 //y=0.72 //x2=70.985 //y2=0.72
r71 (  13 35 ) resistor r=0.751729 //w=0.17 //l=0.085 //layer=li \
 //thickness=0.1 //x=71.385 //y=0.72 //x2=71.47 //y2=0.72
r72 (  13 35 ) resistor r=27.3797 //w=0.187 //l=0.4 //layer=li //thickness=0.1 \
 //x=71.385 //y=0.72 //x2=70.985 //y2=0.72
r73 (  10 35 ) resistor r=1.40859 //w=0.34 //l=0.125 //layer=li \
 //thickness=0.1 //x=70.5 //y=1.685 //x2=70.5 //y2=1.81
r74 (  10 35 ) resistor r=42.0963 //w=0.187 //l=0.615 //layer=li \
 //thickness=0.1 //x=70.5 //y=1.685 //x2=70.5 //y2=1.07
r75 (  9 35 ) resistor r=3.57586 //w=0.17 //l=0.125 //layer=li //thickness=0.1 \
 //x=70.5 //y=0.805 //x2=70.5 //y2=0.68
r76 (  9 35 ) resistor r=18.139 //w=0.187 //l=0.265 //layer=li //thickness=0.1 \
 //x=70.5 //y=0.805 //x2=70.5 //y2=1.07
r77 (  6 35 ) resistor r=3.57586 //w=0.17 //l=0.103078 //layer=li \
 //thickness=0.1 //x=69.615 //y=1.77 //x2=69.53 //y2=1.81
r78 (  6 35 ) resistor r=27.3797 //w=0.187 //l=0.4 //layer=li //thickness=0.1 \
 //x=69.615 //y=1.77 //x2=70.015 //y2=1.77
r79 (  5 35 ) resistor r=5.4201 //w=0.17 //l=0.103078 //layer=li \
 //thickness=0.1 //x=70.415 //y=1.77 //x2=70.5 //y2=1.81
r80 (  5 35 ) resistor r=27.3797 //w=0.187 //l=0.4 //layer=li //thickness=0.1 \
 //x=70.415 //y=1.77 //x2=70.015 //y2=1.77
r81 (  1 35 ) resistor r=3.57586 //w=0.17 //l=0.125 //layer=li //thickness=0.1 \
 //x=69.53 //y=1.685 //x2=69.53 //y2=1.81
r82 (  1 35 ) resistor r=42.0963 //w=0.187 //l=0.615 //layer=li \
 //thickness=0.1 //x=69.53 //y=1.685 //x2=69.53 //y2=1.07
ends PM_TMRDFFSNQNX1\%noxref_53

subckt PM_TMRDFFSNQNX1\%noxref_54 ( 1 5 9 10 13 17 29 )
c65 ( 29 0 ) capacitor c=0.0770393f //x=74.31 //y=0.545
c66 ( 17 0 ) capacitor c=0.00678917f //x=76.385 //y=0.795
c67 ( 13 0 ) capacitor c=0.0155017f //x=76.3 //y=0.71
c68 ( 10 0 ) capacitor c=0.00766319f //x=75.415 //y=1.675
c69 ( 9 0 ) capacitor c=0.00770028f //x=75.415 //y=0.795
c70 ( 5 0 ) capacitor c=0.0216744f //x=75.33 //y=1.76
c71 ( 1 0 ) capacitor c=0.00455693f //x=74.445 //y=1.675
r72 (  17 29 ) resistor r=3.57586 //w=0.17 //l=0.125 //layer=li \
 //thickness=0.1 //x=76.385 //y=0.795 //x2=76.385 //y2=0.67
r73 (  17 29 ) resistor r=41.4118 //w=0.187 //l=0.605 //layer=li \
 //thickness=0.1 //x=76.385 //y=0.795 //x2=76.385 //y2=1.4
r74 (  14 29 ) resistor r=3.57586 //w=0.17 //l=0.103078 //layer=li \
 //thickness=0.1 //x=75.5 //y=0.71 //x2=75.415 //y2=0.67
r75 (  14 29 ) resistor r=27.0374 //w=0.187 //l=0.395 //layer=li \
 //thickness=0.1 //x=75.5 //y=0.71 //x2=75.895 //y2=0.71
r76 (  13 29 ) resistor r=3.57586 //w=0.17 //l=0.103078 //layer=li \
 //thickness=0.1 //x=76.3 //y=0.71 //x2=76.385 //y2=0.67
r77 (  13 29 ) resistor r=27.7219 //w=0.187 //l=0.405 //layer=li \
 //thickness=0.1 //x=76.3 //y=0.71 //x2=75.895 //y2=0.71
r78 (  10 29 ) resistor r=3.57586 //w=0.17 //l=0.125 //layer=li \
 //thickness=0.1 //x=75.415 //y=1.675 //x2=75.415 //y2=1.8
r79 (  10 29 ) resistor r=42.0963 //w=0.187 //l=0.615 //layer=li \
 //thickness=0.1 //x=75.415 //y=1.675 //x2=75.415 //y2=1.06
r80 (  9 29 ) resistor r=3.57586 //w=0.17 //l=0.125 //layer=li //thickness=0.1 \
 //x=75.415 //y=0.795 //x2=75.415 //y2=0.67
r81 (  9 29 ) resistor r=18.139 //w=0.187 //l=0.265 //layer=li //thickness=0.1 \
 //x=75.415 //y=0.795 //x2=75.415 //y2=1.06
r82 (  6 29 ) resistor r=3.57586 //w=0.17 //l=0.103078 //layer=li \
 //thickness=0.1 //x=74.53 //y=1.76 //x2=74.445 //y2=1.8
r83 (  6 29 ) resistor r=27.3797 //w=0.187 //l=0.4 //layer=li //thickness=0.1 \
 //x=74.53 //y=1.76 //x2=74.93 //y2=1.76
r84 (  5 29 ) resistor r=3.57586 //w=0.17 //l=0.103078 //layer=li \
 //thickness=0.1 //x=75.33 //y=1.76 //x2=75.415 //y2=1.8
r85 (  5 29 ) resistor r=27.3797 //w=0.187 //l=0.4 //layer=li //thickness=0.1 \
 //x=75.33 //y=1.76 //x2=74.93 //y2=1.76
r86 (  1 29 ) resistor r=3.57586 //w=0.17 //l=0.125 //layer=li //thickness=0.1 \
 //x=74.445 //y=1.675 //x2=74.445 //y2=1.8
r87 (  1 29 ) resistor r=42.0963 //w=0.187 //l=0.615 //layer=li \
 //thickness=0.1 //x=74.445 //y=1.675 //x2=74.445 //y2=1.06
ends PM_TMRDFFSNQNX1\%noxref_54

subckt PM_TMRDFFSNQNX1\%noxref_55 ( 1 5 9 10 13 17 29 )
c63 ( 29 0 ) capacitor c=0.0738284f //x=77.64 //y=0.545
c64 ( 17 0 ) capacitor c=0.00678917f //x=79.715 //y=0.795
c65 ( 13 0 ) capacitor c=0.0158009f //x=79.63 //y=0.71
c66 ( 10 0 ) capacitor c=0.00926288f //x=78.745 //y=1.675
c67 ( 9 0 ) capacitor c=0.00770028f //x=78.745 //y=0.795
c68 ( 5 0 ) capacitor c=0.0191566f //x=78.66 //y=1.76
c69 ( 1 0 ) capacitor c=0.00901612f //x=77.775 //y=1.675
r70 (  17 29 ) resistor r=3.57586 //w=0.17 //l=0.125 //layer=li \
 //thickness=0.1 //x=79.715 //y=0.795 //x2=79.715 //y2=0.67
r71 (  17 29 ) resistor r=41.4118 //w=0.187 //l=0.605 //layer=li \
 //thickness=0.1 //x=79.715 //y=0.795 //x2=79.715 //y2=1.4
r72 (  14 29 ) resistor r=3.57586 //w=0.17 //l=0.103078 //layer=li \
 //thickness=0.1 //x=78.83 //y=0.71 //x2=78.745 //y2=0.67
r73 (  14 29 ) resistor r=27.3797 //w=0.187 //l=0.4 //layer=li //thickness=0.1 \
 //x=78.83 //y=0.71 //x2=79.23 //y2=0.71
r74 (  13 29 ) resistor r=3.57586 //w=0.17 //l=0.103078 //layer=li \
 //thickness=0.1 //x=79.63 //y=0.71 //x2=79.715 //y2=0.67
r75 (  13 29 ) resistor r=27.3797 //w=0.187 //l=0.4 //layer=li //thickness=0.1 \
 //x=79.63 //y=0.71 //x2=79.23 //y2=0.71
r76 (  10 29 ) resistor r=3.57586 //w=0.17 //l=0.125 //layer=li \
 //thickness=0.1 //x=78.745 //y=1.675 //x2=78.745 //y2=1.8
r77 (  10 29 ) resistor r=42.0963 //w=0.187 //l=0.615 //layer=li \
 //thickness=0.1 //x=78.745 //y=1.675 //x2=78.745 //y2=1.06
r78 (  9 29 ) resistor r=3.57586 //w=0.17 //l=0.125 //layer=li //thickness=0.1 \
 //x=78.745 //y=0.795 //x2=78.745 //y2=0.67
r79 (  9 29 ) resistor r=18.139 //w=0.187 //l=0.265 //layer=li //thickness=0.1 \
 //x=78.745 //y=0.795 //x2=78.745 //y2=1.06
r80 (  6 29 ) resistor r=3.57586 //w=0.17 //l=0.103078 //layer=li \
 //thickness=0.1 //x=77.86 //y=1.76 //x2=77.775 //y2=1.8
r81 (  6 29 ) resistor r=27.3797 //w=0.187 //l=0.4 //layer=li //thickness=0.1 \
 //x=77.86 //y=1.76 //x2=78.26 //y2=1.76
r82 (  5 29 ) resistor r=3.57586 //w=0.17 //l=0.103078 //layer=li \
 //thickness=0.1 //x=78.66 //y=1.76 //x2=78.745 //y2=1.8
r83 (  5 29 ) resistor r=27.3797 //w=0.187 //l=0.4 //layer=li //thickness=0.1 \
 //x=78.66 //y=1.76 //x2=78.26 //y2=1.76
r84 (  1 29 ) resistor r=3.57586 //w=0.17 //l=0.125 //layer=li //thickness=0.1 \
 //x=77.775 //y=1.675 //x2=77.775 //y2=1.8
r85 (  1 29 ) resistor r=42.0963 //w=0.187 //l=0.615 //layer=li \
 //thickness=0.1 //x=77.775 //y=1.675 //x2=77.775 //y2=1.06
ends PM_TMRDFFSNQNX1\%noxref_55

subckt PM_TMRDFFSNQNX1\%noxref_56 ( 1 5 9 10 13 17 29 )
c62 ( 29 0 ) capacitor c=0.0685992f //x=80.97 //y=0.545
c63 ( 17 0 ) capacitor c=0.00709795f //x=83.045 //y=0.795
c64 ( 13 0 ) capacitor c=0.0152565f //x=82.96 //y=0.71
c65 ( 10 0 ) capacitor c=0.0075177f //x=82.075 //y=1.675
c66 ( 9 0 ) capacitor c=0.00770028f //x=82.075 //y=0.795
c67 ( 5 0 ) capacitor c=0.0236235f //x=81.99 //y=1.76
c68 ( 1 0 ) capacitor c=0.00498306f //x=81.105 //y=1.675
r69 (  17 29 ) resistor r=3.57586 //w=0.17 //l=0.125 //layer=li \
 //thickness=0.1 //x=83.045 //y=0.795 //x2=83.045 //y2=0.67
r70 (  17 29 ) resistor r=18.139 //w=0.187 //l=0.265 //layer=li \
 //thickness=0.1 //x=83.045 //y=0.795 //x2=83.045 //y2=1.06
r71 (  14 29 ) resistor r=3.57586 //w=0.17 //l=0.103078 //layer=li \
 //thickness=0.1 //x=82.16 //y=0.71 //x2=82.075 //y2=0.67
r72 (  14 29 ) resistor r=27.3797 //w=0.187 //l=0.4 //layer=li //thickness=0.1 \
 //x=82.16 //y=0.71 //x2=82.56 //y2=0.71
r73 (  13 29 ) resistor r=3.57586 //w=0.17 //l=0.103078 //layer=li \
 //thickness=0.1 //x=82.96 //y=0.71 //x2=83.045 //y2=0.67
r74 (  13 29 ) resistor r=27.3797 //w=0.187 //l=0.4 //layer=li //thickness=0.1 \
 //x=82.96 //y=0.71 //x2=82.56 //y2=0.71
r75 (  10 29 ) resistor r=3.57586 //w=0.17 //l=0.125 //layer=li \
 //thickness=0.1 //x=82.075 //y=1.675 //x2=82.075 //y2=1.8
r76 (  10 29 ) resistor r=42.0963 //w=0.187 //l=0.615 //layer=li \
 //thickness=0.1 //x=82.075 //y=1.675 //x2=82.075 //y2=1.06
r77 (  9 29 ) resistor r=3.57586 //w=0.17 //l=0.125 //layer=li //thickness=0.1 \
 //x=82.075 //y=0.795 //x2=82.075 //y2=0.67
r78 (  9 29 ) resistor r=18.139 //w=0.187 //l=0.265 //layer=li //thickness=0.1 \
 //x=82.075 //y=0.795 //x2=82.075 //y2=1.06
r79 (  6 29 ) resistor r=3.57586 //w=0.17 //l=0.103078 //layer=li \
 //thickness=0.1 //x=81.19 //y=1.76 //x2=81.105 //y2=1.8
r80 (  6 29 ) resistor r=27.3797 //w=0.187 //l=0.4 //layer=li //thickness=0.1 \
 //x=81.19 //y=1.76 //x2=81.59 //y2=1.76
r81 (  5 29 ) resistor r=3.57586 //w=0.17 //l=0.103078 //layer=li \
 //thickness=0.1 //x=81.99 //y=1.76 //x2=82.075 //y2=1.8
r82 (  5 29 ) resistor r=27.3797 //w=0.187 //l=0.4 //layer=li //thickness=0.1 \
 //x=81.99 //y=1.76 //x2=81.59 //y2=1.76
r83 (  1 29 ) resistor r=3.57586 //w=0.17 //l=0.125 //layer=li //thickness=0.1 \
 //x=81.105 //y=1.675 //x2=81.105 //y2=1.8
r84 (  1 29 ) resistor r=42.0963 //w=0.187 //l=0.615 //layer=li \
 //thickness=0.1 //x=81.105 //y=1.675 //x2=81.105 //y2=1.06
ends PM_TMRDFFSNQNX1\%noxref_56
