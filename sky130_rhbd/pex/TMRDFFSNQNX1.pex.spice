// File: TMRDFFSNQNX1.spi.pex
// Created: Tue Apr 29 10:45:46 2025
// Program "Calibre xRC"
// Version "v2023.2_27.15"
// Nominal Temperature: 30C
// Circuit Temperature: 30C
//
simulator lang=spectre
subckt PM_TMRDFFSNQNX1\%GND ( 1 139 143 146 151 159 165 175 181 191 197 203 \
 211 219 227 237 245 253 259 269 275 285 291 297 305 313 321 331 339 347 353 \
 363 369 379 385 391 399 407 415 425 433 441 447 453 466 470 473 476 479 481 \
 483 485 488 491 494 496 498 500 503 506 509 511 513 515 518 520 521 522 523 \
 524 525 526 527 528 529 530 531 532 533 534 535 536 537 538 539 540 )
c976 ( 540 0 ) capacitor c=0.0215013f //x=81.4 //y=1.045
c977 ( 539 0 ) capacitor c=0.0215013f //x=78.07 //y=1.045
c978 ( 538 0 ) capacitor c=0.0207525f //x=74.74 //y=1.045
c979 ( 537 0 ) capacitor c=0.0226075f //x=69.825 //y=1.055
c980 ( 536 0 ) capacitor c=0.0207408f //x=66.6 //y=1.045
c981 ( 535 0 ) capacitor c=0.0207408f //x=63.27 //y=1.045
c982 ( 534 0 ) capacitor c=0.0225954f //x=58.355 //y=1.055
c983 ( 533 0 ) capacitor c=0.0226075f //x=53.545 //y=1.055
c984 ( 532 0 ) capacitor c=0.0207408f //x=50.32 //y=1.045
c985 ( 531 0 ) capacitor c=0.0226075f //x=45.405 //y=1.055
c986 ( 530 0 ) capacitor c=0.0207408f //x=42.18 //y=1.045
c987 ( 529 0 ) capacitor c=0.0207408f //x=38.85 //y=1.045
c988 ( 528 0 ) capacitor c=0.0225954f //x=33.935 //y=1.055
c989 ( 527 0 ) capacitor c=0.0226075f //x=29.125 //y=1.055
c990 ( 526 0 ) capacitor c=0.0207408f //x=25.9 //y=1.045
c991 ( 525 0 ) capacitor c=0.0226075f //x=20.985 //y=1.055
c992 ( 524 0 ) capacitor c=0.0207408f //x=17.76 //y=1.045
c993 ( 523 0 ) capacitor c=0.0207408f //x=14.43 //y=1.045
c994 ( 522 0 ) capacitor c=0.0226206f //x=9.515 //y=1.055
c995 ( 521 0 ) capacitor c=0.0226323f //x=4.705 //y=1.055
c996 ( 520 0 ) capacitor c=0.0207863f //x=1.48 //y=1.045
c997 ( 519 0 ) capacitor c=0.00446416f //x=81.59 //y=0.175
c998 ( 518 0 ) capacitor c=0.101602f //x=80.41 //y=0.175
c999 ( 517 0 ) capacitor c=0.00446416f //x=78.19 //y=0.18
c1000 ( 515 0 ) capacitor c=0.11712f //x=77.08 //y=0.175
c1001 ( 514 0 ) capacitor c=0.00446416f //x=74.93 //y=0.175
c1002 ( 513 0 ) capacitor c=0.106952f //x=73.75 //y=0.175
c1003 ( 512 0 ) capacitor c=0.00446464f //x=70.015 //y=0.175
c1004 ( 511 0 ) capacitor c=0.104217f //x=68.94 //y=0.175
c1005 ( 510 0 ) capacitor c=0.00446416f //x=66.79 //y=0.175
c1006 ( 509 0 ) capacitor c=0.105249f //x=65.61 //y=0.175
c1007 ( 508 0 ) capacitor c=0.00446416f //x=63.39 //y=0.18
c1008 ( 506 0 ) capacitor c=0.108374f //x=62.28 //y=0.175
c1009 ( 505 0 ) capacitor c=0.00446464f //x=58.58 //y=0.18
c1010 ( 503 0 ) capacitor c=0.107355f //x=57.47 //y=0.175
c1011 ( 502 0 ) capacitor c=0.00446464f //x=53.77 //y=0.18
c1012 ( 500 0 ) capacitor c=0.104239f //x=52.66 //y=0.175
c1013 ( 499 0 ) capacitor c=0.00446416f //x=50.51 //y=0.175
c1014 ( 498 0 ) capacitor c=0.108694f //x=49.33 //y=0.175
c1015 ( 497 0 ) capacitor c=0.00446464f //x=45.595 //y=0.175
c1016 ( 496 0 ) capacitor c=0.104206f //x=44.52 //y=0.175
c1017 ( 495 0 ) capacitor c=0.00446416f //x=42.37 //y=0.175
c1018 ( 494 0 ) capacitor c=0.105007f //x=41.19 //y=0.175
c1019 ( 493 0 ) capacitor c=0.00446416f //x=38.97 //y=0.18
c1020 ( 491 0 ) capacitor c=0.108374f //x=37.86 //y=0.175
c1021 ( 490 0 ) capacitor c=0.00446464f //x=34.16 //y=0.18
c1022 ( 488 0 ) capacitor c=0.107355f //x=33.05 //y=0.175
c1023 ( 487 0 ) capacitor c=0.00446464f //x=29.35 //y=0.18
c1024 ( 485 0 ) capacitor c=0.104268f //x=28.24 //y=0.175
c1025 ( 484 0 ) capacitor c=0.00446416f //x=26.09 //y=0.175
c1026 ( 483 0 ) capacitor c=0.108143f //x=24.91 //y=0.175
c1027 ( 482 0 ) capacitor c=0.00446464f //x=21.175 //y=0.175
c1028 ( 481 0 ) capacitor c=0.104217f //x=20.1 //y=0.175
c1029 ( 480 0 ) capacitor c=0.00446416f //x=17.95 //y=0.175
c1030 ( 479 0 ) capacitor c=0.105249f //x=16.77 //y=0.175
c1031 ( 478 0 ) capacitor c=0.00446416f //x=14.55 //y=0.18
c1032 ( 476 0 ) capacitor c=0.108374f //x=13.44 //y=0.175
c1033 ( 475 0 ) capacitor c=0.00446464f //x=9.74 //y=0.18
c1034 ( 473 0 ) capacitor c=0.108361f //x=8.63 //y=0.175
c1035 ( 472 0 ) capacitor c=0.00446464f //x=4.93 //y=0.18
c1036 ( 470 0 ) capacitor c=0.105439f //x=3.82 //y=0.175
c1037 ( 469 0 ) capacitor c=0.00446416f //x=1.67 //y=0.175
c1038 ( 466 0 ) capacitor c=0.278196f //x=83 //y=0.18
c1039 ( 453 0 ) capacitor c=0.0393378f //x=81.505 //y=0.175
c1040 ( 447 0 ) capacitor c=0.0725462f //x=80.24 //y=0.175
c1041 ( 441 0 ) capacitor c=0.0391794f //x=78.175 //y=0.175
c1042 ( 433 0 ) capacitor c=0.0728652f //x=76.91 //y=0.175
c1043 ( 425 0 ) capacitor c=0.0394931f //x=74.845 //y=0.175
c1044 ( 415 0 ) capacitor c=0.13531f //x=73.58 //y=0.175
c1045 ( 407 0 ) capacitor c=0.0342713f //x=69.93 //y=0.175
c1046 ( 399 0 ) capacitor c=0.0727058f //x=68.77 //y=0.175
c1047 ( 391 0 ) capacitor c=0.0392405f //x=66.705 //y=0.175
c1048 ( 385 0 ) capacitor c=0.0727058f //x=65.44 //y=0.175
c1049 ( 379 0 ) capacitor c=0.0392405f //x=63.375 //y=0.175
c1050 ( 369 0 ) capacitor c=0.135066f //x=62.11 //y=0.175
c1051 ( 363 0 ) capacitor c=0.0342713f //x=58.46 //y=0.175
c1052 ( 353 0 ) capacitor c=0.135066f //x=57.3 //y=0.175
c1053 ( 347 0 ) capacitor c=0.0342713f //x=53.65 //y=0.175
c1054 ( 339 0 ) capacitor c=0.0727058f //x=52.49 //y=0.175
c1055 ( 331 0 ) capacitor c=0.0392405f //x=50.425 //y=0.175
c1056 ( 321 0 ) capacitor c=0.135066f //x=49.16 //y=0.175
c1057 ( 313 0 ) capacitor c=0.0342713f //x=45.51 //y=0.175
c1058 ( 305 0 ) capacitor c=0.0727058f //x=44.35 //y=0.175
c1059 ( 297 0 ) capacitor c=0.0392405f //x=42.285 //y=0.175
c1060 ( 291 0 ) capacitor c=0.0727058f //x=41.02 //y=0.175
c1061 ( 285 0 ) capacitor c=0.0392405f //x=38.955 //y=0.175
c1062 ( 275 0 ) capacitor c=0.135066f //x=37.69 //y=0.175
c1063 ( 269 0 ) capacitor c=0.0342713f //x=34.04 //y=0.175
c1064 ( 259 0 ) capacitor c=0.135066f //x=32.88 //y=0.175
c1065 ( 253 0 ) capacitor c=0.0342713f //x=29.23 //y=0.175
c1066 ( 245 0 ) capacitor c=0.0727058f //x=28.07 //y=0.175
c1067 ( 237 0 ) capacitor c=0.0392405f //x=26.005 //y=0.175
c1068 ( 227 0 ) capacitor c=0.135066f //x=24.74 //y=0.175
c1069 ( 219 0 ) capacitor c=0.0342713f //x=21.09 //y=0.175
c1070 ( 211 0 ) capacitor c=0.0727058f //x=19.93 //y=0.175
c1071 ( 203 0 ) capacitor c=0.0392405f //x=17.865 //y=0.175
c1072 ( 197 0 ) capacitor c=0.0727058f //x=16.6 //y=0.175
c1073 ( 191 0 ) capacitor c=0.0392405f //x=14.535 //y=0.175
c1074 ( 181 0 ) capacitor c=0.135108f //x=13.27 //y=0.175
c1075 ( 175 0 ) capacitor c=0.0342869f //x=9.62 //y=0.175
c1076 ( 165 0 ) capacitor c=0.135219f //x=8.46 //y=0.175
c1077 ( 159 0 ) capacitor c=0.0342869f //x=4.81 //y=0.175
c1078 ( 151 0 ) capacitor c=0.0729471f //x=3.65 //y=0.175
c1079 ( 146 0 ) capacitor c=0.197933f //x=1.23 //y=0.18
c1080 ( 143 0 ) capacitor c=0.0430284f //x=1.585 //y=0.175
c1081 ( 139 0 ) capacitor c=2.55822f //x=83 //y=0.18
r1082 (  464 466 ) resistor r=38.7139 //w=0.367 //l=1.11 //layer=li \
 //thickness=0.1 //x=81.89 //y=0.175 //x2=83 //y2=0.175
r1083 (  462 519 ) resistor r=2.87058 //w=0.35 //l=0.085 //layer=li \
 //thickness=0.1 //x=81.675 //y=0.175 //x2=81.59 //y2=0.175
r1084 (  462 464 ) resistor r=7.49864 //w=0.367 //l=0.215 //layer=li \
 //thickness=0.1 //x=81.675 //y=0.175 //x2=81.89 //y2=0.175
r1085 (  457 519 ) resistor r=4.23183 //w=0.7 //l=0.175 //layer=li \
 //thickness=0.1 //x=81.59 //y=0.35 //x2=81.59 //y2=0.175
r1086 (  457 540 ) resistor r=53.7326 //w=0.187 //l=0.785 //layer=li \
 //thickness=0.1 //x=81.59 //y=0.35 //x2=81.59 //y2=1.135
r1087 (  454 518 ) resistor r=5.29055 //w=0.35 //l=0.17 //layer=li \
 //thickness=0.1 //x=80.58 //y=0.175 //x2=80.41 //y2=0.175
r1088 (  454 456 ) resistor r=6.97548 //w=0.367 //l=0.2 //layer=li \
 //thickness=0.1 //x=80.58 //y=0.175 //x2=80.78 //y2=0.175
r1089 (  453 519 ) resistor r=2.87058 //w=0.35 //l=0.085 //layer=li \
 //thickness=0.1 //x=81.505 //y=0.175 //x2=81.59 //y2=0.175
r1090 (  453 456 ) resistor r=25.2861 //w=0.367 //l=0.725 //layer=li \
 //thickness=0.1 //x=81.505 //y=0.175 //x2=80.78 //y2=0.175
r1091 (  448 517 ) resistor r=2.87058 //w=0.35 //l=0.085 //layer=li \
 //thickness=0.1 //x=78.345 //y=0.175 //x2=78.26 //y2=0.175
r1092 (  448 450 ) resistor r=33.3079 //w=0.367 //l=0.955 //layer=li \
 //thickness=0.1 //x=78.345 //y=0.175 //x2=79.3 //y2=0.175
r1093 (  447 518 ) resistor r=5.29055 //w=0.35 //l=0.17 //layer=li \
 //thickness=0.1 //x=80.24 //y=0.175 //x2=80.41 //y2=0.175
r1094 (  447 450 ) resistor r=32.7847 //w=0.367 //l=0.94 //layer=li \
 //thickness=0.1 //x=80.24 //y=0.175 //x2=79.3 //y2=0.175
r1095 (  443 517 ) resistor r=4.23183 //w=0.7 //l=0.175 //layer=li \
 //thickness=0.1 //x=78.26 //y=0.35 //x2=78.26 //y2=0.175
r1096 (  443 539 ) resistor r=53.7326 //w=0.187 //l=0.785 //layer=li \
 //thickness=0.1 //x=78.26 //y=0.35 //x2=78.26 //y2=1.135
r1097 (  442 515 ) resistor r=5.29055 //w=0.35 //l=0.17 //layer=li \
 //thickness=0.1 //x=77.25 //y=0.175 //x2=77.08 //y2=0.175
r1098 (  441 517 ) resistor r=2.87058 //w=0.35 //l=0.085 //layer=li \
 //thickness=0.1 //x=78.175 //y=0.175 //x2=78.26 //y2=0.175
r1099 (  441 442 ) resistor r=32.2616 //w=0.367 //l=0.925 //layer=li \
 //thickness=0.1 //x=78.175 //y=0.175 //x2=77.25 //y2=0.175
r1100 (  436 438 ) resistor r=38.7139 //w=0.367 //l=1.11 //layer=li \
 //thickness=0.1 //x=75.6 //y=0.175 //x2=76.71 //y2=0.175
r1101 (  434 514 ) resistor r=2.87058 //w=0.35 //l=0.085 //layer=li \
 //thickness=0.1 //x=75.015 //y=0.175 //x2=74.93 //y2=0.175
r1102 (  434 436 ) resistor r=20.4033 //w=0.367 //l=0.585 //layer=li \
 //thickness=0.1 //x=75.015 //y=0.175 //x2=75.6 //y2=0.175
r1103 (  433 515 ) resistor r=5.29055 //w=0.35 //l=0.17 //layer=li \
 //thickness=0.1 //x=76.91 //y=0.175 //x2=77.08 //y2=0.175
r1104 (  433 438 ) resistor r=6.97548 //w=0.367 //l=0.2 //layer=li \
 //thickness=0.1 //x=76.91 //y=0.175 //x2=76.71 //y2=0.175
r1105 (  429 514 ) resistor r=4.23183 //w=0.7 //l=0.175 //layer=li \
 //thickness=0.1 //x=74.93 //y=0.35 //x2=74.93 //y2=0.175
r1106 (  429 538 ) resistor r=53.7326 //w=0.187 //l=0.785 //layer=li \
 //thickness=0.1 //x=74.93 //y=0.35 //x2=74.93 //y2=1.135
r1107 (  426 513 ) resistor r=5.29055 //w=0.35 //l=0.17 //layer=li \
 //thickness=0.1 //x=73.92 //y=0.175 //x2=73.75 //y2=0.175
r1108 (  426 428 ) resistor r=19.8801 //w=0.367 //l=0.57 //layer=li \
 //thickness=0.1 //x=73.92 //y=0.175 //x2=74.49 //y2=0.175
r1109 (  425 514 ) resistor r=2.87058 //w=0.35 //l=0.085 //layer=li \
 //thickness=0.1 //x=74.845 //y=0.175 //x2=74.93 //y2=0.175
r1110 (  425 428 ) resistor r=12.3815 //w=0.367 //l=0.355 //layer=li \
 //thickness=0.1 //x=74.845 //y=0.175 //x2=74.49 //y2=0.175
r1111 (  420 422 ) resistor r=38.7139 //w=0.367 //l=1.11 //layer=li \
 //thickness=0.1 //x=71.9 //y=0.175 //x2=73.01 //y2=0.175
r1112 (  418 420 ) resistor r=38.7139 //w=0.367 //l=1.11 //layer=li \
 //thickness=0.1 //x=70.79 //y=0.175 //x2=71.9 //y2=0.175
r1113 (  416 512 ) resistor r=2.87058 //w=0.35 //l=0.085 //layer=li \
 //thickness=0.1 //x=70.1 //y=0.175 //x2=70.015 //y2=0.175
r1114 (  416 418 ) resistor r=24.0654 //w=0.367 //l=0.69 //layer=li \
 //thickness=0.1 //x=70.1 //y=0.175 //x2=70.79 //y2=0.175
r1115 (  415 513 ) resistor r=5.29055 //w=0.35 //l=0.17 //layer=li \
 //thickness=0.1 //x=73.58 //y=0.175 //x2=73.75 //y2=0.175
r1116 (  415 422 ) resistor r=19.8801 //w=0.367 //l=0.57 //layer=li \
 //thickness=0.1 //x=73.58 //y=0.175 //x2=73.01 //y2=0.175
r1117 (  411 512 ) resistor r=4.23183 //w=0.7 //l=0.175 //layer=li \
 //thickness=0.1 //x=70.015 //y=0.35 //x2=70.015 //y2=0.175
r1118 (  411 537 ) resistor r=54.4171 //w=0.187 //l=0.795 //layer=li \
 //thickness=0.1 //x=70.015 //y=0.35 //x2=70.015 //y2=1.145
r1119 (  408 511 ) resistor r=5.29055 //w=0.35 //l=0.17 //layer=li \
 //thickness=0.1 //x=69.11 //y=0.175 //x2=68.94 //y2=0.175
r1120 (  408 410 ) resistor r=19.8801 //w=0.367 //l=0.57 //layer=li \
 //thickness=0.1 //x=69.11 //y=0.175 //x2=69.68 //y2=0.175
r1121 (  407 512 ) resistor r=2.87058 //w=0.35 //l=0.085 //layer=li \
 //thickness=0.1 //x=69.93 //y=0.175 //x2=70.015 //y2=0.175
r1122 (  407 410 ) resistor r=8.71935 //w=0.367 //l=0.25 //layer=li \
 //thickness=0.1 //x=69.93 //y=0.175 //x2=69.68 //y2=0.175
r1123 (  402 404 ) resistor r=38.7139 //w=0.367 //l=1.11 //layer=li \
 //thickness=0.1 //x=67.09 //y=0.175 //x2=68.2 //y2=0.175
r1124 (  400 510 ) resistor r=2.87058 //w=0.35 //l=0.085 //layer=li \
 //thickness=0.1 //x=66.875 //y=0.175 //x2=66.79 //y2=0.175
r1125 (  400 402 ) resistor r=7.49864 //w=0.367 //l=0.215 //layer=li \
 //thickness=0.1 //x=66.875 //y=0.175 //x2=67.09 //y2=0.175
r1126 (  399 511 ) resistor r=5.29055 //w=0.35 //l=0.17 //layer=li \
 //thickness=0.1 //x=68.77 //y=0.175 //x2=68.94 //y2=0.175
r1127 (  399 404 ) resistor r=19.8801 //w=0.367 //l=0.57 //layer=li \
 //thickness=0.1 //x=68.77 //y=0.175 //x2=68.2 //y2=0.175
r1128 (  395 510 ) resistor r=4.23183 //w=0.7 //l=0.175 //layer=li \
 //thickness=0.1 //x=66.79 //y=0.35 //x2=66.79 //y2=0.175
r1129 (  395 536 ) resistor r=53.7326 //w=0.187 //l=0.785 //layer=li \
 //thickness=0.1 //x=66.79 //y=0.35 //x2=66.79 //y2=1.135
r1130 (  392 509 ) resistor r=5.29055 //w=0.35 //l=0.17 //layer=li \
 //thickness=0.1 //x=65.78 //y=0.175 //x2=65.61 //y2=0.175
r1131 (  392 394 ) resistor r=6.97548 //w=0.367 //l=0.2 //layer=li \
 //thickness=0.1 //x=65.78 //y=0.175 //x2=65.98 //y2=0.175
r1132 (  391 510 ) resistor r=2.87058 //w=0.35 //l=0.085 //layer=li \
 //thickness=0.1 //x=66.705 //y=0.175 //x2=66.79 //y2=0.175
r1133 (  391 394 ) resistor r=25.2861 //w=0.367 //l=0.725 //layer=li \
 //thickness=0.1 //x=66.705 //y=0.175 //x2=65.98 //y2=0.175
r1134 (  386 508 ) resistor r=2.87058 //w=0.35 //l=0.085 //layer=li \
 //thickness=0.1 //x=63.545 //y=0.175 //x2=63.46 //y2=0.175
r1135 (  386 388 ) resistor r=33.3079 //w=0.367 //l=0.955 //layer=li \
 //thickness=0.1 //x=63.545 //y=0.175 //x2=64.5 //y2=0.175
r1136 (  385 509 ) resistor r=5.29055 //w=0.35 //l=0.17 //layer=li \
 //thickness=0.1 //x=65.44 //y=0.175 //x2=65.61 //y2=0.175
r1137 (  385 388 ) resistor r=32.7847 //w=0.367 //l=0.94 //layer=li \
 //thickness=0.1 //x=65.44 //y=0.175 //x2=64.5 //y2=0.175
r1138 (  381 508 ) resistor r=4.23183 //w=0.7 //l=0.175 //layer=li \
 //thickness=0.1 //x=63.46 //y=0.35 //x2=63.46 //y2=0.175
r1139 (  381 535 ) resistor r=53.7326 //w=0.187 //l=0.785 //layer=li \
 //thickness=0.1 //x=63.46 //y=0.35 //x2=63.46 //y2=1.135
r1140 (  380 506 ) resistor r=5.29055 //w=0.35 //l=0.17 //layer=li \
 //thickness=0.1 //x=62.45 //y=0.175 //x2=62.28 //y2=0.175
r1141 (  379 508 ) resistor r=2.87058 //w=0.35 //l=0.085 //layer=li \
 //thickness=0.1 //x=63.375 //y=0.175 //x2=63.46 //y2=0.175
r1142 (  379 380 ) resistor r=32.2616 //w=0.367 //l=0.925 //layer=li \
 //thickness=0.1 //x=63.375 //y=0.175 //x2=62.45 //y2=0.175
r1143 (  374 376 ) resistor r=38.7139 //w=0.367 //l=1.11 //layer=li \
 //thickness=0.1 //x=60.8 //y=0.175 //x2=61.91 //y2=0.175
r1144 (  372 374 ) resistor r=38.7139 //w=0.367 //l=1.11 //layer=li \
 //thickness=0.1 //x=59.69 //y=0.175 //x2=60.8 //y2=0.175
r1145 (  370 505 ) resistor r=2.87058 //w=0.35 //l=0.085 //layer=li \
 //thickness=0.1 //x=58.63 //y=0.175 //x2=58.545 //y2=0.175
r1146 (  370 372 ) resistor r=36.97 //w=0.367 //l=1.06 //layer=li \
 //thickness=0.1 //x=58.63 //y=0.175 //x2=59.69 //y2=0.175
r1147 (  369 506 ) resistor r=5.29055 //w=0.35 //l=0.17 //layer=li \
 //thickness=0.1 //x=62.11 //y=0.175 //x2=62.28 //y2=0.175
r1148 (  369 376 ) resistor r=6.97548 //w=0.367 //l=0.2 //layer=li \
 //thickness=0.1 //x=62.11 //y=0.175 //x2=61.91 //y2=0.175
r1149 (  365 505 ) resistor r=4.23183 //w=0.7 //l=0.175 //layer=li \
 //thickness=0.1 //x=58.545 //y=0.35 //x2=58.545 //y2=0.175
r1150 (  365 534 ) resistor r=54.4171 //w=0.187 //l=0.795 //layer=li \
 //thickness=0.1 //x=58.545 //y=0.35 //x2=58.545 //y2=1.145
r1151 (  364 503 ) resistor r=5.29055 //w=0.35 //l=0.17 //layer=li \
 //thickness=0.1 //x=57.64 //y=0.175 //x2=57.47 //y2=0.175
r1152 (  363 505 ) resistor r=2.87058 //w=0.35 //l=0.085 //layer=li \
 //thickness=0.1 //x=58.46 //y=0.175 //x2=58.545 //y2=0.175
r1153 (  363 364 ) resistor r=28.5995 //w=0.367 //l=0.82 //layer=li \
 //thickness=0.1 //x=58.46 //y=0.175 //x2=57.64 //y2=0.175
r1154 (  358 360 ) resistor r=38.7139 //w=0.367 //l=1.11 //layer=li \
 //thickness=0.1 //x=55.99 //y=0.175 //x2=57.1 //y2=0.175
r1155 (  356 358 ) resistor r=38.7139 //w=0.367 //l=1.11 //layer=li \
 //thickness=0.1 //x=54.88 //y=0.175 //x2=55.99 //y2=0.175
r1156 (  354 502 ) resistor r=2.87058 //w=0.35 //l=0.085 //layer=li \
 //thickness=0.1 //x=53.82 //y=0.175 //x2=53.735 //y2=0.175
r1157 (  354 356 ) resistor r=36.97 //w=0.367 //l=1.06 //layer=li \
 //thickness=0.1 //x=53.82 //y=0.175 //x2=54.88 //y2=0.175
r1158 (  353 503 ) resistor r=5.29055 //w=0.35 //l=0.17 //layer=li \
 //thickness=0.1 //x=57.3 //y=0.175 //x2=57.47 //y2=0.175
r1159 (  353 360 ) resistor r=6.97548 //w=0.367 //l=0.2 //layer=li \
 //thickness=0.1 //x=57.3 //y=0.175 //x2=57.1 //y2=0.175
r1160 (  349 502 ) resistor r=4.23183 //w=0.7 //l=0.175 //layer=li \
 //thickness=0.1 //x=53.735 //y=0.35 //x2=53.735 //y2=0.175
r1161 (  349 533 ) resistor r=54.4171 //w=0.187 //l=0.795 //layer=li \
 //thickness=0.1 //x=53.735 //y=0.35 //x2=53.735 //y2=1.145
r1162 (  348 500 ) resistor r=5.29055 //w=0.35 //l=0.17 //layer=li \
 //thickness=0.1 //x=52.83 //y=0.175 //x2=52.66 //y2=0.175
r1163 (  347 502 ) resistor r=2.87058 //w=0.35 //l=0.085 //layer=li \
 //thickness=0.1 //x=53.65 //y=0.175 //x2=53.735 //y2=0.175
r1164 (  347 348 ) resistor r=28.5995 //w=0.367 //l=0.82 //layer=li \
 //thickness=0.1 //x=53.65 //y=0.175 //x2=52.83 //y2=0.175
r1165 (  342 344 ) resistor r=38.7139 //w=0.367 //l=1.11 //layer=li \
 //thickness=0.1 //x=51.18 //y=0.175 //x2=52.29 //y2=0.175
r1166 (  340 499 ) resistor r=2.87058 //w=0.35 //l=0.085 //layer=li \
 //thickness=0.1 //x=50.595 //y=0.175 //x2=50.51 //y2=0.175
r1167 (  340 342 ) resistor r=20.4033 //w=0.367 //l=0.585 //layer=li \
 //thickness=0.1 //x=50.595 //y=0.175 //x2=51.18 //y2=0.175
r1168 (  339 500 ) resistor r=5.29055 //w=0.35 //l=0.17 //layer=li \
 //thickness=0.1 //x=52.49 //y=0.175 //x2=52.66 //y2=0.175
r1169 (  339 344 ) resistor r=6.97548 //w=0.367 //l=0.2 //layer=li \
 //thickness=0.1 //x=52.49 //y=0.175 //x2=52.29 //y2=0.175
r1170 (  335 499 ) resistor r=4.23183 //w=0.7 //l=0.175 //layer=li \
 //thickness=0.1 //x=50.51 //y=0.35 //x2=50.51 //y2=0.175
r1171 (  335 532 ) resistor r=53.7326 //w=0.187 //l=0.785 //layer=li \
 //thickness=0.1 //x=50.51 //y=0.35 //x2=50.51 //y2=1.135
r1172 (  332 498 ) resistor r=5.29055 //w=0.35 //l=0.17 //layer=li \
 //thickness=0.1 //x=49.5 //y=0.175 //x2=49.33 //y2=0.175
r1173 (  332 334 ) resistor r=19.8801 //w=0.367 //l=0.57 //layer=li \
 //thickness=0.1 //x=49.5 //y=0.175 //x2=50.07 //y2=0.175
r1174 (  331 499 ) resistor r=2.87058 //w=0.35 //l=0.085 //layer=li \
 //thickness=0.1 //x=50.425 //y=0.175 //x2=50.51 //y2=0.175
r1175 (  331 334 ) resistor r=12.3815 //w=0.367 //l=0.355 //layer=li \
 //thickness=0.1 //x=50.425 //y=0.175 //x2=50.07 //y2=0.175
r1176 (  326 328 ) resistor r=38.7139 //w=0.367 //l=1.11 //layer=li \
 //thickness=0.1 //x=47.48 //y=0.175 //x2=48.59 //y2=0.175
r1177 (  324 326 ) resistor r=38.7139 //w=0.367 //l=1.11 //layer=li \
 //thickness=0.1 //x=46.37 //y=0.175 //x2=47.48 //y2=0.175
r1178 (  322 497 ) resistor r=2.87058 //w=0.35 //l=0.085 //layer=li \
 //thickness=0.1 //x=45.68 //y=0.175 //x2=45.595 //y2=0.175
r1179 (  322 324 ) resistor r=24.0654 //w=0.367 //l=0.69 //layer=li \
 //thickness=0.1 //x=45.68 //y=0.175 //x2=46.37 //y2=0.175
r1180 (  321 498 ) resistor r=5.29055 //w=0.35 //l=0.17 //layer=li \
 //thickness=0.1 //x=49.16 //y=0.175 //x2=49.33 //y2=0.175
r1181 (  321 328 ) resistor r=19.8801 //w=0.367 //l=0.57 //layer=li \
 //thickness=0.1 //x=49.16 //y=0.175 //x2=48.59 //y2=0.175
r1182 (  317 497 ) resistor r=4.23183 //w=0.7 //l=0.175 //layer=li \
 //thickness=0.1 //x=45.595 //y=0.35 //x2=45.595 //y2=0.175
r1183 (  317 531 ) resistor r=54.4171 //w=0.187 //l=0.795 //layer=li \
 //thickness=0.1 //x=45.595 //y=0.35 //x2=45.595 //y2=1.145
r1184 (  314 496 ) resistor r=5.29055 //w=0.35 //l=0.17 //layer=li \
 //thickness=0.1 //x=44.69 //y=0.175 //x2=44.52 //y2=0.175
r1185 (  314 316 ) resistor r=19.8801 //w=0.367 //l=0.57 //layer=li \
 //thickness=0.1 //x=44.69 //y=0.175 //x2=45.26 //y2=0.175
r1186 (  313 497 ) resistor r=2.87058 //w=0.35 //l=0.085 //layer=li \
 //thickness=0.1 //x=45.51 //y=0.175 //x2=45.595 //y2=0.175
r1187 (  313 316 ) resistor r=8.71935 //w=0.367 //l=0.25 //layer=li \
 //thickness=0.1 //x=45.51 //y=0.175 //x2=45.26 //y2=0.175
r1188 (  308 310 ) resistor r=38.7139 //w=0.367 //l=1.11 //layer=li \
 //thickness=0.1 //x=42.67 //y=0.175 //x2=43.78 //y2=0.175
r1189 (  306 495 ) resistor r=2.87058 //w=0.35 //l=0.085 //layer=li \
 //thickness=0.1 //x=42.455 //y=0.175 //x2=42.37 //y2=0.175
r1190 (  306 308 ) resistor r=7.49864 //w=0.367 //l=0.215 //layer=li \
 //thickness=0.1 //x=42.455 //y=0.175 //x2=42.67 //y2=0.175
r1191 (  305 496 ) resistor r=5.29055 //w=0.35 //l=0.17 //layer=li \
 //thickness=0.1 //x=44.35 //y=0.175 //x2=44.52 //y2=0.175
r1192 (  305 310 ) resistor r=19.8801 //w=0.367 //l=0.57 //layer=li \
 //thickness=0.1 //x=44.35 //y=0.175 //x2=43.78 //y2=0.175
r1193 (  301 495 ) resistor r=4.23183 //w=0.7 //l=0.175 //layer=li \
 //thickness=0.1 //x=42.37 //y=0.35 //x2=42.37 //y2=0.175
r1194 (  301 530 ) resistor r=53.7326 //w=0.187 //l=0.785 //layer=li \
 //thickness=0.1 //x=42.37 //y=0.35 //x2=42.37 //y2=1.135
r1195 (  298 494 ) resistor r=5.29055 //w=0.35 //l=0.17 //layer=li \
 //thickness=0.1 //x=41.36 //y=0.175 //x2=41.19 //y2=0.175
r1196 (  298 300 ) resistor r=6.97548 //w=0.367 //l=0.2 //layer=li \
 //thickness=0.1 //x=41.36 //y=0.175 //x2=41.56 //y2=0.175
r1197 (  297 495 ) resistor r=2.87058 //w=0.35 //l=0.085 //layer=li \
 //thickness=0.1 //x=42.285 //y=0.175 //x2=42.37 //y2=0.175
r1198 (  297 300 ) resistor r=25.2861 //w=0.367 //l=0.725 //layer=li \
 //thickness=0.1 //x=42.285 //y=0.175 //x2=41.56 //y2=0.175
r1199 (  292 493 ) resistor r=2.87058 //w=0.35 //l=0.085 //layer=li \
 //thickness=0.1 //x=39.125 //y=0.175 //x2=39.04 //y2=0.175
r1200 (  292 294 ) resistor r=33.3079 //w=0.367 //l=0.955 //layer=li \
 //thickness=0.1 //x=39.125 //y=0.175 //x2=40.08 //y2=0.175
r1201 (  291 494 ) resistor r=5.29055 //w=0.35 //l=0.17 //layer=li \
 //thickness=0.1 //x=41.02 //y=0.175 //x2=41.19 //y2=0.175
r1202 (  291 294 ) resistor r=32.7847 //w=0.367 //l=0.94 //layer=li \
 //thickness=0.1 //x=41.02 //y=0.175 //x2=40.08 //y2=0.175
r1203 (  287 493 ) resistor r=4.23183 //w=0.7 //l=0.175 //layer=li \
 //thickness=0.1 //x=39.04 //y=0.35 //x2=39.04 //y2=0.175
r1204 (  287 529 ) resistor r=53.7326 //w=0.187 //l=0.785 //layer=li \
 //thickness=0.1 //x=39.04 //y=0.35 //x2=39.04 //y2=1.135
r1205 (  286 491 ) resistor r=5.29055 //w=0.35 //l=0.17 //layer=li \
 //thickness=0.1 //x=38.03 //y=0.175 //x2=37.86 //y2=0.175
r1206 (  285 493 ) resistor r=2.87058 //w=0.35 //l=0.085 //layer=li \
 //thickness=0.1 //x=38.955 //y=0.175 //x2=39.04 //y2=0.175
r1207 (  285 286 ) resistor r=32.2616 //w=0.367 //l=0.925 //layer=li \
 //thickness=0.1 //x=38.955 //y=0.175 //x2=38.03 //y2=0.175
r1208 (  280 282 ) resistor r=38.7139 //w=0.367 //l=1.11 //layer=li \
 //thickness=0.1 //x=36.38 //y=0.175 //x2=37.49 //y2=0.175
r1209 (  278 280 ) resistor r=38.7139 //w=0.367 //l=1.11 //layer=li \
 //thickness=0.1 //x=35.27 //y=0.175 //x2=36.38 //y2=0.175
r1210 (  276 490 ) resistor r=2.87058 //w=0.35 //l=0.085 //layer=li \
 //thickness=0.1 //x=34.21 //y=0.175 //x2=34.125 //y2=0.175
r1211 (  276 278 ) resistor r=36.97 //w=0.367 //l=1.06 //layer=li \
 //thickness=0.1 //x=34.21 //y=0.175 //x2=35.27 //y2=0.175
r1212 (  275 491 ) resistor r=5.29055 //w=0.35 //l=0.17 //layer=li \
 //thickness=0.1 //x=37.69 //y=0.175 //x2=37.86 //y2=0.175
r1213 (  275 282 ) resistor r=6.97548 //w=0.367 //l=0.2 //layer=li \
 //thickness=0.1 //x=37.69 //y=0.175 //x2=37.49 //y2=0.175
r1214 (  271 490 ) resistor r=4.23183 //w=0.7 //l=0.175 //layer=li \
 //thickness=0.1 //x=34.125 //y=0.35 //x2=34.125 //y2=0.175
r1215 (  271 528 ) resistor r=54.4171 //w=0.187 //l=0.795 //layer=li \
 //thickness=0.1 //x=34.125 //y=0.35 //x2=34.125 //y2=1.145
r1216 (  270 488 ) resistor r=5.29055 //w=0.35 //l=0.17 //layer=li \
 //thickness=0.1 //x=33.22 //y=0.175 //x2=33.05 //y2=0.175
r1217 (  269 490 ) resistor r=2.87058 //w=0.35 //l=0.085 //layer=li \
 //thickness=0.1 //x=34.04 //y=0.175 //x2=34.125 //y2=0.175
r1218 (  269 270 ) resistor r=28.5995 //w=0.367 //l=0.82 //layer=li \
 //thickness=0.1 //x=34.04 //y=0.175 //x2=33.22 //y2=0.175
r1219 (  264 266 ) resistor r=38.7139 //w=0.367 //l=1.11 //layer=li \
 //thickness=0.1 //x=31.57 //y=0.175 //x2=32.68 //y2=0.175
r1220 (  262 264 ) resistor r=38.7139 //w=0.367 //l=1.11 //layer=li \
 //thickness=0.1 //x=30.46 //y=0.175 //x2=31.57 //y2=0.175
r1221 (  260 487 ) resistor r=2.87058 //w=0.35 //l=0.085 //layer=li \
 //thickness=0.1 //x=29.4 //y=0.175 //x2=29.315 //y2=0.175
r1222 (  260 262 ) resistor r=36.97 //w=0.367 //l=1.06 //layer=li \
 //thickness=0.1 //x=29.4 //y=0.175 //x2=30.46 //y2=0.175
r1223 (  259 488 ) resistor r=5.29055 //w=0.35 //l=0.17 //layer=li \
 //thickness=0.1 //x=32.88 //y=0.175 //x2=33.05 //y2=0.175
r1224 (  259 266 ) resistor r=6.97548 //w=0.367 //l=0.2 //layer=li \
 //thickness=0.1 //x=32.88 //y=0.175 //x2=32.68 //y2=0.175
r1225 (  255 487 ) resistor r=4.23183 //w=0.7 //l=0.175 //layer=li \
 //thickness=0.1 //x=29.315 //y=0.35 //x2=29.315 //y2=0.175
r1226 (  255 527 ) resistor r=54.4171 //w=0.187 //l=0.795 //layer=li \
 //thickness=0.1 //x=29.315 //y=0.35 //x2=29.315 //y2=1.145
r1227 (  254 485 ) resistor r=5.29055 //w=0.35 //l=0.17 //layer=li \
 //thickness=0.1 //x=28.41 //y=0.175 //x2=28.24 //y2=0.175
r1228 (  253 487 ) resistor r=2.87058 //w=0.35 //l=0.085 //layer=li \
 //thickness=0.1 //x=29.23 //y=0.175 //x2=29.315 //y2=0.175
r1229 (  253 254 ) resistor r=28.5995 //w=0.367 //l=0.82 //layer=li \
 //thickness=0.1 //x=29.23 //y=0.175 //x2=28.41 //y2=0.175
r1230 (  248 250 ) resistor r=38.7139 //w=0.367 //l=1.11 //layer=li \
 //thickness=0.1 //x=26.76 //y=0.175 //x2=27.87 //y2=0.175
r1231 (  246 484 ) resistor r=2.87058 //w=0.35 //l=0.085 //layer=li \
 //thickness=0.1 //x=26.175 //y=0.175 //x2=26.09 //y2=0.175
r1232 (  246 248 ) resistor r=20.4033 //w=0.367 //l=0.585 //layer=li \
 //thickness=0.1 //x=26.175 //y=0.175 //x2=26.76 //y2=0.175
r1233 (  245 485 ) resistor r=5.29055 //w=0.35 //l=0.17 //layer=li \
 //thickness=0.1 //x=28.07 //y=0.175 //x2=28.24 //y2=0.175
r1234 (  245 250 ) resistor r=6.97548 //w=0.367 //l=0.2 //layer=li \
 //thickness=0.1 //x=28.07 //y=0.175 //x2=27.87 //y2=0.175
r1235 (  241 484 ) resistor r=4.23183 //w=0.7 //l=0.175 //layer=li \
 //thickness=0.1 //x=26.09 //y=0.35 //x2=26.09 //y2=0.175
r1236 (  241 526 ) resistor r=53.7326 //w=0.187 //l=0.785 //layer=li \
 //thickness=0.1 //x=26.09 //y=0.35 //x2=26.09 //y2=1.135
r1237 (  238 483 ) resistor r=5.29055 //w=0.35 //l=0.17 //layer=li \
 //thickness=0.1 //x=25.08 //y=0.175 //x2=24.91 //y2=0.175
r1238 (  238 240 ) resistor r=19.8801 //w=0.367 //l=0.57 //layer=li \
 //thickness=0.1 //x=25.08 //y=0.175 //x2=25.65 //y2=0.175
r1239 (  237 484 ) resistor r=2.87058 //w=0.35 //l=0.085 //layer=li \
 //thickness=0.1 //x=26.005 //y=0.175 //x2=26.09 //y2=0.175
r1240 (  237 240 ) resistor r=12.3815 //w=0.367 //l=0.355 //layer=li \
 //thickness=0.1 //x=26.005 //y=0.175 //x2=25.65 //y2=0.175
r1241 (  232 234 ) resistor r=38.7139 //w=0.367 //l=1.11 //layer=li \
 //thickness=0.1 //x=23.06 //y=0.175 //x2=24.17 //y2=0.175
r1242 (  230 232 ) resistor r=38.7139 //w=0.367 //l=1.11 //layer=li \
 //thickness=0.1 //x=21.95 //y=0.175 //x2=23.06 //y2=0.175
r1243 (  228 482 ) resistor r=2.87058 //w=0.35 //l=0.085 //layer=li \
 //thickness=0.1 //x=21.26 //y=0.175 //x2=21.175 //y2=0.175
r1244 (  228 230 ) resistor r=24.0654 //w=0.367 //l=0.69 //layer=li \
 //thickness=0.1 //x=21.26 //y=0.175 //x2=21.95 //y2=0.175
r1245 (  227 483 ) resistor r=5.29055 //w=0.35 //l=0.17 //layer=li \
 //thickness=0.1 //x=24.74 //y=0.175 //x2=24.91 //y2=0.175
r1246 (  227 234 ) resistor r=19.8801 //w=0.367 //l=0.57 //layer=li \
 //thickness=0.1 //x=24.74 //y=0.175 //x2=24.17 //y2=0.175
r1247 (  223 482 ) resistor r=4.23183 //w=0.7 //l=0.175 //layer=li \
 //thickness=0.1 //x=21.175 //y=0.35 //x2=21.175 //y2=0.175
r1248 (  223 525 ) resistor r=54.4171 //w=0.187 //l=0.795 //layer=li \
 //thickness=0.1 //x=21.175 //y=0.35 //x2=21.175 //y2=1.145
r1249 (  220 481 ) resistor r=5.29055 //w=0.35 //l=0.17 //layer=li \
 //thickness=0.1 //x=20.27 //y=0.175 //x2=20.1 //y2=0.175
r1250 (  220 222 ) resistor r=19.8801 //w=0.367 //l=0.57 //layer=li \
 //thickness=0.1 //x=20.27 //y=0.175 //x2=20.84 //y2=0.175
r1251 (  219 482 ) resistor r=2.87058 //w=0.35 //l=0.085 //layer=li \
 //thickness=0.1 //x=21.09 //y=0.175 //x2=21.175 //y2=0.175
r1252 (  219 222 ) resistor r=8.71935 //w=0.367 //l=0.25 //layer=li \
 //thickness=0.1 //x=21.09 //y=0.175 //x2=20.84 //y2=0.175
r1253 (  214 216 ) resistor r=38.7139 //w=0.367 //l=1.11 //layer=li \
 //thickness=0.1 //x=18.25 //y=0.175 //x2=19.36 //y2=0.175
r1254 (  212 480 ) resistor r=2.87058 //w=0.35 //l=0.085 //layer=li \
 //thickness=0.1 //x=18.035 //y=0.175 //x2=17.95 //y2=0.175
r1255 (  212 214 ) resistor r=7.49864 //w=0.367 //l=0.215 //layer=li \
 //thickness=0.1 //x=18.035 //y=0.175 //x2=18.25 //y2=0.175
r1256 (  211 481 ) resistor r=5.29055 //w=0.35 //l=0.17 //layer=li \
 //thickness=0.1 //x=19.93 //y=0.175 //x2=20.1 //y2=0.175
r1257 (  211 216 ) resistor r=19.8801 //w=0.367 //l=0.57 //layer=li \
 //thickness=0.1 //x=19.93 //y=0.175 //x2=19.36 //y2=0.175
r1258 (  207 480 ) resistor r=4.23183 //w=0.7 //l=0.175 //layer=li \
 //thickness=0.1 //x=17.95 //y=0.35 //x2=17.95 //y2=0.175
r1259 (  207 524 ) resistor r=53.7326 //w=0.187 //l=0.785 //layer=li \
 //thickness=0.1 //x=17.95 //y=0.35 //x2=17.95 //y2=1.135
r1260 (  204 479 ) resistor r=5.29055 //w=0.35 //l=0.17 //layer=li \
 //thickness=0.1 //x=16.94 //y=0.175 //x2=16.77 //y2=0.175
r1261 (  204 206 ) resistor r=6.97548 //w=0.367 //l=0.2 //layer=li \
 //thickness=0.1 //x=16.94 //y=0.175 //x2=17.14 //y2=0.175
r1262 (  203 480 ) resistor r=2.87058 //w=0.35 //l=0.085 //layer=li \
 //thickness=0.1 //x=17.865 //y=0.175 //x2=17.95 //y2=0.175
r1263 (  203 206 ) resistor r=25.2861 //w=0.367 //l=0.725 //layer=li \
 //thickness=0.1 //x=17.865 //y=0.175 //x2=17.14 //y2=0.175
r1264 (  198 478 ) resistor r=2.87058 //w=0.35 //l=0.085 //layer=li \
 //thickness=0.1 //x=14.705 //y=0.175 //x2=14.62 //y2=0.175
r1265 (  198 200 ) resistor r=33.3079 //w=0.367 //l=0.955 //layer=li \
 //thickness=0.1 //x=14.705 //y=0.175 //x2=15.66 //y2=0.175
r1266 (  197 479 ) resistor r=5.29055 //w=0.35 //l=0.17 //layer=li \
 //thickness=0.1 //x=16.6 //y=0.175 //x2=16.77 //y2=0.175
r1267 (  197 200 ) resistor r=32.7847 //w=0.367 //l=0.94 //layer=li \
 //thickness=0.1 //x=16.6 //y=0.175 //x2=15.66 //y2=0.175
r1268 (  193 478 ) resistor r=4.23183 //w=0.7 //l=0.175 //layer=li \
 //thickness=0.1 //x=14.62 //y=0.35 //x2=14.62 //y2=0.175
r1269 (  193 523 ) resistor r=53.7326 //w=0.187 //l=0.785 //layer=li \
 //thickness=0.1 //x=14.62 //y=0.35 //x2=14.62 //y2=1.135
r1270 (  192 476 ) resistor r=5.29055 //w=0.35 //l=0.17 //layer=li \
 //thickness=0.1 //x=13.61 //y=0.175 //x2=13.44 //y2=0.175
r1271 (  191 478 ) resistor r=2.87058 //w=0.35 //l=0.085 //layer=li \
 //thickness=0.1 //x=14.535 //y=0.175 //x2=14.62 //y2=0.175
r1272 (  191 192 ) resistor r=32.2616 //w=0.367 //l=0.925 //layer=li \
 //thickness=0.1 //x=14.535 //y=0.175 //x2=13.61 //y2=0.175
r1273 (  186 188 ) resistor r=38.7139 //w=0.367 //l=1.11 //layer=li \
 //thickness=0.1 //x=11.96 //y=0.175 //x2=13.07 //y2=0.175
r1274 (  184 186 ) resistor r=38.7139 //w=0.367 //l=1.11 //layer=li \
 //thickness=0.1 //x=10.85 //y=0.175 //x2=11.96 //y2=0.175
r1275 (  182 475 ) resistor r=2.87058 //w=0.35 //l=0.085 //layer=li \
 //thickness=0.1 //x=9.79 //y=0.175 //x2=9.705 //y2=0.175
r1276 (  182 184 ) resistor r=36.97 //w=0.367 //l=1.06 //layer=li \
 //thickness=0.1 //x=9.79 //y=0.175 //x2=10.85 //y2=0.175
r1277 (  181 476 ) resistor r=5.29055 //w=0.35 //l=0.17 //layer=li \
 //thickness=0.1 //x=13.27 //y=0.175 //x2=13.44 //y2=0.175
r1278 (  181 188 ) resistor r=6.97548 //w=0.367 //l=0.2 //layer=li \
 //thickness=0.1 //x=13.27 //y=0.175 //x2=13.07 //y2=0.175
r1279 (  177 475 ) resistor r=4.23183 //w=0.7 //l=0.175 //layer=li \
 //thickness=0.1 //x=9.705 //y=0.35 //x2=9.705 //y2=0.175
r1280 (  177 522 ) resistor r=54.4171 //w=0.187 //l=0.795 //layer=li \
 //thickness=0.1 //x=9.705 //y=0.35 //x2=9.705 //y2=1.145
r1281 (  176 473 ) resistor r=5.29055 //w=0.35 //l=0.17 //layer=li \
 //thickness=0.1 //x=8.8 //y=0.175 //x2=8.63 //y2=0.175
r1282 (  175 475 ) resistor r=2.87058 //w=0.35 //l=0.085 //layer=li \
 //thickness=0.1 //x=9.62 //y=0.175 //x2=9.705 //y2=0.175
r1283 (  175 176 ) resistor r=28.5995 //w=0.367 //l=0.82 //layer=li \
 //thickness=0.1 //x=9.62 //y=0.175 //x2=8.8 //y2=0.175
r1284 (  170 172 ) resistor r=38.7139 //w=0.367 //l=1.11 //layer=li \
 //thickness=0.1 //x=7.15 //y=0.175 //x2=8.26 //y2=0.175
r1285 (  168 170 ) resistor r=38.7139 //w=0.367 //l=1.11 //layer=li \
 //thickness=0.1 //x=6.04 //y=0.175 //x2=7.15 //y2=0.175
r1286 (  166 472 ) resistor r=2.87058 //w=0.35 //l=0.085 //layer=li \
 //thickness=0.1 //x=4.98 //y=0.175 //x2=4.895 //y2=0.175
r1287 (  166 168 ) resistor r=36.97 //w=0.367 //l=1.06 //layer=li \
 //thickness=0.1 //x=4.98 //y=0.175 //x2=6.04 //y2=0.175
r1288 (  165 473 ) resistor r=5.29055 //w=0.35 //l=0.17 //layer=li \
 //thickness=0.1 //x=8.46 //y=0.175 //x2=8.63 //y2=0.175
r1289 (  165 172 ) resistor r=6.97548 //w=0.367 //l=0.2 //layer=li \
 //thickness=0.1 //x=8.46 //y=0.175 //x2=8.26 //y2=0.175
r1290 (  161 472 ) resistor r=4.23183 //w=0.7 //l=0.175 //layer=li \
 //thickness=0.1 //x=4.895 //y=0.35 //x2=4.895 //y2=0.175
r1291 (  161 521 ) resistor r=54.4171 //w=0.187 //l=0.795 //layer=li \
 //thickness=0.1 //x=4.895 //y=0.35 //x2=4.895 //y2=1.145
r1292 (  160 470 ) resistor r=5.29055 //w=0.35 //l=0.17 //layer=li \
 //thickness=0.1 //x=3.99 //y=0.175 //x2=3.82 //y2=0.175
r1293 (  159 472 ) resistor r=2.87058 //w=0.35 //l=0.085 //layer=li \
 //thickness=0.1 //x=4.81 //y=0.175 //x2=4.895 //y2=0.175
r1294 (  159 160 ) resistor r=28.5995 //w=0.367 //l=0.82 //layer=li \
 //thickness=0.1 //x=4.81 //y=0.175 //x2=3.99 //y2=0.175
r1295 (  154 156 ) resistor r=38.7139 //w=0.367 //l=1.11 //layer=li \
 //thickness=0.1 //x=2.34 //y=0.175 //x2=3.45 //y2=0.175
r1296 (  152 469 ) resistor r=2.87058 //w=0.35 //l=0.085 //layer=li \
 //thickness=0.1 //x=1.755 //y=0.175 //x2=1.67 //y2=0.175
r1297 (  152 154 ) resistor r=20.4033 //w=0.367 //l=0.585 //layer=li \
 //thickness=0.1 //x=1.755 //y=0.175 //x2=2.34 //y2=0.175
r1298 (  151 470 ) resistor r=5.29055 //w=0.35 //l=0.17 //layer=li \
 //thickness=0.1 //x=3.65 //y=0.175 //x2=3.82 //y2=0.175
r1299 (  151 156 ) resistor r=6.97548 //w=0.367 //l=0.2 //layer=li \
 //thickness=0.1 //x=3.65 //y=0.175 //x2=3.45 //y2=0.175
r1300 (  147 469 ) resistor r=4.23183 //w=0.7 //l=0.175 //layer=li \
 //thickness=0.1 //x=1.67 //y=0.35 //x2=1.67 //y2=0.175
r1301 (  147 520 ) resistor r=53.7326 //w=0.187 //l=0.785 //layer=li \
 //thickness=0.1 //x=1.67 //y=0.35 //x2=1.67 //y2=1.135
r1302 (  143 469 ) resistor r=2.87058 //w=0.35 //l=0.085 //layer=li \
 //thickness=0.1 //x=1.585 //y=0.175 //x2=1.67 //y2=0.175
r1303 (  143 146 ) resistor r=12.3815 //w=0.367 //l=0.355 //layer=li \
 //thickness=0.1 //x=1.585 //y=0.175 //x2=1.23 //y2=0.175
r1304 (  139 466 ) resistor r=3.1 //w=0.17 //l=0.51 //layer=mcon //count=3 \
 //x=83 //y=0.18 //x2=83 //y2=0.18
r1305 (  137 464 ) resistor r=3.1 //w=0.17 //l=0.51 //layer=mcon //count=3 \
 //x=81.89 //y=0.18 //x2=81.89 //y2=0.18
r1306 (  137 139 ) resistor r=0.446141 //w=0.311 //l=1.11 //layer=m1 \
 //thickness=0.36 //x=81.89 //y=0.175 //x2=83 //y2=0.175
r1307 (  135 456 ) resistor r=3.1 //w=0.17 //l=0.51 //layer=mcon //count=3 \
 //x=80.78 //y=0.18 //x2=80.78 //y2=0.18
r1308 (  135 137 ) resistor r=0.446141 //w=0.311 //l=1.11 //layer=m1 \
 //thickness=0.36 //x=80.78 //y=0.175 //x2=81.89 //y2=0.175
r1309 (  133 450 ) resistor r=3.1 //w=0.17 //l=0.51 //layer=mcon //count=3 \
 //x=79.3 //y=0.18 //x2=79.3 //y2=0.18
r1310 (  133 135 ) resistor r=0.594855 //w=0.311 //l=1.48 //layer=m1 \
 //thickness=0.36 //x=79.3 //y=0.175 //x2=80.78 //y2=0.175
r1311 (  131 517 ) resistor r=3.1 //w=0.17 //l=0.51 //layer=mcon //count=3 \
 //x=78.19 //y=0.18 //x2=78.19 //y2=0.18
r1312 (  131 133 ) resistor r=0.446141 //w=0.311 //l=1.11 //layer=m1 \
 //thickness=0.36 //x=78.19 //y=0.175 //x2=79.3 //y2=0.175
r1313 (  129 438 ) resistor r=3.1 //w=0.17 //l=0.51 //layer=mcon //count=3 \
 //x=76.71 //y=0.18 //x2=76.71 //y2=0.18
r1314 (  129 131 ) resistor r=0.594855 //w=0.311 //l=1.48 //layer=m1 \
 //thickness=0.36 //x=76.71 //y=0.175 //x2=78.19 //y2=0.175
r1315 (  127 436 ) resistor r=3.1 //w=0.17 //l=0.51 //layer=mcon //count=3 \
 //x=75.6 //y=0.18 //x2=75.6 //y2=0.18
r1316 (  127 129 ) resistor r=0.446141 //w=0.311 //l=1.11 //layer=m1 \
 //thickness=0.36 //x=75.6 //y=0.175 //x2=76.71 //y2=0.175
r1317 (  125 428 ) resistor r=3.1 //w=0.17 //l=0.51 //layer=mcon //count=3 \
 //x=74.49 //y=0.18 //x2=74.49 //y2=0.18
r1318 (  125 127 ) resistor r=0.446141 //w=0.311 //l=1.11 //layer=m1 \
 //thickness=0.36 //x=74.49 //y=0.175 //x2=75.6 //y2=0.175
r1319 (  123 422 ) resistor r=3.1 //w=0.17 //l=0.51 //layer=mcon //count=3 \
 //x=73.01 //y=0.18 //x2=73.01 //y2=0.18
r1320 (  123 125 ) resistor r=0.594855 //w=0.311 //l=1.48 //layer=m1 \
 //thickness=0.36 //x=73.01 //y=0.175 //x2=74.49 //y2=0.175
r1321 (  121 420 ) resistor r=3.1 //w=0.17 //l=0.51 //layer=mcon //count=3 \
 //x=71.9 //y=0.18 //x2=71.9 //y2=0.18
r1322 (  121 123 ) resistor r=0.446141 //w=0.311 //l=1.11 //layer=m1 \
 //thickness=0.36 //x=71.9 //y=0.175 //x2=73.01 //y2=0.175
r1323 (  119 418 ) resistor r=3.1 //w=0.17 //l=0.51 //layer=mcon //count=3 \
 //x=70.79 //y=0.18 //x2=70.79 //y2=0.18
r1324 (  119 121 ) resistor r=0.446141 //w=0.311 //l=1.11 //layer=m1 \
 //thickness=0.36 //x=70.79 //y=0.175 //x2=71.9 //y2=0.175
r1325 (  117 410 ) resistor r=3.1 //w=0.17 //l=0.51 //layer=mcon //count=3 \
 //x=69.68 //y=0.18 //x2=69.68 //y2=0.18
r1326 (  117 119 ) resistor r=0.446141 //w=0.311 //l=1.11 //layer=m1 \
 //thickness=0.36 //x=69.68 //y=0.175 //x2=70.79 //y2=0.175
r1327 (  115 404 ) resistor r=3.1 //w=0.17 //l=0.51 //layer=mcon //count=3 \
 //x=68.2 //y=0.18 //x2=68.2 //y2=0.18
r1328 (  115 117 ) resistor r=0.594855 //w=0.311 //l=1.48 //layer=m1 \
 //thickness=0.36 //x=68.2 //y=0.175 //x2=69.68 //y2=0.175
r1329 (  113 402 ) resistor r=3.1 //w=0.17 //l=0.51 //layer=mcon //count=3 \
 //x=67.09 //y=0.18 //x2=67.09 //y2=0.18
r1330 (  113 115 ) resistor r=0.446141 //w=0.311 //l=1.11 //layer=m1 \
 //thickness=0.36 //x=67.09 //y=0.175 //x2=68.2 //y2=0.175
r1331 (  111 394 ) resistor r=3.1 //w=0.17 //l=0.51 //layer=mcon //count=3 \
 //x=65.98 //y=0.18 //x2=65.98 //y2=0.18
r1332 (  111 113 ) resistor r=0.446141 //w=0.311 //l=1.11 //layer=m1 \
 //thickness=0.36 //x=65.98 //y=0.175 //x2=67.09 //y2=0.175
r1333 (  109 388 ) resistor r=3.1 //w=0.17 //l=0.51 //layer=mcon //count=3 \
 //x=64.5 //y=0.18 //x2=64.5 //y2=0.18
r1334 (  109 111 ) resistor r=0.594855 //w=0.311 //l=1.48 //layer=m1 \
 //thickness=0.36 //x=64.5 //y=0.175 //x2=65.98 //y2=0.175
r1335 (  107 508 ) resistor r=3.1 //w=0.17 //l=0.51 //layer=mcon //count=3 \
 //x=63.39 //y=0.18 //x2=63.39 //y2=0.18
r1336 (  107 109 ) resistor r=0.446141 //w=0.311 //l=1.11 //layer=m1 \
 //thickness=0.36 //x=63.39 //y=0.175 //x2=64.5 //y2=0.175
r1337 (  105 376 ) resistor r=3.1 //w=0.17 //l=0.51 //layer=mcon //count=3 \
 //x=61.91 //y=0.18 //x2=61.91 //y2=0.18
r1338 (  105 107 ) resistor r=0.594855 //w=0.311 //l=1.48 //layer=m1 \
 //thickness=0.36 //x=61.91 //y=0.175 //x2=63.39 //y2=0.175
r1339 (  103 374 ) resistor r=3.1 //w=0.17 //l=0.51 //layer=mcon //count=3 \
 //x=60.8 //y=0.18 //x2=60.8 //y2=0.18
r1340 (  103 105 ) resistor r=0.446141 //w=0.311 //l=1.11 //layer=m1 \
 //thickness=0.36 //x=60.8 //y=0.175 //x2=61.91 //y2=0.175
r1341 (  101 372 ) resistor r=3.1 //w=0.17 //l=0.51 //layer=mcon //count=3 \
 //x=59.69 //y=0.18 //x2=59.69 //y2=0.18
r1342 (  101 103 ) resistor r=0.446141 //w=0.311 //l=1.11 //layer=m1 \
 //thickness=0.36 //x=59.69 //y=0.175 //x2=60.8 //y2=0.175
r1343 (  99 505 ) resistor r=3.1 //w=0.17 //l=0.51 //layer=mcon //count=3 \
 //x=58.58 //y=0.18 //x2=58.58 //y2=0.18
r1344 (  99 101 ) resistor r=0.446141 //w=0.311 //l=1.11 //layer=m1 \
 //thickness=0.36 //x=58.58 //y=0.175 //x2=59.69 //y2=0.175
r1345 (  97 360 ) resistor r=3.1 //w=0.17 //l=0.51 //layer=mcon //count=3 \
 //x=57.1 //y=0.18 //x2=57.1 //y2=0.18
r1346 (  97 99 ) resistor r=0.594855 //w=0.311 //l=1.48 //layer=m1 \
 //thickness=0.36 //x=57.1 //y=0.175 //x2=58.58 //y2=0.175
r1347 (  95 358 ) resistor r=3.1 //w=0.17 //l=0.51 //layer=mcon //count=3 \
 //x=55.99 //y=0.18 //x2=55.99 //y2=0.18
r1348 (  95 97 ) resistor r=0.446141 //w=0.311 //l=1.11 //layer=m1 \
 //thickness=0.36 //x=55.99 //y=0.175 //x2=57.1 //y2=0.175
r1349 (  93 356 ) resistor r=3.1 //w=0.17 //l=0.51 //layer=mcon //count=3 \
 //x=54.88 //y=0.18 //x2=54.88 //y2=0.18
r1350 (  93 95 ) resistor r=0.446141 //w=0.311 //l=1.11 //layer=m1 \
 //thickness=0.36 //x=54.88 //y=0.175 //x2=55.99 //y2=0.175
r1351 (  91 502 ) resistor r=3.1 //w=0.17 //l=0.51 //layer=mcon //count=3 \
 //x=53.77 //y=0.18 //x2=53.77 //y2=0.18
r1352 (  91 93 ) resistor r=0.446141 //w=0.311 //l=1.11 //layer=m1 \
 //thickness=0.36 //x=53.77 //y=0.175 //x2=54.88 //y2=0.175
r1353 (  89 344 ) resistor r=3.1 //w=0.17 //l=0.51 //layer=mcon //count=3 \
 //x=52.29 //y=0.18 //x2=52.29 //y2=0.18
r1354 (  89 91 ) resistor r=0.594855 //w=0.311 //l=1.48 //layer=m1 \
 //thickness=0.36 //x=52.29 //y=0.175 //x2=53.77 //y2=0.175
r1355 (  87 342 ) resistor r=3.1 //w=0.17 //l=0.51 //layer=mcon //count=3 \
 //x=51.18 //y=0.18 //x2=51.18 //y2=0.18
r1356 (  87 89 ) resistor r=0.446141 //w=0.311 //l=1.11 //layer=m1 \
 //thickness=0.36 //x=51.18 //y=0.175 //x2=52.29 //y2=0.175
r1357 (  85 334 ) resistor r=3.1 //w=0.17 //l=0.51 //layer=mcon //count=3 \
 //x=50.07 //y=0.18 //x2=50.07 //y2=0.18
r1358 (  85 87 ) resistor r=0.446141 //w=0.311 //l=1.11 //layer=m1 \
 //thickness=0.36 //x=50.07 //y=0.175 //x2=51.18 //y2=0.175
r1359 (  83 328 ) resistor r=3.1 //w=0.17 //l=0.51 //layer=mcon //count=3 \
 //x=48.59 //y=0.18 //x2=48.59 //y2=0.18
r1360 (  83 85 ) resistor r=0.594855 //w=0.311 //l=1.48 //layer=m1 \
 //thickness=0.36 //x=48.59 //y=0.175 //x2=50.07 //y2=0.175
r1361 (  81 326 ) resistor r=3.1 //w=0.17 //l=0.51 //layer=mcon //count=3 \
 //x=47.48 //y=0.18 //x2=47.48 //y2=0.18
r1362 (  81 83 ) resistor r=0.446141 //w=0.311 //l=1.11 //layer=m1 \
 //thickness=0.36 //x=47.48 //y=0.175 //x2=48.59 //y2=0.175
r1363 (  79 324 ) resistor r=3.1 //w=0.17 //l=0.51 //layer=mcon //count=3 \
 //x=46.37 //y=0.18 //x2=46.37 //y2=0.18
r1364 (  79 81 ) resistor r=0.446141 //w=0.311 //l=1.11 //layer=m1 \
 //thickness=0.36 //x=46.37 //y=0.175 //x2=47.48 //y2=0.175
r1365 (  77 316 ) resistor r=3.1 //w=0.17 //l=0.51 //layer=mcon //count=3 \
 //x=45.26 //y=0.18 //x2=45.26 //y2=0.18
r1366 (  77 79 ) resistor r=0.446141 //w=0.311 //l=1.11 //layer=m1 \
 //thickness=0.36 //x=45.26 //y=0.175 //x2=46.37 //y2=0.175
r1367 (  75 310 ) resistor r=3.1 //w=0.17 //l=0.51 //layer=mcon //count=3 \
 //x=43.78 //y=0.18 //x2=43.78 //y2=0.18
r1368 (  75 77 ) resistor r=0.594855 //w=0.311 //l=1.48 //layer=m1 \
 //thickness=0.36 //x=43.78 //y=0.175 //x2=45.26 //y2=0.175
r1369 (  73 308 ) resistor r=3.1 //w=0.17 //l=0.51 //layer=mcon //count=3 \
 //x=42.67 //y=0.18 //x2=42.67 //y2=0.18
r1370 (  73 75 ) resistor r=0.446141 //w=0.311 //l=1.11 //layer=m1 \
 //thickness=0.36 //x=42.67 //y=0.175 //x2=43.78 //y2=0.175
r1371 (  70 300 ) resistor r=3.1 //w=0.17 //l=0.51 //layer=mcon //count=3 \
 //x=41.56 //y=0.18 //x2=41.56 //y2=0.18
r1372 (  68 294 ) resistor r=3.1 //w=0.17 //l=0.51 //layer=mcon //count=3 \
 //x=40.08 //y=0.18 //x2=40.08 //y2=0.18
r1373 (  68 70 ) resistor r=0.594855 //w=0.311 //l=1.48 //layer=m1 \
 //thickness=0.36 //x=40.08 //y=0.175 //x2=41.56 //y2=0.175
r1374 (  66 493 ) resistor r=3.1 //w=0.17 //l=0.51 //layer=mcon //count=3 \
 //x=38.97 //y=0.18 //x2=38.97 //y2=0.18
r1375 (  66 68 ) resistor r=0.446141 //w=0.311 //l=1.11 //layer=m1 \
 //thickness=0.36 //x=38.97 //y=0.175 //x2=40.08 //y2=0.175
r1376 (  64 282 ) resistor r=3.1 //w=0.17 //l=0.51 //layer=mcon //count=3 \
 //x=37.49 //y=0.18 //x2=37.49 //y2=0.18
r1377 (  64 66 ) resistor r=0.594855 //w=0.311 //l=1.48 //layer=m1 \
 //thickness=0.36 //x=37.49 //y=0.175 //x2=38.97 //y2=0.175
r1378 (  62 280 ) resistor r=3.1 //w=0.17 //l=0.51 //layer=mcon //count=3 \
 //x=36.38 //y=0.18 //x2=36.38 //y2=0.18
r1379 (  62 64 ) resistor r=0.446141 //w=0.311 //l=1.11 //layer=m1 \
 //thickness=0.36 //x=36.38 //y=0.175 //x2=37.49 //y2=0.175
r1380 (  60 278 ) resistor r=3.1 //w=0.17 //l=0.51 //layer=mcon //count=3 \
 //x=35.27 //y=0.18 //x2=35.27 //y2=0.18
r1381 (  60 62 ) resistor r=0.446141 //w=0.311 //l=1.11 //layer=m1 \
 //thickness=0.36 //x=35.27 //y=0.175 //x2=36.38 //y2=0.175
r1382 (  58 490 ) resistor r=3.1 //w=0.17 //l=0.51 //layer=mcon //count=3 \
 //x=34.16 //y=0.18 //x2=34.16 //y2=0.18
r1383 (  58 60 ) resistor r=0.446141 //w=0.311 //l=1.11 //layer=m1 \
 //thickness=0.36 //x=34.16 //y=0.175 //x2=35.27 //y2=0.175
r1384 (  56 266 ) resistor r=3.1 //w=0.17 //l=0.51 //layer=mcon //count=3 \
 //x=32.68 //y=0.18 //x2=32.68 //y2=0.18
r1385 (  56 58 ) resistor r=0.594855 //w=0.311 //l=1.48 //layer=m1 \
 //thickness=0.36 //x=32.68 //y=0.175 //x2=34.16 //y2=0.175
r1386 (  54 264 ) resistor r=3.1 //w=0.17 //l=0.51 //layer=mcon //count=3 \
 //x=31.57 //y=0.18 //x2=31.57 //y2=0.18
r1387 (  54 56 ) resistor r=0.446141 //w=0.311 //l=1.11 //layer=m1 \
 //thickness=0.36 //x=31.57 //y=0.175 //x2=32.68 //y2=0.175
r1388 (  52 262 ) resistor r=3.1 //w=0.17 //l=0.51 //layer=mcon //count=3 \
 //x=30.46 //y=0.18 //x2=30.46 //y2=0.18
r1389 (  52 54 ) resistor r=0.446141 //w=0.311 //l=1.11 //layer=m1 \
 //thickness=0.36 //x=30.46 //y=0.175 //x2=31.57 //y2=0.175
r1390 (  50 487 ) resistor r=3.1 //w=0.17 //l=0.51 //layer=mcon //count=3 \
 //x=29.35 //y=0.18 //x2=29.35 //y2=0.18
r1391 (  50 52 ) resistor r=0.446141 //w=0.311 //l=1.11 //layer=m1 \
 //thickness=0.36 //x=29.35 //y=0.175 //x2=30.46 //y2=0.175
r1392 (  48 250 ) resistor r=3.1 //w=0.17 //l=0.51 //layer=mcon //count=3 \
 //x=27.87 //y=0.18 //x2=27.87 //y2=0.18
r1393 (  48 50 ) resistor r=0.594855 //w=0.311 //l=1.48 //layer=m1 \
 //thickness=0.36 //x=27.87 //y=0.175 //x2=29.35 //y2=0.175
r1394 (  46 248 ) resistor r=3.1 //w=0.17 //l=0.51 //layer=mcon //count=3 \
 //x=26.76 //y=0.18 //x2=26.76 //y2=0.18
r1395 (  46 48 ) resistor r=0.446141 //w=0.311 //l=1.11 //layer=m1 \
 //thickness=0.36 //x=26.76 //y=0.175 //x2=27.87 //y2=0.175
r1396 (  44 240 ) resistor r=3.1 //w=0.17 //l=0.51 //layer=mcon //count=3 \
 //x=25.65 //y=0.18 //x2=25.65 //y2=0.18
r1397 (  44 46 ) resistor r=0.446141 //w=0.311 //l=1.11 //layer=m1 \
 //thickness=0.36 //x=25.65 //y=0.175 //x2=26.76 //y2=0.175
r1398 (  42 234 ) resistor r=3.1 //w=0.17 //l=0.51 //layer=mcon //count=3 \
 //x=24.17 //y=0.18 //x2=24.17 //y2=0.18
r1399 (  42 44 ) resistor r=0.594855 //w=0.311 //l=1.48 //layer=m1 \
 //thickness=0.36 //x=24.17 //y=0.175 //x2=25.65 //y2=0.175
r1400 (  40 232 ) resistor r=3.1 //w=0.17 //l=0.51 //layer=mcon //count=3 \
 //x=23.06 //y=0.18 //x2=23.06 //y2=0.18
r1401 (  40 42 ) resistor r=0.446141 //w=0.311 //l=1.11 //layer=m1 \
 //thickness=0.36 //x=23.06 //y=0.175 //x2=24.17 //y2=0.175
r1402 (  38 230 ) resistor r=3.1 //w=0.17 //l=0.51 //layer=mcon //count=3 \
 //x=21.95 //y=0.18 //x2=21.95 //y2=0.18
r1403 (  38 40 ) resistor r=0.446141 //w=0.311 //l=1.11 //layer=m1 \
 //thickness=0.36 //x=21.95 //y=0.175 //x2=23.06 //y2=0.175
r1404 (  36 222 ) resistor r=3.1 //w=0.17 //l=0.51 //layer=mcon //count=3 \
 //x=20.84 //y=0.18 //x2=20.84 //y2=0.18
r1405 (  36 38 ) resistor r=0.446141 //w=0.311 //l=1.11 //layer=m1 \
 //thickness=0.36 //x=20.84 //y=0.175 //x2=21.95 //y2=0.175
r1406 (  34 216 ) resistor r=3.1 //w=0.17 //l=0.51 //layer=mcon //count=3 \
 //x=19.36 //y=0.18 //x2=19.36 //y2=0.18
r1407 (  34 36 ) resistor r=0.594855 //w=0.311 //l=1.48 //layer=m1 \
 //thickness=0.36 //x=19.36 //y=0.175 //x2=20.84 //y2=0.175
r1408 (  32 214 ) resistor r=3.1 //w=0.17 //l=0.51 //layer=mcon //count=3 \
 //x=18.25 //y=0.18 //x2=18.25 //y2=0.18
r1409 (  32 34 ) resistor r=0.446141 //w=0.311 //l=1.11 //layer=m1 \
 //thickness=0.36 //x=18.25 //y=0.175 //x2=19.36 //y2=0.175
r1410 (  30 206 ) resistor r=3.1 //w=0.17 //l=0.51 //layer=mcon //count=3 \
 //x=17.14 //y=0.18 //x2=17.14 //y2=0.18
r1411 (  30 32 ) resistor r=0.446141 //w=0.311 //l=1.11 //layer=m1 \
 //thickness=0.36 //x=17.14 //y=0.175 //x2=18.25 //y2=0.175
r1412 (  28 200 ) resistor r=3.1 //w=0.17 //l=0.51 //layer=mcon //count=3 \
 //x=15.66 //y=0.18 //x2=15.66 //y2=0.18
r1413 (  28 30 ) resistor r=0.594855 //w=0.311 //l=1.48 //layer=m1 \
 //thickness=0.36 //x=15.66 //y=0.175 //x2=17.14 //y2=0.175
r1414 (  26 478 ) resistor r=3.1 //w=0.17 //l=0.51 //layer=mcon //count=3 \
 //x=14.55 //y=0.18 //x2=14.55 //y2=0.18
r1415 (  26 28 ) resistor r=0.446141 //w=0.311 //l=1.11 //layer=m1 \
 //thickness=0.36 //x=14.55 //y=0.175 //x2=15.66 //y2=0.175
r1416 (  24 188 ) resistor r=3.1 //w=0.17 //l=0.51 //layer=mcon //count=3 \
 //x=13.07 //y=0.18 //x2=13.07 //y2=0.18
r1417 (  24 26 ) resistor r=0.594855 //w=0.311 //l=1.48 //layer=m1 \
 //thickness=0.36 //x=13.07 //y=0.175 //x2=14.55 //y2=0.175
r1418 (  22 186 ) resistor r=3.1 //w=0.17 //l=0.51 //layer=mcon //count=3 \
 //x=11.96 //y=0.18 //x2=11.96 //y2=0.18
r1419 (  22 24 ) resistor r=0.446141 //w=0.311 //l=1.11 //layer=m1 \
 //thickness=0.36 //x=11.96 //y=0.175 //x2=13.07 //y2=0.175
r1420 (  20 184 ) resistor r=3.1 //w=0.17 //l=0.51 //layer=mcon //count=3 \
 //x=10.85 //y=0.18 //x2=10.85 //y2=0.18
r1421 (  20 22 ) resistor r=0.446141 //w=0.311 //l=1.11 //layer=m1 \
 //thickness=0.36 //x=10.85 //y=0.175 //x2=11.96 //y2=0.175
r1422 (  18 475 ) resistor r=3.1 //w=0.17 //l=0.51 //layer=mcon //count=3 \
 //x=9.74 //y=0.18 //x2=9.74 //y2=0.18
r1423 (  18 20 ) resistor r=0.446141 //w=0.311 //l=1.11 //layer=m1 \
 //thickness=0.36 //x=9.74 //y=0.175 //x2=10.85 //y2=0.175
r1424 (  16 172 ) resistor r=3.1 //w=0.17 //l=0.51 //layer=mcon //count=3 \
 //x=8.26 //y=0.18 //x2=8.26 //y2=0.18
r1425 (  16 18 ) resistor r=0.594855 //w=0.311 //l=1.48 //layer=m1 \
 //thickness=0.36 //x=8.26 //y=0.175 //x2=9.74 //y2=0.175
r1426 (  14 170 ) resistor r=3.1 //w=0.17 //l=0.51 //layer=mcon //count=3 \
 //x=7.15 //y=0.18 //x2=7.15 //y2=0.18
r1427 (  14 16 ) resistor r=0.446141 //w=0.311 //l=1.11 //layer=m1 \
 //thickness=0.36 //x=7.15 //y=0.175 //x2=8.26 //y2=0.175
r1428 (  12 168 ) resistor r=3.1 //w=0.17 //l=0.51 //layer=mcon //count=3 \
 //x=6.04 //y=0.18 //x2=6.04 //y2=0.18
r1429 (  12 14 ) resistor r=0.446141 //w=0.311 //l=1.11 //layer=m1 \
 //thickness=0.36 //x=6.04 //y=0.175 //x2=7.15 //y2=0.175
r1430 (  10 472 ) resistor r=3.1 //w=0.17 //l=0.51 //layer=mcon //count=3 \
 //x=4.93 //y=0.18 //x2=4.93 //y2=0.18
r1431 (  10 12 ) resistor r=0.446141 //w=0.311 //l=1.11 //layer=m1 \
 //thickness=0.36 //x=4.93 //y=0.175 //x2=6.04 //y2=0.175
r1432 (  8 156 ) resistor r=3.1 //w=0.17 //l=0.51 //layer=mcon //count=3 \
 //x=3.45 //y=0.18 //x2=3.45 //y2=0.18
r1433 (  8 10 ) resistor r=0.594855 //w=0.311 //l=1.48 //layer=m1 \
 //thickness=0.36 //x=3.45 //y=0.175 //x2=4.93 //y2=0.175
r1434 (  6 154 ) resistor r=3.1 //w=0.17 //l=0.51 //layer=mcon //count=3 \
 //x=2.34 //y=0.18 //x2=2.34 //y2=0.18
r1435 (  6 8 ) resistor r=0.446141 //w=0.311 //l=1.11 //layer=m1 \
 //thickness=0.36 //x=2.34 //y=0.175 //x2=3.45 //y2=0.175
r1436 (  3 146 ) resistor r=3.1 //w=0.17 //l=0.51 //layer=mcon //count=3 \
 //x=1.23 //y=0.18 //x2=1.23 //y2=0.18
r1437 (  3 6 ) resistor r=0.446141 //w=0.311 //l=1.11 //layer=m1 \
 //thickness=0.36 //x=1.23 //y=0.175 //x2=2.34 //y2=0.175
r1438 (  1 73 ) resistor r=0.223071 //w=0.311 //l=0.555 //layer=m1 \
 //thickness=0.36 //x=42.115 //y=0.175 //x2=42.67 //y2=0.175
r1439 (  1 70 ) resistor r=0.223071 //w=0.311 //l=0.555 //layer=m1 \
 //thickness=0.36 //x=42.115 //y=0.175 //x2=41.56 //y2=0.175
ends PM_TMRDFFSNQNX1\%GND

subckt PM_TMRDFFSNQNX1\%VDD ( 1 139 151 159 169 175 183 191 201 211 217 225 \
 233 243 253 259 267 277 287 291 301 311 319 323 333 343 351 361 367 375 383 \
 393 399 407 415 425 435 441 449 457 467 477 483 491 501 511 515 525 535 543 \
 547 557 567 575 585 591 599 607 617 623 631 639 649 659 665 673 681 691 701 \
 707 715 725 735 739 749 759 767 771 781 791 799 809 815 823 831 841 847 862 \
 866 869 875 881 885 890 895 900 906 912 916 921 926 931 937 943 947 952 957 \
 962 963 964 965 966 967 968 969 970 971 972 973 974 975 976 977 978 979 980 \
 981 982 983 984 985 986 987 988 989 990 991 992 993 994 995 996 997 998 999 \
 1000 1001 1002 1003 1004 1005 1006 1007 1008 1009 1010 1011 1012 1013 1014 \
 1015 1016 1017 1018 1019 1020 1021 1022 1023 1024 1025 1026 1027 1028 1029 )
c1064 ( 1029 0 ) capacitor c=0.0476809f //x=76.155 //y=5.205
c1065 ( 1028 0 ) capacitor c=0.0241715f //x=75.275 //y=5.205
c1066 ( 1027 0 ) capacitor c=0.0467094f //x=74.405 //y=5.205
c1067 ( 1026 0 ) capacitor c=0.045218f //x=72.525 //y=5.2
c1068 ( 1025 0 ) capacitor c=0.0241521f //x=71.645 //y=5.2
c1069 ( 1024 0 ) capacitor c=0.0241521f //x=70.765 //y=5.2
c1070 ( 1023 0 ) capacitor c=0.0531852f //x=69.895 //y=5.2
c1071 ( 1022 0 ) capacitor c=0.0381675f //x=68.015 //y=5.2
c1072 ( 1021 0 ) capacitor c=0.0241306f //x=67.135 //y=5.2
c1073 ( 1020 0 ) capacitor c=0.0493661f //x=66.265 //y=5.2
c1074 ( 1019 0 ) capacitor c=0.0381506f //x=64.685 //y=5.2
c1075 ( 1018 0 ) capacitor c=0.0240074f //x=63.805 //y=5.2
c1076 ( 1017 0 ) capacitor c=0.0492093f //x=62.935 //y=5.2
c1077 ( 1016 0 ) capacitor c=0.045218f //x=61.055 //y=5.2
c1078 ( 1015 0 ) capacitor c=0.0241521f //x=60.175 //y=5.2
c1079 ( 1014 0 ) capacitor c=0.0241521f //x=59.295 //y=5.2
c1080 ( 1013 0 ) capacitor c=0.053132f //x=58.425 //y=5.2
c1081 ( 1012 0 ) capacitor c=0.045218f //x=56.245 //y=5.2
c1082 ( 1011 0 ) capacitor c=0.0241521f //x=55.365 //y=5.2
c1083 ( 1010 0 ) capacitor c=0.0241521f //x=54.485 //y=5.2
c1084 ( 1009 0 ) capacitor c=0.0531894f //x=53.615 //y=5.2
c1085 ( 1008 0 ) capacitor c=0.038068f //x=51.735 //y=5.2
c1086 ( 1007 0 ) capacitor c=0.0240081f //x=50.855 //y=5.2
c1087 ( 1006 0 ) capacitor c=0.0492093f //x=49.985 //y=5.2
c1088 ( 1005 0 ) capacitor c=0.045218f //x=48.105 //y=5.2
c1089 ( 1004 0 ) capacitor c=0.0241521f //x=47.225 //y=5.2
c1090 ( 1003 0 ) capacitor c=0.0241521f //x=46.345 //y=5.2
c1091 ( 1002 0 ) capacitor c=0.0531894f //x=45.475 //y=5.2
c1092 ( 1001 0 ) capacitor c=0.038068f //x=43.595 //y=5.2
c1093 ( 1000 0 ) capacitor c=0.0240081f //x=42.715 //y=5.2
c1094 ( 999 0 ) capacitor c=0.0490306f //x=41.845 //y=5.2
c1095 ( 998 0 ) capacitor c=0.038068f //x=40.265 //y=5.2
c1096 ( 997 0 ) capacitor c=0.0240074f //x=39.385 //y=5.2
c1097 ( 996 0 ) capacitor c=0.0492093f //x=38.515 //y=5.2
c1098 ( 995 0 ) capacitor c=0.045218f //x=36.635 //y=5.2
c1099 ( 994 0 ) capacitor c=0.0241521f //x=35.755 //y=5.2
c1100 ( 993 0 ) capacitor c=0.0241521f //x=34.875 //y=5.2
c1101 ( 992 0 ) capacitor c=0.053132f //x=34.005 //y=5.2
c1102 ( 991 0 ) capacitor c=0.045218f //x=31.825 //y=5.2
c1103 ( 990 0 ) capacitor c=0.0241521f //x=30.945 //y=5.2
c1104 ( 989 0 ) capacitor c=0.0241521f //x=30.065 //y=5.2
c1105 ( 988 0 ) capacitor c=0.0531894f //x=29.195 //y=5.2
c1106 ( 987 0 ) capacitor c=0.038068f //x=27.315 //y=5.2
c1107 ( 986 0 ) capacitor c=0.0240081f //x=26.435 //y=5.2
c1108 ( 985 0 ) capacitor c=0.0492093f //x=25.565 //y=5.2
c1109 ( 984 0 ) capacitor c=0.045218f //x=23.685 //y=5.2
c1110 ( 983 0 ) capacitor c=0.0241521f //x=22.805 //y=5.2
c1111 ( 982 0 ) capacitor c=0.0241521f //x=21.925 //y=5.2
c1112 ( 981 0 ) capacitor c=0.0531894f //x=21.055 //y=5.2
c1113 ( 980 0 ) capacitor c=0.038068f //x=19.175 //y=5.2
c1114 ( 979 0 ) capacitor c=0.0240081f //x=18.295 //y=5.2
c1115 ( 978 0 ) capacitor c=0.0490306f //x=17.425 //y=5.2
c1116 ( 977 0 ) capacitor c=0.038068f //x=15.845 //y=5.2
c1117 ( 976 0 ) capacitor c=0.0240074f //x=14.965 //y=5.2
c1118 ( 975 0 ) capacitor c=0.0492093f //x=14.095 //y=5.2
c1119 ( 974 0 ) capacitor c=0.045218f //x=12.215 //y=5.2
c1120 ( 973 0 ) capacitor c=0.0241521f //x=11.335 //y=5.2
c1121 ( 972 0 ) capacitor c=0.0241521f //x=10.455 //y=5.2
c1122 ( 971 0 ) capacitor c=0.053132f //x=9.585 //y=5.2
c1123 ( 970 0 ) capacitor c=0.045218f //x=7.405 //y=5.2
c1124 ( 969 0 ) capacitor c=0.0241521f //x=6.525 //y=5.2
c1125 ( 968 0 ) capacitor c=0.0242401f //x=5.645 //y=5.2
c1126 ( 967 0 ) capacitor c=0.0532367f //x=4.775 //y=5.2
c1127 ( 966 0 ) capacitor c=0.0381506f //x=2.895 //y=5.2
c1128 ( 965 0 ) capacitor c=0.0241853f //x=2.015 //y=5.2
c1129 ( 964 0 ) capacitor c=0.0531988f //x=1.145 //y=5.2
c1130 ( 963 0 ) capacitor c=0.113453f //x=80.41 //y=7.585
c1131 ( 962 0 ) capacitor c=0.121185f //x=77.08 //y=7.585
c1132 ( 961 0 ) capacitor c=0.00597439f //x=76.3 //y=7.585
c1133 ( 960 0 ) capacitor c=0.00597439f //x=75.42 //y=7.585
c1134 ( 959 0 ) capacitor c=0.00597439f //x=74.49 //y=7.58
c1135 ( 957 0 ) capacitor c=0.136728f //x=73.75 //y=7.585
c1136 ( 956 0 ) capacitor c=0.00597439f //x=72.67 //y=7.585
c1137 ( 955 0 ) capacitor c=0.00597439f //x=71.79 //y=7.585
c1138 ( 954 0 ) capacitor c=0.00597439f //x=70.91 //y=7.585
c1139 ( 953 0 ) capacitor c=0.00597439f //x=70.03 //y=7.585
c1140 ( 952 0 ) capacitor c=0.134834f //x=68.94 //y=7.585
c1141 ( 951 0 ) capacitor c=0.00597439f //x=68.2 //y=7.58
c1142 ( 949 0 ) capacitor c=0.00597439f //x=67.28 //y=7.585
c1143 ( 948 0 ) capacitor c=0.00597439f //x=66.4 //y=7.585
c1144 ( 947 0 ) capacitor c=0.116056f //x=65.61 //y=7.585
c1145 ( 946 0 ) capacitor c=0.00597439f //x=64.83 //y=7.585
c1146 ( 945 0 ) capacitor c=0.00597439f //x=63.95 //y=7.585
c1147 ( 944 0 ) capacitor c=0.00597439f //x=63.07 //y=7.585
c1148 ( 943 0 ) capacitor c=0.134644f //x=62.28 //y=7.585
c1149 ( 942 0 ) capacitor c=0.00597439f //x=61.2 //y=7.585
c1150 ( 941 0 ) capacitor c=0.00597439f //x=60.32 //y=7.585
c1151 ( 940 0 ) capacitor c=0.00597439f //x=59.44 //y=7.585
c1152 ( 939 0 ) capacitor c=0.00597439f //x=58.58 //y=7.58
c1153 ( 937 0 ) capacitor c=0.155205f //x=57.47 //y=7.585
c1154 ( 936 0 ) capacitor c=0.00597439f //x=56.39 //y=7.585
c1155 ( 935 0 ) capacitor c=0.00597439f //x=55.51 //y=7.585
c1156 ( 934 0 ) capacitor c=0.00597439f //x=54.63 //y=7.585
c1157 ( 933 0 ) capacitor c=0.00597439f //x=53.77 //y=7.58
c1158 ( 931 0 ) capacitor c=0.13534f //x=52.66 //y=7.585
c1159 ( 930 0 ) capacitor c=0.00597439f //x=51.88 //y=7.585
c1160 ( 929 0 ) capacitor c=0.00597439f //x=51 //y=7.585
c1161 ( 928 0 ) capacitor c=0.00597439f //x=50.07 //y=7.58
c1162 ( 926 0 ) capacitor c=0.138873f //x=49.33 //y=7.585
c1163 ( 925 0 ) capacitor c=0.00597439f //x=48.25 //y=7.585
c1164 ( 924 0 ) capacitor c=0.00597439f //x=47.37 //y=7.585
c1165 ( 923 0 ) capacitor c=0.00597439f //x=46.49 //y=7.585
c1166 ( 922 0 ) capacitor c=0.00597439f //x=45.61 //y=7.585
c1167 ( 921 0 ) capacitor c=0.135232f //x=44.52 //y=7.585
c1168 ( 920 0 ) capacitor c=0.00597439f //x=43.78 //y=7.58
c1169 ( 918 0 ) capacitor c=0.00597439f //x=42.86 //y=7.585
c1170 ( 917 0 ) capacitor c=0.00597439f //x=41.98 //y=7.585
c1171 ( 916 0 ) capacitor c=0.114443f //x=41.19 //y=7.585
c1172 ( 915 0 ) capacitor c=0.00597439f //x=40.41 //y=7.585
c1173 ( 914 0 ) capacitor c=0.00597439f //x=39.53 //y=7.585
c1174 ( 913 0 ) capacitor c=0.00597439f //x=38.65 //y=7.585
c1175 ( 912 0 ) capacitor c=0.134644f //x=37.86 //y=7.585
c1176 ( 911 0 ) capacitor c=0.00597439f //x=36.78 //y=7.585
c1177 ( 910 0 ) capacitor c=0.00597439f //x=35.9 //y=7.585
c1178 ( 909 0 ) capacitor c=0.00597439f //x=35.02 //y=7.585
c1179 ( 908 0 ) capacitor c=0.00597439f //x=34.16 //y=7.58
c1180 ( 906 0 ) capacitor c=0.155205f //x=33.05 //y=7.585
c1181 ( 905 0 ) capacitor c=0.00597439f //x=31.97 //y=7.585
c1182 ( 904 0 ) capacitor c=0.00597439f //x=31.09 //y=7.585
c1183 ( 903 0 ) capacitor c=0.00597439f //x=30.21 //y=7.585
c1184 ( 902 0 ) capacitor c=0.00597439f //x=29.35 //y=7.58
c1185 ( 900 0 ) capacitor c=0.13534f //x=28.24 //y=7.585
c1186 ( 899 0 ) capacitor c=0.00597439f //x=27.46 //y=7.585
c1187 ( 898 0 ) capacitor c=0.00597439f //x=26.58 //y=7.585
c1188 ( 897 0 ) capacitor c=0.00597439f //x=25.65 //y=7.58
c1189 ( 895 0 ) capacitor c=0.13886f //x=24.91 //y=7.585
c1190 ( 894 0 ) capacitor c=0.00597439f //x=23.83 //y=7.585
c1191 ( 893 0 ) capacitor c=0.00597439f //x=22.95 //y=7.585
c1192 ( 892 0 ) capacitor c=0.00597439f //x=22.07 //y=7.585
c1193 ( 891 0 ) capacitor c=0.00597439f //x=21.19 //y=7.585
c1194 ( 890 0 ) capacitor c=0.135232f //x=20.1 //y=7.585
c1195 ( 889 0 ) capacitor c=0.00597439f //x=19.36 //y=7.58
c1196 ( 887 0 ) capacitor c=0.00597439f //x=18.44 //y=7.585
c1197 ( 886 0 ) capacitor c=0.00597439f //x=17.56 //y=7.585
c1198 ( 885 0 ) capacitor c=0.114443f //x=16.77 //y=7.585
c1199 ( 884 0 ) capacitor c=0.00597439f //x=15.99 //y=7.585
c1200 ( 883 0 ) capacitor c=0.00597439f //x=15.11 //y=7.585
c1201 ( 882 0 ) capacitor c=0.00597439f //x=14.23 //y=7.585
c1202 ( 881 0 ) capacitor c=0.134644f //x=13.44 //y=7.585
c1203 ( 880 0 ) capacitor c=0.00597439f //x=12.36 //y=7.585
c1204 ( 879 0 ) capacitor c=0.00597439f //x=11.48 //y=7.585
c1205 ( 878 0 ) capacitor c=0.00597439f //x=10.6 //y=7.585
c1206 ( 877 0 ) capacitor c=0.00597439f //x=9.74 //y=7.58
c1207 ( 875 0 ) capacitor c=0.155205f //x=8.63 //y=7.585
c1208 ( 874 0 ) capacitor c=0.00597439f //x=7.55 //y=7.585
c1209 ( 873 0 ) capacitor c=0.00597439f //x=6.67 //y=7.585
c1210 ( 872 0 ) capacitor c=0.00597439f //x=5.79 //y=7.585
c1211 ( 871 0 ) capacitor c=0.00597439f //x=4.93 //y=7.58
c1212 ( 869 0 ) capacitor c=0.137421f //x=3.82 //y=7.585
c1213 ( 868 0 ) capacitor c=0.00597439f //x=3.04 //y=7.585
c1214 ( 867 0 ) capacitor c=0.00597439f //x=2.16 //y=7.585
c1215 ( 866 0 ) capacitor c=0.267249f //x=1.23 //y=7.58
c1216 ( 862 0 ) capacitor c=0.354252f //x=83 //y=7.58
c1217 ( 847 0 ) capacitor c=0.122102f //x=80.24 //y=7.585
c1218 ( 841 0 ) capacitor c=0.0238235f //x=76.91 //y=7.585
c1219 ( 831 0 ) capacitor c=0.0288071f //x=76.215 //y=7.585
c1220 ( 823 0 ) capacitor c=0.0287754f //x=75.335 //y=7.585
c1221 ( 815 0 ) capacitor c=0.024303f //x=74.455 //y=7.585
c1222 ( 809 0 ) capacitor c=0.0397734f //x=73.58 //y=7.585
c1223 ( 799 0 ) capacitor c=0.0291138f //x=72.585 //y=7.585
c1224 ( 791 0 ) capacitor c=0.0290172f //x=71.705 //y=7.585
c1225 ( 781 0 ) capacitor c=0.0287649f //x=70.825 //y=7.585
c1226 ( 771 0 ) capacitor c=0.0386886f //x=69.945 //y=7.585
c1227 ( 767 0 ) capacitor c=0.0239099f //x=68.77 //y=7.585
c1228 ( 759 0 ) capacitor c=0.0291286f //x=68.075 //y=7.585
c1229 ( 749 0 ) capacitor c=0.029371f //x=67.195 //y=7.585
c1230 ( 739 0 ) capacitor c=0.024303f //x=66.315 //y=7.585
c1231 ( 735 0 ) capacitor c=0.0238235f //x=65.44 //y=7.585
c1232 ( 725 0 ) capacitor c=0.0291247f //x=64.745 //y=7.585
c1233 ( 715 0 ) capacitor c=0.0291028f //x=63.865 //y=7.585
c1234 ( 707 0 ) capacitor c=0.024303f //x=62.985 //y=7.585
c1235 ( 701 0 ) capacitor c=0.0397734f //x=62.11 //y=7.585
c1236 ( 691 0 ) capacitor c=0.0291138f //x=61.115 //y=7.585
c1237 ( 681 0 ) capacitor c=0.0290172f //x=60.235 //y=7.585
c1238 ( 673 0 ) capacitor c=0.0287649f //x=59.355 //y=7.585
c1239 ( 665 0 ) capacitor c=0.0386886f //x=58.475 //y=7.585
c1240 ( 659 0 ) capacitor c=0.0397734f //x=57.3 //y=7.585
c1241 ( 649 0 ) capacitor c=0.0291138f //x=56.305 //y=7.585
c1242 ( 639 0 ) capacitor c=0.0290163f //x=55.425 //y=7.585
c1243 ( 631 0 ) capacitor c=0.0287649f //x=54.545 //y=7.585
c1244 ( 623 0 ) capacitor c=0.0386886f //x=53.665 //y=7.585
c1245 ( 617 0 ) capacitor c=0.0238235f //x=52.49 //y=7.585
c1246 ( 607 0 ) capacitor c=0.0291008f //x=51.795 //y=7.585
c1247 ( 599 0 ) capacitor c=0.0291028f //x=50.915 //y=7.585
c1248 ( 591 0 ) capacitor c=0.024303f //x=50.035 //y=7.585
c1249 ( 585 0 ) capacitor c=0.0397734f //x=49.16 //y=7.585
c1250 ( 575 0 ) capacitor c=0.0291138f //x=48.165 //y=7.585
c1251 ( 567 0 ) capacitor c=0.0290172f //x=47.285 //y=7.585
c1252 ( 557 0 ) capacitor c=0.0287649f //x=46.405 //y=7.585
c1253 ( 547 0 ) capacitor c=0.0386886f //x=45.525 //y=7.585
c1254 ( 543 0 ) capacitor c=0.0238235f //x=44.35 //y=7.585
c1255 ( 535 0 ) capacitor c=0.0291008f //x=43.655 //y=7.585
c1256 ( 525 0 ) capacitor c=0.0291028f //x=42.775 //y=7.585
c1257 ( 515 0 ) capacitor c=0.024303f //x=41.895 //y=7.585
c1258 ( 511 0 ) capacitor c=0.0238235f //x=41.02 //y=7.585
c1259 ( 501 0 ) capacitor c=0.0291007f //x=40.325 //y=7.585
c1260 ( 491 0 ) capacitor c=0.0291028f //x=39.445 //y=7.585
c1261 ( 483 0 ) capacitor c=0.024303f //x=38.565 //y=7.585
c1262 ( 477 0 ) capacitor c=0.0397734f //x=37.69 //y=7.585
c1263 ( 467 0 ) capacitor c=0.0291138f //x=36.695 //y=7.585
c1264 ( 457 0 ) capacitor c=0.0290172f //x=35.815 //y=7.585
c1265 ( 449 0 ) capacitor c=0.0287649f //x=34.935 //y=7.585
c1266 ( 441 0 ) capacitor c=0.0386886f //x=34.055 //y=7.585
c1267 ( 435 0 ) capacitor c=0.0397734f //x=32.88 //y=7.585
c1268 ( 425 0 ) capacitor c=0.0291138f //x=31.885 //y=7.585
c1269 ( 415 0 ) capacitor c=0.0290163f //x=31.005 //y=7.585
c1270 ( 407 0 ) capacitor c=0.0287649f //x=30.125 //y=7.585
c1271 ( 399 0 ) capacitor c=0.0386886f //x=29.245 //y=7.585
c1272 ( 393 0 ) capacitor c=0.0238235f //x=28.07 //y=7.585
c1273 ( 383 0 ) capacitor c=0.0291008f //x=27.375 //y=7.585
c1274 ( 375 0 ) capacitor c=0.0291028f //x=26.495 //y=7.585
c1275 ( 367 0 ) capacitor c=0.024303f //x=25.615 //y=7.585
c1276 ( 361 0 ) capacitor c=0.0397734f //x=24.74 //y=7.585
c1277 ( 351 0 ) capacitor c=0.0291138f //x=23.745 //y=7.585
c1278 ( 343 0 ) capacitor c=0.0290172f //x=22.865 //y=7.585
c1279 ( 333 0 ) capacitor c=0.0287649f //x=21.985 //y=7.585
c1280 ( 323 0 ) capacitor c=0.0386886f //x=21.105 //y=7.585
c1281 ( 319 0 ) capacitor c=0.0238235f //x=19.93 //y=7.585
c1282 ( 311 0 ) capacitor c=0.0291008f //x=19.235 //y=7.585
c1283 ( 301 0 ) capacitor c=0.0291028f //x=18.355 //y=7.585
c1284 ( 291 0 ) capacitor c=0.024303f //x=17.475 //y=7.585
c1285 ( 287 0 ) capacitor c=0.0238235f //x=16.6 //y=7.585
c1286 ( 277 0 ) capacitor c=0.0291007f //x=15.905 //y=7.585
c1287 ( 267 0 ) capacitor c=0.0291028f //x=15.025 //y=7.585
c1288 ( 259 0 ) capacitor c=0.024303f //x=14.145 //y=7.585
c1289 ( 253 0 ) capacitor c=0.0397734f //x=13.27 //y=7.585
c1290 ( 243 0 ) capacitor c=0.0291138f //x=12.275 //y=7.585
c1291 ( 233 0 ) capacitor c=0.0290172f //x=11.395 //y=7.585
c1292 ( 225 0 ) capacitor c=0.0287649f //x=10.515 //y=7.585
c1293 ( 217 0 ) capacitor c=0.0386886f //x=9.635 //y=7.585
c1294 ( 211 0 ) capacitor c=0.0397734f //x=8.46 //y=7.585
c1295 ( 201 0 ) capacitor c=0.0291138f //x=7.465 //y=7.585
c1296 ( 191 0 ) capacitor c=0.0290163f //x=6.585 //y=7.585
c1297 ( 183 0 ) capacitor c=0.0287792f //x=5.705 //y=7.585
c1298 ( 175 0 ) capacitor c=0.0386886f //x=4.825 //y=7.585
c1299 ( 169 0 ) capacitor c=0.0238235f //x=3.65 //y=7.585
c1300 ( 159 0 ) capacitor c=0.0291286f //x=2.955 //y=7.585
c1301 ( 151 0 ) capacitor c=0.0289072f //x=2.075 //y=7.585
c1302 ( 139 0 ) capacitor c=2.78802f //x=83 //y=7.58
r1303 (  860 862 ) resistor r=38.7139 //w=0.367 //l=1.11 //layer=li \
 //thickness=0.1 //x=81.89 //y=7.585 //x2=83 //y2=7.585
r1304 (  858 860 ) resistor r=38.7139 //w=0.367 //l=1.11 //layer=li \
 //thickness=0.1 //x=80.78 //y=7.585 //x2=81.89 //y2=7.585
r1305 (  856 963 ) resistor r=5.29055 //w=0.35 //l=0.17 //layer=li \
 //thickness=0.1 //x=80.58 //y=7.585 //x2=80.41 //y2=7.585
r1306 (  856 858 ) resistor r=6.97548 //w=0.367 //l=0.2 //layer=li \
 //thickness=0.1 //x=80.58 //y=7.585 //x2=80.78 //y2=7.585
r1307 (  850 852 ) resistor r=38.7139 //w=0.367 //l=1.11 //layer=li \
 //thickness=0.1 //x=78.19 //y=7.585 //x2=79.3 //y2=7.585
r1308 (  848 962 ) resistor r=5.29055 //w=0.35 //l=0.17 //layer=li \
 //thickness=0.1 //x=77.25 //y=7.585 //x2=77.08 //y2=7.585
r1309 (  848 850 ) resistor r=32.7847 //w=0.367 //l=0.94 //layer=li \
 //thickness=0.1 //x=77.25 //y=7.585 //x2=78.19 //y2=7.585
r1310 (  847 963 ) resistor r=5.29055 //w=0.35 //l=0.17 //layer=li \
 //thickness=0.1 //x=80.24 //y=7.585 //x2=80.41 //y2=7.585
r1311 (  847 852 ) resistor r=32.7847 //w=0.367 //l=0.94 //layer=li \
 //thickness=0.1 //x=80.24 //y=7.585 //x2=79.3 //y2=7.585
r1312 (  842 961 ) resistor r=2.87058 //w=0.35 //l=0.085 //layer=li \
 //thickness=0.1 //x=76.385 //y=7.585 //x2=76.3 //y2=7.585
r1313 (  842 844 ) resistor r=11.3351 //w=0.367 //l=0.325 //layer=li \
 //thickness=0.1 //x=76.385 //y=7.585 //x2=76.71 //y2=7.585
r1314 (  841 962 ) resistor r=5.29055 //w=0.35 //l=0.17 //layer=li \
 //thickness=0.1 //x=76.91 //y=7.585 //x2=77.08 //y2=7.585
r1315 (  841 844 ) resistor r=6.97548 //w=0.367 //l=0.2 //layer=li \
 //thickness=0.1 //x=76.91 //y=7.585 //x2=76.71 //y2=7.585
r1316 (  835 961 ) resistor r=4.23183 //w=0.7 //l=0.175 //layer=li \
 //thickness=0.1 //x=76.3 //y=7.41 //x2=76.3 //y2=7.585
r1317 (  835 1029 ) resistor r=56.8128 //w=0.187 //l=0.83 //layer=li \
 //thickness=0.1 //x=76.3 //y=7.41 //x2=76.3 //y2=6.58
r1318 (  832 960 ) resistor r=2.87058 //w=0.35 //l=0.085 //layer=li \
 //thickness=0.1 //x=75.505 //y=7.585 //x2=75.42 //y2=7.585
r1319 (  832 834 ) resistor r=3.31335 //w=0.367 //l=0.095 //layer=li \
 //thickness=0.1 //x=75.505 //y=7.585 //x2=75.6 //y2=7.585
r1320 (  831 961 ) resistor r=2.87058 //w=0.35 //l=0.085 //layer=li \
 //thickness=0.1 //x=76.215 //y=7.585 //x2=76.3 //y2=7.585
r1321 (  831 834 ) resistor r=21.4496 //w=0.367 //l=0.615 //layer=li \
 //thickness=0.1 //x=76.215 //y=7.585 //x2=75.6 //y2=7.585
r1322 (  825 960 ) resistor r=4.23183 //w=0.7 //l=0.175 //layer=li \
 //thickness=0.1 //x=75.42 //y=7.41 //x2=75.42 //y2=7.585
r1323 (  825 1028 ) resistor r=33.5401 //w=0.187 //l=0.49 //layer=li \
 //thickness=0.1 //x=75.42 //y=7.41 //x2=75.42 //y2=6.92
r1324 (  824 959 ) resistor r=2.87058 //w=0.35 //l=0.085 //layer=li \
 //thickness=0.1 //x=74.625 //y=7.585 //x2=74.54 //y2=7.585
r1325 (  823 960 ) resistor r=2.87058 //w=0.35 //l=0.085 //layer=li \
 //thickness=0.1 //x=75.335 //y=7.585 //x2=75.42 //y2=7.585
r1326 (  823 824 ) resistor r=24.7629 //w=0.367 //l=0.71 //layer=li \
 //thickness=0.1 //x=75.335 //y=7.585 //x2=74.625 //y2=7.585
r1327 (  817 959 ) resistor r=4.23183 //w=0.7 //l=0.175 //layer=li \
 //thickness=0.1 //x=74.54 //y=7.41 //x2=74.54 //y2=7.585
r1328 (  817 1027 ) resistor r=56.8128 //w=0.187 //l=0.83 //layer=li \
 //thickness=0.1 //x=74.54 //y=7.41 //x2=74.54 //y2=6.58
r1329 (  816 957 ) resistor r=5.29055 //w=0.35 //l=0.17 //layer=li \
 //thickness=0.1 //x=73.92 //y=7.585 //x2=73.75 //y2=7.585
r1330 (  815 959 ) resistor r=2.87058 //w=0.35 //l=0.085 //layer=li \
 //thickness=0.1 //x=74.455 //y=7.585 //x2=74.54 //y2=7.585
r1331 (  815 816 ) resistor r=18.6594 //w=0.367 //l=0.535 //layer=li \
 //thickness=0.1 //x=74.455 //y=7.585 //x2=73.92 //y2=7.585
r1332 (  810 956 ) resistor r=2.87058 //w=0.35 //l=0.085 //layer=li \
 //thickness=0.1 //x=72.755 //y=7.585 //x2=72.67 //y2=7.585
r1333 (  810 812 ) resistor r=8.89373 //w=0.367 //l=0.255 //layer=li \
 //thickness=0.1 //x=72.755 //y=7.585 //x2=73.01 //y2=7.585
r1334 (  809 957 ) resistor r=5.29055 //w=0.35 //l=0.17 //layer=li \
 //thickness=0.1 //x=73.58 //y=7.585 //x2=73.75 //y2=7.585
r1335 (  809 812 ) resistor r=19.8801 //w=0.367 //l=0.57 //layer=li \
 //thickness=0.1 //x=73.58 //y=7.585 //x2=73.01 //y2=7.585
r1336 (  803 956 ) resistor r=4.23183 //w=0.7 //l=0.175 //layer=li \
 //thickness=0.1 //x=72.67 //y=7.41 //x2=72.67 //y2=7.585
r1337 (  803 1026 ) resistor r=33.1979 //w=0.187 //l=0.485 //layer=li \
 //thickness=0.1 //x=72.67 //y=7.41 //x2=72.67 //y2=6.925
r1338 (  800 955 ) resistor r=2.87058 //w=0.35 //l=0.085 //layer=li \
 //thickness=0.1 //x=71.875 //y=7.585 //x2=71.79 //y2=7.585
r1339 (  800 802 ) resistor r=0.871935 //w=0.367 //l=0.025 //layer=li \
 //thickness=0.1 //x=71.875 //y=7.585 //x2=71.9 //y2=7.585
r1340 (  799 956 ) resistor r=2.87058 //w=0.35 //l=0.085 //layer=li \
 //thickness=0.1 //x=72.585 //y=7.585 //x2=72.67 //y2=7.585
r1341 (  799 802 ) resistor r=23.891 //w=0.367 //l=0.685 //layer=li \
 //thickness=0.1 //x=72.585 //y=7.585 //x2=71.9 //y2=7.585
r1342 (  793 955 ) resistor r=4.23183 //w=0.7 //l=0.175 //layer=li \
 //thickness=0.1 //x=71.79 //y=7.41 //x2=71.79 //y2=7.585
r1343 (  793 1025 ) resistor r=33.1979 //w=0.187 //l=0.485 //layer=li \
 //thickness=0.1 //x=71.79 //y=7.41 //x2=71.79 //y2=6.925
r1344 (  792 954 ) resistor r=2.87058 //w=0.35 //l=0.085 //layer=li \
 //thickness=0.1 //x=70.995 //y=7.585 //x2=70.91 //y2=7.585
r1345 (  791 955 ) resistor r=2.87058 //w=0.35 //l=0.085 //layer=li \
 //thickness=0.1 //x=71.705 //y=7.585 //x2=71.79 //y2=7.585
r1346 (  791 792 ) resistor r=24.7629 //w=0.367 //l=0.71 //layer=li \
 //thickness=0.1 //x=71.705 //y=7.585 //x2=70.995 //y2=7.585
r1347 (  785 954 ) resistor r=4.23183 //w=0.7 //l=0.175 //layer=li \
 //thickness=0.1 //x=70.91 //y=7.41 //x2=70.91 //y2=7.585
r1348 (  785 1024 ) resistor r=33.1979 //w=0.187 //l=0.485 //layer=li \
 //thickness=0.1 //x=70.91 //y=7.41 //x2=70.91 //y2=6.925
r1349 (  782 953 ) resistor r=2.87058 //w=0.35 //l=0.085 //layer=li \
 //thickness=0.1 //x=70.115 //y=7.585 //x2=70.03 //y2=7.585
r1350 (  782 784 ) resistor r=23.5422 //w=0.367 //l=0.675 //layer=li \
 //thickness=0.1 //x=70.115 //y=7.585 //x2=70.79 //y2=7.585
r1351 (  781 954 ) resistor r=2.87058 //w=0.35 //l=0.085 //layer=li \
 //thickness=0.1 //x=70.825 //y=7.585 //x2=70.91 //y2=7.585
r1352 (  781 784 ) resistor r=1.22071 //w=0.367 //l=0.035 //layer=li \
 //thickness=0.1 //x=70.825 //y=7.585 //x2=70.79 //y2=7.585
r1353 (  775 953 ) resistor r=4.23183 //w=0.7 //l=0.175 //layer=li \
 //thickness=0.1 //x=70.03 //y=7.41 //x2=70.03 //y2=7.585
r1354 (  775 1023 ) resistor r=56.4706 //w=0.187 //l=0.825 //layer=li \
 //thickness=0.1 //x=70.03 //y=7.41 //x2=70.03 //y2=6.585
r1355 (  772 952 ) resistor r=5.29055 //w=0.35 //l=0.17 //layer=li \
 //thickness=0.1 //x=69.11 //y=7.585 //x2=68.94 //y2=7.585
r1356 (  772 774 ) resistor r=19.8801 //w=0.367 //l=0.57 //layer=li \
 //thickness=0.1 //x=69.11 //y=7.585 //x2=69.68 //y2=7.585
r1357 (  771 953 ) resistor r=2.87058 //w=0.35 //l=0.085 //layer=li \
 //thickness=0.1 //x=69.945 //y=7.585 //x2=70.03 //y2=7.585
r1358 (  771 774 ) resistor r=9.24251 //w=0.367 //l=0.265 //layer=li \
 //thickness=0.1 //x=69.945 //y=7.585 //x2=69.68 //y2=7.585
r1359 (  768 951 ) resistor r=2.87058 //w=0.35 //l=0.085 //layer=li \
 //thickness=0.1 //x=68.245 //y=7.585 //x2=68.16 //y2=7.585
r1360 (  767 952 ) resistor r=5.29055 //w=0.35 //l=0.17 //layer=li \
 //thickness=0.1 //x=68.77 //y=7.585 //x2=68.94 //y2=7.585
r1361 (  767 768 ) resistor r=18.3106 //w=0.367 //l=0.525 //layer=li \
 //thickness=0.1 //x=68.77 //y=7.585 //x2=68.245 //y2=7.585
r1362 (  761 951 ) resistor r=4.23183 //w=0.7 //l=0.175 //layer=li \
 //thickness=0.1 //x=68.16 //y=7.41 //x2=68.16 //y2=7.585
r1363 (  761 1022 ) resistor r=33.1979 //w=0.187 //l=0.485 //layer=li \
 //thickness=0.1 //x=68.16 //y=7.41 //x2=68.16 //y2=6.925
r1364 (  760 949 ) resistor r=2.87058 //w=0.35 //l=0.085 //layer=li \
 //thickness=0.1 //x=67.365 //y=7.585 //x2=67.28 //y2=7.585
r1365 (  759 951 ) resistor r=2.87058 //w=0.35 //l=0.085 //layer=li \
 //thickness=0.1 //x=68.075 //y=7.585 //x2=68.16 //y2=7.585
r1366 (  759 760 ) resistor r=24.7629 //w=0.367 //l=0.71 //layer=li \
 //thickness=0.1 //x=68.075 //y=7.585 //x2=67.365 //y2=7.585
r1367 (  753 949 ) resistor r=4.23183 //w=0.7 //l=0.175 //layer=li \
 //thickness=0.1 //x=67.28 //y=7.41 //x2=67.28 //y2=7.585
r1368 (  753 1021 ) resistor r=33.1979 //w=0.187 //l=0.485 //layer=li \
 //thickness=0.1 //x=67.28 //y=7.41 //x2=67.28 //y2=6.925
r1369 (  750 948 ) resistor r=2.87058 //w=0.35 //l=0.085 //layer=li \
 //thickness=0.1 //x=66.485 //y=7.585 //x2=66.4 //y2=7.585
r1370 (  750 752 ) resistor r=21.1008 //w=0.367 //l=0.605 //layer=li \
 //thickness=0.1 //x=66.485 //y=7.585 //x2=67.09 //y2=7.585
r1371 (  749 949 ) resistor r=2.87058 //w=0.35 //l=0.085 //layer=li \
 //thickness=0.1 //x=67.195 //y=7.585 //x2=67.28 //y2=7.585
r1372 (  749 752 ) resistor r=3.66213 //w=0.367 //l=0.105 //layer=li \
 //thickness=0.1 //x=67.195 //y=7.585 //x2=67.09 //y2=7.585
r1373 (  743 948 ) resistor r=4.23183 //w=0.7 //l=0.175 //layer=li \
 //thickness=0.1 //x=66.4 //y=7.41 //x2=66.4 //y2=7.585
r1374 (  743 1020 ) resistor r=56.4706 //w=0.187 //l=0.825 //layer=li \
 //thickness=0.1 //x=66.4 //y=7.41 //x2=66.4 //y2=6.585
r1375 (  740 947 ) resistor r=5.29055 //w=0.35 //l=0.17 //layer=li \
 //thickness=0.1 //x=65.78 //y=7.585 //x2=65.61 //y2=7.585
r1376 (  740 742 ) resistor r=6.97548 //w=0.367 //l=0.2 //layer=li \
 //thickness=0.1 //x=65.78 //y=7.585 //x2=65.98 //y2=7.585
r1377 (  739 948 ) resistor r=2.87058 //w=0.35 //l=0.085 //layer=li \
 //thickness=0.1 //x=66.315 //y=7.585 //x2=66.4 //y2=7.585
r1378 (  739 742 ) resistor r=11.6839 //w=0.367 //l=0.335 //layer=li \
 //thickness=0.1 //x=66.315 //y=7.585 //x2=65.98 //y2=7.585
r1379 (  736 946 ) resistor r=2.87058 //w=0.35 //l=0.085 //layer=li \
 //thickness=0.1 //x=64.915 //y=7.585 //x2=64.83 //y2=7.585
r1380 (  735 947 ) resistor r=5.29055 //w=0.35 //l=0.17 //layer=li \
 //thickness=0.1 //x=65.44 //y=7.585 //x2=65.61 //y2=7.585
r1381 (  735 736 ) resistor r=18.3106 //w=0.367 //l=0.525 //layer=li \
 //thickness=0.1 //x=65.44 //y=7.585 //x2=64.915 //y2=7.585
r1382 (  729 946 ) resistor r=4.23183 //w=0.7 //l=0.175 //layer=li \
 //thickness=0.1 //x=64.83 //y=7.41 //x2=64.83 //y2=7.585
r1383 (  729 1019 ) resistor r=33.1979 //w=0.187 //l=0.485 //layer=li \
 //thickness=0.1 //x=64.83 //y=7.41 //x2=64.83 //y2=6.925
r1384 (  726 945 ) resistor r=2.87058 //w=0.35 //l=0.085 //layer=li \
 //thickness=0.1 //x=64.035 //y=7.585 //x2=63.95 //y2=7.585
r1385 (  726 728 ) resistor r=16.218 //w=0.367 //l=0.465 //layer=li \
 //thickness=0.1 //x=64.035 //y=7.585 //x2=64.5 //y2=7.585
r1386 (  725 946 ) resistor r=2.87058 //w=0.35 //l=0.085 //layer=li \
 //thickness=0.1 //x=64.745 //y=7.585 //x2=64.83 //y2=7.585
r1387 (  725 728 ) resistor r=8.54496 //w=0.367 //l=0.245 //layer=li \
 //thickness=0.1 //x=64.745 //y=7.585 //x2=64.5 //y2=7.585
r1388 (  719 945 ) resistor r=4.23183 //w=0.7 //l=0.175 //layer=li \
 //thickness=0.1 //x=63.95 //y=7.41 //x2=63.95 //y2=7.585
r1389 (  719 1018 ) resistor r=33.1979 //w=0.187 //l=0.485 //layer=li \
 //thickness=0.1 //x=63.95 //y=7.41 //x2=63.95 //y2=6.925
r1390 (  716 944 ) resistor r=2.87058 //w=0.35 //l=0.085 //layer=li \
 //thickness=0.1 //x=63.155 //y=7.585 //x2=63.07 //y2=7.585
r1391 (  716 718 ) resistor r=8.19619 //w=0.367 //l=0.235 //layer=li \
 //thickness=0.1 //x=63.155 //y=7.585 //x2=63.39 //y2=7.585
r1392 (  715 945 ) resistor r=2.87058 //w=0.35 //l=0.085 //layer=li \
 //thickness=0.1 //x=63.865 //y=7.585 //x2=63.95 //y2=7.585
r1393 (  715 718 ) resistor r=16.5668 //w=0.367 //l=0.475 //layer=li \
 //thickness=0.1 //x=63.865 //y=7.585 //x2=63.39 //y2=7.585
r1394 (  709 944 ) resistor r=4.23183 //w=0.7 //l=0.175 //layer=li \
 //thickness=0.1 //x=63.07 //y=7.41 //x2=63.07 //y2=7.585
r1395 (  709 1017 ) resistor r=56.4706 //w=0.187 //l=0.825 //layer=li \
 //thickness=0.1 //x=63.07 //y=7.41 //x2=63.07 //y2=6.585
r1396 (  708 943 ) resistor r=5.29055 //w=0.35 //l=0.17 //layer=li \
 //thickness=0.1 //x=62.45 //y=7.585 //x2=62.28 //y2=7.585
r1397 (  707 944 ) resistor r=2.87058 //w=0.35 //l=0.085 //layer=li \
 //thickness=0.1 //x=62.985 //y=7.585 //x2=63.07 //y2=7.585
r1398 (  707 708 ) resistor r=18.6594 //w=0.367 //l=0.535 //layer=li \
 //thickness=0.1 //x=62.985 //y=7.585 //x2=62.45 //y2=7.585
r1399 (  702 942 ) resistor r=2.87058 //w=0.35 //l=0.085 //layer=li \
 //thickness=0.1 //x=61.285 //y=7.585 //x2=61.2 //y2=7.585
r1400 (  702 704 ) resistor r=21.7984 //w=0.367 //l=0.625 //layer=li \
 //thickness=0.1 //x=61.285 //y=7.585 //x2=61.91 //y2=7.585
r1401 (  701 943 ) resistor r=5.29055 //w=0.35 //l=0.17 //layer=li \
 //thickness=0.1 //x=62.11 //y=7.585 //x2=62.28 //y2=7.585
r1402 (  701 704 ) resistor r=6.97548 //w=0.367 //l=0.2 //layer=li \
 //thickness=0.1 //x=62.11 //y=7.585 //x2=61.91 //y2=7.585
r1403 (  695 942 ) resistor r=4.23183 //w=0.7 //l=0.175 //layer=li \
 //thickness=0.1 //x=61.2 //y=7.41 //x2=61.2 //y2=7.585
r1404 (  695 1016 ) resistor r=33.1979 //w=0.187 //l=0.485 //layer=li \
 //thickness=0.1 //x=61.2 //y=7.41 //x2=61.2 //y2=6.925
r1405 (  692 941 ) resistor r=2.87058 //w=0.35 //l=0.085 //layer=li \
 //thickness=0.1 //x=60.405 //y=7.585 //x2=60.32 //y2=7.585
r1406 (  692 694 ) resistor r=13.7766 //w=0.367 //l=0.395 //layer=li \
 //thickness=0.1 //x=60.405 //y=7.585 //x2=60.8 //y2=7.585
r1407 (  691 942 ) resistor r=2.87058 //w=0.35 //l=0.085 //layer=li \
 //thickness=0.1 //x=61.115 //y=7.585 //x2=61.2 //y2=7.585
r1408 (  691 694 ) resistor r=10.9864 //w=0.367 //l=0.315 //layer=li \
 //thickness=0.1 //x=61.115 //y=7.585 //x2=60.8 //y2=7.585
r1409 (  685 941 ) resistor r=4.23183 //w=0.7 //l=0.175 //layer=li \
 //thickness=0.1 //x=60.32 //y=7.41 //x2=60.32 //y2=7.585
r1410 (  685 1015 ) resistor r=33.1979 //w=0.187 //l=0.485 //layer=li \
 //thickness=0.1 //x=60.32 //y=7.41 //x2=60.32 //y2=6.925
r1411 (  682 940 ) resistor r=2.87058 //w=0.35 //l=0.085 //layer=li \
 //thickness=0.1 //x=59.525 //y=7.585 //x2=59.44 //y2=7.585
r1412 (  682 684 ) resistor r=5.75477 //w=0.367 //l=0.165 //layer=li \
 //thickness=0.1 //x=59.525 //y=7.585 //x2=59.69 //y2=7.585
r1413 (  681 941 ) resistor r=2.87058 //w=0.35 //l=0.085 //layer=li \
 //thickness=0.1 //x=60.235 //y=7.585 //x2=60.32 //y2=7.585
r1414 (  681 684 ) resistor r=19.0082 //w=0.367 //l=0.545 //layer=li \
 //thickness=0.1 //x=60.235 //y=7.585 //x2=59.69 //y2=7.585
r1415 (  675 940 ) resistor r=4.23183 //w=0.7 //l=0.175 //layer=li \
 //thickness=0.1 //x=59.44 //y=7.41 //x2=59.44 //y2=7.585
r1416 (  675 1014 ) resistor r=33.1979 //w=0.187 //l=0.485 //layer=li \
 //thickness=0.1 //x=59.44 //y=7.41 //x2=59.44 //y2=6.925
r1417 (  674 939 ) resistor r=2.87058 //w=0.35 //l=0.085 //layer=li \
 //thickness=0.1 //x=58.645 //y=7.585 //x2=58.56 //y2=7.585
r1418 (  673 940 ) resistor r=2.87058 //w=0.35 //l=0.085 //layer=li \
 //thickness=0.1 //x=59.355 //y=7.585 //x2=59.44 //y2=7.585
r1419 (  673 674 ) resistor r=24.7629 //w=0.367 //l=0.71 //layer=li \
 //thickness=0.1 //x=59.355 //y=7.585 //x2=58.645 //y2=7.585
r1420 (  667 939 ) resistor r=4.23183 //w=0.7 //l=0.175 //layer=li \
 //thickness=0.1 //x=58.56 //y=7.41 //x2=58.56 //y2=7.585
r1421 (  667 1013 ) resistor r=56.4706 //w=0.187 //l=0.825 //layer=li \
 //thickness=0.1 //x=58.56 //y=7.41 //x2=58.56 //y2=6.585
r1422 (  666 937 ) resistor r=5.29055 //w=0.35 //l=0.17 //layer=li \
 //thickness=0.1 //x=57.64 //y=7.585 //x2=57.47 //y2=7.585
r1423 (  665 939 ) resistor r=2.87058 //w=0.35 //l=0.085 //layer=li \
 //thickness=0.1 //x=58.475 //y=7.585 //x2=58.56 //y2=7.585
r1424 (  665 666 ) resistor r=29.1226 //w=0.367 //l=0.835 //layer=li \
 //thickness=0.1 //x=58.475 //y=7.585 //x2=57.64 //y2=7.585
r1425 (  660 936 ) resistor r=2.87058 //w=0.35 //l=0.085 //layer=li \
 //thickness=0.1 //x=56.475 //y=7.585 //x2=56.39 //y2=7.585
r1426 (  660 662 ) resistor r=21.7984 //w=0.367 //l=0.625 //layer=li \
 //thickness=0.1 //x=56.475 //y=7.585 //x2=57.1 //y2=7.585
r1427 (  659 937 ) resistor r=5.29055 //w=0.35 //l=0.17 //layer=li \
 //thickness=0.1 //x=57.3 //y=7.585 //x2=57.47 //y2=7.585
r1428 (  659 662 ) resistor r=6.97548 //w=0.367 //l=0.2 //layer=li \
 //thickness=0.1 //x=57.3 //y=7.585 //x2=57.1 //y2=7.585
r1429 (  653 936 ) resistor r=4.23183 //w=0.7 //l=0.175 //layer=li \
 //thickness=0.1 //x=56.39 //y=7.41 //x2=56.39 //y2=7.585
r1430 (  653 1012 ) resistor r=33.1979 //w=0.187 //l=0.485 //layer=li \
 //thickness=0.1 //x=56.39 //y=7.41 //x2=56.39 //y2=6.925
r1431 (  650 935 ) resistor r=2.87058 //w=0.35 //l=0.085 //layer=li \
 //thickness=0.1 //x=55.595 //y=7.585 //x2=55.51 //y2=7.585
r1432 (  650 652 ) resistor r=13.7766 //w=0.367 //l=0.395 //layer=li \
 //thickness=0.1 //x=55.595 //y=7.585 //x2=55.99 //y2=7.585
r1433 (  649 936 ) resistor r=2.87058 //w=0.35 //l=0.085 //layer=li \
 //thickness=0.1 //x=56.305 //y=7.585 //x2=56.39 //y2=7.585
r1434 (  649 652 ) resistor r=10.9864 //w=0.367 //l=0.315 //layer=li \
 //thickness=0.1 //x=56.305 //y=7.585 //x2=55.99 //y2=7.585
r1435 (  643 935 ) resistor r=4.23183 //w=0.7 //l=0.175 //layer=li \
 //thickness=0.1 //x=55.51 //y=7.41 //x2=55.51 //y2=7.585
r1436 (  643 1011 ) resistor r=33.1979 //w=0.187 //l=0.485 //layer=li \
 //thickness=0.1 //x=55.51 //y=7.41 //x2=55.51 //y2=6.925
r1437 (  640 934 ) resistor r=2.87058 //w=0.35 //l=0.085 //layer=li \
 //thickness=0.1 //x=54.715 //y=7.585 //x2=54.63 //y2=7.585
r1438 (  640 642 ) resistor r=5.75477 //w=0.367 //l=0.165 //layer=li \
 //thickness=0.1 //x=54.715 //y=7.585 //x2=54.88 //y2=7.585
r1439 (  639 935 ) resistor r=2.87058 //w=0.35 //l=0.085 //layer=li \
 //thickness=0.1 //x=55.425 //y=7.585 //x2=55.51 //y2=7.585
r1440 (  639 642 ) resistor r=19.0082 //w=0.367 //l=0.545 //layer=li \
 //thickness=0.1 //x=55.425 //y=7.585 //x2=54.88 //y2=7.585
r1441 (  633 934 ) resistor r=4.23183 //w=0.7 //l=0.175 //layer=li \
 //thickness=0.1 //x=54.63 //y=7.41 //x2=54.63 //y2=7.585
r1442 (  633 1010 ) resistor r=33.1979 //w=0.187 //l=0.485 //layer=li \
 //thickness=0.1 //x=54.63 //y=7.41 //x2=54.63 //y2=6.925
r1443 (  632 933 ) resistor r=2.87058 //w=0.35 //l=0.085 //layer=li \
 //thickness=0.1 //x=53.835 //y=7.585 //x2=53.75 //y2=7.585
r1444 (  631 934 ) resistor r=2.87058 //w=0.35 //l=0.085 //layer=li \
 //thickness=0.1 //x=54.545 //y=7.585 //x2=54.63 //y2=7.585
r1445 (  631 632 ) resistor r=24.7629 //w=0.367 //l=0.71 //layer=li \
 //thickness=0.1 //x=54.545 //y=7.585 //x2=53.835 //y2=7.585
r1446 (  625 933 ) resistor r=4.23183 //w=0.7 //l=0.175 //layer=li \
 //thickness=0.1 //x=53.75 //y=7.41 //x2=53.75 //y2=7.585
r1447 (  625 1009 ) resistor r=56.4706 //w=0.187 //l=0.825 //layer=li \
 //thickness=0.1 //x=53.75 //y=7.41 //x2=53.75 //y2=6.585
r1448 (  624 931 ) resistor r=5.29055 //w=0.35 //l=0.17 //layer=li \
 //thickness=0.1 //x=52.83 //y=7.585 //x2=52.66 //y2=7.585
r1449 (  623 933 ) resistor r=2.87058 //w=0.35 //l=0.085 //layer=li \
 //thickness=0.1 //x=53.665 //y=7.585 //x2=53.75 //y2=7.585
r1450 (  623 624 ) resistor r=29.1226 //w=0.367 //l=0.835 //layer=li \
 //thickness=0.1 //x=53.665 //y=7.585 //x2=52.83 //y2=7.585
r1451 (  618 930 ) resistor r=2.87058 //w=0.35 //l=0.085 //layer=li \
 //thickness=0.1 //x=51.965 //y=7.585 //x2=51.88 //y2=7.585
r1452 (  618 620 ) resistor r=11.3351 //w=0.367 //l=0.325 //layer=li \
 //thickness=0.1 //x=51.965 //y=7.585 //x2=52.29 //y2=7.585
r1453 (  617 931 ) resistor r=5.29055 //w=0.35 //l=0.17 //layer=li \
 //thickness=0.1 //x=52.49 //y=7.585 //x2=52.66 //y2=7.585
r1454 (  617 620 ) resistor r=6.97548 //w=0.367 //l=0.2 //layer=li \
 //thickness=0.1 //x=52.49 //y=7.585 //x2=52.29 //y2=7.585
r1455 (  611 930 ) resistor r=4.23183 //w=0.7 //l=0.175 //layer=li \
 //thickness=0.1 //x=51.88 //y=7.41 //x2=51.88 //y2=7.585
r1456 (  611 1008 ) resistor r=33.1979 //w=0.187 //l=0.485 //layer=li \
 //thickness=0.1 //x=51.88 //y=7.41 //x2=51.88 //y2=6.925
r1457 (  608 929 ) resistor r=2.87058 //w=0.35 //l=0.085 //layer=li \
 //thickness=0.1 //x=51.085 //y=7.585 //x2=51 //y2=7.585
r1458 (  608 610 ) resistor r=3.31335 //w=0.367 //l=0.095 //layer=li \
 //thickness=0.1 //x=51.085 //y=7.585 //x2=51.18 //y2=7.585
r1459 (  607 930 ) resistor r=2.87058 //w=0.35 //l=0.085 //layer=li \
 //thickness=0.1 //x=51.795 //y=7.585 //x2=51.88 //y2=7.585
r1460 (  607 610 ) resistor r=21.4496 //w=0.367 //l=0.615 //layer=li \
 //thickness=0.1 //x=51.795 //y=7.585 //x2=51.18 //y2=7.585
r1461 (  601 929 ) resistor r=4.23183 //w=0.7 //l=0.175 //layer=li \
 //thickness=0.1 //x=51 //y=7.41 //x2=51 //y2=7.585
r1462 (  601 1007 ) resistor r=33.1979 //w=0.187 //l=0.485 //layer=li \
 //thickness=0.1 //x=51 //y=7.41 //x2=51 //y2=6.925
r1463 (  600 928 ) resistor r=2.87058 //w=0.35 //l=0.085 //layer=li \
 //thickness=0.1 //x=50.205 //y=7.585 //x2=50.12 //y2=7.585
r1464 (  599 929 ) resistor r=2.87058 //w=0.35 //l=0.085 //layer=li \
 //thickness=0.1 //x=50.915 //y=7.585 //x2=51 //y2=7.585
r1465 (  599 600 ) resistor r=24.7629 //w=0.367 //l=0.71 //layer=li \
 //thickness=0.1 //x=50.915 //y=7.585 //x2=50.205 //y2=7.585
r1466 (  593 928 ) resistor r=4.23183 //w=0.7 //l=0.175 //layer=li \
 //thickness=0.1 //x=50.12 //y=7.41 //x2=50.12 //y2=7.585
r1467 (  593 1006 ) resistor r=56.4706 //w=0.187 //l=0.825 //layer=li \
 //thickness=0.1 //x=50.12 //y=7.41 //x2=50.12 //y2=6.585
r1468 (  592 926 ) resistor r=5.29055 //w=0.35 //l=0.17 //layer=li \
 //thickness=0.1 //x=49.5 //y=7.585 //x2=49.33 //y2=7.585
r1469 (  591 928 ) resistor r=2.87058 //w=0.35 //l=0.085 //layer=li \
 //thickness=0.1 //x=50.035 //y=7.585 //x2=50.12 //y2=7.585
r1470 (  591 592 ) resistor r=18.6594 //w=0.367 //l=0.535 //layer=li \
 //thickness=0.1 //x=50.035 //y=7.585 //x2=49.5 //y2=7.585
r1471 (  586 925 ) resistor r=2.87058 //w=0.35 //l=0.085 //layer=li \
 //thickness=0.1 //x=48.335 //y=7.585 //x2=48.25 //y2=7.585
r1472 (  586 588 ) resistor r=8.89373 //w=0.367 //l=0.255 //layer=li \
 //thickness=0.1 //x=48.335 //y=7.585 //x2=48.59 //y2=7.585
r1473 (  585 926 ) resistor r=5.29055 //w=0.35 //l=0.17 //layer=li \
 //thickness=0.1 //x=49.16 //y=7.585 //x2=49.33 //y2=7.585
r1474 (  585 588 ) resistor r=19.8801 //w=0.367 //l=0.57 //layer=li \
 //thickness=0.1 //x=49.16 //y=7.585 //x2=48.59 //y2=7.585
r1475 (  579 925 ) resistor r=4.23183 //w=0.7 //l=0.175 //layer=li \
 //thickness=0.1 //x=48.25 //y=7.41 //x2=48.25 //y2=7.585
r1476 (  579 1005 ) resistor r=33.1979 //w=0.187 //l=0.485 //layer=li \
 //thickness=0.1 //x=48.25 //y=7.41 //x2=48.25 //y2=6.925
r1477 (  576 924 ) resistor r=2.87058 //w=0.35 //l=0.085 //layer=li \
 //thickness=0.1 //x=47.455 //y=7.585 //x2=47.37 //y2=7.585
r1478 (  576 578 ) resistor r=0.871935 //w=0.367 //l=0.025 //layer=li \
 //thickness=0.1 //x=47.455 //y=7.585 //x2=47.48 //y2=7.585
r1479 (  575 925 ) resistor r=2.87058 //w=0.35 //l=0.085 //layer=li \
 //thickness=0.1 //x=48.165 //y=7.585 //x2=48.25 //y2=7.585
r1480 (  575 578 ) resistor r=23.891 //w=0.367 //l=0.685 //layer=li \
 //thickness=0.1 //x=48.165 //y=7.585 //x2=47.48 //y2=7.585
r1481 (  569 924 ) resistor r=4.23183 //w=0.7 //l=0.175 //layer=li \
 //thickness=0.1 //x=47.37 //y=7.41 //x2=47.37 //y2=7.585
r1482 (  569 1004 ) resistor r=33.1979 //w=0.187 //l=0.485 //layer=li \
 //thickness=0.1 //x=47.37 //y=7.41 //x2=47.37 //y2=6.925
r1483 (  568 923 ) resistor r=2.87058 //w=0.35 //l=0.085 //layer=li \
 //thickness=0.1 //x=46.575 //y=7.585 //x2=46.49 //y2=7.585
r1484 (  567 924 ) resistor r=2.87058 //w=0.35 //l=0.085 //layer=li \
 //thickness=0.1 //x=47.285 //y=7.585 //x2=47.37 //y2=7.585
r1485 (  567 568 ) resistor r=24.7629 //w=0.367 //l=0.71 //layer=li \
 //thickness=0.1 //x=47.285 //y=7.585 //x2=46.575 //y2=7.585
r1486 (  561 923 ) resistor r=4.23183 //w=0.7 //l=0.175 //layer=li \
 //thickness=0.1 //x=46.49 //y=7.41 //x2=46.49 //y2=7.585
r1487 (  561 1003 ) resistor r=33.1979 //w=0.187 //l=0.485 //layer=li \
 //thickness=0.1 //x=46.49 //y=7.41 //x2=46.49 //y2=6.925
r1488 (  558 922 ) resistor r=2.87058 //w=0.35 //l=0.085 //layer=li \
 //thickness=0.1 //x=45.695 //y=7.585 //x2=45.61 //y2=7.585
r1489 (  558 560 ) resistor r=23.5422 //w=0.367 //l=0.675 //layer=li \
 //thickness=0.1 //x=45.695 //y=7.585 //x2=46.37 //y2=7.585
r1490 (  557 923 ) resistor r=2.87058 //w=0.35 //l=0.085 //layer=li \
 //thickness=0.1 //x=46.405 //y=7.585 //x2=46.49 //y2=7.585
r1491 (  557 560 ) resistor r=1.22071 //w=0.367 //l=0.035 //layer=li \
 //thickness=0.1 //x=46.405 //y=7.585 //x2=46.37 //y2=7.585
r1492 (  551 922 ) resistor r=4.23183 //w=0.7 //l=0.175 //layer=li \
 //thickness=0.1 //x=45.61 //y=7.41 //x2=45.61 //y2=7.585
r1493 (  551 1002 ) resistor r=56.4706 //w=0.187 //l=0.825 //layer=li \
 //thickness=0.1 //x=45.61 //y=7.41 //x2=45.61 //y2=6.585
r1494 (  548 921 ) resistor r=5.29055 //w=0.35 //l=0.17 //layer=li \
 //thickness=0.1 //x=44.69 //y=7.585 //x2=44.52 //y2=7.585
r1495 (  548 550 ) resistor r=19.8801 //w=0.367 //l=0.57 //layer=li \
 //thickness=0.1 //x=44.69 //y=7.585 //x2=45.26 //y2=7.585
r1496 (  547 922 ) resistor r=2.87058 //w=0.35 //l=0.085 //layer=li \
 //thickness=0.1 //x=45.525 //y=7.585 //x2=45.61 //y2=7.585
r1497 (  547 550 ) resistor r=9.24251 //w=0.367 //l=0.265 //layer=li \
 //thickness=0.1 //x=45.525 //y=7.585 //x2=45.26 //y2=7.585
r1498 (  544 920 ) resistor r=2.87058 //w=0.35 //l=0.085 //layer=li \
 //thickness=0.1 //x=43.825 //y=7.585 //x2=43.74 //y2=7.585
r1499 (  543 921 ) resistor r=5.29055 //w=0.35 //l=0.17 //layer=li \
 //thickness=0.1 //x=44.35 //y=7.585 //x2=44.52 //y2=7.585
r1500 (  543 544 ) resistor r=18.3106 //w=0.367 //l=0.525 //layer=li \
 //thickness=0.1 //x=44.35 //y=7.585 //x2=43.825 //y2=7.585
r1501 (  537 920 ) resistor r=4.23183 //w=0.7 //l=0.175 //layer=li \
 //thickness=0.1 //x=43.74 //y=7.41 //x2=43.74 //y2=7.585
r1502 (  537 1001 ) resistor r=33.1979 //w=0.187 //l=0.485 //layer=li \
 //thickness=0.1 //x=43.74 //y=7.41 //x2=43.74 //y2=6.925
r1503 (  536 918 ) resistor r=2.87058 //w=0.35 //l=0.085 //layer=li \
 //thickness=0.1 //x=42.945 //y=7.585 //x2=42.86 //y2=7.585
r1504 (  535 920 ) resistor r=2.87058 //w=0.35 //l=0.085 //layer=li \
 //thickness=0.1 //x=43.655 //y=7.585 //x2=43.74 //y2=7.585
r1505 (  535 536 ) resistor r=24.7629 //w=0.367 //l=0.71 //layer=li \
 //thickness=0.1 //x=43.655 //y=7.585 //x2=42.945 //y2=7.585
r1506 (  529 918 ) resistor r=4.23183 //w=0.7 //l=0.175 //layer=li \
 //thickness=0.1 //x=42.86 //y=7.41 //x2=42.86 //y2=7.585
r1507 (  529 1000 ) resistor r=33.1979 //w=0.187 //l=0.485 //layer=li \
 //thickness=0.1 //x=42.86 //y=7.41 //x2=42.86 //y2=6.925
r1508 (  526 917 ) resistor r=2.87058 //w=0.35 //l=0.085 //layer=li \
 //thickness=0.1 //x=42.065 //y=7.585 //x2=41.98 //y2=7.585
r1509 (  526 528 ) resistor r=21.1008 //w=0.367 //l=0.605 //layer=li \
 //thickness=0.1 //x=42.065 //y=7.585 //x2=42.67 //y2=7.585
r1510 (  525 918 ) resistor r=2.87058 //w=0.35 //l=0.085 //layer=li \
 //thickness=0.1 //x=42.775 //y=7.585 //x2=42.86 //y2=7.585
r1511 (  525 528 ) resistor r=3.66213 //w=0.367 //l=0.105 //layer=li \
 //thickness=0.1 //x=42.775 //y=7.585 //x2=42.67 //y2=7.585
r1512 (  519 917 ) resistor r=4.23183 //w=0.7 //l=0.175 //layer=li \
 //thickness=0.1 //x=41.98 //y=7.41 //x2=41.98 //y2=7.585
r1513 (  519 999 ) resistor r=56.4706 //w=0.187 //l=0.825 //layer=li \
 //thickness=0.1 //x=41.98 //y=7.41 //x2=41.98 //y2=6.585
r1514 (  516 916 ) resistor r=5.29055 //w=0.35 //l=0.17 //layer=li \
 //thickness=0.1 //x=41.36 //y=7.585 //x2=41.19 //y2=7.585
r1515 (  516 518 ) resistor r=6.97548 //w=0.367 //l=0.2 //layer=li \
 //thickness=0.1 //x=41.36 //y=7.585 //x2=41.56 //y2=7.585
r1516 (  515 917 ) resistor r=2.87058 //w=0.35 //l=0.085 //layer=li \
 //thickness=0.1 //x=41.895 //y=7.585 //x2=41.98 //y2=7.585
r1517 (  515 518 ) resistor r=11.6839 //w=0.367 //l=0.335 //layer=li \
 //thickness=0.1 //x=41.895 //y=7.585 //x2=41.56 //y2=7.585
r1518 (  512 915 ) resistor r=2.87058 //w=0.35 //l=0.085 //layer=li \
 //thickness=0.1 //x=40.495 //y=7.585 //x2=40.41 //y2=7.585
r1519 (  511 916 ) resistor r=5.29055 //w=0.35 //l=0.17 //layer=li \
 //thickness=0.1 //x=41.02 //y=7.585 //x2=41.19 //y2=7.585
r1520 (  511 512 ) resistor r=18.3106 //w=0.367 //l=0.525 //layer=li \
 //thickness=0.1 //x=41.02 //y=7.585 //x2=40.495 //y2=7.585
r1521 (  505 915 ) resistor r=4.23183 //w=0.7 //l=0.175 //layer=li \
 //thickness=0.1 //x=40.41 //y=7.41 //x2=40.41 //y2=7.585
r1522 (  505 998 ) resistor r=33.1979 //w=0.187 //l=0.485 //layer=li \
 //thickness=0.1 //x=40.41 //y=7.41 //x2=40.41 //y2=6.925
r1523 (  502 914 ) resistor r=2.87058 //w=0.35 //l=0.085 //layer=li \
 //thickness=0.1 //x=39.615 //y=7.585 //x2=39.53 //y2=7.585
r1524 (  502 504 ) resistor r=16.218 //w=0.367 //l=0.465 //layer=li \
 //thickness=0.1 //x=39.615 //y=7.585 //x2=40.08 //y2=7.585
r1525 (  501 915 ) resistor r=2.87058 //w=0.35 //l=0.085 //layer=li \
 //thickness=0.1 //x=40.325 //y=7.585 //x2=40.41 //y2=7.585
r1526 (  501 504 ) resistor r=8.54496 //w=0.367 //l=0.245 //layer=li \
 //thickness=0.1 //x=40.325 //y=7.585 //x2=40.08 //y2=7.585
r1527 (  495 914 ) resistor r=4.23183 //w=0.7 //l=0.175 //layer=li \
 //thickness=0.1 //x=39.53 //y=7.41 //x2=39.53 //y2=7.585
r1528 (  495 997 ) resistor r=33.1979 //w=0.187 //l=0.485 //layer=li \
 //thickness=0.1 //x=39.53 //y=7.41 //x2=39.53 //y2=6.925
r1529 (  492 913 ) resistor r=2.87058 //w=0.35 //l=0.085 //layer=li \
 //thickness=0.1 //x=38.735 //y=7.585 //x2=38.65 //y2=7.585
r1530 (  492 494 ) resistor r=8.19619 //w=0.367 //l=0.235 //layer=li \
 //thickness=0.1 //x=38.735 //y=7.585 //x2=38.97 //y2=7.585
r1531 (  491 914 ) resistor r=2.87058 //w=0.35 //l=0.085 //layer=li \
 //thickness=0.1 //x=39.445 //y=7.585 //x2=39.53 //y2=7.585
r1532 (  491 494 ) resistor r=16.5668 //w=0.367 //l=0.475 //layer=li \
 //thickness=0.1 //x=39.445 //y=7.585 //x2=38.97 //y2=7.585
r1533 (  485 913 ) resistor r=4.23183 //w=0.7 //l=0.175 //layer=li \
 //thickness=0.1 //x=38.65 //y=7.41 //x2=38.65 //y2=7.585
r1534 (  485 996 ) resistor r=56.4706 //w=0.187 //l=0.825 //layer=li \
 //thickness=0.1 //x=38.65 //y=7.41 //x2=38.65 //y2=6.585
r1535 (  484 912 ) resistor r=5.29055 //w=0.35 //l=0.17 //layer=li \
 //thickness=0.1 //x=38.03 //y=7.585 //x2=37.86 //y2=7.585
r1536 (  483 913 ) resistor r=2.87058 //w=0.35 //l=0.085 //layer=li \
 //thickness=0.1 //x=38.565 //y=7.585 //x2=38.65 //y2=7.585
r1537 (  483 484 ) resistor r=18.6594 //w=0.367 //l=0.535 //layer=li \
 //thickness=0.1 //x=38.565 //y=7.585 //x2=38.03 //y2=7.585
r1538 (  478 911 ) resistor r=2.87058 //w=0.35 //l=0.085 //layer=li \
 //thickness=0.1 //x=36.865 //y=7.585 //x2=36.78 //y2=7.585
r1539 (  478 480 ) resistor r=21.7984 //w=0.367 //l=0.625 //layer=li \
 //thickness=0.1 //x=36.865 //y=7.585 //x2=37.49 //y2=7.585
r1540 (  477 912 ) resistor r=5.29055 //w=0.35 //l=0.17 //layer=li \
 //thickness=0.1 //x=37.69 //y=7.585 //x2=37.86 //y2=7.585
r1541 (  477 480 ) resistor r=6.97548 //w=0.367 //l=0.2 //layer=li \
 //thickness=0.1 //x=37.69 //y=7.585 //x2=37.49 //y2=7.585
r1542 (  471 911 ) resistor r=4.23183 //w=0.7 //l=0.175 //layer=li \
 //thickness=0.1 //x=36.78 //y=7.41 //x2=36.78 //y2=7.585
r1543 (  471 995 ) resistor r=33.1979 //w=0.187 //l=0.485 //layer=li \
 //thickness=0.1 //x=36.78 //y=7.41 //x2=36.78 //y2=6.925
r1544 (  468 910 ) resistor r=2.87058 //w=0.35 //l=0.085 //layer=li \
 //thickness=0.1 //x=35.985 //y=7.585 //x2=35.9 //y2=7.585
r1545 (  468 470 ) resistor r=13.7766 //w=0.367 //l=0.395 //layer=li \
 //thickness=0.1 //x=35.985 //y=7.585 //x2=36.38 //y2=7.585
r1546 (  467 911 ) resistor r=2.87058 //w=0.35 //l=0.085 //layer=li \
 //thickness=0.1 //x=36.695 //y=7.585 //x2=36.78 //y2=7.585
r1547 (  467 470 ) resistor r=10.9864 //w=0.367 //l=0.315 //layer=li \
 //thickness=0.1 //x=36.695 //y=7.585 //x2=36.38 //y2=7.585
r1548 (  461 910 ) resistor r=4.23183 //w=0.7 //l=0.175 //layer=li \
 //thickness=0.1 //x=35.9 //y=7.41 //x2=35.9 //y2=7.585
r1549 (  461 994 ) resistor r=33.1979 //w=0.187 //l=0.485 //layer=li \
 //thickness=0.1 //x=35.9 //y=7.41 //x2=35.9 //y2=6.925
r1550 (  458 909 ) resistor r=2.87058 //w=0.35 //l=0.085 //layer=li \
 //thickness=0.1 //x=35.105 //y=7.585 //x2=35.02 //y2=7.585
r1551 (  458 460 ) resistor r=5.75477 //w=0.367 //l=0.165 //layer=li \
 //thickness=0.1 //x=35.105 //y=7.585 //x2=35.27 //y2=7.585
r1552 (  457 910 ) resistor r=2.87058 //w=0.35 //l=0.085 //layer=li \
 //thickness=0.1 //x=35.815 //y=7.585 //x2=35.9 //y2=7.585
r1553 (  457 460 ) resistor r=19.0082 //w=0.367 //l=0.545 //layer=li \
 //thickness=0.1 //x=35.815 //y=7.585 //x2=35.27 //y2=7.585
r1554 (  451 909 ) resistor r=4.23183 //w=0.7 //l=0.175 //layer=li \
 //thickness=0.1 //x=35.02 //y=7.41 //x2=35.02 //y2=7.585
r1555 (  451 993 ) resistor r=33.1979 //w=0.187 //l=0.485 //layer=li \
 //thickness=0.1 //x=35.02 //y=7.41 //x2=35.02 //y2=6.925
r1556 (  450 908 ) resistor r=2.87058 //w=0.35 //l=0.085 //layer=li \
 //thickness=0.1 //x=34.225 //y=7.585 //x2=34.14 //y2=7.585
r1557 (  449 909 ) resistor r=2.87058 //w=0.35 //l=0.085 //layer=li \
 //thickness=0.1 //x=34.935 //y=7.585 //x2=35.02 //y2=7.585
r1558 (  449 450 ) resistor r=24.7629 //w=0.367 //l=0.71 //layer=li \
 //thickness=0.1 //x=34.935 //y=7.585 //x2=34.225 //y2=7.585
r1559 (  443 908 ) resistor r=4.23183 //w=0.7 //l=0.175 //layer=li \
 //thickness=0.1 //x=34.14 //y=7.41 //x2=34.14 //y2=7.585
r1560 (  443 992 ) resistor r=56.4706 //w=0.187 //l=0.825 //layer=li \
 //thickness=0.1 //x=34.14 //y=7.41 //x2=34.14 //y2=6.585
r1561 (  442 906 ) resistor r=5.29055 //w=0.35 //l=0.17 //layer=li \
 //thickness=0.1 //x=33.22 //y=7.585 //x2=33.05 //y2=7.585
r1562 (  441 908 ) resistor r=2.87058 //w=0.35 //l=0.085 //layer=li \
 //thickness=0.1 //x=34.055 //y=7.585 //x2=34.14 //y2=7.585
r1563 (  441 442 ) resistor r=29.1226 //w=0.367 //l=0.835 //layer=li \
 //thickness=0.1 //x=34.055 //y=7.585 //x2=33.22 //y2=7.585
r1564 (  436 905 ) resistor r=2.87058 //w=0.35 //l=0.085 //layer=li \
 //thickness=0.1 //x=32.055 //y=7.585 //x2=31.97 //y2=7.585
r1565 (  436 438 ) resistor r=21.7984 //w=0.367 //l=0.625 //layer=li \
 //thickness=0.1 //x=32.055 //y=7.585 //x2=32.68 //y2=7.585
r1566 (  435 906 ) resistor r=5.29055 //w=0.35 //l=0.17 //layer=li \
 //thickness=0.1 //x=32.88 //y=7.585 //x2=33.05 //y2=7.585
r1567 (  435 438 ) resistor r=6.97548 //w=0.367 //l=0.2 //layer=li \
 //thickness=0.1 //x=32.88 //y=7.585 //x2=32.68 //y2=7.585
r1568 (  429 905 ) resistor r=4.23183 //w=0.7 //l=0.175 //layer=li \
 //thickness=0.1 //x=31.97 //y=7.41 //x2=31.97 //y2=7.585
r1569 (  429 991 ) resistor r=33.1979 //w=0.187 //l=0.485 //layer=li \
 //thickness=0.1 //x=31.97 //y=7.41 //x2=31.97 //y2=6.925
r1570 (  426 904 ) resistor r=2.87058 //w=0.35 //l=0.085 //layer=li \
 //thickness=0.1 //x=31.175 //y=7.585 //x2=31.09 //y2=7.585
r1571 (  426 428 ) resistor r=13.7766 //w=0.367 //l=0.395 //layer=li \
 //thickness=0.1 //x=31.175 //y=7.585 //x2=31.57 //y2=7.585
r1572 (  425 905 ) resistor r=2.87058 //w=0.35 //l=0.085 //layer=li \
 //thickness=0.1 //x=31.885 //y=7.585 //x2=31.97 //y2=7.585
r1573 (  425 428 ) resistor r=10.9864 //w=0.367 //l=0.315 //layer=li \
 //thickness=0.1 //x=31.885 //y=7.585 //x2=31.57 //y2=7.585
r1574 (  419 904 ) resistor r=4.23183 //w=0.7 //l=0.175 //layer=li \
 //thickness=0.1 //x=31.09 //y=7.41 //x2=31.09 //y2=7.585
r1575 (  419 990 ) resistor r=33.1979 //w=0.187 //l=0.485 //layer=li \
 //thickness=0.1 //x=31.09 //y=7.41 //x2=31.09 //y2=6.925
r1576 (  416 903 ) resistor r=2.87058 //w=0.35 //l=0.085 //layer=li \
 //thickness=0.1 //x=30.295 //y=7.585 //x2=30.21 //y2=7.585
r1577 (  416 418 ) resistor r=5.75477 //w=0.367 //l=0.165 //layer=li \
 //thickness=0.1 //x=30.295 //y=7.585 //x2=30.46 //y2=7.585
r1578 (  415 904 ) resistor r=2.87058 //w=0.35 //l=0.085 //layer=li \
 //thickness=0.1 //x=31.005 //y=7.585 //x2=31.09 //y2=7.585
r1579 (  415 418 ) resistor r=19.0082 //w=0.367 //l=0.545 //layer=li \
 //thickness=0.1 //x=31.005 //y=7.585 //x2=30.46 //y2=7.585
r1580 (  409 903 ) resistor r=4.23183 //w=0.7 //l=0.175 //layer=li \
 //thickness=0.1 //x=30.21 //y=7.41 //x2=30.21 //y2=7.585
r1581 (  409 989 ) resistor r=33.1979 //w=0.187 //l=0.485 //layer=li \
 //thickness=0.1 //x=30.21 //y=7.41 //x2=30.21 //y2=6.925
r1582 (  408 902 ) resistor r=2.87058 //w=0.35 //l=0.085 //layer=li \
 //thickness=0.1 //x=29.415 //y=7.585 //x2=29.33 //y2=7.585
r1583 (  407 903 ) resistor r=2.87058 //w=0.35 //l=0.085 //layer=li \
 //thickness=0.1 //x=30.125 //y=7.585 //x2=30.21 //y2=7.585
r1584 (  407 408 ) resistor r=24.7629 //w=0.367 //l=0.71 //layer=li \
 //thickness=0.1 //x=30.125 //y=7.585 //x2=29.415 //y2=7.585
r1585 (  401 902 ) resistor r=4.23183 //w=0.7 //l=0.175 //layer=li \
 //thickness=0.1 //x=29.33 //y=7.41 //x2=29.33 //y2=7.585
r1586 (  401 988 ) resistor r=56.4706 //w=0.187 //l=0.825 //layer=li \
 //thickness=0.1 //x=29.33 //y=7.41 //x2=29.33 //y2=6.585
r1587 (  400 900 ) resistor r=5.29055 //w=0.35 //l=0.17 //layer=li \
 //thickness=0.1 //x=28.41 //y=7.585 //x2=28.24 //y2=7.585
r1588 (  399 902 ) resistor r=2.87058 //w=0.35 //l=0.085 //layer=li \
 //thickness=0.1 //x=29.245 //y=7.585 //x2=29.33 //y2=7.585
r1589 (  399 400 ) resistor r=29.1226 //w=0.367 //l=0.835 //layer=li \
 //thickness=0.1 //x=29.245 //y=7.585 //x2=28.41 //y2=7.585
r1590 (  394 899 ) resistor r=2.87058 //w=0.35 //l=0.085 //layer=li \
 //thickness=0.1 //x=27.545 //y=7.585 //x2=27.46 //y2=7.585
r1591 (  394 396 ) resistor r=11.3351 //w=0.367 //l=0.325 //layer=li \
 //thickness=0.1 //x=27.545 //y=7.585 //x2=27.87 //y2=7.585
r1592 (  393 900 ) resistor r=5.29055 //w=0.35 //l=0.17 //layer=li \
 //thickness=0.1 //x=28.07 //y=7.585 //x2=28.24 //y2=7.585
r1593 (  393 396 ) resistor r=6.97548 //w=0.367 //l=0.2 //layer=li \
 //thickness=0.1 //x=28.07 //y=7.585 //x2=27.87 //y2=7.585
r1594 (  387 899 ) resistor r=4.23183 //w=0.7 //l=0.175 //layer=li \
 //thickness=0.1 //x=27.46 //y=7.41 //x2=27.46 //y2=7.585
r1595 (  387 987 ) resistor r=33.1979 //w=0.187 //l=0.485 //layer=li \
 //thickness=0.1 //x=27.46 //y=7.41 //x2=27.46 //y2=6.925
r1596 (  384 898 ) resistor r=2.87058 //w=0.35 //l=0.085 //layer=li \
 //thickness=0.1 //x=26.665 //y=7.585 //x2=26.58 //y2=7.585
r1597 (  384 386 ) resistor r=3.31335 //w=0.367 //l=0.095 //layer=li \
 //thickness=0.1 //x=26.665 //y=7.585 //x2=26.76 //y2=7.585
r1598 (  383 899 ) resistor r=2.87058 //w=0.35 //l=0.085 //layer=li \
 //thickness=0.1 //x=27.375 //y=7.585 //x2=27.46 //y2=7.585
r1599 (  383 386 ) resistor r=21.4496 //w=0.367 //l=0.615 //layer=li \
 //thickness=0.1 //x=27.375 //y=7.585 //x2=26.76 //y2=7.585
r1600 (  377 898 ) resistor r=4.23183 //w=0.7 //l=0.175 //layer=li \
 //thickness=0.1 //x=26.58 //y=7.41 //x2=26.58 //y2=7.585
r1601 (  377 986 ) resistor r=33.1979 //w=0.187 //l=0.485 //layer=li \
 //thickness=0.1 //x=26.58 //y=7.41 //x2=26.58 //y2=6.925
r1602 (  376 897 ) resistor r=2.87058 //w=0.35 //l=0.085 //layer=li \
 //thickness=0.1 //x=25.785 //y=7.585 //x2=25.7 //y2=7.585
r1603 (  375 898 ) resistor r=2.87058 //w=0.35 //l=0.085 //layer=li \
 //thickness=0.1 //x=26.495 //y=7.585 //x2=26.58 //y2=7.585
r1604 (  375 376 ) resistor r=24.7629 //w=0.367 //l=0.71 //layer=li \
 //thickness=0.1 //x=26.495 //y=7.585 //x2=25.785 //y2=7.585
r1605 (  369 897 ) resistor r=4.23183 //w=0.7 //l=0.175 //layer=li \
 //thickness=0.1 //x=25.7 //y=7.41 //x2=25.7 //y2=7.585
r1606 (  369 985 ) resistor r=56.4706 //w=0.187 //l=0.825 //layer=li \
 //thickness=0.1 //x=25.7 //y=7.41 //x2=25.7 //y2=6.585
r1607 (  368 895 ) resistor r=5.29055 //w=0.35 //l=0.17 //layer=li \
 //thickness=0.1 //x=25.08 //y=7.585 //x2=24.91 //y2=7.585
r1608 (  367 897 ) resistor r=2.87058 //w=0.35 //l=0.085 //layer=li \
 //thickness=0.1 //x=25.615 //y=7.585 //x2=25.7 //y2=7.585
r1609 (  367 368 ) resistor r=18.6594 //w=0.367 //l=0.535 //layer=li \
 //thickness=0.1 //x=25.615 //y=7.585 //x2=25.08 //y2=7.585
r1610 (  362 894 ) resistor r=2.87058 //w=0.35 //l=0.085 //layer=li \
 //thickness=0.1 //x=23.915 //y=7.585 //x2=23.83 //y2=7.585
r1611 (  362 364 ) resistor r=8.89373 //w=0.367 //l=0.255 //layer=li \
 //thickness=0.1 //x=23.915 //y=7.585 //x2=24.17 //y2=7.585
r1612 (  361 895 ) resistor r=5.29055 //w=0.35 //l=0.17 //layer=li \
 //thickness=0.1 //x=24.74 //y=7.585 //x2=24.91 //y2=7.585
r1613 (  361 364 ) resistor r=19.8801 //w=0.367 //l=0.57 //layer=li \
 //thickness=0.1 //x=24.74 //y=7.585 //x2=24.17 //y2=7.585
r1614 (  355 894 ) resistor r=4.23183 //w=0.7 //l=0.175 //layer=li \
 //thickness=0.1 //x=23.83 //y=7.41 //x2=23.83 //y2=7.585
r1615 (  355 984 ) resistor r=33.1979 //w=0.187 //l=0.485 //layer=li \
 //thickness=0.1 //x=23.83 //y=7.41 //x2=23.83 //y2=6.925
r1616 (  352 893 ) resistor r=2.87058 //w=0.35 //l=0.085 //layer=li \
 //thickness=0.1 //x=23.035 //y=7.585 //x2=22.95 //y2=7.585
r1617 (  352 354 ) resistor r=0.871935 //w=0.367 //l=0.025 //layer=li \
 //thickness=0.1 //x=23.035 //y=7.585 //x2=23.06 //y2=7.585
r1618 (  351 894 ) resistor r=2.87058 //w=0.35 //l=0.085 //layer=li \
 //thickness=0.1 //x=23.745 //y=7.585 //x2=23.83 //y2=7.585
r1619 (  351 354 ) resistor r=23.891 //w=0.367 //l=0.685 //layer=li \
 //thickness=0.1 //x=23.745 //y=7.585 //x2=23.06 //y2=7.585
r1620 (  345 893 ) resistor r=4.23183 //w=0.7 //l=0.175 //layer=li \
 //thickness=0.1 //x=22.95 //y=7.41 //x2=22.95 //y2=7.585
r1621 (  345 983 ) resistor r=33.1979 //w=0.187 //l=0.485 //layer=li \
 //thickness=0.1 //x=22.95 //y=7.41 //x2=22.95 //y2=6.925
r1622 (  344 892 ) resistor r=2.87058 //w=0.35 //l=0.085 //layer=li \
 //thickness=0.1 //x=22.155 //y=7.585 //x2=22.07 //y2=7.585
r1623 (  343 893 ) resistor r=2.87058 //w=0.35 //l=0.085 //layer=li \
 //thickness=0.1 //x=22.865 //y=7.585 //x2=22.95 //y2=7.585
r1624 (  343 344 ) resistor r=24.7629 //w=0.367 //l=0.71 //layer=li \
 //thickness=0.1 //x=22.865 //y=7.585 //x2=22.155 //y2=7.585
r1625 (  337 892 ) resistor r=4.23183 //w=0.7 //l=0.175 //layer=li \
 //thickness=0.1 //x=22.07 //y=7.41 //x2=22.07 //y2=7.585
r1626 (  337 982 ) resistor r=33.1979 //w=0.187 //l=0.485 //layer=li \
 //thickness=0.1 //x=22.07 //y=7.41 //x2=22.07 //y2=6.925
r1627 (  334 891 ) resistor r=2.87058 //w=0.35 //l=0.085 //layer=li \
 //thickness=0.1 //x=21.275 //y=7.585 //x2=21.19 //y2=7.585
r1628 (  334 336 ) resistor r=23.5422 //w=0.367 //l=0.675 //layer=li \
 //thickness=0.1 //x=21.275 //y=7.585 //x2=21.95 //y2=7.585
r1629 (  333 892 ) resistor r=2.87058 //w=0.35 //l=0.085 //layer=li \
 //thickness=0.1 //x=21.985 //y=7.585 //x2=22.07 //y2=7.585
r1630 (  333 336 ) resistor r=1.22071 //w=0.367 //l=0.035 //layer=li \
 //thickness=0.1 //x=21.985 //y=7.585 //x2=21.95 //y2=7.585
r1631 (  327 891 ) resistor r=4.23183 //w=0.7 //l=0.175 //layer=li \
 //thickness=0.1 //x=21.19 //y=7.41 //x2=21.19 //y2=7.585
r1632 (  327 981 ) resistor r=56.4706 //w=0.187 //l=0.825 //layer=li \
 //thickness=0.1 //x=21.19 //y=7.41 //x2=21.19 //y2=6.585
r1633 (  324 890 ) resistor r=5.29055 //w=0.35 //l=0.17 //layer=li \
 //thickness=0.1 //x=20.27 //y=7.585 //x2=20.1 //y2=7.585
r1634 (  324 326 ) resistor r=19.8801 //w=0.367 //l=0.57 //layer=li \
 //thickness=0.1 //x=20.27 //y=7.585 //x2=20.84 //y2=7.585
r1635 (  323 891 ) resistor r=2.87058 //w=0.35 //l=0.085 //layer=li \
 //thickness=0.1 //x=21.105 //y=7.585 //x2=21.19 //y2=7.585
r1636 (  323 326 ) resistor r=9.24251 //w=0.367 //l=0.265 //layer=li \
 //thickness=0.1 //x=21.105 //y=7.585 //x2=20.84 //y2=7.585
r1637 (  320 889 ) resistor r=2.87058 //w=0.35 //l=0.085 //layer=li \
 //thickness=0.1 //x=19.405 //y=7.585 //x2=19.32 //y2=7.585
r1638 (  319 890 ) resistor r=5.29055 //w=0.35 //l=0.17 //layer=li \
 //thickness=0.1 //x=19.93 //y=7.585 //x2=20.1 //y2=7.585
r1639 (  319 320 ) resistor r=18.3106 //w=0.367 //l=0.525 //layer=li \
 //thickness=0.1 //x=19.93 //y=7.585 //x2=19.405 //y2=7.585
r1640 (  313 889 ) resistor r=4.23183 //w=0.7 //l=0.175 //layer=li \
 //thickness=0.1 //x=19.32 //y=7.41 //x2=19.32 //y2=7.585
r1641 (  313 980 ) resistor r=33.1979 //w=0.187 //l=0.485 //layer=li \
 //thickness=0.1 //x=19.32 //y=7.41 //x2=19.32 //y2=6.925
r1642 (  312 887 ) resistor r=2.87058 //w=0.35 //l=0.085 //layer=li \
 //thickness=0.1 //x=18.525 //y=7.585 //x2=18.44 //y2=7.585
r1643 (  311 889 ) resistor r=2.87058 //w=0.35 //l=0.085 //layer=li \
 //thickness=0.1 //x=19.235 //y=7.585 //x2=19.32 //y2=7.585
r1644 (  311 312 ) resistor r=24.7629 //w=0.367 //l=0.71 //layer=li \
 //thickness=0.1 //x=19.235 //y=7.585 //x2=18.525 //y2=7.585
r1645 (  305 887 ) resistor r=4.23183 //w=0.7 //l=0.175 //layer=li \
 //thickness=0.1 //x=18.44 //y=7.41 //x2=18.44 //y2=7.585
r1646 (  305 979 ) resistor r=33.1979 //w=0.187 //l=0.485 //layer=li \
 //thickness=0.1 //x=18.44 //y=7.41 //x2=18.44 //y2=6.925
r1647 (  302 886 ) resistor r=2.87058 //w=0.35 //l=0.085 //layer=li \
 //thickness=0.1 //x=17.645 //y=7.585 //x2=17.56 //y2=7.585
r1648 (  302 304 ) resistor r=21.1008 //w=0.367 //l=0.605 //layer=li \
 //thickness=0.1 //x=17.645 //y=7.585 //x2=18.25 //y2=7.585
r1649 (  301 887 ) resistor r=2.87058 //w=0.35 //l=0.085 //layer=li \
 //thickness=0.1 //x=18.355 //y=7.585 //x2=18.44 //y2=7.585
r1650 (  301 304 ) resistor r=3.66213 //w=0.367 //l=0.105 //layer=li \
 //thickness=0.1 //x=18.355 //y=7.585 //x2=18.25 //y2=7.585
r1651 (  295 886 ) resistor r=4.23183 //w=0.7 //l=0.175 //layer=li \
 //thickness=0.1 //x=17.56 //y=7.41 //x2=17.56 //y2=7.585
r1652 (  295 978 ) resistor r=56.4706 //w=0.187 //l=0.825 //layer=li \
 //thickness=0.1 //x=17.56 //y=7.41 //x2=17.56 //y2=6.585
r1653 (  292 885 ) resistor r=5.29055 //w=0.35 //l=0.17 //layer=li \
 //thickness=0.1 //x=16.94 //y=7.585 //x2=16.77 //y2=7.585
r1654 (  292 294 ) resistor r=6.97548 //w=0.367 //l=0.2 //layer=li \
 //thickness=0.1 //x=16.94 //y=7.585 //x2=17.14 //y2=7.585
r1655 (  291 886 ) resistor r=2.87058 //w=0.35 //l=0.085 //layer=li \
 //thickness=0.1 //x=17.475 //y=7.585 //x2=17.56 //y2=7.585
r1656 (  291 294 ) resistor r=11.6839 //w=0.367 //l=0.335 //layer=li \
 //thickness=0.1 //x=17.475 //y=7.585 //x2=17.14 //y2=7.585
r1657 (  288 884 ) resistor r=2.87058 //w=0.35 //l=0.085 //layer=li \
 //thickness=0.1 //x=16.075 //y=7.585 //x2=15.99 //y2=7.585
r1658 (  287 885 ) resistor r=5.29055 //w=0.35 //l=0.17 //layer=li \
 //thickness=0.1 //x=16.6 //y=7.585 //x2=16.77 //y2=7.585
r1659 (  287 288 ) resistor r=18.3106 //w=0.367 //l=0.525 //layer=li \
 //thickness=0.1 //x=16.6 //y=7.585 //x2=16.075 //y2=7.585
r1660 (  281 884 ) resistor r=4.23183 //w=0.7 //l=0.175 //layer=li \
 //thickness=0.1 //x=15.99 //y=7.41 //x2=15.99 //y2=7.585
r1661 (  281 977 ) resistor r=33.1979 //w=0.187 //l=0.485 //layer=li \
 //thickness=0.1 //x=15.99 //y=7.41 //x2=15.99 //y2=6.925
r1662 (  278 883 ) resistor r=2.87058 //w=0.35 //l=0.085 //layer=li \
 //thickness=0.1 //x=15.195 //y=7.585 //x2=15.11 //y2=7.585
r1663 (  278 280 ) resistor r=16.218 //w=0.367 //l=0.465 //layer=li \
 //thickness=0.1 //x=15.195 //y=7.585 //x2=15.66 //y2=7.585
r1664 (  277 884 ) resistor r=2.87058 //w=0.35 //l=0.085 //layer=li \
 //thickness=0.1 //x=15.905 //y=7.585 //x2=15.99 //y2=7.585
r1665 (  277 280 ) resistor r=8.54496 //w=0.367 //l=0.245 //layer=li \
 //thickness=0.1 //x=15.905 //y=7.585 //x2=15.66 //y2=7.585
r1666 (  271 883 ) resistor r=4.23183 //w=0.7 //l=0.175 //layer=li \
 //thickness=0.1 //x=15.11 //y=7.41 //x2=15.11 //y2=7.585
r1667 (  271 976 ) resistor r=33.1979 //w=0.187 //l=0.485 //layer=li \
 //thickness=0.1 //x=15.11 //y=7.41 //x2=15.11 //y2=6.925
r1668 (  268 882 ) resistor r=2.87058 //w=0.35 //l=0.085 //layer=li \
 //thickness=0.1 //x=14.315 //y=7.585 //x2=14.23 //y2=7.585
r1669 (  268 270 ) resistor r=8.19619 //w=0.367 //l=0.235 //layer=li \
 //thickness=0.1 //x=14.315 //y=7.585 //x2=14.55 //y2=7.585
r1670 (  267 883 ) resistor r=2.87058 //w=0.35 //l=0.085 //layer=li \
 //thickness=0.1 //x=15.025 //y=7.585 //x2=15.11 //y2=7.585
r1671 (  267 270 ) resistor r=16.5668 //w=0.367 //l=0.475 //layer=li \
 //thickness=0.1 //x=15.025 //y=7.585 //x2=14.55 //y2=7.585
r1672 (  261 882 ) resistor r=4.23183 //w=0.7 //l=0.175 //layer=li \
 //thickness=0.1 //x=14.23 //y=7.41 //x2=14.23 //y2=7.585
r1673 (  261 975 ) resistor r=56.4706 //w=0.187 //l=0.825 //layer=li \
 //thickness=0.1 //x=14.23 //y=7.41 //x2=14.23 //y2=6.585
r1674 (  260 881 ) resistor r=5.29055 //w=0.35 //l=0.17 //layer=li \
 //thickness=0.1 //x=13.61 //y=7.585 //x2=13.44 //y2=7.585
r1675 (  259 882 ) resistor r=2.87058 //w=0.35 //l=0.085 //layer=li \
 //thickness=0.1 //x=14.145 //y=7.585 //x2=14.23 //y2=7.585
r1676 (  259 260 ) resistor r=18.6594 //w=0.367 //l=0.535 //layer=li \
 //thickness=0.1 //x=14.145 //y=7.585 //x2=13.61 //y2=7.585
r1677 (  254 880 ) resistor r=2.87058 //w=0.35 //l=0.085 //layer=li \
 //thickness=0.1 //x=12.445 //y=7.585 //x2=12.36 //y2=7.585
r1678 (  254 256 ) resistor r=21.7984 //w=0.367 //l=0.625 //layer=li \
 //thickness=0.1 //x=12.445 //y=7.585 //x2=13.07 //y2=7.585
r1679 (  253 881 ) resistor r=5.29055 //w=0.35 //l=0.17 //layer=li \
 //thickness=0.1 //x=13.27 //y=7.585 //x2=13.44 //y2=7.585
r1680 (  253 256 ) resistor r=6.97548 //w=0.367 //l=0.2 //layer=li \
 //thickness=0.1 //x=13.27 //y=7.585 //x2=13.07 //y2=7.585
r1681 (  247 880 ) resistor r=4.23183 //w=0.7 //l=0.175 //layer=li \
 //thickness=0.1 //x=12.36 //y=7.41 //x2=12.36 //y2=7.585
r1682 (  247 974 ) resistor r=33.1979 //w=0.187 //l=0.485 //layer=li \
 //thickness=0.1 //x=12.36 //y=7.41 //x2=12.36 //y2=6.925
r1683 (  244 879 ) resistor r=2.87058 //w=0.35 //l=0.085 //layer=li \
 //thickness=0.1 //x=11.565 //y=7.585 //x2=11.48 //y2=7.585
r1684 (  244 246 ) resistor r=13.7766 //w=0.367 //l=0.395 //layer=li \
 //thickness=0.1 //x=11.565 //y=7.585 //x2=11.96 //y2=7.585
r1685 (  243 880 ) resistor r=2.87058 //w=0.35 //l=0.085 //layer=li \
 //thickness=0.1 //x=12.275 //y=7.585 //x2=12.36 //y2=7.585
r1686 (  243 246 ) resistor r=10.9864 //w=0.367 //l=0.315 //layer=li \
 //thickness=0.1 //x=12.275 //y=7.585 //x2=11.96 //y2=7.585
r1687 (  237 879 ) resistor r=4.23183 //w=0.7 //l=0.175 //layer=li \
 //thickness=0.1 //x=11.48 //y=7.41 //x2=11.48 //y2=7.585
r1688 (  237 973 ) resistor r=33.1979 //w=0.187 //l=0.485 //layer=li \
 //thickness=0.1 //x=11.48 //y=7.41 //x2=11.48 //y2=6.925
r1689 (  234 878 ) resistor r=2.87058 //w=0.35 //l=0.085 //layer=li \
 //thickness=0.1 //x=10.685 //y=7.585 //x2=10.6 //y2=7.585
r1690 (  234 236 ) resistor r=5.75477 //w=0.367 //l=0.165 //layer=li \
 //thickness=0.1 //x=10.685 //y=7.585 //x2=10.85 //y2=7.585
r1691 (  233 879 ) resistor r=2.87058 //w=0.35 //l=0.085 //layer=li \
 //thickness=0.1 //x=11.395 //y=7.585 //x2=11.48 //y2=7.585
r1692 (  233 236 ) resistor r=19.0082 //w=0.367 //l=0.545 //layer=li \
 //thickness=0.1 //x=11.395 //y=7.585 //x2=10.85 //y2=7.585
r1693 (  227 878 ) resistor r=4.23183 //w=0.7 //l=0.175 //layer=li \
 //thickness=0.1 //x=10.6 //y=7.41 //x2=10.6 //y2=7.585
r1694 (  227 972 ) resistor r=33.1979 //w=0.187 //l=0.485 //layer=li \
 //thickness=0.1 //x=10.6 //y=7.41 //x2=10.6 //y2=6.925
r1695 (  226 877 ) resistor r=2.87058 //w=0.35 //l=0.085 //layer=li \
 //thickness=0.1 //x=9.805 //y=7.585 //x2=9.72 //y2=7.585
r1696 (  225 878 ) resistor r=2.87058 //w=0.35 //l=0.085 //layer=li \
 //thickness=0.1 //x=10.515 //y=7.585 //x2=10.6 //y2=7.585
r1697 (  225 226 ) resistor r=24.7629 //w=0.367 //l=0.71 //layer=li \
 //thickness=0.1 //x=10.515 //y=7.585 //x2=9.805 //y2=7.585
r1698 (  219 877 ) resistor r=4.23183 //w=0.7 //l=0.175 //layer=li \
 //thickness=0.1 //x=9.72 //y=7.41 //x2=9.72 //y2=7.585
r1699 (  219 971 ) resistor r=56.4706 //w=0.187 //l=0.825 //layer=li \
 //thickness=0.1 //x=9.72 //y=7.41 //x2=9.72 //y2=6.585
r1700 (  218 875 ) resistor r=5.29055 //w=0.35 //l=0.17 //layer=li \
 //thickness=0.1 //x=8.8 //y=7.585 //x2=8.63 //y2=7.585
r1701 (  217 877 ) resistor r=2.87058 //w=0.35 //l=0.085 //layer=li \
 //thickness=0.1 //x=9.635 //y=7.585 //x2=9.72 //y2=7.585
r1702 (  217 218 ) resistor r=29.1226 //w=0.367 //l=0.835 //layer=li \
 //thickness=0.1 //x=9.635 //y=7.585 //x2=8.8 //y2=7.585
r1703 (  212 874 ) resistor r=2.87058 //w=0.35 //l=0.085 //layer=li \
 //thickness=0.1 //x=7.635 //y=7.585 //x2=7.55 //y2=7.585
r1704 (  212 214 ) resistor r=21.7984 //w=0.367 //l=0.625 //layer=li \
 //thickness=0.1 //x=7.635 //y=7.585 //x2=8.26 //y2=7.585
r1705 (  211 875 ) resistor r=5.29055 //w=0.35 //l=0.17 //layer=li \
 //thickness=0.1 //x=8.46 //y=7.585 //x2=8.63 //y2=7.585
r1706 (  211 214 ) resistor r=6.97548 //w=0.367 //l=0.2 //layer=li \
 //thickness=0.1 //x=8.46 //y=7.585 //x2=8.26 //y2=7.585
r1707 (  205 874 ) resistor r=4.23183 //w=0.7 //l=0.175 //layer=li \
 //thickness=0.1 //x=7.55 //y=7.41 //x2=7.55 //y2=7.585
r1708 (  205 970 ) resistor r=33.1979 //w=0.187 //l=0.485 //layer=li \
 //thickness=0.1 //x=7.55 //y=7.41 //x2=7.55 //y2=6.925
r1709 (  202 873 ) resistor r=2.87058 //w=0.35 //l=0.085 //layer=li \
 //thickness=0.1 //x=6.755 //y=7.585 //x2=6.67 //y2=7.585
r1710 (  202 204 ) resistor r=13.7766 //w=0.367 //l=0.395 //layer=li \
 //thickness=0.1 //x=6.755 //y=7.585 //x2=7.15 //y2=7.585
r1711 (  201 874 ) resistor r=2.87058 //w=0.35 //l=0.085 //layer=li \
 //thickness=0.1 //x=7.465 //y=7.585 //x2=7.55 //y2=7.585
r1712 (  201 204 ) resistor r=10.9864 //w=0.367 //l=0.315 //layer=li \
 //thickness=0.1 //x=7.465 //y=7.585 //x2=7.15 //y2=7.585
r1713 (  195 873 ) resistor r=4.23183 //w=0.7 //l=0.175 //layer=li \
 //thickness=0.1 //x=6.67 //y=7.41 //x2=6.67 //y2=7.585
r1714 (  195 969 ) resistor r=33.1979 //w=0.187 //l=0.485 //layer=li \
 //thickness=0.1 //x=6.67 //y=7.41 //x2=6.67 //y2=6.925
r1715 (  192 872 ) resistor r=2.87058 //w=0.35 //l=0.085 //layer=li \
 //thickness=0.1 //x=5.875 //y=7.585 //x2=5.79 //y2=7.585
r1716 (  192 194 ) resistor r=5.75477 //w=0.367 //l=0.165 //layer=li \
 //thickness=0.1 //x=5.875 //y=7.585 //x2=6.04 //y2=7.585
r1717 (  191 873 ) resistor r=2.87058 //w=0.35 //l=0.085 //layer=li \
 //thickness=0.1 //x=6.585 //y=7.585 //x2=6.67 //y2=7.585
r1718 (  191 194 ) resistor r=19.0082 //w=0.367 //l=0.545 //layer=li \
 //thickness=0.1 //x=6.585 //y=7.585 //x2=6.04 //y2=7.585
r1719 (  185 872 ) resistor r=4.23183 //w=0.7 //l=0.175 //layer=li \
 //thickness=0.1 //x=5.79 //y=7.41 //x2=5.79 //y2=7.585
r1720 (  185 968 ) resistor r=33.1979 //w=0.187 //l=0.485 //layer=li \
 //thickness=0.1 //x=5.79 //y=7.41 //x2=5.79 //y2=6.925
r1721 (  184 871 ) resistor r=2.87058 //w=0.35 //l=0.085 //layer=li \
 //thickness=0.1 //x=4.995 //y=7.585 //x2=4.91 //y2=7.585
r1722 (  183 872 ) resistor r=2.87058 //w=0.35 //l=0.085 //layer=li \
 //thickness=0.1 //x=5.705 //y=7.585 //x2=5.79 //y2=7.585
r1723 (  183 184 ) resistor r=24.7629 //w=0.367 //l=0.71 //layer=li \
 //thickness=0.1 //x=5.705 //y=7.585 //x2=4.995 //y2=7.585
r1724 (  177 871 ) resistor r=4.23183 //w=0.7 //l=0.175 //layer=li \
 //thickness=0.1 //x=4.91 //y=7.41 //x2=4.91 //y2=7.585
r1725 (  177 967 ) resistor r=56.4706 //w=0.187 //l=0.825 //layer=li \
 //thickness=0.1 //x=4.91 //y=7.41 //x2=4.91 //y2=6.585
r1726 (  176 869 ) resistor r=5.29055 //w=0.35 //l=0.17 //layer=li \
 //thickness=0.1 //x=3.99 //y=7.585 //x2=3.82 //y2=7.585
r1727 (  175 871 ) resistor r=2.87058 //w=0.35 //l=0.085 //layer=li \
 //thickness=0.1 //x=4.825 //y=7.585 //x2=4.91 //y2=7.585
r1728 (  175 176 ) resistor r=29.1226 //w=0.367 //l=0.835 //layer=li \
 //thickness=0.1 //x=4.825 //y=7.585 //x2=3.99 //y2=7.585
r1729 (  170 868 ) resistor r=2.87058 //w=0.35 //l=0.085 //layer=li \
 //thickness=0.1 //x=3.125 //y=7.585 //x2=3.04 //y2=7.585
r1730 (  170 172 ) resistor r=11.3351 //w=0.367 //l=0.325 //layer=li \
 //thickness=0.1 //x=3.125 //y=7.585 //x2=3.45 //y2=7.585
r1731 (  169 869 ) resistor r=5.29055 //w=0.35 //l=0.17 //layer=li \
 //thickness=0.1 //x=3.65 //y=7.585 //x2=3.82 //y2=7.585
r1732 (  169 172 ) resistor r=6.97548 //w=0.367 //l=0.2 //layer=li \
 //thickness=0.1 //x=3.65 //y=7.585 //x2=3.45 //y2=7.585
r1733 (  163 868 ) resistor r=4.23183 //w=0.7 //l=0.175 //layer=li \
 //thickness=0.1 //x=3.04 //y=7.41 //x2=3.04 //y2=7.585
r1734 (  163 966 ) resistor r=33.1979 //w=0.187 //l=0.485 //layer=li \
 //thickness=0.1 //x=3.04 //y=7.41 //x2=3.04 //y2=6.925
r1735 (  160 867 ) resistor r=2.87058 //w=0.35 //l=0.085 //layer=li \
 //thickness=0.1 //x=2.245 //y=7.585 //x2=2.16 //y2=7.585
r1736 (  160 162 ) resistor r=3.31335 //w=0.367 //l=0.095 //layer=li \
 //thickness=0.1 //x=2.245 //y=7.585 //x2=2.34 //y2=7.585
r1737 (  159 868 ) resistor r=2.87058 //w=0.35 //l=0.085 //layer=li \
 //thickness=0.1 //x=2.955 //y=7.585 //x2=3.04 //y2=7.585
r1738 (  159 162 ) resistor r=21.4496 //w=0.367 //l=0.615 //layer=li \
 //thickness=0.1 //x=2.955 //y=7.585 //x2=2.34 //y2=7.585
r1739 (  153 867 ) resistor r=4.23183 //w=0.7 //l=0.175 //layer=li \
 //thickness=0.1 //x=2.16 //y=7.41 //x2=2.16 //y2=7.585
r1740 (  153 965 ) resistor r=33.1979 //w=0.187 //l=0.485 //layer=li \
 //thickness=0.1 //x=2.16 //y=7.41 //x2=2.16 //y2=6.925
r1741 (  152 866 ) resistor r=2.87058 //w=0.35 //l=0.085 //layer=li \
 //thickness=0.1 //x=1.365 //y=7.585 //x2=1.28 //y2=7.585
r1742 (  151 867 ) resistor r=2.87058 //w=0.35 //l=0.085 //layer=li \
 //thickness=0.1 //x=2.075 //y=7.585 //x2=2.16 //y2=7.585
r1743 (  151 152 ) resistor r=24.7629 //w=0.367 //l=0.71 //layer=li \
 //thickness=0.1 //x=2.075 //y=7.585 //x2=1.365 //y2=7.585
r1744 (  145 866 ) resistor r=4.23183 //w=0.7 //l=0.175 //layer=li \
 //thickness=0.1 //x=1.28 //y=7.41 //x2=1.28 //y2=7.585
r1745 (  145 964 ) resistor r=56.4706 //w=0.187 //l=0.825 //layer=li \
 //thickness=0.1 //x=1.28 //y=7.41 //x2=1.28 //y2=6.585
r1746 (  139 862 ) resistor r=3.1 //w=0.17 //l=0.51 //layer=mcon //count=3 \
 //x=83 //y=7.58 //x2=83 //y2=7.58
r1747 (  137 860 ) resistor r=3.1 //w=0.17 //l=0.51 //layer=mcon //count=3 \
 //x=81.89 //y=7.58 //x2=81.89 //y2=7.58
r1748 (  137 139 ) resistor r=0.446141 //w=0.311 //l=1.11 //layer=m1 \
 //thickness=0.36 //x=81.89 //y=7.585 //x2=83 //y2=7.585
r1749 (  135 858 ) resistor r=3.1 //w=0.17 //l=0.51 //layer=mcon //count=3 \
 //x=80.78 //y=7.58 //x2=80.78 //y2=7.58
r1750 (  135 137 ) resistor r=0.446141 //w=0.311 //l=1.11 //layer=m1 \
 //thickness=0.36 //x=80.78 //y=7.585 //x2=81.89 //y2=7.585
r1751 (  133 852 ) resistor r=3.1 //w=0.17 //l=0.51 //layer=mcon //count=3 \
 //x=79.3 //y=7.58 //x2=79.3 //y2=7.58
r1752 (  133 135 ) resistor r=0.594855 //w=0.311 //l=1.48 //layer=m1 \
 //thickness=0.36 //x=79.3 //y=7.585 //x2=80.78 //y2=7.585
r1753 (  131 850 ) resistor r=3.1 //w=0.17 //l=0.51 //layer=mcon //count=3 \
 //x=78.19 //y=7.58 //x2=78.19 //y2=7.58
r1754 (  131 133 ) resistor r=0.446141 //w=0.311 //l=1.11 //layer=m1 \
 //thickness=0.36 //x=78.19 //y=7.585 //x2=79.3 //y2=7.585
r1755 (  129 844 ) resistor r=3.1 //w=0.17 //l=0.51 //layer=mcon //count=3 \
 //x=76.71 //y=7.58 //x2=76.71 //y2=7.58
r1756 (  129 131 ) resistor r=0.594855 //w=0.311 //l=1.48 //layer=m1 \
 //thickness=0.36 //x=76.71 //y=7.585 //x2=78.19 //y2=7.585
r1757 (  127 834 ) resistor r=3.1 //w=0.17 //l=0.51 //layer=mcon //count=3 \
 //x=75.6 //y=7.58 //x2=75.6 //y2=7.58
r1758 (  127 129 ) resistor r=0.446141 //w=0.311 //l=1.11 //layer=m1 \
 //thickness=0.36 //x=75.6 //y=7.585 //x2=76.71 //y2=7.585
r1759 (  125 959 ) resistor r=3.1 //w=0.17 //l=0.51 //layer=mcon //count=3 \
 //x=74.49 //y=7.58 //x2=74.49 //y2=7.58
r1760 (  125 127 ) resistor r=0.446141 //w=0.311 //l=1.11 //layer=m1 \
 //thickness=0.36 //x=74.49 //y=7.585 //x2=75.6 //y2=7.585
r1761 (  123 812 ) resistor r=3.1 //w=0.17 //l=0.51 //layer=mcon //count=3 \
 //x=73.01 //y=7.58 //x2=73.01 //y2=7.58
r1762 (  123 125 ) resistor r=0.594855 //w=0.311 //l=1.48 //layer=m1 \
 //thickness=0.36 //x=73.01 //y=7.585 //x2=74.49 //y2=7.585
r1763 (  121 802 ) resistor r=3.1 //w=0.17 //l=0.51 //layer=mcon //count=3 \
 //x=71.9 //y=7.58 //x2=71.9 //y2=7.58
r1764 (  121 123 ) resistor r=0.446141 //w=0.311 //l=1.11 //layer=m1 \
 //thickness=0.36 //x=71.9 //y=7.585 //x2=73.01 //y2=7.585
r1765 (  119 784 ) resistor r=3.1 //w=0.17 //l=0.51 //layer=mcon //count=3 \
 //x=70.79 //y=7.58 //x2=70.79 //y2=7.58
r1766 (  119 121 ) resistor r=0.446141 //w=0.311 //l=1.11 //layer=m1 \
 //thickness=0.36 //x=70.79 //y=7.585 //x2=71.9 //y2=7.585
r1767 (  117 774 ) resistor r=3.1 //w=0.17 //l=0.51 //layer=mcon //count=3 \
 //x=69.68 //y=7.58 //x2=69.68 //y2=7.58
r1768 (  117 119 ) resistor r=0.446141 //w=0.311 //l=1.11 //layer=m1 \
 //thickness=0.36 //x=69.68 //y=7.585 //x2=70.79 //y2=7.585
r1769 (  115 951 ) resistor r=3.1 //w=0.17 //l=0.51 //layer=mcon //count=3 \
 //x=68.2 //y=7.58 //x2=68.2 //y2=7.58
r1770 (  115 117 ) resistor r=0.594855 //w=0.311 //l=1.48 //layer=m1 \
 //thickness=0.36 //x=68.2 //y=7.585 //x2=69.68 //y2=7.585
r1771 (  113 752 ) resistor r=3.1 //w=0.17 //l=0.51 //layer=mcon //count=3 \
 //x=67.09 //y=7.58 //x2=67.09 //y2=7.58
r1772 (  113 115 ) resistor r=0.446141 //w=0.311 //l=1.11 //layer=m1 \
 //thickness=0.36 //x=67.09 //y=7.585 //x2=68.2 //y2=7.585
r1773 (  111 742 ) resistor r=3.1 //w=0.17 //l=0.51 //layer=mcon //count=3 \
 //x=65.98 //y=7.58 //x2=65.98 //y2=7.58
r1774 (  111 113 ) resistor r=0.446141 //w=0.311 //l=1.11 //layer=m1 \
 //thickness=0.36 //x=65.98 //y=7.585 //x2=67.09 //y2=7.585
r1775 (  109 728 ) resistor r=3.1 //w=0.17 //l=0.51 //layer=mcon //count=3 \
 //x=64.5 //y=7.58 //x2=64.5 //y2=7.58
r1776 (  109 111 ) resistor r=0.594855 //w=0.311 //l=1.48 //layer=m1 \
 //thickness=0.36 //x=64.5 //y=7.585 //x2=65.98 //y2=7.585
r1777 (  107 718 ) resistor r=3.1 //w=0.17 //l=0.51 //layer=mcon //count=3 \
 //x=63.39 //y=7.58 //x2=63.39 //y2=7.58
r1778 (  107 109 ) resistor r=0.446141 //w=0.311 //l=1.11 //layer=m1 \
 //thickness=0.36 //x=63.39 //y=7.585 //x2=64.5 //y2=7.585
r1779 (  105 704 ) resistor r=3.1 //w=0.17 //l=0.51 //layer=mcon //count=3 \
 //x=61.91 //y=7.58 //x2=61.91 //y2=7.58
r1780 (  105 107 ) resistor r=0.594855 //w=0.311 //l=1.48 //layer=m1 \
 //thickness=0.36 //x=61.91 //y=7.585 //x2=63.39 //y2=7.585
r1781 (  103 694 ) resistor r=3.1 //w=0.17 //l=0.51 //layer=mcon //count=3 \
 //x=60.8 //y=7.58 //x2=60.8 //y2=7.58
r1782 (  103 105 ) resistor r=0.446141 //w=0.311 //l=1.11 //layer=m1 \
 //thickness=0.36 //x=60.8 //y=7.585 //x2=61.91 //y2=7.585
r1783 (  101 684 ) resistor r=3.1 //w=0.17 //l=0.51 //layer=mcon //count=3 \
 //x=59.69 //y=7.58 //x2=59.69 //y2=7.58
r1784 (  101 103 ) resistor r=0.446141 //w=0.311 //l=1.11 //layer=m1 \
 //thickness=0.36 //x=59.69 //y=7.585 //x2=60.8 //y2=7.585
r1785 (  99 939 ) resistor r=3.1 //w=0.17 //l=0.51 //layer=mcon //count=3 \
 //x=58.58 //y=7.58 //x2=58.58 //y2=7.58
r1786 (  99 101 ) resistor r=0.446141 //w=0.311 //l=1.11 //layer=m1 \
 //thickness=0.36 //x=58.58 //y=7.585 //x2=59.69 //y2=7.585
r1787 (  97 662 ) resistor r=3.1 //w=0.17 //l=0.51 //layer=mcon //count=3 \
 //x=57.1 //y=7.58 //x2=57.1 //y2=7.58
r1788 (  97 99 ) resistor r=0.594855 //w=0.311 //l=1.48 //layer=m1 \
 //thickness=0.36 //x=57.1 //y=7.585 //x2=58.58 //y2=7.585
r1789 (  95 652 ) resistor r=3.1 //w=0.17 //l=0.51 //layer=mcon //count=3 \
 //x=55.99 //y=7.58 //x2=55.99 //y2=7.58
r1790 (  95 97 ) resistor r=0.446141 //w=0.311 //l=1.11 //layer=m1 \
 //thickness=0.36 //x=55.99 //y=7.585 //x2=57.1 //y2=7.585
r1791 (  93 642 ) resistor r=3.1 //w=0.17 //l=0.51 //layer=mcon //count=3 \
 //x=54.88 //y=7.58 //x2=54.88 //y2=7.58
r1792 (  93 95 ) resistor r=0.446141 //w=0.311 //l=1.11 //layer=m1 \
 //thickness=0.36 //x=54.88 //y=7.585 //x2=55.99 //y2=7.585
r1793 (  91 933 ) resistor r=3.1 //w=0.17 //l=0.51 //layer=mcon //count=3 \
 //x=53.77 //y=7.58 //x2=53.77 //y2=7.58
r1794 (  91 93 ) resistor r=0.446141 //w=0.311 //l=1.11 //layer=m1 \
 //thickness=0.36 //x=53.77 //y=7.585 //x2=54.88 //y2=7.585
r1795 (  89 620 ) resistor r=3.1 //w=0.17 //l=0.51 //layer=mcon //count=3 \
 //x=52.29 //y=7.58 //x2=52.29 //y2=7.58
r1796 (  89 91 ) resistor r=0.594855 //w=0.311 //l=1.48 //layer=m1 \
 //thickness=0.36 //x=52.29 //y=7.585 //x2=53.77 //y2=7.585
r1797 (  87 610 ) resistor r=3.1 //w=0.17 //l=0.51 //layer=mcon //count=3 \
 //x=51.18 //y=7.58 //x2=51.18 //y2=7.58
r1798 (  87 89 ) resistor r=0.446141 //w=0.311 //l=1.11 //layer=m1 \
 //thickness=0.36 //x=51.18 //y=7.585 //x2=52.29 //y2=7.585
r1799 (  85 928 ) resistor r=3.1 //w=0.17 //l=0.51 //layer=mcon //count=3 \
 //x=50.07 //y=7.58 //x2=50.07 //y2=7.58
r1800 (  85 87 ) resistor r=0.446141 //w=0.311 //l=1.11 //layer=m1 \
 //thickness=0.36 //x=50.07 //y=7.585 //x2=51.18 //y2=7.585
r1801 (  83 588 ) resistor r=3.1 //w=0.17 //l=0.51 //layer=mcon //count=3 \
 //x=48.59 //y=7.58 //x2=48.59 //y2=7.58
r1802 (  83 85 ) resistor r=0.594855 //w=0.311 //l=1.48 //layer=m1 \
 //thickness=0.36 //x=48.59 //y=7.585 //x2=50.07 //y2=7.585
r1803 (  81 578 ) resistor r=3.1 //w=0.17 //l=0.51 //layer=mcon //count=3 \
 //x=47.48 //y=7.58 //x2=47.48 //y2=7.58
r1804 (  81 83 ) resistor r=0.446141 //w=0.311 //l=1.11 //layer=m1 \
 //thickness=0.36 //x=47.48 //y=7.585 //x2=48.59 //y2=7.585
r1805 (  79 560 ) resistor r=3.1 //w=0.17 //l=0.51 //layer=mcon //count=3 \
 //x=46.37 //y=7.58 //x2=46.37 //y2=7.58
r1806 (  79 81 ) resistor r=0.446141 //w=0.311 //l=1.11 //layer=m1 \
 //thickness=0.36 //x=46.37 //y=7.585 //x2=47.48 //y2=7.585
r1807 (  77 550 ) resistor r=3.1 //w=0.17 //l=0.51 //layer=mcon //count=3 \
 //x=45.26 //y=7.58 //x2=45.26 //y2=7.58
r1808 (  77 79 ) resistor r=0.446141 //w=0.311 //l=1.11 //layer=m1 \
 //thickness=0.36 //x=45.26 //y=7.585 //x2=46.37 //y2=7.585
r1809 (  75 920 ) resistor r=3.1 //w=0.17 //l=0.51 //layer=mcon //count=3 \
 //x=43.78 //y=7.58 //x2=43.78 //y2=7.58
r1810 (  75 77 ) resistor r=0.594855 //w=0.311 //l=1.48 //layer=m1 \
 //thickness=0.36 //x=43.78 //y=7.585 //x2=45.26 //y2=7.585
r1811 (  73 528 ) resistor r=3.1 //w=0.17 //l=0.51 //layer=mcon //count=3 \
 //x=42.67 //y=7.58 //x2=42.67 //y2=7.58
r1812 (  73 75 ) resistor r=0.446141 //w=0.311 //l=1.11 //layer=m1 \
 //thickness=0.36 //x=42.67 //y=7.585 //x2=43.78 //y2=7.585
r1813 (  70 518 ) resistor r=3.1 //w=0.17 //l=0.51 //layer=mcon //count=3 \
 //x=41.56 //y=7.58 //x2=41.56 //y2=7.58
r1814 (  68 504 ) resistor r=3.1 //w=0.17 //l=0.51 //layer=mcon //count=3 \
 //x=40.08 //y=7.58 //x2=40.08 //y2=7.58
r1815 (  68 70 ) resistor r=0.594855 //w=0.311 //l=1.48 //layer=m1 \
 //thickness=0.36 //x=40.08 //y=7.585 //x2=41.56 //y2=7.585
r1816 (  66 494 ) resistor r=3.1 //w=0.17 //l=0.51 //layer=mcon //count=3 \
 //x=38.97 //y=7.58 //x2=38.97 //y2=7.58
r1817 (  66 68 ) resistor r=0.446141 //w=0.311 //l=1.11 //layer=m1 \
 //thickness=0.36 //x=38.97 //y=7.585 //x2=40.08 //y2=7.585
r1818 (  64 480 ) resistor r=3.1 //w=0.17 //l=0.51 //layer=mcon //count=3 \
 //x=37.49 //y=7.58 //x2=37.49 //y2=7.58
r1819 (  64 66 ) resistor r=0.594855 //w=0.311 //l=1.48 //layer=m1 \
 //thickness=0.36 //x=37.49 //y=7.585 //x2=38.97 //y2=7.585
r1820 (  62 470 ) resistor r=3.1 //w=0.17 //l=0.51 //layer=mcon //count=3 \
 //x=36.38 //y=7.58 //x2=36.38 //y2=7.58
r1821 (  62 64 ) resistor r=0.446141 //w=0.311 //l=1.11 //layer=m1 \
 //thickness=0.36 //x=36.38 //y=7.585 //x2=37.49 //y2=7.585
r1822 (  60 460 ) resistor r=3.1 //w=0.17 //l=0.51 //layer=mcon //count=3 \
 //x=35.27 //y=7.58 //x2=35.27 //y2=7.58
r1823 (  60 62 ) resistor r=0.446141 //w=0.311 //l=1.11 //layer=m1 \
 //thickness=0.36 //x=35.27 //y=7.585 //x2=36.38 //y2=7.585
r1824 (  58 908 ) resistor r=3.1 //w=0.17 //l=0.51 //layer=mcon //count=3 \
 //x=34.16 //y=7.58 //x2=34.16 //y2=7.58
r1825 (  58 60 ) resistor r=0.446141 //w=0.311 //l=1.11 //layer=m1 \
 //thickness=0.36 //x=34.16 //y=7.585 //x2=35.27 //y2=7.585
r1826 (  56 438 ) resistor r=3.1 //w=0.17 //l=0.51 //layer=mcon //count=3 \
 //x=32.68 //y=7.58 //x2=32.68 //y2=7.58
r1827 (  56 58 ) resistor r=0.594855 //w=0.311 //l=1.48 //layer=m1 \
 //thickness=0.36 //x=32.68 //y=7.585 //x2=34.16 //y2=7.585
r1828 (  54 428 ) resistor r=3.1 //w=0.17 //l=0.51 //layer=mcon //count=3 \
 //x=31.57 //y=7.58 //x2=31.57 //y2=7.58
r1829 (  54 56 ) resistor r=0.446141 //w=0.311 //l=1.11 //layer=m1 \
 //thickness=0.36 //x=31.57 //y=7.585 //x2=32.68 //y2=7.585
r1830 (  52 418 ) resistor r=3.1 //w=0.17 //l=0.51 //layer=mcon //count=3 \
 //x=30.46 //y=7.58 //x2=30.46 //y2=7.58
r1831 (  52 54 ) resistor r=0.446141 //w=0.311 //l=1.11 //layer=m1 \
 //thickness=0.36 //x=30.46 //y=7.585 //x2=31.57 //y2=7.585
r1832 (  50 902 ) resistor r=3.1 //w=0.17 //l=0.51 //layer=mcon //count=3 \
 //x=29.35 //y=7.58 //x2=29.35 //y2=7.58
r1833 (  50 52 ) resistor r=0.446141 //w=0.311 //l=1.11 //layer=m1 \
 //thickness=0.36 //x=29.35 //y=7.585 //x2=30.46 //y2=7.585
r1834 (  48 396 ) resistor r=3.1 //w=0.17 //l=0.51 //layer=mcon //count=3 \
 //x=27.87 //y=7.58 //x2=27.87 //y2=7.58
r1835 (  48 50 ) resistor r=0.594855 //w=0.311 //l=1.48 //layer=m1 \
 //thickness=0.36 //x=27.87 //y=7.585 //x2=29.35 //y2=7.585
r1836 (  46 386 ) resistor r=3.1 //w=0.17 //l=0.51 //layer=mcon //count=3 \
 //x=26.76 //y=7.58 //x2=26.76 //y2=7.58
r1837 (  46 48 ) resistor r=0.446141 //w=0.311 //l=1.11 //layer=m1 \
 //thickness=0.36 //x=26.76 //y=7.585 //x2=27.87 //y2=7.585
r1838 (  44 897 ) resistor r=3.1 //w=0.17 //l=0.51 //layer=mcon //count=3 \
 //x=25.65 //y=7.58 //x2=25.65 //y2=7.58
r1839 (  44 46 ) resistor r=0.446141 //w=0.311 //l=1.11 //layer=m1 \
 //thickness=0.36 //x=25.65 //y=7.585 //x2=26.76 //y2=7.585
r1840 (  42 364 ) resistor r=3.1 //w=0.17 //l=0.51 //layer=mcon //count=3 \
 //x=24.17 //y=7.58 //x2=24.17 //y2=7.58
r1841 (  42 44 ) resistor r=0.594855 //w=0.311 //l=1.48 //layer=m1 \
 //thickness=0.36 //x=24.17 //y=7.585 //x2=25.65 //y2=7.585
r1842 (  40 354 ) resistor r=3.1 //w=0.17 //l=0.51 //layer=mcon //count=3 \
 //x=23.06 //y=7.58 //x2=23.06 //y2=7.58
r1843 (  40 42 ) resistor r=0.446141 //w=0.311 //l=1.11 //layer=m1 \
 //thickness=0.36 //x=23.06 //y=7.585 //x2=24.17 //y2=7.585
r1844 (  38 336 ) resistor r=3.1 //w=0.17 //l=0.51 //layer=mcon //count=3 \
 //x=21.95 //y=7.58 //x2=21.95 //y2=7.58
r1845 (  38 40 ) resistor r=0.446141 //w=0.311 //l=1.11 //layer=m1 \
 //thickness=0.36 //x=21.95 //y=7.585 //x2=23.06 //y2=7.585
r1846 (  36 326 ) resistor r=3.1 //w=0.17 //l=0.51 //layer=mcon //count=3 \
 //x=20.84 //y=7.58 //x2=20.84 //y2=7.58
r1847 (  36 38 ) resistor r=0.446141 //w=0.311 //l=1.11 //layer=m1 \
 //thickness=0.36 //x=20.84 //y=7.585 //x2=21.95 //y2=7.585
r1848 (  34 889 ) resistor r=3.1 //w=0.17 //l=0.51 //layer=mcon //count=3 \
 //x=19.36 //y=7.58 //x2=19.36 //y2=7.58
r1849 (  34 36 ) resistor r=0.594855 //w=0.311 //l=1.48 //layer=m1 \
 //thickness=0.36 //x=19.36 //y=7.585 //x2=20.84 //y2=7.585
r1850 (  32 304 ) resistor r=3.1 //w=0.17 //l=0.51 //layer=mcon //count=3 \
 //x=18.25 //y=7.58 //x2=18.25 //y2=7.58
r1851 (  32 34 ) resistor r=0.446141 //w=0.311 //l=1.11 //layer=m1 \
 //thickness=0.36 //x=18.25 //y=7.585 //x2=19.36 //y2=7.585
r1852 (  30 294 ) resistor r=3.1 //w=0.17 //l=0.51 //layer=mcon //count=3 \
 //x=17.14 //y=7.58 //x2=17.14 //y2=7.58
r1853 (  30 32 ) resistor r=0.446141 //w=0.311 //l=1.11 //layer=m1 \
 //thickness=0.36 //x=17.14 //y=7.585 //x2=18.25 //y2=7.585
r1854 (  28 280 ) resistor r=3.1 //w=0.17 //l=0.51 //layer=mcon //count=3 \
 //x=15.66 //y=7.58 //x2=15.66 //y2=7.58
r1855 (  28 30 ) resistor r=0.594855 //w=0.311 //l=1.48 //layer=m1 \
 //thickness=0.36 //x=15.66 //y=7.585 //x2=17.14 //y2=7.585
r1856 (  26 270 ) resistor r=3.1 //w=0.17 //l=0.51 //layer=mcon //count=3 \
 //x=14.55 //y=7.58 //x2=14.55 //y2=7.58
r1857 (  26 28 ) resistor r=0.446141 //w=0.311 //l=1.11 //layer=m1 \
 //thickness=0.36 //x=14.55 //y=7.585 //x2=15.66 //y2=7.585
r1858 (  24 256 ) resistor r=3.1 //w=0.17 //l=0.51 //layer=mcon //count=3 \
 //x=13.07 //y=7.58 //x2=13.07 //y2=7.58
r1859 (  24 26 ) resistor r=0.594855 //w=0.311 //l=1.48 //layer=m1 \
 //thickness=0.36 //x=13.07 //y=7.585 //x2=14.55 //y2=7.585
r1860 (  22 246 ) resistor r=3.1 //w=0.17 //l=0.51 //layer=mcon //count=3 \
 //x=11.96 //y=7.58 //x2=11.96 //y2=7.58
r1861 (  22 24 ) resistor r=0.446141 //w=0.311 //l=1.11 //layer=m1 \
 //thickness=0.36 //x=11.96 //y=7.585 //x2=13.07 //y2=7.585
r1862 (  20 236 ) resistor r=3.1 //w=0.17 //l=0.51 //layer=mcon //count=3 \
 //x=10.85 //y=7.58 //x2=10.85 //y2=7.58
r1863 (  20 22 ) resistor r=0.446141 //w=0.311 //l=1.11 //layer=m1 \
 //thickness=0.36 //x=10.85 //y=7.585 //x2=11.96 //y2=7.585
r1864 (  18 877 ) resistor r=3.1 //w=0.17 //l=0.51 //layer=mcon //count=3 \
 //x=9.74 //y=7.58 //x2=9.74 //y2=7.58
r1865 (  18 20 ) resistor r=0.446141 //w=0.311 //l=1.11 //layer=m1 \
 //thickness=0.36 //x=9.74 //y=7.585 //x2=10.85 //y2=7.585
r1866 (  16 214 ) resistor r=3.1 //w=0.17 //l=0.51 //layer=mcon //count=3 \
 //x=8.26 //y=7.58 //x2=8.26 //y2=7.58
r1867 (  16 18 ) resistor r=0.594855 //w=0.311 //l=1.48 //layer=m1 \
 //thickness=0.36 //x=8.26 //y=7.585 //x2=9.74 //y2=7.585
r1868 (  14 204 ) resistor r=3.1 //w=0.17 //l=0.51 //layer=mcon //count=3 \
 //x=7.15 //y=7.58 //x2=7.15 //y2=7.58
r1869 (  14 16 ) resistor r=0.446141 //w=0.311 //l=1.11 //layer=m1 \
 //thickness=0.36 //x=7.15 //y=7.585 //x2=8.26 //y2=7.585
r1870 (  12 194 ) resistor r=3.1 //w=0.17 //l=0.51 //layer=mcon //count=3 \
 //x=6.04 //y=7.58 //x2=6.04 //y2=7.58
r1871 (  12 14 ) resistor r=0.446141 //w=0.311 //l=1.11 //layer=m1 \
 //thickness=0.36 //x=6.04 //y=7.585 //x2=7.15 //y2=7.585
r1872 (  10 871 ) resistor r=3.1 //w=0.17 //l=0.51 //layer=mcon //count=3 \
 //x=4.93 //y=7.58 //x2=4.93 //y2=7.58
r1873 (  10 12 ) resistor r=0.446141 //w=0.311 //l=1.11 //layer=m1 \
 //thickness=0.36 //x=4.93 //y=7.585 //x2=6.04 //y2=7.585
r1874 (  8 172 ) resistor r=3.1 //w=0.17 //l=0.51 //layer=mcon //count=3 \
 //x=3.45 //y=7.58 //x2=3.45 //y2=7.58
r1875 (  8 10 ) resistor r=0.594855 //w=0.311 //l=1.48 //layer=m1 \
 //thickness=0.36 //x=3.45 //y=7.585 //x2=4.93 //y2=7.585
r1876 (  6 162 ) resistor r=3.1 //w=0.17 //l=0.51 //layer=mcon //count=3 \
 //x=2.34 //y=7.58 //x2=2.34 //y2=7.58
r1877 (  6 8 ) resistor r=0.446141 //w=0.311 //l=1.11 //layer=m1 \
 //thickness=0.36 //x=2.34 //y=7.585 //x2=3.45 //y2=7.585
r1878 (  3 866 ) resistor r=3.1 //w=0.17 //l=0.51 //layer=mcon //count=3 \
 //x=1.23 //y=7.58 //x2=1.23 //y2=7.58
r1879 (  3 6 ) resistor r=0.446141 //w=0.311 //l=1.11 //layer=m1 \
 //thickness=0.36 //x=1.23 //y=7.585 //x2=2.34 //y2=7.585
r1880 (  1 73 ) resistor r=0.223071 //w=0.311 //l=0.555 //layer=m1 \
 //thickness=0.36 //x=42.115 //y=7.585 //x2=42.67 //y2=7.585
r1881 (  1 70 ) resistor r=0.223071 //w=0.311 //l=0.555 //layer=m1 \
 //thickness=0.36 //x=42.115 //y=7.585 //x2=41.56 //y2=7.585
ends PM_TMRDFFSNQNX1\%VDD

subckt PM_TMRDFFSNQNX1\%noxref_3 ( 1 2 3 4 17 18 29 31 32 36 38 46 53 54 55 56 \
 57 58 59 60 61 62 63 64 66 72 73 74 75 79 80 81 82 83 85 91 92 93 94 114 116 \
 117 )
c244 ( 117 0 ) capacitor c=0.0220291f //x=2.455 //y=5.2
c245 ( 116 0 ) capacitor c=0.0217503f //x=1.575 //y=5.2
c246 ( 114 0 ) capacitor c=0.0084702f //x=2.45 //y=1.085
c247 ( 94 0 ) capacitor c=0.0556143f //x=10.015 //y=4.97
c248 ( 93 0 ) capacitor c=0.0293157f //x=10.305 //y=4.97
c249 ( 92 0 ) capacitor c=0.0347816f //x=9.97 //y=1.4
c250 ( 91 0 ) capacitor c=0.0187487f //x=9.97 //y=1.055
c251 ( 85 0 ) capacitor c=0.0137055f //x=9.815 //y=1.555
c252 ( 83 0 ) capacitor c=0.0149861f //x=9.815 //y=0.9
c253 ( 82 0 ) capacitor c=0.0965257f //x=9.44 //y=2.095
c254 ( 81 0 ) capacitor c=0.0229444f //x=9.44 //y=1.71
c255 ( 80 0 ) capacitor c=0.0234352f //x=9.44 //y=1.4
c256 ( 79 0 ) capacitor c=0.0198724f //x=9.44 //y=1.055
c257 ( 75 0 ) capacitor c=0.055995f //x=5.205 //y=4.97
c258 ( 74 0 ) capacitor c=0.0298189f //x=5.495 //y=4.97
c259 ( 73 0 ) capacitor c=0.0347816f //x=5.16 //y=1.4
c260 ( 72 0 ) capacitor c=0.0187487f //x=5.16 //y=1.055
c261 ( 66 0 ) capacitor c=0.0137055f //x=5.005 //y=1.555
c262 ( 64 0 ) capacitor c=0.0149861f //x=5.005 //y=0.9
c263 ( 63 0 ) capacitor c=0.0965245f //x=4.63 //y=2.095
c264 ( 62 0 ) capacitor c=0.0229444f //x=4.63 //y=1.71
c265 ( 61 0 ) capacitor c=0.0234352f //x=4.63 //y=1.4
c266 ( 60 0 ) capacitor c=0.0198724f //x=4.63 //y=1.055
c267 ( 59 0 ) capacitor c=0.110114f //x=10.38 //y=6.2
c268 ( 58 0 ) capacitor c=0.158956f //x=9.94 //y=6.2
c269 ( 57 0 ) capacitor c=0.110114f //x=5.57 //y=6.2
c270 ( 56 0 ) capacitor c=0.158956f //x=5.13 //y=6.2
c271 ( 53 0 ) capacitor c=0.0023043f //x=2.6 //y=5.38
c272 ( 46 0 ) capacitor c=0.100197f //x=9.74 //y=2.26
c273 ( 38 0 ) capacitor c=0.104868f //x=4.93 //y=2.26
c274 ( 36 0 ) capacitor c=0.110973f //x=3.08 //y=2.77
c275 ( 32 0 ) capacitor c=0.00468667f //x=2.725 //y=1.835
c276 ( 31 0 ) capacitor c=0.013082f //x=2.995 //y=1.835
c277 ( 29 0 ) capacitor c=0.0140934f //x=2.995 //y=5.38
c278 ( 18 0 ) capacitor c=0.00295092f //x=1.805 //y=5.38
c279 ( 17 0 ) capacitor c=0.0162034f //x=2.515 //y=5.38
c280 ( 4 0 ) capacitor c=0.00988709f //x=5.195 //y=2.77
c281 ( 3 0 ) capacitor c=0.110983f //x=9.625 //y=2.77
c282 ( 2 0 ) capacitor c=0.0138865f //x=3.195 //y=2.77
c283 ( 1 0 ) capacitor c=0.0386784f //x=4.785 //y=2.77
r284 (  93 95 ) resistor r=26.9307 //w=0.15 //l=0.106066 //layer=ply \
 //thickness=0.18 //x=10.305 //y=4.97 //x2=10.38 //y2=5.045
r285 (  93 94 ) resistor r=148.702 //w=0.094 //l=0.29 //layer=ply \
 //thickness=0.18 //x=10.305 //y=4.97 //x2=10.015 //y2=4.97
r286 (  92 113 ) resistor r=45.1352 //w=0.168 //l=0.173853 //layer=ply \
 //thickness=0.18 //x=9.97 //y=1.4 //x2=9.93 //y2=1.555
r287 (  91 112 ) resistor r=45.1352 //w=0.168 //l=0.173853 //layer=ply \
 //thickness=0.18 //x=9.97 //y=1.055 //x2=9.93 //y2=0.9
r288 (  91 92 ) resistor r=176.904 //w=0.094 //l=0.345 //layer=ply \
 //thickness=0.18 //x=9.97 //y=1.055 //x2=9.97 //y2=1.4
r289 (  88 94 ) resistor r=22.7971 //w=0.269 //l=0.106066 //layer=ply \
 //thickness=0.18 //x=9.94 //y=5.045 //x2=10.015 //y2=4.97
r290 (  88 111 ) resistor r=35.8364 //w=0.269 //l=0.270185 //layer=ply \
 //thickness=0.18 //x=9.94 //y=5.045 //x2=9.74 //y2=4.88
r291 (  86 107 ) resistor r=10.701 //w=0.21 //l=0.115 //layer=ply \
 //thickness=0.18 //x=9.595 //y=1.555 //x2=9.48 //y2=1.555
r292 (  85 113 ) resistor r=5.52526 //w=0.168 //l=0.115 //layer=ply \
 //thickness=0.18 //x=9.815 //y=1.555 //x2=9.93 //y2=1.555
r293 (  84 106 ) resistor r=5.52526 //w=0.168 //l=0.115 //layer=ply \
 //thickness=0.18 //x=9.595 //y=0.9 //x2=9.48 //y2=0.9
r294 (  83 112 ) resistor r=5.52526 //w=0.168 //l=0.115 //layer=ply \
 //thickness=0.18 //x=9.815 //y=0.9 //x2=9.93 //y2=0.9
r295 (  83 84 ) resistor r=112.809 //w=0.094 //l=0.22 //layer=ply \
 //thickness=0.18 //x=9.815 //y=0.9 //x2=9.595 //y2=0.9
r296 (  82 109 ) resistor r=58.7805 //w=0.246 //l=0.373497 //layer=ply \
 //thickness=0.18 //x=9.44 //y=2.095 //x2=9.74 //y2=2.26
r297 (  81 107 ) resistor r=39.5823 //w=0.21 //l=0.173853 //layer=ply \
 //thickness=0.18 //x=9.44 //y=1.71 //x2=9.48 //y2=1.555
r298 (  81 82 ) resistor r=197.415 //w=0.094 //l=0.385 //layer=ply \
 //thickness=0.18 //x=9.44 //y=1.71 //x2=9.44 //y2=2.095
r299 (  80 107 ) resistor r=39.5823 //w=0.21 //l=0.173853 //layer=ply \
 //thickness=0.18 //x=9.44 //y=1.4 //x2=9.48 //y2=1.555
r300 (  79 106 ) resistor r=45.1352 //w=0.168 //l=0.173853 //layer=ply \
 //thickness=0.18 //x=9.44 //y=1.055 //x2=9.48 //y2=0.9
r301 (  79 80 ) resistor r=176.904 //w=0.094 //l=0.345 //layer=ply \
 //thickness=0.18 //x=9.44 //y=1.055 //x2=9.44 //y2=1.4
r302 (  74 76 ) resistor r=26.9307 //w=0.15 //l=0.106066 //layer=ply \
 //thickness=0.18 //x=5.495 //y=4.97 //x2=5.57 //y2=5.045
r303 (  74 75 ) resistor r=148.702 //w=0.094 //l=0.29 //layer=ply \
 //thickness=0.18 //x=5.495 //y=4.97 //x2=5.205 //y2=4.97
r304 (  73 105 ) resistor r=45.1352 //w=0.168 //l=0.173853 //layer=ply \
 //thickness=0.18 //x=5.16 //y=1.4 //x2=5.12 //y2=1.555
r305 (  72 104 ) resistor r=45.1352 //w=0.168 //l=0.173853 //layer=ply \
 //thickness=0.18 //x=5.16 //y=1.055 //x2=5.12 //y2=0.9
r306 (  72 73 ) resistor r=176.904 //w=0.094 //l=0.345 //layer=ply \
 //thickness=0.18 //x=5.16 //y=1.055 //x2=5.16 //y2=1.4
r307 (  69 75 ) resistor r=22.7971 //w=0.269 //l=0.106066 //layer=ply \
 //thickness=0.18 //x=5.13 //y=5.045 //x2=5.205 //y2=4.97
r308 (  69 103 ) resistor r=35.8364 //w=0.269 //l=0.270185 //layer=ply \
 //thickness=0.18 //x=5.13 //y=5.045 //x2=4.93 //y2=4.88
r309 (  67 99 ) resistor r=10.701 //w=0.21 //l=0.115 //layer=ply \
 //thickness=0.18 //x=4.785 //y=1.555 //x2=4.67 //y2=1.555
r310 (  66 105 ) resistor r=5.52526 //w=0.168 //l=0.115 //layer=ply \
 //thickness=0.18 //x=5.005 //y=1.555 //x2=5.12 //y2=1.555
r311 (  65 98 ) resistor r=5.52526 //w=0.168 //l=0.115 //layer=ply \
 //thickness=0.18 //x=4.785 //y=0.9 //x2=4.67 //y2=0.9
r312 (  64 104 ) resistor r=5.52526 //w=0.168 //l=0.115 //layer=ply \
 //thickness=0.18 //x=5.005 //y=0.9 //x2=5.12 //y2=0.9
r313 (  64 65 ) resistor r=112.809 //w=0.094 //l=0.22 //layer=ply \
 //thickness=0.18 //x=5.005 //y=0.9 //x2=4.785 //y2=0.9
r314 (  63 101 ) resistor r=58.7805 //w=0.246 //l=0.373497 //layer=ply \
 //thickness=0.18 //x=4.63 //y=2.095 //x2=4.93 //y2=2.26
r315 (  62 99 ) resistor r=39.5823 //w=0.21 //l=0.173853 //layer=ply \
 //thickness=0.18 //x=4.63 //y=1.71 //x2=4.67 //y2=1.555
r316 (  62 63 ) resistor r=197.415 //w=0.094 //l=0.385 //layer=ply \
 //thickness=0.18 //x=4.63 //y=1.71 //x2=4.63 //y2=2.095
r317 (  61 99 ) resistor r=39.5823 //w=0.21 //l=0.173853 //layer=ply \
 //thickness=0.18 //x=4.63 //y=1.4 //x2=4.67 //y2=1.555
r318 (  60 98 ) resistor r=45.1352 //w=0.168 //l=0.173853 //layer=ply \
 //thickness=0.18 //x=4.63 //y=1.055 //x2=4.67 //y2=0.9
r319 (  60 61 ) resistor r=176.904 //w=0.094 //l=0.345 //layer=ply \
 //thickness=0.18 //x=4.63 //y=1.055 //x2=4.63 //y2=1.4
r320 (  59 95 ) resistor r=592.245 //w=0.094 //l=1.155 //layer=ply \
 //thickness=0.18 //x=10.38 //y=6.2 //x2=10.38 //y2=5.045
r321 (  58 88 ) resistor r=592.245 //w=0.094 //l=1.155 //layer=ply \
 //thickness=0.18 //x=9.94 //y=6.2 //x2=9.94 //y2=5.045
r322 (  57 76 ) resistor r=592.245 //w=0.094 //l=1.155 //layer=ply \
 //thickness=0.18 //x=5.57 //y=6.2 //x2=5.57 //y2=5.045
r323 (  56 69 ) resistor r=592.245 //w=0.094 //l=1.155 //layer=ply \
 //thickness=0.18 //x=5.13 //y=6.2 //x2=5.13 //y2=5.045
r324 (  55 85 ) resistor r=56.4043 //w=0.094 //l=0.11 //layer=ply \
 //thickness=0.18 //x=9.705 //y=1.555 //x2=9.815 //y2=1.555
r325 (  55 86 ) resistor r=56.4043 //w=0.094 //l=0.11 //layer=ply \
 //thickness=0.18 //x=9.705 //y=1.555 //x2=9.595 //y2=1.555
r326 (  54 66 ) resistor r=56.4043 //w=0.094 //l=0.11 //layer=ply \
 //thickness=0.18 //x=4.895 //y=1.555 //x2=5.005 //y2=1.555
r327 (  54 67 ) resistor r=56.4043 //w=0.094 //l=0.11 //layer=ply \
 //thickness=0.18 //x=4.895 //y=1.555 //x2=4.785 //y2=1.555
r328 (  51 111 ) resistor r=152 //w=0.17 //l=0.17 //layer=licon //count=1 \
 //x=9.74 //y=4.88 //x2=9.74 //y2=4.88
r329 (  49 51 ) resistor r=144.428 //w=0.187 //l=2.11 //layer=li \
 //thickness=0.1 //x=9.74 //y=2.77 //x2=9.74 //y2=4.88
r330 (  46 109 ) resistor r=152 //w=0.17 //l=0.17 //layer=licon //count=1 \
 //x=9.74 //y=2.26 //x2=9.74 //y2=2.26
r331 (  46 49 ) resistor r=34.9091 //w=0.187 //l=0.51 //layer=li \
 //thickness=0.1 //x=9.74 //y=2.26 //x2=9.74 //y2=2.77
r332 (  43 103 ) resistor r=152 //w=0.17 //l=0.17 //layer=licon //count=1 \
 //x=4.93 //y=4.88 //x2=4.93 //y2=4.88
r333 (  41 43 ) resistor r=144.77 //w=0.187 //l=2.115 //layer=li \
 //thickness=0.1 //x=4.93 //y=2.765 //x2=4.93 //y2=4.88
r334 (  38 101 ) resistor r=152 //w=0.17 //l=0.17 //layer=licon //count=1 \
 //x=4.93 //y=2.26 //x2=4.93 //y2=2.26
r335 (  38 41 ) resistor r=34.5668 //w=0.187 //l=0.505 //layer=li \
 //thickness=0.1 //x=4.93 //y=2.26 //x2=4.93 //y2=2.765
r336 (  34 36 ) resistor r=172.834 //w=0.187 //l=2.525 //layer=li \
 //thickness=0.1 //x=3.08 //y=5.295 //x2=3.08 //y2=2.77
r337 (  33 36 ) resistor r=58.1818 //w=0.187 //l=0.85 //layer=li \
 //thickness=0.1 //x=3.08 //y=1.92 //x2=3.08 //y2=2.77
r338 (  31 33 ) resistor r=7.15173 //w=0.17 //l=0.120208 //layer=li \
 //thickness=0.1 //x=2.995 //y=1.835 //x2=3.08 //y2=1.92
r339 (  31 32 ) resistor r=18.4813 //w=0.187 //l=0.27 //layer=li \
 //thickness=0.1 //x=2.995 //y=1.835 //x2=2.725 //y2=1.835
r340 (  30 53 ) resistor r=5.4201 //w=0.17 //l=0.085 //layer=li \
 //thickness=0.1 //x=2.685 //y=5.38 //x2=2.6 //y2=5.38
r341 (  29 34 ) resistor r=7.15173 //w=0.17 //l=0.120208 //layer=li \
 //thickness=0.1 //x=2.995 //y=5.38 //x2=3.08 //y2=5.295
r342 (  29 30 ) resistor r=21.2193 //w=0.187 //l=0.31 //layer=li \
 //thickness=0.1 //x=2.995 //y=5.38 //x2=2.685 //y2=5.38
r343 (  25 32 ) resistor r=7.15173 //w=0.17 //l=0.120208 //layer=li \
 //thickness=0.1 //x=2.64 //y=1.75 //x2=2.725 //y2=1.835
r344 (  25 114 ) resistor r=39.016 //w=0.187 //l=0.57 //layer=li \
 //thickness=0.1 //x=2.64 //y=1.75 //x2=2.64 //y2=1.18
r345 (  19 53 ) resistor r=1.40859 //w=0.34 //l=0.085 //layer=li \
 //thickness=0.1 //x=2.6 //y=5.465 //x2=2.6 //y2=5.38
r346 (  19 117 ) resistor r=30.1176 //w=0.187 //l=0.44 //layer=li \
 //thickness=0.1 //x=2.6 //y=5.465 //x2=2.6 //y2=5.905
r347 (  17 53 ) resistor r=5.4201 //w=0.17 //l=0.085 //layer=li \
 //thickness=0.1 //x=2.515 //y=5.38 //x2=2.6 //y2=5.38
r348 (  17 18 ) resistor r=48.5989 //w=0.187 //l=0.71 //layer=li \
 //thickness=0.1 //x=2.515 //y=5.38 //x2=1.805 //y2=5.38
r349 (  11 18 ) resistor r=7.15173 //w=0.17 //l=0.120208 //layer=li \
 //thickness=0.1 //x=1.72 //y=5.465 //x2=1.805 //y2=5.38
r350 (  11 116 ) resistor r=30.1176 //w=0.187 //l=0.44 //layer=li \
 //thickness=0.1 //x=1.72 //y=5.465 //x2=1.72 //y2=5.905
r351 (  10 49 ) resistor r=9.3 //w=0.17 //l=0.17 //layer=mcon //count=1 \
 //x=9.74 //y=2.77 //x2=9.74 //y2=2.77
r352 (  8 41 ) resistor r=9.3 //w=0.17 //l=0.17 //layer=mcon //count=1 \
 //x=4.93 //y=2.765 //x2=4.93 //y2=2.765
r353 (  6 36 ) resistor r=9.3 //w=0.17 //l=0.17 //layer=mcon //count=1 \
 //x=3.08 //y=2.77 //x2=3.08 //y2=2.77
r354 (  4 8 ) resistor r=0.164988 //w=0.206 //l=0.267488 //layer=m1 \
 //thickness=0.36 //x=5.195 //y=2.77 //x2=4.93 //y2=2.765
r355 (  3 10 ) resistor r=0.0717383 //w=0.224 //l=0.115 //layer=m1 \
 //thickness=0.36 //x=9.625 //y=2.77 //x2=9.74 //y2=2.77
r356 (  3 4 ) resistor r=4.2271 //w=0.131 //l=4.43 //layer=m1 //thickness=0.36 \
 //x=9.625 //y=2.77 //x2=5.195 //y2=2.77
r357 (  2 6 ) resistor r=0.0717383 //w=0.224 //l=0.115 //layer=m1 \
 //thickness=0.36 //x=3.195 //y=2.77 //x2=3.08 //y2=2.77
r358 (  1 8 ) resistor r=0.0921728 //w=0.206 //l=0.147479 //layer=m1 \
 //thickness=0.36 //x=4.785 //y=2.77 //x2=4.93 //y2=2.765
r359 (  1 2 ) resistor r=1.51718 //w=0.131 //l=1.59 //layer=m1 \
 //thickness=0.36 //x=4.785 //y=2.77 //x2=3.195 //y2=2.77
ends PM_TMRDFFSNQNX1\%noxref_3

subckt PM_TMRDFFSNQNX1\%noxref_4 ( 1 2 13 14 21 29 35 36 40 42 49 50 51 52 53 \
 54 55 56 57 61 63 66 67 77 80 82 83 84 )
c164 ( 84 0 ) capacitor c=0.023087f //x=11.775 //y=5.2
c165 ( 83 0 ) capacitor c=0.023519f //x=10.895 //y=5.2
c166 ( 82 0 ) capacitor c=0.0224735f //x=10.015 //y=5.2
c167 ( 80 0 ) capacitor c=0.00872971f //x=12.025 //y=1.095
c168 ( 77 0 ) capacitor c=0.0588816f //x=14.55 //y=4.88
c169 ( 67 0 ) capacitor c=0.0318948f //x=14.885 //y=1.39
c170 ( 66 0 ) capacitor c=0.0187384f //x=14.885 //y=1.045
c171 ( 63 0 ) capacitor c=0.0141798f //x=14.73 //y=1.545
c172 ( 61 0 ) capacitor c=0.0149844f //x=14.73 //y=0.89
c173 ( 57 0 ) capacitor c=0.0813322f //x=14.355 //y=2.095
c174 ( 56 0 ) capacitor c=0.0229267f //x=14.355 //y=1.7
c175 ( 55 0 ) capacitor c=0.0234352f //x=14.355 //y=1.39
c176 ( 54 0 ) capacitor c=0.0199343f //x=14.355 //y=1.045
c177 ( 53 0 ) capacitor c=0.110275f //x=14.89 //y=6.2
c178 ( 52 0 ) capacitor c=0.154305f //x=14.45 //y=6.2
c179 ( 50 0 ) capacitor c=0.00106608f //x=11.92 //y=5.335
c180 ( 49 0 ) capacitor c=0.00207319f //x=11.04 //y=5.335
c181 ( 42 0 ) capacitor c=0.0869732f //x=14.55 //y=2.26
c182 ( 40 0 ) capacitor c=0.107064f //x=12.7 //y=2.77
c183 ( 36 0 ) capacitor c=0.00398962f //x=12.3 //y=1.845
c184 ( 35 0 ) capacitor c=0.0137288f //x=12.615 //y=1.845
c185 ( 29 0 ) capacitor c=0.0284988f //x=12.615 //y=5.335
c186 ( 21 0 ) capacitor c=0.0176454f //x=11.835 //y=5.335
c187 ( 14 0 ) capacitor c=0.00332903f //x=10.245 //y=5.335
c188 ( 13 0 ) capacitor c=0.0148427f //x=10.955 //y=5.335
c189 ( 2 0 ) capacitor c=0.00808366f //x=12.815 //y=2.77
c190 ( 1 0 ) capacitor c=0.0353429f //x=14.435 //y=2.77
r191 (  75 77 ) resistor r=20.6867 //w=0.233 //l=0.1 //layer=ply \
 //thickness=0.18 //x=14.45 //y=4.88 //x2=14.55 //y2=4.88
r192 (  68 77 ) resistor r=70.3348 //w=0.233 //l=0.414367 //layer=ply \
 //thickness=0.18 //x=14.89 //y=5.045 //x2=14.55 //y2=4.88
r193 (  67 79 ) resistor r=45.1352 //w=0.168 //l=0.173853 //layer=ply \
 //thickness=0.18 //x=14.885 //y=1.39 //x2=14.845 //y2=1.545
r194 (  66 78 ) resistor r=45.1352 //w=0.168 //l=0.173853 //layer=ply \
 //thickness=0.18 //x=14.885 //y=1.045 //x2=14.845 //y2=0.89
r195 (  66 67 ) resistor r=176.904 //w=0.094 //l=0.345 //layer=ply \
 //thickness=0.18 //x=14.885 //y=1.045 //x2=14.885 //y2=1.39
r196 (  64 74 ) resistor r=10.701 //w=0.21 //l=0.115 //layer=ply \
 //thickness=0.18 //x=14.51 //y=1.545 //x2=14.395 //y2=1.545
r197 (  63 79 ) resistor r=5.52526 //w=0.168 //l=0.115 //layer=ply \
 //thickness=0.18 //x=14.73 //y=1.545 //x2=14.845 //y2=1.545
r198 (  62 73 ) resistor r=5.52526 //w=0.168 //l=0.115 //layer=ply \
 //thickness=0.18 //x=14.51 //y=0.89 //x2=14.395 //y2=0.89
r199 (  61 78 ) resistor r=5.52526 //w=0.168 //l=0.115 //layer=ply \
 //thickness=0.18 //x=14.73 //y=0.89 //x2=14.845 //y2=0.89
r200 (  61 62 ) resistor r=112.809 //w=0.094 //l=0.22 //layer=ply \
 //thickness=0.18 //x=14.73 //y=0.89 //x2=14.51 //y2=0.89
r201 (  58 75 ) resistor r=13.0941 //w=0.233 //l=0.165 //layer=ply \
 //thickness=0.18 //x=14.45 //y=5.045 //x2=14.45 //y2=4.88
r202 (  57 72 ) resistor r=34.8111 //w=0.27 //l=0.264953 //layer=ply \
 //thickness=0.18 //x=14.355 //y=2.095 //x2=14.55 //y2=2.26
r203 (  56 74 ) resistor r=39.5823 //w=0.21 //l=0.173853 //layer=ply \
 //thickness=0.18 //x=14.355 //y=1.7 //x2=14.395 //y2=1.545
r204 (  56 57 ) resistor r=202.543 //w=0.094 //l=0.395 //layer=ply \
 //thickness=0.18 //x=14.355 //y=1.7 //x2=14.355 //y2=2.095
r205 (  55 74 ) resistor r=39.5823 //w=0.21 //l=0.173853 //layer=ply \
 //thickness=0.18 //x=14.355 //y=1.39 //x2=14.395 //y2=1.545
r206 (  54 73 ) resistor r=45.1352 //w=0.168 //l=0.173853 //layer=ply \
 //thickness=0.18 //x=14.355 //y=1.045 //x2=14.395 //y2=0.89
r207 (  54 55 ) resistor r=176.904 //w=0.094 //l=0.345 //layer=ply \
 //thickness=0.18 //x=14.355 //y=1.045 //x2=14.355 //y2=1.39
r208 (  53 68 ) resistor r=592.245 //w=0.094 //l=1.155 //layer=ply \
 //thickness=0.18 //x=14.89 //y=6.2 //x2=14.89 //y2=5.045
r209 (  52 58 ) resistor r=592.245 //w=0.094 //l=1.155 //layer=ply \
 //thickness=0.18 //x=14.45 //y=6.2 //x2=14.45 //y2=5.045
r210 (  51 63 ) resistor r=56.4043 //w=0.094 //l=0.11 //layer=ply \
 //thickness=0.18 //x=14.62 //y=1.545 //x2=14.73 //y2=1.545
r211 (  51 64 ) resistor r=56.4043 //w=0.094 //l=0.11 //layer=ply \
 //thickness=0.18 //x=14.62 //y=1.545 //x2=14.51 //y2=1.545
r212 (  47 77 ) resistor r=152 //w=0.17 //l=0.17 //layer=licon //count=1 \
 //x=14.55 //y=4.88 //x2=14.55 //y2=4.88
r213 (  45 47 ) resistor r=144.428 //w=0.187 //l=2.11 //layer=li \
 //thickness=0.1 //x=14.55 //y=2.77 //x2=14.55 //y2=4.88
r214 (  42 72 ) resistor r=152 //w=0.17 //l=0.17 //layer=licon //count=1 \
 //x=14.55 //y=2.26 //x2=14.55 //y2=2.26
r215 (  42 45 ) resistor r=34.9091 //w=0.187 //l=0.51 //layer=li \
 //thickness=0.1 //x=14.55 //y=2.26 //x2=14.55 //y2=2.77
r216 (  38 40 ) resistor r=169.754 //w=0.187 //l=2.48 //layer=li \
 //thickness=0.1 //x=12.7 //y=5.25 //x2=12.7 //y2=2.77
r217 (  37 40 ) resistor r=57.4973 //w=0.187 //l=0.84 //layer=li \
 //thickness=0.1 //x=12.7 //y=1.93 //x2=12.7 //y2=2.77
r218 (  35 37 ) resistor r=7.15173 //w=0.17 //l=0.120208 //layer=li \
 //thickness=0.1 //x=12.615 //y=1.845 //x2=12.7 //y2=1.93
r219 (  35 36 ) resistor r=21.5615 //w=0.187 //l=0.315 //layer=li \
 //thickness=0.1 //x=12.615 //y=1.845 //x2=12.3 //y2=1.845
r220 (  31 36 ) resistor r=7.15173 //w=0.17 //l=0.120208 //layer=li \
 //thickness=0.1 //x=12.215 //y=1.76 //x2=12.3 //y2=1.845
r221 (  31 80 ) resistor r=39.016 //w=0.187 //l=0.57 //layer=li \
 //thickness=0.1 //x=12.215 //y=1.76 //x2=12.215 //y2=1.19
r222 (  30 50 ) resistor r=5.4201 //w=0.17 //l=0.085 //layer=li \
 //thickness=0.1 //x=12.005 //y=5.335 //x2=11.92 //y2=5.335
r223 (  29 38 ) resistor r=7.15173 //w=0.17 //l=0.120208 //layer=li \
 //thickness=0.1 //x=12.615 //y=5.335 //x2=12.7 //y2=5.25
r224 (  29 30 ) resistor r=41.754 //w=0.187 //l=0.61 //layer=li \
 //thickness=0.1 //x=12.615 //y=5.335 //x2=12.005 //y2=5.335
r225 (  23 50 ) resistor r=1.40859 //w=0.34 //l=0.085 //layer=li \
 //thickness=0.1 //x=11.92 //y=5.42 //x2=11.92 //y2=5.335
r226 (  23 84 ) resistor r=33.1979 //w=0.187 //l=0.485 //layer=li \
 //thickness=0.1 //x=11.92 //y=5.42 //x2=11.92 //y2=5.905
r227 (  22 49 ) resistor r=5.4201 //w=0.17 //l=0.085 //layer=li \
 //thickness=0.1 //x=11.125 //y=5.335 //x2=11.04 //y2=5.335
r228 (  21 50 ) resistor r=5.4201 //w=0.17 //l=0.085 //layer=li \
 //thickness=0.1 //x=11.835 //y=5.335 //x2=11.92 //y2=5.335
r229 (  21 22 ) resistor r=48.5989 //w=0.187 //l=0.71 //layer=li \
 //thickness=0.1 //x=11.835 //y=5.335 //x2=11.125 //y2=5.335
r230 (  15 49 ) resistor r=1.40859 //w=0.34 //l=0.085 //layer=li \
 //thickness=0.1 //x=11.04 //y=5.42 //x2=11.04 //y2=5.335
r231 (  15 83 ) resistor r=33.1979 //w=0.187 //l=0.485 //layer=li \
 //thickness=0.1 //x=11.04 //y=5.42 //x2=11.04 //y2=5.905
r232 (  13 49 ) resistor r=5.4201 //w=0.17 //l=0.085 //layer=li \
 //thickness=0.1 //x=10.955 //y=5.335 //x2=11.04 //y2=5.335
r233 (  13 14 ) resistor r=48.5989 //w=0.187 //l=0.71 //layer=li \
 //thickness=0.1 //x=10.955 //y=5.335 //x2=10.245 //y2=5.335
r234 (  7 14 ) resistor r=7.15173 //w=0.17 //l=0.120208 //layer=li \
 //thickness=0.1 //x=10.16 //y=5.42 //x2=10.245 //y2=5.335
r235 (  7 82 ) resistor r=33.1979 //w=0.187 //l=0.485 //layer=li \
 //thickness=0.1 //x=10.16 //y=5.42 //x2=10.16 //y2=5.905
r236 (  6 45 ) resistor r=9.3 //w=0.17 //l=0.17 //layer=mcon //count=1 \
 //x=14.55 //y=2.77 //x2=14.55 //y2=2.77
r237 (  4 40 ) resistor r=9.3 //w=0.17 //l=0.17 //layer=mcon //count=1 \
 //x=12.7 //y=2.77 //x2=12.7 //y2=2.77
r238 (  2 4 ) resistor r=0.0717383 //w=0.224 //l=0.115 //layer=m1 \
 //thickness=0.36 //x=12.815 //y=2.77 //x2=12.7 //y2=2.77
r239 (  1 6 ) resistor r=0.0717383 //w=0.224 //l=0.115 //layer=m1 \
 //thickness=0.36 //x=14.435 //y=2.77 //x2=14.55 //y2=2.77
r240 (  1 2 ) resistor r=1.5458 //w=0.131 //l=1.62 //layer=m1 //thickness=0.36 \
 //x=14.435 //y=2.77 //x2=12.815 //y2=2.77
ends PM_TMRDFFSNQNX1\%noxref_4

subckt PM_TMRDFFSNQNX1\%noxref_5 ( 1 2 3 4 11 13 23 24 31 39 45 46 50 52 61 62 \
 64 65 67 68 69 70 71 72 73 74 75 80 82 84 90 91 92 93 94 95 99 101 104 105 \
 110 111 114 128 131 133 134 135 )
c278 ( 135 0 ) capacitor c=0.023087f //x=6.965 //y=5.2
c279 ( 134 0 ) capacitor c=0.023519f //x=6.085 //y=5.2
c280 ( 133 0 ) capacitor c=0.0224735f //x=5.205 //y=5.2
c281 ( 131 0 ) capacitor c=0.00853354f //x=7.215 //y=1.095
c282 ( 128 0 ) capacitor c=0.0588816f //x=17.88 //y=4.88
c283 ( 114 0 ) capacitor c=0.0331534f //x=2.37 //y=4.88
c284 ( 111 0 ) capacitor c=0.0279499f //x=2.34 //y=2.095
c285 ( 110 0 ) capacitor c=0.0422587f //x=2.34 //y=2.26
c286 ( 105 0 ) capacitor c=0.0318948f //x=18.215 //y=1.39
c287 ( 104 0 ) capacitor c=0.0187384f //x=18.215 //y=1.045
c288 ( 101 0 ) capacitor c=0.0141798f //x=18.06 //y=1.545
c289 ( 99 0 ) capacitor c=0.0149844f //x=18.06 //y=0.89
c290 ( 95 0 ) capacitor c=0.0813322f //x=17.685 //y=2.095
c291 ( 94 0 ) capacitor c=0.0229267f //x=17.685 //y=1.7
c292 ( 93 0 ) capacitor c=0.0234352f //x=17.685 //y=1.39
c293 ( 92 0 ) capacitor c=0.0199343f //x=17.685 //y=1.045
c294 ( 91 0 ) capacitor c=0.0429696f //x=2.905 //y=1.43
c295 ( 90 0 ) capacitor c=0.0192208f //x=2.905 //y=1.085
c296 ( 84 0 ) capacitor c=0.0158629f //x=2.75 //y=1.585
c297 ( 82 0 ) capacitor c=0.0157803f //x=2.75 //y=0.93
c298 ( 80 0 ) capacitor c=0.0299681f //x=2.745 //y=4.97
c299 ( 75 0 ) capacitor c=0.0205163f //x=2.375 //y=1.74
c300 ( 74 0 ) capacitor c=0.0168481f //x=2.375 //y=1.43
c301 ( 73 0 ) capacitor c=0.0174783f //x=2.375 //y=1.085
c302 ( 72 0 ) capacitor c=0.110275f //x=18.22 //y=6.2
c303 ( 71 0 ) capacitor c=0.154305f //x=17.78 //y=6.2
c304 ( 70 0 ) capacitor c=0.15358f //x=2.82 //y=6.2
c305 ( 69 0 ) capacitor c=0.110281f //x=2.38 //y=6.2
c306 ( 65 0 ) capacitor c=0.0755336f //x=7.887 //y=4.085
c307 ( 64 0 ) capacitor c=0.0101843f //x=7.885 //y=4.25
c308 ( 62 0 ) capacitor c=0.00106608f //x=7.11 //y=5.335
c309 ( 61 0 ) capacitor c=0.00207162f //x=6.23 //y=5.335
c310 ( 52 0 ) capacitor c=0.0888543f //x=17.88 //y=2.26
c311 ( 50 0 ) capacitor c=0.0236247f //x=7.89 //y=5.25
c312 ( 46 0 ) capacitor c=0.00431225f //x=7.49 //y=1.845
c313 ( 45 0 ) capacitor c=0.0141453f //x=7.805 //y=1.845
c314 ( 39 0 ) capacitor c=0.0281378f //x=7.805 //y=5.335
c315 ( 31 0 ) capacitor c=0.0176454f //x=7.025 //y=5.335
c316 ( 24 0 ) capacitor c=0.00351598f //x=5.435 //y=5.335
c317 ( 23 0 ) capacitor c=0.0154196f //x=6.145 //y=5.335
c318 ( 13 0 ) capacitor c=0.0765924f //x=2.34 //y=2.26
c319 ( 11 0 ) capacitor c=0.00453889f //x=2.34 //y=4.715
c320 ( 4 0 ) capacitor c=0.00551102f //x=8 //y=4.25
c321 ( 3 0 ) capacitor c=0.141703f //x=17.765 //y=4.25
c322 ( 2 0 ) capacitor c=0.0165998f //x=2.455 //y=4.25
c323 ( 1 0 ) capacitor c=0.143583f //x=7.77 //y=4.25
r324 (  126 128 ) resistor r=20.6867 //w=0.233 //l=0.1 //layer=ply \
 //thickness=0.18 //x=17.78 //y=4.88 //x2=17.88 //y2=4.88
r325 (  116 117 ) resistor r=32.4568 //w=0.214 //l=0.075 //layer=ply \
 //thickness=0.18 //x=2.37 //y=4.97 //x2=2.37 //y2=5.045
r326 (  114 116 ) resistor r=20.271 //w=0.214 //l=0.09 //layer=ply \
 //thickness=0.18 //x=2.37 //y=4.88 //x2=2.37 //y2=4.97
r327 (  110 111 ) resistor r=52.7279 //w=0.214 //l=0.165 //layer=ply \
 //thickness=0.18 //x=2.34 //y=2.26 //x2=2.34 //y2=2.095
r328 (  106 128 ) resistor r=70.3348 //w=0.233 //l=0.414367 //layer=ply \
 //thickness=0.18 //x=18.22 //y=5.045 //x2=17.88 //y2=4.88
r329 (  105 130 ) resistor r=45.1352 //w=0.168 //l=0.173853 //layer=ply \
 //thickness=0.18 //x=18.215 //y=1.39 //x2=18.175 //y2=1.545
r330 (  104 129 ) resistor r=45.1352 //w=0.168 //l=0.173853 //layer=ply \
 //thickness=0.18 //x=18.215 //y=1.045 //x2=18.175 //y2=0.89
r331 (  104 105 ) resistor r=176.904 //w=0.094 //l=0.345 //layer=ply \
 //thickness=0.18 //x=18.215 //y=1.045 //x2=18.215 //y2=1.39
r332 (  102 125 ) resistor r=10.701 //w=0.21 //l=0.115 //layer=ply \
 //thickness=0.18 //x=17.84 //y=1.545 //x2=17.725 //y2=1.545
r333 (  101 130 ) resistor r=5.52526 //w=0.168 //l=0.115 //layer=ply \
 //thickness=0.18 //x=18.06 //y=1.545 //x2=18.175 //y2=1.545
r334 (  100 124 ) resistor r=5.52526 //w=0.168 //l=0.115 //layer=ply \
 //thickness=0.18 //x=17.84 //y=0.89 //x2=17.725 //y2=0.89
r335 (  99 129 ) resistor r=5.52526 //w=0.168 //l=0.115 //layer=ply \
 //thickness=0.18 //x=18.06 //y=0.89 //x2=18.175 //y2=0.89
r336 (  99 100 ) resistor r=112.809 //w=0.094 //l=0.22 //layer=ply \
 //thickness=0.18 //x=18.06 //y=0.89 //x2=17.84 //y2=0.89
r337 (  96 126 ) resistor r=13.0941 //w=0.233 //l=0.165 //layer=ply \
 //thickness=0.18 //x=17.78 //y=5.045 //x2=17.78 //y2=4.88
r338 (  95 123 ) resistor r=34.8111 //w=0.27 //l=0.264953 //layer=ply \
 //thickness=0.18 //x=17.685 //y=2.095 //x2=17.88 //y2=2.26
r339 (  94 125 ) resistor r=39.5823 //w=0.21 //l=0.173853 //layer=ply \
 //thickness=0.18 //x=17.685 //y=1.7 //x2=17.725 //y2=1.545
r340 (  94 95 ) resistor r=202.543 //w=0.094 //l=0.395 //layer=ply \
 //thickness=0.18 //x=17.685 //y=1.7 //x2=17.685 //y2=2.095
r341 (  93 125 ) resistor r=39.5823 //w=0.21 //l=0.173853 //layer=ply \
 //thickness=0.18 //x=17.685 //y=1.39 //x2=17.725 //y2=1.545
r342 (  92 124 ) resistor r=45.1352 //w=0.168 //l=0.173853 //layer=ply \
 //thickness=0.18 //x=17.685 //y=1.045 //x2=17.725 //y2=0.89
r343 (  92 93 ) resistor r=176.904 //w=0.094 //l=0.345 //layer=ply \
 //thickness=0.18 //x=17.685 //y=1.045 //x2=17.685 //y2=1.39
r344 (  91 121 ) resistor r=45.1352 //w=0.168 //l=0.173853 //layer=ply \
 //thickness=0.18 //x=2.905 //y=1.43 //x2=2.865 //y2=1.585
r345 (  90 120 ) resistor r=45.1352 //w=0.168 //l=0.173853 //layer=ply \
 //thickness=0.18 //x=2.905 //y=1.085 //x2=2.865 //y2=0.93
r346 (  90 91 ) resistor r=176.904 //w=0.094 //l=0.345 //layer=ply \
 //thickness=0.18 //x=2.905 //y=1.085 //x2=2.905 //y2=1.43
r347 (  85 119 ) resistor r=10.701 //w=0.21 //l=0.115 //layer=ply \
 //thickness=0.18 //x=2.53 //y=1.585 //x2=2.415 //y2=1.585
r348 (  84 121 ) resistor r=5.52526 //w=0.168 //l=0.115 //layer=ply \
 //thickness=0.18 //x=2.75 //y=1.585 //x2=2.865 //y2=1.585
r349 (  83 118 ) resistor r=5.52526 //w=0.168 //l=0.115 //layer=ply \
 //thickness=0.18 //x=2.53 //y=0.93 //x2=2.415 //y2=0.93
r350 (  82 120 ) resistor r=5.52526 //w=0.168 //l=0.115 //layer=ply \
 //thickness=0.18 //x=2.75 //y=0.93 //x2=2.865 //y2=0.93
r351 (  82 83 ) resistor r=112.809 //w=0.094 //l=0.22 //layer=ply \
 //thickness=0.18 //x=2.75 //y=0.93 //x2=2.53 //y2=0.93
r352 (  81 116 ) resistor r=16.5046 //w=0.27 //l=0.135 //layer=ply \
 //thickness=0.18 //x=2.505 //y=4.97 //x2=2.37 //y2=4.97
r353 (  80 87 ) resistor r=26.9307 //w=0.15 //l=0.106066 //layer=ply \
 //thickness=0.18 //x=2.745 //y=4.97 //x2=2.82 //y2=5.045
r354 (  80 81 ) resistor r=123.064 //w=0.094 //l=0.24 //layer=ply \
 //thickness=0.18 //x=2.745 //y=4.97 //x2=2.505 //y2=4.97
r355 (  75 119 ) resistor r=39.5823 //w=0.21 //l=0.173853 //layer=ply \
 //thickness=0.18 //x=2.375 //y=1.74 //x2=2.415 //y2=1.585
r356 (  75 111 ) resistor r=182.032 //w=0.094 //l=0.355 //layer=ply \
 //thickness=0.18 //x=2.375 //y=1.74 //x2=2.375 //y2=2.095
r357 (  74 119 ) resistor r=39.5823 //w=0.21 //l=0.173853 //layer=ply \
 //thickness=0.18 //x=2.375 //y=1.43 //x2=2.415 //y2=1.585
r358 (  73 118 ) resistor r=45.1352 //w=0.168 //l=0.173853 //layer=ply \
 //thickness=0.18 //x=2.375 //y=1.085 //x2=2.415 //y2=0.93
r359 (  73 74 ) resistor r=176.904 //w=0.094 //l=0.345 //layer=ply \
 //thickness=0.18 //x=2.375 //y=1.085 //x2=2.375 //y2=1.43
r360 (  72 106 ) resistor r=592.245 //w=0.094 //l=1.155 //layer=ply \
 //thickness=0.18 //x=18.22 //y=6.2 //x2=18.22 //y2=5.045
r361 (  71 96 ) resistor r=592.245 //w=0.094 //l=1.155 //layer=ply \
 //thickness=0.18 //x=17.78 //y=6.2 //x2=17.78 //y2=5.045
r362 (  70 87 ) resistor r=592.245 //w=0.094 //l=1.155 //layer=ply \
 //thickness=0.18 //x=2.82 //y=6.2 //x2=2.82 //y2=5.045
r363 (  69 117 ) resistor r=592.245 //w=0.094 //l=1.155 //layer=ply \
 //thickness=0.18 //x=2.38 //y=6.2 //x2=2.38 //y2=5.045
r364 (  68 101 ) resistor r=56.4043 //w=0.094 //l=0.11 //layer=ply \
 //thickness=0.18 //x=17.95 //y=1.545 //x2=18.06 //y2=1.545
r365 (  68 102 ) resistor r=56.4043 //w=0.094 //l=0.11 //layer=ply \
 //thickness=0.18 //x=17.95 //y=1.545 //x2=17.84 //y2=1.545
r366 (  67 84 ) resistor r=56.4043 //w=0.094 //l=0.11 //layer=ply \
 //thickness=0.18 //x=2.64 //y=1.585 //x2=2.75 //y2=1.585
r367 (  67 85 ) resistor r=56.4043 //w=0.094 //l=0.11 //layer=ply \
 //thickness=0.18 //x=2.64 //y=1.585 //x2=2.53 //y2=1.585
r368 (  64 66 ) resistor r=11 //w=0.192 //l=0.165 //layer=li //thickness=0.1 \
 //x=7.887 //y=4.25 //x2=7.887 //y2=4.415
r369 (  64 65 ) resistor r=11 //w=0.192 //l=0.165 //layer=li //thickness=0.1 \
 //x=7.887 //y=4.25 //x2=7.887 //y2=4.085
r370 (  60 114 ) resistor r=152 //w=0.17 //l=0.17 //layer=licon //count=1 \
 //x=2.37 //y=4.88 //x2=2.37 //y2=4.88
r371 (  57 128 ) resistor r=152 //w=0.17 //l=0.17 //layer=licon //count=1 \
 //x=17.88 //y=4.88 //x2=17.88 //y2=4.88
r372 (  55 57 ) resistor r=43.123 //w=0.187 //l=0.63 //layer=li \
 //thickness=0.1 //x=17.88 //y=4.25 //x2=17.88 //y2=4.88
r373 (  52 123 ) resistor r=152 //w=0.17 //l=0.17 //layer=licon //count=1 \
 //x=17.88 //y=2.26 //x2=17.88 //y2=2.26
r374 (  52 55 ) resistor r=136.214 //w=0.187 //l=1.99 //layer=li \
 //thickness=0.1 //x=17.88 //y=2.26 //x2=17.88 //y2=4.25
r375 (  50 66 ) resistor r=57.1551 //w=0.187 //l=0.835 //layer=li \
 //thickness=0.1 //x=7.89 //y=5.25 //x2=7.89 //y2=4.415
r376 (  47 65 ) resistor r=147.508 //w=0.187 //l=2.155 //layer=li \
 //thickness=0.1 //x=7.89 //y=1.93 //x2=7.89 //y2=4.085
r377 (  45 47 ) resistor r=7.15173 //w=0.17 //l=0.120208 //layer=li \
 //thickness=0.1 //x=7.805 //y=1.845 //x2=7.89 //y2=1.93
r378 (  45 46 ) resistor r=21.5615 //w=0.187 //l=0.315 //layer=li \
 //thickness=0.1 //x=7.805 //y=1.845 //x2=7.49 //y2=1.845
r379 (  41 46 ) resistor r=7.15173 //w=0.17 //l=0.120208 //layer=li \
 //thickness=0.1 //x=7.405 //y=1.76 //x2=7.49 //y2=1.845
r380 (  41 131 ) resistor r=39.016 //w=0.187 //l=0.57 //layer=li \
 //thickness=0.1 //x=7.405 //y=1.76 //x2=7.405 //y2=1.19
r381 (  40 62 ) resistor r=5.4201 //w=0.17 //l=0.085 //layer=li \
 //thickness=0.1 //x=7.195 //y=5.335 //x2=7.11 //y2=5.335
r382 (  39 50 ) resistor r=7.15173 //w=0.17 //l=0.120208 //layer=li \
 //thickness=0.1 //x=7.805 //y=5.335 //x2=7.89 //y2=5.25
r383 (  39 40 ) resistor r=41.754 //w=0.187 //l=0.61 //layer=li \
 //thickness=0.1 //x=7.805 //y=5.335 //x2=7.195 //y2=5.335
r384 (  33 62 ) resistor r=1.40859 //w=0.34 //l=0.085 //layer=li \
 //thickness=0.1 //x=7.11 //y=5.42 //x2=7.11 //y2=5.335
r385 (  33 135 ) resistor r=33.1979 //w=0.187 //l=0.485 //layer=li \
 //thickness=0.1 //x=7.11 //y=5.42 //x2=7.11 //y2=5.905
r386 (  32 61 ) resistor r=5.4201 //w=0.17 //l=0.085 //layer=li \
 //thickness=0.1 //x=6.315 //y=5.335 //x2=6.23 //y2=5.335
r387 (  31 62 ) resistor r=5.4201 //w=0.17 //l=0.085 //layer=li \
 //thickness=0.1 //x=7.025 //y=5.335 //x2=7.11 //y2=5.335
r388 (  31 32 ) resistor r=48.5989 //w=0.187 //l=0.71 //layer=li \
 //thickness=0.1 //x=7.025 //y=5.335 //x2=6.315 //y2=5.335
r389 (  25 61 ) resistor r=1.40859 //w=0.34 //l=0.085 //layer=li \
 //thickness=0.1 //x=6.23 //y=5.42 //x2=6.23 //y2=5.335
r390 (  25 134 ) resistor r=33.1979 //w=0.187 //l=0.485 //layer=li \
 //thickness=0.1 //x=6.23 //y=5.42 //x2=6.23 //y2=5.905
r391 (  23 61 ) resistor r=5.4201 //w=0.17 //l=0.085 //layer=li \
 //thickness=0.1 //x=6.145 //y=5.335 //x2=6.23 //y2=5.335
r392 (  23 24 ) resistor r=48.5989 //w=0.187 //l=0.71 //layer=li \
 //thickness=0.1 //x=6.145 //y=5.335 //x2=5.435 //y2=5.335
r393 (  17 24 ) resistor r=7.15173 //w=0.17 //l=0.120208 //layer=li \
 //thickness=0.1 //x=5.35 //y=5.42 //x2=5.435 //y2=5.335
r394 (  17 133 ) resistor r=33.1979 //w=0.187 //l=0.485 //layer=li \
 //thickness=0.1 //x=5.35 //y=5.42 //x2=5.35 //y2=5.905
r395 (  13 110 ) resistor r=152 //w=0.17 //l=0.17 //layer=licon //count=1 \
 //x=2.34 //y=2.26 //x2=2.34 //y2=2.26
r396 (  13 16 ) resistor r=136.214 //w=0.187 //l=1.99 //layer=li \
 //thickness=0.1 //x=2.34 //y=2.26 //x2=2.34 //y2=4.25
r397 (  11 60 ) resistor r=11.4737 //w=0.186 //l=0.172337 //layer=li \
 //thickness=0.1 //x=2.34 //y=4.715 //x2=2.355 //y2=4.88
r398 (  11 16 ) resistor r=31.8289 //w=0.187 //l=0.465 //layer=li \
 //thickness=0.1 //x=2.34 //y=4.715 //x2=2.34 //y2=4.25
r399 (  10 55 ) resistor r=9.3 //w=0.17 //l=0.17 //layer=mcon //count=1 \
 //x=17.88 //y=4.25 //x2=17.88 //y2=4.25
r400 (  8 64 ) resistor r=9.3 //w=0.17 //l=0.17 //layer=mcon //count=1 \
 //x=7.885 //y=4.25 //x2=7.885 //y2=4.25
r401 (  6 16 ) resistor r=9.3 //w=0.17 //l=0.17 //layer=mcon //count=1 \
 //x=2.34 //y=4.25 //x2=2.34 //y2=4.25
r402 (  4 8 ) resistor r=0.0880901 //w=0.191 //l=0.115 //layer=m1 \
 //thickness=0.36 //x=8 //y=4.25 //x2=7.885 //y2=4.25
r403 (  3 10 ) resistor r=0.0717383 //w=0.224 //l=0.115 //layer=m1 \
 //thickness=0.36 //x=17.765 //y=4.25 //x2=17.88 //y2=4.25
r404 (  3 4 ) resistor r=9.31775 //w=0.131 //l=9.765 //layer=m1 \
 //thickness=0.36 //x=17.765 //y=4.25 //x2=8 //y2=4.25
r405 (  2 6 ) resistor r=0.0717383 //w=0.224 //l=0.115 //layer=m1 \
 //thickness=0.36 //x=2.455 //y=4.25 //x2=2.34 //y2=4.25
r406 (  1 8 ) resistor r=0.0880901 //w=0.191 //l=0.115 //layer=m1 \
 //thickness=0.36 //x=7.77 //y=4.25 //x2=7.885 //y2=4.25
r407 (  1 2 ) resistor r=5.07156 //w=0.131 //l=5.315 //layer=m1 \
 //thickness=0.36 //x=7.77 //y=4.25 //x2=2.455 //y2=4.25
ends PM_TMRDFFSNQNX1\%noxref_5

subckt PM_TMRDFFSNQNX1\%noxref_6 ( 1 2 3 4 5 6 16 24 37 38 49 51 52 56 58 65 \
 66 67 68 69 70 71 72 73 74 78 79 80 85 87 90 91 95 96 97 102 104 107 108 112 \
 113 114 119 121 124 125 127 128 133 137 138 143 147 148 153 156 158 159 )
c324 ( 159 0 ) capacitor c=0.0220291f //x=15.405 //y=5.2
c325 ( 158 0 ) capacitor c=0.0217503f //x=14.525 //y=5.2
c326 ( 156 0 ) capacitor c=0.00866655f //x=15.4 //y=1.085
c327 ( 153 0 ) capacitor c=0.0587755f //x=23.43 //y=4.88
c328 ( 148 0 ) capacitor c=0.0273931f //x=23.43 //y=2.095
c329 ( 147 0 ) capacitor c=0.0456313f //x=23.43 //y=2.26
c330 ( 143 0 ) capacitor c=0.0587755f //x=11.96 //y=4.88
c331 ( 138 0 ) capacitor c=0.0273931f //x=11.96 //y=2.095
c332 ( 137 0 ) capacitor c=0.0456313f //x=11.96 //y=2.26
c333 ( 133 0 ) capacitor c=0.058931f //x=7.15 //y=4.88
c334 ( 128 0 ) capacitor c=0.0267105f //x=7.15 //y=2.095
c335 ( 127 0 ) capacitor c=0.0457054f //x=7.15 //y=2.26
c336 ( 125 0 ) capacitor c=0.0432517f //x=23.95 //y=1.44
c337 ( 124 0 ) capacitor c=0.0200379f //x=23.95 //y=1.095
c338 ( 121 0 ) capacitor c=0.0148873f //x=23.795 //y=1.595
c339 ( 119 0 ) capacitor c=0.0157803f //x=23.795 //y=0.94
c340 ( 114 0 ) capacitor c=0.0218028f //x=23.42 //y=1.75
c341 ( 113 0 ) capacitor c=0.0207459f //x=23.42 //y=1.44
c342 ( 112 0 ) capacitor c=0.0194308f //x=23.42 //y=1.095
c343 ( 108 0 ) capacitor c=0.0432517f //x=12.48 //y=1.44
c344 ( 107 0 ) capacitor c=0.0200379f //x=12.48 //y=1.095
c345 ( 104 0 ) capacitor c=0.0148873f //x=12.325 //y=1.595
c346 ( 102 0 ) capacitor c=0.0157803f //x=12.325 //y=0.94
c347 ( 97 0 ) capacitor c=0.0218028f //x=11.95 //y=1.75
c348 ( 96 0 ) capacitor c=0.0207459f //x=11.95 //y=1.44
c349 ( 95 0 ) capacitor c=0.0194308f //x=11.95 //y=1.095
c350 ( 91 0 ) capacitor c=0.0432517f //x=7.67 //y=1.44
c351 ( 90 0 ) capacitor c=0.0200379f //x=7.67 //y=1.095
c352 ( 87 0 ) capacitor c=0.0158629f //x=7.515 //y=1.595
c353 ( 85 0 ) capacitor c=0.0157803f //x=7.515 //y=0.94
c354 ( 80 0 ) capacitor c=0.0218028f //x=7.14 //y=1.75
c355 ( 79 0 ) capacitor c=0.0207459f //x=7.14 //y=1.44
c356 ( 78 0 ) capacitor c=0.0194308f //x=7.14 //y=1.095
c357 ( 74 0 ) capacitor c=0.158794f //x=23.61 //y=6.2
c358 ( 73 0 ) capacitor c=0.110114f //x=23.17 //y=6.2
c359 ( 72 0 ) capacitor c=0.158794f //x=12.14 //y=6.2
c360 ( 71 0 ) capacitor c=0.110114f //x=11.7 //y=6.2
c361 ( 70 0 ) capacitor c=0.158048f //x=7.33 //y=6.2
c362 ( 69 0 ) capacitor c=0.110114f //x=6.89 //y=6.2
c363 ( 65 0 ) capacitor c=0.00211606f //x=15.55 //y=5.38
c364 ( 58 0 ) capacitor c=0.0820102f //x=23.43 //y=2.26
c365 ( 56 0 ) capacitor c=0.106638f //x=16.03 //y=3.88
c366 ( 52 0 ) capacitor c=0.00404073f //x=15.675 //y=1.835
c367 ( 51 0 ) capacitor c=0.0122201f //x=15.945 //y=1.835
c368 ( 49 0 ) capacitor c=0.0137522f //x=15.945 //y=5.38
c369 ( 38 0 ) capacitor c=0.00251635f //x=14.755 //y=5.38
c370 ( 37 0 ) capacitor c=0.0142529f //x=15.465 //y=5.38
c371 ( 24 0 ) capacitor c=0.0834768f //x=11.96 //y=2.26
c372 ( 16 0 ) capacitor c=0.0842778f //x=7.15 //y=2.26
c373 ( 6 0 ) capacitor c=0.0043044f //x=16.145 //y=3.88
c374 ( 5 0 ) capacitor c=0.130401f //x=23.315 //y=3.88
c375 ( 4 0 ) capacitor c=0.00443912f //x=12.075 //y=3.88
c376 ( 3 0 ) capacitor c=0.0668348f //x=15.915 //y=3.88
c377 ( 2 0 ) capacitor c=0.0143354f //x=7.265 //y=3.88
c378 ( 1 0 ) capacitor c=0.0815699f //x=11.845 //y=3.88
r379 (  147 148 ) resistor r=52.7279 //w=0.214 //l=0.165 //layer=ply \
 //thickness=0.18 //x=23.43 //y=2.26 //x2=23.43 //y2=2.095
r380 (  137 138 ) resistor r=52.7279 //w=0.214 //l=0.165 //layer=ply \
 //thickness=0.18 //x=11.96 //y=2.26 //x2=11.96 //y2=2.095
r381 (  127 128 ) resistor r=52.7279 //w=0.214 //l=0.165 //layer=ply \
 //thickness=0.18 //x=7.15 //y=2.26 //x2=7.15 //y2=2.095
r382 (  125 155 ) resistor r=45.1352 //w=0.168 //l=0.173853 //layer=ply \
 //thickness=0.18 //x=23.95 //y=1.44 //x2=23.91 //y2=1.595
r383 (  124 154 ) resistor r=45.1352 //w=0.168 //l=0.173853 //layer=ply \
 //thickness=0.18 //x=23.95 //y=1.095 //x2=23.91 //y2=0.94
r384 (  124 125 ) resistor r=176.904 //w=0.094 //l=0.345 //layer=ply \
 //thickness=0.18 //x=23.95 //y=1.095 //x2=23.95 //y2=1.44
r385 (  122 151 ) resistor r=10.701 //w=0.21 //l=0.115 //layer=ply \
 //thickness=0.18 //x=23.575 //y=1.595 //x2=23.46 //y2=1.595
r386 (  121 155 ) resistor r=5.52526 //w=0.168 //l=0.115 //layer=ply \
 //thickness=0.18 //x=23.795 //y=1.595 //x2=23.91 //y2=1.595
r387 (  120 150 ) resistor r=5.52526 //w=0.168 //l=0.115 //layer=ply \
 //thickness=0.18 //x=23.575 //y=0.94 //x2=23.46 //y2=0.94
r388 (  119 154 ) resistor r=5.52526 //w=0.168 //l=0.115 //layer=ply \
 //thickness=0.18 //x=23.795 //y=0.94 //x2=23.91 //y2=0.94
r389 (  119 120 ) resistor r=112.809 //w=0.094 //l=0.22 //layer=ply \
 //thickness=0.18 //x=23.795 //y=0.94 //x2=23.575 //y2=0.94
r390 (  116 153 ) resistor r=37.236 //w=0.233 //l=0.249199 //layer=ply \
 //thickness=0.18 //x=23.61 //y=5.045 //x2=23.43 //y2=4.88
r391 (  114 151 ) resistor r=39.5823 //w=0.21 //l=0.173853 //layer=ply \
 //thickness=0.18 //x=23.42 //y=1.75 //x2=23.46 //y2=1.595
r392 (  114 148 ) resistor r=176.904 //w=0.094 //l=0.345 //layer=ply \
 //thickness=0.18 //x=23.42 //y=1.75 //x2=23.42 //y2=2.095
r393 (  113 151 ) resistor r=39.5823 //w=0.21 //l=0.173853 //layer=ply \
 //thickness=0.18 //x=23.42 //y=1.44 //x2=23.46 //y2=1.595
r394 (  112 150 ) resistor r=45.1352 //w=0.168 //l=0.173853 //layer=ply \
 //thickness=0.18 //x=23.42 //y=1.095 //x2=23.46 //y2=0.94
r395 (  112 113 ) resistor r=176.904 //w=0.094 //l=0.345 //layer=ply \
 //thickness=0.18 //x=23.42 //y=1.095 //x2=23.42 //y2=1.44
r396 (  109 153 ) resistor r=53.7854 //w=0.233 //l=0.332415 //layer=ply \
 //thickness=0.18 //x=23.17 //y=5.045 //x2=23.43 //y2=4.88
r397 (  108 145 ) resistor r=45.1352 //w=0.168 //l=0.173853 //layer=ply \
 //thickness=0.18 //x=12.48 //y=1.44 //x2=12.44 //y2=1.595
r398 (  107 144 ) resistor r=45.1352 //w=0.168 //l=0.173853 //layer=ply \
 //thickness=0.18 //x=12.48 //y=1.095 //x2=12.44 //y2=0.94
r399 (  107 108 ) resistor r=176.904 //w=0.094 //l=0.345 //layer=ply \
 //thickness=0.18 //x=12.48 //y=1.095 //x2=12.48 //y2=1.44
r400 (  105 141 ) resistor r=10.701 //w=0.21 //l=0.115 //layer=ply \
 //thickness=0.18 //x=12.105 //y=1.595 //x2=11.99 //y2=1.595
r401 (  104 145 ) resistor r=5.52526 //w=0.168 //l=0.115 //layer=ply \
 //thickness=0.18 //x=12.325 //y=1.595 //x2=12.44 //y2=1.595
r402 (  103 140 ) resistor r=5.52526 //w=0.168 //l=0.115 //layer=ply \
 //thickness=0.18 //x=12.105 //y=0.94 //x2=11.99 //y2=0.94
r403 (  102 144 ) resistor r=5.52526 //w=0.168 //l=0.115 //layer=ply \
 //thickness=0.18 //x=12.325 //y=0.94 //x2=12.44 //y2=0.94
r404 (  102 103 ) resistor r=112.809 //w=0.094 //l=0.22 //layer=ply \
 //thickness=0.18 //x=12.325 //y=0.94 //x2=12.105 //y2=0.94
r405 (  99 143 ) resistor r=37.236 //w=0.233 //l=0.249199 //layer=ply \
 //thickness=0.18 //x=12.14 //y=5.045 //x2=11.96 //y2=4.88
r406 (  97 141 ) resistor r=39.5823 //w=0.21 //l=0.173853 //layer=ply \
 //thickness=0.18 //x=11.95 //y=1.75 //x2=11.99 //y2=1.595
r407 (  97 138 ) resistor r=176.904 //w=0.094 //l=0.345 //layer=ply \
 //thickness=0.18 //x=11.95 //y=1.75 //x2=11.95 //y2=2.095
r408 (  96 141 ) resistor r=39.5823 //w=0.21 //l=0.173853 //layer=ply \
 //thickness=0.18 //x=11.95 //y=1.44 //x2=11.99 //y2=1.595
r409 (  95 140 ) resistor r=45.1352 //w=0.168 //l=0.173853 //layer=ply \
 //thickness=0.18 //x=11.95 //y=1.095 //x2=11.99 //y2=0.94
r410 (  95 96 ) resistor r=176.904 //w=0.094 //l=0.345 //layer=ply \
 //thickness=0.18 //x=11.95 //y=1.095 //x2=11.95 //y2=1.44
r411 (  92 143 ) resistor r=53.7854 //w=0.233 //l=0.332415 //layer=ply \
 //thickness=0.18 //x=11.7 //y=5.045 //x2=11.96 //y2=4.88
r412 (  91 135 ) resistor r=45.1352 //w=0.168 //l=0.173853 //layer=ply \
 //thickness=0.18 //x=7.67 //y=1.44 //x2=7.63 //y2=1.595
r413 (  90 134 ) resistor r=45.1352 //w=0.168 //l=0.173853 //layer=ply \
 //thickness=0.18 //x=7.67 //y=1.095 //x2=7.63 //y2=0.94
r414 (  90 91 ) resistor r=176.904 //w=0.094 //l=0.345 //layer=ply \
 //thickness=0.18 //x=7.67 //y=1.095 //x2=7.67 //y2=1.44
r415 (  88 131 ) resistor r=10.701 //w=0.21 //l=0.115 //layer=ply \
 //thickness=0.18 //x=7.295 //y=1.595 //x2=7.18 //y2=1.595
r416 (  87 135 ) resistor r=5.52526 //w=0.168 //l=0.115 //layer=ply \
 //thickness=0.18 //x=7.515 //y=1.595 //x2=7.63 //y2=1.595
r417 (  86 130 ) resistor r=5.52526 //w=0.168 //l=0.115 //layer=ply \
 //thickness=0.18 //x=7.295 //y=0.94 //x2=7.18 //y2=0.94
r418 (  85 134 ) resistor r=5.52526 //w=0.168 //l=0.115 //layer=ply \
 //thickness=0.18 //x=7.515 //y=0.94 //x2=7.63 //y2=0.94
r419 (  85 86 ) resistor r=112.809 //w=0.094 //l=0.22 //layer=ply \
 //thickness=0.18 //x=7.515 //y=0.94 //x2=7.295 //y2=0.94
r420 (  82 133 ) resistor r=37.236 //w=0.233 //l=0.249199 //layer=ply \
 //thickness=0.18 //x=7.33 //y=5.045 //x2=7.15 //y2=4.88
r421 (  80 131 ) resistor r=39.5823 //w=0.21 //l=0.173853 //layer=ply \
 //thickness=0.18 //x=7.14 //y=1.75 //x2=7.18 //y2=1.595
r422 (  80 128 ) resistor r=176.904 //w=0.094 //l=0.345 //layer=ply \
 //thickness=0.18 //x=7.14 //y=1.75 //x2=7.14 //y2=2.095
r423 (  79 131 ) resistor r=39.5823 //w=0.21 //l=0.173853 //layer=ply \
 //thickness=0.18 //x=7.14 //y=1.44 //x2=7.18 //y2=1.595
r424 (  78 130 ) resistor r=45.1352 //w=0.168 //l=0.173853 //layer=ply \
 //thickness=0.18 //x=7.14 //y=1.095 //x2=7.18 //y2=0.94
r425 (  78 79 ) resistor r=176.904 //w=0.094 //l=0.345 //layer=ply \
 //thickness=0.18 //x=7.14 //y=1.095 //x2=7.14 //y2=1.44
r426 (  75 133 ) resistor r=53.7854 //w=0.233 //l=0.332415 //layer=ply \
 //thickness=0.18 //x=6.89 //y=5.045 //x2=7.15 //y2=4.88
r427 (  74 116 ) resistor r=592.245 //w=0.094 //l=1.155 //layer=ply \
 //thickness=0.18 //x=23.61 //y=6.2 //x2=23.61 //y2=5.045
r428 (  73 109 ) resistor r=592.245 //w=0.094 //l=1.155 //layer=ply \
 //thickness=0.18 //x=23.17 //y=6.2 //x2=23.17 //y2=5.045
r429 (  72 99 ) resistor r=592.245 //w=0.094 //l=1.155 //layer=ply \
 //thickness=0.18 //x=12.14 //y=6.2 //x2=12.14 //y2=5.045
r430 (  71 92 ) resistor r=592.245 //w=0.094 //l=1.155 //layer=ply \
 //thickness=0.18 //x=11.7 //y=6.2 //x2=11.7 //y2=5.045
r431 (  70 82 ) resistor r=592.245 //w=0.094 //l=1.155 //layer=ply \
 //thickness=0.18 //x=7.33 //y=6.2 //x2=7.33 //y2=5.045
r432 (  69 75 ) resistor r=592.245 //w=0.094 //l=1.155 //layer=ply \
 //thickness=0.18 //x=6.89 //y=6.2 //x2=6.89 //y2=5.045
r433 (  68 121 ) resistor r=56.4043 //w=0.094 //l=0.11 //layer=ply \
 //thickness=0.18 //x=23.685 //y=1.595 //x2=23.795 //y2=1.595
r434 (  68 122 ) resistor r=56.4043 //w=0.094 //l=0.11 //layer=ply \
 //thickness=0.18 //x=23.685 //y=1.595 //x2=23.575 //y2=1.595
r435 (  67 104 ) resistor r=56.4043 //w=0.094 //l=0.11 //layer=ply \
 //thickness=0.18 //x=12.215 //y=1.595 //x2=12.325 //y2=1.595
r436 (  67 105 ) resistor r=56.4043 //w=0.094 //l=0.11 //layer=ply \
 //thickness=0.18 //x=12.215 //y=1.595 //x2=12.105 //y2=1.595
r437 (  66 87 ) resistor r=56.4043 //w=0.094 //l=0.11 //layer=ply \
 //thickness=0.18 //x=7.405 //y=1.595 //x2=7.515 //y2=1.595
r438 (  66 88 ) resistor r=56.4043 //w=0.094 //l=0.11 //layer=ply \
 //thickness=0.18 //x=7.405 //y=1.595 //x2=7.295 //y2=1.595
r439 (  63 153 ) resistor r=152 //w=0.17 //l=0.17 //layer=licon //count=1 \
 //x=23.43 //y=4.88 //x2=23.43 //y2=4.88
r440 (  61 63 ) resistor r=68.4492 //w=0.187 //l=1 //layer=li //thickness=0.1 \
 //x=23.43 //y=3.88 //x2=23.43 //y2=4.88
r441 (  58 147 ) resistor r=152 //w=0.17 //l=0.17 //layer=licon //count=1 \
 //x=23.43 //y=2.26 //x2=23.43 //y2=2.26
r442 (  58 61 ) resistor r=110.888 //w=0.187 //l=1.62 //layer=li \
 //thickness=0.1 //x=23.43 //y=2.26 //x2=23.43 //y2=3.88
r443 (  54 56 ) resistor r=96.8556 //w=0.187 //l=1.415 //layer=li \
 //thickness=0.1 //x=16.03 //y=5.295 //x2=16.03 //y2=3.88
r444 (  53 56 ) resistor r=134.16 //w=0.187 //l=1.96 //layer=li \
 //thickness=0.1 //x=16.03 //y=1.92 //x2=16.03 //y2=3.88
r445 (  51 53 ) resistor r=7.15173 //w=0.17 //l=0.120208 //layer=li \
 //thickness=0.1 //x=15.945 //y=1.835 //x2=16.03 //y2=1.92
r446 (  51 52 ) resistor r=18.4813 //w=0.187 //l=0.27 //layer=li \
 //thickness=0.1 //x=15.945 //y=1.835 //x2=15.675 //y2=1.835
r447 (  50 65 ) resistor r=5.4201 //w=0.17 //l=0.085 //layer=li \
 //thickness=0.1 //x=15.635 //y=5.38 //x2=15.55 //y2=5.38
r448 (  49 54 ) resistor r=7.15173 //w=0.17 //l=0.120208 //layer=li \
 //thickness=0.1 //x=15.945 //y=5.38 //x2=16.03 //y2=5.295
r449 (  49 50 ) resistor r=21.2193 //w=0.187 //l=0.31 //layer=li \
 //thickness=0.1 //x=15.945 //y=5.38 //x2=15.635 //y2=5.38
r450 (  45 52 ) resistor r=7.15173 //w=0.17 //l=0.120208 //layer=li \
 //thickness=0.1 //x=15.59 //y=1.75 //x2=15.675 //y2=1.835
r451 (  45 156 ) resistor r=39.016 //w=0.187 //l=0.57 //layer=li \
 //thickness=0.1 //x=15.59 //y=1.75 //x2=15.59 //y2=1.18
r452 (  39 65 ) resistor r=1.40859 //w=0.34 //l=0.085 //layer=li \
 //thickness=0.1 //x=15.55 //y=5.465 //x2=15.55 //y2=5.38
r453 (  39 159 ) resistor r=30.1176 //w=0.187 //l=0.44 //layer=li \
 //thickness=0.1 //x=15.55 //y=5.465 //x2=15.55 //y2=5.905
r454 (  37 65 ) resistor r=5.4201 //w=0.17 //l=0.085 //layer=li \
 //thickness=0.1 //x=15.465 //y=5.38 //x2=15.55 //y2=5.38
r455 (  37 38 ) resistor r=48.5989 //w=0.187 //l=0.71 //layer=li \
 //thickness=0.1 //x=15.465 //y=5.38 //x2=14.755 //y2=5.38
r456 (  31 38 ) resistor r=7.15173 //w=0.17 //l=0.120208 //layer=li \
 //thickness=0.1 //x=14.67 //y=5.465 //x2=14.755 //y2=5.38
r457 (  31 158 ) resistor r=30.1176 //w=0.187 //l=0.44 //layer=li \
 //thickness=0.1 //x=14.67 //y=5.465 //x2=14.67 //y2=5.905
r458 (  29 143 ) resistor r=152 //w=0.17 //l=0.17 //layer=licon //count=1 \
 //x=11.96 //y=4.88 //x2=11.96 //y2=4.88
r459 (  27 29 ) resistor r=68.4492 //w=0.187 //l=1 //layer=li //thickness=0.1 \
 //x=11.96 //y=3.88 //x2=11.96 //y2=4.88
r460 (  24 137 ) resistor r=152 //w=0.17 //l=0.17 //layer=licon //count=1 \
 //x=11.96 //y=2.26 //x2=11.96 //y2=2.26
r461 (  24 27 ) resistor r=110.888 //w=0.187 //l=1.62 //layer=li \
 //thickness=0.1 //x=11.96 //y=2.26 //x2=11.96 //y2=3.88
r462 (  21 133 ) resistor r=152 //w=0.17 //l=0.17 //layer=licon //count=1 \
 //x=7.15 //y=4.88 //x2=7.15 //y2=4.88
r463 (  19 21 ) resistor r=68.4492 //w=0.187 //l=1 //layer=li //thickness=0.1 \
 //x=7.15 //y=3.88 //x2=7.15 //y2=4.88
r464 (  16 127 ) resistor r=152 //w=0.17 //l=0.17 //layer=licon //count=1 \
 //x=7.15 //y=2.26 //x2=7.15 //y2=2.26
r465 (  16 19 ) resistor r=110.888 //w=0.187 //l=1.62 //layer=li \
 //thickness=0.1 //x=7.15 //y=2.26 //x2=7.15 //y2=3.88
r466 (  14 61 ) resistor r=9.3 //w=0.17 //l=0.17 //layer=mcon //count=1 \
 //x=23.43 //y=3.88 //x2=23.43 //y2=3.88
r467 (  12 56 ) resistor r=9.3 //w=0.17 //l=0.17 //layer=mcon //count=1 \
 //x=16.03 //y=3.88 //x2=16.03 //y2=3.88
r468 (  10 27 ) resistor r=9.3 //w=0.17 //l=0.17 //layer=mcon //count=1 \
 //x=11.96 //y=3.88 //x2=11.96 //y2=3.88
r469 (  8 19 ) resistor r=9.3 //w=0.17 //l=0.17 //layer=mcon //count=1 \
 //x=7.15 //y=3.88 //x2=7.15 //y2=3.88
r470 (  6 12 ) resistor r=0.0880901 //w=0.191 //l=0.115 //layer=m1 \
 //thickness=0.36 //x=16.145 //y=3.88 //x2=16.03 //y2=3.88
r471 (  5 14 ) resistor r=0.0717383 //w=0.224 //l=0.115 //layer=m1 \
 //thickness=0.36 //x=23.315 //y=3.88 //x2=23.43 //y2=3.88
r472 (  5 6 ) resistor r=6.8416 //w=0.131 //l=7.17 //layer=m1 //thickness=0.36 \
 //x=23.315 //y=3.88 //x2=16.145 //y2=3.88
r473 (  4 10 ) resistor r=0.0880901 //w=0.191 //l=0.115 //layer=m1 \
 //thickness=0.36 //x=12.075 //y=3.88 //x2=11.96 //y2=3.88
r474 (  3 12 ) resistor r=0.0880901 //w=0.191 //l=0.115 //layer=m1 \
 //thickness=0.36 //x=15.915 //y=3.88 //x2=16.03 //y2=3.88
r475 (  3 4 ) resistor r=3.66412 //w=0.131 //l=3.84 //layer=m1 \
 //thickness=0.36 //x=15.915 //y=3.88 //x2=12.075 //y2=3.88
r476 (  2 8 ) resistor r=0.0717383 //w=0.224 //l=0.115 //layer=m1 \
 //thickness=0.36 //x=7.265 //y=3.88 //x2=7.15 //y2=3.88
r477 (  1 10 ) resistor r=0.0880901 //w=0.191 //l=0.115 //layer=m1 \
 //thickness=0.36 //x=11.845 //y=3.88 //x2=11.96 //y2=3.88
r478 (  1 2 ) resistor r=4.37023 //w=0.131 //l=4.58 //layer=m1 \
 //thickness=0.36 //x=11.845 //y=3.88 //x2=7.265 //y2=3.88
ends PM_TMRDFFSNQNX1\%noxref_6

subckt PM_TMRDFFSNQNX1\%noxref_7 ( 1 2 7 9 19 20 27 35 41 42 46 49 50 51 52 53 \
 54 55 56 61 63 65 71 72 74 75 78 86 88 89 90 )
c183 ( 90 0 ) capacitor c=0.023087f //x=23.245 //y=5.2
c184 ( 89 0 ) capacitor c=0.023519f //x=22.365 //y=5.2
c185 ( 88 0 ) capacitor c=0.0224735f //x=21.485 //y=5.2
c186 ( 86 0 ) capacitor c=0.00872971f //x=23.495 //y=1.095
c187 ( 78 0 ) capacitor c=0.0331095f //x=18.65 //y=4.88
c188 ( 75 0 ) capacitor c=0.0279499f //x=18.62 //y=2.095
c189 ( 74 0 ) capacitor c=0.0421676f //x=18.62 //y=2.26
c190 ( 72 0 ) capacitor c=0.0429696f //x=19.185 //y=1.43
c191 ( 71 0 ) capacitor c=0.0192208f //x=19.185 //y=1.085
c192 ( 65 0 ) capacitor c=0.0148884f //x=19.03 //y=1.585
c193 ( 63 0 ) capacitor c=0.0157803f //x=19.03 //y=0.93
c194 ( 61 0 ) capacitor c=0.0295235f //x=19.025 //y=4.97
c195 ( 56 0 ) capacitor c=0.0205163f //x=18.655 //y=1.74
c196 ( 55 0 ) capacitor c=0.0168481f //x=18.655 //y=1.43
c197 ( 54 0 ) capacitor c=0.0174783f //x=18.655 //y=1.085
c198 ( 53 0 ) capacitor c=0.15358f //x=19.1 //y=6.2
c199 ( 52 0 ) capacitor c=0.110281f //x=18.66 //y=6.2
c200 ( 50 0 ) capacitor c=0.00106608f //x=23.39 //y=5.335
c201 ( 49 0 ) capacitor c=0.00207319f //x=22.51 //y=5.335
c202 ( 46 0 ) capacitor c=0.108218f //x=24.17 //y=4.25
c203 ( 42 0 ) capacitor c=0.00398962f //x=23.77 //y=1.845
c204 ( 41 0 ) capacitor c=0.0137288f //x=24.085 //y=1.845
c205 ( 35 0 ) capacitor c=0.0284988f //x=24.085 //y=5.335
c206 ( 27 0 ) capacitor c=0.0176454f //x=23.305 //y=5.335
c207 ( 20 0 ) capacitor c=0.00332903f //x=21.715 //y=5.335
c208 ( 19 0 ) capacitor c=0.0148427f //x=22.425 //y=5.335
c209 ( 9 0 ) capacitor c=0.0709461f //x=18.62 //y=2.26
c210 ( 7 0 ) capacitor c=0.00453889f //x=18.62 //y=4.715
c211 ( 2 0 ) capacitor c=0.00621861f //x=18.735 //y=4.25
c212 ( 1 0 ) capacitor c=0.0857087f //x=24.055 //y=4.25
r213 (  80 81 ) resistor r=32.4568 //w=0.214 //l=0.075 //layer=ply \
 //thickness=0.18 //x=18.65 //y=4.97 //x2=18.65 //y2=5.045
r214 (  78 80 ) resistor r=20.271 //w=0.214 //l=0.09 //layer=ply \
 //thickness=0.18 //x=18.65 //y=4.88 //x2=18.65 //y2=4.97
r215 (  74 75 ) resistor r=52.7279 //w=0.214 //l=0.165 //layer=ply \
 //thickness=0.18 //x=18.62 //y=2.26 //x2=18.62 //y2=2.095
r216 (  72 85 ) resistor r=45.1352 //w=0.168 //l=0.173853 //layer=ply \
 //thickness=0.18 //x=19.185 //y=1.43 //x2=19.145 //y2=1.585
r217 (  71 84 ) resistor r=45.1352 //w=0.168 //l=0.173853 //layer=ply \
 //thickness=0.18 //x=19.185 //y=1.085 //x2=19.145 //y2=0.93
r218 (  71 72 ) resistor r=176.904 //w=0.094 //l=0.345 //layer=ply \
 //thickness=0.18 //x=19.185 //y=1.085 //x2=19.185 //y2=1.43
r219 (  66 83 ) resistor r=10.701 //w=0.21 //l=0.115 //layer=ply \
 //thickness=0.18 //x=18.81 //y=1.585 //x2=18.695 //y2=1.585
r220 (  65 85 ) resistor r=5.52526 //w=0.168 //l=0.115 //layer=ply \
 //thickness=0.18 //x=19.03 //y=1.585 //x2=19.145 //y2=1.585
r221 (  64 82 ) resistor r=5.52526 //w=0.168 //l=0.115 //layer=ply \
 //thickness=0.18 //x=18.81 //y=0.93 //x2=18.695 //y2=0.93
r222 (  63 84 ) resistor r=5.52526 //w=0.168 //l=0.115 //layer=ply \
 //thickness=0.18 //x=19.03 //y=0.93 //x2=19.145 //y2=0.93
r223 (  63 64 ) resistor r=112.809 //w=0.094 //l=0.22 //layer=ply \
 //thickness=0.18 //x=19.03 //y=0.93 //x2=18.81 //y2=0.93
r224 (  62 80 ) resistor r=16.5046 //w=0.27 //l=0.135 //layer=ply \
 //thickness=0.18 //x=18.785 //y=4.97 //x2=18.65 //y2=4.97
r225 (  61 68 ) resistor r=26.9307 //w=0.15 //l=0.106066 //layer=ply \
 //thickness=0.18 //x=19.025 //y=4.97 //x2=19.1 //y2=5.045
r226 (  61 62 ) resistor r=123.064 //w=0.094 //l=0.24 //layer=ply \
 //thickness=0.18 //x=19.025 //y=4.97 //x2=18.785 //y2=4.97
r227 (  56 83 ) resistor r=39.5823 //w=0.21 //l=0.173853 //layer=ply \
 //thickness=0.18 //x=18.655 //y=1.74 //x2=18.695 //y2=1.585
r228 (  56 75 ) resistor r=182.032 //w=0.094 //l=0.355 //layer=ply \
 //thickness=0.18 //x=18.655 //y=1.74 //x2=18.655 //y2=2.095
r229 (  55 83 ) resistor r=39.5823 //w=0.21 //l=0.173853 //layer=ply \
 //thickness=0.18 //x=18.655 //y=1.43 //x2=18.695 //y2=1.585
r230 (  54 82 ) resistor r=45.1352 //w=0.168 //l=0.173853 //layer=ply \
 //thickness=0.18 //x=18.655 //y=1.085 //x2=18.695 //y2=0.93
r231 (  54 55 ) resistor r=176.904 //w=0.094 //l=0.345 //layer=ply \
 //thickness=0.18 //x=18.655 //y=1.085 //x2=18.655 //y2=1.43
r232 (  53 68 ) resistor r=592.245 //w=0.094 //l=1.155 //layer=ply \
 //thickness=0.18 //x=19.1 //y=6.2 //x2=19.1 //y2=5.045
r233 (  52 81 ) resistor r=592.245 //w=0.094 //l=1.155 //layer=ply \
 //thickness=0.18 //x=18.66 //y=6.2 //x2=18.66 //y2=5.045
r234 (  51 65 ) resistor r=56.4043 //w=0.094 //l=0.11 //layer=ply \
 //thickness=0.18 //x=18.92 //y=1.585 //x2=19.03 //y2=1.585
r235 (  51 66 ) resistor r=56.4043 //w=0.094 //l=0.11 //layer=ply \
 //thickness=0.18 //x=18.92 //y=1.585 //x2=18.81 //y2=1.585
r236 (  48 78 ) resistor r=152 //w=0.17 //l=0.17 //layer=licon //count=1 \
 //x=18.65 //y=4.88 //x2=18.65 //y2=4.88
r237 (  44 46 ) resistor r=68.4492 //w=0.187 //l=1 //layer=li //thickness=0.1 \
 //x=24.17 //y=5.25 //x2=24.17 //y2=4.25
r238 (  43 46 ) resistor r=158.802 //w=0.187 //l=2.32 //layer=li \
 //thickness=0.1 //x=24.17 //y=1.93 //x2=24.17 //y2=4.25
r239 (  41 43 ) resistor r=7.15173 //w=0.17 //l=0.120208 //layer=li \
 //thickness=0.1 //x=24.085 //y=1.845 //x2=24.17 //y2=1.93
r240 (  41 42 ) resistor r=21.5615 //w=0.187 //l=0.315 //layer=li \
 //thickness=0.1 //x=24.085 //y=1.845 //x2=23.77 //y2=1.845
r241 (  37 42 ) resistor r=7.15173 //w=0.17 //l=0.120208 //layer=li \
 //thickness=0.1 //x=23.685 //y=1.76 //x2=23.77 //y2=1.845
r242 (  37 86 ) resistor r=39.016 //w=0.187 //l=0.57 //layer=li \
 //thickness=0.1 //x=23.685 //y=1.76 //x2=23.685 //y2=1.19
r243 (  36 50 ) resistor r=5.4201 //w=0.17 //l=0.085 //layer=li \
 //thickness=0.1 //x=23.475 //y=5.335 //x2=23.39 //y2=5.335
r244 (  35 44 ) resistor r=7.15173 //w=0.17 //l=0.120208 //layer=li \
 //thickness=0.1 //x=24.085 //y=5.335 //x2=24.17 //y2=5.25
r245 (  35 36 ) resistor r=41.754 //w=0.187 //l=0.61 //layer=li \
 //thickness=0.1 //x=24.085 //y=5.335 //x2=23.475 //y2=5.335
r246 (  29 50 ) resistor r=1.40859 //w=0.34 //l=0.085 //layer=li \
 //thickness=0.1 //x=23.39 //y=5.42 //x2=23.39 //y2=5.335
r247 (  29 90 ) resistor r=33.1979 //w=0.187 //l=0.485 //layer=li \
 //thickness=0.1 //x=23.39 //y=5.42 //x2=23.39 //y2=5.905
r248 (  28 49 ) resistor r=5.4201 //w=0.17 //l=0.085 //layer=li \
 //thickness=0.1 //x=22.595 //y=5.335 //x2=22.51 //y2=5.335
r249 (  27 50 ) resistor r=5.4201 //w=0.17 //l=0.085 //layer=li \
 //thickness=0.1 //x=23.305 //y=5.335 //x2=23.39 //y2=5.335
r250 (  27 28 ) resistor r=48.5989 //w=0.187 //l=0.71 //layer=li \
 //thickness=0.1 //x=23.305 //y=5.335 //x2=22.595 //y2=5.335
r251 (  21 49 ) resistor r=1.40859 //w=0.34 //l=0.085 //layer=li \
 //thickness=0.1 //x=22.51 //y=5.42 //x2=22.51 //y2=5.335
r252 (  21 89 ) resistor r=33.1979 //w=0.187 //l=0.485 //layer=li \
 //thickness=0.1 //x=22.51 //y=5.42 //x2=22.51 //y2=5.905
r253 (  19 49 ) resistor r=5.4201 //w=0.17 //l=0.085 //layer=li \
 //thickness=0.1 //x=22.425 //y=5.335 //x2=22.51 //y2=5.335
r254 (  19 20 ) resistor r=48.5989 //w=0.187 //l=0.71 //layer=li \
 //thickness=0.1 //x=22.425 //y=5.335 //x2=21.715 //y2=5.335
r255 (  13 20 ) resistor r=7.15173 //w=0.17 //l=0.120208 //layer=li \
 //thickness=0.1 //x=21.63 //y=5.42 //x2=21.715 //y2=5.335
r256 (  13 88 ) resistor r=33.1979 //w=0.187 //l=0.485 //layer=li \
 //thickness=0.1 //x=21.63 //y=5.42 //x2=21.63 //y2=5.905
r257 (  9 74 ) resistor r=152 //w=0.17 //l=0.17 //layer=licon //count=1 \
 //x=18.62 //y=2.26 //x2=18.62 //y2=2.26
r258 (  9 12 ) resistor r=136.214 //w=0.187 //l=1.99 //layer=li \
 //thickness=0.1 //x=18.62 //y=2.26 //x2=18.62 //y2=4.25
r259 (  7 48 ) resistor r=11.4737 //w=0.186 //l=0.172337 //layer=li \
 //thickness=0.1 //x=18.62 //y=4.715 //x2=18.635 //y2=4.88
r260 (  7 12 ) resistor r=31.8289 //w=0.187 //l=0.465 //layer=li \
 //thickness=0.1 //x=18.62 //y=4.715 //x2=18.62 //y2=4.25
r261 (  6 46 ) resistor r=9.3 //w=0.17 //l=0.17 //layer=mcon //count=1 \
 //x=24.17 //y=4.25 //x2=24.17 //y2=4.25
r262 (  4 12 ) resistor r=9.3 //w=0.17 //l=0.17 //layer=mcon //count=1 \
 //x=18.62 //y=4.25 //x2=18.62 //y2=4.25
r263 (  2 4 ) resistor r=0.0717383 //w=0.224 //l=0.115 //layer=m1 \
 //thickness=0.36 //x=18.735 //y=4.25 //x2=18.62 //y2=4.25
r264 (  1 6 ) resistor r=0.0738079 //w=0.207 //l=0.115 //layer=m1 \
 //thickness=0.36 //x=24.055 //y=4.25 //x2=24.17 //y2=4.25
r265 (  1 2 ) resistor r=5.07634 //w=0.131 //l=5.32 //layer=m1 \
 //thickness=0.36 //x=24.055 //y=4.25 //x2=18.735 //y2=4.25
ends PM_TMRDFFSNQNX1\%noxref_7

subckt PM_TMRDFFSNQNX1\%noxref_8 ( 1 2 3 4 17 18 29 31 32 36 38 46 53 54 55 56 \
 57 58 59 60 61 62 63 64 66 72 73 74 75 79 80 81 82 83 85 91 92 93 94 114 116 \
 117 )
c232 ( 117 0 ) capacitor c=0.0220291f //x=26.875 //y=5.2
c233 ( 116 0 ) capacitor c=0.0217503f //x=25.995 //y=5.2
c234 ( 114 0 ) capacitor c=0.0084702f //x=26.87 //y=1.085
c235 ( 94 0 ) capacitor c=0.0556143f //x=34.435 //y=4.97
c236 ( 93 0 ) capacitor c=0.0293157f //x=34.725 //y=4.97
c237 ( 92 0 ) capacitor c=0.0347816f //x=34.39 //y=1.4
c238 ( 91 0 ) capacitor c=0.0187487f //x=34.39 //y=1.055
c239 ( 85 0 ) capacitor c=0.0137055f //x=34.235 //y=1.555
c240 ( 83 0 ) capacitor c=0.0149861f //x=34.235 //y=0.9
c241 ( 82 0 ) capacitor c=0.096037f //x=33.86 //y=2.095
c242 ( 81 0 ) capacitor c=0.0228993f //x=33.86 //y=1.71
c243 ( 80 0 ) capacitor c=0.0234352f //x=33.86 //y=1.4
c244 ( 79 0 ) capacitor c=0.0198724f //x=33.86 //y=1.055
c245 ( 75 0 ) capacitor c=0.0557698f //x=29.625 //y=4.97
c246 ( 74 0 ) capacitor c=0.0293157f //x=29.915 //y=4.97
c247 ( 73 0 ) capacitor c=0.0347816f //x=29.58 //y=1.4
c248 ( 72 0 ) capacitor c=0.0187487f //x=29.58 //y=1.055
c249 ( 66 0 ) capacitor c=0.0137055f //x=29.425 //y=1.555
c250 ( 64 0 ) capacitor c=0.0149861f //x=29.425 //y=0.9
c251 ( 63 0 ) capacitor c=0.096037f //x=29.05 //y=2.095
c252 ( 62 0 ) capacitor c=0.0228993f //x=29.05 //y=1.71
c253 ( 61 0 ) capacitor c=0.0234352f //x=29.05 //y=1.4
c254 ( 60 0 ) capacitor c=0.0198724f //x=29.05 //y=1.055
c255 ( 59 0 ) capacitor c=0.110114f //x=34.8 //y=6.2
c256 ( 58 0 ) capacitor c=0.158956f //x=34.36 //y=6.2
c257 ( 57 0 ) capacitor c=0.110114f //x=29.99 //y=6.2
c258 ( 56 0 ) capacitor c=0.158956f //x=29.55 //y=6.2
c259 ( 53 0 ) capacitor c=0.00211606f //x=27.02 //y=5.38
c260 ( 46 0 ) capacitor c=0.0943831f //x=34.16 //y=2.26
c261 ( 38 0 ) capacitor c=0.0969522f //x=29.35 //y=2.26
c262 ( 36 0 ) capacitor c=0.105125f //x=27.5 //y=2.77
c263 ( 32 0 ) capacitor c=0.00404073f //x=27.145 //y=1.835
c264 ( 31 0 ) capacitor c=0.0122201f //x=27.415 //y=1.835
c265 ( 29 0 ) capacitor c=0.0137995f //x=27.415 //y=5.38
c266 ( 18 0 ) capacitor c=0.00251635f //x=26.225 //y=5.38
c267 ( 17 0 ) capacitor c=0.0143649f //x=26.935 //y=5.38
c268 ( 4 0 ) capacitor c=0.00673266f //x=29.615 //y=2.77
c269 ( 3 0 ) capacitor c=0.0686809f //x=34.045 //y=2.77
c270 ( 2 0 ) capacitor c=0.0121637f //x=27.615 //y=2.77
c271 ( 1 0 ) capacitor c=0.0230071f //x=29.205 //y=2.77
r272 (  93 95 ) resistor r=26.9307 //w=0.15 //l=0.106066 //layer=ply \
 //thickness=0.18 //x=34.725 //y=4.97 //x2=34.8 //y2=5.045
r273 (  93 94 ) resistor r=148.702 //w=0.094 //l=0.29 //layer=ply \
 //thickness=0.18 //x=34.725 //y=4.97 //x2=34.435 //y2=4.97
r274 (  92 113 ) resistor r=45.1352 //w=0.168 //l=0.173853 //layer=ply \
 //thickness=0.18 //x=34.39 //y=1.4 //x2=34.35 //y2=1.555
r275 (  91 112 ) resistor r=45.1352 //w=0.168 //l=0.173853 //layer=ply \
 //thickness=0.18 //x=34.39 //y=1.055 //x2=34.35 //y2=0.9
r276 (  91 92 ) resistor r=176.904 //w=0.094 //l=0.345 //layer=ply \
 //thickness=0.18 //x=34.39 //y=1.055 //x2=34.39 //y2=1.4
r277 (  88 94 ) resistor r=22.7971 //w=0.269 //l=0.106066 //layer=ply \
 //thickness=0.18 //x=34.36 //y=5.045 //x2=34.435 //y2=4.97
r278 (  88 111 ) resistor r=35.8364 //w=0.269 //l=0.270185 //layer=ply \
 //thickness=0.18 //x=34.36 //y=5.045 //x2=34.16 //y2=4.88
r279 (  86 107 ) resistor r=10.701 //w=0.21 //l=0.115 //layer=ply \
 //thickness=0.18 //x=34.015 //y=1.555 //x2=33.9 //y2=1.555
r280 (  85 113 ) resistor r=5.52526 //w=0.168 //l=0.115 //layer=ply \
 //thickness=0.18 //x=34.235 //y=1.555 //x2=34.35 //y2=1.555
r281 (  84 106 ) resistor r=5.52526 //w=0.168 //l=0.115 //layer=ply \
 //thickness=0.18 //x=34.015 //y=0.9 //x2=33.9 //y2=0.9
r282 (  83 112 ) resistor r=5.52526 //w=0.168 //l=0.115 //layer=ply \
 //thickness=0.18 //x=34.235 //y=0.9 //x2=34.35 //y2=0.9
r283 (  83 84 ) resistor r=112.809 //w=0.094 //l=0.22 //layer=ply \
 //thickness=0.18 //x=34.235 //y=0.9 //x2=34.015 //y2=0.9
r284 (  82 109 ) resistor r=58.7805 //w=0.246 //l=0.373497 //layer=ply \
 //thickness=0.18 //x=33.86 //y=2.095 //x2=34.16 //y2=2.26
r285 (  81 107 ) resistor r=39.5823 //w=0.21 //l=0.173853 //layer=ply \
 //thickness=0.18 //x=33.86 //y=1.71 //x2=33.9 //y2=1.555
r286 (  81 82 ) resistor r=197.415 //w=0.094 //l=0.385 //layer=ply \
 //thickness=0.18 //x=33.86 //y=1.71 //x2=33.86 //y2=2.095
r287 (  80 107 ) resistor r=39.5823 //w=0.21 //l=0.173853 //layer=ply \
 //thickness=0.18 //x=33.86 //y=1.4 //x2=33.9 //y2=1.555
r288 (  79 106 ) resistor r=45.1352 //w=0.168 //l=0.173853 //layer=ply \
 //thickness=0.18 //x=33.86 //y=1.055 //x2=33.9 //y2=0.9
r289 (  79 80 ) resistor r=176.904 //w=0.094 //l=0.345 //layer=ply \
 //thickness=0.18 //x=33.86 //y=1.055 //x2=33.86 //y2=1.4
r290 (  74 76 ) resistor r=26.9307 //w=0.15 //l=0.106066 //layer=ply \
 //thickness=0.18 //x=29.915 //y=4.97 //x2=29.99 //y2=5.045
r291 (  74 75 ) resistor r=148.702 //w=0.094 //l=0.29 //layer=ply \
 //thickness=0.18 //x=29.915 //y=4.97 //x2=29.625 //y2=4.97
r292 (  73 105 ) resistor r=45.1352 //w=0.168 //l=0.173853 //layer=ply \
 //thickness=0.18 //x=29.58 //y=1.4 //x2=29.54 //y2=1.555
r293 (  72 104 ) resistor r=45.1352 //w=0.168 //l=0.173853 //layer=ply \
 //thickness=0.18 //x=29.58 //y=1.055 //x2=29.54 //y2=0.9
r294 (  72 73 ) resistor r=176.904 //w=0.094 //l=0.345 //layer=ply \
 //thickness=0.18 //x=29.58 //y=1.055 //x2=29.58 //y2=1.4
r295 (  69 75 ) resistor r=22.7971 //w=0.269 //l=0.106066 //layer=ply \
 //thickness=0.18 //x=29.55 //y=5.045 //x2=29.625 //y2=4.97
r296 (  69 103 ) resistor r=35.8364 //w=0.269 //l=0.270185 //layer=ply \
 //thickness=0.18 //x=29.55 //y=5.045 //x2=29.35 //y2=4.88
r297 (  67 99 ) resistor r=10.701 //w=0.21 //l=0.115 //layer=ply \
 //thickness=0.18 //x=29.205 //y=1.555 //x2=29.09 //y2=1.555
r298 (  66 105 ) resistor r=5.52526 //w=0.168 //l=0.115 //layer=ply \
 //thickness=0.18 //x=29.425 //y=1.555 //x2=29.54 //y2=1.555
r299 (  65 98 ) resistor r=5.52526 //w=0.168 //l=0.115 //layer=ply \
 //thickness=0.18 //x=29.205 //y=0.9 //x2=29.09 //y2=0.9
r300 (  64 104 ) resistor r=5.52526 //w=0.168 //l=0.115 //layer=ply \
 //thickness=0.18 //x=29.425 //y=0.9 //x2=29.54 //y2=0.9
r301 (  64 65 ) resistor r=112.809 //w=0.094 //l=0.22 //layer=ply \
 //thickness=0.18 //x=29.425 //y=0.9 //x2=29.205 //y2=0.9
r302 (  63 101 ) resistor r=58.7805 //w=0.246 //l=0.373497 //layer=ply \
 //thickness=0.18 //x=29.05 //y=2.095 //x2=29.35 //y2=2.26
r303 (  62 99 ) resistor r=39.5823 //w=0.21 //l=0.173853 //layer=ply \
 //thickness=0.18 //x=29.05 //y=1.71 //x2=29.09 //y2=1.555
r304 (  62 63 ) resistor r=197.415 //w=0.094 //l=0.385 //layer=ply \
 //thickness=0.18 //x=29.05 //y=1.71 //x2=29.05 //y2=2.095
r305 (  61 99 ) resistor r=39.5823 //w=0.21 //l=0.173853 //layer=ply \
 //thickness=0.18 //x=29.05 //y=1.4 //x2=29.09 //y2=1.555
r306 (  60 98 ) resistor r=45.1352 //w=0.168 //l=0.173853 //layer=ply \
 //thickness=0.18 //x=29.05 //y=1.055 //x2=29.09 //y2=0.9
r307 (  60 61 ) resistor r=176.904 //w=0.094 //l=0.345 //layer=ply \
 //thickness=0.18 //x=29.05 //y=1.055 //x2=29.05 //y2=1.4
r308 (  59 95 ) resistor r=592.245 //w=0.094 //l=1.155 //layer=ply \
 //thickness=0.18 //x=34.8 //y=6.2 //x2=34.8 //y2=5.045
r309 (  58 88 ) resistor r=592.245 //w=0.094 //l=1.155 //layer=ply \
 //thickness=0.18 //x=34.36 //y=6.2 //x2=34.36 //y2=5.045
r310 (  57 76 ) resistor r=592.245 //w=0.094 //l=1.155 //layer=ply \
 //thickness=0.18 //x=29.99 //y=6.2 //x2=29.99 //y2=5.045
r311 (  56 69 ) resistor r=592.245 //w=0.094 //l=1.155 //layer=ply \
 //thickness=0.18 //x=29.55 //y=6.2 //x2=29.55 //y2=5.045
r312 (  55 85 ) resistor r=56.4043 //w=0.094 //l=0.11 //layer=ply \
 //thickness=0.18 //x=34.125 //y=1.555 //x2=34.235 //y2=1.555
r313 (  55 86 ) resistor r=56.4043 //w=0.094 //l=0.11 //layer=ply \
 //thickness=0.18 //x=34.125 //y=1.555 //x2=34.015 //y2=1.555
r314 (  54 66 ) resistor r=56.4043 //w=0.094 //l=0.11 //layer=ply \
 //thickness=0.18 //x=29.315 //y=1.555 //x2=29.425 //y2=1.555
r315 (  54 67 ) resistor r=56.4043 //w=0.094 //l=0.11 //layer=ply \
 //thickness=0.18 //x=29.315 //y=1.555 //x2=29.205 //y2=1.555
r316 (  51 111 ) resistor r=152 //w=0.17 //l=0.17 //layer=licon //count=1 \
 //x=34.16 //y=4.88 //x2=34.16 //y2=4.88
r317 (  49 51 ) resistor r=144.428 //w=0.187 //l=2.11 //layer=li \
 //thickness=0.1 //x=34.16 //y=2.77 //x2=34.16 //y2=4.88
r318 (  46 109 ) resistor r=152 //w=0.17 //l=0.17 //layer=licon //count=1 \
 //x=34.16 //y=2.26 //x2=34.16 //y2=2.26
r319 (  46 49 ) resistor r=34.9091 //w=0.187 //l=0.51 //layer=li \
 //thickness=0.1 //x=34.16 //y=2.26 //x2=34.16 //y2=2.77
r320 (  43 103 ) resistor r=152 //w=0.17 //l=0.17 //layer=licon //count=1 \
 //x=29.35 //y=4.88 //x2=29.35 //y2=4.88
r321 (  41 43 ) resistor r=144.77 //w=0.187 //l=2.115 //layer=li \
 //thickness=0.1 //x=29.35 //y=2.765 //x2=29.35 //y2=4.88
r322 (  38 101 ) resistor r=152 //w=0.17 //l=0.17 //layer=licon //count=1 \
 //x=29.35 //y=2.26 //x2=29.35 //y2=2.26
r323 (  38 41 ) resistor r=34.5668 //w=0.187 //l=0.505 //layer=li \
 //thickness=0.1 //x=29.35 //y=2.26 //x2=29.35 //y2=2.765
r324 (  34 36 ) resistor r=172.834 //w=0.187 //l=2.525 //layer=li \
 //thickness=0.1 //x=27.5 //y=5.295 //x2=27.5 //y2=2.77
r325 (  33 36 ) resistor r=58.1818 //w=0.187 //l=0.85 //layer=li \
 //thickness=0.1 //x=27.5 //y=1.92 //x2=27.5 //y2=2.77
r326 (  31 33 ) resistor r=7.15173 //w=0.17 //l=0.120208 //layer=li \
 //thickness=0.1 //x=27.415 //y=1.835 //x2=27.5 //y2=1.92
r327 (  31 32 ) resistor r=18.4813 //w=0.187 //l=0.27 //layer=li \
 //thickness=0.1 //x=27.415 //y=1.835 //x2=27.145 //y2=1.835
r328 (  30 53 ) resistor r=5.4201 //w=0.17 //l=0.085 //layer=li \
 //thickness=0.1 //x=27.105 //y=5.38 //x2=27.02 //y2=5.38
r329 (  29 34 ) resistor r=7.15173 //w=0.17 //l=0.120208 //layer=li \
 //thickness=0.1 //x=27.415 //y=5.38 //x2=27.5 //y2=5.295
r330 (  29 30 ) resistor r=21.2193 //w=0.187 //l=0.31 //layer=li \
 //thickness=0.1 //x=27.415 //y=5.38 //x2=27.105 //y2=5.38
r331 (  25 32 ) resistor r=7.15173 //w=0.17 //l=0.120208 //layer=li \
 //thickness=0.1 //x=27.06 //y=1.75 //x2=27.145 //y2=1.835
r332 (  25 114 ) resistor r=39.016 //w=0.187 //l=0.57 //layer=li \
 //thickness=0.1 //x=27.06 //y=1.75 //x2=27.06 //y2=1.18
r333 (  19 53 ) resistor r=1.40859 //w=0.34 //l=0.085 //layer=li \
 //thickness=0.1 //x=27.02 //y=5.465 //x2=27.02 //y2=5.38
r334 (  19 117 ) resistor r=30.1176 //w=0.187 //l=0.44 //layer=li \
 //thickness=0.1 //x=27.02 //y=5.465 //x2=27.02 //y2=5.905
r335 (  17 53 ) resistor r=5.4201 //w=0.17 //l=0.085 //layer=li \
 //thickness=0.1 //x=26.935 //y=5.38 //x2=27.02 //y2=5.38
r336 (  17 18 ) resistor r=48.5989 //w=0.187 //l=0.71 //layer=li \
 //thickness=0.1 //x=26.935 //y=5.38 //x2=26.225 //y2=5.38
r337 (  11 18 ) resistor r=7.15173 //w=0.17 //l=0.120208 //layer=li \
 //thickness=0.1 //x=26.14 //y=5.465 //x2=26.225 //y2=5.38
r338 (  11 116 ) resistor r=30.1176 //w=0.187 //l=0.44 //layer=li \
 //thickness=0.1 //x=26.14 //y=5.465 //x2=26.14 //y2=5.905
r339 (  10 49 ) resistor r=9.3 //w=0.17 //l=0.17 //layer=mcon //count=1 \
 //x=34.16 //y=2.77 //x2=34.16 //y2=2.77
r340 (  8 41 ) resistor r=9.3 //w=0.17 //l=0.17 //layer=mcon //count=1 \
 //x=29.35 //y=2.765 //x2=29.35 //y2=2.765
r341 (  6 36 ) resistor r=9.3 //w=0.17 //l=0.17 //layer=mcon //count=1 \
 //x=27.5 //y=2.77 //x2=27.5 //y2=2.77
r342 (  4 8 ) resistor r=0.164988 //w=0.206 //l=0.267488 //layer=m1 \
 //thickness=0.36 //x=29.615 //y=2.77 //x2=29.35 //y2=2.765
r343 (  3 10 ) resistor r=0.0717383 //w=0.224 //l=0.115 //layer=m1 \
 //thickness=0.36 //x=34.045 //y=2.77 //x2=34.16 //y2=2.77
r344 (  3 4 ) resistor r=4.2271 //w=0.131 //l=4.43 //layer=m1 //thickness=0.36 \
 //x=34.045 //y=2.77 //x2=29.615 //y2=2.77
r345 (  2 6 ) resistor r=0.0717383 //w=0.224 //l=0.115 //layer=m1 \
 //thickness=0.36 //x=27.615 //y=2.77 //x2=27.5 //y2=2.77
r346 (  1 8 ) resistor r=0.0921728 //w=0.206 //l=0.147479 //layer=m1 \
 //thickness=0.36 //x=29.205 //y=2.77 //x2=29.35 //y2=2.765
r347 (  1 2 ) resistor r=1.51718 //w=0.131 //l=1.59 //layer=m1 \
 //thickness=0.36 //x=29.205 //y=2.77 //x2=27.615 //y2=2.77
ends PM_TMRDFFSNQNX1\%noxref_8

subckt PM_TMRDFFSNQNX1\%noxref_9 ( 1 2 13 14 21 29 35 36 40 42 49 50 51 52 53 \
 54 55 56 57 61 63 66 67 77 80 82 83 84 )
c166 ( 84 0 ) capacitor c=0.023087f //x=36.195 //y=5.2
c167 ( 83 0 ) capacitor c=0.023519f //x=35.315 //y=5.2
c168 ( 82 0 ) capacitor c=0.0224735f //x=34.435 //y=5.2
c169 ( 80 0 ) capacitor c=0.00872971f //x=36.445 //y=1.095
c170 ( 77 0 ) capacitor c=0.0588816f //x=38.97 //y=4.88
c171 ( 67 0 ) capacitor c=0.0318948f //x=39.305 //y=1.39
c172 ( 66 0 ) capacitor c=0.0187384f //x=39.305 //y=1.045
c173 ( 63 0 ) capacitor c=0.0141798f //x=39.15 //y=1.545
c174 ( 61 0 ) capacitor c=0.0149844f //x=39.15 //y=0.89
c175 ( 57 0 ) capacitor c=0.0813322f //x=38.775 //y=2.095
c176 ( 56 0 ) capacitor c=0.0229267f //x=38.775 //y=1.7
c177 ( 55 0 ) capacitor c=0.0234352f //x=38.775 //y=1.39
c178 ( 54 0 ) capacitor c=0.0199343f //x=38.775 //y=1.045
c179 ( 53 0 ) capacitor c=0.110275f //x=39.31 //y=6.2
c180 ( 52 0 ) capacitor c=0.154305f //x=38.87 //y=6.2
c181 ( 50 0 ) capacitor c=0.00106608f //x=36.34 //y=5.335
c182 ( 49 0 ) capacitor c=0.00207319f //x=35.46 //y=5.335
c183 ( 42 0 ) capacitor c=0.0839295f //x=38.97 //y=2.26
c184 ( 40 0 ) capacitor c=0.10402f //x=37.12 //y=2.77
c185 ( 36 0 ) capacitor c=0.00398962f //x=36.72 //y=1.845
c186 ( 35 0 ) capacitor c=0.0137288f //x=37.035 //y=1.845
c187 ( 29 0 ) capacitor c=0.0284988f //x=37.035 //y=5.335
c188 ( 21 0 ) capacitor c=0.0176454f //x=36.255 //y=5.335
c189 ( 14 0 ) capacitor c=0.00332903f //x=34.665 //y=5.335
c190 ( 13 0 ) capacitor c=0.0148427f //x=35.375 //y=5.335
c191 ( 2 0 ) capacitor c=0.00808366f //x=37.235 //y=2.77
c192 ( 1 0 ) capacitor c=0.0353429f //x=38.855 //y=2.77
r193 (  75 77 ) resistor r=20.6867 //w=0.233 //l=0.1 //layer=ply \
 //thickness=0.18 //x=38.87 //y=4.88 //x2=38.97 //y2=4.88
r194 (  68 77 ) resistor r=70.3348 //w=0.233 //l=0.414367 //layer=ply \
 //thickness=0.18 //x=39.31 //y=5.045 //x2=38.97 //y2=4.88
r195 (  67 79 ) resistor r=45.1352 //w=0.168 //l=0.173853 //layer=ply \
 //thickness=0.18 //x=39.305 //y=1.39 //x2=39.265 //y2=1.545
r196 (  66 78 ) resistor r=45.1352 //w=0.168 //l=0.173853 //layer=ply \
 //thickness=0.18 //x=39.305 //y=1.045 //x2=39.265 //y2=0.89
r197 (  66 67 ) resistor r=176.904 //w=0.094 //l=0.345 //layer=ply \
 //thickness=0.18 //x=39.305 //y=1.045 //x2=39.305 //y2=1.39
r198 (  64 74 ) resistor r=10.701 //w=0.21 //l=0.115 //layer=ply \
 //thickness=0.18 //x=38.93 //y=1.545 //x2=38.815 //y2=1.545
r199 (  63 79 ) resistor r=5.52526 //w=0.168 //l=0.115 //layer=ply \
 //thickness=0.18 //x=39.15 //y=1.545 //x2=39.265 //y2=1.545
r200 (  62 73 ) resistor r=5.52526 //w=0.168 //l=0.115 //layer=ply \
 //thickness=0.18 //x=38.93 //y=0.89 //x2=38.815 //y2=0.89
r201 (  61 78 ) resistor r=5.52526 //w=0.168 //l=0.115 //layer=ply \
 //thickness=0.18 //x=39.15 //y=0.89 //x2=39.265 //y2=0.89
r202 (  61 62 ) resistor r=112.809 //w=0.094 //l=0.22 //layer=ply \
 //thickness=0.18 //x=39.15 //y=0.89 //x2=38.93 //y2=0.89
r203 (  58 75 ) resistor r=13.0941 //w=0.233 //l=0.165 //layer=ply \
 //thickness=0.18 //x=38.87 //y=5.045 //x2=38.87 //y2=4.88
r204 (  57 72 ) resistor r=34.8111 //w=0.27 //l=0.264953 //layer=ply \
 //thickness=0.18 //x=38.775 //y=2.095 //x2=38.97 //y2=2.26
r205 (  56 74 ) resistor r=39.5823 //w=0.21 //l=0.173853 //layer=ply \
 //thickness=0.18 //x=38.775 //y=1.7 //x2=38.815 //y2=1.545
r206 (  56 57 ) resistor r=202.543 //w=0.094 //l=0.395 //layer=ply \
 //thickness=0.18 //x=38.775 //y=1.7 //x2=38.775 //y2=2.095
r207 (  55 74 ) resistor r=39.5823 //w=0.21 //l=0.173853 //layer=ply \
 //thickness=0.18 //x=38.775 //y=1.39 //x2=38.815 //y2=1.545
r208 (  54 73 ) resistor r=45.1352 //w=0.168 //l=0.173853 //layer=ply \
 //thickness=0.18 //x=38.775 //y=1.045 //x2=38.815 //y2=0.89
r209 (  54 55 ) resistor r=176.904 //w=0.094 //l=0.345 //layer=ply \
 //thickness=0.18 //x=38.775 //y=1.045 //x2=38.775 //y2=1.39
r210 (  53 68 ) resistor r=592.245 //w=0.094 //l=1.155 //layer=ply \
 //thickness=0.18 //x=39.31 //y=6.2 //x2=39.31 //y2=5.045
r211 (  52 58 ) resistor r=592.245 //w=0.094 //l=1.155 //layer=ply \
 //thickness=0.18 //x=38.87 //y=6.2 //x2=38.87 //y2=5.045
r212 (  51 63 ) resistor r=56.4043 //w=0.094 //l=0.11 //layer=ply \
 //thickness=0.18 //x=39.04 //y=1.545 //x2=39.15 //y2=1.545
r213 (  51 64 ) resistor r=56.4043 //w=0.094 //l=0.11 //layer=ply \
 //thickness=0.18 //x=39.04 //y=1.545 //x2=38.93 //y2=1.545
r214 (  47 77 ) resistor r=152 //w=0.17 //l=0.17 //layer=licon //count=1 \
 //x=38.97 //y=4.88 //x2=38.97 //y2=4.88
r215 (  45 47 ) resistor r=144.428 //w=0.187 //l=2.11 //layer=li \
 //thickness=0.1 //x=38.97 //y=2.77 //x2=38.97 //y2=4.88
r216 (  42 72 ) resistor r=152 //w=0.17 //l=0.17 //layer=licon //count=1 \
 //x=38.97 //y=2.26 //x2=38.97 //y2=2.26
r217 (  42 45 ) resistor r=34.9091 //w=0.187 //l=0.51 //layer=li \
 //thickness=0.1 //x=38.97 //y=2.26 //x2=38.97 //y2=2.77
r218 (  38 40 ) resistor r=169.754 //w=0.187 //l=2.48 //layer=li \
 //thickness=0.1 //x=37.12 //y=5.25 //x2=37.12 //y2=2.77
r219 (  37 40 ) resistor r=57.4973 //w=0.187 //l=0.84 //layer=li \
 //thickness=0.1 //x=37.12 //y=1.93 //x2=37.12 //y2=2.77
r220 (  35 37 ) resistor r=7.15173 //w=0.17 //l=0.120208 //layer=li \
 //thickness=0.1 //x=37.035 //y=1.845 //x2=37.12 //y2=1.93
r221 (  35 36 ) resistor r=21.5615 //w=0.187 //l=0.315 //layer=li \
 //thickness=0.1 //x=37.035 //y=1.845 //x2=36.72 //y2=1.845
r222 (  31 36 ) resistor r=7.15173 //w=0.17 //l=0.120208 //layer=li \
 //thickness=0.1 //x=36.635 //y=1.76 //x2=36.72 //y2=1.845
r223 (  31 80 ) resistor r=39.016 //w=0.187 //l=0.57 //layer=li \
 //thickness=0.1 //x=36.635 //y=1.76 //x2=36.635 //y2=1.19
r224 (  30 50 ) resistor r=5.4201 //w=0.17 //l=0.085 //layer=li \
 //thickness=0.1 //x=36.425 //y=5.335 //x2=36.34 //y2=5.335
r225 (  29 38 ) resistor r=7.15173 //w=0.17 //l=0.120208 //layer=li \
 //thickness=0.1 //x=37.035 //y=5.335 //x2=37.12 //y2=5.25
r226 (  29 30 ) resistor r=41.754 //w=0.187 //l=0.61 //layer=li \
 //thickness=0.1 //x=37.035 //y=5.335 //x2=36.425 //y2=5.335
r227 (  23 50 ) resistor r=1.40859 //w=0.34 //l=0.085 //layer=li \
 //thickness=0.1 //x=36.34 //y=5.42 //x2=36.34 //y2=5.335
r228 (  23 84 ) resistor r=33.1979 //w=0.187 //l=0.485 //layer=li \
 //thickness=0.1 //x=36.34 //y=5.42 //x2=36.34 //y2=5.905
r229 (  22 49 ) resistor r=5.4201 //w=0.17 //l=0.085 //layer=li \
 //thickness=0.1 //x=35.545 //y=5.335 //x2=35.46 //y2=5.335
r230 (  21 50 ) resistor r=5.4201 //w=0.17 //l=0.085 //layer=li \
 //thickness=0.1 //x=36.255 //y=5.335 //x2=36.34 //y2=5.335
r231 (  21 22 ) resistor r=48.5989 //w=0.187 //l=0.71 //layer=li \
 //thickness=0.1 //x=36.255 //y=5.335 //x2=35.545 //y2=5.335
r232 (  15 49 ) resistor r=1.40859 //w=0.34 //l=0.085 //layer=li \
 //thickness=0.1 //x=35.46 //y=5.42 //x2=35.46 //y2=5.335
r233 (  15 83 ) resistor r=33.1979 //w=0.187 //l=0.485 //layer=li \
 //thickness=0.1 //x=35.46 //y=5.42 //x2=35.46 //y2=5.905
r234 (  13 49 ) resistor r=5.4201 //w=0.17 //l=0.085 //layer=li \
 //thickness=0.1 //x=35.375 //y=5.335 //x2=35.46 //y2=5.335
r235 (  13 14 ) resistor r=48.5989 //w=0.187 //l=0.71 //layer=li \
 //thickness=0.1 //x=35.375 //y=5.335 //x2=34.665 //y2=5.335
r236 (  7 14 ) resistor r=7.15173 //w=0.17 //l=0.120208 //layer=li \
 //thickness=0.1 //x=34.58 //y=5.42 //x2=34.665 //y2=5.335
r237 (  7 82 ) resistor r=33.1979 //w=0.187 //l=0.485 //layer=li \
 //thickness=0.1 //x=34.58 //y=5.42 //x2=34.58 //y2=5.905
r238 (  6 45 ) resistor r=9.3 //w=0.17 //l=0.17 //layer=mcon //count=1 \
 //x=38.97 //y=2.77 //x2=38.97 //y2=2.77
r239 (  4 40 ) resistor r=9.3 //w=0.17 //l=0.17 //layer=mcon //count=1 \
 //x=37.12 //y=2.77 //x2=37.12 //y2=2.77
r240 (  2 4 ) resistor r=0.0717383 //w=0.224 //l=0.115 //layer=m1 \
 //thickness=0.36 //x=37.235 //y=2.77 //x2=37.12 //y2=2.77
r241 (  1 6 ) resistor r=0.0717383 //w=0.224 //l=0.115 //layer=m1 \
 //thickness=0.36 //x=38.855 //y=2.77 //x2=38.97 //y2=2.77
r242 (  1 2 ) resistor r=1.5458 //w=0.131 //l=1.62 //layer=m1 //thickness=0.36 \
 //x=38.855 //y=2.77 //x2=37.235 //y2=2.77
ends PM_TMRDFFSNQNX1\%noxref_9

subckt PM_TMRDFFSNQNX1\%noxref_10 ( 1 2 3 4 11 13 23 24 31 39 45 46 50 52 61 \
 62 64 65 67 68 69 70 71 72 73 74 75 80 82 84 90 91 92 93 94 95 99 101 104 105 \
 110 111 114 128 131 133 134 135 )
c282 ( 135 0 ) capacitor c=0.023087f //x=31.385 //y=5.2
c283 ( 134 0 ) capacitor c=0.023519f //x=30.505 //y=5.2
c284 ( 133 0 ) capacitor c=0.0224735f //x=29.625 //y=5.2
c285 ( 131 0 ) capacitor c=0.00853354f //x=31.635 //y=1.095
c286 ( 128 0 ) capacitor c=0.0588816f //x=42.3 //y=4.88
c287 ( 114 0 ) capacitor c=0.0331095f //x=26.79 //y=4.88
c288 ( 111 0 ) capacitor c=0.0279499f //x=26.76 //y=2.095
c289 ( 110 0 ) capacitor c=0.0421676f //x=26.76 //y=2.26
c290 ( 105 0 ) capacitor c=0.0318948f //x=42.635 //y=1.39
c291 ( 104 0 ) capacitor c=0.0187384f //x=42.635 //y=1.045
c292 ( 101 0 ) capacitor c=0.0141798f //x=42.48 //y=1.545
c293 ( 99 0 ) capacitor c=0.0149844f //x=42.48 //y=0.89
c294 ( 95 0 ) capacitor c=0.0813322f //x=42.105 //y=2.095
c295 ( 94 0 ) capacitor c=0.0229267f //x=42.105 //y=1.7
c296 ( 93 0 ) capacitor c=0.0234352f //x=42.105 //y=1.39
c297 ( 92 0 ) capacitor c=0.0199343f //x=42.105 //y=1.045
c298 ( 91 0 ) capacitor c=0.0429696f //x=27.325 //y=1.43
c299 ( 90 0 ) capacitor c=0.0192208f //x=27.325 //y=1.085
c300 ( 84 0 ) capacitor c=0.0148884f //x=27.17 //y=1.585
c301 ( 82 0 ) capacitor c=0.0157803f //x=27.17 //y=0.93
c302 ( 80 0 ) capacitor c=0.0295235f //x=27.165 //y=4.97
c303 ( 75 0 ) capacitor c=0.0205163f //x=26.795 //y=1.74
c304 ( 74 0 ) capacitor c=0.0168481f //x=26.795 //y=1.43
c305 ( 73 0 ) capacitor c=0.0174783f //x=26.795 //y=1.085
c306 ( 72 0 ) capacitor c=0.110275f //x=42.64 //y=6.2
c307 ( 71 0 ) capacitor c=0.154305f //x=42.2 //y=6.2
c308 ( 70 0 ) capacitor c=0.15358f //x=27.24 //y=6.2
c309 ( 69 0 ) capacitor c=0.110281f //x=26.8 //y=6.2
c310 ( 65 0 ) capacitor c=0.0715637f //x=32.307 //y=4.085
c311 ( 64 0 ) capacitor c=0.0101843f //x=32.305 //y=4.25
c312 ( 62 0 ) capacitor c=0.00106608f //x=31.53 //y=5.335
c313 ( 61 0 ) capacitor c=0.00207162f //x=30.65 //y=5.335
c314 ( 52 0 ) capacitor c=0.0857541f //x=42.3 //y=2.26
c315 ( 50 0 ) capacitor c=0.0236247f //x=32.31 //y=5.25
c316 ( 46 0 ) capacitor c=0.00398962f //x=31.91 //y=1.845
c317 ( 45 0 ) capacitor c=0.0135805f //x=32.225 //y=1.845
c318 ( 39 0 ) capacitor c=0.0281378f //x=32.225 //y=5.335
c319 ( 31 0 ) capacitor c=0.0176454f //x=31.445 //y=5.335
c320 ( 24 0 ) capacitor c=0.00332903f //x=29.855 //y=5.335
c321 ( 23 0 ) capacitor c=0.014837f //x=30.565 //y=5.335
c322 ( 13 0 ) capacitor c=0.0709324f //x=26.76 //y=2.26
c323 ( 11 0 ) capacitor c=0.00453889f //x=26.76 //y=4.715
c324 ( 4 0 ) capacitor c=0.00551102f //x=32.42 //y=4.25
c325 ( 3 0 ) capacitor c=0.141703f //x=42.185 //y=4.25
c326 ( 2 0 ) capacitor c=0.00979524f //x=26.875 //y=4.25
c327 ( 1 0 ) capacitor c=0.0882171f //x=32.19 //y=4.25
r328 (  126 128 ) resistor r=20.6867 //w=0.233 //l=0.1 //layer=ply \
 //thickness=0.18 //x=42.2 //y=4.88 //x2=42.3 //y2=4.88
r329 (  116 117 ) resistor r=32.4568 //w=0.214 //l=0.075 //layer=ply \
 //thickness=0.18 //x=26.79 //y=4.97 //x2=26.79 //y2=5.045
r330 (  114 116 ) resistor r=20.271 //w=0.214 //l=0.09 //layer=ply \
 //thickness=0.18 //x=26.79 //y=4.88 //x2=26.79 //y2=4.97
r331 (  110 111 ) resistor r=52.7279 //w=0.214 //l=0.165 //layer=ply \
 //thickness=0.18 //x=26.76 //y=2.26 //x2=26.76 //y2=2.095
r332 (  106 128 ) resistor r=70.3348 //w=0.233 //l=0.414367 //layer=ply \
 //thickness=0.18 //x=42.64 //y=5.045 //x2=42.3 //y2=4.88
r333 (  105 130 ) resistor r=45.1352 //w=0.168 //l=0.173853 //layer=ply \
 //thickness=0.18 //x=42.635 //y=1.39 //x2=42.595 //y2=1.545
r334 (  104 129 ) resistor r=45.1352 //w=0.168 //l=0.173853 //layer=ply \
 //thickness=0.18 //x=42.635 //y=1.045 //x2=42.595 //y2=0.89
r335 (  104 105 ) resistor r=176.904 //w=0.094 //l=0.345 //layer=ply \
 //thickness=0.18 //x=42.635 //y=1.045 //x2=42.635 //y2=1.39
r336 (  102 125 ) resistor r=10.701 //w=0.21 //l=0.115 //layer=ply \
 //thickness=0.18 //x=42.26 //y=1.545 //x2=42.145 //y2=1.545
r337 (  101 130 ) resistor r=5.52526 //w=0.168 //l=0.115 //layer=ply \
 //thickness=0.18 //x=42.48 //y=1.545 //x2=42.595 //y2=1.545
r338 (  100 124 ) resistor r=5.52526 //w=0.168 //l=0.115 //layer=ply \
 //thickness=0.18 //x=42.26 //y=0.89 //x2=42.145 //y2=0.89
r339 (  99 129 ) resistor r=5.52526 //w=0.168 //l=0.115 //layer=ply \
 //thickness=0.18 //x=42.48 //y=0.89 //x2=42.595 //y2=0.89
r340 (  99 100 ) resistor r=112.809 //w=0.094 //l=0.22 //layer=ply \
 //thickness=0.18 //x=42.48 //y=0.89 //x2=42.26 //y2=0.89
r341 (  96 126 ) resistor r=13.0941 //w=0.233 //l=0.165 //layer=ply \
 //thickness=0.18 //x=42.2 //y=5.045 //x2=42.2 //y2=4.88
r342 (  95 123 ) resistor r=34.8111 //w=0.27 //l=0.264953 //layer=ply \
 //thickness=0.18 //x=42.105 //y=2.095 //x2=42.3 //y2=2.26
r343 (  94 125 ) resistor r=39.5823 //w=0.21 //l=0.173853 //layer=ply \
 //thickness=0.18 //x=42.105 //y=1.7 //x2=42.145 //y2=1.545
r344 (  94 95 ) resistor r=202.543 //w=0.094 //l=0.395 //layer=ply \
 //thickness=0.18 //x=42.105 //y=1.7 //x2=42.105 //y2=2.095
r345 (  93 125 ) resistor r=39.5823 //w=0.21 //l=0.173853 //layer=ply \
 //thickness=0.18 //x=42.105 //y=1.39 //x2=42.145 //y2=1.545
r346 (  92 124 ) resistor r=45.1352 //w=0.168 //l=0.173853 //layer=ply \
 //thickness=0.18 //x=42.105 //y=1.045 //x2=42.145 //y2=0.89
r347 (  92 93 ) resistor r=176.904 //w=0.094 //l=0.345 //layer=ply \
 //thickness=0.18 //x=42.105 //y=1.045 //x2=42.105 //y2=1.39
r348 (  91 121 ) resistor r=45.1352 //w=0.168 //l=0.173853 //layer=ply \
 //thickness=0.18 //x=27.325 //y=1.43 //x2=27.285 //y2=1.585
r349 (  90 120 ) resistor r=45.1352 //w=0.168 //l=0.173853 //layer=ply \
 //thickness=0.18 //x=27.325 //y=1.085 //x2=27.285 //y2=0.93
r350 (  90 91 ) resistor r=176.904 //w=0.094 //l=0.345 //layer=ply \
 //thickness=0.18 //x=27.325 //y=1.085 //x2=27.325 //y2=1.43
r351 (  85 119 ) resistor r=10.701 //w=0.21 //l=0.115 //layer=ply \
 //thickness=0.18 //x=26.95 //y=1.585 //x2=26.835 //y2=1.585
r352 (  84 121 ) resistor r=5.52526 //w=0.168 //l=0.115 //layer=ply \
 //thickness=0.18 //x=27.17 //y=1.585 //x2=27.285 //y2=1.585
r353 (  83 118 ) resistor r=5.52526 //w=0.168 //l=0.115 //layer=ply \
 //thickness=0.18 //x=26.95 //y=0.93 //x2=26.835 //y2=0.93
r354 (  82 120 ) resistor r=5.52526 //w=0.168 //l=0.115 //layer=ply \
 //thickness=0.18 //x=27.17 //y=0.93 //x2=27.285 //y2=0.93
r355 (  82 83 ) resistor r=112.809 //w=0.094 //l=0.22 //layer=ply \
 //thickness=0.18 //x=27.17 //y=0.93 //x2=26.95 //y2=0.93
r356 (  81 116 ) resistor r=16.5046 //w=0.27 //l=0.135 //layer=ply \
 //thickness=0.18 //x=26.925 //y=4.97 //x2=26.79 //y2=4.97
r357 (  80 87 ) resistor r=26.9307 //w=0.15 //l=0.106066 //layer=ply \
 //thickness=0.18 //x=27.165 //y=4.97 //x2=27.24 //y2=5.045
r358 (  80 81 ) resistor r=123.064 //w=0.094 //l=0.24 //layer=ply \
 //thickness=0.18 //x=27.165 //y=4.97 //x2=26.925 //y2=4.97
r359 (  75 119 ) resistor r=39.5823 //w=0.21 //l=0.173853 //layer=ply \
 //thickness=0.18 //x=26.795 //y=1.74 //x2=26.835 //y2=1.585
r360 (  75 111 ) resistor r=182.032 //w=0.094 //l=0.355 //layer=ply \
 //thickness=0.18 //x=26.795 //y=1.74 //x2=26.795 //y2=2.095
r361 (  74 119 ) resistor r=39.5823 //w=0.21 //l=0.173853 //layer=ply \
 //thickness=0.18 //x=26.795 //y=1.43 //x2=26.835 //y2=1.585
r362 (  73 118 ) resistor r=45.1352 //w=0.168 //l=0.173853 //layer=ply \
 //thickness=0.18 //x=26.795 //y=1.085 //x2=26.835 //y2=0.93
r363 (  73 74 ) resistor r=176.904 //w=0.094 //l=0.345 //layer=ply \
 //thickness=0.18 //x=26.795 //y=1.085 //x2=26.795 //y2=1.43
r364 (  72 106 ) resistor r=592.245 //w=0.094 //l=1.155 //layer=ply \
 //thickness=0.18 //x=42.64 //y=6.2 //x2=42.64 //y2=5.045
r365 (  71 96 ) resistor r=592.245 //w=0.094 //l=1.155 //layer=ply \
 //thickness=0.18 //x=42.2 //y=6.2 //x2=42.2 //y2=5.045
r366 (  70 87 ) resistor r=592.245 //w=0.094 //l=1.155 //layer=ply \
 //thickness=0.18 //x=27.24 //y=6.2 //x2=27.24 //y2=5.045
r367 (  69 117 ) resistor r=592.245 //w=0.094 //l=1.155 //layer=ply \
 //thickness=0.18 //x=26.8 //y=6.2 //x2=26.8 //y2=5.045
r368 (  68 101 ) resistor r=56.4043 //w=0.094 //l=0.11 //layer=ply \
 //thickness=0.18 //x=42.37 //y=1.545 //x2=42.48 //y2=1.545
r369 (  68 102 ) resistor r=56.4043 //w=0.094 //l=0.11 //layer=ply \
 //thickness=0.18 //x=42.37 //y=1.545 //x2=42.26 //y2=1.545
r370 (  67 84 ) resistor r=56.4043 //w=0.094 //l=0.11 //layer=ply \
 //thickness=0.18 //x=27.06 //y=1.585 //x2=27.17 //y2=1.585
r371 (  67 85 ) resistor r=56.4043 //w=0.094 //l=0.11 //layer=ply \
 //thickness=0.18 //x=27.06 //y=1.585 //x2=26.95 //y2=1.585
r372 (  64 66 ) resistor r=11 //w=0.192 //l=0.165 //layer=li //thickness=0.1 \
 //x=32.307 //y=4.25 //x2=32.307 //y2=4.415
r373 (  64 65 ) resistor r=11 //w=0.192 //l=0.165 //layer=li //thickness=0.1 \
 //x=32.307 //y=4.25 //x2=32.307 //y2=4.085
r374 (  60 114 ) resistor r=152 //w=0.17 //l=0.17 //layer=licon //count=1 \
 //x=26.79 //y=4.88 //x2=26.79 //y2=4.88
r375 (  57 128 ) resistor r=152 //w=0.17 //l=0.17 //layer=licon //count=1 \
 //x=42.3 //y=4.88 //x2=42.3 //y2=4.88
r376 (  55 57 ) resistor r=43.123 //w=0.187 //l=0.63 //layer=li \
 //thickness=0.1 //x=42.3 //y=4.25 //x2=42.3 //y2=4.88
r377 (  52 123 ) resistor r=152 //w=0.17 //l=0.17 //layer=licon //count=1 \
 //x=42.3 //y=2.26 //x2=42.3 //y2=2.26
r378 (  52 55 ) resistor r=136.214 //w=0.187 //l=1.99 //layer=li \
 //thickness=0.1 //x=42.3 //y=2.26 //x2=42.3 //y2=4.25
r379 (  50 66 ) resistor r=57.1551 //w=0.187 //l=0.835 //layer=li \
 //thickness=0.1 //x=32.31 //y=5.25 //x2=32.31 //y2=4.415
r380 (  47 65 ) resistor r=147.508 //w=0.187 //l=2.155 //layer=li \
 //thickness=0.1 //x=32.31 //y=1.93 //x2=32.31 //y2=4.085
r381 (  45 47 ) resistor r=7.15173 //w=0.17 //l=0.120208 //layer=li \
 //thickness=0.1 //x=32.225 //y=1.845 //x2=32.31 //y2=1.93
r382 (  45 46 ) resistor r=21.5615 //w=0.187 //l=0.315 //layer=li \
 //thickness=0.1 //x=32.225 //y=1.845 //x2=31.91 //y2=1.845
r383 (  41 46 ) resistor r=7.15173 //w=0.17 //l=0.120208 //layer=li \
 //thickness=0.1 //x=31.825 //y=1.76 //x2=31.91 //y2=1.845
r384 (  41 131 ) resistor r=39.016 //w=0.187 //l=0.57 //layer=li \
 //thickness=0.1 //x=31.825 //y=1.76 //x2=31.825 //y2=1.19
r385 (  40 62 ) resistor r=5.4201 //w=0.17 //l=0.085 //layer=li \
 //thickness=0.1 //x=31.615 //y=5.335 //x2=31.53 //y2=5.335
r386 (  39 50 ) resistor r=7.15173 //w=0.17 //l=0.120208 //layer=li \
 //thickness=0.1 //x=32.225 //y=5.335 //x2=32.31 //y2=5.25
r387 (  39 40 ) resistor r=41.754 //w=0.187 //l=0.61 //layer=li \
 //thickness=0.1 //x=32.225 //y=5.335 //x2=31.615 //y2=5.335
r388 (  33 62 ) resistor r=1.40859 //w=0.34 //l=0.085 //layer=li \
 //thickness=0.1 //x=31.53 //y=5.42 //x2=31.53 //y2=5.335
r389 (  33 135 ) resistor r=33.1979 //w=0.187 //l=0.485 //layer=li \
 //thickness=0.1 //x=31.53 //y=5.42 //x2=31.53 //y2=5.905
r390 (  32 61 ) resistor r=5.4201 //w=0.17 //l=0.085 //layer=li \
 //thickness=0.1 //x=30.735 //y=5.335 //x2=30.65 //y2=5.335
r391 (  31 62 ) resistor r=5.4201 //w=0.17 //l=0.085 //layer=li \
 //thickness=0.1 //x=31.445 //y=5.335 //x2=31.53 //y2=5.335
r392 (  31 32 ) resistor r=48.5989 //w=0.187 //l=0.71 //layer=li \
 //thickness=0.1 //x=31.445 //y=5.335 //x2=30.735 //y2=5.335
r393 (  25 61 ) resistor r=1.40859 //w=0.34 //l=0.085 //layer=li \
 //thickness=0.1 //x=30.65 //y=5.42 //x2=30.65 //y2=5.335
r394 (  25 134 ) resistor r=33.1979 //w=0.187 //l=0.485 //layer=li \
 //thickness=0.1 //x=30.65 //y=5.42 //x2=30.65 //y2=5.905
r395 (  23 61 ) resistor r=5.4201 //w=0.17 //l=0.085 //layer=li \
 //thickness=0.1 //x=30.565 //y=5.335 //x2=30.65 //y2=5.335
r396 (  23 24 ) resistor r=48.5989 //w=0.187 //l=0.71 //layer=li \
 //thickness=0.1 //x=30.565 //y=5.335 //x2=29.855 //y2=5.335
r397 (  17 24 ) resistor r=7.15173 //w=0.17 //l=0.120208 //layer=li \
 //thickness=0.1 //x=29.77 //y=5.42 //x2=29.855 //y2=5.335
r398 (  17 133 ) resistor r=33.1979 //w=0.187 //l=0.485 //layer=li \
 //thickness=0.1 //x=29.77 //y=5.42 //x2=29.77 //y2=5.905
r399 (  13 110 ) resistor r=152 //w=0.17 //l=0.17 //layer=licon //count=1 \
 //x=26.76 //y=2.26 //x2=26.76 //y2=2.26
r400 (  13 16 ) resistor r=136.214 //w=0.187 //l=1.99 //layer=li \
 //thickness=0.1 //x=26.76 //y=2.26 //x2=26.76 //y2=4.25
r401 (  11 60 ) resistor r=11.4737 //w=0.186 //l=0.172337 //layer=li \
 //thickness=0.1 //x=26.76 //y=4.715 //x2=26.775 //y2=4.88
r402 (  11 16 ) resistor r=31.8289 //w=0.187 //l=0.465 //layer=li \
 //thickness=0.1 //x=26.76 //y=4.715 //x2=26.76 //y2=4.25
r403 (  10 55 ) resistor r=9.3 //w=0.17 //l=0.17 //layer=mcon //count=1 \
 //x=42.3 //y=4.25 //x2=42.3 //y2=4.25
r404 (  8 64 ) resistor r=9.3 //w=0.17 //l=0.17 //layer=mcon //count=1 \
 //x=32.305 //y=4.25 //x2=32.305 //y2=4.25
r405 (  6 16 ) resistor r=9.3 //w=0.17 //l=0.17 //layer=mcon //count=1 \
 //x=26.76 //y=4.25 //x2=26.76 //y2=4.25
r406 (  4 8 ) resistor r=0.0880901 //w=0.191 //l=0.115 //layer=m1 \
 //thickness=0.36 //x=32.42 //y=4.25 //x2=32.305 //y2=4.25
r407 (  3 10 ) resistor r=0.0717383 //w=0.224 //l=0.115 //layer=m1 \
 //thickness=0.36 //x=42.185 //y=4.25 //x2=42.3 //y2=4.25
r408 (  3 4 ) resistor r=9.31775 //w=0.131 //l=9.765 //layer=m1 \
 //thickness=0.36 //x=42.185 //y=4.25 //x2=32.42 //y2=4.25
r409 (  2 6 ) resistor r=0.0717383 //w=0.224 //l=0.115 //layer=m1 \
 //thickness=0.36 //x=26.875 //y=4.25 //x2=26.76 //y2=4.25
r410 (  1 8 ) resistor r=0.0880901 //w=0.191 //l=0.115 //layer=m1 \
 //thickness=0.36 //x=32.19 //y=4.25 //x2=32.305 //y2=4.25
r411 (  1 2 ) resistor r=5.07156 //w=0.131 //l=5.315 //layer=m1 \
 //thickness=0.36 //x=32.19 //y=4.25 //x2=26.875 //y2=4.25
ends PM_TMRDFFSNQNX1\%noxref_10

subckt PM_TMRDFFSNQNX1\%noxref_11 ( 1 2 3 4 5 6 16 24 37 38 49 51 52 56 58 65 \
 66 67 68 69 70 71 72 73 74 78 79 80 85 87 90 91 95 96 97 102 104 107 108 112 \
 113 114 119 121 124 125 127 128 133 137 138 143 147 148 153 156 158 159 )
c322 ( 159 0 ) capacitor c=0.0220291f //x=39.825 //y=5.2
c323 ( 158 0 ) capacitor c=0.0217503f //x=38.945 //y=5.2
c324 ( 156 0 ) capacitor c=0.00866655f //x=39.82 //y=1.085
c325 ( 153 0 ) capacitor c=0.0587755f //x=47.85 //y=4.88
c326 ( 148 0 ) capacitor c=0.0273931f //x=47.85 //y=2.095
c327 ( 147 0 ) capacitor c=0.0456313f //x=47.85 //y=2.26
c328 ( 143 0 ) capacitor c=0.0587755f //x=36.38 //y=4.88
c329 ( 138 0 ) capacitor c=0.0273931f //x=36.38 //y=2.095
c330 ( 137 0 ) capacitor c=0.0456313f //x=36.38 //y=2.26
c331 ( 133 0 ) capacitor c=0.058931f //x=31.57 //y=4.88
c332 ( 128 0 ) capacitor c=0.0267105f //x=31.57 //y=2.095
c333 ( 127 0 ) capacitor c=0.0456313f //x=31.57 //y=2.26
c334 ( 125 0 ) capacitor c=0.0432517f //x=48.37 //y=1.44
c335 ( 124 0 ) capacitor c=0.0200379f //x=48.37 //y=1.095
c336 ( 121 0 ) capacitor c=0.0148873f //x=48.215 //y=1.595
c337 ( 119 0 ) capacitor c=0.0157803f //x=48.215 //y=0.94
c338 ( 114 0 ) capacitor c=0.0218028f //x=47.84 //y=1.75
c339 ( 113 0 ) capacitor c=0.0207459f //x=47.84 //y=1.44
c340 ( 112 0 ) capacitor c=0.0194308f //x=47.84 //y=1.095
c341 ( 108 0 ) capacitor c=0.0432517f //x=36.9 //y=1.44
c342 ( 107 0 ) capacitor c=0.0200379f //x=36.9 //y=1.095
c343 ( 104 0 ) capacitor c=0.0148873f //x=36.745 //y=1.595
c344 ( 102 0 ) capacitor c=0.0157803f //x=36.745 //y=0.94
c345 ( 97 0 ) capacitor c=0.0218028f //x=36.37 //y=1.75
c346 ( 96 0 ) capacitor c=0.0207459f //x=36.37 //y=1.44
c347 ( 95 0 ) capacitor c=0.0194308f //x=36.37 //y=1.095
c348 ( 91 0 ) capacitor c=0.0432517f //x=32.09 //y=1.44
c349 ( 90 0 ) capacitor c=0.0200379f //x=32.09 //y=1.095
c350 ( 87 0 ) capacitor c=0.0148873f //x=31.935 //y=1.595
c351 ( 85 0 ) capacitor c=0.0157803f //x=31.935 //y=0.94
c352 ( 80 0 ) capacitor c=0.0218028f //x=31.56 //y=1.75
c353 ( 79 0 ) capacitor c=0.0207459f //x=31.56 //y=1.44
c354 ( 78 0 ) capacitor c=0.0194308f //x=31.56 //y=1.095
c355 ( 74 0 ) capacitor c=0.158794f //x=48.03 //y=6.2
c356 ( 73 0 ) capacitor c=0.110114f //x=47.59 //y=6.2
c357 ( 72 0 ) capacitor c=0.158794f //x=36.56 //y=6.2
c358 ( 71 0 ) capacitor c=0.110114f //x=36.12 //y=6.2
c359 ( 70 0 ) capacitor c=0.158048f //x=31.75 //y=6.2
c360 ( 69 0 ) capacitor c=0.110114f //x=31.31 //y=6.2
c361 ( 65 0 ) capacitor c=0.00211606f //x=39.97 //y=5.38
c362 ( 58 0 ) capacitor c=0.0796302f //x=47.85 //y=2.26
c363 ( 56 0 ) capacitor c=0.103614f //x=40.45 //y=3.88
c364 ( 52 0 ) capacitor c=0.00404073f //x=40.095 //y=1.835
c365 ( 51 0 ) capacitor c=0.0122201f //x=40.365 //y=1.835
c366 ( 49 0 ) capacitor c=0.0137522f //x=40.365 //y=5.38
c367 ( 38 0 ) capacitor c=0.00251635f //x=39.175 //y=5.38
c368 ( 37 0 ) capacitor c=0.0142529f //x=39.885 //y=5.38
c369 ( 24 0 ) capacitor c=0.0811636f //x=36.38 //y=2.26
c370 ( 16 0 ) capacitor c=0.0796434f //x=31.57 //y=2.26
c371 ( 6 0 ) capacitor c=0.00405261f //x=40.565 //y=3.88
c372 ( 5 0 ) capacitor c=0.120326f //x=47.735 //y=3.88
c373 ( 4 0 ) capacitor c=0.00412452f //x=36.495 //y=3.88
c374 ( 3 0 ) capacitor c=0.0546427f //x=40.335 //y=3.88
c375 ( 2 0 ) capacitor c=0.0138772f //x=31.685 //y=3.88
c376 ( 1 0 ) capacitor c=0.0670382f //x=36.265 //y=3.88
r377 (  147 148 ) resistor r=52.7279 //w=0.214 //l=0.165 //layer=ply \
 //thickness=0.18 //x=47.85 //y=2.26 //x2=47.85 //y2=2.095
r378 (  137 138 ) resistor r=52.7279 //w=0.214 //l=0.165 //layer=ply \
 //thickness=0.18 //x=36.38 //y=2.26 //x2=36.38 //y2=2.095
r379 (  127 128 ) resistor r=52.7279 //w=0.214 //l=0.165 //layer=ply \
 //thickness=0.18 //x=31.57 //y=2.26 //x2=31.57 //y2=2.095
r380 (  125 155 ) resistor r=45.1352 //w=0.168 //l=0.173853 //layer=ply \
 //thickness=0.18 //x=48.37 //y=1.44 //x2=48.33 //y2=1.595
r381 (  124 154 ) resistor r=45.1352 //w=0.168 //l=0.173853 //layer=ply \
 //thickness=0.18 //x=48.37 //y=1.095 //x2=48.33 //y2=0.94
r382 (  124 125 ) resistor r=176.904 //w=0.094 //l=0.345 //layer=ply \
 //thickness=0.18 //x=48.37 //y=1.095 //x2=48.37 //y2=1.44
r383 (  122 151 ) resistor r=10.701 //w=0.21 //l=0.115 //layer=ply \
 //thickness=0.18 //x=47.995 //y=1.595 //x2=47.88 //y2=1.595
r384 (  121 155 ) resistor r=5.52526 //w=0.168 //l=0.115 //layer=ply \
 //thickness=0.18 //x=48.215 //y=1.595 //x2=48.33 //y2=1.595
r385 (  120 150 ) resistor r=5.52526 //w=0.168 //l=0.115 //layer=ply \
 //thickness=0.18 //x=47.995 //y=0.94 //x2=47.88 //y2=0.94
r386 (  119 154 ) resistor r=5.52526 //w=0.168 //l=0.115 //layer=ply \
 //thickness=0.18 //x=48.215 //y=0.94 //x2=48.33 //y2=0.94
r387 (  119 120 ) resistor r=112.809 //w=0.094 //l=0.22 //layer=ply \
 //thickness=0.18 //x=48.215 //y=0.94 //x2=47.995 //y2=0.94
r388 (  116 153 ) resistor r=37.236 //w=0.233 //l=0.249199 //layer=ply \
 //thickness=0.18 //x=48.03 //y=5.045 //x2=47.85 //y2=4.88
r389 (  114 151 ) resistor r=39.5823 //w=0.21 //l=0.173853 //layer=ply \
 //thickness=0.18 //x=47.84 //y=1.75 //x2=47.88 //y2=1.595
r390 (  114 148 ) resistor r=176.904 //w=0.094 //l=0.345 //layer=ply \
 //thickness=0.18 //x=47.84 //y=1.75 //x2=47.84 //y2=2.095
r391 (  113 151 ) resistor r=39.5823 //w=0.21 //l=0.173853 //layer=ply \
 //thickness=0.18 //x=47.84 //y=1.44 //x2=47.88 //y2=1.595
r392 (  112 150 ) resistor r=45.1352 //w=0.168 //l=0.173853 //layer=ply \
 //thickness=0.18 //x=47.84 //y=1.095 //x2=47.88 //y2=0.94
r393 (  112 113 ) resistor r=176.904 //w=0.094 //l=0.345 //layer=ply \
 //thickness=0.18 //x=47.84 //y=1.095 //x2=47.84 //y2=1.44
r394 (  109 153 ) resistor r=53.7854 //w=0.233 //l=0.332415 //layer=ply \
 //thickness=0.18 //x=47.59 //y=5.045 //x2=47.85 //y2=4.88
r395 (  108 145 ) resistor r=45.1352 //w=0.168 //l=0.173853 //layer=ply \
 //thickness=0.18 //x=36.9 //y=1.44 //x2=36.86 //y2=1.595
r396 (  107 144 ) resistor r=45.1352 //w=0.168 //l=0.173853 //layer=ply \
 //thickness=0.18 //x=36.9 //y=1.095 //x2=36.86 //y2=0.94
r397 (  107 108 ) resistor r=176.904 //w=0.094 //l=0.345 //layer=ply \
 //thickness=0.18 //x=36.9 //y=1.095 //x2=36.9 //y2=1.44
r398 (  105 141 ) resistor r=10.701 //w=0.21 //l=0.115 //layer=ply \
 //thickness=0.18 //x=36.525 //y=1.595 //x2=36.41 //y2=1.595
r399 (  104 145 ) resistor r=5.52526 //w=0.168 //l=0.115 //layer=ply \
 //thickness=0.18 //x=36.745 //y=1.595 //x2=36.86 //y2=1.595
r400 (  103 140 ) resistor r=5.52526 //w=0.168 //l=0.115 //layer=ply \
 //thickness=0.18 //x=36.525 //y=0.94 //x2=36.41 //y2=0.94
r401 (  102 144 ) resistor r=5.52526 //w=0.168 //l=0.115 //layer=ply \
 //thickness=0.18 //x=36.745 //y=0.94 //x2=36.86 //y2=0.94
r402 (  102 103 ) resistor r=112.809 //w=0.094 //l=0.22 //layer=ply \
 //thickness=0.18 //x=36.745 //y=0.94 //x2=36.525 //y2=0.94
r403 (  99 143 ) resistor r=37.236 //w=0.233 //l=0.249199 //layer=ply \
 //thickness=0.18 //x=36.56 //y=5.045 //x2=36.38 //y2=4.88
r404 (  97 141 ) resistor r=39.5823 //w=0.21 //l=0.173853 //layer=ply \
 //thickness=0.18 //x=36.37 //y=1.75 //x2=36.41 //y2=1.595
r405 (  97 138 ) resistor r=176.904 //w=0.094 //l=0.345 //layer=ply \
 //thickness=0.18 //x=36.37 //y=1.75 //x2=36.37 //y2=2.095
r406 (  96 141 ) resistor r=39.5823 //w=0.21 //l=0.173853 //layer=ply \
 //thickness=0.18 //x=36.37 //y=1.44 //x2=36.41 //y2=1.595
r407 (  95 140 ) resistor r=45.1352 //w=0.168 //l=0.173853 //layer=ply \
 //thickness=0.18 //x=36.37 //y=1.095 //x2=36.41 //y2=0.94
r408 (  95 96 ) resistor r=176.904 //w=0.094 //l=0.345 //layer=ply \
 //thickness=0.18 //x=36.37 //y=1.095 //x2=36.37 //y2=1.44
r409 (  92 143 ) resistor r=53.7854 //w=0.233 //l=0.332415 //layer=ply \
 //thickness=0.18 //x=36.12 //y=5.045 //x2=36.38 //y2=4.88
r410 (  91 135 ) resistor r=45.1352 //w=0.168 //l=0.173853 //layer=ply \
 //thickness=0.18 //x=32.09 //y=1.44 //x2=32.05 //y2=1.595
r411 (  90 134 ) resistor r=45.1352 //w=0.168 //l=0.173853 //layer=ply \
 //thickness=0.18 //x=32.09 //y=1.095 //x2=32.05 //y2=0.94
r412 (  90 91 ) resistor r=176.904 //w=0.094 //l=0.345 //layer=ply \
 //thickness=0.18 //x=32.09 //y=1.095 //x2=32.09 //y2=1.44
r413 (  88 131 ) resistor r=10.701 //w=0.21 //l=0.115 //layer=ply \
 //thickness=0.18 //x=31.715 //y=1.595 //x2=31.6 //y2=1.595
r414 (  87 135 ) resistor r=5.52526 //w=0.168 //l=0.115 //layer=ply \
 //thickness=0.18 //x=31.935 //y=1.595 //x2=32.05 //y2=1.595
r415 (  86 130 ) resistor r=5.52526 //w=0.168 //l=0.115 //layer=ply \
 //thickness=0.18 //x=31.715 //y=0.94 //x2=31.6 //y2=0.94
r416 (  85 134 ) resistor r=5.52526 //w=0.168 //l=0.115 //layer=ply \
 //thickness=0.18 //x=31.935 //y=0.94 //x2=32.05 //y2=0.94
r417 (  85 86 ) resistor r=112.809 //w=0.094 //l=0.22 //layer=ply \
 //thickness=0.18 //x=31.935 //y=0.94 //x2=31.715 //y2=0.94
r418 (  82 133 ) resistor r=37.236 //w=0.233 //l=0.249199 //layer=ply \
 //thickness=0.18 //x=31.75 //y=5.045 //x2=31.57 //y2=4.88
r419 (  80 131 ) resistor r=39.5823 //w=0.21 //l=0.173853 //layer=ply \
 //thickness=0.18 //x=31.56 //y=1.75 //x2=31.6 //y2=1.595
r420 (  80 128 ) resistor r=176.904 //w=0.094 //l=0.345 //layer=ply \
 //thickness=0.18 //x=31.56 //y=1.75 //x2=31.56 //y2=2.095
r421 (  79 131 ) resistor r=39.5823 //w=0.21 //l=0.173853 //layer=ply \
 //thickness=0.18 //x=31.56 //y=1.44 //x2=31.6 //y2=1.595
r422 (  78 130 ) resistor r=45.1352 //w=0.168 //l=0.173853 //layer=ply \
 //thickness=0.18 //x=31.56 //y=1.095 //x2=31.6 //y2=0.94
r423 (  78 79 ) resistor r=176.904 //w=0.094 //l=0.345 //layer=ply \
 //thickness=0.18 //x=31.56 //y=1.095 //x2=31.56 //y2=1.44
r424 (  75 133 ) resistor r=53.7854 //w=0.233 //l=0.332415 //layer=ply \
 //thickness=0.18 //x=31.31 //y=5.045 //x2=31.57 //y2=4.88
r425 (  74 116 ) resistor r=592.245 //w=0.094 //l=1.155 //layer=ply \
 //thickness=0.18 //x=48.03 //y=6.2 //x2=48.03 //y2=5.045
r426 (  73 109 ) resistor r=592.245 //w=0.094 //l=1.155 //layer=ply \
 //thickness=0.18 //x=47.59 //y=6.2 //x2=47.59 //y2=5.045
r427 (  72 99 ) resistor r=592.245 //w=0.094 //l=1.155 //layer=ply \
 //thickness=0.18 //x=36.56 //y=6.2 //x2=36.56 //y2=5.045
r428 (  71 92 ) resistor r=592.245 //w=0.094 //l=1.155 //layer=ply \
 //thickness=0.18 //x=36.12 //y=6.2 //x2=36.12 //y2=5.045
r429 (  70 82 ) resistor r=592.245 //w=0.094 //l=1.155 //layer=ply \
 //thickness=0.18 //x=31.75 //y=6.2 //x2=31.75 //y2=5.045
r430 (  69 75 ) resistor r=592.245 //w=0.094 //l=1.155 //layer=ply \
 //thickness=0.18 //x=31.31 //y=6.2 //x2=31.31 //y2=5.045
r431 (  68 121 ) resistor r=56.4043 //w=0.094 //l=0.11 //layer=ply \
 //thickness=0.18 //x=48.105 //y=1.595 //x2=48.215 //y2=1.595
r432 (  68 122 ) resistor r=56.4043 //w=0.094 //l=0.11 //layer=ply \
 //thickness=0.18 //x=48.105 //y=1.595 //x2=47.995 //y2=1.595
r433 (  67 104 ) resistor r=56.4043 //w=0.094 //l=0.11 //layer=ply \
 //thickness=0.18 //x=36.635 //y=1.595 //x2=36.745 //y2=1.595
r434 (  67 105 ) resistor r=56.4043 //w=0.094 //l=0.11 //layer=ply \
 //thickness=0.18 //x=36.635 //y=1.595 //x2=36.525 //y2=1.595
r435 (  66 87 ) resistor r=56.4043 //w=0.094 //l=0.11 //layer=ply \
 //thickness=0.18 //x=31.825 //y=1.595 //x2=31.935 //y2=1.595
r436 (  66 88 ) resistor r=56.4043 //w=0.094 //l=0.11 //layer=ply \
 //thickness=0.18 //x=31.825 //y=1.595 //x2=31.715 //y2=1.595
r437 (  63 153 ) resistor r=152 //w=0.17 //l=0.17 //layer=licon //count=1 \
 //x=47.85 //y=4.88 //x2=47.85 //y2=4.88
r438 (  61 63 ) resistor r=68.4492 //w=0.187 //l=1 //layer=li //thickness=0.1 \
 //x=47.85 //y=3.88 //x2=47.85 //y2=4.88
r439 (  58 147 ) resistor r=152 //w=0.17 //l=0.17 //layer=licon //count=1 \
 //x=47.85 //y=2.26 //x2=47.85 //y2=2.26
r440 (  58 61 ) resistor r=110.888 //w=0.187 //l=1.62 //layer=li \
 //thickness=0.1 //x=47.85 //y=2.26 //x2=47.85 //y2=3.88
r441 (  54 56 ) resistor r=96.8556 //w=0.187 //l=1.415 //layer=li \
 //thickness=0.1 //x=40.45 //y=5.295 //x2=40.45 //y2=3.88
r442 (  53 56 ) resistor r=134.16 //w=0.187 //l=1.96 //layer=li \
 //thickness=0.1 //x=40.45 //y=1.92 //x2=40.45 //y2=3.88
r443 (  51 53 ) resistor r=7.15173 //w=0.17 //l=0.120208 //layer=li \
 //thickness=0.1 //x=40.365 //y=1.835 //x2=40.45 //y2=1.92
r444 (  51 52 ) resistor r=18.4813 //w=0.187 //l=0.27 //layer=li \
 //thickness=0.1 //x=40.365 //y=1.835 //x2=40.095 //y2=1.835
r445 (  50 65 ) resistor r=5.4201 //w=0.17 //l=0.085 //layer=li \
 //thickness=0.1 //x=40.055 //y=5.38 //x2=39.97 //y2=5.38
r446 (  49 54 ) resistor r=7.15173 //w=0.17 //l=0.120208 //layer=li \
 //thickness=0.1 //x=40.365 //y=5.38 //x2=40.45 //y2=5.295
r447 (  49 50 ) resistor r=21.2193 //w=0.187 //l=0.31 //layer=li \
 //thickness=0.1 //x=40.365 //y=5.38 //x2=40.055 //y2=5.38
r448 (  45 52 ) resistor r=7.15173 //w=0.17 //l=0.120208 //layer=li \
 //thickness=0.1 //x=40.01 //y=1.75 //x2=40.095 //y2=1.835
r449 (  45 156 ) resistor r=39.016 //w=0.187 //l=0.57 //layer=li \
 //thickness=0.1 //x=40.01 //y=1.75 //x2=40.01 //y2=1.18
r450 (  39 65 ) resistor r=1.40859 //w=0.34 //l=0.085 //layer=li \
 //thickness=0.1 //x=39.97 //y=5.465 //x2=39.97 //y2=5.38
r451 (  39 159 ) resistor r=30.1176 //w=0.187 //l=0.44 //layer=li \
 //thickness=0.1 //x=39.97 //y=5.465 //x2=39.97 //y2=5.905
r452 (  37 65 ) resistor r=5.4201 //w=0.17 //l=0.085 //layer=li \
 //thickness=0.1 //x=39.885 //y=5.38 //x2=39.97 //y2=5.38
r453 (  37 38 ) resistor r=48.5989 //w=0.187 //l=0.71 //layer=li \
 //thickness=0.1 //x=39.885 //y=5.38 //x2=39.175 //y2=5.38
r454 (  31 38 ) resistor r=7.15173 //w=0.17 //l=0.120208 //layer=li \
 //thickness=0.1 //x=39.09 //y=5.465 //x2=39.175 //y2=5.38
r455 (  31 158 ) resistor r=30.1176 //w=0.187 //l=0.44 //layer=li \
 //thickness=0.1 //x=39.09 //y=5.465 //x2=39.09 //y2=5.905
r456 (  29 143 ) resistor r=152 //w=0.17 //l=0.17 //layer=licon //count=1 \
 //x=36.38 //y=4.88 //x2=36.38 //y2=4.88
r457 (  27 29 ) resistor r=68.4492 //w=0.187 //l=1 //layer=li //thickness=0.1 \
 //x=36.38 //y=3.88 //x2=36.38 //y2=4.88
r458 (  24 137 ) resistor r=152 //w=0.17 //l=0.17 //layer=licon //count=1 \
 //x=36.38 //y=2.26 //x2=36.38 //y2=2.26
r459 (  24 27 ) resistor r=110.888 //w=0.187 //l=1.62 //layer=li \
 //thickness=0.1 //x=36.38 //y=2.26 //x2=36.38 //y2=3.88
r460 (  21 133 ) resistor r=152 //w=0.17 //l=0.17 //layer=licon //count=1 \
 //x=31.57 //y=4.88 //x2=31.57 //y2=4.88
r461 (  19 21 ) resistor r=68.4492 //w=0.187 //l=1 //layer=li //thickness=0.1 \
 //x=31.57 //y=3.88 //x2=31.57 //y2=4.88
r462 (  16 127 ) resistor r=152 //w=0.17 //l=0.17 //layer=licon //count=1 \
 //x=31.57 //y=2.26 //x2=31.57 //y2=2.26
r463 (  16 19 ) resistor r=110.888 //w=0.187 //l=1.62 //layer=li \
 //thickness=0.1 //x=31.57 //y=2.26 //x2=31.57 //y2=3.88
r464 (  14 61 ) resistor r=9.3 //w=0.17 //l=0.17 //layer=mcon //count=1 \
 //x=47.85 //y=3.88 //x2=47.85 //y2=3.88
r465 (  12 56 ) resistor r=9.3 //w=0.17 //l=0.17 //layer=mcon //count=1 \
 //x=40.45 //y=3.88 //x2=40.45 //y2=3.88
r466 (  10 27 ) resistor r=9.3 //w=0.17 //l=0.17 //layer=mcon //count=1 \
 //x=36.38 //y=3.88 //x2=36.38 //y2=3.88
r467 (  8 19 ) resistor r=9.3 //w=0.17 //l=0.17 //layer=mcon //count=1 \
 //x=31.57 //y=3.88 //x2=31.57 //y2=3.88
r468 (  6 12 ) resistor r=0.0880901 //w=0.191 //l=0.115 //layer=m1 \
 //thickness=0.36 //x=40.565 //y=3.88 //x2=40.45 //y2=3.88
r469 (  5 14 ) resistor r=0.0717383 //w=0.224 //l=0.115 //layer=m1 \
 //thickness=0.36 //x=47.735 //y=3.88 //x2=47.85 //y2=3.88
r470 (  5 6 ) resistor r=6.8416 //w=0.131 //l=7.17 //layer=m1 //thickness=0.36 \
 //x=47.735 //y=3.88 //x2=40.565 //y2=3.88
r471 (  4 10 ) resistor r=0.0880901 //w=0.191 //l=0.115 //layer=m1 \
 //thickness=0.36 //x=36.495 //y=3.88 //x2=36.38 //y2=3.88
r472 (  3 12 ) resistor r=0.0880901 //w=0.191 //l=0.115 //layer=m1 \
 //thickness=0.36 //x=40.335 //y=3.88 //x2=40.45 //y2=3.88
r473 (  3 4 ) resistor r=3.66412 //w=0.131 //l=3.84 //layer=m1 \
 //thickness=0.36 //x=40.335 //y=3.88 //x2=36.495 //y2=3.88
r474 (  2 8 ) resistor r=0.0717383 //w=0.224 //l=0.115 //layer=m1 \
 //thickness=0.36 //x=31.685 //y=3.88 //x2=31.57 //y2=3.88
r475 (  1 10 ) resistor r=0.0880901 //w=0.191 //l=0.115 //layer=m1 \
 //thickness=0.36 //x=36.265 //y=3.88 //x2=36.38 //y2=3.88
r476 (  1 2 ) resistor r=4.37023 //w=0.131 //l=4.58 //layer=m1 \
 //thickness=0.36 //x=36.265 //y=3.88 //x2=31.685 //y2=3.88
ends PM_TMRDFFSNQNX1\%noxref_11

subckt PM_TMRDFFSNQNX1\%noxref_12 ( 1 2 7 9 19 20 27 35 41 42 46 49 50 51 52 \
 53 54 55 56 61 63 65 71 72 74 75 78 86 88 89 90 )
c181 ( 90 0 ) capacitor c=0.023087f //x=47.665 //y=5.2
c182 ( 89 0 ) capacitor c=0.023519f //x=46.785 //y=5.2
c183 ( 88 0 ) capacitor c=0.0224735f //x=45.905 //y=5.2
c184 ( 86 0 ) capacitor c=0.00872971f //x=47.915 //y=1.095
c185 ( 78 0 ) capacitor c=0.0331095f //x=43.07 //y=4.88
c186 ( 75 0 ) capacitor c=0.0279499f //x=43.04 //y=2.095
c187 ( 74 0 ) capacitor c=0.0421676f //x=43.04 //y=2.26
c188 ( 72 0 ) capacitor c=0.0429696f //x=43.605 //y=1.43
c189 ( 71 0 ) capacitor c=0.0192208f //x=43.605 //y=1.085
c190 ( 65 0 ) capacitor c=0.0148884f //x=43.45 //y=1.585
c191 ( 63 0 ) capacitor c=0.0157803f //x=43.45 //y=0.93
c192 ( 61 0 ) capacitor c=0.0295235f //x=43.445 //y=4.97
c193 ( 56 0 ) capacitor c=0.0205163f //x=43.075 //y=1.74
c194 ( 55 0 ) capacitor c=0.0168481f //x=43.075 //y=1.43
c195 ( 54 0 ) capacitor c=0.0174783f //x=43.075 //y=1.085
c196 ( 53 0 ) capacitor c=0.15358f //x=43.52 //y=6.2
c197 ( 52 0 ) capacitor c=0.110281f //x=43.08 //y=6.2
c198 ( 50 0 ) capacitor c=0.00106608f //x=47.81 //y=5.335
c199 ( 49 0 ) capacitor c=0.00207319f //x=46.93 //y=5.335
c200 ( 46 0 ) capacitor c=0.106168f //x=48.59 //y=4.25
c201 ( 42 0 ) capacitor c=0.00398962f //x=48.19 //y=1.845
c202 ( 41 0 ) capacitor c=0.0137288f //x=48.505 //y=1.845
c203 ( 35 0 ) capacitor c=0.0284988f //x=48.505 //y=5.335
c204 ( 27 0 ) capacitor c=0.0176454f //x=47.725 //y=5.335
c205 ( 20 0 ) capacitor c=0.00332903f //x=46.135 //y=5.335
c206 ( 19 0 ) capacitor c=0.0148427f //x=46.845 //y=5.335
c207 ( 9 0 ) capacitor c=0.0689632f //x=43.04 //y=2.26
c208 ( 7 0 ) capacitor c=0.00453889f //x=43.04 //y=4.715
c209 ( 2 0 ) capacitor c=0.00621861f //x=43.155 //y=4.25
c210 ( 1 0 ) capacitor c=0.0841928f //x=48.475 //y=4.25
r211 (  80 81 ) resistor r=32.4568 //w=0.214 //l=0.075 //layer=ply \
 //thickness=0.18 //x=43.07 //y=4.97 //x2=43.07 //y2=5.045
r212 (  78 80 ) resistor r=20.271 //w=0.214 //l=0.09 //layer=ply \
 //thickness=0.18 //x=43.07 //y=4.88 //x2=43.07 //y2=4.97
r213 (  74 75 ) resistor r=52.7279 //w=0.214 //l=0.165 //layer=ply \
 //thickness=0.18 //x=43.04 //y=2.26 //x2=43.04 //y2=2.095
r214 (  72 85 ) resistor r=45.1352 //w=0.168 //l=0.173853 //layer=ply \
 //thickness=0.18 //x=43.605 //y=1.43 //x2=43.565 //y2=1.585
r215 (  71 84 ) resistor r=45.1352 //w=0.168 //l=0.173853 //layer=ply \
 //thickness=0.18 //x=43.605 //y=1.085 //x2=43.565 //y2=0.93
r216 (  71 72 ) resistor r=176.904 //w=0.094 //l=0.345 //layer=ply \
 //thickness=0.18 //x=43.605 //y=1.085 //x2=43.605 //y2=1.43
r217 (  66 83 ) resistor r=10.701 //w=0.21 //l=0.115 //layer=ply \
 //thickness=0.18 //x=43.23 //y=1.585 //x2=43.115 //y2=1.585
r218 (  65 85 ) resistor r=5.52526 //w=0.168 //l=0.115 //layer=ply \
 //thickness=0.18 //x=43.45 //y=1.585 //x2=43.565 //y2=1.585
r219 (  64 82 ) resistor r=5.52526 //w=0.168 //l=0.115 //layer=ply \
 //thickness=0.18 //x=43.23 //y=0.93 //x2=43.115 //y2=0.93
r220 (  63 84 ) resistor r=5.52526 //w=0.168 //l=0.115 //layer=ply \
 //thickness=0.18 //x=43.45 //y=0.93 //x2=43.565 //y2=0.93
r221 (  63 64 ) resistor r=112.809 //w=0.094 //l=0.22 //layer=ply \
 //thickness=0.18 //x=43.45 //y=0.93 //x2=43.23 //y2=0.93
r222 (  62 80 ) resistor r=16.5046 //w=0.27 //l=0.135 //layer=ply \
 //thickness=0.18 //x=43.205 //y=4.97 //x2=43.07 //y2=4.97
r223 (  61 68 ) resistor r=26.9307 //w=0.15 //l=0.106066 //layer=ply \
 //thickness=0.18 //x=43.445 //y=4.97 //x2=43.52 //y2=5.045
r224 (  61 62 ) resistor r=123.064 //w=0.094 //l=0.24 //layer=ply \
 //thickness=0.18 //x=43.445 //y=4.97 //x2=43.205 //y2=4.97
r225 (  56 83 ) resistor r=39.5823 //w=0.21 //l=0.173853 //layer=ply \
 //thickness=0.18 //x=43.075 //y=1.74 //x2=43.115 //y2=1.585
r226 (  56 75 ) resistor r=182.032 //w=0.094 //l=0.355 //layer=ply \
 //thickness=0.18 //x=43.075 //y=1.74 //x2=43.075 //y2=2.095
r227 (  55 83 ) resistor r=39.5823 //w=0.21 //l=0.173853 //layer=ply \
 //thickness=0.18 //x=43.075 //y=1.43 //x2=43.115 //y2=1.585
r228 (  54 82 ) resistor r=45.1352 //w=0.168 //l=0.173853 //layer=ply \
 //thickness=0.18 //x=43.075 //y=1.085 //x2=43.115 //y2=0.93
r229 (  54 55 ) resistor r=176.904 //w=0.094 //l=0.345 //layer=ply \
 //thickness=0.18 //x=43.075 //y=1.085 //x2=43.075 //y2=1.43
r230 (  53 68 ) resistor r=592.245 //w=0.094 //l=1.155 //layer=ply \
 //thickness=0.18 //x=43.52 //y=6.2 //x2=43.52 //y2=5.045
r231 (  52 81 ) resistor r=592.245 //w=0.094 //l=1.155 //layer=ply \
 //thickness=0.18 //x=43.08 //y=6.2 //x2=43.08 //y2=5.045
r232 (  51 65 ) resistor r=56.4043 //w=0.094 //l=0.11 //layer=ply \
 //thickness=0.18 //x=43.34 //y=1.585 //x2=43.45 //y2=1.585
r233 (  51 66 ) resistor r=56.4043 //w=0.094 //l=0.11 //layer=ply \
 //thickness=0.18 //x=43.34 //y=1.585 //x2=43.23 //y2=1.585
r234 (  48 78 ) resistor r=152 //w=0.17 //l=0.17 //layer=licon //count=1 \
 //x=43.07 //y=4.88 //x2=43.07 //y2=4.88
r235 (  44 46 ) resistor r=68.4492 //w=0.187 //l=1 //layer=li //thickness=0.1 \
 //x=48.59 //y=5.25 //x2=48.59 //y2=4.25
r236 (  43 46 ) resistor r=158.802 //w=0.187 //l=2.32 //layer=li \
 //thickness=0.1 //x=48.59 //y=1.93 //x2=48.59 //y2=4.25
r237 (  41 43 ) resistor r=7.15173 //w=0.17 //l=0.120208 //layer=li \
 //thickness=0.1 //x=48.505 //y=1.845 //x2=48.59 //y2=1.93
r238 (  41 42 ) resistor r=21.5615 //w=0.187 //l=0.315 //layer=li \
 //thickness=0.1 //x=48.505 //y=1.845 //x2=48.19 //y2=1.845
r239 (  37 42 ) resistor r=7.15173 //w=0.17 //l=0.120208 //layer=li \
 //thickness=0.1 //x=48.105 //y=1.76 //x2=48.19 //y2=1.845
r240 (  37 86 ) resistor r=39.016 //w=0.187 //l=0.57 //layer=li \
 //thickness=0.1 //x=48.105 //y=1.76 //x2=48.105 //y2=1.19
r241 (  36 50 ) resistor r=5.4201 //w=0.17 //l=0.085 //layer=li \
 //thickness=0.1 //x=47.895 //y=5.335 //x2=47.81 //y2=5.335
r242 (  35 44 ) resistor r=7.15173 //w=0.17 //l=0.120208 //layer=li \
 //thickness=0.1 //x=48.505 //y=5.335 //x2=48.59 //y2=5.25
r243 (  35 36 ) resistor r=41.754 //w=0.187 //l=0.61 //layer=li \
 //thickness=0.1 //x=48.505 //y=5.335 //x2=47.895 //y2=5.335
r244 (  29 50 ) resistor r=1.40859 //w=0.34 //l=0.085 //layer=li \
 //thickness=0.1 //x=47.81 //y=5.42 //x2=47.81 //y2=5.335
r245 (  29 90 ) resistor r=33.1979 //w=0.187 //l=0.485 //layer=li \
 //thickness=0.1 //x=47.81 //y=5.42 //x2=47.81 //y2=5.905
r246 (  28 49 ) resistor r=5.4201 //w=0.17 //l=0.085 //layer=li \
 //thickness=0.1 //x=47.015 //y=5.335 //x2=46.93 //y2=5.335
r247 (  27 50 ) resistor r=5.4201 //w=0.17 //l=0.085 //layer=li \
 //thickness=0.1 //x=47.725 //y=5.335 //x2=47.81 //y2=5.335
r248 (  27 28 ) resistor r=48.5989 //w=0.187 //l=0.71 //layer=li \
 //thickness=0.1 //x=47.725 //y=5.335 //x2=47.015 //y2=5.335
r249 (  21 49 ) resistor r=1.40859 //w=0.34 //l=0.085 //layer=li \
 //thickness=0.1 //x=46.93 //y=5.42 //x2=46.93 //y2=5.335
r250 (  21 89 ) resistor r=33.1979 //w=0.187 //l=0.485 //layer=li \
 //thickness=0.1 //x=46.93 //y=5.42 //x2=46.93 //y2=5.905
r251 (  19 49 ) resistor r=5.4201 //w=0.17 //l=0.085 //layer=li \
 //thickness=0.1 //x=46.845 //y=5.335 //x2=46.93 //y2=5.335
r252 (  19 20 ) resistor r=48.5989 //w=0.187 //l=0.71 //layer=li \
 //thickness=0.1 //x=46.845 //y=5.335 //x2=46.135 //y2=5.335
r253 (  13 20 ) resistor r=7.15173 //w=0.17 //l=0.120208 //layer=li \
 //thickness=0.1 //x=46.05 //y=5.42 //x2=46.135 //y2=5.335
r254 (  13 88 ) resistor r=33.1979 //w=0.187 //l=0.485 //layer=li \
 //thickness=0.1 //x=46.05 //y=5.42 //x2=46.05 //y2=5.905
r255 (  9 74 ) resistor r=152 //w=0.17 //l=0.17 //layer=licon //count=1 \
 //x=43.04 //y=2.26 //x2=43.04 //y2=2.26
r256 (  9 12 ) resistor r=136.214 //w=0.187 //l=1.99 //layer=li \
 //thickness=0.1 //x=43.04 //y=2.26 //x2=43.04 //y2=4.25
r257 (  7 48 ) resistor r=11.4737 //w=0.186 //l=0.172337 //layer=li \
 //thickness=0.1 //x=43.04 //y=4.715 //x2=43.055 //y2=4.88
r258 (  7 12 ) resistor r=31.8289 //w=0.187 //l=0.465 //layer=li \
 //thickness=0.1 //x=43.04 //y=4.715 //x2=43.04 //y2=4.25
r259 (  6 46 ) resistor r=9.3 //w=0.17 //l=0.17 //layer=mcon //count=1 \
 //x=48.59 //y=4.25 //x2=48.59 //y2=4.25
r260 (  4 12 ) resistor r=9.3 //w=0.17 //l=0.17 //layer=mcon //count=1 \
 //x=43.04 //y=4.25 //x2=43.04 //y2=4.25
r261 (  2 4 ) resistor r=0.0717383 //w=0.224 //l=0.115 //layer=m1 \
 //thickness=0.36 //x=43.155 //y=4.25 //x2=43.04 //y2=4.25
r262 (  1 6 ) resistor r=0.0717383 //w=0.224 //l=0.115 //layer=m1 \
 //thickness=0.36 //x=48.475 //y=4.25 //x2=48.59 //y2=4.25
r263 (  1 2 ) resistor r=5.07634 //w=0.131 //l=5.32 //layer=m1 \
 //thickness=0.36 //x=48.475 //y=4.25 //x2=43.155 //y2=4.25
ends PM_TMRDFFSNQNX1\%noxref_12

subckt PM_TMRDFFSNQNX1\%D ( 1 2 3 4 11 12 13 14 15 16 17 18 19 20 21 22 23 25 \
 38 49 58 59 60 61 62 63 64 65 66 67 68 69 70 74 76 79 80 84 85 86 87 91 93 96 \
 97 101 102 103 104 108 110 113 114 124 133 142 )
c323 ( 142 0 ) capacitor c=0.0588816f //x=50.44 //y=4.88
c324 ( 133 0 ) capacitor c=0.0588816f //x=26.02 //y=4.88
c325 ( 124 0 ) capacitor c=0.0667949f //x=1.6 //y=4.88
c326 ( 114 0 ) capacitor c=0.0318948f //x=50.775 //y=1.39
c327 ( 113 0 ) capacitor c=0.0187384f //x=50.775 //y=1.045
c328 ( 110 0 ) capacitor c=0.0141798f //x=50.62 //y=1.545
c329 ( 108 0 ) capacitor c=0.0149844f //x=50.62 //y=0.89
c330 ( 104 0 ) capacitor c=0.0813322f //x=50.245 //y=2.095
c331 ( 103 0 ) capacitor c=0.0229267f //x=50.245 //y=1.7
c332 ( 102 0 ) capacitor c=0.0234352f //x=50.245 //y=1.39
c333 ( 101 0 ) capacitor c=0.0199343f //x=50.245 //y=1.045
c334 ( 97 0 ) capacitor c=0.0318948f //x=26.355 //y=1.39
c335 ( 96 0 ) capacitor c=0.0187384f //x=26.355 //y=1.045
c336 ( 93 0 ) capacitor c=0.0141798f //x=26.2 //y=1.545
c337 ( 91 0 ) capacitor c=0.0149844f //x=26.2 //y=0.89
c338 ( 87 0 ) capacitor c=0.0813322f //x=25.825 //y=2.095
c339 ( 86 0 ) capacitor c=0.0229267f //x=25.825 //y=1.7
c340 ( 85 0 ) capacitor c=0.0234352f //x=25.825 //y=1.39
c341 ( 84 0 ) capacitor c=0.0199343f //x=25.825 //y=1.045
c342 ( 80 0 ) capacitor c=0.0318948f //x=1.935 //y=1.39
c343 ( 79 0 ) capacitor c=0.0187384f //x=1.935 //y=1.045
c344 ( 76 0 ) capacitor c=0.0141798f //x=1.78 //y=1.545
c345 ( 74 0 ) capacitor c=0.0149844f //x=1.78 //y=0.89
c346 ( 70 0 ) capacitor c=0.0844059f //x=1.405 //y=2.095
c347 ( 69 0 ) capacitor c=0.0229722f //x=1.405 //y=1.7
c348 ( 68 0 ) capacitor c=0.0234352f //x=1.405 //y=1.39
c349 ( 67 0 ) capacitor c=0.0199343f //x=1.405 //y=1.045
c350 ( 66 0 ) capacitor c=0.110275f //x=50.78 //y=6.2
c351 ( 65 0 ) capacitor c=0.154305f //x=50.34 //y=6.2
c352 ( 64 0 ) capacitor c=0.110275f //x=26.36 //y=6.2
c353 ( 63 0 ) capacitor c=0.154305f //x=25.92 //y=6.2
c354 ( 62 0 ) capacitor c=0.110275f //x=1.94 //y=6.2
c355 ( 61 0 ) capacitor c=0.154305f //x=1.5 //y=6.2
c356 ( 49 0 ) capacitor c=0.0877439f //x=50.44 //y=2.26
c357 ( 38 0 ) capacitor c=0.0899325f //x=26.02 //y=2.26
c358 ( 25 0 ) capacitor c=0.111725f //x=1.6 //y=2.26
c359 ( 4 0 ) capacitor c=0.00583987f //x=26.135 //y=3.14
c360 ( 3 0 ) capacitor c=0.366619f //x=50.325 //y=3.14
c361 ( 2 0 ) capacitor c=0.0150814f //x=1.715 //y=3.14
c362 ( 1 0 ) capacitor c=0.47261f //x=25.905 //y=3.14
r363 (  140 142 ) resistor r=20.6867 //w=0.233 //l=0.1 //layer=ply \
 //thickness=0.18 //x=50.34 //y=4.88 //x2=50.44 //y2=4.88
r364 (  131 133 ) resistor r=20.6867 //w=0.233 //l=0.1 //layer=ply \
 //thickness=0.18 //x=25.92 //y=4.88 //x2=26.02 //y2=4.88
r365 (  122 124 ) resistor r=20.6867 //w=0.233 //l=0.1 //layer=ply \
 //thickness=0.18 //x=1.5 //y=4.88 //x2=1.6 //y2=4.88
r366 (  115 142 ) resistor r=70.3348 //w=0.233 //l=0.414367 //layer=ply \
 //thickness=0.18 //x=50.78 //y=5.045 //x2=50.44 //y2=4.88
r367 (  114 144 ) resistor r=45.1352 //w=0.168 //l=0.173853 //layer=ply \
 //thickness=0.18 //x=50.775 //y=1.39 //x2=50.735 //y2=1.545
r368 (  113 143 ) resistor r=45.1352 //w=0.168 //l=0.173853 //layer=ply \
 //thickness=0.18 //x=50.775 //y=1.045 //x2=50.735 //y2=0.89
r369 (  113 114 ) resistor r=176.904 //w=0.094 //l=0.345 //layer=ply \
 //thickness=0.18 //x=50.775 //y=1.045 //x2=50.775 //y2=1.39
r370 (  111 139 ) resistor r=10.701 //w=0.21 //l=0.115 //layer=ply \
 //thickness=0.18 //x=50.4 //y=1.545 //x2=50.285 //y2=1.545
r371 (  110 144 ) resistor r=5.52526 //w=0.168 //l=0.115 //layer=ply \
 //thickness=0.18 //x=50.62 //y=1.545 //x2=50.735 //y2=1.545
r372 (  109 138 ) resistor r=5.52526 //w=0.168 //l=0.115 //layer=ply \
 //thickness=0.18 //x=50.4 //y=0.89 //x2=50.285 //y2=0.89
r373 (  108 143 ) resistor r=5.52526 //w=0.168 //l=0.115 //layer=ply \
 //thickness=0.18 //x=50.62 //y=0.89 //x2=50.735 //y2=0.89
r374 (  108 109 ) resistor r=112.809 //w=0.094 //l=0.22 //layer=ply \
 //thickness=0.18 //x=50.62 //y=0.89 //x2=50.4 //y2=0.89
r375 (  105 140 ) resistor r=13.0941 //w=0.233 //l=0.165 //layer=ply \
 //thickness=0.18 //x=50.34 //y=5.045 //x2=50.34 //y2=4.88
r376 (  104 137 ) resistor r=34.8111 //w=0.27 //l=0.264953 //layer=ply \
 //thickness=0.18 //x=50.245 //y=2.095 //x2=50.44 //y2=2.26
r377 (  103 139 ) resistor r=39.5823 //w=0.21 //l=0.173853 //layer=ply \
 //thickness=0.18 //x=50.245 //y=1.7 //x2=50.285 //y2=1.545
r378 (  103 104 ) resistor r=202.543 //w=0.094 //l=0.395 //layer=ply \
 //thickness=0.18 //x=50.245 //y=1.7 //x2=50.245 //y2=2.095
r379 (  102 139 ) resistor r=39.5823 //w=0.21 //l=0.173853 //layer=ply \
 //thickness=0.18 //x=50.245 //y=1.39 //x2=50.285 //y2=1.545
r380 (  101 138 ) resistor r=45.1352 //w=0.168 //l=0.173853 //layer=ply \
 //thickness=0.18 //x=50.245 //y=1.045 //x2=50.285 //y2=0.89
r381 (  101 102 ) resistor r=176.904 //w=0.094 //l=0.345 //layer=ply \
 //thickness=0.18 //x=50.245 //y=1.045 //x2=50.245 //y2=1.39
r382 (  98 133 ) resistor r=70.3348 //w=0.233 //l=0.414367 //layer=ply \
 //thickness=0.18 //x=26.36 //y=5.045 //x2=26.02 //y2=4.88
r383 (  97 135 ) resistor r=45.1352 //w=0.168 //l=0.173853 //layer=ply \
 //thickness=0.18 //x=26.355 //y=1.39 //x2=26.315 //y2=1.545
r384 (  96 134 ) resistor r=45.1352 //w=0.168 //l=0.173853 //layer=ply \
 //thickness=0.18 //x=26.355 //y=1.045 //x2=26.315 //y2=0.89
r385 (  96 97 ) resistor r=176.904 //w=0.094 //l=0.345 //layer=ply \
 //thickness=0.18 //x=26.355 //y=1.045 //x2=26.355 //y2=1.39
r386 (  94 130 ) resistor r=10.701 //w=0.21 //l=0.115 //layer=ply \
 //thickness=0.18 //x=25.98 //y=1.545 //x2=25.865 //y2=1.545
r387 (  93 135 ) resistor r=5.52526 //w=0.168 //l=0.115 //layer=ply \
 //thickness=0.18 //x=26.2 //y=1.545 //x2=26.315 //y2=1.545
r388 (  92 129 ) resistor r=5.52526 //w=0.168 //l=0.115 //layer=ply \
 //thickness=0.18 //x=25.98 //y=0.89 //x2=25.865 //y2=0.89
r389 (  91 134 ) resistor r=5.52526 //w=0.168 //l=0.115 //layer=ply \
 //thickness=0.18 //x=26.2 //y=0.89 //x2=26.315 //y2=0.89
r390 (  91 92 ) resistor r=112.809 //w=0.094 //l=0.22 //layer=ply \
 //thickness=0.18 //x=26.2 //y=0.89 //x2=25.98 //y2=0.89
r391 (  88 131 ) resistor r=13.0941 //w=0.233 //l=0.165 //layer=ply \
 //thickness=0.18 //x=25.92 //y=5.045 //x2=25.92 //y2=4.88
r392 (  87 128 ) resistor r=34.8111 //w=0.27 //l=0.264953 //layer=ply \
 //thickness=0.18 //x=25.825 //y=2.095 //x2=26.02 //y2=2.26
r393 (  86 130 ) resistor r=39.5823 //w=0.21 //l=0.173853 //layer=ply \
 //thickness=0.18 //x=25.825 //y=1.7 //x2=25.865 //y2=1.545
r394 (  86 87 ) resistor r=202.543 //w=0.094 //l=0.395 //layer=ply \
 //thickness=0.18 //x=25.825 //y=1.7 //x2=25.825 //y2=2.095
r395 (  85 130 ) resistor r=39.5823 //w=0.21 //l=0.173853 //layer=ply \
 //thickness=0.18 //x=25.825 //y=1.39 //x2=25.865 //y2=1.545
r396 (  84 129 ) resistor r=45.1352 //w=0.168 //l=0.173853 //layer=ply \
 //thickness=0.18 //x=25.825 //y=1.045 //x2=25.865 //y2=0.89
r397 (  84 85 ) resistor r=176.904 //w=0.094 //l=0.345 //layer=ply \
 //thickness=0.18 //x=25.825 //y=1.045 //x2=25.825 //y2=1.39
r398 (  81 124 ) resistor r=70.3348 //w=0.233 //l=0.414367 //layer=ply \
 //thickness=0.18 //x=1.94 //y=5.045 //x2=1.6 //y2=4.88
r399 (  80 126 ) resistor r=45.1352 //w=0.168 //l=0.173853 //layer=ply \
 //thickness=0.18 //x=1.935 //y=1.39 //x2=1.895 //y2=1.545
r400 (  79 125 ) resistor r=45.1352 //w=0.168 //l=0.173853 //layer=ply \
 //thickness=0.18 //x=1.935 //y=1.045 //x2=1.895 //y2=0.89
r401 (  79 80 ) resistor r=176.904 //w=0.094 //l=0.345 //layer=ply \
 //thickness=0.18 //x=1.935 //y=1.045 //x2=1.935 //y2=1.39
r402 (  77 121 ) resistor r=10.701 //w=0.21 //l=0.115 //layer=ply \
 //thickness=0.18 //x=1.56 //y=1.545 //x2=1.445 //y2=1.545
r403 (  76 126 ) resistor r=5.52526 //w=0.168 //l=0.115 //layer=ply \
 //thickness=0.18 //x=1.78 //y=1.545 //x2=1.895 //y2=1.545
r404 (  75 120 ) resistor r=5.52526 //w=0.168 //l=0.115 //layer=ply \
 //thickness=0.18 //x=1.56 //y=0.89 //x2=1.445 //y2=0.89
r405 (  74 125 ) resistor r=5.52526 //w=0.168 //l=0.115 //layer=ply \
 //thickness=0.18 //x=1.78 //y=0.89 //x2=1.895 //y2=0.89
r406 (  74 75 ) resistor r=112.809 //w=0.094 //l=0.22 //layer=ply \
 //thickness=0.18 //x=1.78 //y=0.89 //x2=1.56 //y2=0.89
r407 (  71 122 ) resistor r=13.0941 //w=0.233 //l=0.165 //layer=ply \
 //thickness=0.18 //x=1.5 //y=5.045 //x2=1.5 //y2=4.88
r408 (  70 119 ) resistor r=34.8111 //w=0.27 //l=0.264953 //layer=ply \
 //thickness=0.18 //x=1.405 //y=2.095 //x2=1.6 //y2=2.26
r409 (  69 121 ) resistor r=39.5823 //w=0.21 //l=0.173853 //layer=ply \
 //thickness=0.18 //x=1.405 //y=1.7 //x2=1.445 //y2=1.545
r410 (  69 70 ) resistor r=202.543 //w=0.094 //l=0.395 //layer=ply \
 //thickness=0.18 //x=1.405 //y=1.7 //x2=1.405 //y2=2.095
r411 (  68 121 ) resistor r=39.5823 //w=0.21 //l=0.173853 //layer=ply \
 //thickness=0.18 //x=1.405 //y=1.39 //x2=1.445 //y2=1.545
r412 (  67 120 ) resistor r=45.1352 //w=0.168 //l=0.173853 //layer=ply \
 //thickness=0.18 //x=1.405 //y=1.045 //x2=1.445 //y2=0.89
r413 (  67 68 ) resistor r=176.904 //w=0.094 //l=0.345 //layer=ply \
 //thickness=0.18 //x=1.405 //y=1.045 //x2=1.405 //y2=1.39
r414 (  66 115 ) resistor r=592.245 //w=0.094 //l=1.155 //layer=ply \
 //thickness=0.18 //x=50.78 //y=6.2 //x2=50.78 //y2=5.045
r415 (  65 105 ) resistor r=592.245 //w=0.094 //l=1.155 //layer=ply \
 //thickness=0.18 //x=50.34 //y=6.2 //x2=50.34 //y2=5.045
r416 (  64 98 ) resistor r=592.245 //w=0.094 //l=1.155 //layer=ply \
 //thickness=0.18 //x=26.36 //y=6.2 //x2=26.36 //y2=5.045
r417 (  63 88 ) resistor r=592.245 //w=0.094 //l=1.155 //layer=ply \
 //thickness=0.18 //x=25.92 //y=6.2 //x2=25.92 //y2=5.045
r418 (  62 81 ) resistor r=592.245 //w=0.094 //l=1.155 //layer=ply \
 //thickness=0.18 //x=1.94 //y=6.2 //x2=1.94 //y2=5.045
r419 (  61 71 ) resistor r=592.245 //w=0.094 //l=1.155 //layer=ply \
 //thickness=0.18 //x=1.5 //y=6.2 //x2=1.5 //y2=5.045
r420 (  60 110 ) resistor r=56.4043 //w=0.094 //l=0.11 //layer=ply \
 //thickness=0.18 //x=50.51 //y=1.545 //x2=50.62 //y2=1.545
r421 (  60 111 ) resistor r=56.4043 //w=0.094 //l=0.11 //layer=ply \
 //thickness=0.18 //x=50.51 //y=1.545 //x2=50.4 //y2=1.545
r422 (  59 93 ) resistor r=56.4043 //w=0.094 //l=0.11 //layer=ply \
 //thickness=0.18 //x=26.09 //y=1.545 //x2=26.2 //y2=1.545
r423 (  59 94 ) resistor r=56.4043 //w=0.094 //l=0.11 //layer=ply \
 //thickness=0.18 //x=26.09 //y=1.545 //x2=25.98 //y2=1.545
r424 (  58 76 ) resistor r=56.4043 //w=0.094 //l=0.11 //layer=ply \
 //thickness=0.18 //x=1.67 //y=1.545 //x2=1.78 //y2=1.545
r425 (  58 77 ) resistor r=56.4043 //w=0.094 //l=0.11 //layer=ply \
 //thickness=0.18 //x=1.67 //y=1.545 //x2=1.56 //y2=1.545
r426 (  56 142 ) resistor r=152 //w=0.17 //l=0.17 //layer=licon //count=1 \
 //x=50.44 //y=4.88 //x2=50.44 //y2=4.88
r427 (  49 137 ) resistor r=152 //w=0.17 //l=0.17 //layer=licon //count=1 \
 //x=50.44 //y=2.26 //x2=50.44 //y2=2.26
r428 (  46 133 ) resistor r=152 //w=0.17 //l=0.17 //layer=licon //count=1 \
 //x=26.02 //y=4.88 //x2=26.02 //y2=4.88
r429 (  38 128 ) resistor r=152 //w=0.17 //l=0.17 //layer=licon //count=1 \
 //x=26.02 //y=2.26 //x2=26.02 //y2=2.26
r430 (  35 124 ) resistor r=152 //w=0.17 //l=0.17 //layer=licon //count=1 \
 //x=1.6 //y=4.88 //x2=1.6 //y2=4.88
r431 (  25 119 ) resistor r=152 //w=0.17 //l=0.17 //layer=licon //count=1 \
 //x=1.6 //y=2.26 //x2=1.6 //y2=2.26
r432 (  23 56 ) resistor r=43.123 //w=0.187 //l=0.63 //layer=li \
 //thickness=0.1 //x=50.44 //y=4.25 //x2=50.44 //y2=4.88
r433 (  22 23 ) resistor r=25.3262 //w=0.187 //l=0.37 //layer=li \
 //thickness=0.1 //x=50.44 //y=3.88 //x2=50.44 //y2=4.25
r434 (  21 22 ) resistor r=50.6524 //w=0.187 //l=0.74 //layer=li \
 //thickness=0.1 //x=50.44 //y=3.14 //x2=50.44 //y2=3.88
r435 (  21 49 ) resistor r=60.2353 //w=0.187 //l=0.88 //layer=li \
 //thickness=0.1 //x=50.44 //y=3.14 //x2=50.44 //y2=2.26
r436 (  20 46 ) resistor r=43.123 //w=0.187 //l=0.63 //layer=li \
 //thickness=0.1 //x=26.02 //y=4.25 //x2=26.02 //y2=4.88
r437 (  19 20 ) resistor r=25.3262 //w=0.187 //l=0.37 //layer=li \
 //thickness=0.1 //x=26.02 //y=3.88 //x2=26.02 //y2=4.25
r438 (  18 19 ) resistor r=50.6524 //w=0.187 //l=0.74 //layer=li \
 //thickness=0.1 //x=26.02 //y=3.14 //x2=26.02 //y2=3.88
r439 (  17 18 ) resistor r=25.3262 //w=0.187 //l=0.37 //layer=li \
 //thickness=0.1 //x=26.02 //y=2.77 //x2=26.02 //y2=3.14
r440 (  17 38 ) resistor r=34.9091 //w=0.187 //l=0.51 //layer=li \
 //thickness=0.1 //x=26.02 //y=2.77 //x2=26.02 //y2=2.26
r441 (  16 35 ) resistor r=17.7968 //w=0.187 //l=0.26 //layer=li \
 //thickness=0.1 //x=1.6 //y=4.62 //x2=1.6 //y2=4.88
r442 (  15 16 ) resistor r=25.3262 //w=0.187 //l=0.37 //layer=li \
 //thickness=0.1 //x=1.6 //y=4.25 //x2=1.6 //y2=4.62
r443 (  14 15 ) resistor r=25.3262 //w=0.187 //l=0.37 //layer=li \
 //thickness=0.1 //x=1.6 //y=3.88 //x2=1.6 //y2=4.25
r444 (  13 14 ) resistor r=25.3262 //w=0.187 //l=0.37 //layer=li \
 //thickness=0.1 //x=1.6 //y=3.51 //x2=1.6 //y2=3.88
r445 (  12 13 ) resistor r=25.3262 //w=0.187 //l=0.37 //layer=li \
 //thickness=0.1 //x=1.6 //y=3.14 //x2=1.6 //y2=3.51
r446 (  11 12 ) resistor r=25.3262 //w=0.187 //l=0.37 //layer=li \
 //thickness=0.1 //x=1.6 //y=2.77 //x2=1.6 //y2=3.14
r447 (  11 25 ) resistor r=34.9091 //w=0.187 //l=0.51 //layer=li \
 //thickness=0.1 //x=1.6 //y=2.77 //x2=1.6 //y2=2.26
r448 (  10 21 ) resistor r=9.3 //w=0.17 //l=0.17 //layer=mcon //count=1 \
 //x=50.44 //y=3.14 //x2=50.44 //y2=3.14
r449 (  8 18 ) resistor r=9.3 //w=0.17 //l=0.17 //layer=mcon //count=1 \
 //x=26.02 //y=3.14 //x2=26.02 //y2=3.14
r450 (  6 12 ) resistor r=9.3 //w=0.17 //l=0.17 //layer=mcon //count=1 //x=1.6 \
 //y=3.14 //x2=1.6 //y2=3.14
r451 (  4 8 ) resistor r=0.0880901 //w=0.191 //l=0.115 //layer=m1 \
 //thickness=0.36 //x=26.135 //y=3.14 //x2=26.02 //y2=3.14
r452 (  3 10 ) resistor r=0.0717383 //w=0.224 //l=0.115 //layer=m1 \
 //thickness=0.36 //x=50.325 //y=3.14 //x2=50.44 //y2=3.14
r453 (  3 4 ) resistor r=23.0821 //w=0.131 //l=24.19 //layer=m1 \
 //thickness=0.36 //x=50.325 //y=3.14 //x2=26.135 //y2=3.14
r454 (  2 6 ) resistor r=0.0717383 //w=0.224 //l=0.115 //layer=m1 \
 //thickness=0.36 //x=1.715 //y=3.14 //x2=1.6 //y2=3.14
r455 (  1 8 ) resistor r=0.0880901 //w=0.191 //l=0.115 //layer=m1 \
 //thickness=0.36 //x=25.905 //y=3.14 //x2=26.02 //y2=3.14
r456 (  1 2 ) resistor r=23.0821 //w=0.131 //l=24.19 //layer=m1 \
 //thickness=0.36 //x=25.905 //y=3.14 //x2=1.715 //y2=3.14
ends PM_TMRDFFSNQNX1\%D

subckt PM_TMRDFFSNQNX1\%noxref_14 ( 1 2 3 4 17 18 29 31 32 36 38 46 53 54 55 \
 56 57 58 59 60 61 62 63 64 66 72 73 74 75 79 80 81 82 83 85 91 92 93 94 114 \
 116 117 )
c236 ( 117 0 ) capacitor c=0.0220291f //x=51.295 //y=5.2
c237 ( 116 0 ) capacitor c=0.0217503f //x=50.415 //y=5.2
c238 ( 114 0 ) capacitor c=0.0084702f //x=51.29 //y=1.085
c239 ( 94 0 ) capacitor c=0.0556143f //x=58.855 //y=4.97
c240 ( 93 0 ) capacitor c=0.0293157f //x=59.145 //y=4.97
c241 ( 92 0 ) capacitor c=0.0347816f //x=58.81 //y=1.4
c242 ( 91 0 ) capacitor c=0.0187487f //x=58.81 //y=1.055
c243 ( 85 0 ) capacitor c=0.0137055f //x=58.655 //y=1.555
c244 ( 83 0 ) capacitor c=0.0149861f //x=58.655 //y=0.9
c245 ( 82 0 ) capacitor c=0.096037f //x=58.28 //y=2.095
c246 ( 81 0 ) capacitor c=0.0228993f //x=58.28 //y=1.71
c247 ( 80 0 ) capacitor c=0.0234352f //x=58.28 //y=1.4
c248 ( 79 0 ) capacitor c=0.0198724f //x=58.28 //y=1.055
c249 ( 75 0 ) capacitor c=0.0557698f //x=54.045 //y=4.97
c250 ( 74 0 ) capacitor c=0.0293157f //x=54.335 //y=4.97
c251 ( 73 0 ) capacitor c=0.0347816f //x=54 //y=1.4
c252 ( 72 0 ) capacitor c=0.0187487f //x=54 //y=1.055
c253 ( 66 0 ) capacitor c=0.0137055f //x=53.845 //y=1.555
c254 ( 64 0 ) capacitor c=0.0149861f //x=53.845 //y=0.9
c255 ( 63 0 ) capacitor c=0.096037f //x=53.47 //y=2.095
c256 ( 62 0 ) capacitor c=0.0228993f //x=53.47 //y=1.71
c257 ( 61 0 ) capacitor c=0.0234352f //x=53.47 //y=1.4
c258 ( 60 0 ) capacitor c=0.0198724f //x=53.47 //y=1.055
c259 ( 59 0 ) capacitor c=0.110114f //x=59.22 //y=6.2
c260 ( 58 0 ) capacitor c=0.158956f //x=58.78 //y=6.2
c261 ( 57 0 ) capacitor c=0.110114f //x=54.41 //y=6.2
c262 ( 56 0 ) capacitor c=0.158956f //x=53.97 //y=6.2
c263 ( 53 0 ) capacitor c=0.00211606f //x=51.44 //y=5.38
c264 ( 46 0 ) capacitor c=0.0943831f //x=58.58 //y=2.26
c265 ( 38 0 ) capacitor c=0.0969368f //x=53.77 //y=2.26
c266 ( 36 0 ) capacitor c=0.104691f //x=51.92 //y=2.77
c267 ( 32 0 ) capacitor c=0.00404073f //x=51.565 //y=1.835
c268 ( 31 0 ) capacitor c=0.0122201f //x=51.835 //y=1.835
c269 ( 29 0 ) capacitor c=0.0137995f //x=51.835 //y=5.38
c270 ( 18 0 ) capacitor c=0.00251635f //x=50.645 //y=5.38
c271 ( 17 0 ) capacitor c=0.0143649f //x=51.355 //y=5.38
c272 ( 4 0 ) capacitor c=0.00673266f //x=54.035 //y=2.77
c273 ( 3 0 ) capacitor c=0.0686809f //x=58.465 //y=2.77
c274 ( 2 0 ) capacitor c=0.00544459f //x=52.035 //y=2.77
c275 ( 1 0 ) capacitor c=0.0230071f //x=53.625 //y=2.77
r276 (  93 95 ) resistor r=26.9307 //w=0.15 //l=0.106066 //layer=ply \
 //thickness=0.18 //x=59.145 //y=4.97 //x2=59.22 //y2=5.045
r277 (  93 94 ) resistor r=148.702 //w=0.094 //l=0.29 //layer=ply \
 //thickness=0.18 //x=59.145 //y=4.97 //x2=58.855 //y2=4.97
r278 (  92 113 ) resistor r=45.1352 //w=0.168 //l=0.173853 //layer=ply \
 //thickness=0.18 //x=58.81 //y=1.4 //x2=58.77 //y2=1.555
r279 (  91 112 ) resistor r=45.1352 //w=0.168 //l=0.173853 //layer=ply \
 //thickness=0.18 //x=58.81 //y=1.055 //x2=58.77 //y2=0.9
r280 (  91 92 ) resistor r=176.904 //w=0.094 //l=0.345 //layer=ply \
 //thickness=0.18 //x=58.81 //y=1.055 //x2=58.81 //y2=1.4
r281 (  88 94 ) resistor r=22.7971 //w=0.269 //l=0.106066 //layer=ply \
 //thickness=0.18 //x=58.78 //y=5.045 //x2=58.855 //y2=4.97
r282 (  88 111 ) resistor r=35.8364 //w=0.269 //l=0.270185 //layer=ply \
 //thickness=0.18 //x=58.78 //y=5.045 //x2=58.58 //y2=4.88
r283 (  86 107 ) resistor r=10.701 //w=0.21 //l=0.115 //layer=ply \
 //thickness=0.18 //x=58.435 //y=1.555 //x2=58.32 //y2=1.555
r284 (  85 113 ) resistor r=5.52526 //w=0.168 //l=0.115 //layer=ply \
 //thickness=0.18 //x=58.655 //y=1.555 //x2=58.77 //y2=1.555
r285 (  84 106 ) resistor r=5.52526 //w=0.168 //l=0.115 //layer=ply \
 //thickness=0.18 //x=58.435 //y=0.9 //x2=58.32 //y2=0.9
r286 (  83 112 ) resistor r=5.52526 //w=0.168 //l=0.115 //layer=ply \
 //thickness=0.18 //x=58.655 //y=0.9 //x2=58.77 //y2=0.9
r287 (  83 84 ) resistor r=112.809 //w=0.094 //l=0.22 //layer=ply \
 //thickness=0.18 //x=58.655 //y=0.9 //x2=58.435 //y2=0.9
r288 (  82 109 ) resistor r=58.7805 //w=0.246 //l=0.373497 //layer=ply \
 //thickness=0.18 //x=58.28 //y=2.095 //x2=58.58 //y2=2.26
r289 (  81 107 ) resistor r=39.5823 //w=0.21 //l=0.173853 //layer=ply \
 //thickness=0.18 //x=58.28 //y=1.71 //x2=58.32 //y2=1.555
r290 (  81 82 ) resistor r=197.415 //w=0.094 //l=0.385 //layer=ply \
 //thickness=0.18 //x=58.28 //y=1.71 //x2=58.28 //y2=2.095
r291 (  80 107 ) resistor r=39.5823 //w=0.21 //l=0.173853 //layer=ply \
 //thickness=0.18 //x=58.28 //y=1.4 //x2=58.32 //y2=1.555
r292 (  79 106 ) resistor r=45.1352 //w=0.168 //l=0.173853 //layer=ply \
 //thickness=0.18 //x=58.28 //y=1.055 //x2=58.32 //y2=0.9
r293 (  79 80 ) resistor r=176.904 //w=0.094 //l=0.345 //layer=ply \
 //thickness=0.18 //x=58.28 //y=1.055 //x2=58.28 //y2=1.4
r294 (  74 76 ) resistor r=26.9307 //w=0.15 //l=0.106066 //layer=ply \
 //thickness=0.18 //x=54.335 //y=4.97 //x2=54.41 //y2=5.045
r295 (  74 75 ) resistor r=148.702 //w=0.094 //l=0.29 //layer=ply \
 //thickness=0.18 //x=54.335 //y=4.97 //x2=54.045 //y2=4.97
r296 (  73 105 ) resistor r=45.1352 //w=0.168 //l=0.173853 //layer=ply \
 //thickness=0.18 //x=54 //y=1.4 //x2=53.96 //y2=1.555
r297 (  72 104 ) resistor r=45.1352 //w=0.168 //l=0.173853 //layer=ply \
 //thickness=0.18 //x=54 //y=1.055 //x2=53.96 //y2=0.9
r298 (  72 73 ) resistor r=176.904 //w=0.094 //l=0.345 //layer=ply \
 //thickness=0.18 //x=54 //y=1.055 //x2=54 //y2=1.4
r299 (  69 75 ) resistor r=22.7971 //w=0.269 //l=0.106066 //layer=ply \
 //thickness=0.18 //x=53.97 //y=5.045 //x2=54.045 //y2=4.97
r300 (  69 103 ) resistor r=35.8364 //w=0.269 //l=0.270185 //layer=ply \
 //thickness=0.18 //x=53.97 //y=5.045 //x2=53.77 //y2=4.88
r301 (  67 99 ) resistor r=10.701 //w=0.21 //l=0.115 //layer=ply \
 //thickness=0.18 //x=53.625 //y=1.555 //x2=53.51 //y2=1.555
r302 (  66 105 ) resistor r=5.52526 //w=0.168 //l=0.115 //layer=ply \
 //thickness=0.18 //x=53.845 //y=1.555 //x2=53.96 //y2=1.555
r303 (  65 98 ) resistor r=5.52526 //w=0.168 //l=0.115 //layer=ply \
 //thickness=0.18 //x=53.625 //y=0.9 //x2=53.51 //y2=0.9
r304 (  64 104 ) resistor r=5.52526 //w=0.168 //l=0.115 //layer=ply \
 //thickness=0.18 //x=53.845 //y=0.9 //x2=53.96 //y2=0.9
r305 (  64 65 ) resistor r=112.809 //w=0.094 //l=0.22 //layer=ply \
 //thickness=0.18 //x=53.845 //y=0.9 //x2=53.625 //y2=0.9
r306 (  63 101 ) resistor r=58.7805 //w=0.246 //l=0.373497 //layer=ply \
 //thickness=0.18 //x=53.47 //y=2.095 //x2=53.77 //y2=2.26
r307 (  62 99 ) resistor r=39.5823 //w=0.21 //l=0.173853 //layer=ply \
 //thickness=0.18 //x=53.47 //y=1.71 //x2=53.51 //y2=1.555
r308 (  62 63 ) resistor r=197.415 //w=0.094 //l=0.385 //layer=ply \
 //thickness=0.18 //x=53.47 //y=1.71 //x2=53.47 //y2=2.095
r309 (  61 99 ) resistor r=39.5823 //w=0.21 //l=0.173853 //layer=ply \
 //thickness=0.18 //x=53.47 //y=1.4 //x2=53.51 //y2=1.555
r310 (  60 98 ) resistor r=45.1352 //w=0.168 //l=0.173853 //layer=ply \
 //thickness=0.18 //x=53.47 //y=1.055 //x2=53.51 //y2=0.9
r311 (  60 61 ) resistor r=176.904 //w=0.094 //l=0.345 //layer=ply \
 //thickness=0.18 //x=53.47 //y=1.055 //x2=53.47 //y2=1.4
r312 (  59 95 ) resistor r=592.245 //w=0.094 //l=1.155 //layer=ply \
 //thickness=0.18 //x=59.22 //y=6.2 //x2=59.22 //y2=5.045
r313 (  58 88 ) resistor r=592.245 //w=0.094 //l=1.155 //layer=ply \
 //thickness=0.18 //x=58.78 //y=6.2 //x2=58.78 //y2=5.045
r314 (  57 76 ) resistor r=592.245 //w=0.094 //l=1.155 //layer=ply \
 //thickness=0.18 //x=54.41 //y=6.2 //x2=54.41 //y2=5.045
r315 (  56 69 ) resistor r=592.245 //w=0.094 //l=1.155 //layer=ply \
 //thickness=0.18 //x=53.97 //y=6.2 //x2=53.97 //y2=5.045
r316 (  55 85 ) resistor r=56.4043 //w=0.094 //l=0.11 //layer=ply \
 //thickness=0.18 //x=58.545 //y=1.555 //x2=58.655 //y2=1.555
r317 (  55 86 ) resistor r=56.4043 //w=0.094 //l=0.11 //layer=ply \
 //thickness=0.18 //x=58.545 //y=1.555 //x2=58.435 //y2=1.555
r318 (  54 66 ) resistor r=56.4043 //w=0.094 //l=0.11 //layer=ply \
 //thickness=0.18 //x=53.735 //y=1.555 //x2=53.845 //y2=1.555
r319 (  54 67 ) resistor r=56.4043 //w=0.094 //l=0.11 //layer=ply \
 //thickness=0.18 //x=53.735 //y=1.555 //x2=53.625 //y2=1.555
r320 (  51 111 ) resistor r=152 //w=0.17 //l=0.17 //layer=licon //count=1 \
 //x=58.58 //y=4.88 //x2=58.58 //y2=4.88
r321 (  49 51 ) resistor r=144.428 //w=0.187 //l=2.11 //layer=li \
 //thickness=0.1 //x=58.58 //y=2.77 //x2=58.58 //y2=4.88
r322 (  46 109 ) resistor r=152 //w=0.17 //l=0.17 //layer=licon //count=1 \
 //x=58.58 //y=2.26 //x2=58.58 //y2=2.26
r323 (  46 49 ) resistor r=34.9091 //w=0.187 //l=0.51 //layer=li \
 //thickness=0.1 //x=58.58 //y=2.26 //x2=58.58 //y2=2.77
r324 (  43 103 ) resistor r=152 //w=0.17 //l=0.17 //layer=licon //count=1 \
 //x=53.77 //y=4.88 //x2=53.77 //y2=4.88
r325 (  41 43 ) resistor r=144.77 //w=0.187 //l=2.115 //layer=li \
 //thickness=0.1 //x=53.77 //y=2.765 //x2=53.77 //y2=4.88
r326 (  38 101 ) resistor r=152 //w=0.17 //l=0.17 //layer=licon //count=1 \
 //x=53.77 //y=2.26 //x2=53.77 //y2=2.26
r327 (  38 41 ) resistor r=34.5668 //w=0.187 //l=0.505 //layer=li \
 //thickness=0.1 //x=53.77 //y=2.26 //x2=53.77 //y2=2.765
r328 (  34 36 ) resistor r=172.834 //w=0.187 //l=2.525 //layer=li \
 //thickness=0.1 //x=51.92 //y=5.295 //x2=51.92 //y2=2.77
r329 (  33 36 ) resistor r=58.1818 //w=0.187 //l=0.85 //layer=li \
 //thickness=0.1 //x=51.92 //y=1.92 //x2=51.92 //y2=2.77
r330 (  31 33 ) resistor r=7.15173 //w=0.17 //l=0.120208 //layer=li \
 //thickness=0.1 //x=51.835 //y=1.835 //x2=51.92 //y2=1.92
r331 (  31 32 ) resistor r=18.4813 //w=0.187 //l=0.27 //layer=li \
 //thickness=0.1 //x=51.835 //y=1.835 //x2=51.565 //y2=1.835
r332 (  30 53 ) resistor r=5.4201 //w=0.17 //l=0.085 //layer=li \
 //thickness=0.1 //x=51.525 //y=5.38 //x2=51.44 //y2=5.38
r333 (  29 34 ) resistor r=7.15173 //w=0.17 //l=0.120208 //layer=li \
 //thickness=0.1 //x=51.835 //y=5.38 //x2=51.92 //y2=5.295
r334 (  29 30 ) resistor r=21.2193 //w=0.187 //l=0.31 //layer=li \
 //thickness=0.1 //x=51.835 //y=5.38 //x2=51.525 //y2=5.38
r335 (  25 32 ) resistor r=7.15173 //w=0.17 //l=0.120208 //layer=li \
 //thickness=0.1 //x=51.48 //y=1.75 //x2=51.565 //y2=1.835
r336 (  25 114 ) resistor r=39.016 //w=0.187 //l=0.57 //layer=li \
 //thickness=0.1 //x=51.48 //y=1.75 //x2=51.48 //y2=1.18
r337 (  19 53 ) resistor r=1.40859 //w=0.34 //l=0.085 //layer=li \
 //thickness=0.1 //x=51.44 //y=5.465 //x2=51.44 //y2=5.38
r338 (  19 117 ) resistor r=30.1176 //w=0.187 //l=0.44 //layer=li \
 //thickness=0.1 //x=51.44 //y=5.465 //x2=51.44 //y2=5.905
r339 (  17 53 ) resistor r=5.4201 //w=0.17 //l=0.085 //layer=li \
 //thickness=0.1 //x=51.355 //y=5.38 //x2=51.44 //y2=5.38
r340 (  17 18 ) resistor r=48.5989 //w=0.187 //l=0.71 //layer=li \
 //thickness=0.1 //x=51.355 //y=5.38 //x2=50.645 //y2=5.38
r341 (  11 18 ) resistor r=7.15173 //w=0.17 //l=0.120208 //layer=li \
 //thickness=0.1 //x=50.56 //y=5.465 //x2=50.645 //y2=5.38
r342 (  11 116 ) resistor r=30.1176 //w=0.187 //l=0.44 //layer=li \
 //thickness=0.1 //x=50.56 //y=5.465 //x2=50.56 //y2=5.905
r343 (  10 49 ) resistor r=9.3 //w=0.17 //l=0.17 //layer=mcon //count=1 \
 //x=58.58 //y=2.77 //x2=58.58 //y2=2.77
r344 (  8 41 ) resistor r=9.3 //w=0.17 //l=0.17 //layer=mcon //count=1 \
 //x=53.77 //y=2.765 //x2=53.77 //y2=2.765
r345 (  6 36 ) resistor r=9.3 //w=0.17 //l=0.17 //layer=mcon //count=1 \
 //x=51.92 //y=2.77 //x2=51.92 //y2=2.77
r346 (  4 8 ) resistor r=0.164988 //w=0.206 //l=0.267488 //layer=m1 \
 //thickness=0.36 //x=54.035 //y=2.77 //x2=53.77 //y2=2.765
r347 (  3 10 ) resistor r=0.0717383 //w=0.224 //l=0.115 //layer=m1 \
 //thickness=0.36 //x=58.465 //y=2.77 //x2=58.58 //y2=2.77
r348 (  3 4 ) resistor r=4.2271 //w=0.131 //l=4.43 //layer=m1 //thickness=0.36 \
 //x=58.465 //y=2.77 //x2=54.035 //y2=2.77
r349 (  2 6 ) resistor r=0.0717383 //w=0.224 //l=0.115 //layer=m1 \
 //thickness=0.36 //x=52.035 //y=2.77 //x2=51.92 //y2=2.77
r350 (  1 8 ) resistor r=0.0921728 //w=0.206 //l=0.147479 //layer=m1 \
 //thickness=0.36 //x=53.625 //y=2.77 //x2=53.77 //y2=2.765
r351 (  1 2 ) resistor r=1.51718 //w=0.131 //l=1.59 //layer=m1 \
 //thickness=0.36 //x=53.625 //y=2.77 //x2=52.035 //y2=2.77
ends PM_TMRDFFSNQNX1\%noxref_14

subckt PM_TMRDFFSNQNX1\%noxref_15 ( 1 2 13 14 21 29 35 36 40 42 49 50 51 52 53 \
 54 55 56 57 61 63 66 67 77 80 82 83 84 )
c164 ( 84 0 ) capacitor c=0.023087f //x=60.615 //y=5.2
c165 ( 83 0 ) capacitor c=0.023519f //x=59.735 //y=5.2
c166 ( 82 0 ) capacitor c=0.0224735f //x=58.855 //y=5.2
c167 ( 80 0 ) capacitor c=0.00872971f //x=60.865 //y=1.095
c168 ( 77 0 ) capacitor c=0.0588816f //x=63.39 //y=4.88
c169 ( 67 0 ) capacitor c=0.0318948f //x=63.725 //y=1.39
c170 ( 66 0 ) capacitor c=0.0187384f //x=63.725 //y=1.045
c171 ( 63 0 ) capacitor c=0.0141798f //x=63.57 //y=1.545
c172 ( 61 0 ) capacitor c=0.0149844f //x=63.57 //y=0.89
c173 ( 57 0 ) capacitor c=0.0813322f //x=63.195 //y=2.095
c174 ( 56 0 ) capacitor c=0.0229267f //x=63.195 //y=1.7
c175 ( 55 0 ) capacitor c=0.0234352f //x=63.195 //y=1.39
c176 ( 54 0 ) capacitor c=0.0199343f //x=63.195 //y=1.045
c177 ( 53 0 ) capacitor c=0.110275f //x=63.73 //y=6.2
c178 ( 52 0 ) capacitor c=0.154305f //x=63.29 //y=6.2
c179 ( 50 0 ) capacitor c=0.00106608f //x=60.76 //y=5.335
c180 ( 49 0 ) capacitor c=0.00207319f //x=59.88 //y=5.335
c181 ( 42 0 ) capacitor c=0.0839295f //x=63.39 //y=2.26
c182 ( 40 0 ) capacitor c=0.10402f //x=61.54 //y=2.77
c183 ( 36 0 ) capacitor c=0.00398962f //x=61.14 //y=1.845
c184 ( 35 0 ) capacitor c=0.0137288f //x=61.455 //y=1.845
c185 ( 29 0 ) capacitor c=0.0284988f //x=61.455 //y=5.335
c186 ( 21 0 ) capacitor c=0.0176454f //x=60.675 //y=5.335
c187 ( 14 0 ) capacitor c=0.00332903f //x=59.085 //y=5.335
c188 ( 13 0 ) capacitor c=0.0148427f //x=59.795 //y=5.335
c189 ( 2 0 ) capacitor c=0.00808366f //x=61.655 //y=2.77
c190 ( 1 0 ) capacitor c=0.0353429f //x=63.275 //y=2.77
r191 (  75 77 ) resistor r=20.6867 //w=0.233 //l=0.1 //layer=ply \
 //thickness=0.18 //x=63.29 //y=4.88 //x2=63.39 //y2=4.88
r192 (  68 77 ) resistor r=70.3348 //w=0.233 //l=0.414367 //layer=ply \
 //thickness=0.18 //x=63.73 //y=5.045 //x2=63.39 //y2=4.88
r193 (  67 79 ) resistor r=45.1352 //w=0.168 //l=0.173853 //layer=ply \
 //thickness=0.18 //x=63.725 //y=1.39 //x2=63.685 //y2=1.545
r194 (  66 78 ) resistor r=45.1352 //w=0.168 //l=0.173853 //layer=ply \
 //thickness=0.18 //x=63.725 //y=1.045 //x2=63.685 //y2=0.89
r195 (  66 67 ) resistor r=176.904 //w=0.094 //l=0.345 //layer=ply \
 //thickness=0.18 //x=63.725 //y=1.045 //x2=63.725 //y2=1.39
r196 (  64 74 ) resistor r=10.701 //w=0.21 //l=0.115 //layer=ply \
 //thickness=0.18 //x=63.35 //y=1.545 //x2=63.235 //y2=1.545
r197 (  63 79 ) resistor r=5.52526 //w=0.168 //l=0.115 //layer=ply \
 //thickness=0.18 //x=63.57 //y=1.545 //x2=63.685 //y2=1.545
r198 (  62 73 ) resistor r=5.52526 //w=0.168 //l=0.115 //layer=ply \
 //thickness=0.18 //x=63.35 //y=0.89 //x2=63.235 //y2=0.89
r199 (  61 78 ) resistor r=5.52526 //w=0.168 //l=0.115 //layer=ply \
 //thickness=0.18 //x=63.57 //y=0.89 //x2=63.685 //y2=0.89
r200 (  61 62 ) resistor r=112.809 //w=0.094 //l=0.22 //layer=ply \
 //thickness=0.18 //x=63.57 //y=0.89 //x2=63.35 //y2=0.89
r201 (  58 75 ) resistor r=13.0941 //w=0.233 //l=0.165 //layer=ply \
 //thickness=0.18 //x=63.29 //y=5.045 //x2=63.29 //y2=4.88
r202 (  57 72 ) resistor r=34.8111 //w=0.27 //l=0.264953 //layer=ply \
 //thickness=0.18 //x=63.195 //y=2.095 //x2=63.39 //y2=2.26
r203 (  56 74 ) resistor r=39.5823 //w=0.21 //l=0.173853 //layer=ply \
 //thickness=0.18 //x=63.195 //y=1.7 //x2=63.235 //y2=1.545
r204 (  56 57 ) resistor r=202.543 //w=0.094 //l=0.395 //layer=ply \
 //thickness=0.18 //x=63.195 //y=1.7 //x2=63.195 //y2=2.095
r205 (  55 74 ) resistor r=39.5823 //w=0.21 //l=0.173853 //layer=ply \
 //thickness=0.18 //x=63.195 //y=1.39 //x2=63.235 //y2=1.545
r206 (  54 73 ) resistor r=45.1352 //w=0.168 //l=0.173853 //layer=ply \
 //thickness=0.18 //x=63.195 //y=1.045 //x2=63.235 //y2=0.89
r207 (  54 55 ) resistor r=176.904 //w=0.094 //l=0.345 //layer=ply \
 //thickness=0.18 //x=63.195 //y=1.045 //x2=63.195 //y2=1.39
r208 (  53 68 ) resistor r=592.245 //w=0.094 //l=1.155 //layer=ply \
 //thickness=0.18 //x=63.73 //y=6.2 //x2=63.73 //y2=5.045
r209 (  52 58 ) resistor r=592.245 //w=0.094 //l=1.155 //layer=ply \
 //thickness=0.18 //x=63.29 //y=6.2 //x2=63.29 //y2=5.045
r210 (  51 63 ) resistor r=56.4043 //w=0.094 //l=0.11 //layer=ply \
 //thickness=0.18 //x=63.46 //y=1.545 //x2=63.57 //y2=1.545
r211 (  51 64 ) resistor r=56.4043 //w=0.094 //l=0.11 //layer=ply \
 //thickness=0.18 //x=63.46 //y=1.545 //x2=63.35 //y2=1.545
r212 (  47 77 ) resistor r=152 //w=0.17 //l=0.17 //layer=licon //count=1 \
 //x=63.39 //y=4.88 //x2=63.39 //y2=4.88
r213 (  45 47 ) resistor r=144.428 //w=0.187 //l=2.11 //layer=li \
 //thickness=0.1 //x=63.39 //y=2.77 //x2=63.39 //y2=4.88
r214 (  42 72 ) resistor r=152 //w=0.17 //l=0.17 //layer=licon //count=1 \
 //x=63.39 //y=2.26 //x2=63.39 //y2=2.26
r215 (  42 45 ) resistor r=34.9091 //w=0.187 //l=0.51 //layer=li \
 //thickness=0.1 //x=63.39 //y=2.26 //x2=63.39 //y2=2.77
r216 (  38 40 ) resistor r=169.754 //w=0.187 //l=2.48 //layer=li \
 //thickness=0.1 //x=61.54 //y=5.25 //x2=61.54 //y2=2.77
r217 (  37 40 ) resistor r=57.4973 //w=0.187 //l=0.84 //layer=li \
 //thickness=0.1 //x=61.54 //y=1.93 //x2=61.54 //y2=2.77
r218 (  35 37 ) resistor r=7.15173 //w=0.17 //l=0.120208 //layer=li \
 //thickness=0.1 //x=61.455 //y=1.845 //x2=61.54 //y2=1.93
r219 (  35 36 ) resistor r=21.5615 //w=0.187 //l=0.315 //layer=li \
 //thickness=0.1 //x=61.455 //y=1.845 //x2=61.14 //y2=1.845
r220 (  31 36 ) resistor r=7.15173 //w=0.17 //l=0.120208 //layer=li \
 //thickness=0.1 //x=61.055 //y=1.76 //x2=61.14 //y2=1.845
r221 (  31 80 ) resistor r=39.016 //w=0.187 //l=0.57 //layer=li \
 //thickness=0.1 //x=61.055 //y=1.76 //x2=61.055 //y2=1.19
r222 (  30 50 ) resistor r=5.4201 //w=0.17 //l=0.085 //layer=li \
 //thickness=0.1 //x=60.845 //y=5.335 //x2=60.76 //y2=5.335
r223 (  29 38 ) resistor r=7.15173 //w=0.17 //l=0.120208 //layer=li \
 //thickness=0.1 //x=61.455 //y=5.335 //x2=61.54 //y2=5.25
r224 (  29 30 ) resistor r=41.754 //w=0.187 //l=0.61 //layer=li \
 //thickness=0.1 //x=61.455 //y=5.335 //x2=60.845 //y2=5.335
r225 (  23 50 ) resistor r=1.40859 //w=0.34 //l=0.085 //layer=li \
 //thickness=0.1 //x=60.76 //y=5.42 //x2=60.76 //y2=5.335
r226 (  23 84 ) resistor r=33.1979 //w=0.187 //l=0.485 //layer=li \
 //thickness=0.1 //x=60.76 //y=5.42 //x2=60.76 //y2=5.905
r227 (  22 49 ) resistor r=5.4201 //w=0.17 //l=0.085 //layer=li \
 //thickness=0.1 //x=59.965 //y=5.335 //x2=59.88 //y2=5.335
r228 (  21 50 ) resistor r=5.4201 //w=0.17 //l=0.085 //layer=li \
 //thickness=0.1 //x=60.675 //y=5.335 //x2=60.76 //y2=5.335
r229 (  21 22 ) resistor r=48.5989 //w=0.187 //l=0.71 //layer=li \
 //thickness=0.1 //x=60.675 //y=5.335 //x2=59.965 //y2=5.335
r230 (  15 49 ) resistor r=1.40859 //w=0.34 //l=0.085 //layer=li \
 //thickness=0.1 //x=59.88 //y=5.42 //x2=59.88 //y2=5.335
r231 (  15 83 ) resistor r=33.1979 //w=0.187 //l=0.485 //layer=li \
 //thickness=0.1 //x=59.88 //y=5.42 //x2=59.88 //y2=5.905
r232 (  13 49 ) resistor r=5.4201 //w=0.17 //l=0.085 //layer=li \
 //thickness=0.1 //x=59.795 //y=5.335 //x2=59.88 //y2=5.335
r233 (  13 14 ) resistor r=48.5989 //w=0.187 //l=0.71 //layer=li \
 //thickness=0.1 //x=59.795 //y=5.335 //x2=59.085 //y2=5.335
r234 (  7 14 ) resistor r=7.15173 //w=0.17 //l=0.120208 //layer=li \
 //thickness=0.1 //x=59 //y=5.42 //x2=59.085 //y2=5.335
r235 (  7 82 ) resistor r=33.1979 //w=0.187 //l=0.485 //layer=li \
 //thickness=0.1 //x=59 //y=5.42 //x2=59 //y2=5.905
r236 (  6 45 ) resistor r=9.3 //w=0.17 //l=0.17 //layer=mcon //count=1 \
 //x=63.39 //y=2.77 //x2=63.39 //y2=2.77
r237 (  4 40 ) resistor r=9.3 //w=0.17 //l=0.17 //layer=mcon //count=1 \
 //x=61.54 //y=2.77 //x2=61.54 //y2=2.77
r238 (  2 4 ) resistor r=0.0717383 //w=0.224 //l=0.115 //layer=m1 \
 //thickness=0.36 //x=61.655 //y=2.77 //x2=61.54 //y2=2.77
r239 (  1 6 ) resistor r=0.0717383 //w=0.224 //l=0.115 //layer=m1 \
 //thickness=0.36 //x=63.275 //y=2.77 //x2=63.39 //y2=2.77
r240 (  1 2 ) resistor r=1.5458 //w=0.131 //l=1.62 //layer=m1 //thickness=0.36 \
 //x=63.275 //y=2.77 //x2=61.655 //y2=2.77
ends PM_TMRDFFSNQNX1\%noxref_15

subckt PM_TMRDFFSNQNX1\%CLK ( 1 2 3 4 5 6 7 8 9 10 23 24 25 26 27 28 29 30 31 \
 32 33 34 35 36 37 39 49 51 58 66 68 74 82 84 95 96 97 98 99 100 101 102 103 \
 104 105 106 107 108 109 110 111 112 113 114 115 117 123 124 125 126 127 132 \
 133 134 139 141 143 149 150 151 152 153 155 161 162 163 164 165 170 171 172 \
 177 179 181 187 188 189 190 191 193 199 200 201 202 203 208 209 210 215 217 \
 219 225 226 230 239 240 243 254 263 264 267 278 287 288 291 )
c752 ( 291 0 ) capacitor c=0.0331838f //x=64.16 //y=4.88
c753 ( 288 0 ) capacitor c=0.0279499f //x=64.13 //y=2.095
c754 ( 287 0 ) capacitor c=0.0421676f //x=64.13 //y=2.26
c755 ( 278 0 ) capacitor c=0.0334842f //x=54.88 //y=4.88
c756 ( 267 0 ) capacitor c=0.0331706f //x=39.74 //y=4.88
c757 ( 264 0 ) capacitor c=0.0279499f //x=39.71 //y=2.095
c758 ( 263 0 ) capacitor c=0.0421676f //x=39.71 //y=2.26
c759 ( 254 0 ) capacitor c=0.0334842f //x=30.46 //y=4.88
c760 ( 243 0 ) capacitor c=0.0331706f //x=15.32 //y=4.88
c761 ( 240 0 ) capacitor c=0.0279499f //x=15.29 //y=2.095
c762 ( 239 0 ) capacitor c=0.0421676f //x=15.29 //y=2.26
c763 ( 230 0 ) capacitor c=0.0334842f //x=6.04 //y=4.88
c764 ( 226 0 ) capacitor c=0.0429696f //x=64.695 //y=1.43
c765 ( 225 0 ) capacitor c=0.0192208f //x=64.695 //y=1.085
c766 ( 219 0 ) capacitor c=0.0148884f //x=64.54 //y=1.585
c767 ( 217 0 ) capacitor c=0.0157803f //x=64.54 //y=0.93
c768 ( 215 0 ) capacitor c=0.0299681f //x=64.535 //y=4.97
c769 ( 210 0 ) capacitor c=0.0205163f //x=64.165 //y=1.74
c770 ( 209 0 ) capacitor c=0.0168481f //x=64.165 //y=1.43
c771 ( 208 0 ) capacitor c=0.0174783f //x=64.165 //y=1.085
c772 ( 203 0 ) capacitor c=0.0245352f //x=55.215 //y=4.97
c773 ( 202 0 ) capacitor c=0.0825763f //x=54.97 //y=2.095
c774 ( 201 0 ) capacitor c=0.0170266f //x=54.97 //y=1.63
c775 ( 200 0 ) capacitor c=0.018609f //x=54.97 //y=1.4
c776 ( 199 0 ) capacitor c=0.0187309f //x=54.97 //y=1.09
c777 ( 193 0 ) capacitor c=0.014725f //x=54.815 //y=1.555
c778 ( 191 0 ) capacitor c=0.0146567f //x=54.815 //y=0.935
c779 ( 190 0 ) capacitor c=0.0335408f //x=54.445 //y=1.4
c780 ( 189 0 ) capacitor c=0.0173761f //x=54.445 //y=1.09
c781 ( 188 0 ) capacitor c=0.0429696f //x=40.275 //y=1.43
c782 ( 187 0 ) capacitor c=0.0192208f //x=40.275 //y=1.085
c783 ( 181 0 ) capacitor c=0.0148884f //x=40.12 //y=1.585
c784 ( 179 0 ) capacitor c=0.0157803f //x=40.12 //y=0.93
c785 ( 177 0 ) capacitor c=0.0295235f //x=40.115 //y=4.97
c786 ( 172 0 ) capacitor c=0.0205163f //x=39.745 //y=1.74
c787 ( 171 0 ) capacitor c=0.0168481f //x=39.745 //y=1.43
c788 ( 170 0 ) capacitor c=0.0174783f //x=39.745 //y=1.085
c789 ( 165 0 ) capacitor c=0.0245352f //x=30.795 //y=4.97
c790 ( 164 0 ) capacitor c=0.0825763f //x=30.55 //y=2.095
c791 ( 163 0 ) capacitor c=0.0170266f //x=30.55 //y=1.63
c792 ( 162 0 ) capacitor c=0.018609f //x=30.55 //y=1.4
c793 ( 161 0 ) capacitor c=0.0187309f //x=30.55 //y=1.09
c794 ( 155 0 ) capacitor c=0.014725f //x=30.395 //y=1.555
c795 ( 153 0 ) capacitor c=0.0146567f //x=30.395 //y=0.935
c796 ( 152 0 ) capacitor c=0.0335408f //x=30.025 //y=1.4
c797 ( 151 0 ) capacitor c=0.0173761f //x=30.025 //y=1.09
c798 ( 150 0 ) capacitor c=0.0429696f //x=15.855 //y=1.43
c799 ( 149 0 ) capacitor c=0.0192208f //x=15.855 //y=1.085
c800 ( 143 0 ) capacitor c=0.0148884f //x=15.7 //y=1.585
c801 ( 141 0 ) capacitor c=0.0157803f //x=15.7 //y=0.93
c802 ( 139 0 ) capacitor c=0.0295235f //x=15.695 //y=4.97
c803 ( 134 0 ) capacitor c=0.0205163f //x=15.325 //y=1.74
c804 ( 133 0 ) capacitor c=0.0168481f //x=15.325 //y=1.43
c805 ( 132 0 ) capacitor c=0.0174783f //x=15.325 //y=1.085
c806 ( 127 0 ) capacitor c=0.0245352f //x=6.375 //y=4.97
c807 ( 126 0 ) capacitor c=0.0826403f //x=6.13 //y=2.095
c808 ( 125 0 ) capacitor c=0.0170266f //x=6.13 //y=1.63
c809 ( 124 0 ) capacitor c=0.018609f //x=6.13 //y=1.4
c810 ( 123 0 ) capacitor c=0.0187309f //x=6.13 //y=1.09
c811 ( 117 0 ) capacitor c=0.014725f //x=5.975 //y=1.555
c812 ( 115 0 ) capacitor c=0.0146567f //x=5.975 //y=0.935
c813 ( 114 0 ) capacitor c=0.0335408f //x=5.605 //y=1.4
c814 ( 113 0 ) capacitor c=0.0173761f //x=5.605 //y=1.09
c815 ( 112 0 ) capacitor c=0.15358f //x=64.61 //y=6.2
c816 ( 111 0 ) capacitor c=0.110281f //x=64.17 //y=6.2
c817 ( 110 0 ) capacitor c=0.110114f //x=55.29 //y=6.2
c818 ( 109 0 ) capacitor c=0.11012f //x=54.85 //y=6.2
c819 ( 108 0 ) capacitor c=0.15358f //x=40.19 //y=6.2
c820 ( 107 0 ) capacitor c=0.110281f //x=39.75 //y=6.2
c821 ( 106 0 ) capacitor c=0.110114f //x=30.87 //y=6.2
c822 ( 105 0 ) capacitor c=0.11012f //x=30.43 //y=6.2
c823 ( 104 0 ) capacitor c=0.15358f //x=15.77 //y=6.2
c824 ( 103 0 ) capacitor c=0.110281f //x=15.33 //y=6.2
c825 ( 102 0 ) capacitor c=0.110114f //x=6.45 //y=6.2
c826 ( 101 0 ) capacitor c=0.11012f //x=6.01 //y=6.2
c827 ( 84 0 ) capacitor c=0.0687295f //x=64.13 //y=2.26
c828 ( 82 0 ) capacitor c=0.00369614f //x=64.13 //y=4.715
c829 ( 74 0 ) capacitor c=0.0900341f //x=54.88 //y=2.26
c830 ( 68 0 ) capacitor c=0.0687295f //x=39.71 //y=2.26
c831 ( 66 0 ) capacitor c=0.00369614f //x=39.71 //y=4.715
c832 ( 58 0 ) capacitor c=0.0900341f //x=30.46 //y=2.26
c833 ( 51 0 ) capacitor c=0.0707124f //x=15.29 //y=2.26
c834 ( 49 0 ) capacitor c=0.00369614f //x=15.29 //y=4.715
c835 ( 39 0 ) capacitor c=0.0953538f //x=6.04 //y=2.26
c836 ( 10 0 ) capacitor c=0.00697397f //x=54.995 //y=4.62
c837 ( 9 0 ) capacitor c=0.213744f //x=64.015 //y=4.62
c838 ( 8 0 ) capacitor c=0.00680508f //x=39.825 //y=4.62
c839 ( 7 0 ) capacitor c=0.354845f //x=54.765 //y=4.62
c840 ( 6 0 ) capacitor c=0.00697397f //x=30.575 //y=4.62
c841 ( 5 0 ) capacitor c=0.201328f //x=39.595 //y=4.62
c842 ( 4 0 ) capacitor c=0.00680508f //x=15.405 //y=4.62
c843 ( 3 0 ) capacitor c=0.353849f //x=30.345 //y=4.62
c844 ( 2 0 ) capacitor c=0.0154455f //x=6.155 //y=4.62
c845 ( 1 0 ) capacitor c=0.201328f //x=15.175 //y=4.62
r846 (  293 294 ) resistor r=32.4568 //w=0.214 //l=0.075 //layer=ply \
 //thickness=0.18 //x=64.16 //y=4.97 //x2=64.16 //y2=5.045
r847 (  291 293 ) resistor r=20.271 //w=0.214 //l=0.09 //layer=ply \
 //thickness=0.18 //x=64.16 //y=4.88 //x2=64.16 //y2=4.97
r848 (  287 288 ) resistor r=52.7279 //w=0.214 //l=0.165 //layer=ply \
 //thickness=0.18 //x=64.13 //y=2.26 //x2=64.13 //y2=2.095
r849 (  280 281 ) resistor r=32.4568 //w=0.214 //l=0.075 //layer=ply \
 //thickness=0.18 //x=54.88 //y=4.97 //x2=54.88 //y2=5.045
r850 (  278 280 ) resistor r=20.271 //w=0.214 //l=0.09 //layer=ply \
 //thickness=0.18 //x=54.88 //y=4.88 //x2=54.88 //y2=4.97
r851 (  269 270 ) resistor r=32.4568 //w=0.214 //l=0.075 //layer=ply \
 //thickness=0.18 //x=39.74 //y=4.97 //x2=39.74 //y2=5.045
r852 (  267 269 ) resistor r=20.271 //w=0.214 //l=0.09 //layer=ply \
 //thickness=0.18 //x=39.74 //y=4.88 //x2=39.74 //y2=4.97
r853 (  263 264 ) resistor r=52.7279 //w=0.214 //l=0.165 //layer=ply \
 //thickness=0.18 //x=39.71 //y=2.26 //x2=39.71 //y2=2.095
r854 (  256 257 ) resistor r=32.4568 //w=0.214 //l=0.075 //layer=ply \
 //thickness=0.18 //x=30.46 //y=4.97 //x2=30.46 //y2=5.045
r855 (  254 256 ) resistor r=20.271 //w=0.214 //l=0.09 //layer=ply \
 //thickness=0.18 //x=30.46 //y=4.88 //x2=30.46 //y2=4.97
r856 (  245 246 ) resistor r=32.4568 //w=0.214 //l=0.075 //layer=ply \
 //thickness=0.18 //x=15.32 //y=4.97 //x2=15.32 //y2=5.045
r857 (  243 245 ) resistor r=20.271 //w=0.214 //l=0.09 //layer=ply \
 //thickness=0.18 //x=15.32 //y=4.88 //x2=15.32 //y2=4.97
r858 (  239 240 ) resistor r=52.7279 //w=0.214 //l=0.165 //layer=ply \
 //thickness=0.18 //x=15.29 //y=2.26 //x2=15.29 //y2=2.095
r859 (  232 233 ) resistor r=32.4568 //w=0.214 //l=0.075 //layer=ply \
 //thickness=0.18 //x=6.04 //y=4.97 //x2=6.04 //y2=5.045
r860 (  230 232 ) resistor r=20.271 //w=0.214 //l=0.09 //layer=ply \
 //thickness=0.18 //x=6.04 //y=4.88 //x2=6.04 //y2=4.97
r861 (  226 298 ) resistor r=45.1352 //w=0.168 //l=0.173853 //layer=ply \
 //thickness=0.18 //x=64.695 //y=1.43 //x2=64.655 //y2=1.585
r862 (  225 297 ) resistor r=45.1352 //w=0.168 //l=0.173853 //layer=ply \
 //thickness=0.18 //x=64.695 //y=1.085 //x2=64.655 //y2=0.93
r863 (  225 226 ) resistor r=176.904 //w=0.094 //l=0.345 //layer=ply \
 //thickness=0.18 //x=64.695 //y=1.085 //x2=64.695 //y2=1.43
r864 (  220 296 ) resistor r=10.701 //w=0.21 //l=0.115 //layer=ply \
 //thickness=0.18 //x=64.32 //y=1.585 //x2=64.205 //y2=1.585
r865 (  219 298 ) resistor r=5.52526 //w=0.168 //l=0.115 //layer=ply \
 //thickness=0.18 //x=64.54 //y=1.585 //x2=64.655 //y2=1.585
r866 (  218 295 ) resistor r=5.52526 //w=0.168 //l=0.115 //layer=ply \
 //thickness=0.18 //x=64.32 //y=0.93 //x2=64.205 //y2=0.93
r867 (  217 297 ) resistor r=5.52526 //w=0.168 //l=0.115 //layer=ply \
 //thickness=0.18 //x=64.54 //y=0.93 //x2=64.655 //y2=0.93
r868 (  217 218 ) resistor r=112.809 //w=0.094 //l=0.22 //layer=ply \
 //thickness=0.18 //x=64.54 //y=0.93 //x2=64.32 //y2=0.93
r869 (  216 293 ) resistor r=16.5046 //w=0.27 //l=0.135 //layer=ply \
 //thickness=0.18 //x=64.295 //y=4.97 //x2=64.16 //y2=4.97
r870 (  215 222 ) resistor r=26.9307 //w=0.15 //l=0.106066 //layer=ply \
 //thickness=0.18 //x=64.535 //y=4.97 //x2=64.61 //y2=5.045
r871 (  215 216 ) resistor r=123.064 //w=0.094 //l=0.24 //layer=ply \
 //thickness=0.18 //x=64.535 //y=4.97 //x2=64.295 //y2=4.97
r872 (  210 296 ) resistor r=39.5823 //w=0.21 //l=0.173853 //layer=ply \
 //thickness=0.18 //x=64.165 //y=1.74 //x2=64.205 //y2=1.585
r873 (  210 288 ) resistor r=182.032 //w=0.094 //l=0.355 //layer=ply \
 //thickness=0.18 //x=64.165 //y=1.74 //x2=64.165 //y2=2.095
r874 (  209 296 ) resistor r=39.5823 //w=0.21 //l=0.173853 //layer=ply \
 //thickness=0.18 //x=64.165 //y=1.43 //x2=64.205 //y2=1.585
r875 (  208 295 ) resistor r=45.1352 //w=0.168 //l=0.173853 //layer=ply \
 //thickness=0.18 //x=64.165 //y=1.085 //x2=64.205 //y2=0.93
r876 (  208 209 ) resistor r=176.904 //w=0.094 //l=0.345 //layer=ply \
 //thickness=0.18 //x=64.165 //y=1.085 //x2=64.165 //y2=1.43
r877 (  204 280 ) resistor r=16.5046 //w=0.27 //l=0.135 //layer=ply \
 //thickness=0.18 //x=55.015 //y=4.97 //x2=54.88 //y2=4.97
r878 (  203 205 ) resistor r=26.9307 //w=0.15 //l=0.106066 //layer=ply \
 //thickness=0.18 //x=55.215 //y=4.97 //x2=55.29 //y2=5.045
r879 (  203 204 ) resistor r=102.553 //w=0.094 //l=0.2 //layer=ply \
 //thickness=0.18 //x=55.215 //y=4.97 //x2=55.015 //y2=4.97
r880 (  202 285 ) resistor r=38.6777 //w=0.284 //l=0.198997 //layer=ply \
 //thickness=0.18 //x=54.97 //y=2.095 //x2=54.895 //y2=2.26
r881 (  201 283 ) resistor r=21.2976 //w=0.217 //l=0.0928709 //layer=ply \
 //thickness=0.18 //x=54.97 //y=1.63 //x2=54.93 //y2=1.555
r882 (  201 202 ) resistor r=238.436 //w=0.094 //l=0.465 //layer=ply \
 //thickness=0.18 //x=54.97 //y=1.63 //x2=54.97 //y2=2.095
r883 (  200 283 ) resistor r=39.0671 //w=0.217 //l=0.173853 //layer=ply \
 //thickness=0.18 //x=54.97 //y=1.4 //x2=54.93 //y2=1.555
r884 (  199 282 ) resistor r=45.1352 //w=0.168 //l=0.173853 //layer=ply \
 //thickness=0.18 //x=54.97 //y=1.09 //x2=54.93 //y2=0.935
r885 (  199 200 ) resistor r=158.957 //w=0.094 //l=0.31 //layer=ply \
 //thickness=0.18 //x=54.97 //y=1.09 //x2=54.97 //y2=1.4
r886 (  194 276 ) resistor r=5.52526 //w=0.168 //l=0.115 //layer=ply \
 //thickness=0.18 //x=54.6 //y=1.555 //x2=54.485 //y2=1.555
r887 (  193 283 ) resistor r=11.4558 //w=0.217 //l=0.115 //layer=ply \
 //thickness=0.18 //x=54.815 //y=1.555 //x2=54.93 //y2=1.555
r888 (  192 275 ) resistor r=5.52526 //w=0.168 //l=0.115 //layer=ply \
 //thickness=0.18 //x=54.6 //y=0.935 //x2=54.485 //y2=0.935
r889 (  191 282 ) resistor r=5.52526 //w=0.168 //l=0.115 //layer=ply \
 //thickness=0.18 //x=54.815 //y=0.935 //x2=54.93 //y2=0.935
r890 (  191 192 ) resistor r=110.245 //w=0.094 //l=0.215 //layer=ply \
 //thickness=0.18 //x=54.815 //y=0.935 //x2=54.6 //y2=0.935
r891 (  190 276 ) resistor r=45.1352 //w=0.168 //l=0.173853 //layer=ply \
 //thickness=0.18 //x=54.445 //y=1.4 //x2=54.485 //y2=1.555
r892 (  189 275 ) resistor r=45.1352 //w=0.168 //l=0.173853 //layer=ply \
 //thickness=0.18 //x=54.445 //y=1.09 //x2=54.485 //y2=0.935
r893 (  189 190 ) resistor r=158.957 //w=0.094 //l=0.31 //layer=ply \
 //thickness=0.18 //x=54.445 //y=1.09 //x2=54.445 //y2=1.4
r894 (  188 274 ) resistor r=45.1352 //w=0.168 //l=0.173853 //layer=ply \
 //thickness=0.18 //x=40.275 //y=1.43 //x2=40.235 //y2=1.585
r895 (  187 273 ) resistor r=45.1352 //w=0.168 //l=0.173853 //layer=ply \
 //thickness=0.18 //x=40.275 //y=1.085 //x2=40.235 //y2=0.93
r896 (  187 188 ) resistor r=176.904 //w=0.094 //l=0.345 //layer=ply \
 //thickness=0.18 //x=40.275 //y=1.085 //x2=40.275 //y2=1.43
r897 (  182 272 ) resistor r=10.701 //w=0.21 //l=0.115 //layer=ply \
 //thickness=0.18 //x=39.9 //y=1.585 //x2=39.785 //y2=1.585
r898 (  181 274 ) resistor r=5.52526 //w=0.168 //l=0.115 //layer=ply \
 //thickness=0.18 //x=40.12 //y=1.585 //x2=40.235 //y2=1.585
r899 (  180 271 ) resistor r=5.52526 //w=0.168 //l=0.115 //layer=ply \
 //thickness=0.18 //x=39.9 //y=0.93 //x2=39.785 //y2=0.93
r900 (  179 273 ) resistor r=5.52526 //w=0.168 //l=0.115 //layer=ply \
 //thickness=0.18 //x=40.12 //y=0.93 //x2=40.235 //y2=0.93
r901 (  179 180 ) resistor r=112.809 //w=0.094 //l=0.22 //layer=ply \
 //thickness=0.18 //x=40.12 //y=0.93 //x2=39.9 //y2=0.93
r902 (  178 269 ) resistor r=16.5046 //w=0.27 //l=0.135 //layer=ply \
 //thickness=0.18 //x=39.875 //y=4.97 //x2=39.74 //y2=4.97
r903 (  177 184 ) resistor r=26.9307 //w=0.15 //l=0.106066 //layer=ply \
 //thickness=0.18 //x=40.115 //y=4.97 //x2=40.19 //y2=5.045
r904 (  177 178 ) resistor r=123.064 //w=0.094 //l=0.24 //layer=ply \
 //thickness=0.18 //x=40.115 //y=4.97 //x2=39.875 //y2=4.97
r905 (  172 272 ) resistor r=39.5823 //w=0.21 //l=0.173853 //layer=ply \
 //thickness=0.18 //x=39.745 //y=1.74 //x2=39.785 //y2=1.585
r906 (  172 264 ) resistor r=182.032 //w=0.094 //l=0.355 //layer=ply \
 //thickness=0.18 //x=39.745 //y=1.74 //x2=39.745 //y2=2.095
r907 (  171 272 ) resistor r=39.5823 //w=0.21 //l=0.173853 //layer=ply \
 //thickness=0.18 //x=39.745 //y=1.43 //x2=39.785 //y2=1.585
r908 (  170 271 ) resistor r=45.1352 //w=0.168 //l=0.173853 //layer=ply \
 //thickness=0.18 //x=39.745 //y=1.085 //x2=39.785 //y2=0.93
r909 (  170 171 ) resistor r=176.904 //w=0.094 //l=0.345 //layer=ply \
 //thickness=0.18 //x=39.745 //y=1.085 //x2=39.745 //y2=1.43
r910 (  166 256 ) resistor r=16.5046 //w=0.27 //l=0.135 //layer=ply \
 //thickness=0.18 //x=30.595 //y=4.97 //x2=30.46 //y2=4.97
r911 (  165 167 ) resistor r=26.9307 //w=0.15 //l=0.106066 //layer=ply \
 //thickness=0.18 //x=30.795 //y=4.97 //x2=30.87 //y2=5.045
r912 (  165 166 ) resistor r=102.553 //w=0.094 //l=0.2 //layer=ply \
 //thickness=0.18 //x=30.795 //y=4.97 //x2=30.595 //y2=4.97
r913 (  164 261 ) resistor r=38.6777 //w=0.284 //l=0.198997 //layer=ply \
 //thickness=0.18 //x=30.55 //y=2.095 //x2=30.475 //y2=2.26
r914 (  163 259 ) resistor r=21.2976 //w=0.217 //l=0.0928709 //layer=ply \
 //thickness=0.18 //x=30.55 //y=1.63 //x2=30.51 //y2=1.555
r915 (  163 164 ) resistor r=238.436 //w=0.094 //l=0.465 //layer=ply \
 //thickness=0.18 //x=30.55 //y=1.63 //x2=30.55 //y2=2.095
r916 (  162 259 ) resistor r=39.0671 //w=0.217 //l=0.173853 //layer=ply \
 //thickness=0.18 //x=30.55 //y=1.4 //x2=30.51 //y2=1.555
r917 (  161 258 ) resistor r=45.1352 //w=0.168 //l=0.173853 //layer=ply \
 //thickness=0.18 //x=30.55 //y=1.09 //x2=30.51 //y2=0.935
r918 (  161 162 ) resistor r=158.957 //w=0.094 //l=0.31 //layer=ply \
 //thickness=0.18 //x=30.55 //y=1.09 //x2=30.55 //y2=1.4
r919 (  156 252 ) resistor r=5.52526 //w=0.168 //l=0.115 //layer=ply \
 //thickness=0.18 //x=30.18 //y=1.555 //x2=30.065 //y2=1.555
r920 (  155 259 ) resistor r=11.4558 //w=0.217 //l=0.115 //layer=ply \
 //thickness=0.18 //x=30.395 //y=1.555 //x2=30.51 //y2=1.555
r921 (  154 251 ) resistor r=5.52526 //w=0.168 //l=0.115 //layer=ply \
 //thickness=0.18 //x=30.18 //y=0.935 //x2=30.065 //y2=0.935
r922 (  153 258 ) resistor r=5.52526 //w=0.168 //l=0.115 //layer=ply \
 //thickness=0.18 //x=30.395 //y=0.935 //x2=30.51 //y2=0.935
r923 (  153 154 ) resistor r=110.245 //w=0.094 //l=0.215 //layer=ply \
 //thickness=0.18 //x=30.395 //y=0.935 //x2=30.18 //y2=0.935
r924 (  152 252 ) resistor r=45.1352 //w=0.168 //l=0.173853 //layer=ply \
 //thickness=0.18 //x=30.025 //y=1.4 //x2=30.065 //y2=1.555
r925 (  151 251 ) resistor r=45.1352 //w=0.168 //l=0.173853 //layer=ply \
 //thickness=0.18 //x=30.025 //y=1.09 //x2=30.065 //y2=0.935
r926 (  151 152 ) resistor r=158.957 //w=0.094 //l=0.31 //layer=ply \
 //thickness=0.18 //x=30.025 //y=1.09 //x2=30.025 //y2=1.4
r927 (  150 250 ) resistor r=45.1352 //w=0.168 //l=0.173853 //layer=ply \
 //thickness=0.18 //x=15.855 //y=1.43 //x2=15.815 //y2=1.585
r928 (  149 249 ) resistor r=45.1352 //w=0.168 //l=0.173853 //layer=ply \
 //thickness=0.18 //x=15.855 //y=1.085 //x2=15.815 //y2=0.93
r929 (  149 150 ) resistor r=176.904 //w=0.094 //l=0.345 //layer=ply \
 //thickness=0.18 //x=15.855 //y=1.085 //x2=15.855 //y2=1.43
r930 (  144 248 ) resistor r=10.701 //w=0.21 //l=0.115 //layer=ply \
 //thickness=0.18 //x=15.48 //y=1.585 //x2=15.365 //y2=1.585
r931 (  143 250 ) resistor r=5.52526 //w=0.168 //l=0.115 //layer=ply \
 //thickness=0.18 //x=15.7 //y=1.585 //x2=15.815 //y2=1.585
r932 (  142 247 ) resistor r=5.52526 //w=0.168 //l=0.115 //layer=ply \
 //thickness=0.18 //x=15.48 //y=0.93 //x2=15.365 //y2=0.93
r933 (  141 249 ) resistor r=5.52526 //w=0.168 //l=0.115 //layer=ply \
 //thickness=0.18 //x=15.7 //y=0.93 //x2=15.815 //y2=0.93
r934 (  141 142 ) resistor r=112.809 //w=0.094 //l=0.22 //layer=ply \
 //thickness=0.18 //x=15.7 //y=0.93 //x2=15.48 //y2=0.93
r935 (  140 245 ) resistor r=16.5046 //w=0.27 //l=0.135 //layer=ply \
 //thickness=0.18 //x=15.455 //y=4.97 //x2=15.32 //y2=4.97
r936 (  139 146 ) resistor r=26.9307 //w=0.15 //l=0.106066 //layer=ply \
 //thickness=0.18 //x=15.695 //y=4.97 //x2=15.77 //y2=5.045
r937 (  139 140 ) resistor r=123.064 //w=0.094 //l=0.24 //layer=ply \
 //thickness=0.18 //x=15.695 //y=4.97 //x2=15.455 //y2=4.97
r938 (  134 248 ) resistor r=39.5823 //w=0.21 //l=0.173853 //layer=ply \
 //thickness=0.18 //x=15.325 //y=1.74 //x2=15.365 //y2=1.585
r939 (  134 240 ) resistor r=182.032 //w=0.094 //l=0.355 //layer=ply \
 //thickness=0.18 //x=15.325 //y=1.74 //x2=15.325 //y2=2.095
r940 (  133 248 ) resistor r=39.5823 //w=0.21 //l=0.173853 //layer=ply \
 //thickness=0.18 //x=15.325 //y=1.43 //x2=15.365 //y2=1.585
r941 (  132 247 ) resistor r=45.1352 //w=0.168 //l=0.173853 //layer=ply \
 //thickness=0.18 //x=15.325 //y=1.085 //x2=15.365 //y2=0.93
r942 (  132 133 ) resistor r=176.904 //w=0.094 //l=0.345 //layer=ply \
 //thickness=0.18 //x=15.325 //y=1.085 //x2=15.325 //y2=1.43
r943 (  128 232 ) resistor r=16.5046 //w=0.27 //l=0.135 //layer=ply \
 //thickness=0.18 //x=6.175 //y=4.97 //x2=6.04 //y2=4.97
r944 (  127 129 ) resistor r=26.9307 //w=0.15 //l=0.106066 //layer=ply \
 //thickness=0.18 //x=6.375 //y=4.97 //x2=6.45 //y2=5.045
r945 (  127 128 ) resistor r=102.553 //w=0.094 //l=0.2 //layer=ply \
 //thickness=0.18 //x=6.375 //y=4.97 //x2=6.175 //y2=4.97
r946 (  126 237 ) resistor r=38.6777 //w=0.284 //l=0.198997 //layer=ply \
 //thickness=0.18 //x=6.13 //y=2.095 //x2=6.055 //y2=2.26
r947 (  125 235 ) resistor r=21.2976 //w=0.217 //l=0.0928709 //layer=ply \
 //thickness=0.18 //x=6.13 //y=1.63 //x2=6.09 //y2=1.555
r948 (  125 126 ) resistor r=238.436 //w=0.094 //l=0.465 //layer=ply \
 //thickness=0.18 //x=6.13 //y=1.63 //x2=6.13 //y2=2.095
r949 (  124 235 ) resistor r=39.0671 //w=0.217 //l=0.173853 //layer=ply \
 //thickness=0.18 //x=6.13 //y=1.4 //x2=6.09 //y2=1.555
r950 (  123 234 ) resistor r=45.1352 //w=0.168 //l=0.173853 //layer=ply \
 //thickness=0.18 //x=6.13 //y=1.09 //x2=6.09 //y2=0.935
r951 (  123 124 ) resistor r=158.957 //w=0.094 //l=0.31 //layer=ply \
 //thickness=0.18 //x=6.13 //y=1.09 //x2=6.13 //y2=1.4
r952 (  118 228 ) resistor r=5.52526 //w=0.168 //l=0.115 //layer=ply \
 //thickness=0.18 //x=5.76 //y=1.555 //x2=5.645 //y2=1.555
r953 (  117 235 ) resistor r=11.4558 //w=0.217 //l=0.115 //layer=ply \
 //thickness=0.18 //x=5.975 //y=1.555 //x2=6.09 //y2=1.555
r954 (  116 227 ) resistor r=5.52526 //w=0.168 //l=0.115 //layer=ply \
 //thickness=0.18 //x=5.76 //y=0.935 //x2=5.645 //y2=0.935
r955 (  115 234 ) resistor r=5.52526 //w=0.168 //l=0.115 //layer=ply \
 //thickness=0.18 //x=5.975 //y=0.935 //x2=6.09 //y2=0.935
r956 (  115 116 ) resistor r=110.245 //w=0.094 //l=0.215 //layer=ply \
 //thickness=0.18 //x=5.975 //y=0.935 //x2=5.76 //y2=0.935
r957 (  114 228 ) resistor r=45.1352 //w=0.168 //l=0.173853 //layer=ply \
 //thickness=0.18 //x=5.605 //y=1.4 //x2=5.645 //y2=1.555
r958 (  113 227 ) resistor r=45.1352 //w=0.168 //l=0.173853 //layer=ply \
 //thickness=0.18 //x=5.605 //y=1.09 //x2=5.645 //y2=0.935
r959 (  113 114 ) resistor r=158.957 //w=0.094 //l=0.31 //layer=ply \
 //thickness=0.18 //x=5.605 //y=1.09 //x2=5.605 //y2=1.4
r960 (  112 222 ) resistor r=592.245 //w=0.094 //l=1.155 //layer=ply \
 //thickness=0.18 //x=64.61 //y=6.2 //x2=64.61 //y2=5.045
r961 (  111 294 ) resistor r=592.245 //w=0.094 //l=1.155 //layer=ply \
 //thickness=0.18 //x=64.17 //y=6.2 //x2=64.17 //y2=5.045
r962 (  110 205 ) resistor r=592.245 //w=0.094 //l=1.155 //layer=ply \
 //thickness=0.18 //x=55.29 //y=6.2 //x2=55.29 //y2=5.045
r963 (  109 281 ) resistor r=592.245 //w=0.094 //l=1.155 //layer=ply \
 //thickness=0.18 //x=54.85 //y=6.2 //x2=54.85 //y2=5.045
r964 (  108 184 ) resistor r=592.245 //w=0.094 //l=1.155 //layer=ply \
 //thickness=0.18 //x=40.19 //y=6.2 //x2=40.19 //y2=5.045
r965 (  107 270 ) resistor r=592.245 //w=0.094 //l=1.155 //layer=ply \
 //thickness=0.18 //x=39.75 //y=6.2 //x2=39.75 //y2=5.045
r966 (  106 167 ) resistor r=592.245 //w=0.094 //l=1.155 //layer=ply \
 //thickness=0.18 //x=30.87 //y=6.2 //x2=30.87 //y2=5.045
r967 (  105 257 ) resistor r=592.245 //w=0.094 //l=1.155 //layer=ply \
 //thickness=0.18 //x=30.43 //y=6.2 //x2=30.43 //y2=5.045
r968 (  104 146 ) resistor r=592.245 //w=0.094 //l=1.155 //layer=ply \
 //thickness=0.18 //x=15.77 //y=6.2 //x2=15.77 //y2=5.045
r969 (  103 246 ) resistor r=592.245 //w=0.094 //l=1.155 //layer=ply \
 //thickness=0.18 //x=15.33 //y=6.2 //x2=15.33 //y2=5.045
r970 (  102 129 ) resistor r=592.245 //w=0.094 //l=1.155 //layer=ply \
 //thickness=0.18 //x=6.45 //y=6.2 //x2=6.45 //y2=5.045
r971 (  101 233 ) resistor r=592.245 //w=0.094 //l=1.155 //layer=ply \
 //thickness=0.18 //x=6.01 //y=6.2 //x2=6.01 //y2=5.045
r972 (  100 219 ) resistor r=56.4043 //w=0.094 //l=0.11 //layer=ply \
 //thickness=0.18 //x=64.43 //y=1.585 //x2=64.54 //y2=1.585
r973 (  100 220 ) resistor r=56.4043 //w=0.094 //l=0.11 //layer=ply \
 //thickness=0.18 //x=64.43 //y=1.585 //x2=64.32 //y2=1.585
r974 (  99 193 ) resistor r=55.3787 //w=0.094 //l=0.108 //layer=ply \
 //thickness=0.18 //x=54.707 //y=1.555 //x2=54.815 //y2=1.555
r975 (  99 194 ) resistor r=54.866 //w=0.094 //l=0.107 //layer=ply \
 //thickness=0.18 //x=54.707 //y=1.555 //x2=54.6 //y2=1.555
r976 (  98 181 ) resistor r=56.4043 //w=0.094 //l=0.11 //layer=ply \
 //thickness=0.18 //x=40.01 //y=1.585 //x2=40.12 //y2=1.585
r977 (  98 182 ) resistor r=56.4043 //w=0.094 //l=0.11 //layer=ply \
 //thickness=0.18 //x=40.01 //y=1.585 //x2=39.9 //y2=1.585
r978 (  97 155 ) resistor r=55.3787 //w=0.094 //l=0.108 //layer=ply \
 //thickness=0.18 //x=30.287 //y=1.555 //x2=30.395 //y2=1.555
r979 (  97 156 ) resistor r=54.866 //w=0.094 //l=0.107 //layer=ply \
 //thickness=0.18 //x=30.287 //y=1.555 //x2=30.18 //y2=1.555
r980 (  96 143 ) resistor r=56.4043 //w=0.094 //l=0.11 //layer=ply \
 //thickness=0.18 //x=15.59 //y=1.585 //x2=15.7 //y2=1.585
r981 (  96 144 ) resistor r=56.4043 //w=0.094 //l=0.11 //layer=ply \
 //thickness=0.18 //x=15.59 //y=1.585 //x2=15.48 //y2=1.585
r982 (  95 117 ) resistor r=55.3787 //w=0.094 //l=0.108 //layer=ply \
 //thickness=0.18 //x=5.867 //y=1.555 //x2=5.975 //y2=1.555
r983 (  95 118 ) resistor r=54.866 //w=0.094 //l=0.107 //layer=ply \
 //thickness=0.18 //x=5.867 //y=1.555 //x2=5.76 //y2=1.555
r984 (  94 291 ) resistor r=152 //w=0.17 //l=0.17 //layer=licon //count=1 \
 //x=64.16 //y=4.88 //x2=64.16 //y2=4.88
r985 (  92 267 ) resistor r=152 //w=0.17 //l=0.17 //layer=licon //count=1 \
 //x=39.74 //y=4.88 //x2=39.74 //y2=4.88
r986 (  90 243 ) resistor r=152 //w=0.17 //l=0.17 //layer=licon //count=1 \
 //x=15.32 //y=4.88 //x2=15.32 //y2=4.88
r987 (  84 287 ) resistor r=152 //w=0.17 //l=0.17 //layer=licon //count=1 \
 //x=64.13 //y=2.26 //x2=64.13 //y2=2.26
r988 (  82 94 ) resistor r=11.4737 //w=0.186 //l=0.172337 //layer=li \
 //thickness=0.1 //x=64.13 //y=4.715 //x2=64.145 //y2=4.88
r989 (  80 278 ) resistor r=152 //w=0.17 //l=0.17 //layer=licon //count=1 \
 //x=54.88 //y=4.88 //x2=54.88 //y2=4.88
r990 (  74 285 ) resistor r=152 //w=0.17 //l=0.17 //layer=licon //count=1 \
 //x=54.88 //y=2.26 //x2=54.88 //y2=2.26
r991 (  68 263 ) resistor r=152 //w=0.17 //l=0.17 //layer=licon //count=1 \
 //x=39.71 //y=2.26 //x2=39.71 //y2=2.26
r992 (  66 92 ) resistor r=11.4737 //w=0.186 //l=0.172337 //layer=li \
 //thickness=0.1 //x=39.71 //y=4.715 //x2=39.725 //y2=4.88
r993 (  64 254 ) resistor r=152 //w=0.17 //l=0.17 //layer=licon //count=1 \
 //x=30.46 //y=4.88 //x2=30.46 //y2=4.88
r994 (  58 261 ) resistor r=152 //w=0.17 //l=0.17 //layer=licon //count=1 \
 //x=30.46 //y=2.26 //x2=30.46 //y2=2.26
r995 (  51 239 ) resistor r=152 //w=0.17 //l=0.17 //layer=licon //count=1 \
 //x=15.29 //y=2.26 //x2=15.29 //y2=2.26
r996 (  49 90 ) resistor r=11.4737 //w=0.186 //l=0.172337 //layer=li \
 //thickness=0.1 //x=15.29 //y=4.715 //x2=15.305 //y2=4.88
r997 (  47 230 ) resistor r=152 //w=0.17 //l=0.17 //layer=licon //count=1 \
 //x=6.04 //y=4.88 //x2=6.04 //y2=4.88
r998 (  39 237 ) resistor r=152 //w=0.17 //l=0.17 //layer=licon //count=1 \
 //x=6.04 //y=2.26 //x2=6.04 //y2=2.26
r999 (  37 82 ) resistor r=6.50267 //w=0.187 //l=0.095 //layer=li \
 //thickness=0.1 //x=64.13 //y=4.62 //x2=64.13 //y2=4.715
r1000 (  36 37 ) resistor r=126.631 //w=0.187 //l=1.85 //layer=li \
 //thickness=0.1 //x=64.13 //y=2.77 //x2=64.13 //y2=4.62
r1001 (  36 84 ) resistor r=34.9091 //w=0.187 //l=0.51 //layer=li \
 //thickness=0.1 //x=64.13 //y=2.77 //x2=64.13 //y2=2.26
r1002 (  35 80 ) resistor r=17.7968 //w=0.187 //l=0.26 //layer=li \
 //thickness=0.1 //x=54.88 //y=4.62 //x2=54.88 //y2=4.88
r1003 (  34 35 ) resistor r=50.6524 //w=0.187 //l=0.74 //layer=li \
 //thickness=0.1 //x=54.88 //y=3.88 //x2=54.88 //y2=4.62
r1004 (  34 74 ) resistor r=110.888 //w=0.187 //l=1.62 //layer=li \
 //thickness=0.1 //x=54.88 //y=3.88 //x2=54.88 //y2=2.26
r1005 (  33 66 ) resistor r=6.50267 //w=0.187 //l=0.095 //layer=li \
 //thickness=0.1 //x=39.71 //y=4.62 //x2=39.71 //y2=4.715
r1006 (  32 33 ) resistor r=126.631 //w=0.187 //l=1.85 //layer=li \
 //thickness=0.1 //x=39.71 //y=2.77 //x2=39.71 //y2=4.62
r1007 (  32 68 ) resistor r=34.9091 //w=0.187 //l=0.51 //layer=li \
 //thickness=0.1 //x=39.71 //y=2.77 //x2=39.71 //y2=2.26
r1008 (  31 64 ) resistor r=17.7968 //w=0.187 //l=0.26 //layer=li \
 //thickness=0.1 //x=30.46 //y=4.62 //x2=30.46 //y2=4.88
r1009 (  30 31 ) resistor r=50.6524 //w=0.187 //l=0.74 //layer=li \
 //thickness=0.1 //x=30.46 //y=3.88 //x2=30.46 //y2=4.62
r1010 (  30 58 ) resistor r=110.888 //w=0.187 //l=1.62 //layer=li \
 //thickness=0.1 //x=30.46 //y=3.88 //x2=30.46 //y2=2.26
r1011 (  29 49 ) resistor r=6.50267 //w=0.187 //l=0.095 //layer=li \
 //thickness=0.1 //x=15.29 //y=4.62 //x2=15.29 //y2=4.715
r1012 (  28 29 ) resistor r=75.9786 //w=0.187 //l=1.11 //layer=li \
 //thickness=0.1 //x=15.29 //y=3.51 //x2=15.29 //y2=4.62
r1013 (  27 28 ) resistor r=50.6524 //w=0.187 //l=0.74 //layer=li \
 //thickness=0.1 //x=15.29 //y=2.77 //x2=15.29 //y2=3.51
r1014 (  27 51 ) resistor r=34.9091 //w=0.187 //l=0.51 //layer=li \
 //thickness=0.1 //x=15.29 //y=2.77 //x2=15.29 //y2=2.26
r1015 (  26 47 ) resistor r=17.7968 //w=0.187 //l=0.26 //layer=li \
 //thickness=0.1 //x=6.04 //y=4.62 //x2=6.04 //y2=4.88
r1016 (  25 26 ) resistor r=50.6524 //w=0.187 //l=0.74 //layer=li \
 //thickness=0.1 //x=6.04 //y=3.88 //x2=6.04 //y2=4.62
r1017 (  24 25 ) resistor r=25.3262 //w=0.187 //l=0.37 //layer=li \
 //thickness=0.1 //x=6.04 //y=3.51 //x2=6.04 //y2=3.88
r1018 (  23 24 ) resistor r=75.9786 //w=0.187 //l=1.11 //layer=li \
 //thickness=0.1 //x=6.04 //y=2.4 //x2=6.04 //y2=3.51
r1019 (  23 39 ) resistor r=9.58289 //w=0.187 //l=0.14 //layer=li \
 //thickness=0.1 //x=6.04 //y=2.4 //x2=6.04 //y2=2.26
r1020 (  22 37 ) resistor r=9.3 //w=0.17 //l=0.17 //layer=mcon //count=1 \
 //x=64.13 //y=4.62 //x2=64.13 //y2=4.62
r1021 (  20 35 ) resistor r=9.3 //w=0.17 //l=0.17 //layer=mcon //count=1 \
 //x=54.88 //y=4.62 //x2=54.88 //y2=4.62
r1022 (  18 33 ) resistor r=9.3 //w=0.17 //l=0.17 //layer=mcon //count=1 \
 //x=39.71 //y=4.62 //x2=39.71 //y2=4.62
r1023 (  16 31 ) resistor r=9.3 //w=0.17 //l=0.17 //layer=mcon //count=1 \
 //x=30.46 //y=4.62 //x2=30.46 //y2=4.62
r1024 (  14 29 ) resistor r=9.3 //w=0.17 //l=0.17 //layer=mcon //count=1 \
 //x=15.29 //y=4.62 //x2=15.29 //y2=4.62
r1025 (  12 26 ) resistor r=9.3 //w=0.17 //l=0.17 //layer=mcon //count=1 \
 //x=6.04 //y=4.62 //x2=6.04 //y2=4.62
r1026 (  10 20 ) resistor r=0.0880901 //w=0.191 //l=0.115 //layer=m1 \
 //thickness=0.36 //x=54.995 //y=4.62 //x2=54.88 //y2=4.62
r1027 (  9 22 ) resistor r=0.0717383 //w=0.224 //l=0.115 //layer=m1 \
 //thickness=0.36 //x=64.015 //y=4.62 //x2=64.13 //y2=4.62
r1028 (  9 10 ) resistor r=8.60687 //w=0.131 //l=9.02 //layer=m1 \
 //thickness=0.36 //x=64.015 //y=4.62 //x2=54.995 //y2=4.62
r1029 (  8 18 ) resistor r=0.0880901 //w=0.191 //l=0.115 //layer=m1 \
 //thickness=0.36 //x=39.825 //y=4.62 //x2=39.71 //y2=4.62
r1030 (  7 20 ) resistor r=0.0880901 //w=0.191 //l=0.115 //layer=m1 \
 //thickness=0.36 //x=54.765 //y=4.62 //x2=54.88 //y2=4.62
r1031 (  7 8 ) resistor r=14.2557 //w=0.131 //l=14.94 //layer=m1 \
 //thickness=0.36 //x=54.765 //y=4.62 //x2=39.825 //y2=4.62
r1032 (  6 16 ) resistor r=0.0880901 //w=0.191 //l=0.115 //layer=m1 \
 //thickness=0.36 //x=30.575 //y=4.62 //x2=30.46 //y2=4.62
r1033 (  5 18 ) resistor r=0.0880901 //w=0.191 //l=0.115 //layer=m1 \
 //thickness=0.36 //x=39.595 //y=4.62 //x2=39.71 //y2=4.62
r1034 (  5 6 ) resistor r=8.60687 //w=0.131 //l=9.02 //layer=m1 \
 //thickness=0.36 //x=39.595 //y=4.62 //x2=30.575 //y2=4.62
r1035 (  4 14 ) resistor r=0.0880901 //w=0.191 //l=0.115 //layer=m1 \
 //thickness=0.36 //x=15.405 //y=4.62 //x2=15.29 //y2=4.62
r1036 (  3 16 ) resistor r=0.0880901 //w=0.191 //l=0.115 //layer=m1 \
 //thickness=0.36 //x=30.345 //y=4.62 //x2=30.46 //y2=4.62
r1037 (  3 4 ) resistor r=14.2557 //w=0.131 //l=14.94 //layer=m1 \
 //thickness=0.36 //x=30.345 //y=4.62 //x2=15.405 //y2=4.62
r1038 (  2 12 ) resistor r=0.0717383 //w=0.224 //l=0.115 //layer=m1 \
 //thickness=0.36 //x=6.155 //y=4.62 //x2=6.04 //y2=4.62
r1039 (  1 14 ) resistor r=0.0880901 //w=0.191 //l=0.115 //layer=m1 \
 //thickness=0.36 //x=15.175 //y=4.62 //x2=15.29 //y2=4.62
r1040 (  1 2 ) resistor r=8.60687 //w=0.131 //l=9.02 //layer=m1 \
 //thickness=0.36 //x=15.175 //y=4.62 //x2=6.155 //y2=4.62
ends PM_TMRDFFSNQNX1\%CLK

subckt PM_TMRDFFSNQNX1\%noxref_17 ( 1 2 3 4 11 13 23 24 31 39 45 46 50 52 61 \
 62 64 65 67 68 69 70 71 72 73 74 75 80 82 84 90 91 92 93 94 95 99 101 104 105 \
 110 111 114 128 131 133 134 135 )
c291 ( 135 0 ) capacitor c=0.023087f //x=55.805 //y=5.2
c292 ( 134 0 ) capacitor c=0.023519f //x=54.925 //y=5.2
c293 ( 133 0 ) capacitor c=0.0224735f //x=54.045 //y=5.2
c294 ( 131 0 ) capacitor c=0.00853354f //x=56.055 //y=1.095
c295 ( 128 0 ) capacitor c=0.0597793f //x=66.72 //y=4.88
c296 ( 114 0 ) capacitor c=0.0331095f //x=51.21 //y=4.88
c297 ( 111 0 ) capacitor c=0.0279499f //x=51.18 //y=2.095
c298 ( 110 0 ) capacitor c=0.0421676f //x=51.18 //y=2.26
c299 ( 105 0 ) capacitor c=0.0318948f //x=67.055 //y=1.39
c300 ( 104 0 ) capacitor c=0.0187384f //x=67.055 //y=1.045
c301 ( 101 0 ) capacitor c=0.0141798f //x=66.9 //y=1.545
c302 ( 99 0 ) capacitor c=0.0149844f //x=66.9 //y=0.89
c303 ( 95 0 ) capacitor c=0.0813322f //x=66.525 //y=2.095
c304 ( 94 0 ) capacitor c=0.0229267f //x=66.525 //y=1.7
c305 ( 93 0 ) capacitor c=0.0234352f //x=66.525 //y=1.39
c306 ( 92 0 ) capacitor c=0.0199343f //x=66.525 //y=1.045
c307 ( 91 0 ) capacitor c=0.0429696f //x=51.745 //y=1.43
c308 ( 90 0 ) capacitor c=0.0192208f //x=51.745 //y=1.085
c309 ( 84 0 ) capacitor c=0.0148884f //x=51.59 //y=1.585
c310 ( 82 0 ) capacitor c=0.0157803f //x=51.59 //y=0.93
c311 ( 80 0 ) capacitor c=0.0295235f //x=51.585 //y=4.97
c312 ( 75 0 ) capacitor c=0.0205163f //x=51.215 //y=1.74
c313 ( 74 0 ) capacitor c=0.0168481f //x=51.215 //y=1.43
c314 ( 73 0 ) capacitor c=0.0174783f //x=51.215 //y=1.085
c315 ( 72 0 ) capacitor c=0.110275f //x=67.06 //y=6.2
c316 ( 71 0 ) capacitor c=0.154305f //x=66.62 //y=6.2
c317 ( 70 0 ) capacitor c=0.15358f //x=51.66 //y=6.2
c318 ( 69 0 ) capacitor c=0.110281f //x=51.22 //y=6.2
c319 ( 65 0 ) capacitor c=0.0715637f //x=56.727 //y=4.085
c320 ( 64 0 ) capacitor c=0.0101843f //x=56.725 //y=4.25
c321 ( 62 0 ) capacitor c=0.00106608f //x=55.95 //y=5.335
c322 ( 61 0 ) capacitor c=0.00207162f //x=55.07 //y=5.335
c323 ( 52 0 ) capacitor c=0.0878627f //x=66.72 //y=2.26
c324 ( 50 0 ) capacitor c=0.0236247f //x=56.73 //y=5.25
c325 ( 46 0 ) capacitor c=0.00398962f //x=56.33 //y=1.845
c326 ( 45 0 ) capacitor c=0.0135805f //x=56.645 //y=1.845
c327 ( 39 0 ) capacitor c=0.0281378f //x=56.645 //y=5.335
c328 ( 31 0 ) capacitor c=0.0176454f //x=55.865 //y=5.335
c329 ( 24 0 ) capacitor c=0.00332903f //x=54.275 //y=5.335
c330 ( 23 0 ) capacitor c=0.014837f //x=54.985 //y=5.335
c331 ( 13 0 ) capacitor c=0.0676664f //x=51.18 //y=2.26
c332 ( 11 0 ) capacitor c=0.00453889f //x=51.18 //y=4.715
c333 ( 4 0 ) capacitor c=0.00551102f //x=56.84 //y=4.25
c334 ( 3 0 ) capacitor c=0.173174f //x=66.605 //y=4.25
c335 ( 2 0 ) capacitor c=0.0100678f //x=51.295 //y=4.25
c336 ( 1 0 ) capacitor c=0.0882171f //x=56.61 //y=4.25
r337 (  126 128 ) resistor r=20.6867 //w=0.233 //l=0.1 //layer=ply \
 //thickness=0.18 //x=66.62 //y=4.88 //x2=66.72 //y2=4.88
r338 (  116 117 ) resistor r=32.4568 //w=0.214 //l=0.075 //layer=ply \
 //thickness=0.18 //x=51.21 //y=4.97 //x2=51.21 //y2=5.045
r339 (  114 116 ) resistor r=20.271 //w=0.214 //l=0.09 //layer=ply \
 //thickness=0.18 //x=51.21 //y=4.88 //x2=51.21 //y2=4.97
r340 (  110 111 ) resistor r=52.7279 //w=0.214 //l=0.165 //layer=ply \
 //thickness=0.18 //x=51.18 //y=2.26 //x2=51.18 //y2=2.095
r341 (  106 128 ) resistor r=70.3348 //w=0.233 //l=0.414367 //layer=ply \
 //thickness=0.18 //x=67.06 //y=5.045 //x2=66.72 //y2=4.88
r342 (  105 130 ) resistor r=45.1352 //w=0.168 //l=0.173853 //layer=ply \
 //thickness=0.18 //x=67.055 //y=1.39 //x2=67.015 //y2=1.545
r343 (  104 129 ) resistor r=45.1352 //w=0.168 //l=0.173853 //layer=ply \
 //thickness=0.18 //x=67.055 //y=1.045 //x2=67.015 //y2=0.89
r344 (  104 105 ) resistor r=176.904 //w=0.094 //l=0.345 //layer=ply \
 //thickness=0.18 //x=67.055 //y=1.045 //x2=67.055 //y2=1.39
r345 (  102 125 ) resistor r=10.701 //w=0.21 //l=0.115 //layer=ply \
 //thickness=0.18 //x=66.68 //y=1.545 //x2=66.565 //y2=1.545
r346 (  101 130 ) resistor r=5.52526 //w=0.168 //l=0.115 //layer=ply \
 //thickness=0.18 //x=66.9 //y=1.545 //x2=67.015 //y2=1.545
r347 (  100 124 ) resistor r=5.52526 //w=0.168 //l=0.115 //layer=ply \
 //thickness=0.18 //x=66.68 //y=0.89 //x2=66.565 //y2=0.89
r348 (  99 129 ) resistor r=5.52526 //w=0.168 //l=0.115 //layer=ply \
 //thickness=0.18 //x=66.9 //y=0.89 //x2=67.015 //y2=0.89
r349 (  99 100 ) resistor r=112.809 //w=0.094 //l=0.22 //layer=ply \
 //thickness=0.18 //x=66.9 //y=0.89 //x2=66.68 //y2=0.89
r350 (  96 126 ) resistor r=13.0941 //w=0.233 //l=0.165 //layer=ply \
 //thickness=0.18 //x=66.62 //y=5.045 //x2=66.62 //y2=4.88
r351 (  95 123 ) resistor r=34.8111 //w=0.27 //l=0.264953 //layer=ply \
 //thickness=0.18 //x=66.525 //y=2.095 //x2=66.72 //y2=2.26
r352 (  94 125 ) resistor r=39.5823 //w=0.21 //l=0.173853 //layer=ply \
 //thickness=0.18 //x=66.525 //y=1.7 //x2=66.565 //y2=1.545
r353 (  94 95 ) resistor r=202.543 //w=0.094 //l=0.395 //layer=ply \
 //thickness=0.18 //x=66.525 //y=1.7 //x2=66.525 //y2=2.095
r354 (  93 125 ) resistor r=39.5823 //w=0.21 //l=0.173853 //layer=ply \
 //thickness=0.18 //x=66.525 //y=1.39 //x2=66.565 //y2=1.545
r355 (  92 124 ) resistor r=45.1352 //w=0.168 //l=0.173853 //layer=ply \
 //thickness=0.18 //x=66.525 //y=1.045 //x2=66.565 //y2=0.89
r356 (  92 93 ) resistor r=176.904 //w=0.094 //l=0.345 //layer=ply \
 //thickness=0.18 //x=66.525 //y=1.045 //x2=66.525 //y2=1.39
r357 (  91 121 ) resistor r=45.1352 //w=0.168 //l=0.173853 //layer=ply \
 //thickness=0.18 //x=51.745 //y=1.43 //x2=51.705 //y2=1.585
r358 (  90 120 ) resistor r=45.1352 //w=0.168 //l=0.173853 //layer=ply \
 //thickness=0.18 //x=51.745 //y=1.085 //x2=51.705 //y2=0.93
r359 (  90 91 ) resistor r=176.904 //w=0.094 //l=0.345 //layer=ply \
 //thickness=0.18 //x=51.745 //y=1.085 //x2=51.745 //y2=1.43
r360 (  85 119 ) resistor r=10.701 //w=0.21 //l=0.115 //layer=ply \
 //thickness=0.18 //x=51.37 //y=1.585 //x2=51.255 //y2=1.585
r361 (  84 121 ) resistor r=5.52526 //w=0.168 //l=0.115 //layer=ply \
 //thickness=0.18 //x=51.59 //y=1.585 //x2=51.705 //y2=1.585
r362 (  83 118 ) resistor r=5.52526 //w=0.168 //l=0.115 //layer=ply \
 //thickness=0.18 //x=51.37 //y=0.93 //x2=51.255 //y2=0.93
r363 (  82 120 ) resistor r=5.52526 //w=0.168 //l=0.115 //layer=ply \
 //thickness=0.18 //x=51.59 //y=0.93 //x2=51.705 //y2=0.93
r364 (  82 83 ) resistor r=112.809 //w=0.094 //l=0.22 //layer=ply \
 //thickness=0.18 //x=51.59 //y=0.93 //x2=51.37 //y2=0.93
r365 (  81 116 ) resistor r=16.5046 //w=0.27 //l=0.135 //layer=ply \
 //thickness=0.18 //x=51.345 //y=4.97 //x2=51.21 //y2=4.97
r366 (  80 87 ) resistor r=26.9307 //w=0.15 //l=0.106066 //layer=ply \
 //thickness=0.18 //x=51.585 //y=4.97 //x2=51.66 //y2=5.045
r367 (  80 81 ) resistor r=123.064 //w=0.094 //l=0.24 //layer=ply \
 //thickness=0.18 //x=51.585 //y=4.97 //x2=51.345 //y2=4.97
r368 (  75 119 ) resistor r=39.5823 //w=0.21 //l=0.173853 //layer=ply \
 //thickness=0.18 //x=51.215 //y=1.74 //x2=51.255 //y2=1.585
r369 (  75 111 ) resistor r=182.032 //w=0.094 //l=0.355 //layer=ply \
 //thickness=0.18 //x=51.215 //y=1.74 //x2=51.215 //y2=2.095
r370 (  74 119 ) resistor r=39.5823 //w=0.21 //l=0.173853 //layer=ply \
 //thickness=0.18 //x=51.215 //y=1.43 //x2=51.255 //y2=1.585
r371 (  73 118 ) resistor r=45.1352 //w=0.168 //l=0.173853 //layer=ply \
 //thickness=0.18 //x=51.215 //y=1.085 //x2=51.255 //y2=0.93
r372 (  73 74 ) resistor r=176.904 //w=0.094 //l=0.345 //layer=ply \
 //thickness=0.18 //x=51.215 //y=1.085 //x2=51.215 //y2=1.43
r373 (  72 106 ) resistor r=592.245 //w=0.094 //l=1.155 //layer=ply \
 //thickness=0.18 //x=67.06 //y=6.2 //x2=67.06 //y2=5.045
r374 (  71 96 ) resistor r=592.245 //w=0.094 //l=1.155 //layer=ply \
 //thickness=0.18 //x=66.62 //y=6.2 //x2=66.62 //y2=5.045
r375 (  70 87 ) resistor r=592.245 //w=0.094 //l=1.155 //layer=ply \
 //thickness=0.18 //x=51.66 //y=6.2 //x2=51.66 //y2=5.045
r376 (  69 117 ) resistor r=592.245 //w=0.094 //l=1.155 //layer=ply \
 //thickness=0.18 //x=51.22 //y=6.2 //x2=51.22 //y2=5.045
r377 (  68 101 ) resistor r=56.4043 //w=0.094 //l=0.11 //layer=ply \
 //thickness=0.18 //x=66.79 //y=1.545 //x2=66.9 //y2=1.545
r378 (  68 102 ) resistor r=56.4043 //w=0.094 //l=0.11 //layer=ply \
 //thickness=0.18 //x=66.79 //y=1.545 //x2=66.68 //y2=1.545
r379 (  67 84 ) resistor r=56.4043 //w=0.094 //l=0.11 //layer=ply \
 //thickness=0.18 //x=51.48 //y=1.585 //x2=51.59 //y2=1.585
r380 (  67 85 ) resistor r=56.4043 //w=0.094 //l=0.11 //layer=ply \
 //thickness=0.18 //x=51.48 //y=1.585 //x2=51.37 //y2=1.585
r381 (  64 66 ) resistor r=11 //w=0.192 //l=0.165 //layer=li //thickness=0.1 \
 //x=56.727 //y=4.25 //x2=56.727 //y2=4.415
r382 (  64 65 ) resistor r=11 //w=0.192 //l=0.165 //layer=li //thickness=0.1 \
 //x=56.727 //y=4.25 //x2=56.727 //y2=4.085
r383 (  60 114 ) resistor r=152 //w=0.17 //l=0.17 //layer=licon //count=1 \
 //x=51.21 //y=4.88 //x2=51.21 //y2=4.88
r384 (  57 128 ) resistor r=152 //w=0.17 //l=0.17 //layer=licon //count=1 \
 //x=66.72 //y=4.88 //x2=66.72 //y2=4.88
r385 (  55 57 ) resistor r=43.123 //w=0.187 //l=0.63 //layer=li \
 //thickness=0.1 //x=66.72 //y=4.25 //x2=66.72 //y2=4.88
r386 (  52 123 ) resistor r=152 //w=0.17 //l=0.17 //layer=licon //count=1 \
 //x=66.72 //y=2.26 //x2=66.72 //y2=2.26
r387 (  52 55 ) resistor r=136.214 //w=0.187 //l=1.99 //layer=li \
 //thickness=0.1 //x=66.72 //y=2.26 //x2=66.72 //y2=4.25
r388 (  50 66 ) resistor r=57.1551 //w=0.187 //l=0.835 //layer=li \
 //thickness=0.1 //x=56.73 //y=5.25 //x2=56.73 //y2=4.415
r389 (  47 65 ) resistor r=147.508 //w=0.187 //l=2.155 //layer=li \
 //thickness=0.1 //x=56.73 //y=1.93 //x2=56.73 //y2=4.085
r390 (  45 47 ) resistor r=7.15173 //w=0.17 //l=0.120208 //layer=li \
 //thickness=0.1 //x=56.645 //y=1.845 //x2=56.73 //y2=1.93
r391 (  45 46 ) resistor r=21.5615 //w=0.187 //l=0.315 //layer=li \
 //thickness=0.1 //x=56.645 //y=1.845 //x2=56.33 //y2=1.845
r392 (  41 46 ) resistor r=7.15173 //w=0.17 //l=0.120208 //layer=li \
 //thickness=0.1 //x=56.245 //y=1.76 //x2=56.33 //y2=1.845
r393 (  41 131 ) resistor r=39.016 //w=0.187 //l=0.57 //layer=li \
 //thickness=0.1 //x=56.245 //y=1.76 //x2=56.245 //y2=1.19
r394 (  40 62 ) resistor r=5.4201 //w=0.17 //l=0.085 //layer=li \
 //thickness=0.1 //x=56.035 //y=5.335 //x2=55.95 //y2=5.335
r395 (  39 50 ) resistor r=7.15173 //w=0.17 //l=0.120208 //layer=li \
 //thickness=0.1 //x=56.645 //y=5.335 //x2=56.73 //y2=5.25
r396 (  39 40 ) resistor r=41.754 //w=0.187 //l=0.61 //layer=li \
 //thickness=0.1 //x=56.645 //y=5.335 //x2=56.035 //y2=5.335
r397 (  33 62 ) resistor r=1.40859 //w=0.34 //l=0.085 //layer=li \
 //thickness=0.1 //x=55.95 //y=5.42 //x2=55.95 //y2=5.335
r398 (  33 135 ) resistor r=33.1979 //w=0.187 //l=0.485 //layer=li \
 //thickness=0.1 //x=55.95 //y=5.42 //x2=55.95 //y2=5.905
r399 (  32 61 ) resistor r=5.4201 //w=0.17 //l=0.085 //layer=li \
 //thickness=0.1 //x=55.155 //y=5.335 //x2=55.07 //y2=5.335
r400 (  31 62 ) resistor r=5.4201 //w=0.17 //l=0.085 //layer=li \
 //thickness=0.1 //x=55.865 //y=5.335 //x2=55.95 //y2=5.335
r401 (  31 32 ) resistor r=48.5989 //w=0.187 //l=0.71 //layer=li \
 //thickness=0.1 //x=55.865 //y=5.335 //x2=55.155 //y2=5.335
r402 (  25 61 ) resistor r=1.40859 //w=0.34 //l=0.085 //layer=li \
 //thickness=0.1 //x=55.07 //y=5.42 //x2=55.07 //y2=5.335
r403 (  25 134 ) resistor r=33.1979 //w=0.187 //l=0.485 //layer=li \
 //thickness=0.1 //x=55.07 //y=5.42 //x2=55.07 //y2=5.905
r404 (  23 61 ) resistor r=5.4201 //w=0.17 //l=0.085 //layer=li \
 //thickness=0.1 //x=54.985 //y=5.335 //x2=55.07 //y2=5.335
r405 (  23 24 ) resistor r=48.5989 //w=0.187 //l=0.71 //layer=li \
 //thickness=0.1 //x=54.985 //y=5.335 //x2=54.275 //y2=5.335
r406 (  17 24 ) resistor r=7.15173 //w=0.17 //l=0.120208 //layer=li \
 //thickness=0.1 //x=54.19 //y=5.42 //x2=54.275 //y2=5.335
r407 (  17 133 ) resistor r=33.1979 //w=0.187 //l=0.485 //layer=li \
 //thickness=0.1 //x=54.19 //y=5.42 //x2=54.19 //y2=5.905
r408 (  13 110 ) resistor r=152 //w=0.17 //l=0.17 //layer=licon //count=1 \
 //x=51.18 //y=2.26 //x2=51.18 //y2=2.26
r409 (  13 16 ) resistor r=136.214 //w=0.187 //l=1.99 //layer=li \
 //thickness=0.1 //x=51.18 //y=2.26 //x2=51.18 //y2=4.25
r410 (  11 60 ) resistor r=11.4737 //w=0.186 //l=0.172337 //layer=li \
 //thickness=0.1 //x=51.18 //y=4.715 //x2=51.195 //y2=4.88
r411 (  11 16 ) resistor r=31.8289 //w=0.187 //l=0.465 //layer=li \
 //thickness=0.1 //x=51.18 //y=4.715 //x2=51.18 //y2=4.25
r412 (  10 55 ) resistor r=9.3 //w=0.17 //l=0.17 //layer=mcon //count=1 \
 //x=66.72 //y=4.25 //x2=66.72 //y2=4.25
r413 (  8 64 ) resistor r=9.3 //w=0.17 //l=0.17 //layer=mcon //count=1 \
 //x=56.725 //y=4.25 //x2=56.725 //y2=4.25
r414 (  6 16 ) resistor r=9.3 //w=0.17 //l=0.17 //layer=mcon //count=1 \
 //x=51.18 //y=4.25 //x2=51.18 //y2=4.25
r415 (  4 8 ) resistor r=0.0880901 //w=0.191 //l=0.115 //layer=m1 \
 //thickness=0.36 //x=56.84 //y=4.25 //x2=56.725 //y2=4.25
r416 (  3 10 ) resistor r=0.0717383 //w=0.224 //l=0.115 //layer=m1 \
 //thickness=0.36 //x=66.605 //y=4.25 //x2=66.72 //y2=4.25
r417 (  3 4 ) resistor r=9.31775 //w=0.131 //l=9.765 //layer=m1 \
 //thickness=0.36 //x=66.605 //y=4.25 //x2=56.84 //y2=4.25
r418 (  2 6 ) resistor r=0.0717383 //w=0.224 //l=0.115 //layer=m1 \
 //thickness=0.36 //x=51.295 //y=4.25 //x2=51.18 //y2=4.25
r419 (  1 8 ) resistor r=0.0880901 //w=0.191 //l=0.115 //layer=m1 \
 //thickness=0.36 //x=56.61 //y=4.25 //x2=56.725 //y2=4.25
r420 (  1 2 ) resistor r=5.07156 //w=0.131 //l=5.315 //layer=m1 \
 //thickness=0.36 //x=56.61 //y=4.25 //x2=51.295 //y2=4.25
ends PM_TMRDFFSNQNX1\%noxref_17

subckt PM_TMRDFFSNQNX1\%SN ( 1 2 3 4 5 6 7 8 9 10 23 24 25 26 27 28 29 30 31 \
 33 43 52 60 68 77 84 85 86 87 88 89 90 91 92 93 94 95 96 97 98 99 100 101 102 \
 103 104 106 112 113 114 115 116 121 122 123 125 131 132 133 134 135 140 141 \
 142 144 150 151 152 153 154 159 160 161 163 169 170 171 172 173 178 179 180 \
 182 188 189 190 191 192 197 198 199 201 207 208 209 210 211 219 230 241 252 \
 263 274 )
c818 ( 274 0 ) capacitor c=0.0337007f //x=71.16 //y=4.88
c819 ( 263 0 ) capacitor c=0.0335551f //x=59.69 //y=4.88
c820 ( 252 0 ) capacitor c=0.0335551f //x=46.74 //y=4.88
c821 ( 241 0 ) capacitor c=0.0335551f //x=35.27 //y=4.88
c822 ( 230 0 ) capacitor c=0.0335551f //x=22.32 //y=4.88
c823 ( 219 0 ) capacitor c=0.0335551f //x=10.85 //y=4.88
c824 ( 211 0 ) capacitor c=0.0245352f //x=71.495 //y=4.97
c825 ( 210 0 ) capacitor c=0.0827272f //x=71.25 //y=2.095
c826 ( 209 0 ) capacitor c=0.0170266f //x=71.25 //y=1.63
c827 ( 208 0 ) capacitor c=0.018609f //x=71.25 //y=1.4
c828 ( 207 0 ) capacitor c=0.0187309f //x=71.25 //y=1.09
c829 ( 201 0 ) capacitor c=0.014725f //x=71.095 //y=1.555
c830 ( 199 0 ) capacitor c=0.0146567f //x=71.095 //y=0.935
c831 ( 198 0 ) capacitor c=0.0335408f //x=70.725 //y=1.4
c832 ( 197 0 ) capacitor c=0.0173761f //x=70.725 //y=1.09
c833 ( 192 0 ) capacitor c=0.0245352f //x=60.025 //y=4.97
c834 ( 191 0 ) capacitor c=0.0825033f //x=59.78 //y=2.095
c835 ( 190 0 ) capacitor c=0.0170266f //x=59.78 //y=1.63
c836 ( 189 0 ) capacitor c=0.018609f //x=59.78 //y=1.4
c837 ( 188 0 ) capacitor c=0.0187309f //x=59.78 //y=1.09
c838 ( 182 0 ) capacitor c=0.014725f //x=59.625 //y=1.555
c839 ( 180 0 ) capacitor c=0.0146567f //x=59.625 //y=0.935
c840 ( 179 0 ) capacitor c=0.0335408f //x=59.255 //y=1.4
c841 ( 178 0 ) capacitor c=0.0173761f //x=59.255 //y=1.09
c842 ( 173 0 ) capacitor c=0.0245352f //x=47.075 //y=4.97
c843 ( 172 0 ) capacitor c=0.0825033f //x=46.83 //y=2.095
c844 ( 171 0 ) capacitor c=0.0170266f //x=46.83 //y=1.63
c845 ( 170 0 ) capacitor c=0.018609f //x=46.83 //y=1.4
c846 ( 169 0 ) capacitor c=0.0187309f //x=46.83 //y=1.09
c847 ( 163 0 ) capacitor c=0.014725f //x=46.675 //y=1.555
c848 ( 161 0 ) capacitor c=0.0146567f //x=46.675 //y=0.935
c849 ( 160 0 ) capacitor c=0.0335408f //x=46.305 //y=1.4
c850 ( 159 0 ) capacitor c=0.0173761f //x=46.305 //y=1.09
c851 ( 154 0 ) capacitor c=0.0245352f //x=35.605 //y=4.97
c852 ( 153 0 ) capacitor c=0.0825033f //x=35.36 //y=2.095
c853 ( 152 0 ) capacitor c=0.0170266f //x=35.36 //y=1.63
c854 ( 151 0 ) capacitor c=0.018609f //x=35.36 //y=1.4
c855 ( 150 0 ) capacitor c=0.0187309f //x=35.36 //y=1.09
c856 ( 144 0 ) capacitor c=0.014725f //x=35.205 //y=1.555
c857 ( 142 0 ) capacitor c=0.0146567f //x=35.205 //y=0.935
c858 ( 141 0 ) capacitor c=0.0335408f //x=34.835 //y=1.4
c859 ( 140 0 ) capacitor c=0.0173761f //x=34.835 //y=1.09
c860 ( 135 0 ) capacitor c=0.0245352f //x=22.655 //y=4.97
c861 ( 134 0 ) capacitor c=0.0825033f //x=22.41 //y=2.095
c862 ( 133 0 ) capacitor c=0.0170266f //x=22.41 //y=1.63
c863 ( 132 0 ) capacitor c=0.018609f //x=22.41 //y=1.4
c864 ( 131 0 ) capacitor c=0.0187309f //x=22.41 //y=1.09
c865 ( 125 0 ) capacitor c=0.014725f //x=22.255 //y=1.555
c866 ( 123 0 ) capacitor c=0.0146567f //x=22.255 //y=0.935
c867 ( 122 0 ) capacitor c=0.0335408f //x=21.885 //y=1.4
c868 ( 121 0 ) capacitor c=0.0173761f //x=21.885 //y=1.09
c869 ( 116 0 ) capacitor c=0.0245352f //x=11.185 //y=4.97
c870 ( 115 0 ) capacitor c=0.0826756f //x=10.94 //y=2.095
c871 ( 114 0 ) capacitor c=0.0170266f //x=10.94 //y=1.63
c872 ( 113 0 ) capacitor c=0.018609f //x=10.94 //y=1.4
c873 ( 112 0 ) capacitor c=0.0187309f //x=10.94 //y=1.09
c874 ( 106 0 ) capacitor c=0.014725f //x=10.785 //y=1.555
c875 ( 104 0 ) capacitor c=0.0146567f //x=10.785 //y=0.935
c876 ( 103 0 ) capacitor c=0.0335408f //x=10.415 //y=1.4
c877 ( 102 0 ) capacitor c=0.0173761f //x=10.415 //y=1.09
c878 ( 101 0 ) capacitor c=0.110114f //x=71.57 //y=6.2
c879 ( 100 0 ) capacitor c=0.11012f //x=71.13 //y=6.2
c880 ( 99 0 ) capacitor c=0.110114f //x=60.1 //y=6.2
c881 ( 98 0 ) capacitor c=0.11012f //x=59.66 //y=6.2
c882 ( 97 0 ) capacitor c=0.110114f //x=47.15 //y=6.2
c883 ( 96 0 ) capacitor c=0.11012f //x=46.71 //y=6.2
c884 ( 95 0 ) capacitor c=0.110114f //x=35.68 //y=6.2
c885 ( 94 0 ) capacitor c=0.11012f //x=35.24 //y=6.2
c886 ( 93 0 ) capacitor c=0.110114f //x=22.73 //y=6.2
c887 ( 92 0 ) capacitor c=0.11012f //x=22.29 //y=6.2
c888 ( 91 0 ) capacitor c=0.110114f //x=11.26 //y=6.2
c889 ( 90 0 ) capacitor c=0.11012f //x=10.82 //y=6.2
c890 ( 77 0 ) capacitor c=0.0905446f //x=71.16 //y=2.26
c891 ( 68 0 ) capacitor c=0.0895052f //x=59.69 //y=2.26
c892 ( 60 0 ) capacitor c=0.0878512f //x=46.74 //y=2.26
c893 ( 52 0 ) capacitor c=0.0895052f //x=35.27 //y=2.26
c894 ( 43 0 ) capacitor c=0.0904947f //x=22.32 //y=2.26
c895 ( 33 0 ) capacitor c=0.0921487f //x=10.85 //y=2.26
c896 ( 10 0 ) capacitor c=0.00692137f //x=59.805 //y=2.4
c897 ( 9 0 ) capacitor c=0.263633f //x=71.045 //y=2.4
c898 ( 8 0 ) capacitor c=0.00666809f //x=46.855 //y=2.4
c899 ( 7 0 ) capacitor c=0.252177f //x=59.575 //y=2.4
c900 ( 6 0 ) capacitor c=0.00692137f //x=35.385 //y=2.4
c901 ( 5 0 ) capacitor c=0.237521f //x=46.625 //y=2.4
c902 ( 4 0 ) capacitor c=0.00692137f //x=22.435 //y=2.4
c903 ( 3 0 ) capacitor c=0.266406f //x=35.155 //y=2.4
c904 ( 2 0 ) capacitor c=0.0154797f //x=10.965 //y=2.4
c905 ( 1 0 ) capacitor c=0.248273f //x=22.205 //y=2.4
r906 (  276 277 ) resistor r=32.4568 //w=0.214 //l=0.075 //layer=ply \
 //thickness=0.18 //x=71.16 //y=4.97 //x2=71.16 //y2=5.045
r907 (  274 276 ) resistor r=20.271 //w=0.214 //l=0.09 //layer=ply \
 //thickness=0.18 //x=71.16 //y=4.88 //x2=71.16 //y2=4.97
r908 (  265 266 ) resistor r=32.4568 //w=0.214 //l=0.075 //layer=ply \
 //thickness=0.18 //x=59.69 //y=4.97 //x2=59.69 //y2=5.045
r909 (  263 265 ) resistor r=20.271 //w=0.214 //l=0.09 //layer=ply \
 //thickness=0.18 //x=59.69 //y=4.88 //x2=59.69 //y2=4.97
r910 (  254 255 ) resistor r=32.4568 //w=0.214 //l=0.075 //layer=ply \
 //thickness=0.18 //x=46.74 //y=4.97 //x2=46.74 //y2=5.045
r911 (  252 254 ) resistor r=20.271 //w=0.214 //l=0.09 //layer=ply \
 //thickness=0.18 //x=46.74 //y=4.88 //x2=46.74 //y2=4.97
r912 (  243 244 ) resistor r=32.4568 //w=0.214 //l=0.075 //layer=ply \
 //thickness=0.18 //x=35.27 //y=4.97 //x2=35.27 //y2=5.045
r913 (  241 243 ) resistor r=20.271 //w=0.214 //l=0.09 //layer=ply \
 //thickness=0.18 //x=35.27 //y=4.88 //x2=35.27 //y2=4.97
r914 (  232 233 ) resistor r=32.4568 //w=0.214 //l=0.075 //layer=ply \
 //thickness=0.18 //x=22.32 //y=4.97 //x2=22.32 //y2=5.045
r915 (  230 232 ) resistor r=20.271 //w=0.214 //l=0.09 //layer=ply \
 //thickness=0.18 //x=22.32 //y=4.88 //x2=22.32 //y2=4.97
r916 (  221 222 ) resistor r=32.4568 //w=0.214 //l=0.075 //layer=ply \
 //thickness=0.18 //x=10.85 //y=4.97 //x2=10.85 //y2=5.045
r917 (  219 221 ) resistor r=20.271 //w=0.214 //l=0.09 //layer=ply \
 //thickness=0.18 //x=10.85 //y=4.88 //x2=10.85 //y2=4.97
r918 (  212 276 ) resistor r=16.5046 //w=0.27 //l=0.135 //layer=ply \
 //thickness=0.18 //x=71.295 //y=4.97 //x2=71.16 //y2=4.97
r919 (  211 213 ) resistor r=26.9307 //w=0.15 //l=0.106066 //layer=ply \
 //thickness=0.18 //x=71.495 //y=4.97 //x2=71.57 //y2=5.045
r920 (  211 212 ) resistor r=102.553 //w=0.094 //l=0.2 //layer=ply \
 //thickness=0.18 //x=71.495 //y=4.97 //x2=71.295 //y2=4.97
r921 (  210 281 ) resistor r=38.6777 //w=0.284 //l=0.198997 //layer=ply \
 //thickness=0.18 //x=71.25 //y=2.095 //x2=71.175 //y2=2.26
r922 (  209 279 ) resistor r=21.2976 //w=0.217 //l=0.0928709 //layer=ply \
 //thickness=0.18 //x=71.25 //y=1.63 //x2=71.21 //y2=1.555
r923 (  209 210 ) resistor r=238.436 //w=0.094 //l=0.465 //layer=ply \
 //thickness=0.18 //x=71.25 //y=1.63 //x2=71.25 //y2=2.095
r924 (  208 279 ) resistor r=39.0671 //w=0.217 //l=0.173853 //layer=ply \
 //thickness=0.18 //x=71.25 //y=1.4 //x2=71.21 //y2=1.555
r925 (  207 278 ) resistor r=45.1352 //w=0.168 //l=0.173853 //layer=ply \
 //thickness=0.18 //x=71.25 //y=1.09 //x2=71.21 //y2=0.935
r926 (  207 208 ) resistor r=158.957 //w=0.094 //l=0.31 //layer=ply \
 //thickness=0.18 //x=71.25 //y=1.09 //x2=71.25 //y2=1.4
r927 (  202 272 ) resistor r=5.52526 //w=0.168 //l=0.115 //layer=ply \
 //thickness=0.18 //x=70.88 //y=1.555 //x2=70.765 //y2=1.555
r928 (  201 279 ) resistor r=11.4558 //w=0.217 //l=0.115 //layer=ply \
 //thickness=0.18 //x=71.095 //y=1.555 //x2=71.21 //y2=1.555
r929 (  200 271 ) resistor r=5.52526 //w=0.168 //l=0.115 //layer=ply \
 //thickness=0.18 //x=70.88 //y=0.935 //x2=70.765 //y2=0.935
r930 (  199 278 ) resistor r=5.52526 //w=0.168 //l=0.115 //layer=ply \
 //thickness=0.18 //x=71.095 //y=0.935 //x2=71.21 //y2=0.935
r931 (  199 200 ) resistor r=110.245 //w=0.094 //l=0.215 //layer=ply \
 //thickness=0.18 //x=71.095 //y=0.935 //x2=70.88 //y2=0.935
r932 (  198 272 ) resistor r=45.1352 //w=0.168 //l=0.173853 //layer=ply \
 //thickness=0.18 //x=70.725 //y=1.4 //x2=70.765 //y2=1.555
r933 (  197 271 ) resistor r=45.1352 //w=0.168 //l=0.173853 //layer=ply \
 //thickness=0.18 //x=70.725 //y=1.09 //x2=70.765 //y2=0.935
r934 (  197 198 ) resistor r=158.957 //w=0.094 //l=0.31 //layer=ply \
 //thickness=0.18 //x=70.725 //y=1.09 //x2=70.725 //y2=1.4
r935 (  193 265 ) resistor r=16.5046 //w=0.27 //l=0.135 //layer=ply \
 //thickness=0.18 //x=59.825 //y=4.97 //x2=59.69 //y2=4.97
r936 (  192 194 ) resistor r=26.9307 //w=0.15 //l=0.106066 //layer=ply \
 //thickness=0.18 //x=60.025 //y=4.97 //x2=60.1 //y2=5.045
r937 (  192 193 ) resistor r=102.553 //w=0.094 //l=0.2 //layer=ply \
 //thickness=0.18 //x=60.025 //y=4.97 //x2=59.825 //y2=4.97
r938 (  191 270 ) resistor r=38.6777 //w=0.284 //l=0.198997 //layer=ply \
 //thickness=0.18 //x=59.78 //y=2.095 //x2=59.705 //y2=2.26
r939 (  190 268 ) resistor r=21.2976 //w=0.217 //l=0.0928709 //layer=ply \
 //thickness=0.18 //x=59.78 //y=1.63 //x2=59.74 //y2=1.555
r940 (  190 191 ) resistor r=238.436 //w=0.094 //l=0.465 //layer=ply \
 //thickness=0.18 //x=59.78 //y=1.63 //x2=59.78 //y2=2.095
r941 (  189 268 ) resistor r=39.0671 //w=0.217 //l=0.173853 //layer=ply \
 //thickness=0.18 //x=59.78 //y=1.4 //x2=59.74 //y2=1.555
r942 (  188 267 ) resistor r=45.1352 //w=0.168 //l=0.173853 //layer=ply \
 //thickness=0.18 //x=59.78 //y=1.09 //x2=59.74 //y2=0.935
r943 (  188 189 ) resistor r=158.957 //w=0.094 //l=0.31 //layer=ply \
 //thickness=0.18 //x=59.78 //y=1.09 //x2=59.78 //y2=1.4
r944 (  183 261 ) resistor r=5.52526 //w=0.168 //l=0.115 //layer=ply \
 //thickness=0.18 //x=59.41 //y=1.555 //x2=59.295 //y2=1.555
r945 (  182 268 ) resistor r=11.4558 //w=0.217 //l=0.115 //layer=ply \
 //thickness=0.18 //x=59.625 //y=1.555 //x2=59.74 //y2=1.555
r946 (  181 260 ) resistor r=5.52526 //w=0.168 //l=0.115 //layer=ply \
 //thickness=0.18 //x=59.41 //y=0.935 //x2=59.295 //y2=0.935
r947 (  180 267 ) resistor r=5.52526 //w=0.168 //l=0.115 //layer=ply \
 //thickness=0.18 //x=59.625 //y=0.935 //x2=59.74 //y2=0.935
r948 (  180 181 ) resistor r=110.245 //w=0.094 //l=0.215 //layer=ply \
 //thickness=0.18 //x=59.625 //y=0.935 //x2=59.41 //y2=0.935
r949 (  179 261 ) resistor r=45.1352 //w=0.168 //l=0.173853 //layer=ply \
 //thickness=0.18 //x=59.255 //y=1.4 //x2=59.295 //y2=1.555
r950 (  178 260 ) resistor r=45.1352 //w=0.168 //l=0.173853 //layer=ply \
 //thickness=0.18 //x=59.255 //y=1.09 //x2=59.295 //y2=0.935
r951 (  178 179 ) resistor r=158.957 //w=0.094 //l=0.31 //layer=ply \
 //thickness=0.18 //x=59.255 //y=1.09 //x2=59.255 //y2=1.4
r952 (  174 254 ) resistor r=16.5046 //w=0.27 //l=0.135 //layer=ply \
 //thickness=0.18 //x=46.875 //y=4.97 //x2=46.74 //y2=4.97
r953 (  173 175 ) resistor r=26.9307 //w=0.15 //l=0.106066 //layer=ply \
 //thickness=0.18 //x=47.075 //y=4.97 //x2=47.15 //y2=5.045
r954 (  173 174 ) resistor r=102.553 //w=0.094 //l=0.2 //layer=ply \
 //thickness=0.18 //x=47.075 //y=4.97 //x2=46.875 //y2=4.97
r955 (  172 259 ) resistor r=38.6777 //w=0.284 //l=0.198997 //layer=ply \
 //thickness=0.18 //x=46.83 //y=2.095 //x2=46.755 //y2=2.26
r956 (  171 257 ) resistor r=21.2976 //w=0.217 //l=0.0928709 //layer=ply \
 //thickness=0.18 //x=46.83 //y=1.63 //x2=46.79 //y2=1.555
r957 (  171 172 ) resistor r=238.436 //w=0.094 //l=0.465 //layer=ply \
 //thickness=0.18 //x=46.83 //y=1.63 //x2=46.83 //y2=2.095
r958 (  170 257 ) resistor r=39.0671 //w=0.217 //l=0.173853 //layer=ply \
 //thickness=0.18 //x=46.83 //y=1.4 //x2=46.79 //y2=1.555
r959 (  169 256 ) resistor r=45.1352 //w=0.168 //l=0.173853 //layer=ply \
 //thickness=0.18 //x=46.83 //y=1.09 //x2=46.79 //y2=0.935
r960 (  169 170 ) resistor r=158.957 //w=0.094 //l=0.31 //layer=ply \
 //thickness=0.18 //x=46.83 //y=1.09 //x2=46.83 //y2=1.4
r961 (  164 250 ) resistor r=5.52526 //w=0.168 //l=0.115 //layer=ply \
 //thickness=0.18 //x=46.46 //y=1.555 //x2=46.345 //y2=1.555
r962 (  163 257 ) resistor r=11.4558 //w=0.217 //l=0.115 //layer=ply \
 //thickness=0.18 //x=46.675 //y=1.555 //x2=46.79 //y2=1.555
r963 (  162 249 ) resistor r=5.52526 //w=0.168 //l=0.115 //layer=ply \
 //thickness=0.18 //x=46.46 //y=0.935 //x2=46.345 //y2=0.935
r964 (  161 256 ) resistor r=5.52526 //w=0.168 //l=0.115 //layer=ply \
 //thickness=0.18 //x=46.675 //y=0.935 //x2=46.79 //y2=0.935
r965 (  161 162 ) resistor r=110.245 //w=0.094 //l=0.215 //layer=ply \
 //thickness=0.18 //x=46.675 //y=0.935 //x2=46.46 //y2=0.935
r966 (  160 250 ) resistor r=45.1352 //w=0.168 //l=0.173853 //layer=ply \
 //thickness=0.18 //x=46.305 //y=1.4 //x2=46.345 //y2=1.555
r967 (  159 249 ) resistor r=45.1352 //w=0.168 //l=0.173853 //layer=ply \
 //thickness=0.18 //x=46.305 //y=1.09 //x2=46.345 //y2=0.935
r968 (  159 160 ) resistor r=158.957 //w=0.094 //l=0.31 //layer=ply \
 //thickness=0.18 //x=46.305 //y=1.09 //x2=46.305 //y2=1.4
r969 (  155 243 ) resistor r=16.5046 //w=0.27 //l=0.135 //layer=ply \
 //thickness=0.18 //x=35.405 //y=4.97 //x2=35.27 //y2=4.97
r970 (  154 156 ) resistor r=26.9307 //w=0.15 //l=0.106066 //layer=ply \
 //thickness=0.18 //x=35.605 //y=4.97 //x2=35.68 //y2=5.045
r971 (  154 155 ) resistor r=102.553 //w=0.094 //l=0.2 //layer=ply \
 //thickness=0.18 //x=35.605 //y=4.97 //x2=35.405 //y2=4.97
r972 (  153 248 ) resistor r=38.6777 //w=0.284 //l=0.198997 //layer=ply \
 //thickness=0.18 //x=35.36 //y=2.095 //x2=35.285 //y2=2.26
r973 (  152 246 ) resistor r=21.2976 //w=0.217 //l=0.0928709 //layer=ply \
 //thickness=0.18 //x=35.36 //y=1.63 //x2=35.32 //y2=1.555
r974 (  152 153 ) resistor r=238.436 //w=0.094 //l=0.465 //layer=ply \
 //thickness=0.18 //x=35.36 //y=1.63 //x2=35.36 //y2=2.095
r975 (  151 246 ) resistor r=39.0671 //w=0.217 //l=0.173853 //layer=ply \
 //thickness=0.18 //x=35.36 //y=1.4 //x2=35.32 //y2=1.555
r976 (  150 245 ) resistor r=45.1352 //w=0.168 //l=0.173853 //layer=ply \
 //thickness=0.18 //x=35.36 //y=1.09 //x2=35.32 //y2=0.935
r977 (  150 151 ) resistor r=158.957 //w=0.094 //l=0.31 //layer=ply \
 //thickness=0.18 //x=35.36 //y=1.09 //x2=35.36 //y2=1.4
r978 (  145 239 ) resistor r=5.52526 //w=0.168 //l=0.115 //layer=ply \
 //thickness=0.18 //x=34.99 //y=1.555 //x2=34.875 //y2=1.555
r979 (  144 246 ) resistor r=11.4558 //w=0.217 //l=0.115 //layer=ply \
 //thickness=0.18 //x=35.205 //y=1.555 //x2=35.32 //y2=1.555
r980 (  143 238 ) resistor r=5.52526 //w=0.168 //l=0.115 //layer=ply \
 //thickness=0.18 //x=34.99 //y=0.935 //x2=34.875 //y2=0.935
r981 (  142 245 ) resistor r=5.52526 //w=0.168 //l=0.115 //layer=ply \
 //thickness=0.18 //x=35.205 //y=0.935 //x2=35.32 //y2=0.935
r982 (  142 143 ) resistor r=110.245 //w=0.094 //l=0.215 //layer=ply \
 //thickness=0.18 //x=35.205 //y=0.935 //x2=34.99 //y2=0.935
r983 (  141 239 ) resistor r=45.1352 //w=0.168 //l=0.173853 //layer=ply \
 //thickness=0.18 //x=34.835 //y=1.4 //x2=34.875 //y2=1.555
r984 (  140 238 ) resistor r=45.1352 //w=0.168 //l=0.173853 //layer=ply \
 //thickness=0.18 //x=34.835 //y=1.09 //x2=34.875 //y2=0.935
r985 (  140 141 ) resistor r=158.957 //w=0.094 //l=0.31 //layer=ply \
 //thickness=0.18 //x=34.835 //y=1.09 //x2=34.835 //y2=1.4
r986 (  136 232 ) resistor r=16.5046 //w=0.27 //l=0.135 //layer=ply \
 //thickness=0.18 //x=22.455 //y=4.97 //x2=22.32 //y2=4.97
r987 (  135 137 ) resistor r=26.9307 //w=0.15 //l=0.106066 //layer=ply \
 //thickness=0.18 //x=22.655 //y=4.97 //x2=22.73 //y2=5.045
r988 (  135 136 ) resistor r=102.553 //w=0.094 //l=0.2 //layer=ply \
 //thickness=0.18 //x=22.655 //y=4.97 //x2=22.455 //y2=4.97
r989 (  134 237 ) resistor r=38.6777 //w=0.284 //l=0.198997 //layer=ply \
 //thickness=0.18 //x=22.41 //y=2.095 //x2=22.335 //y2=2.26
r990 (  133 235 ) resistor r=21.2976 //w=0.217 //l=0.0928709 //layer=ply \
 //thickness=0.18 //x=22.41 //y=1.63 //x2=22.37 //y2=1.555
r991 (  133 134 ) resistor r=238.436 //w=0.094 //l=0.465 //layer=ply \
 //thickness=0.18 //x=22.41 //y=1.63 //x2=22.41 //y2=2.095
r992 (  132 235 ) resistor r=39.0671 //w=0.217 //l=0.173853 //layer=ply \
 //thickness=0.18 //x=22.41 //y=1.4 //x2=22.37 //y2=1.555
r993 (  131 234 ) resistor r=45.1352 //w=0.168 //l=0.173853 //layer=ply \
 //thickness=0.18 //x=22.41 //y=1.09 //x2=22.37 //y2=0.935
r994 (  131 132 ) resistor r=158.957 //w=0.094 //l=0.31 //layer=ply \
 //thickness=0.18 //x=22.41 //y=1.09 //x2=22.41 //y2=1.4
r995 (  126 228 ) resistor r=5.52526 //w=0.168 //l=0.115 //layer=ply \
 //thickness=0.18 //x=22.04 //y=1.555 //x2=21.925 //y2=1.555
r996 (  125 235 ) resistor r=11.4558 //w=0.217 //l=0.115 //layer=ply \
 //thickness=0.18 //x=22.255 //y=1.555 //x2=22.37 //y2=1.555
r997 (  124 227 ) resistor r=5.52526 //w=0.168 //l=0.115 //layer=ply \
 //thickness=0.18 //x=22.04 //y=0.935 //x2=21.925 //y2=0.935
r998 (  123 234 ) resistor r=5.52526 //w=0.168 //l=0.115 //layer=ply \
 //thickness=0.18 //x=22.255 //y=0.935 //x2=22.37 //y2=0.935
r999 (  123 124 ) resistor r=110.245 //w=0.094 //l=0.215 //layer=ply \
 //thickness=0.18 //x=22.255 //y=0.935 //x2=22.04 //y2=0.935
r1000 (  122 228 ) resistor r=45.1352 //w=0.168 //l=0.173853 //layer=ply \
 //thickness=0.18 //x=21.885 //y=1.4 //x2=21.925 //y2=1.555
r1001 (  121 227 ) resistor r=45.1352 //w=0.168 //l=0.173853 //layer=ply \
 //thickness=0.18 //x=21.885 //y=1.09 //x2=21.925 //y2=0.935
r1002 (  121 122 ) resistor r=158.957 //w=0.094 //l=0.31 //layer=ply \
 //thickness=0.18 //x=21.885 //y=1.09 //x2=21.885 //y2=1.4
r1003 (  117 221 ) resistor r=16.5046 //w=0.27 //l=0.135 //layer=ply \
 //thickness=0.18 //x=10.985 //y=4.97 //x2=10.85 //y2=4.97
r1004 (  116 118 ) resistor r=26.9307 //w=0.15 //l=0.106066 //layer=ply \
 //thickness=0.18 //x=11.185 //y=4.97 //x2=11.26 //y2=5.045
r1005 (  116 117 ) resistor r=102.553 //w=0.094 //l=0.2 //layer=ply \
 //thickness=0.18 //x=11.185 //y=4.97 //x2=10.985 //y2=4.97
r1006 (  115 226 ) resistor r=38.6777 //w=0.284 //l=0.198997 //layer=ply \
 //thickness=0.18 //x=10.94 //y=2.095 //x2=10.865 //y2=2.26
r1007 (  114 224 ) resistor r=21.2976 //w=0.217 //l=0.0928709 //layer=ply \
 //thickness=0.18 //x=10.94 //y=1.63 //x2=10.9 //y2=1.555
r1008 (  114 115 ) resistor r=238.436 //w=0.094 //l=0.465 //layer=ply \
 //thickness=0.18 //x=10.94 //y=1.63 //x2=10.94 //y2=2.095
r1009 (  113 224 ) resistor r=39.0671 //w=0.217 //l=0.173853 //layer=ply \
 //thickness=0.18 //x=10.94 //y=1.4 //x2=10.9 //y2=1.555
r1010 (  112 223 ) resistor r=45.1352 //w=0.168 //l=0.173853 //layer=ply \
 //thickness=0.18 //x=10.94 //y=1.09 //x2=10.9 //y2=0.935
r1011 (  112 113 ) resistor r=158.957 //w=0.094 //l=0.31 //layer=ply \
 //thickness=0.18 //x=10.94 //y=1.09 //x2=10.94 //y2=1.4
r1012 (  107 217 ) resistor r=5.52526 //w=0.168 //l=0.115 //layer=ply \
 //thickness=0.18 //x=10.57 //y=1.555 //x2=10.455 //y2=1.555
r1013 (  106 224 ) resistor r=11.4558 //w=0.217 //l=0.115 //layer=ply \
 //thickness=0.18 //x=10.785 //y=1.555 //x2=10.9 //y2=1.555
r1014 (  105 216 ) resistor r=5.52526 //w=0.168 //l=0.115 //layer=ply \
 //thickness=0.18 //x=10.57 //y=0.935 //x2=10.455 //y2=0.935
r1015 (  104 223 ) resistor r=5.52526 //w=0.168 //l=0.115 //layer=ply \
 //thickness=0.18 //x=10.785 //y=0.935 //x2=10.9 //y2=0.935
r1016 (  104 105 ) resistor r=110.245 //w=0.094 //l=0.215 //layer=ply \
 //thickness=0.18 //x=10.785 //y=0.935 //x2=10.57 //y2=0.935
r1017 (  103 217 ) resistor r=45.1352 //w=0.168 //l=0.173853 //layer=ply \
 //thickness=0.18 //x=10.415 //y=1.4 //x2=10.455 //y2=1.555
r1018 (  102 216 ) resistor r=45.1352 //w=0.168 //l=0.173853 //layer=ply \
 //thickness=0.18 //x=10.415 //y=1.09 //x2=10.455 //y2=0.935
r1019 (  102 103 ) resistor r=158.957 //w=0.094 //l=0.31 //layer=ply \
 //thickness=0.18 //x=10.415 //y=1.09 //x2=10.415 //y2=1.4
r1020 (  101 213 ) resistor r=592.245 //w=0.094 //l=1.155 //layer=ply \
 //thickness=0.18 //x=71.57 //y=6.2 //x2=71.57 //y2=5.045
r1021 (  100 277 ) resistor r=592.245 //w=0.094 //l=1.155 //layer=ply \
 //thickness=0.18 //x=71.13 //y=6.2 //x2=71.13 //y2=5.045
r1022 (  99 194 ) resistor r=592.245 //w=0.094 //l=1.155 //layer=ply \
 //thickness=0.18 //x=60.1 //y=6.2 //x2=60.1 //y2=5.045
r1023 (  98 266 ) resistor r=592.245 //w=0.094 //l=1.155 //layer=ply \
 //thickness=0.18 //x=59.66 //y=6.2 //x2=59.66 //y2=5.045
r1024 (  97 175 ) resistor r=592.245 //w=0.094 //l=1.155 //layer=ply \
 //thickness=0.18 //x=47.15 //y=6.2 //x2=47.15 //y2=5.045
r1025 (  96 255 ) resistor r=592.245 //w=0.094 //l=1.155 //layer=ply \
 //thickness=0.18 //x=46.71 //y=6.2 //x2=46.71 //y2=5.045
r1026 (  95 156 ) resistor r=592.245 //w=0.094 //l=1.155 //layer=ply \
 //thickness=0.18 //x=35.68 //y=6.2 //x2=35.68 //y2=5.045
r1027 (  94 244 ) resistor r=592.245 //w=0.094 //l=1.155 //layer=ply \
 //thickness=0.18 //x=35.24 //y=6.2 //x2=35.24 //y2=5.045
r1028 (  93 137 ) resistor r=592.245 //w=0.094 //l=1.155 //layer=ply \
 //thickness=0.18 //x=22.73 //y=6.2 //x2=22.73 //y2=5.045
r1029 (  92 233 ) resistor r=592.245 //w=0.094 //l=1.155 //layer=ply \
 //thickness=0.18 //x=22.29 //y=6.2 //x2=22.29 //y2=5.045
r1030 (  91 118 ) resistor r=592.245 //w=0.094 //l=1.155 //layer=ply \
 //thickness=0.18 //x=11.26 //y=6.2 //x2=11.26 //y2=5.045
r1031 (  90 222 ) resistor r=592.245 //w=0.094 //l=1.155 //layer=ply \
 //thickness=0.18 //x=10.82 //y=6.2 //x2=10.82 //y2=5.045
r1032 (  89 201 ) resistor r=55.3787 //w=0.094 //l=0.108 //layer=ply \
 //thickness=0.18 //x=70.987 //y=1.555 //x2=71.095 //y2=1.555
r1033 (  89 202 ) resistor r=54.866 //w=0.094 //l=0.107 //layer=ply \
 //thickness=0.18 //x=70.987 //y=1.555 //x2=70.88 //y2=1.555
r1034 (  88 182 ) resistor r=55.3787 //w=0.094 //l=0.108 //layer=ply \
 //thickness=0.18 //x=59.517 //y=1.555 //x2=59.625 //y2=1.555
r1035 (  88 183 ) resistor r=54.866 //w=0.094 //l=0.107 //layer=ply \
 //thickness=0.18 //x=59.517 //y=1.555 //x2=59.41 //y2=1.555
r1036 (  87 163 ) resistor r=55.3787 //w=0.094 //l=0.108 //layer=ply \
 //thickness=0.18 //x=46.567 //y=1.555 //x2=46.675 //y2=1.555
r1037 (  87 164 ) resistor r=54.866 //w=0.094 //l=0.107 //layer=ply \
 //thickness=0.18 //x=46.567 //y=1.555 //x2=46.46 //y2=1.555
r1038 (  86 144 ) resistor r=55.3787 //w=0.094 //l=0.108 //layer=ply \
 //thickness=0.18 //x=35.097 //y=1.555 //x2=35.205 //y2=1.555
r1039 (  86 145 ) resistor r=54.866 //w=0.094 //l=0.107 //layer=ply \
 //thickness=0.18 //x=35.097 //y=1.555 //x2=34.99 //y2=1.555
r1040 (  85 125 ) resistor r=55.3787 //w=0.094 //l=0.108 //layer=ply \
 //thickness=0.18 //x=22.147 //y=1.555 //x2=22.255 //y2=1.555
r1041 (  85 126 ) resistor r=54.866 //w=0.094 //l=0.107 //layer=ply \
 //thickness=0.18 //x=22.147 //y=1.555 //x2=22.04 //y2=1.555
r1042 (  84 106 ) resistor r=55.3787 //w=0.094 //l=0.108 //layer=ply \
 //thickness=0.18 //x=10.677 //y=1.555 //x2=10.785 //y2=1.555
r1043 (  84 107 ) resistor r=54.866 //w=0.094 //l=0.107 //layer=ply \
 //thickness=0.18 //x=10.677 //y=1.555 //x2=10.57 //y2=1.555
r1044 (  82 274 ) resistor r=152 //w=0.17 //l=0.17 //layer=licon //count=1 \
 //x=71.16 //y=4.88 //x2=71.16 //y2=4.88
r1045 (  77 281 ) resistor r=152 //w=0.17 //l=0.17 //layer=licon //count=1 \
 //x=71.16 //y=2.26 //x2=71.16 //y2=2.26
r1046 (  74 263 ) resistor r=152 //w=0.17 //l=0.17 //layer=licon //count=1 \
 //x=59.69 //y=4.88 //x2=59.69 //y2=4.88
r1047 (  68 270 ) resistor r=152 //w=0.17 //l=0.17 //layer=licon //count=1 \
 //x=59.69 //y=2.26 //x2=59.69 //y2=2.26
r1048 (  65 252 ) resistor r=152 //w=0.17 //l=0.17 //layer=licon //count=1 \
 //x=46.74 //y=4.88 //x2=46.74 //y2=4.88
r1049 (  63 65 ) resistor r=169.754 //w=0.187 //l=2.48 //layer=li \
 //thickness=0.1 //x=46.74 //y=2.4 //x2=46.74 //y2=4.88
r1050 (  60 259 ) resistor r=152 //w=0.17 //l=0.17 //layer=licon //count=1 \
 //x=46.74 //y=2.26 //x2=46.74 //y2=2.26
r1051 (  60 63 ) resistor r=9.58289 //w=0.187 //l=0.14 //layer=li \
 //thickness=0.1 //x=46.74 //y=2.26 //x2=46.74 //y2=2.4
r1052 (  57 241 ) resistor r=152 //w=0.17 //l=0.17 //layer=licon //count=1 \
 //x=35.27 //y=4.88 //x2=35.27 //y2=4.88
r1053 (  52 248 ) resistor r=152 //w=0.17 //l=0.17 //layer=licon //count=1 \
 //x=35.27 //y=2.26 //x2=35.27 //y2=2.26
r1054 (  49 230 ) resistor r=152 //w=0.17 //l=0.17 //layer=licon //count=1 \
 //x=22.32 //y=4.88 //x2=22.32 //y2=4.88
r1055 (  43 237 ) resistor r=152 //w=0.17 //l=0.17 //layer=licon //count=1 \
 //x=22.32 //y=2.26 //x2=22.32 //y2=2.26
r1056 (  40 219 ) resistor r=152 //w=0.17 //l=0.17 //layer=licon //count=1 \
 //x=10.85 //y=4.88 //x2=10.85 //y2=4.88
r1057 (  33 226 ) resistor r=152 //w=0.17 //l=0.17 //layer=licon //count=1 \
 //x=10.85 //y=2.26 //x2=10.85 //y2=2.26
r1058 (  31 82 ) resistor r=169.754 //w=0.187 //l=2.48 //layer=li \
 //thickness=0.1 //x=71.16 //y=2.4 //x2=71.16 //y2=4.88
r1059 (  31 77 ) resistor r=9.58289 //w=0.187 //l=0.14 //layer=li \
 //thickness=0.1 //x=71.16 //y=2.4 //x2=71.16 //y2=2.26
r1060 (  30 74 ) resistor r=144.428 //w=0.187 //l=2.11 //layer=li \
 //thickness=0.1 //x=59.69 //y=2.77 //x2=59.69 //y2=4.88
r1061 (  29 30 ) resistor r=25.3262 //w=0.187 //l=0.37 //layer=li \
 //thickness=0.1 //x=59.69 //y=2.4 //x2=59.69 //y2=2.77
r1062 (  29 68 ) resistor r=9.58289 //w=0.187 //l=0.14 //layer=li \
 //thickness=0.1 //x=59.69 //y=2.4 //x2=59.69 //y2=2.26
r1063 (  28 57 ) resistor r=169.754 //w=0.187 //l=2.48 //layer=li \
 //thickness=0.1 //x=35.27 //y=2.4 //x2=35.27 //y2=4.88
r1064 (  28 52 ) resistor r=9.58289 //w=0.187 //l=0.14 //layer=li \
 //thickness=0.1 //x=35.27 //y=2.4 //x2=35.27 //y2=2.26
r1065 (  27 49 ) resistor r=144.428 //w=0.187 //l=2.11 //layer=li \
 //thickness=0.1 //x=22.32 //y=2.77 //x2=22.32 //y2=4.88
r1066 (  26 27 ) resistor r=25.3262 //w=0.187 //l=0.37 //layer=li \
 //thickness=0.1 //x=22.32 //y=2.4 //x2=22.32 //y2=2.77
r1067 (  26 43 ) resistor r=9.58289 //w=0.187 //l=0.14 //layer=li \
 //thickness=0.1 //x=22.32 //y=2.4 //x2=22.32 //y2=2.26
r1068 (  25 40 ) resistor r=93.7754 //w=0.187 //l=1.37 //layer=li \
 //thickness=0.1 //x=10.85 //y=3.51 //x2=10.85 //y2=4.88
r1069 (  24 25 ) resistor r=50.6524 //w=0.187 //l=0.74 //layer=li \
 //thickness=0.1 //x=10.85 //y=2.77 //x2=10.85 //y2=3.51
r1070 (  23 24 ) resistor r=25.3262 //w=0.187 //l=0.37 //layer=li \
 //thickness=0.1 //x=10.85 //y=2.4 //x2=10.85 //y2=2.77
r1071 (  23 33 ) resistor r=9.58289 //w=0.187 //l=0.14 //layer=li \
 //thickness=0.1 //x=10.85 //y=2.4 //x2=10.85 //y2=2.26
r1072 (  22 31 ) resistor r=9.3 //w=0.17 //l=0.17 //layer=mcon //count=1 \
 //x=71.16 //y=2.4 //x2=71.16 //y2=2.4
r1073 (  20 29 ) resistor r=9.3 //w=0.17 //l=0.17 //layer=mcon //count=1 \
 //x=59.69 //y=2.4 //x2=59.69 //y2=2.4
r1074 (  18 63 ) resistor r=9.3 //w=0.17 //l=0.17 //layer=mcon //count=1 \
 //x=46.74 //y=2.4 //x2=46.74 //y2=2.4
r1075 (  16 28 ) resistor r=9.3 //w=0.17 //l=0.17 //layer=mcon //count=1 \
 //x=35.27 //y=2.4 //x2=35.27 //y2=2.4
r1076 (  14 26 ) resistor r=9.3 //w=0.17 //l=0.17 //layer=mcon //count=1 \
 //x=22.32 //y=2.4 //x2=22.32 //y2=2.4
r1077 (  12 23 ) resistor r=9.3 //w=0.17 //l=0.17 //layer=mcon //count=1 \
 //x=10.85 //y=2.4 //x2=10.85 //y2=2.4
r1078 (  10 20 ) resistor r=0.0880901 //w=0.191 //l=0.115 //layer=m1 \
 //thickness=0.36 //x=59.805 //y=2.4 //x2=59.69 //y2=2.4
r1079 (  9 22 ) resistor r=0.0717383 //w=0.224 //l=0.115 //layer=m1 \
 //thickness=0.36 //x=71.045 //y=2.4 //x2=71.16 //y2=2.4
r1080 (  9 10 ) resistor r=10.7252 //w=0.131 //l=11.24 //layer=m1 \
 //thickness=0.36 //x=71.045 //y=2.4 //x2=59.805 //y2=2.4
r1081 (  8 18 ) resistor r=0.0880901 //w=0.191 //l=0.115 //layer=m1 \
 //thickness=0.36 //x=46.855 //y=2.4 //x2=46.74 //y2=2.4
r1082 (  7 20 ) resistor r=0.0880901 //w=0.191 //l=0.115 //layer=m1 \
 //thickness=0.36 //x=59.575 //y=2.4 //x2=59.69 //y2=2.4
r1083 (  7 8 ) resistor r=12.1374 //w=0.131 //l=12.72 //layer=m1 \
 //thickness=0.36 //x=59.575 //y=2.4 //x2=46.855 //y2=2.4
r1084 (  6 16 ) resistor r=0.0880901 //w=0.191 //l=0.115 //layer=m1 \
 //thickness=0.36 //x=35.385 //y=2.4 //x2=35.27 //y2=2.4
r1085 (  5 18 ) resistor r=0.0880901 //w=0.191 //l=0.115 //layer=m1 \
 //thickness=0.36 //x=46.625 //y=2.4 //x2=46.74 //y2=2.4
r1086 (  5 6 ) resistor r=10.7252 //w=0.131 //l=11.24 //layer=m1 \
 //thickness=0.36 //x=46.625 //y=2.4 //x2=35.385 //y2=2.4
r1087 (  4 14 ) resistor r=0.0880901 //w=0.191 //l=0.115 //layer=m1 \
 //thickness=0.36 //x=22.435 //y=2.4 //x2=22.32 //y2=2.4
r1088 (  3 16 ) resistor r=0.0880901 //w=0.191 //l=0.115 //layer=m1 \
 //thickness=0.36 //x=35.155 //y=2.4 //x2=35.27 //y2=2.4
r1089 (  3 4 ) resistor r=12.1374 //w=0.131 //l=12.72 //layer=m1 \
 //thickness=0.36 //x=35.155 //y=2.4 //x2=22.435 //y2=2.4
r1090 (  2 12 ) resistor r=0.0717383 //w=0.224 //l=0.115 //layer=m1 \
 //thickness=0.36 //x=10.965 //y=2.4 //x2=10.85 //y2=2.4
r1091 (  1 14 ) resistor r=0.0880901 //w=0.191 //l=0.115 //layer=m1 \
 //thickness=0.36 //x=22.205 //y=2.4 //x2=22.32 //y2=2.4
r1092 (  1 2 ) resistor r=10.7252 //w=0.131 //l=11.24 //layer=m1 \
 //thickness=0.36 //x=22.205 //y=2.4 //x2=10.965 //y2=2.4
ends PM_TMRDFFSNQNX1\%SN

subckt PM_TMRDFFSNQNX1\%noxref_19 ( 1 2 3 4 5 6 16 24 37 38 49 51 52 56 58 65 \
 66 67 68 69 70 71 72 73 74 78 79 80 85 87 90 91 95 96 97 102 104 107 108 112 \
 113 114 119 121 124 125 127 128 133 137 138 143 147 148 153 156 158 159 )
c321 ( 159 0 ) capacitor c=0.0220291f //x=64.245 //y=5.2
c322 ( 158 0 ) capacitor c=0.0217503f //x=63.365 //y=5.2
c323 ( 156 0 ) capacitor c=0.00866655f //x=64.24 //y=1.085
c324 ( 153 0 ) capacitor c=0.0587755f //x=72.27 //y=4.88
c325 ( 148 0 ) capacitor c=0.0273931f //x=72.27 //y=2.095
c326 ( 147 0 ) capacitor c=0.0458323f //x=72.27 //y=2.26
c327 ( 143 0 ) capacitor c=0.0587755f //x=60.8 //y=4.88
c328 ( 138 0 ) capacitor c=0.0273931f //x=60.8 //y=2.095
c329 ( 137 0 ) capacitor c=0.0456313f //x=60.8 //y=2.26
c330 ( 133 0 ) capacitor c=0.058931f //x=55.99 //y=4.88
c331 ( 128 0 ) capacitor c=0.0267105f //x=55.99 //y=2.095
c332 ( 127 0 ) capacitor c=0.0456313f //x=55.99 //y=2.26
c333 ( 125 0 ) capacitor c=0.0432517f //x=72.79 //y=1.44
c334 ( 124 0 ) capacitor c=0.0200379f //x=72.79 //y=1.095
c335 ( 121 0 ) capacitor c=0.0158629f //x=72.635 //y=1.595
c336 ( 119 0 ) capacitor c=0.0157803f //x=72.635 //y=0.94
c337 ( 114 0 ) capacitor c=0.0218028f //x=72.26 //y=1.75
c338 ( 113 0 ) capacitor c=0.0207459f //x=72.26 //y=1.44
c339 ( 112 0 ) capacitor c=0.0194308f //x=72.26 //y=1.095
c340 ( 108 0 ) capacitor c=0.0432517f //x=61.32 //y=1.44
c341 ( 107 0 ) capacitor c=0.0200379f //x=61.32 //y=1.095
c342 ( 104 0 ) capacitor c=0.0148873f //x=61.165 //y=1.595
c343 ( 102 0 ) capacitor c=0.0157803f //x=61.165 //y=0.94
c344 ( 97 0 ) capacitor c=0.0218028f //x=60.79 //y=1.75
c345 ( 96 0 ) capacitor c=0.0207459f //x=60.79 //y=1.44
c346 ( 95 0 ) capacitor c=0.0194308f //x=60.79 //y=1.095
c347 ( 91 0 ) capacitor c=0.0432517f //x=56.51 //y=1.44
c348 ( 90 0 ) capacitor c=0.0200379f //x=56.51 //y=1.095
c349 ( 87 0 ) capacitor c=0.0148873f //x=56.355 //y=1.595
c350 ( 85 0 ) capacitor c=0.0157803f //x=56.355 //y=0.94
c351 ( 80 0 ) capacitor c=0.0218028f //x=55.98 //y=1.75
c352 ( 79 0 ) capacitor c=0.0207459f //x=55.98 //y=1.44
c353 ( 78 0 ) capacitor c=0.0194308f //x=55.98 //y=1.095
c354 ( 74 0 ) capacitor c=0.158794f //x=72.45 //y=6.2
c355 ( 73 0 ) capacitor c=0.110114f //x=72.01 //y=6.2
c356 ( 72 0 ) capacitor c=0.158794f //x=60.98 //y=6.2
c357 ( 71 0 ) capacitor c=0.110114f //x=60.54 //y=6.2
c358 ( 70 0 ) capacitor c=0.158048f //x=56.17 //y=6.2
c359 ( 69 0 ) capacitor c=0.110114f //x=55.73 //y=6.2
c360 ( 65 0 ) capacitor c=0.0023043f //x=64.39 //y=5.38
c361 ( 58 0 ) capacitor c=0.0841207f //x=72.27 //y=2.26
c362 ( 56 0 ) capacitor c=0.10491f //x=64.87 //y=3.88
c363 ( 52 0 ) capacitor c=0.00404073f //x=64.515 //y=1.835
c364 ( 51 0 ) capacitor c=0.0122201f //x=64.785 //y=1.835
c365 ( 49 0 ) capacitor c=0.0140462f //x=64.785 //y=5.38
c366 ( 38 0 ) capacitor c=0.00251635f //x=63.595 //y=5.38
c367 ( 37 0 ) capacitor c=0.0143111f //x=64.305 //y=5.38
c368 ( 24 0 ) capacitor c=0.0811636f //x=60.8 //y=2.26
c369 ( 16 0 ) capacitor c=0.0796434f //x=55.99 //y=2.26
c370 ( 6 0 ) capacitor c=0.00405261f //x=64.985 //y=3.88
c371 ( 5 0 ) capacitor c=0.125528f //x=72.155 //y=3.88
c372 ( 4 0 ) capacitor c=0.00412452f //x=60.915 //y=3.88
c373 ( 3 0 ) capacitor c=0.0546427f //x=64.755 //y=3.88
c374 ( 2 0 ) capacitor c=0.0138772f //x=56.105 //y=3.88
c375 ( 1 0 ) capacitor c=0.0670382f //x=60.685 //y=3.88
r376 (  147 148 ) resistor r=52.7279 //w=0.214 //l=0.165 //layer=ply \
 //thickness=0.18 //x=72.27 //y=2.26 //x2=72.27 //y2=2.095
r377 (  137 138 ) resistor r=52.7279 //w=0.214 //l=0.165 //layer=ply \
 //thickness=0.18 //x=60.8 //y=2.26 //x2=60.8 //y2=2.095
r378 (  127 128 ) resistor r=52.7279 //w=0.214 //l=0.165 //layer=ply \
 //thickness=0.18 //x=55.99 //y=2.26 //x2=55.99 //y2=2.095
r379 (  125 155 ) resistor r=45.1352 //w=0.168 //l=0.173853 //layer=ply \
 //thickness=0.18 //x=72.79 //y=1.44 //x2=72.75 //y2=1.595
r380 (  124 154 ) resistor r=45.1352 //w=0.168 //l=0.173853 //layer=ply \
 //thickness=0.18 //x=72.79 //y=1.095 //x2=72.75 //y2=0.94
r381 (  124 125 ) resistor r=176.904 //w=0.094 //l=0.345 //layer=ply \
 //thickness=0.18 //x=72.79 //y=1.095 //x2=72.79 //y2=1.44
r382 (  122 151 ) resistor r=10.701 //w=0.21 //l=0.115 //layer=ply \
 //thickness=0.18 //x=72.415 //y=1.595 //x2=72.3 //y2=1.595
r383 (  121 155 ) resistor r=5.52526 //w=0.168 //l=0.115 //layer=ply \
 //thickness=0.18 //x=72.635 //y=1.595 //x2=72.75 //y2=1.595
r384 (  120 150 ) resistor r=5.52526 //w=0.168 //l=0.115 //layer=ply \
 //thickness=0.18 //x=72.415 //y=0.94 //x2=72.3 //y2=0.94
r385 (  119 154 ) resistor r=5.52526 //w=0.168 //l=0.115 //layer=ply \
 //thickness=0.18 //x=72.635 //y=0.94 //x2=72.75 //y2=0.94
r386 (  119 120 ) resistor r=112.809 //w=0.094 //l=0.22 //layer=ply \
 //thickness=0.18 //x=72.635 //y=0.94 //x2=72.415 //y2=0.94
r387 (  116 153 ) resistor r=37.236 //w=0.233 //l=0.249199 //layer=ply \
 //thickness=0.18 //x=72.45 //y=5.045 //x2=72.27 //y2=4.88
r388 (  114 151 ) resistor r=39.5823 //w=0.21 //l=0.173853 //layer=ply \
 //thickness=0.18 //x=72.26 //y=1.75 //x2=72.3 //y2=1.595
r389 (  114 148 ) resistor r=176.904 //w=0.094 //l=0.345 //layer=ply \
 //thickness=0.18 //x=72.26 //y=1.75 //x2=72.26 //y2=2.095
r390 (  113 151 ) resistor r=39.5823 //w=0.21 //l=0.173853 //layer=ply \
 //thickness=0.18 //x=72.26 //y=1.44 //x2=72.3 //y2=1.595
r391 (  112 150 ) resistor r=45.1352 //w=0.168 //l=0.173853 //layer=ply \
 //thickness=0.18 //x=72.26 //y=1.095 //x2=72.3 //y2=0.94
r392 (  112 113 ) resistor r=176.904 //w=0.094 //l=0.345 //layer=ply \
 //thickness=0.18 //x=72.26 //y=1.095 //x2=72.26 //y2=1.44
r393 (  109 153 ) resistor r=53.7854 //w=0.233 //l=0.332415 //layer=ply \
 //thickness=0.18 //x=72.01 //y=5.045 //x2=72.27 //y2=4.88
r394 (  108 145 ) resistor r=45.1352 //w=0.168 //l=0.173853 //layer=ply \
 //thickness=0.18 //x=61.32 //y=1.44 //x2=61.28 //y2=1.595
r395 (  107 144 ) resistor r=45.1352 //w=0.168 //l=0.173853 //layer=ply \
 //thickness=0.18 //x=61.32 //y=1.095 //x2=61.28 //y2=0.94
r396 (  107 108 ) resistor r=176.904 //w=0.094 //l=0.345 //layer=ply \
 //thickness=0.18 //x=61.32 //y=1.095 //x2=61.32 //y2=1.44
r397 (  105 141 ) resistor r=10.701 //w=0.21 //l=0.115 //layer=ply \
 //thickness=0.18 //x=60.945 //y=1.595 //x2=60.83 //y2=1.595
r398 (  104 145 ) resistor r=5.52526 //w=0.168 //l=0.115 //layer=ply \
 //thickness=0.18 //x=61.165 //y=1.595 //x2=61.28 //y2=1.595
r399 (  103 140 ) resistor r=5.52526 //w=0.168 //l=0.115 //layer=ply \
 //thickness=0.18 //x=60.945 //y=0.94 //x2=60.83 //y2=0.94
r400 (  102 144 ) resistor r=5.52526 //w=0.168 //l=0.115 //layer=ply \
 //thickness=0.18 //x=61.165 //y=0.94 //x2=61.28 //y2=0.94
r401 (  102 103 ) resistor r=112.809 //w=0.094 //l=0.22 //layer=ply \
 //thickness=0.18 //x=61.165 //y=0.94 //x2=60.945 //y2=0.94
r402 (  99 143 ) resistor r=37.236 //w=0.233 //l=0.249199 //layer=ply \
 //thickness=0.18 //x=60.98 //y=5.045 //x2=60.8 //y2=4.88
r403 (  97 141 ) resistor r=39.5823 //w=0.21 //l=0.173853 //layer=ply \
 //thickness=0.18 //x=60.79 //y=1.75 //x2=60.83 //y2=1.595
r404 (  97 138 ) resistor r=176.904 //w=0.094 //l=0.345 //layer=ply \
 //thickness=0.18 //x=60.79 //y=1.75 //x2=60.79 //y2=2.095
r405 (  96 141 ) resistor r=39.5823 //w=0.21 //l=0.173853 //layer=ply \
 //thickness=0.18 //x=60.79 //y=1.44 //x2=60.83 //y2=1.595
r406 (  95 140 ) resistor r=45.1352 //w=0.168 //l=0.173853 //layer=ply \
 //thickness=0.18 //x=60.79 //y=1.095 //x2=60.83 //y2=0.94
r407 (  95 96 ) resistor r=176.904 //w=0.094 //l=0.345 //layer=ply \
 //thickness=0.18 //x=60.79 //y=1.095 //x2=60.79 //y2=1.44
r408 (  92 143 ) resistor r=53.7854 //w=0.233 //l=0.332415 //layer=ply \
 //thickness=0.18 //x=60.54 //y=5.045 //x2=60.8 //y2=4.88
r409 (  91 135 ) resistor r=45.1352 //w=0.168 //l=0.173853 //layer=ply \
 //thickness=0.18 //x=56.51 //y=1.44 //x2=56.47 //y2=1.595
r410 (  90 134 ) resistor r=45.1352 //w=0.168 //l=0.173853 //layer=ply \
 //thickness=0.18 //x=56.51 //y=1.095 //x2=56.47 //y2=0.94
r411 (  90 91 ) resistor r=176.904 //w=0.094 //l=0.345 //layer=ply \
 //thickness=0.18 //x=56.51 //y=1.095 //x2=56.51 //y2=1.44
r412 (  88 131 ) resistor r=10.701 //w=0.21 //l=0.115 //layer=ply \
 //thickness=0.18 //x=56.135 //y=1.595 //x2=56.02 //y2=1.595
r413 (  87 135 ) resistor r=5.52526 //w=0.168 //l=0.115 //layer=ply \
 //thickness=0.18 //x=56.355 //y=1.595 //x2=56.47 //y2=1.595
r414 (  86 130 ) resistor r=5.52526 //w=0.168 //l=0.115 //layer=ply \
 //thickness=0.18 //x=56.135 //y=0.94 //x2=56.02 //y2=0.94
r415 (  85 134 ) resistor r=5.52526 //w=0.168 //l=0.115 //layer=ply \
 //thickness=0.18 //x=56.355 //y=0.94 //x2=56.47 //y2=0.94
r416 (  85 86 ) resistor r=112.809 //w=0.094 //l=0.22 //layer=ply \
 //thickness=0.18 //x=56.355 //y=0.94 //x2=56.135 //y2=0.94
r417 (  82 133 ) resistor r=37.236 //w=0.233 //l=0.249199 //layer=ply \
 //thickness=0.18 //x=56.17 //y=5.045 //x2=55.99 //y2=4.88
r418 (  80 131 ) resistor r=39.5823 //w=0.21 //l=0.173853 //layer=ply \
 //thickness=0.18 //x=55.98 //y=1.75 //x2=56.02 //y2=1.595
r419 (  80 128 ) resistor r=176.904 //w=0.094 //l=0.345 //layer=ply \
 //thickness=0.18 //x=55.98 //y=1.75 //x2=55.98 //y2=2.095
r420 (  79 131 ) resistor r=39.5823 //w=0.21 //l=0.173853 //layer=ply \
 //thickness=0.18 //x=55.98 //y=1.44 //x2=56.02 //y2=1.595
r421 (  78 130 ) resistor r=45.1352 //w=0.168 //l=0.173853 //layer=ply \
 //thickness=0.18 //x=55.98 //y=1.095 //x2=56.02 //y2=0.94
r422 (  78 79 ) resistor r=176.904 //w=0.094 //l=0.345 //layer=ply \
 //thickness=0.18 //x=55.98 //y=1.095 //x2=55.98 //y2=1.44
r423 (  75 133 ) resistor r=53.7854 //w=0.233 //l=0.332415 //layer=ply \
 //thickness=0.18 //x=55.73 //y=5.045 //x2=55.99 //y2=4.88
r424 (  74 116 ) resistor r=592.245 //w=0.094 //l=1.155 //layer=ply \
 //thickness=0.18 //x=72.45 //y=6.2 //x2=72.45 //y2=5.045
r425 (  73 109 ) resistor r=592.245 //w=0.094 //l=1.155 //layer=ply \
 //thickness=0.18 //x=72.01 //y=6.2 //x2=72.01 //y2=5.045
r426 (  72 99 ) resistor r=592.245 //w=0.094 //l=1.155 //layer=ply \
 //thickness=0.18 //x=60.98 //y=6.2 //x2=60.98 //y2=5.045
r427 (  71 92 ) resistor r=592.245 //w=0.094 //l=1.155 //layer=ply \
 //thickness=0.18 //x=60.54 //y=6.2 //x2=60.54 //y2=5.045
r428 (  70 82 ) resistor r=592.245 //w=0.094 //l=1.155 //layer=ply \
 //thickness=0.18 //x=56.17 //y=6.2 //x2=56.17 //y2=5.045
r429 (  69 75 ) resistor r=592.245 //w=0.094 //l=1.155 //layer=ply \
 //thickness=0.18 //x=55.73 //y=6.2 //x2=55.73 //y2=5.045
r430 (  68 121 ) resistor r=56.4043 //w=0.094 //l=0.11 //layer=ply \
 //thickness=0.18 //x=72.525 //y=1.595 //x2=72.635 //y2=1.595
r431 (  68 122 ) resistor r=56.4043 //w=0.094 //l=0.11 //layer=ply \
 //thickness=0.18 //x=72.525 //y=1.595 //x2=72.415 //y2=1.595
r432 (  67 104 ) resistor r=56.4043 //w=0.094 //l=0.11 //layer=ply \
 //thickness=0.18 //x=61.055 //y=1.595 //x2=61.165 //y2=1.595
r433 (  67 105 ) resistor r=56.4043 //w=0.094 //l=0.11 //layer=ply \
 //thickness=0.18 //x=61.055 //y=1.595 //x2=60.945 //y2=1.595
r434 (  66 87 ) resistor r=56.4043 //w=0.094 //l=0.11 //layer=ply \
 //thickness=0.18 //x=56.245 //y=1.595 //x2=56.355 //y2=1.595
r435 (  66 88 ) resistor r=56.4043 //w=0.094 //l=0.11 //layer=ply \
 //thickness=0.18 //x=56.245 //y=1.595 //x2=56.135 //y2=1.595
r436 (  63 153 ) resistor r=152 //w=0.17 //l=0.17 //layer=licon //count=1 \
 //x=72.27 //y=4.88 //x2=72.27 //y2=4.88
r437 (  61 63 ) resistor r=68.4492 //w=0.187 //l=1 //layer=li //thickness=0.1 \
 //x=72.27 //y=3.88 //x2=72.27 //y2=4.88
r438 (  58 147 ) resistor r=152 //w=0.17 //l=0.17 //layer=licon //count=1 \
 //x=72.27 //y=2.26 //x2=72.27 //y2=2.26
r439 (  58 61 ) resistor r=110.888 //w=0.187 //l=1.62 //layer=li \
 //thickness=0.1 //x=72.27 //y=2.26 //x2=72.27 //y2=3.88
r440 (  54 56 ) resistor r=96.8556 //w=0.187 //l=1.415 //layer=li \
 //thickness=0.1 //x=64.87 //y=5.295 //x2=64.87 //y2=3.88
r441 (  53 56 ) resistor r=134.16 //w=0.187 //l=1.96 //layer=li \
 //thickness=0.1 //x=64.87 //y=1.92 //x2=64.87 //y2=3.88
r442 (  51 53 ) resistor r=7.15173 //w=0.17 //l=0.120208 //layer=li \
 //thickness=0.1 //x=64.785 //y=1.835 //x2=64.87 //y2=1.92
r443 (  51 52 ) resistor r=18.4813 //w=0.187 //l=0.27 //layer=li \
 //thickness=0.1 //x=64.785 //y=1.835 //x2=64.515 //y2=1.835
r444 (  50 65 ) resistor r=5.4201 //w=0.17 //l=0.085 //layer=li \
 //thickness=0.1 //x=64.475 //y=5.38 //x2=64.39 //y2=5.38
r445 (  49 54 ) resistor r=7.15173 //w=0.17 //l=0.120208 //layer=li \
 //thickness=0.1 //x=64.785 //y=5.38 //x2=64.87 //y2=5.295
r446 (  49 50 ) resistor r=21.2193 //w=0.187 //l=0.31 //layer=li \
 //thickness=0.1 //x=64.785 //y=5.38 //x2=64.475 //y2=5.38
r447 (  45 52 ) resistor r=7.15173 //w=0.17 //l=0.120208 //layer=li \
 //thickness=0.1 //x=64.43 //y=1.75 //x2=64.515 //y2=1.835
r448 (  45 156 ) resistor r=39.016 //w=0.187 //l=0.57 //layer=li \
 //thickness=0.1 //x=64.43 //y=1.75 //x2=64.43 //y2=1.18
r449 (  39 65 ) resistor r=1.40859 //w=0.34 //l=0.085 //layer=li \
 //thickness=0.1 //x=64.39 //y=5.465 //x2=64.39 //y2=5.38
r450 (  39 159 ) resistor r=30.1176 //w=0.187 //l=0.44 //layer=li \
 //thickness=0.1 //x=64.39 //y=5.465 //x2=64.39 //y2=5.905
r451 (  37 65 ) resistor r=5.4201 //w=0.17 //l=0.085 //layer=li \
 //thickness=0.1 //x=64.305 //y=5.38 //x2=64.39 //y2=5.38
r452 (  37 38 ) resistor r=48.5989 //w=0.187 //l=0.71 //layer=li \
 //thickness=0.1 //x=64.305 //y=5.38 //x2=63.595 //y2=5.38
r453 (  31 38 ) resistor r=7.15173 //w=0.17 //l=0.120208 //layer=li \
 //thickness=0.1 //x=63.51 //y=5.465 //x2=63.595 //y2=5.38
r454 (  31 158 ) resistor r=30.1176 //w=0.187 //l=0.44 //layer=li \
 //thickness=0.1 //x=63.51 //y=5.465 //x2=63.51 //y2=5.905
r455 (  29 143 ) resistor r=152 //w=0.17 //l=0.17 //layer=licon //count=1 \
 //x=60.8 //y=4.88 //x2=60.8 //y2=4.88
r456 (  27 29 ) resistor r=68.4492 //w=0.187 //l=1 //layer=li //thickness=0.1 \
 //x=60.8 //y=3.88 //x2=60.8 //y2=4.88
r457 (  24 137 ) resistor r=152 //w=0.17 //l=0.17 //layer=licon //count=1 \
 //x=60.8 //y=2.26 //x2=60.8 //y2=2.26
r458 (  24 27 ) resistor r=110.888 //w=0.187 //l=1.62 //layer=li \
 //thickness=0.1 //x=60.8 //y=2.26 //x2=60.8 //y2=3.88
r459 (  21 133 ) resistor r=152 //w=0.17 //l=0.17 //layer=licon //count=1 \
 //x=55.99 //y=4.88 //x2=55.99 //y2=4.88
r460 (  19 21 ) resistor r=68.4492 //w=0.187 //l=1 //layer=li //thickness=0.1 \
 //x=55.99 //y=3.88 //x2=55.99 //y2=4.88
r461 (  16 127 ) resistor r=152 //w=0.17 //l=0.17 //layer=licon //count=1 \
 //x=55.99 //y=2.26 //x2=55.99 //y2=2.26
r462 (  16 19 ) resistor r=110.888 //w=0.187 //l=1.62 //layer=li \
 //thickness=0.1 //x=55.99 //y=2.26 //x2=55.99 //y2=3.88
r463 (  14 61 ) resistor r=9.3 //w=0.17 //l=0.17 //layer=mcon //count=1 \
 //x=72.27 //y=3.88 //x2=72.27 //y2=3.88
r464 (  12 56 ) resistor r=9.3 //w=0.17 //l=0.17 //layer=mcon //count=1 \
 //x=64.87 //y=3.88 //x2=64.87 //y2=3.88
r465 (  10 27 ) resistor r=9.3 //w=0.17 //l=0.17 //layer=mcon //count=1 \
 //x=60.8 //y=3.88 //x2=60.8 //y2=3.88
r466 (  8 19 ) resistor r=9.3 //w=0.17 //l=0.17 //layer=mcon //count=1 \
 //x=55.99 //y=3.88 //x2=55.99 //y2=3.88
r467 (  6 12 ) resistor r=0.0880901 //w=0.191 //l=0.115 //layer=m1 \
 //thickness=0.36 //x=64.985 //y=3.88 //x2=64.87 //y2=3.88
r468 (  5 14 ) resistor r=0.0717383 //w=0.224 //l=0.115 //layer=m1 \
 //thickness=0.36 //x=72.155 //y=3.88 //x2=72.27 //y2=3.88
r469 (  5 6 ) resistor r=6.8416 //w=0.131 //l=7.17 //layer=m1 //thickness=0.36 \
 //x=72.155 //y=3.88 //x2=64.985 //y2=3.88
r470 (  4 10 ) resistor r=0.0880901 //w=0.191 //l=0.115 //layer=m1 \
 //thickness=0.36 //x=60.915 //y=3.88 //x2=60.8 //y2=3.88
r471 (  3 12 ) resistor r=0.0880901 //w=0.191 //l=0.115 //layer=m1 \
 //thickness=0.36 //x=64.755 //y=3.88 //x2=64.87 //y2=3.88
r472 (  3 4 ) resistor r=3.66412 //w=0.131 //l=3.84 //layer=m1 \
 //thickness=0.36 //x=64.755 //y=3.88 //x2=60.915 //y2=3.88
r473 (  2 8 ) resistor r=0.0717383 //w=0.224 //l=0.115 //layer=m1 \
 //thickness=0.36 //x=56.105 //y=3.88 //x2=55.99 //y2=3.88
r474 (  1 10 ) resistor r=0.0880901 //w=0.191 //l=0.115 //layer=m1 \
 //thickness=0.36 //x=60.685 //y=3.88 //x2=60.8 //y2=3.88
r475 (  1 2 ) resistor r=4.37023 //w=0.131 //l=4.58 //layer=m1 \
 //thickness=0.36 //x=60.685 //y=3.88 //x2=56.105 //y2=3.88
ends PM_TMRDFFSNQNX1\%noxref_19

subckt PM_TMRDFFSNQNX1\%noxref_20 ( 1 2 7 9 19 20 27 35 41 42 46 49 50 51 52 \
 53 54 55 56 61 63 65 71 72 74 75 78 86 88 89 90 )
c183 ( 90 0 ) capacitor c=0.023087f //x=72.085 //y=5.2
c184 ( 89 0 ) capacitor c=0.023519f //x=71.205 //y=5.2
c185 ( 88 0 ) capacitor c=0.0224735f //x=70.325 //y=5.2
c186 ( 86 0 ) capacitor c=0.0087111f //x=72.335 //y=1.095
c187 ( 78 0 ) capacitor c=0.0331534f //x=67.49 //y=4.88
c188 ( 75 0 ) capacitor c=0.0279499f //x=67.46 //y=2.095
c189 ( 74 0 ) capacitor c=0.0421676f //x=67.46 //y=2.26
c190 ( 72 0 ) capacitor c=0.0429696f //x=68.025 //y=1.43
c191 ( 71 0 ) capacitor c=0.0192208f //x=68.025 //y=1.085
c192 ( 65 0 ) capacitor c=0.0148884f //x=67.87 //y=1.585
c193 ( 63 0 ) capacitor c=0.0157803f //x=67.87 //y=0.93
c194 ( 61 0 ) capacitor c=0.0299681f //x=67.865 //y=4.97
c195 ( 56 0 ) capacitor c=0.0205163f //x=67.495 //y=1.74
c196 ( 55 0 ) capacitor c=0.0168481f //x=67.495 //y=1.43
c197 ( 54 0 ) capacitor c=0.0174783f //x=67.495 //y=1.085
c198 ( 53 0 ) capacitor c=0.15358f //x=67.94 //y=6.2
c199 ( 52 0 ) capacitor c=0.110281f //x=67.5 //y=6.2
c200 ( 50 0 ) capacitor c=0.00106608f //x=72.23 //y=5.335
c201 ( 49 0 ) capacitor c=0.00207319f //x=71.35 //y=5.335
c202 ( 46 0 ) capacitor c=0.106476f //x=73.01 //y=4.25
c203 ( 42 0 ) capacitor c=0.00463522f //x=72.61 //y=1.845
c204 ( 41 0 ) capacitor c=0.0148737f //x=72.925 //y=1.845
c205 ( 35 0 ) capacitor c=0.0281866f //x=72.925 //y=5.335
c206 ( 27 0 ) capacitor c=0.0176454f //x=72.145 //y=5.335
c207 ( 20 0 ) capacitor c=0.00332903f //x=70.555 //y=5.335
c208 ( 19 0 ) capacitor c=0.0148427f //x=71.265 //y=5.335
c209 ( 9 0 ) capacitor c=0.070954f //x=67.46 //y=2.26
c210 ( 7 0 ) capacitor c=0.00453889f //x=67.46 //y=4.715
c211 ( 2 0 ) capacitor c=0.00822824f //x=67.575 //y=4.25
c212 ( 1 0 ) capacitor c=0.0897196f //x=72.895 //y=4.25
r213 (  80 81 ) resistor r=32.4568 //w=0.214 //l=0.075 //layer=ply \
 //thickness=0.18 //x=67.49 //y=4.97 //x2=67.49 //y2=5.045
r214 (  78 80 ) resistor r=20.271 //w=0.214 //l=0.09 //layer=ply \
 //thickness=0.18 //x=67.49 //y=4.88 //x2=67.49 //y2=4.97
r215 (  74 75 ) resistor r=52.7279 //w=0.214 //l=0.165 //layer=ply \
 //thickness=0.18 //x=67.46 //y=2.26 //x2=67.46 //y2=2.095
r216 (  72 85 ) resistor r=45.1352 //w=0.168 //l=0.173853 //layer=ply \
 //thickness=0.18 //x=68.025 //y=1.43 //x2=67.985 //y2=1.585
r217 (  71 84 ) resistor r=45.1352 //w=0.168 //l=0.173853 //layer=ply \
 //thickness=0.18 //x=68.025 //y=1.085 //x2=67.985 //y2=0.93
r218 (  71 72 ) resistor r=176.904 //w=0.094 //l=0.345 //layer=ply \
 //thickness=0.18 //x=68.025 //y=1.085 //x2=68.025 //y2=1.43
r219 (  66 83 ) resistor r=10.701 //w=0.21 //l=0.115 //layer=ply \
 //thickness=0.18 //x=67.65 //y=1.585 //x2=67.535 //y2=1.585
r220 (  65 85 ) resistor r=5.52526 //w=0.168 //l=0.115 //layer=ply \
 //thickness=0.18 //x=67.87 //y=1.585 //x2=67.985 //y2=1.585
r221 (  64 82 ) resistor r=5.52526 //w=0.168 //l=0.115 //layer=ply \
 //thickness=0.18 //x=67.65 //y=0.93 //x2=67.535 //y2=0.93
r222 (  63 84 ) resistor r=5.52526 //w=0.168 //l=0.115 //layer=ply \
 //thickness=0.18 //x=67.87 //y=0.93 //x2=67.985 //y2=0.93
r223 (  63 64 ) resistor r=112.809 //w=0.094 //l=0.22 //layer=ply \
 //thickness=0.18 //x=67.87 //y=0.93 //x2=67.65 //y2=0.93
r224 (  62 80 ) resistor r=16.5046 //w=0.27 //l=0.135 //layer=ply \
 //thickness=0.18 //x=67.625 //y=4.97 //x2=67.49 //y2=4.97
r225 (  61 68 ) resistor r=26.9307 //w=0.15 //l=0.106066 //layer=ply \
 //thickness=0.18 //x=67.865 //y=4.97 //x2=67.94 //y2=5.045
r226 (  61 62 ) resistor r=123.064 //w=0.094 //l=0.24 //layer=ply \
 //thickness=0.18 //x=67.865 //y=4.97 //x2=67.625 //y2=4.97
r227 (  56 83 ) resistor r=39.5823 //w=0.21 //l=0.173853 //layer=ply \
 //thickness=0.18 //x=67.495 //y=1.74 //x2=67.535 //y2=1.585
r228 (  56 75 ) resistor r=182.032 //w=0.094 //l=0.355 //layer=ply \
 //thickness=0.18 //x=67.495 //y=1.74 //x2=67.495 //y2=2.095
r229 (  55 83 ) resistor r=39.5823 //w=0.21 //l=0.173853 //layer=ply \
 //thickness=0.18 //x=67.495 //y=1.43 //x2=67.535 //y2=1.585
r230 (  54 82 ) resistor r=45.1352 //w=0.168 //l=0.173853 //layer=ply \
 //thickness=0.18 //x=67.495 //y=1.085 //x2=67.535 //y2=0.93
r231 (  54 55 ) resistor r=176.904 //w=0.094 //l=0.345 //layer=ply \
 //thickness=0.18 //x=67.495 //y=1.085 //x2=67.495 //y2=1.43
r232 (  53 68 ) resistor r=592.245 //w=0.094 //l=1.155 //layer=ply \
 //thickness=0.18 //x=67.94 //y=6.2 //x2=67.94 //y2=5.045
r233 (  52 81 ) resistor r=592.245 //w=0.094 //l=1.155 //layer=ply \
 //thickness=0.18 //x=67.5 //y=6.2 //x2=67.5 //y2=5.045
r234 (  51 65 ) resistor r=56.4043 //w=0.094 //l=0.11 //layer=ply \
 //thickness=0.18 //x=67.76 //y=1.585 //x2=67.87 //y2=1.585
r235 (  51 66 ) resistor r=56.4043 //w=0.094 //l=0.11 //layer=ply \
 //thickness=0.18 //x=67.76 //y=1.585 //x2=67.65 //y2=1.585
r236 (  48 78 ) resistor r=152 //w=0.17 //l=0.17 //layer=licon //count=1 \
 //x=67.49 //y=4.88 //x2=67.49 //y2=4.88
r237 (  44 46 ) resistor r=68.4492 //w=0.187 //l=1 //layer=li //thickness=0.1 \
 //x=73.01 //y=5.25 //x2=73.01 //y2=4.25
r238 (  43 46 ) resistor r=158.802 //w=0.187 //l=2.32 //layer=li \
 //thickness=0.1 //x=73.01 //y=1.93 //x2=73.01 //y2=4.25
r239 (  41 43 ) resistor r=7.15173 //w=0.17 //l=0.120208 //layer=li \
 //thickness=0.1 //x=72.925 //y=1.845 //x2=73.01 //y2=1.93
r240 (  41 42 ) resistor r=21.5615 //w=0.187 //l=0.315 //layer=li \
 //thickness=0.1 //x=72.925 //y=1.845 //x2=72.61 //y2=1.845
r241 (  37 42 ) resistor r=7.15173 //w=0.17 //l=0.120208 //layer=li \
 //thickness=0.1 //x=72.525 //y=1.76 //x2=72.61 //y2=1.845
r242 (  37 86 ) resistor r=39.016 //w=0.187 //l=0.57 //layer=li \
 //thickness=0.1 //x=72.525 //y=1.76 //x2=72.525 //y2=1.19
r243 (  36 50 ) resistor r=5.4201 //w=0.17 //l=0.085 //layer=li \
 //thickness=0.1 //x=72.315 //y=5.335 //x2=72.23 //y2=5.335
r244 (  35 44 ) resistor r=7.15173 //w=0.17 //l=0.120208 //layer=li \
 //thickness=0.1 //x=72.925 //y=5.335 //x2=73.01 //y2=5.25
r245 (  35 36 ) resistor r=41.754 //w=0.187 //l=0.61 //layer=li \
 //thickness=0.1 //x=72.925 //y=5.335 //x2=72.315 //y2=5.335
r246 (  29 50 ) resistor r=1.40859 //w=0.34 //l=0.085 //layer=li \
 //thickness=0.1 //x=72.23 //y=5.42 //x2=72.23 //y2=5.335
r247 (  29 90 ) resistor r=33.1979 //w=0.187 //l=0.485 //layer=li \
 //thickness=0.1 //x=72.23 //y=5.42 //x2=72.23 //y2=5.905
r248 (  28 49 ) resistor r=5.4201 //w=0.17 //l=0.085 //layer=li \
 //thickness=0.1 //x=71.435 //y=5.335 //x2=71.35 //y2=5.335
r249 (  27 50 ) resistor r=5.4201 //w=0.17 //l=0.085 //layer=li \
 //thickness=0.1 //x=72.145 //y=5.335 //x2=72.23 //y2=5.335
r250 (  27 28 ) resistor r=48.5989 //w=0.187 //l=0.71 //layer=li \
 //thickness=0.1 //x=72.145 //y=5.335 //x2=71.435 //y2=5.335
r251 (  21 49 ) resistor r=1.40859 //w=0.34 //l=0.085 //layer=li \
 //thickness=0.1 //x=71.35 //y=5.42 //x2=71.35 //y2=5.335
r252 (  21 89 ) resistor r=33.1979 //w=0.187 //l=0.485 //layer=li \
 //thickness=0.1 //x=71.35 //y=5.42 //x2=71.35 //y2=5.905
r253 (  19 49 ) resistor r=5.4201 //w=0.17 //l=0.085 //layer=li \
 //thickness=0.1 //x=71.265 //y=5.335 //x2=71.35 //y2=5.335
r254 (  19 20 ) resistor r=48.5989 //w=0.187 //l=0.71 //layer=li \
 //thickness=0.1 //x=71.265 //y=5.335 //x2=70.555 //y2=5.335
r255 (  13 20 ) resistor r=7.15173 //w=0.17 //l=0.120208 //layer=li \
 //thickness=0.1 //x=70.47 //y=5.42 //x2=70.555 //y2=5.335
r256 (  13 88 ) resistor r=33.1979 //w=0.187 //l=0.485 //layer=li \
 //thickness=0.1 //x=70.47 //y=5.42 //x2=70.47 //y2=5.905
r257 (  9 74 ) resistor r=152 //w=0.17 //l=0.17 //layer=licon //count=1 \
 //x=67.46 //y=2.26 //x2=67.46 //y2=2.26
r258 (  9 12 ) resistor r=136.214 //w=0.187 //l=1.99 //layer=li \
 //thickness=0.1 //x=67.46 //y=2.26 //x2=67.46 //y2=4.25
r259 (  7 48 ) resistor r=11.4737 //w=0.186 //l=0.172337 //layer=li \
 //thickness=0.1 //x=67.46 //y=4.715 //x2=67.475 //y2=4.88
r260 (  7 12 ) resistor r=31.8289 //w=0.187 //l=0.465 //layer=li \
 //thickness=0.1 //x=67.46 //y=4.715 //x2=67.46 //y2=4.25
r261 (  6 46 ) resistor r=9.3 //w=0.17 //l=0.17 //layer=mcon //count=1 \
 //x=73.01 //y=4.25 //x2=73.01 //y2=4.25
r262 (  4 12 ) resistor r=9.3 //w=0.17 //l=0.17 //layer=mcon //count=1 \
 //x=67.46 //y=4.25 //x2=67.46 //y2=4.25
r263 (  2 4 ) resistor r=0.0717383 //w=0.224 //l=0.115 //layer=m1 \
 //thickness=0.36 //x=67.575 //y=4.25 //x2=67.46 //y2=4.25
r264 (  1 6 ) resistor r=0.0717383 //w=0.224 //l=0.115 //layer=m1 \
 //thickness=0.36 //x=72.895 //y=4.25 //x2=73.01 //y2=4.25
r265 (  1 2 ) resistor r=5.07634 //w=0.131 //l=5.32 //layer=m1 \
 //thickness=0.36 //x=72.895 //y=4.25 //x2=67.575 //y2=4.25
ends PM_TMRDFFSNQNX1\%noxref_20

subckt PM_TMRDFFSNQNX1\%noxref_21 ( 1 2 3 4 6 7 8 9 10 27 28 39 41 42 46 48 55 \
 57 65 69 73 76 77 78 79 80 81 82 83 84 85 86 87 88 89 91 97 98 99 100 104 105 \
 106 111 113 115 121 122 123 124 125 130 132 134 140 141 151 152 155 163 164 \
 167 175 177 178 )
c438 ( 178 0 ) capacitor c=0.0220291f //x=43.155 //y=5.2
c439 ( 177 0 ) capacitor c=0.0217503f //x=42.275 //y=5.2
c440 ( 175 0 ) capacitor c=0.0084702f //x=43.15 //y=1.085
c441 ( 167 0 ) capacitor c=0.0352016f //x=82.28 //y=4.885
c442 ( 164 0 ) capacitor c=0.0279733f //x=82.26 //y=2.095
c443 ( 163 0 ) capacitor c=0.0467621f //x=82.26 //y=2.26
c444 ( 155 0 ) capacitor c=0.03845f //x=75.64 //y=4.885
c445 ( 152 0 ) capacitor c=0.0300885f //x=75.6 //y=2.095
c446 ( 151 0 ) capacitor c=0.0520257f //x=75.6 //y=2.26
c447 ( 141 0 ) capacitor c=0.0237734f //x=82.825 //y=1.435
c448 ( 140 0 ) capacitor c=0.0191782f //x=82.825 //y=1.085
c449 ( 134 0 ) capacitor c=0.0351663f //x=82.67 //y=1.585
c450 ( 132 0 ) capacitor c=0.0157803f //x=82.67 //y=0.93
c451 ( 130 0 ) capacitor c=0.0373879f //x=82.665 //y=4.975
c452 ( 125 0 ) capacitor c=0.0200628f //x=82.295 //y=1.74
c453 ( 124 0 ) capacitor c=0.0168575f //x=82.295 //y=1.435
c454 ( 123 0 ) capacitor c=0.0174993f //x=82.295 //y=1.085
c455 ( 122 0 ) capacitor c=0.0447087f //x=76.165 //y=1.43
c456 ( 121 0 ) capacitor c=0.019286f //x=76.165 //y=1.085
c457 ( 115 0 ) capacitor c=0.0187932f //x=76.01 //y=1.585
c458 ( 113 0 ) capacitor c=0.0157795f //x=76.01 //y=0.93
c459 ( 111 0 ) capacitor c=0.029531f //x=76.005 //y=4.975
c460 ( 106 0 ) capacitor c=0.0206178f //x=75.635 //y=1.74
c461 ( 105 0 ) capacitor c=0.016848f //x=75.635 //y=1.43
c462 ( 104 0 ) capacitor c=0.0174777f //x=75.635 //y=1.085
c463 ( 100 0 ) capacitor c=0.0556143f //x=45.905 //y=4.97
c464 ( 99 0 ) capacitor c=0.0293157f //x=46.195 //y=4.97
c465 ( 98 0 ) capacitor c=0.0347816f //x=45.86 //y=1.4
c466 ( 97 0 ) capacitor c=0.0187487f //x=45.86 //y=1.055
c467 ( 91 0 ) capacitor c=0.0137055f //x=45.705 //y=1.555
c468 ( 89 0 ) capacitor c=0.0149861f //x=45.705 //y=0.9
c469 ( 88 0 ) capacitor c=0.096037f //x=45.33 //y=2.095
c470 ( 87 0 ) capacitor c=0.0228993f //x=45.33 //y=1.71
c471 ( 86 0 ) capacitor c=0.0234352f //x=45.33 //y=1.4
c472 ( 85 0 ) capacitor c=0.0198724f //x=45.33 //y=1.055
c473 ( 84 0 ) capacitor c=0.15325f //x=82.74 //y=6.205
c474 ( 83 0 ) capacitor c=0.110411f //x=82.3 //y=6.205
c475 ( 82 0 ) capacitor c=0.154236f //x=76.08 //y=6.205
c476 ( 81 0 ) capacitor c=0.110294f //x=75.64 //y=6.205
c477 ( 80 0 ) capacitor c=0.110114f //x=46.27 //y=6.2
c478 ( 79 0 ) capacitor c=0.158956f //x=45.83 //y=6.2
c479 ( 73 0 ) capacitor c=0.00501304f //x=82.28 //y=4.885
c480 ( 69 0 ) capacitor c=0.00211606f //x=43.3 //y=5.38
c481 ( 65 0 ) capacitor c=0.0899745f //x=82.26 //y=2.26
c482 ( 57 0 ) capacitor c=0.105317f //x=75.6 //y=2.26
c483 ( 55 0 ) capacitor c=0.00669947f //x=75.6 //y=4.72
c484 ( 48 0 ) capacitor c=0.0938724f //x=45.63 //y=2.26
c485 ( 46 0 ) capacitor c=0.10219f //x=43.78 //y=2.77
c486 ( 42 0 ) capacitor c=0.00404073f //x=43.425 //y=1.835
c487 ( 41 0 ) capacitor c=0.0122201f //x=43.695 //y=1.835
c488 ( 39 0 ) capacitor c=0.0137995f //x=43.695 //y=5.38
c489 ( 28 0 ) capacitor c=0.00251459f //x=42.505 //y=5.38
c490 ( 27 0 ) capacitor c=0.0143649f //x=43.215 //y=5.38
c491 ( 10 0 ) capacitor c=0.0100708f //x=75.715 //y=4.25
c492 ( 9 0 ) capacitor c=0.189034f //x=82.145 //y=4.25
c493 ( 8 0 ) capacitor c=1.21334e-19 //x=51.265 //y=3.14
c494 ( 7 0 ) capacitor c=0.431449f //x=75.485 //y=3.14
c495 ( 4 0 ) capacitor c=0.00409365f //x=45.745 //y=2.77
c496 ( 3 0 ) capacitor c=0.0720829f //x=51.095 //y=2.77
c497 ( 2 0 ) capacitor c=0.0120208f //x=43.895 //y=2.77
c498 ( 1 0 ) capacitor c=0.0233304f //x=45.515 //y=2.77
r499 (  169 170 ) resistor r=32.4568 //w=0.214 //l=0.075 //layer=ply \
 //thickness=0.18 //x=82.28 //y=4.975 //x2=82.28 //y2=5.05
r500 (  167 169 ) resistor r=20.271 //w=0.214 //l=0.09 //layer=ply \
 //thickness=0.18 //x=82.28 //y=4.885 //x2=82.28 //y2=4.975
r501 (  163 164 ) resistor r=52.7279 //w=0.214 //l=0.165 //layer=ply \
 //thickness=0.18 //x=82.26 //y=2.26 //x2=82.26 //y2=2.095
r502 (  155 157 ) resistor r=20.271 //w=0.214 //l=0.09 //layer=ply \
 //thickness=0.18 //x=75.64 //y=4.885 //x2=75.64 //y2=4.975
r503 (  151 152 ) resistor r=52.7279 //w=0.214 //l=0.165 //layer=ply \
 //thickness=0.18 //x=75.6 //y=2.26 //x2=75.6 //y2=2.095
r504 (  141 174 ) resistor r=4.95774 //w=0.164 //l=0.112 //layer=ply \
 //thickness=0.18 //x=82.825 //y=1.435 //x2=82.825 //y2=1.547
r505 (  140 173 ) resistor r=45.1352 //w=0.168 //l=0.173853 //layer=ply \
 //thickness=0.18 //x=82.825 //y=1.085 //x2=82.785 //y2=0.93
r506 (  140 141 ) resistor r=179.468 //w=0.094 //l=0.35 //layer=ply \
 //thickness=0.18 //x=82.825 //y=1.085 //x2=82.825 //y2=1.435
r507 (  135 172 ) resistor r=10.8103 //w=0.211 //l=0.115 //layer=ply \
 //thickness=0.18 //x=82.45 //y=1.585 //x2=82.335 //y2=1.585
r508 (  134 174 ) resistor r=45.9962 //w=0.164 //l=0.17296 //layer=ply \
 //thickness=0.18 //x=82.67 //y=1.585 //x2=82.825 //y2=1.547
r509 (  133 171 ) resistor r=5.52526 //w=0.168 //l=0.115 //layer=ply \
 //thickness=0.18 //x=82.45 //y=0.93 //x2=82.335 //y2=0.93
r510 (  132 173 ) resistor r=5.52526 //w=0.168 //l=0.115 //layer=ply \
 //thickness=0.18 //x=82.67 //y=0.93 //x2=82.785 //y2=0.93
r511 (  132 133 ) resistor r=112.809 //w=0.094 //l=0.22 //layer=ply \
 //thickness=0.18 //x=82.67 //y=0.93 //x2=82.45 //y2=0.93
r512 (  131 169 ) resistor r=16.5046 //w=0.27 //l=0.135 //layer=ply \
 //thickness=0.18 //x=82.415 //y=4.975 //x2=82.28 //y2=4.975
r513 (  130 137 ) resistor r=26.9307 //w=0.15 //l=0.106066 //layer=ply \
 //thickness=0.18 //x=82.665 //y=4.975 //x2=82.74 //y2=5.05
r514 (  130 131 ) resistor r=128.191 //w=0.094 //l=0.25 //layer=ply \
 //thickness=0.18 //x=82.665 //y=4.975 //x2=82.415 //y2=4.975
r515 (  125 172 ) resistor r=39.5036 //w=0.211 //l=0.173853 //layer=ply \
 //thickness=0.18 //x=82.295 //y=1.74 //x2=82.335 //y2=1.585
r516 (  125 164 ) resistor r=182.032 //w=0.094 //l=0.355 //layer=ply \
 //thickness=0.18 //x=82.295 //y=1.74 //x2=82.295 //y2=2.095
r517 (  124 172 ) resistor r=38.3614 //w=0.211 //l=0.168819 //layer=ply \
 //thickness=0.18 //x=82.295 //y=1.435 //x2=82.335 //y2=1.585
r518 (  123 171 ) resistor r=45.1352 //w=0.168 //l=0.173853 //layer=ply \
 //thickness=0.18 //x=82.295 //y=1.085 //x2=82.335 //y2=0.93
r519 (  123 124 ) resistor r=179.468 //w=0.094 //l=0.35 //layer=ply \
 //thickness=0.18 //x=82.295 //y=1.085 //x2=82.295 //y2=1.435
r520 (  122 161 ) resistor r=45.1352 //w=0.168 //l=0.173853 //layer=ply \
 //thickness=0.18 //x=76.165 //y=1.43 //x2=76.125 //y2=1.585
r521 (  121 160 ) resistor r=45.1352 //w=0.168 //l=0.173853 //layer=ply \
 //thickness=0.18 //x=76.165 //y=1.085 //x2=76.125 //y2=0.93
r522 (  121 122 ) resistor r=176.904 //w=0.094 //l=0.345 //layer=ply \
 //thickness=0.18 //x=76.165 //y=1.085 //x2=76.165 //y2=1.43
r523 (  116 159 ) resistor r=10.701 //w=0.21 //l=0.115 //layer=ply \
 //thickness=0.18 //x=75.79 //y=1.585 //x2=75.675 //y2=1.585
r524 (  115 161 ) resistor r=5.52526 //w=0.168 //l=0.115 //layer=ply \
 //thickness=0.18 //x=76.01 //y=1.585 //x2=76.125 //y2=1.585
r525 (  114 158 ) resistor r=5.52526 //w=0.168 //l=0.115 //layer=ply \
 //thickness=0.18 //x=75.79 //y=0.93 //x2=75.675 //y2=0.93
r526 (  113 160 ) resistor r=5.52526 //w=0.168 //l=0.115 //layer=ply \
 //thickness=0.18 //x=76.01 //y=0.93 //x2=76.125 //y2=0.93
r527 (  113 114 ) resistor r=112.809 //w=0.094 //l=0.22 //layer=ply \
 //thickness=0.18 //x=76.01 //y=0.93 //x2=75.79 //y2=0.93
r528 (  112 157 ) resistor r=16.5046 //w=0.27 //l=0.135 //layer=ply \
 //thickness=0.18 //x=75.775 //y=4.975 //x2=75.64 //y2=4.975
r529 (  111 118 ) resistor r=26.9307 //w=0.15 //l=0.106066 //layer=ply \
 //thickness=0.18 //x=76.005 //y=4.975 //x2=76.08 //y2=5.05
r530 (  111 112 ) resistor r=117.936 //w=0.094 //l=0.23 //layer=ply \
 //thickness=0.18 //x=76.005 //y=4.975 //x2=75.775 //y2=4.975
r531 (  108 157 ) resistor r=32.4568 //w=0.214 //l=0.075 //layer=ply \
 //thickness=0.18 //x=75.64 //y=5.05 //x2=75.64 //y2=4.975
r532 (  106 159 ) resistor r=39.5823 //w=0.21 //l=0.173853 //layer=ply \
 //thickness=0.18 //x=75.635 //y=1.74 //x2=75.675 //y2=1.585
r533 (  106 152 ) resistor r=182.032 //w=0.094 //l=0.355 //layer=ply \
 //thickness=0.18 //x=75.635 //y=1.74 //x2=75.635 //y2=2.095
r534 (  105 159 ) resistor r=39.5823 //w=0.21 //l=0.173853 //layer=ply \
 //thickness=0.18 //x=75.635 //y=1.43 //x2=75.675 //y2=1.585
r535 (  104 158 ) resistor r=45.1352 //w=0.168 //l=0.173853 //layer=ply \
 //thickness=0.18 //x=75.635 //y=1.085 //x2=75.675 //y2=0.93
r536 (  104 105 ) resistor r=176.904 //w=0.094 //l=0.345 //layer=ply \
 //thickness=0.18 //x=75.635 //y=1.085 //x2=75.635 //y2=1.43
r537 (  99 101 ) resistor r=26.9307 //w=0.15 //l=0.106066 //layer=ply \
 //thickness=0.18 //x=46.195 //y=4.97 //x2=46.27 //y2=5.045
r538 (  99 100 ) resistor r=148.702 //w=0.094 //l=0.29 //layer=ply \
 //thickness=0.18 //x=46.195 //y=4.97 //x2=45.905 //y2=4.97
r539 (  98 149 ) resistor r=45.1352 //w=0.168 //l=0.173853 //layer=ply \
 //thickness=0.18 //x=45.86 //y=1.4 //x2=45.82 //y2=1.555
r540 (  97 148 ) resistor r=45.1352 //w=0.168 //l=0.173853 //layer=ply \
 //thickness=0.18 //x=45.86 //y=1.055 //x2=45.82 //y2=0.9
r541 (  97 98 ) resistor r=176.904 //w=0.094 //l=0.345 //layer=ply \
 //thickness=0.18 //x=45.86 //y=1.055 //x2=45.86 //y2=1.4
r542 (  94 100 ) resistor r=22.7971 //w=0.269 //l=0.106066 //layer=ply \
 //thickness=0.18 //x=45.83 //y=5.045 //x2=45.905 //y2=4.97
r543 (  94 147 ) resistor r=35.8364 //w=0.269 //l=0.270185 //layer=ply \
 //thickness=0.18 //x=45.83 //y=5.045 //x2=45.63 //y2=4.88
r544 (  92 143 ) resistor r=10.701 //w=0.21 //l=0.115 //layer=ply \
 //thickness=0.18 //x=45.485 //y=1.555 //x2=45.37 //y2=1.555
r545 (  91 149 ) resistor r=5.52526 //w=0.168 //l=0.115 //layer=ply \
 //thickness=0.18 //x=45.705 //y=1.555 //x2=45.82 //y2=1.555
r546 (  90 142 ) resistor r=5.52526 //w=0.168 //l=0.115 //layer=ply \
 //thickness=0.18 //x=45.485 //y=0.9 //x2=45.37 //y2=0.9
r547 (  89 148 ) resistor r=5.52526 //w=0.168 //l=0.115 //layer=ply \
 //thickness=0.18 //x=45.705 //y=0.9 //x2=45.82 //y2=0.9
r548 (  89 90 ) resistor r=112.809 //w=0.094 //l=0.22 //layer=ply \
 //thickness=0.18 //x=45.705 //y=0.9 //x2=45.485 //y2=0.9
r549 (  88 145 ) resistor r=58.7805 //w=0.246 //l=0.373497 //layer=ply \
 //thickness=0.18 //x=45.33 //y=2.095 //x2=45.63 //y2=2.26
r550 (  87 143 ) resistor r=39.5823 //w=0.21 //l=0.173853 //layer=ply \
 //thickness=0.18 //x=45.33 //y=1.71 //x2=45.37 //y2=1.555
r551 (  87 88 ) resistor r=197.415 //w=0.094 //l=0.385 //layer=ply \
 //thickness=0.18 //x=45.33 //y=1.71 //x2=45.33 //y2=2.095
r552 (  86 143 ) resistor r=39.5823 //w=0.21 //l=0.173853 //layer=ply \
 //thickness=0.18 //x=45.33 //y=1.4 //x2=45.37 //y2=1.555
r553 (  85 142 ) resistor r=45.1352 //w=0.168 //l=0.173853 //layer=ply \
 //thickness=0.18 //x=45.33 //y=1.055 //x2=45.37 //y2=0.9
r554 (  85 86 ) resistor r=176.904 //w=0.094 //l=0.345 //layer=ply \
 //thickness=0.18 //x=45.33 //y=1.055 //x2=45.33 //y2=1.4
r555 (  84 137 ) resistor r=592.245 //w=0.094 //l=1.155 //layer=ply \
 //thickness=0.18 //x=82.74 //y=6.205 //x2=82.74 //y2=5.05
r556 (  83 170 ) resistor r=592.245 //w=0.094 //l=1.155 //layer=ply \
 //thickness=0.18 //x=82.3 //y=6.205 //x2=82.3 //y2=5.05
r557 (  82 118 ) resistor r=592.245 //w=0.094 //l=1.155 //layer=ply \
 //thickness=0.18 //x=76.08 //y=6.205 //x2=76.08 //y2=5.05
r558 (  81 108 ) resistor r=592.245 //w=0.094 //l=1.155 //layer=ply \
 //thickness=0.18 //x=75.64 //y=6.205 //x2=75.64 //y2=5.05
r559 (  80 101 ) resistor r=592.245 //w=0.094 //l=1.155 //layer=ply \
 //thickness=0.18 //x=46.27 //y=6.2 //x2=46.27 //y2=5.045
r560 (  79 94 ) resistor r=592.245 //w=0.094 //l=1.155 //layer=ply \
 //thickness=0.18 //x=45.83 //y=6.2 //x2=45.83 //y2=5.045
r561 (  78 134 ) resistor r=56.4043 //w=0.094 //l=0.11 //layer=ply \
 //thickness=0.18 //x=82.56 //y=1.585 //x2=82.67 //y2=1.585
r562 (  78 135 ) resistor r=56.4043 //w=0.094 //l=0.11 //layer=ply \
 //thickness=0.18 //x=82.56 //y=1.585 //x2=82.45 //y2=1.585
r563 (  77 115 ) resistor r=56.4043 //w=0.094 //l=0.11 //layer=ply \
 //thickness=0.18 //x=75.9 //y=1.585 //x2=76.01 //y2=1.585
r564 (  77 116 ) resistor r=56.4043 //w=0.094 //l=0.11 //layer=ply \
 //thickness=0.18 //x=75.9 //y=1.585 //x2=75.79 //y2=1.585
r565 (  76 91 ) resistor r=56.4043 //w=0.094 //l=0.11 //layer=ply \
 //thickness=0.18 //x=45.595 //y=1.555 //x2=45.705 //y2=1.555
r566 (  76 92 ) resistor r=56.4043 //w=0.094 //l=0.11 //layer=ply \
 //thickness=0.18 //x=45.595 //y=1.555 //x2=45.485 //y2=1.555
r567 (  73 167 ) resistor r=152 //w=0.17 //l=0.17 //layer=licon //count=1 \
 //x=82.28 //y=4.885 //x2=82.28 //y2=4.885
r568 (  73 74 ) resistor r=10.3507 //w=0.207 //l=0.165 //layer=li \
 //thickness=0.1 //x=82.27 //y=4.885 //x2=82.27 //y2=4.72
r569 (  71 155 ) resistor r=152 //w=0.17 //l=0.17 //layer=licon //count=1 \
 //x=75.64 //y=4.885 //x2=75.64 //y2=4.885
r570 (  68 74 ) resistor r=32.1711 //w=0.187 //l=0.47 //layer=li \
 //thickness=0.1 //x=82.26 //y=4.25 //x2=82.26 //y2=4.72
r571 (  65 163 ) resistor r=152 //w=0.17 //l=0.17 //layer=licon //count=1 \
 //x=82.26 //y=2.26 //x2=82.26 //y2=2.26
r572 (  65 68 ) resistor r=136.214 //w=0.187 //l=1.99 //layer=li \
 //thickness=0.1 //x=82.26 //y=2.26 //x2=82.26 //y2=4.25
r573 (  60 62 ) resistor r=75.9786 //w=0.187 //l=1.11 //layer=li \
 //thickness=0.1 //x=75.6 //y=3.14 //x2=75.6 //y2=4.25
r574 (  57 151 ) resistor r=152 //w=0.17 //l=0.17 //layer=licon //count=1 \
 //x=75.6 //y=2.26 //x2=75.6 //y2=2.26
r575 (  57 60 ) resistor r=60.2353 //w=0.187 //l=0.88 //layer=li \
 //thickness=0.1 //x=75.6 //y=2.26 //x2=75.6 //y2=3.14
r576 (  55 71 ) resistor r=11.2426 //w=0.191 //l=0.174714 //layer=li \
 //thickness=0.1 //x=75.6 //y=4.72 //x2=75.62 //y2=4.885
r577 (  55 62 ) resistor r=32.1711 //w=0.187 //l=0.47 //layer=li \
 //thickness=0.1 //x=75.6 //y=4.72 //x2=75.6 //y2=4.25
r578 (  53 147 ) resistor r=152 //w=0.17 //l=0.17 //layer=licon //count=1 \
 //x=45.63 //y=4.88 //x2=45.63 //y2=4.88
r579 (  51 53 ) resistor r=144.428 //w=0.187 //l=2.11 //layer=li \
 //thickness=0.1 //x=45.63 //y=2.77 //x2=45.63 //y2=4.88
r580 (  48 145 ) resistor r=152 //w=0.17 //l=0.17 //layer=licon //count=1 \
 //x=45.63 //y=2.26 //x2=45.63 //y2=2.26
r581 (  48 51 ) resistor r=34.9091 //w=0.187 //l=0.51 //layer=li \
 //thickness=0.1 //x=45.63 //y=2.26 //x2=45.63 //y2=2.77
r582 (  44 46 ) resistor r=172.834 //w=0.187 //l=2.525 //layer=li \
 //thickness=0.1 //x=43.78 //y=5.295 //x2=43.78 //y2=2.77
r583 (  43 46 ) resistor r=58.1818 //w=0.187 //l=0.85 //layer=li \
 //thickness=0.1 //x=43.78 //y=1.92 //x2=43.78 //y2=2.77
r584 (  41 43 ) resistor r=7.15173 //w=0.17 //l=0.120208 //layer=li \
 //thickness=0.1 //x=43.695 //y=1.835 //x2=43.78 //y2=1.92
r585 (  41 42 ) resistor r=18.4813 //w=0.187 //l=0.27 //layer=li \
 //thickness=0.1 //x=43.695 //y=1.835 //x2=43.425 //y2=1.835
r586 (  40 69 ) resistor r=5.4201 //w=0.17 //l=0.085 //layer=li \
 //thickness=0.1 //x=43.385 //y=5.38 //x2=43.3 //y2=5.38
r587 (  39 44 ) resistor r=7.15173 //w=0.17 //l=0.120208 //layer=li \
 //thickness=0.1 //x=43.695 //y=5.38 //x2=43.78 //y2=5.295
r588 (  39 40 ) resistor r=21.2193 //w=0.187 //l=0.31 //layer=li \
 //thickness=0.1 //x=43.695 //y=5.38 //x2=43.385 //y2=5.38
r589 (  35 42 ) resistor r=7.15173 //w=0.17 //l=0.120208 //layer=li \
 //thickness=0.1 //x=43.34 //y=1.75 //x2=43.425 //y2=1.835
r590 (  35 175 ) resistor r=39.016 //w=0.187 //l=0.57 //layer=li \
 //thickness=0.1 //x=43.34 //y=1.75 //x2=43.34 //y2=1.18
r591 (  29 69 ) resistor r=1.40859 //w=0.34 //l=0.085 //layer=li \
 //thickness=0.1 //x=43.3 //y=5.465 //x2=43.3 //y2=5.38
r592 (  29 178 ) resistor r=30.1176 //w=0.187 //l=0.44 //layer=li \
 //thickness=0.1 //x=43.3 //y=5.465 //x2=43.3 //y2=5.905
r593 (  27 69 ) resistor r=5.4201 //w=0.17 //l=0.085 //layer=li \
 //thickness=0.1 //x=43.215 //y=5.38 //x2=43.3 //y2=5.38
r594 (  27 28 ) resistor r=48.5989 //w=0.187 //l=0.71 //layer=li \
 //thickness=0.1 //x=43.215 //y=5.38 //x2=42.505 //y2=5.38
r595 (  21 28 ) resistor r=7.15173 //w=0.17 //l=0.120208 //layer=li \
 //thickness=0.1 //x=42.42 //y=5.465 //x2=42.505 //y2=5.38
r596 (  21 177 ) resistor r=30.1176 //w=0.187 //l=0.44 //layer=li \
 //thickness=0.1 //x=42.42 //y=5.465 //x2=42.42 //y2=5.905
r597 (  20 68 ) resistor r=9.3 //w=0.17 //l=0.17 //layer=mcon //count=1 \
 //x=82.26 //y=4.25 //x2=82.26 //y2=4.25
r598 (  18 60 ) resistor r=9.3 //w=0.17 //l=0.17 //layer=mcon //count=1 \
 //x=75.6 //y=3.14 //x2=75.6 //y2=3.14
r599 (  16 62 ) resistor r=9.3 //w=0.17 //l=0.17 //layer=mcon //count=1 \
 //x=75.6 //y=4.25 //x2=75.6 //y2=4.25
r600 (  14 51 ) resistor r=9.3 //w=0.17 //l=0.17 //layer=mcon //count=1 \
 //x=45.63 //y=2.77 //x2=45.63 //y2=2.77
r601 (  12 46 ) resistor r=9.3 //w=0.17 //l=0.17 //layer=mcon //count=1 \
 //x=43.78 //y=2.77 //x2=43.78 //y2=2.77
r602 (  10 16 ) resistor r=0.0717383 //w=0.224 //l=0.115 //layer=m1 \
 //thickness=0.36 //x=75.715 //y=4.25 //x2=75.6 //y2=4.25
r603 (  9 20 ) resistor r=0.0717383 //w=0.224 //l=0.115 //layer=m1 \
 //thickness=0.36 //x=82.145 //y=4.25 //x2=82.26 //y2=4.25
r604 (  9 10 ) resistor r=6.1355 //w=0.131 //l=6.43 //layer=m1 \
 //thickness=0.36 //x=82.145 //y=4.25 //x2=75.715 //y2=4.25
r605 (  7 18 ) resistor r=0.0717383 //w=0.224 //l=0.115 //layer=m1 \
 //thickness=0.36 //x=75.485 //y=3.14 //x2=75.6 //y2=3.14
r606 (  7 8 ) resistor r=23.1107 //w=0.131 //l=24.22 //layer=m1 \
 //thickness=0.36 //x=75.485 //y=3.14 //x2=51.265 //y2=3.14
r607 (  6 8 ) resistor r=0.0698411 //w=0.17 //l=0.120208 //layer=m1 \
 //thickness=0.36 //x=51.18 //y=3.055 //x2=51.265 //y2=3.14
r608 (  5 6 ) resistor r=0.19084 //w=0.131 //l=0.2 //layer=m1 //thickness=0.36 \
 //x=51.18 //y=2.855 //x2=51.18 //y2=3.055
r609 (  4 14 ) resistor r=0.0880901 //w=0.191 //l=0.115 //layer=m1 \
 //thickness=0.36 //x=45.745 //y=2.77 //x2=45.63 //y2=2.77
r610 (  3 5 ) resistor r=0.0698411 //w=0.17 //l=0.120208 //layer=m1 \
 //thickness=0.36 //x=51.095 //y=2.77 //x2=51.18 //y2=2.855
r611 (  3 4 ) resistor r=5.10496 //w=0.131 //l=5.35 //layer=m1 \
 //thickness=0.36 //x=51.095 //y=2.77 //x2=45.745 //y2=2.77
r612 (  2 12 ) resistor r=0.0717383 //w=0.224 //l=0.115 //layer=m1 \
 //thickness=0.36 //x=43.895 //y=2.77 //x2=43.78 //y2=2.77
r613 (  1 14 ) resistor r=0.0880901 //w=0.191 //l=0.115 //layer=m1 \
 //thickness=0.36 //x=45.515 //y=2.77 //x2=45.63 //y2=2.77
r614 (  1 2 ) resistor r=1.5458 //w=0.131 //l=1.62 //layer=m1 //thickness=0.36 \
 //x=45.515 //y=2.77 //x2=43.895 //y2=2.77
ends PM_TMRDFFSNQNX1\%noxref_21

subckt PM_TMRDFFSNQNX1\%noxref_22 ( 1 2 13 14 15 23 29 30 37 50 51 52 53 54 )
c91 ( 54 0 ) capacitor c=0.034295f //x=79.475 //y=5.205
c92 ( 53 0 ) capacitor c=0.0174957f //x=78.595 //y=5.205
c93 ( 51 0 ) capacitor c=0.0214849f //x=75.715 //y=5.205
c94 ( 50 0 ) capacitor c=0.0217161f //x=74.835 //y=5.205
c95 ( 49 0 ) capacitor c=0.00115294f //x=78.74 //y=7.09
c96 ( 37 0 ) capacitor c=0.0131238f //x=79.535 //y=7.09
c97 ( 30 0 ) capacitor c=0.00386507f //x=77.945 //y=7.09
c98 ( 29 0 ) capacitor c=0.00951687f //x=78.655 //y=7.09
c99 ( 23 0 ) capacitor c=0.0455351f //x=77.86 //y=5.39
c100 ( 15 0 ) capacitor c=0.00871244f //x=75.86 //y=5.475
c101 ( 14 0 ) capacitor c=0.00290434f //x=75.065 //y=5.39
c102 ( 13 0 ) capacitor c=0.0139202f //x=75.775 //y=5.39
c103 ( 2 0 ) capacitor c=0.0091252f //x=75.975 //y=5.39
c104 ( 1 0 ) capacitor c=0.0484159f //x=77.745 //y=5.39
r105 (  39 54 ) resistor r=5.81818 //w=0.187 //l=0.085 //layer=li \
 //thickness=0.1 //x=79.62 //y=7.005 //x2=79.62 //y2=6.92
r106 (  38 49 ) resistor r=5.4201 //w=0.17 //l=0.085 //layer=li \
 //thickness=0.1 //x=78.825 //y=7.09 //x2=78.74 //y2=7.09
r107 (  37 39 ) resistor r=7.15173 //w=0.17 //l=0.120208 //layer=li \
 //thickness=0.1 //x=79.535 //y=7.09 //x2=79.62 //y2=7.005
r108 (  37 38 ) resistor r=48.5989 //w=0.187 //l=0.71 //layer=li \
 //thickness=0.1 //x=79.535 //y=7.09 //x2=78.825 //y2=7.09
r109 (  31 49 ) resistor r=1.40859 //w=0.34 //l=0.085 //layer=li \
 //thickness=0.1 //x=78.74 //y=7.005 //x2=78.74 //y2=7.09
r110 (  31 53 ) resistor r=5.81818 //w=0.187 //l=0.085 //layer=li \
 //thickness=0.1 //x=78.74 //y=7.005 //x2=78.74 //y2=6.92
r111 (  29 49 ) resistor r=5.4201 //w=0.17 //l=0.085 //layer=li \
 //thickness=0.1 //x=78.655 //y=7.09 //x2=78.74 //y2=7.09
r112 (  29 30 ) resistor r=48.5989 //w=0.187 //l=0.71 //layer=li \
 //thickness=0.1 //x=78.655 //y=7.09 //x2=77.945 //y2=7.09
r113 (  23 52 ) resistor r=58.1818 //w=0.187 //l=0.85 //layer=li \
 //thickness=0.1 //x=77.86 //y=5.39 //x2=77.86 //y2=6.24
r114 (  21 30 ) resistor r=7.15173 //w=0.17 //l=0.120208 //layer=li \
 //thickness=0.1 //x=77.86 //y=7.005 //x2=77.945 //y2=7.09
r115 (  21 52 ) resistor r=5.81818 //w=0.187 //l=0.085 //layer=li \
 //thickness=0.1 //x=77.86 //y=7.005 //x2=77.86 //y2=6.92
r116 (  15 48 ) resistor r=3.57586 //w=0.17 //l=0.125 //layer=li \
 //thickness=0.1 //x=75.86 //y=5.475 //x2=75.86 //y2=5.35
r117 (  15 51 ) resistor r=52.3636 //w=0.187 //l=0.765 //layer=li \
 //thickness=0.1 //x=75.86 //y=5.475 //x2=75.86 //y2=6.24
r118 (  13 48 ) resistor r=3.57586 //w=0.17 //l=0.103078 //layer=li \
 //thickness=0.1 //x=75.775 //y=5.39 //x2=75.86 //y2=5.35
r119 (  13 14 ) resistor r=48.5989 //w=0.187 //l=0.71 //layer=li \
 //thickness=0.1 //x=75.775 //y=5.39 //x2=75.065 //y2=5.39
r120 (  7 14 ) resistor r=7.15173 //w=0.17 //l=0.120208 //layer=li \
 //thickness=0.1 //x=74.98 //y=5.475 //x2=75.065 //y2=5.39
r121 (  7 50 ) resistor r=29.0909 //w=0.187 //l=0.425 //layer=li \
 //thickness=0.1 //x=74.98 //y=5.475 //x2=74.98 //y2=5.9
r122 (  6 23 ) resistor r=9.3 //w=0.17 //l=0.17 //layer=mcon //count=1 \
 //x=77.86 //y=5.39 //x2=77.86 //y2=5.39
r123 (  4 48 ) resistor r=9.3 //w=0.17 //l=0.17 //layer=mcon //count=1 \
 //x=75.86 //y=5.39 //x2=75.86 //y2=5.39
r124 (  2 4 ) resistor r=0.0717383 //w=0.224 //l=0.115 //layer=m1 \
 //thickness=0.36 //x=75.975 //y=5.39 //x2=75.86 //y2=5.39
r125 (  1 6 ) resistor r=0.0717383 //w=0.224 //l=0.115 //layer=m1 \
 //thickness=0.36 //x=77.745 //y=5.39 //x2=77.86 //y2=5.39
r126 (  1 2 ) resistor r=1.68893 //w=0.131 //l=1.77 //layer=m1 \
 //thickness=0.36 //x=77.745 //y=5.39 //x2=75.975 //y2=5.39
ends PM_TMRDFFSNQNX1\%noxref_22

subckt PM_TMRDFFSNQNX1\%noxref_23 ( 1 2 3 4 5 6 21 22 33 35 36 40 42 50 58 65 \
 66 67 68 69 70 71 72 73 74 75 76 77 78 79 81 87 88 89 90 94 95 96 97 101 103 \
 106 107 108 109 113 114 115 116 120 122 128 129 139 152 155 157 158 )
c349 ( 158 0 ) capacitor c=0.0220291f //x=67.575 //y=5.2
c350 ( 157 0 ) capacitor c=0.0217503f //x=66.695 //y=5.2
c351 ( 155 0 ) capacitor c=0.0084702f //x=67.57 //y=1.085
c352 ( 152 0 ) capacitor c=0.0655948f //x=78.19 //y=4.885
c353 ( 139 0 ) capacitor c=0.0545009f //x=74.49 //y=2.26
c354 ( 129 0 ) capacitor c=0.0342409f //x=78.525 //y=1.39
c355 ( 128 0 ) capacitor c=0.0187384f //x=78.525 //y=1.045
c356 ( 122 0 ) capacitor c=0.0141797f //x=78.37 //y=1.545
c357 ( 120 0 ) capacitor c=0.0149844f //x=78.37 //y=0.89
c358 ( 116 0 ) capacitor c=0.10193f //x=77.995 //y=2.095
c359 ( 115 0 ) capacitor c=0.0225105f //x=77.995 //y=1.7
c360 ( 114 0 ) capacitor c=0.0234376f //x=77.995 //y=1.39
c361 ( 113 0 ) capacitor c=0.0199343f //x=77.995 //y=1.045
c362 ( 109 0 ) capacitor c=0.0318948f //x=75.195 //y=1.39
c363 ( 108 0 ) capacitor c=0.0187384f //x=75.195 //y=1.045
c364 ( 107 0 ) capacitor c=0.0607141f //x=74.835 //y=4.975
c365 ( 106 0 ) capacitor c=0.0292043f //x=75.125 //y=4.975
c366 ( 103 0 ) capacitor c=0.0157913f //x=75.04 //y=1.545
c367 ( 101 0 ) capacitor c=0.0149844f //x=75.04 //y=0.89
c368 ( 97 0 ) capacitor c=0.0302441f //x=74.665 //y=2.095
c369 ( 96 0 ) capacitor c=0.0238107f //x=74.665 //y=1.7
c370 ( 95 0 ) capacitor c=0.0234352f //x=74.665 //y=1.39
c371 ( 94 0 ) capacitor c=0.0199931f //x=74.665 //y=1.045
c372 ( 90 0 ) capacitor c=0.0555336f //x=70.325 //y=4.97
c373 ( 89 0 ) capacitor c=0.0293157f //x=70.615 //y=4.97
c374 ( 88 0 ) capacitor c=0.0347816f //x=70.28 //y=1.4
c375 ( 87 0 ) capacitor c=0.0187487f //x=70.28 //y=1.055
c376 ( 81 0 ) capacitor c=0.0137055f //x=70.125 //y=1.555
c377 ( 79 0 ) capacitor c=0.0149861f //x=70.125 //y=0.9
c378 ( 78 0 ) capacitor c=0.096037f //x=69.75 //y=2.095
c379 ( 77 0 ) capacitor c=0.0228993f //x=69.75 //y=1.71
c380 ( 76 0 ) capacitor c=0.0234352f //x=69.75 //y=1.4
c381 ( 75 0 ) capacitor c=0.0198724f //x=69.75 //y=1.055
c382 ( 74 0 ) capacitor c=0.110336f //x=78.52 //y=6.205
c383 ( 73 0 ) capacitor c=0.154049f //x=78.08 //y=6.205
c384 ( 72 0 ) capacitor c=0.110003f //x=75.2 //y=6.205
c385 ( 71 0 ) capacitor c=0.15424f //x=74.76 //y=6.205
c386 ( 70 0 ) capacitor c=0.110114f //x=70.69 //y=6.2
c387 ( 69 0 ) capacitor c=0.158956f //x=70.25 //y=6.2
c388 ( 65 0 ) capacitor c=0.0023043f //x=67.72 //y=5.38
c389 ( 58 0 ) capacitor c=0.117496f //x=78.19 //y=2.26
c390 ( 50 0 ) capacitor c=0.0971978f //x=74.49 //y=2.26
c391 ( 42 0 ) capacitor c=0.0964287f //x=70.05 //y=2.26
c392 ( 40 0 ) capacitor c=0.104451f //x=68.2 //y=4.62
c393 ( 36 0 ) capacitor c=0.00404073f //x=67.845 //y=1.835
c394 ( 35 0 ) capacitor c=0.0122201f //x=68.115 //y=1.835
c395 ( 33 0 ) capacitor c=0.0139793f //x=68.115 //y=5.38
c396 ( 22 0 ) capacitor c=0.00272496f //x=66.925 //y=5.38
c397 ( 21 0 ) capacitor c=0.0154563f //x=67.635 //y=5.38
c398 ( 6 0 ) capacitor c=0.00561501f //x=74.605 //y=4.62
c399 ( 5 0 ) capacitor c=0.085624f //x=78.075 //y=4.62
c400 ( 4 0 ) capacitor c=0.00510592f //x=70.165 //y=4.62
c401 ( 3 0 ) capacitor c=0.100896f //x=74.375 //y=4.62
c402 ( 2 0 ) capacitor c=0.0110676f //x=68.315 //y=4.62
c403 ( 1 0 ) capacitor c=0.0443366f //x=69.935 //y=4.62
r404 (  150 152 ) resistor r=22.7554 //w=0.233 //l=0.11 //layer=ply \
 //thickness=0.18 //x=78.08 //y=4.885 //x2=78.19 //y2=4.885
r405 (  129 154 ) resistor r=45.1352 //w=0.168 //l=0.173853 //layer=ply \
 //thickness=0.18 //x=78.525 //y=1.39 //x2=78.485 //y2=1.545
r406 (  128 153 ) resistor r=45.1352 //w=0.168 //l=0.173853 //layer=ply \
 //thickness=0.18 //x=78.525 //y=1.045 //x2=78.485 //y2=0.89
r407 (  128 129 ) resistor r=176.904 //w=0.094 //l=0.345 //layer=ply \
 //thickness=0.18 //x=78.525 //y=1.045 //x2=78.525 //y2=1.39
r408 (  125 152 ) resistor r=68.2661 //w=0.233 //l=0.404166 //layer=ply \
 //thickness=0.18 //x=78.52 //y=5.05 //x2=78.19 //y2=4.885
r409 (  123 149 ) resistor r=10.701 //w=0.21 //l=0.115 //layer=ply \
 //thickness=0.18 //x=78.15 //y=1.545 //x2=78.035 //y2=1.545
r410 (  122 154 ) resistor r=5.52526 //w=0.168 //l=0.115 //layer=ply \
 //thickness=0.18 //x=78.37 //y=1.545 //x2=78.485 //y2=1.545
r411 (  121 148 ) resistor r=5.52526 //w=0.168 //l=0.115 //layer=ply \
 //thickness=0.18 //x=78.15 //y=0.89 //x2=78.035 //y2=0.89
r412 (  120 153 ) resistor r=5.52526 //w=0.168 //l=0.115 //layer=ply \
 //thickness=0.18 //x=78.37 //y=0.89 //x2=78.485 //y2=0.89
r413 (  120 121 ) resistor r=112.809 //w=0.094 //l=0.22 //layer=ply \
 //thickness=0.18 //x=78.37 //y=0.89 //x2=78.15 //y2=0.89
r414 (  117 150 ) resistor r=13.0941 //w=0.233 //l=0.165 //layer=ply \
 //thickness=0.18 //x=78.08 //y=5.05 //x2=78.08 //y2=4.885
r415 (  116 147 ) resistor r=34.8111 //w=0.27 //l=0.264953 //layer=ply \
 //thickness=0.18 //x=77.995 //y=2.095 //x2=78.19 //y2=2.26
r416 (  115 149 ) resistor r=39.5823 //w=0.21 //l=0.173853 //layer=ply \
 //thickness=0.18 //x=77.995 //y=1.7 //x2=78.035 //y2=1.545
r417 (  115 116 ) resistor r=202.543 //w=0.094 //l=0.395 //layer=ply \
 //thickness=0.18 //x=77.995 //y=1.7 //x2=77.995 //y2=2.095
r418 (  114 149 ) resistor r=39.5823 //w=0.21 //l=0.173853 //layer=ply \
 //thickness=0.18 //x=77.995 //y=1.39 //x2=78.035 //y2=1.545
r419 (  113 148 ) resistor r=45.1352 //w=0.168 //l=0.173853 //layer=ply \
 //thickness=0.18 //x=77.995 //y=1.045 //x2=78.035 //y2=0.89
r420 (  113 114 ) resistor r=176.904 //w=0.094 //l=0.345 //layer=ply \
 //thickness=0.18 //x=77.995 //y=1.045 //x2=77.995 //y2=1.39
r421 (  109 145 ) resistor r=45.1352 //w=0.168 //l=0.173853 //layer=ply \
 //thickness=0.18 //x=75.195 //y=1.39 //x2=75.155 //y2=1.545
r422 (  108 144 ) resistor r=45.1352 //w=0.168 //l=0.173853 //layer=ply \
 //thickness=0.18 //x=75.195 //y=1.045 //x2=75.155 //y2=0.89
r423 (  108 109 ) resistor r=176.904 //w=0.094 //l=0.345 //layer=ply \
 //thickness=0.18 //x=75.195 //y=1.045 //x2=75.195 //y2=1.39
r424 (  106 110 ) resistor r=26.9307 //w=0.15 //l=0.106066 //layer=ply \
 //thickness=0.18 //x=75.125 //y=4.975 //x2=75.2 //y2=5.05
r425 (  106 107 ) resistor r=148.702 //w=0.094 //l=0.29 //layer=ply \
 //thickness=0.18 //x=75.125 //y=4.975 //x2=74.835 //y2=4.975
r426 (  104 143 ) resistor r=10.701 //w=0.21 //l=0.115 //layer=ply \
 //thickness=0.18 //x=74.82 //y=1.545 //x2=74.705 //y2=1.545
r427 (  103 145 ) resistor r=5.52526 //w=0.168 //l=0.115 //layer=ply \
 //thickness=0.18 //x=75.04 //y=1.545 //x2=75.155 //y2=1.545
r428 (  102 142 ) resistor r=5.52526 //w=0.168 //l=0.115 //layer=ply \
 //thickness=0.18 //x=74.82 //y=0.89 //x2=74.705 //y2=0.89
r429 (  101 144 ) resistor r=5.52526 //w=0.168 //l=0.115 //layer=ply \
 //thickness=0.18 //x=75.04 //y=0.89 //x2=75.155 //y2=0.89
r430 (  101 102 ) resistor r=112.809 //w=0.094 //l=0.22 //layer=ply \
 //thickness=0.18 //x=75.04 //y=0.89 //x2=74.82 //y2=0.89
r431 (  98 107 ) resistor r=22.1787 //w=0.252 //l=0.106066 //layer=ply \
 //thickness=0.18 //x=74.76 //y=5.05 //x2=74.835 //y2=4.975
r432 (  98 141 ) resistor r=51.6429 //w=0.252 //l=0.34271 //layer=ply \
 //thickness=0.18 //x=74.76 //y=5.05 //x2=74.49 //y2=4.885
r433 (  97 139 ) resistor r=30.4513 //w=0.277 //l=0.243926 //layer=ply \
 //thickness=0.18 //x=74.665 //y=2.095 //x2=74.49 //y2=2.26
r434 (  96 143 ) resistor r=39.5823 //w=0.21 //l=0.173853 //layer=ply \
 //thickness=0.18 //x=74.665 //y=1.7 //x2=74.705 //y2=1.545
r435 (  96 97 ) resistor r=202.543 //w=0.094 //l=0.395 //layer=ply \
 //thickness=0.18 //x=74.665 //y=1.7 //x2=74.665 //y2=2.095
r436 (  95 143 ) resistor r=39.5823 //w=0.21 //l=0.173853 //layer=ply \
 //thickness=0.18 //x=74.665 //y=1.39 //x2=74.705 //y2=1.545
r437 (  94 142 ) resistor r=45.1352 //w=0.168 //l=0.173853 //layer=ply \
 //thickness=0.18 //x=74.665 //y=1.045 //x2=74.705 //y2=0.89
r438 (  94 95 ) resistor r=176.904 //w=0.094 //l=0.345 //layer=ply \
 //thickness=0.18 //x=74.665 //y=1.045 //x2=74.665 //y2=1.39
r439 (  89 91 ) resistor r=26.9307 //w=0.15 //l=0.106066 //layer=ply \
 //thickness=0.18 //x=70.615 //y=4.97 //x2=70.69 //y2=5.045
r440 (  89 90 ) resistor r=148.702 //w=0.094 //l=0.29 //layer=ply \
 //thickness=0.18 //x=70.615 //y=4.97 //x2=70.325 //y2=4.97
r441 (  88 137 ) resistor r=45.1352 //w=0.168 //l=0.173853 //layer=ply \
 //thickness=0.18 //x=70.28 //y=1.4 //x2=70.24 //y2=1.555
r442 (  87 136 ) resistor r=45.1352 //w=0.168 //l=0.173853 //layer=ply \
 //thickness=0.18 //x=70.28 //y=1.055 //x2=70.24 //y2=0.9
r443 (  87 88 ) resistor r=176.904 //w=0.094 //l=0.345 //layer=ply \
 //thickness=0.18 //x=70.28 //y=1.055 //x2=70.28 //y2=1.4
r444 (  84 90 ) resistor r=22.7971 //w=0.269 //l=0.106066 //layer=ply \
 //thickness=0.18 //x=70.25 //y=5.045 //x2=70.325 //y2=4.97
r445 (  84 135 ) resistor r=35.8364 //w=0.269 //l=0.270185 //layer=ply \
 //thickness=0.18 //x=70.25 //y=5.045 //x2=70.05 //y2=4.88
r446 (  82 131 ) resistor r=10.701 //w=0.21 //l=0.115 //layer=ply \
 //thickness=0.18 //x=69.905 //y=1.555 //x2=69.79 //y2=1.555
r447 (  81 137 ) resistor r=5.52526 //w=0.168 //l=0.115 //layer=ply \
 //thickness=0.18 //x=70.125 //y=1.555 //x2=70.24 //y2=1.555
r448 (  80 130 ) resistor r=5.52526 //w=0.168 //l=0.115 //layer=ply \
 //thickness=0.18 //x=69.905 //y=0.9 //x2=69.79 //y2=0.9
r449 (  79 136 ) resistor r=5.52526 //w=0.168 //l=0.115 //layer=ply \
 //thickness=0.18 //x=70.125 //y=0.9 //x2=70.24 //y2=0.9
r450 (  79 80 ) resistor r=112.809 //w=0.094 //l=0.22 //layer=ply \
 //thickness=0.18 //x=70.125 //y=0.9 //x2=69.905 //y2=0.9
r451 (  78 133 ) resistor r=58.7805 //w=0.246 //l=0.373497 //layer=ply \
 //thickness=0.18 //x=69.75 //y=2.095 //x2=70.05 //y2=2.26
r452 (  77 131 ) resistor r=39.5823 //w=0.21 //l=0.173853 //layer=ply \
 //thickness=0.18 //x=69.75 //y=1.71 //x2=69.79 //y2=1.555
r453 (  77 78 ) resistor r=197.415 //w=0.094 //l=0.385 //layer=ply \
 //thickness=0.18 //x=69.75 //y=1.71 //x2=69.75 //y2=2.095
r454 (  76 131 ) resistor r=39.5823 //w=0.21 //l=0.173853 //layer=ply \
 //thickness=0.18 //x=69.75 //y=1.4 //x2=69.79 //y2=1.555
r455 (  75 130 ) resistor r=45.1352 //w=0.168 //l=0.173853 //layer=ply \
 //thickness=0.18 //x=69.75 //y=1.055 //x2=69.79 //y2=0.9
r456 (  75 76 ) resistor r=176.904 //w=0.094 //l=0.345 //layer=ply \
 //thickness=0.18 //x=69.75 //y=1.055 //x2=69.75 //y2=1.4
r457 (  74 125 ) resistor r=592.245 //w=0.094 //l=1.155 //layer=ply \
 //thickness=0.18 //x=78.52 //y=6.205 //x2=78.52 //y2=5.05
r458 (  73 117 ) resistor r=592.245 //w=0.094 //l=1.155 //layer=ply \
 //thickness=0.18 //x=78.08 //y=6.205 //x2=78.08 //y2=5.05
r459 (  72 110 ) resistor r=592.245 //w=0.094 //l=1.155 //layer=ply \
 //thickness=0.18 //x=75.2 //y=6.205 //x2=75.2 //y2=5.05
r460 (  71 98 ) resistor r=592.245 //w=0.094 //l=1.155 //layer=ply \
 //thickness=0.18 //x=74.76 //y=6.205 //x2=74.76 //y2=5.05
r461 (  70 91 ) resistor r=592.245 //w=0.094 //l=1.155 //layer=ply \
 //thickness=0.18 //x=70.69 //y=6.2 //x2=70.69 //y2=5.045
r462 (  69 84 ) resistor r=592.245 //w=0.094 //l=1.155 //layer=ply \
 //thickness=0.18 //x=70.25 //y=6.2 //x2=70.25 //y2=5.045
r463 (  68 122 ) resistor r=56.4043 //w=0.094 //l=0.11 //layer=ply \
 //thickness=0.18 //x=78.26 //y=1.545 //x2=78.37 //y2=1.545
r464 (  68 123 ) resistor r=56.4043 //w=0.094 //l=0.11 //layer=ply \
 //thickness=0.18 //x=78.26 //y=1.545 //x2=78.15 //y2=1.545
r465 (  67 103 ) resistor r=56.4043 //w=0.094 //l=0.11 //layer=ply \
 //thickness=0.18 //x=74.93 //y=1.545 //x2=75.04 //y2=1.545
r466 (  67 104 ) resistor r=56.4043 //w=0.094 //l=0.11 //layer=ply \
 //thickness=0.18 //x=74.93 //y=1.545 //x2=74.82 //y2=1.545
r467 (  66 81 ) resistor r=56.4043 //w=0.094 //l=0.11 //layer=ply \
 //thickness=0.18 //x=70.015 //y=1.555 //x2=70.125 //y2=1.555
r468 (  66 82 ) resistor r=56.4043 //w=0.094 //l=0.11 //layer=ply \
 //thickness=0.18 //x=70.015 //y=1.555 //x2=69.905 //y2=1.555
r469 (  63 152 ) resistor r=152 //w=0.17 //l=0.17 //layer=licon //count=1 \
 //x=78.19 //y=4.885 //x2=78.19 //y2=4.885
r470 (  61 63 ) resistor r=18.139 //w=0.187 //l=0.265 //layer=li \
 //thickness=0.1 //x=78.19 //y=4.62 //x2=78.19 //y2=4.885
r471 (  58 147 ) resistor r=152 //w=0.17 //l=0.17 //layer=licon //count=1 \
 //x=78.19 //y=2.26 //x2=78.19 //y2=2.26
r472 (  58 61 ) resistor r=161.54 //w=0.187 //l=2.36 //layer=li \
 //thickness=0.1 //x=78.19 //y=2.26 //x2=78.19 //y2=4.62
r473 (  55 141 ) resistor r=152 //w=0.17 //l=0.17 //layer=licon //count=1 \
 //x=74.49 //y=4.885 //x2=74.49 //y2=4.885
r474 (  53 55 ) resistor r=18.139 //w=0.187 //l=0.265 //layer=li \
 //thickness=0.1 //x=74.49 //y=4.62 //x2=74.49 //y2=4.885
r475 (  50 139 ) resistor r=152 //w=0.17 //l=0.17 //layer=licon //count=1 \
 //x=74.49 //y=2.26 //x2=74.49 //y2=2.26
r476 (  50 53 ) resistor r=161.54 //w=0.187 //l=2.36 //layer=li \
 //thickness=0.1 //x=74.49 //y=2.26 //x2=74.49 //y2=4.62
r477 (  47 135 ) resistor r=152 //w=0.17 //l=0.17 //layer=licon //count=1 \
 //x=70.05 //y=4.88 //x2=70.05 //y2=4.88
r478 (  45 47 ) resistor r=17.7968 //w=0.187 //l=0.26 //layer=li \
 //thickness=0.1 //x=70.05 //y=4.62 //x2=70.05 //y2=4.88
r479 (  42 133 ) resistor r=152 //w=0.17 //l=0.17 //layer=licon //count=1 \
 //x=70.05 //y=2.26 //x2=70.05 //y2=2.26
r480 (  42 45 ) resistor r=161.54 //w=0.187 //l=2.36 //layer=li \
 //thickness=0.1 //x=70.05 //y=2.26 //x2=70.05 //y2=4.62
r481 (  38 40 ) resistor r=46.2032 //w=0.187 //l=0.675 //layer=li \
 //thickness=0.1 //x=68.2 //y=5.295 //x2=68.2 //y2=4.62
r482 (  37 40 ) resistor r=184.813 //w=0.187 //l=2.7 //layer=li \
 //thickness=0.1 //x=68.2 //y=1.92 //x2=68.2 //y2=4.62
r483 (  35 37 ) resistor r=7.15173 //w=0.17 //l=0.120208 //layer=li \
 //thickness=0.1 //x=68.115 //y=1.835 //x2=68.2 //y2=1.92
r484 (  35 36 ) resistor r=18.4813 //w=0.187 //l=0.27 //layer=li \
 //thickness=0.1 //x=68.115 //y=1.835 //x2=67.845 //y2=1.835
r485 (  34 65 ) resistor r=5.4201 //w=0.17 //l=0.085 //layer=li \
 //thickness=0.1 //x=67.805 //y=5.38 //x2=67.72 //y2=5.38
r486 (  33 38 ) resistor r=7.15173 //w=0.17 //l=0.120208 //layer=li \
 //thickness=0.1 //x=68.115 //y=5.38 //x2=68.2 //y2=5.295
r487 (  33 34 ) resistor r=21.2193 //w=0.187 //l=0.31 //layer=li \
 //thickness=0.1 //x=68.115 //y=5.38 //x2=67.805 //y2=5.38
r488 (  29 36 ) resistor r=7.15173 //w=0.17 //l=0.120208 //layer=li \
 //thickness=0.1 //x=67.76 //y=1.75 //x2=67.845 //y2=1.835
r489 (  29 155 ) resistor r=39.016 //w=0.187 //l=0.57 //layer=li \
 //thickness=0.1 //x=67.76 //y=1.75 //x2=67.76 //y2=1.18
r490 (  23 65 ) resistor r=1.40859 //w=0.34 //l=0.085 //layer=li \
 //thickness=0.1 //x=67.72 //y=5.465 //x2=67.72 //y2=5.38
r491 (  23 158 ) resistor r=30.1176 //w=0.187 //l=0.44 //layer=li \
 //thickness=0.1 //x=67.72 //y=5.465 //x2=67.72 //y2=5.905
r492 (  21 65 ) resistor r=5.4201 //w=0.17 //l=0.085 //layer=li \
 //thickness=0.1 //x=67.635 //y=5.38 //x2=67.72 //y2=5.38
r493 (  21 22 ) resistor r=48.5989 //w=0.187 //l=0.71 //layer=li \
 //thickness=0.1 //x=67.635 //y=5.38 //x2=66.925 //y2=5.38
r494 (  15 22 ) resistor r=7.15173 //w=0.17 //l=0.120208 //layer=li \
 //thickness=0.1 //x=66.84 //y=5.465 //x2=66.925 //y2=5.38
r495 (  15 157 ) resistor r=30.1176 //w=0.187 //l=0.44 //layer=li \
 //thickness=0.1 //x=66.84 //y=5.465 //x2=66.84 //y2=5.905
r496 (  14 61 ) resistor r=9.3 //w=0.17 //l=0.17 //layer=mcon //count=1 \
 //x=78.19 //y=4.62 //x2=78.19 //y2=4.62
r497 (  12 53 ) resistor r=9.3 //w=0.17 //l=0.17 //layer=mcon //count=1 \
 //x=74.49 //y=4.62 //x2=74.49 //y2=4.62
r498 (  10 45 ) resistor r=9.3 //w=0.17 //l=0.17 //layer=mcon //count=1 \
 //x=70.05 //y=4.62 //x2=70.05 //y2=4.62
r499 (  8 40 ) resistor r=9.3 //w=0.17 //l=0.17 //layer=mcon //count=1 \
 //x=68.2 //y=4.62 //x2=68.2 //y2=4.62
r500 (  6 12 ) resistor r=0.0880901 //w=0.191 //l=0.115 //layer=m1 \
 //thickness=0.36 //x=74.605 //y=4.62 //x2=74.49 //y2=4.62
r501 (  5 14 ) resistor r=0.0717383 //w=0.224 //l=0.115 //layer=m1 \
 //thickness=0.36 //x=78.075 //y=4.62 //x2=78.19 //y2=4.62
r502 (  5 6 ) resistor r=3.31107 //w=0.131 //l=3.47 //layer=m1 \
 //thickness=0.36 //x=78.075 //y=4.62 //x2=74.605 //y2=4.62
r503 (  4 10 ) resistor r=0.0880901 //w=0.191 //l=0.115 //layer=m1 \
 //thickness=0.36 //x=70.165 //y=4.62 //x2=70.05 //y2=4.62
r504 (  3 12 ) resistor r=0.0880901 //w=0.191 //l=0.115 //layer=m1 \
 //thickness=0.36 //x=74.375 //y=4.62 //x2=74.49 //y2=4.62
r505 (  3 4 ) resistor r=4.01718 //w=0.131 //l=4.21 //layer=m1 \
 //thickness=0.36 //x=74.375 //y=4.62 //x2=70.165 //y2=4.62
r506 (  2 8 ) resistor r=0.0717383 //w=0.224 //l=0.115 //layer=m1 \
 //thickness=0.36 //x=68.315 //y=4.62 //x2=68.2 //y2=4.62
r507 (  1 10 ) resistor r=0.0880901 //w=0.191 //l=0.115 //layer=m1 \
 //thickness=0.36 //x=69.935 //y=4.62 //x2=70.05 //y2=4.62
r508 (  1 2 ) resistor r=1.5458 //w=0.131 //l=1.62 //layer=m1 //thickness=0.36 \
 //x=69.935 //y=4.62 //x2=68.315 //y2=4.62
ends PM_TMRDFFSNQNX1\%noxref_23

subckt PM_TMRDFFSNQNX1\%noxref_24 ( 1 2 3 4 5 6 23 24 35 37 38 42 44 52 61 67 \
 68 69 70 71 72 73 74 75 76 77 78 79 80 81 83 89 90 91 92 99 100 101 102 103 \
 105 108 111 112 113 114 115 116 117 118 122 124 127 128 129 130 151 158 160 \
 161 )
c450 ( 161 0 ) capacitor c=0.0220291f //x=18.735 //y=5.2
c451 ( 160 0 ) capacitor c=0.0217503f //x=17.855 //y=5.2
c452 ( 158 0 ) capacitor c=0.0084702f //x=18.73 //y=1.085
c453 ( 151 0 ) capacitor c=0.0583848f //x=81.15 //y=2.26
c454 ( 130 0 ) capacitor c=0.0316774f //x=81.855 //y=1.39
c455 ( 129 0 ) capacitor c=0.0187384f //x=81.855 //y=1.045
c456 ( 128 0 ) capacitor c=0.0590362f //x=81.495 //y=4.975
c457 ( 127 0 ) capacitor c=0.0296075f //x=81.785 //y=4.975
c458 ( 124 0 ) capacitor c=0.0157912f //x=81.7 //y=1.545
c459 ( 122 0 ) capacitor c=0.0149844f //x=81.7 //y=0.89
c460 ( 118 0 ) capacitor c=0.0302441f //x=81.325 //y=2.095
c461 ( 117 0 ) capacitor c=0.0234157f //x=81.325 //y=1.7
c462 ( 116 0 ) capacitor c=0.0234376f //x=81.325 //y=1.39
c463 ( 115 0 ) capacitor c=0.0199931f //x=81.325 //y=1.045
c464 ( 114 0 ) capacitor c=0.0962905f //x=79.495 //y=2.095
c465 ( 113 0 ) capacitor c=0.0249466f //x=79.495 //y=1.74
c466 ( 112 0 ) capacitor c=0.0234397f //x=79.495 //y=1.43
c467 ( 111 0 ) capacitor c=0.0193195f //x=79.495 //y=1.085
c468 ( 108 0 ) capacitor c=0.0631944f //x=79.4 //y=5.05
c469 ( 105 0 ) capacitor c=0.0187941f //x=79.34 //y=1.585
c470 ( 103 0 ) capacitor c=0.0157803f //x=79.34 //y=0.93
c471 ( 102 0 ) capacitor c=0.010629f //x=79.035 //y=4.975
c472 ( 101 0 ) capacitor c=0.0194269f //x=79.325 //y=4.975
c473 ( 100 0 ) capacitor c=0.0365717f //x=78.965 //y=1.43
c474 ( 99 0 ) capacitor c=0.0175988f //x=78.965 //y=1.085
c475 ( 92 0 ) capacitor c=0.0556143f //x=21.485 //y=4.97
c476 ( 91 0 ) capacitor c=0.0293157f //x=21.775 //y=4.97
c477 ( 90 0 ) capacitor c=0.0347816f //x=21.44 //y=1.4
c478 ( 89 0 ) capacitor c=0.0187487f //x=21.44 //y=1.055
c479 ( 83 0 ) capacitor c=0.0137055f //x=21.285 //y=1.555
c480 ( 81 0 ) capacitor c=0.0149861f //x=21.285 //y=0.9
c481 ( 80 0 ) capacitor c=0.096037f //x=20.91 //y=2.095
c482 ( 79 0 ) capacitor c=0.0228993f //x=20.91 //y=1.71
c483 ( 78 0 ) capacitor c=0.0234352f //x=20.91 //y=1.4
c484 ( 77 0 ) capacitor c=0.0198724f //x=20.91 //y=1.055
c485 ( 76 0 ) capacitor c=0.110622f //x=81.86 //y=6.205
c486 ( 75 0 ) capacitor c=0.154068f //x=81.42 //y=6.205
c487 ( 74 0 ) capacitor c=0.154291f //x=79.4 //y=6.205
c488 ( 73 0 ) capacitor c=0.110404f //x=78.96 //y=6.205
c489 ( 72 0 ) capacitor c=0.110114f //x=21.85 //y=6.2
c490 ( 71 0 ) capacitor c=0.158956f //x=21.41 //y=6.2
c491 ( 67 0 ) capacitor c=0.00211606f //x=18.88 //y=5.38
c492 ( 61 0 ) capacitor c=0.100881f //x=81.15 //y=2.26
c493 ( 52 0 ) capacitor c=0.105667f //x=79.67 //y=2.26
c494 ( 44 0 ) capacitor c=0.0962061f //x=21.21 //y=2.26
c495 ( 42 0 ) capacitor c=0.104221f //x=19.36 //y=3.51
c496 ( 38 0 ) capacitor c=0.00404073f //x=19.005 //y=1.835
c497 ( 37 0 ) capacitor c=0.0122201f //x=19.275 //y=1.835
c498 ( 35 0 ) capacitor c=0.0137995f //x=19.275 //y=5.38
c499 ( 24 0 ) capacitor c=0.00251459f //x=18.085 //y=5.38
c500 ( 23 0 ) capacitor c=0.0143649f //x=18.795 //y=5.38
c501 ( 6 0 ) capacitor c=0.0112698f //x=79.785 //y=2.26
c502 ( 5 0 ) capacitor c=0.0463273f //x=81.035 //y=2.26
c503 ( 4 0 ) capacitor c=0.004304f //x=21.325 //y=3.51
c504 ( 3 0 ) capacitor c=0.987666f //x=79.555 //y=3.51
c505 ( 2 0 ) capacitor c=0.0124845f //x=19.475 //y=3.51
c506 ( 1 0 ) capacitor c=0.0280612f //x=21.095 //y=3.51
r507 (  130 157 ) resistor r=45.1352 //w=0.168 //l=0.173853 //layer=ply \
 //thickness=0.18 //x=81.855 //y=1.39 //x2=81.815 //y2=1.545
r508 (  129 156 ) resistor r=45.1352 //w=0.168 //l=0.173853 //layer=ply \
 //thickness=0.18 //x=81.855 //y=1.045 //x2=81.815 //y2=0.89
r509 (  129 130 ) resistor r=176.904 //w=0.094 //l=0.345 //layer=ply \
 //thickness=0.18 //x=81.855 //y=1.045 //x2=81.855 //y2=1.39
r510 (  127 131 ) resistor r=26.9307 //w=0.15 //l=0.106066 //layer=ply \
 //thickness=0.18 //x=81.785 //y=4.975 //x2=81.86 //y2=5.05
r511 (  127 128 ) resistor r=148.702 //w=0.094 //l=0.29 //layer=ply \
 //thickness=0.18 //x=81.785 //y=4.975 //x2=81.495 //y2=4.975
r512 (  125 155 ) resistor r=10.701 //w=0.21 //l=0.115 //layer=ply \
 //thickness=0.18 //x=81.48 //y=1.545 //x2=81.365 //y2=1.545
r513 (  124 157 ) resistor r=5.52526 //w=0.168 //l=0.115 //layer=ply \
 //thickness=0.18 //x=81.7 //y=1.545 //x2=81.815 //y2=1.545
r514 (  123 154 ) resistor r=5.52526 //w=0.168 //l=0.115 //layer=ply \
 //thickness=0.18 //x=81.48 //y=0.89 //x2=81.365 //y2=0.89
r515 (  122 156 ) resistor r=5.52526 //w=0.168 //l=0.115 //layer=ply \
 //thickness=0.18 //x=81.7 //y=0.89 //x2=81.815 //y2=0.89
r516 (  122 123 ) resistor r=112.809 //w=0.094 //l=0.22 //layer=ply \
 //thickness=0.18 //x=81.7 //y=0.89 //x2=81.48 //y2=0.89
r517 (  119 128 ) resistor r=22.1787 //w=0.252 //l=0.106066 //layer=ply \
 //thickness=0.18 //x=81.42 //y=5.05 //x2=81.495 //y2=4.975
r518 (  119 153 ) resistor r=51.6429 //w=0.252 //l=0.34271 //layer=ply \
 //thickness=0.18 //x=81.42 //y=5.05 //x2=81.15 //y2=4.885
r519 (  118 151 ) resistor r=30.4513 //w=0.277 //l=0.243926 //layer=ply \
 //thickness=0.18 //x=81.325 //y=2.095 //x2=81.15 //y2=2.26
r520 (  117 155 ) resistor r=39.5823 //w=0.21 //l=0.173853 //layer=ply \
 //thickness=0.18 //x=81.325 //y=1.7 //x2=81.365 //y2=1.545
r521 (  117 118 ) resistor r=202.543 //w=0.094 //l=0.395 //layer=ply \
 //thickness=0.18 //x=81.325 //y=1.7 //x2=81.325 //y2=2.095
r522 (  116 155 ) resistor r=39.5823 //w=0.21 //l=0.173853 //layer=ply \
 //thickness=0.18 //x=81.325 //y=1.39 //x2=81.365 //y2=1.545
r523 (  115 154 ) resistor r=45.1352 //w=0.168 //l=0.173853 //layer=ply \
 //thickness=0.18 //x=81.325 //y=1.045 //x2=81.365 //y2=0.89
r524 (  115 116 ) resistor r=176.904 //w=0.094 //l=0.345 //layer=ply \
 //thickness=0.18 //x=81.325 //y=1.045 //x2=81.325 //y2=1.39
r525 (  114 147 ) resistor r=30.4513 //w=0.277 //l=0.243926 //layer=ply \
 //thickness=0.18 //x=79.495 //y=2.095 //x2=79.67 //y2=2.26
r526 (  113 145 ) resistor r=39.5823 //w=0.21 //l=0.173853 //layer=ply \
 //thickness=0.18 //x=79.495 //y=1.74 //x2=79.455 //y2=1.585
r527 (  113 114 ) resistor r=182.032 //w=0.094 //l=0.355 //layer=ply \
 //thickness=0.18 //x=79.495 //y=1.74 //x2=79.495 //y2=2.095
r528 (  112 145 ) resistor r=39.5823 //w=0.21 //l=0.173853 //layer=ply \
 //thickness=0.18 //x=79.495 //y=1.43 //x2=79.455 //y2=1.585
r529 (  111 144 ) resistor r=45.1352 //w=0.168 //l=0.173853 //layer=ply \
 //thickness=0.18 //x=79.495 //y=1.085 //x2=79.455 //y2=0.93
r530 (  111 112 ) resistor r=176.904 //w=0.094 //l=0.345 //layer=ply \
 //thickness=0.18 //x=79.495 //y=1.085 //x2=79.495 //y2=1.43
r531 (  108 149 ) resistor r=51.6429 //w=0.252 //l=0.34271 //layer=ply \
 //thickness=0.18 //x=79.4 //y=5.05 //x2=79.67 //y2=4.885
r532 (  106 143 ) resistor r=5.52526 //w=0.168 //l=0.115 //layer=ply \
 //thickness=0.18 //x=79.12 //y=1.585 //x2=79.005 //y2=1.585
r533 (  105 145 ) resistor r=10.701 //w=0.21 //l=0.115 //layer=ply \
 //thickness=0.18 //x=79.34 //y=1.585 //x2=79.455 //y2=1.585
r534 (  104 142 ) resistor r=5.52526 //w=0.168 //l=0.115 //layer=ply \
 //thickness=0.18 //x=79.12 //y=0.93 //x2=79.005 //y2=0.93
r535 (  103 144 ) resistor r=5.52526 //w=0.168 //l=0.115 //layer=ply \
 //thickness=0.18 //x=79.34 //y=0.93 //x2=79.455 //y2=0.93
r536 (  103 104 ) resistor r=112.809 //w=0.094 //l=0.22 //layer=ply \
 //thickness=0.18 //x=79.34 //y=0.93 //x2=79.12 //y2=0.93
r537 (  101 108 ) resistor r=22.1787 //w=0.252 //l=0.106066 //layer=ply \
 //thickness=0.18 //x=79.325 //y=4.975 //x2=79.4 //y2=5.05
r538 (  101 102 ) resistor r=148.702 //w=0.094 //l=0.29 //layer=ply \
 //thickness=0.18 //x=79.325 //y=4.975 //x2=79.035 //y2=4.975
r539 (  100 143 ) resistor r=45.1352 //w=0.168 //l=0.173853 //layer=ply \
 //thickness=0.18 //x=78.965 //y=1.43 //x2=79.005 //y2=1.585
r540 (  99 142 ) resistor r=45.1352 //w=0.168 //l=0.173853 //layer=ply \
 //thickness=0.18 //x=78.965 //y=1.085 //x2=79.005 //y2=0.93
r541 (  99 100 ) resistor r=176.904 //w=0.094 //l=0.345 //layer=ply \
 //thickness=0.18 //x=78.965 //y=1.085 //x2=78.965 //y2=1.43
r542 (  96 102 ) resistor r=26.9307 //w=0.15 //l=0.106066 //layer=ply \
 //thickness=0.18 //x=78.96 //y=5.05 //x2=79.035 //y2=4.975
r543 (  91 93 ) resistor r=26.9307 //w=0.15 //l=0.106066 //layer=ply \
 //thickness=0.18 //x=21.775 //y=4.97 //x2=21.85 //y2=5.045
r544 (  91 92 ) resistor r=148.702 //w=0.094 //l=0.29 //layer=ply \
 //thickness=0.18 //x=21.775 //y=4.97 //x2=21.485 //y2=4.97
r545 (  90 141 ) resistor r=45.1352 //w=0.168 //l=0.173853 //layer=ply \
 //thickness=0.18 //x=21.44 //y=1.4 //x2=21.4 //y2=1.555
r546 (  89 140 ) resistor r=45.1352 //w=0.168 //l=0.173853 //layer=ply \
 //thickness=0.18 //x=21.44 //y=1.055 //x2=21.4 //y2=0.9
r547 (  89 90 ) resistor r=176.904 //w=0.094 //l=0.345 //layer=ply \
 //thickness=0.18 //x=21.44 //y=1.055 //x2=21.44 //y2=1.4
r548 (  86 92 ) resistor r=22.7971 //w=0.269 //l=0.106066 //layer=ply \
 //thickness=0.18 //x=21.41 //y=5.045 //x2=21.485 //y2=4.97
r549 (  86 139 ) resistor r=35.8364 //w=0.269 //l=0.270185 //layer=ply \
 //thickness=0.18 //x=21.41 //y=5.045 //x2=21.21 //y2=4.88
r550 (  84 135 ) resistor r=10.701 //w=0.21 //l=0.115 //layer=ply \
 //thickness=0.18 //x=21.065 //y=1.555 //x2=20.95 //y2=1.555
r551 (  83 141 ) resistor r=5.52526 //w=0.168 //l=0.115 //layer=ply \
 //thickness=0.18 //x=21.285 //y=1.555 //x2=21.4 //y2=1.555
r552 (  82 134 ) resistor r=5.52526 //w=0.168 //l=0.115 //layer=ply \
 //thickness=0.18 //x=21.065 //y=0.9 //x2=20.95 //y2=0.9
r553 (  81 140 ) resistor r=5.52526 //w=0.168 //l=0.115 //layer=ply \
 //thickness=0.18 //x=21.285 //y=0.9 //x2=21.4 //y2=0.9
r554 (  81 82 ) resistor r=112.809 //w=0.094 //l=0.22 //layer=ply \
 //thickness=0.18 //x=21.285 //y=0.9 //x2=21.065 //y2=0.9
r555 (  80 137 ) resistor r=58.7805 //w=0.246 //l=0.373497 //layer=ply \
 //thickness=0.18 //x=20.91 //y=2.095 //x2=21.21 //y2=2.26
r556 (  79 135 ) resistor r=39.5823 //w=0.21 //l=0.173853 //layer=ply \
 //thickness=0.18 //x=20.91 //y=1.71 //x2=20.95 //y2=1.555
r557 (  79 80 ) resistor r=197.415 //w=0.094 //l=0.385 //layer=ply \
 //thickness=0.18 //x=20.91 //y=1.71 //x2=20.91 //y2=2.095
r558 (  78 135 ) resistor r=39.5823 //w=0.21 //l=0.173853 //layer=ply \
 //thickness=0.18 //x=20.91 //y=1.4 //x2=20.95 //y2=1.555
r559 (  77 134 ) resistor r=45.1352 //w=0.168 //l=0.173853 //layer=ply \
 //thickness=0.18 //x=20.91 //y=1.055 //x2=20.95 //y2=0.9
r560 (  77 78 ) resistor r=176.904 //w=0.094 //l=0.345 //layer=ply \
 //thickness=0.18 //x=20.91 //y=1.055 //x2=20.91 //y2=1.4
r561 (  76 131 ) resistor r=592.245 //w=0.094 //l=1.155 //layer=ply \
 //thickness=0.18 //x=81.86 //y=6.205 //x2=81.86 //y2=5.05
r562 (  75 119 ) resistor r=592.245 //w=0.094 //l=1.155 //layer=ply \
 //thickness=0.18 //x=81.42 //y=6.205 //x2=81.42 //y2=5.05
r563 (  74 108 ) resistor r=592.245 //w=0.094 //l=1.155 //layer=ply \
 //thickness=0.18 //x=79.4 //y=6.205 //x2=79.4 //y2=5.05
r564 (  73 96 ) resistor r=592.245 //w=0.094 //l=1.155 //layer=ply \
 //thickness=0.18 //x=78.96 //y=6.205 //x2=78.96 //y2=5.05
r565 (  72 93 ) resistor r=592.245 //w=0.094 //l=1.155 //layer=ply \
 //thickness=0.18 //x=21.85 //y=6.2 //x2=21.85 //y2=5.045
r566 (  71 86 ) resistor r=592.245 //w=0.094 //l=1.155 //layer=ply \
 //thickness=0.18 //x=21.41 //y=6.2 //x2=21.41 //y2=5.045
r567 (  70 124 ) resistor r=56.4043 //w=0.094 //l=0.11 //layer=ply \
 //thickness=0.18 //x=81.59 //y=1.545 //x2=81.7 //y2=1.545
r568 (  70 125 ) resistor r=56.4043 //w=0.094 //l=0.11 //layer=ply \
 //thickness=0.18 //x=81.59 //y=1.545 //x2=81.48 //y2=1.545
r569 (  69 105 ) resistor r=56.4043 //w=0.094 //l=0.11 //layer=ply \
 //thickness=0.18 //x=79.23 //y=1.585 //x2=79.34 //y2=1.585
r570 (  69 106 ) resistor r=56.4043 //w=0.094 //l=0.11 //layer=ply \
 //thickness=0.18 //x=79.23 //y=1.585 //x2=79.12 //y2=1.585
r571 (  68 83 ) resistor r=56.4043 //w=0.094 //l=0.11 //layer=ply \
 //thickness=0.18 //x=21.175 //y=1.555 //x2=21.285 //y2=1.555
r572 (  68 84 ) resistor r=56.4043 //w=0.094 //l=0.11 //layer=ply \
 //thickness=0.18 //x=21.175 //y=1.555 //x2=21.065 //y2=1.555
r573 (  65 153 ) resistor r=152 //w=0.17 //l=0.17 //layer=licon //count=1 \
 //x=81.15 //y=4.885 //x2=81.15 //y2=4.885
r574 (  61 151 ) resistor r=152 //w=0.17 //l=0.17 //layer=licon //count=1 \
 //x=81.15 //y=2.26 //x2=81.15 //y2=2.26
r575 (  61 65 ) resistor r=179.679 //w=0.187 //l=2.625 //layer=li \
 //thickness=0.1 //x=81.15 //y=2.26 //x2=81.15 //y2=4.885
r576 (  58 149 ) resistor r=152 //w=0.17 //l=0.17 //layer=licon //count=1 \
 //x=79.67 //y=4.885 //x2=79.67 //y2=4.885
r577 (  56 58 ) resistor r=94.1176 //w=0.187 //l=1.375 //layer=li \
 //thickness=0.1 //x=79.67 //y=3.51 //x2=79.67 //y2=4.885
r578 (  52 147 ) resistor r=152 //w=0.17 //l=0.17 //layer=licon //count=1 \
 //x=79.67 //y=2.26 //x2=79.67 //y2=2.26
r579 (  52 56 ) resistor r=85.5615 //w=0.187 //l=1.25 //layer=li \
 //thickness=0.1 //x=79.67 //y=2.26 //x2=79.67 //y2=3.51
r580 (  49 139 ) resistor r=152 //w=0.17 //l=0.17 //layer=licon //count=1 \
 //x=21.21 //y=4.88 //x2=21.21 //y2=4.88
r581 (  47 49 ) resistor r=93.7754 //w=0.187 //l=1.37 //layer=li \
 //thickness=0.1 //x=21.21 //y=3.51 //x2=21.21 //y2=4.88
r582 (  44 137 ) resistor r=152 //w=0.17 //l=0.17 //layer=licon //count=1 \
 //x=21.21 //y=2.26 //x2=21.21 //y2=2.26
r583 (  44 47 ) resistor r=85.5615 //w=0.187 //l=1.25 //layer=li \
 //thickness=0.1 //x=21.21 //y=2.26 //x2=21.21 //y2=3.51
r584 (  40 42 ) resistor r=122.182 //w=0.187 //l=1.785 //layer=li \
 //thickness=0.1 //x=19.36 //y=5.295 //x2=19.36 //y2=3.51
r585 (  39 42 ) resistor r=108.834 //w=0.187 //l=1.59 //layer=li \
 //thickness=0.1 //x=19.36 //y=1.92 //x2=19.36 //y2=3.51
r586 (  37 39 ) resistor r=7.15173 //w=0.17 //l=0.120208 //layer=li \
 //thickness=0.1 //x=19.275 //y=1.835 //x2=19.36 //y2=1.92
r587 (  37 38 ) resistor r=18.4813 //w=0.187 //l=0.27 //layer=li \
 //thickness=0.1 //x=19.275 //y=1.835 //x2=19.005 //y2=1.835
r588 (  36 67 ) resistor r=5.4201 //w=0.17 //l=0.085 //layer=li \
 //thickness=0.1 //x=18.965 //y=5.38 //x2=18.88 //y2=5.38
r589 (  35 40 ) resistor r=7.15173 //w=0.17 //l=0.120208 //layer=li \
 //thickness=0.1 //x=19.275 //y=5.38 //x2=19.36 //y2=5.295
r590 (  35 36 ) resistor r=21.2193 //w=0.187 //l=0.31 //layer=li \
 //thickness=0.1 //x=19.275 //y=5.38 //x2=18.965 //y2=5.38
r591 (  31 38 ) resistor r=7.15173 //w=0.17 //l=0.120208 //layer=li \
 //thickness=0.1 //x=18.92 //y=1.75 //x2=19.005 //y2=1.835
r592 (  31 158 ) resistor r=39.016 //w=0.187 //l=0.57 //layer=li \
 //thickness=0.1 //x=18.92 //y=1.75 //x2=18.92 //y2=1.18
r593 (  25 67 ) resistor r=1.40859 //w=0.34 //l=0.085 //layer=li \
 //thickness=0.1 //x=18.88 //y=5.465 //x2=18.88 //y2=5.38
r594 (  25 161 ) resistor r=30.1176 //w=0.187 //l=0.44 //layer=li \
 //thickness=0.1 //x=18.88 //y=5.465 //x2=18.88 //y2=5.905
r595 (  23 67 ) resistor r=5.4201 //w=0.17 //l=0.085 //layer=li \
 //thickness=0.1 //x=18.795 //y=5.38 //x2=18.88 //y2=5.38
r596 (  23 24 ) resistor r=48.5989 //w=0.187 //l=0.71 //layer=li \
 //thickness=0.1 //x=18.795 //y=5.38 //x2=18.085 //y2=5.38
r597 (  17 24 ) resistor r=7.15173 //w=0.17 //l=0.120208 //layer=li \
 //thickness=0.1 //x=18 //y=5.465 //x2=18.085 //y2=5.38
r598 (  17 160 ) resistor r=30.1176 //w=0.187 //l=0.44 //layer=li \
 //thickness=0.1 //x=18 //y=5.465 //x2=18 //y2=5.905
r599 (  16 61 ) resistor r=9.3 //w=0.17 //l=0.17 //layer=mcon //count=1 \
 //x=81.15 //y=2.26 //x2=81.15 //y2=2.26
r600 (  14 56 ) resistor r=9.3 //w=0.17 //l=0.17 //layer=mcon //count=1 \
 //x=79.67 //y=3.51 //x2=79.67 //y2=3.51
r601 (  12 52 ) resistor r=9.3 //w=0.17 //l=0.17 //layer=mcon //count=1 \
 //x=79.67 //y=2.26 //x2=79.67 //y2=2.26
r602 (  10 47 ) resistor r=9.3 //w=0.17 //l=0.17 //layer=mcon //count=1 \
 //x=21.21 //y=3.51 //x2=21.21 //y2=3.51
r603 (  8 42 ) resistor r=9.3 //w=0.17 //l=0.17 //layer=mcon //count=1 \
 //x=19.36 //y=3.51 //x2=19.36 //y2=3.51
r604 (  6 12 ) resistor r=0.0717383 //w=0.224 //l=0.115 //layer=m1 \
 //thickness=0.36 //x=79.785 //y=2.26 //x2=79.67 //y2=2.26
r605 (  5 16 ) resistor r=0.0717383 //w=0.224 //l=0.115 //layer=m1 \
 //thickness=0.36 //x=81.035 //y=2.26 //x2=81.15 //y2=2.26
r606 (  5 6 ) resistor r=1.19275 //w=0.131 //l=1.25 //layer=m1 \
 //thickness=0.36 //x=81.035 //y=2.26 //x2=79.785 //y2=2.26
r607 (  4 10 ) resistor r=0.0880901 //w=0.191 //l=0.115 //layer=m1 \
 //thickness=0.36 //x=21.325 //y=3.51 //x2=21.21 //y2=3.51
r608 (  3 14 ) resistor r=0.0717383 //w=0.224 //l=0.115 //layer=m1 \
 //thickness=0.36 //x=79.555 //y=3.51 //x2=79.67 //y2=3.51
r609 (  3 4 ) resistor r=55.563 //w=0.131 //l=58.23 //layer=m1 \
 //thickness=0.36 //x=79.555 //y=3.51 //x2=21.325 //y2=3.51
r610 (  2 8 ) resistor r=0.0717383 //w=0.224 //l=0.115 //layer=m1 \
 //thickness=0.36 //x=19.475 //y=3.51 //x2=19.36 //y2=3.51
r611 (  1 10 ) resistor r=0.0880901 //w=0.191 //l=0.115 //layer=m1 \
 //thickness=0.36 //x=21.095 //y=3.51 //x2=21.21 //y2=3.51
r612 (  1 2 ) resistor r=1.5458 //w=0.131 //l=1.62 //layer=m1 //thickness=0.36 \
 //x=21.095 //y=3.51 //x2=19.475 //y2=3.51
ends PM_TMRDFFSNQNX1\%noxref_24

subckt PM_TMRDFFSNQNX1\%noxref_25 ( 1 2 13 14 15 21 27 28 35 46 47 48 49 50 )
c89 ( 50 0 ) capacitor c=0.0308836f //x=82.815 //y=5.205
c90 ( 49 0 ) capacitor c=0.0173945f //x=81.935 //y=5.205
c91 ( 47 0 ) capacitor c=0.0169278f //x=79.035 //y=5.205
c92 ( 46 0 ) capacitor c=0.0166762f //x=78.155 //y=5.205
c93 ( 45 0 ) capacitor c=0.00115294f //x=82.08 //y=7.09
c94 ( 35 0 ) capacitor c=0.0132983f //x=82.875 //y=7.09
c95 ( 28 0 ) capacitor c=0.00388794f //x=81.285 //y=7.09
c96 ( 27 0 ) capacitor c=0.00985708f //x=81.995 //y=7.09
c97 ( 21 0 ) capacitor c=0.0442221f //x=81.2 //y=5.39
c98 ( 15 0 ) capacitor c=0.0105083f //x=79.18 //y=5.475
c99 ( 14 0 ) capacitor c=0.00227812f //x=78.385 //y=5.39
c100 ( 13 0 ) capacitor c=0.0174384f //x=79.095 //y=5.39
c101 ( 2 0 ) capacitor c=0.00682032f //x=79.295 //y=5.39
c102 ( 1 0 ) capacitor c=0.0574911f //x=81.085 //y=5.39
r103 (  37 50 ) resistor r=5.81818 //w=0.187 //l=0.085 //layer=li \
 //thickness=0.1 //x=82.96 //y=7.005 //x2=82.96 //y2=6.92
r104 (  36 45 ) resistor r=5.4201 //w=0.17 //l=0.085 //layer=li \
 //thickness=0.1 //x=82.165 //y=7.09 //x2=82.08 //y2=7.09
r105 (  35 37 ) resistor r=7.15173 //w=0.17 //l=0.120208 //layer=li \
 //thickness=0.1 //x=82.875 //y=7.09 //x2=82.96 //y2=7.005
r106 (  35 36 ) resistor r=48.5989 //w=0.187 //l=0.71 //layer=li \
 //thickness=0.1 //x=82.875 //y=7.09 //x2=82.165 //y2=7.09
r107 (  29 45 ) resistor r=1.40859 //w=0.34 //l=0.085 //layer=li \
 //thickness=0.1 //x=82.08 //y=7.005 //x2=82.08 //y2=7.09
r108 (  29 49 ) resistor r=5.81818 //w=0.187 //l=0.085 //layer=li \
 //thickness=0.1 //x=82.08 //y=7.005 //x2=82.08 //y2=6.92
r109 (  27 45 ) resistor r=5.4201 //w=0.17 //l=0.085 //layer=li \
 //thickness=0.1 //x=81.995 //y=7.09 //x2=82.08 //y2=7.09
r110 (  27 28 ) resistor r=48.5989 //w=0.187 //l=0.71 //layer=li \
 //thickness=0.1 //x=81.995 //y=7.09 //x2=81.285 //y2=7.09
r111 (  21 48 ) resistor r=58.1818 //w=0.187 //l=0.85 //layer=li \
 //thickness=0.1 //x=81.2 //y=5.39 //x2=81.2 //y2=6.24
r112 (  19 28 ) resistor r=7.15173 //w=0.17 //l=0.120208 //layer=li \
 //thickness=0.1 //x=81.2 //y=7.005 //x2=81.285 //y2=7.09
r113 (  19 48 ) resistor r=5.81818 //w=0.187 //l=0.085 //layer=li \
 //thickness=0.1 //x=81.2 //y=7.005 //x2=81.2 //y2=6.92
r114 (  15 44 ) resistor r=3.57586 //w=0.17 //l=0.125 //layer=li \
 //thickness=0.1 //x=79.18 //y=5.475 //x2=79.18 //y2=5.35
r115 (  15 47 ) resistor r=52.3636 //w=0.187 //l=0.765 //layer=li \
 //thickness=0.1 //x=79.18 //y=5.475 //x2=79.18 //y2=6.24
r116 (  13 44 ) resistor r=3.57586 //w=0.17 //l=0.103078 //layer=li \
 //thickness=0.1 //x=79.095 //y=5.39 //x2=79.18 //y2=5.35
r117 (  13 14 ) resistor r=48.5989 //w=0.187 //l=0.71 //layer=li \
 //thickness=0.1 //x=79.095 //y=5.39 //x2=78.385 //y2=5.39
r118 (  7 14 ) resistor r=7.15173 //w=0.17 //l=0.120208 //layer=li \
 //thickness=0.1 //x=78.3 //y=5.475 //x2=78.385 //y2=5.39
r119 (  7 46 ) resistor r=29.0909 //w=0.187 //l=0.425 //layer=li \
 //thickness=0.1 //x=78.3 //y=5.475 //x2=78.3 //y2=5.9
r120 (  6 21 ) resistor r=9.3 //w=0.17 //l=0.17 //layer=mcon //count=1 \
 //x=81.2 //y=5.39 //x2=81.2 //y2=5.39
r121 (  4 44 ) resistor r=9.3 //w=0.17 //l=0.17 //layer=mcon //count=1 \
 //x=79.18 //y=5.39 //x2=79.18 //y2=5.39
r122 (  2 4 ) resistor r=0.0717383 //w=0.224 //l=0.115 //layer=m1 \
 //thickness=0.36 //x=79.295 //y=5.39 //x2=79.18 //y2=5.39
r123 (  1 6 ) resistor r=0.0717383 //w=0.224 //l=0.115 //layer=m1 \
 //thickness=0.36 //x=81.085 //y=5.39 //x2=81.2 //y2=5.39
r124 (  1 2 ) resistor r=1.70802 //w=0.131 //l=1.79 //layer=m1 \
 //thickness=0.36 //x=81.085 //y=5.39 //x2=79.295 //y2=5.39
ends PM_TMRDFFSNQNX1\%noxref_25

subckt PM_TMRDFFSNQNX1\%QN ( 1 2 3 4 11 12 13 14 15 16 17 30 31 44 46 47 61 62 \
 63 64 68 69 )
c169 ( 69 0 ) capacitor c=0.0167617f //x=82.375 //y=5.205
c170 ( 68 0 ) capacitor c=0.0164812f //x=81.495 //y=5.205
c171 ( 64 0 ) capacitor c=0.0108176f //x=82.37 //y=1.085
c172 ( 63 0 ) capacitor c=0.0131637f //x=79.04 //y=1.085
c173 ( 62 0 ) capacitor c=0.0131367f //x=75.71 //y=1.085
c174 ( 61 0 ) capacitor c=0.00421476f //x=82.52 //y=5.39
c175 ( 47 0 ) capacitor c=0.00775877f //x=82.645 //y=1.825
c176 ( 46 0 ) capacitor c=0.0165978f //x=82.915 //y=1.825
c177 ( 44 0 ) capacitor c=0.0160142f //x=82.915 //y=5.39
c178 ( 31 0 ) capacitor c=0.0029383f //x=81.725 //y=5.39
c179 ( 30 0 ) capacitor c=0.0155464f //x=82.435 //y=5.39
c180 ( 11 0 ) capacitor c=0.133166f //x=83 //y=2.4
c181 ( 4 0 ) capacitor c=0.0054338f //x=79.345 //y=1.36
c182 ( 3 0 ) capacitor c=0.0704773f //x=82.445 //y=1.36
c183 ( 2 0 ) capacitor c=0.0153777f //x=76.015 //y=1.36
c184 ( 1 0 ) capacitor c=0.0651236f //x=79.115 //y=1.36
r185 (  60 62 ) resistor r=13.3953 //w=0.172 //l=0.18 //layer=li \
 //thickness=0.1 //x=75.897 //y=1.36 //x2=75.897 //y2=1.18
r186 (  46 48 ) resistor r=7.15173 //w=0.17 //l=0.120208 //layer=li \
 //thickness=0.1 //x=82.915 //y=1.825 //x2=83 //y2=1.91
r187 (  46 47 ) resistor r=18.4813 //w=0.187 //l=0.27 //layer=li \
 //thickness=0.1 //x=82.915 //y=1.825 //x2=82.645 //y2=1.825
r188 (  45 61 ) resistor r=5.4201 //w=0.17 //l=0.085 //layer=li \
 //thickness=0.1 //x=82.605 //y=5.39 //x2=82.52 //y2=5.39
r189 (  44 49 ) resistor r=7.15173 //w=0.17 //l=0.120208 //layer=li \
 //thickness=0.1 //x=82.915 //y=5.39 //x2=83 //y2=5.305
r190 (  44 45 ) resistor r=21.2193 //w=0.187 //l=0.31 //layer=li \
 //thickness=0.1 //x=82.915 //y=5.39 //x2=82.605 //y2=5.39
r191 (  43 64 ) resistor r=12.3209 //w=0.187 //l=0.18 //layer=li \
 //thickness=0.1 //x=82.56 //y=1.36 //x2=82.56 //y2=1.18
r192 (  38 47 ) resistor r=7.15173 //w=0.17 //l=0.120208 //layer=li \
 //thickness=0.1 //x=82.56 //y=1.74 //x2=82.645 //y2=1.825
r193 (  38 43 ) resistor r=26.0107 //w=0.187 //l=0.38 //layer=li \
 //thickness=0.1 //x=82.56 //y=1.74 //x2=82.56 //y2=1.36
r194 (  32 61 ) resistor r=1.40859 //w=0.34 //l=0.085 //layer=li \
 //thickness=0.1 //x=82.52 //y=5.475 //x2=82.52 //y2=5.39
r195 (  32 69 ) resistor r=29.0909 //w=0.187 //l=0.425 //layer=li \
 //thickness=0.1 //x=82.52 //y=5.475 //x2=82.52 //y2=5.9
r196 (  30 61 ) resistor r=5.4201 //w=0.17 //l=0.085 //layer=li \
 //thickness=0.1 //x=82.435 //y=5.39 //x2=82.52 //y2=5.39
r197 (  30 31 ) resistor r=48.5989 //w=0.187 //l=0.71 //layer=li \
 //thickness=0.1 //x=82.435 //y=5.39 //x2=81.725 //y2=5.39
r198 (  24 31 ) resistor r=7.15173 //w=0.17 //l=0.120208 //layer=li \
 //thickness=0.1 //x=81.64 //y=5.475 //x2=81.725 //y2=5.39
r199 (  24 68 ) resistor r=29.0909 //w=0.187 //l=0.425 //layer=li \
 //thickness=0.1 //x=81.64 //y=5.475 //x2=81.64 //y2=5.9
r200 (  22 63 ) resistor r=12.3209 //w=0.187 //l=0.18 //layer=li \
 //thickness=0.1 //x=79.23 //y=1.36 //x2=79.23 //y2=1.18
r201 (  17 49 ) resistor r=46.8877 //w=0.187 //l=0.685 //layer=li \
 //thickness=0.1 //x=83 //y=4.62 //x2=83 //y2=5.305
r202 (  16 17 ) resistor r=25.3262 //w=0.187 //l=0.37 //layer=li \
 //thickness=0.1 //x=83 //y=4.25 //x2=83 //y2=4.62
r203 (  15 16 ) resistor r=25.3262 //w=0.187 //l=0.37 //layer=li \
 //thickness=0.1 //x=83 //y=3.88 //x2=83 //y2=4.25
r204 (  14 15 ) resistor r=25.3262 //w=0.187 //l=0.37 //layer=li \
 //thickness=0.1 //x=83 //y=3.51 //x2=83 //y2=3.88
r205 (  13 14 ) resistor r=25.3262 //w=0.187 //l=0.37 //layer=li \
 //thickness=0.1 //x=83 //y=3.14 //x2=83 //y2=3.51
r206 (  12 13 ) resistor r=25.3262 //w=0.187 //l=0.37 //layer=li \
 //thickness=0.1 //x=83 //y=2.77 //x2=83 //y2=3.14
r207 (  11 12 ) resistor r=25.3262 //w=0.187 //l=0.37 //layer=li \
 //thickness=0.1 //x=83 //y=2.4 //x2=83 //y2=2.77
r208 (  11 48 ) resistor r=33.5401 //w=0.187 //l=0.49 //layer=li \
 //thickness=0.1 //x=83 //y=2.4 //x2=83 //y2=1.91
r209 (  10 43 ) resistor r=9.3 //w=0.17 //l=0.17 //layer=mcon //count=1 \
 //x=82.56 //y=1.36 //x2=82.56 //y2=1.36
r210 (  8 22 ) resistor r=9.3 //w=0.17 //l=0.17 //layer=mcon //count=1 \
 //x=79.23 //y=1.36 //x2=79.23 //y2=1.36
r211 (  6 60 ) resistor r=9.3 //w=0.17 //l=0.17 //layer=mcon //count=1 \
 //x=75.9 //y=1.36 //x2=75.9 //y2=1.36
r212 (  4 8 ) resistor r=0.0880901 //w=0.191 //l=0.115 //layer=m1 \
 //thickness=0.36 //x=79.345 //y=1.36 //x2=79.23 //y2=1.36
r213 (  3 10 ) resistor r=0.0717383 //w=0.224 //l=0.115 //layer=m1 \
 //thickness=0.36 //x=82.445 //y=1.36 //x2=82.56 //y2=1.36
r214 (  3 4 ) resistor r=2.95802 //w=0.131 //l=3.1 //layer=m1 //thickness=0.36 \
 //x=82.445 //y=1.36 //x2=79.345 //y2=1.36
r215 (  2 6 ) resistor r=0.0717383 //w=0.224 //l=0.115 //layer=m1 \
 //thickness=0.36 //x=76.015 //y=1.36 //x2=75.9 //y2=1.36
r216 (  1 8 ) resistor r=0.0880901 //w=0.191 //l=0.115 //layer=m1 \
 //thickness=0.36 //x=79.115 //y=1.36 //x2=79.23 //y2=1.36
r217 (  1 2 ) resistor r=2.95802 //w=0.131 //l=3.1 //layer=m1 //thickness=0.36 \
 //x=79.115 //y=1.36 //x2=76.015 //y2=1.36
ends PM_TMRDFFSNQNX1\%QN

subckt PM_TMRDFFSNQNX1\%noxref_27 ( 1 5 9 10 13 17 29 )
c50 ( 29 0 ) capacitor c=0.0632971f //x=1.05 //y=0.545
c51 ( 17 0 ) capacitor c=0.0072343f //x=3.125 //y=0.795
c52 ( 13 0 ) capacitor c=0.0147753f //x=3.04 //y=0.71
c53 ( 10 0 ) capacitor c=0.00638095f //x=2.155 //y=1.675
c54 ( 9 0 ) capacitor c=0.006761f //x=2.155 //y=0.795
c55 ( 5 0 ) capacitor c=0.02021f //x=2.07 //y=1.76
c56 ( 1 0 ) capacitor c=0.0113547f //x=1.185 //y=1.675
r57 (  17 29 ) resistor r=3.57586 //w=0.17 //l=0.125 //layer=li \
 //thickness=0.1 //x=3.125 //y=0.795 //x2=3.125 //y2=0.67
r58 (  17 29 ) resistor r=18.139 //w=0.187 //l=0.265 //layer=li \
 //thickness=0.1 //x=3.125 //y=0.795 //x2=3.125 //y2=1.06
r59 (  14 29 ) resistor r=3.57586 //w=0.17 //l=0.103078 //layer=li \
 //thickness=0.1 //x=2.24 //y=0.71 //x2=2.155 //y2=0.67
r60 (  14 29 ) resistor r=27.3797 //w=0.187 //l=0.4 //layer=li //thickness=0.1 \
 //x=2.24 //y=0.71 //x2=2.64 //y2=0.71
r61 (  13 29 ) resistor r=3.57586 //w=0.17 //l=0.103078 //layer=li \
 //thickness=0.1 //x=3.04 //y=0.71 //x2=3.125 //y2=0.67
r62 (  13 29 ) resistor r=27.3797 //w=0.187 //l=0.4 //layer=li //thickness=0.1 \
 //x=3.04 //y=0.71 //x2=2.64 //y2=0.71
r63 (  10 29 ) resistor r=3.57586 //w=0.17 //l=0.125 //layer=li \
 //thickness=0.1 //x=2.155 //y=1.675 //x2=2.155 //y2=1.8
r64 (  10 29 ) resistor r=42.0963 //w=0.187 //l=0.615 //layer=li \
 //thickness=0.1 //x=2.155 //y=1.675 //x2=2.155 //y2=1.06
r65 (  9 29 ) resistor r=3.57586 //w=0.17 //l=0.125 //layer=li //thickness=0.1 \
 //x=2.155 //y=0.795 //x2=2.155 //y2=0.67
r66 (  9 29 ) resistor r=18.139 //w=0.187 //l=0.265 //layer=li //thickness=0.1 \
 //x=2.155 //y=0.795 //x2=2.155 //y2=1.06
r67 (  6 29 ) resistor r=3.57586 //w=0.17 //l=0.103078 //layer=li \
 //thickness=0.1 //x=1.27 //y=1.76 //x2=1.185 //y2=1.8
r68 (  6 29 ) resistor r=27.3797 //w=0.187 //l=0.4 //layer=li //thickness=0.1 \
 //x=1.27 //y=1.76 //x2=1.67 //y2=1.76
r69 (  5 29 ) resistor r=3.57586 //w=0.17 //l=0.103078 //layer=li \
 //thickness=0.1 //x=2.07 //y=1.76 //x2=2.155 //y2=1.8
r70 (  5 29 ) resistor r=27.3797 //w=0.187 //l=0.4 //layer=li //thickness=0.1 \
 //x=2.07 //y=1.76 //x2=1.67 //y2=1.76
r71 (  1 29 ) resistor r=3.57586 //w=0.17 //l=0.125 //layer=li //thickness=0.1 \
 //x=1.185 //y=1.675 //x2=1.185 //y2=1.8
r72 (  1 29 ) resistor r=42.0963 //w=0.187 //l=0.615 //layer=li \
 //thickness=0.1 //x=1.185 //y=1.675 //x2=1.185 //y2=1.06
ends PM_TMRDFFSNQNX1\%noxref_27

subckt PM_TMRDFFSNQNX1\%noxref_28 ( 1 5 9 13 17 35 )
c51 ( 35 0 ) capacitor c=0.0680128f //x=4.275 //y=0.555
c52 ( 17 0 ) capacitor c=0.018806f //x=6.265 //y=1.77
c53 ( 13 0 ) capacitor c=0.0155484f //x=6.265 //y=0.72
c54 ( 9 0 ) capacitor c=0.00678203f //x=5.38 //y=0.805
c55 ( 5 0 ) capacitor c=0.017077f //x=5.295 //y=1.77
c56 ( 1 0 ) capacitor c=0.00729042f //x=4.41 //y=1.685
r57 (  18 35 ) resistor r=5.4201 //w=0.17 //l=0.103078 //layer=li \
 //thickness=0.1 //x=5.465 //y=1.77 //x2=5.38 //y2=1.81
r58 (  18 35 ) resistor r=27.3797 //w=0.187 //l=0.4 //layer=li //thickness=0.1 \
 //x=5.465 //y=1.77 //x2=5.865 //y2=1.77
r59 (  17 35 ) resistor r=0.751729 //w=0.17 //l=0.085 //layer=li \
 //thickness=0.1 //x=6.265 //y=1.77 //x2=6.35 //y2=1.77
r60 (  17 35 ) resistor r=27.3797 //w=0.187 //l=0.4 //layer=li //thickness=0.1 \
 //x=6.265 //y=1.77 //x2=5.865 //y2=1.77
r61 (  14 35 ) resistor r=3.57586 //w=0.17 //l=0.103078 //layer=li \
 //thickness=0.1 //x=5.465 //y=0.72 //x2=5.38 //y2=0.68
r62 (  14 35 ) resistor r=27.3797 //w=0.187 //l=0.4 //layer=li //thickness=0.1 \
 //x=5.465 //y=0.72 //x2=5.865 //y2=0.72
r63 (  13 35 ) resistor r=0.751729 //w=0.17 //l=0.085 //layer=li \
 //thickness=0.1 //x=6.265 //y=0.72 //x2=6.35 //y2=0.72
r64 (  13 35 ) resistor r=27.3797 //w=0.187 //l=0.4 //layer=li //thickness=0.1 \
 //x=6.265 //y=0.72 //x2=5.865 //y2=0.72
r65 (  10 35 ) resistor r=1.40859 //w=0.34 //l=0.125 //layer=li \
 //thickness=0.1 //x=5.38 //y=1.685 //x2=5.38 //y2=1.81
r66 (  10 35 ) resistor r=42.0963 //w=0.187 //l=0.615 //layer=li \
 //thickness=0.1 //x=5.38 //y=1.685 //x2=5.38 //y2=1.07
r67 (  9 35 ) resistor r=3.57586 //w=0.17 //l=0.125 //layer=li //thickness=0.1 \
 //x=5.38 //y=0.805 //x2=5.38 //y2=0.68
r68 (  9 35 ) resistor r=18.139 //w=0.187 //l=0.265 //layer=li //thickness=0.1 \
 //x=5.38 //y=0.805 //x2=5.38 //y2=1.07
r69 (  6 35 ) resistor r=3.57586 //w=0.17 //l=0.103078 //layer=li \
 //thickness=0.1 //x=4.495 //y=1.77 //x2=4.41 //y2=1.81
r70 (  6 35 ) resistor r=27.3797 //w=0.187 //l=0.4 //layer=li //thickness=0.1 \
 //x=4.495 //y=1.77 //x2=4.895 //y2=1.77
r71 (  5 35 ) resistor r=5.4201 //w=0.17 //l=0.103078 //layer=li \
 //thickness=0.1 //x=5.295 //y=1.77 //x2=5.38 //y2=1.81
r72 (  5 35 ) resistor r=27.3797 //w=0.187 //l=0.4 //layer=li //thickness=0.1 \
 //x=5.295 //y=1.77 //x2=4.895 //y2=1.77
r73 (  1 35 ) resistor r=3.57586 //w=0.17 //l=0.125 //layer=li //thickness=0.1 \
 //x=4.41 //y=1.685 //x2=4.41 //y2=1.81
r74 (  1 35 ) resistor r=42.0963 //w=0.187 //l=0.615 //layer=li \
 //thickness=0.1 //x=4.41 //y=1.685 //x2=4.41 //y2=1.07
ends PM_TMRDFFSNQNX1\%noxref_28

subckt PM_TMRDFFSNQNX1\%noxref_29 ( 1 3 11 15 25 28 29 )
c52 ( 29 0 ) capacitor c=0.041888f //x=6.785 //y=0.555
c53 ( 28 0 ) capacitor c=0.00460056f //x=5.68 //y=1.09
c54 ( 25 0 ) capacitor c=0.00156479f //x=6.92 //y=1.175
c55 ( 15 0 ) capacitor c=0.00737666f //x=7.89 //y=0.805
c56 ( 11 0 ) capacitor c=0.0145763f //x=7.805 //y=0.72
c57 ( 3 0 ) capacitor c=0.00718386f //x=6.92 //y=0.805
c58 ( 1 0 ) capacitor c=0.022715f //x=6.835 //y=1.175
r59 (  15 29 ) resistor r=3.57586 //w=0.17 //l=0.125 //layer=li \
 //thickness=0.1 //x=7.89 //y=0.805 //x2=7.89 //y2=0.68
r60 (  15 29 ) resistor r=18.139 //w=0.187 //l=0.265 //layer=li \
 //thickness=0.1 //x=7.89 //y=0.805 //x2=7.89 //y2=1.07
r61 (  12 29 ) resistor r=3.57586 //w=0.17 //l=0.103078 //layer=li \
 //thickness=0.1 //x=7.005 //y=0.72 //x2=6.92 //y2=0.68
r62 (  12 29 ) resistor r=27.3797 //w=0.187 //l=0.4 //layer=li //thickness=0.1 \
 //x=7.005 //y=0.72 //x2=7.405 //y2=0.72
r63 (  11 29 ) resistor r=3.57586 //w=0.17 //l=0.103078 //layer=li \
 //thickness=0.1 //x=7.805 //y=0.72 //x2=7.89 //y2=0.68
r64 (  11 29 ) resistor r=27.3797 //w=0.187 //l=0.4 //layer=li //thickness=0.1 \
 //x=7.805 //y=0.72 //x2=7.405 //y2=0.72
r65 (  7 25 ) resistor r=5.4201 //w=0.17 //l=0.085 //layer=li //thickness=0.1 \
 //x=6.92 //y=1.26 //x2=6.92 //y2=1.175
r66 (  7 29 ) resistor r=10.2674 //w=0.187 //l=0.15 //layer=li //thickness=0.1 \
 //x=6.92 //y=1.26 //x2=6.92 //y2=1.41
r67 (  4 25 ) resistor r=5.4201 //w=0.17 //l=0.085 //layer=li //thickness=0.1 \
 //x=6.92 //y=1.09 //x2=6.92 //y2=1.175
r68 (  4 29 ) resistor r=1.36898 //w=0.187 //l=0.02 //layer=li //thickness=0.1 \
 //x=6.92 //y=1.09 //x2=6.92 //y2=1.07
r69 (  3 29 ) resistor r=3.57586 //w=0.17 //l=0.125 //layer=li //thickness=0.1 \
 //x=6.92 //y=0.805 //x2=6.92 //y2=0.68
r70 (  3 29 ) resistor r=18.139 //w=0.187 //l=0.265 //layer=li //thickness=0.1 \
 //x=6.92 //y=0.805 //x2=6.92 //y2=1.07
r71 (  2 28 ) resistor r=0.751729 //w=0.17 //l=0.085 //layer=li \
 //thickness=0.1 //x=5.955 //y=1.175 //x2=5.87 //y2=1.175
r72 (  1 25 ) resistor r=1.40859 //w=0.34 //l=0.085 //layer=li //thickness=0.1 \
 //x=6.835 //y=1.175 //x2=6.92 //y2=1.175
r73 (  1 2 ) resistor r=60.2353 //w=0.187 //l=0.88 //layer=li //thickness=0.1 \
 //x=6.835 //y=1.175 //x2=5.955 //y2=1.175
ends PM_TMRDFFSNQNX1\%noxref_29

subckt PM_TMRDFFSNQNX1\%noxref_30 ( 1 5 9 13 17 35 )
c53 ( 35 0 ) capacitor c=0.0679545f //x=9.085 //y=0.555
c54 ( 17 0 ) capacitor c=0.0193993f //x=11.075 //y=1.77
c55 ( 13 0 ) capacitor c=0.0155066f //x=11.075 //y=0.72
c56 ( 9 0 ) capacitor c=0.00678203f //x=10.19 //y=0.805
c57 ( 5 0 ) capacitor c=0.0174845f //x=10.105 //y=1.77
c58 ( 1 0 ) capacitor c=0.00729042f //x=9.22 //y=1.685
r59 (  18 35 ) resistor r=5.4201 //w=0.17 //l=0.103078 //layer=li \
 //thickness=0.1 //x=10.275 //y=1.77 //x2=10.19 //y2=1.81
r60 (  18 35 ) resistor r=27.3797 //w=0.187 //l=0.4 //layer=li //thickness=0.1 \
 //x=10.275 //y=1.77 //x2=10.675 //y2=1.77
r61 (  17 35 ) resistor r=0.751729 //w=0.17 //l=0.085 //layer=li \
 //thickness=0.1 //x=11.075 //y=1.77 //x2=11.16 //y2=1.77
r62 (  17 35 ) resistor r=27.3797 //w=0.187 //l=0.4 //layer=li //thickness=0.1 \
 //x=11.075 //y=1.77 //x2=10.675 //y2=1.77
r63 (  14 35 ) resistor r=3.57586 //w=0.17 //l=0.103078 //layer=li \
 //thickness=0.1 //x=10.275 //y=0.72 //x2=10.19 //y2=0.68
r64 (  14 35 ) resistor r=27.3797 //w=0.187 //l=0.4 //layer=li //thickness=0.1 \
 //x=10.275 //y=0.72 //x2=10.675 //y2=0.72
r65 (  13 35 ) resistor r=0.751729 //w=0.17 //l=0.085 //layer=li \
 //thickness=0.1 //x=11.075 //y=0.72 //x2=11.16 //y2=0.72
r66 (  13 35 ) resistor r=27.3797 //w=0.187 //l=0.4 //layer=li //thickness=0.1 \
 //x=11.075 //y=0.72 //x2=10.675 //y2=0.72
r67 (  10 35 ) resistor r=1.40859 //w=0.34 //l=0.125 //layer=li \
 //thickness=0.1 //x=10.19 //y=1.685 //x2=10.19 //y2=1.81
r68 (  10 35 ) resistor r=42.0963 //w=0.187 //l=0.615 //layer=li \
 //thickness=0.1 //x=10.19 //y=1.685 //x2=10.19 //y2=1.07
r69 (  9 35 ) resistor r=3.57586 //w=0.17 //l=0.125 //layer=li //thickness=0.1 \
 //x=10.19 //y=0.805 //x2=10.19 //y2=0.68
r70 (  9 35 ) resistor r=18.139 //w=0.187 //l=0.265 //layer=li //thickness=0.1 \
 //x=10.19 //y=0.805 //x2=10.19 //y2=1.07
r71 (  6 35 ) resistor r=3.57586 //w=0.17 //l=0.103078 //layer=li \
 //thickness=0.1 //x=9.305 //y=1.77 //x2=9.22 //y2=1.81
r72 (  6 35 ) resistor r=27.3797 //w=0.187 //l=0.4 //layer=li //thickness=0.1 \
 //x=9.305 //y=1.77 //x2=9.705 //y2=1.77
r73 (  5 35 ) resistor r=5.4201 //w=0.17 //l=0.103078 //layer=li \
 //thickness=0.1 //x=10.105 //y=1.77 //x2=10.19 //y2=1.81
r74 (  5 35 ) resistor r=27.3797 //w=0.187 //l=0.4 //layer=li //thickness=0.1 \
 //x=10.105 //y=1.77 //x2=9.705 //y2=1.77
r75 (  1 35 ) resistor r=3.57586 //w=0.17 //l=0.125 //layer=li //thickness=0.1 \
 //x=9.22 //y=1.685 //x2=9.22 //y2=1.81
r76 (  1 35 ) resistor r=42.0963 //w=0.187 //l=0.615 //layer=li \
 //thickness=0.1 //x=9.22 //y=1.685 //x2=9.22 //y2=1.07
ends PM_TMRDFFSNQNX1\%noxref_30

subckt PM_TMRDFFSNQNX1\%noxref_31 ( 1 3 11 15 25 28 29 )
c52 ( 29 0 ) capacitor c=0.0414744f //x=11.595 //y=0.555
c53 ( 28 0 ) capacitor c=0.00460343f //x=10.49 //y=1.09
c54 ( 25 0 ) capacitor c=0.00156479f //x=11.73 //y=1.175
c55 ( 15 0 ) capacitor c=0.00737666f //x=12.7 //y=0.805
c56 ( 11 0 ) capacitor c=0.0144274f //x=12.615 //y=0.72
c57 ( 3 0 ) capacitor c=0.00718386f //x=11.73 //y=0.805
c58 ( 1 0 ) capacitor c=0.0218873f //x=11.645 //y=1.175
r59 (  15 29 ) resistor r=3.57586 //w=0.17 //l=0.125 //layer=li \
 //thickness=0.1 //x=12.7 //y=0.805 //x2=12.7 //y2=0.68
r60 (  15 29 ) resistor r=18.139 //w=0.187 //l=0.265 //layer=li \
 //thickness=0.1 //x=12.7 //y=0.805 //x2=12.7 //y2=1.07
r61 (  12 29 ) resistor r=3.57586 //w=0.17 //l=0.103078 //layer=li \
 //thickness=0.1 //x=11.815 //y=0.72 //x2=11.73 //y2=0.68
r62 (  12 29 ) resistor r=27.3797 //w=0.187 //l=0.4 //layer=li //thickness=0.1 \
 //x=11.815 //y=0.72 //x2=12.215 //y2=0.72
r63 (  11 29 ) resistor r=3.57586 //w=0.17 //l=0.103078 //layer=li \
 //thickness=0.1 //x=12.615 //y=0.72 //x2=12.7 //y2=0.68
r64 (  11 29 ) resistor r=27.3797 //w=0.187 //l=0.4 //layer=li //thickness=0.1 \
 //x=12.615 //y=0.72 //x2=12.215 //y2=0.72
r65 (  7 25 ) resistor r=5.4201 //w=0.17 //l=0.085 //layer=li //thickness=0.1 \
 //x=11.73 //y=1.26 //x2=11.73 //y2=1.175
r66 (  7 29 ) resistor r=10.2674 //w=0.187 //l=0.15 //layer=li //thickness=0.1 \
 //x=11.73 //y=1.26 //x2=11.73 //y2=1.41
r67 (  4 25 ) resistor r=5.4201 //w=0.17 //l=0.085 //layer=li //thickness=0.1 \
 //x=11.73 //y=1.09 //x2=11.73 //y2=1.175
r68 (  4 29 ) resistor r=1.36898 //w=0.187 //l=0.02 //layer=li //thickness=0.1 \
 //x=11.73 //y=1.09 //x2=11.73 //y2=1.07
r69 (  3 29 ) resistor r=3.57586 //w=0.17 //l=0.125 //layer=li //thickness=0.1 \
 //x=11.73 //y=0.805 //x2=11.73 //y2=0.68
r70 (  3 29 ) resistor r=18.139 //w=0.187 //l=0.265 //layer=li //thickness=0.1 \
 //x=11.73 //y=0.805 //x2=11.73 //y2=1.07
r71 (  2 28 ) resistor r=0.751729 //w=0.17 //l=0.085 //layer=li \
 //thickness=0.1 //x=10.765 //y=1.175 //x2=10.68 //y2=1.175
r72 (  1 25 ) resistor r=1.40859 //w=0.34 //l=0.085 //layer=li //thickness=0.1 \
 //x=11.645 //y=1.175 //x2=11.73 //y2=1.175
r73 (  1 2 ) resistor r=60.2353 //w=0.187 //l=0.88 //layer=li //thickness=0.1 \
 //x=11.645 //y=1.175 //x2=10.765 //y2=1.175
ends PM_TMRDFFSNQNX1\%noxref_31

subckt PM_TMRDFFSNQNX1\%noxref_32 ( 1 5 9 10 13 17 29 )
c51 ( 29 0 ) capacitor c=0.0632682f //x=14 //y=0.545
c52 ( 17 0 ) capacitor c=0.00722223f //x=16.075 //y=0.795
c53 ( 13 0 ) capacitor c=0.0145084f //x=15.99 //y=0.71
c54 ( 10 0 ) capacitor c=0.00582081f //x=15.105 //y=1.675
c55 ( 9 0 ) capacitor c=0.006761f //x=15.105 //y=0.795
c56 ( 5 0 ) capacitor c=0.0173046f //x=15.02 //y=1.76
c57 ( 1 0 ) capacitor c=0.00733328f //x=14.135 //y=1.675
r58 (  17 29 ) resistor r=3.57586 //w=0.17 //l=0.125 //layer=li \
 //thickness=0.1 //x=16.075 //y=0.795 //x2=16.075 //y2=0.67
r59 (  17 29 ) resistor r=18.139 //w=0.187 //l=0.265 //layer=li \
 //thickness=0.1 //x=16.075 //y=0.795 //x2=16.075 //y2=1.06
r60 (  14 29 ) resistor r=3.57586 //w=0.17 //l=0.103078 //layer=li \
 //thickness=0.1 //x=15.19 //y=0.71 //x2=15.105 //y2=0.67
r61 (  14 29 ) resistor r=27.3797 //w=0.187 //l=0.4 //layer=li //thickness=0.1 \
 //x=15.19 //y=0.71 //x2=15.59 //y2=0.71
r62 (  13 29 ) resistor r=3.57586 //w=0.17 //l=0.103078 //layer=li \
 //thickness=0.1 //x=15.99 //y=0.71 //x2=16.075 //y2=0.67
r63 (  13 29 ) resistor r=27.3797 //w=0.187 //l=0.4 //layer=li //thickness=0.1 \
 //x=15.99 //y=0.71 //x2=15.59 //y2=0.71
r64 (  10 29 ) resistor r=3.57586 //w=0.17 //l=0.125 //layer=li \
 //thickness=0.1 //x=15.105 //y=1.675 //x2=15.105 //y2=1.8
r65 (  10 29 ) resistor r=42.0963 //w=0.187 //l=0.615 //layer=li \
 //thickness=0.1 //x=15.105 //y=1.675 //x2=15.105 //y2=1.06
r66 (  9 29 ) resistor r=3.57586 //w=0.17 //l=0.125 //layer=li //thickness=0.1 \
 //x=15.105 //y=0.795 //x2=15.105 //y2=0.67
r67 (  9 29 ) resistor r=18.139 //w=0.187 //l=0.265 //layer=li //thickness=0.1 \
 //x=15.105 //y=0.795 //x2=15.105 //y2=1.06
r68 (  6 29 ) resistor r=3.57586 //w=0.17 //l=0.103078 //layer=li \
 //thickness=0.1 //x=14.22 //y=1.76 //x2=14.135 //y2=1.8
r69 (  6 29 ) resistor r=27.3797 //w=0.187 //l=0.4 //layer=li //thickness=0.1 \
 //x=14.22 //y=1.76 //x2=14.62 //y2=1.76
r70 (  5 29 ) resistor r=3.57586 //w=0.17 //l=0.103078 //layer=li \
 //thickness=0.1 //x=15.02 //y=1.76 //x2=15.105 //y2=1.8
r71 (  5 29 ) resistor r=27.3797 //w=0.187 //l=0.4 //layer=li //thickness=0.1 \
 //x=15.02 //y=1.76 //x2=14.62 //y2=1.76
r72 (  1 29 ) resistor r=3.57586 //w=0.17 //l=0.125 //layer=li //thickness=0.1 \
 //x=14.135 //y=1.675 //x2=14.135 //y2=1.8
r73 (  1 29 ) resistor r=42.0963 //w=0.187 //l=0.615 //layer=li \
 //thickness=0.1 //x=14.135 //y=1.675 //x2=14.135 //y2=1.06
ends PM_TMRDFFSNQNX1\%noxref_32

subckt PM_TMRDFFSNQNX1\%noxref_33 ( 1 5 9 10 13 17 29 )
c51 ( 29 0 ) capacitor c=0.0632684f //x=17.33 //y=0.545
c52 ( 17 0 ) capacitor c=0.0072343f //x=19.405 //y=0.795
c53 ( 13 0 ) capacitor c=0.0145084f //x=19.32 //y=0.71
c54 ( 10 0 ) capacitor c=0.00582081f //x=18.435 //y=1.675
c55 ( 9 0 ) capacitor c=0.006761f //x=18.435 //y=0.795
c56 ( 5 0 ) capacitor c=0.0173046f //x=18.35 //y=1.76
c57 ( 1 0 ) capacitor c=0.00733328f //x=17.465 //y=1.675
r58 (  17 29 ) resistor r=3.57586 //w=0.17 //l=0.125 //layer=li \
 //thickness=0.1 //x=19.405 //y=0.795 //x2=19.405 //y2=0.67
r59 (  17 29 ) resistor r=18.139 //w=0.187 //l=0.265 //layer=li \
 //thickness=0.1 //x=19.405 //y=0.795 //x2=19.405 //y2=1.06
r60 (  14 29 ) resistor r=3.57586 //w=0.17 //l=0.103078 //layer=li \
 //thickness=0.1 //x=18.52 //y=0.71 //x2=18.435 //y2=0.67
r61 (  14 29 ) resistor r=27.3797 //w=0.187 //l=0.4 //layer=li //thickness=0.1 \
 //x=18.52 //y=0.71 //x2=18.92 //y2=0.71
r62 (  13 29 ) resistor r=3.57586 //w=0.17 //l=0.103078 //layer=li \
 //thickness=0.1 //x=19.32 //y=0.71 //x2=19.405 //y2=0.67
r63 (  13 29 ) resistor r=27.3797 //w=0.187 //l=0.4 //layer=li //thickness=0.1 \
 //x=19.32 //y=0.71 //x2=18.92 //y2=0.71
r64 (  10 29 ) resistor r=3.57586 //w=0.17 //l=0.125 //layer=li \
 //thickness=0.1 //x=18.435 //y=1.675 //x2=18.435 //y2=1.8
r65 (  10 29 ) resistor r=42.0963 //w=0.187 //l=0.615 //layer=li \
 //thickness=0.1 //x=18.435 //y=1.675 //x2=18.435 //y2=1.06
r66 (  9 29 ) resistor r=3.57586 //w=0.17 //l=0.125 //layer=li //thickness=0.1 \
 //x=18.435 //y=0.795 //x2=18.435 //y2=0.67
r67 (  9 29 ) resistor r=18.139 //w=0.187 //l=0.265 //layer=li //thickness=0.1 \
 //x=18.435 //y=0.795 //x2=18.435 //y2=1.06
r68 (  6 29 ) resistor r=3.57586 //w=0.17 //l=0.103078 //layer=li \
 //thickness=0.1 //x=17.55 //y=1.76 //x2=17.465 //y2=1.8
r69 (  6 29 ) resistor r=27.3797 //w=0.187 //l=0.4 //layer=li //thickness=0.1 \
 //x=17.55 //y=1.76 //x2=17.95 //y2=1.76
r70 (  5 29 ) resistor r=3.57586 //w=0.17 //l=0.103078 //layer=li \
 //thickness=0.1 //x=18.35 //y=1.76 //x2=18.435 //y2=1.8
r71 (  5 29 ) resistor r=27.3797 //w=0.187 //l=0.4 //layer=li //thickness=0.1 \
 //x=18.35 //y=1.76 //x2=17.95 //y2=1.76
r72 (  1 29 ) resistor r=3.57586 //w=0.17 //l=0.125 //layer=li //thickness=0.1 \
 //x=17.465 //y=1.675 //x2=17.465 //y2=1.8
r73 (  1 29 ) resistor r=42.0963 //w=0.187 //l=0.615 //layer=li \
 //thickness=0.1 //x=17.465 //y=1.675 //x2=17.465 //y2=1.06
ends PM_TMRDFFSNQNX1\%noxref_33

subckt PM_TMRDFFSNQNX1\%noxref_34 ( 1 5 9 13 17 35 )
c52 ( 35 0 ) capacitor c=0.0673029f //x=20.555 //y=0.555
c53 ( 17 0 ) capacitor c=0.0178286f //x=22.545 //y=1.77
c54 ( 13 0 ) capacitor c=0.0154917f //x=22.545 //y=0.72
c55 ( 9 0 ) capacitor c=0.00678203f //x=21.66 //y=0.805
c56 ( 5 0 ) capacitor c=0.0164013f //x=21.575 //y=1.77
c57 ( 1 0 ) capacitor c=0.00696517f //x=20.69 //y=1.685
r58 (  18 35 ) resistor r=5.4201 //w=0.17 //l=0.103078 //layer=li \
 //thickness=0.1 //x=21.745 //y=1.77 //x2=21.66 //y2=1.81
r59 (  18 35 ) resistor r=27.3797 //w=0.187 //l=0.4 //layer=li //thickness=0.1 \
 //x=21.745 //y=1.77 //x2=22.145 //y2=1.77
r60 (  17 35 ) resistor r=0.751729 //w=0.17 //l=0.085 //layer=li \
 //thickness=0.1 //x=22.545 //y=1.77 //x2=22.63 //y2=1.77
r61 (  17 35 ) resistor r=27.3797 //w=0.187 //l=0.4 //layer=li //thickness=0.1 \
 //x=22.545 //y=1.77 //x2=22.145 //y2=1.77
r62 (  14 35 ) resistor r=3.57586 //w=0.17 //l=0.103078 //layer=li \
 //thickness=0.1 //x=21.745 //y=0.72 //x2=21.66 //y2=0.68
r63 (  14 35 ) resistor r=27.3797 //w=0.187 //l=0.4 //layer=li //thickness=0.1 \
 //x=21.745 //y=0.72 //x2=22.145 //y2=0.72
r64 (  13 35 ) resistor r=0.751729 //w=0.17 //l=0.085 //layer=li \
 //thickness=0.1 //x=22.545 //y=0.72 //x2=22.63 //y2=0.72
r65 (  13 35 ) resistor r=27.3797 //w=0.187 //l=0.4 //layer=li //thickness=0.1 \
 //x=22.545 //y=0.72 //x2=22.145 //y2=0.72
r66 (  10 35 ) resistor r=1.40859 //w=0.34 //l=0.125 //layer=li \
 //thickness=0.1 //x=21.66 //y=1.685 //x2=21.66 //y2=1.81
r67 (  10 35 ) resistor r=42.0963 //w=0.187 //l=0.615 //layer=li \
 //thickness=0.1 //x=21.66 //y=1.685 //x2=21.66 //y2=1.07
r68 (  9 35 ) resistor r=3.57586 //w=0.17 //l=0.125 //layer=li //thickness=0.1 \
 //x=21.66 //y=0.805 //x2=21.66 //y2=0.68
r69 (  9 35 ) resistor r=18.139 //w=0.187 //l=0.265 //layer=li //thickness=0.1 \
 //x=21.66 //y=0.805 //x2=21.66 //y2=1.07
r70 (  6 35 ) resistor r=3.57586 //w=0.17 //l=0.103078 //layer=li \
 //thickness=0.1 //x=20.775 //y=1.77 //x2=20.69 //y2=1.81
r71 (  6 35 ) resistor r=27.3797 //w=0.187 //l=0.4 //layer=li //thickness=0.1 \
 //x=20.775 //y=1.77 //x2=21.175 //y2=1.77
r72 (  5 35 ) resistor r=5.4201 //w=0.17 //l=0.103078 //layer=li \
 //thickness=0.1 //x=21.575 //y=1.77 //x2=21.66 //y2=1.81
r73 (  5 35 ) resistor r=27.3797 //w=0.187 //l=0.4 //layer=li //thickness=0.1 \
 //x=21.575 //y=1.77 //x2=21.175 //y2=1.77
r74 (  1 35 ) resistor r=3.57586 //w=0.17 //l=0.125 //layer=li //thickness=0.1 \
 //x=20.69 //y=1.685 //x2=20.69 //y2=1.81
r75 (  1 35 ) resistor r=42.0963 //w=0.187 //l=0.615 //layer=li \
 //thickness=0.1 //x=20.69 //y=1.685 //x2=20.69 //y2=1.07
ends PM_TMRDFFSNQNX1\%noxref_34

subckt PM_TMRDFFSNQNX1\%noxref_35 ( 1 3 11 15 25 28 29 )
c52 ( 29 0 ) capacitor c=0.0413887f //x=23.065 //y=0.555
c53 ( 28 0 ) capacitor c=0.00457437f //x=21.96 //y=1.09
c54 ( 25 0 ) capacitor c=0.00156479f //x=23.2 //y=1.175
c55 ( 15 0 ) capacitor c=0.00737666f //x=24.17 //y=0.805
c56 ( 11 0 ) capacitor c=0.0144274f //x=24.085 //y=0.72
c57 ( 3 0 ) capacitor c=0.00718386f //x=23.2 //y=0.805
c58 ( 1 0 ) capacitor c=0.0218873f //x=23.115 //y=1.175
r59 (  15 29 ) resistor r=3.57586 //w=0.17 //l=0.125 //layer=li \
 //thickness=0.1 //x=24.17 //y=0.805 //x2=24.17 //y2=0.68
r60 (  15 29 ) resistor r=18.139 //w=0.187 //l=0.265 //layer=li \
 //thickness=0.1 //x=24.17 //y=0.805 //x2=24.17 //y2=1.07
r61 (  12 29 ) resistor r=3.57586 //w=0.17 //l=0.103078 //layer=li \
 //thickness=0.1 //x=23.285 //y=0.72 //x2=23.2 //y2=0.68
r62 (  12 29 ) resistor r=27.3797 //w=0.187 //l=0.4 //layer=li //thickness=0.1 \
 //x=23.285 //y=0.72 //x2=23.685 //y2=0.72
r63 (  11 29 ) resistor r=3.57586 //w=0.17 //l=0.103078 //layer=li \
 //thickness=0.1 //x=24.085 //y=0.72 //x2=24.17 //y2=0.68
r64 (  11 29 ) resistor r=27.3797 //w=0.187 //l=0.4 //layer=li //thickness=0.1 \
 //x=24.085 //y=0.72 //x2=23.685 //y2=0.72
r65 (  7 25 ) resistor r=5.4201 //w=0.17 //l=0.085 //layer=li //thickness=0.1 \
 //x=23.2 //y=1.26 //x2=23.2 //y2=1.175
r66 (  7 29 ) resistor r=10.2674 //w=0.187 //l=0.15 //layer=li //thickness=0.1 \
 //x=23.2 //y=1.26 //x2=23.2 //y2=1.41
r67 (  4 25 ) resistor r=5.4201 //w=0.17 //l=0.085 //layer=li //thickness=0.1 \
 //x=23.2 //y=1.09 //x2=23.2 //y2=1.175
r68 (  4 29 ) resistor r=1.36898 //w=0.187 //l=0.02 //layer=li //thickness=0.1 \
 //x=23.2 //y=1.09 //x2=23.2 //y2=1.07
r69 (  3 29 ) resistor r=3.57586 //w=0.17 //l=0.125 //layer=li //thickness=0.1 \
 //x=23.2 //y=0.805 //x2=23.2 //y2=0.68
r70 (  3 29 ) resistor r=18.139 //w=0.187 //l=0.265 //layer=li //thickness=0.1 \
 //x=23.2 //y=0.805 //x2=23.2 //y2=1.07
r71 (  2 28 ) resistor r=0.751729 //w=0.17 //l=0.085 //layer=li \
 //thickness=0.1 //x=22.235 //y=1.175 //x2=22.15 //y2=1.175
r72 (  1 25 ) resistor r=1.40859 //w=0.34 //l=0.085 //layer=li //thickness=0.1 \
 //x=23.115 //y=1.175 //x2=23.2 //y2=1.175
r73 (  1 2 ) resistor r=60.2353 //w=0.187 //l=0.88 //layer=li //thickness=0.1 \
 //x=23.115 //y=1.175 //x2=22.235 //y2=1.175
ends PM_TMRDFFSNQNX1\%noxref_35

subckt PM_TMRDFFSNQNX1\%noxref_36 ( 1 5 9 10 13 17 29 )
c51 ( 29 0 ) capacitor c=0.0633518f //x=25.47 //y=0.545
c52 ( 17 0 ) capacitor c=0.0072343f //x=27.545 //y=0.795
c53 ( 13 0 ) capacitor c=0.0145084f //x=27.46 //y=0.71
c54 ( 10 0 ) capacitor c=0.00582081f //x=26.575 //y=1.675
c55 ( 9 0 ) capacitor c=0.006761f //x=26.575 //y=0.795
c56 ( 5 0 ) capacitor c=0.0173046f //x=26.49 //y=1.76
c57 ( 1 0 ) capacitor c=0.00733328f //x=25.605 //y=1.675
r58 (  17 29 ) resistor r=3.57586 //w=0.17 //l=0.125 //layer=li \
 //thickness=0.1 //x=27.545 //y=0.795 //x2=27.545 //y2=0.67
r59 (  17 29 ) resistor r=18.139 //w=0.187 //l=0.265 //layer=li \
 //thickness=0.1 //x=27.545 //y=0.795 //x2=27.545 //y2=1.06
r60 (  14 29 ) resistor r=3.57586 //w=0.17 //l=0.103078 //layer=li \
 //thickness=0.1 //x=26.66 //y=0.71 //x2=26.575 //y2=0.67
r61 (  14 29 ) resistor r=27.3797 //w=0.187 //l=0.4 //layer=li //thickness=0.1 \
 //x=26.66 //y=0.71 //x2=27.06 //y2=0.71
r62 (  13 29 ) resistor r=3.57586 //w=0.17 //l=0.103078 //layer=li \
 //thickness=0.1 //x=27.46 //y=0.71 //x2=27.545 //y2=0.67
r63 (  13 29 ) resistor r=27.3797 //w=0.187 //l=0.4 //layer=li //thickness=0.1 \
 //x=27.46 //y=0.71 //x2=27.06 //y2=0.71
r64 (  10 29 ) resistor r=3.57586 //w=0.17 //l=0.125 //layer=li \
 //thickness=0.1 //x=26.575 //y=1.675 //x2=26.575 //y2=1.8
r65 (  10 29 ) resistor r=42.0963 //w=0.187 //l=0.615 //layer=li \
 //thickness=0.1 //x=26.575 //y=1.675 //x2=26.575 //y2=1.06
r66 (  9 29 ) resistor r=3.57586 //w=0.17 //l=0.125 //layer=li //thickness=0.1 \
 //x=26.575 //y=0.795 //x2=26.575 //y2=0.67
r67 (  9 29 ) resistor r=18.139 //w=0.187 //l=0.265 //layer=li //thickness=0.1 \
 //x=26.575 //y=0.795 //x2=26.575 //y2=1.06
r68 (  6 29 ) resistor r=3.57586 //w=0.17 //l=0.103078 //layer=li \
 //thickness=0.1 //x=25.69 //y=1.76 //x2=25.605 //y2=1.8
r69 (  6 29 ) resistor r=27.3797 //w=0.187 //l=0.4 //layer=li //thickness=0.1 \
 //x=25.69 //y=1.76 //x2=26.09 //y2=1.76
r70 (  5 29 ) resistor r=3.57586 //w=0.17 //l=0.103078 //layer=li \
 //thickness=0.1 //x=26.49 //y=1.76 //x2=26.575 //y2=1.8
r71 (  5 29 ) resistor r=27.3797 //w=0.187 //l=0.4 //layer=li //thickness=0.1 \
 //x=26.49 //y=1.76 //x2=26.09 //y2=1.76
r72 (  1 29 ) resistor r=3.57586 //w=0.17 //l=0.125 //layer=li //thickness=0.1 \
 //x=25.605 //y=1.675 //x2=25.605 //y2=1.8
r73 (  1 29 ) resistor r=42.0963 //w=0.187 //l=0.615 //layer=li \
 //thickness=0.1 //x=25.605 //y=1.675 //x2=25.605 //y2=1.06
ends PM_TMRDFFSNQNX1\%noxref_36

subckt PM_TMRDFFSNQNX1\%noxref_37 ( 1 5 9 13 17 35 )
c49 ( 35 0 ) capacitor c=0.0673195f //x=28.695 //y=0.555
c50 ( 17 0 ) capacitor c=0.0178317f //x=30.685 //y=1.77
c51 ( 13 0 ) capacitor c=0.0154936f //x=30.685 //y=0.72
c52 ( 9 0 ) capacitor c=0.00678203f //x=29.8 //y=0.805
c53 ( 5 0 ) capacitor c=0.0164013f //x=29.715 //y=1.77
c54 ( 1 0 ) capacitor c=0.00696517f //x=28.83 //y=1.685
r55 (  18 35 ) resistor r=5.4201 //w=0.17 //l=0.103078 //layer=li \
 //thickness=0.1 //x=29.885 //y=1.77 //x2=29.8 //y2=1.81
r56 (  18 35 ) resistor r=27.3797 //w=0.187 //l=0.4 //layer=li //thickness=0.1 \
 //x=29.885 //y=1.77 //x2=30.285 //y2=1.77
r57 (  17 35 ) resistor r=0.751729 //w=0.17 //l=0.085 //layer=li \
 //thickness=0.1 //x=30.685 //y=1.77 //x2=30.77 //y2=1.77
r58 (  17 35 ) resistor r=27.3797 //w=0.187 //l=0.4 //layer=li //thickness=0.1 \
 //x=30.685 //y=1.77 //x2=30.285 //y2=1.77
r59 (  14 35 ) resistor r=3.57586 //w=0.17 //l=0.103078 //layer=li \
 //thickness=0.1 //x=29.885 //y=0.72 //x2=29.8 //y2=0.68
r60 (  14 35 ) resistor r=27.3797 //w=0.187 //l=0.4 //layer=li //thickness=0.1 \
 //x=29.885 //y=0.72 //x2=30.285 //y2=0.72
r61 (  13 35 ) resistor r=0.751729 //w=0.17 //l=0.085 //layer=li \
 //thickness=0.1 //x=30.685 //y=0.72 //x2=30.77 //y2=0.72
r62 (  13 35 ) resistor r=27.3797 //w=0.187 //l=0.4 //layer=li //thickness=0.1 \
 //x=30.685 //y=0.72 //x2=30.285 //y2=0.72
r63 (  10 35 ) resistor r=1.40859 //w=0.34 //l=0.125 //layer=li \
 //thickness=0.1 //x=29.8 //y=1.685 //x2=29.8 //y2=1.81
r64 (  10 35 ) resistor r=42.0963 //w=0.187 //l=0.615 //layer=li \
 //thickness=0.1 //x=29.8 //y=1.685 //x2=29.8 //y2=1.07
r65 (  9 35 ) resistor r=3.57586 //w=0.17 //l=0.125 //layer=li //thickness=0.1 \
 //x=29.8 //y=0.805 //x2=29.8 //y2=0.68
r66 (  9 35 ) resistor r=18.139 //w=0.187 //l=0.265 //layer=li //thickness=0.1 \
 //x=29.8 //y=0.805 //x2=29.8 //y2=1.07
r67 (  6 35 ) resistor r=3.57586 //w=0.17 //l=0.103078 //layer=li \
 //thickness=0.1 //x=28.915 //y=1.77 //x2=28.83 //y2=1.81
r68 (  6 35 ) resistor r=27.3797 //w=0.187 //l=0.4 //layer=li //thickness=0.1 \
 //x=28.915 //y=1.77 //x2=29.315 //y2=1.77
r69 (  5 35 ) resistor r=5.4201 //w=0.17 //l=0.103078 //layer=li \
 //thickness=0.1 //x=29.715 //y=1.77 //x2=29.8 //y2=1.81
r70 (  5 35 ) resistor r=27.3797 //w=0.187 //l=0.4 //layer=li //thickness=0.1 \
 //x=29.715 //y=1.77 //x2=29.315 //y2=1.77
r71 (  1 35 ) resistor r=3.57586 //w=0.17 //l=0.125 //layer=li //thickness=0.1 \
 //x=28.83 //y=1.685 //x2=28.83 //y2=1.81
r72 (  1 35 ) resistor r=42.0963 //w=0.187 //l=0.615 //layer=li \
 //thickness=0.1 //x=28.83 //y=1.685 //x2=28.83 //y2=1.07
ends PM_TMRDFFSNQNX1\%noxref_37

subckt PM_TMRDFFSNQNX1\%noxref_38 ( 1 3 11 15 25 28 29 )
c52 ( 29 0 ) capacitor c=0.0414739f //x=31.205 //y=0.555
c53 ( 28 0 ) capacitor c=0.0045748f //x=30.1 //y=1.09
c54 ( 25 0 ) capacitor c=0.00156479f //x=31.34 //y=1.175
c55 ( 15 0 ) capacitor c=0.00737666f //x=32.31 //y=0.805
c56 ( 11 0 ) capacitor c=0.0144274f //x=32.225 //y=0.72
c57 ( 3 0 ) capacitor c=0.00718386f //x=31.34 //y=0.805
c58 ( 1 0 ) capacitor c=0.0218888f //x=31.255 //y=1.175
r59 (  15 29 ) resistor r=3.57586 //w=0.17 //l=0.125 //layer=li \
 //thickness=0.1 //x=32.31 //y=0.805 //x2=32.31 //y2=0.68
r60 (  15 29 ) resistor r=18.139 //w=0.187 //l=0.265 //layer=li \
 //thickness=0.1 //x=32.31 //y=0.805 //x2=32.31 //y2=1.07
r61 (  12 29 ) resistor r=3.57586 //w=0.17 //l=0.103078 //layer=li \
 //thickness=0.1 //x=31.425 //y=0.72 //x2=31.34 //y2=0.68
r62 (  12 29 ) resistor r=27.3797 //w=0.187 //l=0.4 //layer=li //thickness=0.1 \
 //x=31.425 //y=0.72 //x2=31.825 //y2=0.72
r63 (  11 29 ) resistor r=3.57586 //w=0.17 //l=0.103078 //layer=li \
 //thickness=0.1 //x=32.225 //y=0.72 //x2=32.31 //y2=0.68
r64 (  11 29 ) resistor r=27.3797 //w=0.187 //l=0.4 //layer=li //thickness=0.1 \
 //x=32.225 //y=0.72 //x2=31.825 //y2=0.72
r65 (  7 25 ) resistor r=5.4201 //w=0.17 //l=0.085 //layer=li //thickness=0.1 \
 //x=31.34 //y=1.26 //x2=31.34 //y2=1.175
r66 (  7 29 ) resistor r=10.2674 //w=0.187 //l=0.15 //layer=li //thickness=0.1 \
 //x=31.34 //y=1.26 //x2=31.34 //y2=1.41
r67 (  4 25 ) resistor r=5.4201 //w=0.17 //l=0.085 //layer=li //thickness=0.1 \
 //x=31.34 //y=1.09 //x2=31.34 //y2=1.175
r68 (  4 29 ) resistor r=1.36898 //w=0.187 //l=0.02 //layer=li //thickness=0.1 \
 //x=31.34 //y=1.09 //x2=31.34 //y2=1.07
r69 (  3 29 ) resistor r=3.57586 //w=0.17 //l=0.125 //layer=li //thickness=0.1 \
 //x=31.34 //y=0.805 //x2=31.34 //y2=0.68
r70 (  3 29 ) resistor r=18.139 //w=0.187 //l=0.265 //layer=li //thickness=0.1 \
 //x=31.34 //y=0.805 //x2=31.34 //y2=1.07
r71 (  2 28 ) resistor r=0.751729 //w=0.17 //l=0.085 //layer=li \
 //thickness=0.1 //x=30.375 //y=1.175 //x2=30.29 //y2=1.175
r72 (  1 25 ) resistor r=1.40859 //w=0.34 //l=0.085 //layer=li //thickness=0.1 \
 //x=31.255 //y=1.175 //x2=31.34 //y2=1.175
r73 (  1 2 ) resistor r=60.2353 //w=0.187 //l=0.88 //layer=li //thickness=0.1 \
 //x=31.255 //y=1.175 //x2=30.375 //y2=1.175
ends PM_TMRDFFSNQNX1\%noxref_38

subckt PM_TMRDFFSNQNX1\%noxref_39 ( 1 5 9 13 17 35 )
c52 ( 35 0 ) capacitor c=0.0673029f //x=33.505 //y=0.555
c53 ( 17 0 ) capacitor c=0.0178286f //x=35.495 //y=1.77
c54 ( 13 0 ) capacitor c=0.0154917f //x=35.495 //y=0.72
c55 ( 9 0 ) capacitor c=0.00678203f //x=34.61 //y=0.805
c56 ( 5 0 ) capacitor c=0.0164013f //x=34.525 //y=1.77
c57 ( 1 0 ) capacitor c=0.00696517f //x=33.64 //y=1.685
r58 (  18 35 ) resistor r=5.4201 //w=0.17 //l=0.103078 //layer=li \
 //thickness=0.1 //x=34.695 //y=1.77 //x2=34.61 //y2=1.81
r59 (  18 35 ) resistor r=27.3797 //w=0.187 //l=0.4 //layer=li //thickness=0.1 \
 //x=34.695 //y=1.77 //x2=35.095 //y2=1.77
r60 (  17 35 ) resistor r=0.751729 //w=0.17 //l=0.085 //layer=li \
 //thickness=0.1 //x=35.495 //y=1.77 //x2=35.58 //y2=1.77
r61 (  17 35 ) resistor r=27.3797 //w=0.187 //l=0.4 //layer=li //thickness=0.1 \
 //x=35.495 //y=1.77 //x2=35.095 //y2=1.77
r62 (  14 35 ) resistor r=3.57586 //w=0.17 //l=0.103078 //layer=li \
 //thickness=0.1 //x=34.695 //y=0.72 //x2=34.61 //y2=0.68
r63 (  14 35 ) resistor r=27.3797 //w=0.187 //l=0.4 //layer=li //thickness=0.1 \
 //x=34.695 //y=0.72 //x2=35.095 //y2=0.72
r64 (  13 35 ) resistor r=0.751729 //w=0.17 //l=0.085 //layer=li \
 //thickness=0.1 //x=35.495 //y=0.72 //x2=35.58 //y2=0.72
r65 (  13 35 ) resistor r=27.3797 //w=0.187 //l=0.4 //layer=li //thickness=0.1 \
 //x=35.495 //y=0.72 //x2=35.095 //y2=0.72
r66 (  10 35 ) resistor r=1.40859 //w=0.34 //l=0.125 //layer=li \
 //thickness=0.1 //x=34.61 //y=1.685 //x2=34.61 //y2=1.81
r67 (  10 35 ) resistor r=42.0963 //w=0.187 //l=0.615 //layer=li \
 //thickness=0.1 //x=34.61 //y=1.685 //x2=34.61 //y2=1.07
r68 (  9 35 ) resistor r=3.57586 //w=0.17 //l=0.125 //layer=li //thickness=0.1 \
 //x=34.61 //y=0.805 //x2=34.61 //y2=0.68
r69 (  9 35 ) resistor r=18.139 //w=0.187 //l=0.265 //layer=li //thickness=0.1 \
 //x=34.61 //y=0.805 //x2=34.61 //y2=1.07
r70 (  6 35 ) resistor r=3.57586 //w=0.17 //l=0.103078 //layer=li \
 //thickness=0.1 //x=33.725 //y=1.77 //x2=33.64 //y2=1.81
r71 (  6 35 ) resistor r=27.3797 //w=0.187 //l=0.4 //layer=li //thickness=0.1 \
 //x=33.725 //y=1.77 //x2=34.125 //y2=1.77
r72 (  5 35 ) resistor r=5.4201 //w=0.17 //l=0.103078 //layer=li \
 //thickness=0.1 //x=34.525 //y=1.77 //x2=34.61 //y2=1.81
r73 (  5 35 ) resistor r=27.3797 //w=0.187 //l=0.4 //layer=li //thickness=0.1 \
 //x=34.525 //y=1.77 //x2=34.125 //y2=1.77
r74 (  1 35 ) resistor r=3.57586 //w=0.17 //l=0.125 //layer=li //thickness=0.1 \
 //x=33.64 //y=1.685 //x2=33.64 //y2=1.81
r75 (  1 35 ) resistor r=42.0963 //w=0.187 //l=0.615 //layer=li \
 //thickness=0.1 //x=33.64 //y=1.685 //x2=33.64 //y2=1.07
ends PM_TMRDFFSNQNX1\%noxref_39

subckt PM_TMRDFFSNQNX1\%noxref_40 ( 1 3 11 15 25 28 29 )
c52 ( 29 0 ) capacitor c=0.0414744f //x=36.015 //y=0.555
c53 ( 28 0 ) capacitor c=0.00457437f //x=34.91 //y=1.09
c54 ( 25 0 ) capacitor c=0.00156479f //x=36.15 //y=1.175
c55 ( 15 0 ) capacitor c=0.00737666f //x=37.12 //y=0.805
c56 ( 11 0 ) capacitor c=0.0144274f //x=37.035 //y=0.72
c57 ( 3 0 ) capacitor c=0.00718386f //x=36.15 //y=0.805
c58 ( 1 0 ) capacitor c=0.0218873f //x=36.065 //y=1.175
r59 (  15 29 ) resistor r=3.57586 //w=0.17 //l=0.125 //layer=li \
 //thickness=0.1 //x=37.12 //y=0.805 //x2=37.12 //y2=0.68
r60 (  15 29 ) resistor r=18.139 //w=0.187 //l=0.265 //layer=li \
 //thickness=0.1 //x=37.12 //y=0.805 //x2=37.12 //y2=1.07
r61 (  12 29 ) resistor r=3.57586 //w=0.17 //l=0.103078 //layer=li \
 //thickness=0.1 //x=36.235 //y=0.72 //x2=36.15 //y2=0.68
r62 (  12 29 ) resistor r=27.3797 //w=0.187 //l=0.4 //layer=li //thickness=0.1 \
 //x=36.235 //y=0.72 //x2=36.635 //y2=0.72
r63 (  11 29 ) resistor r=3.57586 //w=0.17 //l=0.103078 //layer=li \
 //thickness=0.1 //x=37.035 //y=0.72 //x2=37.12 //y2=0.68
r64 (  11 29 ) resistor r=27.3797 //w=0.187 //l=0.4 //layer=li //thickness=0.1 \
 //x=37.035 //y=0.72 //x2=36.635 //y2=0.72
r65 (  7 25 ) resistor r=5.4201 //w=0.17 //l=0.085 //layer=li //thickness=0.1 \
 //x=36.15 //y=1.26 //x2=36.15 //y2=1.175
r66 (  7 29 ) resistor r=10.2674 //w=0.187 //l=0.15 //layer=li //thickness=0.1 \
 //x=36.15 //y=1.26 //x2=36.15 //y2=1.41
r67 (  4 25 ) resistor r=5.4201 //w=0.17 //l=0.085 //layer=li //thickness=0.1 \
 //x=36.15 //y=1.09 //x2=36.15 //y2=1.175
r68 (  4 29 ) resistor r=1.36898 //w=0.187 //l=0.02 //layer=li //thickness=0.1 \
 //x=36.15 //y=1.09 //x2=36.15 //y2=1.07
r69 (  3 29 ) resistor r=3.57586 //w=0.17 //l=0.125 //layer=li //thickness=0.1 \
 //x=36.15 //y=0.805 //x2=36.15 //y2=0.68
r70 (  3 29 ) resistor r=18.139 //w=0.187 //l=0.265 //layer=li //thickness=0.1 \
 //x=36.15 //y=0.805 //x2=36.15 //y2=1.07
r71 (  2 28 ) resistor r=0.751729 //w=0.17 //l=0.085 //layer=li \
 //thickness=0.1 //x=35.185 //y=1.175 //x2=35.1 //y2=1.175
r72 (  1 25 ) resistor r=1.40859 //w=0.34 //l=0.085 //layer=li //thickness=0.1 \
 //x=36.065 //y=1.175 //x2=36.15 //y2=1.175
r73 (  1 2 ) resistor r=60.2353 //w=0.187 //l=0.88 //layer=li //thickness=0.1 \
 //x=36.065 //y=1.175 //x2=35.185 //y2=1.175
ends PM_TMRDFFSNQNX1\%noxref_40

subckt PM_TMRDFFSNQNX1\%noxref_41 ( 1 5 9 10 13 17 29 )
c51 ( 29 0 ) capacitor c=0.0632682f //x=38.42 //y=0.545
c52 ( 17 0 ) capacitor c=0.00722223f //x=40.495 //y=0.795
c53 ( 13 0 ) capacitor c=0.0145084f //x=40.41 //y=0.71
c54 ( 10 0 ) capacitor c=0.00582081f //x=39.525 //y=1.675
c55 ( 9 0 ) capacitor c=0.006761f //x=39.525 //y=0.795
c56 ( 5 0 ) capacitor c=0.0173046f //x=39.44 //y=1.76
c57 ( 1 0 ) capacitor c=0.00733328f //x=38.555 //y=1.675
r58 (  17 29 ) resistor r=3.57586 //w=0.17 //l=0.125 //layer=li \
 //thickness=0.1 //x=40.495 //y=0.795 //x2=40.495 //y2=0.67
r59 (  17 29 ) resistor r=18.139 //w=0.187 //l=0.265 //layer=li \
 //thickness=0.1 //x=40.495 //y=0.795 //x2=40.495 //y2=1.06
r60 (  14 29 ) resistor r=3.57586 //w=0.17 //l=0.103078 //layer=li \
 //thickness=0.1 //x=39.61 //y=0.71 //x2=39.525 //y2=0.67
r61 (  14 29 ) resistor r=27.3797 //w=0.187 //l=0.4 //layer=li //thickness=0.1 \
 //x=39.61 //y=0.71 //x2=40.01 //y2=0.71
r62 (  13 29 ) resistor r=3.57586 //w=0.17 //l=0.103078 //layer=li \
 //thickness=0.1 //x=40.41 //y=0.71 //x2=40.495 //y2=0.67
r63 (  13 29 ) resistor r=27.3797 //w=0.187 //l=0.4 //layer=li //thickness=0.1 \
 //x=40.41 //y=0.71 //x2=40.01 //y2=0.71
r64 (  10 29 ) resistor r=3.57586 //w=0.17 //l=0.125 //layer=li \
 //thickness=0.1 //x=39.525 //y=1.675 //x2=39.525 //y2=1.8
r65 (  10 29 ) resistor r=42.0963 //w=0.187 //l=0.615 //layer=li \
 //thickness=0.1 //x=39.525 //y=1.675 //x2=39.525 //y2=1.06
r66 (  9 29 ) resistor r=3.57586 //w=0.17 //l=0.125 //layer=li //thickness=0.1 \
 //x=39.525 //y=0.795 //x2=39.525 //y2=0.67
r67 (  9 29 ) resistor r=18.139 //w=0.187 //l=0.265 //layer=li //thickness=0.1 \
 //x=39.525 //y=0.795 //x2=39.525 //y2=1.06
r68 (  6 29 ) resistor r=3.57586 //w=0.17 //l=0.103078 //layer=li \
 //thickness=0.1 //x=38.64 //y=1.76 //x2=38.555 //y2=1.8
r69 (  6 29 ) resistor r=27.3797 //w=0.187 //l=0.4 //layer=li //thickness=0.1 \
 //x=38.64 //y=1.76 //x2=39.04 //y2=1.76
r70 (  5 29 ) resistor r=3.57586 //w=0.17 //l=0.103078 //layer=li \
 //thickness=0.1 //x=39.44 //y=1.76 //x2=39.525 //y2=1.8
r71 (  5 29 ) resistor r=27.3797 //w=0.187 //l=0.4 //layer=li //thickness=0.1 \
 //x=39.44 //y=1.76 //x2=39.04 //y2=1.76
r72 (  1 29 ) resistor r=3.57586 //w=0.17 //l=0.125 //layer=li //thickness=0.1 \
 //x=38.555 //y=1.675 //x2=38.555 //y2=1.8
r73 (  1 29 ) resistor r=42.0963 //w=0.187 //l=0.615 //layer=li \
 //thickness=0.1 //x=38.555 //y=1.675 //x2=38.555 //y2=1.06
ends PM_TMRDFFSNQNX1\%noxref_41

subckt PM_TMRDFFSNQNX1\%noxref_42 ( 1 5 9 10 13 17 29 )
c51 ( 29 0 ) capacitor c=0.063352f //x=41.75 //y=0.545
c52 ( 17 0 ) capacitor c=0.0072343f //x=43.825 //y=0.795
c53 ( 13 0 ) capacitor c=0.0145084f //x=43.74 //y=0.71
c54 ( 10 0 ) capacitor c=0.00582081f //x=42.855 //y=1.675
c55 ( 9 0 ) capacitor c=0.006761f //x=42.855 //y=0.795
c56 ( 5 0 ) capacitor c=0.0173046f //x=42.77 //y=1.76
c57 ( 1 0 ) capacitor c=0.00733328f //x=41.885 //y=1.675
r58 (  17 29 ) resistor r=3.57586 //w=0.17 //l=0.125 //layer=li \
 //thickness=0.1 //x=43.825 //y=0.795 //x2=43.825 //y2=0.67
r59 (  17 29 ) resistor r=18.139 //w=0.187 //l=0.265 //layer=li \
 //thickness=0.1 //x=43.825 //y=0.795 //x2=43.825 //y2=1.06
r60 (  14 29 ) resistor r=3.57586 //w=0.17 //l=0.103078 //layer=li \
 //thickness=0.1 //x=42.94 //y=0.71 //x2=42.855 //y2=0.67
r61 (  14 29 ) resistor r=27.3797 //w=0.187 //l=0.4 //layer=li //thickness=0.1 \
 //x=42.94 //y=0.71 //x2=43.34 //y2=0.71
r62 (  13 29 ) resistor r=3.57586 //w=0.17 //l=0.103078 //layer=li \
 //thickness=0.1 //x=43.74 //y=0.71 //x2=43.825 //y2=0.67
r63 (  13 29 ) resistor r=27.3797 //w=0.187 //l=0.4 //layer=li //thickness=0.1 \
 //x=43.74 //y=0.71 //x2=43.34 //y2=0.71
r64 (  10 29 ) resistor r=3.57586 //w=0.17 //l=0.125 //layer=li \
 //thickness=0.1 //x=42.855 //y=1.675 //x2=42.855 //y2=1.8
r65 (  10 29 ) resistor r=42.0963 //w=0.187 //l=0.615 //layer=li \
 //thickness=0.1 //x=42.855 //y=1.675 //x2=42.855 //y2=1.06
r66 (  9 29 ) resistor r=3.57586 //w=0.17 //l=0.125 //layer=li //thickness=0.1 \
 //x=42.855 //y=0.795 //x2=42.855 //y2=0.67
r67 (  9 29 ) resistor r=18.139 //w=0.187 //l=0.265 //layer=li //thickness=0.1 \
 //x=42.855 //y=0.795 //x2=42.855 //y2=1.06
r68 (  6 29 ) resistor r=3.57586 //w=0.17 //l=0.103078 //layer=li \
 //thickness=0.1 //x=41.97 //y=1.76 //x2=41.885 //y2=1.8
r69 (  6 29 ) resistor r=27.3797 //w=0.187 //l=0.4 //layer=li //thickness=0.1 \
 //x=41.97 //y=1.76 //x2=42.37 //y2=1.76
r70 (  5 29 ) resistor r=3.57586 //w=0.17 //l=0.103078 //layer=li \
 //thickness=0.1 //x=42.77 //y=1.76 //x2=42.855 //y2=1.8
r71 (  5 29 ) resistor r=27.3797 //w=0.187 //l=0.4 //layer=li //thickness=0.1 \
 //x=42.77 //y=1.76 //x2=42.37 //y2=1.76
r72 (  1 29 ) resistor r=3.57586 //w=0.17 //l=0.125 //layer=li //thickness=0.1 \
 //x=41.885 //y=1.675 //x2=41.885 //y2=1.8
r73 (  1 29 ) resistor r=42.0963 //w=0.187 //l=0.615 //layer=li \
 //thickness=0.1 //x=41.885 //y=1.675 //x2=41.885 //y2=1.06
ends PM_TMRDFFSNQNX1\%noxref_42

subckt PM_TMRDFFSNQNX1\%noxref_43 ( 1 5 9 13 17 35 )
c52 ( 35 0 ) capacitor c=0.0673029f //x=44.975 //y=0.555
c53 ( 17 0 ) capacitor c=0.0178286f //x=46.965 //y=1.77
c54 ( 13 0 ) capacitor c=0.0154917f //x=46.965 //y=0.72
c55 ( 9 0 ) capacitor c=0.00678203f //x=46.08 //y=0.805
c56 ( 5 0 ) capacitor c=0.0164013f //x=45.995 //y=1.77
c57 ( 1 0 ) capacitor c=0.00696517f //x=45.11 //y=1.685
r58 (  18 35 ) resistor r=5.4201 //w=0.17 //l=0.103078 //layer=li \
 //thickness=0.1 //x=46.165 //y=1.77 //x2=46.08 //y2=1.81
r59 (  18 35 ) resistor r=27.3797 //w=0.187 //l=0.4 //layer=li //thickness=0.1 \
 //x=46.165 //y=1.77 //x2=46.565 //y2=1.77
r60 (  17 35 ) resistor r=0.751729 //w=0.17 //l=0.085 //layer=li \
 //thickness=0.1 //x=46.965 //y=1.77 //x2=47.05 //y2=1.77
r61 (  17 35 ) resistor r=27.3797 //w=0.187 //l=0.4 //layer=li //thickness=0.1 \
 //x=46.965 //y=1.77 //x2=46.565 //y2=1.77
r62 (  14 35 ) resistor r=3.57586 //w=0.17 //l=0.103078 //layer=li \
 //thickness=0.1 //x=46.165 //y=0.72 //x2=46.08 //y2=0.68
r63 (  14 35 ) resistor r=27.3797 //w=0.187 //l=0.4 //layer=li //thickness=0.1 \
 //x=46.165 //y=0.72 //x2=46.565 //y2=0.72
r64 (  13 35 ) resistor r=0.751729 //w=0.17 //l=0.085 //layer=li \
 //thickness=0.1 //x=46.965 //y=0.72 //x2=47.05 //y2=0.72
r65 (  13 35 ) resistor r=27.3797 //w=0.187 //l=0.4 //layer=li //thickness=0.1 \
 //x=46.965 //y=0.72 //x2=46.565 //y2=0.72
r66 (  10 35 ) resistor r=1.40859 //w=0.34 //l=0.125 //layer=li \
 //thickness=0.1 //x=46.08 //y=1.685 //x2=46.08 //y2=1.81
r67 (  10 35 ) resistor r=42.0963 //w=0.187 //l=0.615 //layer=li \
 //thickness=0.1 //x=46.08 //y=1.685 //x2=46.08 //y2=1.07
r68 (  9 35 ) resistor r=3.57586 //w=0.17 //l=0.125 //layer=li //thickness=0.1 \
 //x=46.08 //y=0.805 //x2=46.08 //y2=0.68
r69 (  9 35 ) resistor r=18.139 //w=0.187 //l=0.265 //layer=li //thickness=0.1 \
 //x=46.08 //y=0.805 //x2=46.08 //y2=1.07
r70 (  6 35 ) resistor r=3.57586 //w=0.17 //l=0.103078 //layer=li \
 //thickness=0.1 //x=45.195 //y=1.77 //x2=45.11 //y2=1.81
r71 (  6 35 ) resistor r=27.3797 //w=0.187 //l=0.4 //layer=li //thickness=0.1 \
 //x=45.195 //y=1.77 //x2=45.595 //y2=1.77
r72 (  5 35 ) resistor r=5.4201 //w=0.17 //l=0.103078 //layer=li \
 //thickness=0.1 //x=45.995 //y=1.77 //x2=46.08 //y2=1.81
r73 (  5 35 ) resistor r=27.3797 //w=0.187 //l=0.4 //layer=li //thickness=0.1 \
 //x=45.995 //y=1.77 //x2=45.595 //y2=1.77
r74 (  1 35 ) resistor r=3.57586 //w=0.17 //l=0.125 //layer=li //thickness=0.1 \
 //x=45.11 //y=1.685 //x2=45.11 //y2=1.81
r75 (  1 35 ) resistor r=42.0963 //w=0.187 //l=0.615 //layer=li \
 //thickness=0.1 //x=45.11 //y=1.685 //x2=45.11 //y2=1.07
ends PM_TMRDFFSNQNX1\%noxref_43

subckt PM_TMRDFFSNQNX1\%noxref_44 ( 1 3 11 15 25 28 29 )
c52 ( 29 0 ) capacitor c=0.0413887f //x=47.485 //y=0.555
c53 ( 28 0 ) capacitor c=0.00457437f //x=46.38 //y=1.09
c54 ( 25 0 ) capacitor c=0.00156479f //x=47.62 //y=1.175
c55 ( 15 0 ) capacitor c=0.00737666f //x=48.59 //y=0.805
c56 ( 11 0 ) capacitor c=0.0144274f //x=48.505 //y=0.72
c57 ( 3 0 ) capacitor c=0.00718386f //x=47.62 //y=0.805
c58 ( 1 0 ) capacitor c=0.0218873f //x=47.535 //y=1.175
r59 (  15 29 ) resistor r=3.57586 //w=0.17 //l=0.125 //layer=li \
 //thickness=0.1 //x=48.59 //y=0.805 //x2=48.59 //y2=0.68
r60 (  15 29 ) resistor r=18.139 //w=0.187 //l=0.265 //layer=li \
 //thickness=0.1 //x=48.59 //y=0.805 //x2=48.59 //y2=1.07
r61 (  12 29 ) resistor r=3.57586 //w=0.17 //l=0.103078 //layer=li \
 //thickness=0.1 //x=47.705 //y=0.72 //x2=47.62 //y2=0.68
r62 (  12 29 ) resistor r=27.3797 //w=0.187 //l=0.4 //layer=li //thickness=0.1 \
 //x=47.705 //y=0.72 //x2=48.105 //y2=0.72
r63 (  11 29 ) resistor r=3.57586 //w=0.17 //l=0.103078 //layer=li \
 //thickness=0.1 //x=48.505 //y=0.72 //x2=48.59 //y2=0.68
r64 (  11 29 ) resistor r=27.3797 //w=0.187 //l=0.4 //layer=li //thickness=0.1 \
 //x=48.505 //y=0.72 //x2=48.105 //y2=0.72
r65 (  7 25 ) resistor r=5.4201 //w=0.17 //l=0.085 //layer=li //thickness=0.1 \
 //x=47.62 //y=1.26 //x2=47.62 //y2=1.175
r66 (  7 29 ) resistor r=10.2674 //w=0.187 //l=0.15 //layer=li //thickness=0.1 \
 //x=47.62 //y=1.26 //x2=47.62 //y2=1.41
r67 (  4 25 ) resistor r=5.4201 //w=0.17 //l=0.085 //layer=li //thickness=0.1 \
 //x=47.62 //y=1.09 //x2=47.62 //y2=1.175
r68 (  4 29 ) resistor r=1.36898 //w=0.187 //l=0.02 //layer=li //thickness=0.1 \
 //x=47.62 //y=1.09 //x2=47.62 //y2=1.07
r69 (  3 29 ) resistor r=3.57586 //w=0.17 //l=0.125 //layer=li //thickness=0.1 \
 //x=47.62 //y=0.805 //x2=47.62 //y2=0.68
r70 (  3 29 ) resistor r=18.139 //w=0.187 //l=0.265 //layer=li //thickness=0.1 \
 //x=47.62 //y=0.805 //x2=47.62 //y2=1.07
r71 (  2 28 ) resistor r=0.751729 //w=0.17 //l=0.085 //layer=li \
 //thickness=0.1 //x=46.655 //y=1.175 //x2=46.57 //y2=1.175
r72 (  1 25 ) resistor r=1.40859 //w=0.34 //l=0.085 //layer=li //thickness=0.1 \
 //x=47.535 //y=1.175 //x2=47.62 //y2=1.175
r73 (  1 2 ) resistor r=60.2353 //w=0.187 //l=0.88 //layer=li //thickness=0.1 \
 //x=47.535 //y=1.175 //x2=46.655 //y2=1.175
ends PM_TMRDFFSNQNX1\%noxref_44

subckt PM_TMRDFFSNQNX1\%noxref_45 ( 1 5 9 10 13 17 29 )
c51 ( 29 0 ) capacitor c=0.0633518f //x=49.89 //y=0.545
c52 ( 17 0 ) capacitor c=0.0072343f //x=51.965 //y=0.795
c53 ( 13 0 ) capacitor c=0.0145084f //x=51.88 //y=0.71
c54 ( 10 0 ) capacitor c=0.00582081f //x=50.995 //y=1.675
c55 ( 9 0 ) capacitor c=0.006761f //x=50.995 //y=0.795
c56 ( 5 0 ) capacitor c=0.0173046f //x=50.91 //y=1.76
c57 ( 1 0 ) capacitor c=0.00733328f //x=50.025 //y=1.675
r58 (  17 29 ) resistor r=3.57586 //w=0.17 //l=0.125 //layer=li \
 //thickness=0.1 //x=51.965 //y=0.795 //x2=51.965 //y2=0.67
r59 (  17 29 ) resistor r=18.139 //w=0.187 //l=0.265 //layer=li \
 //thickness=0.1 //x=51.965 //y=0.795 //x2=51.965 //y2=1.06
r60 (  14 29 ) resistor r=3.57586 //w=0.17 //l=0.103078 //layer=li \
 //thickness=0.1 //x=51.08 //y=0.71 //x2=50.995 //y2=0.67
r61 (  14 29 ) resistor r=27.3797 //w=0.187 //l=0.4 //layer=li //thickness=0.1 \
 //x=51.08 //y=0.71 //x2=51.48 //y2=0.71
r62 (  13 29 ) resistor r=3.57586 //w=0.17 //l=0.103078 //layer=li \
 //thickness=0.1 //x=51.88 //y=0.71 //x2=51.965 //y2=0.67
r63 (  13 29 ) resistor r=27.3797 //w=0.187 //l=0.4 //layer=li //thickness=0.1 \
 //x=51.88 //y=0.71 //x2=51.48 //y2=0.71
r64 (  10 29 ) resistor r=3.57586 //w=0.17 //l=0.125 //layer=li \
 //thickness=0.1 //x=50.995 //y=1.675 //x2=50.995 //y2=1.8
r65 (  10 29 ) resistor r=42.0963 //w=0.187 //l=0.615 //layer=li \
 //thickness=0.1 //x=50.995 //y=1.675 //x2=50.995 //y2=1.06
r66 (  9 29 ) resistor r=3.57586 //w=0.17 //l=0.125 //layer=li //thickness=0.1 \
 //x=50.995 //y=0.795 //x2=50.995 //y2=0.67
r67 (  9 29 ) resistor r=18.139 //w=0.187 //l=0.265 //layer=li //thickness=0.1 \
 //x=50.995 //y=0.795 //x2=50.995 //y2=1.06
r68 (  6 29 ) resistor r=3.57586 //w=0.17 //l=0.103078 //layer=li \
 //thickness=0.1 //x=50.11 //y=1.76 //x2=50.025 //y2=1.8
r69 (  6 29 ) resistor r=27.3797 //w=0.187 //l=0.4 //layer=li //thickness=0.1 \
 //x=50.11 //y=1.76 //x2=50.51 //y2=1.76
r70 (  5 29 ) resistor r=3.57586 //w=0.17 //l=0.103078 //layer=li \
 //thickness=0.1 //x=50.91 //y=1.76 //x2=50.995 //y2=1.8
r71 (  5 29 ) resistor r=27.3797 //w=0.187 //l=0.4 //layer=li //thickness=0.1 \
 //x=50.91 //y=1.76 //x2=50.51 //y2=1.76
r72 (  1 29 ) resistor r=3.57586 //w=0.17 //l=0.125 //layer=li //thickness=0.1 \
 //x=50.025 //y=1.675 //x2=50.025 //y2=1.8
r73 (  1 29 ) resistor r=42.0963 //w=0.187 //l=0.615 //layer=li \
 //thickness=0.1 //x=50.025 //y=1.675 //x2=50.025 //y2=1.06
ends PM_TMRDFFSNQNX1\%noxref_45

subckt PM_TMRDFFSNQNX1\%noxref_46 ( 1 5 9 13 17 35 )
c49 ( 35 0 ) capacitor c=0.0673195f //x=53.115 //y=0.555
c50 ( 17 0 ) capacitor c=0.0178317f //x=55.105 //y=1.77
c51 ( 13 0 ) capacitor c=0.0154936f //x=55.105 //y=0.72
c52 ( 9 0 ) capacitor c=0.00678203f //x=54.22 //y=0.805
c53 ( 5 0 ) capacitor c=0.0164013f //x=54.135 //y=1.77
c54 ( 1 0 ) capacitor c=0.00696517f //x=53.25 //y=1.685
r55 (  18 35 ) resistor r=5.4201 //w=0.17 //l=0.103078 //layer=li \
 //thickness=0.1 //x=54.305 //y=1.77 //x2=54.22 //y2=1.81
r56 (  18 35 ) resistor r=27.3797 //w=0.187 //l=0.4 //layer=li //thickness=0.1 \
 //x=54.305 //y=1.77 //x2=54.705 //y2=1.77
r57 (  17 35 ) resistor r=0.751729 //w=0.17 //l=0.085 //layer=li \
 //thickness=0.1 //x=55.105 //y=1.77 //x2=55.19 //y2=1.77
r58 (  17 35 ) resistor r=27.3797 //w=0.187 //l=0.4 //layer=li //thickness=0.1 \
 //x=55.105 //y=1.77 //x2=54.705 //y2=1.77
r59 (  14 35 ) resistor r=3.57586 //w=0.17 //l=0.103078 //layer=li \
 //thickness=0.1 //x=54.305 //y=0.72 //x2=54.22 //y2=0.68
r60 (  14 35 ) resistor r=27.3797 //w=0.187 //l=0.4 //layer=li //thickness=0.1 \
 //x=54.305 //y=0.72 //x2=54.705 //y2=0.72
r61 (  13 35 ) resistor r=0.751729 //w=0.17 //l=0.085 //layer=li \
 //thickness=0.1 //x=55.105 //y=0.72 //x2=55.19 //y2=0.72
r62 (  13 35 ) resistor r=27.3797 //w=0.187 //l=0.4 //layer=li //thickness=0.1 \
 //x=55.105 //y=0.72 //x2=54.705 //y2=0.72
r63 (  10 35 ) resistor r=1.40859 //w=0.34 //l=0.125 //layer=li \
 //thickness=0.1 //x=54.22 //y=1.685 //x2=54.22 //y2=1.81
r64 (  10 35 ) resistor r=42.0963 //w=0.187 //l=0.615 //layer=li \
 //thickness=0.1 //x=54.22 //y=1.685 //x2=54.22 //y2=1.07
r65 (  9 35 ) resistor r=3.57586 //w=0.17 //l=0.125 //layer=li //thickness=0.1 \
 //x=54.22 //y=0.805 //x2=54.22 //y2=0.68
r66 (  9 35 ) resistor r=18.139 //w=0.187 //l=0.265 //layer=li //thickness=0.1 \
 //x=54.22 //y=0.805 //x2=54.22 //y2=1.07
r67 (  6 35 ) resistor r=3.57586 //w=0.17 //l=0.103078 //layer=li \
 //thickness=0.1 //x=53.335 //y=1.77 //x2=53.25 //y2=1.81
r68 (  6 35 ) resistor r=27.3797 //w=0.187 //l=0.4 //layer=li //thickness=0.1 \
 //x=53.335 //y=1.77 //x2=53.735 //y2=1.77
r69 (  5 35 ) resistor r=5.4201 //w=0.17 //l=0.103078 //layer=li \
 //thickness=0.1 //x=54.135 //y=1.77 //x2=54.22 //y2=1.81
r70 (  5 35 ) resistor r=27.3797 //w=0.187 //l=0.4 //layer=li //thickness=0.1 \
 //x=54.135 //y=1.77 //x2=53.735 //y2=1.77
r71 (  1 35 ) resistor r=3.57586 //w=0.17 //l=0.125 //layer=li //thickness=0.1 \
 //x=53.25 //y=1.685 //x2=53.25 //y2=1.81
r72 (  1 35 ) resistor r=42.0963 //w=0.187 //l=0.615 //layer=li \
 //thickness=0.1 //x=53.25 //y=1.685 //x2=53.25 //y2=1.07
ends PM_TMRDFFSNQNX1\%noxref_46

subckt PM_TMRDFFSNQNX1\%noxref_47 ( 1 3 11 15 25 28 29 )
c52 ( 29 0 ) capacitor c=0.0414739f //x=55.625 //y=0.555
c53 ( 28 0 ) capacitor c=0.0045748f //x=54.52 //y=1.09
c54 ( 25 0 ) capacitor c=0.00156479f //x=55.76 //y=1.175
c55 ( 15 0 ) capacitor c=0.00737666f //x=56.73 //y=0.805
c56 ( 11 0 ) capacitor c=0.0144274f //x=56.645 //y=0.72
c57 ( 3 0 ) capacitor c=0.00718386f //x=55.76 //y=0.805
c58 ( 1 0 ) capacitor c=0.0218888f //x=55.675 //y=1.175
r59 (  15 29 ) resistor r=3.57586 //w=0.17 //l=0.125 //layer=li \
 //thickness=0.1 //x=56.73 //y=0.805 //x2=56.73 //y2=0.68
r60 (  15 29 ) resistor r=18.139 //w=0.187 //l=0.265 //layer=li \
 //thickness=0.1 //x=56.73 //y=0.805 //x2=56.73 //y2=1.07
r61 (  12 29 ) resistor r=3.57586 //w=0.17 //l=0.103078 //layer=li \
 //thickness=0.1 //x=55.845 //y=0.72 //x2=55.76 //y2=0.68
r62 (  12 29 ) resistor r=27.3797 //w=0.187 //l=0.4 //layer=li //thickness=0.1 \
 //x=55.845 //y=0.72 //x2=56.245 //y2=0.72
r63 (  11 29 ) resistor r=3.57586 //w=0.17 //l=0.103078 //layer=li \
 //thickness=0.1 //x=56.645 //y=0.72 //x2=56.73 //y2=0.68
r64 (  11 29 ) resistor r=27.3797 //w=0.187 //l=0.4 //layer=li //thickness=0.1 \
 //x=56.645 //y=0.72 //x2=56.245 //y2=0.72
r65 (  7 25 ) resistor r=5.4201 //w=0.17 //l=0.085 //layer=li //thickness=0.1 \
 //x=55.76 //y=1.26 //x2=55.76 //y2=1.175
r66 (  7 29 ) resistor r=10.2674 //w=0.187 //l=0.15 //layer=li //thickness=0.1 \
 //x=55.76 //y=1.26 //x2=55.76 //y2=1.41
r67 (  4 25 ) resistor r=5.4201 //w=0.17 //l=0.085 //layer=li //thickness=0.1 \
 //x=55.76 //y=1.09 //x2=55.76 //y2=1.175
r68 (  4 29 ) resistor r=1.36898 //w=0.187 //l=0.02 //layer=li //thickness=0.1 \
 //x=55.76 //y=1.09 //x2=55.76 //y2=1.07
r69 (  3 29 ) resistor r=3.57586 //w=0.17 //l=0.125 //layer=li //thickness=0.1 \
 //x=55.76 //y=0.805 //x2=55.76 //y2=0.68
r70 (  3 29 ) resistor r=18.139 //w=0.187 //l=0.265 //layer=li //thickness=0.1 \
 //x=55.76 //y=0.805 //x2=55.76 //y2=1.07
r71 (  2 28 ) resistor r=0.751729 //w=0.17 //l=0.085 //layer=li \
 //thickness=0.1 //x=54.795 //y=1.175 //x2=54.71 //y2=1.175
r72 (  1 25 ) resistor r=1.40859 //w=0.34 //l=0.085 //layer=li //thickness=0.1 \
 //x=55.675 //y=1.175 //x2=55.76 //y2=1.175
r73 (  1 2 ) resistor r=60.2353 //w=0.187 //l=0.88 //layer=li //thickness=0.1 \
 //x=55.675 //y=1.175 //x2=54.795 //y2=1.175
ends PM_TMRDFFSNQNX1\%noxref_47

subckt PM_TMRDFFSNQNX1\%noxref_48 ( 1 5 9 13 17 35 )
c52 ( 35 0 ) capacitor c=0.0673029f //x=57.925 //y=0.555
c53 ( 17 0 ) capacitor c=0.0178286f //x=59.915 //y=1.77
c54 ( 13 0 ) capacitor c=0.0154917f //x=59.915 //y=0.72
c55 ( 9 0 ) capacitor c=0.00678203f //x=59.03 //y=0.805
c56 ( 5 0 ) capacitor c=0.0164013f //x=58.945 //y=1.77
c57 ( 1 0 ) capacitor c=0.00696517f //x=58.06 //y=1.685
r58 (  18 35 ) resistor r=5.4201 //w=0.17 //l=0.103078 //layer=li \
 //thickness=0.1 //x=59.115 //y=1.77 //x2=59.03 //y2=1.81
r59 (  18 35 ) resistor r=27.3797 //w=0.187 //l=0.4 //layer=li //thickness=0.1 \
 //x=59.115 //y=1.77 //x2=59.515 //y2=1.77
r60 (  17 35 ) resistor r=0.751729 //w=0.17 //l=0.085 //layer=li \
 //thickness=0.1 //x=59.915 //y=1.77 //x2=60 //y2=1.77
r61 (  17 35 ) resistor r=27.3797 //w=0.187 //l=0.4 //layer=li //thickness=0.1 \
 //x=59.915 //y=1.77 //x2=59.515 //y2=1.77
r62 (  14 35 ) resistor r=3.57586 //w=0.17 //l=0.103078 //layer=li \
 //thickness=0.1 //x=59.115 //y=0.72 //x2=59.03 //y2=0.68
r63 (  14 35 ) resistor r=27.3797 //w=0.187 //l=0.4 //layer=li //thickness=0.1 \
 //x=59.115 //y=0.72 //x2=59.515 //y2=0.72
r64 (  13 35 ) resistor r=0.751729 //w=0.17 //l=0.085 //layer=li \
 //thickness=0.1 //x=59.915 //y=0.72 //x2=60 //y2=0.72
r65 (  13 35 ) resistor r=27.3797 //w=0.187 //l=0.4 //layer=li //thickness=0.1 \
 //x=59.915 //y=0.72 //x2=59.515 //y2=0.72
r66 (  10 35 ) resistor r=1.40859 //w=0.34 //l=0.125 //layer=li \
 //thickness=0.1 //x=59.03 //y=1.685 //x2=59.03 //y2=1.81
r67 (  10 35 ) resistor r=42.0963 //w=0.187 //l=0.615 //layer=li \
 //thickness=0.1 //x=59.03 //y=1.685 //x2=59.03 //y2=1.07
r68 (  9 35 ) resistor r=3.57586 //w=0.17 //l=0.125 //layer=li //thickness=0.1 \
 //x=59.03 //y=0.805 //x2=59.03 //y2=0.68
r69 (  9 35 ) resistor r=18.139 //w=0.187 //l=0.265 //layer=li //thickness=0.1 \
 //x=59.03 //y=0.805 //x2=59.03 //y2=1.07
r70 (  6 35 ) resistor r=3.57586 //w=0.17 //l=0.103078 //layer=li \
 //thickness=0.1 //x=58.145 //y=1.77 //x2=58.06 //y2=1.81
r71 (  6 35 ) resistor r=27.3797 //w=0.187 //l=0.4 //layer=li //thickness=0.1 \
 //x=58.145 //y=1.77 //x2=58.545 //y2=1.77
r72 (  5 35 ) resistor r=5.4201 //w=0.17 //l=0.103078 //layer=li \
 //thickness=0.1 //x=58.945 //y=1.77 //x2=59.03 //y2=1.81
r73 (  5 35 ) resistor r=27.3797 //w=0.187 //l=0.4 //layer=li //thickness=0.1 \
 //x=58.945 //y=1.77 //x2=58.545 //y2=1.77
r74 (  1 35 ) resistor r=3.57586 //w=0.17 //l=0.125 //layer=li //thickness=0.1 \
 //x=58.06 //y=1.685 //x2=58.06 //y2=1.81
r75 (  1 35 ) resistor r=42.0963 //w=0.187 //l=0.615 //layer=li \
 //thickness=0.1 //x=58.06 //y=1.685 //x2=58.06 //y2=1.07
ends PM_TMRDFFSNQNX1\%noxref_48

subckt PM_TMRDFFSNQNX1\%noxref_49 ( 1 3 11 15 25 28 29 )
c52 ( 29 0 ) capacitor c=0.0414744f //x=60.435 //y=0.555
c53 ( 28 0 ) capacitor c=0.00457437f //x=59.33 //y=1.09
c54 ( 25 0 ) capacitor c=0.00156479f //x=60.57 //y=1.175
c55 ( 15 0 ) capacitor c=0.00737666f //x=61.54 //y=0.805
c56 ( 11 0 ) capacitor c=0.0144274f //x=61.455 //y=0.72
c57 ( 3 0 ) capacitor c=0.00718386f //x=60.57 //y=0.805
c58 ( 1 0 ) capacitor c=0.0218873f //x=60.485 //y=1.175
r59 (  15 29 ) resistor r=3.57586 //w=0.17 //l=0.125 //layer=li \
 //thickness=0.1 //x=61.54 //y=0.805 //x2=61.54 //y2=0.68
r60 (  15 29 ) resistor r=18.139 //w=0.187 //l=0.265 //layer=li \
 //thickness=0.1 //x=61.54 //y=0.805 //x2=61.54 //y2=1.07
r61 (  12 29 ) resistor r=3.57586 //w=0.17 //l=0.103078 //layer=li \
 //thickness=0.1 //x=60.655 //y=0.72 //x2=60.57 //y2=0.68
r62 (  12 29 ) resistor r=27.3797 //w=0.187 //l=0.4 //layer=li //thickness=0.1 \
 //x=60.655 //y=0.72 //x2=61.055 //y2=0.72
r63 (  11 29 ) resistor r=3.57586 //w=0.17 //l=0.103078 //layer=li \
 //thickness=0.1 //x=61.455 //y=0.72 //x2=61.54 //y2=0.68
r64 (  11 29 ) resistor r=27.3797 //w=0.187 //l=0.4 //layer=li //thickness=0.1 \
 //x=61.455 //y=0.72 //x2=61.055 //y2=0.72
r65 (  7 25 ) resistor r=5.4201 //w=0.17 //l=0.085 //layer=li //thickness=0.1 \
 //x=60.57 //y=1.26 //x2=60.57 //y2=1.175
r66 (  7 29 ) resistor r=10.2674 //w=0.187 //l=0.15 //layer=li //thickness=0.1 \
 //x=60.57 //y=1.26 //x2=60.57 //y2=1.41
r67 (  4 25 ) resistor r=5.4201 //w=0.17 //l=0.085 //layer=li //thickness=0.1 \
 //x=60.57 //y=1.09 //x2=60.57 //y2=1.175
r68 (  4 29 ) resistor r=1.36898 //w=0.187 //l=0.02 //layer=li //thickness=0.1 \
 //x=60.57 //y=1.09 //x2=60.57 //y2=1.07
r69 (  3 29 ) resistor r=3.57586 //w=0.17 //l=0.125 //layer=li //thickness=0.1 \
 //x=60.57 //y=0.805 //x2=60.57 //y2=0.68
r70 (  3 29 ) resistor r=18.139 //w=0.187 //l=0.265 //layer=li //thickness=0.1 \
 //x=60.57 //y=0.805 //x2=60.57 //y2=1.07
r71 (  2 28 ) resistor r=0.751729 //w=0.17 //l=0.085 //layer=li \
 //thickness=0.1 //x=59.605 //y=1.175 //x2=59.52 //y2=1.175
r72 (  1 25 ) resistor r=1.40859 //w=0.34 //l=0.085 //layer=li //thickness=0.1 \
 //x=60.485 //y=1.175 //x2=60.57 //y2=1.175
r73 (  1 2 ) resistor r=60.2353 //w=0.187 //l=0.88 //layer=li //thickness=0.1 \
 //x=60.485 //y=1.175 //x2=59.605 //y2=1.175
ends PM_TMRDFFSNQNX1\%noxref_49

subckt PM_TMRDFFSNQNX1\%noxref_50 ( 1 5 9 10 13 17 29 )
c51 ( 29 0 ) capacitor c=0.0632682f //x=62.84 //y=0.545
c52 ( 17 0 ) capacitor c=0.00722223f //x=64.915 //y=0.795
c53 ( 13 0 ) capacitor c=0.0145084f //x=64.83 //y=0.71
c54 ( 10 0 ) capacitor c=0.00582081f //x=63.945 //y=1.675
c55 ( 9 0 ) capacitor c=0.006761f //x=63.945 //y=0.795
c56 ( 5 0 ) capacitor c=0.0173046f //x=63.86 //y=1.76
c57 ( 1 0 ) capacitor c=0.00733328f //x=62.975 //y=1.675
r58 (  17 29 ) resistor r=3.57586 //w=0.17 //l=0.125 //layer=li \
 //thickness=0.1 //x=64.915 //y=0.795 //x2=64.915 //y2=0.67
r59 (  17 29 ) resistor r=18.139 //w=0.187 //l=0.265 //layer=li \
 //thickness=0.1 //x=64.915 //y=0.795 //x2=64.915 //y2=1.06
r60 (  14 29 ) resistor r=3.57586 //w=0.17 //l=0.103078 //layer=li \
 //thickness=0.1 //x=64.03 //y=0.71 //x2=63.945 //y2=0.67
r61 (  14 29 ) resistor r=27.3797 //w=0.187 //l=0.4 //layer=li //thickness=0.1 \
 //x=64.03 //y=0.71 //x2=64.43 //y2=0.71
r62 (  13 29 ) resistor r=3.57586 //w=0.17 //l=0.103078 //layer=li \
 //thickness=0.1 //x=64.83 //y=0.71 //x2=64.915 //y2=0.67
r63 (  13 29 ) resistor r=27.3797 //w=0.187 //l=0.4 //layer=li //thickness=0.1 \
 //x=64.83 //y=0.71 //x2=64.43 //y2=0.71
r64 (  10 29 ) resistor r=3.57586 //w=0.17 //l=0.125 //layer=li \
 //thickness=0.1 //x=63.945 //y=1.675 //x2=63.945 //y2=1.8
r65 (  10 29 ) resistor r=42.0963 //w=0.187 //l=0.615 //layer=li \
 //thickness=0.1 //x=63.945 //y=1.675 //x2=63.945 //y2=1.06
r66 (  9 29 ) resistor r=3.57586 //w=0.17 //l=0.125 //layer=li //thickness=0.1 \
 //x=63.945 //y=0.795 //x2=63.945 //y2=0.67
r67 (  9 29 ) resistor r=18.139 //w=0.187 //l=0.265 //layer=li //thickness=0.1 \
 //x=63.945 //y=0.795 //x2=63.945 //y2=1.06
r68 (  6 29 ) resistor r=3.57586 //w=0.17 //l=0.103078 //layer=li \
 //thickness=0.1 //x=63.06 //y=1.76 //x2=62.975 //y2=1.8
r69 (  6 29 ) resistor r=27.3797 //w=0.187 //l=0.4 //layer=li //thickness=0.1 \
 //x=63.06 //y=1.76 //x2=63.46 //y2=1.76
r70 (  5 29 ) resistor r=3.57586 //w=0.17 //l=0.103078 //layer=li \
 //thickness=0.1 //x=63.86 //y=1.76 //x2=63.945 //y2=1.8
r71 (  5 29 ) resistor r=27.3797 //w=0.187 //l=0.4 //layer=li //thickness=0.1 \
 //x=63.86 //y=1.76 //x2=63.46 //y2=1.76
r72 (  1 29 ) resistor r=3.57586 //w=0.17 //l=0.125 //layer=li //thickness=0.1 \
 //x=62.975 //y=1.675 //x2=62.975 //y2=1.8
r73 (  1 29 ) resistor r=42.0963 //w=0.187 //l=0.615 //layer=li \
 //thickness=0.1 //x=62.975 //y=1.675 //x2=62.975 //y2=1.06
ends PM_TMRDFFSNQNX1\%noxref_50

subckt PM_TMRDFFSNQNX1\%noxref_51 ( 1 5 9 10 13 17 29 )
c51 ( 29 0 ) capacitor c=0.0632684f //x=66.17 //y=0.545
c52 ( 17 0 ) capacitor c=0.0072343f //x=68.245 //y=0.795
c53 ( 13 0 ) capacitor c=0.0145084f //x=68.16 //y=0.71
c54 ( 10 0 ) capacitor c=0.00582081f //x=67.275 //y=1.675
c55 ( 9 0 ) capacitor c=0.006761f //x=67.275 //y=0.795
c56 ( 5 0 ) capacitor c=0.0173046f //x=67.19 //y=1.76
c57 ( 1 0 ) capacitor c=0.00733328f //x=66.305 //y=1.675
r58 (  17 29 ) resistor r=3.57586 //w=0.17 //l=0.125 //layer=li \
 //thickness=0.1 //x=68.245 //y=0.795 //x2=68.245 //y2=0.67
r59 (  17 29 ) resistor r=18.139 //w=0.187 //l=0.265 //layer=li \
 //thickness=0.1 //x=68.245 //y=0.795 //x2=68.245 //y2=1.06
r60 (  14 29 ) resistor r=3.57586 //w=0.17 //l=0.103078 //layer=li \
 //thickness=0.1 //x=67.36 //y=0.71 //x2=67.275 //y2=0.67
r61 (  14 29 ) resistor r=27.3797 //w=0.187 //l=0.4 //layer=li //thickness=0.1 \
 //x=67.36 //y=0.71 //x2=67.76 //y2=0.71
r62 (  13 29 ) resistor r=3.57586 //w=0.17 //l=0.103078 //layer=li \
 //thickness=0.1 //x=68.16 //y=0.71 //x2=68.245 //y2=0.67
r63 (  13 29 ) resistor r=27.3797 //w=0.187 //l=0.4 //layer=li //thickness=0.1 \
 //x=68.16 //y=0.71 //x2=67.76 //y2=0.71
r64 (  10 29 ) resistor r=3.57586 //w=0.17 //l=0.125 //layer=li \
 //thickness=0.1 //x=67.275 //y=1.675 //x2=67.275 //y2=1.8
r65 (  10 29 ) resistor r=42.0963 //w=0.187 //l=0.615 //layer=li \
 //thickness=0.1 //x=67.275 //y=1.675 //x2=67.275 //y2=1.06
r66 (  9 29 ) resistor r=3.57586 //w=0.17 //l=0.125 //layer=li //thickness=0.1 \
 //x=67.275 //y=0.795 //x2=67.275 //y2=0.67
r67 (  9 29 ) resistor r=18.139 //w=0.187 //l=0.265 //layer=li //thickness=0.1 \
 //x=67.275 //y=0.795 //x2=67.275 //y2=1.06
r68 (  6 29 ) resistor r=3.57586 //w=0.17 //l=0.103078 //layer=li \
 //thickness=0.1 //x=66.39 //y=1.76 //x2=66.305 //y2=1.8
r69 (  6 29 ) resistor r=27.3797 //w=0.187 //l=0.4 //layer=li //thickness=0.1 \
 //x=66.39 //y=1.76 //x2=66.79 //y2=1.76
r70 (  5 29 ) resistor r=3.57586 //w=0.17 //l=0.103078 //layer=li \
 //thickness=0.1 //x=67.19 //y=1.76 //x2=67.275 //y2=1.8
r71 (  5 29 ) resistor r=27.3797 //w=0.187 //l=0.4 //layer=li //thickness=0.1 \
 //x=67.19 //y=1.76 //x2=66.79 //y2=1.76
r72 (  1 29 ) resistor r=3.57586 //w=0.17 //l=0.125 //layer=li //thickness=0.1 \
 //x=66.305 //y=1.675 //x2=66.305 //y2=1.8
r73 (  1 29 ) resistor r=42.0963 //w=0.187 //l=0.615 //layer=li \
 //thickness=0.1 //x=66.305 //y=1.675 //x2=66.305 //y2=1.06
ends PM_TMRDFFSNQNX1\%noxref_51

subckt PM_TMRDFFSNQNX1\%noxref_52 ( 1 5 9 13 17 35 )
c51 ( 35 0 ) capacitor c=0.0680259f //x=69.395 //y=0.555
c52 ( 17 0 ) capacitor c=0.0180446f //x=71.385 //y=1.77
c53 ( 13 0 ) capacitor c=0.0155283f //x=71.385 //y=0.72
c54 ( 9 0 ) capacitor c=0.00678203f //x=70.5 //y=0.805
c55 ( 5 0 ) capacitor c=0.0164013f //x=70.415 //y=1.77
c56 ( 1 0 ) capacitor c=0.00696517f //x=69.53 //y=1.685
r57 (  18 35 ) resistor r=5.4201 //w=0.17 //l=0.103078 //layer=li \
 //thickness=0.1 //x=70.585 //y=1.77 //x2=70.5 //y2=1.81
r58 (  18 35 ) resistor r=27.3797 //w=0.187 //l=0.4 //layer=li //thickness=0.1 \
 //x=70.585 //y=1.77 //x2=70.985 //y2=1.77
r59 (  17 35 ) resistor r=0.751729 //w=0.17 //l=0.085 //layer=li \
 //thickness=0.1 //x=71.385 //y=1.77 //x2=71.47 //y2=1.77
r60 (  17 35 ) resistor r=27.3797 //w=0.187 //l=0.4 //layer=li //thickness=0.1 \
 //x=71.385 //y=1.77 //x2=70.985 //y2=1.77
r61 (  14 35 ) resistor r=3.57586 //w=0.17 //l=0.103078 //layer=li \
 //thickness=0.1 //x=70.585 //y=0.72 //x2=70.5 //y2=0.68
r62 (  14 35 ) resistor r=27.3797 //w=0.187 //l=0.4 //layer=li //thickness=0.1 \
 //x=70.585 //y=0.72 //x2=70.985 //y2=0.72
r63 (  13 35 ) resistor r=0.751729 //w=0.17 //l=0.085 //layer=li \
 //thickness=0.1 //x=71.385 //y=0.72 //x2=71.47 //y2=0.72
r64 (  13 35 ) resistor r=27.3797 //w=0.187 //l=0.4 //layer=li //thickness=0.1 \
 //x=71.385 //y=0.72 //x2=70.985 //y2=0.72
r65 (  10 35 ) resistor r=1.40859 //w=0.34 //l=0.125 //layer=li \
 //thickness=0.1 //x=70.5 //y=1.685 //x2=70.5 //y2=1.81
r66 (  10 35 ) resistor r=42.0963 //w=0.187 //l=0.615 //layer=li \
 //thickness=0.1 //x=70.5 //y=1.685 //x2=70.5 //y2=1.07
r67 (  9 35 ) resistor r=3.57586 //w=0.17 //l=0.125 //layer=li //thickness=0.1 \
 //x=70.5 //y=0.805 //x2=70.5 //y2=0.68
r68 (  9 35 ) resistor r=18.139 //w=0.187 //l=0.265 //layer=li //thickness=0.1 \
 //x=70.5 //y=0.805 //x2=70.5 //y2=1.07
r69 (  6 35 ) resistor r=3.57586 //w=0.17 //l=0.103078 //layer=li \
 //thickness=0.1 //x=69.615 //y=1.77 //x2=69.53 //y2=1.81
r70 (  6 35 ) resistor r=27.3797 //w=0.187 //l=0.4 //layer=li //thickness=0.1 \
 //x=69.615 //y=1.77 //x2=70.015 //y2=1.77
r71 (  5 35 ) resistor r=5.4201 //w=0.17 //l=0.103078 //layer=li \
 //thickness=0.1 //x=70.415 //y=1.77 //x2=70.5 //y2=1.81
r72 (  5 35 ) resistor r=27.3797 //w=0.187 //l=0.4 //layer=li //thickness=0.1 \
 //x=70.415 //y=1.77 //x2=70.015 //y2=1.77
r73 (  1 35 ) resistor r=3.57586 //w=0.17 //l=0.125 //layer=li //thickness=0.1 \
 //x=69.53 //y=1.685 //x2=69.53 //y2=1.81
r74 (  1 35 ) resistor r=42.0963 //w=0.187 //l=0.615 //layer=li \
 //thickness=0.1 //x=69.53 //y=1.685 //x2=69.53 //y2=1.07
ends PM_TMRDFFSNQNX1\%noxref_52

subckt PM_TMRDFFSNQNX1\%noxref_53 ( 1 3 11 15 25 28 29 )
c52 ( 29 0 ) capacitor c=0.042068f //x=71.905 //y=0.555
c53 ( 28 0 ) capacitor c=0.00457437f //x=70.8 //y=1.09
c54 ( 25 0 ) capacitor c=0.00156479f //x=72.04 //y=1.175
c55 ( 15 0 ) capacitor c=0.00737666f //x=73.01 //y=0.805
c56 ( 11 0 ) capacitor c=0.014695f //x=72.925 //y=0.72
c57 ( 3 0 ) capacitor c=0.00718386f //x=72.04 //y=0.805
c58 ( 1 0 ) capacitor c=0.0234159f //x=71.955 //y=1.175
r59 (  15 29 ) resistor r=3.57586 //w=0.17 //l=0.125 //layer=li \
 //thickness=0.1 //x=73.01 //y=0.805 //x2=73.01 //y2=0.68
r60 (  15 29 ) resistor r=18.139 //w=0.187 //l=0.265 //layer=li \
 //thickness=0.1 //x=73.01 //y=0.805 //x2=73.01 //y2=1.07
r61 (  12 29 ) resistor r=3.57586 //w=0.17 //l=0.103078 //layer=li \
 //thickness=0.1 //x=72.125 //y=0.72 //x2=72.04 //y2=0.68
r62 (  12 29 ) resistor r=27.3797 //w=0.187 //l=0.4 //layer=li //thickness=0.1 \
 //x=72.125 //y=0.72 //x2=72.525 //y2=0.72
r63 (  11 29 ) resistor r=3.57586 //w=0.17 //l=0.103078 //layer=li \
 //thickness=0.1 //x=72.925 //y=0.72 //x2=73.01 //y2=0.68
r64 (  11 29 ) resistor r=27.3797 //w=0.187 //l=0.4 //layer=li //thickness=0.1 \
 //x=72.925 //y=0.72 //x2=72.525 //y2=0.72
r65 (  7 25 ) resistor r=5.4201 //w=0.17 //l=0.085 //layer=li //thickness=0.1 \
 //x=72.04 //y=1.26 //x2=72.04 //y2=1.175
r66 (  7 29 ) resistor r=10.2674 //w=0.187 //l=0.15 //layer=li //thickness=0.1 \
 //x=72.04 //y=1.26 //x2=72.04 //y2=1.41
r67 (  4 25 ) resistor r=5.4201 //w=0.17 //l=0.085 //layer=li //thickness=0.1 \
 //x=72.04 //y=1.09 //x2=72.04 //y2=1.175
r68 (  4 29 ) resistor r=1.36898 //w=0.187 //l=0.02 //layer=li //thickness=0.1 \
 //x=72.04 //y=1.09 //x2=72.04 //y2=1.07
r69 (  3 29 ) resistor r=3.57586 //w=0.17 //l=0.125 //layer=li //thickness=0.1 \
 //x=72.04 //y=0.805 //x2=72.04 //y2=0.68
r70 (  3 29 ) resistor r=18.139 //w=0.187 //l=0.265 //layer=li //thickness=0.1 \
 //x=72.04 //y=0.805 //x2=72.04 //y2=1.07
r71 (  2 28 ) resistor r=0.751729 //w=0.17 //l=0.085 //layer=li \
 //thickness=0.1 //x=71.075 //y=1.175 //x2=70.99 //y2=1.175
r72 (  1 25 ) resistor r=1.40859 //w=0.34 //l=0.085 //layer=li //thickness=0.1 \
 //x=71.955 //y=1.175 //x2=72.04 //y2=1.175
r73 (  1 2 ) resistor r=60.2353 //w=0.187 //l=0.88 //layer=li //thickness=0.1 \
 //x=71.955 //y=1.175 //x2=71.075 //y2=1.175
ends PM_TMRDFFSNQNX1\%noxref_53

subckt PM_TMRDFFSNQNX1\%noxref_54 ( 1 5 9 10 13 17 29 )
c57 ( 29 0 ) capacitor c=0.0761166f //x=74.31 //y=0.545
c58 ( 17 0 ) capacitor c=0.0072249f //x=76.385 //y=0.795
c59 ( 13 0 ) capacitor c=0.0154142f //x=76.3 //y=0.71
c60 ( 10 0 ) capacitor c=0.00754234f //x=75.415 //y=1.675
c61 ( 9 0 ) capacitor c=0.006761f //x=75.415 //y=0.795
c62 ( 5 0 ) capacitor c=0.0213241f //x=75.33 //y=1.76
c63 ( 1 0 ) capacitor c=0.00492513f //x=74.445 //y=1.675
r64 (  17 29 ) resistor r=3.57586 //w=0.17 //l=0.125 //layer=li \
 //thickness=0.1 //x=76.385 //y=0.795 //x2=76.385 //y2=0.67
r65 (  17 29 ) resistor r=41.4118 //w=0.187 //l=0.605 //layer=li \
 //thickness=0.1 //x=76.385 //y=0.795 //x2=76.385 //y2=1.4
r66 (  14 29 ) resistor r=3.57586 //w=0.17 //l=0.103078 //layer=li \
 //thickness=0.1 //x=75.5 //y=0.71 //x2=75.415 //y2=0.67
r67 (  14 29 ) resistor r=27.0374 //w=0.187 //l=0.395 //layer=li \
 //thickness=0.1 //x=75.5 //y=0.71 //x2=75.895 //y2=0.71
r68 (  13 29 ) resistor r=3.57586 //w=0.17 //l=0.103078 //layer=li \
 //thickness=0.1 //x=76.3 //y=0.71 //x2=76.385 //y2=0.67
r69 (  13 29 ) resistor r=27.7219 //w=0.187 //l=0.405 //layer=li \
 //thickness=0.1 //x=76.3 //y=0.71 //x2=75.895 //y2=0.71
r70 (  10 29 ) resistor r=3.57586 //w=0.17 //l=0.125 //layer=li \
 //thickness=0.1 //x=75.415 //y=1.675 //x2=75.415 //y2=1.8
r71 (  10 29 ) resistor r=42.0963 //w=0.187 //l=0.615 //layer=li \
 //thickness=0.1 //x=75.415 //y=1.675 //x2=75.415 //y2=1.06
r72 (  9 29 ) resistor r=3.57586 //w=0.17 //l=0.125 //layer=li //thickness=0.1 \
 //x=75.415 //y=0.795 //x2=75.415 //y2=0.67
r73 (  9 29 ) resistor r=18.139 //w=0.187 //l=0.265 //layer=li //thickness=0.1 \
 //x=75.415 //y=0.795 //x2=75.415 //y2=1.06
r74 (  6 29 ) resistor r=3.57586 //w=0.17 //l=0.103078 //layer=li \
 //thickness=0.1 //x=74.53 //y=1.76 //x2=74.445 //y2=1.8
r75 (  6 29 ) resistor r=27.3797 //w=0.187 //l=0.4 //layer=li //thickness=0.1 \
 //x=74.53 //y=1.76 //x2=74.93 //y2=1.76
r76 (  5 29 ) resistor r=3.57586 //w=0.17 //l=0.103078 //layer=li \
 //thickness=0.1 //x=75.33 //y=1.76 //x2=75.415 //y2=1.8
r77 (  5 29 ) resistor r=27.3797 //w=0.187 //l=0.4 //layer=li //thickness=0.1 \
 //x=75.33 //y=1.76 //x2=74.93 //y2=1.76
r78 (  1 29 ) resistor r=3.57586 //w=0.17 //l=0.125 //layer=li //thickness=0.1 \
 //x=74.445 //y=1.675 //x2=74.445 //y2=1.8
r79 (  1 29 ) resistor r=42.0963 //w=0.187 //l=0.615 //layer=li \
 //thickness=0.1 //x=74.445 //y=1.675 //x2=74.445 //y2=1.06
ends PM_TMRDFFSNQNX1\%noxref_54

subckt PM_TMRDFFSNQNX1\%noxref_55 ( 1 5 9 10 13 17 29 )
c55 ( 29 0 ) capacitor c=0.0723103f //x=77.64 //y=0.545
c56 ( 17 0 ) capacitor c=0.0072249f //x=79.715 //y=0.795
c57 ( 13 0 ) capacitor c=0.0155051f //x=79.63 //y=0.71
c58 ( 10 0 ) capacitor c=0.00907139f //x=78.745 //y=1.675
c59 ( 9 0 ) capacitor c=0.006761f //x=78.745 //y=0.795
c60 ( 5 0 ) capacitor c=0.019003f //x=78.66 //y=1.76
c61 ( 1 0 ) capacitor c=0.00885385f //x=77.775 //y=1.675
r62 (  17 29 ) resistor r=3.57586 //w=0.17 //l=0.125 //layer=li \
 //thickness=0.1 //x=79.715 //y=0.795 //x2=79.715 //y2=0.67
r63 (  17 29 ) resistor r=41.4118 //w=0.187 //l=0.605 //layer=li \
 //thickness=0.1 //x=79.715 //y=0.795 //x2=79.715 //y2=1.4
r64 (  14 29 ) resistor r=3.57586 //w=0.17 //l=0.103078 //layer=li \
 //thickness=0.1 //x=78.83 //y=0.71 //x2=78.745 //y2=0.67
r65 (  14 29 ) resistor r=27.3797 //w=0.187 //l=0.4 //layer=li //thickness=0.1 \
 //x=78.83 //y=0.71 //x2=79.23 //y2=0.71
r66 (  13 29 ) resistor r=3.57586 //w=0.17 //l=0.103078 //layer=li \
 //thickness=0.1 //x=79.63 //y=0.71 //x2=79.715 //y2=0.67
r67 (  13 29 ) resistor r=27.3797 //w=0.187 //l=0.4 //layer=li //thickness=0.1 \
 //x=79.63 //y=0.71 //x2=79.23 //y2=0.71
r68 (  10 29 ) resistor r=3.57586 //w=0.17 //l=0.125 //layer=li \
 //thickness=0.1 //x=78.745 //y=1.675 //x2=78.745 //y2=1.8
r69 (  10 29 ) resistor r=42.0963 //w=0.187 //l=0.615 //layer=li \
 //thickness=0.1 //x=78.745 //y=1.675 //x2=78.745 //y2=1.06
r70 (  9 29 ) resistor r=3.57586 //w=0.17 //l=0.125 //layer=li //thickness=0.1 \
 //x=78.745 //y=0.795 //x2=78.745 //y2=0.67
r71 (  9 29 ) resistor r=18.139 //w=0.187 //l=0.265 //layer=li //thickness=0.1 \
 //x=78.745 //y=0.795 //x2=78.745 //y2=1.06
r72 (  6 29 ) resistor r=3.57586 //w=0.17 //l=0.103078 //layer=li \
 //thickness=0.1 //x=77.86 //y=1.76 //x2=77.775 //y2=1.8
r73 (  6 29 ) resistor r=27.3797 //w=0.187 //l=0.4 //layer=li //thickness=0.1 \
 //x=77.86 //y=1.76 //x2=78.26 //y2=1.76
r74 (  5 29 ) resistor r=3.57586 //w=0.17 //l=0.103078 //layer=li \
 //thickness=0.1 //x=78.66 //y=1.76 //x2=78.745 //y2=1.8
r75 (  5 29 ) resistor r=27.3797 //w=0.187 //l=0.4 //layer=li //thickness=0.1 \
 //x=78.66 //y=1.76 //x2=78.26 //y2=1.76
r76 (  1 29 ) resistor r=3.57586 //w=0.17 //l=0.125 //layer=li //thickness=0.1 \
 //x=77.775 //y=1.675 //x2=77.775 //y2=1.8
r77 (  1 29 ) resistor r=42.0963 //w=0.187 //l=0.615 //layer=li \
 //thickness=0.1 //x=77.775 //y=1.675 //x2=77.775 //y2=1.06
ends PM_TMRDFFSNQNX1\%noxref_55

subckt PM_TMRDFFSNQNX1\%noxref_56 ( 1 5 9 10 13 17 29 )
c53 ( 29 0 ) capacitor c=0.0643725f //x=80.97 //y=0.545
c54 ( 17 0 ) capacitor c=0.00722228f //x=83.045 //y=0.795
c55 ( 13 0 ) capacitor c=0.0141607f //x=82.96 //y=0.71
c56 ( 10 0 ) capacitor c=0.00712138f //x=82.075 //y=1.675
c57 ( 9 0 ) capacitor c=0.006761f //x=82.075 //y=0.795
c58 ( 5 0 ) capacitor c=0.0233454f //x=81.99 //y=1.76
c59 ( 1 0 ) capacitor c=0.00481264f //x=81.105 //y=1.675
r60 (  17 29 ) resistor r=3.57586 //w=0.17 //l=0.125 //layer=li \
 //thickness=0.1 //x=83.045 //y=0.795 //x2=83.045 //y2=0.67
r61 (  17 29 ) resistor r=18.139 //w=0.187 //l=0.265 //layer=li \
 //thickness=0.1 //x=83.045 //y=0.795 //x2=83.045 //y2=1.06
r62 (  14 29 ) resistor r=3.57586 //w=0.17 //l=0.103078 //layer=li \
 //thickness=0.1 //x=82.16 //y=0.71 //x2=82.075 //y2=0.67
r63 (  14 29 ) resistor r=27.3797 //w=0.187 //l=0.4 //layer=li //thickness=0.1 \
 //x=82.16 //y=0.71 //x2=82.56 //y2=0.71
r64 (  13 29 ) resistor r=3.57586 //w=0.17 //l=0.103078 //layer=li \
 //thickness=0.1 //x=82.96 //y=0.71 //x2=83.045 //y2=0.67
r65 (  13 29 ) resistor r=27.3797 //w=0.187 //l=0.4 //layer=li //thickness=0.1 \
 //x=82.96 //y=0.71 //x2=82.56 //y2=0.71
r66 (  10 29 ) resistor r=3.57586 //w=0.17 //l=0.125 //layer=li \
 //thickness=0.1 //x=82.075 //y=1.675 //x2=82.075 //y2=1.8
r67 (  10 29 ) resistor r=42.0963 //w=0.187 //l=0.615 //layer=li \
 //thickness=0.1 //x=82.075 //y=1.675 //x2=82.075 //y2=1.06
r68 (  9 29 ) resistor r=3.57586 //w=0.17 //l=0.125 //layer=li //thickness=0.1 \
 //x=82.075 //y=0.795 //x2=82.075 //y2=0.67
r69 (  9 29 ) resistor r=18.139 //w=0.187 //l=0.265 //layer=li //thickness=0.1 \
 //x=82.075 //y=0.795 //x2=82.075 //y2=1.06
r70 (  6 29 ) resistor r=3.57586 //w=0.17 //l=0.103078 //layer=li \
 //thickness=0.1 //x=81.19 //y=1.76 //x2=81.105 //y2=1.8
r71 (  6 29 ) resistor r=27.3797 //w=0.187 //l=0.4 //layer=li //thickness=0.1 \
 //x=81.19 //y=1.76 //x2=81.59 //y2=1.76
r72 (  5 29 ) resistor r=3.57586 //w=0.17 //l=0.103078 //layer=li \
 //thickness=0.1 //x=81.99 //y=1.76 //x2=82.075 //y2=1.8
r73 (  5 29 ) resistor r=27.3797 //w=0.187 //l=0.4 //layer=li //thickness=0.1 \
 //x=81.99 //y=1.76 //x2=81.59 //y2=1.76
r74 (  1 29 ) resistor r=3.57586 //w=0.17 //l=0.125 //layer=li //thickness=0.1 \
 //x=81.105 //y=1.675 //x2=81.105 //y2=1.8
r75 (  1 29 ) resistor r=42.0963 //w=0.187 //l=0.615 //layer=li \
 //thickness=0.1 //x=81.105 //y=1.675 //x2=81.105 //y2=1.06
ends PM_TMRDFFSNQNX1\%noxref_56
