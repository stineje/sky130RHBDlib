// File: aoai4x1_pcell.spi.pex
// Created: Thu Jan 22 07:12:05 2026
// Program "Calibre xRC"
// Version "v2023.2_27.15"
// Nominal Temperature: 30C
// Circuit Temperature: 30C
//
simulator lang=spectre
subckt PM_AOAI4X1_PCELL\%noxref_1 ( 3 8 9 11 12 14 15 16 18 19 20 23 24 27 29 \
 34 38 40 44 51 53 54 57 65 82 87 95 96 97 98 99 100 101 105 107 110 112 113 \
 118 128 130 131 )
c263 ( 128 0 ) capacitor c=0.00878249f //x=1.96 //y=0.905
c264 ( 118 0 ) capacitor c=0.0426341f //x=4.285 //y=4.705
c265 ( 113 0 ) capacitor c=0.0337825f //x=4.775 //y=1.25
c266 ( 112 0 ) capacitor c=0.0183823f //x=4.775 //y=0.905
c267 ( 110 0 ) capacitor c=0.0350928f //x=4.705 //y=4.795
c268 ( 107 0 ) capacitor c=0.013578f //x=4.62 //y=1.405
c269 ( 105 0 ) capacitor c=0.0157803f //x=4.62 //y=0.75
c270 ( 101 0 ) capacitor c=0.0787231f //x=4.245 //y=1.915
c271 ( 100 0 ) capacitor c=0.0230165f //x=4.245 //y=1.56
c272 ( 99 0 ) capacitor c=0.0234348f //x=4.245 //y=1.25
c273 ( 98 0 ) capacitor c=0.019134f //x=4.245 //y=0.905
c274 ( 97 0 ) capacitor c=0.110994f //x=4.78 //y=6.025
c275 ( 96 0 ) capacitor c=0.154777f //x=4.34 //y=6.025
c276 ( 87 0 ) capacitor c=4.74639e-19 //x=4.44 //y=2.08
c277 ( 82 0 ) capacitor c=0.00705226f //x=4.285 //y=4.705
c278 ( 65 0 ) capacitor c=0.0325392f //x=2.11 //y=5.38
c279 ( 57 0 ) capacitor c=0.0291911f //x=1.23 //y=5.38
c280 ( 54 0 ) capacitor c=0.0774598f //x=4.275 //y=2.585
c281 ( 53 0 ) capacitor c=0.00528707f //x=4.435 //y=2.585
c282 ( 51 0 ) capacitor c=0.00557932f //x=2.75 //y=2.585
c283 ( 44 0 ) capacitor c=0.00772734f //x=4.285 //y=4.705
c284 ( 40 0 ) capacitor c=0.0063606f //x=4.44 //y=2.08
c285 ( 38 0 ) capacitor c=0.0141822f //x=4.44 //y=2.59
c286 ( 34 0 ) capacitor c=0.0148986f //x=2.59 //y=2.59
c287 ( 29 0 ) capacitor c=0.011771f //x=2.15 //y=1
c288 ( 27 0 ) capacitor c=6.70882e-19 //x=2.11 //y=5.38
c289 ( 24 0 ) capacitor c=0.0129472f //x=2.11 //y=5.2
c290 ( 23 0 ) capacitor c=0.0106213f //x=1.23 //y=5.38
c291 ( 20 0 ) capacitor c=0.0626275f //x=4.44 //y=4.585
c292 ( 19 0 ) capacitor c=0.0110376f //x=4.44 //y=2.745
c293 ( 18 0 ) capacitor c=0.00428329f //x=4.44 //y=2.425
c294 ( 16 0 ) capacitor c=0.0762425f //x=2.59 //y=5.115
c295 ( 15 0 ) capacitor c=0.0117766f //x=2.59 //y=2.745
c296 ( 14 0 ) capacitor c=0.0169876f //x=2.59 //y=2.425
c297 ( 12 0 ) capacitor c=0.00837358f //x=2.235 //y=1.655
c298 ( 11 0 ) capacitor c=0.0136795f //x=2.505 //y=1.655
c299 ( 9 0 ) capacitor c=0.0123394f //x=2.505 //y=5.2
c300 ( 8 0 ) capacitor c=0.012699f //x=2.15 //y=1.57
c301 ( 3 0 ) capacitor c=0.019362f //x=1.995 //y=5.2
r302 (  120 121 ) resistor r=32.4568 //w=0.214 //l=0.075 //layer=ply \
 //thickness=0.18 //x=4.285 //y=4.795 //x2=4.285 //y2=4.87
r303 (  118 120 ) resistor r=20.271 //w=0.214 //l=0.09 //layer=ply \
 //thickness=0.18 //x=4.285 //y=4.705 //x2=4.285 //y2=4.795
r304 (  113 127 ) resistor r=45.1352 //w=0.168 //l=0.173853 //layer=ply \
 //thickness=0.18 //x=4.775 //y=1.25 //x2=4.735 //y2=1.405
r305 (  112 126 ) resistor r=45.1352 //w=0.168 //l=0.173853 //layer=ply \
 //thickness=0.18 //x=4.775 //y=0.905 //x2=4.735 //y2=0.75
r306 (  112 113 ) resistor r=176.904 //w=0.094 //l=0.345 //layer=ply \
 //thickness=0.18 //x=4.775 //y=0.905 //x2=4.775 //y2=1.25
r307 (  111 120 ) resistor r=16.5046 //w=0.27 //l=0.135 //layer=ply \
 //thickness=0.18 //x=4.42 //y=4.795 //x2=4.285 //y2=4.795
r308 (  110 114 ) resistor r=26.9307 //w=0.15 //l=0.106066 //layer=ply \
 //thickness=0.18 //x=4.705 //y=4.795 //x2=4.78 //y2=4.87
r309 (  110 111 ) resistor r=146.138 //w=0.094 //l=0.285 //layer=ply \
 //thickness=0.18 //x=4.705 //y=4.795 //x2=4.42 //y2=4.795
r310 (  108 125 ) resistor r=10.701 //w=0.21 //l=0.115 //layer=ply \
 //thickness=0.18 //x=4.4 //y=1.405 //x2=4.285 //y2=1.405
r311 (  107 127 ) resistor r=5.52526 //w=0.168 //l=0.115 //layer=ply \
 //thickness=0.18 //x=4.62 //y=1.405 //x2=4.735 //y2=1.405
r312 (  106 124 ) resistor r=5.52526 //w=0.168 //l=0.115 //layer=ply \
 //thickness=0.18 //x=4.4 //y=0.75 //x2=4.285 //y2=0.75
r313 (  105 126 ) resistor r=5.52526 //w=0.168 //l=0.115 //layer=ply \
 //thickness=0.18 //x=4.62 //y=0.75 //x2=4.735 //y2=0.75
r314 (  105 106 ) resistor r=112.809 //w=0.094 //l=0.22 //layer=ply \
 //thickness=0.18 //x=4.62 //y=0.75 //x2=4.4 //y2=0.75
r315 (  101 123 ) resistor r=34.8111 //w=0.27 //l=0.264953 //layer=ply \
 //thickness=0.18 //x=4.245 //y=1.915 //x2=4.44 //y2=2.08
r316 (  100 125 ) resistor r=39.5823 //w=0.21 //l=0.173853 //layer=ply \
 //thickness=0.18 //x=4.245 //y=1.56 //x2=4.285 //y2=1.405
r317 (  100 101 ) resistor r=182.032 //w=0.094 //l=0.355 //layer=ply \
 //thickness=0.18 //x=4.245 //y=1.56 //x2=4.245 //y2=1.915
r318 (  99 125 ) resistor r=39.5823 //w=0.21 //l=0.173853 //layer=ply \
 //thickness=0.18 //x=4.245 //y=1.25 //x2=4.285 //y2=1.405
r319 (  98 124 ) resistor r=45.1352 //w=0.168 //l=0.173853 //layer=ply \
 //thickness=0.18 //x=4.245 //y=0.905 //x2=4.285 //y2=0.75
r320 (  98 99 ) resistor r=176.904 //w=0.094 //l=0.345 //layer=ply \
 //thickness=0.18 //x=4.245 //y=0.905 //x2=4.245 //y2=1.25
r321 (  97 114 ) resistor r=592.245 //w=0.094 //l=1.155 //layer=ply \
 //thickness=0.18 //x=4.78 //y=6.025 //x2=4.78 //y2=4.87
r322 (  96 121 ) resistor r=592.245 //w=0.094 //l=1.155 //layer=ply \
 //thickness=0.18 //x=4.34 //y=6.025 //x2=4.34 //y2=4.87
r323 (  95 107 ) resistor r=56.4043 //w=0.094 //l=0.11 //layer=ply \
 //thickness=0.18 //x=4.51 //y=1.405 //x2=4.62 //y2=1.405
r324 (  95 108 ) resistor r=56.4043 //w=0.094 //l=0.11 //layer=ply \
 //thickness=0.18 //x=4.51 //y=1.405 //x2=4.4 //y2=1.405
r325 (  87 123 ) resistor r=152 //w=0.17 //l=0.17 //layer=licon //count=1 \
 //x=4.44 //y=2.08 //x2=4.44 //y2=2.08
r326 (  82 118 ) resistor r=152 //w=0.17 //l=0.17 //layer=licon //count=1 \
 //x=4.285 //y=4.705 //x2=4.285 //y2=4.705
r327 (  65 131 ) resistor r=23.615 //w=0.187 //l=0.345 //layer=li \
 //thickness=0.1 //x=2.11 //y=5.38 //x2=2.11 //y2=5.725
r328 (  57 130 ) resistor r=23.615 //w=0.187 //l=0.345 //layer=li \
 //thickness=0.1 //x=1.23 //y=5.38 //x2=1.23 //y2=5.725
r329 (  53 54 ) resistor r=0.10734 //w=0.281 //l=0.16 //layer=m2 \
 //thickness=0.36 //x=4.435 //y=2.585 //x2=4.275 //y2=2.585
r330 (  51 54 ) resistor r=1.45515 //w=0.131 //l=1.525 //layer=m2 \
 //thickness=0.36 //x=2.75 //y=2.59 //x2=4.275 //y2=2.59
r331 (  49 51 ) resistor r=0.10734 //w=0.281 //l=0.16 //layer=m2 \
 //thickness=0.36 //x=2.59 //y=2.585 //x2=2.75 //y2=2.585
r332 (  44 82 ) resistor r=9.3 //w=0.17 //l=0.17 //layer=mcon //count=1 \
 //x=4.285 //y=4.705 //x2=4.285 //y2=4.705
r333 (  44 45 ) resistor r=0.0853524 //w=0.227 //l=0.155 //layer=m1 \
 //thickness=0.36 //x=4.285 //y=4.702 //x2=4.44 //y2=4.702
r334 (  40 87 ) resistor r=9.3 //w=0.17 //l=0.17 //layer=mcon //count=1 \
 //x=4.44 //y=2.08 //x2=4.44 //y2=2.08
r335 (  40 42 ) resistor r=0.0985786 //w=0.206 //l=0.135 //layer=m1 \
 //thickness=0.36 //x=4.437 //y=2.08 //x2=4.437 //y2=2.215
r336 (  36 53 ) resistor r=4.5 //w=0.15 //l=0.15 //layer=via1 //count=1 \
 //x=4.435 //y=2.585 //x2=4.435 //y2=2.585
r337 (  36 38 ) resistor r=0.00167112 //w=0.374 //l=0.005 //layer=m1 \
 //thickness=0.36 //x=4.385 //y=2.585 //x2=4.385 //y2=2.59
r338 (  32 49 ) resistor r=4.5 //w=0.15 //l=0.15 //layer=via1 //count=1 \
 //x=2.59 //y=2.585 //x2=2.59 //y2=2.585
r339 (  32 34 ) resistor r=0.00166223 //w=0.376 //l=0.005 //layer=m1 \
 //thickness=0.36 //x=2.642 //y=2.585 //x2=2.642 //y2=2.59
r340 (  29 128 ) resistor r=9.3 //w=0.17 //l=0.17 //layer=mcon //count=1 \
 //x=2.15 //y=1 //x2=2.15 //y2=1
r341 (  27 65 ) resistor r=9.3 //w=0.17 //l=0.17 //layer=mcon //count=1 \
 //x=2.11 //y=5.38 //x2=2.11 //y2=5.38
r342 (  24 27 ) resistor r=0.117801 //w=0.191 //l=0.18 //layer=m1 \
 //thickness=0.36 //x=2.11 //y=5.2 //x2=2.11 //y2=5.38
r343 (  23 57 ) resistor r=9.3 //w=0.17 //l=0.17 //layer=mcon //count=1 \
 //x=1.23 //y=5.38 //x2=1.23 //y2=5.38
r344 (  21 23 ) resistor r=0.10274 //w=0.219 //l=0.18 //layer=m1 \
 //thickness=0.36 //x=1.23 //y=5.2 //x2=1.23 //y2=5.38
r345 (  20 45 ) resistor r=0.0249239 //w=0.227 //l=0.117 //layer=m1 \
 //thickness=0.36 //x=4.44 //y=4.585 //x2=4.44 //y2=4.702
r346 (  19 38 ) resistor r=0.089409 //w=0.374 //l=0.180416 //layer=m1 \
 //thickness=0.36 //x=4.44 //y=2.745 //x2=4.385 //y2=2.59
r347 (  19 20 ) resistor r=1.75573 //w=0.131 //l=1.84 //layer=m1 \
 //thickness=0.36 //x=4.44 //y=2.745 //x2=4.44 //y2=4.585
r348 (  18 36 ) resistor r=0.0910802 //w=0.374 //l=0.185472 //layer=m1 \
 //thickness=0.36 //x=4.44 //y=2.425 //x2=4.385 //y2=2.585
r349 (  18 42 ) resistor r=0.200382 //w=0.131 //l=0.21 //layer=m1 \
 //thickness=0.36 //x=4.44 //y=2.425 //x2=4.44 //y2=2.215
r350 (  15 34 ) resistor r=0.0894971 //w=0.376 //l=0.179123 //layer=m1 \
 //thickness=0.36 //x=2.59 //y=2.745 //x2=2.642 //y2=2.59
r351 (  15 16 ) resistor r=2.26145 //w=0.131 //l=2.37 //layer=m1 \
 //thickness=0.36 //x=2.59 //y=2.745 //x2=2.59 //y2=5.115
r352 (  14 32 ) resistor r=0.0911593 //w=0.376 //l=0.184174 //layer=m1 \
 //thickness=0.36 //x=2.59 //y=2.425 //x2=2.642 //y2=2.585
r353 (  13 14 ) resistor r=0.653626 //w=0.131 //l=0.685 //layer=m1 \
 //thickness=0.36 //x=2.59 //y=1.74 //x2=2.59 //y2=2.425
r354 (  11 13 ) resistor r=0.0698411 //w=0.17 //l=0.120208 //layer=m1 \
 //thickness=0.36 //x=2.505 //y=1.655 //x2=2.59 //y2=1.74
r355 (  11 12 ) resistor r=0.257634 //w=0.131 //l=0.27 //layer=m1 \
 //thickness=0.36 //x=2.505 //y=1.655 //x2=2.235 //y2=1.655
r356 (  10 24 ) resistor r=0.0257089 //w=0.23 //l=0.115 //layer=m1 \
 //thickness=0.36 //x=2.225 //y=5.2 //x2=2.11 //y2=5.2
r357 (  9 16 ) resistor r=0.0698411 //w=0.17 //l=0.120208 //layer=m1 \
 //thickness=0.36 //x=2.505 //y=5.2 //x2=2.59 //y2=5.115
r358 (  9 10 ) resistor r=0.267176 //w=0.131 //l=0.28 //layer=m1 \
 //thickness=0.36 //x=2.505 //y=5.2 //x2=2.225 //y2=5.2
r359 (  8 12 ) resistor r=0.0698411 //w=0.17 //l=0.120208 //layer=m1 \
 //thickness=0.36 //x=2.15 //y=1.57 //x2=2.235 //y2=1.655
r360 (  7 29 ) resistor r=0.0913624 //w=0.191 //l=0.12 //layer=m1 \
 //thickness=0.36 //x=2.15 //y=1.12 //x2=2.15 //y2=1
r361 (  7 8 ) resistor r=0.429389 //w=0.131 //l=0.45 //layer=m1 \
 //thickness=0.36 //x=2.15 //y=1.12 //x2=2.15 //y2=1.57
r362 (  4 21 ) resistor r=0.0227762 //w=0.219 //l=0.115 //layer=m1 \
 //thickness=0.36 //x=1.345 //y=5.2 //x2=1.23 //y2=5.2
r363 (  3 24 ) resistor r=0.0257089 //w=0.23 //l=0.115 //layer=m1 \
 //thickness=0.36 //x=1.995 //y=5.2 //x2=2.11 //y2=5.2
r364 (  3 4 ) resistor r=0.620229 //w=0.131 //l=0.65 //layer=m1 \
 //thickness=0.36 //x=1.995 //y=5.2 //x2=1.345 //y2=5.2
ends PM_AOAI4X1_PCELL\%noxref_1

subckt PM_AOAI4X1_PCELL\%noxref_2 ( 1 2 3 4 5 6 7 9 12 13 14 16 17 22 30 34 36 \
 39 40 47 49 50 58 75 84 88 89 90 91 92 93 94 98 100 103 104 114 117 118 121 )
c267 ( 118 0 ) capacitor c=0.00901091f //x=5.29 //y=0.905
c268 ( 117 0 ) capacitor c=0.00876479f //x=4.32 //y=0.905
c269 ( 114 0 ) capacitor c=0.0682508f //x=7.77 //y=4.7
c270 ( 104 0 ) capacitor c=0.0318956f //x=8.105 //y=1.21
c271 ( 103 0 ) capacitor c=0.0186809f //x=8.105 //y=0.865
c272 ( 100 0 ) capacitor c=0.0141821f //x=7.95 //y=1.365
c273 ( 98 0 ) capacitor c=0.0158553f //x=7.95 //y=0.71
c274 ( 94 0 ) capacitor c=0.0815046f //x=7.575 //y=1.915
c275 ( 93 0 ) capacitor c=0.0229235f //x=7.575 //y=1.52
c276 ( 92 0 ) capacitor c=0.0234359f //x=7.575 //y=1.21
c277 ( 91 0 ) capacitor c=0.0198759f //x=7.575 //y=0.865
c278 ( 90 0 ) capacitor c=0.110369f //x=8.11 //y=6.02
c279 ( 89 0 ) capacitor c=0.154619f //x=7.67 //y=6.02
c280 ( 84 0 ) capacitor c=8.13451e-19 //x=7.77 //y=4.7
c281 ( 75 0 ) capacitor c=5.17312e-19 //x=7.77 //y=2.08
c282 ( 58 0 ) capacitor c=0.0245539f //x=5.44 //y=5.38
c283 ( 50 0 ) capacitor c=0.0772176f //x=7.6 //y=2.585
c284 ( 49 0 ) capacitor c=0.00407557f //x=7.76 //y=2.585
c285 ( 47 0 ) capacitor c=0.00547085f //x=6.075 //y=2.585
c286 ( 40 0 ) capacitor c=0.0619196f //x=7.772 //y=4.56
c287 ( 39 0 ) capacitor c=0.00635496f //x=7.77 //y=4.7
c288 ( 36 0 ) capacitor c=0.00617935f //x=7.77 //y=2.08
c289 ( 34 0 ) capacitor c=0.0145932f //x=7.77 //y=2.59
c290 ( 30 0 ) capacitor c=0.0143422f //x=5.92 //y=2.59
c291 ( 22 0 ) capacitor c=0.0136691f //x=5.435 //y=5.21
c292 ( 21 0 ) capacitor c=0.00513603f //x=5.48 //y=1.655
c293 ( 17 0 ) capacitor c=0.0114695f //x=7.77 //y=2.745
c294 ( 16 0 ) capacitor c=0.0044026f //x=7.77 //y=2.425
c295 ( 14 0 ) capacitor c=0.0761917f //x=5.92 //y=5.125
c296 ( 13 0 ) capacitor c=0.0124328f //x=5.92 //y=2.745
c297 ( 12 0 ) capacitor c=0.0173317f //x=5.92 //y=2.425
c298 ( 9 0 ) capacitor c=0.0141638f //x=5.835 //y=1.655
c299 ( 7 0 ) capacitor c=0.0112568f //x=5.835 //y=5.21
c300 ( 6 0 ) capacitor c=0.00792854f //x=5.48 //y=1.57
c301 ( 5 0 ) capacitor c=0.00855942f //x=5.48 //y=1.12
c302 ( 4 0 ) capacitor c=0.00230949f //x=4.595 //y=1.655
c303 ( 3 0 ) capacitor c=0.0217217f //x=5.395 //y=1.655
c304 ( 2 0 ) capacitor c=0.00638036f //x=4.51 //y=1.57
c305 ( 1 0 ) capacitor c=0.00825276f //x=4.51 //y=1.125
r306 (  112 114 ) resistor r=20.6867 //w=0.233 //l=0.1 //layer=ply \
 //thickness=0.18 //x=7.67 //y=4.7 //x2=7.77 //y2=4.7
r307 (  105 114 ) resistor r=70.3348 //w=0.233 //l=0.414367 //layer=ply \
 //thickness=0.18 //x=8.11 //y=4.865 //x2=7.77 //y2=4.7
r308 (  104 116 ) resistor r=45.1352 //w=0.168 //l=0.173853 //layer=ply \
 //thickness=0.18 //x=8.105 //y=1.21 //x2=8.065 //y2=1.365
r309 (  103 115 ) resistor r=45.1352 //w=0.168 //l=0.173853 //layer=ply \
 //thickness=0.18 //x=8.105 //y=0.865 //x2=8.065 //y2=0.71
r310 (  103 104 ) resistor r=176.904 //w=0.094 //l=0.345 //layer=ply \
 //thickness=0.18 //x=8.105 //y=0.865 //x2=8.105 //y2=1.21
r311 (  101 111 ) resistor r=10.701 //w=0.21 //l=0.115 //layer=ply \
 //thickness=0.18 //x=7.73 //y=1.365 //x2=7.615 //y2=1.365
r312 (  100 116 ) resistor r=5.52526 //w=0.168 //l=0.115 //layer=ply \
 //thickness=0.18 //x=7.95 //y=1.365 //x2=8.065 //y2=1.365
r313 (  99 110 ) resistor r=5.52526 //w=0.168 //l=0.115 //layer=ply \
 //thickness=0.18 //x=7.73 //y=0.71 //x2=7.615 //y2=0.71
r314 (  98 115 ) resistor r=5.52526 //w=0.168 //l=0.115 //layer=ply \
 //thickness=0.18 //x=7.95 //y=0.71 //x2=8.065 //y2=0.71
r315 (  98 99 ) resistor r=112.809 //w=0.094 //l=0.22 //layer=ply \
 //thickness=0.18 //x=7.95 //y=0.71 //x2=7.73 //y2=0.71
r316 (  95 112 ) resistor r=13.0941 //w=0.233 //l=0.165 //layer=ply \
 //thickness=0.18 //x=7.67 //y=4.865 //x2=7.67 //y2=4.7
r317 (  94 109 ) resistor r=34.8111 //w=0.27 //l=0.264953 //layer=ply \
 //thickness=0.18 //x=7.575 //y=1.915 //x2=7.77 //y2=2.08
r318 (  93 111 ) resistor r=39.5823 //w=0.21 //l=0.173853 //layer=ply \
 //thickness=0.18 //x=7.575 //y=1.52 //x2=7.615 //y2=1.365
r319 (  93 94 ) resistor r=202.543 //w=0.094 //l=0.395 //layer=ply \
 //thickness=0.18 //x=7.575 //y=1.52 //x2=7.575 //y2=1.915
r320 (  92 111 ) resistor r=39.5823 //w=0.21 //l=0.173853 //layer=ply \
 //thickness=0.18 //x=7.575 //y=1.21 //x2=7.615 //y2=1.365
r321 (  91 110 ) resistor r=45.1352 //w=0.168 //l=0.173853 //layer=ply \
 //thickness=0.18 //x=7.575 //y=0.865 //x2=7.615 //y2=0.71
r322 (  91 92 ) resistor r=176.904 //w=0.094 //l=0.345 //layer=ply \
 //thickness=0.18 //x=7.575 //y=0.865 //x2=7.575 //y2=1.21
r323 (  90 105 ) resistor r=592.245 //w=0.094 //l=1.155 //layer=ply \
 //thickness=0.18 //x=8.11 //y=6.02 //x2=8.11 //y2=4.865
r324 (  89 95 ) resistor r=592.245 //w=0.094 //l=1.155 //layer=ply \
 //thickness=0.18 //x=7.67 //y=6.02 //x2=7.67 //y2=4.865
r325 (  88 100 ) resistor r=56.4043 //w=0.094 //l=0.11 //layer=ply \
 //thickness=0.18 //x=7.84 //y=1.365 //x2=7.95 //y2=1.365
r326 (  88 101 ) resistor r=56.4043 //w=0.094 //l=0.11 //layer=ply \
 //thickness=0.18 //x=7.84 //y=1.365 //x2=7.73 //y2=1.365
r327 (  84 114 ) resistor r=152 //w=0.17 //l=0.17 //layer=licon //count=1 \
 //x=7.77 //y=4.7 //x2=7.77 //y2=4.7
r328 (  75 109 ) resistor r=152 //w=0.17 //l=0.17 //layer=licon //count=1 \
 //x=7.77 //y=2.08 //x2=7.77 //y2=2.08
r329 (  58 121 ) resistor r=23.2727 //w=0.187 //l=0.34 //layer=li \
 //thickness=0.1 //x=5.44 //y=5.38 //x2=5.44 //y2=5.72
r330 (  49 50 ) resistor r=0.104807 //w=0.281 //l=0.16 //layer=m2 \
 //thickness=0.36 //x=7.76 //y=2.585 //x2=7.6 //y2=2.585
r331 (  47 50 ) resistor r=1.40165 //w=0.136 //l=1.525 //layer=m2 \
 //thickness=0.36 //x=6.075 //y=2.587 //x2=7.6 //y2=2.587
r332 (  45 47 ) resistor r=0.104807 //w=0.281 //l=0.16 //layer=m2 \
 //thickness=0.36 //x=5.915 //y=2.585 //x2=6.075 //y2=2.585
r333 (  39 84 ) resistor r=9.3 //w=0.17 //l=0.17 //layer=mcon //count=1 \
 //x=7.77 //y=4.7 //x2=7.77 //y2=4.7
r334 (  39 40 ) resistor r=0.103207 //w=0.196 //l=0.14 //layer=m1 \
 //thickness=0.36 //x=7.772 //y=4.7 //x2=7.772 //y2=4.56
r335 (  36 75 ) resistor r=9.3 //w=0.17 //l=0.17 //layer=mcon //count=1 \
 //x=7.77 //y=2.08 //x2=7.77 //y2=2.08
r336 (  32 49 ) resistor r=4.5 //w=0.15 //l=0.15 //layer=via1 //count=1 \
 //x=7.76 //y=2.585 //x2=7.76 //y2=2.585
r337 (  32 34 ) resistor r=0.00168464 //w=0.371 //l=0.005 //layer=m1 \
 //thickness=0.36 //x=7.712 //y=2.585 //x2=7.712 //y2=2.59
r338 (  28 45 ) resistor r=4.5 //w=0.15 //l=0.15 //layer=via1 //count=1 \
 //x=5.915 //y=2.585 //x2=5.915 //y2=2.585
r339 (  28 30 ) resistor r=0.00164908 //w=0.379 //l=0.005 //layer=m1 \
 //thickness=0.36 //x=5.97 //y=2.585 //x2=5.97 //y2=2.59
r340 (  26 118 ) resistor r=9.3 //w=0.17 //l=0.17 //layer=mcon //count=1 \
 //x=5.48 //y=1 //x2=5.48 //y2=1
r341 (  24 58 ) resistor r=9.3 //w=0.17 //l=0.17 //layer=mcon //count=1 \
 //x=5.44 //y=5.38 //x2=5.44 //y2=5.38
r342 (  22 24 ) resistor r=0.0974771 //w=0.218 //l=0.17 //layer=m1 \
 //thickness=0.36 //x=5.435 //y=5.21 //x2=5.435 //y2=5.38
r343 (  20 117 ) resistor r=9.3 //w=0.17 //l=0.17 //layer=mcon //count=1 \
 //x=4.51 //y=1 //x2=4.51 //y2=1
r344 (  17 34 ) resistor r=0.0892801 //w=0.371 //l=0.1817 //layer=m1 \
 //thickness=0.36 //x=7.77 //y=2.745 //x2=7.712 //y2=2.59
r345 (  17 40 ) resistor r=1.73187 //w=0.131 //l=1.815 //layer=m1 \
 //thickness=0.36 //x=7.77 //y=2.745 //x2=7.77 //y2=4.56
r346 (  16 32 ) resistor r=0.0909648 //w=0.371 //l=0.186762 //layer=m1 \
 //thickness=0.36 //x=7.77 //y=2.425 //x2=7.712 //y2=2.585
r347 (  15 36 ) resistor r=0.0933015 //w=0.201 //l=0.125 //layer=m1 \
 //thickness=0.36 //x=7.77 //y=2.205 //x2=7.77 //y2=2.08
r348 (  15 16 ) resistor r=0.209924 //w=0.131 //l=0.22 //layer=m1 \
 //thickness=0.36 //x=7.77 //y=2.205 //x2=7.77 //y2=2.425
r349 (  13 30 ) resistor r=0.0896323 //w=0.379 //l=0.178255 //layer=m1 \
 //thickness=0.36 //x=5.92 //y=2.745 //x2=5.97 //y2=2.59
r350 (  13 14 ) resistor r=2.27099 //w=0.131 //l=2.38 //layer=m1 \
 //thickness=0.36 //x=5.92 //y=2.745 //x2=5.92 //y2=5.125
r351 (  12 28 ) resistor r=0.0912814 //w=0.379 //l=0.183303 //layer=m1 \
 //thickness=0.36 //x=5.92 //y=2.425 //x2=5.97 //y2=2.585
r352 (  11 12 ) resistor r=0.653626 //w=0.131 //l=0.685 //layer=m1 \
 //thickness=0.36 //x=5.92 //y=1.74 //x2=5.92 //y2=2.425
r353 (  10 21 ) resistor r=0.0529306 //w=0.17 //l=0.085 //layer=m1 \
 //thickness=0.36 //x=5.565 //y=1.655 //x2=5.48 //y2=1.655
r354 (  9 11 ) resistor r=0.0698411 //w=0.17 //l=0.120208 //layer=m1 \
 //thickness=0.36 //x=5.835 //y=1.655 //x2=5.92 //y2=1.74
r355 (  9 10 ) resistor r=0.257634 //w=0.131 //l=0.27 //layer=m1 \
 //thickness=0.36 //x=5.835 //y=1.655 //x2=5.565 //y2=1.655
r356 (  8 22 ) resistor r=0.0225019 //w=0.218 //l=0.12 //layer=m1 \
 //thickness=0.36 //x=5.555 //y=5.21 //x2=5.435 //y2=5.21
r357 (  7 14 ) resistor r=0.0698411 //w=0.17 //l=0.120208 //layer=m1 \
 //thickness=0.36 //x=5.835 //y=5.21 //x2=5.92 //y2=5.125
r358 (  7 8 ) resistor r=0.267176 //w=0.131 //l=0.28 //layer=m1 \
 //thickness=0.36 //x=5.835 //y=5.21 //x2=5.555 //y2=5.21
r359 (  6 21 ) resistor r=0.0137558 //w=0.34 //l=0.085 //layer=m1 \
 //thickness=0.36 //x=5.48 //y=1.57 //x2=5.48 //y2=1.655
r360 (  5 26 ) resistor r=0.0728765 //w=0.25 //l=0.121491 //layer=m1 \
 //thickness=0.36 //x=5.48 //y=1.12 //x2=5.477 //y2=1
r361 (  5 6 ) resistor r=0.429389 //w=0.131 //l=0.45 //layer=m1 \
 //thickness=0.36 //x=5.48 //y=1.12 //x2=5.48 //y2=1.57
r362 (  3 21 ) resistor r=0.0529306 //w=0.17 //l=0.085 //layer=m1 \
 //thickness=0.36 //x=5.395 //y=1.655 //x2=5.48 //y2=1.655
r363 (  3 4 ) resistor r=0.763359 //w=0.131 //l=0.8 //layer=m1 \
 //thickness=0.36 //x=5.395 //y=1.655 //x2=4.595 //y2=1.655
r364 (  2 4 ) resistor r=0.0698411 //w=0.17 //l=0.120208 //layer=m1 \
 //thickness=0.36 //x=4.51 //y=1.57 //x2=4.595 //y2=1.655
r365 (  1 20 ) resistor r=0.0764279 //w=0.233 //l=0.126491 //layer=m1 \
 //thickness=0.36 //x=4.51 //y=1.125 //x2=4.507 //y2=1
r366 (  1 2 ) resistor r=0.424618 //w=0.131 //l=0.445 //layer=m1 \
 //thickness=0.36 //x=4.51 //y=1.125 //x2=4.51 //y2=1.57
ends PM_AOAI4X1_PCELL\%noxref_2

subckt PM_AOAI4X1_PCELL\%noxref_3 ( 1 11 12 21 42 50 66 93 103 116 119 120 124 \
 125 126 127 128 129 130 131 )
c193 ( 131 0 ) capacitor c=0.0392195f //x=9.065 //y=5.02
c194 ( 130 0 ) capacitor c=0.024747f //x=8.185 //y=5.02
c195 ( 129 0 ) capacitor c=0.0652533f //x=7.315 //y=5.02
c196 ( 128 0 ) capacitor c=0.0230094f //x=4.415 //y=5.025
c197 ( 127 0 ) capacitor c=0.0399063f //x=2.405 //y=5.02
c198 ( 126 0 ) capacitor c=0.0247431f //x=1.525 //y=5.02
c199 ( 125 0 ) capacitor c=0.0678024f //x=0.655 //y=5.02
c200 ( 124 0 ) capacitor c=0.249911f //x=9.25 //y=7.4
c201 ( 122 0 ) capacitor c=0.00591168f //x=8.33 //y=7.4
c202 ( 121 0 ) capacitor c=0.00591168f //x=7.45 //y=7.4
c203 ( 120 0 ) capacitor c=0.130552f //x=6.66 //y=7.4
c204 ( 119 0 ) capacitor c=0.126437f //x=3.33 //y=7.4
c205 ( 118 0 ) capacitor c=0.00591168f //x=2.55 //y=7.4
c206 ( 117 0 ) capacitor c=0.00591168f //x=1.67 //y=7.4
c207 ( 116 0 ) capacitor c=0.253139f //x=0.74 //y=7.4
c208 ( 103 0 ) capacitor c=0.0284687f //x=9.125 //y=7.4
c209 ( 93 0 ) capacitor c=0.0288404f //x=8.245 //y=7.4
c210 ( 81 0 ) capacitor c=0.0281468f //x=7.365 //y=7.4
c211 ( 66 0 ) capacitor c=0.137893f //x=6.49 //y=7.4
c212 ( 60 0 ) capacitor c=0.0275781f //x=3.16 //y=7.4
c213 ( 50 0 ) capacitor c=0.0284687f //x=2.465 //y=7.4
c214 ( 42 0 ) capacitor c=0.0288404f //x=1.585 //y=7.4
c215 ( 25 0 ) capacitor c=0.00498911f //x=4.56 //y=7.4
c216 ( 21 0 ) capacitor c=0.203116f //x=9.25 //y=7.4
c217 ( 12 0 ) capacitor c=0.00916089f //x=4.56 //y=7.23
c218 ( 11 0 ) capacitor c=0.00572492f //x=4.56 //y=6.855
c219 ( 1 0 ) capacitor c=0.17911f //x=4.475 //y=7.4
r220 (  105 124 ) resistor r=4.11603 //w=0.68 //l=0.17 //layer=li \
 //thickness=0.1 //x=9.21 //y=7.23 //x2=9.21 //y2=7.4
r221 (  105 131 ) resistor r=33.1979 //w=0.187 //l=0.485 //layer=li \
 //thickness=0.1 //x=9.21 //y=7.23 //x2=9.21 //y2=6.745
r222 (  104 122 ) resistor r=2.94794 //w=0.34 //l=0.085 //layer=li \
 //thickness=0.1 //x=8.415 //y=7.4 //x2=8.33 //y2=7.4
r223 (  103 124 ) resistor r=2.94794 //w=0.34 //l=0.085 //layer=li \
 //thickness=0.1 //x=9.125 //y=7.4 //x2=9.21 //y2=7.4
r224 (  103 104 ) resistor r=25.4566 //w=0.357 //l=0.71 //layer=li \
 //thickness=0.1 //x=9.125 //y=7.4 //x2=8.415 //y2=7.4
r225 (  97 122 ) resistor r=4.11603 //w=0.68 //l=0.17 //layer=li \
 //thickness=0.1 //x=8.33 //y=7.23 //x2=8.33 //y2=7.4
r226 (  97 130 ) resistor r=33.1979 //w=0.187 //l=0.485 //layer=li \
 //thickness=0.1 //x=8.33 //y=7.23 //x2=8.33 //y2=6.745
r227 (  94 121 ) resistor r=2.94794 //w=0.34 //l=0.085 //layer=li \
 //thickness=0.1 //x=7.535 //y=7.4 //x2=7.45 //y2=7.4
r228 (  94 96 ) resistor r=21.6919 //w=0.357 //l=0.605 //layer=li \
 //thickness=0.1 //x=7.535 //y=7.4 //x2=8.14 //y2=7.4
r229 (  93 122 ) resistor r=2.94794 //w=0.34 //l=0.085 //layer=li \
 //thickness=0.1 //x=8.245 //y=7.4 //x2=8.33 //y2=7.4
r230 (  93 96 ) resistor r=3.76471 //w=0.357 //l=0.105 //layer=li \
 //thickness=0.1 //x=8.245 //y=7.4 //x2=8.14 //y2=7.4
r231 (  85 121 ) resistor r=4.11603 //w=0.68 //l=0.17 //layer=li \
 //thickness=0.1 //x=7.45 //y=7.23 //x2=7.45 //y2=7.4
r232 (  85 129 ) resistor r=56.4706 //w=0.187 //l=0.825 //layer=li \
 //thickness=0.1 //x=7.45 //y=7.23 //x2=7.45 //y2=6.405
r233 (  82 120 ) resistor r=5.4201 //w=0.34 //l=0.17 //layer=li \
 //thickness=0.1 //x=6.83 //y=7.4 //x2=6.66 //y2=7.4
r234 (  82 84 ) resistor r=7.17087 //w=0.357 //l=0.2 //layer=li \
 //thickness=0.1 //x=6.83 //y=7.4 //x2=7.03 //y2=7.4
r235 (  81 121 ) resistor r=2.94794 //w=0.34 //l=0.085 //layer=li \
 //thickness=0.1 //x=7.365 //y=7.4 //x2=7.45 //y2=7.4
r236 (  81 84 ) resistor r=12.0112 //w=0.357 //l=0.335 //layer=li \
 //thickness=0.1 //x=7.365 //y=7.4 //x2=7.03 //y2=7.4
r237 (  69 71 ) resistor r=39.7983 //w=0.357 //l=1.11 //layer=li \
 //thickness=0.1 //x=4.44 //y=7.4 //x2=5.55 //y2=7.4
r238 (  67 119 ) resistor r=5.4201 //w=0.34 //l=0.17 //layer=li \
 //thickness=0.1 //x=3.5 //y=7.4 //x2=3.33 //y2=7.4
r239 (  67 69 ) resistor r=33.7031 //w=0.357 //l=0.94 //layer=li \
 //thickness=0.1 //x=3.5 //y=7.4 //x2=4.44 //y2=7.4
r240 (  66 120 ) resistor r=5.4201 //w=0.34 //l=0.17 //layer=li \
 //thickness=0.1 //x=6.49 //y=7.4 //x2=6.66 //y2=7.4
r241 (  66 71 ) resistor r=33.7031 //w=0.357 //l=0.94 //layer=li \
 //thickness=0.1 //x=6.49 //y=7.4 //x2=5.55 //y2=7.4
r242 (  61 118 ) resistor r=2.94794 //w=0.34 //l=0.085 //layer=li \
 //thickness=0.1 //x=2.635 //y=7.4 //x2=2.55 //y2=7.4
r243 (  61 63 ) resistor r=11.6527 //w=0.357 //l=0.325 //layer=li \
 //thickness=0.1 //x=2.635 //y=7.4 //x2=2.96 //y2=7.4
r244 (  60 119 ) resistor r=5.4201 //w=0.34 //l=0.17 //layer=li \
 //thickness=0.1 //x=3.16 //y=7.4 //x2=3.33 //y2=7.4
r245 (  60 63 ) resistor r=7.17087 //w=0.357 //l=0.2 //layer=li \
 //thickness=0.1 //x=3.16 //y=7.4 //x2=2.96 //y2=7.4
r246 (  54 118 ) resistor r=4.11603 //w=0.68 //l=0.17 //layer=li \
 //thickness=0.1 //x=2.55 //y=7.23 //x2=2.55 //y2=7.4
r247 (  54 127 ) resistor r=33.1979 //w=0.187 //l=0.485 //layer=li \
 //thickness=0.1 //x=2.55 //y=7.23 //x2=2.55 //y2=6.745
r248 (  51 117 ) resistor r=2.94794 //w=0.34 //l=0.085 //layer=li \
 //thickness=0.1 //x=1.755 //y=7.4 //x2=1.67 //y2=7.4
r249 (  51 53 ) resistor r=3.40616 //w=0.357 //l=0.095 //layer=li \
 //thickness=0.1 //x=1.755 //y=7.4 //x2=1.85 //y2=7.4
r250 (  50 118 ) resistor r=2.94794 //w=0.34 //l=0.085 //layer=li \
 //thickness=0.1 //x=2.465 //y=7.4 //x2=2.55 //y2=7.4
r251 (  50 53 ) resistor r=22.0504 //w=0.357 //l=0.615 //layer=li \
 //thickness=0.1 //x=2.465 //y=7.4 //x2=1.85 //y2=7.4
r252 (  44 117 ) resistor r=4.11603 //w=0.68 //l=0.17 //layer=li \
 //thickness=0.1 //x=1.67 //y=7.23 //x2=1.67 //y2=7.4
r253 (  44 126 ) resistor r=33.1979 //w=0.187 //l=0.485 //layer=li \
 //thickness=0.1 //x=1.67 //y=7.23 //x2=1.67 //y2=6.745
r254 (  43 116 ) resistor r=2.94794 //w=0.34 //l=0.085 //layer=li \
 //thickness=0.1 //x=0.875 //y=7.4 //x2=0.79 //y2=7.4
r255 (  42 117 ) resistor r=2.94794 //w=0.34 //l=0.085 //layer=li \
 //thickness=0.1 //x=1.585 //y=7.4 //x2=1.67 //y2=7.4
r256 (  42 43 ) resistor r=25.4566 //w=0.357 //l=0.71 //layer=li \
 //thickness=0.1 //x=1.585 //y=7.4 //x2=0.875 //y2=7.4
r257 (  34 116 ) resistor r=4.11603 //w=0.68 //l=0.17 //layer=li \
 //thickness=0.1 //x=0.79 //y=7.23 //x2=0.79 //y2=7.4
r258 (  34 125 ) resistor r=56.4706 //w=0.187 //l=0.825 //layer=li \
 //thickness=0.1 //x=0.79 //y=7.23 //x2=0.79 //y2=6.405
r259 (  27 128 ) resistor r=9.3 //w=0.17 //l=0.17 //layer=mcon //count=1 \
 //x=4.56 //y=6.74 //x2=4.56 //y2=6.74
r260 (  21 124 ) resistor r=3.1 //w=0.17 //l=0.51 //layer=mcon //count=3 \
 //x=9.25 //y=7.4 //x2=9.25 //y2=7.4
r261 (  19 96 ) resistor r=3.1 //w=0.17 //l=0.51 //layer=mcon //count=3 \
 //x=8.14 //y=7.4 //x2=8.14 //y2=7.4
r262 (  19 21 ) resistor r=0.460963 //w=0.301 //l=1.11 //layer=m1 \
 //thickness=0.36 //x=8.14 //y=7.4 //x2=9.25 //y2=7.4
r263 (  17 84 ) resistor r=3.1 //w=0.17 //l=0.51 //layer=mcon //count=3 \
 //x=7.03 //y=7.4 //x2=7.03 //y2=7.4
r264 (  17 19 ) resistor r=0.460963 //w=0.301 //l=1.11 //layer=m1 \
 //thickness=0.36 //x=7.03 //y=7.4 //x2=8.14 //y2=7.4
r265 (  15 71 ) resistor r=3.1 //w=0.17 //l=0.51 //layer=mcon //count=3 \
 //x=5.55 //y=7.4 //x2=5.55 //y2=7.4
r266 (  15 17 ) resistor r=0.614618 //w=0.301 //l=1.48 //layer=m1 \
 //thickness=0.36 //x=5.55 //y=7.4 //x2=7.03 //y2=7.4
r267 (  13 25 ) resistor r=0.0287885 //w=0.34 //l=0.085 //layer=m1 \
 //thickness=0.36 //x=4.645 //y=7.4 //x2=4.56 //y2=7.4
r268 (  13 15 ) resistor r=0.375831 //w=0.301 //l=0.905 //layer=m1 \
 //thickness=0.36 //x=4.645 //y=7.4 //x2=5.55 //y2=7.4
r269 (  12 25 ) resistor r=0.0401957 //w=0.68 //l=0.17 //layer=m1 \
 //thickness=0.36 //x=4.56 //y=7.23 //x2=4.56 //y2=7.4
r270 (  11 27 ) resistor r=0.0723371 //w=0.218 //l=0.115 //layer=m1 \
 //thickness=0.36 //x=4.56 //y=6.855 //x2=4.56 //y2=6.74
r271 (  11 12 ) resistor r=0.357824 //w=0.131 //l=0.375 //layer=m1 \
 //thickness=0.36 //x=4.56 //y=6.855 //x2=4.56 //y2=7.23
r272 (  10 69 ) resistor r=3.1 //w=0.17 //l=0.51 //layer=mcon //count=3 \
 //x=4.44 //y=7.4 //x2=4.44 //y2=7.4
r273 (  8 63 ) resistor r=3.1 //w=0.17 //l=0.51 //layer=mcon //count=3 \
 //x=2.96 //y=7.4 //x2=2.96 //y2=7.4
r274 (  8 10 ) resistor r=0.614618 //w=0.301 //l=1.48 //layer=m1 \
 //thickness=0.36 //x=2.96 //y=7.4 //x2=4.44 //y2=7.4
r275 (  6 53 ) resistor r=3.1 //w=0.17 //l=0.51 //layer=mcon //count=3 \
 //x=1.85 //y=7.4 //x2=1.85 //y2=7.4
r276 (  6 8 ) resistor r=0.460963 //w=0.301 //l=1.11 //layer=m1 \
 //thickness=0.36 //x=1.85 //y=7.4 //x2=2.96 //y2=7.4
r277 (  3 116 ) resistor r=3.1 //w=0.17 //l=0.51 //layer=mcon //count=3 \
 //x=0.74 //y=7.4 //x2=0.74 //y2=7.4
r278 (  3 6 ) resistor r=0.460963 //w=0.301 //l=1.11 //layer=m1 \
 //thickness=0.36 //x=0.74 //y=7.4 //x2=1.85 //y2=7.4
r279 (  1 25 ) resistor r=0.0287885 //w=0.34 //l=0.085 //layer=m1 \
 //thickness=0.36 //x=4.475 //y=7.4 //x2=4.56 //y2=7.4
r280 (  1 10 ) resistor r=0.0145349 //w=0.301 //l=0.035 //layer=m1 \
 //thickness=0.36 //x=4.475 //y=7.4 //x2=4.44 //y2=7.4
ends PM_AOAI4X1_PCELL\%noxref_3

subckt PM_AOAI4X1_PCELL\%noxref_4 ( 4 7 8 11 16 20 21 22 23 24 25 26 30 32 35 \
 36 46 )
c96 ( 46 0 ) capacitor c=0.0682508f //x=1.11 //y=4.7
c97 ( 36 0 ) capacitor c=0.0318956f //x=1.445 //y=1.21
c98 ( 35 0 ) capacitor c=0.0186809f //x=1.445 //y=0.865
c99 ( 32 0 ) capacitor c=0.0141821f //x=1.29 //y=1.365
c100 ( 30 0 ) capacitor c=0.0158553f //x=1.29 //y=0.71
c101 ( 26 0 ) capacitor c=0.088055f //x=0.915 //y=1.915
c102 ( 25 0 ) capacitor c=0.0229235f //x=0.915 //y=1.52
c103 ( 24 0 ) capacitor c=0.0234359f //x=0.915 //y=1.21
c104 ( 23 0 ) capacitor c=0.0198759f //x=0.915 //y=0.865
c105 ( 22 0 ) capacitor c=0.110369f //x=1.45 //y=6.02
c106 ( 21 0 ) capacitor c=0.154619f //x=1.01 //y=6.02
c107 ( 16 0 ) capacitor c=8.13451e-19 //x=1.11 //y=4.7
c108 ( 11 0 ) capacitor c=7.85889e-19 //x=1.11 //y=2.08
c109 ( 8 0 ) capacitor c=0.10646f //x=1.112 //y=4.56
c110 ( 7 0 ) capacitor c=0.0113945f //x=1.11 //y=4.7
c111 ( 4 0 ) capacitor c=0.0108617f //x=1.11 //y=2.08
r112 (  44 46 ) resistor r=20.6867 //w=0.233 //l=0.1 //layer=ply \
 //thickness=0.18 //x=1.01 //y=4.7 //x2=1.11 //y2=4.7
r113 (  37 46 ) resistor r=70.3348 //w=0.233 //l=0.414367 //layer=ply \
 //thickness=0.18 //x=1.45 //y=4.865 //x2=1.11 //y2=4.7
r114 (  36 48 ) resistor r=45.1352 //w=0.168 //l=0.173853 //layer=ply \
 //thickness=0.18 //x=1.445 //y=1.21 //x2=1.405 //y2=1.365
r115 (  35 47 ) resistor r=45.1352 //w=0.168 //l=0.173853 //layer=ply \
 //thickness=0.18 //x=1.445 //y=0.865 //x2=1.405 //y2=0.71
r116 (  35 36 ) resistor r=176.904 //w=0.094 //l=0.345 //layer=ply \
 //thickness=0.18 //x=1.445 //y=0.865 //x2=1.445 //y2=1.21
r117 (  33 43 ) resistor r=10.701 //w=0.21 //l=0.115 //layer=ply \
 //thickness=0.18 //x=1.07 //y=1.365 //x2=0.955 //y2=1.365
r118 (  32 48 ) resistor r=5.52526 //w=0.168 //l=0.115 //layer=ply \
 //thickness=0.18 //x=1.29 //y=1.365 //x2=1.405 //y2=1.365
r119 (  31 42 ) resistor r=5.52526 //w=0.168 //l=0.115 //layer=ply \
 //thickness=0.18 //x=1.07 //y=0.71 //x2=0.955 //y2=0.71
r120 (  30 47 ) resistor r=5.52526 //w=0.168 //l=0.115 //layer=ply \
 //thickness=0.18 //x=1.29 //y=0.71 //x2=1.405 //y2=0.71
r121 (  30 31 ) resistor r=112.809 //w=0.094 //l=0.22 //layer=ply \
 //thickness=0.18 //x=1.29 //y=0.71 //x2=1.07 //y2=0.71
r122 (  27 44 ) resistor r=13.0941 //w=0.233 //l=0.165 //layer=ply \
 //thickness=0.18 //x=1.01 //y=4.865 //x2=1.01 //y2=4.7
r123 (  26 41 ) resistor r=34.8111 //w=0.27 //l=0.264953 //layer=ply \
 //thickness=0.18 //x=0.915 //y=1.915 //x2=1.11 //y2=2.08
r124 (  25 43 ) resistor r=39.5823 //w=0.21 //l=0.173853 //layer=ply \
 //thickness=0.18 //x=0.915 //y=1.52 //x2=0.955 //y2=1.365
r125 (  25 26 ) resistor r=202.543 //w=0.094 //l=0.395 //layer=ply \
 //thickness=0.18 //x=0.915 //y=1.52 //x2=0.915 //y2=1.915
r126 (  24 43 ) resistor r=39.5823 //w=0.21 //l=0.173853 //layer=ply \
 //thickness=0.18 //x=0.915 //y=1.21 //x2=0.955 //y2=1.365
r127 (  23 42 ) resistor r=45.1352 //w=0.168 //l=0.173853 //layer=ply \
 //thickness=0.18 //x=0.915 //y=0.865 //x2=0.955 //y2=0.71
r128 (  23 24 ) resistor r=176.904 //w=0.094 //l=0.345 //layer=ply \
 //thickness=0.18 //x=0.915 //y=0.865 //x2=0.915 //y2=1.21
r129 (  22 37 ) resistor r=592.245 //w=0.094 //l=1.155 //layer=ply \
 //thickness=0.18 //x=1.45 //y=6.02 //x2=1.45 //y2=4.865
r130 (  21 27 ) resistor r=592.245 //w=0.094 //l=1.155 //layer=ply \
 //thickness=0.18 //x=1.01 //y=6.02 //x2=1.01 //y2=4.865
r131 (  20 32 ) resistor r=56.4043 //w=0.094 //l=0.11 //layer=ply \
 //thickness=0.18 //x=1.18 //y=1.365 //x2=1.29 //y2=1.365
r132 (  20 33 ) resistor r=56.4043 //w=0.094 //l=0.11 //layer=ply \
 //thickness=0.18 //x=1.18 //y=1.365 //x2=1.07 //y2=1.365
r133 (  16 46 ) resistor r=152 //w=0.17 //l=0.17 //layer=licon //count=1 \
 //x=1.11 //y=4.7 //x2=1.11 //y2=4.7
r134 (  11 41 ) resistor r=152 //w=0.17 //l=0.17 //layer=licon //count=1 \
 //x=1.11 //y=2.08 //x2=1.11 //y2=2.08
r135 (  7 16 ) resistor r=9.3 //w=0.17 //l=0.17 //layer=mcon //count=1 \
 //x=1.11 //y=4.7 //x2=1.11 //y2=4.7
r136 (  7 8 ) resistor r=0.103207 //w=0.196 //l=0.14 //layer=m1 \
 //thickness=0.36 //x=1.112 //y=4.7 //x2=1.112 //y2=4.56
r137 (  4 11 ) resistor r=9.3 //w=0.17 //l=0.17 //layer=mcon //count=1 \
 //x=1.11 //y=2.08 //x2=1.11 //y2=2.08
r138 (  1 4 ) resistor r=0.0933015 //w=0.201 //l=0.125 //layer=m1 \
 //thickness=0.36 //x=1.11 //y=2.205 //x2=1.11 //y2=2.08
r139 (  1 8 ) resistor r=2.24714 //w=0.131 //l=2.355 //layer=m1 \
 //thickness=0.36 //x=1.11 //y=2.205 //x2=1.11 //y2=4.56
ends PM_AOAI4X1_PCELL\%noxref_4

subckt PM_AOAI4X1_PCELL\%noxref_5 ( 2 4 10 15 19 20 21 22 23 24 29 31 33 39 40 \
 42 43 46 )
c104 ( 46 0 ) capacitor c=0.0393541f //x=1.88 //y=4.7
c105 ( 43 0 ) capacitor c=0.0284095f //x=1.85 //y=1.915
c106 ( 42 0 ) capacitor c=0.0476356f //x=1.85 //y=2.08
c107 ( 40 0 ) capacitor c=0.0439708f //x=2.415 //y=1.25
c108 ( 39 0 ) capacitor c=0.0192582f //x=2.415 //y=0.905
c109 ( 33 0 ) capacitor c=0.0162526f //x=2.26 //y=1.405
c110 ( 31 0 ) capacitor c=0.0157807f //x=2.26 //y=0.75
c111 ( 29 0 ) capacitor c=0.0372668f //x=2.255 //y=4.79
c112 ( 24 0 ) capacitor c=0.0210762f //x=1.885 //y=1.56
c113 ( 23 0 ) capacitor c=0.0168511f //x=1.885 //y=1.25
c114 ( 22 0 ) capacitor c=0.0175485f //x=1.885 //y=0.905
c115 ( 21 0 ) capacitor c=0.155269f //x=2.33 //y=6.02
c116 ( 20 0 ) capacitor c=0.110375f //x=1.89 //y=6.02
c117 ( 15 0 ) capacitor c=8.9038e-19 //x=1.88 //y=4.7
c118 ( 10 0 ) capacitor c=7.72439e-19 //x=1.85 //y=2.08
c119 ( 4 0 ) capacitor c=0.00687137f //x=1.85 //y=2.08
c120 ( 2 0 ) capacitor c=0.0640231f //x=1.85 //y=4.555
r121 (  48 49 ) resistor r=32.4568 //w=0.214 //l=0.075 //layer=ply \
 //thickness=0.18 //x=1.88 //y=4.79 //x2=1.88 //y2=4.865
r122 (  46 48 ) resistor r=20.271 //w=0.214 //l=0.09 //layer=ply \
 //thickness=0.18 //x=1.88 //y=4.7 //x2=1.88 //y2=4.79
r123 (  42 43 ) resistor r=52.7279 //w=0.214 //l=0.165 //layer=ply \
 //thickness=0.18 //x=1.85 //y=2.08 //x2=1.85 //y2=1.915
r124 (  40 53 ) resistor r=45.1352 //w=0.168 //l=0.173853 //layer=ply \
 //thickness=0.18 //x=2.415 //y=1.25 //x2=2.375 //y2=1.405
r125 (  39 52 ) resistor r=45.1352 //w=0.168 //l=0.173853 //layer=ply \
 //thickness=0.18 //x=2.415 //y=0.905 //x2=2.375 //y2=0.75
r126 (  39 40 ) resistor r=176.904 //w=0.094 //l=0.345 //layer=ply \
 //thickness=0.18 //x=2.415 //y=0.905 //x2=2.415 //y2=1.25
r127 (  34 51 ) resistor r=10.701 //w=0.21 //l=0.115 //layer=ply \
 //thickness=0.18 //x=2.04 //y=1.405 //x2=1.925 //y2=1.405
r128 (  33 53 ) resistor r=5.52526 //w=0.168 //l=0.115 //layer=ply \
 //thickness=0.18 //x=2.26 //y=1.405 //x2=2.375 //y2=1.405
r129 (  32 50 ) resistor r=5.52526 //w=0.168 //l=0.115 //layer=ply \
 //thickness=0.18 //x=2.04 //y=0.75 //x2=1.925 //y2=0.75
r130 (  31 52 ) resistor r=5.52526 //w=0.168 //l=0.115 //layer=ply \
 //thickness=0.18 //x=2.26 //y=0.75 //x2=2.375 //y2=0.75
r131 (  31 32 ) resistor r=112.809 //w=0.094 //l=0.22 //layer=ply \
 //thickness=0.18 //x=2.26 //y=0.75 //x2=2.04 //y2=0.75
r132 (  30 48 ) resistor r=16.5046 //w=0.27 //l=0.135 //layer=ply \
 //thickness=0.18 //x=2.015 //y=4.79 //x2=1.88 //y2=4.79
r133 (  29 36 ) resistor r=26.9307 //w=0.15 //l=0.106066 //layer=ply \
 //thickness=0.18 //x=2.255 //y=4.79 //x2=2.33 //y2=4.865
r134 (  29 30 ) resistor r=123.064 //w=0.094 //l=0.24 //layer=ply \
 //thickness=0.18 //x=2.255 //y=4.79 //x2=2.015 //y2=4.79
r135 (  24 51 ) resistor r=39.5823 //w=0.21 //l=0.173853 //layer=ply \
 //thickness=0.18 //x=1.885 //y=1.56 //x2=1.925 //y2=1.405
r136 (  24 43 ) resistor r=182.032 //w=0.094 //l=0.355 //layer=ply \
 //thickness=0.18 //x=1.885 //y=1.56 //x2=1.885 //y2=1.915
r137 (  23 51 ) resistor r=39.5823 //w=0.21 //l=0.173853 //layer=ply \
 //thickness=0.18 //x=1.885 //y=1.25 //x2=1.925 //y2=1.405
r138 (  22 50 ) resistor r=45.1352 //w=0.168 //l=0.173853 //layer=ply \
 //thickness=0.18 //x=1.885 //y=0.905 //x2=1.925 //y2=0.75
r139 (  22 23 ) resistor r=176.904 //w=0.094 //l=0.345 //layer=ply \
 //thickness=0.18 //x=1.885 //y=0.905 //x2=1.885 //y2=1.25
r140 (  21 36 ) resistor r=592.245 //w=0.094 //l=1.155 //layer=ply \
 //thickness=0.18 //x=2.33 //y=6.02 //x2=2.33 //y2=4.865
r141 (  20 49 ) resistor r=592.245 //w=0.094 //l=1.155 //layer=ply \
 //thickness=0.18 //x=1.89 //y=6.02 //x2=1.89 //y2=4.865
r142 (  19 33 ) resistor r=56.4043 //w=0.094 //l=0.11 //layer=ply \
 //thickness=0.18 //x=2.15 //y=1.405 //x2=2.26 //y2=1.405
r143 (  19 34 ) resistor r=56.4043 //w=0.094 //l=0.11 //layer=ply \
 //thickness=0.18 //x=2.15 //y=1.405 //x2=2.04 //y2=1.405
r144 (  15 46 ) resistor r=152 //w=0.17 //l=0.17 //layer=licon //count=1 \
 //x=1.88 //y=4.7 //x2=1.88 //y2=4.7
r145 (  10 42 ) resistor r=152 //w=0.17 //l=0.17 //layer=licon //count=1 \
 //x=1.85 //y=2.08 //x2=1.85 //y2=2.08
r146 (  8 15 ) resistor r=9.3 //w=0.17 //l=0.17 //layer=mcon //count=1 \
 //x=1.88 //y=4.7 //x2=1.88 //y2=4.7
r147 (  4 10 ) resistor r=9.3 //w=0.17 //l=0.17 //layer=mcon //count=1 \
 //x=1.85 //y=2.08 //x2=1.85 //y2=2.08
r148 (  4 6 ) resistor r=0.0936408 //w=0.196 //l=0.125 //layer=m1 \
 //thickness=0.36 //x=1.852 //y=2.08 //x2=1.852 //y2=2.205
r149 (  2 8 ) resistor r=0.0878548 //w=0.228 //l=0.159295 //layer=m1 \
 //thickness=0.36 //x=1.85 //y=4.555 //x2=1.88 //y2=4.7
r150 (  2 6 ) resistor r=2.24237 //w=0.131 //l=2.35 //layer=m1 \
 //thickness=0.36 //x=1.85 //y=4.555 //x2=1.85 //y2=2.205
ends PM_AOAI4X1_PCELL\%noxref_5

subckt PM_AOAI4X1_PCELL\%noxref_6 ( 1 3 5 10 14 17 20 30 46 47 48 )
c94 ( 48 0 ) capacitor c=0.0348842f //x=5.735 //y=5.025
c95 ( 46 0 ) capacitor c=0.0118024f //x=3.985 //y=5.025
c96 ( 30 0 ) capacitor c=0.0302598f //x=5 //y=5.38
c97 ( 20 0 ) capacitor c=0.045655f //x=4.12 //y=5.38
c98 ( 17 0 ) capacitor c=0.0164155f //x=5.88 //y=6.74
c99 ( 14 0 ) capacitor c=0.00604334f //x=5 //y=6.74
c100 ( 10 0 ) capacitor c=0.0112437f //x=5 //y=5.21
c101 ( 5 0 ) capacitor c=0.012947f //x=4.12 //y=5.21
c102 ( 3 0 ) capacitor c=0.00694548f //x=5.75 //y=6.91
c103 ( 1 0 ) capacitor c=0.0131356f //x=4.88 //y=5.21
r104 (  37 47 ) resistor r=23.2727 //w=0.187 //l=0.34 //layer=li \
 //thickness=0.1 //x=5 //y=6.74 //x2=5 //y2=6.4
r105 (  30 47 ) resistor r=23.2727 //w=0.187 //l=0.34 //layer=li \
 //thickness=0.1 //x=5 //y=5.38 //x2=5 //y2=5.72
r106 (  20 46 ) resistor r=23.2727 //w=0.187 //l=0.34 //layer=li \
 //thickness=0.1 //x=4.12 //y=5.38 //x2=4.12 //y2=5.72
r107 (  17 48 ) resistor r=9.3 //w=0.17 //l=0.17 //layer=mcon //count=1 \
 //x=5.88 //y=6.74 //x2=5.88 //y2=6.74
r108 (  17 18 ) resistor r=0.0932018 //w=0.228 //l=0.17 //layer=m1 \
 //thickness=0.36 //x=5.872 //y=6.74 //x2=5.872 //y2=6.91
r109 (  14 37 ) resistor r=9.3 //w=0.17 //l=0.17 //layer=mcon //count=1 //x=5 \
 //y=6.74 //x2=5 //y2=6.74
r110 (  14 15 ) resistor r=0.0992991 //w=0.214 //l=0.17 //layer=m1 \
 //thickness=0.36 //x=5 //y=6.74 //x2=5 //y2=6.91
r111 (  12 30 ) resistor r=9.3 //w=0.17 //l=0.17 //layer=mcon //count=1 //x=5 \
 //y=5.38 //x2=5 //y2=5.38
r112 (  10 12 ) resistor r=0.097032 //w=0.219 //l=0.17 //layer=m1 \
 //thickness=0.36 //x=5 //y=5.21 //x2=5 //y2=5.38
r113 (  7 20 ) resistor r=9.3 //w=0.17 //l=0.17 //layer=mcon //count=1 \
 //x=4.12 //y=5.38 //x2=4.12 //y2=5.38
r114 (  5 7 ) resistor r=0.0997653 //w=0.213 //l=0.17 //layer=m1 \
 //thickness=0.36 //x=4.12 //y=5.21 //x2=4.12 //y2=5.38
r115 (  4 15 ) resistor r=0.0213909 //w=0.214 //l=0.115 //layer=m1 \
 //thickness=0.36 //x=5.115 //y=6.91 //x2=5 //y2=6.91
r116 (  3 18 ) resistor r=0.0251868 //w=0.228 //l=0.122 //layer=m1 \
 //thickness=0.36 //x=5.75 //y=6.91 //x2=5.872 //y2=6.91
r117 (  3 4 ) resistor r=0.605916 //w=0.131 //l=0.635 //layer=m1 \
 //thickness=0.36 //x=5.75 //y=6.91 //x2=5.115 //y2=6.91
r118 (  2 5 ) resistor r=0.0211096 //w=0.213 //l=0.115 //layer=m1 \
 //thickness=0.36 //x=4.235 //y=5.21 //x2=4.12 //y2=5.21
r119 (  1 10 ) resistor r=0.0227762 //w=0.219 //l=0.12 //layer=m1 \
 //thickness=0.36 //x=4.88 //y=5.21 //x2=5 //y2=5.21
r120 (  1 2 ) resistor r=0.615458 //w=0.131 //l=0.645 //layer=m1 \
 //thickness=0.36 //x=4.88 //y=5.21 //x2=4.235 //y2=5.21
ends PM_AOAI4X1_PCELL\%noxref_6

subckt PM_AOAI4X1_PCELL\%noxref_7 ( 4 8 9 12 17 21 22 23 24 25 26 31 33 35 41 \
 42 44 45 48 )
c119 ( 48 0 ) capacitor c=0.0404287f //x=5.215 //y=4.705
c120 ( 45 0 ) capacitor c=0.0292709f //x=5.18 //y=1.915
c121 ( 44 0 ) capacitor c=0.0468503f //x=5.18 //y=2.08
c122 ( 42 0 ) capacitor c=0.0237765f //x=5.745 //y=1.255
c123 ( 41 0 ) capacitor c=0.0191782f //x=5.745 //y=0.905
c124 ( 35 0 ) capacitor c=0.035988f //x=5.59 //y=1.405
c125 ( 33 0 ) capacitor c=0.0157803f //x=5.59 //y=0.75
c126 ( 31 0 ) capacitor c=0.036638f //x=5.585 //y=4.795
c127 ( 26 0 ) capacitor c=0.0206674f //x=5.215 //y=1.56
c128 ( 25 0 ) capacitor c=0.0169638f //x=5.215 //y=1.255
c129 ( 24 0 ) capacitor c=0.0185462f //x=5.215 //y=0.905
c130 ( 23 0 ) capacitor c=0.155887f //x=5.66 //y=6.025
c131 ( 22 0 ) capacitor c=0.110534f //x=5.22 //y=6.025
c132 ( 17 0 ) capacitor c=0.00113117f //x=5.215 //y=4.705
c133 ( 12 0 ) capacitor c=9.45497e-19 //x=5.18 //y=2.08
c134 ( 9 0 ) capacitor c=0.0570424f //x=5.215 //y=4.56
c135 ( 8 0 ) capacitor c=0.0061903f //x=5.215 //y=4.705
c136 ( 4 0 ) capacitor c=0.00573992f //x=5.18 //y=2.08
r137 (  50 51 ) resistor r=32.4568 //w=0.214 //l=0.075 //layer=ply \
 //thickness=0.18 //x=5.215 //y=4.795 //x2=5.215 //y2=4.87
r138 (  48 50 ) resistor r=20.271 //w=0.214 //l=0.09 //layer=ply \
 //thickness=0.18 //x=5.215 //y=4.705 //x2=5.215 //y2=4.795
r139 (  44 45 ) resistor r=52.7279 //w=0.214 //l=0.165 //layer=ply \
 //thickness=0.18 //x=5.18 //y=2.08 //x2=5.18 //y2=1.915
r140 (  42 55 ) resistor r=4.95774 //w=0.164 //l=0.112 //layer=ply \
 //thickness=0.18 //x=5.745 //y=1.255 //x2=5.745 //y2=1.367
r141 (  41 54 ) resistor r=45.1352 //w=0.168 //l=0.173853 //layer=ply \
 //thickness=0.18 //x=5.745 //y=0.905 //x2=5.705 //y2=0.75
r142 (  41 42 ) resistor r=179.468 //w=0.094 //l=0.35 //layer=ply \
 //thickness=0.18 //x=5.745 //y=0.905 //x2=5.745 //y2=1.255
r143 (  36 53 ) resistor r=10.8103 //w=0.211 //l=0.115 //layer=ply \
 //thickness=0.18 //x=5.37 //y=1.405 //x2=5.255 //y2=1.405
r144 (  35 55 ) resistor r=45.9962 //w=0.164 //l=0.17296 //layer=ply \
 //thickness=0.18 //x=5.59 //y=1.405 //x2=5.745 //y2=1.367
r145 (  34 52 ) resistor r=5.52526 //w=0.168 //l=0.115 //layer=ply \
 //thickness=0.18 //x=5.37 //y=0.75 //x2=5.255 //y2=0.75
r146 (  33 54 ) resistor r=5.52526 //w=0.168 //l=0.115 //layer=ply \
 //thickness=0.18 //x=5.59 //y=0.75 //x2=5.705 //y2=0.75
r147 (  33 34 ) resistor r=112.809 //w=0.094 //l=0.22 //layer=ply \
 //thickness=0.18 //x=5.59 //y=0.75 //x2=5.37 //y2=0.75
r148 (  32 50 ) resistor r=16.5046 //w=0.27 //l=0.135 //layer=ply \
 //thickness=0.18 //x=5.35 //y=4.795 //x2=5.215 //y2=4.795
r149 (  31 38 ) resistor r=26.9307 //w=0.15 //l=0.106066 //layer=ply \
 //thickness=0.18 //x=5.585 //y=4.795 //x2=5.66 //y2=4.87
r150 (  31 32 ) resistor r=120.5 //w=0.094 //l=0.235 //layer=ply \
 //thickness=0.18 //x=5.585 //y=4.795 //x2=5.35 //y2=4.795
r151 (  26 53 ) resistor r=39.5036 //w=0.211 //l=0.173853 //layer=ply \
 //thickness=0.18 //x=5.215 //y=1.56 //x2=5.255 //y2=1.405
r152 (  26 45 ) resistor r=182.032 //w=0.094 //l=0.355 //layer=ply \
 //thickness=0.18 //x=5.215 //y=1.56 //x2=5.215 //y2=1.915
r153 (  25 53 ) resistor r=38.3614 //w=0.211 //l=0.168819 //layer=ply \
 //thickness=0.18 //x=5.215 //y=1.255 //x2=5.255 //y2=1.405
r154 (  24 52 ) resistor r=45.1352 //w=0.168 //l=0.173853 //layer=ply \
 //thickness=0.18 //x=5.215 //y=0.905 //x2=5.255 //y2=0.75
r155 (  24 25 ) resistor r=179.468 //w=0.094 //l=0.35 //layer=ply \
 //thickness=0.18 //x=5.215 //y=0.905 //x2=5.215 //y2=1.255
r156 (  23 38 ) resistor r=592.245 //w=0.094 //l=1.155 //layer=ply \
 //thickness=0.18 //x=5.66 //y=6.025 //x2=5.66 //y2=4.87
r157 (  22 51 ) resistor r=592.245 //w=0.094 //l=1.155 //layer=ply \
 //thickness=0.18 //x=5.22 //y=6.025 //x2=5.22 //y2=4.87
r158 (  21 35 ) resistor r=56.4043 //w=0.094 //l=0.11 //layer=ply \
 //thickness=0.18 //x=5.48 //y=1.405 //x2=5.59 //y2=1.405
r159 (  21 36 ) resistor r=56.4043 //w=0.094 //l=0.11 //layer=ply \
 //thickness=0.18 //x=5.48 //y=1.405 //x2=5.37 //y2=1.405
r160 (  17 48 ) resistor r=152 //w=0.17 //l=0.17 //layer=licon //count=1 \
 //x=5.215 //y=4.705 //x2=5.215 //y2=4.705
r161 (  12 44 ) resistor r=152 //w=0.17 //l=0.17 //layer=licon //count=1 \
 //x=5.18 //y=2.08 //x2=5.18 //y2=2.08
r162 (  8 17 ) resistor r=9.3 //w=0.17 //l=0.17 //layer=mcon //count=1 \
 //x=5.215 //y=4.705 //x2=5.215 //y2=4.705
r163 (  8 9 ) resistor r=0.105739 //w=0.201 //l=0.145 //layer=m1 \
 //thickness=0.36 //x=5.215 //y=4.705 //x2=5.215 //y2=4.56
r164 (  6 9 ) resistor r=2.2376 //w=0.131 //l=2.345 //layer=m1 \
 //thickness=0.36 //x=5.18 //y=2.215 //x2=5.18 //y2=4.56
r165 (  4 12 ) resistor r=9.3 //w=0.17 //l=0.17 //layer=mcon //count=1 \
 //x=5.18 //y=2.08 //x2=5.18 //y2=2.08
r166 (  4 6 ) resistor r=0.0977888 //w=0.216 //l=0.135 //layer=m1 \
 //thickness=0.36 //x=5.177 //y=2.08 //x2=5.177 //y2=2.215
ends PM_AOAI4X1_PCELL\%noxref_7

subckt PM_AOAI4X1_PCELL\%noxref_8 ( 1 7 25 28 29 33 34 39 42 57 66 80 85 90 \
 101 109 119 120 121 122 )
c215 ( 122 0 ) capacitor c=0.00843555f //x=7.65 //y=0.865
c216 ( 121 0 ) capacitor c=0.0737481f //x=3.89 //y=0.365
c217 ( 120 0 ) capacitor c=0.00843555f //x=0.99 //y=0.865
c218 ( 119 0 ) capacitor c=0.1125f //x=6.66 //y=0
c219 ( 116 0 ) capacitor c=0.00591168f //x=5.965 //y=0
c220 ( 113 0 ) capacitor c=0.00591168f //x=4.995 //y=0
c221 ( 110 0 ) capacitor c=0.00591168f //x=4.025 //y=0
c222 ( 109 0 ) capacitor c=0.112646f //x=3.33 //y=0
c223 ( 101 0 ) capacitor c=0.315045f //x=9.25 //y=0
c224 ( 90 0 ) capacitor c=0.0219529f //x=6.49 //y=0
c225 ( 85 0 ) capacitor c=0.00739123f //x=5.965 //y=0.445
c226 ( 80 0 ) capacitor c=0.0152893f //x=5.88 //y=0.53
c227 ( 76 0 ) capacitor c=0.0253251f //x=5.88 //y=0
c228 ( 71 0 ) capacitor c=0.00726869f //x=4.995 //y=0.445
c229 ( 66 0 ) capacitor c=0.0165507f //x=4.91 //y=0.53
c230 ( 62 0 ) capacitor c=0.025309f //x=4.91 //y=0
c231 ( 57 0 ) capacitor c=0.00739123f //x=4.025 //y=0.445
c232 ( 54 0 ) capacitor c=0.0227441f //x=3.94 //y=0
c233 ( 42 0 ) capacitor c=0.183052f //x=0.74 //y=0
c234 ( 39 0 ) capacitor c=0.123925f //x=3.16 //y=0
c235 ( 36 0 ) capacitor c=0.0050875f //x=7.84 //y=0
c236 ( 34 0 ) capacitor c=0.0278993f //x=7.837 //y=0.825
c237 ( 33 0 ) capacitor c=0.0137458f //x=7.84 //y=0.955
c238 ( 31 0 ) capacitor c=0.0050875f //x=1.18 //y=0
c239 ( 29 0 ) capacitor c=0.0278993f //x=1.177 //y=0.825
c240 ( 28 0 ) capacitor c=0.0168135f //x=1.18 //y=0.955
c241 ( 25 0 ) capacitor c=0.0848486f //x=9.25 //y=0
c242 ( 7 0 ) capacitor c=0.220529f //x=7.755 //y=0
c243 ( 1 0 ) capacitor c=0.0587616f //x=1.095 //y=0
r244 (  99 101 ) resistor r=39.7983 //w=0.357 //l=1.11 //layer=li \
 //thickness=0.1 //x=8.14 //y=0 //x2=9.25 //y2=0
r245 (  97 99 ) resistor r=39.7983 //w=0.357 //l=1.11 //layer=li \
 //thickness=0.1 //x=7.03 //y=0 //x2=8.14 //y2=0
r246 (  95 119 ) resistor r=5.4201 //w=0.34 //l=0.17 //layer=li \
 //thickness=0.1 //x=6.83 //y=0 //x2=6.66 //y2=0
r247 (  95 97 ) resistor r=7.17087 //w=0.357 //l=0.2 //layer=li \
 //thickness=0.1 //x=6.83 //y=0 //x2=7.03 //y2=0
r248 (  91 116 ) resistor r=2.94794 //w=0.34 //l=0.085 //layer=li \
 //thickness=0.1 //x=6.05 //y=0 //x2=5.965 //y2=0
r249 (  90 119 ) resistor r=5.4201 //w=0.34 //l=0.17 //layer=li \
 //thickness=0.1 //x=6.49 //y=0 //x2=6.66 //y2=0
r250 (  90 91 ) resistor r=15.7759 //w=0.357 //l=0.44 //layer=li \
 //thickness=0.1 //x=6.49 //y=0 //x2=6.05 //y2=0
r251 (  86 121 ) resistor r=5.4201 //w=0.17 //l=0.085 //layer=li \
 //thickness=0.1 //x=5.965 //y=0.615 //x2=5.965 //y2=0.53
r252 (  86 121 ) resistor r=18.139 //w=0.187 //l=0.265 //layer=li \
 //thickness=0.1 //x=5.965 //y=0.615 //x2=5.965 //y2=0.88
r253 (  85 121 ) resistor r=5.4201 //w=0.17 //l=0.085 //layer=li \
 //thickness=0.1 //x=5.965 //y=0.445 //x2=5.965 //y2=0.53
r254 (  84 116 ) resistor r=4.11603 //w=0.68 //l=0.17 //layer=li \
 //thickness=0.1 //x=5.965 //y=0.17 //x2=5.965 //y2=0
r255 (  84 85 ) resistor r=18.8235 //w=0.187 //l=0.275 //layer=li \
 //thickness=0.1 //x=5.965 //y=0.17 //x2=5.965 //y2=0.445
r256 (  81 121 ) resistor r=6.4 //w=0.17 //l=0.085 //layer=li //thickness=0.1 \
 //x=5.08 //y=0.53 //x2=4.995 //y2=0.53
r257 (  81 121 ) resistor r=27.3797 //w=0.187 //l=0.4 //layer=li \
 //thickness=0.1 //x=5.08 //y=0.53 //x2=5.48 //y2=0.53
r258 (  80 121 ) resistor r=1.40859 //w=0.34 //l=0.085 //layer=li \
 //thickness=0.1 //x=5.88 //y=0.53 //x2=5.965 //y2=0.53
r259 (  80 121 ) resistor r=27.3797 //w=0.187 //l=0.4 //layer=li \
 //thickness=0.1 //x=5.88 //y=0.53 //x2=5.48 //y2=0.53
r260 (  77 113 ) resistor r=2.94794 //w=0.34 //l=0.085 //layer=li \
 //thickness=0.1 //x=5.08 //y=0 //x2=4.995 //y2=0
r261 (  77 79 ) resistor r=16.8515 //w=0.357 //l=0.47 //layer=li \
 //thickness=0.1 //x=5.08 //y=0 //x2=5.55 //y2=0
r262 (  76 116 ) resistor r=2.94794 //w=0.34 //l=0.085 //layer=li \
 //thickness=0.1 //x=5.88 //y=0 //x2=5.965 //y2=0
r263 (  76 79 ) resistor r=11.8319 //w=0.357 //l=0.33 //layer=li \
 //thickness=0.1 //x=5.88 //y=0 //x2=5.55 //y2=0
r264 (  72 121 ) resistor r=6.4 //w=0.17 //l=0.085 //layer=li //thickness=0.1 \
 //x=4.995 //y=0.615 //x2=4.995 //y2=0.53
r265 (  72 121 ) resistor r=18.139 //w=0.187 //l=0.265 //layer=li \
 //thickness=0.1 //x=4.995 //y=0.615 //x2=4.995 //y2=0.88
r266 (  71 121 ) resistor r=6.4 //w=0.17 //l=0.085 //layer=li //thickness=0.1 \
 //x=4.995 //y=0.445 //x2=4.995 //y2=0.53
r267 (  70 113 ) resistor r=4.11603 //w=0.68 //l=0.17 //layer=li \
 //thickness=0.1 //x=4.995 //y=0.17 //x2=4.995 //y2=0
r268 (  70 71 ) resistor r=18.8235 //w=0.187 //l=0.275 //layer=li \
 //thickness=0.1 //x=4.995 //y=0.17 //x2=4.995 //y2=0.445
r269 (  67 121 ) resistor r=1.40859 //w=0.34 //l=0.085 //layer=li \
 //thickness=0.1 //x=4.11 //y=0.53 //x2=4.025 //y2=0.53
r270 (  67 121 ) resistor r=27.3797 //w=0.187 //l=0.4 //layer=li \
 //thickness=0.1 //x=4.11 //y=0.53 //x2=4.51 //y2=0.53
r271 (  66 121 ) resistor r=6.4 //w=0.17 //l=0.085 //layer=li //thickness=0.1 \
 //x=4.91 //y=0.53 //x2=4.995 //y2=0.53
r272 (  66 121 ) resistor r=27.3797 //w=0.187 //l=0.4 //layer=li \
 //thickness=0.1 //x=4.91 //y=0.53 //x2=4.51 //y2=0.53
r273 (  63 110 ) resistor r=2.94794 //w=0.34 //l=0.085 //layer=li \
 //thickness=0.1 //x=4.11 //y=0 //x2=4.025 //y2=0
r274 (  63 65 ) resistor r=11.8319 //w=0.357 //l=0.33 //layer=li \
 //thickness=0.1 //x=4.11 //y=0 //x2=4.44 //y2=0
r275 (  62 113 ) resistor r=2.94794 //w=0.34 //l=0.085 //layer=li \
 //thickness=0.1 //x=4.91 //y=0 //x2=4.995 //y2=0
r276 (  62 65 ) resistor r=16.8515 //w=0.357 //l=0.47 //layer=li \
 //thickness=0.1 //x=4.91 //y=0 //x2=4.44 //y2=0
r277 (  58 121 ) resistor r=5.4201 //w=0.17 //l=0.085 //layer=li \
 //thickness=0.1 //x=4.025 //y=0.615 //x2=4.025 //y2=0.53
r278 (  58 121 ) resistor r=41.4118 //w=0.187 //l=0.605 //layer=li \
 //thickness=0.1 //x=4.025 //y=0.615 //x2=4.025 //y2=1.22
r279 (  57 121 ) resistor r=5.4201 //w=0.17 //l=0.085 //layer=li \
 //thickness=0.1 //x=4.025 //y=0.445 //x2=4.025 //y2=0.53
r280 (  56 110 ) resistor r=4.11603 //w=0.68 //l=0.17 //layer=li \
 //thickness=0.1 //x=4.025 //y=0.17 //x2=4.025 //y2=0
r281 (  56 57 ) resistor r=18.8235 //w=0.187 //l=0.275 //layer=li \
 //thickness=0.1 //x=4.025 //y=0.17 //x2=4.025 //y2=0.445
r282 (  55 109 ) resistor r=5.4201 //w=0.34 //l=0.17 //layer=li \
 //thickness=0.1 //x=3.5 //y=0 //x2=3.33 //y2=0
r283 (  54 110 ) resistor r=2.94794 //w=0.34 //l=0.085 //layer=li \
 //thickness=0.1 //x=3.94 //y=0 //x2=4.025 //y2=0
r284 (  54 55 ) resistor r=15.7759 //w=0.357 //l=0.44 //layer=li \
 //thickness=0.1 //x=3.94 //y=0 //x2=3.5 //y2=0
r285 (  44 46 ) resistor r=39.7983 //w=0.357 //l=1.11 //layer=li \
 //thickness=0.1 //x=1.85 //y=0 //x2=2.96 //y2=0
r286 (  42 44 ) resistor r=39.7983 //w=0.357 //l=1.11 //layer=li \
 //thickness=0.1 //x=0.74 //y=0 //x2=1.85 //y2=0
r287 (  39 109 ) resistor r=5.4201 //w=0.34 //l=0.17 //layer=li \
 //thickness=0.1 //x=3.16 //y=0 //x2=3.33 //y2=0
r288 (  39 46 ) resistor r=7.17087 //w=0.357 //l=0.2 //layer=li \
 //thickness=0.1 //x=3.16 //y=0 //x2=2.96 //y2=0
r289 (  33 122 ) resistor r=9.3 //w=0.17 //l=0.17 //layer=mcon //count=1 \
 //x=7.84 //y=0.955 //x2=7.84 //y2=0.955
r290 (  33 34 ) resistor r=0.0939994 //w=0.226 //l=0.13 //layer=m1 \
 //thickness=0.36 //x=7.837 //y=0.955 //x2=7.837 //y2=0.825
r291 (  28 120 ) resistor r=9.3 //w=0.17 //l=0.17 //layer=mcon //count=1 \
 //x=1.18 //y=0.955 //x2=1.18 //y2=0.955
r292 (  28 29 ) resistor r=0.0939994 //w=0.226 //l=0.13 //layer=m1 \
 //thickness=0.36 //x=1.177 //y=0.955 //x2=1.177 //y2=0.825
r293 (  25 101 ) resistor r=3.1 //w=0.17 //l=0.51 //layer=mcon //count=3 \
 //x=9.25 //y=0 //x2=9.25 //y2=0
r294 (  23 99 ) resistor r=3.1 //w=0.17 //l=0.51 //layer=mcon //count=3 \
 //x=8.14 //y=0 //x2=8.14 //y2=0
r295 (  23 25 ) resistor r=0.460963 //w=0.301 //l=1.11 //layer=m1 \
 //thickness=0.36 //x=8.14 //y=0 //x2=9.25 //y2=0
r296 (  21 36 ) resistor r=0.0287885 //w=0.34 //l=0.085 //layer=m1 \
 //thickness=0.36 //x=7.925 //y=0 //x2=7.84 //y2=0
r297 (  21 23 ) resistor r=0.0892857 //w=0.301 //l=0.215 //layer=m1 \
 //thickness=0.36 //x=7.925 //y=0 //x2=8.14 //y2=0
r298 (  19 36 ) resistor r=0.0401957 //w=0.68 //l=0.17 //layer=m1 \
 //thickness=0.36 //x=7.84 //y=0.17 //x2=7.84 //y2=0
r299 (  19 34 ) resistor r=0.625 //w=0.131 //l=0.655 //layer=m1 \
 //thickness=0.36 //x=7.84 //y=0.17 //x2=7.84 //y2=0.825
r300 (  18 97 ) resistor r=3.1 //w=0.17 //l=0.51 //layer=mcon //count=3 \
 //x=7.03 //y=0 //x2=7.03 //y2=0
r301 (  16 79 ) resistor r=3.1 //w=0.17 //l=0.51 //layer=mcon //count=3 \
 //x=5.55 //y=0 //x2=5.55 //y2=0
r302 (  16 18 ) resistor r=0.614618 //w=0.301 //l=1.48 //layer=m1 \
 //thickness=0.36 //x=5.55 //y=0 //x2=7.03 //y2=0
r303 (  14 65 ) resistor r=3.1 //w=0.17 //l=0.51 //layer=mcon //count=3 \
 //x=4.44 //y=0 //x2=4.44 //y2=0
r304 (  14 16 ) resistor r=0.460963 //w=0.301 //l=1.11 //layer=m1 \
 //thickness=0.36 //x=4.44 //y=0 //x2=5.55 //y2=0
r305 (  12 46 ) resistor r=3.1 //w=0.17 //l=0.51 //layer=mcon //count=3 \
 //x=2.96 //y=0 //x2=2.96 //y2=0
r306 (  12 14 ) resistor r=0.614618 //w=0.301 //l=1.48 //layer=m1 \
 //thickness=0.36 //x=2.96 //y=0 //x2=4.44 //y2=0
r307 (  10 44 ) resistor r=3.1 //w=0.17 //l=0.51 //layer=mcon //count=3 \
 //x=1.85 //y=0 //x2=1.85 //y2=0
r308 (  10 12 ) resistor r=0.460963 //w=0.301 //l=1.11 //layer=m1 \
 //thickness=0.36 //x=1.85 //y=0 //x2=2.96 //y2=0
r309 (  8 31 ) resistor r=0.0287885 //w=0.34 //l=0.085 //layer=m1 \
 //thickness=0.36 //x=1.265 //y=0 //x2=1.18 //y2=0
r310 (  8 10 ) resistor r=0.24294 //w=0.301 //l=0.585 //layer=m1 \
 //thickness=0.36 //x=1.265 //y=0 //x2=1.85 //y2=0
r311 (  7 36 ) resistor r=0.0287885 //w=0.34 //l=0.085 //layer=m1 \
 //thickness=0.36 //x=7.755 //y=0 //x2=7.84 //y2=0
r312 (  7 18 ) resistor r=0.30108 //w=0.301 //l=0.725 //layer=m1 \
 //thickness=0.36 //x=7.755 //y=0 //x2=7.03 //y2=0
r313 (  5 31 ) resistor r=0.0401957 //w=0.68 //l=0.17 //layer=m1 \
 //thickness=0.36 //x=1.18 //y=0.17 //x2=1.18 //y2=0
r314 (  5 29 ) resistor r=0.625 //w=0.131 //l=0.655 //layer=m1 \
 //thickness=0.36 //x=1.18 //y=0.17 //x2=1.18 //y2=0.825
r315 (  3 42 ) resistor r=3.1 //w=0.17 //l=0.51 //layer=mcon //count=3 \
 //x=0.74 //y=0 //x2=0.74 //y2=0
r316 (  1 31 ) resistor r=0.0287885 //w=0.34 //l=0.085 //layer=m1 \
 //thickness=0.36 //x=1.095 //y=0 //x2=1.18 //y2=0
r317 (  1 3 ) resistor r=0.147425 //w=0.301 //l=0.355 //layer=m1 \
 //thickness=0.36 //x=1.095 //y=0 //x2=0.74 //y2=0
ends PM_AOAI4X1_PCELL\%noxref_8

subckt PM_AOAI4X1_PCELL\%noxref_9 ( 2 4 10 15 19 20 21 22 23 24 29 31 33 39 40 \
 42 43 46 )
c102 ( 46 0 ) capacitor c=0.0393541f //x=8.54 //y=4.7
c103 ( 43 0 ) capacitor c=0.0303735f //x=8.51 //y=1.915
c104 ( 42 0 ) capacitor c=0.0476996f //x=8.51 //y=2.08
c105 ( 40 0 ) capacitor c=0.0439708f //x=9.075 //y=1.25
c106 ( 39 0 ) capacitor c=0.0192582f //x=9.075 //y=0.905
c107 ( 33 0 ) capacitor c=0.0162526f //x=8.92 //y=1.405
c108 ( 31 0 ) capacitor c=0.0157807f //x=8.92 //y=0.75
c109 ( 29 0 ) capacitor c=0.0372668f //x=8.915 //y=4.79
c110 ( 24 0 ) capacitor c=0.0210762f //x=8.545 //y=1.56
c111 ( 23 0 ) capacitor c=0.0168511f //x=8.545 //y=1.25
c112 ( 22 0 ) capacitor c=0.0175485f //x=8.545 //y=0.905
c113 ( 21 0 ) capacitor c=0.155269f //x=8.99 //y=6.02
c114 ( 20 0 ) capacitor c=0.110375f //x=8.55 //y=6.02
c115 ( 15 0 ) capacitor c=8.9038e-19 //x=8.54 //y=4.7
c116 ( 10 0 ) capacitor c=7.72439e-19 //x=8.51 //y=2.08
c117 ( 4 0 ) capacitor c=0.00687137f //x=8.51 //y=2.08
c118 ( 2 0 ) capacitor c=0.0637323f //x=8.51 //y=4.555
r119 (  48 49 ) resistor r=32.4568 //w=0.214 //l=0.075 //layer=ply \
 //thickness=0.18 //x=8.54 //y=4.79 //x2=8.54 //y2=4.865
r120 (  46 48 ) resistor r=20.271 //w=0.214 //l=0.09 //layer=ply \
 //thickness=0.18 //x=8.54 //y=4.7 //x2=8.54 //y2=4.79
r121 (  42 43 ) resistor r=52.7279 //w=0.214 //l=0.165 //layer=ply \
 //thickness=0.18 //x=8.51 //y=2.08 //x2=8.51 //y2=1.915
r122 (  40 53 ) resistor r=45.1352 //w=0.168 //l=0.173853 //layer=ply \
 //thickness=0.18 //x=9.075 //y=1.25 //x2=9.035 //y2=1.405
r123 (  39 52 ) resistor r=45.1352 //w=0.168 //l=0.173853 //layer=ply \
 //thickness=0.18 //x=9.075 //y=0.905 //x2=9.035 //y2=0.75
r124 (  39 40 ) resistor r=176.904 //w=0.094 //l=0.345 //layer=ply \
 //thickness=0.18 //x=9.075 //y=0.905 //x2=9.075 //y2=1.25
r125 (  34 51 ) resistor r=10.701 //w=0.21 //l=0.115 //layer=ply \
 //thickness=0.18 //x=8.7 //y=1.405 //x2=8.585 //y2=1.405
r126 (  33 53 ) resistor r=5.52526 //w=0.168 //l=0.115 //layer=ply \
 //thickness=0.18 //x=8.92 //y=1.405 //x2=9.035 //y2=1.405
r127 (  32 50 ) resistor r=5.52526 //w=0.168 //l=0.115 //layer=ply \
 //thickness=0.18 //x=8.7 //y=0.75 //x2=8.585 //y2=0.75
r128 (  31 52 ) resistor r=5.52526 //w=0.168 //l=0.115 //layer=ply \
 //thickness=0.18 //x=8.92 //y=0.75 //x2=9.035 //y2=0.75
r129 (  31 32 ) resistor r=112.809 //w=0.094 //l=0.22 //layer=ply \
 //thickness=0.18 //x=8.92 //y=0.75 //x2=8.7 //y2=0.75
r130 (  30 48 ) resistor r=16.5046 //w=0.27 //l=0.135 //layer=ply \
 //thickness=0.18 //x=8.675 //y=4.79 //x2=8.54 //y2=4.79
r131 (  29 36 ) resistor r=26.9307 //w=0.15 //l=0.106066 //layer=ply \
 //thickness=0.18 //x=8.915 //y=4.79 //x2=8.99 //y2=4.865
r132 (  29 30 ) resistor r=123.064 //w=0.094 //l=0.24 //layer=ply \
 //thickness=0.18 //x=8.915 //y=4.79 //x2=8.675 //y2=4.79
r133 (  24 51 ) resistor r=39.5823 //w=0.21 //l=0.173853 //layer=ply \
 //thickness=0.18 //x=8.545 //y=1.56 //x2=8.585 //y2=1.405
r134 (  24 43 ) resistor r=182.032 //w=0.094 //l=0.355 //layer=ply \
 //thickness=0.18 //x=8.545 //y=1.56 //x2=8.545 //y2=1.915
r135 (  23 51 ) resistor r=39.5823 //w=0.21 //l=0.173853 //layer=ply \
 //thickness=0.18 //x=8.545 //y=1.25 //x2=8.585 //y2=1.405
r136 (  22 50 ) resistor r=45.1352 //w=0.168 //l=0.173853 //layer=ply \
 //thickness=0.18 //x=8.545 //y=0.905 //x2=8.585 //y2=0.75
r137 (  22 23 ) resistor r=176.904 //w=0.094 //l=0.345 //layer=ply \
 //thickness=0.18 //x=8.545 //y=0.905 //x2=8.545 //y2=1.25
r138 (  21 36 ) resistor r=592.245 //w=0.094 //l=1.155 //layer=ply \
 //thickness=0.18 //x=8.99 //y=6.02 //x2=8.99 //y2=4.865
r139 (  20 49 ) resistor r=592.245 //w=0.094 //l=1.155 //layer=ply \
 //thickness=0.18 //x=8.55 //y=6.02 //x2=8.55 //y2=4.865
r140 (  19 33 ) resistor r=56.4043 //w=0.094 //l=0.11 //layer=ply \
 //thickness=0.18 //x=8.81 //y=1.405 //x2=8.92 //y2=1.405
r141 (  19 34 ) resistor r=56.4043 //w=0.094 //l=0.11 //layer=ply \
 //thickness=0.18 //x=8.81 //y=1.405 //x2=8.7 //y2=1.405
r142 (  15 46 ) resistor r=152 //w=0.17 //l=0.17 //layer=licon //count=1 \
 //x=8.54 //y=4.7 //x2=8.54 //y2=4.7
r143 (  10 42 ) resistor r=152 //w=0.17 //l=0.17 //layer=licon //count=1 \
 //x=8.51 //y=2.08 //x2=8.51 //y2=2.08
r144 (  8 15 ) resistor r=9.3 //w=0.17 //l=0.17 //layer=mcon //count=1 \
 //x=8.54 //y=4.7 //x2=8.54 //y2=4.7
r145 (  4 10 ) resistor r=9.3 //w=0.17 //l=0.17 //layer=mcon //count=1 \
 //x=8.51 //y=2.08 //x2=8.51 //y2=2.08
r146 (  4 6 ) resistor r=0.0936408 //w=0.196 //l=0.125 //layer=m1 \
 //thickness=0.36 //x=8.512 //y=2.08 //x2=8.512 //y2=2.205
r147 (  2 8 ) resistor r=0.0878548 //w=0.228 //l=0.159295 //layer=m1 \
 //thickness=0.36 //x=8.51 //y=4.555 //x2=8.54 //y2=4.7
r148 (  2 6 ) resistor r=2.24237 //w=0.131 //l=2.35 //layer=m1 \
 //thickness=0.36 //x=8.51 //y=4.555 //x2=8.51 //y2=2.205
ends PM_AOAI4X1_PCELL\%noxref_9

subckt PM_AOAI4X1_PCELL\%noxref_10 ( 3 8 9 11 12 14 17 18 21 23 26 34 46 48 49 )
c111 ( 46 0 ) capacitor c=0.00878249f //x=8.62 //y=0.905
c112 ( 34 0 ) capacitor c=0.0325998f //x=8.77 //y=5.38
c113 ( 26 0 ) capacitor c=0.0291371f //x=7.89 //y=5.38
c114 ( 23 0 ) capacitor c=0.0149056f //x=8.81 //y=1
c115 ( 21 0 ) capacitor c=6.70882e-19 //x=8.77 //y=5.38
c116 ( 18 0 ) capacitor c=0.0159641f //x=8.77 //y=5.2
c117 ( 17 0 ) capacitor c=0.0102556f //x=7.89 //y=5.38
c118 ( 14 0 ) capacitor c=0.133979f //x=9.25 //y=5.115
c119 ( 12 0 ) capacitor c=0.0069619f //x=8.895 //y=1.655
c120 ( 11 0 ) capacitor c=0.0165738f //x=9.165 //y=1.655
c121 ( 9 0 ) capacitor c=0.0143926f //x=9.165 //y=5.2
c122 ( 8 0 ) capacitor c=0.0133876f //x=8.81 //y=1.57
c123 ( 3 0 ) capacitor c=0.019362f //x=8.655 //y=5.2
r124 (  34 49 ) resistor r=23.615 //w=0.187 //l=0.345 //layer=li \
 //thickness=0.1 //x=8.77 //y=5.38 //x2=8.77 //y2=5.725
r125 (  26 48 ) resistor r=23.615 //w=0.187 //l=0.345 //layer=li \
 //thickness=0.1 //x=7.89 //y=5.38 //x2=7.89 //y2=5.725
r126 (  23 46 ) resistor r=9.3 //w=0.17 //l=0.17 //layer=mcon //count=1 \
 //x=8.81 //y=1 //x2=8.81 //y2=1
r127 (  21 34 ) resistor r=9.3 //w=0.17 //l=0.17 //layer=mcon //count=1 \
 //x=8.77 //y=5.38 //x2=8.77 //y2=5.38
r128 (  18 21 ) resistor r=0.117801 //w=0.191 //l=0.18 //layer=m1 \
 //thickness=0.36 //x=8.77 //y=5.2 //x2=8.77 //y2=5.38
r129 (  17 26 ) resistor r=9.3 //w=0.17 //l=0.17 //layer=mcon //count=1 \
 //x=7.89 //y=5.38 //x2=7.89 //y2=5.38
r130 (  15 17 ) resistor r=0.10274 //w=0.219 //l=0.18 //layer=m1 \
 //thickness=0.36 //x=7.89 //y=5.2 //x2=7.89 //y2=5.38
r131 (  13 14 ) resistor r=3.22042 //w=0.131 //l=3.375 //layer=m1 \
 //thickness=0.36 //x=9.25 //y=1.74 //x2=9.25 //y2=5.115
r132 (  11 13 ) resistor r=0.0698411 //w=0.17 //l=0.120208 //layer=m1 \
 //thickness=0.36 //x=9.165 //y=1.655 //x2=9.25 //y2=1.74
r133 (  11 12 ) resistor r=0.257634 //w=0.131 //l=0.27 //layer=m1 \
 //thickness=0.36 //x=9.165 //y=1.655 //x2=8.895 //y2=1.655
r134 (  10 18 ) resistor r=0.0257089 //w=0.23 //l=0.115 //layer=m1 \
 //thickness=0.36 //x=8.885 //y=5.2 //x2=8.77 //y2=5.2
r135 (  9 14 ) resistor r=0.0698411 //w=0.17 //l=0.120208 //layer=m1 \
 //thickness=0.36 //x=9.165 //y=5.2 //x2=9.25 //y2=5.115
r136 (  9 10 ) resistor r=0.267176 //w=0.131 //l=0.28 //layer=m1 \
 //thickness=0.36 //x=9.165 //y=5.2 //x2=8.885 //y2=5.2
r137 (  8 12 ) resistor r=0.0698411 //w=0.17 //l=0.120208 //layer=m1 \
 //thickness=0.36 //x=8.81 //y=1.57 //x2=8.895 //y2=1.655
r138 (  7 23 ) resistor r=0.0913624 //w=0.191 //l=0.12 //layer=m1 \
 //thickness=0.36 //x=8.81 //y=1.12 //x2=8.81 //y2=1
r139 (  7 8 ) resistor r=0.429389 //w=0.131 //l=0.45 //layer=m1 \
 //thickness=0.36 //x=8.81 //y=1.12 //x2=8.81 //y2=1.57
r140 (  4 15 ) resistor r=0.0227762 //w=0.219 //l=0.115 //layer=m1 \
 //thickness=0.36 //x=8.005 //y=5.2 //x2=7.89 //y2=5.2
r141 (  3 18 ) resistor r=0.0257089 //w=0.23 //l=0.115 //layer=m1 \
 //thickness=0.36 //x=8.655 //y=5.2 //x2=8.77 //y2=5.2
r142 (  3 4 ) resistor r=0.620229 //w=0.131 //l=0.65 //layer=m1 \
 //thickness=0.36 //x=8.655 //y=5.2 //x2=8.005 //y2=5.2
ends PM_AOAI4X1_PCELL\%noxref_10

subckt PM_AOAI4X1_PCELL\%noxref_11 ( 1 5 9 10 13 17 29 )
c61 ( 29 0 ) capacitor c=0.0672366f //x=0.56 //y=0.365
c62 ( 17 0 ) capacitor c=0.00709791f //x=2.635 //y=0.615
c63 ( 13 0 ) capacitor c=0.0157877f //x=2.55 //y=0.53
c64 ( 10 0 ) capacitor c=0.00963509f //x=1.665 //y=1.495
c65 ( 9 0 ) capacitor c=0.00770028f //x=1.665 //y=0.615
c66 ( 5 0 ) capacitor c=0.0246013f //x=1.58 //y=1.58
c67 ( 1 0 ) capacitor c=0.0115037f //x=0.695 //y=1.495
r68 (  17 29 ) resistor r=3.57586 //w=0.17 //l=0.125 //layer=li \
 //thickness=0.1 //x=2.635 //y=0.615 //x2=2.635 //y2=0.49
r69 (  17 29 ) resistor r=18.139 //w=0.187 //l=0.265 //layer=li \
 //thickness=0.1 //x=2.635 //y=0.615 //x2=2.635 //y2=0.88
r70 (  14 29 ) resistor r=3.57586 //w=0.17 //l=0.103078 //layer=li \
 //thickness=0.1 //x=1.75 //y=0.53 //x2=1.665 //y2=0.49
r71 (  14 29 ) resistor r=27.3797 //w=0.187 //l=0.4 //layer=li //thickness=0.1 \
 //x=1.75 //y=0.53 //x2=2.15 //y2=0.53
r72 (  13 29 ) resistor r=3.57586 //w=0.17 //l=0.103078 //layer=li \
 //thickness=0.1 //x=2.55 //y=0.53 //x2=2.635 //y2=0.49
r73 (  13 29 ) resistor r=27.3797 //w=0.187 //l=0.4 //layer=li //thickness=0.1 \
 //x=2.55 //y=0.53 //x2=2.15 //y2=0.53
r74 (  10 29 ) resistor r=3.57586 //w=0.17 //l=0.125 //layer=li \
 //thickness=0.1 //x=1.665 //y=1.495 //x2=1.665 //y2=1.62
r75 (  10 29 ) resistor r=42.0963 //w=0.187 //l=0.615 //layer=li \
 //thickness=0.1 //x=1.665 //y=1.495 //x2=1.665 //y2=0.88
r76 (  9 29 ) resistor r=3.57586 //w=0.17 //l=0.125 //layer=li //thickness=0.1 \
 //x=1.665 //y=0.615 //x2=1.665 //y2=0.49
r77 (  9 29 ) resistor r=18.139 //w=0.187 //l=0.265 //layer=li //thickness=0.1 \
 //x=1.665 //y=0.615 //x2=1.665 //y2=0.88
r78 (  6 29 ) resistor r=3.57586 //w=0.17 //l=0.103078 //layer=li \
 //thickness=0.1 //x=0.78 //y=1.58 //x2=0.695 //y2=1.62
r79 (  6 29 ) resistor r=27.3797 //w=0.187 //l=0.4 //layer=li //thickness=0.1 \
 //x=0.78 //y=1.58 //x2=1.18 //y2=1.58
r80 (  5 29 ) resistor r=3.57586 //w=0.17 //l=0.103078 //layer=li \
 //thickness=0.1 //x=1.58 //y=1.58 //x2=1.665 //y2=1.62
r81 (  5 29 ) resistor r=27.3797 //w=0.187 //l=0.4 //layer=li //thickness=0.1 \
 //x=1.58 //y=1.58 //x2=1.18 //y2=1.58
r82 (  1 29 ) resistor r=3.57586 //w=0.17 //l=0.125 //layer=li //thickness=0.1 \
 //x=0.695 //y=1.495 //x2=0.695 //y2=1.62
r83 (  1 29 ) resistor r=42.0963 //w=0.187 //l=0.615 //layer=li \
 //thickness=0.1 //x=0.695 //y=1.495 //x2=0.695 //y2=0.88
ends PM_AOAI4X1_PCELL\%noxref_11

subckt PM_AOAI4X1_PCELL\%noxref_12 ( 1 5 9 10 13 17 29 )
c55 ( 29 0 ) capacitor c=0.0684023f //x=7.22 //y=0.365
c56 ( 17 0 ) capacitor c=0.00709791f //x=9.295 //y=0.615
c57 ( 13 0 ) capacitor c=0.0157877f //x=9.21 //y=0.53
c58 ( 10 0 ) capacitor c=0.00955329f //x=8.325 //y=1.495
c59 ( 9 0 ) capacitor c=0.00770028f //x=8.325 //y=0.615
c60 ( 5 0 ) capacitor c=0.0229059f //x=8.24 //y=1.58
c61 ( 1 0 ) capacitor c=0.00776706f //x=7.355 //y=1.495
r62 (  17 29 ) resistor r=3.57586 //w=0.17 //l=0.125 //layer=li \
 //thickness=0.1 //x=9.295 //y=0.615 //x2=9.295 //y2=0.49
r63 (  17 29 ) resistor r=18.139 //w=0.187 //l=0.265 //layer=li \
 //thickness=0.1 //x=9.295 //y=0.615 //x2=9.295 //y2=0.88
r64 (  14 29 ) resistor r=3.57586 //w=0.17 //l=0.103078 //layer=li \
 //thickness=0.1 //x=8.41 //y=0.53 //x2=8.325 //y2=0.49
r65 (  14 29 ) resistor r=27.3797 //w=0.187 //l=0.4 //layer=li //thickness=0.1 \
 //x=8.41 //y=0.53 //x2=8.81 //y2=0.53
r66 (  13 29 ) resistor r=3.57586 //w=0.17 //l=0.103078 //layer=li \
 //thickness=0.1 //x=9.21 //y=0.53 //x2=9.295 //y2=0.49
r67 (  13 29 ) resistor r=27.3797 //w=0.187 //l=0.4 //layer=li //thickness=0.1 \
 //x=9.21 //y=0.53 //x2=8.81 //y2=0.53
r68 (  10 29 ) resistor r=3.57586 //w=0.17 //l=0.125 //layer=li \
 //thickness=0.1 //x=8.325 //y=1.495 //x2=8.325 //y2=1.62
r69 (  10 29 ) resistor r=42.0963 //w=0.187 //l=0.615 //layer=li \
 //thickness=0.1 //x=8.325 //y=1.495 //x2=8.325 //y2=0.88
r70 (  9 29 ) resistor r=3.57586 //w=0.17 //l=0.125 //layer=li //thickness=0.1 \
 //x=8.325 //y=0.615 //x2=8.325 //y2=0.49
r71 (  9 29 ) resistor r=18.139 //w=0.187 //l=0.265 //layer=li //thickness=0.1 \
 //x=8.325 //y=0.615 //x2=8.325 //y2=0.88
r72 (  6 29 ) resistor r=3.57586 //w=0.17 //l=0.103078 //layer=li \
 //thickness=0.1 //x=7.44 //y=1.58 //x2=7.355 //y2=1.62
r73 (  6 29 ) resistor r=27.3797 //w=0.187 //l=0.4 //layer=li //thickness=0.1 \
 //x=7.44 //y=1.58 //x2=7.84 //y2=1.58
r74 (  5 29 ) resistor r=3.57586 //w=0.17 //l=0.103078 //layer=li \
 //thickness=0.1 //x=8.24 //y=1.58 //x2=8.325 //y2=1.62
r75 (  5 29 ) resistor r=27.3797 //w=0.187 //l=0.4 //layer=li //thickness=0.1 \
 //x=8.24 //y=1.58 //x2=7.84 //y2=1.58
r76 (  1 29 ) resistor r=3.57586 //w=0.17 //l=0.125 //layer=li //thickness=0.1 \
 //x=7.355 //y=1.495 //x2=7.355 //y2=1.62
r77 (  1 29 ) resistor r=42.0963 //w=0.187 //l=0.615 //layer=li \
 //thickness=0.1 //x=7.355 //y=1.495 //x2=7.355 //y2=0.88
ends PM_AOAI4X1_PCELL\%noxref_12
