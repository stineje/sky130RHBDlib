// File: NAND2X1.spi.NAND2X1.pxi
// Created: Tue Apr 29 10:43:14 2025
//
simulator lang=spectre
x_PM_NAND2X1\%GND ( GND N_GND_c_21_p N_GND_c_4_p N_GND_c_1_p N_GND_c_2_p \
 N_GND_M0_noxref_d )  PM_NAND2X1\%GND
x_PM_NAND2X1\%VDD ( VDD N_VDD_c_63_p N_VDD_c_40_p N_VDD_c_49_p N_VDD_c_38_n \
 N_VDD_c_39_n N_VDD_M2_noxref_s N_VDD_M3_noxref_d N_VDD_M5_noxref_d )  \
 PM_NAND2X1\%VDD
x_PM_NAND2X1\%A ( A A A A A A A N_A_c_73_n N_A_M0_noxref_g N_A_M2_noxref_g \
 N_A_M3_noxref_g N_A_c_74_n N_A_c_76_n N_A_c_77_n N_A_c_78_n N_A_c_79_n \
 N_A_c_80_n N_A_c_81_n N_A_c_83_n N_A_c_90_n )  PM_NAND2X1\%A
x_PM_NAND2X1\%B ( B B B B B B B N_B_c_137_n N_B_c_128_n N_B_M1_noxref_g \
 N_B_M4_noxref_g N_B_M5_noxref_g N_B_c_144_n N_B_c_147_n N_B_c_149_n \
 N_B_c_160_p N_B_c_174_p N_B_c_168_p N_B_c_152_n N_B_c_153_n N_B_c_154_n \
 N_B_c_162_p N_B_c_156_n )  PM_NAND2X1\%B
x_PM_NAND2X1\%Y ( Y Y Y Y Y Y Y N_Y_c_197_n N_Y_c_200_n N_Y_c_202_n \
 N_Y_c_191_n N_Y_c_243_p N_Y_c_232_n N_Y_M1_noxref_d N_Y_M2_noxref_d \
 N_Y_M4_noxref_d )  PM_NAND2X1\%Y
x_PM_NAND2X1\%noxref_6 ( N_noxref_6_c_266_n N_noxref_6_c_249_n \
 N_noxref_6_c_253_n N_noxref_6_c_256_n N_noxref_6_c_257_n N_noxref_6_c_259_n \
 N_noxref_6_M0_noxref_s )  PM_NAND2X1\%noxref_6
cc_1 ( N_GND_c_1_p N_VDD_c_38_n ) capacitor c=0.00989514f //x=1.23 //y=0.18 \
 //x2=1.23 //y2=7.58
cc_2 ( N_GND_c_2_p N_VDD_c_39_n ) capacitor c=0.00989514f //x=3.08 //y=0.18 \
 //x2=3.08 //y2=7.58
cc_3 ( N_GND_c_1_p N_A_c_73_n ) capacitor c=0.0180518f //x=1.23 //y=0.18 \
 //x2=1.6 //y2=2.26
cc_4 ( N_GND_c_4_p N_A_c_74_n ) capacitor c=0.00135783f //x=1.585 //y=0.175 \
 //x2=1.405 //y2=1.045
cc_5 ( N_GND_M0_noxref_d N_A_c_74_n ) capacitor c=0.00220047f //x=1.48 \
 //y=1.045 //x2=1.405 //y2=1.045
cc_6 ( N_GND_M0_noxref_d N_A_c_76_n ) capacitor c=0.00255985f //x=1.48 \
 //y=1.045 //x2=1.405 //y2=1.39
cc_7 ( N_GND_c_1_p N_A_c_77_n ) capacitor c=0.00264481f //x=1.23 //y=0.18 \
 //x2=1.405 //y2=1.7
cc_8 ( N_GND_c_1_p N_A_c_78_n ) capacitor c=0.0121947f //x=1.23 //y=0.18 \
 //x2=1.405 //y2=2.095
cc_9 ( N_GND_M0_noxref_d N_A_c_79_n ) capacitor c=0.0131374f //x=1.48 \
 //y=1.045 //x2=1.78 //y2=0.89
cc_10 ( N_GND_M0_noxref_d N_A_c_80_n ) capacitor c=0.00193146f //x=1.48 \
 //y=1.045 //x2=1.78 //y2=1.545
cc_11 ( N_GND_c_2_p N_A_c_81_n ) capacitor c=0.00131234f //x=3.08 //y=0.18 \
 //x2=1.935 //y2=1.045
cc_12 ( N_GND_M0_noxref_d N_A_c_81_n ) capacitor c=0.00257848f //x=1.48 \
 //y=1.045 //x2=1.935 //y2=1.045
cc_13 ( N_GND_M0_noxref_d N_A_c_83_n ) capacitor c=0.00255985f //x=1.48 \
 //y=1.045 //x2=1.935 //y2=1.39
cc_14 ( N_GND_c_1_p N_B_c_128_n ) capacitor c=9.2064e-19 //x=1.23 //y=0.18 \
 //x2=2.34 //y2=2.26
cc_15 ( N_GND_c_2_p N_B_c_128_n ) capacitor c=9.53263e-19 //x=3.08 //y=0.18 \
 //x2=2.34 //y2=2.26
cc_16 ( N_GND_c_1_p Y ) capacitor c=0.00101801f //x=1.23 //y=0.18 //x2=3.08 \
 //y2=2.4
cc_17 ( N_GND_c_2_p N_Y_c_191_n ) capacitor c=0.0468439f //x=3.08 //y=0.18 \
 //x2=2.995 //y2=1.835
cc_18 ( N_GND_c_1_p N_Y_M1_noxref_d ) capacitor c=8.58106e-19 //x=1.23 \
 //y=0.18 //x2=2.45 //y2=1.085
cc_19 ( N_GND_c_2_p N_Y_M1_noxref_d ) capacitor c=0.00618259f //x=3.08 \
 //y=0.18 //x2=2.45 //y2=1.085
cc_20 ( N_GND_M0_noxref_d N_Y_M1_noxref_d ) capacitor c=0.00143464f //x=1.48 \
 //y=1.045 //x2=2.45 //y2=1.085
cc_21 ( N_GND_c_21_p N_noxref_6_c_249_n ) capacitor c=0.00711001f //x=3.08 \
 //y=0.18 //x2=2.07 //y2=1.76
cc_22 ( N_GND_c_4_p N_noxref_6_c_249_n ) capacitor c=0.00111556f //x=1.585 \
 //y=0.175 //x2=2.07 //y2=1.76
cc_23 ( N_GND_c_2_p N_noxref_6_c_249_n ) capacitor c=0.00181083f //x=3.08 \
 //y=0.18 //x2=2.07 //y2=1.76
cc_24 ( N_GND_M0_noxref_d N_noxref_6_c_249_n ) capacitor c=0.00909955f \
 //x=1.48 //y=1.045 //x2=2.07 //y2=1.76
cc_25 ( N_GND_c_21_p N_noxref_6_c_253_n ) capacitor c=0.00724992f //x=3.08 \
 //y=0.18 //x2=2.155 //y2=0.795
cc_26 ( N_GND_c_2_p N_noxref_6_c_253_n ) capacitor c=0.0161197f //x=3.08 \
 //y=0.18 //x2=2.155 //y2=0.795
cc_27 ( N_GND_M0_noxref_d N_noxref_6_c_253_n ) capacitor c=0.033812f //x=1.48 \
 //y=1.045 //x2=2.155 //y2=0.795
cc_28 ( N_GND_c_1_p N_noxref_6_c_256_n ) capacitor c=2.91423e-19 //x=1.23 \
 //y=0.18 //x2=2.155 //y2=1.675
cc_29 ( N_GND_c_21_p N_noxref_6_c_257_n ) capacitor c=0.0199827f //x=3.08 \
 //y=0.18 //x2=3.04 //y2=0.71
cc_30 ( N_GND_c_2_p N_noxref_6_c_257_n ) capacitor c=0.0400716f //x=3.08 \
 //y=0.18 //x2=3.04 //y2=0.71
cc_31 ( N_GND_c_21_p N_noxref_6_c_259_n ) capacitor c=0.00720883f //x=3.08 \
 //y=0.18 //x2=3.125 //y2=0.795
cc_32 ( N_GND_c_2_p N_noxref_6_c_259_n ) capacitor c=0.0598951f //x=3.08 \
 //y=0.18 //x2=3.125 //y2=0.795
cc_33 ( N_GND_c_21_p N_noxref_6_M0_noxref_s ) capacitor c=0.00724992f //x=3.08 \
 //y=0.18 //x2=1.05 //y2=0.545
cc_34 ( N_GND_c_4_p N_noxref_6_M0_noxref_s ) capacitor c=0.014661f //x=1.585 \
 //y=0.175 //x2=1.05 //y2=0.545
cc_35 ( N_GND_c_1_p N_noxref_6_M0_noxref_s ) capacitor c=0.0594057f //x=1.23 \
 //y=0.18 //x2=1.05 //y2=0.545
cc_36 ( N_GND_c_2_p N_noxref_6_M0_noxref_s ) capacitor c=0.00344356f //x=3.08 \
 //y=0.18 //x2=1.05 //y2=0.545
cc_37 ( N_GND_M0_noxref_d N_noxref_6_M0_noxref_s ) capacitor c=0.0334197f \
 //x=1.48 //y=1.045 //x2=1.05 //y2=0.545
cc_38 ( N_VDD_c_40_p N_A_c_73_n ) capacitor c=3.98531e-19 //x=2.075 //y=7.585 \
 //x2=1.6 //y2=2.26
cc_39 ( N_VDD_c_38_n N_A_c_73_n ) capacitor c=0.016845f //x=1.23 //y=7.58 \
 //x2=1.6 //y2=2.26
cc_40 ( N_VDD_c_40_p N_A_M2_noxref_g ) capacitor c=0.00732332f //x=2.075 \
 //y=7.585 //x2=1.5 //y2=6.2
cc_41 ( N_VDD_M2_noxref_s N_A_M2_noxref_g ) capacitor c=0.054195f //x=1.145 \
 //y=5.2 //x2=1.5 //y2=6.2
cc_42 ( N_VDD_c_40_p N_A_M3_noxref_g ) capacitor c=0.00677553f //x=2.075 \
 //y=7.585 //x2=1.94 //y2=6.2
cc_43 ( N_VDD_M3_noxref_d N_A_M3_noxref_g ) capacitor c=0.015318f //x=2.015 \
 //y=5.2 //x2=1.94 //y2=6.2
cc_44 ( N_VDD_c_38_n N_A_c_90_n ) capacitor c=0.0292267f //x=1.23 //y=7.58 \
 //x2=1.6 //y2=4.88
cc_45 ( N_VDD_c_38_n N_B_c_128_n ) capacitor c=6.61004e-19 //x=1.23 //y=7.58 \
 //x2=2.34 //y2=2.26
cc_46 ( N_VDD_c_39_n N_B_c_128_n ) capacitor c=6.09526e-19 //x=3.08 //y=7.58 \
 //x2=2.34 //y2=2.26
cc_47 ( N_VDD_c_49_p N_B_M4_noxref_g ) capacitor c=0.00678607f //x=2.955 \
 //y=7.585 //x2=2.38 //y2=6.2
cc_48 ( N_VDD_M3_noxref_d N_B_M4_noxref_g ) capacitor c=0.015318f //x=2.015 \
 //y=5.2 //x2=2.38 //y2=6.2
cc_49 ( N_VDD_c_49_p N_B_M5_noxref_g ) capacitor c=0.00677553f //x=2.955 \
 //y=7.585 //x2=2.82 //y2=6.2
cc_50 ( N_VDD_c_39_n N_B_M5_noxref_g ) capacitor c=0.024326f //x=3.08 //y=7.58 \
 //x2=2.82 //y2=6.2
cc_51 ( N_VDD_M5_noxref_d N_B_M5_noxref_g ) capacitor c=0.0430452f //x=2.895 \
 //y=5.2 //x2=2.82 //y2=6.2
cc_52 ( N_VDD_c_38_n Y ) capacitor c=0.00159771f //x=1.23 //y=7.58 //x2=3.08 \
 //y2=2.4
cc_53 ( N_VDD_c_39_n Y ) capacitor c=0.0468798f //x=3.08 //y=7.58 //x2=3.08 \
 //y2=2.4
cc_54 ( N_VDD_c_40_p N_Y_c_197_n ) capacitor c=5.7743e-19 //x=2.075 //y=7.585 \
 //x2=2.515 //y2=5.38
cc_55 ( N_VDD_c_49_p N_Y_c_197_n ) capacitor c=5.7743e-19 //x=2.955 //y=7.585 \
 //x2=2.515 //y2=5.38
cc_56 ( N_VDD_M3_noxref_d N_Y_c_197_n ) capacitor c=0.0132783f //x=2.015 \
 //y=5.2 //x2=2.515 //y2=5.38
cc_57 ( N_VDD_c_38_n N_Y_c_200_n ) capacitor c=0.00989999f //x=1.23 //y=7.58 \
 //x2=1.805 //y2=5.38
cc_58 ( N_VDD_M2_noxref_s N_Y_c_200_n ) capacitor c=0.087833f //x=1.145 \
 //y=5.2 //x2=1.805 //y2=5.38
cc_59 ( N_VDD_c_49_p N_Y_c_202_n ) capacitor c=8.72934e-19 //x=2.955 //y=7.585 \
 //x2=2.995 //y2=5.38
cc_60 ( N_VDD_M5_noxref_d N_Y_c_202_n ) capacitor c=0.0167847f //x=2.895 \
 //y=5.2 //x2=2.995 //y2=5.38
cc_61 ( N_VDD_c_63_p N_Y_M2_noxref_d ) capacitor c=0.00720906f //x=3.08 \
 //y=7.58 //x2=1.575 //y2=5.2
cc_62 ( N_VDD_c_40_p N_Y_M2_noxref_d ) capacitor c=0.0138506f //x=2.075 \
 //y=7.585 //x2=1.575 //y2=5.2
cc_63 ( N_VDD_c_39_n N_Y_M2_noxref_d ) capacitor c=0.00204676f //x=3.08 \
 //y=7.58 //x2=1.575 //y2=5.2
cc_64 ( N_VDD_M3_noxref_d N_Y_M2_noxref_d ) capacitor c=0.0664752f //x=2.015 \
 //y=5.2 //x2=1.575 //y2=5.2
cc_65 ( N_VDD_c_63_p N_Y_M4_noxref_d ) capacitor c=0.00720906f //x=3.08 \
 //y=7.58 //x2=2.455 //y2=5.2
cc_66 ( N_VDD_c_49_p N_Y_M4_noxref_d ) capacitor c=0.0138783f //x=2.955 \
 //y=7.585 //x2=2.455 //y2=5.2
cc_67 ( N_VDD_c_39_n N_Y_M4_noxref_d ) capacitor c=0.0136712f //x=3.08 \
 //y=7.58 //x2=2.455 //y2=5.2
cc_68 ( N_VDD_M2_noxref_s N_Y_M4_noxref_d ) capacitor c=0.00111971f //x=1.145 \
 //y=5.2 //x2=2.455 //y2=5.2
cc_69 ( N_VDD_M3_noxref_d N_Y_M4_noxref_d ) capacitor c=0.0664752f //x=2.015 \
 //y=5.2 //x2=2.455 //y2=5.2
cc_70 ( N_VDD_M5_noxref_d N_Y_M4_noxref_d ) capacitor c=0.0664752f //x=2.895 \
 //y=5.2 //x2=2.455 //y2=5.2
cc_71 ( N_A_c_73_n N_B_c_137_n ) capacitor c=0.00400249f //x=1.6 //y=2.26 \
 //x2=2.34 //y2=4.715
cc_72 ( N_A_c_90_n N_B_c_137_n ) capacitor c=0.00417994f //x=1.6 //y=4.88 \
 //x2=2.34 //y2=4.715
cc_73 ( N_A_c_73_n N_B_c_128_n ) capacitor c=0.0892371f //x=1.6 //y=2.26 \
 //x2=2.34 //y2=2.26
cc_74 ( N_A_c_78_n N_B_c_128_n ) capacitor c=0.00308814f //x=1.405 //y=2.095 \
 //x2=2.34 //y2=2.26
cc_75 ( N_A_M2_noxref_g N_B_M4_noxref_g ) capacitor c=0.0104611f //x=1.5 \
 //y=6.2 //x2=2.38 //y2=6.2
cc_76 ( N_A_M3_noxref_g N_B_M4_noxref_g ) capacitor c=0.106811f //x=1.94 \
 //y=6.2 //x2=2.38 //y2=6.2
cc_77 ( N_A_M3_noxref_g N_B_M5_noxref_g ) capacitor c=0.0100341f //x=1.94 \
 //y=6.2 //x2=2.82 //y2=6.2
cc_78 ( N_A_c_74_n N_B_c_144_n ) capacitor c=4.86506e-19 //x=1.405 //y=1.045 \
 //x2=2.375 //y2=1.085
cc_79 ( N_A_c_76_n N_B_c_144_n ) capacitor c=0.00152104f //x=1.405 //y=1.39 \
 //x2=2.375 //y2=1.085
cc_80 ( N_A_c_81_n N_B_c_144_n ) capacitor c=0.0151475f //x=1.935 //y=1.045 \
 //x2=2.375 //y2=1.085
cc_81 ( N_A_c_77_n N_B_c_147_n ) capacitor c=0.00109982f //x=1.405 //y=1.7 \
 //x2=2.375 //y2=1.43
cc_82 ( N_A_c_83_n N_B_c_147_n ) capacitor c=0.0111064f //x=1.935 //y=1.39 \
 //x2=2.375 //y2=1.43
cc_83 ( N_A_c_77_n N_B_c_149_n ) capacitor c=9.57794e-19 //x=1.405 //y=1.7 \
 //x2=2.375 //y2=1.74
cc_84 ( N_A_c_78_n N_B_c_149_n ) capacitor c=0.00662747f //x=1.405 //y=2.095 \
 //x2=2.375 //y2=1.74
cc_85 ( N_A_c_83_n N_B_c_149_n ) capacitor c=0.00862358f //x=1.935 //y=1.39 \
 //x2=2.375 //y2=1.74
cc_86 ( N_A_c_81_n N_B_c_152_n ) capacitor c=0.00124821f //x=1.935 //y=1.045 \
 //x2=2.905 //y2=1.085
cc_87 ( N_A_c_83_n N_B_c_153_n ) capacitor c=0.00200715f //x=1.935 //y=1.39 \
 //x2=2.905 //y2=1.43
cc_88 ( N_A_c_73_n N_B_c_154_n ) capacitor c=0.00307062f //x=1.6 //y=2.26 \
 //x2=2.34 //y2=2.26
cc_89 ( N_A_c_78_n N_B_c_154_n ) capacitor c=0.0179092f //x=1.405 //y=2.095 \
 //x2=2.34 //y2=2.26
cc_90 ( N_A_c_73_n N_B_c_156_n ) capacitor c=0.00344981f //x=1.6 //y=2.26 \
 //x2=2.37 //y2=4.88
cc_91 ( N_A_c_90_n N_B_c_156_n ) capacitor c=0.0293367f //x=1.6 //y=4.88 \
 //x2=2.37 //y2=4.88
cc_92 ( N_A_c_73_n Y ) capacitor c=0.00396426f //x=1.6 //y=2.26 //x2=3.08 \
 //y2=2.4
cc_93 ( N_A_M3_noxref_g N_Y_c_197_n ) capacitor c=0.0204115f //x=1.94 //y=6.2 \
 //x2=2.515 //y2=5.38
cc_94 ( N_A_c_73_n N_Y_c_200_n ) capacitor c=0.0055959f //x=1.6 //y=2.26 \
 //x2=1.805 //y2=5.38
cc_95 ( N_A_M2_noxref_g N_Y_c_200_n ) capacitor c=0.0177326f //x=1.5 //y=6.2 \
 //x2=1.805 //y2=5.38
cc_96 ( N_A_c_90_n N_Y_c_200_n ) capacitor c=0.00605692f //x=1.6 //y=4.88 \
 //x2=1.805 //y2=5.38
cc_97 ( N_A_M3_noxref_g N_Y_M2_noxref_d ) capacitor c=0.0173476f //x=1.94 \
 //y=6.2 //x2=1.575 //y2=5.2
cc_98 ( N_A_c_78_n N_noxref_6_c_266_n ) capacitor c=0.0034165f //x=1.405 \
 //y=2.095 //x2=1.185 //y2=1.675
cc_99 ( N_A_c_73_n N_noxref_6_c_249_n ) capacitor c=0.0118986f //x=1.6 \
 //y=2.26 //x2=2.07 //y2=1.76
cc_100 ( N_A_c_77_n N_noxref_6_c_249_n ) capacitor c=0.00703567f //x=1.405 \
 //y=1.7 //x2=2.07 //y2=1.76
cc_101 ( N_A_c_78_n N_noxref_6_c_249_n ) capacitor c=0.0216532f //x=1.405 \
 //y=2.095 //x2=2.07 //y2=1.76
cc_102 ( N_A_c_80_n N_noxref_6_c_249_n ) capacitor c=0.00780629f //x=1.78 \
 //y=1.545 //x2=2.07 //y2=1.76
cc_103 ( N_A_c_83_n N_noxref_6_c_249_n ) capacitor c=0.00339872f //x=1.935 \
 //y=1.39 //x2=2.07 //y2=1.76
cc_104 ( N_A_c_78_n N_noxref_6_c_256_n ) capacitor c=6.71402e-19 //x=1.405 \
 //y=2.095 //x2=2.155 //y2=1.675
cc_105 ( N_A_c_74_n N_noxref_6_M0_noxref_s ) capacitor c=0.0326577f //x=1.405 \
 //y=1.045 //x2=1.05 //y2=0.545
cc_106 ( N_A_c_77_n N_noxref_6_M0_noxref_s ) capacitor c=3.48408e-19 //x=1.405 \
 //y=1.7 //x2=1.05 //y2=0.545
cc_107 ( N_A_c_81_n N_noxref_6_M0_noxref_s ) capacitor c=0.0120759f //x=1.935 \
 //y=1.045 //x2=1.05 //y2=0.545
cc_108 ( N_B_c_137_n Y ) capacitor c=0.0101115f //x=2.34 //y=4.715 //x2=3.08 \
 //y2=2.4
cc_109 ( N_B_c_128_n Y ) capacitor c=0.0840845f //x=2.34 //y=2.26 //x2=3.08 \
 //y2=2.4
cc_110 ( N_B_c_160_p Y ) capacitor c=0.0142673f //x=2.745 //y=4.97 //x2=3.08 \
 //y2=2.4
cc_111 ( N_B_c_154_n Y ) capacitor c=0.00877984f //x=2.34 //y=2.26 //x2=3.08 \
 //y2=2.4
cc_112 ( N_B_c_162_p Y ) capacitor c=0.00306024f //x=2.34 //y=2.095 //x2=3.08 \
 //y2=2.4
cc_113 ( N_B_c_156_n Y ) capacitor c=0.00533692f //x=2.37 //y=4.88 //x2=3.08 \
 //y2=2.4
cc_114 ( N_B_c_137_n N_Y_c_197_n ) capacitor c=0.0127867f //x=2.34 //y=4.715 \
 //x2=2.515 //y2=5.38
cc_115 ( N_B_M4_noxref_g N_Y_c_197_n ) capacitor c=0.0166699f //x=2.38 //y=6.2 \
 //x2=2.515 //y2=5.38
cc_116 ( N_B_c_156_n N_Y_c_197_n ) capacitor c=0.00399417f //x=2.37 //y=4.88 \
 //x2=2.515 //y2=5.38
cc_117 ( N_B_M5_noxref_g N_Y_c_202_n ) capacitor c=0.0223814f //x=2.82 //y=6.2 \
 //x2=2.995 //y2=5.38
cc_118 ( N_B_c_168_p N_Y_c_191_n ) capacitor c=0.00359704f //x=2.75 //y=1.585 \
 //x2=2.995 //y2=1.835
cc_119 ( N_B_c_153_n N_Y_c_191_n ) capacitor c=0.00457401f //x=2.905 //y=1.43 \
 //x2=2.995 //y2=1.835
cc_120 ( N_B_c_160_p N_Y_c_232_n ) capacitor c=0.00421574f //x=2.745 //y=4.97 \
 //x2=2.6 //y2=5.38
cc_121 ( N_B_c_144_n N_Y_M1_noxref_d ) capacitor c=0.00217566f //x=2.375 \
 //y=1.085 //x2=2.45 //y2=1.085
cc_122 ( N_B_c_147_n N_Y_M1_noxref_d ) capacitor c=0.0034598f //x=2.375 \
 //y=1.43 //x2=2.45 //y2=1.085
cc_123 ( N_B_c_149_n N_Y_M1_noxref_d ) capacitor c=0.0065582f //x=2.375 \
 //y=1.74 //x2=2.45 //y2=1.085
cc_124 ( N_B_c_174_p N_Y_M1_noxref_d ) capacitor c=0.00241102f //x=2.75 \
 //y=0.93 //x2=2.45 //y2=1.085
cc_125 ( N_B_c_168_p N_Y_M1_noxref_d ) capacitor c=0.0138845f //x=2.75 \
 //y=1.585 //x2=2.45 //y2=1.085
cc_126 ( N_B_c_152_n N_Y_M1_noxref_d ) capacitor c=0.00132245f //x=2.905 \
 //y=1.085 //x2=2.45 //y2=1.085
cc_127 ( N_B_c_153_n N_Y_M1_noxref_d ) capacitor c=0.00566463f //x=2.905 \
 //y=1.43 //x2=2.45 //y2=1.085
cc_128 ( N_B_c_162_p N_Y_M1_noxref_d ) capacitor c=0.00660593f //x=2.34 \
 //y=2.095 //x2=2.45 //y2=1.085
cc_129 ( N_B_M4_noxref_g N_Y_M4_noxref_d ) capacitor c=0.0173476f //x=2.38 \
 //y=6.2 //x2=2.455 //y2=5.2
cc_130 ( N_B_M5_noxref_g N_Y_M4_noxref_d ) capacitor c=0.0179769f //x=2.82 \
 //y=6.2 //x2=2.455 //y2=5.2
cc_131 ( N_B_c_149_n N_noxref_6_c_256_n ) capacitor c=0.00623646f //x=2.375 \
 //y=1.74 //x2=2.155 //y2=1.675
cc_132 ( N_B_c_154_n N_noxref_6_c_256_n ) capacitor c=0.00172768f //x=2.34 \
 //y=2.26 //x2=2.155 //y2=1.675
cc_133 ( N_B_c_128_n N_noxref_6_c_257_n ) capacitor c=0.00161845f //x=2.34 \
 //y=2.26 //x2=3.04 //y2=0.71
cc_134 ( N_B_c_144_n N_noxref_6_c_257_n ) capacitor c=0.0186143f //x=2.375 \
 //y=1.085 //x2=3.04 //y2=0.71
cc_135 ( N_B_c_152_n N_noxref_6_c_257_n ) capacitor c=0.00656458f //x=2.905 \
 //y=1.085 //x2=3.04 //y2=0.71
cc_136 ( N_B_c_154_n N_noxref_6_c_257_n ) capacitor c=2.1838e-19 //x=2.34 \
 //y=2.26 //x2=3.04 //y2=0.71
cc_137 ( N_B_c_144_n N_noxref_6_M0_noxref_s ) capacitor c=0.00623646f \
 //x=2.375 //y=1.085 //x2=1.05 //y2=0.545
cc_138 ( N_B_c_152_n N_noxref_6_M0_noxref_s ) capacitor c=0.0143002f //x=2.905 \
 //y=1.085 //x2=1.05 //y2=0.545
cc_139 ( N_B_c_153_n N_noxref_6_M0_noxref_s ) capacitor c=0.00290153f \
 //x=2.905 //y=1.43 //x2=1.05 //y2=0.545
cc_140 ( N_Y_c_243_p N_noxref_6_c_266_n ) capacitor c=3.15806e-19 //x=2.725 \
 //y=1.835 //x2=1.185 //y2=1.675
cc_141 ( N_Y_c_243_p N_noxref_6_c_256_n ) capacitor c=0.0201674f //x=2.725 \
 //y=1.835 //x2=2.155 //y2=1.675
cc_142 ( N_Y_c_191_n N_noxref_6_c_257_n ) capacitor c=0.00469114f //x=2.995 \
 //y=1.835 //x2=3.04 //y2=0.71
cc_143 ( N_Y_M1_noxref_d N_noxref_6_c_257_n ) capacitor c=0.0118355f //x=2.45 \
 //y=1.085 //x2=3.04 //y2=0.71
cc_144 ( N_Y_c_191_n N_noxref_6_M0_noxref_s ) capacitor c=0.0144625f //x=2.995 \
 //y=1.835 //x2=1.05 //y2=0.545
cc_145 ( N_Y_M1_noxref_d N_noxref_6_M0_noxref_s ) capacitor c=0.0437911f \
 //x=2.45 //y=1.085 //x2=1.05 //y2=0.545
