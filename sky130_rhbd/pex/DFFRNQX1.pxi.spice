// File: DFFRNQX1.spi.DFFRNQX1.pxi
// Created: Fri Feb 20 10:10:19 2026
//
simulator lang=spectre
x_PM_DFFRNQX1\%noxref_1 ( N_noxref_1_c_30_p N_noxref_1_c_24_p \
 N_noxref_1_c_25_p N_noxref_1_c_26_p N_noxref_1_c_143_p N_noxref_1_c_187_p \
 N_noxref_1_c_8_p N_noxref_1_c_9_p N_noxref_1_c_16_p N_noxref_1_c_2_p \
 N_noxref_1_c_3_p N_noxref_1_c_87_p N_noxref_1_c_154_p N_noxref_1_c_121_p \
 N_noxref_1_c_6_p N_noxref_1_c_5_p N_noxref_1_c_10_p N_noxref_1_c_27_p \
 N_noxref_1_c_39_p N_noxref_1_c_40_p N_noxref_1_c_163_p N_noxref_1_c_158_p \
 N_noxref_1_c_17_p N_noxref_1_c_177_p N_noxref_1_c_11_p N_noxref_1_c_7_p \
 N_noxref_1_c_43_p N_noxref_1_c_28_p N_noxref_1_c_99_p N_noxref_1_c_110_p \
 N_noxref_1_c_108_p N_noxref_1_c_123_p N_noxref_1_c_112_p N_noxref_1_c_18_p \
 N_noxref_1_c_29_p N_noxref_1_c_34_p N_noxref_1_c_142_p N_noxref_1_c_285_p \
 N_noxref_1_c_164_p N_noxref_1_c_181_p N_noxref_1_c_12_p \
 N_noxref_1_M2_noxref_g N_noxref_1_M6_noxref_g N_noxref_1_M20_noxref_g \
 N_noxref_1_M21_noxref_g N_noxref_1_M28_noxref_g N_noxref_1_M29_noxref_g \
 N_noxref_1_c_55_p N_noxref_1_c_56_p N_noxref_1_c_57_p N_noxref_1_c_78_p \
 N_noxref_1_c_79_p N_noxref_1_c_80_p N_noxref_1_c_81_p N_noxref_1_c_259_p \
 N_noxref_1_c_260_p N_noxref_1_c_262_p N_noxref_1_c_237_p N_noxref_1_c_385_p \
 N_noxref_1_c_386_p N_noxref_1_c_261_p N_noxref_1_c_263_p N_noxref_1_c_32_p \
 N_noxref_1_c_61_p N_noxref_1_c_35_p N_noxref_1_c_15_p N_noxref_1_M5_noxref_d \
 N_noxref_1_M22_noxref_d N_noxref_1_M24_noxref_d N_noxref_1_M26_noxref_d )  \
 PM_DFFRNQX1\%noxref_1
x_PM_DFFRNQX1\%noxref_2 ( N_noxref_2_c_432_n N_noxref_2_c_433_n \
 N_noxref_2_c_561_p N_noxref_2_c_539_p N_noxref_2_c_434_n N_noxref_2_c_435_n \
 N_noxref_2_c_501_p N_noxref_2_c_437_n N_noxref_2_c_463_p N_noxref_2_c_457_p \
 N_noxref_2_c_458_p N_noxref_2_c_459_p N_noxref_2_c_439_n N_noxref_2_c_474_p \
 N_noxref_2_c_596_p N_noxref_2_c_447_n N_noxref_2_c_448_n N_noxref_2_c_460_p \
 N_noxref_2_c_449_n N_noxref_2_c_461_p N_noxref_2_c_506_p N_noxref_2_c_450_n \
 N_noxref_2_c_560_p N_noxref_2_c_462_p N_noxref_2_c_467_p \
 N_noxref_2_M8_noxref_g N_noxref_2_M32_noxref_g N_noxref_2_M33_noxref_g \
 N_noxref_2_c_486_p N_noxref_2_c_487_p N_noxref_2_c_489_p N_noxref_2_c_465_p \
 N_noxref_2_c_646_p N_noxref_2_c_659_p N_noxref_2_c_488_p N_noxref_2_c_490_p \
 N_noxref_2_c_468_p N_noxref_2_c_469_p N_noxref_2_M7_noxref_d \
 N_noxref_2_M28_noxref_d N_noxref_2_M30_noxref_d )  PM_DFFRNQX1\%noxref_2
x_PM_DFFRNQX1\%CLK ( CLK CLK CLK CLK CLK CLK CLK CLK CLK N_CLK_c_710_n \
 N_CLK_c_753_n N_CLK_c_713_n N_CLK_c_756_n N_CLK_c_716_n N_CLK_c_762_n \
 N_CLK_c_724_n N_CLK_c_725_n N_CLK_c_729_n N_CLK_c_765_n N_CLK_c_769_n \
 N_CLK_M1_noxref_g N_CLK_M9_noxref_g N_CLK_M18_noxref_g N_CLK_M19_noxref_g \
 N_CLK_M34_noxref_g N_CLK_M35_noxref_g N_CLK_c_917_p N_CLK_c_919_p \
 N_CLK_c_955_p N_CLK_c_956_p N_CLK_c_735_n N_CLK_c_736_n N_CLK_c_737_n \
 N_CLK_c_738_n N_CLK_c_742_n N_CLK_c_776_n N_CLK_c_779_n N_CLK_c_972_p \
 N_CLK_c_973_p N_CLK_c_781_n N_CLK_c_782_n N_CLK_c_783_n N_CLK_c_784_n \
 N_CLK_c_858_p N_CLK_c_743_n N_CLK_c_787_n )  PM_DFFRNQX1\%CLK
x_PM_DFFRNQX1\%noxref_4 ( N_noxref_4_c_1103_n N_noxref_4_c_1002_n \
 N_noxref_4_c_1004_n N_noxref_4_c_1007_n N_noxref_4_c_1012_n \
 N_noxref_4_c_1019_n N_noxref_4_c_1024_n N_noxref_4_c_1028_n \
 N_noxref_4_c_1030_n N_noxref_4_c_1040_n N_noxref_4_c_1042_n \
 N_noxref_4_c_1045_n N_noxref_4_c_1046_n N_noxref_4_c_1050_n \
 N_noxref_4_c_1051_n N_noxref_4_c_1148_p N_noxref_4_c_1139_p \
 N_noxref_4_c_1143_p N_noxref_4_c_1140_p N_noxref_4_c_1222_p \
 N_noxref_4_c_1114_n N_noxref_4_c_1052_n N_noxref_4_c_1055_n \
 N_noxref_4_c_1343_p N_noxref_4_c_1145_p N_noxref_4_c_1056_n \
 N_noxref_4_c_1058_n N_noxref_4_c_1061_n N_noxref_4_c_1065_n \
 N_noxref_4_c_1069_n N_noxref_4_c_1091_n N_noxref_4_c_1094_n \
 N_noxref_4_c_1097_n N_noxref_4_c_1101_n N_noxref_4_c_1131_n \
 N_noxref_4_c_1146_p N_noxref_4_c_1071_n N_noxref_4_c_1251_p \
 N_noxref_4_c_1132_n N_noxref_4_c_1073_n N_noxref_4_c_1345_p \
 N_noxref_4_c_1295_p N_noxref_4_c_1150_p N_noxref_4_c_1147_p \
 N_noxref_4_M3_noxref_g N_noxref_4_M11_noxref_g N_noxref_4_M22_noxref_g \
 N_noxref_4_M23_noxref_g N_noxref_4_M38_noxref_g N_noxref_4_M39_noxref_g \
 N_noxref_4_c_1365_p N_noxref_4_c_1366_p N_noxref_4_c_1368_p \
 N_noxref_4_c_1349_p N_noxref_4_c_1385_p N_noxref_4_c_1398_p \
 N_noxref_4_c_1367_p N_noxref_4_c_1369_p N_noxref_4_c_1083_n \
 N_noxref_4_c_1296_p N_noxref_4_c_1184_p N_noxref_4_c_1185_p \
 N_noxref_4_c_1187_p N_noxref_4_c_1151_p N_noxref_4_c_1388_p \
 N_noxref_4_c_1408_p N_noxref_4_c_1186_p N_noxref_4_c_1188_p \
 N_noxref_4_c_1154_p N_noxref_4_c_1155_p N_noxref_4_M2_noxref_d \
 N_noxref_4_M16_noxref_d N_noxref_4_M18_noxref_d N_noxref_4_M20_noxref_d )  \
 PM_DFFRNQX1\%noxref_4
x_PM_DFFRNQX1\%RN ( RN RN RN RN RN RN RN RN RN RN RN RN RN N_RN_c_1472_n \
 N_RN_c_1550_n N_RN_c_1589_n N_RN_c_1593_n N_RN_c_1476_n N_RN_c_1480_n \
 N_RN_c_1483_n N_RN_c_1557_n N_RN_c_1607_n N_RN_c_1609_n N_RN_c_1493_n \
 N_RN_c_1494_n N_RN_c_1558_n N_RN_c_1561_n N_RN_c_1615_n N_RN_c_1618_n \
 N_RN_M5_noxref_g N_RN_M10_noxref_g N_RN_M12_noxref_g N_RN_M26_noxref_g \
 N_RN_M27_noxref_g N_RN_M36_noxref_g N_RN_M37_noxref_g N_RN_M40_noxref_g \
 N_RN_M41_noxref_g N_RN_c_1504_n N_RN_c_1506_n N_RN_c_1509_n N_RN_c_1510_n \
 N_RN_c_1512_n N_RN_c_1516_n N_RN_c_1518_n N_RN_c_1567_n N_RN_c_1568_n \
 N_RN_c_1569_n N_RN_c_1669_p N_RN_c_1670_p N_RN_c_1671_p N_RN_c_1672_p \
 N_RN_c_1625_n N_RN_c_1628_n N_RN_c_1842_p N_RN_c_1843_p N_RN_c_1630_n \
 N_RN_c_1631_n N_RN_c_1632_n N_RN_c_1633_n N_RN_c_1652_p N_RN_c_1522_n \
 N_RN_c_1523_n N_RN_c_1525_n N_RN_c_1570_n N_RN_c_1572_n N_RN_c_1573_n \
 N_RN_c_1636_n )  PM_DFFRNQX1\%RN
x_PM_DFFRNQX1\%noxref_6 ( N_noxref_6_c_1895_n N_noxref_6_c_1907_n \
 N_noxref_6_c_1999_p N_noxref_6_c_1940_p N_noxref_6_c_1988_p \
 N_noxref_6_c_1996_p N_noxref_6_c_1981_p N_noxref_6_c_1921_p \
 N_noxref_6_c_1908_n N_noxref_6_c_1974_p N_noxref_6_c_1909_n \
 N_noxref_6_c_1924_p N_noxref_6_c_1925_p N_noxref_6_c_1896_n \
 N_noxref_6_c_1910_n N_noxref_6_c_1993_p N_noxref_6_c_1977_p \
 N_noxref_6_c_1926_p N_noxref_6_c_1937_p N_noxref_6_c_1932_p \
 N_noxref_6_c_1927_p N_noxref_6_c_1978_p N_noxref_6_c_1928_p \
 N_noxref_6_c_1946_p N_noxref_6_c_1899_n N_noxref_6_c_1915_n \
 N_noxref_6_c_1994_p N_noxref_6_c_1929_p N_noxref_6_c_1934_p \
 N_noxref_6_M14_noxref_g N_noxref_6_M44_noxref_g N_noxref_6_M45_noxref_g \
 N_noxref_6_c_1957_p N_noxref_6_c_1958_p N_noxref_6_c_1960_p \
 N_noxref_6_c_1939_p N_noxref_6_c_2132_p N_noxref_6_c_2133_p \
 N_noxref_6_c_1959_p N_noxref_6_c_1961_p N_noxref_6_c_1935_p \
 N_noxref_6_M13_noxref_d N_noxref_6_M38_noxref_d N_noxref_6_M40_noxref_d \
 N_noxref_6_M42_noxref_d )  PM_DFFRNQX1\%noxref_6
x_PM_DFFRNQX1\%noxref_7 ( N_noxref_7_c_2293_n N_noxref_7_c_2171_n \
 N_noxref_7_c_2298_n N_noxref_7_c_2173_n N_noxref_7_c_2174_n \
 N_noxref_7_c_2182_n N_noxref_7_c_2183_n N_noxref_7_c_2241_n \
 N_noxref_7_c_2313_n N_noxref_7_c_2420_n N_noxref_7_c_2422_n \
 N_noxref_7_c_2426_n N_noxref_7_c_2242_n N_noxref_7_c_2439_n \
 N_noxref_7_c_2243_n N_noxref_7_c_2314_n N_noxref_7_c_2377_n \
 N_noxref_7_c_2315_n N_noxref_7_c_2488_n N_noxref_7_c_2496_n \
 N_noxref_7_c_2497_n N_noxref_7_c_2316_n N_noxref_7_c_2188_n \
 N_noxref_7_c_2189_n N_noxref_7_c_2246_n N_noxref_7_c_2318_n \
 N_noxref_7_c_2457_n N_noxref_7_c_2461_n N_noxref_7_c_2502_n \
 N_noxref_7_c_2503_n N_noxref_7_c_2192_n N_noxref_7_c_2196_n \
 N_noxref_7_c_2197_n N_noxref_7_c_2198_n N_noxref_7_c_2251_n \
 N_noxref_7_c_2199_n N_noxref_7_c_2406_n N_noxref_7_c_2408_n \
 N_noxref_7_c_2335_n N_noxref_7_c_2336_n N_noxref_7_c_2340_n \
 N_noxref_7_c_2203_n N_noxref_7_c_2207_n N_noxref_7_c_2258_n \
 N_noxref_7_c_2343_n N_noxref_7_c_2474_n N_noxref_7_c_2513_n \
 N_noxref_7_c_2517_n N_noxref_7_M0_noxref_g N_noxref_7_M7_noxref_g \
 N_noxref_7_M15_noxref_g N_noxref_7_M16_noxref_g N_noxref_7_M17_noxref_g \
 N_noxref_7_M30_noxref_g N_noxref_7_M31_noxref_g N_noxref_7_M46_noxref_g \
 N_noxref_7_M47_noxref_g N_noxref_7_c_2350_n N_noxref_7_c_2351_n \
 N_noxref_7_c_2352_n N_noxref_7_c_2353_n N_noxref_7_c_2702_p \
 N_noxref_7_c_2717_p N_noxref_7_c_2356_n N_noxref_7_c_2358_n \
 N_noxref_7_c_2361_n N_noxref_7_c_2364_n N_noxref_7_c_2213_n \
 N_noxref_7_c_2216_n N_noxref_7_c_2218_n N_noxref_7_c_2273_n \
 N_noxref_7_c_2276_n N_noxref_7_c_2278_n N_noxref_7_c_2221_n \
 N_noxref_7_c_2222_n N_noxref_7_c_2523_n N_noxref_7_c_2526_n \
 N_noxref_7_c_2528_n N_noxref_7_c_2551_p N_noxref_7_c_2578_p \
 N_noxref_7_c_2564_p N_noxref_7_c_2531_n N_noxref_7_c_2532_n \
 N_noxref_7_c_2223_n N_noxref_7_c_2289_n N_noxref_7_c_2226_n \
 N_noxref_7_c_2533_n N_noxref_7_c_2544_p N_noxref_7_c_2536_n \
 N_noxref_7_M10_noxref_d N_noxref_7_M32_noxref_d N_noxref_7_M34_noxref_d \
 N_noxref_7_M36_noxref_d )  PM_DFFRNQX1\%noxref_7
x_PM_DFFRNQX1\%Q ( Q Q Q Q Q Q Q Q Q Q Q Q N_Q_c_2790_n N_Q_c_2794_n \
 N_Q_c_2795_n N_Q_c_2844_n N_Q_c_2845_n N_Q_c_2934_n N_Q_c_2935_n N_Q_c_2846_n \
 N_Q_c_2937_n N_Q_c_2783_n N_Q_c_2848_n N_Q_c_2940_n N_Q_c_2970_p N_Q_c_2856_n \
 Q N_Q_c_2857_n N_Q_c_2952_n N_Q_c_2784_n N_Q_c_2801_n N_Q_c_2804_n \
 N_Q_c_2871_n N_Q_c_2957_n N_Q_M13_noxref_g N_Q_M42_noxref_g N_Q_M43_noxref_g \
 N_Q_c_2811_n N_Q_c_2812_n N_Q_c_2813_n N_Q_c_2888_n N_Q_c_2890_n N_Q_c_2894_n \
 N_Q_c_2896_n N_Q_c_2814_n N_Q_c_2817_n N_Q_c_2818_n N_Q_M15_noxref_d \
 N_Q_M44_noxref_d N_Q_M46_noxref_d )  PM_DFFRNQX1\%Q
x_PM_DFFRNQX1\%VDD ( VDD N_VDD_c_3043_n N_VDD_c_3178_n N_VDD_c_3180_n \
 N_VDD_c_3152_n N_VDD_c_3056_n N_VDD_c_3191_n N_VDD_c_3058_n N_VDD_c_3061_n \
 N_VDD_c_3065_n N_VDD_c_3069_n N_VDD_c_3070_n N_VDD_c_3114_n N_VDD_c_3119_n \
 N_VDD_c_3154_n N_VDD_c_3233_n N_VDD_c_3333_n N_VDD_c_3194_n N_VDD_c_3235_n \
 N_VDD_c_3267_n N_VDD_c_3271_n N_VDD_c_3272_n N_VDD_c_3334_n N_VDD_c_3336_n \
 N_VDD_c_3073_n N_VDD_c_3077_n N_VDD_c_3124_n N_VDD_c_3202_n N_VDD_c_3277_n \
 N_VDD_M16_noxref_s N_VDD_M17_noxref_d N_VDD_M19_noxref_d N_VDD_M21_noxref_d \
 N_VDD_M22_noxref_s N_VDD_M23_noxref_d N_VDD_M25_noxref_d N_VDD_M27_noxref_d \
 N_VDD_M28_noxref_s N_VDD_M29_noxref_d N_VDD_M31_noxref_d N_VDD_M32_noxref_s \
 N_VDD_M33_noxref_d N_VDD_M35_noxref_d N_VDD_M37_noxref_d N_VDD_M38_noxref_s \
 N_VDD_M39_noxref_d N_VDD_M41_noxref_d N_VDD_M43_noxref_d N_VDD_M44_noxref_s \
 N_VDD_M45_noxref_d N_VDD_M47_noxref_d )  PM_DFFRNQX1\%VDD
x_PM_DFFRNQX1\%noxref_10 ( N_noxref_10_c_3450_n N_noxref_10_c_3477_p \
 N_noxref_10_c_3440_n N_noxref_10_c_3479_p N_noxref_10_c_3445_n \
 N_noxref_10_M1_noxref_d N_noxref_10_M2_noxref_s )  PM_DFFRNQX1\%noxref_10
x_PM_DFFRNQX1\%noxref_11 ( N_noxref_11_c_3534_p N_noxref_11_c_3544_p \
 N_noxref_11_c_3504_n N_noxref_11_c_3546_p N_noxref_11_c_3507_n \
 N_noxref_11_M4_noxref_d N_noxref_11_M5_noxref_s )  PM_DFFRNQX1\%noxref_11
x_PM_DFFRNQX1\%D ( D D N_D_c_3574_n N_D_c_3575_n N_D_c_3607_n N_D_c_3578_n \
 N_D_M4_noxref_g N_D_M24_noxref_g N_D_M25_noxref_g N_D_c_3618_n N_D_c_3621_n \
 N_D_c_3673_n N_D_c_3674_n N_D_c_3623_n N_D_c_3624_n N_D_c_3625_n N_D_c_3626_n \
 N_D_c_3586_n N_D_c_3588_n )  PM_DFFRNQX1\%D
x_PM_DFFRNQX1\%noxref_13 ( N_noxref_13_c_3695_n N_noxref_13_c_3736_p \
 N_noxref_13_c_3711_n N_noxref_13_c_3738_p N_noxref_13_c_3716_n \
 N_noxref_13_M9_noxref_d N_noxref_13_M10_noxref_s )  PM_DFFRNQX1\%noxref_13
x_PM_DFFRNQX1\%noxref_14 ( N_noxref_14_c_3763_n N_noxref_14_c_3803_p \
 N_noxref_14_c_3780_n N_noxref_14_c_3805_p N_noxref_14_c_3783_n \
 N_noxref_14_M12_noxref_d N_noxref_14_M13_noxref_s )  PM_DFFRNQX1\%noxref_14
x_PM_DFFRNQX1\%GND ( GND N_GND_c_4165_p N_GND_c_4034_n N_GND_c_3830_n \
 N_GND_c_3918_n N_GND_c_3831_n N_GND_c_3871_n N_GND_c_3875_n N_GND_c_3913_n \
 N_GND_c_3921_n N_GND_c_3983_n N_GND_c_4041_n N_GND_c_4043_n N_GND_c_3924_n \
 N_GND_c_3835_n N_GND_c_3845_n N_GND_c_3881_n N_GND_c_3935_n N_GND_c_4002_n \
 N_GND_c_4013_n N_GND_c_3848_n N_GND_c_4055_n N_GND_c_3849_n N_GND_c_3851_n \
 N_GND_c_3894_n N_GND_c_3947_n N_GND_c_4018_n N_GND_c_3852_n N_GND_c_3856_n \
 N_GND_c_3896_n N_GND_c_3955_n N_GND_c_4019_n N_GND_M0_noxref_d \
 N_GND_M3_noxref_d N_GND_M6_noxref_d N_GND_M8_noxref_d N_GND_M11_noxref_d \
 N_GND_M14_noxref_d )  PM_DFFRNQX1\%GND
x_PM_DFFRNQX1\%noxref_16 ( N_noxref_16_c_4299_n N_noxref_16_c_4300_n \
 N_noxref_16_c_4311_n N_noxref_16_c_4289_n N_noxref_16_c_4291_n \
 N_noxref_16_M0_noxref_s )  PM_DFFRNQX1\%noxref_16
x_PM_DFFRNQX1\%noxref_17 ( N_noxref_17_c_4341_n N_noxref_17_c_4342_n \
 N_noxref_17_c_4360_n N_noxref_17_c_4361_n N_noxref_17_c_4344_n \
 N_noxref_17_M3_noxref_s )  PM_DFFRNQX1\%noxref_17
x_PM_DFFRNQX1\%noxref_18 ( N_noxref_18_c_4399_n N_noxref_18_c_4400_n \
 N_noxref_18_c_4445_n N_noxref_18_c_4407_n N_noxref_18_c_4412_n \
 N_noxref_18_c_4454_n N_noxref_18_M6_noxref_s )  PM_DFFRNQX1\%noxref_18
x_PM_DFFRNQX1\%noxref_19 ( N_noxref_19_c_4467_n N_noxref_19_c_4468_n \
 N_noxref_19_c_4493_n N_noxref_19_c_4479_n N_noxref_19_c_4481_n \
 N_noxref_19_M8_noxref_s )  PM_DFFRNQX1\%noxref_19
x_PM_DFFRNQX1\%noxref_20 ( N_noxref_20_c_4526_n N_noxref_20_c_4527_n \
 N_noxref_20_c_4553_n N_noxref_20_c_4540_n N_noxref_20_c_4542_n \
 N_noxref_20_M11_noxref_s )  PM_DFFRNQX1\%noxref_20
x_PM_DFFRNQX1\%noxref_21 ( N_noxref_21_c_4583_n N_noxref_21_c_4585_n \
 N_noxref_21_c_4628_n N_noxref_21_c_4593_n N_noxref_21_c_4601_n \
 N_noxref_21_c_4635_n N_noxref_21_M14_noxref_s )  PM_DFFRNQX1\%noxref_21
cc_1 ( N_noxref_1_M29_noxref_g N_noxref_2_c_432_n ) capacitor c=0.00889217f \
 //x=11.505 //y=6.2 //x2=12.05 //y2=5.38
cc_2 ( N_noxref_1_c_2_p N_noxref_2_c_433_n ) capacitor c=0.00326079f //x=8.83 \
 //y=1.76 //x2=12.205 //y2=1.75
cc_3 ( N_noxref_1_c_3_p N_noxref_2_c_434_n ) capacitor c=0.00218808f //x=9.23 \
 //y=1.845 //x2=12.29 //y2=1.835
cc_4 ( N_noxref_1_c_3_p N_noxref_2_c_435_n ) capacitor c=0.00203766f //x=9.23 \
 //y=1.845 //x2=12.645 //y2=3.355
cc_5 ( N_noxref_1_c_5_p N_noxref_2_c_435_n ) capacitor c=0.00286284f \
 //x=11.165 //y=3.35 //x2=12.645 //y2=3.355
cc_6 ( N_noxref_1_c_6_p N_noxref_2_c_437_n ) capacitor c=0.0028534f //x=9.315 \
 //y=5.25 //x2=12.645 //y2=5.295
cc_7 ( N_noxref_1_c_7_p N_noxref_2_c_437_n ) capacitor c=0.00196578f \
 //x=11.167 //y=4.74 //x2=12.645 //y2=5.295
cc_8 ( N_noxref_1_c_8_p N_noxref_2_c_439_n ) capacitor c=5.58535e-19 //x=8.535 \
 //y=5.56 //x2=11.285 //y2=5.56
cc_9 ( N_noxref_1_c_9_p N_noxref_2_c_439_n ) capacitor c=0.00104762f //x=9.23 \
 //y=5.335 //x2=11.285 //y2=5.56
cc_10 ( N_noxref_1_c_10_p N_noxref_2_c_439_n ) capacitor c=6.37679e-19 \
 //x=11.165 //y=3.67 //x2=11.285 //y2=5.56
cc_11 ( N_noxref_1_c_11_p N_noxref_2_c_439_n ) capacitor c=0.0117744f \
 //x=11.165 //y=4.88 //x2=11.285 //y2=5.56
cc_12 ( N_noxref_1_c_12_p N_noxref_2_c_439_n ) capacitor c=0.00277154f \
 //x=11.165 //y=4.88 //x2=11.285 //y2=5.56
cc_13 ( N_noxref_1_M28_noxref_g N_noxref_2_c_439_n ) capacitor c=0.00201806f \
 //x=11.065 //y=6.2 //x2=11.285 //y2=5.56
cc_14 ( N_noxref_1_M29_noxref_g N_noxref_2_c_439_n ) capacitor c=0.00192712f \
 //x=11.505 //y=6.2 //x2=11.285 //y2=5.56
cc_15 ( N_noxref_1_c_15_p N_noxref_2_c_439_n ) capacitor c=0.00192702f \
 //x=11.165 //y=4.88 //x2=11.285 //y2=5.56
cc_16 ( N_noxref_1_c_16_p N_noxref_2_c_447_n ) capacitor c=6.5615e-19 //x=8.83 \
 //y=1.305 //x2=12.205 //y2=1.18
cc_17 ( N_noxref_1_c_17_p N_noxref_2_c_448_n ) capacitor c=0.00251357f \
 //x=11.165 //y=3.51 //x2=12.645 //y2=3.51
cc_18 ( N_noxref_1_c_18_p N_noxref_2_c_449_n ) capacitor c=0.00526461f \
 //x=11.165 //y=3.51 //x2=12.805 //y2=3.515
cc_19 ( N_noxref_1_c_11_p N_noxref_2_c_450_n ) capacitor c=0.00104426f \
 //x=11.165 //y=4.88 //x2=11.285 //y2=5.56
cc_20 ( N_noxref_1_c_12_p N_noxref_2_c_450_n ) capacitor c=0.00377369f \
 //x=11.165 //y=4.88 //x2=11.285 //y2=5.56
cc_21 ( N_noxref_1_M28_noxref_g N_noxref_2_c_450_n ) capacitor c=0.0158358f \
 //x=11.065 //y=6.2 //x2=11.285 //y2=5.56
cc_22 ( N_noxref_1_M29_noxref_g N_noxref_2_c_450_n ) capacitor c=0.0178987f \
 //x=11.505 //y=6.2 //x2=11.285 //y2=5.56
cc_23 ( N_noxref_1_c_15_p N_noxref_2_c_450_n ) capacitor c=0.0043218f \
 //x=11.165 //y=4.88 //x2=11.285 //y2=5.56
cc_24 ( N_noxref_1_c_24_p CLK ) capacitor c=0.029075f //x=3.765 //y=3.35 \
 //x2=2.655 //y2=2.77
cc_25 ( N_noxref_1_c_25_p CLK ) capacitor c=0.00775314f //x=3.765 //y=3.67 \
 //x2=2.655 //y2=2.77
cc_26 ( N_noxref_1_c_26_p CLK ) capacitor c=0.0245236f //x=3.765 //y=4.75 \
 //x2=2.655 //y2=2.77
cc_27 ( N_noxref_1_c_27_p CLK ) capacitor c=3.35971e-19 //x=3.765 //y=3.51 \
 //x2=2.655 //y2=2.77
cc_28 ( N_noxref_1_c_28_p CLK ) capacitor c=0.00508753f //x=3.925 //y=3.51 \
 //x2=2.655 //y2=2.77
cc_29 ( N_noxref_1_c_29_p CLK ) capacitor c=4.16726e-19 //x=3.765 //y=2.26 \
 //x2=2.655 //y2=2.77
cc_30 ( N_noxref_1_c_30_p N_CLK_c_710_n ) capacitor c=0.0116288f //x=3.765 \
 //y=2.375 //x2=2.655 //y2=2.375
cc_31 ( N_noxref_1_c_29_p N_CLK_c_710_n ) capacitor c=5.42289e-19 //x=3.765 \
 //y=2.26 //x2=2.655 //y2=2.375
cc_32 ( N_noxref_1_c_32_p N_CLK_c_710_n ) capacitor c=0.00139071f //x=3.765 \
 //y=2.26 //x2=2.655 //y2=2.375
cc_33 ( N_noxref_1_c_26_p N_CLK_c_713_n ) capacitor c=0.0082089f //x=3.765 \
 //y=4.75 //x2=2.65 //y2=4.835
cc_34 ( N_noxref_1_c_34_p N_CLK_c_713_n ) capacitor c=7.52809e-19 //x=3.765 \
 //y=4.88 //x2=2.65 //y2=4.835
cc_35 ( N_noxref_1_c_35_p N_CLK_c_713_n ) capacitor c=0.0013272f //x=3.765 \
 //y=4.88 //x2=2.65 //y2=4.835
cc_36 ( N_noxref_1_c_26_p N_CLK_c_716_n ) capacitor c=0.0290574f //x=3.765 \
 //y=4.75 //x2=11.525 //y2=4.62
cc_37 ( N_noxref_1_c_9_p N_CLK_c_716_n ) capacitor c=0.0221452f //x=9.23 \
 //y=5.335 //x2=11.525 //y2=4.62
cc_38 ( N_noxref_1_c_6_p N_CLK_c_716_n ) capacitor c=0.0300479f //x=9.315 \
 //y=5.25 //x2=11.525 //y2=4.62
cc_39 ( N_noxref_1_c_39_p N_CLK_c_716_n ) capacitor c=0.0298474f //x=6.777 \
 //y=5.335 //x2=11.525 //y2=4.62
cc_40 ( N_noxref_1_c_40_p N_CLK_c_716_n ) capacitor c=0.040089f //x=7.655 \
 //y=5.335 //x2=11.525 //y2=4.62
cc_41 ( N_noxref_1_c_11_p N_CLK_c_716_n ) capacitor c=0.00404699f //x=11.165 \
 //y=4.88 //x2=11.525 //y2=4.62
cc_42 ( N_noxref_1_c_7_p N_CLK_c_716_n ) capacitor c=0.0269932f //x=11.167 \
 //y=4.74 //x2=11.525 //y2=4.62
cc_43 ( N_noxref_1_c_43_p N_CLK_c_716_n ) capacitor c=0.0021208f //x=4.125 \
 //y=3.51 //x2=11.525 //y2=4.62
cc_44 ( N_noxref_1_c_26_p N_CLK_c_724_n ) capacitor c=0.00655852f //x=3.765 \
 //y=4.75 //x2=2.65 //y2=4.62
cc_45 ( N_noxref_1_c_30_p N_CLK_c_725_n ) capacitor c=5.39999e-19 //x=3.765 \
 //y=2.375 //x2=2.655 //y2=2.26
cc_46 ( N_noxref_1_c_24_p N_CLK_c_725_n ) capacitor c=4.16726e-19 //x=3.765 \
 //y=3.35 //x2=2.655 //y2=2.26
cc_47 ( N_noxref_1_c_29_p N_CLK_c_725_n ) capacitor c=0.00125213f //x=3.765 \
 //y=2.26 //x2=2.655 //y2=2.26
cc_48 ( N_noxref_1_c_32_p N_CLK_c_725_n ) capacitor c=0.00204868f //x=3.765 \
 //y=2.26 //x2=2.655 //y2=2.26
cc_49 ( N_noxref_1_c_26_p N_CLK_c_729_n ) capacitor c=4.56604e-19 //x=3.765 \
 //y=4.75 //x2=2.655 //y2=4.88
cc_50 ( N_noxref_1_c_34_p N_CLK_c_729_n ) capacitor c=0.00113671f //x=3.765 \
 //y=4.88 //x2=2.655 //y2=4.88
cc_51 ( N_noxref_1_c_35_p N_CLK_c_729_n ) capacitor c=0.00186974f //x=3.765 \
 //y=4.88 //x2=2.655 //y2=4.88
cc_52 ( N_noxref_1_M20_noxref_g N_CLK_M18_noxref_g ) capacitor c=0.0101598f \
 //x=3.505 //y=6.2 //x2=2.625 //y2=6.2
cc_53 ( N_noxref_1_M20_noxref_g N_CLK_M19_noxref_g ) capacitor c=0.0607518f \
 //x=3.505 //y=6.2 //x2=3.065 //y2=6.2
cc_54 ( N_noxref_1_M21_noxref_g N_CLK_M19_noxref_g ) capacitor c=0.0101598f \
 //x=3.945 //y=6.2 //x2=3.065 //y2=6.2
cc_55 ( N_noxref_1_c_55_p N_CLK_c_735_n ) capacitor c=0.00456962f //x=3.755 \
 //y=1.095 //x2=2.745 //y2=1.09
cc_56 ( N_noxref_1_c_56_p N_CLK_c_736_n ) capacitor c=0.00438372f //x=3.755 \
 //y=1.44 //x2=2.745 //y2=1.4
cc_57 ( N_noxref_1_c_57_p N_CLK_c_737_n ) capacitor c=0.00438372f //x=3.755 \
 //y=1.75 //x2=2.745 //y2=1.63
cc_58 ( N_noxref_1_c_30_p N_CLK_c_738_n ) capacitor c=0.00141236f //x=3.765 \
 //y=2.375 //x2=2.745 //y2=2.095
cc_59 ( N_noxref_1_c_29_p N_CLK_c_738_n ) capacitor c=0.00209664f //x=3.765 \
 //y=2.26 //x2=2.745 //y2=2.095
cc_60 ( N_noxref_1_c_32_p N_CLK_c_738_n ) capacitor c=0.00933826f //x=3.765 \
 //y=2.26 //x2=2.745 //y2=2.095
cc_61 ( N_noxref_1_c_61_p N_CLK_c_738_n ) capacitor c=0.00438372f //x=3.765 \
 //y=2.095 //x2=2.745 //y2=2.095
cc_62 ( N_noxref_1_c_35_p N_CLK_c_742_n ) capacitor c=0.0616777f //x=3.765 \
 //y=4.88 //x2=2.99 //y2=4.97
cc_63 ( N_noxref_1_c_34_p N_CLK_c_743_n ) capacitor c=9.77556e-19 //x=3.765 \
 //y=4.88 //x2=2.655 //y2=4.88
cc_64 ( N_noxref_1_c_35_p N_CLK_c_743_n ) capacitor c=0.0042693f //x=3.765 \
 //y=4.88 //x2=2.655 //y2=4.88
cc_65 ( N_noxref_1_c_25_p N_noxref_4_c_1002_n ) capacitor c=7.46501e-19 \
 //x=3.765 //y=3.67 //x2=3.61 //y2=5.335
cc_66 ( N_noxref_1_M20_noxref_g N_noxref_4_c_1002_n ) capacitor c=0.00955829f \
 //x=3.505 //y=6.2 //x2=3.61 //y2=5.335
cc_67 ( N_noxref_1_c_39_p N_noxref_4_c_1004_n ) capacitor c=6.09703e-19 \
 //x=6.777 //y=5.335 //x2=3.725 //y2=5.56
cc_68 ( N_noxref_1_M20_noxref_g N_noxref_4_c_1004_n ) capacitor c=0.00226521f \
 //x=3.505 //y=6.2 //x2=3.725 //y2=5.56
cc_69 ( N_noxref_1_M21_noxref_g N_noxref_4_c_1004_n ) capacitor c=0.00381703f \
 //x=3.945 //y=6.2 //x2=3.725 //y2=5.56
cc_70 ( N_noxref_1_c_25_p N_noxref_4_c_1007_n ) capacitor c=0.00109666f \
 //x=3.765 //y=3.67 //x2=4.42 //y2=5.335
cc_71 ( N_noxref_1_c_26_p N_noxref_4_c_1007_n ) capacitor c=0.00228791f \
 //x=3.765 //y=4.75 //x2=4.42 //y2=5.335
cc_72 ( N_noxref_1_c_39_p N_noxref_4_c_1007_n ) capacitor c=0.00306432f \
 //x=6.777 //y=5.335 //x2=4.42 //y2=5.335
cc_73 ( N_noxref_1_c_34_p N_noxref_4_c_1007_n ) capacitor c=0.00130631f \
 //x=3.765 //y=4.88 //x2=4.42 //y2=5.335
cc_74 ( N_noxref_1_M21_noxref_g N_noxref_4_c_1007_n ) capacitor c=0.0110526f \
 //x=3.945 //y=6.2 //x2=4.42 //y2=5.335
cc_75 ( N_noxref_1_c_25_p N_noxref_4_c_1012_n ) capacitor c=2.41711e-19 \
 //x=3.765 //y=3.67 //x2=4.02 //y2=1.305
cc_76 ( N_noxref_1_c_55_p N_noxref_4_c_1012_n ) capacitor c=4.64015e-19 \
 //x=3.755 //y=1.095 //x2=4.02 //y2=1.305
cc_77 ( N_noxref_1_c_56_p N_noxref_4_c_1012_n ) capacitor c=0.0026012f \
 //x=3.755 //y=1.44 //x2=4.02 //y2=1.305
cc_78 ( N_noxref_1_c_78_p N_noxref_4_c_1012_n ) capacitor c=5.29969e-19 \
 //x=4.13 //y=0.94 //x2=4.02 //y2=1.305
cc_79 ( N_noxref_1_c_79_p N_noxref_4_c_1012_n ) capacitor c=5.01408e-19 \
 //x=4.13 //y=1.595 //x2=4.02 //y2=1.305
cc_80 ( N_noxref_1_c_80_p N_noxref_4_c_1012_n ) capacitor c=5.24634e-19 \
 //x=4.285 //y=1.095 //x2=4.02 //y2=1.305
cc_81 ( N_noxref_1_c_81_p N_noxref_4_c_1012_n ) capacitor c=0.00307978f \
 //x=4.285 //y=1.44 //x2=4.02 //y2=1.305
cc_82 ( N_noxref_1_c_56_p N_noxref_4_c_1019_n ) capacitor c=0.00127432f \
 //x=3.755 //y=1.44 //x2=4.02 //y2=1.76
cc_83 ( N_noxref_1_c_57_p N_noxref_4_c_1019_n ) capacitor c=0.00429966f \
 //x=3.755 //y=1.75 //x2=4.02 //y2=1.76
cc_84 ( N_noxref_1_c_79_p N_noxref_4_c_1019_n ) capacitor c=0.00942306f \
 //x=4.13 //y=1.595 //x2=4.02 //y2=1.76
cc_85 ( N_noxref_1_c_81_p N_noxref_4_c_1019_n ) capacitor c=0.00363411f \
 //x=4.285 //y=1.44 //x2=4.02 //y2=1.76
cc_86 ( N_noxref_1_c_61_p N_noxref_4_c_1019_n ) capacitor c=0.00372124f \
 //x=3.765 //y=2.095 //x2=4.02 //y2=1.76
cc_87 ( N_noxref_1_c_87_p N_noxref_4_c_1024_n ) capacitor c=0.00163399f \
 //x=8.915 //y=1.845 //x2=4.42 //y2=1.845
cc_88 ( N_noxref_1_c_43_p N_noxref_4_c_1024_n ) capacitor c=0.0033552f \
 //x=4.125 //y=3.51 //x2=4.42 //y2=1.845
cc_89 ( N_noxref_1_c_79_p N_noxref_4_c_1024_n ) capacitor c=0.00194716f \
 //x=4.13 //y=1.595 //x2=4.42 //y2=1.845
cc_90 ( N_noxref_1_c_81_p N_noxref_4_c_1024_n ) capacitor c=0.00323576f \
 //x=4.285 //y=1.44 //x2=4.42 //y2=1.845
cc_91 ( N_noxref_1_c_25_p N_noxref_4_c_1028_n ) capacitor c=0.00112398f \
 //x=3.765 //y=3.67 //x2=4.105 //y2=1.845
cc_92 ( N_noxref_1_c_43_p N_noxref_4_c_1028_n ) capacitor c=0.00429262f \
 //x=4.125 //y=3.51 //x2=4.105 //y2=1.845
cc_93 ( N_noxref_1_c_30_p N_noxref_4_c_1030_n ) capacitor c=0.0154269f \
 //x=3.765 //y=2.375 //x2=4.505 //y2=3.725
cc_94 ( N_noxref_1_c_24_p N_noxref_4_c_1030_n ) capacitor c=0.0445642f \
 //x=3.765 //y=3.35 //x2=4.505 //y2=3.725
cc_95 ( N_noxref_1_c_25_p N_noxref_4_c_1030_n ) capacitor c=0.017295f \
 //x=3.765 //y=3.67 //x2=4.505 //y2=3.725
cc_96 ( N_noxref_1_c_26_p N_noxref_4_c_1030_n ) capacitor c=0.00245069f \
 //x=3.765 //y=4.75 //x2=4.505 //y2=3.725
cc_97 ( N_noxref_1_c_27_p N_noxref_4_c_1030_n ) capacitor c=6.78671e-19 \
 //x=3.765 //y=3.51 //x2=4.505 //y2=3.725
cc_98 ( N_noxref_1_c_28_p N_noxref_4_c_1030_n ) capacitor c=0.00313722f \
 //x=3.925 //y=3.51 //x2=4.505 //y2=3.725
cc_99 ( N_noxref_1_c_99_p N_noxref_4_c_1030_n ) capacitor c=0.027698f \
 //x=4.725 //y=3.5 //x2=4.505 //y2=3.725
cc_100 ( N_noxref_1_c_29_p N_noxref_4_c_1030_n ) capacitor c=0.00163444f \
 //x=3.765 //y=2.26 //x2=4.505 //y2=3.725
cc_101 ( N_noxref_1_c_32_p N_noxref_4_c_1030_n ) capacitor c=0.0025845f \
 //x=3.765 //y=2.26 //x2=4.505 //y2=3.725
cc_102 ( N_noxref_1_c_61_p N_noxref_4_c_1030_n ) capacitor c=0.00282067f \
 //x=3.765 //y=2.095 //x2=4.505 //y2=3.725
cc_103 ( N_noxref_1_c_26_p N_noxref_4_c_1040_n ) capacitor c=0.0146933f \
 //x=3.765 //y=4.75 //x2=4.505 //y2=4.045
cc_104 ( N_noxref_1_c_99_p N_noxref_4_c_1040_n ) capacitor c=0.00895951f \
 //x=4.725 //y=3.5 //x2=4.505 //y2=4.045
cc_105 ( N_noxref_1_c_26_p N_noxref_4_c_1042_n ) capacitor c=0.0414151f \
 //x=3.765 //y=4.75 //x2=4.505 //y2=5.25
cc_106 ( N_noxref_1_c_34_p N_noxref_4_c_1042_n ) capacitor c=0.00131258f \
 //x=3.765 //y=4.88 //x2=4.505 //y2=5.25
cc_107 ( N_noxref_1_c_35_p N_noxref_4_c_1042_n ) capacitor c=0.00739875f \
 //x=3.765 //y=4.88 //x2=4.505 //y2=5.25
cc_108 ( N_noxref_1_c_108_p N_noxref_4_c_1045_n ) capacitor c=0.00179329f \
 //x=6.575 //y=3.495 //x2=6.355 //y2=2.375
cc_109 ( N_noxref_1_c_24_p N_noxref_4_c_1046_n ) capacitor c=0.00210705f \
 //x=3.765 //y=3.35 //x2=6.355 //y2=3.72
cc_110 ( N_noxref_1_c_110_p N_noxref_4_c_1046_n ) capacitor c=5.07575e-19 \
 //x=5.975 //y=3.51 //x2=6.355 //y2=3.72
cc_111 ( N_noxref_1_c_108_p N_noxref_4_c_1046_n ) capacitor c=0.0286424f \
 //x=6.575 //y=3.495 //x2=6.355 //y2=3.72
cc_112 ( N_noxref_1_c_112_p N_noxref_4_c_1046_n ) capacitor c=3.74737e-19 \
 //x=9.48 //y=3.51 //x2=6.355 //y2=3.72
cc_113 ( N_noxref_1_c_108_p N_noxref_4_c_1050_n ) capacitor c=0.00797853f \
 //x=6.575 //y=3.495 //x2=6.355 //y2=4.04
cc_114 ( N_noxref_1_c_26_p N_noxref_4_c_1051_n ) capacitor c=8.5348e-19 \
 //x=3.765 //y=4.75 //x2=6.355 //y2=4.755
cc_115 ( N_noxref_1_c_26_p N_noxref_4_c_1052_n ) capacitor c=0.0228808f \
 //x=3.765 //y=4.75 //x2=3.725 //y2=5.335
cc_116 ( N_noxref_1_c_34_p N_noxref_4_c_1052_n ) capacitor c=0.00346456f \
 //x=3.765 //y=4.88 //x2=3.725 //y2=5.335
cc_117 ( N_noxref_1_c_35_p N_noxref_4_c_1052_n ) capacitor c=0.00203307f \
 //x=3.765 //y=4.88 //x2=3.725 //y2=5.335
cc_118 ( N_noxref_1_c_26_p N_noxref_4_c_1055_n ) capacitor c=6.15181e-19 \
 //x=3.765 //y=4.75 //x2=4.505 //y2=3.88
cc_119 ( N_noxref_1_c_99_p N_noxref_4_c_1056_n ) capacitor c=0.133263f \
 //x=4.725 //y=3.5 //x2=6.2 //y2=3.88
cc_120 ( N_noxref_1_c_110_p N_noxref_4_c_1056_n ) capacitor c=0.0126826f \
 //x=5.975 //y=3.51 //x2=6.2 //y2=3.88
cc_121 ( N_noxref_1_c_121_p N_noxref_4_c_1058_n ) capacitor c=0.00771097f \
 //x=9.315 //y=3.67 //x2=9.535 //y2=3.895
cc_122 ( N_noxref_1_c_6_p N_noxref_4_c_1058_n ) capacitor c=0.0226453f \
 //x=9.315 //y=5.25 //x2=9.535 //y2=3.895
cc_123 ( N_noxref_1_c_123_p N_noxref_4_c_1058_n ) capacitor c=0.127201f \
 //x=11.005 //y=3.51 //x2=9.535 //y2=3.895
cc_124 ( N_noxref_1_c_121_p N_noxref_4_c_1061_n ) capacitor c=0.00128047f \
 //x=9.315 //y=3.67 //x2=9.19 //y2=3.895
cc_125 ( N_noxref_1_c_6_p N_noxref_4_c_1061_n ) capacitor c=3.14797e-19 \
 //x=9.315 //y=5.25 //x2=9.19 //y2=3.895
cc_126 ( N_noxref_1_c_108_p N_noxref_4_c_1061_n ) capacitor c=0.0477348f \
 //x=6.575 //y=3.495 //x2=9.19 //y2=3.895
cc_127 ( N_noxref_1_c_112_p N_noxref_4_c_1061_n ) capacitor c=0.256732f \
 //x=9.48 //y=3.51 //x2=9.19 //y2=3.895
cc_128 ( N_noxref_1_c_10_p N_noxref_4_c_1065_n ) capacitor c=0.00339401f \
 //x=11.165 //y=3.67 //x2=10.78 //y2=3.88
cc_129 ( N_noxref_1_c_7_p N_noxref_4_c_1065_n ) capacitor c=5.02752e-19 \
 //x=11.167 //y=4.74 //x2=10.78 //y2=3.88
cc_130 ( N_noxref_1_c_123_p N_noxref_4_c_1065_n ) capacitor c=0.0107648f \
 //x=11.005 //y=3.51 //x2=10.78 //y2=3.88
cc_131 ( N_noxref_1_c_18_p N_noxref_4_c_1065_n ) capacitor c=0.0358254f \
 //x=11.165 //y=3.51 //x2=10.78 //y2=3.88
cc_132 ( N_noxref_1_c_10_p N_noxref_4_c_1069_n ) capacitor c=0.00260425f \
 //x=11.165 //y=3.67 //x2=11.38 //y2=3.895
cc_133 ( N_noxref_1_c_7_p N_noxref_4_c_1069_n ) capacitor c=0.0228372f \
 //x=11.167 //y=4.74 //x2=11.38 //y2=3.895
cc_134 ( N_noxref_1_c_26_p N_noxref_4_c_1071_n ) capacitor c=0.00683433f \
 //x=3.765 //y=4.75 //x2=4.67 //y2=3.885
cc_135 ( N_noxref_1_c_99_p N_noxref_4_c_1071_n ) capacitor c=0.0365231f \
 //x=4.725 //y=3.5 //x2=4.67 //y2=3.885
cc_136 ( N_noxref_1_c_26_p N_noxref_4_c_1073_n ) capacitor c=0.00217653f \
 //x=3.765 //y=4.75 //x2=3.725 //y2=5.56
cc_137 ( N_noxref_1_c_34_p N_noxref_4_c_1073_n ) capacitor c=0.00624059f \
 //x=3.765 //y=4.88 //x2=3.725 //y2=5.56
cc_138 ( N_noxref_1_M20_noxref_g N_noxref_4_c_1073_n ) capacitor c=0.0178885f \
 //x=3.505 //y=6.2 //x2=3.725 //y2=5.56
cc_139 ( N_noxref_1_M21_noxref_g N_noxref_4_c_1073_n ) capacitor c=0.0188608f \
 //x=3.945 //y=6.2 //x2=3.725 //y2=5.56
cc_140 ( N_noxref_1_c_35_p N_noxref_4_c_1073_n ) capacitor c=0.00375636f \
 //x=3.765 //y=4.88 //x2=3.725 //y2=5.56
cc_141 ( N_noxref_1_c_39_p N_noxref_4_M22_noxref_g ) capacitor c=0.00461408f \
 //x=6.777 //y=5.335 //x2=6.555 //y2=6.2
cc_142 ( N_noxref_1_c_142_p N_noxref_4_M22_noxref_g ) capacitor c=0.0162284f \
 //x=6.775 //y=5.56 //x2=6.555 //y2=6.2
cc_143 ( N_noxref_1_c_143_p N_noxref_4_M23_noxref_g ) capacitor c=0.00893512f \
 //x=7.535 //y=5.335 //x2=6.995 //y2=6.2
cc_144 ( N_noxref_1_c_39_p N_noxref_4_M23_noxref_g ) capacitor c=0.00229208f \
 //x=6.777 //y=5.335 //x2=6.995 //y2=6.2
cc_145 ( N_noxref_1_c_142_p N_noxref_4_M23_noxref_g ) capacitor c=0.0179041f \
 //x=6.775 //y=5.56 //x2=6.995 //y2=6.2
cc_146 ( N_noxref_1_c_39_p N_noxref_4_c_1083_n ) capacitor c=0.00171885f \
 //x=6.777 //y=5.335 //x2=6.92 //y2=4.97
cc_147 ( N_noxref_1_c_142_p N_noxref_4_c_1083_n ) capacitor c=0.00291477f \
 //x=6.775 //y=5.56 //x2=6.92 //y2=4.97
cc_148 ( N_noxref_1_c_55_p N_noxref_4_M2_noxref_d ) capacitor c=0.00137165f \
 //x=3.755 //y=1.095 //x2=3.83 //y2=1.095
cc_149 ( N_noxref_1_c_56_p N_noxref_4_M2_noxref_d ) capacitor c=0.00237422f \
 //x=3.755 //y=1.44 //x2=3.83 //y2=1.095
cc_150 ( N_noxref_1_c_78_p N_noxref_4_M2_noxref_d ) capacitor c=0.0020782f \
 //x=4.13 //y=0.94 //x2=3.83 //y2=1.095
cc_151 ( N_noxref_1_c_79_p N_noxref_4_M2_noxref_d ) capacitor c=0.00356097f \
 //x=4.13 //y=1.595 //x2=3.83 //y2=1.095
cc_152 ( N_noxref_1_c_80_p N_noxref_4_M2_noxref_d ) capacitor c=0.00139206f \
 //x=4.285 //y=1.095 //x2=3.83 //y2=1.095
cc_153 ( N_noxref_1_c_81_p N_noxref_4_M2_noxref_d ) capacitor c=0.00237422f \
 //x=4.285 //y=1.44 //x2=3.83 //y2=1.095
cc_154 ( N_noxref_1_c_154_p RN ) capacitor c=0.0399557f //x=9.315 //y=3.35 \
 //x2=8.575 //y2=2.77
cc_155 ( N_noxref_1_c_121_p RN ) capacitor c=0.0144538f //x=9.315 //y=3.67 \
 //x2=8.575 //y2=2.77
cc_156 ( N_noxref_1_c_6_p RN ) capacitor c=0.0411806f //x=9.315 //y=5.25 \
 //x2=8.575 //y2=2.77
cc_157 ( N_noxref_1_c_5_p RN ) capacitor c=0.00190328f //x=11.165 //y=3.35 \
 //x2=8.575 //y2=2.77
cc_158 ( N_noxref_1_c_158_p RN ) capacitor c=6.03895e-19 //x=9.315 //y=3.51 \
 //x2=8.575 //y2=2.77
cc_159 ( N_noxref_1_c_7_p RN ) capacitor c=0.00123473f //x=11.167 //y=4.74 \
 //x2=8.575 //y2=2.77
cc_160 ( N_noxref_1_c_112_p RN ) capacitor c=0.0291276f //x=9.48 //y=3.51 \
 //x2=8.575 //y2=2.77
cc_161 ( N_noxref_1_c_9_p N_RN_c_1472_n ) capacitor c=0.00228791f //x=9.23 \
 //y=5.335 //x2=8.575 //y2=4.75
cc_162 ( N_noxref_1_c_6_p N_RN_c_1472_n ) capacitor c=0.0152702f //x=9.315 \
 //y=5.25 //x2=8.575 //y2=4.75
cc_163 ( N_noxref_1_c_163_p N_RN_c_1472_n ) capacitor c=0.022916f //x=8.535 \
 //y=5.335 //x2=8.575 //y2=4.75
cc_164 ( N_noxref_1_c_164_p N_RN_c_1472_n ) capacitor c=0.00266858f //x=8.535 \
 //y=5.56 //x2=8.575 //y2=4.75
cc_165 ( N_noxref_1_c_16_p N_RN_c_1476_n ) capacitor c=5.60322e-19 //x=8.83 \
 //y=1.305 //x2=8.58 //y2=2.305
cc_166 ( N_noxref_1_c_154_p N_RN_c_1476_n ) capacitor c=0.0178354f //x=9.315 \
 //y=3.35 //x2=8.58 //y2=2.305
cc_167 ( N_noxref_1_c_163_p N_RN_c_1476_n ) capacitor c=4.31152e-19 //x=8.535 \
 //y=5.335 //x2=8.58 //y2=2.305
cc_168 ( N_noxref_1_c_112_p N_RN_c_1476_n ) capacitor c=0.00109789f //x=9.48 \
 //y=3.51 //x2=8.58 //y2=2.305
cc_169 ( N_noxref_1_c_16_p N_RN_c_1480_n ) capacitor c=4.13793e-19 //x=8.83 \
 //y=1.305 //x2=8.58 //y2=2.305
cc_170 ( N_noxref_1_c_154_p N_RN_c_1480_n ) capacitor c=0.00372846f //x=9.315 \
 //y=3.35 //x2=8.58 //y2=2.305
cc_171 ( N_noxref_1_c_112_p N_RN_c_1480_n ) capacitor c=0.0208149f //x=9.48 \
 //y=3.51 //x2=8.58 //y2=2.305
cc_172 ( N_noxref_1_c_87_p N_RN_c_1483_n ) capacitor c=0.0215425f //x=8.915 \
 //y=1.845 //x2=16.56 //y2=2.315
cc_173 ( N_noxref_1_c_154_p N_RN_c_1483_n ) capacitor c=0.031465f //x=9.315 \
 //y=3.35 //x2=16.56 //y2=2.315
cc_174 ( N_noxref_1_c_121_p N_RN_c_1483_n ) capacitor c=0.00347573f //x=9.315 \
 //y=3.67 //x2=16.56 //y2=2.315
cc_175 ( N_noxref_1_c_5_p N_RN_c_1483_n ) capacitor c=0.0166725f //x=11.165 \
 //y=3.35 //x2=16.56 //y2=2.315
cc_176 ( N_noxref_1_c_10_p N_RN_c_1483_n ) capacitor c=0.00298073f //x=11.165 \
 //y=3.67 //x2=16.56 //y2=2.315
cc_177 ( N_noxref_1_c_177_p N_RN_c_1483_n ) capacitor c=0.0177708f //x=11.165 \
 //y=2.26 //x2=16.56 //y2=2.315
cc_178 ( N_noxref_1_c_123_p N_RN_c_1483_n ) capacitor c=0.0483419f //x=11.005 \
 //y=3.51 //x2=16.56 //y2=2.315
cc_179 ( N_noxref_1_c_112_p N_RN_c_1483_n ) capacitor c=0.00812897f //x=9.48 \
 //y=3.51 //x2=16.56 //y2=2.315
cc_180 ( N_noxref_1_c_18_p N_RN_c_1483_n ) capacitor c=0.00840581f //x=11.165 \
 //y=3.51 //x2=16.56 //y2=2.315
cc_181 ( N_noxref_1_c_181_p N_RN_c_1483_n ) capacitor c=2.20453e-19 //x=11.165 \
 //y=2.26 //x2=16.56 //y2=2.315
cc_182 ( N_noxref_1_c_154_p N_RN_c_1493_n ) capacitor c=0.00115564f //x=9.315 \
 //y=3.35 //x2=8.575 //y2=2.26
cc_183 ( N_noxref_1_c_9_p N_RN_c_1494_n ) capacitor c=0.00130631f //x=9.23 \
 //y=5.335 //x2=8.575 //y2=4.88
cc_184 ( N_noxref_1_c_6_p N_RN_c_1494_n ) capacitor c=0.00131258f //x=9.315 \
 //y=5.25 //x2=8.575 //y2=4.88
cc_185 ( N_noxref_1_c_163_p N_RN_c_1494_n ) capacitor c=0.00346017f //x=8.535 \
 //y=5.335 //x2=8.575 //y2=4.88
cc_186 ( N_noxref_1_c_164_p N_RN_c_1494_n ) capacitor c=0.00624059f //x=8.535 \
 //y=5.56 //x2=8.575 //y2=4.88
cc_187 ( N_noxref_1_c_187_p N_RN_M26_noxref_g ) capacitor c=0.00955829f \
 //x=8.42 //y=5.335 //x2=8.315 //y2=6.2
cc_188 ( N_noxref_1_c_8_p N_RN_M26_noxref_g ) capacitor c=0.00226521f \
 //x=8.535 //y=5.56 //x2=8.315 //y2=6.2
cc_189 ( N_noxref_1_c_164_p N_RN_M26_noxref_g ) capacitor c=0.0178885f \
 //x=8.535 //y=5.56 //x2=8.315 //y2=6.2
cc_190 ( N_noxref_1_c_8_p N_RN_M27_noxref_g ) capacitor c=0.00368945f \
 //x=8.535 //y=5.56 //x2=8.755 //y2=6.2
cc_191 ( N_noxref_1_c_9_p N_RN_M27_noxref_g ) capacitor c=0.010862f //x=9.23 \
 //y=5.335 //x2=8.755 //y2=6.2
cc_192 ( N_noxref_1_c_164_p N_RN_M27_noxref_g ) capacitor c=0.0188608f \
 //x=8.535 //y=5.56 //x2=8.755 //y2=6.2
cc_193 ( N_noxref_1_c_16_p N_RN_c_1504_n ) capacitor c=4.64015e-19 //x=8.83 \
 //y=1.305 //x2=8.565 //y2=1.095
cc_194 ( N_noxref_1_M5_noxref_d N_RN_c_1504_n ) capacitor c=0.00137165f \
 //x=8.64 //y=1.095 //x2=8.565 //y2=1.095
cc_195 ( N_noxref_1_c_16_p N_RN_c_1506_n ) capacitor c=0.0026012f //x=8.83 \
 //y=1.305 //x2=8.565 //y2=1.44
cc_196 ( N_noxref_1_c_2_p N_RN_c_1506_n ) capacitor c=0.00127432f //x=8.83 \
 //y=1.76 //x2=8.565 //y2=1.44
cc_197 ( N_noxref_1_M5_noxref_d N_RN_c_1506_n ) capacitor c=0.00237422f \
 //x=8.64 //y=1.095 //x2=8.565 //y2=1.44
cc_198 ( N_noxref_1_c_2_p N_RN_c_1509_n ) capacitor c=0.00441386f //x=8.83 \
 //y=1.76 //x2=8.565 //y2=1.75
cc_199 ( N_noxref_1_c_16_p N_RN_c_1510_n ) capacitor c=5.29969e-19 //x=8.83 \
 //y=1.305 //x2=8.94 //y2=0.94
cc_200 ( N_noxref_1_M5_noxref_d N_RN_c_1510_n ) capacitor c=0.0020782f \
 //x=8.64 //y=1.095 //x2=8.94 //y2=0.94
cc_201 ( N_noxref_1_c_16_p N_RN_c_1512_n ) capacitor c=4.32061e-19 //x=8.83 \
 //y=1.305 //x2=8.94 //y2=1.595
cc_202 ( N_noxref_1_c_2_p N_RN_c_1512_n ) capacitor c=0.00930387f //x=8.83 \
 //y=1.76 //x2=8.94 //y2=1.595
cc_203 ( N_noxref_1_c_3_p N_RN_c_1512_n ) capacitor c=0.00194716f //x=9.23 \
 //y=1.845 //x2=8.94 //y2=1.595
cc_204 ( N_noxref_1_M5_noxref_d N_RN_c_1512_n ) capacitor c=0.00356097f \
 //x=8.64 //y=1.095 //x2=8.94 //y2=1.595
cc_205 ( N_noxref_1_c_16_p N_RN_c_1516_n ) capacitor c=5.28622e-19 //x=8.83 \
 //y=1.305 //x2=9.095 //y2=1.095
cc_206 ( N_noxref_1_M5_noxref_d N_RN_c_1516_n ) capacitor c=0.00139206f \
 //x=8.64 //y=1.095 //x2=9.095 //y2=1.095
cc_207 ( N_noxref_1_c_16_p N_RN_c_1518_n ) capacitor c=0.00312156f //x=8.83 \
 //y=1.305 //x2=9.095 //y2=1.44
cc_208 ( N_noxref_1_c_2_p N_RN_c_1518_n ) capacitor c=0.00347599f //x=8.83 \
 //y=1.76 //x2=9.095 //y2=1.44
cc_209 ( N_noxref_1_c_3_p N_RN_c_1518_n ) capacitor c=0.00323576f //x=9.23 \
 //y=1.845 //x2=9.095 //y2=1.44
cc_210 ( N_noxref_1_M5_noxref_d N_RN_c_1518_n ) capacitor c=0.00237422f \
 //x=8.64 //y=1.095 //x2=9.095 //y2=1.44
cc_211 ( N_noxref_1_c_154_p N_RN_c_1522_n ) capacitor c=3.96703e-19 //x=9.315 \
 //y=3.35 //x2=8.575 //y2=2.26
cc_212 ( N_noxref_1_c_2_p N_RN_c_1523_n ) capacitor c=0.0036273f //x=8.83 \
 //y=1.76 //x2=8.575 //y2=2.095
cc_213 ( N_noxref_1_c_154_p N_RN_c_1523_n ) capacitor c=0.00282067f //x=9.315 \
 //y=3.35 //x2=8.575 //y2=2.095
cc_214 ( N_noxref_1_c_6_p N_RN_c_1525_n ) capacitor c=0.00739875f //x=9.315 \
 //y=5.25 //x2=8.575 //y2=4.88
cc_215 ( N_noxref_1_c_163_p N_RN_c_1525_n ) capacitor c=0.00203307f //x=8.535 \
 //y=5.335 //x2=8.575 //y2=4.88
cc_216 ( N_noxref_1_c_164_p N_RN_c_1525_n ) capacitor c=0.00375636f //x=8.535 \
 //y=5.56 //x2=8.575 //y2=4.88
cc_217 ( N_noxref_1_c_24_p N_noxref_7_c_2171_n ) capacitor c=0.00142312f \
 //x=3.765 //y=3.35 //x2=1.545 //y2=4.1
cc_218 ( N_noxref_1_c_26_p N_noxref_7_c_2171_n ) capacitor c=8.0808e-19 \
 //x=3.765 //y=4.75 //x2=1.545 //y2=4.1
cc_219 ( N_noxref_1_c_26_p N_noxref_7_c_2173_n ) capacitor c=5.44383e-19 \
 //x=3.765 //y=4.75 //x2=1.545 //y2=4.755
cc_220 ( N_noxref_1_c_154_p N_noxref_7_c_2174_n ) capacitor c=0.00190464f \
 //x=9.315 //y=3.35 //x2=11.905 //y2=4.09
cc_221 ( N_noxref_1_c_6_p N_noxref_7_c_2174_n ) capacitor c=3.12404e-19 \
 //x=9.315 //y=5.25 //x2=11.905 //y2=4.09
cc_222 ( N_noxref_1_c_5_p N_noxref_7_c_2174_n ) capacitor c=0.0415182f \
 //x=11.165 //y=3.35 //x2=11.905 //y2=4.09
cc_223 ( N_noxref_1_c_10_p N_noxref_7_c_2174_n ) capacitor c=0.0148501f \
 //x=11.165 //y=3.67 //x2=11.905 //y2=4.09
cc_224 ( N_noxref_1_c_17_p N_noxref_7_c_2174_n ) capacitor c=5.52402e-19 \
 //x=11.165 //y=3.51 //x2=11.905 //y2=4.09
cc_225 ( N_noxref_1_c_7_p N_noxref_7_c_2174_n ) capacitor c=0.0167029f \
 //x=11.167 //y=4.74 //x2=11.905 //y2=4.09
cc_226 ( N_noxref_1_c_18_p N_noxref_7_c_2174_n ) capacitor c=0.00365413f \
 //x=11.165 //y=3.51 //x2=11.905 //y2=4.09
cc_227 ( N_noxref_1_c_181_p N_noxref_7_c_2174_n ) capacitor c=3.30333e-19 \
 //x=11.165 //y=2.26 //x2=11.905 //y2=4.09
cc_228 ( N_noxref_1_c_7_p N_noxref_7_c_2182_n ) capacitor c=0.0172847f \
 //x=11.167 //y=4.74 //x2=11.905 //y2=4.41
cc_229 ( N_noxref_1_c_6_p N_noxref_7_c_2183_n ) capacitor c=7.60001e-19 \
 //x=9.315 //y=5.25 //x2=11.905 //y2=4.735
cc_230 ( N_noxref_1_c_11_p N_noxref_7_c_2183_n ) capacitor c=0.0172939f \
 //x=11.165 //y=4.88 //x2=11.905 //y2=4.735
cc_231 ( N_noxref_1_c_7_p N_noxref_7_c_2183_n ) capacitor c=0.0117609f \
 //x=11.167 //y=4.74 //x2=11.905 //y2=4.735
cc_232 ( N_noxref_1_c_12_p N_noxref_7_c_2183_n ) capacitor c=7.51041e-19 \
 //x=11.165 //y=4.88 //x2=11.905 //y2=4.735
cc_233 ( N_noxref_1_c_15_p N_noxref_7_c_2183_n ) capacitor c=0.00200732f \
 //x=11.165 //y=4.88 //x2=11.905 //y2=4.735
cc_234 ( N_noxref_1_c_7_p N_noxref_7_c_2188_n ) capacitor c=6.16997e-19 \
 //x=11.167 //y=4.74 //x2=11.905 //y2=4.25
cc_235 ( N_noxref_1_c_177_p N_noxref_7_c_2189_n ) capacitor c=0.0179797f \
 //x=11.165 //y=2.26 //x2=11.905 //y2=2.26
cc_236 ( N_noxref_1_c_181_p N_noxref_7_c_2189_n ) capacitor c=5.16867e-19 \
 //x=11.165 //y=2.26 //x2=11.905 //y2=2.26
cc_237 ( N_noxref_1_c_237_p N_noxref_7_c_2189_n ) capacitor c=0.00161745f \
 //x=10.97 //y=2.095 //x2=11.905 //y2=2.26
cc_238 ( N_noxref_1_c_25_p N_noxref_7_c_2192_n ) capacitor c=0.0032242f \
 //x=3.765 //y=3.67 //x2=4.12 //y2=4.25
cc_239 ( N_noxref_1_c_26_p N_noxref_7_c_2192_n ) capacitor c=0.024687f \
 //x=3.765 //y=4.75 //x2=4.12 //y2=4.25
cc_240 ( N_noxref_1_c_43_p N_noxref_7_c_2192_n ) capacitor c=0.0166732f \
 //x=4.125 //y=3.51 //x2=4.12 //y2=4.25
cc_241 ( N_noxref_1_c_28_p N_noxref_7_c_2192_n ) capacitor c=0.0160572f \
 //x=3.925 //y=3.51 //x2=4.12 //y2=4.25
cc_242 ( N_noxref_1_c_99_p N_noxref_7_c_2196_n ) capacitor c=0.00840658f \
 //x=4.725 //y=3.5 //x2=4.76 //y2=4.27
cc_243 ( N_noxref_1_c_110_p N_noxref_7_c_2197_n ) capacitor c=0.00495213f \
 //x=5.975 //y=3.51 //x2=5.975 //y2=4.25
cc_244 ( N_noxref_1_c_108_p N_noxref_7_c_2198_n ) capacitor c=0.00107119f \
 //x=6.575 //y=3.495 //x2=6.575 //y2=4.265
cc_245 ( N_noxref_1_c_6_p N_noxref_7_c_2199_n ) capacitor c=0.0232184f \
 //x=9.315 //y=5.25 //x2=12.07 //y2=4.25
cc_246 ( N_noxref_1_c_7_p N_noxref_7_c_2199_n ) capacitor c=0.0253737f \
 //x=11.167 //y=4.74 //x2=12.07 //y2=4.25
cc_247 ( N_noxref_1_c_123_p N_noxref_7_c_2199_n ) capacitor c=0.00976061f \
 //x=11.005 //y=3.51 //x2=12.07 //y2=4.25
cc_248 ( N_noxref_1_c_112_p N_noxref_7_c_2199_n ) capacitor c=0.0180943f \
 //x=9.48 //y=3.51 //x2=12.07 //y2=4.25
cc_249 ( N_noxref_1_c_5_p N_noxref_7_c_2203_n ) capacitor c=3.30333e-19 \
 //x=11.165 //y=3.35 //x2=11.905 //y2=2.26
cc_250 ( N_noxref_1_c_177_p N_noxref_7_c_2203_n ) capacitor c=5.24723e-19 \
 //x=11.165 //y=2.26 //x2=11.905 //y2=2.26
cc_251 ( N_noxref_1_c_181_p N_noxref_7_c_2203_n ) capacitor c=0.00525888f \
 //x=11.165 //y=2.26 //x2=11.905 //y2=2.26
cc_252 ( N_noxref_1_c_237_p N_noxref_7_c_2203_n ) capacitor c=0.00190888f \
 //x=10.97 //y=2.095 //x2=11.905 //y2=2.26
cc_253 ( N_noxref_1_c_11_p N_noxref_7_c_2207_n ) capacitor c=4.80626e-19 \
 //x=11.165 //y=4.88 //x2=11.935 //y2=4.88
cc_254 ( N_noxref_1_c_12_p N_noxref_7_c_2207_n ) capacitor c=0.00397338f \
 //x=11.165 //y=4.88 //x2=11.935 //y2=4.88
cc_255 ( N_noxref_1_c_15_p N_noxref_7_c_2207_n ) capacitor c=0.00283894f \
 //x=11.165 //y=4.88 //x2=11.935 //y2=4.88
cc_256 ( N_noxref_1_M28_noxref_g N_noxref_7_M30_noxref_g ) capacitor \
 c=0.0104892f //x=11.065 //y=6.2 //x2=11.945 //y2=6.2
cc_257 ( N_noxref_1_M29_noxref_g N_noxref_7_M30_noxref_g ) capacitor \
 c=0.107636f //x=11.505 //y=6.2 //x2=11.945 //y2=6.2
cc_258 ( N_noxref_1_M29_noxref_g N_noxref_7_M31_noxref_g ) capacitor \
 c=0.0100341f //x=11.505 //y=6.2 //x2=12.385 //y2=6.2
cc_259 ( N_noxref_1_c_259_p N_noxref_7_c_2213_n ) capacitor c=4.86545e-19 \
 //x=10.97 //y=1.045 //x2=11.94 //y2=1.085
cc_260 ( N_noxref_1_c_260_p N_noxref_7_c_2213_n ) capacitor c=0.00152405f \
 //x=10.97 //y=1.39 //x2=11.94 //y2=1.085
cc_261 ( N_noxref_1_c_261_p N_noxref_7_c_2213_n ) capacitor c=0.0151475f \
 //x=11.5 //y=1.045 //x2=11.94 //y2=1.085
cc_262 ( N_noxref_1_c_262_p N_noxref_7_c_2216_n ) capacitor c=0.00109982f \
 //x=10.97 //y=1.7 //x2=11.94 //y2=1.43
cc_263 ( N_noxref_1_c_263_p N_noxref_7_c_2216_n ) capacitor c=0.0111064f \
 //x=11.5 //y=1.39 //x2=11.94 //y2=1.43
cc_264 ( N_noxref_1_c_262_p N_noxref_7_c_2218_n ) capacitor c=9.58243e-19 \
 //x=10.97 //y=1.7 //x2=11.94 //y2=1.74
cc_265 ( N_noxref_1_c_237_p N_noxref_7_c_2218_n ) capacitor c=0.00662747f \
 //x=10.97 //y=2.095 //x2=11.94 //y2=1.74
cc_266 ( N_noxref_1_c_263_p N_noxref_7_c_2218_n ) capacitor c=0.00862358f \
 //x=11.5 //y=1.39 //x2=11.94 //y2=1.74
cc_267 ( N_noxref_1_c_261_p N_noxref_7_c_2221_n ) capacitor c=0.00127211f \
 //x=11.5 //y=1.045 //x2=12.47 //y2=1.085
cc_268 ( N_noxref_1_c_263_p N_noxref_7_c_2222_n ) capacitor c=0.00204774f \
 //x=11.5 //y=1.39 //x2=12.47 //y2=1.43
cc_269 ( N_noxref_1_c_177_p N_noxref_7_c_2223_n ) capacitor c=0.00161167f \
 //x=11.165 //y=2.26 //x2=11.905 //y2=2.26
cc_270 ( N_noxref_1_c_181_p N_noxref_7_c_2223_n ) capacitor c=0.0018937f \
 //x=11.165 //y=2.26 //x2=11.905 //y2=2.26
cc_271 ( N_noxref_1_c_237_p N_noxref_7_c_2223_n ) capacitor c=0.0181449f \
 //x=10.97 //y=2.095 //x2=11.905 //y2=2.26
cc_272 ( N_noxref_1_c_11_p N_noxref_7_c_2226_n ) capacitor c=0.00158715f \
 //x=11.165 //y=4.88 //x2=11.935 //y2=4.88
cc_273 ( N_noxref_1_c_12_p N_noxref_7_c_2226_n ) capacitor c=0.00237977f \
 //x=11.165 //y=4.88 //x2=11.935 //y2=4.88
cc_274 ( N_noxref_1_c_15_p N_noxref_7_c_2226_n ) capacitor c=0.0297875f \
 //x=11.165 //y=4.88 //x2=11.935 //y2=4.88
cc_275 ( N_noxref_1_c_143_p N_VDD_c_3043_n ) capacitor c=0.00621363f //x=7.535 \
 //y=5.335 //x2=25.965 //y2=7.58
cc_276 ( N_noxref_1_c_187_p N_VDD_c_3043_n ) capacitor c=0.00627192f //x=8.42 \
 //y=5.335 //x2=25.965 //y2=7.58
cc_277 ( N_noxref_1_c_8_p N_VDD_c_3043_n ) capacitor c=0.00256036f //x=8.535 \
 //y=5.56 //x2=25.965 //y2=7.58
cc_278 ( N_noxref_1_c_9_p N_VDD_c_3043_n ) capacitor c=0.00829251f //x=9.23 \
 //y=5.335 //x2=25.965 //y2=7.58
cc_279 ( N_noxref_1_c_121_p N_VDD_c_3043_n ) capacitor c=4.58912e-19 //x=9.315 \
 //y=3.67 //x2=25.965 //y2=7.58
cc_280 ( N_noxref_1_c_10_p N_VDD_c_3043_n ) capacitor c=2.00241e-19 //x=11.165 \
 //y=3.67 //x2=25.965 //y2=7.58
cc_281 ( N_noxref_1_c_39_p N_VDD_c_3043_n ) capacitor c=0.00261804f //x=6.777 \
 //y=5.335 //x2=25.965 //y2=7.58
cc_282 ( N_noxref_1_c_40_p N_VDD_c_3043_n ) capacitor c=0.00270108f //x=7.655 \
 //y=5.335 //x2=25.965 //y2=7.58
cc_283 ( N_noxref_1_c_11_p N_VDD_c_3043_n ) capacitor c=9.07241e-19 //x=11.165 \
 //y=4.88 //x2=25.965 //y2=7.58
cc_284 ( N_noxref_1_c_142_p N_VDD_c_3043_n ) capacitor c=0.0024232f //x=6.775 \
 //y=5.56 //x2=25.965 //y2=7.58
cc_285 ( N_noxref_1_c_285_p N_VDD_c_3043_n ) capacitor c=0.0024232f //x=7.655 \
 //y=5.56 //x2=25.965 //y2=7.58
cc_286 ( N_noxref_1_c_164_p N_VDD_c_3043_n ) capacitor c=0.0024232f //x=8.535 \
 //y=5.56 //x2=25.965 //y2=7.58
cc_287 ( N_noxref_1_c_12_p N_VDD_c_3043_n ) capacitor c=6.22888e-19 //x=11.165 \
 //y=4.88 //x2=25.965 //y2=7.58
cc_288 ( N_noxref_1_M20_noxref_g N_VDD_c_3056_n ) capacitor c=0.00755544f \
 //x=3.505 //y=6.2 //x2=4.08 //y2=7.585
cc_289 ( N_noxref_1_M21_noxref_g N_VDD_c_3056_n ) capacitor c=0.00755754f \
 //x=3.945 //y=6.2 //x2=4.08 //y2=7.585
cc_290 ( N_noxref_1_c_143_p N_VDD_c_3058_n ) capacitor c=0.00202922f //x=7.535 \
 //y=5.335 //x2=7.13 //y2=7.585
cc_291 ( N_noxref_1_c_39_p N_VDD_c_3058_n ) capacitor c=9.3757e-19 //x=6.777 \
 //y=5.335 //x2=7.13 //y2=7.585
cc_292 ( N_noxref_1_c_142_p N_VDD_c_3058_n ) capacitor c=0.0138074f //x=6.775 \
 //y=5.56 //x2=7.13 //y2=7.585
cc_293 ( N_noxref_1_c_143_p N_VDD_c_3061_n ) capacitor c=0.0017708f //x=7.535 \
 //y=5.335 //x2=8.01 //y2=7.585
cc_294 ( N_noxref_1_c_187_p N_VDD_c_3061_n ) capacitor c=0.00202922f //x=8.42 \
 //y=5.335 //x2=8.01 //y2=7.585
cc_295 ( N_noxref_1_c_40_p N_VDD_c_3061_n ) capacitor c=9.4822e-19 //x=7.655 \
 //y=5.335 //x2=8.01 //y2=7.585
cc_296 ( N_noxref_1_c_285_p N_VDD_c_3061_n ) capacitor c=0.0138074f //x=7.655 \
 //y=5.56 //x2=8.01 //y2=7.585
cc_297 ( N_noxref_1_c_187_p N_VDD_c_3065_n ) capacitor c=0.00205906f //x=8.42 \
 //y=5.335 //x2=8.89 //y2=7.585
cc_298 ( N_noxref_1_c_8_p N_VDD_c_3065_n ) capacitor c=8.49654e-19 //x=8.535 \
 //y=5.56 //x2=8.89 //y2=7.585
cc_299 ( N_noxref_1_c_9_p N_VDD_c_3065_n ) capacitor c=0.00204238f //x=9.23 \
 //y=5.335 //x2=8.89 //y2=7.585
cc_300 ( N_noxref_1_c_164_p N_VDD_c_3065_n ) capacitor c=0.0138074f //x=8.535 \
 //y=5.56 //x2=8.89 //y2=7.585
cc_301 ( N_noxref_1_c_9_p N_VDD_c_3069_n ) capacitor c=0.00183742f //x=9.23 \
 //y=5.335 //x2=9.885 //y2=7.585
cc_302 ( N_noxref_1_c_11_p N_VDD_c_3070_n ) capacitor c=6.28113e-19 //x=11.165 \
 //y=4.88 //x2=11.64 //y2=7.585
cc_303 ( N_noxref_1_M28_noxref_g N_VDD_c_3070_n ) capacitor c=0.00732618f \
 //x=11.065 //y=6.2 //x2=11.64 //y2=7.585
cc_304 ( N_noxref_1_M29_noxref_g N_VDD_c_3070_n ) capacitor c=0.00755544f \
 //x=11.505 //y=6.2 //x2=11.64 //y2=7.585
cc_305 ( N_noxref_1_c_39_p N_VDD_c_3073_n ) capacitor c=0.0022955f //x=6.777 \
 //y=5.335 //x2=5.245 //y2=7.585
cc_306 ( N_noxref_1_c_34_p N_VDD_c_3073_n ) capacitor c=0.00224736f //x=3.765 \
 //y=4.88 //x2=5.245 //y2=7.585
cc_307 ( N_noxref_1_c_142_p N_VDD_c_3073_n ) capacitor c=0.00509469f //x=6.775 \
 //y=5.56 //x2=5.245 //y2=7.585
cc_308 ( N_noxref_1_c_35_p N_VDD_c_3073_n ) capacitor c=2.63786e-19 //x=3.765 \
 //y=4.88 //x2=5.245 //y2=7.585
cc_309 ( N_noxref_1_c_8_p N_VDD_c_3077_n ) capacitor c=0.00269779f //x=8.535 \
 //y=5.56 //x2=10.055 //y2=7.585
cc_310 ( N_noxref_1_c_6_p N_VDD_c_3077_n ) capacitor c=0.031323f //x=9.315 \
 //y=5.25 //x2=10.055 //y2=7.585
cc_311 ( N_noxref_1_c_11_p N_VDD_c_3077_n ) capacitor c=0.00447349f //x=11.165 \
 //y=4.88 //x2=10.055 //y2=7.585
cc_312 ( N_noxref_1_c_7_p N_VDD_c_3077_n ) capacitor c=0.00564116f //x=11.167 \
 //y=4.74 //x2=10.055 //y2=7.585
cc_313 ( N_noxref_1_c_164_p N_VDD_c_3077_n ) capacitor c=0.00776541f //x=8.535 \
 //y=5.56 //x2=10.055 //y2=7.585
cc_314 ( N_noxref_1_c_12_p N_VDD_c_3077_n ) capacitor c=0.00370494f //x=11.165 \
 //y=4.88 //x2=10.055 //y2=7.585
cc_315 ( N_noxref_1_c_15_p N_VDD_c_3077_n ) capacitor c=0.0129564f //x=11.165 \
 //y=4.88 //x2=10.055 //y2=7.585
cc_316 ( N_noxref_1_M20_noxref_g N_VDD_M19_noxref_d ) capacitor c=0.015318f \
 //x=3.505 //y=6.2 //x2=3.14 //y2=5.2
cc_317 ( N_noxref_1_M21_noxref_g N_VDD_M21_noxref_d ) capacitor c=0.0394719f \
 //x=3.945 //y=6.2 //x2=4.02 //y2=5.2
cc_318 ( N_noxref_1_c_39_p N_VDD_M22_noxref_s ) capacitor c=0.0441176f \
 //x=6.777 //y=5.335 //x2=6.2 //y2=5.2
cc_319 ( N_noxref_1_c_40_p N_VDD_M22_noxref_s ) capacitor c=7.80122e-19 \
 //x=7.655 //y=5.335 //x2=6.2 //y2=5.2
cc_320 ( N_noxref_1_c_142_p N_VDD_M22_noxref_s ) capacitor c=0.09305f \
 //x=6.775 //y=5.56 //x2=6.2 //y2=5.2
cc_321 ( N_noxref_1_c_143_p N_VDD_M23_noxref_d ) capacitor c=0.00700141f \
 //x=7.535 //y=5.335 //x2=7.07 //y2=5.2
cc_322 ( N_noxref_1_c_142_p N_VDD_M23_noxref_d ) capacitor c=0.0674491f \
 //x=6.775 //y=5.56 //x2=7.07 //y2=5.2
cc_323 ( N_noxref_1_c_285_p N_VDD_M23_noxref_d ) capacitor c=0.0674762f \
 //x=7.655 //y=5.56 //x2=7.07 //y2=5.2
cc_324 ( N_noxref_1_c_187_p N_VDD_M25_noxref_d ) capacitor c=0.00700141f \
 //x=8.42 //y=5.335 //x2=7.95 //y2=5.2
cc_325 ( N_noxref_1_c_285_p N_VDD_M25_noxref_d ) capacitor c=0.067493f \
 //x=7.655 //y=5.56 //x2=7.95 //y2=5.2
cc_326 ( N_noxref_1_c_164_p N_VDD_M25_noxref_d ) capacitor c=0.0674288f \
 //x=8.535 //y=5.56 //x2=7.95 //y2=5.2
cc_327 ( N_noxref_1_c_9_p N_VDD_M27_noxref_d ) capacitor c=0.00700141f \
 //x=9.23 //y=5.335 //x2=8.83 //y2=5.2
cc_328 ( N_noxref_1_c_164_p N_VDD_M27_noxref_d ) capacitor c=0.0673824f \
 //x=8.535 //y=5.56 //x2=8.83 //y2=5.2
cc_329 ( N_noxref_1_c_8_p N_VDD_M28_noxref_s ) capacitor c=0.00536022f \
 //x=8.535 //y=5.56 //x2=10.71 //y2=5.2
cc_330 ( N_noxref_1_c_9_p N_VDD_M28_noxref_s ) capacitor c=0.00211796f \
 //x=9.23 //y=5.335 //x2=10.71 //y2=5.2
cc_331 ( N_noxref_1_c_10_p N_VDD_M28_noxref_s ) capacitor c=0.00111275f \
 //x=11.165 //y=3.67 //x2=10.71 //y2=5.2
cc_332 ( N_noxref_1_M28_noxref_g N_VDD_M28_noxref_s ) capacitor c=0.0567929f \
 //x=11.065 //y=6.2 //x2=10.71 //y2=5.2
cc_333 ( N_noxref_1_M29_noxref_g N_VDD_M29_noxref_d ) capacitor c=0.015318f \
 //x=11.505 //y=6.2 //x2=11.58 //y2=5.2
cc_334 ( N_noxref_1_c_30_p N_noxref_10_c_3440_n ) capacitor c=0.00177186f \
 //x=3.765 //y=2.375 //x2=4.42 //y2=0.72
cc_335 ( N_noxref_1_c_29_p N_noxref_10_c_3440_n ) capacitor c=0.00117306f \
 //x=3.765 //y=2.26 //x2=4.42 //y2=0.72
cc_336 ( N_noxref_1_c_55_p N_noxref_10_c_3440_n ) capacitor c=0.0206349f \
 //x=3.755 //y=1.095 //x2=4.42 //y2=0.72
cc_337 ( N_noxref_1_c_80_p N_noxref_10_c_3440_n ) capacitor c=0.00825432f \
 //x=4.285 //y=1.095 //x2=4.42 //y2=0.72
cc_338 ( N_noxref_1_c_32_p N_noxref_10_c_3440_n ) capacitor c=2.20712e-19 \
 //x=3.765 //y=2.26 //x2=4.42 //y2=0.72
cc_339 ( N_noxref_1_c_56_p N_noxref_10_c_3445_n ) capacitor c=0.0071177f \
 //x=3.755 //y=1.44 //x2=3.535 //y2=1.175
cc_340 ( N_noxref_1_c_55_p N_noxref_10_M2_noxref_s ) capacitor c=0.0071177f \
 //x=3.755 //y=1.095 //x2=3.4 //y2=0.555
cc_341 ( N_noxref_1_c_57_p N_noxref_10_M2_noxref_s ) capacitor c=0.0071177f \
 //x=3.755 //y=1.75 //x2=3.4 //y2=0.555
cc_342 ( N_noxref_1_c_80_p N_noxref_10_M2_noxref_s ) capacitor c=0.015333f \
 //x=4.285 //y=1.095 //x2=3.4 //y2=0.555
cc_343 ( N_noxref_1_c_81_p N_noxref_10_M2_noxref_s ) capacitor c=0.00248746f \
 //x=4.285 //y=1.44 //x2=3.4 //y2=0.555
cc_344 ( N_noxref_1_c_16_p N_noxref_11_c_3504_n ) capacitor c=0.0036878f \
 //x=8.83 //y=1.305 //x2=9.23 //y2=0.72
cc_345 ( N_noxref_1_c_3_p N_noxref_11_c_3504_n ) capacitor c=0.00399931f \
 //x=9.23 //y=1.845 //x2=9.23 //y2=0.72
cc_346 ( N_noxref_1_M5_noxref_d N_noxref_11_c_3504_n ) capacitor c=0.00910163f \
 //x=8.64 //y=1.095 //x2=9.23 //y2=0.72
cc_347 ( N_noxref_1_M5_noxref_d N_noxref_11_c_3507_n ) capacitor c=0.00120711f \
 //x=8.64 //y=1.095 //x2=8.345 //y2=1.175
cc_348 ( N_noxref_1_c_143_p N_noxref_11_M4_noxref_d ) capacitor c=0.00162433f \
 //x=7.535 //y=5.335 //x2=7.105 //y2=1.09
cc_349 ( N_noxref_1_c_16_p N_noxref_11_M4_noxref_d ) capacitor c=0.00802836f \
 //x=8.83 //y=1.305 //x2=7.105 //y2=1.09
cc_350 ( N_noxref_1_c_16_p N_noxref_11_M5_noxref_s ) capacitor c=0.00993092f \
 //x=8.83 //y=1.305 //x2=8.21 //y2=0.555
cc_351 ( N_noxref_1_c_2_p N_noxref_11_M5_noxref_s ) capacitor c=0.0270624f \
 //x=8.83 //y=1.76 //x2=8.21 //y2=0.555
cc_352 ( N_noxref_1_c_3_p N_noxref_11_M5_noxref_s ) capacitor c=0.00871957f \
 //x=9.23 //y=1.845 //x2=8.21 //y2=0.555
cc_353 ( N_noxref_1_c_158_p N_noxref_11_M5_noxref_s ) capacitor c=0.0016218f \
 //x=9.315 //y=3.51 //x2=8.21 //y2=0.555
cc_354 ( N_noxref_1_c_112_p N_noxref_11_M5_noxref_s ) capacitor c=0.00246663f \
 //x=9.48 //y=3.51 //x2=8.21 //y2=0.555
cc_355 ( N_noxref_1_M5_noxref_d N_noxref_11_M5_noxref_s ) capacitor \
 c=0.0279003f //x=8.64 //y=1.095 //x2=8.21 //y2=0.555
cc_356 ( N_noxref_1_c_154_p D ) capacitor c=0.00172399f //x=9.315 //y=3.35 \
 //x2=7.465 //y2=2.77
cc_357 ( N_noxref_1_c_6_p D ) capacitor c=0.00135693f //x=9.315 //y=5.25 \
 //x2=7.465 //y2=2.77
cc_358 ( N_noxref_1_c_112_p D ) capacitor c=0.0289072f //x=9.48 //y=3.51 \
 //x2=7.465 //y2=2.77
cc_359 ( N_noxref_1_c_112_p N_D_c_3574_n ) capacitor c=0.00242061f //x=9.48 \
 //y=3.51 //x2=7.465 //y2=2.375
cc_360 ( N_noxref_1_c_143_p N_D_c_3575_n ) capacitor c=0.0213631f //x=7.535 \
 //y=5.335 //x2=7.465 //y2=4.765
cc_361 ( N_noxref_1_c_40_p N_D_c_3575_n ) capacitor c=0.00239361f //x=7.655 \
 //y=5.335 //x2=7.465 //y2=4.765
cc_362 ( N_noxref_1_c_285_p N_D_c_3575_n ) capacitor c=7.85344e-19 //x=7.655 \
 //y=5.56 //x2=7.465 //y2=4.765
cc_363 ( N_noxref_1_c_143_p N_D_c_3578_n ) capacitor c=0.00492634f //x=7.535 \
 //y=5.335 //x2=7.465 //y2=4.88
cc_364 ( N_noxref_1_c_40_p N_D_c_3578_n ) capacitor c=0.00132214f //x=7.655 \
 //y=5.335 //x2=7.465 //y2=4.88
cc_365 ( N_noxref_1_c_143_p N_D_M24_noxref_g ) capacitor c=0.00858241f \
 //x=7.535 //y=5.335 //x2=7.435 //y2=6.2
cc_366 ( N_noxref_1_c_40_p N_D_M24_noxref_g ) capacitor c=0.00229818f \
 //x=7.655 //y=5.335 //x2=7.435 //y2=6.2
cc_367 ( N_noxref_1_c_285_p N_D_M24_noxref_g ) capacitor c=0.0179041f \
 //x=7.655 //y=5.56 //x2=7.435 //y2=6.2
cc_368 ( N_noxref_1_c_187_p N_D_M25_noxref_g ) capacitor c=0.00955829f \
 //x=8.42 //y=5.335 //x2=7.875 //y2=6.2
cc_369 ( N_noxref_1_c_40_p N_D_M25_noxref_g ) capacitor c=0.00230699f \
 //x=7.655 //y=5.335 //x2=7.875 //y2=6.2
cc_370 ( N_noxref_1_c_285_p N_D_M25_noxref_g ) capacitor c=0.0179041f \
 //x=7.655 //y=5.56 //x2=7.875 //y2=6.2
cc_371 ( N_noxref_1_c_40_p N_D_c_3586_n ) capacitor c=0.00171075f //x=7.655 \
 //y=5.335 //x2=7.8 //y2=4.97
cc_372 ( N_noxref_1_c_285_p N_D_c_3586_n ) capacitor c=0.00290085f //x=7.655 \
 //y=5.56 //x2=7.8 //y2=4.97
cc_373 ( N_noxref_1_c_143_p N_D_c_3588_n ) capacitor c=6.38058e-19 //x=7.535 \
 //y=5.335 //x2=7.465 //y2=4.88
cc_374 ( N_noxref_1_c_30_p N_GND_c_3830_n ) capacitor c=0.0021992f //x=3.765 \
 //y=2.375 //x2=6.235 //y2=0.175
cc_375 ( N_noxref_1_c_16_p N_GND_c_3831_n ) capacitor c=0.00878061f //x=8.83 \
 //y=1.305 //x2=11.15 //y2=0.175
cc_376 ( N_noxref_1_c_3_p N_GND_c_3831_n ) capacitor c=0.00662992f //x=9.23 \
 //y=1.845 //x2=11.15 //y2=0.175
cc_377 ( N_noxref_1_c_121_p N_GND_c_3831_n ) capacitor c=2.94824e-19 //x=9.315 \
 //y=3.67 //x2=11.15 //y2=0.175
cc_378 ( N_noxref_1_M5_noxref_d N_GND_c_3831_n ) capacitor c=2.9462e-19 \
 //x=8.64 //y=1.095 //x2=11.15 //y2=0.175
cc_379 ( N_noxref_1_c_16_p N_GND_c_3835_n ) capacitor c=0.00488628f //x=8.83 \
 //y=1.305 //x2=11.235 //y2=1.135
cc_380 ( N_noxref_1_c_177_p N_GND_c_3835_n ) capacitor c=0.00644213f \
 //x=11.165 //y=2.26 //x2=11.235 //y2=1.135
cc_381 ( N_noxref_1_c_181_p N_GND_c_3835_n ) capacitor c=2.13705e-19 \
 //x=11.165 //y=2.26 //x2=11.235 //y2=1.135
cc_382 ( N_noxref_1_c_259_p N_GND_c_3835_n ) capacitor c=0.00176535f //x=10.97 \
 //y=1.045 //x2=11.235 //y2=1.135
cc_383 ( N_noxref_1_c_260_p N_GND_c_3835_n ) capacitor c=0.0036005f //x=10.97 \
 //y=1.39 //x2=11.235 //y2=1.135
cc_384 ( N_noxref_1_c_262_p N_GND_c_3835_n ) capacitor c=4.2764e-19 //x=10.97 \
 //y=1.7 //x2=11.235 //y2=1.135
cc_385 ( N_noxref_1_c_385_p N_GND_c_3835_n ) capacitor c=9.36995e-19 \
 //x=11.345 //y=0.89 //x2=11.235 //y2=1.135
cc_386 ( N_noxref_1_c_386_p N_GND_c_3835_n ) capacitor c=6.27472e-19 \
 //x=11.345 //y=1.545 //x2=11.235 //y2=1.135
cc_387 ( N_noxref_1_c_261_p N_GND_c_3835_n ) capacitor c=0.00171483f //x=11.5 \
 //y=1.045 //x2=11.235 //y2=1.135
cc_388 ( N_noxref_1_c_263_p N_GND_c_3835_n ) capacitor c=0.00296337f //x=11.5 \
 //y=1.39 //x2=11.235 //y2=1.135
cc_389 ( N_noxref_1_c_259_p N_GND_c_3845_n ) capacitor c=3.51399e-19 //x=10.97 \
 //y=1.045 //x2=11.232 //y2=1.005
cc_390 ( N_noxref_1_c_385_p N_GND_c_3845_n ) capacitor c=0.00850983f \
 //x=11.345 //y=0.89 //x2=11.232 //y2=1.005
cc_391 ( N_noxref_1_c_261_p N_GND_c_3845_n ) capacitor c=4.40196e-19 //x=11.5 \
 //y=1.045 //x2=11.232 //y2=1.005
cc_392 ( N_noxref_1_c_30_p N_GND_c_3848_n ) capacitor c=2.016e-19 //x=3.765 \
 //y=2.375 //x2=5.075 //y2=0.175
cc_393 ( N_noxref_1_c_3_p N_GND_c_3849_n ) capacitor c=6.86343e-19 //x=9.23 \
 //y=1.845 //x2=9.885 //y2=0.175
cc_394 ( N_noxref_1_c_121_p N_GND_c_3849_n ) capacitor c=4.02711e-19 //x=9.315 \
 //y=3.67 //x2=9.885 //y2=0.175
cc_395 ( N_noxref_1_c_259_p N_GND_c_3851_n ) capacitor c=0.00688027f //x=10.97 \
 //y=1.045 //x2=13.215 //y2=0.175
cc_396 ( N_noxref_1_c_110_p N_GND_c_3852_n ) capacitor c=0.00560367f //x=5.975 \
 //y=3.51 //x2=5.245 //y2=0.175
cc_397 ( N_noxref_1_c_29_p N_GND_c_3852_n ) capacitor c=0.00239899f //x=3.765 \
 //y=2.26 //x2=5.245 //y2=0.175
cc_398 ( N_noxref_1_c_81_p N_GND_c_3852_n ) capacitor c=0.00262688f //x=4.285 \
 //y=1.44 //x2=5.245 //y2=0.175
cc_399 ( N_noxref_1_c_32_p N_GND_c_3852_n ) capacitor c=2.63786e-19 //x=3.765 \
 //y=2.26 //x2=5.245 //y2=0.175
cc_400 ( N_noxref_1_c_2_p N_GND_c_3856_n ) capacitor c=0.00285697f //x=8.83 \
 //y=1.76 //x2=10.055 //y2=0.175
cc_401 ( N_noxref_1_c_3_p N_GND_c_3856_n ) capacitor c=0.0329558f //x=9.23 \
 //y=1.845 //x2=10.055 //y2=0.175
cc_402 ( N_noxref_1_c_5_p N_GND_c_3856_n ) capacitor c=0.00781993f //x=11.165 \
 //y=3.35 //x2=10.055 //y2=0.175
cc_403 ( N_noxref_1_c_177_p N_GND_c_3856_n ) capacitor c=0.00351582f \
 //x=11.165 //y=2.26 //x2=10.055 //y2=0.175
cc_404 ( N_noxref_1_c_123_p N_GND_c_3856_n ) capacitor c=0.0039152f //x=11.005 \
 //y=3.51 //x2=10.055 //y2=0.175
cc_405 ( N_noxref_1_c_181_p N_GND_c_3856_n ) capacitor c=0.00354425f \
 //x=11.165 //y=2.26 //x2=10.055 //y2=0.175
cc_406 ( N_noxref_1_c_262_p N_GND_c_3856_n ) capacitor c=0.0015404f //x=10.97 \
 //y=1.7 //x2=10.055 //y2=0.175
cc_407 ( N_noxref_1_c_237_p N_GND_c_3856_n ) capacitor c=0.0093907f //x=10.97 \
 //y=2.095 //x2=10.055 //y2=0.175
cc_408 ( N_noxref_1_c_177_p N_GND_M6_noxref_d ) capacitor c=2.20438e-19 \
 //x=11.165 //y=2.26 //x2=11.045 //y2=1.045
cc_409 ( N_noxref_1_c_259_p N_GND_M6_noxref_d ) capacitor c=0.00192399f \
 //x=10.97 //y=1.045 //x2=11.045 //y2=1.045
cc_410 ( N_noxref_1_c_260_p N_GND_M6_noxref_d ) capacitor c=0.00210798f \
 //x=10.97 //y=1.39 //x2=11.045 //y2=1.045
cc_411 ( N_noxref_1_c_385_p N_GND_M6_noxref_d ) capacitor c=0.00472259f \
 //x=11.345 //y=0.89 //x2=11.045 //y2=1.045
cc_412 ( N_noxref_1_c_386_p N_GND_M6_noxref_d ) capacitor c=0.00166857f \
 //x=11.345 //y=1.545 //x2=11.045 //y2=1.045
cc_413 ( N_noxref_1_c_261_p N_GND_M6_noxref_d ) capacitor c=0.00230174f \
 //x=11.5 //y=1.045 //x2=11.045 //y2=1.045
cc_414 ( N_noxref_1_c_263_p N_GND_M6_noxref_d ) capacitor c=0.00210798f \
 //x=11.5 //y=1.39 //x2=11.045 //y2=1.045
cc_415 ( N_noxref_1_c_110_p N_noxref_17_c_4341_n ) capacitor c=0.00270802f \
 //x=5.975 //y=3.51 //x2=5.835 //y2=1.685
cc_416 ( N_noxref_1_c_110_p N_noxref_17_c_4342_n ) capacitor c=0.00768002f \
 //x=5.975 //y=3.51 //x2=6.72 //y2=1.77
cc_417 ( N_noxref_1_c_112_p N_noxref_17_c_4342_n ) capacitor c=8.84534e-19 \
 //x=9.48 //y=3.51 //x2=6.72 //y2=1.77
cc_418 ( N_noxref_1_c_112_p N_noxref_17_c_4344_n ) capacitor c=0.00797763f \
 //x=9.48 //y=3.51 //x2=7.69 //y2=1.77
cc_419 ( N_noxref_1_c_112_p N_noxref_17_M3_noxref_s ) capacitor c=0.00523529f \
 //x=9.48 //y=3.51 //x2=5.7 //y2=0.555
cc_420 ( N_noxref_1_c_237_p N_noxref_18_c_4399_n ) capacitor c=0.00262672f \
 //x=10.97 //y=2.095 //x2=10.75 //y2=1.675
cc_421 ( N_noxref_1_c_10_p N_noxref_18_c_4400_n ) capacitor c=0.00406558f \
 //x=11.165 //y=3.67 //x2=11.635 //y2=1.76
cc_422 ( N_noxref_1_c_177_p N_noxref_18_c_4400_n ) capacitor c=0.00509504f \
 //x=11.165 //y=2.26 //x2=11.635 //y2=1.76
cc_423 ( N_noxref_1_c_181_p N_noxref_18_c_4400_n ) capacitor c=0.00763108f \
 //x=11.165 //y=2.26 //x2=11.635 //y2=1.76
cc_424 ( N_noxref_1_c_262_p N_noxref_18_c_4400_n ) capacitor c=0.00697076f \
 //x=10.97 //y=1.7 //x2=11.635 //y2=1.76
cc_425 ( N_noxref_1_c_237_p N_noxref_18_c_4400_n ) capacitor c=0.0170561f \
 //x=10.97 //y=2.095 //x2=11.635 //y2=1.76
cc_426 ( N_noxref_1_c_386_p N_noxref_18_c_4400_n ) capacitor c=0.00723574f \
 //x=11.345 //y=1.545 //x2=11.635 //y2=1.76
cc_427 ( N_noxref_1_c_263_p N_noxref_18_c_4400_n ) capacitor c=0.00339872f \
 //x=11.5 //y=1.39 //x2=11.635 //y2=1.76
cc_428 ( N_noxref_1_c_237_p N_noxref_18_c_4407_n ) capacitor c=6.71402e-19 \
 //x=10.97 //y=2.095 //x2=11.72 //y2=1.675
cc_429 ( N_noxref_1_c_259_p N_noxref_18_M6_noxref_s ) capacitor c=0.0295366f \
 //x=10.97 //y=1.045 //x2=10.615 //y2=0.545
cc_430 ( N_noxref_1_c_262_p N_noxref_18_M6_noxref_s ) capacitor c=3.48408e-19 \
 //x=10.97 //y=1.7 //x2=10.615 //y2=0.545
cc_431 ( N_noxref_1_c_261_p N_noxref_18_M6_noxref_s ) capacitor c=0.0125442f \
 //x=11.5 //y=1.045 //x2=10.615 //y2=0.545
cc_432 ( N_noxref_2_c_435_n CLK ) capacitor c=0.00137941f //x=12.645 //y=3.355 \
 //x2=15.605 //y2=2.77
cc_433 ( N_noxref_2_c_437_n CLK ) capacitor c=7.56903e-19 //x=12.645 //y=5.295 \
 //x2=15.605 //y2=2.77
cc_434 ( N_noxref_2_c_457_p CLK ) capacitor c=0.0286724f //x=14.495 //y=3.355 \
 //x2=15.605 //y2=2.77
cc_435 ( N_noxref_2_c_458_p CLK ) capacitor c=0.00781344f //x=14.495 //y=3.675 \
 //x2=15.605 //y2=2.77
cc_436 ( N_noxref_2_c_459_p CLK ) capacitor c=0.0204064f //x=14.495 //y=4.755 \
 //x2=15.605 //y2=2.77
cc_437 ( N_noxref_2_c_460_p CLK ) capacitor c=2.98349e-19 //x=14.495 //y=3.51 \
 //x2=15.605 //y2=2.77
cc_438 ( N_noxref_2_c_461_p CLK ) capacitor c=0.00510347f //x=14.5 //y=3.515 \
 //x2=15.605 //y2=2.77
cc_439 ( N_noxref_2_c_462_p CLK ) capacitor c=3.9149e-19 //x=14.495 //y=2.26 \
 //x2=15.605 //y2=2.77
cc_440 ( N_noxref_2_c_463_p N_CLK_c_753_n ) capacitor c=0.00894339f //x=14.495 \
 //y=2.375 //x2=15.605 //y2=2.375
cc_441 ( N_noxref_2_c_462_p N_CLK_c_753_n ) capacitor c=5.40058e-19 //x=14.495 \
 //y=2.26 //x2=15.605 //y2=2.375
cc_442 ( N_noxref_2_c_465_p N_CLK_c_753_n ) capacitor c=0.00142893f //x=14.195 \
 //y=2.095 //x2=15.605 //y2=2.375
cc_443 ( N_noxref_2_c_459_p N_CLK_c_756_n ) capacitor c=0.0128897f //x=14.495 \
 //y=4.755 //x2=15.6 //y2=4.695
cc_444 ( N_noxref_2_c_467_p N_CLK_c_756_n ) capacitor c=8.3916e-19 //x=14.495 \
 //y=4.88 //x2=15.6 //y2=4.695
cc_445 ( N_noxref_2_c_468_p N_CLK_c_756_n ) capacitor c=7.66769e-19 //x=15.06 \
 //y=4.97 //x2=15.6 //y2=4.695
cc_446 ( N_noxref_2_c_469_p N_CLK_c_756_n ) capacitor c=9.07197e-19 //x=14.77 \
 //y=4.97 //x2=15.6 //y2=4.695
cc_447 ( N_noxref_2_c_432_n N_CLK_c_716_n ) capacitor c=0.00608733f //x=12.05 \
 //y=5.38 //x2=11.525 //y2=4.62
cc_448 ( N_noxref_2_c_439_n N_CLK_c_716_n ) capacitor c=0.0154492f //x=11.285 \
 //y=5.56 //x2=11.525 //y2=4.62
cc_449 ( N_noxref_2_c_437_n N_CLK_c_762_n ) capacitor c=0.0290879f //x=12.645 \
 //y=5.295 //x2=12.125 //y2=4.635
cc_450 ( N_noxref_2_c_459_p N_CLK_c_762_n ) capacitor c=0.0355055f //x=14.495 \
 //y=4.755 //x2=12.125 //y2=4.635
cc_451 ( N_noxref_2_c_474_p N_CLK_c_762_n ) capacitor c=0.0210804f //x=12.165 \
 //y=5.38 //x2=12.125 //y2=4.635
cc_452 ( N_noxref_2_c_463_p N_CLK_c_765_n ) capacitor c=5.39999e-19 //x=14.495 \
 //y=2.375 //x2=15.605 //y2=2.26
cc_453 ( N_noxref_2_c_457_p N_CLK_c_765_n ) capacitor c=3.9149e-19 //x=14.495 \
 //y=3.355 //x2=15.605 //y2=2.26
cc_454 ( N_noxref_2_c_462_p N_CLK_c_765_n ) capacitor c=0.00125213f //x=14.495 \
 //y=2.26 //x2=15.605 //y2=2.26
cc_455 ( N_noxref_2_c_465_p N_CLK_c_765_n ) capacitor c=0.00214573f //x=14.195 \
 //y=2.095 //x2=15.605 //y2=2.26
cc_456 ( N_noxref_2_c_459_p N_CLK_c_769_n ) capacitor c=5.64453e-19 //x=14.495 \
 //y=4.755 //x2=15.605 //y2=4.88
cc_457 ( N_noxref_2_c_467_p N_CLK_c_769_n ) capacitor c=0.00113666f //x=14.495 \
 //y=4.88 //x2=15.605 //y2=4.88
cc_458 ( N_noxref_2_c_468_p N_CLK_c_769_n ) capacitor c=0.00116563f //x=15.06 \
 //y=4.97 //x2=15.605 //y2=4.88
cc_459 ( N_noxref_2_c_469_p N_CLK_c_769_n ) capacitor c=0.0012974f //x=14.77 \
 //y=4.97 //x2=15.605 //y2=4.88
cc_460 ( N_noxref_2_M32_noxref_g N_CLK_M34_noxref_g ) capacitor c=0.0106276f \
 //x=14.695 //y=6.2 //x2=15.575 //y2=6.2
cc_461 ( N_noxref_2_M33_noxref_g N_CLK_M34_noxref_g ) capacitor c=0.107144f \
 //x=15.135 //y=6.2 //x2=15.575 //y2=6.2
cc_462 ( N_noxref_2_M33_noxref_g N_CLK_M35_noxref_g ) capacitor c=0.0101598f \
 //x=15.135 //y=6.2 //x2=16.015 //y2=6.2
cc_463 ( N_noxref_2_c_486_p N_CLK_c_776_n ) capacitor c=5.72528e-19 //x=14.195 \
 //y=1.055 //x2=15.17 //y2=1.09
cc_464 ( N_noxref_2_c_487_p N_CLK_c_776_n ) capacitor c=0.00150277f //x=14.195 \
 //y=1.4 //x2=15.17 //y2=1.09
cc_465 ( N_noxref_2_c_488_p N_CLK_c_776_n ) capacitor c=0.0160123f //x=14.725 \
 //y=1.055 //x2=15.17 //y2=1.09
cc_466 ( N_noxref_2_c_489_p N_CLK_c_779_n ) capacitor c=0.00111227f //x=14.195 \
 //y=1.71 //x2=15.17 //y2=1.4
cc_467 ( N_noxref_2_c_490_p N_CLK_c_779_n ) capacitor c=0.0124075f //x=14.725 \
 //y=1.4 //x2=15.17 //y2=1.4
cc_468 ( N_noxref_2_c_488_p N_CLK_c_781_n ) capacitor c=9.19165e-19 //x=14.725 \
 //y=1.055 //x2=15.695 //y2=1.09
cc_469 ( N_noxref_2_c_490_p N_CLK_c_782_n ) capacitor c=0.0010154f //x=14.725 \
 //y=1.4 //x2=15.695 //y2=1.4
cc_470 ( N_noxref_2_c_490_p N_CLK_c_783_n ) capacitor c=9.23422e-19 //x=14.725 \
 //y=1.4 //x2=15.695 //y2=1.63
cc_471 ( N_noxref_2_c_463_p N_CLK_c_784_n ) capacitor c=0.00136403f //x=14.495 \
 //y=2.375 //x2=15.695 //y2=2.095
cc_472 ( N_noxref_2_c_462_p N_CLK_c_784_n ) capacitor c=0.0020754f //x=14.495 \
 //y=2.26 //x2=15.695 //y2=2.095
cc_473 ( N_noxref_2_c_465_p N_CLK_c_784_n ) capacitor c=0.00964411f //x=14.195 \
 //y=2.095 //x2=15.695 //y2=2.095
cc_474 ( N_noxref_2_c_459_p N_CLK_c_787_n ) capacitor c=5.7788e-19 //x=14.495 \
 //y=4.755 //x2=15.605 //y2=4.88
cc_475 ( N_noxref_2_c_467_p N_CLK_c_787_n ) capacitor c=0.0013104f //x=14.495 \
 //y=4.88 //x2=15.605 //y2=4.88
cc_476 ( N_noxref_2_c_468_p N_CLK_c_787_n ) capacitor c=0.0171374f //x=15.06 \
 //y=4.97 //x2=15.605 //y2=4.88
cc_477 ( N_noxref_2_c_469_p N_CLK_c_787_n ) capacitor c=0.00419533f //x=14.77 \
 //y=4.97 //x2=15.605 //y2=4.88
cc_478 ( N_noxref_2_c_501_p N_noxref_4_c_1091_n ) capacitor c=0.0013819f \
 //x=12.645 //y=3.675 //x2=12.125 //y2=3.865
cc_479 ( N_noxref_2_c_437_n N_noxref_4_c_1091_n ) capacitor c=0.00102062f \
 //x=12.645 //y=5.295 //x2=12.125 //y2=3.865
cc_480 ( N_noxref_2_c_449_n N_noxref_4_c_1091_n ) capacitor c=0.0358254f \
 //x=12.805 //y=3.515 //x2=12.125 //y2=3.865
cc_481 ( N_noxref_2_c_501_p N_noxref_4_c_1094_n ) capacitor c=0.00765069f \
 //x=12.645 //y=3.675 //x2=12.86 //y2=3.9
cc_482 ( N_noxref_2_c_437_n N_noxref_4_c_1094_n ) capacitor c=0.022395f \
 //x=12.645 //y=5.295 //x2=12.86 //y2=3.9
cc_483 ( N_noxref_2_c_506_p N_noxref_4_c_1094_n ) capacitor c=0.128042f \
 //x=14.34 //y=3.515 //x2=12.86 //y2=3.9
cc_484 ( N_noxref_2_c_458_p N_noxref_4_c_1097_n ) capacitor c=0.00342064f \
 //x=14.495 //y=3.675 //x2=14.115 //y2=3.88
cc_485 ( N_noxref_2_c_459_p N_noxref_4_c_1097_n ) capacitor c=6.75872e-19 \
 //x=14.495 //y=4.755 //x2=14.115 //y2=3.88
cc_486 ( N_noxref_2_c_461_p N_noxref_4_c_1097_n ) capacitor c=0.0358254f \
 //x=14.5 //y=3.515 //x2=14.115 //y2=3.88
cc_487 ( N_noxref_2_c_506_p N_noxref_4_c_1097_n ) capacitor c=0.0106805f \
 //x=14.34 //y=3.515 //x2=14.115 //y2=3.88
cc_488 ( N_noxref_2_c_458_p N_noxref_4_c_1101_n ) capacitor c=0.00292429f \
 //x=14.495 //y=3.675 //x2=14.715 //y2=3.9
cc_489 ( N_noxref_2_c_459_p N_noxref_4_c_1101_n ) capacitor c=0.023831f \
 //x=14.495 //y=4.755 //x2=14.715 //y2=3.9
cc_490 ( N_noxref_2_c_457_p RN ) capacitor c=0.00130368f //x=14.495 //y=3.355 \
 //x2=16.715 //y2=2.77
cc_491 ( N_noxref_2_c_459_p RN ) capacitor c=0.00126605f //x=14.495 //y=4.755 \
 //x2=16.715 //y2=2.77
cc_492 ( N_noxref_2_c_434_n N_RN_c_1483_n ) capacitor c=0.0193939f //x=12.29 \
 //y=1.835 //x2=16.56 //y2=2.315
cc_493 ( N_noxref_2_c_435_n N_RN_c_1483_n ) capacitor c=0.0321972f //x=12.645 \
 //y=3.355 //x2=16.56 //y2=2.315
cc_494 ( N_noxref_2_c_501_p N_RN_c_1483_n ) capacitor c=0.00327078f //x=12.645 \
 //y=3.675 //x2=16.56 //y2=2.315
cc_495 ( N_noxref_2_c_463_p N_RN_c_1483_n ) capacitor c=0.016619f //x=14.495 \
 //y=2.375 //x2=16.56 //y2=2.315
cc_496 ( N_noxref_2_c_457_p N_RN_c_1483_n ) capacitor c=0.018395f //x=14.495 \
 //y=3.355 //x2=16.56 //y2=2.315
cc_497 ( N_noxref_2_c_458_p N_RN_c_1483_n ) capacitor c=0.00342885f //x=14.495 \
 //y=3.675 //x2=16.56 //y2=2.315
cc_498 ( N_noxref_2_c_447_n N_RN_c_1483_n ) capacitor c=7.09092e-19 //x=12.205 \
 //y=1.18 //x2=16.56 //y2=2.315
cc_499 ( N_noxref_2_c_449_n N_RN_c_1483_n ) capacitor c=0.00806725f //x=12.805 \
 //y=3.515 //x2=16.56 //y2=2.315
cc_500 ( N_noxref_2_c_461_p N_RN_c_1483_n ) capacitor c=0.00830358f //x=14.5 \
 //y=3.515 //x2=16.56 //y2=2.315
cc_501 ( N_noxref_2_c_506_p N_RN_c_1483_n ) capacitor c=0.0483895f //x=14.34 \
 //y=3.515 //x2=16.56 //y2=2.315
cc_502 ( N_noxref_2_c_462_p N_RN_c_1483_n ) capacitor c=5.18204e-19 //x=14.495 \
 //y=2.26 //x2=16.56 //y2=2.315
cc_503 ( N_noxref_2_c_435_n N_noxref_7_c_2174_n ) capacitor c=0.0418808f \
 //x=12.645 //y=3.355 //x2=11.905 //y2=4.09
cc_504 ( N_noxref_2_c_501_p N_noxref_7_c_2174_n ) capacitor c=0.0148501f \
 //x=12.645 //y=3.675 //x2=11.905 //y2=4.09
cc_505 ( N_noxref_2_c_437_n N_noxref_7_c_2174_n ) capacitor c=0.0164753f \
 //x=12.645 //y=5.295 //x2=11.905 //y2=4.09
cc_506 ( N_noxref_2_c_457_p N_noxref_7_c_2174_n ) capacitor c=0.00191767f \
 //x=14.495 //y=3.355 //x2=11.905 //y2=4.09
cc_507 ( N_noxref_2_c_459_p N_noxref_7_c_2174_n ) capacitor c=3.10515e-19 \
 //x=14.495 //y=4.755 //x2=11.905 //y2=4.09
cc_508 ( N_noxref_2_c_448_n N_noxref_7_c_2174_n ) capacitor c=5.57251e-19 \
 //x=12.645 //y=3.51 //x2=11.905 //y2=4.09
cc_509 ( N_noxref_2_c_449_n N_noxref_7_c_2174_n ) capacitor c=0.00365657f \
 //x=12.805 //y=3.515 //x2=11.905 //y2=4.09
cc_510 ( N_noxref_2_c_432_n N_noxref_7_c_2182_n ) capacitor c=0.00424065f \
 //x=12.05 //y=5.38 //x2=11.905 //y2=4.41
cc_511 ( N_noxref_2_c_437_n N_noxref_7_c_2182_n ) capacitor c=0.0147977f \
 //x=12.645 //y=5.295 //x2=11.905 //y2=4.41
cc_512 ( N_noxref_2_c_432_n N_noxref_7_c_2183_n ) capacitor c=0.0215376f \
 //x=12.05 //y=5.38 //x2=11.905 //y2=4.735
cc_513 ( N_noxref_2_c_437_n N_noxref_7_c_2183_n ) capacitor c=0.0284267f \
 //x=12.645 //y=5.295 //x2=11.905 //y2=4.735
cc_514 ( N_noxref_2_c_459_p N_noxref_7_c_2183_n ) capacitor c=4.62211e-19 \
 //x=14.495 //y=4.755 //x2=11.905 //y2=4.735
cc_515 ( N_noxref_2_M33_noxref_g N_noxref_7_c_2241_n ) capacitor c=0.00893512f \
 //x=15.135 //y=6.2 //x2=15.675 //y2=5.335
cc_516 ( N_noxref_2_c_539_p N_noxref_7_c_2242_n ) capacitor c=8.29536e-19 \
 //x=12.56 //y=1.835 //x2=16.97 //y2=1.76
cc_517 ( N_noxref_2_c_435_n N_noxref_7_c_2243_n ) capacitor c=8.29536e-19 \
 //x=12.645 //y=3.355 //x2=17.055 //y2=1.845
cc_518 ( N_noxref_2_c_437_n N_noxref_7_c_2188_n ) capacitor c=6.15063e-19 \
 //x=12.645 //y=5.295 //x2=11.905 //y2=4.25
cc_519 ( N_noxref_2_c_435_n N_noxref_7_c_2189_n ) capacitor c=0.0138368f \
 //x=12.645 //y=3.355 //x2=11.905 //y2=2.26
cc_520 ( N_noxref_2_c_437_n N_noxref_7_c_2246_n ) capacitor c=0.00261914f \
 //x=12.645 //y=5.295 //x2=14.917 //y2=5.335
cc_521 ( N_noxref_2_c_474_p N_noxref_7_c_2246_n ) capacitor c=5.0812e-19 \
 //x=12.165 //y=5.38 //x2=14.917 //y2=5.335
cc_522 ( N_noxref_2_M32_noxref_g N_noxref_7_c_2246_n ) capacitor c=0.00461408f \
 //x=14.695 //y=6.2 //x2=14.917 //y2=5.335
cc_523 ( N_noxref_2_M33_noxref_g N_noxref_7_c_2246_n ) capacitor c=0.00229208f \
 //x=15.135 //y=6.2 //x2=14.917 //y2=5.335
cc_524 ( N_noxref_2_c_468_p N_noxref_7_c_2246_n ) capacitor c=0.00171885f \
 //x=15.06 //y=4.97 //x2=14.917 //y2=5.335
cc_525 ( N_noxref_2_c_437_n N_noxref_7_c_2251_n ) capacitor c=0.022727f \
 //x=12.645 //y=5.295 //x2=17.3 //y2=4.25
cc_526 ( N_noxref_2_c_459_p N_noxref_7_c_2251_n ) capacitor c=0.0246035f \
 //x=14.495 //y=4.755 //x2=17.3 //y2=4.25
cc_527 ( N_noxref_2_c_506_p N_noxref_7_c_2251_n ) capacitor c=0.0093607f \
 //x=14.34 //y=3.515 //x2=17.3 //y2=4.25
cc_528 ( N_noxref_2_c_437_n N_noxref_7_c_2199_n ) capacitor c=0.00328982f \
 //x=12.645 //y=5.295 //x2=12.07 //y2=4.25
cc_529 ( N_noxref_2_c_435_n N_noxref_7_c_2203_n ) capacitor c=9.26054e-19 \
 //x=12.645 //y=3.355 //x2=11.905 //y2=2.26
cc_530 ( N_noxref_2_c_432_n N_noxref_7_c_2207_n ) capacitor c=0.00469257f \
 //x=12.05 //y=5.38 //x2=11.935 //y2=4.88
cc_531 ( N_noxref_2_c_437_n N_noxref_7_c_2207_n ) capacitor c=7.76118e-19 \
 //x=12.645 //y=5.295 //x2=11.935 //y2=4.88
cc_532 ( N_noxref_2_M32_noxref_g N_noxref_7_c_2258_n ) capacitor c=0.0162284f \
 //x=14.695 //y=6.2 //x2=14.915 //y2=5.56
cc_533 ( N_noxref_2_M33_noxref_g N_noxref_7_c_2258_n ) capacitor c=0.0179041f \
 //x=15.135 //y=6.2 //x2=14.915 //y2=5.56
cc_534 ( N_noxref_2_c_468_p N_noxref_7_c_2258_n ) capacitor c=0.00291477f \
 //x=15.06 //y=4.97 //x2=14.915 //y2=5.56
cc_535 ( N_noxref_2_c_432_n N_noxref_7_M30_noxref_g ) capacitor c=0.00842859f \
 //x=12.05 //y=5.38 //x2=11.945 //y2=6.2
cc_536 ( N_noxref_2_c_474_p N_noxref_7_M30_noxref_g ) capacitor c=0.00192712f \
 //x=12.165 //y=5.38 //x2=11.945 //y2=6.2
cc_537 ( N_noxref_2_c_560_p N_noxref_7_M30_noxref_g ) capacitor c=0.0178987f \
 //x=12.165 //y=5.56 //x2=11.945 //y2=6.2
cc_538 ( N_noxref_2_c_561_p N_noxref_7_M31_noxref_g ) capacitor c=0.0106088f \
 //x=12.56 //y=5.38 //x2=12.385 //y2=6.2
cc_539 ( N_noxref_2_c_474_p N_noxref_7_M31_noxref_g ) capacitor c=0.00312463f \
 //x=12.165 //y=5.38 //x2=12.385 //y2=6.2
cc_540 ( N_noxref_2_c_560_p N_noxref_7_M31_noxref_g ) capacitor c=0.0178506f \
 //x=12.165 //y=5.56 //x2=12.385 //y2=6.2
cc_541 ( N_noxref_2_c_447_n N_noxref_7_c_2213_n ) capacitor c=0.00120406f \
 //x=12.205 //y=1.18 //x2=11.94 //y2=1.085
cc_542 ( N_noxref_2_M7_noxref_d N_noxref_7_c_2213_n ) capacitor c=0.00137165f \
 //x=12.015 //y=1.085 //x2=11.94 //y2=1.085
cc_543 ( N_noxref_2_c_433_n N_noxref_7_c_2216_n ) capacitor c=0.00119302f \
 //x=12.205 //y=1.75 //x2=11.94 //y2=1.43
cc_544 ( N_noxref_2_c_447_n N_noxref_7_c_2216_n ) capacitor c=0.00218772f \
 //x=12.205 //y=1.18 //x2=11.94 //y2=1.43
cc_545 ( N_noxref_2_M7_noxref_d N_noxref_7_c_2216_n ) capacitor c=0.00237422f \
 //x=12.015 //y=1.085 //x2=11.94 //y2=1.43
cc_546 ( N_noxref_2_c_433_n N_noxref_7_c_2218_n ) capacitor c=0.00439215f \
 //x=12.205 //y=1.75 //x2=11.94 //y2=1.74
cc_547 ( N_noxref_2_c_437_n N_noxref_7_c_2273_n ) capacitor c=0.00845606f \
 //x=12.645 //y=5.295 //x2=12.31 //y2=4.97
cc_548 ( N_noxref_2_c_474_p N_noxref_7_c_2273_n ) capacitor c=0.0020909f \
 //x=12.165 //y=5.38 //x2=12.31 //y2=4.97
cc_549 ( N_noxref_2_c_560_p N_noxref_7_c_2273_n ) capacitor c=0.00291714f \
 //x=12.165 //y=5.56 //x2=12.31 //y2=4.97
cc_550 ( N_noxref_2_c_447_n N_noxref_7_c_2276_n ) capacitor c=5.50523e-19 \
 //x=12.205 //y=1.18 //x2=12.315 //y2=0.93
cc_551 ( N_noxref_2_M7_noxref_d N_noxref_7_c_2276_n ) capacitor c=0.0020782f \
 //x=12.015 //y=1.085 //x2=12.315 //y2=0.93
cc_552 ( N_noxref_2_c_433_n N_noxref_7_c_2278_n ) capacitor c=0.00929773f \
 //x=12.205 //y=1.75 //x2=12.315 //y2=1.585
cc_553 ( N_noxref_2_c_539_p N_noxref_7_c_2278_n ) capacitor c=0.00194324f \
 //x=12.56 //y=1.835 //x2=12.315 //y2=1.585
cc_554 ( N_noxref_2_c_447_n N_noxref_7_c_2278_n ) capacitor c=5.67071e-19 \
 //x=12.205 //y=1.18 //x2=12.315 //y2=1.585
cc_555 ( N_noxref_2_M7_noxref_d N_noxref_7_c_2278_n ) capacitor c=0.00356097f \
 //x=12.015 //y=1.085 //x2=12.315 //y2=1.585
cc_556 ( N_noxref_2_c_447_n N_noxref_7_c_2221_n ) capacitor c=0.00108157f \
 //x=12.205 //y=1.18 //x2=12.47 //y2=1.085
cc_557 ( N_noxref_2_M7_noxref_d N_noxref_7_c_2221_n ) capacitor c=8.50095e-19 \
 //x=12.015 //y=1.085 //x2=12.47 //y2=1.085
cc_558 ( N_noxref_2_c_433_n N_noxref_7_c_2222_n ) capacitor c=0.00341295f \
 //x=12.205 //y=1.75 //x2=12.47 //y2=1.43
cc_559 ( N_noxref_2_c_539_p N_noxref_7_c_2222_n ) capacitor c=0.00323005f \
 //x=12.56 //y=1.835 //x2=12.47 //y2=1.43
cc_560 ( N_noxref_2_c_447_n N_noxref_7_c_2222_n ) capacitor c=0.00312028f \
 //x=12.205 //y=1.18 //x2=12.47 //y2=1.43
cc_561 ( N_noxref_2_M7_noxref_d N_noxref_7_c_2222_n ) capacitor c=0.00237422f \
 //x=12.015 //y=1.085 //x2=12.47 //y2=1.43
cc_562 ( N_noxref_2_c_435_n N_noxref_7_c_2223_n ) capacitor c=0.00268898f \
 //x=12.645 //y=3.355 //x2=11.905 //y2=2.26
cc_563 ( N_noxref_2_c_433_n N_noxref_7_c_2289_n ) capacitor c=0.00341688f \
 //x=12.205 //y=1.75 //x2=11.905 //y2=2.095
cc_564 ( N_noxref_2_c_435_n N_noxref_7_c_2289_n ) capacitor c=0.00309058f \
 //x=12.645 //y=3.355 //x2=11.905 //y2=2.095
cc_565 ( N_noxref_2_c_432_n N_noxref_7_c_2226_n ) capacitor c=8.42507e-19 \
 //x=12.05 //y=5.38 //x2=11.935 //y2=4.88
cc_566 ( N_noxref_2_c_437_n N_noxref_7_c_2226_n ) capacitor c=0.00142201f \
 //x=12.645 //y=5.295 //x2=11.935 //y2=4.88
cc_567 ( N_noxref_2_c_432_n N_VDD_c_3043_n ) capacitor c=0.00648267f //x=12.05 \
 //y=5.38 //x2=25.965 //y2=7.58
cc_568 ( N_noxref_2_c_561_p N_VDD_c_3043_n ) capacitor c=0.00492584f //x=12.56 \
 //y=5.38 //x2=25.965 //y2=7.58
cc_569 ( N_noxref_2_c_501_p N_VDD_c_3043_n ) capacitor c=4.58709e-19 \
 //x=12.645 //y=3.675 //x2=25.965 //y2=7.58
cc_570 ( N_noxref_2_c_458_p N_VDD_c_3043_n ) capacitor c=3.99241e-19 \
 //x=14.495 //y=3.675 //x2=25.965 //y2=7.58
cc_571 ( N_noxref_2_c_439_n N_VDD_c_3043_n ) capacitor c=0.00368834f \
 //x=11.285 //y=5.56 //x2=25.965 //y2=7.58
cc_572 ( N_noxref_2_c_474_p N_VDD_c_3043_n ) capacitor c=8.42594e-19 \
 //x=12.165 //y=5.38 //x2=25.965 //y2=7.58
cc_573 ( N_noxref_2_c_596_p N_VDD_c_3043_n ) capacitor c=0.00285853f \
 //x=12.165 //y=5.56 //x2=25.965 //y2=7.58
cc_574 ( N_noxref_2_c_450_n N_VDD_c_3043_n ) capacitor c=0.00224881f \
 //x=11.285 //y=5.56 //x2=25.965 //y2=7.58
cc_575 ( N_noxref_2_c_560_p N_VDD_c_3043_n ) capacitor c=0.00224881f \
 //x=12.165 //y=5.56 //x2=25.965 //y2=7.58
cc_576 ( N_noxref_2_c_432_n N_VDD_c_3070_n ) capacitor c=0.00208087f //x=12.05 \
 //y=5.38 //x2=11.64 //y2=7.585
cc_577 ( N_noxref_2_c_439_n N_VDD_c_3070_n ) capacitor c=9.41185e-19 \
 //x=11.285 //y=5.56 //x2=11.64 //y2=7.585
cc_578 ( N_noxref_2_c_450_n N_VDD_c_3070_n ) capacitor c=0.0136705f //x=11.285 \
 //y=5.56 //x2=11.64 //y2=7.585
cc_579 ( N_noxref_2_c_432_n N_VDD_c_3114_n ) capacitor c=0.00180737f //x=12.05 \
 //y=5.38 //x2=12.52 //y2=7.585
cc_580 ( N_noxref_2_c_561_p N_VDD_c_3114_n ) capacitor c=0.00208087f //x=12.56 \
 //y=5.38 //x2=12.52 //y2=7.585
cc_581 ( N_noxref_2_c_474_p N_VDD_c_3114_n ) capacitor c=4.23719e-19 \
 //x=12.165 //y=5.38 //x2=12.52 //y2=7.585
cc_582 ( N_noxref_2_c_596_p N_VDD_c_3114_n ) capacitor c=5.77976e-19 \
 //x=12.165 //y=5.56 //x2=12.52 //y2=7.585
cc_583 ( N_noxref_2_c_560_p N_VDD_c_3114_n ) capacitor c=0.0136705f //x=12.165 \
 //y=5.56 //x2=12.52 //y2=7.585
cc_584 ( N_noxref_2_M32_noxref_g N_VDD_c_3119_n ) capacitor c=0.00755614f \
 //x=14.695 //y=6.2 //x2=15.27 //y2=7.585
cc_585 ( N_noxref_2_M33_noxref_g N_VDD_c_3119_n ) capacitor c=0.00755544f \
 //x=15.135 //y=6.2 //x2=15.27 //y2=7.585
cc_586 ( N_noxref_2_c_437_n N_VDD_c_3077_n ) capacitor c=0.0013228f //x=12.645 \
 //y=5.295 //x2=10.055 //y2=7.585
cc_587 ( N_noxref_2_c_439_n N_VDD_c_3077_n ) capacitor c=4.91377e-19 \
 //x=11.285 //y=5.56 //x2=10.055 //y2=7.585
cc_588 ( N_noxref_2_c_450_n N_VDD_c_3077_n ) capacitor c=0.0064135f //x=11.285 \
 //y=5.56 //x2=10.055 //y2=7.585
cc_589 ( N_noxref_2_c_437_n N_VDD_c_3124_n ) capacitor c=0.0294123f //x=12.645 \
 //y=5.295 //x2=13.385 //y2=7.585
cc_590 ( N_noxref_2_c_459_p N_VDD_c_3124_n ) capacitor c=0.0119111f //x=14.495 \
 //y=4.755 //x2=13.385 //y2=7.585
cc_591 ( N_noxref_2_c_474_p N_VDD_c_3124_n ) capacitor c=0.0025639f //x=12.165 \
 //y=5.38 //x2=13.385 //y2=7.585
cc_592 ( N_noxref_2_c_596_p N_VDD_c_3124_n ) capacitor c=4.19141e-19 \
 //x=12.165 //y=5.56 //x2=13.385 //y2=7.585
cc_593 ( N_noxref_2_c_560_p N_VDD_c_3124_n ) capacitor c=0.0101861f //x=12.165 \
 //y=5.56 //x2=13.385 //y2=7.585
cc_594 ( N_noxref_2_c_467_p N_VDD_c_3124_n ) capacitor c=0.00370784f \
 //x=14.495 //y=4.88 //x2=13.385 //y2=7.585
cc_595 ( N_noxref_2_c_469_p N_VDD_c_3124_n ) capacitor c=0.00590568f //x=14.77 \
 //y=4.97 //x2=13.385 //y2=7.585
cc_596 ( N_noxref_2_c_439_n N_VDD_M28_noxref_s ) capacitor c=0.0611368f \
 //x=11.285 //y=5.56 //x2=10.71 //y2=5.2
cc_597 ( N_noxref_2_c_474_p N_VDD_M28_noxref_s ) capacitor c=6.52457e-19 \
 //x=12.165 //y=5.38 //x2=10.71 //y2=5.2
cc_598 ( N_noxref_2_c_450_n N_VDD_M28_noxref_s ) capacitor c=0.0887533f \
 //x=11.285 //y=5.56 //x2=10.71 //y2=5.2
cc_599 ( N_noxref_2_c_432_n N_VDD_M29_noxref_d ) capacitor c=0.00734094f \
 //x=12.05 //y=5.38 //x2=11.58 //y2=5.2
cc_600 ( N_noxref_2_c_439_n N_VDD_M29_noxref_d ) capacitor c=0.0043528f \
 //x=11.285 //y=5.56 //x2=11.58 //y2=5.2
cc_601 ( N_noxref_2_c_596_p N_VDD_M29_noxref_d ) capacitor c=0.0043528f \
 //x=12.165 //y=5.56 //x2=11.58 //y2=5.2
cc_602 ( N_noxref_2_c_450_n N_VDD_M29_noxref_d ) capacitor c=0.065554f \
 //x=11.285 //y=5.56 //x2=11.58 //y2=5.2
cc_603 ( N_noxref_2_c_560_p N_VDD_M29_noxref_d ) capacitor c=0.065554f \
 //x=12.165 //y=5.56 //x2=11.58 //y2=5.2
cc_604 ( N_noxref_2_c_561_p N_VDD_M31_noxref_d ) capacitor c=0.00934027f \
 //x=12.56 //y=5.38 //x2=12.46 //y2=5.2
cc_605 ( N_noxref_2_c_596_p N_VDD_M31_noxref_d ) capacitor c=0.00955781f \
 //x=12.165 //y=5.56 //x2=12.46 //y2=5.2
cc_606 ( N_noxref_2_c_448_n N_VDD_M31_noxref_d ) capacitor c=9.65951e-19 \
 //x=12.645 //y=3.51 //x2=12.46 //y2=5.2
cc_607 ( N_noxref_2_c_560_p N_VDD_M31_noxref_d ) capacitor c=0.065554f \
 //x=12.165 //y=5.56 //x2=12.46 //y2=5.2
cc_608 ( N_noxref_2_c_561_p N_VDD_M32_noxref_s ) capacitor c=0.00220019f \
 //x=12.56 //y=5.38 //x2=14.34 //y2=5.2
cc_609 ( N_noxref_2_c_458_p N_VDD_M32_noxref_s ) capacitor c=6.02115e-19 \
 //x=14.495 //y=3.675 //x2=14.34 //y2=5.2
cc_610 ( N_noxref_2_c_459_p N_VDD_M32_noxref_s ) capacitor c=0.0217981f \
 //x=14.495 //y=4.755 //x2=14.34 //y2=5.2
cc_611 ( N_noxref_2_c_474_p N_VDD_M32_noxref_s ) capacitor c=0.00371125f \
 //x=12.165 //y=5.38 //x2=14.34 //y2=5.2
cc_612 ( N_noxref_2_c_596_p N_VDD_M32_noxref_s ) capacitor c=9.52042e-19 \
 //x=12.165 //y=5.56 //x2=14.34 //y2=5.2
cc_613 ( N_noxref_2_c_467_p N_VDD_M32_noxref_s ) capacitor c=0.00983846f \
 //x=14.495 //y=4.88 //x2=14.34 //y2=5.2
cc_614 ( N_noxref_2_M32_noxref_g N_VDD_M32_noxref_s ) capacitor c=0.053419f \
 //x=14.695 //y=6.2 //x2=14.34 //y2=5.2
cc_615 ( N_noxref_2_c_469_p N_VDD_M32_noxref_s ) capacitor c=0.0060625f \
 //x=14.77 //y=4.97 //x2=14.34 //y2=5.2
cc_616 ( N_noxref_2_M33_noxref_g N_VDD_M33_noxref_d ) capacitor c=0.015318f \
 //x=15.135 //y=6.2 //x2=15.21 //y2=5.2
cc_617 ( N_noxref_2_c_447_n N_noxref_13_M9_noxref_d ) capacitor c=3.39394e-19 \
 //x=12.205 //y=1.18 //x2=15.245 //y2=1.09
cc_618 ( N_noxref_2_c_539_p N_GND_c_3871_n ) capacitor c=0.00608539f //x=12.56 \
 //y=1.835 //x2=14.375 //y2=0.175
cc_619 ( N_noxref_2_c_501_p N_GND_c_3871_n ) capacitor c=2.7199e-19 //x=12.645 \
 //y=3.675 //x2=14.375 //y2=0.175
cc_620 ( N_noxref_2_c_447_n N_GND_c_3871_n ) capacitor c=0.00928865f \
 //x=12.205 //y=1.18 //x2=14.375 //y2=0.175
cc_621 ( N_noxref_2_M7_noxref_d N_GND_c_3871_n ) capacitor c=3.01769e-19 \
 //x=12.015 //y=1.085 //x2=14.375 //y2=0.175
cc_622 ( N_noxref_2_c_486_p N_GND_c_3875_n ) capacitor c=3.92414e-19 \
 //x=14.195 //y=1.055 //x2=14.46 //y2=1.015
cc_623 ( N_noxref_2_c_646_p N_GND_c_3875_n ) capacitor c=0.0085115f //x=14.57 \
 //y=0.9 //x2=14.46 //y2=1.015
cc_624 ( N_noxref_2_c_488_p N_GND_c_3875_n ) capacitor c=4.45447e-19 \
 //x=14.725 //y=1.055 //x2=14.46 //y2=1.015
cc_625 ( N_noxref_2_c_439_n N_GND_c_3835_n ) capacitor c=6.80717e-19 \
 //x=11.285 //y=5.56 //x2=11.235 //y2=1.135
cc_626 ( N_noxref_2_c_447_n N_GND_c_3835_n ) capacitor c=0.0140211f //x=12.205 \
 //y=1.18 //x2=11.235 //y2=1.135
cc_627 ( N_noxref_2_M7_noxref_d N_GND_c_3835_n ) capacitor c=2.93544e-19 \
 //x=12.015 //y=1.085 //x2=11.235 //y2=1.135
cc_628 ( N_noxref_2_c_463_p N_GND_c_3881_n ) capacitor c=0.00772482f \
 //x=14.495 //y=2.375 //x2=14.46 //y2=1.145
cc_629 ( N_noxref_2_c_458_p N_GND_c_3881_n ) capacitor c=7.58937e-19 \
 //x=14.495 //y=3.675 //x2=14.46 //y2=1.145
cc_630 ( N_noxref_2_c_447_n N_GND_c_3881_n ) capacitor c=0.00606355f \
 //x=12.205 //y=1.18 //x2=14.46 //y2=1.145
cc_631 ( N_noxref_2_c_462_p N_GND_c_3881_n ) capacitor c=2.22883e-19 \
 //x=14.495 //y=2.26 //x2=14.46 //y2=1.145
cc_632 ( N_noxref_2_c_486_p N_GND_c_3881_n ) capacitor c=0.0015128f //x=14.195 \
 //y=1.055 //x2=14.46 //y2=1.145
cc_633 ( N_noxref_2_c_487_p N_GND_c_3881_n ) capacitor c=0.00350108f \
 //x=14.195 //y=1.4 //x2=14.46 //y2=1.145
cc_634 ( N_noxref_2_c_489_p N_GND_c_3881_n ) capacitor c=4.28277e-19 \
 //x=14.195 //y=1.71 //x2=14.46 //y2=1.145
cc_635 ( N_noxref_2_c_646_p N_GND_c_3881_n ) capacitor c=9.36995e-19 //x=14.57 \
 //y=0.9 //x2=14.46 //y2=1.145
cc_636 ( N_noxref_2_c_659_p N_GND_c_3881_n ) capacitor c=5.79535e-19 //x=14.57 \
 //y=1.555 //x2=14.46 //y2=1.145
cc_637 ( N_noxref_2_c_488_p N_GND_c_3881_n ) capacitor c=0.0017438f //x=14.725 \
 //y=1.055 //x2=14.46 //y2=1.145
cc_638 ( N_noxref_2_c_490_p N_GND_c_3881_n ) capacitor c=0.00276804f \
 //x=14.725 //y=1.4 //x2=14.46 //y2=1.145
cc_639 ( N_noxref_2_c_539_p N_GND_c_3851_n ) capacitor c=7.75992e-19 //x=12.56 \
 //y=1.835 //x2=13.215 //y2=0.175
cc_640 ( N_noxref_2_c_501_p N_GND_c_3851_n ) capacitor c=3.21092e-19 \
 //x=12.645 //y=3.675 //x2=13.215 //y2=0.175
cc_641 ( N_noxref_2_c_486_p N_GND_c_3894_n ) capacitor c=0.00677932f \
 //x=14.195 //y=1.055 //x2=18.025 //y2=0.175
cc_642 ( N_noxref_2_c_435_n N_GND_c_3856_n ) capacitor c=9.32616e-19 \
 //x=12.645 //y=3.355 //x2=10.055 //y2=0.175
cc_643 ( N_noxref_2_c_433_n N_GND_c_3896_n ) capacitor c=0.00460657f \
 //x=12.205 //y=1.75 //x2=13.385 //y2=0.175
cc_644 ( N_noxref_2_c_539_p N_GND_c_3896_n ) capacitor c=0.0300371f //x=12.56 \
 //y=1.835 //x2=13.385 //y2=0.175
cc_645 ( N_noxref_2_c_463_p N_GND_c_3896_n ) capacitor c=0.00343139f \
 //x=14.495 //y=2.375 //x2=13.385 //y2=0.175
cc_646 ( N_noxref_2_c_457_p N_GND_c_3896_n ) capacitor c=0.0109665f //x=14.495 \
 //y=3.355 //x2=13.385 //y2=0.175
cc_647 ( N_noxref_2_c_506_p N_GND_c_3896_n ) capacitor c=0.0039152f //x=14.34 \
 //y=3.515 //x2=13.385 //y2=0.175
cc_648 ( N_noxref_2_c_462_p N_GND_c_3896_n ) capacitor c=0.00379568f \
 //x=14.495 //y=2.26 //x2=13.385 //y2=0.175
cc_649 ( N_noxref_2_c_489_p N_GND_c_3896_n ) capacitor c=0.00170145f \
 //x=14.195 //y=1.71 //x2=13.385 //y2=0.175
cc_650 ( N_noxref_2_c_465_p N_GND_c_3896_n ) capacitor c=0.0102191f //x=14.195 \
 //y=2.095 //x2=13.385 //y2=0.175
cc_651 ( N_noxref_2_c_447_n N_GND_M6_noxref_d ) capacitor c=2.82748e-19 \
 //x=12.205 //y=1.18 //x2=11.045 //y2=1.045
cc_652 ( N_noxref_2_c_463_p N_GND_M8_noxref_d ) capacitor c=4.4417e-19 \
 //x=14.495 //y=2.375 //x2=14.27 //y2=1.055
cc_653 ( N_noxref_2_c_486_p N_GND_M8_noxref_d ) capacitor c=0.00184354f \
 //x=14.195 //y=1.055 //x2=14.27 //y2=1.055
cc_654 ( N_noxref_2_c_487_p N_GND_M8_noxref_d ) capacitor c=0.00210798f \
 //x=14.195 //y=1.4 //x2=14.27 //y2=1.055
cc_655 ( N_noxref_2_c_646_p N_GND_M8_noxref_d ) capacitor c=0.00474029f \
 //x=14.57 //y=0.9 //x2=14.27 //y2=1.055
cc_656 ( N_noxref_2_c_659_p N_GND_M8_noxref_d ) capacitor c=0.00166857f \
 //x=14.57 //y=1.555 //x2=14.27 //y2=1.055
cc_657 ( N_noxref_2_c_488_p N_GND_M8_noxref_d ) capacitor c=0.00230174f \
 //x=14.725 //y=1.055 //x2=14.27 //y2=1.055
cc_658 ( N_noxref_2_c_490_p N_GND_M8_noxref_d ) capacitor c=0.00210798f \
 //x=14.725 //y=1.4 //x2=14.27 //y2=1.055
cc_659 ( N_noxref_2_c_434_n N_noxref_18_c_4407_n ) capacitor c=0.00911405f \
 //x=12.29 //y=1.835 //x2=11.72 //y2=1.675
cc_660 ( N_noxref_2_c_539_p N_noxref_18_c_4412_n ) capacitor c=0.00399245f \
 //x=12.56 //y=1.835 //x2=12.605 //y2=0.71
cc_661 ( N_noxref_2_c_447_n N_noxref_18_c_4412_n ) capacitor c=0.003751f \
 //x=12.205 //y=1.18 //x2=12.605 //y2=0.71
cc_662 ( N_noxref_2_M7_noxref_d N_noxref_18_c_4412_n ) capacitor c=0.00910163f \
 //x=12.015 //y=1.085 //x2=12.605 //y2=0.71
cc_663 ( N_noxref_2_c_433_n N_noxref_18_M6_noxref_s ) capacitor c=0.0175063f \
 //x=12.205 //y=1.75 //x2=10.615 //y2=0.545
cc_664 ( N_noxref_2_c_539_p N_noxref_18_M6_noxref_s ) capacitor c=0.00640979f \
 //x=12.56 //y=1.835 //x2=10.615 //y2=0.545
cc_665 ( N_noxref_2_c_501_p N_noxref_18_M6_noxref_s ) capacitor c=4.15501e-19 \
 //x=12.645 //y=3.675 //x2=10.615 //y2=0.545
cc_666 ( N_noxref_2_c_447_n N_noxref_18_M6_noxref_s ) capacitor c=0.0089443f \
 //x=12.205 //y=1.18 //x2=10.615 //y2=0.545
cc_667 ( N_noxref_2_c_448_n N_noxref_18_M6_noxref_s ) capacitor c=0.0010514f \
 //x=12.645 //y=3.51 //x2=10.615 //y2=0.545
cc_668 ( N_noxref_2_M7_noxref_d N_noxref_18_M6_noxref_s ) capacitor \
 c=0.0275552f //x=12.015 //y=1.085 //x2=10.615 //y2=0.545
cc_669 ( N_noxref_2_c_465_p N_noxref_19_c_4467_n ) capacitor c=0.00262672f \
 //x=14.195 //y=2.095 //x2=13.975 //y2=1.685
cc_670 ( N_noxref_2_c_463_p N_noxref_19_c_4468_n ) capacitor c=0.00428451f \
 //x=14.495 //y=2.375 //x2=14.86 //y2=1.77
cc_671 ( N_noxref_2_c_458_p N_noxref_19_c_4468_n ) capacitor c=0.00270049f \
 //x=14.495 //y=3.675 //x2=14.86 //y2=1.77
cc_672 ( N_noxref_2_c_462_p N_noxref_19_c_4468_n ) capacitor c=0.0104666f \
 //x=14.495 //y=2.26 //x2=14.86 //y2=1.77
cc_673 ( N_noxref_2_c_489_p N_noxref_19_c_4468_n ) capacitor c=0.00705077f \
 //x=14.195 //y=1.71 //x2=14.86 //y2=1.77
cc_674 ( N_noxref_2_c_465_p N_noxref_19_c_4468_n ) capacitor c=0.020708f \
 //x=14.195 //y=2.095 //x2=14.86 //y2=1.77
cc_675 ( N_noxref_2_c_659_p N_noxref_19_c_4468_n ) capacitor c=0.00588627f \
 //x=14.57 //y=1.555 //x2=14.86 //y2=1.77
cc_676 ( N_noxref_2_c_490_p N_noxref_19_c_4468_n ) capacitor c=0.00698822f \
 //x=14.725 //y=1.4 //x2=14.86 //y2=1.77
cc_677 ( N_noxref_2_c_486_p N_noxref_19_M8_noxref_s ) capacitor c=0.0295256f \
 //x=14.195 //y=1.055 //x2=13.84 //y2=0.555
cc_678 ( N_noxref_2_c_489_p N_noxref_19_M8_noxref_s ) capacitor c=7.99997e-19 \
 //x=14.195 //y=1.71 //x2=13.84 //y2=0.555
cc_679 ( N_noxref_2_c_465_p N_noxref_19_M8_noxref_s ) capacitor c=0.00122123f \
 //x=14.195 //y=2.095 //x2=13.84 //y2=0.555
cc_680 ( N_noxref_2_c_488_p N_noxref_19_M8_noxref_s ) capacitor c=0.0125924f \
 //x=14.725 //y=1.055 //x2=13.84 //y2=0.555
cc_681 ( N_CLK_c_713_n N_noxref_4_c_1103_n ) capacitor c=0.0234972f //x=2.65 \
 //y=4.835 //x2=2.725 //y2=5.335
cc_682 ( N_CLK_c_724_n N_noxref_4_c_1103_n ) capacitor c=0.00243571f //x=2.65 \
 //y=4.62 //x2=2.725 //y2=5.335
cc_683 ( N_CLK_c_729_n N_noxref_4_c_1103_n ) capacitor c=0.00492634f //x=2.655 \
 //y=4.88 //x2=2.725 //y2=5.335
cc_684 ( N_CLK_M18_noxref_g N_noxref_4_c_1103_n ) capacitor c=0.00858222f \
 //x=2.625 //y=6.2 //x2=2.725 //y2=5.335
cc_685 ( N_CLK_c_743_n N_noxref_4_c_1103_n ) capacitor c=3.54644e-19 //x=2.655 \
 //y=4.88 //x2=2.725 //y2=5.335
cc_686 ( N_CLK_M19_noxref_g N_noxref_4_c_1002_n ) capacitor c=0.00955829f \
 //x=3.065 //y=6.2 //x2=3.61 //y2=5.335
cc_687 ( N_CLK_c_716_n N_noxref_4_c_1007_n ) capacitor c=0.0206181f //x=11.525 \
 //y=4.62 //x2=4.42 //y2=5.335
cc_688 ( CLK N_noxref_4_c_1030_n ) capacitor c=0.00286279f //x=2.655 //y=2.77 \
 //x2=4.505 //y2=3.725
cc_689 ( CLK N_noxref_4_c_1042_n ) capacitor c=9.29639e-19 //x=2.655 //y=2.77 \
 //x2=4.505 //y2=5.25
cc_690 ( N_CLK_c_716_n N_noxref_4_c_1042_n ) capacitor c=0.0298618f //x=11.525 \
 //y=4.62 //x2=4.505 //y2=5.25
cc_691 ( N_CLK_c_716_n N_noxref_4_c_1051_n ) capacitor c=0.0317543f //x=11.525 \
 //y=4.62 //x2=6.355 //y2=4.755
cc_692 ( N_CLK_c_713_n N_noxref_4_c_1114_n ) capacitor c=0.00512107f //x=2.65 \
 //y=4.835 //x2=2.845 //y2=5.335
cc_693 ( N_CLK_c_716_n N_noxref_4_c_1114_n ) capacitor c=0.0383042f //x=11.525 \
 //y=4.62 //x2=2.845 //y2=5.335
cc_694 ( N_CLK_c_724_n N_noxref_4_c_1114_n ) capacitor c=0.00207204f //x=2.65 \
 //y=4.62 //x2=2.845 //y2=5.335
cc_695 ( N_CLK_c_729_n N_noxref_4_c_1114_n ) capacitor c=0.00132214f //x=2.655 \
 //y=4.88 //x2=2.845 //y2=5.335
cc_696 ( N_CLK_M18_noxref_g N_noxref_4_c_1114_n ) capacitor c=0.00229818f \
 //x=2.625 //y=6.2 //x2=2.845 //y2=5.335
cc_697 ( N_CLK_M19_noxref_g N_noxref_4_c_1114_n ) capacitor c=0.00230699f \
 //x=3.065 //y=6.2 //x2=2.845 //y2=5.335
cc_698 ( N_CLK_c_742_n N_noxref_4_c_1114_n ) capacitor c=0.00170733f //x=2.99 \
 //y=4.97 //x2=2.845 //y2=5.335
cc_699 ( N_CLK_c_716_n N_noxref_4_c_1056_n ) capacitor c=0.00755818f \
 //x=11.525 //y=4.62 //x2=6.2 //y2=3.88
cc_700 ( N_CLK_c_716_n N_noxref_4_c_1058_n ) capacitor c=0.0064996f //x=11.525 \
 //y=4.62 //x2=9.535 //y2=3.895
cc_701 ( N_CLK_c_716_n N_noxref_4_c_1061_n ) capacitor c=0.0193975f //x=11.525 \
 //y=4.62 //x2=9.19 //y2=3.895
cc_702 ( N_CLK_c_716_n N_noxref_4_c_1065_n ) capacitor c=0.0036897f //x=11.525 \
 //y=4.62 //x2=10.78 //y2=3.88
cc_703 ( N_CLK_c_716_n N_noxref_4_c_1069_n ) capacitor c=0.00294091f \
 //x=11.525 //y=4.62 //x2=11.38 //y2=3.895
cc_704 ( N_CLK_c_762_n N_noxref_4_c_1091_n ) capacitor c=0.00625686f \
 //x=12.125 //y=4.635 //x2=12.125 //y2=3.865
cc_705 ( N_CLK_c_762_n N_noxref_4_c_1094_n ) capacitor c=0.00619486f \
 //x=12.125 //y=4.635 //x2=12.86 //y2=3.9
cc_706 ( N_CLK_c_762_n N_noxref_4_c_1097_n ) capacitor c=0.003069f //x=12.125 \
 //y=4.635 //x2=14.115 //y2=3.88
cc_707 ( CLK N_noxref_4_c_1101_n ) capacitor c=6.63302e-19 //x=15.605 //y=2.77 \
 //x2=14.715 //y2=3.9
cc_708 ( N_CLK_c_762_n N_noxref_4_c_1101_n ) capacitor c=0.00554145f \
 //x=12.125 //y=4.635 //x2=14.715 //y2=3.9
cc_709 ( CLK N_noxref_4_c_1131_n ) capacitor c=0.0287878f //x=15.605 //y=2.77 \
 //x2=17.075 //y2=3.88
cc_710 ( N_CLK_c_713_n N_noxref_4_c_1132_n ) capacitor c=0.00134045f //x=2.65 \
 //y=4.835 //x2=2.845 //y2=5.56
cc_711 ( N_CLK_M18_noxref_g N_noxref_4_c_1132_n ) capacitor c=0.0179041f \
 //x=2.625 //y=6.2 //x2=2.845 //y2=5.56
cc_712 ( N_CLK_M19_noxref_g N_noxref_4_c_1132_n ) capacitor c=0.0179041f \
 //x=3.065 //y=6.2 //x2=2.845 //y2=5.56
cc_713 ( N_CLK_c_742_n N_noxref_4_c_1132_n ) capacitor c=0.00293647f //x=2.99 \
 //y=4.97 //x2=2.845 //y2=5.56
cc_714 ( N_CLK_c_716_n RN ) capacitor c=0.0246348f //x=11.525 //y=4.62 \
 //x2=8.575 //y2=2.77
cc_715 ( CLK RN ) capacitor c=0.0566825f //x=15.605 //y=2.77 //x2=16.715 \
 //y2=2.77
cc_716 ( N_CLK_c_756_n RN ) capacitor c=0.00492163f //x=15.6 //y=4.695 \
 //x2=16.715 //y2=2.77
cc_717 ( N_CLK_c_762_n RN ) capacitor c=0.00360307f //x=12.125 //y=4.635 \
 //x2=16.715 //y2=2.77
cc_718 ( CLK RN ) capacitor c=0.00158143f //x=15.605 //y=2.77 //x2=16.715 \
 //y2=2.4
cc_719 ( N_CLK_c_753_n RN ) capacitor c=0.00675925f //x=15.605 //y=2.375 \
 //x2=16.715 //y2=2.4
cc_720 ( N_CLK_c_765_n RN ) capacitor c=9.53526e-19 //x=15.605 //y=2.26 \
 //x2=16.715 //y2=2.4
cc_721 ( N_CLK_c_784_n RN ) capacitor c=0.00135583f //x=15.695 //y=2.095 \
 //x2=16.715 //y2=2.4
cc_722 ( N_CLK_c_716_n N_RN_c_1472_n ) capacitor c=0.00413069f //x=11.525 \
 //y=4.62 //x2=8.575 //y2=4.75
cc_723 ( N_CLK_c_756_n N_RN_c_1550_n ) capacitor c=0.00878903f //x=15.6 \
 //y=4.695 //x2=16.715 //y2=4.75
cc_724 ( N_CLK_c_762_n N_RN_c_1550_n ) capacitor c=0.00241165f //x=12.125 \
 //y=4.635 //x2=16.715 //y2=4.75
cc_725 ( N_CLK_c_769_n N_RN_c_1550_n ) capacitor c=4.56604e-19 //x=15.605 \
 //y=4.88 //x2=16.715 //y2=4.75
cc_726 ( N_CLK_c_787_n N_RN_c_1550_n ) capacitor c=2.32327e-19 //x=15.605 \
 //y=4.88 //x2=16.715 //y2=4.75
cc_727 ( CLK N_RN_c_1483_n ) capacitor c=0.0189298f //x=15.605 //y=2.77 \
 //x2=16.56 //y2=2.315
cc_728 ( N_CLK_c_753_n N_RN_c_1483_n ) capacitor c=0.0167682f //x=15.605 \
 //y=2.375 //x2=16.56 //y2=2.315
cc_729 ( N_CLK_c_765_n N_RN_c_1483_n ) capacitor c=2.63835e-19 //x=15.605 \
 //y=2.26 //x2=16.56 //y2=2.315
cc_730 ( N_CLK_c_753_n N_RN_c_1557_n ) capacitor c=0.00390832f //x=15.605 \
 //y=2.375 //x2=16.88 //y2=2.315
cc_731 ( N_CLK_c_753_n N_RN_c_1558_n ) capacitor c=6.92676e-19 //x=15.605 \
 //y=2.375 //x2=16.715 //y2=2.26
cc_732 ( N_CLK_c_765_n N_RN_c_1558_n ) capacitor c=0.00129119f //x=15.605 \
 //y=2.26 //x2=16.715 //y2=2.26
cc_733 ( N_CLK_c_784_n N_RN_c_1558_n ) capacitor c=0.00210314f //x=15.695 \
 //y=2.095 //x2=16.715 //y2=2.26
cc_734 ( N_CLK_c_756_n N_RN_c_1561_n ) capacitor c=9.59226e-19 //x=15.6 \
 //y=4.695 //x2=16.715 //y2=4.88
cc_735 ( N_CLK_c_769_n N_RN_c_1561_n ) capacitor c=0.00113671f //x=15.605 \
 //y=4.88 //x2=16.715 //y2=4.88
cc_736 ( N_CLK_c_787_n N_RN_c_1561_n ) capacitor c=0.00104879f //x=15.605 \
 //y=4.88 //x2=16.715 //y2=4.88
cc_737 ( N_CLK_M34_noxref_g N_RN_M36_noxref_g ) capacitor c=0.0101598f \
 //x=15.575 //y=6.2 //x2=16.455 //y2=6.2
cc_738 ( N_CLK_M35_noxref_g N_RN_M36_noxref_g ) capacitor c=0.0607518f \
 //x=16.015 //y=6.2 //x2=16.455 //y2=6.2
cc_739 ( N_CLK_M35_noxref_g N_RN_M37_noxref_g ) capacitor c=0.0101598f \
 //x=16.015 //y=6.2 //x2=16.895 //y2=6.2
cc_740 ( N_CLK_c_781_n N_RN_c_1567_n ) capacitor c=0.00456962f //x=15.695 \
 //y=1.09 //x2=16.705 //y2=1.095
cc_741 ( N_CLK_c_782_n N_RN_c_1568_n ) capacitor c=0.00438372f //x=15.695 \
 //y=1.4 //x2=16.705 //y2=1.44
cc_742 ( N_CLK_c_783_n N_RN_c_1569_n ) capacitor c=0.00438372f //x=15.695 \
 //y=1.63 //x2=16.705 //y2=1.75
cc_743 ( N_CLK_c_765_n N_RN_c_1570_n ) capacitor c=0.00155537f //x=15.605 \
 //y=2.26 //x2=16.715 //y2=2.26
cc_744 ( N_CLK_c_784_n N_RN_c_1570_n ) capacitor c=0.00831559f //x=15.695 \
 //y=2.095 //x2=16.715 //y2=2.26
cc_745 ( N_CLK_c_784_n N_RN_c_1572_n ) capacitor c=0.00438372f //x=15.695 \
 //y=2.095 //x2=16.715 //y2=2.095
cc_746 ( N_CLK_c_756_n N_RN_c_1573_n ) capacitor c=0.00139285f //x=15.6 \
 //y=4.695 //x2=16.715 //y2=4.88
cc_747 ( N_CLK_c_769_n N_RN_c_1573_n ) capacitor c=0.00186974f //x=15.605 \
 //y=4.88 //x2=16.715 //y2=4.88
cc_748 ( N_CLK_c_858_p N_RN_c_1573_n ) capacitor c=0.0616777f //x=15.94 \
 //y=4.97 //x2=16.715 //y2=4.88
cc_749 ( N_CLK_c_787_n N_RN_c_1573_n ) capacitor c=0.00440391f //x=15.605 \
 //y=4.88 //x2=16.715 //y2=4.88
cc_750 ( N_CLK_c_710_n N_noxref_7_c_2293_n ) capacitor c=0.0115546f //x=2.655 \
 //y=2.375 //x2=1.545 //y2=2.375
cc_751 ( N_CLK_c_725_n N_noxref_7_c_2293_n ) capacitor c=0.00375644f //x=2.655 \
 //y=2.26 //x2=1.545 //y2=2.375
cc_752 ( N_CLK_c_738_n N_noxref_7_c_2293_n ) capacitor c=0.00140534f //x=2.745 \
 //y=2.095 //x2=1.545 //y2=2.375
cc_753 ( CLK N_noxref_7_c_2171_n ) capacitor c=0.0544022f //x=2.655 //y=2.77 \
 //x2=1.545 //y2=4.1
cc_754 ( N_CLK_c_725_n N_noxref_7_c_2171_n ) capacitor c=4.16726e-19 //x=2.655 \
 //y=2.26 //x2=1.545 //y2=4.1
cc_755 ( CLK N_noxref_7_c_2298_n ) capacitor c=0.00795617f //x=2.655 //y=2.77 \
 //x2=1.545 //y2=4.42
cc_756 ( CLK N_noxref_7_c_2173_n ) capacitor c=0.00593778f //x=2.655 //y=2.77 \
 //x2=1.545 //y2=4.755
cc_757 ( N_CLK_c_713_n N_noxref_7_c_2173_n ) capacitor c=0.00911997f //x=2.65 \
 //y=4.835 //x2=1.545 //y2=4.755
cc_758 ( N_CLK_c_724_n N_noxref_7_c_2173_n ) capacitor c=0.00912377f //x=2.65 \
 //y=4.62 //x2=1.545 //y2=4.755
cc_759 ( N_CLK_c_729_n N_noxref_7_c_2173_n ) capacitor c=0.00402042f //x=2.655 \
 //y=4.88 //x2=1.545 //y2=4.755
cc_760 ( N_CLK_c_743_n N_noxref_7_c_2173_n ) capacitor c=0.00107711f //x=2.655 \
 //y=4.88 //x2=1.545 //y2=4.755
cc_761 ( N_CLK_c_716_n N_noxref_7_c_2182_n ) capacitor c=0.00261296f \
 //x=11.525 //y=4.62 //x2=11.905 //y2=4.41
cc_762 ( N_CLK_c_762_n N_noxref_7_c_2182_n ) capacitor c=0.00232919f \
 //x=12.125 //y=4.635 //x2=11.905 //y2=4.41
cc_763 ( N_CLK_c_716_n N_noxref_7_c_2183_n ) capacitor c=3.14882e-19 \
 //x=11.525 //y=4.62 //x2=11.905 //y2=4.735
cc_764 ( N_CLK_c_762_n N_noxref_7_c_2183_n ) capacitor c=0.0260542f //x=12.125 \
 //y=4.635 //x2=11.905 //y2=4.735
cc_765 ( N_CLK_c_756_n N_noxref_7_c_2241_n ) capacitor c=0.0234494f //x=15.6 \
 //y=4.695 //x2=15.675 //y2=5.335
cc_766 ( N_CLK_c_762_n N_noxref_7_c_2241_n ) capacitor c=0.00121614f \
 //x=12.125 //y=4.635 //x2=15.675 //y2=5.335
cc_767 ( N_CLK_c_769_n N_noxref_7_c_2241_n ) capacitor c=0.00492634f \
 //x=15.605 //y=4.88 //x2=15.675 //y2=5.335
cc_768 ( N_CLK_M34_noxref_g N_noxref_7_c_2241_n ) capacitor c=0.00858239f \
 //x=15.575 //y=6.2 //x2=15.675 //y2=5.335
cc_769 ( N_CLK_c_787_n N_noxref_7_c_2241_n ) capacitor c=3.77911e-19 \
 //x=15.605 //y=4.88 //x2=15.675 //y2=5.335
cc_770 ( N_CLK_M35_noxref_g N_noxref_7_c_2313_n ) capacitor c=0.0103546f \
 //x=16.015 //y=6.2 //x2=16.56 //y2=5.335
cc_771 ( CLK N_noxref_7_c_2314_n ) capacitor c=0.00296423f //x=15.605 //y=2.77 \
 //x2=17.455 //y2=4.095
cc_772 ( CLK N_noxref_7_c_2315_n ) capacitor c=2.99109e-19 //x=15.605 //y=2.77 \
 //x2=17.455 //y2=5.25
cc_773 ( CLK N_noxref_7_c_2316_n ) capacitor c=4.22577e-19 //x=2.655 //y=2.77 \
 //x2=1.545 //y2=4.25
cc_774 ( N_CLK_c_762_n N_noxref_7_c_2246_n ) capacitor c=0.0278748f //x=12.125 \
 //y=4.635 //x2=14.917 //y2=5.335
cc_775 ( N_CLK_c_756_n N_noxref_7_c_2318_n ) capacitor c=0.00463905f //x=15.6 \
 //y=4.695 //x2=15.795 //y2=5.335
cc_776 ( N_CLK_c_762_n N_noxref_7_c_2318_n ) capacitor c=9.74982e-19 \
 //x=12.125 //y=4.635 //x2=15.795 //y2=5.335
cc_777 ( N_CLK_c_769_n N_noxref_7_c_2318_n ) capacitor c=0.00132214f \
 //x=15.605 //y=4.88 //x2=15.795 //y2=5.335
cc_778 ( N_CLK_M34_noxref_g N_noxref_7_c_2318_n ) capacitor c=0.00229818f \
 //x=15.575 //y=6.2 //x2=15.795 //y2=5.335
cc_779 ( N_CLK_M35_noxref_g N_noxref_7_c_2318_n ) capacitor c=0.00230699f \
 //x=16.015 //y=6.2 //x2=15.795 //y2=5.335
cc_780 ( N_CLK_c_858_p N_noxref_7_c_2318_n ) capacitor c=0.0017286f //x=15.94 \
 //y=4.97 //x2=15.795 //y2=5.335
cc_781 ( CLK N_noxref_7_c_2192_n ) capacitor c=0.028849f //x=2.655 //y=2.77 \
 //x2=4.12 //y2=4.25
cc_782 ( N_CLK_c_710_n N_noxref_7_c_2192_n ) capacitor c=0.00154241f //x=2.655 \
 //y=2.375 //x2=4.12 //y2=4.25
cc_783 ( N_CLK_c_713_n N_noxref_7_c_2192_n ) capacitor c=0.00269476f //x=2.65 \
 //y=4.835 //x2=4.12 //y2=4.25
cc_784 ( N_CLK_c_716_n N_noxref_7_c_2192_n ) capacitor c=0.064437f //x=11.525 \
 //y=4.62 //x2=4.12 //y2=4.25
cc_785 ( N_CLK_c_724_n N_noxref_7_c_2192_n ) capacitor c=0.155631f //x=2.65 \
 //y=4.62 //x2=4.12 //y2=4.25
cc_786 ( N_CLK_c_716_n N_noxref_7_c_2196_n ) capacitor c=0.113902f //x=11.525 \
 //y=4.62 //x2=4.76 //y2=4.27
cc_787 ( N_CLK_c_716_n N_noxref_7_c_2197_n ) capacitor c=0.0602971f //x=11.525 \
 //y=4.62 //x2=5.975 //y2=4.25
cc_788 ( CLK N_noxref_7_c_2251_n ) capacitor c=0.023508f //x=15.605 //y=2.77 \
 //x2=17.3 //y2=4.25
cc_789 ( N_CLK_c_756_n N_noxref_7_c_2251_n ) capacitor c=0.00375947f //x=15.6 \
 //y=4.695 //x2=17.3 //y2=4.25
cc_790 ( N_CLK_c_762_n N_noxref_7_c_2251_n ) capacitor c=0.33879f //x=12.125 \
 //y=4.635 //x2=17.3 //y2=4.25
cc_791 ( N_CLK_c_716_n N_noxref_7_c_2199_n ) capacitor c=0.497376f //x=11.525 \
 //y=4.62 //x2=12.07 //y2=4.25
cc_792 ( CLK N_noxref_7_c_2335_n ) capacitor c=0.00242466f //x=2.655 //y=2.77 \
 //x2=1.705 //y2=4.26
cc_793 ( CLK N_noxref_7_c_2336_n ) capacitor c=4.16726e-19 //x=2.655 //y=2.77 \
 //x2=1.545 //y2=2.26
cc_794 ( N_CLK_c_710_n N_noxref_7_c_2336_n ) capacitor c=5.40058e-19 //x=2.655 \
 //y=2.375 //x2=1.545 //y2=2.26
cc_795 ( N_CLK_c_725_n N_noxref_7_c_2336_n ) capacitor c=0.00125213f //x=2.655 \
 //y=2.26 //x2=1.545 //y2=2.26
cc_796 ( N_CLK_c_738_n N_noxref_7_c_2336_n ) capacitor c=0.0020754f //x=2.745 \
 //y=2.095 //x2=1.545 //y2=2.26
cc_797 ( N_CLK_c_713_n N_noxref_7_c_2340_n ) capacitor c=6.32742e-19 //x=2.65 \
 //y=4.835 //x2=1.545 //y2=4.88
cc_798 ( N_CLK_c_729_n N_noxref_7_c_2340_n ) capacitor c=0.00113666f //x=2.655 \
 //y=4.88 //x2=1.545 //y2=4.88
cc_799 ( N_CLK_c_743_n N_noxref_7_c_2340_n ) capacitor c=0.00123917f //x=2.655 \
 //y=4.88 //x2=1.545 //y2=4.88
cc_800 ( N_CLK_c_756_n N_noxref_7_c_2343_n ) capacitor c=0.00169377f //x=15.6 \
 //y=4.695 //x2=15.795 //y2=5.56
cc_801 ( N_CLK_M34_noxref_g N_noxref_7_c_2343_n ) capacitor c=0.0179041f \
 //x=15.575 //y=6.2 //x2=15.795 //y2=5.56
cc_802 ( N_CLK_M35_noxref_g N_noxref_7_c_2343_n ) capacitor c=0.0179041f \
 //x=16.015 //y=6.2 //x2=15.795 //y2=5.56
cc_803 ( N_CLK_c_858_p N_noxref_7_c_2343_n ) capacitor c=0.00293647f //x=15.94 \
 //y=4.97 //x2=15.795 //y2=5.56
cc_804 ( N_CLK_M18_noxref_g N_noxref_7_M16_noxref_g ) capacitor c=0.0106276f \
 //x=2.625 //y=6.2 //x2=1.745 //y2=6.2
cc_805 ( N_CLK_M18_noxref_g N_noxref_7_M17_noxref_g ) capacitor c=0.107144f \
 //x=2.625 //y=6.2 //x2=2.185 //y2=6.2
cc_806 ( N_CLK_M19_noxref_g N_noxref_7_M17_noxref_g ) capacitor c=0.0101598f \
 //x=3.065 //y=6.2 //x2=2.185 //y2=6.2
cc_807 ( N_CLK_c_917_p N_noxref_7_c_2350_n ) capacitor c=5.72528e-19 //x=2.22 \
 //y=1.09 //x2=1.245 //y2=1.055
cc_808 ( N_CLK_c_917_p N_noxref_7_c_2351_n ) capacitor c=0.00150277f //x=2.22 \
 //y=1.09 //x2=1.245 //y2=1.4
cc_809 ( N_CLK_c_919_p N_noxref_7_c_2352_n ) capacitor c=0.00111227f //x=2.22 \
 //y=1.4 //x2=1.245 //y2=1.71
cc_810 ( N_CLK_c_710_n N_noxref_7_c_2353_n ) capacitor c=0.00147006f //x=2.655 \
 //y=2.375 //x2=1.245 //y2=2.095
cc_811 ( N_CLK_c_725_n N_noxref_7_c_2353_n ) capacitor c=0.00214573f //x=2.655 \
 //y=2.26 //x2=1.245 //y2=2.095
cc_812 ( N_CLK_c_738_n N_noxref_7_c_2353_n ) capacitor c=0.00964411f //x=2.745 \
 //y=2.095 //x2=1.245 //y2=2.095
cc_813 ( N_CLK_c_917_p N_noxref_7_c_2356_n ) capacitor c=0.0160123f //x=2.22 \
 //y=1.09 //x2=1.775 //y2=1.055
cc_814 ( N_CLK_c_735_n N_noxref_7_c_2356_n ) capacitor c=9.19165e-19 //x=2.745 \
 //y=1.09 //x2=1.775 //y2=1.055
cc_815 ( N_CLK_c_919_p N_noxref_7_c_2358_n ) capacitor c=0.0124075f //x=2.22 \
 //y=1.4 //x2=1.775 //y2=1.4
cc_816 ( N_CLK_c_736_n N_noxref_7_c_2358_n ) capacitor c=0.0010154f //x=2.745 \
 //y=1.4 //x2=1.775 //y2=1.4
cc_817 ( N_CLK_c_737_n N_noxref_7_c_2358_n ) capacitor c=9.23422e-19 //x=2.745 \
 //y=1.63 //x2=1.775 //y2=1.4
cc_818 ( N_CLK_c_713_n N_noxref_7_c_2361_n ) capacitor c=7.15803e-19 //x=2.65 \
 //y=4.835 //x2=2.11 //y2=4.97
cc_819 ( N_CLK_c_729_n N_noxref_7_c_2361_n ) capacitor c=0.00116563f //x=2.655 \
 //y=4.88 //x2=2.11 //y2=4.97
cc_820 ( N_CLK_c_743_n N_noxref_7_c_2361_n ) capacitor c=0.0169508f //x=2.655 \
 //y=4.88 //x2=2.11 //y2=4.97
cc_821 ( N_CLK_c_713_n N_noxref_7_c_2364_n ) capacitor c=8.67242e-19 //x=2.65 \
 //y=4.835 //x2=1.82 //y2=4.97
cc_822 ( N_CLK_c_729_n N_noxref_7_c_2364_n ) capacitor c=0.0012974f //x=2.655 \
 //y=4.88 //x2=1.82 //y2=4.97
cc_823 ( N_CLK_c_743_n N_noxref_7_c_2364_n ) capacitor c=0.00406071f //x=2.655 \
 //y=4.88 //x2=1.82 //y2=4.97
cc_824 ( N_CLK_M18_noxref_g N_VDD_c_3152_n ) capacitor c=0.00705252f //x=2.625 \
 //y=6.2 //x2=3.2 //y2=7.585
cc_825 ( N_CLK_M19_noxref_g N_VDD_c_3152_n ) capacitor c=0.00755544f //x=3.065 \
 //y=6.2 //x2=3.2 //y2=7.585
cc_826 ( N_CLK_M34_noxref_g N_VDD_c_3154_n ) capacitor c=0.00705252f \
 //x=15.575 //y=6.2 //x2=16.15 //y2=7.585
cc_827 ( N_CLK_M35_noxref_g N_VDD_c_3154_n ) capacitor c=0.00755544f \
 //x=16.015 //y=6.2 //x2=16.15 //y2=7.585
cc_828 ( N_CLK_c_716_n N_VDD_c_3073_n ) capacitor c=0.0263783f //x=11.525 \
 //y=4.62 //x2=5.245 //y2=7.585
cc_829 ( N_CLK_c_716_n N_VDD_c_3077_n ) capacitor c=0.0264951f //x=11.525 \
 //y=4.62 //x2=10.055 //y2=7.585
cc_830 ( N_CLK_c_762_n N_VDD_c_3124_n ) capacitor c=0.026267f //x=12.125 \
 //y=4.635 //x2=13.385 //y2=7.585
cc_831 ( N_CLK_M18_noxref_g N_VDD_M17_noxref_d ) capacitor c=0.015318f \
 //x=2.625 //y=6.2 //x2=2.26 //y2=5.2
cc_832 ( N_CLK_M19_noxref_g N_VDD_M19_noxref_d ) capacitor c=0.015318f \
 //x=3.065 //y=6.2 //x2=3.14 //y2=5.2
cc_833 ( N_CLK_c_716_n N_VDD_M22_noxref_s ) capacitor c=7.08158e-19 //x=11.525 \
 //y=4.62 //x2=6.2 //y2=5.2
cc_834 ( N_CLK_c_716_n N_VDD_M28_noxref_s ) capacitor c=0.00765173f //x=11.525 \
 //y=4.62 //x2=10.71 //y2=5.2
cc_835 ( N_CLK_c_762_n N_VDD_M32_noxref_s ) capacitor c=7.80611e-19 //x=12.125 \
 //y=4.635 //x2=14.34 //y2=5.2
cc_836 ( N_CLK_M34_noxref_g N_VDD_M33_noxref_d ) capacitor c=0.015318f \
 //x=15.575 //y=6.2 //x2=15.21 //y2=5.2
cc_837 ( N_CLK_M35_noxref_g N_VDD_M35_noxref_d ) capacitor c=0.015318f \
 //x=16.015 //y=6.2 //x2=16.09 //y2=5.2
cc_838 ( N_CLK_c_735_n N_noxref_10_c_3450_n ) capacitor c=0.00123426f \
 //x=2.745 //y=1.09 //x2=3.45 //y2=1.175
cc_839 ( N_CLK_c_736_n N_noxref_10_c_3450_n ) capacitor c=0.0129288f //x=2.745 \
 //y=1.4 //x2=3.45 //y2=1.175
cc_840 ( N_CLK_c_737_n N_noxref_10_c_3450_n ) capacitor c=0.00132209f \
 //x=2.745 //y=1.63 //x2=3.45 //y2=1.175
cc_841 ( N_CLK_c_710_n N_noxref_10_M1_noxref_d ) capacitor c=0.00610652f \
 //x=2.655 //y=2.375 //x2=2.295 //y2=1.09
cc_842 ( N_CLK_c_725_n N_noxref_10_M1_noxref_d ) capacitor c=2.2052e-19 \
 //x=2.655 //y=2.26 //x2=2.295 //y2=1.09
cc_843 ( N_CLK_c_917_p N_noxref_10_M1_noxref_d ) capacitor c=0.00253592f \
 //x=2.22 //y=1.09 //x2=2.295 //y2=1.09
cc_844 ( N_CLK_c_919_p N_noxref_10_M1_noxref_d ) capacitor c=0.00604634f \
 //x=2.22 //y=1.4 //x2=2.295 //y2=1.09
cc_845 ( N_CLK_c_955_p N_noxref_10_M1_noxref_d ) capacitor c=0.002686f \
 //x=2.59 //y=0.935 //x2=2.295 //y2=1.09
cc_846 ( N_CLK_c_956_p N_noxref_10_M1_noxref_d ) capacitor c=0.00251995f \
 //x=2.59 //y=1.555 //x2=2.295 //y2=1.09
cc_847 ( N_CLK_c_735_n N_noxref_10_M1_noxref_d ) capacitor c=0.00314523f \
 //x=2.745 //y=1.09 //x2=2.295 //y2=1.09
cc_848 ( N_CLK_c_736_n N_noxref_10_M1_noxref_d ) capacitor c=0.00168289f \
 //x=2.745 //y=1.4 //x2=2.295 //y2=1.09
cc_849 ( N_CLK_c_737_n N_noxref_10_M1_noxref_d ) capacitor c=0.00111165f \
 //x=2.745 //y=1.63 //x2=2.295 //y2=1.09
cc_850 ( N_CLK_c_735_n N_noxref_10_M2_noxref_s ) capacitor c=7.21316e-19 \
 //x=2.745 //y=1.09 //x2=3.4 //y2=0.555
cc_851 ( N_CLK_c_736_n N_noxref_10_M2_noxref_s ) capacitor c=0.00365271f \
 //x=2.745 //y=1.4 //x2=3.4 //y2=0.555
cc_852 ( N_CLK_c_738_n N_noxref_10_M2_noxref_s ) capacitor c=9.86711e-19 \
 //x=2.745 //y=2.095 //x2=3.4 //y2=0.555
cc_853 ( N_CLK_c_716_n D ) capacitor c=0.0260794f //x=11.525 //y=4.62 \
 //x2=7.465 //y2=2.77
cc_854 ( N_CLK_c_716_n N_D_c_3575_n ) capacitor c=0.00410366f //x=11.525 \
 //y=4.62 //x2=7.465 //y2=4.765
cc_855 ( N_CLK_c_781_n N_noxref_13_c_3695_n ) capacitor c=0.00123426f \
 //x=15.695 //y=1.09 //x2=16.4 //y2=1.175
cc_856 ( N_CLK_c_782_n N_noxref_13_c_3695_n ) capacitor c=0.0129288f \
 //x=15.695 //y=1.4 //x2=16.4 //y2=1.175
cc_857 ( N_CLK_c_783_n N_noxref_13_c_3695_n ) capacitor c=0.00132209f \
 //x=15.695 //y=1.63 //x2=16.4 //y2=1.175
cc_858 ( N_CLK_c_753_n N_noxref_13_M9_noxref_d ) capacitor c=0.00600656f \
 //x=15.605 //y=2.375 //x2=15.245 //y2=1.09
cc_859 ( N_CLK_c_765_n N_noxref_13_M9_noxref_d ) capacitor c=2.2052e-19 \
 //x=15.605 //y=2.26 //x2=15.245 //y2=1.09
cc_860 ( N_CLK_c_776_n N_noxref_13_M9_noxref_d ) capacitor c=0.00253592f \
 //x=15.17 //y=1.09 //x2=15.245 //y2=1.09
cc_861 ( N_CLK_c_779_n N_noxref_13_M9_noxref_d ) capacitor c=0.00604066f \
 //x=15.17 //y=1.4 //x2=15.245 //y2=1.09
cc_862 ( N_CLK_c_972_p N_noxref_13_M9_noxref_d ) capacitor c=0.002686f \
 //x=15.54 //y=0.935 //x2=15.245 //y2=1.09
cc_863 ( N_CLK_c_973_p N_noxref_13_M9_noxref_d ) capacitor c=0.00251995f \
 //x=15.54 //y=1.555 //x2=15.245 //y2=1.09
cc_864 ( N_CLK_c_781_n N_noxref_13_M9_noxref_d ) capacitor c=0.00314523f \
 //x=15.695 //y=1.09 //x2=15.245 //y2=1.09
cc_865 ( N_CLK_c_782_n N_noxref_13_M9_noxref_d ) capacitor c=0.00168289f \
 //x=15.695 //y=1.4 //x2=15.245 //y2=1.09
cc_866 ( N_CLK_c_783_n N_noxref_13_M9_noxref_d ) capacitor c=0.00111165f \
 //x=15.695 //y=1.63 //x2=15.245 //y2=1.09
cc_867 ( N_CLK_c_781_n N_noxref_13_M10_noxref_s ) capacitor c=7.21316e-19 \
 //x=15.695 //y=1.09 //x2=16.35 //y2=0.555
cc_868 ( N_CLK_c_782_n N_noxref_13_M10_noxref_s ) capacitor c=0.00365271f \
 //x=15.695 //y=1.4 //x2=16.35 //y2=0.555
cc_869 ( N_CLK_c_784_n N_noxref_13_M10_noxref_s ) capacitor c=9.86711e-19 \
 //x=15.695 //y=2.095 //x2=16.35 //y2=0.555
cc_870 ( N_CLK_c_710_n N_GND_c_3830_n ) capacitor c=9.16602e-19 //x=2.655 \
 //y=2.375 //x2=6.235 //y2=0.175
cc_871 ( N_CLK_c_753_n N_GND_c_3913_n ) capacitor c=7.99941e-19 //x=15.605 \
 //y=2.375 //x2=19.185 //y2=0.175
cc_872 ( N_CLK_c_917_p N_noxref_16_c_4289_n ) capacitor c=0.0167228f //x=2.22 \
 //y=1.09 //x2=2.88 //y2=0.72
cc_873 ( N_CLK_c_735_n N_noxref_16_c_4289_n ) capacitor c=0.00534519f \
 //x=2.745 //y=1.09 //x2=2.88 //y2=0.72
cc_874 ( N_CLK_c_710_n N_noxref_16_c_4291_n ) capacitor c=0.00481455f \
 //x=2.655 //y=2.375 //x2=2.88 //y2=1.77
cc_875 ( N_CLK_c_713_n N_noxref_16_c_4291_n ) capacitor c=8.72493e-19 //x=2.65 \
 //y=4.835 //x2=2.88 //y2=1.77
cc_876 ( N_CLK_c_725_n N_noxref_16_c_4291_n ) capacitor c=0.0105652f //x=2.655 \
 //y=2.26 //x2=2.88 //y2=1.77
cc_877 ( N_CLK_c_919_p N_noxref_16_c_4291_n ) capacitor c=0.0153476f //x=2.22 \
 //y=1.4 //x2=2.88 //y2=1.77
cc_878 ( N_CLK_c_738_n N_noxref_16_c_4291_n ) capacitor c=0.020563f //x=2.745 \
 //y=2.095 //x2=2.88 //y2=1.77
cc_879 ( N_CLK_c_917_p N_noxref_16_M0_noxref_s ) capacitor c=0.00798959f \
 //x=2.22 //y=1.09 //x2=0.89 //y2=0.555
cc_880 ( N_CLK_c_737_n N_noxref_16_M0_noxref_s ) capacitor c=0.00212176f \
 //x=2.745 //y=1.63 //x2=0.89 //y2=0.555
cc_881 ( N_CLK_c_738_n N_noxref_16_M0_noxref_s ) capacitor c=0.00298115f \
 //x=2.745 //y=2.095 //x2=0.89 //y2=0.555
cc_882 ( N_CLK_c_776_n N_noxref_19_c_4479_n ) capacitor c=0.0167228f //x=15.17 \
 //y=1.09 //x2=15.83 //y2=0.72
cc_883 ( N_CLK_c_781_n N_noxref_19_c_4479_n ) capacitor c=0.00534519f \
 //x=15.695 //y=1.09 //x2=15.83 //y2=0.72
cc_884 ( N_CLK_c_753_n N_noxref_19_c_4481_n ) capacitor c=0.0048147f \
 //x=15.605 //y=2.375 //x2=15.83 //y2=1.77
cc_885 ( N_CLK_c_756_n N_noxref_19_c_4481_n ) capacitor c=9.0414e-19 //x=15.6 \
 //y=4.695 //x2=15.83 //y2=1.77
cc_886 ( N_CLK_c_765_n N_noxref_19_c_4481_n ) capacitor c=0.0105652f \
 //x=15.605 //y=2.26 //x2=15.83 //y2=1.77
cc_887 ( N_CLK_c_779_n N_noxref_19_c_4481_n ) capacitor c=0.0153476f //x=15.17 \
 //y=1.4 //x2=15.83 //y2=1.77
cc_888 ( N_CLK_c_784_n N_noxref_19_c_4481_n ) capacitor c=0.0216832f \
 //x=15.695 //y=2.095 //x2=15.83 //y2=1.77
cc_889 ( N_CLK_c_776_n N_noxref_19_M8_noxref_s ) capacitor c=0.00798959f \
 //x=15.17 //y=1.09 //x2=13.84 //y2=0.555
cc_890 ( N_CLK_c_783_n N_noxref_19_M8_noxref_s ) capacitor c=0.00212176f \
 //x=15.695 //y=1.63 //x2=13.84 //y2=0.555
cc_891 ( N_CLK_c_784_n N_noxref_19_M8_noxref_s ) capacitor c=0.00298115f \
 //x=15.695 //y=2.095 //x2=13.84 //y2=0.555
cc_892 ( N_noxref_4_c_1046_n RN ) capacitor c=0.00171698f //x=6.355 //y=3.72 \
 //x2=8.575 //y2=2.77
cc_893 ( N_noxref_4_c_1051_n RN ) capacitor c=5.77971e-19 //x=6.355 //y=4.755 \
 //x2=8.575 //y2=2.77
cc_894 ( N_noxref_4_c_1061_n RN ) capacitor c=0.0223923f //x=9.19 //y=3.895 \
 //x2=8.575 //y2=2.77
cc_895 ( N_noxref_4_c_1139_p RN ) capacitor c=0.00228471f //x=19.305 //y=3.72 \
 //x2=16.715 //y2=2.77
cc_896 ( N_noxref_4_c_1140_p RN ) capacitor c=0.00162605f //x=19.305 //y=4.755 \
 //x2=16.715 //y2=2.77
cc_897 ( N_noxref_4_c_1131_n RN ) capacitor c=0.0275351f //x=17.075 //y=3.88 \
 //x2=16.715 //y2=2.77
cc_898 ( N_noxref_4_c_1139_p RN ) capacitor c=0.038022f //x=19.305 //y=3.72 \
 //x2=20.415 //y2=2.77
cc_899 ( N_noxref_4_c_1143_p RN ) capacitor c=0.00763467f //x=19.305 //y=4.04 \
 //x2=20.415 //y2=2.77
cc_900 ( N_noxref_4_c_1140_p RN ) capacitor c=0.0186993f //x=19.305 //y=4.755 \
 //x2=20.415 //y2=2.77
cc_901 ( N_noxref_4_c_1145_p RN ) capacitor c=2.61099e-19 //x=19.295 //y=3.88 \
 //x2=20.415 //y2=2.77
cc_902 ( N_noxref_4_c_1146_p RN ) capacitor c=0.00319795f //x=17.675 //y=3.87 \
 //x2=20.415 //y2=2.77
cc_903 ( N_noxref_4_c_1147_p RN ) capacitor c=3.36194e-19 //x=19.305 //y=4.88 \
 //x2=20.415 //y2=2.77
cc_904 ( N_noxref_4_c_1148_p N_RN_c_1589_n ) capacitor c=0.00798977f \
 //x=19.305 //y=2.375 //x2=20.415 //y2=2.515
cc_905 ( N_noxref_4_c_1139_p N_RN_c_1589_n ) capacitor c=0.00291253f \
 //x=19.305 //y=3.72 //x2=20.415 //y2=2.515
cc_906 ( N_noxref_4_c_1150_p N_RN_c_1589_n ) capacitor c=0.00120311f \
 //x=19.305 //y=2.26 //x2=20.415 //y2=2.515
cc_907 ( N_noxref_4_c_1151_p N_RN_c_1589_n ) capacitor c=0.00159161f \
 //x=19.005 //y=2.095 //x2=20.415 //y2=2.515
cc_908 ( N_noxref_4_c_1140_p N_RN_c_1593_n ) capacitor c=0.0110307f //x=19.305 \
 //y=4.755 //x2=20.415 //y2=4.765
cc_909 ( N_noxref_4_c_1147_p N_RN_c_1593_n ) capacitor c=2.89813e-19 \
 //x=19.305 //y=4.88 //x2=20.415 //y2=4.765
cc_910 ( N_noxref_4_c_1154_p N_RN_c_1593_n ) capacitor c=7.66769e-19 //x=19.87 \
 //y=4.97 //x2=20.415 //y2=4.765
cc_911 ( N_noxref_4_c_1155_p N_RN_c_1593_n ) capacitor c=7.54501e-19 //x=19.58 \
 //y=4.97 //x2=20.415 //y2=4.765
cc_912 ( N_noxref_4_c_1061_n N_RN_c_1480_n ) capacitor c=0.00209163f //x=9.19 \
 //y=3.895 //x2=8.58 //y2=2.305
cc_913 ( N_noxref_4_c_1058_n N_RN_c_1483_n ) capacitor c=0.00490563f //x=9.535 \
 //y=3.895 //x2=16.56 //y2=2.315
cc_914 ( N_noxref_4_c_1061_n N_RN_c_1483_n ) capacitor c=0.00247263f //x=9.19 \
 //y=3.895 //x2=16.56 //y2=2.315
cc_915 ( N_noxref_4_c_1065_n N_RN_c_1483_n ) capacitor c=0.00531507f //x=10.78 \
 //y=3.88 //x2=16.56 //y2=2.315
cc_916 ( N_noxref_4_c_1069_n N_RN_c_1483_n ) capacitor c=0.0176635f //x=11.38 \
 //y=3.895 //x2=16.56 //y2=2.315
cc_917 ( N_noxref_4_c_1091_n N_RN_c_1483_n ) capacitor c=0.00876106f \
 //x=12.125 //y=3.865 //x2=16.56 //y2=2.315
cc_918 ( N_noxref_4_c_1094_n N_RN_c_1483_n ) capacitor c=0.0052345f //x=12.86 \
 //y=3.9 //x2=16.56 //y2=2.315
cc_919 ( N_noxref_4_c_1097_n N_RN_c_1483_n ) capacitor c=0.00531174f \
 //x=14.115 //y=3.88 //x2=16.56 //y2=2.315
cc_920 ( N_noxref_4_c_1101_n N_RN_c_1483_n ) capacitor c=0.0278905f //x=14.715 \
 //y=3.9 //x2=16.56 //y2=2.315
cc_921 ( N_noxref_4_c_1131_n N_RN_c_1557_n ) capacitor c=0.0278905f //x=17.075 \
 //y=3.88 //x2=16.88 //y2=2.315
cc_922 ( N_noxref_4_c_1148_p N_RN_c_1607_n ) capacitor c=0.00279365f \
 //x=19.305 //y=2.375 //x2=20.37 //y2=2.355
cc_923 ( N_noxref_4_c_1139_p N_RN_c_1607_n ) capacitor c=5.00559e-19 \
 //x=19.305 //y=3.72 //x2=20.37 //y2=2.355
cc_924 ( N_noxref_4_c_1148_p N_RN_c_1609_n ) capacitor c=0.0168121f //x=19.305 \
 //y=2.375 //x2=20.21 //y2=2.355
cc_925 ( N_noxref_4_c_1139_p N_RN_c_1609_n ) capacitor c=0.019227f //x=19.305 \
 //y=3.72 //x2=20.21 //y2=2.355
cc_926 ( N_noxref_4_c_1143_p N_RN_c_1609_n ) capacitor c=0.00255185f \
 //x=19.305 //y=4.04 //x2=20.21 //y2=2.355
cc_927 ( N_noxref_4_c_1131_n N_RN_c_1609_n ) capacitor c=0.0139471f //x=17.075 \
 //y=3.88 //x2=20.21 //y2=2.355
cc_928 ( N_noxref_4_c_1146_p N_RN_c_1609_n ) capacitor c=0.0389454f //x=17.675 \
 //y=3.87 //x2=20.21 //y2=2.355
cc_929 ( N_noxref_4_c_1150_p N_RN_c_1609_n ) capacitor c=2.54369e-19 \
 //x=19.305 //y=2.26 //x2=20.21 //y2=2.355
cc_930 ( N_noxref_4_c_1148_p N_RN_c_1615_n ) capacitor c=5.39999e-19 \
 //x=19.305 //y=2.375 //x2=20.415 //y2=2.26
cc_931 ( N_noxref_4_c_1150_p N_RN_c_1615_n ) capacitor c=0.00124896f \
 //x=19.305 //y=2.26 //x2=20.415 //y2=2.26
cc_932 ( N_noxref_4_c_1151_p N_RN_c_1615_n ) capacitor c=0.00214501f \
 //x=19.005 //y=2.095 //x2=20.415 //y2=2.26
cc_933 ( N_noxref_4_c_1140_p N_RN_c_1618_n ) capacitor c=0.00103399f \
 //x=19.305 //y=4.755 //x2=20.415 //y2=4.88
cc_934 ( N_noxref_4_c_1147_p N_RN_c_1618_n ) capacitor c=0.00113984f \
 //x=19.305 //y=4.88 //x2=20.415 //y2=4.88
cc_935 ( N_noxref_4_c_1154_p N_RN_c_1618_n ) capacitor c=0.00116563f //x=19.87 \
 //y=4.97 //x2=20.415 //y2=4.88
cc_936 ( N_noxref_4_c_1155_p N_RN_c_1618_n ) capacitor c=0.00129812f //x=19.58 \
 //y=4.97 //x2=20.415 //y2=4.88
cc_937 ( N_noxref_4_M38_noxref_g N_RN_M40_noxref_g ) capacitor c=0.0106276f \
 //x=19.505 //y=6.2 //x2=20.385 //y2=6.2
cc_938 ( N_noxref_4_M39_noxref_g N_RN_M40_noxref_g ) capacitor c=0.107144f \
 //x=19.945 //y=6.2 //x2=20.385 //y2=6.2
cc_939 ( N_noxref_4_M39_noxref_g N_RN_M41_noxref_g ) capacitor c=0.0101598f \
 //x=19.945 //y=6.2 //x2=20.825 //y2=6.2
cc_940 ( N_noxref_4_c_1184_p N_RN_c_1625_n ) capacitor c=5.72528e-19 \
 //x=19.005 //y=1.055 //x2=19.98 //y2=1.09
cc_941 ( N_noxref_4_c_1185_p N_RN_c_1625_n ) capacitor c=0.00150277f \
 //x=19.005 //y=1.4 //x2=19.98 //y2=1.09
cc_942 ( N_noxref_4_c_1186_p N_RN_c_1625_n ) capacitor c=0.0160123f //x=19.535 \
 //y=1.055 //x2=19.98 //y2=1.09
cc_943 ( N_noxref_4_c_1187_p N_RN_c_1628_n ) capacitor c=0.00111227f \
 //x=19.005 //y=1.71 //x2=19.98 //y2=1.4
cc_944 ( N_noxref_4_c_1188_p N_RN_c_1628_n ) capacitor c=0.0124075f //x=19.535 \
 //y=1.4 //x2=19.98 //y2=1.4
cc_945 ( N_noxref_4_c_1186_p N_RN_c_1630_n ) capacitor c=9.19165e-19 \
 //x=19.535 //y=1.055 //x2=20.505 //y2=1.09
cc_946 ( N_noxref_4_c_1188_p N_RN_c_1631_n ) capacitor c=0.0010154f //x=19.535 \
 //y=1.4 //x2=20.505 //y2=1.4
cc_947 ( N_noxref_4_c_1188_p N_RN_c_1632_n ) capacitor c=9.23422e-19 \
 //x=19.535 //y=1.4 //x2=20.505 //y2=1.63
cc_948 ( N_noxref_4_c_1148_p N_RN_c_1633_n ) capacitor c=3.54695e-19 \
 //x=19.305 //y=2.375 //x2=20.505 //y2=2.095
cc_949 ( N_noxref_4_c_1150_p N_RN_c_1633_n ) capacitor c=0.00166305f \
 //x=19.305 //y=2.26 //x2=20.505 //y2=2.095
cc_950 ( N_noxref_4_c_1151_p N_RN_c_1633_n ) capacitor c=0.00868554f \
 //x=19.005 //y=2.095 //x2=20.505 //y2=2.095
cc_951 ( N_noxref_4_c_1140_p N_RN_c_1636_n ) capacitor c=0.00116212f \
 //x=19.305 //y=4.755 //x2=20.415 //y2=4.88
cc_952 ( N_noxref_4_c_1147_p N_RN_c_1636_n ) capacitor c=0.00155973f \
 //x=19.305 //y=4.88 //x2=20.415 //y2=4.88
cc_953 ( N_noxref_4_c_1154_p N_RN_c_1636_n ) capacitor c=0.0171374f //x=19.87 \
 //y=4.97 //x2=20.415 //y2=4.88
cc_954 ( N_noxref_4_c_1155_p N_RN_c_1636_n ) capacitor c=0.00484466f //x=19.58 \
 //y=4.97 //x2=20.415 //y2=4.88
cc_955 ( N_noxref_4_M39_noxref_g N_noxref_6_c_1895_n ) capacitor c=0.00973141f \
 //x=19.945 //y=6.2 //x2=20.485 //y2=5.335
cc_956 ( N_noxref_4_M38_noxref_g N_noxref_6_c_1896_n ) capacitor c=0.00461408f \
 //x=19.505 //y=6.2 //x2=19.727 //y2=5.335
cc_957 ( N_noxref_4_M39_noxref_g N_noxref_6_c_1896_n ) capacitor c=0.00229208f \
 //x=19.945 //y=6.2 //x2=19.727 //y2=5.335
cc_958 ( N_noxref_4_c_1154_p N_noxref_6_c_1896_n ) capacitor c=0.00171885f \
 //x=19.87 //y=4.97 //x2=19.727 //y2=5.335
cc_959 ( N_noxref_4_M38_noxref_g N_noxref_6_c_1899_n ) capacitor c=0.0162284f \
 //x=19.505 //y=6.2 //x2=19.725 //y2=5.56
cc_960 ( N_noxref_4_M39_noxref_g N_noxref_6_c_1899_n ) capacitor c=0.0179041f \
 //x=19.945 //y=6.2 //x2=19.725 //y2=5.56
cc_961 ( N_noxref_4_c_1154_p N_noxref_6_c_1899_n ) capacitor c=0.00291477f \
 //x=19.87 //y=4.97 //x2=19.725 //y2=5.56
cc_962 ( N_noxref_4_c_1069_n N_noxref_7_c_2174_n ) capacitor c=6.09845e-19 \
 //x=11.38 //y=3.895 //x2=11.905 //y2=4.09
cc_963 ( N_noxref_4_c_1091_n N_noxref_7_c_2174_n ) capacitor c=0.0256314f \
 //x=12.125 //y=3.865 //x2=11.905 //y2=4.09
cc_964 ( N_noxref_4_c_1069_n N_noxref_7_c_2182_n ) capacitor c=0.00217342f \
 //x=11.38 //y=3.895 //x2=11.905 //y2=4.41
cc_965 ( N_noxref_4_c_1091_n N_noxref_7_c_2182_n ) capacitor c=0.00450608f \
 //x=12.125 //y=3.865 //x2=11.905 //y2=4.41
cc_966 ( N_noxref_4_c_1148_p N_noxref_7_c_2314_n ) capacitor c=0.00357748f \
 //x=19.305 //y=2.375 //x2=17.455 //y2=4.095
cc_967 ( N_noxref_4_c_1139_p N_noxref_7_c_2314_n ) capacitor c=0.0234717f \
 //x=19.305 //y=3.72 //x2=17.455 //y2=4.095
cc_968 ( N_noxref_4_c_1143_p N_noxref_7_c_2314_n ) capacitor c=0.00257738f \
 //x=19.305 //y=4.04 //x2=17.455 //y2=4.095
cc_969 ( N_noxref_4_c_1140_p N_noxref_7_c_2314_n ) capacitor c=9.84588e-19 \
 //x=19.305 //y=4.755 //x2=17.455 //y2=4.095
cc_970 ( N_noxref_4_c_1131_n N_noxref_7_c_2314_n ) capacitor c=2.09913e-19 \
 //x=17.075 //y=3.88 //x2=17.455 //y2=4.095
cc_971 ( N_noxref_4_c_1146_p N_noxref_7_c_2314_n ) capacitor c=0.0293173f \
 //x=17.675 //y=3.87 //x2=17.455 //y2=4.095
cc_972 ( N_noxref_4_c_1140_p N_noxref_7_c_2377_n ) capacitor c=0.00237452f \
 //x=19.305 //y=4.755 //x2=17.455 //y2=4.415
cc_973 ( N_noxref_4_c_1131_n N_noxref_7_c_2377_n ) capacitor c=0.0018855f \
 //x=17.075 //y=3.88 //x2=17.455 //y2=4.415
cc_974 ( N_noxref_4_c_1146_p N_noxref_7_c_2377_n ) capacitor c=0.00583578f \
 //x=17.675 //y=3.87 //x2=17.455 //y2=4.415
cc_975 ( N_noxref_4_c_1140_p N_noxref_7_c_2315_n ) capacitor c=0.00982178f \
 //x=19.305 //y=4.755 //x2=17.455 //y2=5.25
cc_976 ( N_noxref_4_c_1040_n N_noxref_7_c_2192_n ) capacitor c=0.00118691f \
 //x=4.505 //y=4.045 //x2=4.12 //y2=4.25
cc_977 ( N_noxref_4_c_1042_n N_noxref_7_c_2192_n ) capacitor c=4.26819e-19 \
 //x=4.505 //y=5.25 //x2=4.12 //y2=4.25
cc_978 ( N_noxref_4_c_1222_p N_noxref_7_c_2192_n ) capacitor c=0.0219438f \
 //x=1.967 //y=5.335 //x2=4.12 //y2=4.25
cc_979 ( N_noxref_4_c_1071_n N_noxref_7_c_2192_n ) capacitor c=0.0358254f \
 //x=4.67 //y=3.885 //x2=4.12 //y2=4.25
cc_980 ( N_noxref_4_c_1040_n N_noxref_7_c_2196_n ) capacitor c=0.00757286f \
 //x=4.505 //y=4.045 //x2=4.76 //y2=4.27
cc_981 ( N_noxref_4_c_1042_n N_noxref_7_c_2196_n ) capacitor c=0.022593f \
 //x=4.505 //y=5.25 //x2=4.76 //y2=4.27
cc_982 ( N_noxref_4_c_1056_n N_noxref_7_c_2196_n ) capacitor c=0.128481f \
 //x=6.2 //y=3.88 //x2=4.76 //y2=4.27
cc_983 ( N_noxref_4_c_1050_n N_noxref_7_c_2197_n ) capacitor c=0.00133789f \
 //x=6.355 //y=4.04 //x2=5.975 //y2=4.25
cc_984 ( N_noxref_4_c_1051_n N_noxref_7_c_2197_n ) capacitor c=5.06484e-19 \
 //x=6.355 //y=4.755 //x2=5.975 //y2=4.25
cc_985 ( N_noxref_4_c_1056_n N_noxref_7_c_2197_n ) capacitor c=0.012414f \
 //x=6.2 //y=3.88 //x2=5.975 //y2=4.25
cc_986 ( N_noxref_4_c_1061_n N_noxref_7_c_2197_n ) capacitor c=0.0358254f \
 //x=9.19 //y=3.895 //x2=5.975 //y2=4.25
cc_987 ( N_noxref_4_c_1050_n N_noxref_7_c_2198_n ) capacitor c=0.00678219f \
 //x=6.355 //y=4.04 //x2=6.575 //y2=4.265
cc_988 ( N_noxref_4_c_1051_n N_noxref_7_c_2198_n ) capacitor c=0.0235427f \
 //x=6.355 //y=4.755 //x2=6.575 //y2=4.265
cc_989 ( N_noxref_4_c_1061_n N_noxref_7_c_2198_n ) capacitor c=0.0110198f \
 //x=9.19 //y=3.895 //x2=6.575 //y2=4.265
cc_990 ( N_noxref_4_c_1091_n N_noxref_7_c_2251_n ) capacitor c=0.0821257f \
 //x=12.125 //y=3.865 //x2=17.3 //y2=4.25
cc_991 ( N_noxref_4_c_1094_n N_noxref_7_c_2251_n ) capacitor c=0.112836f \
 //x=12.86 //y=3.9 //x2=17.3 //y2=4.25
cc_992 ( N_noxref_4_c_1097_n N_noxref_7_c_2251_n ) capacitor c=0.0588821f \
 //x=14.115 //y=3.88 //x2=17.3 //y2=4.25
cc_993 ( N_noxref_4_c_1101_n N_noxref_7_c_2251_n ) capacitor c=0.210146f \
 //x=14.715 //y=3.9 //x2=17.3 //y2=4.25
cc_994 ( N_noxref_4_c_1131_n N_noxref_7_c_2251_n ) capacitor c=0.0114505f \
 //x=17.075 //y=3.88 //x2=17.3 //y2=4.25
cc_995 ( N_noxref_4_c_1051_n N_noxref_7_c_2199_n ) capacitor c=3.74821e-19 \
 //x=6.355 //y=4.755 //x2=12.07 //y2=4.25
cc_996 ( N_noxref_4_c_1058_n N_noxref_7_c_2199_n ) capacitor c=0.111435f \
 //x=9.535 //y=3.895 //x2=12.07 //y2=4.25
cc_997 ( N_noxref_4_c_1061_n N_noxref_7_c_2199_n ) capacitor c=0.262244f \
 //x=9.19 //y=3.895 //x2=12.07 //y2=4.25
cc_998 ( N_noxref_4_c_1065_n N_noxref_7_c_2199_n ) capacitor c=0.0568414f \
 //x=10.78 //y=3.88 //x2=12.07 //y2=4.25
cc_999 ( N_noxref_4_c_1069_n N_noxref_7_c_2199_n ) capacitor c=0.0235968f \
 //x=11.38 //y=3.895 //x2=12.07 //y2=4.25
cc_1000 ( N_noxref_4_c_1091_n N_noxref_7_c_2199_n ) capacitor c=0.0358686f \
 //x=12.125 //y=3.865 //x2=12.07 //y2=4.25
cc_1001 ( N_noxref_4_c_1143_p N_noxref_7_c_2406_n ) capacitor c=0.00296224f \
 //x=19.305 //y=4.04 //x2=19.51 //y2=4.265
cc_1002 ( N_noxref_4_c_1140_p N_noxref_7_c_2406_n ) capacitor c=0.0305692f \
 //x=19.305 //y=4.755 //x2=19.51 //y2=4.265
cc_1003 ( N_noxref_4_c_1143_p N_noxref_7_c_2408_n ) capacitor c=0.00501225f \
 //x=19.305 //y=4.04 //x2=19.165 //y2=4.265
cc_1004 ( N_noxref_4_c_1140_p N_noxref_7_c_2408_n ) capacitor c=0.00195984f \
 //x=19.305 //y=4.755 //x2=19.165 //y2=4.265
cc_1005 ( N_noxref_4_c_1146_p N_noxref_7_c_2408_n ) capacitor c=0.213124f \
 //x=17.675 //y=3.87 //x2=19.165 //y2=4.265
cc_1006 ( N_noxref_4_c_1222_p N_noxref_7_M16_noxref_g ) capacitor \
 c=0.00501342f //x=1.967 //y=5.335 //x2=1.745 //y2=6.2
cc_1007 ( N_noxref_4_c_1251_p N_noxref_7_M16_noxref_g ) capacitor c=0.0162284f \
 //x=1.965 //y=5.56 //x2=1.745 //y2=6.2
cc_1008 ( N_noxref_4_c_1103_n N_noxref_7_M17_noxref_g ) capacitor \
 c=0.00973141f //x=2.725 //y=5.335 //x2=2.185 //y2=6.2
cc_1009 ( N_noxref_4_c_1222_p N_noxref_7_M17_noxref_g ) capacitor \
 c=0.00229208f //x=1.967 //y=5.335 //x2=2.185 //y2=6.2
cc_1010 ( N_noxref_4_c_1251_p N_noxref_7_M17_noxref_g ) capacitor c=0.0179041f \
 //x=1.965 //y=5.56 //x2=2.185 //y2=6.2
cc_1011 ( N_noxref_4_c_1222_p N_noxref_7_c_2361_n ) capacitor c=0.00171885f \
 //x=1.967 //y=5.335 //x2=2.11 //y2=4.97
cc_1012 ( N_noxref_4_c_1251_p N_noxref_7_c_2361_n ) capacitor c=0.00291477f \
 //x=1.965 //y=5.56 //x2=2.11 //y2=4.97
cc_1013 ( N_noxref_4_c_1139_p Q ) capacitor c=0.00214668f //x=19.305 //y=3.72 \
 //x2=21.525 //y2=2.77
cc_1014 ( N_noxref_4_c_1140_p Q ) capacitor c=9.31608e-19 //x=19.305 //y=4.755 \
 //x2=21.525 //y2=4.62
cc_1015 ( N_noxref_4_c_1145_p N_Q_c_2783_n ) capacitor c=8.86295e-19 \
 //x=19.295 //y=3.88 //x2=21.525 //y2=3.88
cc_1016 ( N_noxref_4_c_1146_p N_Q_c_2784_n ) capacitor c=0.00235949f \
 //x=17.675 //y=3.87 //x2=21.685 //y2=3.865
cc_1017 ( N_noxref_4_c_1103_n N_VDD_c_3043_n ) capacitor c=0.00621352f \
 //x=2.725 //y=5.335 //x2=25.965 //y2=7.58
cc_1018 ( N_noxref_4_c_1002_n N_VDD_c_3043_n ) capacitor c=0.00627191f \
 //x=3.61 //y=5.335 //x2=25.965 //y2=7.58
cc_1019 ( N_noxref_4_c_1004_n N_VDD_c_3043_n ) capacitor c=0.00256019f \
 //x=3.725 //y=5.56 //x2=25.965 //y2=7.58
cc_1020 ( N_noxref_4_c_1007_n N_VDD_c_3043_n ) capacitor c=0.00829248f \
 //x=4.42 //y=5.335 //x2=25.965 //y2=7.58
cc_1021 ( N_noxref_4_c_1040_n N_VDD_c_3043_n ) capacitor c=5.1373e-19 \
 //x=4.505 //y=4.045 //x2=25.965 //y2=7.58
cc_1022 ( N_noxref_4_c_1050_n N_VDD_c_3043_n ) capacitor c=3.34593e-19 \
 //x=6.355 //y=4.04 //x2=25.965 //y2=7.58
cc_1023 ( N_noxref_4_c_1143_p N_VDD_c_3043_n ) capacitor c=4.0659e-19 \
 //x=19.305 //y=4.04 //x2=25.965 //y2=7.58
cc_1024 ( N_noxref_4_c_1222_p N_VDD_c_3043_n ) capacitor c=0.00261804f \
 //x=1.967 //y=5.335 //x2=25.965 //y2=7.58
cc_1025 ( N_noxref_4_c_1114_n N_VDD_c_3043_n ) capacitor c=0.00270108f \
 //x=2.845 //y=5.335 //x2=25.965 //y2=7.58
cc_1026 ( N_noxref_4_c_1251_p N_VDD_c_3043_n ) capacitor c=0.0024232f \
 //x=1.965 //y=5.56 //x2=25.965 //y2=7.58
cc_1027 ( N_noxref_4_c_1132_n N_VDD_c_3043_n ) capacitor c=0.0024232f \
 //x=2.845 //y=5.56 //x2=25.965 //y2=7.58
cc_1028 ( N_noxref_4_c_1073_n N_VDD_c_3043_n ) capacitor c=0.0024232f \
 //x=3.725 //y=5.56 //x2=25.965 //y2=7.58
cc_1029 ( N_noxref_4_c_1222_p N_VDD_c_3178_n ) capacitor c=0.00331944f \
 //x=1.967 //y=5.335 //x2=1.175 //y2=7.58
cc_1030 ( N_noxref_4_c_1251_p N_VDD_c_3178_n ) capacitor c=0.00509469f \
 //x=1.965 //y=5.56 //x2=1.175 //y2=7.58
cc_1031 ( N_noxref_4_c_1103_n N_VDD_c_3180_n ) capacitor c=0.00202922f \
 //x=2.725 //y=5.335 //x2=2.32 //y2=7.585
cc_1032 ( N_noxref_4_c_1222_p N_VDD_c_3180_n ) capacitor c=9.3757e-19 \
 //x=1.967 //y=5.335 //x2=2.32 //y2=7.585
cc_1033 ( N_noxref_4_c_1251_p N_VDD_c_3180_n ) capacitor c=0.0138074f \
 //x=1.965 //y=5.56 //x2=2.32 //y2=7.585
cc_1034 ( N_noxref_4_c_1103_n N_VDD_c_3152_n ) capacitor c=0.0017708f \
 //x=2.725 //y=5.335 //x2=3.2 //y2=7.585
cc_1035 ( N_noxref_4_c_1002_n N_VDD_c_3152_n ) capacitor c=0.00202922f \
 //x=3.61 //y=5.335 //x2=3.2 //y2=7.585
cc_1036 ( N_noxref_4_c_1114_n N_VDD_c_3152_n ) capacitor c=9.4822e-19 \
 //x=2.845 //y=5.335 //x2=3.2 //y2=7.585
cc_1037 ( N_noxref_4_c_1132_n N_VDD_c_3152_n ) capacitor c=0.0138074f \
 //x=2.845 //y=5.56 //x2=3.2 //y2=7.585
cc_1038 ( N_noxref_4_c_1002_n N_VDD_c_3056_n ) capacitor c=0.00205906f \
 //x=3.61 //y=5.335 //x2=4.08 //y2=7.585
cc_1039 ( N_noxref_4_c_1004_n N_VDD_c_3056_n ) capacitor c=8.49654e-19 \
 //x=3.725 //y=5.56 //x2=4.08 //y2=7.585
cc_1040 ( N_noxref_4_c_1007_n N_VDD_c_3056_n ) capacitor c=0.00204238f \
 //x=4.42 //y=5.335 //x2=4.08 //y2=7.585
cc_1041 ( N_noxref_4_c_1073_n N_VDD_c_3056_n ) capacitor c=0.0138074f \
 //x=3.725 //y=5.56 //x2=4.08 //y2=7.585
cc_1042 ( N_noxref_4_c_1007_n N_VDD_c_3191_n ) capacitor c=0.00183742f \
 //x=4.42 //y=5.335 //x2=5.075 //y2=7.585
cc_1043 ( N_noxref_4_M22_noxref_g N_VDD_c_3058_n ) capacitor c=0.00755614f \
 //x=6.555 //y=6.2 //x2=7.13 //y2=7.585
cc_1044 ( N_noxref_4_M23_noxref_g N_VDD_c_3058_n ) capacitor c=0.00755544f \
 //x=6.995 //y=6.2 //x2=7.13 //y2=7.585
cc_1045 ( N_noxref_4_M38_noxref_g N_VDD_c_3194_n ) capacitor c=0.00755614f \
 //x=19.505 //y=6.2 //x2=20.08 //y2=7.585
cc_1046 ( N_noxref_4_M39_noxref_g N_VDD_c_3194_n ) capacitor c=0.00755544f \
 //x=19.945 //y=6.2 //x2=20.08 //y2=7.585
cc_1047 ( N_noxref_4_c_1004_n N_VDD_c_3073_n ) capacitor c=0.00282782f \
 //x=3.725 //y=5.56 //x2=5.245 //y2=7.585
cc_1048 ( N_noxref_4_c_1042_n N_VDD_c_3073_n ) capacitor c=0.0325571f \
 //x=4.505 //y=5.25 //x2=5.245 //y2=7.585
cc_1049 ( N_noxref_4_c_1051_n N_VDD_c_3073_n ) capacitor c=0.0118976f \
 //x=6.355 //y=4.755 //x2=5.245 //y2=7.585
cc_1050 ( N_noxref_4_c_1073_n N_VDD_c_3073_n ) capacitor c=0.00777981f \
 //x=3.725 //y=5.56 //x2=5.245 //y2=7.585
cc_1051 ( N_noxref_4_c_1295_p N_VDD_c_3073_n ) capacitor c=0.00370784f \
 //x=6.355 //y=4.88 //x2=5.245 //y2=7.585
cc_1052 ( N_noxref_4_c_1296_p N_VDD_c_3073_n ) capacitor c=0.00590568f \
 //x=6.63 //y=4.97 //x2=5.245 //y2=7.585
cc_1053 ( N_noxref_4_c_1140_p N_VDD_c_3202_n ) capacitor c=0.0138211f \
 //x=19.305 //y=4.755 //x2=18.195 //y2=7.585
cc_1054 ( N_noxref_4_c_1147_p N_VDD_c_3202_n ) capacitor c=0.00370784f \
 //x=19.305 //y=4.88 //x2=18.195 //y2=7.585
cc_1055 ( N_noxref_4_c_1155_p N_VDD_c_3202_n ) capacitor c=0.00590568f \
 //x=19.58 //y=4.97 //x2=18.195 //y2=7.585
cc_1056 ( N_noxref_4_c_1222_p N_VDD_M16_noxref_s ) capacitor c=0.0453361f \
 //x=1.967 //y=5.335 //x2=1.39 //y2=5.2
cc_1057 ( N_noxref_4_c_1114_n N_VDD_M16_noxref_s ) capacitor c=7.80122e-19 \
 //x=2.845 //y=5.335 //x2=1.39 //y2=5.2
cc_1058 ( N_noxref_4_c_1251_p N_VDD_M16_noxref_s ) capacitor c=0.09305f \
 //x=1.965 //y=5.56 //x2=1.39 //y2=5.2
cc_1059 ( N_noxref_4_c_1103_n N_VDD_M17_noxref_d ) capacitor c=0.00700141f \
 //x=2.725 //y=5.335 //x2=2.26 //y2=5.2
cc_1060 ( N_noxref_4_c_1251_p N_VDD_M17_noxref_d ) capacitor c=0.0674491f \
 //x=1.965 //y=5.56 //x2=2.26 //y2=5.2
cc_1061 ( N_noxref_4_c_1132_n N_VDD_M17_noxref_d ) capacitor c=0.0674762f \
 //x=2.845 //y=5.56 //x2=2.26 //y2=5.2
cc_1062 ( N_noxref_4_c_1002_n N_VDD_M19_noxref_d ) capacitor c=0.00700141f \
 //x=3.61 //y=5.335 //x2=3.14 //y2=5.2
cc_1063 ( N_noxref_4_c_1132_n N_VDD_M19_noxref_d ) capacitor c=0.067493f \
 //x=2.845 //y=5.56 //x2=3.14 //y2=5.2
cc_1064 ( N_noxref_4_c_1073_n N_VDD_M19_noxref_d ) capacitor c=0.0674979f \
 //x=3.725 //y=5.56 //x2=3.14 //y2=5.2
cc_1065 ( N_noxref_4_c_1007_n N_VDD_M21_noxref_d ) capacitor c=0.00700141f \
 //x=4.42 //y=5.335 //x2=4.02 //y2=5.2
cc_1066 ( N_noxref_4_c_1073_n N_VDD_M21_noxref_d ) capacitor c=0.0675002f \
 //x=3.725 //y=5.56 //x2=4.02 //y2=5.2
cc_1067 ( N_noxref_4_c_1004_n N_VDD_M22_noxref_s ) capacitor c=0.00492616f \
 //x=3.725 //y=5.56 //x2=6.2 //y2=5.2
cc_1068 ( N_noxref_4_c_1007_n N_VDD_M22_noxref_s ) capacitor c=9.42705e-19 \
 //x=4.42 //y=5.335 //x2=6.2 //y2=5.2
cc_1069 ( N_noxref_4_c_1050_n N_VDD_M22_noxref_s ) capacitor c=7.08613e-19 \
 //x=6.355 //y=4.04 //x2=6.2 //y2=5.2
cc_1070 ( N_noxref_4_c_1051_n N_VDD_M22_noxref_s ) capacitor c=0.0217981f \
 //x=6.355 //y=4.755 //x2=6.2 //y2=5.2
cc_1071 ( N_noxref_4_c_1114_n N_VDD_M22_noxref_s ) capacitor c=2.11884e-19 \
 //x=2.845 //y=5.335 //x2=6.2 //y2=5.2
cc_1072 ( N_noxref_4_c_1295_p N_VDD_M22_noxref_s ) capacitor c=0.00983846f \
 //x=6.355 //y=4.88 //x2=6.2 //y2=5.2
cc_1073 ( N_noxref_4_M22_noxref_g N_VDD_M22_noxref_s ) capacitor c=0.053419f \
 //x=6.555 //y=6.2 //x2=6.2 //y2=5.2
cc_1074 ( N_noxref_4_c_1296_p N_VDD_M22_noxref_s ) capacitor c=0.00604424f \
 //x=6.63 //y=4.97 //x2=6.2 //y2=5.2
cc_1075 ( N_noxref_4_M23_noxref_g N_VDD_M23_noxref_d ) capacitor c=0.015318f \
 //x=6.995 //y=6.2 //x2=7.07 //y2=5.2
cc_1076 ( N_noxref_4_c_1143_p N_VDD_M38_noxref_s ) capacitor c=7.3096e-19 \
 //x=19.305 //y=4.04 //x2=19.15 //y2=5.2
cc_1077 ( N_noxref_4_c_1140_p N_VDD_M38_noxref_s ) capacitor c=0.0224408f \
 //x=19.305 //y=4.755 //x2=19.15 //y2=5.2
cc_1078 ( N_noxref_4_c_1147_p N_VDD_M38_noxref_s ) capacitor c=0.00983413f \
 //x=19.305 //y=4.88 //x2=19.15 //y2=5.2
cc_1079 ( N_noxref_4_M38_noxref_g N_VDD_M38_noxref_s ) capacitor c=0.053419f \
 //x=19.505 //y=6.2 //x2=19.15 //y2=5.2
cc_1080 ( N_noxref_4_c_1155_p N_VDD_M38_noxref_s ) capacitor c=0.00604424f \
 //x=19.58 //y=4.97 //x2=19.15 //y2=5.2
cc_1081 ( N_noxref_4_M39_noxref_g N_VDD_M39_noxref_d ) capacitor c=0.015318f \
 //x=19.945 //y=6.2 //x2=20.02 //y2=5.2
cc_1082 ( N_noxref_4_c_1012_n N_noxref_10_c_3440_n ) capacitor c=0.0036878f \
 //x=4.02 //y=1.305 //x2=4.42 //y2=0.72
cc_1083 ( N_noxref_4_c_1024_n N_noxref_10_c_3440_n ) capacitor c=0.00365967f \
 //x=4.42 //y=1.845 //x2=4.42 //y2=0.72
cc_1084 ( N_noxref_4_M2_noxref_d N_noxref_10_c_3440_n ) capacitor \
 c=0.00949319f //x=3.83 //y=1.095 //x2=4.42 //y2=0.72
cc_1085 ( N_noxref_4_M2_noxref_d N_noxref_10_c_3445_n ) capacitor \
 c=0.00120711f //x=3.83 //y=1.095 //x2=3.535 //y2=1.175
cc_1086 ( N_noxref_4_c_1103_n N_noxref_10_M1_noxref_d ) capacitor \
 c=0.00161111f //x=2.725 //y=5.335 //x2=2.295 //y2=1.09
cc_1087 ( N_noxref_4_c_1012_n N_noxref_10_M1_noxref_d ) capacitor \
 c=0.00802417f //x=4.02 //y=1.305 //x2=2.295 //y2=1.09
cc_1088 ( N_noxref_4_c_1012_n N_noxref_10_M2_noxref_s ) capacitor c=0.0098487f \
 //x=4.02 //y=1.305 //x2=3.4 //y2=0.555
cc_1089 ( N_noxref_4_c_1019_n N_noxref_10_M2_noxref_s ) capacitor c=0.028602f \
 //x=4.02 //y=1.76 //x2=3.4 //y2=0.555
cc_1090 ( N_noxref_4_c_1024_n N_noxref_10_M2_noxref_s ) capacitor \
 c=0.00911719f //x=4.42 //y=1.845 //x2=3.4 //y2=0.555
cc_1091 ( N_noxref_4_c_1055_n N_noxref_10_M2_noxref_s ) capacitor \
 c=0.00129723f //x=4.505 //y=3.88 //x2=3.4 //y2=0.555
cc_1092 ( N_noxref_4_M2_noxref_d N_noxref_10_M2_noxref_s ) capacitor \
 c=0.0279003f //x=3.83 //y=1.095 //x2=3.4 //y2=0.555
cc_1093 ( N_noxref_4_c_1012_n N_noxref_11_M4_noxref_d ) capacitor \
 c=3.20746e-19 //x=4.02 //y=1.305 //x2=7.105 //y2=1.09
cc_1094 ( N_noxref_4_c_1030_n D ) capacitor c=0.0017365f //x=4.505 //y=3.725 \
 //x2=7.465 //y2=2.77
cc_1095 ( N_noxref_4_c_1042_n D ) capacitor c=6.66489e-19 //x=4.505 //y=5.25 \
 //x2=7.465 //y2=2.77
cc_1096 ( N_noxref_4_c_1046_n D ) capacitor c=0.038367f //x=6.355 //y=3.72 \
 //x2=7.465 //y2=2.77
cc_1097 ( N_noxref_4_c_1050_n D ) capacitor c=0.00774769f //x=6.355 //y=4.04 \
 //x2=7.465 //y2=2.77
cc_1098 ( N_noxref_4_c_1051_n D ) capacitor c=0.015882f //x=6.355 //y=4.755 \
 //x2=7.465 //y2=2.77
cc_1099 ( N_noxref_4_c_1343_p D ) capacitor c=2.90818e-19 //x=6.355 //y=3.88 \
 //x2=7.465 //y2=2.77
cc_1100 ( N_noxref_4_c_1061_n D ) capacitor c=0.0253614f //x=9.19 //y=3.895 \
 //x2=7.465 //y2=2.77
cc_1101 ( N_noxref_4_c_1345_p D ) capacitor c=4.16726e-19 //x=6.355 //y=2.26 \
 //x2=7.465 //y2=2.77
cc_1102 ( N_noxref_4_c_1295_p D ) capacitor c=3.36194e-19 //x=6.355 //y=4.88 \
 //x2=7.465 //y2=2.77
cc_1103 ( N_noxref_4_c_1045_n N_D_c_3574_n ) capacitor c=0.0109668f //x=6.355 \
 //y=2.375 //x2=7.465 //y2=2.375
cc_1104 ( N_noxref_4_c_1345_p N_D_c_3574_n ) capacitor c=5.40058e-19 //x=6.355 \
 //y=2.26 //x2=7.465 //y2=2.375
cc_1105 ( N_noxref_4_c_1349_p N_D_c_3574_n ) capacitor c=0.00147006f //x=6.055 \
 //y=2.095 //x2=7.465 //y2=2.375
cc_1106 ( N_noxref_4_c_1051_n N_D_c_3575_n ) capacitor c=0.0110307f //x=6.355 \
 //y=4.755 //x2=7.465 //y2=4.765
cc_1107 ( N_noxref_4_c_1295_p N_D_c_3575_n ) capacitor c=2.89813e-19 //x=6.355 \
 //y=4.88 //x2=7.465 //y2=4.765
cc_1108 ( N_noxref_4_c_1083_n N_D_c_3575_n ) capacitor c=7.66769e-19 //x=6.92 \
 //y=4.97 //x2=7.465 //y2=4.765
cc_1109 ( N_noxref_4_c_1296_p N_D_c_3575_n ) capacitor c=7.54501e-19 //x=6.63 \
 //y=4.97 //x2=7.465 //y2=4.765
cc_1110 ( N_noxref_4_c_1045_n N_D_c_3607_n ) capacitor c=5.39999e-19 //x=6.355 \
 //y=2.375 //x2=7.465 //y2=2.26
cc_1111 ( N_noxref_4_c_1046_n N_D_c_3607_n ) capacitor c=4.16726e-19 //x=6.355 \
 //y=3.72 //x2=7.465 //y2=2.26
cc_1112 ( N_noxref_4_c_1345_p N_D_c_3607_n ) capacitor c=0.00125213f //x=6.355 \
 //y=2.26 //x2=7.465 //y2=2.26
cc_1113 ( N_noxref_4_c_1349_p N_D_c_3607_n ) capacitor c=0.00214573f //x=6.055 \
 //y=2.095 //x2=7.465 //y2=2.26
cc_1114 ( N_noxref_4_c_1051_n N_D_c_3578_n ) capacitor c=0.00103399f //x=6.355 \
 //y=4.755 //x2=7.465 //y2=4.88
cc_1115 ( N_noxref_4_c_1295_p N_D_c_3578_n ) capacitor c=0.00113984f //x=6.355 \
 //y=4.88 //x2=7.465 //y2=4.88
cc_1116 ( N_noxref_4_c_1083_n N_D_c_3578_n ) capacitor c=0.00116563f //x=6.92 \
 //y=4.97 //x2=7.465 //y2=4.88
cc_1117 ( N_noxref_4_c_1296_p N_D_c_3578_n ) capacitor c=0.00129812f //x=6.63 \
 //y=4.97 //x2=7.465 //y2=4.88
cc_1118 ( N_noxref_4_M22_noxref_g N_D_M24_noxref_g ) capacitor c=0.0106276f \
 //x=6.555 //y=6.2 //x2=7.435 //y2=6.2
cc_1119 ( N_noxref_4_M23_noxref_g N_D_M24_noxref_g ) capacitor c=0.107144f \
 //x=6.995 //y=6.2 //x2=7.435 //y2=6.2
cc_1120 ( N_noxref_4_M23_noxref_g N_D_M25_noxref_g ) capacitor c=0.0101598f \
 //x=6.995 //y=6.2 //x2=7.875 //y2=6.2
cc_1121 ( N_noxref_4_c_1365_p N_D_c_3618_n ) capacitor c=5.72528e-19 //x=6.055 \
 //y=1.055 //x2=7.03 //y2=1.09
cc_1122 ( N_noxref_4_c_1366_p N_D_c_3618_n ) capacitor c=0.00150277f //x=6.055 \
 //y=1.4 //x2=7.03 //y2=1.09
cc_1123 ( N_noxref_4_c_1367_p N_D_c_3618_n ) capacitor c=0.0160123f //x=6.585 \
 //y=1.055 //x2=7.03 //y2=1.09
cc_1124 ( N_noxref_4_c_1368_p N_D_c_3621_n ) capacitor c=0.00111227f //x=6.055 \
 //y=1.71 //x2=7.03 //y2=1.4
cc_1125 ( N_noxref_4_c_1369_p N_D_c_3621_n ) capacitor c=0.0124075f //x=6.585 \
 //y=1.4 //x2=7.03 //y2=1.4
cc_1126 ( N_noxref_4_c_1367_p N_D_c_3623_n ) capacitor c=9.19165e-19 //x=6.585 \
 //y=1.055 //x2=7.555 //y2=1.09
cc_1127 ( N_noxref_4_c_1369_p N_D_c_3624_n ) capacitor c=0.0010154f //x=6.585 \
 //y=1.4 //x2=7.555 //y2=1.4
cc_1128 ( N_noxref_4_c_1369_p N_D_c_3625_n ) capacitor c=9.23422e-19 //x=6.585 \
 //y=1.4 //x2=7.555 //y2=1.63
cc_1129 ( N_noxref_4_c_1045_n N_D_c_3626_n ) capacitor c=0.00140534f //x=6.355 \
 //y=2.375 //x2=7.555 //y2=2.095
cc_1130 ( N_noxref_4_c_1345_p N_D_c_3626_n ) capacitor c=0.0020754f //x=6.355 \
 //y=2.26 //x2=7.555 //y2=2.095
cc_1131 ( N_noxref_4_c_1349_p N_D_c_3626_n ) capacitor c=0.00964411f //x=6.055 \
 //y=2.095 //x2=7.555 //y2=2.095
cc_1132 ( N_noxref_4_c_1051_n N_D_c_3588_n ) capacitor c=0.00116212f //x=6.355 \
 //y=4.755 //x2=7.465 //y2=4.88
cc_1133 ( N_noxref_4_c_1295_p N_D_c_3588_n ) capacitor c=0.00155973f //x=6.355 \
 //y=4.88 //x2=7.465 //y2=4.88
cc_1134 ( N_noxref_4_c_1083_n N_D_c_3588_n ) capacitor c=0.0171374f //x=6.92 \
 //y=4.97 //x2=7.465 //y2=4.88
cc_1135 ( N_noxref_4_c_1296_p N_D_c_3588_n ) capacitor c=0.00484466f //x=6.63 \
 //y=4.97 //x2=7.465 //y2=4.88
cc_1136 ( N_noxref_4_c_1012_n N_GND_c_3830_n ) capacitor c=0.00901861f \
 //x=4.02 //y=1.305 //x2=6.235 //y2=0.175
cc_1137 ( N_noxref_4_c_1024_n N_GND_c_3830_n ) capacitor c=0.00713708f \
 //x=4.42 //y=1.845 //x2=6.235 //y2=0.175
cc_1138 ( N_noxref_4_c_1040_n N_GND_c_3830_n ) capacitor c=5.12818e-19 \
 //x=4.505 //y=4.045 //x2=6.235 //y2=0.175
cc_1139 ( N_noxref_4_M2_noxref_d N_GND_c_3830_n ) capacitor c=2.9462e-19 \
 //x=3.83 //y=1.095 //x2=6.235 //y2=0.175
cc_1140 ( N_noxref_4_c_1365_p N_GND_c_3918_n ) capacitor c=3.97665e-19 \
 //x=6.055 //y=1.055 //x2=6.32 //y2=1.015
cc_1141 ( N_noxref_4_c_1385_p N_GND_c_3918_n ) capacitor c=0.00864776f \
 //x=6.43 //y=0.9 //x2=6.32 //y2=1.015
cc_1142 ( N_noxref_4_c_1367_p N_GND_c_3918_n ) capacitor c=4.45447e-19 \
 //x=6.585 //y=1.055 //x2=6.32 //y2=1.015
cc_1143 ( N_noxref_4_c_1184_p N_GND_c_3921_n ) capacitor c=3.97665e-19 \
 //x=19.005 //y=1.055 //x2=19.27 //y2=1.015
cc_1144 ( N_noxref_4_c_1388_p N_GND_c_3921_n ) capacitor c=0.00864776f \
 //x=19.38 //y=0.9 //x2=19.27 //y2=1.015
cc_1145 ( N_noxref_4_c_1186_p N_GND_c_3921_n ) capacitor c=4.45447e-19 \
 //x=19.535 //y=1.055 //x2=19.27 //y2=1.015
cc_1146 ( N_noxref_4_c_1012_n N_GND_c_3924_n ) capacitor c=0.00543195f \
 //x=4.02 //y=1.305 //x2=6.32 //y2=1.145
cc_1147 ( N_noxref_4_c_1045_n N_GND_c_3924_n ) capacitor c=0.00849742f \
 //x=6.355 //y=2.375 //x2=6.32 //y2=1.145
cc_1148 ( N_noxref_4_c_1050_n N_GND_c_3924_n ) capacitor c=5.53944e-19 \
 //x=6.355 //y=4.04 //x2=6.32 //y2=1.145
cc_1149 ( N_noxref_4_c_1345_p N_GND_c_3924_n ) capacitor c=2.22883e-19 \
 //x=6.355 //y=2.26 //x2=6.32 //y2=1.145
cc_1150 ( N_noxref_4_c_1365_p N_GND_c_3924_n ) capacitor c=0.00156339f \
 //x=6.055 //y=1.055 //x2=6.32 //y2=1.145
cc_1151 ( N_noxref_4_c_1366_p N_GND_c_3924_n ) capacitor c=0.00352472f \
 //x=6.055 //y=1.4 //x2=6.32 //y2=1.145
cc_1152 ( N_noxref_4_c_1368_p N_GND_c_3924_n ) capacitor c=4.63388e-19 \
 //x=6.055 //y=1.71 //x2=6.32 //y2=1.145
cc_1153 ( N_noxref_4_c_1385_p N_GND_c_3924_n ) capacitor c=9.36995e-19 \
 //x=6.43 //y=0.9 //x2=6.32 //y2=1.145
cc_1154 ( N_noxref_4_c_1398_p N_GND_c_3924_n ) capacitor c=5.96388e-19 \
 //x=6.43 //y=1.555 //x2=6.32 //y2=1.145
cc_1155 ( N_noxref_4_c_1367_p N_GND_c_3924_n ) capacitor c=0.0017438f \
 //x=6.585 //y=1.055 //x2=6.32 //y2=1.145
cc_1156 ( N_noxref_4_c_1369_p N_GND_c_3924_n ) capacitor c=0.00276804f \
 //x=6.585 //y=1.4 //x2=6.32 //y2=1.145
cc_1157 ( N_noxref_4_c_1148_p N_GND_c_3935_n ) capacitor c=0.00772482f \
 //x=19.305 //y=2.375 //x2=19.27 //y2=1.145
cc_1158 ( N_noxref_4_c_1143_p N_GND_c_3935_n ) capacitor c=6.6735e-19 \
 //x=19.305 //y=4.04 //x2=19.27 //y2=1.145
cc_1159 ( N_noxref_4_c_1150_p N_GND_c_3935_n ) capacitor c=2.22883e-19 \
 //x=19.305 //y=2.26 //x2=19.27 //y2=1.145
cc_1160 ( N_noxref_4_c_1184_p N_GND_c_3935_n ) capacitor c=0.00156339f \
 //x=19.005 //y=1.055 //x2=19.27 //y2=1.145
cc_1161 ( N_noxref_4_c_1185_p N_GND_c_3935_n ) capacitor c=0.00352472f \
 //x=19.005 //y=1.4 //x2=19.27 //y2=1.145
cc_1162 ( N_noxref_4_c_1187_p N_GND_c_3935_n ) capacitor c=4.40631e-19 \
 //x=19.005 //y=1.71 //x2=19.27 //y2=1.145
cc_1163 ( N_noxref_4_c_1388_p N_GND_c_3935_n ) capacitor c=9.36995e-19 \
 //x=19.38 //y=0.9 //x2=19.27 //y2=1.145
cc_1164 ( N_noxref_4_c_1408_p N_GND_c_3935_n ) capacitor c=5.96388e-19 \
 //x=19.38 //y=1.555 //x2=19.27 //y2=1.145
cc_1165 ( N_noxref_4_c_1186_p N_GND_c_3935_n ) capacitor c=0.0017438f \
 //x=19.535 //y=1.055 //x2=19.27 //y2=1.145
cc_1166 ( N_noxref_4_c_1188_p N_GND_c_3935_n ) capacitor c=0.00276804f \
 //x=19.535 //y=1.4 //x2=19.27 //y2=1.145
cc_1167 ( N_noxref_4_c_1024_n N_GND_c_3848_n ) capacitor c=6.86343e-19 \
 //x=4.42 //y=1.845 //x2=5.075 //y2=0.175
cc_1168 ( N_noxref_4_c_1365_p N_GND_c_3849_n ) capacitor c=0.00677766f \
 //x=6.055 //y=1.055 //x2=9.885 //y2=0.175
cc_1169 ( N_noxref_4_c_1184_p N_GND_c_3947_n ) capacitor c=0.00677766f \
 //x=19.005 //y=1.055 //x2=22.835 //y2=0.175
cc_1170 ( N_noxref_4_c_1019_n N_GND_c_3852_n ) capacitor c=0.0045138f //x=4.02 \
 //y=1.76 //x2=5.245 //y2=0.175
cc_1171 ( N_noxref_4_c_1024_n N_GND_c_3852_n ) capacitor c=0.0349977f //x=4.42 \
 //y=1.845 //x2=5.245 //y2=0.175
cc_1172 ( N_noxref_4_c_1045_n N_GND_c_3852_n ) capacitor c=0.00407472f \
 //x=6.355 //y=2.375 //x2=5.245 //y2=0.175
cc_1173 ( N_noxref_4_c_1046_n N_GND_c_3852_n ) capacitor c=0.0118341f \
 //x=6.355 //y=3.72 //x2=5.245 //y2=0.175
cc_1174 ( N_noxref_4_c_1345_p N_GND_c_3852_n ) capacitor c=0.00394651f \
 //x=6.355 //y=2.26 //x2=5.245 //y2=0.175
cc_1175 ( N_noxref_4_c_1368_p N_GND_c_3852_n ) capacitor c=0.00170145f \
 //x=6.055 //y=1.71 //x2=5.245 //y2=0.175
cc_1176 ( N_noxref_4_c_1349_p N_GND_c_3852_n ) capacitor c=0.0103608f \
 //x=6.055 //y=2.095 //x2=5.245 //y2=0.175
cc_1177 ( N_noxref_4_c_1148_p N_GND_c_3955_n ) capacitor c=0.00369246f \
 //x=19.305 //y=2.375 //x2=18.195 //y2=0.175
cc_1178 ( N_noxref_4_c_1139_p N_GND_c_3955_n ) capacitor c=0.0108616f \
 //x=19.305 //y=3.72 //x2=18.195 //y2=0.175
cc_1179 ( N_noxref_4_c_1146_p N_GND_c_3955_n ) capacitor c=0.00307724f \
 //x=17.675 //y=3.87 //x2=18.195 //y2=0.175
cc_1180 ( N_noxref_4_c_1150_p N_GND_c_3955_n ) capacitor c=0.00379567f \
 //x=19.305 //y=2.26 //x2=18.195 //y2=0.175
cc_1181 ( N_noxref_4_c_1187_p N_GND_c_3955_n ) capacitor c=0.00170145f \
 //x=19.005 //y=1.71 //x2=18.195 //y2=0.175
cc_1182 ( N_noxref_4_c_1151_p N_GND_c_3955_n ) capacitor c=0.0102191f \
 //x=19.005 //y=2.095 //x2=18.195 //y2=0.175
cc_1183 ( N_noxref_4_c_1045_n N_GND_M3_noxref_d ) capacitor c=4.4417e-19 \
 //x=6.355 //y=2.375 //x2=6.13 //y2=1.055
cc_1184 ( N_noxref_4_c_1365_p N_GND_M3_noxref_d ) capacitor c=0.00184354f \
 //x=6.055 //y=1.055 //x2=6.13 //y2=1.055
cc_1185 ( N_noxref_4_c_1366_p N_GND_M3_noxref_d ) capacitor c=0.00210798f \
 //x=6.055 //y=1.4 //x2=6.13 //y2=1.055
cc_1186 ( N_noxref_4_c_1385_p N_GND_M3_noxref_d ) capacitor c=0.00474029f \
 //x=6.43 //y=0.9 //x2=6.13 //y2=1.055
cc_1187 ( N_noxref_4_c_1398_p N_GND_M3_noxref_d ) capacitor c=0.00166857f \
 //x=6.43 //y=1.555 //x2=6.13 //y2=1.055
cc_1188 ( N_noxref_4_c_1367_p N_GND_M3_noxref_d ) capacitor c=0.00230174f \
 //x=6.585 //y=1.055 //x2=6.13 //y2=1.055
cc_1189 ( N_noxref_4_c_1369_p N_GND_M3_noxref_d ) capacitor c=0.00210798f \
 //x=6.585 //y=1.4 //x2=6.13 //y2=1.055
cc_1190 ( N_noxref_4_c_1148_p N_GND_M11_noxref_d ) capacitor c=4.4417e-19 \
 //x=19.305 //y=2.375 //x2=19.08 //y2=1.055
cc_1191 ( N_noxref_4_c_1184_p N_GND_M11_noxref_d ) capacitor c=0.00184354f \
 //x=19.005 //y=1.055 //x2=19.08 //y2=1.055
cc_1192 ( N_noxref_4_c_1185_p N_GND_M11_noxref_d ) capacitor c=0.00210798f \
 //x=19.005 //y=1.4 //x2=19.08 //y2=1.055
cc_1193 ( N_noxref_4_c_1388_p N_GND_M11_noxref_d ) capacitor c=0.00474029f \
 //x=19.38 //y=0.9 //x2=19.08 //y2=1.055
cc_1194 ( N_noxref_4_c_1408_p N_GND_M11_noxref_d ) capacitor c=0.00166857f \
 //x=19.38 //y=1.555 //x2=19.08 //y2=1.055
cc_1195 ( N_noxref_4_c_1186_p N_GND_M11_noxref_d ) capacitor c=0.00230174f \
 //x=19.535 //y=1.055 //x2=19.08 //y2=1.055
cc_1196 ( N_noxref_4_c_1188_p N_GND_M11_noxref_d ) capacitor c=0.00210798f \
 //x=19.535 //y=1.4 //x2=19.08 //y2=1.055
cc_1197 ( N_noxref_4_c_1349_p N_noxref_17_c_4341_n ) capacitor c=0.00262672f \
 //x=6.055 //y=2.095 //x2=5.835 //y2=1.685
cc_1198 ( N_noxref_4_c_1045_n N_noxref_17_c_4342_n ) capacitor c=0.00428451f \
 //x=6.355 //y=2.375 //x2=6.72 //y2=1.77
cc_1199 ( N_noxref_4_c_1050_n N_noxref_17_c_4342_n ) capacitor c=0.00144481f \
 //x=6.355 //y=4.04 //x2=6.72 //y2=1.77
cc_1200 ( N_noxref_4_c_1345_p N_noxref_17_c_4342_n ) capacitor c=0.0104666f \
 //x=6.355 //y=2.26 //x2=6.72 //y2=1.77
cc_1201 ( N_noxref_4_c_1368_p N_noxref_17_c_4342_n ) capacitor c=0.00705077f \
 //x=6.055 //y=1.71 //x2=6.72 //y2=1.77
cc_1202 ( N_noxref_4_c_1349_p N_noxref_17_c_4342_n ) capacitor c=0.0219597f \
 //x=6.055 //y=2.095 //x2=6.72 //y2=1.77
cc_1203 ( N_noxref_4_c_1398_p N_noxref_17_c_4342_n ) capacitor c=0.00588627f \
 //x=6.43 //y=1.555 //x2=6.72 //y2=1.77
cc_1204 ( N_noxref_4_c_1369_p N_noxref_17_c_4342_n ) capacitor c=0.00698822f \
 //x=6.585 //y=1.4 //x2=6.72 //y2=1.77
cc_1205 ( N_noxref_4_c_1365_p N_noxref_17_M3_noxref_s ) capacitor c=0.0295256f \
 //x=6.055 //y=1.055 //x2=5.7 //y2=0.555
cc_1206 ( N_noxref_4_c_1368_p N_noxref_17_M3_noxref_s ) capacitor \
 c=7.99997e-19 //x=6.055 //y=1.71 //x2=5.7 //y2=0.555
cc_1207 ( N_noxref_4_c_1349_p N_noxref_17_M3_noxref_s ) capacitor \
 c=0.00122123f //x=6.055 //y=2.095 //x2=5.7 //y2=0.555
cc_1208 ( N_noxref_4_c_1367_p N_noxref_17_M3_noxref_s ) capacitor c=0.0125924f \
 //x=6.585 //y=1.055 //x2=5.7 //y2=0.555
cc_1209 ( N_noxref_4_c_1151_p N_noxref_20_c_4526_n ) capacitor c=0.00262672f \
 //x=19.005 //y=2.095 //x2=18.785 //y2=1.685
cc_1210 ( N_noxref_4_c_1148_p N_noxref_20_c_4527_n ) capacitor c=0.00428451f \
 //x=19.305 //y=2.375 //x2=19.67 //y2=1.77
cc_1211 ( N_noxref_4_c_1143_p N_noxref_20_c_4527_n ) capacitor c=0.00205403f \
 //x=19.305 //y=4.04 //x2=19.67 //y2=1.77
cc_1212 ( N_noxref_4_c_1150_p N_noxref_20_c_4527_n ) capacitor c=0.0104666f \
 //x=19.305 //y=2.26 //x2=19.67 //y2=1.77
cc_1213 ( N_noxref_4_c_1187_p N_noxref_20_c_4527_n ) capacitor c=0.00705077f \
 //x=19.005 //y=1.71 //x2=19.67 //y2=1.77
cc_1214 ( N_noxref_4_c_1151_p N_noxref_20_c_4527_n ) capacitor c=0.020708f \
 //x=19.005 //y=2.095 //x2=19.67 //y2=1.77
cc_1215 ( N_noxref_4_c_1408_p N_noxref_20_c_4527_n ) capacitor c=0.00588627f \
 //x=19.38 //y=1.555 //x2=19.67 //y2=1.77
cc_1216 ( N_noxref_4_c_1188_p N_noxref_20_c_4527_n ) capacitor c=0.00698822f \
 //x=19.535 //y=1.4 //x2=19.67 //y2=1.77
cc_1217 ( N_noxref_4_c_1184_p N_noxref_20_M11_noxref_s ) capacitor \
 c=0.0295256f //x=19.005 //y=1.055 //x2=18.65 //y2=0.555
cc_1218 ( N_noxref_4_c_1187_p N_noxref_20_M11_noxref_s ) capacitor \
 c=7.99997e-19 //x=19.005 //y=1.71 //x2=18.65 //y2=0.555
cc_1219 ( N_noxref_4_c_1151_p N_noxref_20_M11_noxref_s ) capacitor \
 c=0.00122123f //x=19.005 //y=2.095 //x2=18.65 //y2=0.555
cc_1220 ( N_noxref_4_c_1186_p N_noxref_20_M11_noxref_s ) capacitor \
 c=0.0125924f //x=19.535 //y=1.055 //x2=18.65 //y2=0.555
cc_1221 ( N_RN_c_1589_n N_noxref_6_c_1895_n ) capacitor c=6.33901e-19 \
 //x=20.415 //y=2.515 //x2=20.485 //y2=5.335
cc_1222 ( N_RN_c_1593_n N_noxref_6_c_1895_n ) capacitor c=0.0218571f \
 //x=20.415 //y=4.765 //x2=20.485 //y2=5.335
cc_1223 ( N_RN_c_1618_n N_noxref_6_c_1895_n ) capacitor c=0.00492634f \
 //x=20.415 //y=4.88 //x2=20.485 //y2=5.335
cc_1224 ( N_RN_M40_noxref_g N_noxref_6_c_1895_n ) capacitor c=0.00858241f \
 //x=20.385 //y=6.2 //x2=20.485 //y2=5.335
cc_1225 ( N_RN_c_1636_n N_noxref_6_c_1895_n ) capacitor c=6.15714e-19 \
 //x=20.415 //y=4.88 //x2=20.485 //y2=5.335
cc_1226 ( N_RN_M41_noxref_g N_noxref_6_c_1907_n ) capacitor c=0.0103546f \
 //x=20.825 //y=6.2 //x2=21.37 //y2=5.335
cc_1227 ( RN N_noxref_6_c_1908_n ) capacitor c=0.00152837f //x=20.415 //y=2.77 \
 //x2=22.265 //y2=3.335
cc_1228 ( RN N_noxref_6_c_1909_n ) capacitor c=0.00224708f //x=20.415 //y=2.77 \
 //x2=22.265 //y2=5.25
cc_1229 ( N_RN_c_1593_n N_noxref_6_c_1910_n ) capacitor c=0.00244335f \
 //x=20.415 //y=4.765 //x2=20.605 //y2=5.335
cc_1230 ( N_RN_c_1618_n N_noxref_6_c_1910_n ) capacitor c=0.00132214f \
 //x=20.415 //y=4.88 //x2=20.605 //y2=5.335
cc_1231 ( N_RN_M40_noxref_g N_noxref_6_c_1910_n ) capacitor c=0.00229818f \
 //x=20.385 //y=6.2 //x2=20.605 //y2=5.335
cc_1232 ( N_RN_M41_noxref_g N_noxref_6_c_1910_n ) capacitor c=0.00230699f \
 //x=20.825 //y=6.2 //x2=20.605 //y2=5.335
cc_1233 ( N_RN_c_1652_p N_noxref_6_c_1910_n ) capacitor c=0.00171075f \
 //x=20.75 //y=4.97 //x2=20.605 //y2=5.335
cc_1234 ( N_RN_c_1593_n N_noxref_6_c_1915_n ) capacitor c=7.85344e-19 \
 //x=20.415 //y=4.765 //x2=20.605 //y2=5.56
cc_1235 ( N_RN_M40_noxref_g N_noxref_6_c_1915_n ) capacitor c=0.0179041f \
 //x=20.385 //y=6.2 //x2=20.605 //y2=5.56
cc_1236 ( N_RN_M41_noxref_g N_noxref_6_c_1915_n ) capacitor c=0.0179041f \
 //x=20.825 //y=6.2 //x2=20.605 //y2=5.56
cc_1237 ( N_RN_c_1652_p N_noxref_6_c_1915_n ) capacitor c=0.00290085f \
 //x=20.75 //y=4.97 //x2=20.605 //y2=5.56
cc_1238 ( N_RN_c_1483_n N_noxref_7_c_2174_n ) capacitor c=0.0165827f //x=16.56 \
 //y=2.315 //x2=11.905 //y2=4.09
cc_1239 ( N_RN_M36_noxref_g N_noxref_7_c_2313_n ) capacitor c=0.0103546f \
 //x=16.455 //y=6.2 //x2=16.56 //y2=5.335
cc_1240 ( N_RN_M36_noxref_g N_noxref_7_c_2420_n ) capacitor c=0.00226521f \
 //x=16.455 //y=6.2 //x2=16.675 //y2=5.56
cc_1241 ( N_RN_M37_noxref_g N_noxref_7_c_2420_n ) capacitor c=0.00381703f \
 //x=16.895 //y=6.2 //x2=16.675 //y2=5.56
cc_1242 ( RN N_noxref_7_c_2422_n ) capacitor c=2.13846e-19 //x=16.715 //y=2.4 \
 //x2=17.37 //y2=5.335
cc_1243 ( N_RN_c_1550_n N_noxref_7_c_2422_n ) capacitor c=0.0023499f \
 //x=16.715 //y=4.75 //x2=17.37 //y2=5.335
cc_1244 ( N_RN_c_1561_n N_noxref_7_c_2422_n ) capacitor c=0.00130631f \
 //x=16.715 //y=4.88 //x2=17.37 //y2=5.335
cc_1245 ( N_RN_M37_noxref_g N_noxref_7_c_2422_n ) capacitor c=0.0112553f \
 //x=16.895 //y=6.2 //x2=17.37 //y2=5.335
cc_1246 ( RN N_noxref_7_c_2426_n ) capacitor c=5.60322e-19 //x=16.715 //y=2.4 \
 //x2=16.97 //y2=1.305
cc_1247 ( N_RN_c_1557_n N_noxref_7_c_2426_n ) capacitor c=4.13793e-19 \
 //x=16.88 //y=2.315 //x2=16.97 //y2=1.305
cc_1248 ( N_RN_c_1567_n N_noxref_7_c_2426_n ) capacitor c=4.64015e-19 \
 //x=16.705 //y=1.095 //x2=16.97 //y2=1.305
cc_1249 ( N_RN_c_1568_n N_noxref_7_c_2426_n ) capacitor c=0.0026012f \
 //x=16.705 //y=1.44 //x2=16.97 //y2=1.305
cc_1250 ( N_RN_c_1669_p N_noxref_7_c_2426_n ) capacitor c=5.29969e-19 \
 //x=17.08 //y=0.94 //x2=16.97 //y2=1.305
cc_1251 ( N_RN_c_1670_p N_noxref_7_c_2426_n ) capacitor c=4.32061e-19 \
 //x=17.08 //y=1.595 //x2=16.97 //y2=1.305
cc_1252 ( N_RN_c_1671_p N_noxref_7_c_2426_n ) capacitor c=5.24634e-19 \
 //x=17.235 //y=1.095 //x2=16.97 //y2=1.305
cc_1253 ( N_RN_c_1672_p N_noxref_7_c_2426_n ) capacitor c=0.00307978f \
 //x=17.235 //y=1.44 //x2=16.97 //y2=1.305
cc_1254 ( N_RN_c_1568_n N_noxref_7_c_2242_n ) capacitor c=0.00127432f \
 //x=16.705 //y=1.44 //x2=16.97 //y2=1.76
cc_1255 ( N_RN_c_1569_n N_noxref_7_c_2242_n ) capacitor c=0.00441386f \
 //x=16.705 //y=1.75 //x2=16.97 //y2=1.76
cc_1256 ( N_RN_c_1670_p N_noxref_7_c_2242_n ) capacitor c=0.00942306f \
 //x=17.08 //y=1.595 //x2=16.97 //y2=1.76
cc_1257 ( N_RN_c_1672_p N_noxref_7_c_2242_n ) capacitor c=0.00363411f \
 //x=17.235 //y=1.44 //x2=16.97 //y2=1.76
cc_1258 ( N_RN_c_1572_n N_noxref_7_c_2242_n ) capacitor c=0.00362297f \
 //x=16.715 //y=2.095 //x2=16.97 //y2=1.76
cc_1259 ( N_RN_c_1670_p N_noxref_7_c_2439_n ) capacitor c=0.00194716f \
 //x=17.08 //y=1.595 //x2=17.37 //y2=1.845
cc_1260 ( N_RN_c_1672_p N_noxref_7_c_2439_n ) capacitor c=0.00323576f \
 //x=17.235 //y=1.44 //x2=17.37 //y2=1.845
cc_1261 ( N_RN_c_1609_n N_noxref_7_c_2243_n ) capacitor c=0.021696f //x=20.21 \
 //y=2.355 //x2=17.055 //y2=1.845
cc_1262 ( RN N_noxref_7_c_2314_n ) capacitor c=0.0718816f //x=16.715 //y=2.77 \
 //x2=17.455 //y2=4.095
cc_1263 ( RN N_noxref_7_c_2314_n ) capacitor c=0.00223984f //x=20.415 //y=2.77 \
 //x2=17.455 //y2=4.095
cc_1264 ( RN N_noxref_7_c_2314_n ) capacitor c=0.0171385f //x=16.715 //y=2.4 \
 //x2=17.455 //y2=4.095
cc_1265 ( N_RN_c_1557_n N_noxref_7_c_2314_n ) capacitor c=0.00372846f \
 //x=16.88 //y=2.315 //x2=17.455 //y2=4.095
cc_1266 ( N_RN_c_1609_n N_noxref_7_c_2314_n ) capacitor c=0.0326829f //x=20.21 \
 //y=2.355 //x2=17.455 //y2=4.095
cc_1267 ( N_RN_c_1558_n N_noxref_7_c_2314_n ) capacitor c=0.00115564f \
 //x=16.715 //y=2.26 //x2=17.455 //y2=4.095
cc_1268 ( N_RN_c_1570_n N_noxref_7_c_2314_n ) capacitor c=3.96703e-19 \
 //x=16.715 //y=2.26 //x2=17.455 //y2=4.095
cc_1269 ( N_RN_c_1572_n N_noxref_7_c_2314_n ) capacitor c=0.00282067f \
 //x=16.715 //y=2.095 //x2=17.455 //y2=4.095
cc_1270 ( RN N_noxref_7_c_2377_n ) capacitor c=0.0172847f //x=16.715 //y=2.77 \
 //x2=17.455 //y2=4.415
cc_1271 ( RN N_noxref_7_c_2315_n ) capacitor c=0.0140709f //x=16.715 //y=2.77 \
 //x2=17.455 //y2=5.25
cc_1272 ( RN N_noxref_7_c_2315_n ) capacitor c=8.28074e-19 //x=20.415 //y=2.77 \
 //x2=17.455 //y2=5.25
cc_1273 ( N_RN_c_1550_n N_noxref_7_c_2315_n ) capacitor c=0.0151931f \
 //x=16.715 //y=4.75 //x2=17.455 //y2=5.25
cc_1274 ( N_RN_c_1561_n N_noxref_7_c_2315_n ) capacitor c=0.00131258f \
 //x=16.715 //y=4.88 //x2=17.455 //y2=5.25
cc_1275 ( N_RN_c_1573_n N_noxref_7_c_2315_n ) capacitor c=0.00739875f \
 //x=16.715 //y=4.88 //x2=17.455 //y2=5.25
cc_1276 ( N_RN_c_1483_n N_noxref_7_c_2189_n ) capacitor c=0.0170024f //x=16.56 \
 //y=2.315 //x2=11.905 //y2=2.26
cc_1277 ( RN N_noxref_7_c_2457_n ) capacitor c=4.49075e-19 //x=16.715 //y=2.4 \
 //x2=16.675 //y2=5.335
cc_1278 ( N_RN_c_1550_n N_noxref_7_c_2457_n ) capacitor c=0.0226552f \
 //x=16.715 //y=4.75 //x2=16.675 //y2=5.335
cc_1279 ( N_RN_c_1561_n N_noxref_7_c_2457_n ) capacitor c=0.00346017f \
 //x=16.715 //y=4.88 //x2=16.675 //y2=5.335
cc_1280 ( N_RN_c_1573_n N_noxref_7_c_2457_n ) capacitor c=0.00203307f \
 //x=16.715 //y=4.88 //x2=16.675 //y2=5.335
cc_1281 ( RN N_noxref_7_c_2461_n ) capacitor c=6.89957e-19 //x=16.715 //y=2.77 \
 //x2=17.455 //y2=4.25
cc_1282 ( RN N_noxref_7_c_2251_n ) capacitor c=0.0247f //x=16.715 //y=2.77 \
 //x2=17.3 //y2=4.25
cc_1283 ( N_RN_c_1550_n N_noxref_7_c_2251_n ) capacitor c=0.00332638f \
 //x=16.715 //y=4.75 //x2=17.3 //y2=4.25
cc_1284 ( N_RN_c_1483_n N_noxref_7_c_2251_n ) capacitor c=0.00784859f \
 //x=16.56 //y=2.315 //x2=17.3 //y2=4.25
cc_1285 ( RN N_noxref_7_c_2199_n ) capacitor c=0.0220634f //x=8.575 //y=2.77 \
 //x2=12.07 //y2=4.25
cc_1286 ( N_RN_c_1483_n N_noxref_7_c_2199_n ) capacitor c=0.00100647f \
 //x=16.56 //y=2.315 //x2=12.07 //y2=4.25
cc_1287 ( RN N_noxref_7_c_2406_n ) capacitor c=0.0334529f //x=20.415 //y=2.77 \
 //x2=19.51 //y2=4.265
cc_1288 ( N_RN_c_1589_n N_noxref_7_c_2406_n ) capacitor c=0.00104012f \
 //x=20.415 //y=2.515 //x2=19.51 //y2=4.265
cc_1289 ( N_RN_c_1593_n N_noxref_7_c_2406_n ) capacitor c=0.00326871f \
 //x=20.415 //y=4.765 //x2=19.51 //y2=4.265
cc_1290 ( N_RN_c_1607_n N_noxref_7_c_2406_n ) capacitor c=0.00368627f \
 //x=20.37 //y=2.355 //x2=19.51 //y2=4.265
cc_1291 ( N_RN_c_1609_n N_noxref_7_c_2406_n ) capacitor c=0.0137044f //x=20.21 \
 //y=2.355 //x2=19.51 //y2=4.265
cc_1292 ( RN N_noxref_7_c_2408_n ) capacitor c=0.00325739f //x=16.715 //y=2.77 \
 //x2=19.165 //y2=4.265
cc_1293 ( N_RN_c_1609_n N_noxref_7_c_2408_n ) capacitor c=0.00905576f \
 //x=20.21 //y=2.355 //x2=19.165 //y2=4.265
cc_1294 ( N_RN_c_1550_n N_noxref_7_c_2474_n ) capacitor c=0.00266858f \
 //x=16.715 //y=4.75 //x2=16.675 //y2=5.56
cc_1295 ( N_RN_c_1561_n N_noxref_7_c_2474_n ) capacitor c=0.00624059f \
 //x=16.715 //y=4.88 //x2=16.675 //y2=5.56
cc_1296 ( N_RN_M36_noxref_g N_noxref_7_c_2474_n ) capacitor c=0.0178885f \
 //x=16.455 //y=6.2 //x2=16.675 //y2=5.56
cc_1297 ( N_RN_M37_noxref_g N_noxref_7_c_2474_n ) capacitor c=0.0188608f \
 //x=16.895 //y=6.2 //x2=16.675 //y2=5.56
cc_1298 ( N_RN_c_1573_n N_noxref_7_c_2474_n ) capacitor c=0.00255197f \
 //x=16.715 //y=4.88 //x2=16.675 //y2=5.56
cc_1299 ( N_RN_c_1567_n N_noxref_7_M10_noxref_d ) capacitor c=0.00137165f \
 //x=16.705 //y=1.095 //x2=16.78 //y2=1.095
cc_1300 ( N_RN_c_1568_n N_noxref_7_M10_noxref_d ) capacitor c=0.00237422f \
 //x=16.705 //y=1.44 //x2=16.78 //y2=1.095
cc_1301 ( N_RN_c_1669_p N_noxref_7_M10_noxref_d ) capacitor c=0.0020782f \
 //x=17.08 //y=0.94 //x2=16.78 //y2=1.095
cc_1302 ( N_RN_c_1670_p N_noxref_7_M10_noxref_d ) capacitor c=0.00356097f \
 //x=17.08 //y=1.595 //x2=16.78 //y2=1.095
cc_1303 ( N_RN_c_1671_p N_noxref_7_M10_noxref_d ) capacitor c=0.00139206f \
 //x=17.235 //y=1.095 //x2=16.78 //y2=1.095
cc_1304 ( N_RN_c_1672_p N_noxref_7_M10_noxref_d ) capacitor c=0.00237422f \
 //x=17.235 //y=1.44 //x2=16.78 //y2=1.095
cc_1305 ( RN Q ) capacitor c=0.0363579f //x=20.415 //y=2.77 //x2=21.525 \
 //y2=2.77
cc_1306 ( N_RN_c_1589_n Q ) capacitor c=0.00248968f //x=20.415 //y=2.515 \
 //x2=21.525 //y2=2.77
cc_1307 ( N_RN_c_1607_n Q ) capacitor c=0.00247598f //x=20.37 //y=2.355 \
 //x2=21.525 //y2=2.77
cc_1308 ( RN Q ) capacitor c=0.0178119f //x=20.415 //y=2.77 //x2=21.525 \
 //y2=4.62
cc_1309 ( N_RN_c_1618_n Q ) capacitor c=2.8902e-19 //x=20.415 //y=4.88 \
 //x2=21.525 //y2=4.62
cc_1310 ( N_RN_c_1589_n N_Q_c_2790_n ) capacitor c=0.00770291f //x=20.415 \
 //y=2.515 //x2=21.525 //y2=2.375
cc_1311 ( N_RN_c_1607_n N_Q_c_2790_n ) capacitor c=0.00407348f //x=20.37 \
 //y=2.355 //x2=21.525 //y2=2.375
cc_1312 ( N_RN_c_1615_n N_Q_c_2790_n ) capacitor c=5.39999e-19 //x=20.415 \
 //y=2.26 //x2=21.525 //y2=2.375
cc_1313 ( N_RN_c_1633_n N_Q_c_2790_n ) capacitor c=0.00141318f //x=20.505 \
 //y=2.095 //x2=21.525 //y2=2.375
cc_1314 ( RN N_Q_c_2794_n ) capacitor c=0.00782712f //x=20.415 //y=2.77 \
 //x2=21.525 //y2=4.025
cc_1315 ( RN N_Q_c_2795_n ) capacitor c=6.3306e-19 //x=20.415 //y=2.77 \
 //x2=21.525 //y2=4.75
cc_1316 ( N_RN_c_1593_n N_Q_c_2795_n ) capacitor c=0.0107551f //x=20.415 \
 //y=4.765 //x2=21.525 //y2=4.75
cc_1317 ( N_RN_c_1618_n N_Q_c_2795_n ) capacitor c=6.63375e-19 //x=20.415 \
 //y=4.88 //x2=21.525 //y2=4.75
cc_1318 ( N_RN_c_1636_n N_Q_c_2795_n ) capacitor c=8.42568e-19 //x=20.415 \
 //y=4.88 //x2=21.525 //y2=4.75
cc_1319 ( RN N_Q_c_2783_n ) capacitor c=3.40764e-19 //x=20.415 //y=2.77 \
 //x2=21.525 //y2=3.88
cc_1320 ( RN N_Q_c_2784_n ) capacitor c=0.00327046f //x=20.415 //y=2.77 \
 //x2=21.685 //y2=3.865
cc_1321 ( N_RN_c_1589_n N_Q_c_2801_n ) capacitor c=8.86271e-19 //x=20.415 \
 //y=2.515 //x2=21.525 //y2=2.26
cc_1322 ( N_RN_c_1615_n N_Q_c_2801_n ) capacitor c=0.00124918f //x=20.415 \
 //y=2.26 //x2=21.525 //y2=2.26
cc_1323 ( N_RN_c_1633_n N_Q_c_2801_n ) capacitor c=0.00209664f //x=20.505 \
 //y=2.095 //x2=21.525 //y2=2.26
cc_1324 ( RN N_Q_c_2804_n ) capacitor c=2.94497e-19 //x=20.415 //y=2.77 \
 //x2=21.525 //y2=4.88
cc_1325 ( N_RN_c_1593_n N_Q_c_2804_n ) capacitor c=4.56604e-19 //x=20.415 \
 //y=4.765 //x2=21.525 //y2=4.88
cc_1326 ( N_RN_c_1618_n N_Q_c_2804_n ) capacitor c=0.00113985f //x=20.415 \
 //y=4.88 //x2=21.525 //y2=4.88
cc_1327 ( N_RN_c_1636_n N_Q_c_2804_n ) capacitor c=0.00129812f //x=20.415 \
 //y=4.88 //x2=21.525 //y2=4.88
cc_1328 ( N_RN_M40_noxref_g N_Q_M42_noxref_g ) capacitor c=0.0101598f \
 //x=20.385 //y=6.2 //x2=21.265 //y2=6.2
cc_1329 ( N_RN_M41_noxref_g N_Q_M42_noxref_g ) capacitor c=0.0607518f \
 //x=20.825 //y=6.2 //x2=21.265 //y2=6.2
cc_1330 ( N_RN_M41_noxref_g N_Q_M43_noxref_g ) capacitor c=0.0101598f \
 //x=20.825 //y=6.2 //x2=21.705 //y2=6.2
cc_1331 ( N_RN_c_1630_n N_Q_c_2811_n ) capacitor c=0.00456962f //x=20.505 \
 //y=1.09 //x2=21.515 //y2=1.095
cc_1332 ( N_RN_c_1631_n N_Q_c_2812_n ) capacitor c=0.00438372f //x=20.505 \
 //y=1.4 //x2=21.515 //y2=1.44
cc_1333 ( N_RN_c_1632_n N_Q_c_2813_n ) capacitor c=0.00438372f //x=20.505 \
 //y=1.63 //x2=21.515 //y2=1.75
cc_1334 ( N_RN_c_1589_n N_Q_c_2814_n ) capacitor c=0.00156352f //x=20.415 \
 //y=2.515 //x2=21.525 //y2=2.26
cc_1335 ( N_RN_c_1615_n N_Q_c_2814_n ) capacitor c=0.00204796f //x=20.415 \
 //y=2.26 //x2=21.525 //y2=2.26
cc_1336 ( N_RN_c_1633_n N_Q_c_2814_n ) capacitor c=0.00933826f //x=20.505 \
 //y=2.095 //x2=21.525 //y2=2.26
cc_1337 ( N_RN_c_1633_n N_Q_c_2817_n ) capacitor c=0.00438372f //x=20.505 \
 //y=2.095 //x2=21.525 //y2=2.095
cc_1338 ( N_RN_c_1593_n N_Q_c_2818_n ) capacitor c=0.00124604f //x=20.415 \
 //y=4.765 //x2=21.525 //y2=4.88
cc_1339 ( N_RN_c_1618_n N_Q_c_2818_n ) capacitor c=0.00187046f //x=20.415 \
 //y=4.88 //x2=21.525 //y2=4.88
cc_1340 ( N_RN_c_1652_p N_Q_c_2818_n ) capacitor c=0.0616777f //x=20.75 \
 //y=4.97 //x2=21.525 //y2=4.88
cc_1341 ( N_RN_c_1636_n N_Q_c_2818_n ) capacitor c=0.00487508f //x=20.415 \
 //y=4.88 //x2=21.525 //y2=4.88
cc_1342 ( N_RN_M26_noxref_g N_VDD_c_3065_n ) capacitor c=0.00755544f //x=8.315 \
 //y=6.2 //x2=8.89 //y2=7.585
cc_1343 ( N_RN_M27_noxref_g N_VDD_c_3065_n ) capacitor c=0.00755754f //x=8.755 \
 //y=6.2 //x2=8.89 //y2=7.585
cc_1344 ( N_RN_M36_noxref_g N_VDD_c_3233_n ) capacitor c=0.00755544f \
 //x=16.455 //y=6.2 //x2=17.03 //y2=7.585
cc_1345 ( N_RN_M37_noxref_g N_VDD_c_3233_n ) capacitor c=0.00755754f \
 //x=16.895 //y=6.2 //x2=17.03 //y2=7.585
cc_1346 ( N_RN_M40_noxref_g N_VDD_c_3235_n ) capacitor c=0.00705252f \
 //x=20.385 //y=6.2 //x2=20.96 //y2=7.585
cc_1347 ( N_RN_M41_noxref_g N_VDD_c_3235_n ) capacitor c=0.00755544f \
 //x=20.825 //y=6.2 //x2=20.96 //y2=7.585
cc_1348 ( N_RN_c_1494_n N_VDD_c_3077_n ) capacitor c=0.00224736f //x=8.575 \
 //y=4.88 //x2=10.055 //y2=7.585
cc_1349 ( N_RN_c_1525_n N_VDD_c_3077_n ) capacitor c=2.63786e-19 //x=8.575 \
 //y=4.88 //x2=10.055 //y2=7.585
cc_1350 ( N_RN_c_1561_n N_VDD_c_3202_n ) capacitor c=0.00224736f //x=16.715 \
 //y=4.88 //x2=18.195 //y2=7.585
cc_1351 ( N_RN_c_1573_n N_VDD_c_3202_n ) capacitor c=2.63786e-19 //x=16.715 \
 //y=4.88 //x2=18.195 //y2=7.585
cc_1352 ( N_RN_M26_noxref_g N_VDD_M25_noxref_d ) capacitor c=0.015318f \
 //x=8.315 //y=6.2 //x2=7.95 //y2=5.2
cc_1353 ( N_RN_M27_noxref_g N_VDD_M27_noxref_d ) capacitor c=0.0394719f \
 //x=8.755 //y=6.2 //x2=8.83 //y2=5.2
cc_1354 ( N_RN_M36_noxref_g N_VDD_M35_noxref_d ) capacitor c=0.015318f \
 //x=16.455 //y=6.2 //x2=16.09 //y2=5.2
cc_1355 ( N_RN_M37_noxref_g N_VDD_M37_noxref_d ) capacitor c=0.0394719f \
 //x=16.895 //y=6.2 //x2=16.97 //y2=5.2
cc_1356 ( N_RN_M40_noxref_g N_VDD_M39_noxref_d ) capacitor c=0.015318f \
 //x=20.385 //y=6.2 //x2=20.02 //y2=5.2
cc_1357 ( N_RN_M41_noxref_g N_VDD_M41_noxref_d ) capacitor c=0.015318f \
 //x=20.825 //y=6.2 //x2=20.9 //y2=5.2
cc_1358 ( N_RN_c_1476_n N_noxref_11_c_3504_n ) capacitor c=0.00171382f \
 //x=8.58 //y=2.305 //x2=9.23 //y2=0.72
cc_1359 ( N_RN_c_1493_n N_noxref_11_c_3504_n ) capacitor c=0.00117306f \
 //x=8.575 //y=2.26 //x2=9.23 //y2=0.72
cc_1360 ( N_RN_c_1504_n N_noxref_11_c_3504_n ) capacitor c=0.0206349f \
 //x=8.565 //y=1.095 //x2=9.23 //y2=0.72
cc_1361 ( N_RN_c_1516_n N_noxref_11_c_3504_n ) capacitor c=0.00825432f \
 //x=9.095 //y=1.095 //x2=9.23 //y2=0.72
cc_1362 ( N_RN_c_1522_n N_noxref_11_c_3504_n ) capacitor c=2.20712e-19 \
 //x=8.575 //y=2.26 //x2=9.23 //y2=0.72
cc_1363 ( N_RN_c_1506_n N_noxref_11_c_3507_n ) capacitor c=0.0071177f \
 //x=8.565 //y=1.44 //x2=8.345 //y2=1.175
cc_1364 ( N_RN_c_1476_n N_noxref_11_M5_noxref_s ) capacitor c=4.5489e-19 \
 //x=8.58 //y=2.305 //x2=8.21 //y2=0.555
cc_1365 ( N_RN_c_1504_n N_noxref_11_M5_noxref_s ) capacitor c=0.0071177f \
 //x=8.565 //y=1.095 //x2=8.21 //y2=0.555
cc_1366 ( N_RN_c_1509_n N_noxref_11_M5_noxref_s ) capacitor c=0.0071177f \
 //x=8.565 //y=1.75 //x2=8.21 //y2=0.555
cc_1367 ( N_RN_c_1516_n N_noxref_11_M5_noxref_s ) capacitor c=0.015333f \
 //x=9.095 //y=1.095 //x2=8.21 //y2=0.555
cc_1368 ( N_RN_c_1518_n N_noxref_11_M5_noxref_s ) capacitor c=0.00248746f \
 //x=9.095 //y=1.44 //x2=8.21 //y2=0.555
cc_1369 ( N_RN_c_1472_n D ) capacitor c=6.3306e-19 //x=8.575 //y=4.75 \
 //x2=7.465 //y2=2.77
cc_1370 ( N_RN_c_1476_n D ) capacitor c=0.0587337f //x=8.58 //y=2.305 \
 //x2=7.465 //y2=2.77
cc_1371 ( N_RN_c_1480_n D ) capacitor c=0.00216715f //x=8.58 //y=2.305 \
 //x2=7.465 //y2=2.77
cc_1372 ( N_RN_c_1494_n D ) capacitor c=2.94497e-19 //x=8.575 //y=4.88 \
 //x2=7.465 //y2=2.77
cc_1373 ( N_RN_c_1476_n N_D_c_3574_n ) capacitor c=0.00720438f //x=8.58 \
 //y=2.305 //x2=7.465 //y2=2.375
cc_1374 ( N_RN_c_1480_n N_D_c_3574_n ) capacitor c=0.00526813f //x=8.58 \
 //y=2.305 //x2=7.465 //y2=2.375
cc_1375 ( N_RN_c_1493_n N_D_c_3574_n ) capacitor c=6.92676e-19 //x=8.575 \
 //y=2.26 //x2=7.465 //y2=2.375
cc_1376 ( N_RN_c_1472_n N_D_c_3575_n ) capacitor c=0.0107551f //x=8.575 \
 //y=4.75 //x2=7.465 //y2=4.765
cc_1377 ( N_RN_c_1494_n N_D_c_3575_n ) capacitor c=4.56604e-19 //x=8.575 \
 //y=4.88 //x2=7.465 //y2=4.765
cc_1378 ( N_RN_c_1525_n N_D_c_3575_n ) capacitor c=0.00124604f //x=8.575 \
 //y=4.88 //x2=7.465 //y2=4.765
cc_1379 ( N_RN_c_1476_n N_D_c_3607_n ) capacitor c=9.53526e-19 //x=8.58 \
 //y=2.305 //x2=7.465 //y2=2.26
cc_1380 ( N_RN_c_1493_n N_D_c_3607_n ) capacitor c=0.00129119f //x=8.575 \
 //y=2.26 //x2=7.465 //y2=2.26
cc_1381 ( N_RN_c_1522_n N_D_c_3607_n ) capacitor c=0.00155537f //x=8.575 \
 //y=2.26 //x2=7.465 //y2=2.26
cc_1382 ( RN N_D_c_3578_n ) capacitor c=2.8902e-19 //x=8.575 //y=2.77 \
 //x2=7.465 //y2=4.88
cc_1383 ( N_RN_c_1472_n N_D_c_3578_n ) capacitor c=6.63375e-19 //x=8.575 \
 //y=4.75 //x2=7.465 //y2=4.88
cc_1384 ( N_RN_c_1494_n N_D_c_3578_n ) capacitor c=0.00113985f //x=8.575 \
 //y=4.88 //x2=7.465 //y2=4.88
cc_1385 ( N_RN_c_1525_n N_D_c_3578_n ) capacitor c=0.00187046f //x=8.575 \
 //y=4.88 //x2=7.465 //y2=4.88
cc_1386 ( N_RN_M26_noxref_g N_D_M24_noxref_g ) capacitor c=0.0101598f \
 //x=8.315 //y=6.2 //x2=7.435 //y2=6.2
cc_1387 ( N_RN_M26_noxref_g N_D_M25_noxref_g ) capacitor c=0.0607518f \
 //x=8.315 //y=6.2 //x2=7.875 //y2=6.2
cc_1388 ( N_RN_M27_noxref_g N_D_M25_noxref_g ) capacitor c=0.0101598f \
 //x=8.755 //y=6.2 //x2=7.875 //y2=6.2
cc_1389 ( N_RN_c_1504_n N_D_c_3623_n ) capacitor c=0.00456962f //x=8.565 \
 //y=1.095 //x2=7.555 //y2=1.09
cc_1390 ( N_RN_c_1506_n N_D_c_3624_n ) capacitor c=0.00438372f //x=8.565 \
 //y=1.44 //x2=7.555 //y2=1.4
cc_1391 ( N_RN_c_1509_n N_D_c_3625_n ) capacitor c=0.00438372f //x=8.565 \
 //y=1.75 //x2=7.555 //y2=1.63
cc_1392 ( N_RN_c_1476_n N_D_c_3626_n ) capacitor c=0.00135583f //x=8.58 \
 //y=2.305 //x2=7.555 //y2=2.095
cc_1393 ( N_RN_c_1493_n N_D_c_3626_n ) capacitor c=0.00210314f //x=8.575 \
 //y=2.26 //x2=7.555 //y2=2.095
cc_1394 ( N_RN_c_1522_n N_D_c_3626_n ) capacitor c=0.00831559f //x=8.575 \
 //y=2.26 //x2=7.555 //y2=2.095
cc_1395 ( N_RN_c_1523_n N_D_c_3626_n ) capacitor c=0.00438372f //x=8.575 \
 //y=2.095 //x2=7.555 //y2=2.095
cc_1396 ( N_RN_c_1525_n N_D_c_3586_n ) capacitor c=0.0616777f //x=8.575 \
 //y=4.88 //x2=7.8 //y2=4.97
cc_1397 ( N_RN_c_1472_n N_D_c_3588_n ) capacitor c=8.42568e-19 //x=8.575 \
 //y=4.75 //x2=7.465 //y2=4.88
cc_1398 ( N_RN_c_1494_n N_D_c_3588_n ) capacitor c=0.00129812f //x=8.575 \
 //y=4.88 //x2=7.465 //y2=4.88
cc_1399 ( N_RN_c_1525_n N_D_c_3588_n ) capacitor c=0.00487508f //x=8.575 \
 //y=4.88 //x2=7.465 //y2=4.88
cc_1400 ( N_RN_c_1483_n N_noxref_13_c_3695_n ) capacitor c=0.00519491f \
 //x=16.56 //y=2.315 //x2=16.4 //y2=1.175
cc_1401 ( RN N_noxref_13_c_3711_n ) capacitor c=0.00171044f //x=16.715 //y=2.4 \
 //x2=17.37 //y2=0.72
cc_1402 ( N_RN_c_1558_n N_noxref_13_c_3711_n ) capacitor c=0.00117306f \
 //x=16.715 //y=2.26 //x2=17.37 //y2=0.72
cc_1403 ( N_RN_c_1567_n N_noxref_13_c_3711_n ) capacitor c=0.0206349f \
 //x=16.705 //y=1.095 //x2=17.37 //y2=0.72
cc_1404 ( N_RN_c_1671_p N_noxref_13_c_3711_n ) capacitor c=0.00825432f \
 //x=17.235 //y=1.095 //x2=17.37 //y2=0.72
cc_1405 ( N_RN_c_1570_n N_noxref_13_c_3711_n ) capacitor c=2.20712e-19 \
 //x=16.715 //y=2.26 //x2=17.37 //y2=0.72
cc_1406 ( N_RN_c_1568_n N_noxref_13_c_3716_n ) capacitor c=0.0071177f \
 //x=16.705 //y=1.44 //x2=16.485 //y2=1.175
cc_1407 ( N_RN_c_1483_n N_noxref_13_M9_noxref_d ) capacitor c=0.00716163f \
 //x=16.56 //y=2.315 //x2=15.245 //y2=1.09
cc_1408 ( RN N_noxref_13_M10_noxref_s ) capacitor c=4.5489e-19 //x=16.715 \
 //y=2.4 //x2=16.35 //y2=0.555
cc_1409 ( N_RN_c_1483_n N_noxref_13_M10_noxref_s ) capacitor c=0.00417477f \
 //x=16.56 //y=2.315 //x2=16.35 //y2=0.555
cc_1410 ( N_RN_c_1567_n N_noxref_13_M10_noxref_s ) capacitor c=0.0071177f \
 //x=16.705 //y=1.095 //x2=16.35 //y2=0.555
cc_1411 ( N_RN_c_1569_n N_noxref_13_M10_noxref_s ) capacitor c=0.0071177f \
 //x=16.705 //y=1.75 //x2=16.35 //y2=0.555
cc_1412 ( N_RN_c_1671_p N_noxref_13_M10_noxref_s ) capacitor c=0.015333f \
 //x=17.235 //y=1.095 //x2=16.35 //y2=0.555
cc_1413 ( N_RN_c_1672_p N_noxref_13_M10_noxref_s ) capacitor c=0.00248746f \
 //x=17.235 //y=1.44 //x2=16.35 //y2=0.555
cc_1414 ( N_RN_c_1630_n N_noxref_14_c_3763_n ) capacitor c=0.00123426f \
 //x=20.505 //y=1.09 //x2=21.21 //y2=1.175
cc_1415 ( N_RN_c_1631_n N_noxref_14_c_3763_n ) capacitor c=0.0129288f \
 //x=20.505 //y=1.4 //x2=21.21 //y2=1.175
cc_1416 ( N_RN_c_1632_n N_noxref_14_c_3763_n ) capacitor c=0.00132209f \
 //x=20.505 //y=1.63 //x2=21.21 //y2=1.175
cc_1417 ( N_RN_c_1589_n N_noxref_14_M12_noxref_d ) capacitor c=0.00745753f \
 //x=20.415 //y=2.515 //x2=20.055 //y2=1.09
cc_1418 ( N_RN_c_1607_n N_noxref_14_M12_noxref_d ) capacitor c=0.00198091f \
 //x=20.37 //y=2.355 //x2=20.055 //y2=1.09
cc_1419 ( N_RN_c_1609_n N_noxref_14_M12_noxref_d ) capacitor c=0.00369679f \
 //x=20.21 //y=2.355 //x2=20.055 //y2=1.09
cc_1420 ( N_RN_c_1615_n N_noxref_14_M12_noxref_d ) capacitor c=2.2052e-19 \
 //x=20.415 //y=2.26 //x2=20.055 //y2=1.09
cc_1421 ( N_RN_c_1625_n N_noxref_14_M12_noxref_d ) capacitor c=0.00253592f \
 //x=19.98 //y=1.09 //x2=20.055 //y2=1.09
cc_1422 ( N_RN_c_1628_n N_noxref_14_M12_noxref_d ) capacitor c=0.00604087f \
 //x=19.98 //y=1.4 //x2=20.055 //y2=1.09
cc_1423 ( N_RN_c_1842_p N_noxref_14_M12_noxref_d ) capacitor c=0.002686f \
 //x=20.35 //y=0.935 //x2=20.055 //y2=1.09
cc_1424 ( N_RN_c_1843_p N_noxref_14_M12_noxref_d ) capacitor c=0.00251995f \
 //x=20.35 //y=1.555 //x2=20.055 //y2=1.09
cc_1425 ( N_RN_c_1630_n N_noxref_14_M12_noxref_d ) capacitor c=0.00314523f \
 //x=20.505 //y=1.09 //x2=20.055 //y2=1.09
cc_1426 ( N_RN_c_1631_n N_noxref_14_M12_noxref_d ) capacitor c=0.00168289f \
 //x=20.505 //y=1.4 //x2=20.055 //y2=1.09
cc_1427 ( N_RN_c_1632_n N_noxref_14_M12_noxref_d ) capacitor c=0.00111165f \
 //x=20.505 //y=1.63 //x2=20.055 //y2=1.09
cc_1428 ( N_RN_c_1630_n N_noxref_14_M13_noxref_s ) capacitor c=7.21316e-19 \
 //x=20.505 //y=1.09 //x2=21.16 //y2=0.555
cc_1429 ( N_RN_c_1631_n N_noxref_14_M13_noxref_s ) capacitor c=0.00365271f \
 //x=20.505 //y=1.4 //x2=21.16 //y2=0.555
cc_1430 ( N_RN_c_1633_n N_noxref_14_M13_noxref_s ) capacitor c=9.86711e-19 \
 //x=20.505 //y=2.095 //x2=21.16 //y2=0.555
cc_1431 ( N_RN_c_1476_n N_GND_c_3831_n ) capacitor c=0.00180135f //x=8.58 \
 //y=2.305 //x2=11.15 //y2=0.175
cc_1432 ( N_RN_c_1480_n N_GND_c_3831_n ) capacitor c=0.00547297f //x=8.58 \
 //y=2.305 //x2=11.15 //y2=0.175
cc_1433 ( N_RN_c_1483_n N_GND_c_3831_n ) capacitor c=0.0649595f //x=16.56 \
 //y=2.315 //x2=11.15 //y2=0.175
cc_1434 ( N_RN_c_1483_n N_GND_c_3871_n ) capacitor c=0.0803007f //x=16.56 \
 //y=2.315 //x2=14.375 //y2=0.175
cc_1435 ( RN N_GND_c_3913_n ) capacitor c=0.00180101f //x=16.715 //y=2.4 \
 //x2=19.185 //y2=0.175
cc_1436 ( N_RN_c_1483_n N_GND_c_3913_n ) capacitor c=0.0522514f //x=16.56 \
 //y=2.315 //x2=19.185 //y2=0.175
cc_1437 ( N_RN_c_1557_n N_GND_c_3913_n ) capacitor c=0.00547191f //x=16.88 \
 //y=2.315 //x2=19.185 //y2=0.175
cc_1438 ( N_RN_c_1609_n N_GND_c_3913_n ) capacitor c=0.0632004f //x=20.21 \
 //y=2.355 //x2=19.185 //y2=0.175
cc_1439 ( N_RN_c_1589_n N_GND_c_3983_n ) capacitor c=8.03219e-19 //x=20.415 \
 //y=2.515 //x2=24.1 //y2=0.175
cc_1440 ( N_RN_c_1607_n N_GND_c_3983_n ) capacitor c=0.00258052f //x=20.37 \
 //y=2.355 //x2=24.1 //y2=0.175
cc_1441 ( N_RN_c_1609_n N_GND_c_3983_n ) capacitor c=0.0200728f //x=20.21 \
 //y=2.355 //x2=24.1 //y2=0.175
cc_1442 ( N_RN_c_1483_n N_GND_c_3835_n ) capacitor c=0.00555478f //x=16.56 \
 //y=2.315 //x2=11.235 //y2=1.135
cc_1443 ( N_RN_c_1483_n N_GND_c_3881_n ) capacitor c=0.00505125f //x=16.56 \
 //y=2.315 //x2=14.46 //y2=1.145
cc_1444 ( N_RN_c_1609_n N_GND_c_3935_n ) capacitor c=0.0050997f //x=20.21 \
 //y=2.355 //x2=19.27 //y2=1.145
cc_1445 ( N_RN_c_1483_n N_GND_c_3856_n ) capacitor c=0.0221857f //x=16.56 \
 //y=2.315 //x2=10.055 //y2=0.175
cc_1446 ( N_RN_c_1493_n N_GND_c_3856_n ) capacitor c=0.00224448f //x=8.575 \
 //y=2.26 //x2=10.055 //y2=0.175
cc_1447 ( N_RN_c_1518_n N_GND_c_3856_n ) capacitor c=0.00262688f //x=9.095 \
 //y=1.44 //x2=10.055 //y2=0.175
cc_1448 ( N_RN_c_1522_n N_GND_c_3856_n ) capacitor c=2.63786e-19 //x=8.575 \
 //y=2.26 //x2=10.055 //y2=0.175
cc_1449 ( N_RN_c_1483_n N_GND_c_3896_n ) capacitor c=0.0222613f //x=16.56 \
 //y=2.315 //x2=13.385 //y2=0.175
cc_1450 ( N_RN_c_1609_n N_GND_c_3955_n ) capacitor c=0.0227826f //x=20.21 \
 //y=2.355 //x2=18.195 //y2=0.175
cc_1451 ( N_RN_c_1558_n N_GND_c_3955_n ) capacitor c=0.00218156f //x=16.715 \
 //y=2.26 //x2=18.195 //y2=0.175
cc_1452 ( N_RN_c_1672_p N_GND_c_3955_n ) capacitor c=0.00262688f //x=17.235 \
 //y=1.44 //x2=18.195 //y2=0.175
cc_1453 ( N_RN_c_1570_n N_GND_c_3955_n ) capacitor c=2.63786e-19 //x=16.715 \
 //y=2.26 //x2=18.195 //y2=0.175
cc_1454 ( N_RN_c_1483_n N_noxref_18_c_4399_n ) capacitor c=0.00442321f \
 //x=16.56 //y=2.315 //x2=10.75 //y2=1.675
cc_1455 ( N_RN_c_1483_n N_noxref_18_c_4400_n ) capacitor c=0.0127909f \
 //x=16.56 //y=2.315 //x2=11.635 //y2=1.76
cc_1456 ( N_RN_c_1483_n N_noxref_18_c_4407_n ) capacitor c=0.00436444f \
 //x=16.56 //y=2.315 //x2=11.72 //y2=1.675
cc_1457 ( N_RN_c_1483_n N_noxref_18_c_4412_n ) capacitor c=8.17446e-19 \
 //x=16.56 //y=2.315 //x2=12.605 //y2=0.71
cc_1458 ( N_RN_c_1483_n N_noxref_18_M6_noxref_s ) capacitor c=0.0010705f \
 //x=16.56 //y=2.315 //x2=10.615 //y2=0.545
cc_1459 ( N_RN_c_1483_n N_noxref_19_c_4467_n ) capacitor c=0.00444844f \
 //x=16.56 //y=2.315 //x2=13.975 //y2=1.685
cc_1460 ( N_RN_c_1483_n N_noxref_19_c_4468_n ) capacitor c=0.0132119f \
 //x=16.56 //y=2.315 //x2=14.86 //y2=1.77
cc_1461 ( N_RN_c_1483_n N_noxref_19_c_4481_n ) capacitor c=0.0113756f \
 //x=16.56 //y=2.315 //x2=15.83 //y2=1.77
cc_1462 ( N_RN_c_1483_n N_noxref_19_M8_noxref_s ) capacitor c=0.00828583f \
 //x=16.56 //y=2.315 //x2=13.84 //y2=0.555
cc_1463 ( N_RN_c_1609_n N_noxref_20_c_4526_n ) capacitor c=0.00444844f \
 //x=20.21 //y=2.355 //x2=18.785 //y2=1.685
cc_1464 ( N_RN_c_1609_n N_noxref_20_c_4527_n ) capacitor c=0.0131925f \
 //x=20.21 //y=2.355 //x2=19.67 //y2=1.77
cc_1465 ( N_RN_c_1625_n N_noxref_20_c_4540_n ) capacitor c=0.0167228f \
 //x=19.98 //y=1.09 //x2=20.64 //y2=0.72
cc_1466 ( N_RN_c_1630_n N_noxref_20_c_4540_n ) capacitor c=0.00534519f \
 //x=20.505 //y=1.09 //x2=20.64 //y2=0.72
cc_1467 ( N_RN_c_1589_n N_noxref_20_c_4542_n ) capacitor c=0.00739862f \
 //x=20.415 //y=2.515 //x2=20.64 //y2=1.77
cc_1468 ( N_RN_c_1609_n N_noxref_20_c_4542_n ) capacitor c=0.00730092f \
 //x=20.21 //y=2.355 //x2=20.64 //y2=1.77
cc_1469 ( N_RN_c_1615_n N_noxref_20_c_4542_n ) capacitor c=0.0105652f \
 //x=20.415 //y=2.26 //x2=20.64 //y2=1.77
cc_1470 ( N_RN_c_1628_n N_noxref_20_c_4542_n ) capacitor c=0.0155011f \
 //x=19.98 //y=1.4 //x2=20.64 //y2=1.77
cc_1471 ( N_RN_c_1633_n N_noxref_20_c_4542_n ) capacitor c=0.0223685f \
 //x=20.505 //y=2.095 //x2=20.64 //y2=1.77
cc_1472 ( N_RN_c_1609_n N_noxref_20_M11_noxref_s ) capacitor c=0.00419984f \
 //x=20.21 //y=2.355 //x2=18.65 //y2=0.555
cc_1473 ( N_RN_c_1625_n N_noxref_20_M11_noxref_s ) capacitor c=0.00798959f \
 //x=19.98 //y=1.09 //x2=18.65 //y2=0.555
cc_1474 ( N_RN_c_1632_n N_noxref_20_M11_noxref_s ) capacitor c=0.00212176f \
 //x=20.505 //y=1.63 //x2=18.65 //y2=0.555
cc_1475 ( N_RN_c_1633_n N_noxref_20_M11_noxref_s ) capacitor c=0.00298115f \
 //x=20.505 //y=2.095 //x2=18.65 //y2=0.555
cc_1476 ( N_noxref_6_c_1896_n N_noxref_7_c_2420_n ) capacitor c=6.09703e-19 \
 //x=19.727 //y=5.335 //x2=16.675 //y2=5.56
cc_1477 ( N_noxref_6_c_1896_n N_noxref_7_c_2422_n ) capacitor c=0.00306432f \
 //x=19.727 //y=5.335 //x2=17.37 //y2=5.335
cc_1478 ( N_noxref_6_c_1921_p N_noxref_7_c_2439_n ) capacitor c=0.00163399f \
 //x=21.865 //y=1.845 //x2=17.37 //y2=1.845
cc_1479 ( N_noxref_6_c_1908_n N_noxref_7_c_2488_n ) capacitor c=0.0021282f \
 //x=22.265 //y=3.335 //x2=24.855 //y2=4.095
cc_1480 ( N_noxref_6_c_1909_n N_noxref_7_c_2488_n ) capacitor c=7.07849e-19 \
 //x=22.265 //y=5.25 //x2=24.855 //y2=4.095
cc_1481 ( N_noxref_6_c_1924_p N_noxref_7_c_2488_n ) capacitor c=0.0422235f \
 //x=24.115 //y=3.335 //x2=24.855 //y2=4.095
cc_1482 ( N_noxref_6_c_1925_p N_noxref_7_c_2488_n ) capacitor c=0.014957f \
 //x=24.115 //y=3.655 //x2=24.855 //y2=4.095
cc_1483 ( N_noxref_6_c_1926_p N_noxref_7_c_2488_n ) capacitor c=7.6985e-19 \
 //x=24.115 //y=3.51 //x2=24.855 //y2=4.095
cc_1484 ( N_noxref_6_c_1927_p N_noxref_7_c_2488_n ) capacitor c=0.0166805f \
 //x=24.117 //y=4.74 //x2=24.855 //y2=4.095
cc_1485 ( N_noxref_6_c_1928_p N_noxref_7_c_2488_n ) capacitor c=0.00693435f \
 //x=24.11 //y=3.495 //x2=24.855 //y2=4.095
cc_1486 ( N_noxref_6_c_1929_p N_noxref_7_c_2488_n ) capacitor c=3.49899e-19 \
 //x=24.115 //y=2.26 //x2=24.855 //y2=4.095
cc_1487 ( N_noxref_6_c_1927_p N_noxref_7_c_2496_n ) capacitor c=0.0174568f \
 //x=24.117 //y=4.74 //x2=24.855 //y2=4.415
cc_1488 ( N_noxref_6_c_1909_n N_noxref_7_c_2497_n ) capacitor c=0.00133526f \
 //x=22.265 //y=5.25 //x2=24.855 //y2=4.735
cc_1489 ( N_noxref_6_c_1932_p N_noxref_7_c_2497_n ) capacitor c=0.0172939f \
 //x=24.115 //y=4.88 //x2=24.855 //y2=4.735
cc_1490 ( N_noxref_6_c_1927_p N_noxref_7_c_2497_n ) capacitor c=0.0136061f \
 //x=24.117 //y=4.74 //x2=24.855 //y2=4.735
cc_1491 ( N_noxref_6_c_1934_p N_noxref_7_c_2497_n ) capacitor c=7.76143e-19 \
 //x=24.115 //y=4.88 //x2=24.855 //y2=4.735
cc_1492 ( N_noxref_6_c_1935_p N_noxref_7_c_2497_n ) capacitor c=0.00201171f \
 //x=24.115 //y=4.88 //x2=24.855 //y2=4.735
cc_1493 ( N_noxref_6_c_1927_p N_noxref_7_c_2502_n ) capacitor c=6.89957e-19 \
 //x=24.117 //y=4.74 //x2=24.855 //y2=4.25
cc_1494 ( N_noxref_6_c_1937_p N_noxref_7_c_2503_n ) capacitor c=0.0205342f \
 //x=24.115 //y=2.26 //x2=24.855 //y2=2.26
cc_1495 ( N_noxref_6_c_1929_p N_noxref_7_c_2503_n ) capacitor c=5.16867e-19 \
 //x=24.115 //y=2.26 //x2=24.855 //y2=2.26
cc_1496 ( N_noxref_6_c_1939_p N_noxref_7_c_2503_n ) capacitor c=0.00167888f \
 //x=23.92 //y=2.095 //x2=24.855 //y2=2.26
cc_1497 ( N_noxref_6_c_1940_p N_noxref_7_c_2406_n ) capacitor c=0.0138535f \
 //x=22.18 //y=5.335 //x2=19.51 //y2=4.265
cc_1498 ( N_noxref_6_c_1909_n N_noxref_7_c_2406_n ) capacitor c=0.0300465f \
 //x=22.265 //y=5.25 //x2=19.51 //y2=4.265
cc_1499 ( N_noxref_6_c_1896_n N_noxref_7_c_2406_n ) capacitor c=0.0233355f \
 //x=19.727 //y=5.335 //x2=19.51 //y2=4.265
cc_1500 ( N_noxref_6_c_1910_n N_noxref_7_c_2406_n ) capacitor c=0.0327141f \
 //x=20.605 //y=5.335 //x2=19.51 //y2=4.265
cc_1501 ( N_noxref_6_c_1932_p N_noxref_7_c_2406_n ) capacitor c=0.00288386f \
 //x=24.115 //y=4.88 //x2=19.51 //y2=4.265
cc_1502 ( N_noxref_6_c_1927_p N_noxref_7_c_2406_n ) capacitor c=0.0295438f \
 //x=24.117 //y=4.74 //x2=19.51 //y2=4.265
cc_1503 ( N_noxref_6_c_1946_p N_noxref_7_c_2406_n ) capacitor c=0.00973177f \
 //x=23.95 //y=3.495 //x2=19.51 //y2=4.265
cc_1504 ( N_noxref_6_c_1924_p N_noxref_7_c_2513_n ) capacitor c=3.49899e-19 \
 //x=24.115 //y=3.335 //x2=24.855 //y2=2.26
cc_1505 ( N_noxref_6_c_1937_p N_noxref_7_c_2513_n ) capacitor c=5.24723e-19 \
 //x=24.115 //y=2.26 //x2=24.855 //y2=2.26
cc_1506 ( N_noxref_6_c_1929_p N_noxref_7_c_2513_n ) capacitor c=0.00445529f \
 //x=24.115 //y=2.26 //x2=24.855 //y2=2.26
cc_1507 ( N_noxref_6_c_1939_p N_noxref_7_c_2513_n ) capacitor c=0.00267961f \
 //x=23.92 //y=2.095 //x2=24.855 //y2=2.26
cc_1508 ( N_noxref_6_c_1932_p N_noxref_7_c_2517_n ) capacitor c=4.80626e-19 \
 //x=24.115 //y=4.88 //x2=24.885 //y2=4.88
cc_1509 ( N_noxref_6_c_1934_p N_noxref_7_c_2517_n ) capacitor c=0.00397338f \
 //x=24.115 //y=4.88 //x2=24.885 //y2=4.88
cc_1510 ( N_noxref_6_c_1935_p N_noxref_7_c_2517_n ) capacitor c=0.00283894f \
 //x=24.115 //y=4.88 //x2=24.885 //y2=4.88
cc_1511 ( N_noxref_6_M44_noxref_g N_noxref_7_M46_noxref_g ) capacitor \
 c=0.0104892f //x=24.015 //y=6.2 //x2=24.895 //y2=6.2
cc_1512 ( N_noxref_6_M45_noxref_g N_noxref_7_M46_noxref_g ) capacitor \
 c=0.107636f //x=24.455 //y=6.2 //x2=24.895 //y2=6.2
cc_1513 ( N_noxref_6_M45_noxref_g N_noxref_7_M47_noxref_g ) capacitor \
 c=0.0100341f //x=24.455 //y=6.2 //x2=25.335 //y2=6.2
cc_1514 ( N_noxref_6_c_1957_p N_noxref_7_c_2523_n ) capacitor c=4.86545e-19 \
 //x=23.92 //y=1.045 //x2=24.89 //y2=1.085
cc_1515 ( N_noxref_6_c_1958_p N_noxref_7_c_2523_n ) capacitor c=0.00152405f \
 //x=23.92 //y=1.39 //x2=24.89 //y2=1.085
cc_1516 ( N_noxref_6_c_1959_p N_noxref_7_c_2523_n ) capacitor c=0.0151475f \
 //x=24.45 //y=1.045 //x2=24.89 //y2=1.085
cc_1517 ( N_noxref_6_c_1960_p N_noxref_7_c_2526_n ) capacitor c=0.00109982f \
 //x=23.92 //y=1.7 //x2=24.89 //y2=1.43
cc_1518 ( N_noxref_6_c_1961_p N_noxref_7_c_2526_n ) capacitor c=0.0111064f \
 //x=24.45 //y=1.39 //x2=24.89 //y2=1.43
cc_1519 ( N_noxref_6_c_1960_p N_noxref_7_c_2528_n ) capacitor c=9.58243e-19 \
 //x=23.92 //y=1.7 //x2=24.89 //y2=1.74
cc_1520 ( N_noxref_6_c_1939_p N_noxref_7_c_2528_n ) capacitor c=0.00662747f \
 //x=23.92 //y=2.095 //x2=24.89 //y2=1.74
cc_1521 ( N_noxref_6_c_1961_p N_noxref_7_c_2528_n ) capacitor c=0.00862358f \
 //x=24.45 //y=1.39 //x2=24.89 //y2=1.74
cc_1522 ( N_noxref_6_c_1959_p N_noxref_7_c_2531_n ) capacitor c=0.00127211f \
 //x=24.45 //y=1.045 //x2=25.42 //y2=1.085
cc_1523 ( N_noxref_6_c_1961_p N_noxref_7_c_2532_n ) capacitor c=0.00204774f \
 //x=24.45 //y=1.39 //x2=25.42 //y2=1.43
cc_1524 ( N_noxref_6_c_1937_p N_noxref_7_c_2533_n ) capacitor c=0.00167305f \
 //x=24.115 //y=2.26 //x2=24.855 //y2=2.26
cc_1525 ( N_noxref_6_c_1929_p N_noxref_7_c_2533_n ) capacitor c=0.00266443f \
 //x=24.115 //y=2.26 //x2=24.855 //y2=2.26
cc_1526 ( N_noxref_6_c_1939_p N_noxref_7_c_2533_n ) capacitor c=0.0181449f \
 //x=23.92 //y=2.095 //x2=24.855 //y2=2.26
cc_1527 ( N_noxref_6_c_1932_p N_noxref_7_c_2536_n ) capacitor c=0.00158715f \
 //x=24.115 //y=4.88 //x2=24.885 //y2=4.88
cc_1528 ( N_noxref_6_c_1934_p N_noxref_7_c_2536_n ) capacitor c=0.00237977f \
 //x=24.115 //y=4.88 //x2=24.885 //y2=4.88
cc_1529 ( N_noxref_6_c_1935_p N_noxref_7_c_2536_n ) capacitor c=0.0297875f \
 //x=24.115 //y=4.88 //x2=24.885 //y2=4.88
cc_1530 ( N_noxref_6_c_1908_n Q ) capacitor c=0.043557f //x=22.265 //y=3.335 \
 //x2=21.525 //y2=2.77
cc_1531 ( N_noxref_6_c_1974_p Q ) capacitor c=0.0151188f //x=22.265 //y=3.655 \
 //x2=21.525 //y2=2.77
cc_1532 ( N_noxref_6_c_1909_n Q ) capacitor c=0.00215885f //x=22.265 //y=5.25 \
 //x2=21.525 //y2=2.77
cc_1533 ( N_noxref_6_c_1924_p Q ) capacitor c=0.00209153f //x=24.115 //y=3.335 \
 //x2=21.525 //y2=2.77
cc_1534 ( N_noxref_6_c_1977_p Q ) capacitor c=7.6985e-19 //x=22.265 //y=3.51 \
 //x2=21.525 //y2=2.77
cc_1535 ( N_noxref_6_c_1978_p Q ) capacitor c=0.00696908f //x=22.425 //y=3.495 \
 //x2=21.525 //y2=2.77
cc_1536 ( N_noxref_6_c_1909_n Q ) capacitor c=0.0298271f //x=22.265 //y=5.25 \
 //x2=21.525 //y2=4.62
cc_1537 ( N_noxref_6_c_1927_p Q ) capacitor c=0.00159788f //x=24.117 //y=4.74 \
 //x2=21.525 //y2=4.62
cc_1538 ( N_noxref_6_c_1981_p Q ) capacitor c=0.00203605f //x=22.18 //y=1.845 \
 //x2=25.595 //y2=2.4
cc_1539 ( N_noxref_6_c_1924_p Q ) capacitor c=0.00324628f //x=24.115 //y=3.335 \
 //x2=25.595 //y2=2.4
cc_1540 ( N_noxref_6_c_1909_n Q ) capacitor c=0.00283621f //x=22.265 //y=5.25 \
 //x2=25.595 //y2=4.25
cc_1541 ( N_noxref_6_c_1927_p Q ) capacitor c=0.00285488f //x=24.117 //y=4.74 \
 //x2=25.595 //y2=4.25
cc_1542 ( N_noxref_6_c_1908_n N_Q_c_2790_n ) capacitor c=0.0153006f //x=22.265 \
 //y=3.335 //x2=21.525 //y2=2.375
cc_1543 ( N_noxref_6_c_1907_n N_Q_c_2794_n ) capacitor c=8.57871e-19 //x=21.37 \
 //y=5.335 //x2=21.525 //y2=4.025
cc_1544 ( N_noxref_6_c_1940_p N_Q_c_2794_n ) capacitor c=0.00136123f //x=22.18 \
 //y=5.335 //x2=21.525 //y2=4.025
cc_1545 ( N_noxref_6_c_1988_p N_Q_c_2794_n ) capacitor c=2.11006e-19 //x=21.78 \
 //y=1.305 //x2=21.525 //y2=4.025
cc_1546 ( N_noxref_6_c_1921_p N_Q_c_2794_n ) capacitor c=8.96559e-19 \
 //x=21.865 //y=1.845 //x2=21.525 //y2=4.025
cc_1547 ( N_noxref_6_c_1909_n N_Q_c_2794_n ) capacitor c=0.01761f //x=22.265 \
 //y=5.25 //x2=21.525 //y2=4.025
cc_1548 ( N_noxref_6_c_1940_p N_Q_c_2795_n ) capacitor c=0.0023499f //x=22.18 \
 //y=5.335 //x2=21.525 //y2=4.75
cc_1549 ( N_noxref_6_c_1909_n N_Q_c_2795_n ) capacitor c=0.0152702f //x=22.265 \
 //y=5.25 //x2=21.525 //y2=4.75
cc_1550 ( N_noxref_6_c_1993_p N_Q_c_2795_n ) capacitor c=0.0224759f //x=21.485 \
 //y=5.335 //x2=21.525 //y2=4.75
cc_1551 ( N_noxref_6_c_1994_p N_Q_c_2795_n ) capacitor c=0.00217653f \
 //x=21.485 //y=5.56 //x2=21.525 //y2=4.75
cc_1552 ( N_noxref_6_M45_noxref_g N_Q_c_2844_n ) capacitor c=0.00967396f \
 //x=24.455 //y=6.2 //x2=25 //y2=5.38
cc_1553 ( N_noxref_6_c_1996_p N_Q_c_2845_n ) capacitor c=0.00326079f //x=21.78 \
 //y=1.76 //x2=25.155 //y2=1.75
cc_1554 ( N_noxref_6_c_1981_p N_Q_c_2846_n ) capacitor c=0.00218808f //x=22.18 \
 //y=1.845 //x2=25.24 //y2=1.835
cc_1555 ( N_noxref_6_c_1909_n N_Q_c_2783_n ) capacitor c=7.6985e-19 //x=22.265 \
 //y=5.25 //x2=21.525 //y2=3.88
cc_1556 ( N_noxref_6_c_1999_p N_Q_c_2848_n ) capacitor c=5.58535e-19 \
 //x=21.485 //y=5.56 //x2=24.235 //y2=5.56
cc_1557 ( N_noxref_6_c_1940_p N_Q_c_2848_n ) capacitor c=0.00104762f //x=22.18 \
 //y=5.335 //x2=24.235 //y2=5.56
cc_1558 ( N_noxref_6_c_1925_p N_Q_c_2848_n ) capacitor c=5.61354e-19 \
 //x=24.115 //y=3.655 //x2=24.235 //y2=5.56
cc_1559 ( N_noxref_6_c_1932_p N_Q_c_2848_n ) capacitor c=0.0118019f //x=24.115 \
 //y=4.88 //x2=24.235 //y2=5.56
cc_1560 ( N_noxref_6_c_1934_p N_Q_c_2848_n ) capacitor c=0.00277154f \
 //x=24.115 //y=4.88 //x2=24.235 //y2=5.56
cc_1561 ( N_noxref_6_M44_noxref_g N_Q_c_2848_n ) capacitor c=0.00201806f \
 //x=24.015 //y=6.2 //x2=24.235 //y2=5.56
cc_1562 ( N_noxref_6_M45_noxref_g N_Q_c_2848_n ) capacitor c=0.00192712f \
 //x=24.455 //y=6.2 //x2=24.235 //y2=5.56
cc_1563 ( N_noxref_6_c_1935_p N_Q_c_2848_n ) capacitor c=0.0019468f //x=24.115 \
 //y=4.88 //x2=24.235 //y2=5.56
cc_1564 ( N_noxref_6_c_1988_p N_Q_c_2856_n ) capacitor c=6.5615e-19 //x=21.78 \
 //y=1.305 //x2=25.155 //y2=1.18
cc_1565 ( N_noxref_6_c_1921_p N_Q_c_2857_n ) capacitor c=0.0052544f //x=21.865 \
 //y=1.845 //x2=24.46 //y2=3.88
cc_1566 ( N_noxref_6_c_1974_p N_Q_c_2857_n ) capacitor c=0.00917068f \
 //x=22.265 //y=3.655 //x2=24.46 //y2=3.88
cc_1567 ( N_noxref_6_c_1909_n N_Q_c_2857_n ) capacitor c=0.021689f //x=22.265 \
 //y=5.25 //x2=24.46 //y2=3.88
cc_1568 ( N_noxref_6_c_1925_p N_Q_c_2857_n ) capacitor c=0.00598321f \
 //x=24.115 //y=3.655 //x2=24.46 //y2=3.88
cc_1569 ( N_noxref_6_c_1927_p N_Q_c_2857_n ) capacitor c=0.022913f //x=24.117 \
 //y=4.74 //x2=24.46 //y2=3.88
cc_1570 ( N_noxref_6_c_1978_p N_Q_c_2857_n ) capacitor c=0.0368432f //x=22.425 \
 //y=3.495 //x2=24.46 //y2=3.88
cc_1571 ( N_noxref_6_c_1928_p N_Q_c_2857_n ) capacitor c=0.0368432f //x=24.11 \
 //y=3.495 //x2=24.46 //y2=3.88
cc_1572 ( N_noxref_6_c_1946_p N_Q_c_2857_n ) capacitor c=0.139556f //x=23.95 \
 //y=3.495 //x2=24.46 //y2=3.88
cc_1573 ( N_noxref_6_c_1909_n N_Q_c_2784_n ) capacitor c=0.00336755f \
 //x=22.265 //y=5.25 //x2=21.685 //y2=3.865
cc_1574 ( N_noxref_6_c_1908_n N_Q_c_2801_n ) capacitor c=0.00163444f \
 //x=22.265 //y=3.335 //x2=21.525 //y2=2.26
cc_1575 ( N_noxref_6_c_1940_p N_Q_c_2804_n ) capacitor c=0.00130631f //x=22.18 \
 //y=5.335 //x2=21.525 //y2=4.88
cc_1576 ( N_noxref_6_c_1909_n N_Q_c_2804_n ) capacitor c=0.00131258f \
 //x=22.265 //y=5.25 //x2=21.525 //y2=4.88
cc_1577 ( N_noxref_6_c_1993_p N_Q_c_2804_n ) capacitor c=0.00346456f \
 //x=21.485 //y=5.335 //x2=21.525 //y2=4.88
cc_1578 ( N_noxref_6_c_1994_p N_Q_c_2804_n ) capacitor c=0.00552343f \
 //x=21.485 //y=5.56 //x2=21.525 //y2=4.88
cc_1579 ( N_noxref_6_c_1932_p N_Q_c_2871_n ) capacitor c=0.00104426f \
 //x=24.115 //y=4.88 //x2=24.235 //y2=5.56
cc_1580 ( N_noxref_6_c_1934_p N_Q_c_2871_n ) capacitor c=0.00377369f \
 //x=24.115 //y=4.88 //x2=24.235 //y2=5.56
cc_1581 ( N_noxref_6_M44_noxref_g N_Q_c_2871_n ) capacitor c=0.0158358f \
 //x=24.015 //y=6.2 //x2=24.235 //y2=5.56
cc_1582 ( N_noxref_6_M45_noxref_g N_Q_c_2871_n ) capacitor c=0.0178987f \
 //x=24.455 //y=6.2 //x2=24.235 //y2=5.56
cc_1583 ( N_noxref_6_c_1935_p N_Q_c_2871_n ) capacitor c=0.0043218f //x=24.115 \
 //y=4.88 //x2=24.235 //y2=5.56
cc_1584 ( N_noxref_6_c_1907_n N_Q_M42_noxref_g ) capacitor c=0.0103546f \
 //x=21.37 //y=5.335 //x2=21.265 //y2=6.2
cc_1585 ( N_noxref_6_c_1999_p N_Q_M42_noxref_g ) capacitor c=0.00226521f \
 //x=21.485 //y=5.56 //x2=21.265 //y2=6.2
cc_1586 ( N_noxref_6_c_1994_p N_Q_M42_noxref_g ) capacitor c=0.0178885f \
 //x=21.485 //y=5.56 //x2=21.265 //y2=6.2
cc_1587 ( N_noxref_6_c_1999_p N_Q_M43_noxref_g ) capacitor c=0.00368945f \
 //x=21.485 //y=5.56 //x2=21.705 //y2=6.2
cc_1588 ( N_noxref_6_c_1940_p N_Q_M43_noxref_g ) capacitor c=0.0110767f \
 //x=22.18 //y=5.335 //x2=21.705 //y2=6.2
cc_1589 ( N_noxref_6_c_1994_p N_Q_M43_noxref_g ) capacitor c=0.0188608f \
 //x=21.485 //y=5.56 //x2=21.705 //y2=6.2
cc_1590 ( N_noxref_6_c_1988_p N_Q_c_2811_n ) capacitor c=4.64015e-19 //x=21.78 \
 //y=1.305 //x2=21.515 //y2=1.095
cc_1591 ( N_noxref_6_M13_noxref_d N_Q_c_2811_n ) capacitor c=0.00137165f \
 //x=21.59 //y=1.095 //x2=21.515 //y2=1.095
cc_1592 ( N_noxref_6_c_1988_p N_Q_c_2812_n ) capacitor c=0.0026012f //x=21.78 \
 //y=1.305 //x2=21.515 //y2=1.44
cc_1593 ( N_noxref_6_c_1996_p N_Q_c_2812_n ) capacitor c=0.00127432f //x=21.78 \
 //y=1.76 //x2=21.515 //y2=1.44
cc_1594 ( N_noxref_6_M13_noxref_d N_Q_c_2812_n ) capacitor c=0.00237422f \
 //x=21.59 //y=1.095 //x2=21.515 //y2=1.44
cc_1595 ( N_noxref_6_c_1996_p N_Q_c_2813_n ) capacitor c=0.00429966f //x=21.78 \
 //y=1.76 //x2=21.515 //y2=1.75
cc_1596 ( N_noxref_6_c_1988_p N_Q_c_2888_n ) capacitor c=5.29969e-19 //x=21.78 \
 //y=1.305 //x2=21.89 //y2=0.94
cc_1597 ( N_noxref_6_M13_noxref_d N_Q_c_2888_n ) capacitor c=0.0020782f \
 //x=21.59 //y=1.095 //x2=21.89 //y2=0.94
cc_1598 ( N_noxref_6_c_1988_p N_Q_c_2890_n ) capacitor c=5.17633e-19 //x=21.78 \
 //y=1.305 //x2=21.89 //y2=1.595
cc_1599 ( N_noxref_6_c_1996_p N_Q_c_2890_n ) capacitor c=0.00930387f //x=21.78 \
 //y=1.76 //x2=21.89 //y2=1.595
cc_1600 ( N_noxref_6_c_1981_p N_Q_c_2890_n ) capacitor c=0.00194716f //x=22.18 \
 //y=1.845 //x2=21.89 //y2=1.595
cc_1601 ( N_noxref_6_M13_noxref_d N_Q_c_2890_n ) capacitor c=0.00356097f \
 //x=21.59 //y=1.095 //x2=21.89 //y2=1.595
cc_1602 ( N_noxref_6_c_1988_p N_Q_c_2894_n ) capacitor c=5.28622e-19 //x=21.78 \
 //y=1.305 //x2=22.045 //y2=1.095
cc_1603 ( N_noxref_6_M13_noxref_d N_Q_c_2894_n ) capacitor c=0.00139206f \
 //x=21.59 //y=1.095 //x2=22.045 //y2=1.095
cc_1604 ( N_noxref_6_c_1988_p N_Q_c_2896_n ) capacitor c=0.00312156f //x=21.78 \
 //y=1.305 //x2=22.045 //y2=1.44
cc_1605 ( N_noxref_6_c_1996_p N_Q_c_2896_n ) capacitor c=0.00347599f //x=21.78 \
 //y=1.76 //x2=22.045 //y2=1.44
cc_1606 ( N_noxref_6_c_1981_p N_Q_c_2896_n ) capacitor c=0.00323576f //x=22.18 \
 //y=1.845 //x2=22.045 //y2=1.44
cc_1607 ( N_noxref_6_M13_noxref_d N_Q_c_2896_n ) capacitor c=0.00237422f \
 //x=21.59 //y=1.095 //x2=22.045 //y2=1.44
cc_1608 ( N_noxref_6_c_1908_n N_Q_c_2814_n ) capacitor c=0.0025845f //x=22.265 \
 //y=3.335 //x2=21.525 //y2=2.26
cc_1609 ( N_noxref_6_c_1996_p N_Q_c_2817_n ) capacitor c=0.0036273f //x=21.78 \
 //y=1.76 //x2=21.525 //y2=2.095
cc_1610 ( N_noxref_6_c_1908_n N_Q_c_2817_n ) capacitor c=0.00282067f \
 //x=22.265 //y=3.335 //x2=21.525 //y2=2.095
cc_1611 ( N_noxref_6_c_1909_n N_Q_c_2818_n ) capacitor c=0.00739875f \
 //x=22.265 //y=5.25 //x2=21.525 //y2=4.88
cc_1612 ( N_noxref_6_c_1993_p N_Q_c_2818_n ) capacitor c=0.00203307f \
 //x=21.485 //y=5.335 //x2=21.525 //y2=4.88
cc_1613 ( N_noxref_6_c_1994_p N_Q_c_2818_n ) capacitor c=0.00375636f \
 //x=21.485 //y=5.56 //x2=21.525 //y2=4.88
cc_1614 ( N_noxref_6_c_1895_n N_VDD_c_3043_n ) capacitor c=0.00621363f \
 //x=20.485 //y=5.335 //x2=25.965 //y2=7.58
cc_1615 ( N_noxref_6_c_1907_n N_VDD_c_3043_n ) capacitor c=0.00627191f \
 //x=21.37 //y=5.335 //x2=25.965 //y2=7.58
cc_1616 ( N_noxref_6_c_1999_p N_VDD_c_3043_n ) capacitor c=0.00256019f \
 //x=21.485 //y=5.56 //x2=25.965 //y2=7.58
cc_1617 ( N_noxref_6_c_1940_p N_VDD_c_3043_n ) capacitor c=0.00829247f \
 //x=22.18 //y=5.335 //x2=25.965 //y2=7.58
cc_1618 ( N_noxref_6_c_1974_p N_VDD_c_3043_n ) capacitor c=4.57419e-19 \
 //x=22.265 //y=3.655 //x2=25.965 //y2=7.58
cc_1619 ( N_noxref_6_c_1925_p N_VDD_c_3043_n ) capacitor c=2.00049e-19 \
 //x=24.115 //y=3.655 //x2=25.965 //y2=7.58
cc_1620 ( N_noxref_6_c_1896_n N_VDD_c_3043_n ) capacitor c=0.00261804f \
 //x=19.727 //y=5.335 //x2=25.965 //y2=7.58
cc_1621 ( N_noxref_6_c_1910_n N_VDD_c_3043_n ) capacitor c=0.00270108f \
 //x=20.605 //y=5.335 //x2=25.965 //y2=7.58
cc_1622 ( N_noxref_6_c_1932_p N_VDD_c_3043_n ) capacitor c=9.07241e-19 \
 //x=24.115 //y=4.88 //x2=25.965 //y2=7.58
cc_1623 ( N_noxref_6_c_1899_n N_VDD_c_3043_n ) capacitor c=0.0024232f \
 //x=19.725 //y=5.56 //x2=25.965 //y2=7.58
cc_1624 ( N_noxref_6_c_1915_n N_VDD_c_3043_n ) capacitor c=0.0024232f \
 //x=20.605 //y=5.56 //x2=25.965 //y2=7.58
cc_1625 ( N_noxref_6_c_1994_p N_VDD_c_3043_n ) capacitor c=0.0024232f \
 //x=21.485 //y=5.56 //x2=25.965 //y2=7.58
cc_1626 ( N_noxref_6_c_1934_p N_VDD_c_3043_n ) capacitor c=6.22888e-19 \
 //x=24.115 //y=4.88 //x2=25.965 //y2=7.58
cc_1627 ( N_noxref_6_c_1895_n N_VDD_c_3194_n ) capacitor c=0.00202922f \
 //x=20.485 //y=5.335 //x2=20.08 //y2=7.585
cc_1628 ( N_noxref_6_c_1896_n N_VDD_c_3194_n ) capacitor c=9.3757e-19 \
 //x=19.727 //y=5.335 //x2=20.08 //y2=7.585
cc_1629 ( N_noxref_6_c_1899_n N_VDD_c_3194_n ) capacitor c=0.0138074f \
 //x=19.725 //y=5.56 //x2=20.08 //y2=7.585
cc_1630 ( N_noxref_6_c_1895_n N_VDD_c_3235_n ) capacitor c=0.0017708f \
 //x=20.485 //y=5.335 //x2=20.96 //y2=7.585
cc_1631 ( N_noxref_6_c_1907_n N_VDD_c_3235_n ) capacitor c=0.00202922f \
 //x=21.37 //y=5.335 //x2=20.96 //y2=7.585
cc_1632 ( N_noxref_6_c_1910_n N_VDD_c_3235_n ) capacitor c=9.4822e-19 \
 //x=20.605 //y=5.335 //x2=20.96 //y2=7.585
cc_1633 ( N_noxref_6_c_1915_n N_VDD_c_3235_n ) capacitor c=0.0138074f \
 //x=20.605 //y=5.56 //x2=20.96 //y2=7.585
cc_1634 ( N_noxref_6_c_1907_n N_VDD_c_3267_n ) capacitor c=0.00205906f \
 //x=21.37 //y=5.335 //x2=21.84 //y2=7.585
cc_1635 ( N_noxref_6_c_1999_p N_VDD_c_3267_n ) capacitor c=8.49654e-19 \
 //x=21.485 //y=5.56 //x2=21.84 //y2=7.585
cc_1636 ( N_noxref_6_c_1940_p N_VDD_c_3267_n ) capacitor c=0.00204238f \
 //x=22.18 //y=5.335 //x2=21.84 //y2=7.585
cc_1637 ( N_noxref_6_c_1994_p N_VDD_c_3267_n ) capacitor c=0.0135103f \
 //x=21.485 //y=5.56 //x2=21.84 //y2=7.585
cc_1638 ( N_noxref_6_c_1940_p N_VDD_c_3271_n ) capacitor c=0.00183742f \
 //x=22.18 //y=5.335 //x2=22.835 //y2=7.585
cc_1639 ( N_noxref_6_c_1932_p N_VDD_c_3272_n ) capacitor c=6.28113e-19 \
 //x=24.115 //y=4.88 //x2=24.59 //y2=7.585
cc_1640 ( N_noxref_6_M44_noxref_g N_VDD_c_3272_n ) capacitor c=0.00732618f \
 //x=24.015 //y=6.2 //x2=24.59 //y2=7.585
cc_1641 ( N_noxref_6_M45_noxref_g N_VDD_c_3272_n ) capacitor c=0.00755544f \
 //x=24.455 //y=6.2 //x2=24.59 //y2=7.585
cc_1642 ( N_noxref_6_c_1896_n N_VDD_c_3202_n ) capacitor c=0.0022955f \
 //x=19.727 //y=5.335 //x2=18.195 //y2=7.585
cc_1643 ( N_noxref_6_c_1899_n N_VDD_c_3202_n ) capacitor c=0.00509469f \
 //x=19.725 //y=5.56 //x2=18.195 //y2=7.585
cc_1644 ( N_noxref_6_c_1999_p N_VDD_c_3277_n ) capacitor c=0.00269779f \
 //x=21.485 //y=5.56 //x2=23.005 //y2=7.585
cc_1645 ( N_noxref_6_c_1909_n N_VDD_c_3277_n ) capacitor c=0.0338755f \
 //x=22.265 //y=5.25 //x2=23.005 //y2=7.585
cc_1646 ( N_noxref_6_c_1932_p N_VDD_c_3277_n ) capacitor c=0.00447349f \
 //x=24.115 //y=4.88 //x2=23.005 //y2=7.585
cc_1647 ( N_noxref_6_c_1927_p N_VDD_c_3277_n ) capacitor c=0.00675188f \
 //x=24.117 //y=4.74 //x2=23.005 //y2=7.585
cc_1648 ( N_noxref_6_c_1994_p N_VDD_c_3277_n ) capacitor c=0.00776541f \
 //x=21.485 //y=5.56 //x2=23.005 //y2=7.585
cc_1649 ( N_noxref_6_c_1934_p N_VDD_c_3277_n ) capacitor c=0.00370494f \
 //x=24.115 //y=4.88 //x2=23.005 //y2=7.585
cc_1650 ( N_noxref_6_c_1935_p N_VDD_c_3277_n ) capacitor c=0.0129564f \
 //x=24.115 //y=4.88 //x2=23.005 //y2=7.585
cc_1651 ( N_noxref_6_c_1896_n N_VDD_M38_noxref_s ) capacitor c=0.0441176f \
 //x=19.727 //y=5.335 //x2=19.15 //y2=5.2
cc_1652 ( N_noxref_6_c_1910_n N_VDD_M38_noxref_s ) capacitor c=7.80122e-19 \
 //x=20.605 //y=5.335 //x2=19.15 //y2=5.2
cc_1653 ( N_noxref_6_c_1899_n N_VDD_M38_noxref_s ) capacitor c=0.09305f \
 //x=19.725 //y=5.56 //x2=19.15 //y2=5.2
cc_1654 ( N_noxref_6_c_1895_n N_VDD_M39_noxref_d ) capacitor c=0.00700141f \
 //x=20.485 //y=5.335 //x2=20.02 //y2=5.2
cc_1655 ( N_noxref_6_c_1899_n N_VDD_M39_noxref_d ) capacitor c=0.0674491f \
 //x=19.725 //y=5.56 //x2=20.02 //y2=5.2
cc_1656 ( N_noxref_6_c_1915_n N_VDD_M39_noxref_d ) capacitor c=0.0674762f \
 //x=20.605 //y=5.56 //x2=20.02 //y2=5.2
cc_1657 ( N_noxref_6_c_1907_n N_VDD_M41_noxref_d ) capacitor c=0.00700141f \
 //x=21.37 //y=5.335 //x2=20.9 //y2=5.2
cc_1658 ( N_noxref_6_c_1915_n N_VDD_M41_noxref_d ) capacitor c=0.067493f \
 //x=20.605 //y=5.56 //x2=20.9 //y2=5.2
cc_1659 ( N_noxref_6_c_1994_p N_VDD_M41_noxref_d ) capacitor c=0.0674288f \
 //x=21.485 //y=5.56 //x2=20.9 //y2=5.2
cc_1660 ( N_noxref_6_c_1940_p N_VDD_M43_noxref_d ) capacitor c=0.00700141f \
 //x=22.18 //y=5.335 //x2=21.78 //y2=5.2
cc_1661 ( N_noxref_6_c_1994_p N_VDD_M43_noxref_d ) capacitor c=0.0673824f \
 //x=21.485 //y=5.56 //x2=21.78 //y2=5.2
cc_1662 ( N_noxref_6_c_1999_p N_VDD_M44_noxref_s ) capacitor c=0.00536022f \
 //x=21.485 //y=5.56 //x2=23.66 //y2=5.2
cc_1663 ( N_noxref_6_c_1940_p N_VDD_M44_noxref_s ) capacitor c=0.00211796f \
 //x=22.18 //y=5.335 //x2=23.66 //y2=5.2
cc_1664 ( N_noxref_6_c_1925_p N_VDD_M44_noxref_s ) capacitor c=0.00112123f \
 //x=24.115 //y=3.655 //x2=23.66 //y2=5.2
cc_1665 ( N_noxref_6_M44_noxref_g N_VDD_M44_noxref_s ) capacitor c=0.0567929f \
 //x=24.015 //y=6.2 //x2=23.66 //y2=5.2
cc_1666 ( N_noxref_6_M45_noxref_g N_VDD_M45_noxref_d ) capacitor c=0.015318f \
 //x=24.455 //y=6.2 //x2=24.53 //y2=5.2
cc_1667 ( N_noxref_6_c_1988_p N_noxref_14_c_3780_n ) capacitor c=0.0036878f \
 //x=21.78 //y=1.305 //x2=22.18 //y2=0.72
cc_1668 ( N_noxref_6_c_1981_p N_noxref_14_c_3780_n ) capacitor c=0.00366757f \
 //x=22.18 //y=1.845 //x2=22.18 //y2=0.72
cc_1669 ( N_noxref_6_M13_noxref_d N_noxref_14_c_3780_n ) capacitor \
 c=0.00949319f //x=21.59 //y=1.095 //x2=22.18 //y2=0.72
cc_1670 ( N_noxref_6_M13_noxref_d N_noxref_14_c_3783_n ) capacitor \
 c=0.00120711f //x=21.59 //y=1.095 //x2=21.295 //y2=1.175
cc_1671 ( N_noxref_6_c_1895_n N_noxref_14_M12_noxref_d ) capacitor \
 c=0.00114684f //x=20.485 //y=5.335 //x2=20.055 //y2=1.09
cc_1672 ( N_noxref_6_c_1988_p N_noxref_14_M12_noxref_d ) capacitor \
 c=0.00802836f //x=21.78 //y=1.305 //x2=20.055 //y2=1.09
cc_1673 ( N_noxref_6_c_1988_p N_noxref_14_M13_noxref_s ) capacitor \
 c=0.00993092f //x=21.78 //y=1.305 //x2=21.16 //y2=0.555
cc_1674 ( N_noxref_6_c_1996_p N_noxref_14_M13_noxref_s ) capacitor \
 c=0.0270624f //x=21.78 //y=1.76 //x2=21.16 //y2=0.555
cc_1675 ( N_noxref_6_c_1981_p N_noxref_14_M13_noxref_s ) capacitor \
 c=0.00871957f //x=22.18 //y=1.845 //x2=21.16 //y2=0.555
cc_1676 ( N_noxref_6_c_1977_p N_noxref_14_M13_noxref_s ) capacitor \
 c=0.0016218f //x=22.265 //y=3.51 //x2=21.16 //y2=0.555
cc_1677 ( N_noxref_6_M13_noxref_d N_noxref_14_M13_noxref_s ) capacitor \
 c=0.0279003f //x=21.59 //y=1.095 //x2=21.16 //y2=0.555
cc_1678 ( N_noxref_6_c_1988_p N_GND_c_3983_n ) capacitor c=0.00901861f \
 //x=21.78 //y=1.305 //x2=24.1 //y2=0.175
cc_1679 ( N_noxref_6_c_1981_p N_GND_c_3983_n ) capacitor c=0.00713708f \
 //x=22.18 //y=1.845 //x2=24.1 //y2=0.175
cc_1680 ( N_noxref_6_c_1974_p N_GND_c_3983_n ) capacitor c=5.00363e-19 \
 //x=22.265 //y=3.655 //x2=24.1 //y2=0.175
cc_1681 ( N_noxref_6_M13_noxref_d N_GND_c_3983_n ) capacitor c=2.9462e-19 \
 //x=21.59 //y=1.095 //x2=24.1 //y2=0.175
cc_1682 ( N_noxref_6_c_1988_p N_GND_c_4002_n ) capacitor c=0.00488628f \
 //x=21.78 //y=1.305 //x2=24.185 //y2=1.135
cc_1683 ( N_noxref_6_c_1937_p N_GND_c_4002_n ) capacitor c=0.00689142f \
 //x=24.115 //y=2.26 //x2=24.185 //y2=1.135
cc_1684 ( N_noxref_6_c_1928_p N_GND_c_4002_n ) capacitor c=0.00224243f \
 //x=24.11 //y=3.495 //x2=24.185 //y2=1.135
cc_1685 ( N_noxref_6_c_1929_p N_GND_c_4002_n ) capacitor c=2.13705e-19 \
 //x=24.115 //y=2.26 //x2=24.185 //y2=1.135
cc_1686 ( N_noxref_6_c_1957_p N_GND_c_4002_n ) capacitor c=0.00176535f \
 //x=23.92 //y=1.045 //x2=24.185 //y2=1.135
cc_1687 ( N_noxref_6_c_1958_p N_GND_c_4002_n ) capacitor c=0.0036005f \
 //x=23.92 //y=1.39 //x2=24.185 //y2=1.135
cc_1688 ( N_noxref_6_c_1960_p N_GND_c_4002_n ) capacitor c=4.2764e-19 \
 //x=23.92 //y=1.7 //x2=24.185 //y2=1.135
cc_1689 ( N_noxref_6_c_2132_p N_GND_c_4002_n ) capacitor c=7.35788e-19 \
 //x=24.295 //y=0.89 //x2=24.185 //y2=1.135
cc_1690 ( N_noxref_6_c_2133_p N_GND_c_4002_n ) capacitor c=6.38426e-19 \
 //x=24.295 //y=1.545 //x2=24.185 //y2=1.135
cc_1691 ( N_noxref_6_c_1959_p N_GND_c_4002_n ) capacitor c=0.00158609f \
 //x=24.45 //y=1.045 //x2=24.185 //y2=1.135
cc_1692 ( N_noxref_6_c_1961_p N_GND_c_4002_n ) capacitor c=0.00296337f \
 //x=24.45 //y=1.39 //x2=24.185 //y2=1.135
cc_1693 ( N_noxref_6_c_1957_p N_GND_c_4013_n ) capacitor c=3.51399e-19 \
 //x=23.92 //y=1.045 //x2=24.182 //y2=1.005
cc_1694 ( N_noxref_6_c_2132_p N_GND_c_4013_n ) capacitor c=0.00864609f \
 //x=24.295 //y=0.89 //x2=24.182 //y2=1.005
cc_1695 ( N_noxref_6_c_1959_p N_GND_c_4013_n ) capacitor c=4.45447e-19 \
 //x=24.45 //y=1.045 //x2=24.182 //y2=1.005
cc_1696 ( N_noxref_6_c_1981_p N_GND_c_3947_n ) capacitor c=6.86343e-19 \
 //x=22.18 //y=1.845 //x2=22.835 //y2=0.175
cc_1697 ( N_noxref_6_c_1974_p N_GND_c_3947_n ) capacitor c=4.03806e-19 \
 //x=22.265 //y=3.655 //x2=22.835 //y2=0.175
cc_1698 ( N_noxref_6_c_1957_p N_GND_c_4018_n ) capacitor c=0.00691994f \
 //x=23.92 //y=1.045 //x2=25.965 //y2=0.18
cc_1699 ( N_noxref_6_c_1996_p N_GND_c_4019_n ) capacitor c=0.00285697f \
 //x=21.78 //y=1.76 //x2=23.005 //y2=0.175
cc_1700 ( N_noxref_6_c_1981_p N_GND_c_4019_n ) capacitor c=0.0337353f \
 //x=22.18 //y=1.845 //x2=23.005 //y2=0.175
cc_1701 ( N_noxref_6_c_1924_p N_GND_c_4019_n ) capacitor c=0.00829739f \
 //x=24.115 //y=3.335 //x2=23.005 //y2=0.175
cc_1702 ( N_noxref_6_c_1937_p N_GND_c_4019_n ) capacitor c=0.00427323f \
 //x=24.115 //y=2.26 //x2=23.005 //y2=0.175
cc_1703 ( N_noxref_6_c_1946_p N_GND_c_4019_n ) capacitor c=0.00560367f \
 //x=23.95 //y=3.495 //x2=23.005 //y2=0.175
cc_1704 ( N_noxref_6_c_1929_p N_GND_c_4019_n ) capacitor c=0.00369427f \
 //x=24.115 //y=2.26 //x2=23.005 //y2=0.175
cc_1705 ( N_noxref_6_c_1960_p N_GND_c_4019_n ) capacitor c=0.0015404f \
 //x=23.92 //y=1.7 //x2=23.005 //y2=0.175
cc_1706 ( N_noxref_6_c_1939_p N_GND_c_4019_n ) capacitor c=0.0095324f \
 //x=23.92 //y=2.095 //x2=23.005 //y2=0.175
cc_1707 ( N_noxref_6_c_1937_p N_GND_M14_noxref_d ) capacitor c=2.20438e-19 \
 //x=24.115 //y=2.26 //x2=23.995 //y2=1.045
cc_1708 ( N_noxref_6_c_1957_p N_GND_M14_noxref_d ) capacitor c=0.00192399f \
 //x=23.92 //y=1.045 //x2=23.995 //y2=1.045
cc_1709 ( N_noxref_6_c_1958_p N_GND_M14_noxref_d ) capacitor c=0.00210798f \
 //x=23.92 //y=1.39 //x2=23.995 //y2=1.045
cc_1710 ( N_noxref_6_c_2132_p N_GND_M14_noxref_d ) capacitor c=0.00472259f \
 //x=24.295 //y=0.89 //x2=23.995 //y2=1.045
cc_1711 ( N_noxref_6_c_2133_p N_GND_M14_noxref_d ) capacitor c=0.00166857f \
 //x=24.295 //y=1.545 //x2=23.995 //y2=1.045
cc_1712 ( N_noxref_6_c_1959_p N_GND_M14_noxref_d ) capacitor c=0.00230174f \
 //x=24.45 //y=1.045 //x2=23.995 //y2=1.045
cc_1713 ( N_noxref_6_c_1961_p N_GND_M14_noxref_d ) capacitor c=0.00210798f \
 //x=24.45 //y=1.39 //x2=23.995 //y2=1.045
cc_1714 ( N_noxref_6_c_1946_p N_noxref_21_c_4583_n ) capacitor c=0.00264481f \
 //x=23.95 //y=3.495 //x2=23.7 //y2=1.675
cc_1715 ( N_noxref_6_c_1939_p N_noxref_21_c_4583_n ) capacitor c=0.00262672f \
 //x=23.92 //y=2.095 //x2=23.7 //y2=1.675
cc_1716 ( N_noxref_6_c_1925_p N_noxref_21_c_4585_n ) capacitor c=0.00403091f \
 //x=24.115 //y=3.655 //x2=24.585 //y2=1.76
cc_1717 ( N_noxref_6_c_1937_p N_noxref_21_c_4585_n ) capacitor c=0.00509504f \
 //x=24.115 //y=2.26 //x2=24.585 //y2=1.76
cc_1718 ( N_noxref_6_c_1946_p N_noxref_21_c_4585_n ) capacitor c=9.85544e-19 \
 //x=23.95 //y=3.495 //x2=24.585 //y2=1.76
cc_1719 ( N_noxref_6_c_1929_p N_noxref_21_c_4585_n ) capacitor c=0.00763108f \
 //x=24.115 //y=2.26 //x2=24.585 //y2=1.76
cc_1720 ( N_noxref_6_c_1960_p N_noxref_21_c_4585_n ) capacitor c=0.00697076f \
 //x=23.92 //y=1.7 //x2=24.585 //y2=1.76
cc_1721 ( N_noxref_6_c_1939_p N_noxref_21_c_4585_n ) capacitor c=0.0180008f \
 //x=23.92 //y=2.095 //x2=24.585 //y2=1.76
cc_1722 ( N_noxref_6_c_2133_p N_noxref_21_c_4585_n ) capacitor c=0.00723574f \
 //x=24.295 //y=1.545 //x2=24.585 //y2=1.76
cc_1723 ( N_noxref_6_c_1961_p N_noxref_21_c_4585_n ) capacitor c=0.00339872f \
 //x=24.45 //y=1.39 //x2=24.585 //y2=1.76
cc_1724 ( N_noxref_6_c_1939_p N_noxref_21_c_4593_n ) capacitor c=6.71402e-19 \
 //x=23.92 //y=2.095 //x2=24.67 //y2=1.675
cc_1725 ( N_noxref_6_c_1957_p N_noxref_21_M14_noxref_s ) capacitor \
 c=0.0295366f //x=23.92 //y=1.045 //x2=23.565 //y2=0.545
cc_1726 ( N_noxref_6_c_1960_p N_noxref_21_M14_noxref_s ) capacitor \
 c=3.48408e-19 //x=23.92 //y=1.7 //x2=23.565 //y2=0.545
cc_1727 ( N_noxref_6_c_1959_p N_noxref_21_M14_noxref_s ) capacitor \
 c=0.0125442f //x=24.45 //y=1.045 //x2=23.565 //y2=0.545
cc_1728 ( N_noxref_7_c_2406_n Q ) capacitor c=0.0252026f //x=19.51 //y=4.265 \
 //x2=21.525 //y2=4.62
cc_1729 ( N_noxref_7_c_2488_n Q ) capacitor c=0.0601961f //x=24.855 //y=4.095 \
 //x2=25.595 //y2=2.4
cc_1730 ( N_noxref_7_c_2503_n Q ) capacitor c=0.015397f //x=24.855 //y=2.26 \
 //x2=25.595 //y2=2.4
cc_1731 ( N_noxref_7_c_2513_n Q ) capacitor c=0.00440663f //x=24.855 //y=2.26 \
 //x2=25.595 //y2=2.4
cc_1732 ( N_noxref_7_c_2533_n Q ) capacitor c=0.00281392f //x=24.855 //y=2.26 \
 //x2=25.595 //y2=2.4
cc_1733 ( N_noxref_7_c_2544_p Q ) capacitor c=0.00309058f //x=24.855 //y=2.095 \
 //x2=25.595 //y2=2.4
cc_1734 ( N_noxref_7_c_2488_n Q ) capacitor c=0.00310192f //x=24.855 //y=4.095 \
 //x2=25.595 //y2=4.25
cc_1735 ( N_noxref_7_c_2496_n Q ) capacitor c=0.0146042f //x=24.855 //y=4.415 \
 //x2=25.595 //y2=4.25
cc_1736 ( N_noxref_7_c_2497_n Q ) capacitor c=0.030903f //x=24.855 //y=4.735 \
 //x2=25.595 //y2=4.25
cc_1737 ( N_noxref_7_c_2502_n Q ) capacitor c=0.00468658f //x=24.855 //y=4.25 \
 //x2=25.595 //y2=4.25
cc_1738 ( N_noxref_7_c_2406_n Q ) capacitor c=0.00680075f //x=19.51 //y=4.265 \
 //x2=25.595 //y2=4.25
cc_1739 ( N_noxref_7_c_2517_n Q ) capacitor c=0.00448306f //x=24.885 //y=4.88 \
 //x2=25.595 //y2=4.25
cc_1740 ( N_noxref_7_c_2551_p Q ) capacitor c=0.00845606f //x=25.26 //y=4.97 \
 //x2=25.595 //y2=4.25
cc_1741 ( N_noxref_7_c_2536_n Q ) capacitor c=0.00142201f //x=24.885 //y=4.88 \
 //x2=25.595 //y2=4.25
cc_1742 ( N_noxref_7_c_2488_n Q ) capacitor c=9.19401e-19 //x=24.855 //y=4.095 \
 //x2=25.595 //y2=3.88
cc_1743 ( N_noxref_7_c_2406_n N_Q_c_2794_n ) capacitor c=0.00530315f //x=19.51 \
 //y=4.265 //x2=21.525 //y2=4.025
cc_1744 ( N_noxref_7_c_2406_n N_Q_c_2795_n ) capacitor c=0.00234144f //x=19.51 \
 //y=4.265 //x2=21.525 //y2=4.75
cc_1745 ( N_noxref_7_c_2496_n N_Q_c_2844_n ) capacitor c=0.00405363f \
 //x=24.855 //y=4.415 //x2=25 //y2=5.38
cc_1746 ( N_noxref_7_c_2497_n N_Q_c_2844_n ) capacitor c=0.0222472f //x=24.855 \
 //y=4.735 //x2=25 //y2=5.38
cc_1747 ( N_noxref_7_c_2406_n N_Q_c_2844_n ) capacitor c=0.00278899f //x=19.51 \
 //y=4.265 //x2=25 //y2=5.38
cc_1748 ( N_noxref_7_c_2517_n N_Q_c_2844_n ) capacitor c=0.00469257f \
 //x=24.885 //y=4.88 //x2=25 //y2=5.38
cc_1749 ( N_noxref_7_M46_noxref_g N_Q_c_2844_n ) capacitor c=0.00842859f \
 //x=24.895 //y=6.2 //x2=25 //y2=5.38
cc_1750 ( N_noxref_7_c_2536_n N_Q_c_2844_n ) capacitor c=8.41897e-19 \
 //x=24.885 //y=4.88 //x2=25 //y2=5.38
cc_1751 ( N_noxref_7_c_2526_n N_Q_c_2845_n ) capacitor c=0.00119302f //x=24.89 \
 //y=1.43 //x2=25.155 //y2=1.75
cc_1752 ( N_noxref_7_c_2528_n N_Q_c_2845_n ) capacitor c=0.00439215f //x=24.89 \
 //y=1.74 //x2=25.155 //y2=1.75
cc_1753 ( N_noxref_7_c_2564_p N_Q_c_2845_n ) capacitor c=0.00929773f \
 //x=25.265 //y=1.585 //x2=25.155 //y2=1.75
cc_1754 ( N_noxref_7_c_2532_n N_Q_c_2845_n ) capacitor c=0.00341295f //x=25.42 \
 //y=1.43 //x2=25.155 //y2=1.75
cc_1755 ( N_noxref_7_c_2544_p N_Q_c_2845_n ) capacitor c=0.00341688f \
 //x=24.855 //y=2.095 //x2=25.155 //y2=1.75
cc_1756 ( N_noxref_7_M47_noxref_g N_Q_c_2934_n ) capacitor c=0.0110849f \
 //x=25.335 //y=6.2 //x2=25.51 //y2=5.38
cc_1757 ( N_noxref_7_c_2564_p N_Q_c_2935_n ) capacitor c=0.00194324f \
 //x=25.265 //y=1.585 //x2=25.51 //y2=1.835
cc_1758 ( N_noxref_7_c_2532_n N_Q_c_2935_n ) capacitor c=0.00323005f //x=25.42 \
 //y=1.43 //x2=25.51 //y2=1.835
cc_1759 ( N_noxref_7_c_2488_n N_Q_c_2937_n ) capacitor c=0.0178819f //x=24.855 \
 //y=4.095 //x2=25.595 //y2=4.025
cc_1760 ( N_noxref_7_c_2551_p N_Q_c_2937_n ) capacitor c=0.00127572f //x=25.26 \
 //y=4.97 //x2=25.595 //y2=4.025
cc_1761 ( N_noxref_7_c_2406_n N_Q_c_2848_n ) capacitor c=0.0133617f //x=19.51 \
 //y=4.265 //x2=24.235 //y2=5.56
cc_1762 ( N_noxref_7_M46_noxref_g N_Q_c_2940_n ) capacitor c=0.00192712f \
 //x=24.895 //y=6.2 //x2=25.115 //y2=5.38
cc_1763 ( N_noxref_7_M47_noxref_g N_Q_c_2940_n ) capacitor c=0.00362563f \
 //x=25.335 //y=6.2 //x2=25.115 //y2=5.38
cc_1764 ( N_noxref_7_c_2551_p N_Q_c_2940_n ) capacitor c=0.0020909f //x=25.26 \
 //y=4.97 //x2=25.115 //y2=5.38
cc_1765 ( N_noxref_7_c_2523_n N_Q_c_2856_n ) capacitor c=0.00120406f //x=24.89 \
 //y=1.085 //x2=25.155 //y2=1.18
cc_1766 ( N_noxref_7_c_2526_n N_Q_c_2856_n ) capacitor c=0.00218772f //x=24.89 \
 //y=1.43 //x2=25.155 //y2=1.18
cc_1767 ( N_noxref_7_c_2578_p N_Q_c_2856_n ) capacitor c=5.50523e-19 \
 //x=25.265 //y=0.93 //x2=25.155 //y2=1.18
cc_1768 ( N_noxref_7_c_2564_p N_Q_c_2856_n ) capacitor c=5.67071e-19 \
 //x=25.265 //y=1.585 //x2=25.155 //y2=1.18
cc_1769 ( N_noxref_7_c_2531_n N_Q_c_2856_n ) capacitor c=0.00121175f //x=25.42 \
 //y=1.085 //x2=25.155 //y2=1.18
cc_1770 ( N_noxref_7_c_2532_n N_Q_c_2856_n ) capacitor c=0.00366282f //x=25.42 \
 //y=1.43 //x2=25.155 //y2=1.18
cc_1771 ( N_noxref_7_c_2488_n N_Q_c_2857_n ) capacitor c=2.03917e-19 \
 //x=24.855 //y=4.095 //x2=24.46 //y2=3.88
cc_1772 ( N_noxref_7_c_2496_n N_Q_c_2857_n ) capacitor c=0.00189457f \
 //x=24.855 //y=4.415 //x2=24.46 //y2=3.88
cc_1773 ( N_noxref_7_c_2406_n N_Q_c_2857_n ) capacitor c=0.272124f //x=19.51 \
 //y=4.265 //x2=24.46 //y2=3.88
cc_1774 ( N_noxref_7_c_2488_n N_Q_c_2952_n ) capacitor c=0.0275982f //x=24.855 \
 //y=4.095 //x2=25.06 //y2=3.87
cc_1775 ( N_noxref_7_c_2496_n N_Q_c_2952_n ) capacitor c=0.00450788f \
 //x=24.855 //y=4.415 //x2=25.06 //y2=3.87
cc_1776 ( N_noxref_7_c_2503_n N_Q_c_2952_n ) capacitor c=0.00161291f \
 //x=24.855 //y=2.26 //x2=25.06 //y2=3.87
cc_1777 ( N_noxref_7_c_2406_n N_Q_c_2952_n ) capacitor c=0.0374977f //x=19.51 \
 //y=4.265 //x2=25.06 //y2=3.87
cc_1778 ( N_noxref_7_c_2406_n N_Q_c_2784_n ) capacitor c=0.0374977f //x=19.51 \
 //y=4.265 //x2=21.685 //y2=3.865
cc_1779 ( N_noxref_7_M46_noxref_g N_Q_c_2957_n ) capacitor c=0.0178987f \
 //x=24.895 //y=6.2 //x2=25.115 //y2=5.56
cc_1780 ( N_noxref_7_M47_noxref_g N_Q_c_2957_n ) capacitor c=0.0178506f \
 //x=25.335 //y=6.2 //x2=25.115 //y2=5.56
cc_1781 ( N_noxref_7_c_2551_p N_Q_c_2957_n ) capacitor c=0.00291714f //x=25.26 \
 //y=4.97 //x2=25.115 //y2=5.56
cc_1782 ( N_noxref_7_c_2523_n N_Q_M15_noxref_d ) capacitor c=0.00137165f \
 //x=24.89 //y=1.085 //x2=24.965 //y2=1.085
cc_1783 ( N_noxref_7_c_2526_n N_Q_M15_noxref_d ) capacitor c=0.00237422f \
 //x=24.89 //y=1.43 //x2=24.965 //y2=1.085
cc_1784 ( N_noxref_7_c_2578_p N_Q_M15_noxref_d ) capacitor c=0.0020782f \
 //x=25.265 //y=0.93 //x2=24.965 //y2=1.085
cc_1785 ( N_noxref_7_c_2564_p N_Q_M15_noxref_d ) capacitor c=0.00356097f \
 //x=25.265 //y=1.585 //x2=24.965 //y2=1.085
cc_1786 ( N_noxref_7_c_2531_n N_Q_M15_noxref_d ) capacitor c=8.50095e-19 \
 //x=25.42 //y=1.085 //x2=24.965 //y2=1.085
cc_1787 ( N_noxref_7_c_2532_n N_Q_M15_noxref_d ) capacitor c=0.00237422f \
 //x=25.42 //y=1.43 //x2=24.965 //y2=1.085
cc_1788 ( N_noxref_7_c_2298_n N_VDD_c_3043_n ) capacitor c=3.8494e-19 \
 //x=1.545 //y=4.42 //x2=25.965 //y2=7.58
cc_1789 ( N_noxref_7_c_2241_n N_VDD_c_3043_n ) capacitor c=0.00621352f \
 //x=15.675 //y=5.335 //x2=25.965 //y2=7.58
cc_1790 ( N_noxref_7_c_2313_n N_VDD_c_3043_n ) capacitor c=0.00627192f \
 //x=16.56 //y=5.335 //x2=25.965 //y2=7.58
cc_1791 ( N_noxref_7_c_2420_n N_VDD_c_3043_n ) capacitor c=0.00256036f \
 //x=16.675 //y=5.56 //x2=25.965 //y2=7.58
cc_1792 ( N_noxref_7_c_2422_n N_VDD_c_3043_n ) capacitor c=0.00829214f \
 //x=17.37 //y=5.335 //x2=25.965 //y2=7.58
cc_1793 ( N_noxref_7_c_2377_n N_VDD_c_3043_n ) capacitor c=2.29405e-19 \
 //x=17.455 //y=4.415 //x2=25.965 //y2=7.58
cc_1794 ( N_noxref_7_c_2246_n N_VDD_c_3043_n ) capacitor c=0.00261804f \
 //x=14.917 //y=5.335 //x2=25.965 //y2=7.58
cc_1795 ( N_noxref_7_c_2318_n N_VDD_c_3043_n ) capacitor c=0.00270108f \
 //x=15.795 //y=5.335 //x2=25.965 //y2=7.58
cc_1796 ( N_noxref_7_c_2461_n N_VDD_c_3043_n ) capacitor c=3.94104e-19 \
 //x=17.455 //y=4.25 //x2=25.965 //y2=7.58
cc_1797 ( N_noxref_7_c_2258_n N_VDD_c_3043_n ) capacitor c=0.0024232f \
 //x=14.915 //y=5.56 //x2=25.965 //y2=7.58
cc_1798 ( N_noxref_7_c_2343_n N_VDD_c_3043_n ) capacitor c=0.0024232f \
 //x=15.795 //y=5.56 //x2=25.965 //y2=7.58
cc_1799 ( N_noxref_7_c_2474_n N_VDD_c_3043_n ) capacitor c=0.0024232f \
 //x=16.675 //y=5.56 //x2=25.965 //y2=7.58
cc_1800 ( N_noxref_7_c_2298_n N_VDD_c_3178_n ) capacitor c=0.001923f //x=1.545 \
 //y=4.42 //x2=1.175 //y2=7.58
cc_1801 ( N_noxref_7_c_2173_n N_VDD_c_3178_n ) capacitor c=0.0157044f \
 //x=1.545 //y=4.755 //x2=1.175 //y2=7.58
cc_1802 ( N_noxref_7_c_2316_n N_VDD_c_3178_n ) capacitor c=0.00229603f \
 //x=1.545 //y=4.25 //x2=1.175 //y2=7.58
cc_1803 ( N_noxref_7_c_2340_n N_VDD_c_3178_n ) capacitor c=0.00371026f \
 //x=1.545 //y=4.88 //x2=1.175 //y2=7.58
cc_1804 ( N_noxref_7_c_2364_n N_VDD_c_3178_n ) capacitor c=0.00594885f \
 //x=1.82 //y=4.97 //x2=1.175 //y2=7.58
cc_1805 ( N_noxref_7_c_2298_n N_VDD_c_3180_n ) capacitor c=3.24038e-19 \
 //x=1.545 //y=4.42 //x2=2.32 //y2=7.585
cc_1806 ( N_noxref_7_M16_noxref_g N_VDD_c_3180_n ) capacitor c=0.00755614f \
 //x=1.745 //y=6.2 //x2=2.32 //y2=7.585
cc_1807 ( N_noxref_7_M17_noxref_g N_VDD_c_3180_n ) capacitor c=0.00755544f \
 //x=2.185 //y=6.2 //x2=2.32 //y2=7.585
cc_1808 ( N_noxref_7_M30_noxref_g N_VDD_c_3114_n ) capacitor c=0.00697352f \
 //x=11.945 //y=6.2 //x2=12.52 //y2=7.585
cc_1809 ( N_noxref_7_M31_noxref_g N_VDD_c_3114_n ) capacitor c=0.00755544f \
 //x=12.385 //y=6.2 //x2=12.52 //y2=7.585
cc_1810 ( N_noxref_7_c_2241_n N_VDD_c_3119_n ) capacitor c=0.00202922f \
 //x=15.675 //y=5.335 //x2=15.27 //y2=7.585
cc_1811 ( N_noxref_7_c_2246_n N_VDD_c_3119_n ) capacitor c=9.3757e-19 \
 //x=14.917 //y=5.335 //x2=15.27 //y2=7.585
cc_1812 ( N_noxref_7_c_2258_n N_VDD_c_3119_n ) capacitor c=0.0138074f \
 //x=14.915 //y=5.56 //x2=15.27 //y2=7.585
cc_1813 ( N_noxref_7_c_2241_n N_VDD_c_3154_n ) capacitor c=0.0017708f \
 //x=15.675 //y=5.335 //x2=16.15 //y2=7.585
cc_1814 ( N_noxref_7_c_2313_n N_VDD_c_3154_n ) capacitor c=0.00202922f \
 //x=16.56 //y=5.335 //x2=16.15 //y2=7.585
cc_1815 ( N_noxref_7_c_2318_n N_VDD_c_3154_n ) capacitor c=9.4822e-19 \
 //x=15.795 //y=5.335 //x2=16.15 //y2=7.585
cc_1816 ( N_noxref_7_c_2343_n N_VDD_c_3154_n ) capacitor c=0.0138074f \
 //x=15.795 //y=5.56 //x2=16.15 //y2=7.585
cc_1817 ( N_noxref_7_c_2313_n N_VDD_c_3233_n ) capacitor c=0.00205906f \
 //x=16.56 //y=5.335 //x2=17.03 //y2=7.585
cc_1818 ( N_noxref_7_c_2420_n N_VDD_c_3233_n ) capacitor c=8.49654e-19 \
 //x=16.675 //y=5.56 //x2=17.03 //y2=7.585
cc_1819 ( N_noxref_7_c_2422_n N_VDD_c_3233_n ) capacitor c=0.00204238f \
 //x=17.37 //y=5.335 //x2=17.03 //y2=7.585
cc_1820 ( N_noxref_7_c_2474_n N_VDD_c_3233_n ) capacitor c=0.0138074f \
 //x=16.675 //y=5.56 //x2=17.03 //y2=7.585
cc_1821 ( N_noxref_7_c_2422_n N_VDD_c_3333_n ) capacitor c=0.00157252f \
 //x=17.37 //y=5.335 //x2=18.025 //y2=7.585
cc_1822 ( N_noxref_7_M46_noxref_g N_VDD_c_3334_n ) capacitor c=0.00697352f \
 //x=24.895 //y=6.2 //x2=25.47 //y2=7.585
cc_1823 ( N_noxref_7_M47_noxref_g N_VDD_c_3334_n ) capacitor c=0.00755544f \
 //x=25.335 //y=6.2 //x2=25.47 //y2=7.585
cc_1824 ( N_noxref_7_c_2502_n N_VDD_c_3336_n ) capacitor c=0.00143727f \
 //x=24.855 //y=4.25 //x2=25.965 //y2=7.58
cc_1825 ( N_noxref_7_c_2517_n N_VDD_c_3336_n ) capacitor c=0.00226427f \
 //x=24.885 //y=4.88 //x2=25.965 //y2=7.58
cc_1826 ( N_noxref_7_c_2551_p N_VDD_c_3336_n ) capacitor c=0.0235217f \
 //x=25.26 //y=4.97 //x2=25.965 //y2=7.58
cc_1827 ( N_noxref_7_c_2536_n N_VDD_c_3336_n ) capacitor c=2.73429e-19 \
 //x=24.885 //y=4.88 //x2=25.965 //y2=7.58
cc_1828 ( N_noxref_7_c_2196_n N_VDD_c_3073_n ) capacitor c=5.71665e-19 \
 //x=4.76 //y=4.27 //x2=5.245 //y2=7.585
cc_1829 ( N_noxref_7_c_2197_n N_VDD_c_3073_n ) capacitor c=0.00910495f \
 //x=5.975 //y=4.25 //x2=5.245 //y2=7.585
cc_1830 ( N_noxref_7_c_2188_n N_VDD_c_3077_n ) capacitor c=8.4651e-19 \
 //x=11.905 //y=4.25 //x2=10.055 //y2=7.585
cc_1831 ( N_noxref_7_c_2199_n N_VDD_c_3077_n ) capacitor c=0.00875046f \
 //x=12.07 //y=4.25 //x2=10.055 //y2=7.585
cc_1832 ( N_noxref_7_c_2188_n N_VDD_c_3124_n ) capacitor c=0.00133334f \
 //x=11.905 //y=4.25 //x2=13.385 //y2=7.585
cc_1833 ( N_noxref_7_c_2246_n N_VDD_c_3124_n ) capacitor c=0.0022955f \
 //x=14.917 //y=5.335 //x2=13.385 //y2=7.585
cc_1834 ( N_noxref_7_c_2251_n N_VDD_c_3124_n ) capacitor c=0.00867114f \
 //x=17.3 //y=4.25 //x2=13.385 //y2=7.585
cc_1835 ( N_noxref_7_c_2207_n N_VDD_c_3124_n ) capacitor c=0.00226427f \
 //x=11.935 //y=4.88 //x2=13.385 //y2=7.585
cc_1836 ( N_noxref_7_c_2258_n N_VDD_c_3124_n ) capacitor c=0.00508013f \
 //x=14.915 //y=5.56 //x2=13.385 //y2=7.585
cc_1837 ( N_noxref_7_c_2273_n N_VDD_c_3124_n ) capacitor c=0.0129149f \
 //x=12.31 //y=4.97 //x2=13.385 //y2=7.585
cc_1838 ( N_noxref_7_c_2226_n N_VDD_c_3124_n ) capacitor c=2.73429e-19 \
 //x=11.935 //y=4.88 //x2=13.385 //y2=7.585
cc_1839 ( N_noxref_7_c_2420_n N_VDD_c_3202_n ) capacitor c=0.00282782f \
 //x=16.675 //y=5.56 //x2=18.195 //y2=7.585
cc_1840 ( N_noxref_7_c_2377_n N_VDD_c_3202_n ) capacitor c=0.00175322f \
 //x=17.455 //y=4.415 //x2=18.195 //y2=7.585
cc_1841 ( N_noxref_7_c_2315_n N_VDD_c_3202_n ) capacitor c=0.0309939f \
 //x=17.455 //y=5.25 //x2=18.195 //y2=7.585
cc_1842 ( N_noxref_7_c_2461_n N_VDD_c_3202_n ) capacitor c=0.00507985f \
 //x=17.455 //y=4.25 //x2=18.195 //y2=7.585
cc_1843 ( N_noxref_7_c_2408_n N_VDD_c_3202_n ) capacitor c=0.0195443f \
 //x=19.165 //y=4.265 //x2=18.195 //y2=7.585
cc_1844 ( N_noxref_7_c_2474_n N_VDD_c_3202_n ) capacitor c=0.00777981f \
 //x=16.675 //y=5.56 //x2=18.195 //y2=7.585
cc_1845 ( N_noxref_7_c_2502_n N_VDD_c_3277_n ) capacitor c=8.50173e-19 \
 //x=24.855 //y=4.25 //x2=23.005 //y2=7.585
cc_1846 ( N_noxref_7_c_2406_n N_VDD_c_3277_n ) capacitor c=0.0196209f \
 //x=19.51 //y=4.265 //x2=23.005 //y2=7.585
cc_1847 ( N_noxref_7_c_2298_n N_VDD_M16_noxref_s ) capacitor c=9.65642e-19 \
 //x=1.545 //y=4.42 //x2=1.39 //y2=5.2
cc_1848 ( N_noxref_7_c_2173_n N_VDD_M16_noxref_s ) capacitor c=0.0223496f \
 //x=1.545 //y=4.755 //x2=1.39 //y2=5.2
cc_1849 ( N_noxref_7_c_2335_n N_VDD_M16_noxref_s ) capacitor c=4.28833e-19 \
 //x=1.705 //y=4.26 //x2=1.39 //y2=5.2
cc_1850 ( N_noxref_7_c_2340_n N_VDD_M16_noxref_s ) capacitor c=0.00911317f \
 //x=1.545 //y=4.88 //x2=1.39 //y2=5.2
cc_1851 ( N_noxref_7_M16_noxref_g N_VDD_M16_noxref_s ) capacitor c=0.053419f \
 //x=1.745 //y=6.2 //x2=1.39 //y2=5.2
cc_1852 ( N_noxref_7_c_2364_n N_VDD_M16_noxref_s ) capacitor c=0.00597604f \
 //x=1.82 //y=4.97 //x2=1.39 //y2=5.2
cc_1853 ( N_noxref_7_M17_noxref_g N_VDD_M17_noxref_d ) capacitor c=0.015318f \
 //x=2.185 //y=6.2 //x2=2.26 //y2=5.2
cc_1854 ( N_noxref_7_c_2246_n N_VDD_M28_noxref_s ) capacitor c=4.22189e-19 \
 //x=14.917 //y=5.335 //x2=10.71 //y2=5.2
cc_1855 ( N_noxref_7_M30_noxref_g N_VDD_M29_noxref_d ) capacitor c=0.015318f \
 //x=11.945 //y=6.2 //x2=11.58 //y2=5.2
cc_1856 ( N_noxref_7_c_2226_n N_VDD_M29_noxref_d ) capacitor c=3.50465e-19 \
 //x=11.935 //y=4.88 //x2=11.58 //y2=5.2
cc_1857 ( N_noxref_7_M31_noxref_g N_VDD_M31_noxref_d ) capacitor c=0.0430452f \
 //x=12.385 //y=6.2 //x2=12.46 //y2=5.2
cc_1858 ( N_noxref_7_c_2246_n N_VDD_M32_noxref_s ) capacitor c=0.0442713f \
 //x=14.917 //y=5.335 //x2=14.34 //y2=5.2
cc_1859 ( N_noxref_7_c_2318_n N_VDD_M32_noxref_s ) capacitor c=7.80122e-19 \
 //x=15.795 //y=5.335 //x2=14.34 //y2=5.2
cc_1860 ( N_noxref_7_c_2258_n N_VDD_M32_noxref_s ) capacitor c=0.0908457f \
 //x=14.915 //y=5.56 //x2=14.34 //y2=5.2
cc_1861 ( N_noxref_7_c_2241_n N_VDD_M33_noxref_d ) capacitor c=0.00700141f \
 //x=15.675 //y=5.335 //x2=15.21 //y2=5.2
cc_1862 ( N_noxref_7_c_2258_n N_VDD_M33_noxref_d ) capacitor c=0.0673792f \
 //x=14.915 //y=5.56 //x2=15.21 //y2=5.2
cc_1863 ( N_noxref_7_c_2343_n N_VDD_M33_noxref_d ) capacitor c=0.0674762f \
 //x=15.795 //y=5.56 //x2=15.21 //y2=5.2
cc_1864 ( N_noxref_7_c_2313_n N_VDD_M35_noxref_d ) capacitor c=0.00700141f \
 //x=16.56 //y=5.335 //x2=16.09 //y2=5.2
cc_1865 ( N_noxref_7_c_2343_n N_VDD_M35_noxref_d ) capacitor c=0.067493f \
 //x=15.795 //y=5.56 //x2=16.09 //y2=5.2
cc_1866 ( N_noxref_7_c_2474_n N_VDD_M35_noxref_d ) capacitor c=0.0674979f \
 //x=16.675 //y=5.56 //x2=16.09 //y2=5.2
cc_1867 ( N_noxref_7_c_2422_n N_VDD_M37_noxref_d ) capacitor c=0.00700141f \
 //x=17.37 //y=5.335 //x2=16.97 //y2=5.2
cc_1868 ( N_noxref_7_c_2474_n N_VDD_M37_noxref_d ) capacitor c=0.0675002f \
 //x=16.675 //y=5.56 //x2=16.97 //y2=5.2
cc_1869 ( N_noxref_7_c_2420_n N_VDD_M38_noxref_s ) capacitor c=0.00492616f \
 //x=16.675 //y=5.56 //x2=19.15 //y2=5.2
cc_1870 ( N_noxref_7_c_2422_n N_VDD_M38_noxref_s ) capacitor c=9.42705e-19 \
 //x=17.37 //y=5.335 //x2=19.15 //y2=5.2
cc_1871 ( N_noxref_7_c_2318_n N_VDD_M38_noxref_s ) capacitor c=2.11884e-19 \
 //x=15.795 //y=5.335 //x2=19.15 //y2=5.2
cc_1872 ( N_noxref_7_c_2408_n N_VDD_M38_noxref_s ) capacitor c=4.36524e-19 \
 //x=19.165 //y=4.265 //x2=19.15 //y2=5.2
cc_1873 ( N_noxref_7_c_2406_n N_VDD_M44_noxref_s ) capacitor c=0.00556024f \
 //x=19.51 //y=4.265 //x2=23.66 //y2=5.2
cc_1874 ( N_noxref_7_M46_noxref_g N_VDD_M45_noxref_d ) capacitor c=0.015318f \
 //x=24.895 //y=6.2 //x2=24.53 //y2=5.2
cc_1875 ( N_noxref_7_c_2536_n N_VDD_M45_noxref_d ) capacitor c=3.50465e-19 \
 //x=24.885 //y=4.88 //x2=24.53 //y2=5.2
cc_1876 ( N_noxref_7_M47_noxref_g N_VDD_M47_noxref_d ) capacitor c=0.0430452f \
 //x=25.335 //y=6.2 //x2=25.41 //y2=5.2
cc_1877 ( N_noxref_7_c_2199_n D ) capacitor c=0.023924f //x=12.07 //y=4.25 \
 //x2=7.465 //y2=2.77
cc_1878 ( N_noxref_7_c_2426_n N_noxref_13_c_3711_n ) capacitor c=0.0036878f \
 //x=16.97 //y=1.305 //x2=17.37 //y2=0.72
cc_1879 ( N_noxref_7_c_2439_n N_noxref_13_c_3711_n ) capacitor c=0.00399931f \
 //x=17.37 //y=1.845 //x2=17.37 //y2=0.72
cc_1880 ( N_noxref_7_M10_noxref_d N_noxref_13_c_3711_n ) capacitor \
 c=0.00910163f //x=16.78 //y=1.095 //x2=17.37 //y2=0.72
cc_1881 ( N_noxref_7_M10_noxref_d N_noxref_13_c_3716_n ) capacitor \
 c=0.00120711f //x=16.78 //y=1.095 //x2=16.485 //y2=1.175
cc_1882 ( N_noxref_7_c_2241_n N_noxref_13_M9_noxref_d ) capacitor \
 c=0.00143783f //x=15.675 //y=5.335 //x2=15.245 //y2=1.09
cc_1883 ( N_noxref_7_c_2426_n N_noxref_13_M9_noxref_d ) capacitor \
 c=0.00802417f //x=16.97 //y=1.305 //x2=15.245 //y2=1.09
cc_1884 ( N_noxref_7_c_2426_n N_noxref_13_M10_noxref_s ) capacitor \
 c=0.0098487f //x=16.97 //y=1.305 //x2=16.35 //y2=0.555
cc_1885 ( N_noxref_7_c_2242_n N_noxref_13_M10_noxref_s ) capacitor \
 c=0.0283111f //x=16.97 //y=1.76 //x2=16.35 //y2=0.555
cc_1886 ( N_noxref_7_c_2439_n N_noxref_13_M10_noxref_s ) capacitor \
 c=0.00942148f //x=17.37 //y=1.845 //x2=16.35 //y2=0.555
cc_1887 ( N_noxref_7_c_2461_n N_noxref_13_M10_noxref_s ) capacitor \
 c=0.00108527f //x=17.455 //y=4.25 //x2=16.35 //y2=0.555
cc_1888 ( N_noxref_7_M10_noxref_d N_noxref_13_M10_noxref_s ) capacitor \
 c=0.0279003f //x=16.78 //y=1.095 //x2=16.35 //y2=0.555
cc_1889 ( N_noxref_7_c_2426_n N_noxref_14_M12_noxref_d ) capacitor \
 c=3.20746e-19 //x=16.97 //y=1.305 //x2=20.055 //y2=1.09
cc_1890 ( N_noxref_7_c_2350_n N_GND_c_4034_n ) capacitor c=3.97665e-19 \
 //x=1.245 //y=1.055 //x2=1.51 //y2=1.015
cc_1891 ( N_noxref_7_c_2702_p N_GND_c_4034_n ) capacitor c=0.00864776f \
 //x=1.62 //y=0.9 //x2=1.51 //y2=1.015
cc_1892 ( N_noxref_7_c_2356_n N_GND_c_4034_n ) capacitor c=4.45447e-19 \
 //x=1.775 //y=1.055 //x2=1.51 //y2=1.015
cc_1893 ( N_noxref_7_c_2189_n N_GND_c_3871_n ) capacitor c=0.00210951f \
 //x=11.905 //y=2.26 //x2=14.375 //y2=0.175
cc_1894 ( N_noxref_7_c_2426_n N_GND_c_3913_n ) capacitor c=0.00878061f \
 //x=16.97 //y=1.305 //x2=19.185 //y2=0.175
cc_1895 ( N_noxref_7_c_2439_n N_GND_c_3913_n ) capacitor c=0.00662992f \
 //x=17.37 //y=1.845 //x2=19.185 //y2=0.175
cc_1896 ( N_noxref_7_M10_noxref_d N_GND_c_3913_n ) capacitor c=2.9462e-19 \
 //x=16.78 //y=1.095 //x2=19.185 //y2=0.175
cc_1897 ( N_noxref_7_c_2496_n N_GND_c_4041_n ) capacitor c=2.49555e-19 \
 //x=24.855 //y=4.415 //x2=25.965 //y2=0.18
cc_1898 ( N_noxref_7_c_2503_n N_GND_c_4041_n ) capacitor c=0.00234561f \
 //x=24.855 //y=2.26 //x2=25.965 //y2=0.18
cc_1899 ( N_noxref_7_c_2293_n N_GND_c_4043_n ) capacitor c=0.00849742f \
 //x=1.545 //y=2.375 //x2=1.51 //y2=1.145
cc_1900 ( N_noxref_7_c_2298_n N_GND_c_4043_n ) capacitor c=5.61357e-19 \
 //x=1.545 //y=4.42 //x2=1.51 //y2=1.145
cc_1901 ( N_noxref_7_c_2336_n N_GND_c_4043_n ) capacitor c=2.22883e-19 \
 //x=1.545 //y=2.26 //x2=1.51 //y2=1.145
cc_1902 ( N_noxref_7_c_2350_n N_GND_c_4043_n ) capacitor c=0.00142616f \
 //x=1.245 //y=1.055 //x2=1.51 //y2=1.145
cc_1903 ( N_noxref_7_c_2351_n N_GND_c_4043_n ) capacitor c=0.00411286f \
 //x=1.245 //y=1.4 //x2=1.51 //y2=1.145
cc_1904 ( N_noxref_7_c_2352_n N_GND_c_4043_n ) capacitor c=4.60246e-19 \
 //x=1.245 //y=1.71 //x2=1.51 //y2=1.145
cc_1905 ( N_noxref_7_c_2702_p N_GND_c_4043_n ) capacitor c=7.3749e-19 //x=1.62 \
 //y=0.9 //x2=1.51 //y2=1.145
cc_1906 ( N_noxref_7_c_2717_p N_GND_c_4043_n ) capacitor c=6.09813e-19 \
 //x=1.62 //y=1.555 //x2=1.51 //y2=1.145
cc_1907 ( N_noxref_7_c_2356_n N_GND_c_4043_n ) capacitor c=0.0017438f \
 //x=1.775 //y=1.055 //x2=1.51 //y2=1.145
cc_1908 ( N_noxref_7_c_2358_n N_GND_c_4043_n ) capacitor c=0.00276804f \
 //x=1.775 //y=1.4 //x2=1.51 //y2=1.145
cc_1909 ( N_noxref_7_c_2426_n N_GND_c_3935_n ) capacitor c=0.00543195f \
 //x=16.97 //y=1.305 //x2=19.27 //y2=1.145
cc_1910 ( N_noxref_7_c_2350_n N_GND_c_3848_n ) capacitor c=0.00680635f \
 //x=1.245 //y=1.055 //x2=5.075 //y2=0.175
cc_1911 ( N_noxref_7_c_2293_n N_GND_c_4055_n ) capacitor c=0.00779049f \
 //x=1.545 //y=2.375 //x2=1.175 //y2=0.18
cc_1912 ( N_noxref_7_c_2171_n N_GND_c_4055_n ) capacitor c=0.0126319f \
 //x=1.545 //y=4.1 //x2=1.175 //y2=0.18
cc_1913 ( N_noxref_7_c_2336_n N_GND_c_4055_n ) capacitor c=0.00394776f \
 //x=1.545 //y=2.26 //x2=1.175 //y2=0.18
cc_1914 ( N_noxref_7_c_2352_n N_GND_c_4055_n ) capacitor c=0.00295461f \
 //x=1.245 //y=1.71 //x2=1.175 //y2=0.18
cc_1915 ( N_noxref_7_c_2353_n N_GND_c_4055_n ) capacitor c=0.0112432f \
 //x=1.245 //y=2.095 //x2=1.175 //y2=0.18
cc_1916 ( N_noxref_7_c_2189_n N_GND_c_3851_n ) capacitor c=3.77328e-19 \
 //x=11.905 //y=2.26 //x2=13.215 //y2=0.175
cc_1917 ( N_noxref_7_c_2439_n N_GND_c_3894_n ) capacitor c=6.86343e-19 \
 //x=17.37 //y=1.845 //x2=18.025 //y2=0.175
cc_1918 ( N_noxref_7_c_2503_n N_GND_c_4018_n ) capacitor c=3.77328e-19 \
 //x=24.855 //y=2.26 //x2=25.965 //y2=0.18
cc_1919 ( N_noxref_7_c_2513_n N_GND_c_4018_n ) capacitor c=0.00224736f \
 //x=24.855 //y=2.26 //x2=25.965 //y2=0.18
cc_1920 ( N_noxref_7_c_2532_n N_GND_c_4018_n ) capacitor c=0.0028807f \
 //x=25.42 //y=1.43 //x2=25.965 //y2=0.18
cc_1921 ( N_noxref_7_c_2533_n N_GND_c_4018_n ) capacitor c=2.63786e-19 \
 //x=24.855 //y=2.26 //x2=25.965 //y2=0.18
cc_1922 ( N_noxref_7_c_2203_n N_GND_c_3896_n ) capacitor c=0.00207214f \
 //x=11.905 //y=2.26 //x2=13.385 //y2=0.175
cc_1923 ( N_noxref_7_c_2222_n N_GND_c_3896_n ) capacitor c=0.00275184f \
 //x=12.47 //y=1.43 //x2=13.385 //y2=0.175
cc_1924 ( N_noxref_7_c_2223_n N_GND_c_3896_n ) capacitor c=2.63786e-19 \
 //x=11.905 //y=2.26 //x2=13.385 //y2=0.175
cc_1925 ( N_noxref_7_c_2242_n N_GND_c_3955_n ) capacitor c=0.0045138f \
 //x=16.97 //y=1.76 //x2=18.195 //y2=0.175
cc_1926 ( N_noxref_7_c_2439_n N_GND_c_3955_n ) capacitor c=0.0337719f \
 //x=17.37 //y=1.845 //x2=18.195 //y2=0.175
cc_1927 ( N_noxref_7_c_2293_n N_GND_M0_noxref_d ) capacitor c=4.4417e-19 \
 //x=1.545 //y=2.375 //x2=1.32 //y2=1.055
cc_1928 ( N_noxref_7_c_2350_n N_GND_M0_noxref_d ) capacitor c=0.00184354f \
 //x=1.245 //y=1.055 //x2=1.32 //y2=1.055
cc_1929 ( N_noxref_7_c_2351_n N_GND_M0_noxref_d ) capacitor c=0.00210798f \
 //x=1.245 //y=1.4 //x2=1.32 //y2=1.055
cc_1930 ( N_noxref_7_c_2702_p N_GND_M0_noxref_d ) capacitor c=0.00474029f \
 //x=1.62 //y=0.9 //x2=1.32 //y2=1.055
cc_1931 ( N_noxref_7_c_2717_p N_GND_M0_noxref_d ) capacitor c=0.00166857f \
 //x=1.62 //y=1.555 //x2=1.32 //y2=1.055
cc_1932 ( N_noxref_7_c_2356_n N_GND_M0_noxref_d ) capacitor c=0.00230174f \
 //x=1.775 //y=1.055 //x2=1.32 //y2=1.055
cc_1933 ( N_noxref_7_c_2358_n N_GND_M0_noxref_d ) capacitor c=0.00210798f \
 //x=1.775 //y=1.4 //x2=1.32 //y2=1.055
cc_1934 ( N_noxref_7_c_2353_n N_noxref_16_c_4299_n ) capacitor c=0.00267608f \
 //x=1.245 //y=2.095 //x2=1.025 //y2=1.685
cc_1935 ( N_noxref_7_c_2293_n N_noxref_16_c_4300_n ) capacitor c=0.00428451f \
 //x=1.545 //y=2.375 //x2=1.91 //y2=1.77
cc_1936 ( N_noxref_7_c_2298_n N_noxref_16_c_4300_n ) capacitor c=0.00107729f \
 //x=1.545 //y=4.42 //x2=1.91 //y2=1.77
cc_1937 ( N_noxref_7_c_2336_n N_noxref_16_c_4300_n ) capacitor c=0.0104666f \
 //x=1.545 //y=2.26 //x2=1.91 //y2=1.77
cc_1938 ( N_noxref_7_c_2352_n N_noxref_16_c_4300_n ) capacitor c=0.00703864f \
 //x=1.245 //y=1.71 //x2=1.91 //y2=1.77
cc_1939 ( N_noxref_7_c_2353_n N_noxref_16_c_4300_n ) capacitor c=0.0232409f \
 //x=1.245 //y=2.095 //x2=1.91 //y2=1.77
cc_1940 ( N_noxref_7_c_2717_p N_noxref_16_c_4300_n ) capacitor c=0.00588627f \
 //x=1.62 //y=1.555 //x2=1.91 //y2=1.77
cc_1941 ( N_noxref_7_c_2358_n N_noxref_16_c_4300_n ) capacitor c=0.00698822f \
 //x=1.775 //y=1.4 //x2=1.91 //y2=1.77
cc_1942 ( N_noxref_7_c_2350_n N_noxref_16_M0_noxref_s ) capacitor c=0.0295256f \
 //x=1.245 //y=1.055 //x2=0.89 //y2=0.555
cc_1943 ( N_noxref_7_c_2352_n N_noxref_16_M0_noxref_s ) capacitor \
 c=7.99997e-19 //x=1.245 //y=1.71 //x2=0.89 //y2=0.555
cc_1944 ( N_noxref_7_c_2353_n N_noxref_16_M0_noxref_s ) capacitor \
 c=0.00122123f //x=1.245 //y=2.095 //x2=0.89 //y2=0.555
cc_1945 ( N_noxref_7_c_2356_n N_noxref_16_M0_noxref_s ) capacitor c=0.0125924f \
 //x=1.775 //y=1.055 //x2=0.89 //y2=0.555
cc_1946 ( N_noxref_7_c_2182_n N_noxref_18_c_4407_n ) capacitor c=9.49001e-19 \
 //x=11.905 //y=4.41 //x2=11.72 //y2=1.675
cc_1947 ( N_noxref_7_c_2189_n N_noxref_18_c_4407_n ) capacitor c=7.50092e-19 \
 //x=11.905 //y=2.26 //x2=11.72 //y2=1.675
cc_1948 ( N_noxref_7_c_2218_n N_noxref_18_c_4407_n ) capacitor c=0.00888238f \
 //x=11.94 //y=1.74 //x2=11.72 //y2=1.675
cc_1949 ( N_noxref_7_c_2223_n N_noxref_18_c_4407_n ) capacitor c=0.00175171f \
 //x=11.905 //y=2.26 //x2=11.72 //y2=1.675
cc_1950 ( N_noxref_7_c_2189_n N_noxref_18_c_4412_n ) capacitor c=0.001463f \
 //x=11.905 //y=2.26 //x2=12.605 //y2=0.71
cc_1951 ( N_noxref_7_c_2203_n N_noxref_18_c_4412_n ) capacitor c=8.82141e-19 \
 //x=11.905 //y=2.26 //x2=12.605 //y2=0.71
cc_1952 ( N_noxref_7_c_2213_n N_noxref_18_c_4412_n ) capacitor c=0.0200738f \
 //x=11.94 //y=1.085 //x2=12.605 //y2=0.71
cc_1953 ( N_noxref_7_c_2221_n N_noxref_18_c_4412_n ) capacitor c=0.00825432f \
 //x=12.47 //y=1.085 //x2=12.605 //y2=0.71
cc_1954 ( N_noxref_7_c_2223_n N_noxref_18_c_4412_n ) capacitor c=2.1838e-19 \
 //x=11.905 //y=2.26 //x2=12.605 //y2=0.71
cc_1955 ( N_noxref_7_c_2213_n N_noxref_18_M6_noxref_s ) capacitor \
 c=0.00888238f //x=11.94 //y=1.085 //x2=10.615 //y2=0.545
cc_1956 ( N_noxref_7_c_2221_n N_noxref_18_M6_noxref_s ) capacitor c=0.015333f \
 //x=12.47 //y=1.085 //x2=10.615 //y2=0.545
cc_1957 ( N_noxref_7_c_2222_n N_noxref_18_M6_noxref_s ) capacitor \
 c=0.00248746f //x=12.47 //y=1.43 //x2=10.615 //y2=0.545
cc_1958 ( N_noxref_7_c_2496_n N_noxref_21_c_4593_n ) capacitor c=9.65024e-19 \
 //x=24.855 //y=4.415 //x2=24.67 //y2=1.675
cc_1959 ( N_noxref_7_c_2503_n N_noxref_21_c_4593_n ) capacitor c=7.50092e-19 \
 //x=24.855 //y=2.26 //x2=24.67 //y2=1.675
cc_1960 ( N_noxref_7_c_2528_n N_noxref_21_c_4593_n ) capacitor c=0.00888238f \
 //x=24.89 //y=1.74 //x2=24.67 //y2=1.675
cc_1961 ( N_noxref_7_c_2533_n N_noxref_21_c_4593_n ) capacitor c=0.00175171f \
 //x=24.855 //y=2.26 //x2=24.67 //y2=1.675
cc_1962 ( N_noxref_7_c_2503_n N_noxref_21_c_4601_n ) capacitor c=0.001463f \
 //x=24.855 //y=2.26 //x2=25.555 //y2=0.71
cc_1963 ( N_noxref_7_c_2513_n N_noxref_21_c_4601_n ) capacitor c=8.82141e-19 \
 //x=24.855 //y=2.26 //x2=25.555 //y2=0.71
cc_1964 ( N_noxref_7_c_2523_n N_noxref_21_c_4601_n ) capacitor c=0.0200072f \
 //x=24.89 //y=1.085 //x2=25.555 //y2=0.71
cc_1965 ( N_noxref_7_c_2531_n N_noxref_21_c_4601_n ) capacitor c=0.00825432f \
 //x=25.42 //y=1.085 //x2=25.555 //y2=0.71
cc_1966 ( N_noxref_7_c_2533_n N_noxref_21_c_4601_n ) capacitor c=2.1838e-19 \
 //x=24.855 //y=2.26 //x2=25.555 //y2=0.71
cc_1967 ( N_noxref_7_c_2523_n N_noxref_21_M14_noxref_s ) capacitor \
 c=0.00888238f //x=24.89 //y=1.085 //x2=23.565 //y2=0.545
cc_1968 ( N_noxref_7_c_2531_n N_noxref_21_M14_noxref_s ) capacitor c=0.015333f \
 //x=25.42 //y=1.085 //x2=23.565 //y2=0.545
cc_1969 ( N_noxref_7_c_2532_n N_noxref_21_M14_noxref_s ) capacitor \
 c=0.00248746f //x=25.42 //y=1.43 //x2=23.565 //y2=0.545
cc_1970 ( N_Q_c_2844_n N_VDD_c_3043_n ) capacitor c=0.00648267f //x=25 \
 //y=5.38 //x2=25.965 //y2=7.58
cc_1971 ( N_Q_c_2934_n N_VDD_c_3043_n ) capacitor c=0.00492578f //x=25.51 \
 //y=5.38 //x2=25.965 //y2=7.58
cc_1972 ( N_Q_c_2848_n N_VDD_c_3043_n ) capacitor c=0.00368834f //x=24.235 \
 //y=5.56 //x2=25.965 //y2=7.58
cc_1973 ( N_Q_c_2940_n N_VDD_c_3043_n ) capacitor c=8.4268e-19 //x=25.115 \
 //y=5.38 //x2=25.965 //y2=7.58
cc_1974 ( N_Q_c_2970_p N_VDD_c_3043_n ) capacitor c=0.00285853f //x=25.115 \
 //y=5.56 //x2=25.965 //y2=7.58
cc_1975 ( N_Q_c_2871_n N_VDD_c_3043_n ) capacitor c=0.00224881f //x=24.235 \
 //y=5.56 //x2=25.965 //y2=7.58
cc_1976 ( N_Q_c_2957_n N_VDD_c_3043_n ) capacitor c=0.00224881f //x=25.115 \
 //y=5.56 //x2=25.965 //y2=7.58
cc_1977 ( N_Q_M42_noxref_g N_VDD_c_3267_n ) capacitor c=0.00755544f //x=21.265 \
 //y=6.2 //x2=21.84 //y2=7.585
cc_1978 ( N_Q_M43_noxref_g N_VDD_c_3267_n ) capacitor c=0.00755754f //x=21.705 \
 //y=6.2 //x2=21.84 //y2=7.585
cc_1979 ( N_Q_c_2844_n N_VDD_c_3272_n ) capacitor c=0.00208087f //x=25 \
 //y=5.38 //x2=24.59 //y2=7.585
cc_1980 ( N_Q_c_2848_n N_VDD_c_3272_n ) capacitor c=9.41185e-19 //x=24.235 \
 //y=5.56 //x2=24.59 //y2=7.585
cc_1981 ( N_Q_c_2871_n N_VDD_c_3272_n ) capacitor c=0.0136705f //x=24.235 \
 //y=5.56 //x2=24.59 //y2=7.585
cc_1982 ( N_Q_c_2844_n N_VDD_c_3334_n ) capacitor c=0.00180737f //x=25 \
 //y=5.38 //x2=25.47 //y2=7.585
cc_1983 ( N_Q_c_2934_n N_VDD_c_3334_n ) capacitor c=0.00208087f //x=25.51 \
 //y=5.38 //x2=25.47 //y2=7.585
cc_1984 ( N_Q_c_2940_n N_VDD_c_3334_n ) capacitor c=4.23719e-19 //x=25.115 \
 //y=5.38 //x2=25.47 //y2=7.585
cc_1985 ( N_Q_c_2970_p N_VDD_c_3334_n ) capacitor c=5.77976e-19 //x=25.115 \
 //y=5.56 //x2=25.47 //y2=7.585
cc_1986 ( N_Q_c_2957_n N_VDD_c_3334_n ) capacitor c=0.0136705f //x=25.115 \
 //y=5.56 //x2=25.47 //y2=7.585
cc_1987 ( Q N_VDD_c_3336_n ) capacitor c=0.0374625f //x=25.595 //y=4.25 \
 //x2=25.965 //y2=7.58
cc_1988 ( N_Q_c_2940_n N_VDD_c_3336_n ) capacitor c=0.00379179f //x=25.115 \
 //y=5.38 //x2=25.965 //y2=7.58
cc_1989 ( N_Q_c_2970_p N_VDD_c_3336_n ) capacitor c=0.0016115f //x=25.115 \
 //y=5.56 //x2=25.965 //y2=7.58
cc_1990 ( N_Q_c_2957_n N_VDD_c_3336_n ) capacitor c=0.0101867f //x=25.115 \
 //y=5.56 //x2=25.965 //y2=7.58
cc_1991 ( Q N_VDD_c_3277_n ) capacitor c=0.00150038f //x=25.595 //y=4.25 \
 //x2=23.005 //y2=7.585
cc_1992 ( N_Q_c_2848_n N_VDD_c_3277_n ) capacitor c=4.91377e-19 //x=24.235 \
 //y=5.56 //x2=23.005 //y2=7.585
cc_1993 ( N_Q_c_2804_n N_VDD_c_3277_n ) capacitor c=0.00224736f //x=21.525 \
 //y=4.88 //x2=23.005 //y2=7.585
cc_1994 ( N_Q_c_2871_n N_VDD_c_3277_n ) capacitor c=0.0064135f //x=24.235 \
 //y=5.56 //x2=23.005 //y2=7.585
cc_1995 ( N_Q_c_2818_n N_VDD_c_3277_n ) capacitor c=2.63786e-19 //x=21.525 \
 //y=4.88 //x2=23.005 //y2=7.585
cc_1996 ( N_Q_M42_noxref_g N_VDD_M41_noxref_d ) capacitor c=0.015318f \
 //x=21.265 //y=6.2 //x2=20.9 //y2=5.2
cc_1997 ( N_Q_M43_noxref_g N_VDD_M43_noxref_d ) capacitor c=0.0394719f \
 //x=21.705 //y=6.2 //x2=21.78 //y2=5.2
cc_1998 ( N_Q_c_2848_n N_VDD_M44_noxref_s ) capacitor c=0.0616215f //x=24.235 \
 //y=5.56 //x2=23.66 //y2=5.2
cc_1999 ( N_Q_c_2940_n N_VDD_M44_noxref_s ) capacitor c=6.52457e-19 //x=25.115 \
 //y=5.38 //x2=23.66 //y2=5.2
cc_2000 ( N_Q_c_2871_n N_VDD_M44_noxref_s ) capacitor c=0.0887533f //x=24.235 \
 //y=5.56 //x2=23.66 //y2=5.2
cc_2001 ( N_Q_c_2844_n N_VDD_M45_noxref_d ) capacitor c=0.00734094f //x=25 \
 //y=5.38 //x2=24.53 //y2=5.2
cc_2002 ( N_Q_c_2848_n N_VDD_M45_noxref_d ) capacitor c=0.0043528f //x=24.235 \
 //y=5.56 //x2=24.53 //y2=5.2
cc_2003 ( N_Q_c_2970_p N_VDD_M45_noxref_d ) capacitor c=0.0043528f //x=25.115 \
 //y=5.56 //x2=24.53 //y2=5.2
cc_2004 ( N_Q_c_2871_n N_VDD_M45_noxref_d ) capacitor c=0.065554f //x=24.235 \
 //y=5.56 //x2=24.53 //y2=5.2
cc_2005 ( N_Q_c_2957_n N_VDD_M45_noxref_d ) capacitor c=0.065554f //x=25.115 \
 //y=5.56 //x2=24.53 //y2=5.2
cc_2006 ( Q N_VDD_M47_noxref_d ) capacitor c=0.00122238f //x=25.595 //y=3.88 \
 //x2=25.41 //y2=5.2
cc_2007 ( N_Q_c_2934_n N_VDD_M47_noxref_d ) capacitor c=0.00898356f //x=25.51 \
 //y=5.38 //x2=25.41 //y2=5.2
cc_2008 ( N_Q_c_2970_p N_VDD_M47_noxref_d ) capacitor c=0.00979407f //x=25.115 \
 //y=5.56 //x2=25.41 //y2=5.2
cc_2009 ( N_Q_c_2957_n N_VDD_M47_noxref_d ) capacitor c=0.065554f //x=25.115 \
 //y=5.56 //x2=25.41 //y2=5.2
cc_2010 ( N_Q_c_2790_n N_noxref_14_c_3780_n ) capacitor c=0.00177186f \
 //x=21.525 //y=2.375 //x2=22.18 //y2=0.72
cc_2011 ( N_Q_c_2801_n N_noxref_14_c_3780_n ) capacitor c=0.00117306f \
 //x=21.525 //y=2.26 //x2=22.18 //y2=0.72
cc_2012 ( N_Q_c_2811_n N_noxref_14_c_3780_n ) capacitor c=0.0206349f \
 //x=21.515 //y=1.095 //x2=22.18 //y2=0.72
cc_2013 ( N_Q_c_2894_n N_noxref_14_c_3780_n ) capacitor c=0.00825432f \
 //x=22.045 //y=1.095 //x2=22.18 //y2=0.72
cc_2014 ( N_Q_c_2814_n N_noxref_14_c_3780_n ) capacitor c=2.20712e-19 \
 //x=21.525 //y=2.26 //x2=22.18 //y2=0.72
cc_2015 ( N_Q_c_2812_n N_noxref_14_c_3783_n ) capacitor c=0.0071177f \
 //x=21.515 //y=1.44 //x2=21.295 //y2=1.175
cc_2016 ( N_Q_c_2811_n N_noxref_14_M13_noxref_s ) capacitor c=0.0071177f \
 //x=21.515 //y=1.095 //x2=21.16 //y2=0.555
cc_2017 ( N_Q_c_2813_n N_noxref_14_M13_noxref_s ) capacitor c=0.0071177f \
 //x=21.515 //y=1.75 //x2=21.16 //y2=0.555
cc_2018 ( N_Q_c_2894_n N_noxref_14_M13_noxref_s ) capacitor c=0.015333f \
 //x=22.045 //y=1.095 //x2=21.16 //y2=0.555
cc_2019 ( N_Q_c_2896_n N_noxref_14_M13_noxref_s ) capacitor c=0.00248746f \
 //x=22.045 //y=1.44 //x2=21.16 //y2=0.555
cc_2020 ( N_Q_c_2790_n N_GND_c_3983_n ) capacitor c=0.0021992f //x=21.525 \
 //y=2.375 //x2=24.1 //y2=0.175
cc_2021 ( N_Q_c_2935_n N_GND_c_4041_n ) capacitor c=0.00654514f //x=25.51 \
 //y=1.835 //x2=25.965 //y2=0.18
cc_2022 ( N_Q_c_2856_n N_GND_c_4041_n ) capacitor c=0.00964814f //x=25.155 \
 //y=1.18 //x2=25.965 //y2=0.18
cc_2023 ( N_Q_M15_noxref_d N_GND_c_4041_n ) capacitor c=3.01769e-19 //x=24.965 \
 //y=1.085 //x2=25.965 //y2=0.18
cc_2024 ( N_Q_c_2848_n N_GND_c_4002_n ) capacitor c=7.78402e-19 //x=24.235 \
 //y=5.56 //x2=24.185 //y2=1.135
cc_2025 ( N_Q_c_2856_n N_GND_c_4002_n ) capacitor c=0.0141947f //x=25.155 \
 //y=1.18 //x2=24.185 //y2=1.135
cc_2026 ( N_Q_M15_noxref_d N_GND_c_4002_n ) capacitor c=2.93544e-19 //x=24.965 \
 //y=1.085 //x2=24.185 //y2=1.135
cc_2027 ( N_Q_c_2790_n N_GND_c_3947_n ) capacitor c=2.016e-19 //x=21.525 \
 //y=2.375 //x2=22.835 //y2=0.175
cc_2028 ( N_Q_c_2845_n N_GND_c_4018_n ) capacitor c=0.00528499f //x=25.155 \
 //y=1.75 //x2=25.965 //y2=0.18
cc_2029 ( N_Q_c_2935_n N_GND_c_4018_n ) capacitor c=0.0391779f //x=25.51 \
 //y=1.835 //x2=25.965 //y2=0.18
cc_2030 ( Q N_GND_c_4019_n ) capacitor c=0.0012138f //x=25.595 //y=2.4 \
 //x2=23.005 //y2=0.175
cc_2031 ( N_Q_c_2801_n N_GND_c_4019_n ) capacitor c=0.00239899f //x=21.525 \
 //y=2.26 //x2=23.005 //y2=0.175
cc_2032 ( N_Q_c_2896_n N_GND_c_4019_n ) capacitor c=0.00262688f //x=22.045 \
 //y=1.44 //x2=23.005 //y2=0.175
cc_2033 ( N_Q_c_2814_n N_GND_c_4019_n ) capacitor c=2.63786e-19 //x=21.525 \
 //y=2.26 //x2=23.005 //y2=0.175
cc_2034 ( N_Q_c_2856_n N_GND_M14_noxref_d ) capacitor c=2.82748e-19 //x=25.155 \
 //y=1.18 //x2=23.995 //y2=1.045
cc_2035 ( N_Q_c_2857_n N_noxref_21_c_4585_n ) capacitor c=0.00404915f \
 //x=24.46 //y=3.88 //x2=24.585 //y2=1.76
cc_2036 ( N_Q_c_2846_n N_noxref_21_c_4593_n ) capacitor c=0.00911405f \
 //x=25.24 //y=1.835 //x2=24.67 //y2=1.675
cc_2037 ( N_Q_c_2857_n N_noxref_21_c_4593_n ) capacitor c=0.00175795f \
 //x=24.46 //y=3.88 //x2=24.67 //y2=1.675
cc_2038 ( N_Q_c_2935_n N_noxref_21_c_4601_n ) capacitor c=0.00389706f \
 //x=25.51 //y=1.835 //x2=25.555 //y2=0.71
cc_2039 ( N_Q_c_2856_n N_noxref_21_c_4601_n ) capacitor c=0.00367971f \
 //x=25.155 //y=1.18 //x2=25.555 //y2=0.71
cc_2040 ( N_Q_M15_noxref_d N_noxref_21_c_4601_n ) capacitor c=0.00910163f \
 //x=24.965 //y=1.085 //x2=25.555 //y2=0.71
cc_2041 ( Q N_noxref_21_M14_noxref_s ) capacitor c=8.42257e-19 //x=25.595 \
 //y=3.88 //x2=23.565 //y2=0.545
cc_2042 ( N_Q_c_2845_n N_noxref_21_M14_noxref_s ) capacitor c=0.0175063f \
 //x=25.155 //y=1.75 //x2=23.565 //y2=0.545
cc_2043 ( N_Q_c_2935_n N_noxref_21_M14_noxref_s ) capacitor c=0.00670006f \
 //x=25.51 //y=1.835 //x2=23.565 //y2=0.545
cc_2044 ( N_Q_c_2937_n N_noxref_21_M14_noxref_s ) capacitor c=2.68212e-19 \
 //x=25.595 //y=4.025 //x2=23.565 //y2=0.545
cc_2045 ( N_Q_c_2856_n N_noxref_21_M14_noxref_s ) capacitor c=0.0104675f \
 //x=25.155 //y=1.18 //x2=23.565 //y2=0.545
cc_2046 ( N_Q_M15_noxref_d N_noxref_21_M14_noxref_s ) capacitor c=0.0275552f \
 //x=24.965 //y=1.085 //x2=23.565 //y2=0.545
cc_2047 ( N_VDD_c_3061_n N_D_M24_noxref_g ) capacitor c=0.00705252f //x=8.01 \
 //y=7.585 //x2=7.435 //y2=6.2
cc_2048 ( N_VDD_M23_noxref_d N_D_M24_noxref_g ) capacitor c=0.015318f //x=7.07 \
 //y=5.2 //x2=7.435 //y2=6.2
cc_2049 ( N_VDD_c_3061_n N_D_M25_noxref_g ) capacitor c=0.00755544f //x=8.01 \
 //y=7.585 //x2=7.875 //y2=6.2
cc_2050 ( N_VDD_M25_noxref_d N_D_M25_noxref_g ) capacitor c=0.015318f //x=7.95 \
 //y=5.2 //x2=7.875 //y2=6.2
cc_2051 ( N_VDD_c_3178_n N_GND_c_4055_n ) capacitor c=0.00989514f //x=1.175 \
 //y=7.58 //x2=1.175 //y2=0.18
cc_2052 ( N_VDD_c_3336_n N_GND_c_4018_n ) capacitor c=0.00989514f //x=25.965 \
 //y=7.58 //x2=25.965 //y2=0.18
cc_2053 ( N_VDD_c_3073_n N_GND_c_3852_n ) capacitor c=0.00654453f //x=5.245 \
 //y=7.585 //x2=5.245 //y2=0.175
cc_2054 ( N_VDD_c_3077_n N_GND_c_3856_n ) capacitor c=0.00654453f //x=10.055 \
 //y=7.585 //x2=10.055 //y2=0.175
cc_2055 ( N_VDD_c_3124_n N_GND_c_3896_n ) capacitor c=0.00654453f //x=13.385 \
 //y=7.585 //x2=13.385 //y2=0.175
cc_2056 ( N_VDD_c_3202_n N_GND_c_3955_n ) capacitor c=0.00663779f //x=18.195 \
 //y=7.585 //x2=18.195 //y2=0.175
cc_2057 ( N_VDD_c_3277_n N_GND_c_4019_n ) capacitor c=0.00654453f //x=23.005 \
 //y=7.585 //x2=23.005 //y2=0.175
cc_2058 ( N_noxref_10_c_3450_n N_GND_c_3830_n ) capacitor c=0.0079063f \
 //x=3.45 //y=1.175 //x2=6.235 //y2=0.175
cc_2059 ( N_noxref_10_c_3477_p N_GND_c_3830_n ) capacitor c=0.00673395f \
 //x=3.535 //y=0.805 //x2=6.235 //y2=0.175
cc_2060 ( N_noxref_10_c_3440_n N_GND_c_3830_n ) capacitor c=0.00958276f \
 //x=4.42 //y=0.72 //x2=6.235 //y2=0.175
cc_2061 ( N_noxref_10_c_3479_p N_GND_c_3830_n ) capacitor c=0.00232964f \
 //x=4.505 //y=0.805 //x2=6.235 //y2=0.175
cc_2062 ( N_noxref_10_M1_noxref_d N_GND_c_3830_n ) capacitor c=0.0134285f \
 //x=2.295 //y=1.09 //x2=6.235 //y2=0.175
cc_2063 ( N_noxref_10_M1_noxref_d N_GND_c_4043_n ) capacitor c=0.0156367f \
 //x=2.295 //y=1.09 //x2=1.51 //y2=1.145
cc_2064 ( N_noxref_10_c_3450_n N_GND_c_3848_n ) capacitor c=0.0080792f \
 //x=3.45 //y=1.175 //x2=5.075 //y2=0.175
cc_2065 ( N_noxref_10_c_3477_p N_GND_c_3848_n ) capacitor c=0.0140847f \
 //x=3.535 //y=0.805 //x2=5.075 //y2=0.175
cc_2066 ( N_noxref_10_c_3440_n N_GND_c_3848_n ) capacitor c=0.0364997f \
 //x=4.42 //y=0.72 //x2=5.075 //y2=0.175
cc_2067 ( N_noxref_10_c_3479_p N_GND_c_3848_n ) capacitor c=0.013886f \
 //x=4.505 //y=0.805 //x2=5.075 //y2=0.175
cc_2068 ( N_noxref_10_M2_noxref_s N_GND_c_4055_n ) capacitor c=8.16352e-19 \
 //x=3.4 //y=0.555 //x2=1.175 //y2=0.18
cc_2069 ( N_noxref_10_c_3440_n N_GND_c_4018_n ) capacitor c=0.00189358f \
 //x=4.42 //y=0.72 //x2=25.965 //y2=0.18
cc_2070 ( N_noxref_10_M1_noxref_d N_GND_c_4018_n ) capacitor c=2.7648e-19 \
 //x=2.295 //y=1.09 //x2=25.965 //y2=0.18
cc_2071 ( N_noxref_10_c_3479_p N_GND_c_3852_n ) capacitor c=0.037873f \
 //x=4.505 //y=0.805 //x2=5.245 //y2=0.175
cc_2072 ( N_noxref_10_M2_noxref_s N_GND_c_3852_n ) capacitor c=0.0051897f \
 //x=3.4 //y=0.555 //x2=5.245 //y2=0.175
cc_2073 ( N_noxref_10_M1_noxref_d N_GND_M0_noxref_d ) capacitor c=3.12752e-19 \
 //x=2.295 //y=1.09 //x2=1.32 //y2=1.055
cc_2074 ( N_noxref_10_c_3477_p N_noxref_16_c_4311_n ) capacitor c=2.15937e-19 \
 //x=3.535 //y=0.805 //x2=1.995 //y2=0.805
cc_2075 ( N_noxref_10_c_3450_n N_noxref_16_c_4289_n ) capacitor c=0.0132582f \
 //x=3.45 //y=1.175 //x2=2.88 //y2=0.72
cc_2076 ( N_noxref_10_M1_noxref_d N_noxref_16_c_4289_n ) capacitor c=0.016458f \
 //x=2.295 //y=1.09 //x2=2.88 //y2=0.72
cc_2077 ( N_noxref_10_c_3450_n N_noxref_16_c_4291_n ) capacitor c=0.00954209f \
 //x=3.45 //y=1.175 //x2=2.88 //y2=1.77
cc_2078 ( N_noxref_10_M1_noxref_d N_noxref_16_c_4291_n ) capacitor \
 c=0.0152674f //x=2.295 //y=1.09 //x2=2.88 //y2=1.77
cc_2079 ( N_noxref_10_c_3450_n N_noxref_16_M0_noxref_s ) capacitor c=0.023368f \
 //x=3.45 //y=1.175 //x2=0.89 //y2=0.555
cc_2080 ( N_noxref_10_c_3477_p N_noxref_16_M0_noxref_s ) capacitor \
 c=0.0175461f //x=3.535 //y=0.805 //x2=0.89 //y2=0.555
cc_2081 ( N_noxref_10_c_3479_p N_noxref_16_M0_noxref_s ) capacitor \
 c=2.98576e-19 //x=4.505 //y=0.805 //x2=0.89 //y2=0.555
cc_2082 ( N_noxref_10_M1_noxref_d N_noxref_16_M0_noxref_s ) capacitor \
 c=0.0187969f //x=2.295 //y=1.09 //x2=0.89 //y2=0.555
cc_2083 ( N_noxref_10_M2_noxref_s N_noxref_16_M0_noxref_s ) capacitor \
 c=0.0210819f //x=3.4 //y=0.555 //x2=0.89 //y2=0.555
cc_2084 ( N_noxref_10_c_3479_p N_noxref_17_M3_noxref_s ) capacitor \
 c=0.00368328f //x=4.505 //y=0.805 //x2=5.7 //y2=0.555
cc_2085 ( N_noxref_10_M2_noxref_s N_noxref_17_M3_noxref_s ) capacitor \
 c=0.00125282f //x=3.4 //y=0.555 //x2=5.7 //y2=0.555
cc_2086 ( N_noxref_11_M4_noxref_d N_D_c_3574_n ) capacitor c=0.00610736f \
 //x=7.105 //y=1.09 //x2=7.465 //y2=2.375
cc_2087 ( N_noxref_11_M4_noxref_d N_D_c_3607_n ) capacitor c=2.2052e-19 \
 //x=7.105 //y=1.09 //x2=7.465 //y2=2.26
cc_2088 ( N_noxref_11_M4_noxref_d N_D_c_3618_n ) capacitor c=0.00253592f \
 //x=7.105 //y=1.09 //x2=7.03 //y2=1.09
cc_2089 ( N_noxref_11_M4_noxref_d N_D_c_3621_n ) capacitor c=0.00604087f \
 //x=7.105 //y=1.09 //x2=7.03 //y2=1.4
cc_2090 ( N_noxref_11_M4_noxref_d N_D_c_3673_n ) capacitor c=0.002686f \
 //x=7.105 //y=1.09 //x2=7.4 //y2=0.935
cc_2091 ( N_noxref_11_M4_noxref_d N_D_c_3674_n ) capacitor c=0.00251995f \
 //x=7.105 //y=1.09 //x2=7.4 //y2=1.555
cc_2092 ( N_noxref_11_c_3534_p N_D_c_3623_n ) capacitor c=0.00123426f //x=8.26 \
 //y=1.175 //x2=7.555 //y2=1.09
cc_2093 ( N_noxref_11_M4_noxref_d N_D_c_3623_n ) capacitor c=0.00314523f \
 //x=7.105 //y=1.09 //x2=7.555 //y2=1.09
cc_2094 ( N_noxref_11_M5_noxref_s N_D_c_3623_n ) capacitor c=7.21316e-19 \
 //x=8.21 //y=0.555 //x2=7.555 //y2=1.09
cc_2095 ( N_noxref_11_c_3534_p N_D_c_3624_n ) capacitor c=0.0129288f //x=8.26 \
 //y=1.175 //x2=7.555 //y2=1.4
cc_2096 ( N_noxref_11_M4_noxref_d N_D_c_3624_n ) capacitor c=0.00168289f \
 //x=7.105 //y=1.09 //x2=7.555 //y2=1.4
cc_2097 ( N_noxref_11_M5_noxref_s N_D_c_3624_n ) capacitor c=0.00365271f \
 //x=8.21 //y=0.555 //x2=7.555 //y2=1.4
cc_2098 ( N_noxref_11_c_3534_p N_D_c_3625_n ) capacitor c=0.00132209f //x=8.26 \
 //y=1.175 //x2=7.555 //y2=1.63
cc_2099 ( N_noxref_11_M4_noxref_d N_D_c_3625_n ) capacitor c=0.00111165f \
 //x=7.105 //y=1.09 //x2=7.555 //y2=1.63
cc_2100 ( N_noxref_11_M5_noxref_s N_D_c_3626_n ) capacitor c=9.86711e-19 \
 //x=8.21 //y=0.555 //x2=7.555 //y2=2.095
cc_2101 ( N_noxref_11_c_3534_p N_GND_c_3831_n ) capacitor c=0.0079063f \
 //x=8.26 //y=1.175 //x2=11.15 //y2=0.175
cc_2102 ( N_noxref_11_c_3544_p N_GND_c_3831_n ) capacitor c=0.00683713f \
 //x=8.345 //y=0.805 //x2=11.15 //y2=0.175
cc_2103 ( N_noxref_11_c_3504_n N_GND_c_3831_n ) capacitor c=0.00948373f \
 //x=9.23 //y=0.72 //x2=11.15 //y2=0.175
cc_2104 ( N_noxref_11_c_3546_p N_GND_c_3831_n ) capacitor c=0.00232964f \
 //x=9.315 //y=0.805 //x2=11.15 //y2=0.175
cc_2105 ( N_noxref_11_M4_noxref_d N_GND_c_3831_n ) capacitor c=0.0134285f \
 //x=7.105 //y=1.09 //x2=11.15 //y2=0.175
cc_2106 ( N_noxref_11_M4_noxref_d N_GND_c_3924_n ) capacitor c=0.0154456f \
 //x=7.105 //y=1.09 //x2=6.32 //y2=1.145
cc_2107 ( N_noxref_11_c_3534_p N_GND_c_3849_n ) capacitor c=0.0080792f \
 //x=8.26 //y=1.175 //x2=9.885 //y2=0.175
cc_2108 ( N_noxref_11_c_3544_p N_GND_c_3849_n ) capacitor c=0.0140609f \
 //x=8.345 //y=0.805 //x2=9.885 //y2=0.175
cc_2109 ( N_noxref_11_c_3504_n N_GND_c_3849_n ) capacitor c=0.0365187f \
 //x=9.23 //y=0.72 //x2=9.885 //y2=0.175
cc_2110 ( N_noxref_11_c_3546_p N_GND_c_3849_n ) capacitor c=0.013886f \
 //x=9.315 //y=0.805 //x2=9.885 //y2=0.175
cc_2111 ( N_noxref_11_c_3504_n N_GND_c_4018_n ) capacitor c=0.00189358f \
 //x=9.23 //y=0.72 //x2=25.965 //y2=0.18
cc_2112 ( N_noxref_11_M4_noxref_d N_GND_c_4018_n ) capacitor c=2.7648e-19 \
 //x=7.105 //y=1.09 //x2=25.965 //y2=0.18
cc_2113 ( N_noxref_11_M5_noxref_s N_GND_c_3852_n ) capacitor c=8.16352e-19 \
 //x=8.21 //y=0.555 //x2=5.245 //y2=0.175
cc_2114 ( N_noxref_11_c_3546_p N_GND_c_3856_n ) capacitor c=0.0374312f \
 //x=9.315 //y=0.805 //x2=10.055 //y2=0.175
cc_2115 ( N_noxref_11_M5_noxref_s N_GND_c_3856_n ) capacitor c=0.00519576f \
 //x=8.21 //y=0.555 //x2=10.055 //y2=0.175
cc_2116 ( N_noxref_11_M4_noxref_d N_GND_M3_noxref_d ) capacitor c=3.12752e-19 \
 //x=7.105 //y=1.09 //x2=6.13 //y2=1.055
cc_2117 ( N_noxref_11_c_3544_p N_noxref_17_c_4360_n ) capacitor c=2.15937e-19 \
 //x=8.345 //y=0.805 //x2=6.805 //y2=0.805
cc_2118 ( N_noxref_11_c_3534_p N_noxref_17_c_4361_n ) capacitor c=0.0132582f \
 //x=8.26 //y=1.175 //x2=7.69 //y2=0.72
cc_2119 ( N_noxref_11_M4_noxref_d N_noxref_17_c_4361_n ) capacitor c=0.016458f \
 //x=7.105 //y=1.09 //x2=7.69 //y2=0.72
cc_2120 ( N_noxref_11_c_3534_p N_noxref_17_c_4344_n ) capacitor c=0.00954209f \
 //x=8.26 //y=1.175 //x2=7.69 //y2=1.77
cc_2121 ( N_noxref_11_M4_noxref_d N_noxref_17_c_4344_n ) capacitor \
 c=0.0152939f //x=7.105 //y=1.09 //x2=7.69 //y2=1.77
cc_2122 ( N_noxref_11_c_3534_p N_noxref_17_M3_noxref_s ) capacitor c=0.023368f \
 //x=8.26 //y=1.175 //x2=5.7 //y2=0.555
cc_2123 ( N_noxref_11_c_3544_p N_noxref_17_M3_noxref_s ) capacitor \
 c=0.0175532f //x=8.345 //y=0.805 //x2=5.7 //y2=0.555
cc_2124 ( N_noxref_11_c_3546_p N_noxref_17_M3_noxref_s ) capacitor \
 c=2.98721e-19 //x=9.315 //y=0.805 //x2=5.7 //y2=0.555
cc_2125 ( N_noxref_11_M4_noxref_d N_noxref_17_M3_noxref_s ) capacitor \
 c=0.0187685f //x=7.105 //y=1.09 //x2=5.7 //y2=0.555
cc_2126 ( N_noxref_11_M5_noxref_s N_noxref_17_M3_noxref_s ) capacitor \
 c=0.021082f //x=8.21 //y=0.555 //x2=5.7 //y2=0.555
cc_2127 ( N_noxref_11_c_3546_p N_noxref_18_M6_noxref_s ) capacitor \
 c=0.00370912f //x=9.315 //y=0.805 //x2=10.615 //y2=0.545
cc_2128 ( N_noxref_11_M5_noxref_s N_noxref_18_M6_noxref_s ) capacitor \
 c=0.00101401f //x=8.21 //y=0.555 //x2=10.615 //y2=0.545
cc_2129 ( N_D_c_3574_n N_GND_c_3831_n ) capacitor c=9.16602e-19 //x=7.465 \
 //y=2.375 //x2=11.15 //y2=0.175
cc_2130 ( N_D_c_3618_n N_noxref_17_c_4361_n ) capacitor c=0.0167228f //x=7.03 \
 //y=1.09 //x2=7.69 //y2=0.72
cc_2131 ( N_D_c_3623_n N_noxref_17_c_4361_n ) capacitor c=0.00534519f \
 //x=7.555 //y=1.09 //x2=7.69 //y2=0.72
cc_2132 ( N_D_c_3574_n N_noxref_17_c_4344_n ) capacitor c=0.0048147f //x=7.465 \
 //y=2.375 //x2=7.69 //y2=1.77
cc_2133 ( N_D_c_3607_n N_noxref_17_c_4344_n ) capacitor c=0.0105652f //x=7.465 \
 //y=2.26 //x2=7.69 //y2=1.77
cc_2134 ( N_D_c_3621_n N_noxref_17_c_4344_n ) capacitor c=0.0153476f //x=7.03 \
 //y=1.4 //x2=7.69 //y2=1.77
cc_2135 ( N_D_c_3626_n N_noxref_17_c_4344_n ) capacitor c=0.0220606f //x=7.555 \
 //y=2.095 //x2=7.69 //y2=1.77
cc_2136 ( N_D_c_3618_n N_noxref_17_M3_noxref_s ) capacitor c=0.00798959f \
 //x=7.03 //y=1.09 //x2=5.7 //y2=0.555
cc_2137 ( N_D_c_3625_n N_noxref_17_M3_noxref_s ) capacitor c=0.00212176f \
 //x=7.555 //y=1.63 //x2=5.7 //y2=0.555
cc_2138 ( N_D_c_3626_n N_noxref_17_M3_noxref_s ) capacitor c=0.00298115f \
 //x=7.555 //y=2.095 //x2=5.7 //y2=0.555
cc_2139 ( N_noxref_13_c_3695_n N_GND_c_3913_n ) capacitor c=0.00533679f \
 //x=16.4 //y=1.175 //x2=19.185 //y2=0.175
cc_2140 ( N_noxref_13_c_3736_p N_GND_c_3913_n ) capacitor c=0.00428537f \
 //x=16.485 //y=0.805 //x2=19.185 //y2=0.175
cc_2141 ( N_noxref_13_c_3711_n N_GND_c_3913_n ) capacitor c=0.00948373f \
 //x=17.37 //y=0.72 //x2=19.185 //y2=0.175
cc_2142 ( N_noxref_13_c_3738_p N_GND_c_3913_n ) capacitor c=0.00232964f \
 //x=17.455 //y=0.805 //x2=19.185 //y2=0.175
cc_2143 ( N_noxref_13_M9_noxref_d N_GND_c_3913_n ) capacitor c=0.0131076f \
 //x=15.245 //y=1.09 //x2=19.185 //y2=0.175
cc_2144 ( N_noxref_13_M9_noxref_d N_GND_c_3881_n ) capacitor c=0.0154456f \
 //x=15.245 //y=1.09 //x2=14.46 //y2=1.145
cc_2145 ( N_noxref_13_c_3695_n N_GND_c_3894_n ) capacitor c=0.0091517f \
 //x=16.4 //y=1.175 //x2=18.025 //y2=0.175
cc_2146 ( N_noxref_13_c_3736_p N_GND_c_3894_n ) capacitor c=0.0141583f \
 //x=16.485 //y=0.805 //x2=18.025 //y2=0.175
cc_2147 ( N_noxref_13_c_3711_n N_GND_c_3894_n ) capacitor c=0.0365187f \
 //x=17.37 //y=0.72 //x2=18.025 //y2=0.175
cc_2148 ( N_noxref_13_c_3738_p N_GND_c_3894_n ) capacitor c=0.013886f \
 //x=17.455 //y=0.805 //x2=18.025 //y2=0.175
cc_2149 ( N_noxref_13_c_3711_n N_GND_c_4018_n ) capacitor c=0.00189358f \
 //x=17.37 //y=0.72 //x2=25.965 //y2=0.18
cc_2150 ( N_noxref_13_M9_noxref_d N_GND_c_4018_n ) capacitor c=2.7648e-19 \
 //x=15.245 //y=1.09 //x2=25.965 //y2=0.18
cc_2151 ( N_noxref_13_M10_noxref_s N_GND_c_3896_n ) capacitor c=8.16352e-19 \
 //x=16.35 //y=0.555 //x2=13.385 //y2=0.175
cc_2152 ( N_noxref_13_c_3738_p N_GND_c_3955_n ) capacitor c=0.037873f \
 //x=17.455 //y=0.805 //x2=18.195 //y2=0.175
cc_2153 ( N_noxref_13_M10_noxref_s N_GND_c_3955_n ) capacitor c=0.0051897f \
 //x=16.35 //y=0.555 //x2=18.195 //y2=0.175
cc_2154 ( N_noxref_13_M9_noxref_d N_GND_M8_noxref_d ) capacitor c=3.12752e-19 \
 //x=15.245 //y=1.09 //x2=14.27 //y2=1.055
cc_2155 ( N_noxref_13_c_3736_p N_noxref_19_c_4493_n ) capacitor c=2.15937e-19 \
 //x=16.485 //y=0.805 //x2=14.945 //y2=0.805
cc_2156 ( N_noxref_13_c_3695_n N_noxref_19_c_4479_n ) capacitor c=0.0130857f \
 //x=16.4 //y=1.175 //x2=15.83 //y2=0.72
cc_2157 ( N_noxref_13_M9_noxref_d N_noxref_19_c_4479_n ) capacitor \
 c=0.0160925f //x=15.245 //y=1.09 //x2=15.83 //y2=0.72
cc_2158 ( N_noxref_13_c_3695_n N_noxref_19_c_4481_n ) capacitor c=0.00944538f \
 //x=16.4 //y=1.175 //x2=15.83 //y2=1.77
cc_2159 ( N_noxref_13_M9_noxref_d N_noxref_19_c_4481_n ) capacitor \
 c=0.0152605f //x=15.245 //y=1.09 //x2=15.83 //y2=1.77
cc_2160 ( N_noxref_13_c_3695_n N_noxref_19_M8_noxref_s ) capacitor \
 c=0.0223986f //x=16.4 //y=1.175 //x2=13.84 //y2=0.555
cc_2161 ( N_noxref_13_c_3736_p N_noxref_19_M8_noxref_s ) capacitor \
 c=0.0175461f //x=16.485 //y=0.805 //x2=13.84 //y2=0.555
cc_2162 ( N_noxref_13_c_3738_p N_noxref_19_M8_noxref_s ) capacitor \
 c=2.98576e-19 //x=17.455 //y=0.805 //x2=13.84 //y2=0.555
cc_2163 ( N_noxref_13_M9_noxref_d N_noxref_19_M8_noxref_s ) capacitor \
 c=0.0187674f //x=15.245 //y=1.09 //x2=13.84 //y2=0.555
cc_2164 ( N_noxref_13_M10_noxref_s N_noxref_19_M8_noxref_s ) capacitor \
 c=0.0210819f //x=16.35 //y=0.555 //x2=13.84 //y2=0.555
cc_2165 ( N_noxref_13_c_3738_p N_noxref_20_M11_noxref_s ) capacitor \
 c=0.00368328f //x=17.455 //y=0.805 //x2=18.65 //y2=0.555
cc_2166 ( N_noxref_13_M10_noxref_s N_noxref_20_M11_noxref_s ) capacitor \
 c=0.00125282f //x=16.35 //y=0.555 //x2=18.65 //y2=0.555
cc_2167 ( N_noxref_14_c_3763_n N_GND_c_3983_n ) capacitor c=0.0079063f \
 //x=21.21 //y=1.175 //x2=24.1 //y2=0.175
cc_2168 ( N_noxref_14_c_3803_p N_GND_c_3983_n ) capacitor c=0.00674195f \
 //x=21.295 //y=0.805 //x2=24.1 //y2=0.175
cc_2169 ( N_noxref_14_c_3780_n N_GND_c_3983_n ) capacitor c=0.0096072f \
 //x=22.18 //y=0.72 //x2=24.1 //y2=0.175
cc_2170 ( N_noxref_14_c_3805_p N_GND_c_3983_n ) capacitor c=0.00232964f \
 //x=22.265 //y=0.805 //x2=24.1 //y2=0.175
cc_2171 ( N_noxref_14_M12_noxref_d N_GND_c_3983_n ) capacitor c=0.0130717f \
 //x=20.055 //y=1.09 //x2=24.1 //y2=0.175
cc_2172 ( N_noxref_14_M12_noxref_d N_GND_c_3935_n ) capacitor c=0.0154456f \
 //x=20.055 //y=1.09 //x2=19.27 //y2=1.145
cc_2173 ( N_noxref_14_c_3763_n N_GND_c_3947_n ) capacitor c=0.0080792f \
 //x=21.21 //y=1.175 //x2=22.835 //y2=0.175
cc_2174 ( N_noxref_14_c_3803_p N_GND_c_3947_n ) capacitor c=0.0140604f \
 //x=21.295 //y=0.805 //x2=22.835 //y2=0.175
cc_2175 ( N_noxref_14_c_3780_n N_GND_c_3947_n ) capacitor c=0.0364637f \
 //x=22.18 //y=0.72 //x2=22.835 //y2=0.175
cc_2176 ( N_noxref_14_c_3805_p N_GND_c_3947_n ) capacitor c=0.013886f \
 //x=22.265 //y=0.805 //x2=22.835 //y2=0.175
cc_2177 ( N_noxref_14_c_3780_n N_GND_c_4018_n ) capacitor c=0.00189358f \
 //x=22.18 //y=0.72 //x2=25.965 //y2=0.18
cc_2178 ( N_noxref_14_M12_noxref_d N_GND_c_4018_n ) capacitor c=2.7648e-19 \
 //x=20.055 //y=1.09 //x2=25.965 //y2=0.18
cc_2179 ( N_noxref_14_M13_noxref_s N_GND_c_3955_n ) capacitor c=8.16352e-19 \
 //x=21.16 //y=0.555 //x2=18.195 //y2=0.175
cc_2180 ( N_noxref_14_c_3805_p N_GND_c_4019_n ) capacitor c=0.0374312f \
 //x=22.265 //y=0.805 //x2=23.005 //y2=0.175
cc_2181 ( N_noxref_14_M13_noxref_s N_GND_c_4019_n ) capacitor c=0.00519576f \
 //x=21.16 //y=0.555 //x2=23.005 //y2=0.175
cc_2182 ( N_noxref_14_M12_noxref_d N_GND_M11_noxref_d ) capacitor \
 c=3.12752e-19 //x=20.055 //y=1.09 //x2=19.08 //y2=1.055
cc_2183 ( N_noxref_14_c_3803_p N_noxref_20_c_4553_n ) capacitor c=2.15937e-19 \
 //x=21.295 //y=0.805 //x2=19.755 //y2=0.805
cc_2184 ( N_noxref_14_c_3763_n N_noxref_20_c_4540_n ) capacitor c=0.0132582f \
 //x=21.21 //y=1.175 //x2=20.64 //y2=0.72
cc_2185 ( N_noxref_14_M12_noxref_d N_noxref_20_c_4540_n ) capacitor \
 c=0.0160925f //x=20.055 //y=1.09 //x2=20.64 //y2=0.72
cc_2186 ( N_noxref_14_c_3763_n N_noxref_20_c_4542_n ) capacitor c=0.00954209f \
 //x=21.21 //y=1.175 //x2=20.64 //y2=1.77
cc_2187 ( N_noxref_14_M12_noxref_d N_noxref_20_c_4542_n ) capacitor \
 c=0.014937f //x=20.055 //y=1.09 //x2=20.64 //y2=1.77
cc_2188 ( N_noxref_14_c_3763_n N_noxref_20_M11_noxref_s ) capacitor \
 c=0.023368f //x=21.21 //y=1.175 //x2=18.65 //y2=0.555
cc_2189 ( N_noxref_14_c_3803_p N_noxref_20_M11_noxref_s ) capacitor \
 c=0.0175532f //x=21.295 //y=0.805 //x2=18.65 //y2=0.555
cc_2190 ( N_noxref_14_c_3805_p N_noxref_20_M11_noxref_s ) capacitor \
 c=2.98721e-19 //x=22.265 //y=0.805 //x2=18.65 //y2=0.555
cc_2191 ( N_noxref_14_M12_noxref_d N_noxref_20_M11_noxref_s ) capacitor \
 c=0.0187685f //x=20.055 //y=1.09 //x2=18.65 //y2=0.555
cc_2192 ( N_noxref_14_M13_noxref_s N_noxref_20_M11_noxref_s ) capacitor \
 c=0.021082f //x=21.16 //y=0.555 //x2=18.65 //y2=0.555
cc_2193 ( N_noxref_14_c_3805_p N_noxref_21_M14_noxref_s ) capacitor \
 c=0.00370912f //x=22.265 //y=0.805 //x2=23.565 //y2=0.545
cc_2194 ( N_noxref_14_M13_noxref_s N_noxref_21_M14_noxref_s ) capacitor \
 c=0.00101401f //x=21.16 //y=0.555 //x2=23.565 //y2=0.545
cc_2195 ( N_GND_c_4165_p N_noxref_16_c_4300_n ) capacitor c=0.00293992f \
 //x=1.425 //y=0.175 //x2=1.91 //y2=1.77
cc_2196 ( N_GND_c_3830_n N_noxref_16_c_4300_n ) capacitor c=7.0078e-19 \
 //x=6.235 //y=0.175 //x2=1.91 //y2=1.77
cc_2197 ( N_GND_c_4043_n N_noxref_16_c_4300_n ) capacitor c=0.00377523f \
 //x=1.51 //y=1.145 //x2=1.91 //y2=1.77
cc_2198 ( N_GND_c_3848_n N_noxref_16_c_4300_n ) capacitor c=0.00371813f \
 //x=5.075 //y=0.175 //x2=1.91 //y2=1.77
cc_2199 ( N_GND_M0_noxref_d N_noxref_16_c_4300_n ) capacitor c=0.00578031f \
 //x=1.32 //y=1.055 //x2=1.91 //y2=1.77
cc_2200 ( N_GND_c_4034_n N_noxref_16_c_4311_n ) capacitor c=0.0169052f \
 //x=1.51 //y=1.015 //x2=1.995 //y2=0.805
cc_2201 ( N_GND_c_3830_n N_noxref_16_c_4311_n ) capacitor c=0.00710913f \
 //x=6.235 //y=0.175 //x2=1.995 //y2=0.805
cc_2202 ( N_GND_c_3848_n N_noxref_16_c_4311_n ) capacitor c=0.0140604f \
 //x=5.075 //y=0.175 //x2=1.995 //y2=0.805
cc_2203 ( N_GND_c_4055_n N_noxref_16_c_4311_n ) capacitor c=0.00323118f \
 //x=1.175 //y=0.18 //x2=1.995 //y2=0.805
cc_2204 ( N_GND_c_3830_n N_noxref_16_c_4289_n ) capacitor c=0.0138621f \
 //x=6.235 //y=0.175 //x2=2.88 //y2=0.72
cc_2205 ( N_GND_c_3848_n N_noxref_16_c_4289_n ) capacitor c=0.0356451f \
 //x=5.075 //y=0.175 //x2=2.88 //y2=0.72
cc_2206 ( N_GND_c_4018_n N_noxref_16_c_4289_n ) capacitor c=0.00177266f \
 //x=25.965 //y=0.18 //x2=2.88 //y2=0.72
cc_2207 ( N_GND_c_4165_p N_noxref_16_M0_noxref_s ) capacitor c=0.00710913f \
 //x=1.425 //y=0.175 //x2=0.89 //y2=0.555
cc_2208 ( N_GND_c_4034_n N_noxref_16_M0_noxref_s ) capacitor c=0.0173062f \
 //x=1.51 //y=1.015 //x2=0.89 //y2=0.555
cc_2209 ( N_GND_c_3830_n N_noxref_16_M0_noxref_s ) capacitor c=0.00683407f \
 //x=6.235 //y=0.175 //x2=0.89 //y2=0.555
cc_2210 ( N_GND_c_4043_n N_noxref_16_M0_noxref_s ) capacitor c=0.0113024f \
 //x=1.51 //y=1.145 //x2=0.89 //y2=0.555
cc_2211 ( N_GND_c_3848_n N_noxref_16_M0_noxref_s ) capacitor c=0.0272246f \
 //x=5.075 //y=0.175 //x2=0.89 //y2=0.555
cc_2212 ( N_GND_c_4055_n N_noxref_16_M0_noxref_s ) capacitor c=0.0675506f \
 //x=1.175 //y=0.18 //x2=0.89 //y2=0.555
cc_2213 ( N_GND_c_3852_n N_noxref_16_M0_noxref_s ) capacitor c=0.00166413f \
 //x=5.245 //y=0.175 //x2=0.89 //y2=0.555
cc_2214 ( N_GND_M0_noxref_d N_noxref_16_M0_noxref_s ) capacitor c=0.0271316f \
 //x=1.32 //y=1.055 //x2=0.89 //y2=0.555
cc_2215 ( N_GND_c_3830_n N_noxref_17_c_4342_n ) capacitor c=0.0011329f \
 //x=6.235 //y=0.175 //x2=6.72 //y2=1.77
cc_2216 ( N_GND_c_3831_n N_noxref_17_c_4342_n ) capacitor c=6.68055e-19 \
 //x=11.15 //y=0.175 //x2=6.72 //y2=1.77
cc_2217 ( N_GND_c_3924_n N_noxref_17_c_4342_n ) capacitor c=0.00375838f \
 //x=6.32 //y=1.145 //x2=6.72 //y2=1.77
cc_2218 ( N_GND_c_3849_n N_noxref_17_c_4342_n ) capacitor c=0.0038933f \
 //x=9.885 //y=0.175 //x2=6.72 //y2=1.77
cc_2219 ( N_GND_M3_noxref_d N_noxref_17_c_4342_n ) capacitor c=0.00578031f \
 //x=6.13 //y=1.055 //x2=6.72 //y2=1.77
cc_2220 ( N_GND_c_3918_n N_noxref_17_c_4360_n ) capacitor c=0.0169052f \
 //x=6.32 //y=1.015 //x2=6.805 //y2=0.805
cc_2221 ( N_GND_c_3831_n N_noxref_17_c_4360_n ) capacitor c=0.00710913f \
 //x=11.15 //y=0.175 //x2=6.805 //y2=0.805
cc_2222 ( N_GND_c_3849_n N_noxref_17_c_4360_n ) capacitor c=0.0140604f \
 //x=9.885 //y=0.175 //x2=6.805 //y2=0.805
cc_2223 ( N_GND_c_3852_n N_noxref_17_c_4360_n ) capacitor c=0.00322478f \
 //x=5.245 //y=0.175 //x2=6.805 //y2=0.805
cc_2224 ( N_GND_c_3831_n N_noxref_17_c_4361_n ) capacitor c=0.0140761f \
 //x=11.15 //y=0.175 //x2=7.69 //y2=0.72
cc_2225 ( N_GND_c_3849_n N_noxref_17_c_4361_n ) capacitor c=0.0356451f \
 //x=9.885 //y=0.175 //x2=7.69 //y2=0.72
cc_2226 ( N_GND_c_4018_n N_noxref_17_c_4361_n ) capacitor c=0.00177266f \
 //x=25.965 //y=0.18 //x2=7.69 //y2=0.72
cc_2227 ( N_GND_c_3830_n N_noxref_17_M3_noxref_s ) capacitor c=0.00710913f \
 //x=6.235 //y=0.175 //x2=5.7 //y2=0.555
cc_2228 ( N_GND_c_3918_n N_noxref_17_M3_noxref_s ) capacitor c=0.0173062f \
 //x=6.32 //y=1.015 //x2=5.7 //y2=0.555
cc_2229 ( N_GND_c_3831_n N_noxref_17_M3_noxref_s ) capacitor c=0.00683407f \
 //x=11.15 //y=0.175 //x2=5.7 //y2=0.555
cc_2230 ( N_GND_c_3924_n N_noxref_17_M3_noxref_s ) capacitor c=0.00988958f \
 //x=6.32 //y=1.145 //x2=5.7 //y2=0.555
cc_2231 ( N_GND_c_3849_n N_noxref_17_M3_noxref_s ) capacitor c=0.0272246f \
 //x=9.885 //y=0.175 //x2=5.7 //y2=0.555
cc_2232 ( N_GND_c_3852_n N_noxref_17_M3_noxref_s ) capacitor c=0.0634633f \
 //x=5.245 //y=0.175 //x2=5.7 //y2=0.555
cc_2233 ( N_GND_c_3856_n N_noxref_17_M3_noxref_s ) capacitor c=0.00166451f \
 //x=10.055 //y=0.175 //x2=5.7 //y2=0.555
cc_2234 ( N_GND_M3_noxref_d N_noxref_17_M3_noxref_s ) capacitor c=0.0271316f \
 //x=6.13 //y=1.055 //x2=5.7 //y2=0.555
cc_2235 ( N_GND_c_3831_n N_noxref_18_c_4400_n ) capacitor c=9.79596e-19 \
 //x=11.15 //y=0.175 //x2=11.635 //y2=1.76
cc_2236 ( N_GND_c_3871_n N_noxref_18_c_4400_n ) capacitor c=7.45647e-19 \
 //x=14.375 //y=0.175 //x2=11.635 //y2=1.76
cc_2237 ( N_GND_c_3835_n N_noxref_18_c_4400_n ) capacitor c=0.00398656f \
 //x=11.235 //y=1.135 //x2=11.635 //y2=1.76
cc_2238 ( N_GND_c_3851_n N_noxref_18_c_4400_n ) capacitor c=0.00395774f \
 //x=13.215 //y=0.175 //x2=11.635 //y2=1.76
cc_2239 ( N_GND_M6_noxref_d N_noxref_18_c_4400_n ) capacitor c=0.00578453f \
 //x=11.045 //y=1.045 //x2=11.635 //y2=1.76
cc_2240 ( N_GND_c_3871_n N_noxref_18_c_4445_n ) capacitor c=0.00310334f \
 //x=14.375 //y=0.175 //x2=11.72 //y2=0.795
cc_2241 ( N_GND_c_3845_n N_noxref_18_c_4445_n ) capacitor c=0.0119573f \
 //x=11.232 //y=1.005 //x2=11.72 //y2=0.795
cc_2242 ( N_GND_c_3851_n N_noxref_18_c_4445_n ) capacitor c=0.0147548f \
 //x=13.215 //y=0.175 //x2=11.72 //y2=0.795
cc_2243 ( N_GND_c_3856_n N_noxref_18_c_4445_n ) capacitor c=0.00282583f \
 //x=10.055 //y=0.175 //x2=11.72 //y2=0.795
cc_2244 ( N_GND_c_3896_n N_noxref_18_c_4445_n ) capacitor c=2.99181e-19 \
 //x=13.385 //y=0.175 //x2=11.72 //y2=0.795
cc_2245 ( N_GND_c_3856_n N_noxref_18_c_4407_n ) capacitor c=2.8386e-19 \
 //x=10.055 //y=0.175 //x2=11.72 //y2=1.675
cc_2246 ( N_GND_c_3871_n N_noxref_18_c_4412_n ) capacitor c=0.0098961f \
 //x=14.375 //y=0.175 //x2=12.605 //y2=0.71
cc_2247 ( N_GND_c_3851_n N_noxref_18_c_4412_n ) capacitor c=0.0374802f \
 //x=13.215 //y=0.175 //x2=12.605 //y2=0.71
cc_2248 ( N_GND_c_4018_n N_noxref_18_c_4412_n ) capacitor c=0.00198372f \
 //x=25.965 //y=0.18 //x2=12.605 //y2=0.71
cc_2249 ( N_GND_c_3871_n N_noxref_18_c_4454_n ) capacitor c=0.00250941f \
 //x=14.375 //y=0.175 //x2=12.69 //y2=0.795
cc_2250 ( N_GND_c_3851_n N_noxref_18_c_4454_n ) capacitor c=0.0145307f \
 //x=13.215 //y=0.175 //x2=12.69 //y2=0.795
cc_2251 ( N_GND_c_3896_n N_noxref_18_c_4454_n ) capacitor c=0.0396774f \
 //x=13.385 //y=0.175 //x2=12.69 //y2=0.795
cc_2252 ( N_GND_c_3831_n N_noxref_18_M6_noxref_s ) capacitor c=0.0045077f \
 //x=11.15 //y=0.175 //x2=10.615 //y2=0.545
cc_2253 ( N_GND_c_3835_n N_noxref_18_M6_noxref_s ) capacitor c=0.0100945f \
 //x=11.235 //y=1.135 //x2=10.615 //y2=0.545
cc_2254 ( N_GND_c_3845_n N_noxref_18_M6_noxref_s ) capacitor c=0.0170608f \
 //x=11.232 //y=1.005 //x2=10.615 //y2=0.545
cc_2255 ( N_GND_c_3851_n N_noxref_18_M6_noxref_s ) capacitor c=0.0147643f \
 //x=13.215 //y=0.175 //x2=10.615 //y2=0.545
cc_2256 ( N_GND_c_3856_n N_noxref_18_M6_noxref_s ) capacitor c=0.0528206f \
 //x=10.055 //y=0.175 //x2=10.615 //y2=0.545
cc_2257 ( N_GND_c_3896_n N_noxref_18_M6_noxref_s ) capacitor c=0.00648063f \
 //x=13.385 //y=0.175 //x2=10.615 //y2=0.545
cc_2258 ( N_GND_M6_noxref_d N_noxref_18_M6_noxref_s ) capacitor c=0.0271276f \
 //x=11.045 //y=1.045 //x2=10.615 //y2=0.545
cc_2259 ( N_GND_c_3871_n N_noxref_19_c_4468_n ) capacitor c=0.0011329f \
 //x=14.375 //y=0.175 //x2=14.86 //y2=1.77
cc_2260 ( N_GND_c_3913_n N_noxref_19_c_4468_n ) capacitor c=7.40908e-19 \
 //x=19.185 //y=0.175 //x2=14.86 //y2=1.77
cc_2261 ( N_GND_c_3881_n N_noxref_19_c_4468_n ) capacitor c=0.00365894f \
 //x=14.46 //y=1.145 //x2=14.86 //y2=1.77
cc_2262 ( N_GND_c_3894_n N_noxref_19_c_4468_n ) capacitor c=0.00392232f \
 //x=18.025 //y=0.175 //x2=14.86 //y2=1.77
cc_2263 ( N_GND_M8_noxref_d N_noxref_19_c_4468_n ) capacitor c=0.00578031f \
 //x=14.27 //y=1.055 //x2=14.86 //y2=1.77
cc_2264 ( N_GND_c_3875_n N_noxref_19_c_4493_n ) capacitor c=0.0169052f \
 //x=14.46 //y=1.015 //x2=14.945 //y2=0.805
cc_2265 ( N_GND_c_3913_n N_noxref_19_c_4493_n ) capacitor c=0.00439789f \
 //x=19.185 //y=0.175 //x2=14.945 //y2=0.805
cc_2266 ( N_GND_c_3894_n N_noxref_19_c_4493_n ) capacitor c=0.0141638f \
 //x=18.025 //y=0.175 //x2=14.945 //y2=0.805
cc_2267 ( N_GND_c_3896_n N_noxref_19_c_4493_n ) capacitor c=0.00322442f \
 //x=13.385 //y=0.175 //x2=14.945 //y2=0.805
cc_2268 ( N_GND_c_3913_n N_noxref_19_c_4479_n ) capacitor c=0.0124364f \
 //x=19.185 //y=0.175 //x2=15.83 //y2=0.72
cc_2269 ( N_GND_c_3894_n N_noxref_19_c_4479_n ) capacitor c=0.0361346f \
 //x=18.025 //y=0.175 //x2=15.83 //y2=0.72
cc_2270 ( N_GND_c_4018_n N_noxref_19_c_4479_n ) capacitor c=0.00177266f \
 //x=25.965 //y=0.18 //x2=15.83 //y2=0.72
cc_2271 ( N_GND_c_3871_n N_noxref_19_M8_noxref_s ) capacitor c=0.00439789f \
 //x=14.375 //y=0.175 //x2=13.84 //y2=0.555
cc_2272 ( N_GND_c_3875_n N_noxref_19_M8_noxref_s ) capacitor c=0.0125586f \
 //x=14.46 //y=1.015 //x2=13.84 //y2=0.555
cc_2273 ( N_GND_c_3913_n N_noxref_19_M8_noxref_s ) capacitor c=0.0044479f \
 //x=19.185 //y=0.175 //x2=13.84 //y2=0.555
cc_2274 ( N_GND_c_3881_n N_noxref_19_M8_noxref_s ) capacitor c=0.00972044f \
 //x=14.46 //y=1.145 //x2=13.84 //y2=0.555
cc_2275 ( N_GND_c_3894_n N_noxref_19_M8_noxref_s ) capacitor c=0.0273693f \
 //x=18.025 //y=0.175 //x2=13.84 //y2=0.555
cc_2276 ( N_GND_c_3896_n N_noxref_19_M8_noxref_s ) capacitor c=0.0624873f \
 //x=13.385 //y=0.175 //x2=13.84 //y2=0.555
cc_2277 ( N_GND_c_3955_n N_noxref_19_M8_noxref_s ) capacitor c=0.00166413f \
 //x=18.195 //y=0.175 //x2=13.84 //y2=0.555
cc_2278 ( N_GND_M8_noxref_d N_noxref_19_M8_noxref_s ) capacitor c=0.0271316f \
 //x=14.27 //y=1.055 //x2=13.84 //y2=0.555
cc_2279 ( N_GND_c_3913_n N_noxref_20_c_4527_n ) capacitor c=0.0011329f \
 //x=19.185 //y=0.175 //x2=19.67 //y2=1.77
cc_2280 ( N_GND_c_3983_n N_noxref_20_c_4527_n ) capacitor c=7.40908e-19 \
 //x=24.1 //y=0.175 //x2=19.67 //y2=1.77
cc_2281 ( N_GND_c_3935_n N_noxref_20_c_4527_n ) capacitor c=0.00371075f \
 //x=19.27 //y=1.145 //x2=19.67 //y2=1.77
cc_2282 ( N_GND_c_3947_n N_noxref_20_c_4527_n ) capacitor c=0.00392232f \
 //x=22.835 //y=0.175 //x2=19.67 //y2=1.77
cc_2283 ( N_GND_M11_noxref_d N_noxref_20_c_4527_n ) capacitor c=0.00578031f \
 //x=19.08 //y=1.055 //x2=19.67 //y2=1.77
cc_2284 ( N_GND_c_3921_n N_noxref_20_c_4553_n ) capacitor c=0.0169052f \
 //x=19.27 //y=1.015 //x2=19.755 //y2=0.805
cc_2285 ( N_GND_c_3983_n N_noxref_20_c_4553_n ) capacitor c=0.00439789f \
 //x=24.1 //y=0.175 //x2=19.755 //y2=0.805
cc_2286 ( N_GND_c_3947_n N_noxref_20_c_4553_n ) capacitor c=0.0141638f \
 //x=22.835 //y=0.175 //x2=19.755 //y2=0.805
cc_2287 ( N_GND_c_3955_n N_noxref_20_c_4553_n ) capacitor c=0.00322478f \
 //x=18.195 //y=0.175 //x2=19.755 //y2=0.805
cc_2288 ( N_GND_c_3983_n N_noxref_20_c_4540_n ) capacitor c=0.0133369f \
 //x=24.1 //y=0.175 //x2=20.64 //y2=0.72
cc_2289 ( N_GND_c_3947_n N_noxref_20_c_4540_n ) capacitor c=0.0358997f \
 //x=22.835 //y=0.175 //x2=20.64 //y2=0.72
cc_2290 ( N_GND_c_4018_n N_noxref_20_c_4540_n ) capacitor c=0.00177266f \
 //x=25.965 //y=0.18 //x2=20.64 //y2=0.72
cc_2291 ( N_GND_c_3913_n N_noxref_20_M11_noxref_s ) capacitor c=0.00439789f \
 //x=19.185 //y=0.175 //x2=18.65 //y2=0.555
cc_2292 ( N_GND_c_3921_n N_noxref_20_M11_noxref_s ) capacitor c=0.0173062f \
 //x=19.27 //y=1.015 //x2=18.65 //y2=0.555
cc_2293 ( N_GND_c_3983_n N_noxref_20_M11_noxref_s ) capacitor c=0.00683407f \
 //x=24.1 //y=0.175 //x2=18.65 //y2=0.555
cc_2294 ( N_GND_c_3935_n N_noxref_20_M11_noxref_s ) capacitor c=0.00988958f \
 //x=19.27 //y=1.145 //x2=18.65 //y2=0.555
cc_2295 ( N_GND_c_3947_n N_noxref_20_M11_noxref_s ) capacitor c=0.027328f \
 //x=22.835 //y=0.175 //x2=18.65 //y2=0.555
cc_2296 ( N_GND_c_3955_n N_noxref_20_M11_noxref_s ) capacitor c=0.0634633f \
 //x=18.195 //y=0.175 //x2=18.65 //y2=0.555
cc_2297 ( N_GND_c_4019_n N_noxref_20_M11_noxref_s ) capacitor c=0.00166451f \
 //x=23.005 //y=0.175 //x2=18.65 //y2=0.555
cc_2298 ( N_GND_M11_noxref_d N_noxref_20_M11_noxref_s ) capacitor c=0.0271316f \
 //x=19.08 //y=1.055 //x2=18.65 //y2=0.555
cc_2299 ( N_GND_c_3983_n N_noxref_21_c_4585_n ) capacitor c=9.79596e-19 \
 //x=24.1 //y=0.175 //x2=24.585 //y2=1.76
cc_2300 ( N_GND_c_4041_n N_noxref_21_c_4585_n ) capacitor c=0.00203804f \
 //x=25.965 //y=0.18 //x2=24.585 //y2=1.76
cc_2301 ( N_GND_c_4002_n N_noxref_21_c_4585_n ) capacitor c=0.0040061f \
 //x=24.185 //y=1.135 //x2=24.585 //y2=1.76
cc_2302 ( N_GND_c_4018_n N_noxref_21_c_4585_n ) capacitor c=0.00387051f \
 //x=25.965 //y=0.18 //x2=24.585 //y2=1.76
cc_2303 ( N_GND_M14_noxref_d N_noxref_21_c_4585_n ) capacitor c=0.00578453f \
 //x=23.995 //y=1.045 //x2=24.585 //y2=1.76
cc_2304 ( N_GND_c_4041_n N_noxref_21_c_4628_n ) capacitor c=0.00560241f \
 //x=25.965 //y=0.18 //x2=24.67 //y2=0.795
cc_2305 ( N_GND_c_4013_n N_noxref_21_c_4628_n ) capacitor c=0.0167642f \
 //x=24.182 //y=1.005 //x2=24.67 //y2=0.795
cc_2306 ( N_GND_c_4018_n N_noxref_21_c_4628_n ) capacitor c=0.0148823f \
 //x=25.965 //y=0.18 //x2=24.67 //y2=0.795
cc_2307 ( N_GND_c_4019_n N_noxref_21_c_4628_n ) capacitor c=0.00282583f \
 //x=23.005 //y=0.175 //x2=24.67 //y2=0.795
cc_2308 ( N_GND_c_4019_n N_noxref_21_c_4593_n ) capacitor c=2.8386e-19 \
 //x=23.005 //y=0.175 //x2=24.67 //y2=1.675
cc_2309 ( N_GND_c_4041_n N_noxref_21_c_4601_n ) capacitor c=0.0100002f \
 //x=25.965 //y=0.18 //x2=25.555 //y2=0.71
cc_2310 ( N_GND_c_4018_n N_noxref_21_c_4601_n ) capacitor c=0.039544f \
 //x=25.965 //y=0.18 //x2=25.555 //y2=0.71
cc_2311 ( N_GND_c_4041_n N_noxref_21_c_4635_n ) capacitor c=0.00253402f \
 //x=25.965 //y=0.18 //x2=25.64 //y2=0.795
cc_2312 ( N_GND_c_4018_n N_noxref_21_c_4635_n ) capacitor c=0.0567734f \
 //x=25.965 //y=0.18 //x2=25.64 //y2=0.795
cc_2313 ( N_GND_c_3983_n N_noxref_21_M14_noxref_s ) capacitor c=0.00724992f \
 //x=24.1 //y=0.175 //x2=23.565 //y2=0.545
cc_2314 ( N_GND_c_4002_n N_noxref_21_M14_noxref_s ) capacitor c=0.0101884f \
 //x=24.185 //y=1.135 //x2=23.565 //y2=0.545
cc_2315 ( N_GND_c_4013_n N_noxref_21_M14_noxref_s ) capacitor c=0.0173062f \
 //x=24.182 //y=1.005 //x2=23.565 //y2=0.545
cc_2316 ( N_GND_c_4018_n N_noxref_21_M14_noxref_s ) capacitor c=0.0212998f \
 //x=25.965 //y=0.18 //x2=23.565 //y2=0.545
cc_2317 ( N_GND_c_4019_n N_noxref_21_M14_noxref_s ) capacitor c=0.0528206f \
 //x=23.005 //y=0.175 //x2=23.565 //y2=0.545
cc_2318 ( N_GND_M14_noxref_d N_noxref_21_M14_noxref_s ) capacitor c=0.0271276f \
 //x=23.995 //y=1.045 //x2=23.565 //y2=0.545
cc_2319 ( N_noxref_18_c_4407_n N_noxref_19_c_4467_n ) capacitor c=6.40432e-19 \
 //x=11.72 //y=1.675 //x2=13.975 //y2=1.685
cc_2320 ( N_noxref_18_c_4454_n N_noxref_19_M8_noxref_s ) capacitor \
 c=0.00453771f //x=12.69 //y=0.795 //x2=13.84 //y2=0.555
cc_2321 ( N_noxref_18_M6_noxref_s N_noxref_19_M8_noxref_s ) capacitor \
 c=6.40432e-19 //x=10.615 //y=0.545 //x2=13.84 //y2=0.555
