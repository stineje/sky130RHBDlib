// File: DFFRNQX1.spi.DFFRNQX1.pxi
// Created: Tue Apr 29 10:40:01 2025
//
simulator lang=spectre
x_PM_DFFRNQX1\%VDD ( VDD N_VDD_c_9_p N_VDD_c_1_p N_VDD_c_113_p N_VDD_c_104_p \
 N_VDD_c_27_p N_VDD_c_83_p N_VDD_c_84_p N_VDD_c_10_p N_VDD_c_11_p N_VDD_c_17_p \
 N_VDD_c_21_p N_VDD_c_87_p N_VDD_c_25_p N_VDD_c_53_p N_VDD_c_89_p N_VDD_c_90_p \
 N_VDD_c_65_p N_VDD_c_108_p N_VDD_c_168_p N_VDD_c_260_p N_VDD_c_261_p \
 N_VDD_c_137_p N_VDD_c_172_p N_VDD_c_198_p N_VDD_c_224_p N_VDD_c_264_p \
 N_VDD_c_186_p N_VDD_c_187_p N_VDD_c_2_p N_VDD_c_3_p N_VDD_c_4_p N_VDD_c_5_p \
 N_VDD_c_6_p N_VDD_c_7_p N_VDD_M16_noxref_s N_VDD_M17_noxref_d \
 N_VDD_M19_noxref_d N_VDD_M21_noxref_d N_VDD_M22_noxref_s N_VDD_M23_noxref_d \
 N_VDD_M25_noxref_d N_VDD_M27_noxref_d N_VDD_M28_noxref_s N_VDD_M29_noxref_d \
 N_VDD_M31_noxref_d N_VDD_M32_noxref_s N_VDD_M33_noxref_d N_VDD_M35_noxref_d \
 N_VDD_M37_noxref_d N_VDD_M38_noxref_s N_VDD_M39_noxref_d N_VDD_M41_noxref_d \
 N_VDD_M43_noxref_d N_VDD_M44_noxref_s N_VDD_M45_noxref_d N_VDD_M47_noxref_d ) \
 PM_DFFRNQX1\%VDD
x_PM_DFFRNQX1\%GND ( GND N_GND_c_339_p N_GND_c_464_p N_GND_c_332_n \
 N_GND_c_340_p N_GND_c_341_p N_GND_c_389_p N_GND_c_348_p N_GND_c_355_p \
 N_GND_c_363_p N_GND_c_370_p N_GND_c_392_p N_GND_c_399_p N_GND_c_443_p \
 N_GND_c_333_n N_GND_c_334_n N_GND_c_335_n N_GND_c_336_n N_GND_c_337_n \
 N_GND_c_338_n N_GND_M0_noxref_d N_GND_M3_noxref_d N_GND_M6_noxref_d \
 N_GND_M8_noxref_d N_GND_M11_noxref_d N_GND_M14_noxref_d )  PM_DFFRNQX1\%GND
x_PM_DFFRNQX1\%noxref_3 ( N_noxref_3_c_675_n N_noxref_3_c_679_n \
 N_noxref_3_c_680_n N_noxref_3_c_747_p N_noxref_3_c_632_n N_noxref_3_c_633_n \
 N_noxref_3_c_637_n N_noxref_3_c_639_n N_noxref_3_c_643_n N_noxref_3_c_682_n \
 N_noxref_3_c_785_p N_noxref_3_c_647_n N_noxref_3_c_648_n N_noxref_3_c_875_p \
 N_noxref_3_c_800_p N_noxref_3_M2_noxref_g N_noxref_3_M6_noxref_g \
 N_noxref_3_M20_noxref_g N_noxref_3_M21_noxref_g N_noxref_3_M28_noxref_g \
 N_noxref_3_M29_noxref_g N_noxref_3_c_733_p N_noxref_3_c_734_p \
 N_noxref_3_c_735_p N_noxref_3_c_775_p N_noxref_3_c_755_p N_noxref_3_c_777_p \
 N_noxref_3_c_756_p N_noxref_3_c_684_n N_noxref_3_c_686_n N_noxref_3_c_687_n \
 N_noxref_3_c_688_n N_noxref_3_c_689_n N_noxref_3_c_690_n N_noxref_3_c_691_n \
 N_noxref_3_c_693_n N_noxref_3_c_721_p N_noxref_3_c_738_p N_noxref_3_c_711_p \
 N_noxref_3_c_659_n N_noxref_3_M5_noxref_d N_noxref_3_M22_noxref_d \
 N_noxref_3_M24_noxref_d N_noxref_3_M26_noxref_d )  PM_DFFRNQX1\%noxref_3
x_PM_DFFRNQX1\%noxref_4 ( N_noxref_4_c_932_n N_noxref_4_c_949_n \
 N_noxref_4_c_901_n N_noxref_4_c_905_n N_noxref_4_c_907_n N_noxref_4_c_933_n \
 N_noxref_4_c_992_p N_noxref_4_c_910_n N_noxref_4_c_912_n N_noxref_4_c_1019_p \
 N_noxref_4_M8_noxref_g N_noxref_4_M32_noxref_g N_noxref_4_M33_noxref_g \
 N_noxref_4_c_936_n N_noxref_4_c_938_n N_noxref_4_c_939_n N_noxref_4_c_940_n \
 N_noxref_4_c_941_n N_noxref_4_c_942_n N_noxref_4_c_943_n N_noxref_4_c_945_n \
 N_noxref_4_c_965_p N_noxref_4_c_919_n N_noxref_4_M7_noxref_d \
 N_noxref_4_M28_noxref_d N_noxref_4_M30_noxref_d )  PM_DFFRNQX1\%noxref_4
x_PM_DFFRNQX1\%CLK ( N_CLK_c_1050_n N_CLK_c_1067_n CLK CLK CLK CLK CLK CLK CLK \
 CLK CLK N_CLK_c_1080_n N_CLK_c_1068_n N_CLK_c_1081_n N_CLK_c_1069_n \
 N_CLK_c_1103_n N_CLK_c_1104_n N_CLK_c_1106_n N_CLK_c_1070_n N_CLK_c_1131_n \
 N_CLK_c_1132_n N_CLK_c_1071_n N_CLK_M1_noxref_g N_CLK_M9_noxref_g \
 N_CLK_M18_noxref_g N_CLK_M19_noxref_g N_CLK_M34_noxref_g N_CLK_M35_noxref_g \
 N_CLK_c_1239_p N_CLK_c_1241_p N_CLK_c_1266_p N_CLK_c_1273_p N_CLK_c_1112_n \
 N_CLK_c_1113_n N_CLK_c_1114_n N_CLK_c_1115_n N_CLK_c_1118_n N_CLK_c_1137_n \
 N_CLK_c_1140_n N_CLK_c_1290_p N_CLK_c_1297_p N_CLK_c_1142_n N_CLK_c_1143_n \
 N_CLK_c_1144_n N_CLK_c_1145_n N_CLK_c_1203_p N_CLK_c_1119_n N_CLK_c_1147_n )  \
 PM_DFFRNQX1\%CLK
x_PM_DFFRNQX1\%noxref_6 ( N_noxref_6_c_1375_n N_noxref_6_c_1376_n \
 N_noxref_6_c_1350_n N_noxref_6_c_1383_n N_noxref_6_c_1302_n \
 N_noxref_6_c_1306_n N_noxref_6_c_1308_n N_noxref_6_c_1312_n \
 N_noxref_6_c_1351_n N_noxref_6_c_1390_n N_noxref_6_c_1316_n \
 N_noxref_6_c_1317_n N_noxref_6_c_1320_n N_noxref_6_c_1438_n \
 N_noxref_6_c_1399_n N_noxref_6_M3_noxref_g N_noxref_6_M11_noxref_g \
 N_noxref_6_M22_noxref_g N_noxref_6_M23_noxref_g N_noxref_6_M38_noxref_g \
 N_noxref_6_M39_noxref_g N_noxref_6_c_1354_n N_noxref_6_c_1356_n \
 N_noxref_6_c_1357_n N_noxref_6_c_1358_n N_noxref_6_c_1359_n \
 N_noxref_6_c_1360_n N_noxref_6_c_1361_n N_noxref_6_c_1363_n \
 N_noxref_6_c_1404_n N_noxref_6_c_1331_n N_noxref_6_c_1364_n \
 N_noxref_6_c_1366_n N_noxref_6_c_1367_n N_noxref_6_c_1368_n \
 N_noxref_6_c_1369_n N_noxref_6_c_1370_n N_noxref_6_c_1371_n \
 N_noxref_6_c_1373_n N_noxref_6_c_1456_p N_noxref_6_c_1333_n \
 N_noxref_6_M2_noxref_d N_noxref_6_M16_noxref_d N_noxref_6_M18_noxref_d \
 N_noxref_6_M20_noxref_d )  PM_DFFRNQX1\%noxref_6
x_PM_DFFRNQX1\%RN ( N_RN_c_1573_n N_RN_c_1581_n N_RN_c_1583_n N_RN_c_1587_n RN \
 RN RN RN RN RN RN RN RN RN RN RN RN N_RN_c_1606_n N_RN_c_1557_n N_RN_c_1649_n \
 N_RN_c_1558_n N_RN_c_1682_n N_RN_c_1559_n N_RN_c_1590_n N_RN_c_1613_n \
 N_RN_c_1591_n N_RN_c_1656_n N_RN_c_1657_n N_RN_c_1592_n N_RN_c_1718_p \
 N_RN_c_1719_p N_RN_c_1687_n N_RN_c_1560_n N_RN_M5_noxref_g N_RN_M10_noxref_g \
 N_RN_M12_noxref_g N_RN_M26_noxref_g N_RN_M27_noxref_g N_RN_M36_noxref_g \
 N_RN_M37_noxref_g N_RN_M40_noxref_g N_RN_M41_noxref_g N_RN_c_1618_n \
 N_RN_c_1619_n N_RN_c_1620_n N_RN_c_1621_n N_RN_c_1622_n N_RN_c_1624_n \
 N_RN_c_1625_n N_RN_c_1661_n N_RN_c_1662_n N_RN_c_1663_n N_RN_c_1793_p \
 N_RN_c_1769_p N_RN_c_1795_p N_RN_c_1770_p N_RN_c_1692_n N_RN_c_1695_n \
 N_RN_c_1866_p N_RN_c_1873_p N_RN_c_1697_n N_RN_c_1698_n N_RN_c_1699_n \
 N_RN_c_1700_n N_RN_c_1733_p N_RN_c_1627_n N_RN_c_1628_n N_RN_c_1630_n \
 N_RN_c_1665_n N_RN_c_1667_n N_RN_c_1668_n N_RN_c_1702_n )  PM_DFFRNQX1\%RN
x_PM_DFFRNQX1\%Q ( Q Q Q Q Q Q Q Q Q Q Q Q Q N_Q_c_1919_n N_Q_c_1886_n \
 N_Q_c_1887_n N_Q_c_1891_n N_Q_c_1893_n N_Q_c_1920_n N_Q_c_2055_p N_Q_c_1896_n \
 N_Q_c_1943_n N_Q_c_1944_n N_Q_c_1945_n N_Q_c_1897_n N_Q_c_2028_p N_Q_c_1921_n \
 N_Q_c_1922_n N_Q_c_1923_n N_Q_c_2011_p N_Q_c_1898_n N_Q_c_1899_n \
 N_Q_M13_noxref_g N_Q_M42_noxref_g N_Q_M43_noxref_g N_Q_c_1950_n N_Q_c_1951_n \
 N_Q_c_1952_n N_Q_c_1989_p N_Q_c_1964_p N_Q_c_1991_p N_Q_c_1965_p N_Q_c_1953_n \
 N_Q_c_1956_n N_Q_c_1957_n N_Q_M15_noxref_d N_Q_M44_noxref_d N_Q_M46_noxref_d ) \
 PM_DFFRNQX1\%Q
x_PM_DFFRNQX1\%noxref_9 ( N_noxref_9_c_2066_n N_noxref_9_c_2070_n \
 N_noxref_9_c_2072_n N_noxref_9_c_2076_n N_noxref_9_c_2096_n \
 N_noxref_9_c_2123_n N_noxref_9_c_2080_n N_noxref_9_c_2114_n \
 N_noxref_9_c_2141_n N_noxref_9_M13_noxref_d N_noxref_9_M38_noxref_d \
 N_noxref_9_M40_noxref_d N_noxref_9_M42_noxref_d )  PM_DFFRNQX1\%noxref_9
x_PM_DFFRNQX1\%noxref_10 ( N_noxref_10_c_2170_n N_noxref_10_c_2179_n \
 N_noxref_10_M14_noxref_g N_noxref_10_M44_noxref_g N_noxref_10_M45_noxref_g \
 N_noxref_10_c_2183_n N_noxref_10_c_2185_n N_noxref_10_c_2186_n \
 N_noxref_10_c_2187_n N_noxref_10_c_2188_n N_noxref_10_c_2189_n \
 N_noxref_10_c_2190_n N_noxref_10_c_2192_n N_noxref_10_c_2177_n )  \
 PM_DFFRNQX1\%noxref_10
x_PM_DFFRNQX1\%noxref_11 ( N_noxref_11_c_2240_n N_noxref_11_c_2244_n \
 N_noxref_11_c_2247_n N_noxref_11_c_2343_n N_noxref_11_c_2249_n \
 N_noxref_11_c_2260_n N_noxref_11_c_2263_n N_noxref_11_c_2345_n \
 N_noxref_11_c_2266_n N_noxref_11_c_2268_n N_noxref_11_c_2272_n \
 N_noxref_11_c_2274_n N_noxref_11_c_2278_n N_noxref_11_c_2322_n \
 N_noxref_11_c_2499_n N_noxref_11_c_2282_n N_noxref_11_c_2538_n \
 N_noxref_11_c_2283_n N_noxref_11_c_2432_n N_noxref_11_c_2514_n \
 N_noxref_11_M0_noxref_g N_noxref_11_M7_noxref_g N_noxref_11_M15_noxref_g \
 N_noxref_11_M16_noxref_g N_noxref_11_M17_noxref_g N_noxref_11_M30_noxref_g \
 N_noxref_11_M31_noxref_g N_noxref_11_M46_noxref_g N_noxref_11_M47_noxref_g \
 N_noxref_11_c_2325_n N_noxref_11_c_2327_n N_noxref_11_c_2328_n \
 N_noxref_11_c_2329_n N_noxref_11_c_2330_n N_noxref_11_c_2331_n \
 N_noxref_11_c_2332_n N_noxref_11_c_2334_n N_noxref_11_c_2447_n \
 N_noxref_11_c_2299_n N_noxref_11_c_2354_n N_noxref_11_c_2357_n \
 N_noxref_11_c_2359_n N_noxref_11_c_2389_n N_noxref_11_c_2391_n \
 N_noxref_11_c_2392_n N_noxref_11_c_2362_n N_noxref_11_c_2363_n \
 N_noxref_11_c_2548_n N_noxref_11_c_2549_n N_noxref_11_c_2550_n \
 N_noxref_11_c_2551_n N_noxref_11_c_2554_n N_noxref_11_c_2555_n \
 N_noxref_11_c_2557_n N_noxref_11_c_2558_n N_noxref_11_c_2364_n \
 N_noxref_11_c_2398_n N_noxref_11_c_2366_n N_noxref_11_c_2560_n \
 N_noxref_11_c_2562_n N_noxref_11_c_2564_n N_noxref_11_M10_noxref_d \
 N_noxref_11_M32_noxref_d N_noxref_11_M34_noxref_d N_noxref_11_M36_noxref_d )  \
 PM_DFFRNQX1\%noxref_11
x_PM_DFFRNQX1\%noxref_12 ( N_noxref_12_c_2674_n N_noxref_12_c_2648_n \
 N_noxref_12_c_2652_n N_noxref_12_c_2655_n N_noxref_12_c_2666_n \
 N_noxref_12_M0_noxref_s )  PM_DFFRNQX1\%noxref_12
x_PM_DFFRNQX1\%noxref_13 ( N_noxref_13_c_2696_n N_noxref_13_c_2698_n \
 N_noxref_13_c_2701_n N_noxref_13_c_2704_n N_noxref_13_c_2715_n \
 N_noxref_13_M1_noxref_d N_noxref_13_M2_noxref_s )  PM_DFFRNQX1\%noxref_13
x_PM_DFFRNQX1\%D ( D D N_D_c_2755_n N_D_c_2749_n N_D_c_2778_n N_D_M4_noxref_g \
 N_D_M24_noxref_g N_D_M25_noxref_g N_D_c_2782_n N_D_c_2785_n N_D_c_2826_p \
 N_D_c_2833_p N_D_c_2787_n N_D_c_2788_n N_D_c_2789_n N_D_c_2790_n N_D_c_2767_n \
 N_D_c_2768_n )  PM_DFFRNQX1\%D
x_PM_DFFRNQX1\%noxref_15 ( N_noxref_15_c_2854_n N_noxref_15_c_2838_n \
 N_noxref_15_c_2842_n N_noxref_15_c_2845_n N_noxref_15_c_2856_n \
 N_noxref_15_M3_noxref_s )  PM_DFFRNQX1\%noxref_15
x_PM_DFFRNQX1\%noxref_16 ( N_noxref_16_c_2889_n N_noxref_16_c_2891_n \
 N_noxref_16_c_2894_n N_noxref_16_c_2897_n N_noxref_16_c_2906_n \
 N_noxref_16_M4_noxref_d N_noxref_16_M5_noxref_s )  PM_DFFRNQX1\%noxref_16
x_PM_DFFRNQX1\%noxref_17 ( N_noxref_17_c_2962_n N_noxref_17_c_2943_n \
 N_noxref_17_c_2947_n N_noxref_17_c_2950_n N_noxref_17_c_2951_n \
 N_noxref_17_c_2954_n N_noxref_17_M6_noxref_s )  PM_DFFRNQX1\%noxref_17
x_PM_DFFRNQX1\%noxref_18 ( N_noxref_18_c_3011_n N_noxref_18_c_2995_n \
 N_noxref_18_c_2999_n N_noxref_18_c_3002_n N_noxref_18_c_3025_n \
 N_noxref_18_M8_noxref_s )  PM_DFFRNQX1\%noxref_18
x_PM_DFFRNQX1\%noxref_19 ( N_noxref_19_c_3046_n N_noxref_19_c_3048_n \
 N_noxref_19_c_3051_n N_noxref_19_c_3054_n N_noxref_19_c_3079_n \
 N_noxref_19_M9_noxref_d N_noxref_19_M10_noxref_s )  PM_DFFRNQX1\%noxref_19
x_PM_DFFRNQX1\%noxref_20 ( N_noxref_20_c_3116_n N_noxref_20_c_3100_n \
 N_noxref_20_c_3104_n N_noxref_20_c_3107_n N_noxref_20_c_3130_n \
 N_noxref_20_M11_noxref_s )  PM_DFFRNQX1\%noxref_20
x_PM_DFFRNQX1\%noxref_21 ( N_noxref_21_c_3152_n N_noxref_21_c_3154_n \
 N_noxref_21_c_3157_n N_noxref_21_c_3160_n N_noxref_21_c_3184_n \
 N_noxref_21_M12_noxref_d N_noxref_21_M13_noxref_s )  PM_DFFRNQX1\%noxref_21
x_PM_DFFRNQX1\%noxref_22 ( N_noxref_22_c_3223_n N_noxref_22_c_3206_n \
 N_noxref_22_c_3210_n N_noxref_22_c_3213_n N_noxref_22_c_3214_n \
 N_noxref_22_c_3216_n N_noxref_22_M14_noxref_s )  PM_DFFRNQX1\%noxref_22
cc_1 ( N_VDD_c_1_p N_GND_c_332_n ) capacitor c=0.00989514f //x=1.175 //y=7.58 \
 //x2=1.175 //y2=0.18
cc_2 ( N_VDD_c_2_p N_GND_c_333_n ) capacitor c=0.00989514f //x=25.965 //y=7.58 \
 //x2=25.965 //y2=0.18
cc_3 ( N_VDD_c_3_p N_GND_c_334_n ) capacitor c=0.00500791f //x=5.245 //y=7.585 \
 //x2=5.245 //y2=0.175
cc_4 ( N_VDD_c_4_p N_GND_c_335_n ) capacitor c=0.00500791f //x=10.055 \
 //y=7.585 //x2=10.055 //y2=0.175
cc_5 ( N_VDD_c_5_p N_GND_c_336_n ) capacitor c=0.00500791f //x=13.385 \
 //y=7.585 //x2=13.385 //y2=0.175
cc_6 ( N_VDD_c_6_p N_GND_c_337_n ) capacitor c=0.00524733f //x=18.195 \
 //y=7.585 //x2=18.195 //y2=0.175
cc_7 ( N_VDD_c_7_p N_GND_c_338_n ) capacitor c=0.00500791f //x=23.005 \
 //y=7.585 //x2=23.005 //y2=0.175
cc_8 ( N_VDD_c_3_p N_noxref_3_c_632_n ) capacitor c=6.58823e-19 //x=5.245 \
 //y=7.585 //x2=3.765 //y2=2.26
cc_9 ( N_VDD_c_9_p N_noxref_3_c_633_n ) capacitor c=0.00444939f //x=25.965 \
 //y=7.58 //x2=7.57 //y2=5.335
cc_10 ( N_VDD_c_10_p N_noxref_3_c_633_n ) capacitor c=4.32416e-19 //x=7.13 \
 //y=7.585 //x2=7.57 //y2=5.335
cc_11 ( N_VDD_c_11_p N_noxref_3_c_633_n ) capacitor c=4.32416e-19 //x=8.01 \
 //y=7.585 //x2=7.57 //y2=5.335
cc_12 ( N_VDD_M23_noxref_d N_noxref_3_c_633_n ) capacitor c=0.0112992f \
 //x=7.07 //y=5.2 //x2=7.57 //y2=5.335
cc_13 ( N_VDD_c_3_p N_noxref_3_c_637_n ) capacitor c=0.00863585f //x=5.245 \
 //y=7.585 //x2=6.86 //y2=5.335
cc_14 ( N_VDD_M22_noxref_s N_noxref_3_c_637_n ) capacitor c=0.0831083f //x=6.2 \
 //y=5.2 //x2=6.86 //y2=5.335
cc_15 ( N_VDD_c_9_p N_noxref_3_c_639_n ) capacitor c=0.00442256f //x=25.965 \
 //y=7.58 //x2=8.45 //y2=5.335
cc_16 ( N_VDD_c_11_p N_noxref_3_c_639_n ) capacitor c=4.32416e-19 //x=8.01 \
 //y=7.585 //x2=8.45 //y2=5.335
cc_17 ( N_VDD_c_17_p N_noxref_3_c_639_n ) capacitor c=4.32416e-19 //x=8.89 \
 //y=7.585 //x2=8.45 //y2=5.335
cc_18 ( N_VDD_M25_noxref_d N_noxref_3_c_639_n ) capacitor c=0.0112992f \
 //x=7.95 //y=5.2 //x2=8.45 //y2=5.335
cc_19 ( N_VDD_c_9_p N_noxref_3_c_643_n ) capacitor c=0.00434594f //x=25.965 \
 //y=7.58 //x2=9.23 //y2=5.335
cc_20 ( N_VDD_c_17_p N_noxref_3_c_643_n ) capacitor c=7.47443e-19 //x=8.89 \
 //y=7.585 //x2=9.23 //y2=5.335
cc_21 ( N_VDD_c_21_p N_noxref_3_c_643_n ) capacitor c=0.00199034f //x=9.885 \
 //y=7.585 //x2=9.23 //y2=5.335
cc_22 ( N_VDD_M27_noxref_d N_noxref_3_c_643_n ) capacitor c=0.0112992f \
 //x=8.83 //y=5.2 //x2=9.23 //y2=5.335
cc_23 ( N_VDD_c_4_p N_noxref_3_c_647_n ) capacitor c=0.0426864f //x=10.055 \
 //y=7.585 //x2=9.315 //y2=3.51
cc_24 ( N_VDD_c_9_p N_noxref_3_c_648_n ) capacitor c=0.00125241f //x=25.965 \
 //y=7.58 //x2=11.165 //y2=2.26
cc_25 ( N_VDD_c_25_p N_noxref_3_c_648_n ) capacitor c=2.88017e-19 //x=11.64 \
 //y=7.585 //x2=11.165 //y2=2.26
cc_26 ( N_VDD_c_4_p N_noxref_3_c_648_n ) capacitor c=0.0134208f //x=10.055 \
 //y=7.585 //x2=11.165 //y2=2.26
cc_27 ( N_VDD_c_27_p N_noxref_3_M20_noxref_g ) capacitor c=0.00679791f \
 //x=4.08 //y=7.585 //x2=3.505 //y2=6.2
cc_28 ( N_VDD_M19_noxref_d N_noxref_3_M20_noxref_g ) capacitor c=0.015318f \
 //x=3.14 //y=5.2 //x2=3.505 //y2=6.2
cc_29 ( N_VDD_c_27_p N_noxref_3_M21_noxref_g ) capacitor c=0.00680002f \
 //x=4.08 //y=7.585 //x2=3.945 //y2=6.2
cc_30 ( N_VDD_M21_noxref_d N_noxref_3_M21_noxref_g ) capacitor c=0.0394719f \
 //x=4.02 //y=5.2 //x2=3.945 //y2=6.2
cc_31 ( N_VDD_c_25_p N_noxref_3_M28_noxref_g ) capacitor c=0.00732332f \
 //x=11.64 //y=7.585 //x2=11.065 //y2=6.2
cc_32 ( N_VDD_M28_noxref_s N_noxref_3_M28_noxref_g ) capacitor c=0.054195f \
 //x=10.71 //y=5.2 //x2=11.065 //y2=6.2
cc_33 ( N_VDD_c_25_p N_noxref_3_M29_noxref_g ) capacitor c=0.00677553f \
 //x=11.64 //y=7.585 //x2=11.505 //y2=6.2
cc_34 ( N_VDD_M29_noxref_d N_noxref_3_M29_noxref_g ) capacitor c=0.015318f \
 //x=11.58 //y=5.2 //x2=11.505 //y2=6.2
cc_35 ( N_VDD_c_4_p N_noxref_3_c_659_n ) capacitor c=0.0154093f //x=10.055 \
 //y=7.585 //x2=11.165 //y2=4.88
cc_36 ( N_VDD_c_9_p N_noxref_3_M22_noxref_d ) capacitor c=0.00275309f \
 //x=25.965 //y=7.58 //x2=6.63 //y2=5.2
cc_37 ( N_VDD_c_10_p N_noxref_3_M22_noxref_d ) capacitor c=0.0140577f //x=7.13 \
 //y=7.585 //x2=6.63 //y2=5.2
cc_38 ( N_VDD_M23_noxref_d N_noxref_3_M22_noxref_d ) capacitor c=0.0664752f \
 //x=7.07 //y=5.2 //x2=6.63 //y2=5.2
cc_39 ( N_VDD_c_9_p N_noxref_3_M24_noxref_d ) capacitor c=0.00275309f \
 //x=25.965 //y=7.58 //x2=7.51 //y2=5.2
cc_40 ( N_VDD_c_11_p N_noxref_3_M24_noxref_d ) capacitor c=0.0140577f //x=8.01 \
 //y=7.585 //x2=7.51 //y2=5.2
cc_41 ( N_VDD_c_4_p N_noxref_3_M24_noxref_d ) capacitor c=4.9285e-19 \
 //x=10.055 //y=7.585 //x2=7.51 //y2=5.2
cc_42 ( N_VDD_M22_noxref_s N_noxref_3_M24_noxref_d ) capacitor c=0.00130656f \
 //x=6.2 //y=5.2 //x2=7.51 //y2=5.2
cc_43 ( N_VDD_M23_noxref_d N_noxref_3_M24_noxref_d ) capacitor c=0.0664752f \
 //x=7.07 //y=5.2 //x2=7.51 //y2=5.2
cc_44 ( N_VDD_M25_noxref_d N_noxref_3_M24_noxref_d ) capacitor c=0.0664752f \
 //x=7.95 //y=5.2 //x2=7.51 //y2=5.2
cc_45 ( N_VDD_c_9_p N_noxref_3_M26_noxref_d ) capacitor c=0.00275309f \
 //x=25.965 //y=7.58 //x2=8.39 //y2=5.2
cc_46 ( N_VDD_c_17_p N_noxref_3_M26_noxref_d ) capacitor c=0.0140577f //x=8.89 \
 //y=7.585 //x2=8.39 //y2=5.2
cc_47 ( N_VDD_c_4_p N_noxref_3_M26_noxref_d ) capacitor c=0.00939849f \
 //x=10.055 //y=7.585 //x2=8.39 //y2=5.2
cc_48 ( N_VDD_M25_noxref_d N_noxref_3_M26_noxref_d ) capacitor c=0.0664752f \
 //x=7.95 //y=5.2 //x2=8.39 //y2=5.2
cc_49 ( N_VDD_M27_noxref_d N_noxref_3_M26_noxref_d ) capacitor c=0.0664752f \
 //x=8.83 //y=5.2 //x2=8.39 //y2=5.2
cc_50 ( N_VDD_M28_noxref_s N_noxref_3_M26_noxref_d ) capacitor c=4.52683e-19 \
 //x=10.71 //y=5.2 //x2=8.39 //y2=5.2
cc_51 ( N_VDD_c_9_p N_noxref_4_c_901_n ) capacitor c=0.00453712f //x=25.965 \
 //y=7.58 //x2=12.08 //y2=5.38
cc_52 ( N_VDD_c_25_p N_noxref_4_c_901_n ) capacitor c=4.48891e-19 //x=11.64 \
 //y=7.585 //x2=12.08 //y2=5.38
cc_53 ( N_VDD_c_53_p N_noxref_4_c_901_n ) capacitor c=4.48891e-19 //x=12.52 \
 //y=7.585 //x2=12.08 //y2=5.38
cc_54 ( N_VDD_M29_noxref_d N_noxref_4_c_901_n ) capacitor c=0.012455f \
 //x=11.58 //y=5.2 //x2=12.08 //y2=5.38
cc_55 ( N_VDD_c_4_p N_noxref_4_c_905_n ) capacitor c=0.00985474f //x=10.055 \
 //y=7.585 //x2=11.37 //y2=5.38
cc_56 ( N_VDD_M28_noxref_s N_noxref_4_c_905_n ) capacitor c=0.087833f \
 //x=10.71 //y=5.2 //x2=11.37 //y2=5.38
cc_57 ( N_VDD_c_9_p N_noxref_4_c_907_n ) capacitor c=0.00301812f //x=25.965 \
 //y=7.58 //x2=12.56 //y2=5.38
cc_58 ( N_VDD_c_53_p N_noxref_4_c_907_n ) capacitor c=7.72907e-19 //x=12.52 \
 //y=7.585 //x2=12.56 //y2=5.38
cc_59 ( N_VDD_M31_noxref_d N_noxref_4_c_907_n ) capacitor c=0.0158576f \
 //x=12.46 //y=5.2 //x2=12.56 //y2=5.38
cc_60 ( N_VDD_c_4_p N_noxref_4_c_910_n ) capacitor c=0.00151618f //x=10.055 \
 //y=7.585 //x2=12.645 //y2=3.51
cc_61 ( N_VDD_c_5_p N_noxref_4_c_910_n ) capacitor c=0.0428942f //x=13.385 \
 //y=7.585 //x2=12.645 //y2=3.51
cc_62 ( N_VDD_c_9_p N_noxref_4_c_912_n ) capacitor c=9.09811e-19 //x=25.965 \
 //y=7.58 //x2=14.495 //y2=2.26
cc_63 ( N_VDD_c_5_p N_noxref_4_c_912_n ) capacitor c=0.0133749f //x=13.385 \
 //y=7.585 //x2=14.495 //y2=2.26
cc_64 ( N_VDD_M32_noxref_s N_noxref_4_c_912_n ) capacitor c=0.0125365f \
 //x=14.34 //y=5.2 //x2=14.495 //y2=2.26
cc_65 ( N_VDD_c_65_p N_noxref_4_M32_noxref_g ) capacitor c=0.00755614f \
 //x=15.27 //y=7.585 //x2=14.695 //y2=6.2
cc_66 ( N_VDD_M32_noxref_s N_noxref_4_M32_noxref_g ) capacitor c=0.0477201f \
 //x=14.34 //y=5.2 //x2=14.695 //y2=6.2
cc_67 ( N_VDD_c_65_p N_noxref_4_M33_noxref_g ) capacitor c=0.00679791f \
 //x=15.27 //y=7.585 //x2=15.135 //y2=6.2
cc_68 ( N_VDD_M33_noxref_d N_noxref_4_M33_noxref_g ) capacitor c=0.015318f \
 //x=15.21 //y=5.2 //x2=15.135 //y2=6.2
cc_69 ( N_VDD_c_5_p N_noxref_4_c_919_n ) capacitor c=0.00757682f //x=13.385 \
 //y=7.585 //x2=14.77 //y2=4.97
cc_70 ( N_VDD_M32_noxref_s N_noxref_4_c_919_n ) capacitor c=0.00444941f \
 //x=14.34 //y=5.2 //x2=14.77 //y2=4.97
cc_71 ( N_VDD_c_9_p N_noxref_4_M28_noxref_d ) capacitor c=0.00275298f \
 //x=25.965 //y=7.58 //x2=11.14 //y2=5.2
cc_72 ( N_VDD_c_25_p N_noxref_4_M28_noxref_d ) capacitor c=0.0140544f \
 //x=11.64 //y=7.585 //x2=11.14 //y2=5.2
cc_73 ( N_VDD_c_5_p N_noxref_4_M28_noxref_d ) capacitor c=6.94454e-19 \
 //x=13.385 //y=7.585 //x2=11.14 //y2=5.2
cc_74 ( N_VDD_M29_noxref_d N_noxref_4_M28_noxref_d ) capacitor c=0.0664752f \
 //x=11.58 //y=5.2 //x2=11.14 //y2=5.2
cc_75 ( N_VDD_c_9_p N_noxref_4_M30_noxref_d ) capacitor c=0.00275298f \
 //x=25.965 //y=7.58 //x2=12.02 //y2=5.2
cc_76 ( N_VDD_c_53_p N_noxref_4_M30_noxref_d ) capacitor c=0.0140544f \
 //x=12.52 //y=7.585 //x2=12.02 //y2=5.2
cc_77 ( N_VDD_c_5_p N_noxref_4_M30_noxref_d ) capacitor c=0.0120541f \
 //x=13.385 //y=7.585 //x2=12.02 //y2=5.2
cc_78 ( N_VDD_M28_noxref_s N_noxref_4_M30_noxref_d ) capacitor c=0.00111971f \
 //x=10.71 //y=5.2 //x2=12.02 //y2=5.2
cc_79 ( N_VDD_M29_noxref_d N_noxref_4_M30_noxref_d ) capacitor c=0.0664752f \
 //x=11.58 //y=5.2 //x2=12.02 //y2=5.2
cc_80 ( N_VDD_M31_noxref_d N_noxref_4_M30_noxref_d ) capacitor c=0.0664752f \
 //x=12.46 //y=5.2 //x2=12.02 //y2=5.2
cc_81 ( N_VDD_M32_noxref_s N_noxref_4_M30_noxref_d ) capacitor c=3.73257e-19 \
 //x=14.34 //y=5.2 //x2=12.02 //y2=5.2
cc_82 ( N_VDD_c_9_p N_CLK_c_1050_n ) capacitor c=0.0969802f //x=25.965 \
 //y=7.58 //x2=15.49 //y2=4.62
cc_83 ( N_VDD_c_83_p N_CLK_c_1050_n ) capacitor c=0.00258661f //x=5.075 \
 //y=7.585 //x2=15.49 //y2=4.62
cc_84 ( N_VDD_c_84_p N_CLK_c_1050_n ) capacitor c=0.00329211f //x=6.25 \
 //y=7.585 //x2=15.49 //y2=4.62
cc_85 ( N_VDD_c_10_p N_CLK_c_1050_n ) capacitor c=0.00135946f //x=7.13 \
 //y=7.585 //x2=15.49 //y2=4.62
cc_86 ( N_VDD_c_21_p N_CLK_c_1050_n ) capacitor c=0.00258661f //x=9.885 \
 //y=7.585 //x2=15.49 //y2=4.62
cc_87 ( N_VDD_c_87_p N_CLK_c_1050_n ) capacitor c=0.0020986f //x=10.76 \
 //y=7.585 //x2=15.49 //y2=4.62
cc_88 ( N_VDD_c_25_p N_CLK_c_1050_n ) capacitor c=7.81825e-19 //x=11.64 \
 //y=7.585 //x2=15.49 //y2=4.62
cc_89 ( N_VDD_c_89_p N_CLK_c_1050_n ) capacitor c=0.00205644f //x=13.215 \
 //y=7.585 //x2=15.49 //y2=4.62
cc_90 ( N_VDD_c_90_p N_CLK_c_1050_n ) capacitor c=0.00329211f //x=14.39 \
 //y=7.585 //x2=15.49 //y2=4.62
cc_91 ( N_VDD_c_65_p N_CLK_c_1050_n ) capacitor c=0.00135946f //x=15.27 \
 //y=7.585 //x2=15.49 //y2=4.62
cc_92 ( N_VDD_c_3_p N_CLK_c_1050_n ) capacitor c=0.0389825f //x=5.245 \
 //y=7.585 //x2=15.49 //y2=4.62
cc_93 ( N_VDD_c_4_p N_CLK_c_1050_n ) capacitor c=0.0389825f //x=10.055 \
 //y=7.585 //x2=15.49 //y2=4.62
cc_94 ( N_VDD_c_5_p N_CLK_c_1050_n ) capacitor c=0.0389825f //x=13.385 \
 //y=7.585 //x2=15.49 //y2=4.62
cc_95 ( N_VDD_M22_noxref_s N_CLK_c_1050_n ) capacitor c=0.00179503f //x=6.2 \
 //y=5.2 //x2=15.49 //y2=4.62
cc_96 ( N_VDD_M28_noxref_s N_CLK_c_1050_n ) capacitor c=0.00541087f //x=10.71 \
 //y=5.2 //x2=15.49 //y2=4.62
cc_97 ( N_VDD_M31_noxref_d N_CLK_c_1050_n ) capacitor c=6.71664e-19 //x=12.46 \
 //y=5.2 //x2=15.49 //y2=4.62
cc_98 ( N_VDD_M32_noxref_s N_CLK_c_1050_n ) capacitor c=0.00179503f //x=14.34 \
 //y=5.2 //x2=15.49 //y2=4.62
cc_99 ( N_VDD_c_9_p N_CLK_c_1067_n ) capacitor c=0.00146219f //x=25.965 \
 //y=7.58 //x2=2.77 //y2=4.62
cc_100 ( N_VDD_c_9_p N_CLK_c_1068_n ) capacitor c=2.03193e-19 //x=25.965 \
 //y=7.58 //x2=2.655 //y2=4.88
cc_101 ( N_VDD_c_9_p N_CLK_c_1069_n ) capacitor c=2.03193e-19 //x=25.965 \
 //y=7.58 //x2=15.605 //y2=4.88
cc_102 ( N_VDD_c_1_p N_CLK_c_1070_n ) capacitor c=9.53425e-19 //x=1.175 \
 //y=7.58 //x2=2.682 //y2=4.535
cc_103 ( N_VDD_c_5_p N_CLK_c_1071_n ) capacitor c=6.15921e-19 //x=13.385 \
 //y=7.585 //x2=15.632 //y2=4.535
cc_104 ( N_VDD_c_104_p N_CLK_M18_noxref_g ) capacitor c=0.00680845f //x=3.2 \
 //y=7.585 //x2=2.625 //y2=6.2
cc_105 ( N_VDD_M17_noxref_d N_CLK_M18_noxref_g ) capacitor c=0.015318f \
 //x=2.26 //y=5.2 //x2=2.625 //y2=6.2
cc_106 ( N_VDD_c_104_p N_CLK_M19_noxref_g ) capacitor c=0.00679791f //x=3.2 \
 //y=7.585 //x2=3.065 //y2=6.2
cc_107 ( N_VDD_M19_noxref_d N_CLK_M19_noxref_g ) capacitor c=0.015318f \
 //x=3.14 //y=5.2 //x2=3.065 //y2=6.2
cc_108 ( N_VDD_c_108_p N_CLK_M34_noxref_g ) capacitor c=0.00680845f //x=16.15 \
 //y=7.585 //x2=15.575 //y2=6.2
cc_109 ( N_VDD_M33_noxref_d N_CLK_M34_noxref_g ) capacitor c=0.015318f \
 //x=15.21 //y=5.2 //x2=15.575 //y2=6.2
cc_110 ( N_VDD_c_108_p N_CLK_M35_noxref_g ) capacitor c=0.00679791f //x=16.15 \
 //y=7.585 //x2=16.015 //y2=6.2
cc_111 ( N_VDD_M35_noxref_d N_CLK_M35_noxref_g ) capacitor c=0.015318f \
 //x=16.09 //y=5.2 //x2=16.015 //y2=6.2
cc_112 ( N_VDD_c_9_p N_noxref_6_c_1302_n ) capacitor c=0.00449361f //x=25.965 \
 //y=7.58 //x2=2.76 //y2=5.335
cc_113 ( N_VDD_c_113_p N_noxref_6_c_1302_n ) capacitor c=4.32713e-19 //x=2.32 \
 //y=7.585 //x2=2.76 //y2=5.335
cc_114 ( N_VDD_c_104_p N_noxref_6_c_1302_n ) capacitor c=4.3239e-19 //x=3.2 \
 //y=7.585 //x2=2.76 //y2=5.335
cc_115 ( N_VDD_M17_noxref_d N_noxref_6_c_1302_n ) capacitor c=0.0115154f \
 //x=2.26 //y=5.2 //x2=2.76 //y2=5.335
cc_116 ( N_VDD_c_1_p N_noxref_6_c_1306_n ) capacitor c=0.00880189f //x=1.175 \
 //y=7.58 //x2=2.05 //y2=5.335
cc_117 ( N_VDD_M16_noxref_s N_noxref_6_c_1306_n ) capacitor c=0.0831083f \
 //x=1.39 //y=5.2 //x2=2.05 //y2=5.335
cc_118 ( N_VDD_c_9_p N_noxref_6_c_1308_n ) capacitor c=0.00442256f //x=25.965 \
 //y=7.58 //x2=3.64 //y2=5.335
cc_119 ( N_VDD_c_104_p N_noxref_6_c_1308_n ) capacitor c=4.32416e-19 //x=3.2 \
 //y=7.585 //x2=3.64 //y2=5.335
cc_120 ( N_VDD_c_27_p N_noxref_6_c_1308_n ) capacitor c=4.32416e-19 //x=4.08 \
 //y=7.585 //x2=3.64 //y2=5.335
cc_121 ( N_VDD_M19_noxref_d N_noxref_6_c_1308_n ) capacitor c=0.0112992f \
 //x=3.14 //y=5.2 //x2=3.64 //y2=5.335
cc_122 ( N_VDD_c_9_p N_noxref_6_c_1312_n ) capacitor c=0.00434594f //x=25.965 \
 //y=7.58 //x2=4.42 //y2=5.335
cc_123 ( N_VDD_c_27_p N_noxref_6_c_1312_n ) capacitor c=7.47443e-19 //x=4.08 \
 //y=7.585 //x2=4.42 //y2=5.335
cc_124 ( N_VDD_c_83_p N_noxref_6_c_1312_n ) capacitor c=0.00199034f //x=5.075 \
 //y=7.585 //x2=4.42 //y2=5.335
cc_125 ( N_VDD_M21_noxref_d N_noxref_6_c_1312_n ) capacitor c=0.0112992f \
 //x=4.02 //y=5.2 //x2=4.42 //y2=5.335
cc_126 ( N_VDD_c_3_p N_noxref_6_c_1316_n ) capacitor c=0.0427116f //x=5.245 \
 //y=7.585 //x2=4.505 //y2=3.88
cc_127 ( N_VDD_c_9_p N_noxref_6_c_1317_n ) capacitor c=9.09811e-19 //x=25.965 \
 //y=7.58 //x2=6.355 //y2=2.26
cc_128 ( N_VDD_c_3_p N_noxref_6_c_1317_n ) capacitor c=0.0134711f //x=5.245 \
 //y=7.585 //x2=6.355 //y2=2.26
cc_129 ( N_VDD_M22_noxref_s N_noxref_6_c_1317_n ) capacitor c=0.0120369f \
 //x=6.2 //y=5.2 //x2=6.355 //y2=2.26
cc_130 ( N_VDD_c_9_p N_noxref_6_c_1320_n ) capacitor c=9.22979e-19 //x=25.965 \
 //y=7.58 //x2=19.305 //y2=2.26
cc_131 ( N_VDD_c_6_p N_noxref_6_c_1320_n ) capacitor c=0.0160182f //x=18.195 \
 //y=7.585 //x2=19.305 //y2=2.26
cc_132 ( N_VDD_M38_noxref_s N_noxref_6_c_1320_n ) capacitor c=0.0123185f \
 //x=19.15 //y=5.2 //x2=19.305 //y2=2.26
cc_133 ( N_VDD_c_10_p N_noxref_6_M22_noxref_g ) capacitor c=0.00755614f \
 //x=7.13 //y=7.585 //x2=6.555 //y2=6.2
cc_134 ( N_VDD_M22_noxref_s N_noxref_6_M22_noxref_g ) capacitor c=0.0477201f \
 //x=6.2 //y=5.2 //x2=6.555 //y2=6.2
cc_135 ( N_VDD_c_10_p N_noxref_6_M23_noxref_g ) capacitor c=0.00679791f \
 //x=7.13 //y=7.585 //x2=6.995 //y2=6.2
cc_136 ( N_VDD_M23_noxref_d N_noxref_6_M23_noxref_g ) capacitor c=0.015318f \
 //x=7.07 //y=5.2 //x2=6.995 //y2=6.2
cc_137 ( N_VDD_c_137_p N_noxref_6_M38_noxref_g ) capacitor c=0.00755614f \
 //x=20.08 //y=7.585 //x2=19.505 //y2=6.2
cc_138 ( N_VDD_M38_noxref_s N_noxref_6_M38_noxref_g ) capacitor c=0.0477201f \
 //x=19.15 //y=5.2 //x2=19.505 //y2=6.2
cc_139 ( N_VDD_c_137_p N_noxref_6_M39_noxref_g ) capacitor c=0.00679791f \
 //x=20.08 //y=7.585 //x2=19.945 //y2=6.2
cc_140 ( N_VDD_M39_noxref_d N_noxref_6_M39_noxref_g ) capacitor c=0.015318f \
 //x=20.02 //y=5.2 //x2=19.945 //y2=6.2
cc_141 ( N_VDD_c_3_p N_noxref_6_c_1331_n ) capacitor c=0.00757682f //x=5.245 \
 //y=7.585 //x2=6.63 //y2=4.97
cc_142 ( N_VDD_M22_noxref_s N_noxref_6_c_1331_n ) capacitor c=0.00444941f \
 //x=6.2 //y=5.2 //x2=6.63 //y2=4.97
cc_143 ( N_VDD_c_6_p N_noxref_6_c_1333_n ) capacitor c=0.00757682f //x=18.195 \
 //y=7.585 //x2=19.58 //y2=4.97
cc_144 ( N_VDD_M38_noxref_s N_noxref_6_c_1333_n ) capacitor c=0.0044516f \
 //x=19.15 //y=5.2 //x2=19.58 //y2=4.97
cc_145 ( N_VDD_c_9_p N_noxref_6_M16_noxref_d ) capacitor c=0.00285148f \
 //x=25.965 //y=7.58 //x2=1.82 //y2=5.2
cc_146 ( N_VDD_c_113_p N_noxref_6_M16_noxref_d ) capacitor c=0.0141242f \
 //x=2.32 //y=7.585 //x2=1.82 //y2=5.2
cc_147 ( N_VDD_M17_noxref_d N_noxref_6_M16_noxref_d ) capacitor c=0.0664752f \
 //x=2.26 //y=5.2 //x2=1.82 //y2=5.2
cc_148 ( N_VDD_c_9_p N_noxref_6_M18_noxref_d ) capacitor c=0.0027526f \
 //x=25.965 //y=7.58 //x2=2.7 //y2=5.2
cc_149 ( N_VDD_c_104_p N_noxref_6_M18_noxref_d ) capacitor c=0.0140573f \
 //x=3.2 //y=7.585 //x2=2.7 //y2=5.2
cc_150 ( N_VDD_c_3_p N_noxref_6_M18_noxref_d ) capacitor c=4.9285e-19 \
 //x=5.245 //y=7.585 //x2=2.7 //y2=5.2
cc_151 ( N_VDD_M16_noxref_s N_noxref_6_M18_noxref_d ) capacitor c=0.00130656f \
 //x=1.39 //y=5.2 //x2=2.7 //y2=5.2
cc_152 ( N_VDD_M17_noxref_d N_noxref_6_M18_noxref_d ) capacitor c=0.0664752f \
 //x=2.26 //y=5.2 //x2=2.7 //y2=5.2
cc_153 ( N_VDD_M19_noxref_d N_noxref_6_M18_noxref_d ) capacitor c=0.0664752f \
 //x=3.14 //y=5.2 //x2=2.7 //y2=5.2
cc_154 ( N_VDD_c_9_p N_noxref_6_M20_noxref_d ) capacitor c=0.00275309f \
 //x=25.965 //y=7.58 //x2=3.58 //y2=5.2
cc_155 ( N_VDD_c_27_p N_noxref_6_M20_noxref_d ) capacitor c=0.01376f //x=4.08 \
 //y=7.585 //x2=3.58 //y2=5.2
cc_156 ( N_VDD_c_3_p N_noxref_6_M20_noxref_d ) capacitor c=0.00939849f \
 //x=5.245 //y=7.585 //x2=3.58 //y2=5.2
cc_157 ( N_VDD_M19_noxref_d N_noxref_6_M20_noxref_d ) capacitor c=0.0664752f \
 //x=3.14 //y=5.2 //x2=3.58 //y2=5.2
cc_158 ( N_VDD_M21_noxref_d N_noxref_6_M20_noxref_d ) capacitor c=0.0664752f \
 //x=4.02 //y=5.2 //x2=3.58 //y2=5.2
cc_159 ( N_VDD_M22_noxref_s N_noxref_6_M20_noxref_d ) capacitor c=3.57641e-19 \
 //x=6.2 //y=5.2 //x2=3.58 //y2=5.2
cc_160 ( N_VDD_c_4_p N_RN_c_1557_n ) capacitor c=6.09414e-19 //x=10.055 \
 //y=7.585 //x2=8.575 //y2=4.88
cc_161 ( N_VDD_c_6_p N_RN_c_1558_n ) capacitor c=0.00120865f //x=18.195 \
 //y=7.585 //x2=16.715 //y2=4.88
cc_162 ( N_VDD_c_9_p N_RN_c_1559_n ) capacitor c=2.05728e-19 //x=25.965 \
 //y=7.58 //x2=20.415 //y2=4.88
cc_163 ( N_VDD_c_6_p N_RN_c_1560_n ) capacitor c=7.31405e-19 //x=18.195 \
 //y=7.585 //x2=20.442 //y2=4.535
cc_164 ( N_VDD_c_17_p N_RN_M26_noxref_g ) capacitor c=0.00679791f //x=8.89 \
 //y=7.585 //x2=8.315 //y2=6.2
cc_165 ( N_VDD_M25_noxref_d N_RN_M26_noxref_g ) capacitor c=0.015318f //x=7.95 \
 //y=5.2 //x2=8.315 //y2=6.2
cc_166 ( N_VDD_c_17_p N_RN_M27_noxref_g ) capacitor c=0.00680002f //x=8.89 \
 //y=7.585 //x2=8.755 //y2=6.2
cc_167 ( N_VDD_M27_noxref_d N_RN_M27_noxref_g ) capacitor c=0.0394719f \
 //x=8.83 //y=5.2 //x2=8.755 //y2=6.2
cc_168 ( N_VDD_c_168_p N_RN_M36_noxref_g ) capacitor c=0.00679791f //x=17.03 \
 //y=7.585 //x2=16.455 //y2=6.2
cc_169 ( N_VDD_M35_noxref_d N_RN_M36_noxref_g ) capacitor c=0.015318f \
 //x=16.09 //y=5.2 //x2=16.455 //y2=6.2
cc_170 ( N_VDD_c_168_p N_RN_M37_noxref_g ) capacitor c=0.00680002f //x=17.03 \
 //y=7.585 //x2=16.895 //y2=6.2
cc_171 ( N_VDD_M37_noxref_d N_RN_M37_noxref_g ) capacitor c=0.0394719f \
 //x=16.97 //y=5.2 //x2=16.895 //y2=6.2
cc_172 ( N_VDD_c_172_p N_RN_M40_noxref_g ) capacitor c=0.00680845f //x=20.96 \
 //y=7.585 //x2=20.385 //y2=6.2
cc_173 ( N_VDD_M39_noxref_d N_RN_M40_noxref_g ) capacitor c=0.015318f \
 //x=20.02 //y=5.2 //x2=20.385 //y2=6.2
cc_174 ( N_VDD_c_172_p N_RN_M41_noxref_g ) capacitor c=0.00679791f //x=20.96 \
 //y=7.585 //x2=20.825 //y2=6.2
cc_175 ( N_VDD_M41_noxref_d N_RN_M41_noxref_g ) capacitor c=0.015318f //x=20.9 \
 //y=5.2 //x2=20.825 //y2=6.2
cc_176 ( N_VDD_c_7_p Q ) capacitor c=2.6258e-19 //x=23.005 //y=7.585 \
 //x2=21.58 //y2=4.62
cc_177 ( N_VDD_c_9_p Q ) capacitor c=0.015195f //x=25.965 //y=7.58 //x2=25.65 \
 //y2=3.88
cc_178 ( N_VDD_M47_noxref_d Q ) capacitor c=4.05367e-19 //x=25.41 //y=5.2 \
 //x2=25.65 //y2=3.88
cc_179 ( N_VDD_c_2_p Q ) capacitor c=0.00285659f //x=25.965 //y=7.58 \
 //x2=25.65 //y2=4.25
cc_180 ( N_VDD_c_2_p Q ) capacitor c=0.00946859f //x=25.965 //y=7.58 \
 //x2=25.65 //y2=4.62
cc_181 ( N_VDD_c_9_p Q ) capacitor c=2.28095e-19 //x=25.965 //y=7.58 \
 //x2=25.65 //y2=4.99
cc_182 ( N_VDD_c_2_p Q ) capacitor c=0.0093005f //x=25.965 //y=7.58 //x2=25.65 \
 //y2=4.99
cc_183 ( N_VDD_c_7_p Q ) capacitor c=0.00151558f //x=23.005 //y=7.585 \
 //x2=25.65 //y2=4.99
cc_184 ( N_VDD_c_7_p N_Q_c_1886_n ) capacitor c=2.85085e-19 //x=23.005 \
 //y=7.585 //x2=21.525 //y2=4.88
cc_185 ( N_VDD_c_9_p N_Q_c_1887_n ) capacitor c=0.00459998f //x=25.965 \
 //y=7.58 //x2=25.03 //y2=5.38
cc_186 ( N_VDD_c_186_p N_Q_c_1887_n ) capacitor c=4.49205e-19 //x=24.59 \
 //y=7.585 //x2=25.03 //y2=5.38
cc_187 ( N_VDD_c_187_p N_Q_c_1887_n ) capacitor c=4.49193e-19 //x=25.47 \
 //y=7.585 //x2=25.03 //y2=5.38
cc_188 ( N_VDD_M45_noxref_d N_Q_c_1887_n ) capacitor c=0.0126907f //x=24.53 \
 //y=5.2 //x2=25.03 //y2=5.38
cc_189 ( N_VDD_c_7_p N_Q_c_1891_n ) capacitor c=0.00985474f //x=23.005 \
 //y=7.585 //x2=24.32 //y2=5.38
cc_190 ( N_VDD_M44_noxref_s N_Q_c_1891_n ) capacitor c=0.087833f //x=23.66 \
 //y=5.2 //x2=24.32 //y2=5.38
cc_191 ( N_VDD_c_9_p N_Q_c_1893_n ) capacitor c=0.00312108f //x=25.965 \
 //y=7.58 //x2=25.51 //y2=5.38
cc_192 ( N_VDD_c_187_p N_Q_c_1893_n ) capacitor c=7.22416e-19 //x=25.47 \
 //y=7.585 //x2=25.51 //y2=5.38
cc_193 ( N_VDD_M47_noxref_d N_Q_c_1893_n ) capacitor c=0.0163426f //x=25.41 \
 //y=5.2 //x2=25.51 //y2=5.38
cc_194 ( N_VDD_c_2_p N_Q_c_1896_n ) capacitor c=0.0154944f //x=25.965 //y=7.58 \
 //x2=25.595 //y2=5.295
cc_195 ( N_VDD_c_7_p N_Q_c_1897_n ) capacitor c=3.23102e-19 //x=23.005 \
 //y=7.585 //x2=21.552 //y2=4.535
cc_196 ( N_VDD_c_2_p N_Q_c_1898_n ) capacitor c=0.00770228f //x=25.965 \
 //y=7.58 //x2=25.622 //y2=4.535
cc_197 ( N_VDD_c_2_p N_Q_c_1899_n ) capacitor c=0.00775987f //x=25.965 \
 //y=7.58 //x2=25.622 //y2=4.905
cc_198 ( N_VDD_c_198_p N_Q_M42_noxref_g ) capacitor c=0.00679791f //x=21.84 \
 //y=7.585 //x2=21.265 //y2=6.2
cc_199 ( N_VDD_M41_noxref_d N_Q_M42_noxref_g ) capacitor c=0.015318f //x=20.9 \
 //y=5.2 //x2=21.265 //y2=6.2
cc_200 ( N_VDD_c_198_p N_Q_M43_noxref_g ) capacitor c=0.00680002f //x=21.84 \
 //y=7.585 //x2=21.705 //y2=6.2
cc_201 ( N_VDD_M43_noxref_d N_Q_M43_noxref_g ) capacitor c=0.0394719f \
 //x=21.78 //y=5.2 //x2=21.705 //y2=6.2
cc_202 ( N_VDD_c_9_p N_Q_M44_noxref_d ) capacitor c=0.00285139f //x=25.965 \
 //y=7.58 //x2=24.09 //y2=5.2
cc_203 ( N_VDD_c_186_p N_Q_M44_noxref_d ) capacitor c=0.0141209f //x=24.59 \
 //y=7.585 //x2=24.09 //y2=5.2
cc_204 ( N_VDD_c_2_p N_Q_M44_noxref_d ) capacitor c=6.94454e-19 //x=25.965 \
 //y=7.58 //x2=24.09 //y2=5.2
cc_205 ( N_VDD_M45_noxref_d N_Q_M44_noxref_d ) capacitor c=0.0664752f \
 //x=24.53 //y=5.2 //x2=24.09 //y2=5.2
cc_206 ( N_VDD_c_9_p N_Q_M46_noxref_d ) capacitor c=0.00294258f //x=25.965 \
 //y=7.58 //x2=24.97 //y2=5.2
cc_207 ( N_VDD_c_187_p N_Q_M46_noxref_d ) capacitor c=0.0138783f //x=25.47 \
 //y=7.585 //x2=24.97 //y2=5.2
cc_208 ( N_VDD_c_2_p N_Q_M46_noxref_d ) capacitor c=0.0123189f //x=25.965 \
 //y=7.58 //x2=24.97 //y2=5.2
cc_209 ( N_VDD_M44_noxref_s N_Q_M46_noxref_d ) capacitor c=0.00111971f \
 //x=23.66 //y=5.2 //x2=24.97 //y2=5.2
cc_210 ( N_VDD_M45_noxref_d N_Q_M46_noxref_d ) capacitor c=0.0664752f \
 //x=24.53 //y=5.2 //x2=24.97 //y2=5.2
cc_211 ( N_VDD_M47_noxref_d N_Q_M46_noxref_d ) capacitor c=0.0664752f \
 //x=25.41 //y=5.2 //x2=24.97 //y2=5.2
cc_212 ( N_VDD_c_9_p N_noxref_9_c_2066_n ) capacitor c=0.00451543f //x=25.965 \
 //y=7.58 //x2=20.52 //y2=5.335
cc_213 ( N_VDD_c_137_p N_noxref_9_c_2066_n ) capacitor c=4.32713e-19 //x=20.08 \
 //y=7.585 //x2=20.52 //y2=5.335
cc_214 ( N_VDD_c_172_p N_noxref_9_c_2066_n ) capacitor c=4.32713e-19 //x=20.96 \
 //y=7.585 //x2=20.52 //y2=5.335
cc_215 ( N_VDD_M39_noxref_d N_noxref_9_c_2066_n ) capacitor c=0.0115154f \
 //x=20.02 //y=5.2 //x2=20.52 //y2=5.335
cc_216 ( N_VDD_c_6_p N_noxref_9_c_2070_n ) capacitor c=0.00863585f //x=18.195 \
 //y=7.585 //x2=19.81 //y2=5.335
cc_217 ( N_VDD_M38_noxref_s N_noxref_9_c_2070_n ) capacitor c=0.0831083f \
 //x=19.15 //y=5.2 //x2=19.81 //y2=5.335
cc_218 ( N_VDD_c_9_p N_noxref_9_c_2072_n ) capacitor c=0.00449039f //x=25.965 \
 //y=7.58 //x2=21.4 //y2=5.335
cc_219 ( N_VDD_c_172_p N_noxref_9_c_2072_n ) capacitor c=4.32713e-19 //x=20.96 \
 //y=7.585 //x2=21.4 //y2=5.335
cc_220 ( N_VDD_c_198_p N_noxref_9_c_2072_n ) capacitor c=4.32713e-19 //x=21.84 \
 //y=7.585 //x2=21.4 //y2=5.335
cc_221 ( N_VDD_M41_noxref_d N_noxref_9_c_2072_n ) capacitor c=0.0115154f \
 //x=20.9 //y=5.2 //x2=21.4 //y2=5.335
cc_222 ( N_VDD_c_9_p N_noxref_9_c_2076_n ) capacitor c=0.00443036f //x=25.965 \
 //y=7.58 //x2=22.18 //y2=5.335
cc_223 ( N_VDD_c_198_p N_noxref_9_c_2076_n ) capacitor c=7.48482e-19 //x=21.84 \
 //y=7.585 //x2=22.18 //y2=5.335
cc_224 ( N_VDD_c_224_p N_noxref_9_c_2076_n ) capacitor c=0.00199449f \
 //x=22.835 //y=7.585 //x2=22.18 //y2=5.335
cc_225 ( N_VDD_M43_noxref_d N_noxref_9_c_2076_n ) capacitor c=0.0115154f \
 //x=21.78 //y=5.2 //x2=22.18 //y2=5.335
cc_226 ( N_VDD_c_7_p N_noxref_9_c_2080_n ) capacitor c=0.0452986f //x=23.005 \
 //y=7.585 //x2=22.265 //y2=3.51
cc_227 ( N_VDD_c_9_p N_noxref_9_M38_noxref_d ) capacitor c=0.00285148f \
 //x=25.965 //y=7.58 //x2=19.58 //y2=5.2
cc_228 ( N_VDD_c_137_p N_noxref_9_M38_noxref_d ) capacitor c=0.0141242f \
 //x=20.08 //y=7.585 //x2=19.58 //y2=5.2
cc_229 ( N_VDD_M39_noxref_d N_noxref_9_M38_noxref_d ) capacitor c=0.0664752f \
 //x=20.02 //y=5.2 //x2=19.58 //y2=5.2
cc_230 ( N_VDD_c_9_p N_noxref_9_M40_noxref_d ) capacitor c=0.00285148f \
 //x=25.965 //y=7.58 //x2=20.46 //y2=5.2
cc_231 ( N_VDD_c_172_p N_noxref_9_M40_noxref_d ) capacitor c=0.0141242f \
 //x=20.96 //y=7.585 //x2=20.46 //y2=5.2
cc_232 ( N_VDD_c_7_p N_noxref_9_M40_noxref_d ) capacitor c=4.9285e-19 \
 //x=23.005 //y=7.585 //x2=20.46 //y2=5.2
cc_233 ( N_VDD_M38_noxref_s N_noxref_9_M40_noxref_d ) capacitor c=0.00130656f \
 //x=19.15 //y=5.2 //x2=20.46 //y2=5.2
cc_234 ( N_VDD_M39_noxref_d N_noxref_9_M40_noxref_d ) capacitor c=0.0664752f \
 //x=20.02 //y=5.2 //x2=20.46 //y2=5.2
cc_235 ( N_VDD_M41_noxref_d N_noxref_9_M40_noxref_d ) capacitor c=0.0664752f \
 //x=20.9 //y=5.2 //x2=20.46 //y2=5.2
cc_236 ( N_VDD_c_9_p N_noxref_9_M42_noxref_d ) capacitor c=0.00285148f \
 //x=25.965 //y=7.58 //x2=21.34 //y2=5.2
cc_237 ( N_VDD_c_198_p N_noxref_9_M42_noxref_d ) capacitor c=0.0138265f \
 //x=21.84 //y=7.585 //x2=21.34 //y2=5.2
cc_238 ( N_VDD_c_7_p N_noxref_9_M42_noxref_d ) capacitor c=0.00939849f \
 //x=23.005 //y=7.585 //x2=21.34 //y2=5.2
cc_239 ( N_VDD_M41_noxref_d N_noxref_9_M42_noxref_d ) capacitor c=0.0664752f \
 //x=20.9 //y=5.2 //x2=21.34 //y2=5.2
cc_240 ( N_VDD_M43_noxref_d N_noxref_9_M42_noxref_d ) capacitor c=0.0664752f \
 //x=21.78 //y=5.2 //x2=21.34 //y2=5.2
cc_241 ( N_VDD_M44_noxref_s N_noxref_9_M42_noxref_d ) capacitor c=4.52683e-19 \
 //x=23.66 //y=5.2 //x2=21.34 //y2=5.2
cc_242 ( N_VDD_c_9_p N_noxref_10_c_2170_n ) capacitor c=0.00126176f //x=25.965 \
 //y=7.58 //x2=24.115 //y2=2.26
cc_243 ( N_VDD_c_186_p N_noxref_10_c_2170_n ) capacitor c=2.88573e-19 \
 //x=24.59 //y=7.585 //x2=24.115 //y2=2.26
cc_244 ( N_VDD_c_7_p N_noxref_10_c_2170_n ) capacitor c=0.0160121f //x=23.005 \
 //y=7.585 //x2=24.115 //y2=2.26
cc_245 ( N_VDD_c_186_p N_noxref_10_M44_noxref_g ) capacitor c=0.00732332f \
 //x=24.59 //y=7.585 //x2=24.015 //y2=6.2
cc_246 ( N_VDD_M44_noxref_s N_noxref_10_M44_noxref_g ) capacitor c=0.054195f \
 //x=23.66 //y=5.2 //x2=24.015 //y2=6.2
cc_247 ( N_VDD_c_186_p N_noxref_10_M45_noxref_g ) capacitor c=0.00677553f \
 //x=24.59 //y=7.585 //x2=24.455 //y2=6.2
cc_248 ( N_VDD_M45_noxref_d N_noxref_10_M45_noxref_g ) capacitor c=0.015318f \
 //x=24.53 //y=5.2 //x2=24.455 //y2=6.2
cc_249 ( N_VDD_c_7_p N_noxref_10_c_2177_n ) capacitor c=0.0154093f //x=23.005 \
 //y=7.585 //x2=24.115 //y2=4.88
cc_250 ( N_VDD_c_9_p N_noxref_11_c_2240_n ) capacitor c=0.0425624f //x=25.965 \
 //y=7.58 //x2=11.79 //y2=4.25
cc_251 ( N_VDD_c_113_p N_noxref_11_c_2240_n ) capacitor c=0.00113267f //x=2.32 \
 //y=7.585 //x2=11.79 //y2=4.25
cc_252 ( N_VDD_c_3_p N_noxref_11_c_2240_n ) capacitor c=0.0140577f //x=5.245 \
 //y=7.585 //x2=11.79 //y2=4.25
cc_253 ( N_VDD_c_4_p N_noxref_11_c_2240_n ) capacitor c=0.0140577f //x=10.055 \
 //y=7.585 //x2=11.79 //y2=4.25
cc_254 ( N_VDD_c_9_p N_noxref_11_c_2244_n ) capacitor c=0.00189506f //x=25.965 \
 //y=7.58 //x2=1.66 //y2=4.25
cc_255 ( N_VDD_c_1_p N_noxref_11_c_2244_n ) capacitor c=0.0017219f //x=1.175 \
 //y=7.58 //x2=1.66 //y2=4.25
cc_256 ( N_VDD_M16_noxref_s N_noxref_11_c_2244_n ) capacitor c=0.00128247f \
 //x=1.39 //y=5.2 //x2=1.66 //y2=4.25
cc_257 ( N_VDD_c_9_p N_noxref_11_c_2247_n ) capacitor c=0.0256512f //x=25.965 \
 //y=7.58 //x2=17.34 //y2=4.25
cc_258 ( N_VDD_c_5_p N_noxref_11_c_2247_n ) capacitor c=0.0140577f //x=13.385 \
 //y=7.585 //x2=17.34 //y2=4.25
cc_259 ( N_VDD_c_9_p N_noxref_11_c_2249_n ) capacitor c=0.0509175f //x=25.965 \
 //y=7.58 //x2=24.74 //y2=4.25
cc_260 ( N_VDD_c_260_p N_noxref_11_c_2249_n ) capacitor c=0.00162234f \
 //x=18.025 //y=7.585 //x2=24.74 //y2=4.25
cc_261 ( N_VDD_c_261_p N_noxref_11_c_2249_n ) capacitor c=0.00271488f //x=19.2 \
 //y=7.585 //x2=24.74 //y2=4.25
cc_262 ( N_VDD_c_137_p N_noxref_11_c_2249_n ) capacitor c=0.00113405f \
 //x=20.08 //y=7.585 //x2=24.74 //y2=4.25
cc_263 ( N_VDD_c_224_p N_noxref_11_c_2249_n ) capacitor c=0.00214169f \
 //x=22.835 //y=7.585 //x2=24.74 //y2=4.25
cc_264 ( N_VDD_c_264_p N_noxref_11_c_2249_n ) capacitor c=0.00172127f \
 //x=23.71 //y=7.585 //x2=24.74 //y2=4.25
cc_265 ( N_VDD_c_186_p N_noxref_11_c_2249_n ) capacitor c=6.61227e-19 \
 //x=24.59 //y=7.585 //x2=24.74 //y2=4.25
cc_266 ( N_VDD_c_6_p N_noxref_11_c_2249_n ) capacitor c=0.0269493f //x=18.195 \
 //y=7.585 //x2=24.74 //y2=4.25
cc_267 ( N_VDD_c_7_p N_noxref_11_c_2249_n ) capacitor c=0.0269493f //x=23.005 \
 //y=7.585 //x2=24.74 //y2=4.25
cc_268 ( N_VDD_M38_noxref_s N_noxref_11_c_2249_n ) capacitor c=0.00122829f \
 //x=19.15 //y=5.2 //x2=24.74 //y2=4.25
cc_269 ( N_VDD_M44_noxref_s N_noxref_11_c_2249_n ) capacitor c=0.00363045f \
 //x=23.66 //y=5.2 //x2=24.74 //y2=4.25
cc_270 ( N_VDD_c_9_p N_noxref_11_c_2260_n ) capacitor c=0.0017556f //x=25.965 \
 //y=7.58 //x2=17.57 //y2=4.25
cc_271 ( N_VDD_c_260_p N_noxref_11_c_2260_n ) capacitor c=5.20321e-19 \
 //x=18.025 //y=7.585 //x2=17.57 //y2=4.25
cc_272 ( N_VDD_c_6_p N_noxref_11_c_2260_n ) capacitor c=0.00104972f //x=18.195 \
 //y=7.585 //x2=17.57 //y2=4.25
cc_273 ( N_VDD_c_9_p N_noxref_11_c_2263_n ) capacitor c=9.2195e-19 //x=25.965 \
 //y=7.58 //x2=1.545 //y2=2.26
cc_274 ( N_VDD_c_1_p N_noxref_11_c_2263_n ) capacitor c=0.0159723f //x=1.175 \
 //y=7.58 //x2=1.545 //y2=2.26
cc_275 ( N_VDD_M16_noxref_s N_noxref_11_c_2263_n ) capacitor c=0.0122994f \
 //x=1.39 //y=5.2 //x2=1.545 //y2=2.26
cc_276 ( N_VDD_c_4_p N_noxref_11_c_2266_n ) capacitor c=4.57806e-19 //x=10.055 \
 //y=7.585 //x2=11.905 //y2=2.26
cc_277 ( N_VDD_c_5_p N_noxref_11_c_2266_n ) capacitor c=3.21957e-19 //x=13.385 \
 //y=7.585 //x2=11.905 //y2=2.26
cc_278 ( N_VDD_c_9_p N_noxref_11_c_2268_n ) capacitor c=0.00444798f //x=25.965 \
 //y=7.58 //x2=15.71 //y2=5.335
cc_279 ( N_VDD_c_65_p N_noxref_11_c_2268_n ) capacitor c=4.32416e-19 //x=15.27 \
 //y=7.585 //x2=15.71 //y2=5.335
cc_280 ( N_VDD_c_108_p N_noxref_11_c_2268_n ) capacitor c=4.3239e-19 //x=16.15 \
 //y=7.585 //x2=15.71 //y2=5.335
cc_281 ( N_VDD_M33_noxref_d N_noxref_11_c_2268_n ) capacitor c=0.0112992f \
 //x=15.21 //y=5.2 //x2=15.71 //y2=5.335
cc_282 ( N_VDD_c_5_p N_noxref_11_c_2272_n ) capacitor c=0.00863585f //x=13.385 \
 //y=7.585 //x2=15 //y2=5.335
cc_283 ( N_VDD_M32_noxref_s N_noxref_11_c_2272_n ) capacitor c=0.0831083f \
 //x=14.34 //y=5.2 //x2=15 //y2=5.335
cc_284 ( N_VDD_c_9_p N_noxref_11_c_2274_n ) capacitor c=0.00449039f //x=25.965 \
 //y=7.58 //x2=16.59 //y2=5.335
cc_285 ( N_VDD_c_108_p N_noxref_11_c_2274_n ) capacitor c=4.32713e-19 \
 //x=16.15 //y=7.585 //x2=16.59 //y2=5.335
cc_286 ( N_VDD_c_168_p N_noxref_11_c_2274_n ) capacitor c=4.32713e-19 \
 //x=17.03 //y=7.585 //x2=16.59 //y2=5.335
cc_287 ( N_VDD_M35_noxref_d N_noxref_11_c_2274_n ) capacitor c=0.0115154f \
 //x=16.09 //y=5.2 //x2=16.59 //y2=5.335
cc_288 ( N_VDD_c_9_p N_noxref_11_c_2278_n ) capacitor c=0.00442884f //x=25.965 \
 //y=7.58 //x2=17.37 //y2=5.335
cc_289 ( N_VDD_c_168_p N_noxref_11_c_2278_n ) capacitor c=7.48482e-19 \
 //x=17.03 //y=7.585 //x2=17.37 //y2=5.335
cc_290 ( N_VDD_c_260_p N_noxref_11_c_2278_n ) capacitor c=0.00199428f \
 //x=18.025 //y=7.585 //x2=17.37 //y2=5.335
cc_291 ( N_VDD_M37_noxref_d N_noxref_11_c_2278_n ) capacitor c=0.0115154f \
 //x=16.97 //y=5.2 //x2=17.37 //y2=5.335
cc_292 ( N_VDD_c_6_p N_noxref_11_c_2282_n ) capacitor c=0.0452317f //x=18.195 \
 //y=7.585 //x2=17.455 //y2=4.25
cc_293 ( N_VDD_c_2_p N_noxref_11_c_2283_n ) capacitor c=6.91186e-19 //x=25.965 \
 //y=7.58 //x2=24.855 //y2=2.26
cc_294 ( N_VDD_c_7_p N_noxref_11_c_2283_n ) capacitor c=6.2696e-19 //x=23.005 \
 //y=7.585 //x2=24.855 //y2=2.26
cc_295 ( N_VDD_c_113_p N_noxref_11_M16_noxref_g ) capacitor c=0.00755614f \
 //x=2.32 //y=7.585 //x2=1.745 //y2=6.2
cc_296 ( N_VDD_M16_noxref_s N_noxref_11_M16_noxref_g ) capacitor c=0.0477201f \
 //x=1.39 //y=5.2 //x2=1.745 //y2=6.2
cc_297 ( N_VDD_c_113_p N_noxref_11_M17_noxref_g ) capacitor c=0.00679791f \
 //x=2.32 //y=7.585 //x2=2.185 //y2=6.2
cc_298 ( N_VDD_M17_noxref_d N_noxref_11_M17_noxref_g ) capacitor c=0.015318f \
 //x=2.26 //y=5.2 //x2=2.185 //y2=6.2
cc_299 ( N_VDD_c_53_p N_noxref_11_M30_noxref_g ) capacitor c=0.00678607f \
 //x=12.52 //y=7.585 //x2=11.945 //y2=6.2
cc_300 ( N_VDD_M29_noxref_d N_noxref_11_M30_noxref_g ) capacitor c=0.015318f \
 //x=11.58 //y=5.2 //x2=11.945 //y2=6.2
cc_301 ( N_VDD_c_53_p N_noxref_11_M31_noxref_g ) capacitor c=0.00677553f \
 //x=12.52 //y=7.585 //x2=12.385 //y2=6.2
cc_302 ( N_VDD_c_5_p N_noxref_11_M31_noxref_g ) capacitor c=0.00928743f \
 //x=13.385 //y=7.585 //x2=12.385 //y2=6.2
cc_303 ( N_VDD_M31_noxref_d N_noxref_11_M31_noxref_g ) capacitor c=0.0430452f \
 //x=12.46 //y=5.2 //x2=12.385 //y2=6.2
cc_304 ( N_VDD_c_187_p N_noxref_11_M46_noxref_g ) capacitor c=0.00678607f \
 //x=25.47 //y=7.585 //x2=24.895 //y2=6.2
cc_305 ( N_VDD_M45_noxref_d N_noxref_11_M46_noxref_g ) capacitor c=0.015318f \
 //x=24.53 //y=5.2 //x2=24.895 //y2=6.2
cc_306 ( N_VDD_c_187_p N_noxref_11_M47_noxref_g ) capacitor c=0.00677553f \
 //x=25.47 //y=7.585 //x2=25.335 //y2=6.2
cc_307 ( N_VDD_c_2_p N_noxref_11_M47_noxref_g ) capacitor c=0.0242878f \
 //x=25.965 //y=7.58 //x2=25.335 //y2=6.2
cc_308 ( N_VDD_M47_noxref_d N_noxref_11_M47_noxref_g ) capacitor c=0.0430452f \
 //x=25.41 //y=5.2 //x2=25.335 //y2=6.2
cc_309 ( N_VDD_c_1_p N_noxref_11_c_2299_n ) capacitor c=0.00757682f //x=1.175 \
 //y=7.58 //x2=1.82 //y2=4.97
cc_310 ( N_VDD_M16_noxref_s N_noxref_11_c_2299_n ) capacitor c=0.00445143f \
 //x=1.39 //y=5.2 //x2=1.82 //y2=4.97
cc_311 ( N_VDD_c_9_p N_noxref_11_M32_noxref_d ) capacitor c=0.00275309f \
 //x=25.965 //y=7.58 //x2=14.77 //y2=5.2
cc_312 ( N_VDD_c_65_p N_noxref_11_M32_noxref_d ) capacitor c=0.0140577f \
 //x=15.27 //y=7.585 //x2=14.77 //y2=5.2
cc_313 ( N_VDD_M33_noxref_d N_noxref_11_M32_noxref_d ) capacitor c=0.0664752f \
 //x=15.21 //y=5.2 //x2=14.77 //y2=5.2
cc_314 ( N_VDD_c_9_p N_noxref_11_M34_noxref_d ) capacitor c=0.00283073f \
 //x=25.965 //y=7.58 //x2=15.65 //y2=5.2
cc_315 ( N_VDD_c_108_p N_noxref_11_M34_noxref_d ) capacitor c=0.0141102f \
 //x=16.15 //y=7.585 //x2=15.65 //y2=5.2
cc_316 ( N_VDD_c_6_p N_noxref_11_M34_noxref_d ) capacitor c=4.9285e-19 \
 //x=18.195 //y=7.585 //x2=15.65 //y2=5.2
cc_317 ( N_VDD_M32_noxref_s N_noxref_11_M34_noxref_d ) capacitor c=0.00130656f \
 //x=14.34 //y=5.2 //x2=15.65 //y2=5.2
cc_318 ( N_VDD_M33_noxref_d N_noxref_11_M34_noxref_d ) capacitor c=0.0664752f \
 //x=15.21 //y=5.2 //x2=15.65 //y2=5.2
cc_319 ( N_VDD_M35_noxref_d N_noxref_11_M34_noxref_d ) capacitor c=0.0664752f \
 //x=16.09 //y=5.2 //x2=15.65 //y2=5.2
cc_320 ( N_VDD_c_9_p N_noxref_11_M36_noxref_d ) capacitor c=0.00285148f \
 //x=25.965 //y=7.58 //x2=16.53 //y2=5.2
cc_321 ( N_VDD_c_168_p N_noxref_11_M36_noxref_d ) capacitor c=0.0138265f \
 //x=17.03 //y=7.585 //x2=16.53 //y2=5.2
cc_322 ( N_VDD_c_6_p N_noxref_11_M36_noxref_d ) capacitor c=0.00939849f \
 //x=18.195 //y=7.585 //x2=16.53 //y2=5.2
cc_323 ( N_VDD_M35_noxref_d N_noxref_11_M36_noxref_d ) capacitor c=0.0664752f \
 //x=16.09 //y=5.2 //x2=16.53 //y2=5.2
cc_324 ( N_VDD_M37_noxref_d N_noxref_11_M36_noxref_d ) capacitor c=0.0664752f \
 //x=16.97 //y=5.2 //x2=16.53 //y2=5.2
cc_325 ( N_VDD_M38_noxref_s N_noxref_11_M36_noxref_d ) capacitor c=3.57641e-19 \
 //x=19.15 //y=5.2 //x2=16.53 //y2=5.2
cc_326 ( N_VDD_c_9_p N_D_c_2749_n ) capacitor c=2.03391e-19 //x=25.965 \
 //y=7.58 //x2=7.465 //y2=4.88
cc_327 ( N_VDD_c_3_p N_D_c_2749_n ) capacitor c=5.89117e-19 //x=5.245 \
 //y=7.585 //x2=7.465 //y2=4.88
cc_328 ( N_VDD_c_11_p N_D_M24_noxref_g ) capacitor c=0.00680845f //x=8.01 \
 //y=7.585 //x2=7.435 //y2=6.2
cc_329 ( N_VDD_M23_noxref_d N_D_M24_noxref_g ) capacitor c=0.015318f //x=7.07 \
 //y=5.2 //x2=7.435 //y2=6.2
cc_330 ( N_VDD_c_11_p N_D_M25_noxref_g ) capacitor c=0.00679791f //x=8.01 \
 //y=7.585 //x2=7.875 //y2=6.2
cc_331 ( N_VDD_M25_noxref_d N_D_M25_noxref_g ) capacitor c=0.015318f //x=7.95 \
 //y=5.2 //x2=7.875 //y2=6.2
cc_332 ( N_GND_c_339_p N_noxref_3_c_675_n ) capacitor c=0.0324965f //x=25.965 \
 //y=0.18 //x2=9.2 //y2=3.51
cc_333 ( N_GND_c_340_p N_noxref_3_c_675_n ) capacitor c=0.00174454f //x=5.075 \
 //y=0.175 //x2=9.2 //y2=3.51
cc_334 ( N_GND_c_341_p N_noxref_3_c_675_n ) capacitor c=0.00152439f //x=6.235 \
 //y=0.175 //x2=9.2 //y2=3.51
cc_335 ( N_GND_c_334_n N_noxref_3_c_675_n ) capacitor c=0.00820859f //x=5.245 \
 //y=0.175 //x2=9.2 //y2=3.51
cc_336 ( N_GND_c_339_p N_noxref_3_c_679_n ) capacitor c=0.00172486f //x=25.965 \
 //y=0.18 //x2=3.88 //y2=3.51
cc_337 ( N_GND_c_335_n N_noxref_3_c_680_n ) capacitor c=0.0058231f //x=10.055 \
 //y=0.175 //x2=11.05 //y2=3.51
cc_338 ( N_GND_c_334_n N_noxref_3_c_632_n ) capacitor c=9.53263e-19 //x=5.245 \
 //y=0.175 //x2=3.765 //y2=2.26
cc_339 ( N_GND_c_335_n N_noxref_3_c_682_n ) capacitor c=0.0432238f //x=10.055 \
 //y=0.175 //x2=9.23 //y2=1.845
cc_340 ( N_GND_c_335_n N_noxref_3_c_648_n ) capacitor c=0.0156446f //x=10.055 \
 //y=0.175 //x2=11.165 //y2=2.26
cc_341 ( N_GND_c_348_p N_noxref_3_c_684_n ) capacitor c=0.00135783f //x=11.15 \
 //y=0.175 //x2=10.97 //y2=1.045
cc_342 ( N_GND_M6_noxref_d N_noxref_3_c_684_n ) capacitor c=0.00220047f \
 //x=11.045 //y=1.045 //x2=10.97 //y2=1.045
cc_343 ( N_GND_M6_noxref_d N_noxref_3_c_686_n ) capacitor c=0.00255985f \
 //x=11.045 //y=1.045 //x2=10.97 //y2=1.39
cc_344 ( N_GND_c_335_n N_noxref_3_c_687_n ) capacitor c=0.00189421f //x=10.055 \
 //y=0.175 //x2=10.97 //y2=1.7
cc_345 ( N_GND_c_335_n N_noxref_3_c_688_n ) capacitor c=0.00992619f //x=10.055 \
 //y=0.175 //x2=10.97 //y2=2.095
cc_346 ( N_GND_M6_noxref_d N_noxref_3_c_689_n ) capacitor c=0.0131374f \
 //x=11.045 //y=1.045 //x2=11.345 //y2=0.89
cc_347 ( N_GND_M6_noxref_d N_noxref_3_c_690_n ) capacitor c=0.00193146f \
 //x=11.045 //y=1.045 //x2=11.345 //y2=1.545
cc_348 ( N_GND_c_355_p N_noxref_3_c_691_n ) capacitor c=0.00131234f //x=13.215 \
 //y=0.175 //x2=11.5 //y2=1.045
cc_349 ( N_GND_M6_noxref_d N_noxref_3_c_691_n ) capacitor c=0.00257848f \
 //x=11.045 //y=1.045 //x2=11.5 //y2=1.045
cc_350 ( N_GND_M6_noxref_d N_noxref_3_c_693_n ) capacitor c=0.00255985f \
 //x=11.045 //y=1.045 //x2=11.5 //y2=1.39
cc_351 ( N_GND_c_335_n N_noxref_3_M5_noxref_d ) capacitor c=0.00591582f \
 //x=10.055 //y=0.175 //x2=8.64 //y2=1.095
cc_352 ( N_GND_c_336_n N_noxref_4_c_932_n ) capacitor c=0.0058231f //x=13.385 \
 //y=0.175 //x2=14.38 //y2=3.51
cc_353 ( N_GND_c_336_n N_noxref_4_c_933_n ) capacitor c=0.0436242f //x=13.385 \
 //y=0.175 //x2=12.56 //y2=1.835
cc_354 ( N_GND_c_335_n N_noxref_4_c_910_n ) capacitor c=9.64732e-19 //x=10.055 \
 //y=0.175 //x2=12.645 //y2=3.51
cc_355 ( N_GND_c_336_n N_noxref_4_c_912_n ) capacitor c=0.0156442f //x=13.385 \
 //y=0.175 //x2=14.495 //y2=2.26
cc_356 ( N_GND_c_363_p N_noxref_4_c_936_n ) capacitor c=0.00133465f //x=14.375 \
 //y=0.175 //x2=14.195 //y2=1.055
cc_357 ( N_GND_M8_noxref_d N_noxref_4_c_936_n ) capacitor c=0.00211996f \
 //x=14.27 //y=1.055 //x2=14.195 //y2=1.055
cc_358 ( N_GND_M8_noxref_d N_noxref_4_c_938_n ) capacitor c=0.00255985f \
 //x=14.27 //y=1.055 //x2=14.195 //y2=1.4
cc_359 ( N_GND_c_336_n N_noxref_4_c_939_n ) capacitor c=0.00195164f //x=13.385 \
 //y=0.175 //x2=14.195 //y2=1.71
cc_360 ( N_GND_c_336_n N_noxref_4_c_940_n ) capacitor c=0.0110952f //x=13.385 \
 //y=0.175 //x2=14.195 //y2=2.095
cc_361 ( N_GND_M8_noxref_d N_noxref_4_c_941_n ) capacitor c=0.0131387f \
 //x=14.27 //y=1.055 //x2=14.57 //y2=0.9
cc_362 ( N_GND_M8_noxref_d N_noxref_4_c_942_n ) capacitor c=0.00193165f \
 //x=14.27 //y=1.055 //x2=14.57 //y2=1.555
cc_363 ( N_GND_c_370_p N_noxref_4_c_943_n ) capacitor c=0.00129623f //x=18.025 \
 //y=0.175 //x2=14.725 //y2=1.055
cc_364 ( N_GND_M8_noxref_d N_noxref_4_c_943_n ) capacitor c=0.00257848f \
 //x=14.27 //y=1.055 //x2=14.725 //y2=1.055
cc_365 ( N_GND_M8_noxref_d N_noxref_4_c_945_n ) capacitor c=0.00255985f \
 //x=14.27 //y=1.055 //x2=14.725 //y2=1.4
cc_366 ( N_GND_c_335_n N_noxref_4_M7_noxref_d ) capacitor c=8.58106e-19 \
 //x=10.055 //y=0.175 //x2=12.015 //y2=1.085
cc_367 ( N_GND_c_336_n N_noxref_4_M7_noxref_d ) capacitor c=0.00616547f \
 //x=13.385 //y=0.175 //x2=12.015 //y2=1.085
cc_368 ( N_GND_M6_noxref_d N_noxref_4_M7_noxref_d ) capacitor c=0.00143464f \
 //x=11.045 //y=1.045 //x2=12.015 //y2=1.085
cc_369 ( N_GND_c_332_n N_CLK_c_1080_n ) capacitor c=7.65588e-19 //x=1.175 \
 //y=0.18 //x2=2.655 //y2=2.26
cc_370 ( N_GND_c_336_n N_CLK_c_1081_n ) capacitor c=6.06131e-19 //x=13.385 \
 //y=0.175 //x2=15.605 //y2=2.26
cc_371 ( N_GND_c_337_n N_noxref_6_c_1350_n ) capacitor c=0.00390258f \
 //x=18.195 //y=0.175 //x2=19.19 //y2=3.88
cc_372 ( N_GND_c_334_n N_noxref_6_c_1351_n ) capacitor c=0.0459494f //x=5.245 \
 //y=0.175 //x2=4.42 //y2=1.845
cc_373 ( N_GND_c_334_n N_noxref_6_c_1317_n ) capacitor c=0.0178133f //x=5.245 \
 //y=0.175 //x2=6.355 //y2=2.26
cc_374 ( N_GND_c_337_n N_noxref_6_c_1320_n ) capacitor c=0.0155796f //x=18.195 \
 //y=0.175 //x2=19.305 //y2=2.26
cc_375 ( N_GND_c_341_p N_noxref_6_c_1354_n ) capacitor c=0.00133465f //x=6.235 \
 //y=0.175 //x2=6.055 //y2=1.055
cc_376 ( N_GND_M3_noxref_d N_noxref_6_c_1354_n ) capacitor c=0.00211996f \
 //x=6.13 //y=1.055 //x2=6.055 //y2=1.055
cc_377 ( N_GND_M3_noxref_d N_noxref_6_c_1356_n ) capacitor c=0.00255985f \
 //x=6.13 //y=1.055 //x2=6.055 //y2=1.4
cc_378 ( N_GND_c_334_n N_noxref_6_c_1357_n ) capacitor c=0.00204716f //x=5.245 \
 //y=0.175 //x2=6.055 //y2=1.71
cc_379 ( N_GND_c_334_n N_noxref_6_c_1358_n ) capacitor c=0.0118433f //x=5.245 \
 //y=0.175 //x2=6.055 //y2=2.095
cc_380 ( N_GND_M3_noxref_d N_noxref_6_c_1359_n ) capacitor c=0.0131387f \
 //x=6.13 //y=1.055 //x2=6.43 //y2=0.9
cc_381 ( N_GND_M3_noxref_d N_noxref_6_c_1360_n ) capacitor c=0.00193165f \
 //x=6.13 //y=1.055 //x2=6.43 //y2=1.555
cc_382 ( N_GND_c_389_p N_noxref_6_c_1361_n ) capacitor c=0.00129623f //x=9.885 \
 //y=0.175 //x2=6.585 //y2=1.055
cc_383 ( N_GND_M3_noxref_d N_noxref_6_c_1361_n ) capacitor c=0.00257848f \
 //x=6.13 //y=1.055 //x2=6.585 //y2=1.055
cc_384 ( N_GND_M3_noxref_d N_noxref_6_c_1363_n ) capacitor c=0.00255985f \
 //x=6.13 //y=1.055 //x2=6.585 //y2=1.4
cc_385 ( N_GND_c_392_p N_noxref_6_c_1364_n ) capacitor c=0.00133465f \
 //x=19.185 //y=0.175 //x2=19.005 //y2=1.055
cc_386 ( N_GND_M11_noxref_d N_noxref_6_c_1364_n ) capacitor c=0.00211996f \
 //x=19.08 //y=1.055 //x2=19.005 //y2=1.055
cc_387 ( N_GND_M11_noxref_d N_noxref_6_c_1366_n ) capacitor c=0.00255985f \
 //x=19.08 //y=1.055 //x2=19.005 //y2=1.4
cc_388 ( N_GND_c_337_n N_noxref_6_c_1367_n ) capacitor c=0.00204716f \
 //x=18.195 //y=0.175 //x2=19.005 //y2=1.71
cc_389 ( N_GND_c_337_n N_noxref_6_c_1368_n ) capacitor c=0.0110952f //x=18.195 \
 //y=0.175 //x2=19.005 //y2=2.095
cc_390 ( N_GND_M11_noxref_d N_noxref_6_c_1369_n ) capacitor c=0.0131387f \
 //x=19.08 //y=1.055 //x2=19.38 //y2=0.9
cc_391 ( N_GND_M11_noxref_d N_noxref_6_c_1370_n ) capacitor c=0.00193165f \
 //x=19.08 //y=1.055 //x2=19.38 //y2=1.555
cc_392 ( N_GND_c_399_p N_noxref_6_c_1371_n ) capacitor c=0.00129623f \
 //x=22.835 //y=0.175 //x2=19.535 //y2=1.055
cc_393 ( N_GND_M11_noxref_d N_noxref_6_c_1371_n ) capacitor c=0.00257848f \
 //x=19.08 //y=1.055 //x2=19.535 //y2=1.055
cc_394 ( N_GND_M11_noxref_d N_noxref_6_c_1373_n ) capacitor c=0.00255985f \
 //x=19.08 //y=1.055 //x2=19.535 //y2=1.4
cc_395 ( N_GND_c_334_n N_noxref_6_M2_noxref_d ) capacitor c=0.00591582f \
 //x=5.245 //y=0.175 //x2=3.83 //y2=1.095
cc_396 ( N_GND_c_339_p N_RN_c_1573_n ) capacitor c=0.0754923f //x=25.965 \
 //y=0.18 //x2=16.6 //y2=2.4
cc_397 ( N_GND_c_389_p N_RN_c_1573_n ) capacitor c=0.00318809f //x=9.885 \
 //y=0.175 //x2=16.6 //y2=2.4
cc_398 ( N_GND_c_348_p N_RN_c_1573_n ) capacitor c=0.00347867f //x=11.15 \
 //y=0.175 //x2=16.6 //y2=2.4
cc_399 ( N_GND_c_355_p N_RN_c_1573_n ) capacitor c=0.00412122f //x=13.215 \
 //y=0.175 //x2=16.6 //y2=2.4
cc_400 ( N_GND_c_363_p N_RN_c_1573_n ) capacitor c=0.00274395f //x=14.375 \
 //y=0.175 //x2=16.6 //y2=2.4
cc_401 ( N_GND_c_370_p N_RN_c_1573_n ) capacitor c=0.00111248f //x=18.025 \
 //y=0.175 //x2=16.6 //y2=2.4
cc_402 ( N_GND_c_335_n N_RN_c_1573_n ) capacitor c=0.0418918f //x=10.055 \
 //y=0.175 //x2=16.6 //y2=2.4
cc_403 ( N_GND_c_336_n N_RN_c_1573_n ) capacitor c=0.0418918f //x=13.385 \
 //y=0.175 //x2=16.6 //y2=2.4
cc_404 ( N_GND_c_339_p N_RN_c_1581_n ) capacitor c=0.0022131f //x=25.965 \
 //y=0.18 //x2=8.69 //y2=2.4
cc_405 ( N_GND_c_389_p N_RN_c_1581_n ) capacitor c=4.18994e-19 //x=9.885 \
 //y=0.175 //x2=8.69 //y2=2.4
cc_406 ( N_GND_c_339_p N_RN_c_1583_n ) capacitor c=0.0354995f //x=25.965 \
 //y=0.18 //x2=20.3 //y2=2.4
cc_407 ( N_GND_c_370_p N_RN_c_1583_n ) capacitor c=0.0031881f //x=18.025 \
 //y=0.175 //x2=20.3 //y2=2.4
cc_408 ( N_GND_c_392_p N_RN_c_1583_n ) capacitor c=0.00274395f //x=19.185 \
 //y=0.175 //x2=20.3 //y2=2.4
cc_409 ( N_GND_c_337_n N_RN_c_1583_n ) capacitor c=0.0430854f //x=18.195 \
 //y=0.175 //x2=20.3 //y2=2.4
cc_410 ( N_GND_c_339_p N_RN_c_1587_n ) capacitor c=0.00195474f //x=25.965 \
 //y=0.18 //x2=16.83 //y2=2.4
cc_411 ( N_GND_c_335_n RN ) capacitor c=2.6258e-19 //x=10.055 //y=0.175 \
 //x2=8.63 //y2=2.77
cc_412 ( N_GND_c_337_n RN ) capacitor c=2.6258e-19 //x=18.195 //y=0.175 \
 //x2=16.77 //y2=2.77
cc_413 ( N_GND_c_335_n N_RN_c_1590_n ) capacitor c=3.07601e-19 //x=10.055 \
 //y=0.175 //x2=8.602 //y2=2.685
cc_414 ( N_GND_c_337_n N_RN_c_1591_n ) capacitor c=3.07601e-19 //x=18.195 \
 //y=0.175 //x2=16.742 //y2=2.685
cc_415 ( N_GND_c_337_n N_RN_c_1592_n ) capacitor c=5.95501e-19 //x=18.195 \
 //y=0.175 //x2=20.442 //y2=2.685
cc_416 ( N_GND_c_338_n Q ) capacitor c=2.6258e-19 //x=23.005 //y=0.175 \
 //x2=21.58 //y2=2.77
cc_417 ( N_GND_c_339_p Q ) capacitor c=0.00234091f //x=25.965 //y=0.18 \
 //x2=21.58 //y2=3.88
cc_418 ( N_GND_c_333_n Q ) capacitor c=0.00946859f //x=25.965 //y=0.18 \
 //x2=25.65 //y2=2.4
cc_419 ( N_GND_c_333_n Q ) capacitor c=0.00946859f //x=25.965 //y=0.18 \
 //x2=25.65 //y2=2.77
cc_420 ( N_GND_c_339_p Q ) capacitor c=0.0173503f //x=25.965 //y=0.18 \
 //x2=25.65 //y2=3.88
cc_421 ( N_GND_c_338_n N_Q_c_1919_n ) capacitor c=9.73439e-19 //x=23.005 \
 //y=0.175 //x2=21.525 //y2=2.26
cc_422 ( N_GND_c_333_n N_Q_c_1920_n ) capacitor c=0.0229396f //x=25.965 \
 //y=0.18 //x2=25.51 //y2=1.835
cc_423 ( N_GND_c_338_n N_Q_c_1921_n ) capacitor c=9.64732e-19 //x=23.005 \
 //y=0.175 //x2=25.622 //y2=2.315
cc_424 ( N_GND_c_333_n N_Q_c_1922_n ) capacitor c=0.00778088f //x=25.965 \
 //y=0.18 //x2=25.622 //y2=2.685
cc_425 ( N_GND_c_333_n N_Q_c_1923_n ) capacitor c=0.00173978f //x=25.965 \
 //y=0.18 //x2=25.622 //y2=3.055
cc_426 ( N_GND_c_333_n N_Q_M15_noxref_d ) capacitor c=0.00618259f //x=25.965 \
 //y=0.18 //x2=24.965 //y2=1.085
cc_427 ( N_GND_c_338_n N_Q_M15_noxref_d ) capacitor c=8.58106e-19 //x=23.005 \
 //y=0.175 //x2=24.965 //y2=1.085
cc_428 ( N_GND_M14_noxref_d N_Q_M15_noxref_d ) capacitor c=0.00143464f \
 //x=23.995 //y=1.045 //x2=24.965 //y2=1.085
cc_429 ( N_GND_c_338_n N_noxref_9_c_2096_n ) capacitor c=0.0455982f //x=23.005 \
 //y=0.175 //x2=22.18 //y2=1.845
cc_430 ( N_GND_c_339_p N_noxref_9_c_2080_n ) capacitor c=0.00297453f \
 //x=25.965 //y=0.18 //x2=22.265 //y2=3.51
cc_431 ( N_GND_c_399_p N_noxref_9_c_2080_n ) capacitor c=7.27101e-19 \
 //x=22.835 //y=0.175 //x2=22.265 //y2=3.51
cc_432 ( N_GND_c_338_n N_noxref_9_M13_noxref_d ) capacitor c=0.00591582f \
 //x=23.005 //y=0.175 //x2=21.59 //y2=1.095
cc_433 ( N_GND_c_338_n N_noxref_10_c_2170_n ) capacitor c=0.0179404f \
 //x=23.005 //y=0.175 //x2=24.115 //y2=2.26
cc_434 ( N_GND_c_339_p N_noxref_10_c_2179_n ) capacitor c=0.012768f //x=25.965 \
 //y=0.18 //x2=24.115 //y2=3.51
cc_435 ( N_GND_c_399_p N_noxref_10_c_2179_n ) capacitor c=8.02089e-19 \
 //x=22.835 //y=0.175 //x2=24.115 //y2=3.51
cc_436 ( N_GND_c_443_p N_noxref_10_c_2179_n ) capacitor c=0.00189777f //x=24.1 \
 //y=0.175 //x2=24.115 //y2=3.51
cc_437 ( N_GND_c_338_n N_noxref_10_c_2179_n ) capacitor c=0.00820859f \
 //x=23.005 //y=0.175 //x2=24.115 //y2=3.51
cc_438 ( N_GND_c_443_p N_noxref_10_c_2183_n ) capacitor c=0.00135783f //x=24.1 \
 //y=0.175 //x2=23.92 //y2=1.045
cc_439 ( N_GND_M14_noxref_d N_noxref_10_c_2183_n ) capacitor c=0.00220047f \
 //x=23.995 //y=1.045 //x2=23.92 //y2=1.045
cc_440 ( N_GND_M14_noxref_d N_noxref_10_c_2185_n ) capacitor c=0.00255985f \
 //x=23.995 //y=1.045 //x2=23.92 //y2=1.39
cc_441 ( N_GND_c_338_n N_noxref_10_c_2186_n ) capacitor c=0.00189421f \
 //x=23.005 //y=0.175 //x2=23.92 //y2=1.7
cc_442 ( N_GND_c_338_n N_noxref_10_c_2187_n ) capacitor c=0.0106743f \
 //x=23.005 //y=0.175 //x2=23.92 //y2=2.095
cc_443 ( N_GND_M14_noxref_d N_noxref_10_c_2188_n ) capacitor c=0.0131374f \
 //x=23.995 //y=1.045 //x2=24.295 //y2=0.89
cc_444 ( N_GND_M14_noxref_d N_noxref_10_c_2189_n ) capacitor c=0.00193146f \
 //x=23.995 //y=1.045 //x2=24.295 //y2=1.545
cc_445 ( N_GND_c_333_n N_noxref_10_c_2190_n ) capacitor c=0.00131234f \
 //x=25.965 //y=0.18 //x2=24.45 //y2=1.045
cc_446 ( N_GND_M14_noxref_d N_noxref_10_c_2190_n ) capacitor c=0.00257848f \
 //x=23.995 //y=1.045 //x2=24.45 //y2=1.045
cc_447 ( N_GND_M14_noxref_d N_noxref_10_c_2192_n ) capacitor c=0.00255985f \
 //x=23.995 //y=1.045 //x2=24.45 //y2=1.39
cc_448 ( N_GND_c_339_p N_noxref_11_c_2240_n ) capacitor c=0.0122542f \
 //x=25.965 //y=0.18 //x2=11.79 //y2=4.25
cc_449 ( N_GND_c_339_p N_noxref_11_c_2244_n ) capacitor c=0.0015897f \
 //x=25.965 //y=0.18 //x2=1.66 //y2=4.25
cc_450 ( N_GND_c_339_p N_noxref_11_c_2249_n ) capacitor c=0.011168f //x=25.965 \
 //y=0.18 //x2=24.74 //y2=4.25
cc_451 ( N_GND_c_332_n N_noxref_11_c_2263_n ) capacitor c=0.0180363f //x=1.175 \
 //y=0.18 //x2=1.545 //y2=2.26
cc_452 ( N_GND_c_335_n N_noxref_11_c_2266_n ) capacitor c=7.4738e-19 \
 //x=10.055 //y=0.175 //x2=11.905 //y2=2.26
cc_453 ( N_GND_c_336_n N_noxref_11_c_2266_n ) capacitor c=7.76678e-19 \
 //x=13.385 //y=0.175 //x2=11.905 //y2=2.26
cc_454 ( N_GND_c_337_n N_noxref_11_c_2322_n ) capacitor c=0.0430857f \
 //x=18.195 //y=0.175 //x2=17.37 //y2=1.845
cc_455 ( N_GND_c_333_n N_noxref_11_c_2283_n ) capacitor c=9.94548e-19 \
 //x=25.965 //y=0.18 //x2=24.855 //y2=2.26
cc_456 ( N_GND_c_338_n N_noxref_11_c_2283_n ) capacitor c=9.2064e-19 \
 //x=23.005 //y=0.175 //x2=24.855 //y2=2.26
cc_457 ( N_GND_c_464_p N_noxref_11_c_2325_n ) capacitor c=0.00133465f \
 //x=1.425 //y=0.175 //x2=1.245 //y2=1.055
cc_458 ( N_GND_M0_noxref_d N_noxref_11_c_2325_n ) capacitor c=0.00211996f \
 //x=1.32 //y=1.055 //x2=1.245 //y2=1.055
cc_459 ( N_GND_M0_noxref_d N_noxref_11_c_2327_n ) capacitor c=0.00255985f \
 //x=1.32 //y=1.055 //x2=1.245 //y2=1.4
cc_460 ( N_GND_c_332_n N_noxref_11_c_2328_n ) capacitor c=0.00295461f \
 //x=1.175 //y=0.18 //x2=1.245 //y2=1.71
cc_461 ( N_GND_c_332_n N_noxref_11_c_2329_n ) capacitor c=0.0134214f //x=1.175 \
 //y=0.18 //x2=1.245 //y2=2.095
cc_462 ( N_GND_M0_noxref_d N_noxref_11_c_2330_n ) capacitor c=0.0131387f \
 //x=1.32 //y=1.055 //x2=1.62 //y2=0.9
cc_463 ( N_GND_M0_noxref_d N_noxref_11_c_2331_n ) capacitor c=0.00193165f \
 //x=1.32 //y=1.055 //x2=1.62 //y2=1.555
cc_464 ( N_GND_c_340_p N_noxref_11_c_2332_n ) capacitor c=0.00129623f \
 //x=5.075 //y=0.175 //x2=1.775 //y2=1.055
cc_465 ( N_GND_M0_noxref_d N_noxref_11_c_2332_n ) capacitor c=0.00257848f \
 //x=1.32 //y=1.055 //x2=1.775 //y2=1.055
cc_466 ( N_GND_M0_noxref_d N_noxref_11_c_2334_n ) capacitor c=0.00255985f \
 //x=1.32 //y=1.055 //x2=1.775 //y2=1.4
cc_467 ( N_GND_c_337_n N_noxref_11_M10_noxref_d ) capacitor c=0.00591582f \
 //x=18.195 //y=0.175 //x2=16.78 //y2=1.095
cc_468 ( N_GND_c_339_p N_noxref_12_c_2648_n ) capacitor c=0.00618966f \
 //x=25.965 //y=0.18 //x2=1.91 //y2=1.77
cc_469 ( N_GND_c_464_p N_noxref_12_c_2648_n ) capacitor c=0.00110148f \
 //x=1.425 //y=0.175 //x2=1.91 //y2=1.77
cc_470 ( N_GND_c_340_p N_noxref_12_c_2648_n ) capacitor c=0.0017942f //x=5.075 \
 //y=0.175 //x2=1.91 //y2=1.77
cc_471 ( N_GND_M0_noxref_d N_noxref_12_c_2648_n ) capacitor c=0.0089491f \
 //x=1.32 //y=1.055 //x2=1.91 //y2=1.77
cc_472 ( N_GND_c_339_p N_noxref_12_c_2652_n ) capacitor c=0.00576803f \
 //x=25.965 //y=0.18 //x2=1.995 //y2=0.805
cc_473 ( N_GND_c_340_p N_noxref_12_c_2652_n ) capacitor c=0.0140604f //x=5.075 \
 //y=0.175 //x2=1.995 //y2=0.805
cc_474 ( N_GND_M0_noxref_d N_noxref_12_c_2652_n ) capacitor c=0.033954f \
 //x=1.32 //y=1.055 //x2=1.995 //y2=0.805
cc_475 ( N_GND_c_339_p N_noxref_12_c_2655_n ) capacitor c=0.0139064f \
 //x=25.965 //y=0.18 //x2=2.88 //y2=0.72
cc_476 ( N_GND_c_340_p N_noxref_12_c_2655_n ) capacitor c=0.0356451f //x=5.075 \
 //y=0.175 //x2=2.88 //y2=0.72
cc_477 ( N_GND_c_333_n N_noxref_12_c_2655_n ) capacitor c=0.00177266f \
 //x=25.965 //y=0.18 //x2=2.88 //y2=0.72
cc_478 ( N_GND_c_339_p N_noxref_12_M0_noxref_s ) capacitor c=0.012556f \
 //x=25.965 //y=0.18 //x2=0.89 //y2=0.555
cc_479 ( N_GND_c_464_p N_noxref_12_M0_noxref_s ) capacitor c=0.0140604f \
 //x=1.425 //y=0.175 //x2=0.89 //y2=0.555
cc_480 ( N_GND_c_332_n N_noxref_12_M0_noxref_s ) capacitor c=0.0712607f \
 //x=1.175 //y=0.18 //x2=0.89 //y2=0.555
cc_481 ( N_GND_c_340_p N_noxref_12_M0_noxref_s ) capacitor c=0.0131642f \
 //x=5.075 //y=0.175 //x2=0.89 //y2=0.555
cc_482 ( N_GND_c_334_n N_noxref_12_M0_noxref_s ) capacitor c=3.31601e-19 \
 //x=5.245 //y=0.175 //x2=0.89 //y2=0.555
cc_483 ( N_GND_M0_noxref_d N_noxref_12_M0_noxref_s ) capacitor c=0.033718f \
 //x=1.32 //y=1.055 //x2=0.89 //y2=0.555
cc_484 ( N_GND_c_339_p N_noxref_13_c_2696_n ) capacitor c=0.00403022f \
 //x=25.965 //y=0.18 //x2=3.45 //y2=1.175
cc_485 ( N_GND_c_340_p N_noxref_13_c_2696_n ) capacitor c=0.00830851f \
 //x=5.075 //y=0.175 //x2=3.45 //y2=1.175
cc_486 ( N_GND_c_339_p N_noxref_13_c_2698_n ) capacitor c=0.00576803f \
 //x=25.965 //y=0.18 //x2=3.535 //y2=0.805
cc_487 ( N_GND_c_340_p N_noxref_13_c_2698_n ) capacitor c=0.0140604f //x=5.075 \
 //y=0.175 //x2=3.535 //y2=0.805
cc_488 ( N_GND_M0_noxref_d N_noxref_13_c_2698_n ) capacitor c=6.21394e-19 \
 //x=1.32 //y=1.055 //x2=3.535 //y2=0.805
cc_489 ( N_GND_c_339_p N_noxref_13_c_2701_n ) capacitor c=0.0118394f \
 //x=25.965 //y=0.18 //x2=4.42 //y2=0.72
cc_490 ( N_GND_c_340_p N_noxref_13_c_2701_n ) capacitor c=0.0365819f //x=5.075 \
 //y=0.175 //x2=4.42 //y2=0.72
cc_491 ( N_GND_c_333_n N_noxref_13_c_2701_n ) capacitor c=0.00189358f \
 //x=25.965 //y=0.18 //x2=4.42 //y2=0.72
cc_492 ( N_GND_c_339_p N_noxref_13_c_2704_n ) capacitor c=0.00287576f \
 //x=25.965 //y=0.18 //x2=4.505 //y2=0.805
cc_493 ( N_GND_c_340_p N_noxref_13_c_2704_n ) capacitor c=0.0142854f //x=5.075 \
 //y=0.175 //x2=4.505 //y2=0.805
cc_494 ( N_GND_c_334_n N_noxref_13_c_2704_n ) capacitor c=0.0404137f //x=5.245 \
 //y=0.175 //x2=4.505 //y2=0.805
cc_495 ( N_GND_M0_noxref_d N_noxref_13_M1_noxref_d ) capacitor c=0.00162435f \
 //x=1.32 //y=1.055 //x2=2.295 //y2=1.09
cc_496 ( N_GND_c_332_n N_noxref_13_M2_noxref_s ) capacitor c=8.16352e-19 \
 //x=1.175 //y=0.18 //x2=3.4 //y2=0.555
cc_497 ( N_GND_c_334_n N_noxref_13_M2_noxref_s ) capacitor c=0.00183204f \
 //x=5.245 //y=0.175 //x2=3.4 //y2=0.555
cc_498 ( N_GND_c_334_n N_D_c_2755_n ) capacitor c=8.55471e-19 //x=5.245 \
 //y=0.175 //x2=7.465 //y2=2.26
cc_499 ( N_GND_c_339_p N_noxref_15_c_2838_n ) capacitor c=0.00551257f \
 //x=25.965 //y=0.18 //x2=6.72 //y2=1.77
cc_500 ( N_GND_c_341_p N_noxref_15_c_2838_n ) capacitor c=0.00111699f \
 //x=6.235 //y=0.175 //x2=6.72 //y2=1.77
cc_501 ( N_GND_c_389_p N_noxref_15_c_2838_n ) capacitor c=0.00180972f \
 //x=9.885 //y=0.175 //x2=6.72 //y2=1.77
cc_502 ( N_GND_M3_noxref_d N_noxref_15_c_2838_n ) capacitor c=0.0088767f \
 //x=6.13 //y=1.055 //x2=6.72 //y2=1.77
cc_503 ( N_GND_c_339_p N_noxref_15_c_2842_n ) capacitor c=0.00287676f \
 //x=25.965 //y=0.18 //x2=6.805 //y2=0.805
cc_504 ( N_GND_c_389_p N_noxref_15_c_2842_n ) capacitor c=0.0143483f //x=9.885 \
 //y=0.175 //x2=6.805 //y2=0.805
cc_505 ( N_GND_M3_noxref_d N_noxref_15_c_2842_n ) capacitor c=0.033954f \
 //x=6.13 //y=1.055 //x2=6.805 //y2=0.805
cc_506 ( N_GND_c_339_p N_noxref_15_c_2845_n ) capacitor c=0.0117699f \
 //x=25.965 //y=0.18 //x2=7.69 //y2=0.72
cc_507 ( N_GND_c_389_p N_noxref_15_c_2845_n ) capacitor c=0.0362407f //x=9.885 \
 //y=0.175 //x2=7.69 //y2=0.72
cc_508 ( N_GND_c_333_n N_noxref_15_c_2845_n ) capacitor c=0.00177266f \
 //x=25.965 //y=0.18 //x2=7.69 //y2=0.72
cc_509 ( N_GND_c_339_p N_noxref_15_M3_noxref_s ) capacitor c=0.00575129f \
 //x=25.965 //y=0.18 //x2=5.7 //y2=0.555
cc_510 ( N_GND_c_341_p N_noxref_15_M3_noxref_s ) capacitor c=0.0143483f \
 //x=6.235 //y=0.175 //x2=5.7 //y2=0.555
cc_511 ( N_GND_c_389_p N_noxref_15_M3_noxref_s ) capacitor c=0.0133967f \
 //x=9.885 //y=0.175 //x2=5.7 //y2=0.555
cc_512 ( N_GND_c_334_n N_noxref_15_M3_noxref_s ) capacitor c=0.0696963f \
 //x=5.245 //y=0.175 //x2=5.7 //y2=0.555
cc_513 ( N_GND_c_335_n N_noxref_15_M3_noxref_s ) capacitor c=3.31601e-19 \
 //x=10.055 //y=0.175 //x2=5.7 //y2=0.555
cc_514 ( N_GND_M3_noxref_d N_noxref_15_M3_noxref_s ) capacitor c=0.033718f \
 //x=6.13 //y=1.055 //x2=5.7 //y2=0.555
cc_515 ( N_GND_c_339_p N_noxref_16_c_2889_n ) capacitor c=0.00385483f \
 //x=25.965 //y=0.18 //x2=8.26 //y2=1.175
cc_516 ( N_GND_c_389_p N_noxref_16_c_2889_n ) capacitor c=0.00949615f \
 //x=9.885 //y=0.175 //x2=8.26 //y2=1.175
cc_517 ( N_GND_c_339_p N_noxref_16_c_2891_n ) capacitor c=0.00287676f \
 //x=25.965 //y=0.18 //x2=8.345 //y2=0.805
cc_518 ( N_GND_c_389_p N_noxref_16_c_2891_n ) capacitor c=0.0143483f //x=9.885 \
 //y=0.175 //x2=8.345 //y2=0.805
cc_519 ( N_GND_M3_noxref_d N_noxref_16_c_2891_n ) capacitor c=6.21394e-19 \
 //x=6.13 //y=1.055 //x2=8.345 //y2=0.805
cc_520 ( N_GND_c_339_p N_noxref_16_c_2894_n ) capacitor c=0.0105236f \
 //x=25.965 //y=0.18 //x2=9.23 //y2=0.72
cc_521 ( N_GND_c_389_p N_noxref_16_c_2894_n ) capacitor c=0.0363935f //x=9.885 \
 //y=0.175 //x2=9.23 //y2=0.72
cc_522 ( N_GND_c_333_n N_noxref_16_c_2894_n ) capacitor c=0.00189358f \
 //x=25.965 //y=0.18 //x2=9.23 //y2=0.72
cc_523 ( N_GND_c_339_p N_noxref_16_c_2897_n ) capacitor c=0.00254308f \
 //x=25.965 //y=0.18 //x2=9.315 //y2=0.805
cc_524 ( N_GND_c_389_p N_noxref_16_c_2897_n ) capacitor c=0.0140503f //x=9.885 \
 //y=0.175 //x2=9.315 //y2=0.805
cc_525 ( N_GND_c_335_n N_noxref_16_c_2897_n ) capacitor c=0.0404137f \
 //x=10.055 //y=0.175 //x2=9.315 //y2=0.805
cc_526 ( N_GND_M3_noxref_d N_noxref_16_M4_noxref_d ) capacitor c=0.00162435f \
 //x=6.13 //y=1.055 //x2=7.105 //y2=1.09
cc_527 ( N_GND_c_334_n N_noxref_16_M5_noxref_s ) capacitor c=8.16352e-19 \
 //x=5.245 //y=0.175 //x2=8.21 //y2=0.555
cc_528 ( N_GND_c_335_n N_noxref_16_M5_noxref_s ) capacitor c=0.00183576f \
 //x=10.055 //y=0.175 //x2=8.21 //y2=0.555
cc_529 ( N_GND_c_339_p N_noxref_17_c_2943_n ) capacitor c=0.00517479f \
 //x=25.965 //y=0.18 //x2=11.635 //y2=1.76
cc_530 ( N_GND_c_348_p N_noxref_17_c_2943_n ) capacitor c=0.00112996f \
 //x=11.15 //y=0.175 //x2=11.635 //y2=1.76
cc_531 ( N_GND_c_355_p N_noxref_17_c_2943_n ) capacitor c=0.00182524f \
 //x=13.215 //y=0.175 //x2=11.635 //y2=1.76
cc_532 ( N_GND_M6_noxref_d N_noxref_17_c_2943_n ) capacitor c=0.00862619f \
 //x=11.045 //y=1.045 //x2=11.635 //y2=1.76
cc_533 ( N_GND_c_339_p N_noxref_17_c_2947_n ) capacitor c=0.00259097f \
 //x=25.965 //y=0.18 //x2=11.72 //y2=0.795
cc_534 ( N_GND_c_355_p N_noxref_17_c_2947_n ) capacitor c=0.0147125f \
 //x=13.215 //y=0.175 //x2=11.72 //y2=0.795
cc_535 ( N_GND_M6_noxref_d N_noxref_17_c_2947_n ) capacitor c=0.033812f \
 //x=11.045 //y=1.045 //x2=11.72 //y2=0.795
cc_536 ( N_GND_c_335_n N_noxref_17_c_2950_n ) capacitor c=2.91423e-19 \
 //x=10.055 //y=0.175 //x2=11.72 //y2=1.675
cc_537 ( N_GND_c_339_p N_noxref_17_c_2951_n ) capacitor c=0.0106959f \
 //x=25.965 //y=0.18 //x2=12.605 //y2=0.71
cc_538 ( N_GND_c_355_p N_noxref_17_c_2951_n ) capacitor c=0.0374662f \
 //x=13.215 //y=0.175 //x2=12.605 //y2=0.71
cc_539 ( N_GND_c_333_n N_noxref_17_c_2951_n ) capacitor c=0.00198372f \
 //x=25.965 //y=0.18 //x2=12.605 //y2=0.71
cc_540 ( N_GND_c_339_p N_noxref_17_c_2954_n ) capacitor c=0.00258902f \
 //x=25.965 //y=0.18 //x2=12.69 //y2=0.795
cc_541 ( N_GND_c_355_p N_noxref_17_c_2954_n ) capacitor c=0.0146462f \
 //x=13.215 //y=0.175 //x2=12.69 //y2=0.795
cc_542 ( N_GND_c_336_n N_noxref_17_c_2954_n ) capacitor c=0.0431718f \
 //x=13.385 //y=0.175 //x2=12.69 //y2=0.795
cc_543 ( N_GND_c_339_p N_noxref_17_M6_noxref_s ) capacitor c=0.00259097f \
 //x=25.965 //y=0.18 //x2=10.615 //y2=0.545
cc_544 ( N_GND_c_348_p N_noxref_17_M6_noxref_s ) capacitor c=0.0147125f \
 //x=11.15 //y=0.175 //x2=10.615 //y2=0.545
cc_545 ( N_GND_c_335_n N_noxref_17_M6_noxref_s ) capacitor c=0.0583534f \
 //x=10.055 //y=0.175 //x2=10.615 //y2=0.545
cc_546 ( N_GND_c_336_n N_noxref_17_M6_noxref_s ) capacitor c=0.00198098f \
 //x=13.385 //y=0.175 //x2=10.615 //y2=0.545
cc_547 ( N_GND_M6_noxref_d N_noxref_17_M6_noxref_s ) capacitor c=0.0334197f \
 //x=11.045 //y=1.045 //x2=10.615 //y2=0.545
cc_548 ( N_GND_c_339_p N_noxref_18_c_2995_n ) capacitor c=0.00517803f \
 //x=25.965 //y=0.18 //x2=14.86 //y2=1.77
cc_549 ( N_GND_c_363_p N_noxref_18_c_2995_n ) capacitor c=0.00111572f \
 //x=14.375 //y=0.175 //x2=14.86 //y2=1.77
cc_550 ( N_GND_c_370_p N_noxref_18_c_2995_n ) capacitor c=0.00180844f \
 //x=18.025 //y=0.175 //x2=14.86 //y2=1.77
cc_551 ( N_GND_M8_noxref_d N_noxref_18_c_2995_n ) capacitor c=0.00853195f \
 //x=14.27 //y=1.055 //x2=14.86 //y2=1.77
cc_552 ( N_GND_c_339_p N_noxref_18_c_2999_n ) capacitor c=0.00254564f \
 //x=25.965 //y=0.18 //x2=14.945 //y2=0.805
cc_553 ( N_GND_c_370_p N_noxref_18_c_2999_n ) capacitor c=0.0141145f \
 //x=18.025 //y=0.175 //x2=14.945 //y2=0.805
cc_554 ( N_GND_M8_noxref_d N_noxref_18_c_2999_n ) capacitor c=0.033954f \
 //x=14.27 //y=1.055 //x2=14.945 //y2=0.805
cc_555 ( N_GND_c_339_p N_noxref_18_c_3002_n ) capacitor c=0.0104527f \
 //x=25.965 //y=0.18 //x2=15.83 //y2=0.72
cc_556 ( N_GND_c_370_p N_noxref_18_c_3002_n ) capacitor c=0.0361062f \
 //x=18.025 //y=0.175 //x2=15.83 //y2=0.72
cc_557 ( N_GND_c_333_n N_noxref_18_c_3002_n ) capacitor c=0.00177266f \
 //x=25.965 //y=0.18 //x2=15.83 //y2=0.72
cc_558 ( N_GND_c_339_p N_noxref_18_M8_noxref_s ) capacitor c=0.00507768f \
 //x=25.965 //y=0.18 //x2=13.84 //y2=0.555
cc_559 ( N_GND_c_363_p N_noxref_18_M8_noxref_s ) capacitor c=0.0141145f \
 //x=14.375 //y=0.175 //x2=13.84 //y2=0.555
cc_560 ( N_GND_c_370_p N_noxref_18_M8_noxref_s ) capacitor c=0.0131542f \
 //x=18.025 //y=0.175 //x2=13.84 //y2=0.555
cc_561 ( N_GND_c_336_n N_noxref_18_M8_noxref_s ) capacitor c=0.0696963f \
 //x=13.385 //y=0.175 //x2=13.84 //y2=0.555
cc_562 ( N_GND_c_337_n N_noxref_18_M8_noxref_s ) capacitor c=3.31601e-19 \
 //x=18.195 //y=0.175 //x2=13.84 //y2=0.555
cc_563 ( N_GND_M8_noxref_d N_noxref_18_M8_noxref_s ) capacitor c=0.033718f \
 //x=14.27 //y=1.055 //x2=13.84 //y2=0.555
cc_564 ( N_GND_c_339_p N_noxref_19_c_3046_n ) capacitor c=0.00353223f \
 //x=25.965 //y=0.18 //x2=16.4 //y2=1.175
cc_565 ( N_GND_c_370_p N_noxref_19_c_3046_n ) capacitor c=0.00935019f \
 //x=18.025 //y=0.175 //x2=16.4 //y2=1.175
cc_566 ( N_GND_c_339_p N_noxref_19_c_3048_n ) capacitor c=0.00254564f \
 //x=25.965 //y=0.18 //x2=16.485 //y2=0.805
cc_567 ( N_GND_c_370_p N_noxref_19_c_3048_n ) capacitor c=0.0141145f \
 //x=18.025 //y=0.175 //x2=16.485 //y2=0.805
cc_568 ( N_GND_M8_noxref_d N_noxref_19_c_3048_n ) capacitor c=6.21394e-19 \
 //x=14.27 //y=1.055 //x2=16.485 //y2=0.805
cc_569 ( N_GND_c_339_p N_noxref_19_c_3051_n ) capacitor c=0.0105236f \
 //x=25.965 //y=0.18 //x2=17.37 //y2=0.72
cc_570 ( N_GND_c_370_p N_noxref_19_c_3051_n ) capacitor c=0.0364401f \
 //x=18.025 //y=0.175 //x2=17.37 //y2=0.72
cc_571 ( N_GND_c_333_n N_noxref_19_c_3051_n ) capacitor c=0.00189358f \
 //x=25.965 //y=0.18 //x2=17.37 //y2=0.72
cc_572 ( N_GND_c_339_p N_noxref_19_c_3054_n ) capacitor c=0.00254308f \
 //x=25.965 //y=0.18 //x2=17.455 //y2=0.805
cc_573 ( N_GND_c_370_p N_noxref_19_c_3054_n ) capacitor c=0.0140503f \
 //x=18.025 //y=0.175 //x2=17.455 //y2=0.805
cc_574 ( N_GND_c_337_n N_noxref_19_c_3054_n ) capacitor c=0.0404137f \
 //x=18.195 //y=0.175 //x2=17.455 //y2=0.805
cc_575 ( N_GND_M8_noxref_d N_noxref_19_M9_noxref_d ) capacitor c=0.00162435f \
 //x=14.27 //y=1.055 //x2=15.245 //y2=1.09
cc_576 ( N_GND_c_336_n N_noxref_19_M10_noxref_s ) capacitor c=8.16352e-19 \
 //x=13.385 //y=0.175 //x2=16.35 //y2=0.555
cc_577 ( N_GND_c_337_n N_noxref_19_M10_noxref_s ) capacitor c=0.00183204f \
 //x=18.195 //y=0.175 //x2=16.35 //y2=0.555
cc_578 ( N_GND_c_339_p N_noxref_20_c_3100_n ) capacitor c=0.00517803f \
 //x=25.965 //y=0.18 //x2=19.67 //y2=1.77
cc_579 ( N_GND_c_392_p N_noxref_20_c_3100_n ) capacitor c=0.00111572f \
 //x=19.185 //y=0.175 //x2=19.67 //y2=1.77
cc_580 ( N_GND_c_399_p N_noxref_20_c_3100_n ) capacitor c=0.00180844f \
 //x=22.835 //y=0.175 //x2=19.67 //y2=1.77
cc_581 ( N_GND_M11_noxref_d N_noxref_20_c_3100_n ) capacitor c=0.00853195f \
 //x=19.08 //y=1.055 //x2=19.67 //y2=1.77
cc_582 ( N_GND_c_339_p N_noxref_20_c_3104_n ) capacitor c=0.00254564f \
 //x=25.965 //y=0.18 //x2=19.755 //y2=0.805
cc_583 ( N_GND_c_399_p N_noxref_20_c_3104_n ) capacitor c=0.0141145f \
 //x=22.835 //y=0.175 //x2=19.755 //y2=0.805
cc_584 ( N_GND_M11_noxref_d N_noxref_20_c_3104_n ) capacitor c=0.033954f \
 //x=19.08 //y=1.055 //x2=19.755 //y2=0.805
cc_585 ( N_GND_c_339_p N_noxref_20_c_3107_n ) capacitor c=0.0113382f \
 //x=25.965 //y=0.18 //x2=20.64 //y2=0.72
cc_586 ( N_GND_c_399_p N_noxref_20_c_3107_n ) capacitor c=0.0358849f \
 //x=22.835 //y=0.175 //x2=20.64 //y2=0.72
cc_587 ( N_GND_c_333_n N_noxref_20_c_3107_n ) capacitor c=0.00177266f \
 //x=25.965 //y=0.18 //x2=20.64 //y2=0.72
cc_588 ( N_GND_c_339_p N_noxref_20_M11_noxref_s ) capacitor c=0.00799255f \
 //x=25.965 //y=0.18 //x2=18.65 //y2=0.555
cc_589 ( N_GND_c_392_p N_noxref_20_M11_noxref_s ) capacitor c=0.0141145f \
 //x=19.185 //y=0.175 //x2=18.65 //y2=0.555
cc_590 ( N_GND_c_399_p N_noxref_20_M11_noxref_s ) capacitor c=0.0131642f \
 //x=22.835 //y=0.175 //x2=18.65 //y2=0.555
cc_591 ( N_GND_c_337_n N_noxref_20_M11_noxref_s ) capacitor c=0.0696963f \
 //x=18.195 //y=0.175 //x2=18.65 //y2=0.555
cc_592 ( N_GND_c_338_n N_noxref_20_M11_noxref_s ) capacitor c=3.31601e-19 \
 //x=23.005 //y=0.175 //x2=18.65 //y2=0.555
cc_593 ( N_GND_M11_noxref_d N_noxref_20_M11_noxref_s ) capacitor c=0.033718f \
 //x=19.08 //y=1.055 //x2=18.65 //y2=0.555
cc_594 ( N_GND_c_339_p N_noxref_21_c_3152_n ) capacitor c=0.00403022f \
 //x=25.965 //y=0.18 //x2=21.21 //y2=1.175
cc_595 ( N_GND_c_399_p N_noxref_21_c_3152_n ) capacitor c=0.00830851f \
 //x=22.835 //y=0.175 //x2=21.21 //y2=1.175
cc_596 ( N_GND_c_339_p N_noxref_21_c_3154_n ) capacitor c=0.00576803f \
 //x=25.965 //y=0.18 //x2=21.295 //y2=0.805
cc_597 ( N_GND_c_399_p N_noxref_21_c_3154_n ) capacitor c=0.0140604f \
 //x=22.835 //y=0.175 //x2=21.295 //y2=0.805
cc_598 ( N_GND_M11_noxref_d N_noxref_21_c_3154_n ) capacitor c=6.21394e-19 \
 //x=19.08 //y=1.055 //x2=21.295 //y2=0.805
cc_599 ( N_GND_c_339_p N_noxref_21_c_3157_n ) capacitor c=0.0122047f \
 //x=25.965 //y=0.18 //x2=22.18 //y2=0.72
cc_600 ( N_GND_c_399_p N_noxref_21_c_3157_n ) capacitor c=0.0363043f \
 //x=22.835 //y=0.175 //x2=22.18 //y2=0.72
cc_601 ( N_GND_c_333_n N_noxref_21_c_3157_n ) capacitor c=0.00189358f \
 //x=25.965 //y=0.18 //x2=22.18 //y2=0.72
cc_602 ( N_GND_c_339_p N_noxref_21_c_3160_n ) capacitor c=0.00286787f \
 //x=25.965 //y=0.18 //x2=22.265 //y2=0.805
cc_603 ( N_GND_c_399_p N_noxref_21_c_3160_n ) capacitor c=0.0142801f \
 //x=22.835 //y=0.175 //x2=22.265 //y2=0.805
cc_604 ( N_GND_c_338_n N_noxref_21_c_3160_n ) capacitor c=0.0404137f \
 //x=23.005 //y=0.175 //x2=22.265 //y2=0.805
cc_605 ( N_GND_M11_noxref_d N_noxref_21_M12_noxref_d ) capacitor c=0.00162435f \
 //x=19.08 //y=1.055 //x2=20.055 //y2=1.09
cc_606 ( N_GND_c_337_n N_noxref_21_M13_noxref_s ) capacitor c=8.16352e-19 \
 //x=18.195 //y=0.175 //x2=21.16 //y2=0.555
cc_607 ( N_GND_c_338_n N_noxref_21_M13_noxref_s ) capacitor c=0.00183576f \
 //x=23.005 //y=0.175 //x2=21.16 //y2=0.555
cc_608 ( N_GND_c_339_p N_noxref_22_c_3206_n ) capacitor c=0.00556334f \
 //x=25.965 //y=0.18 //x2=24.585 //y2=1.76
cc_609 ( N_GND_c_443_p N_noxref_22_c_3206_n ) capacitor c=0.00113126f //x=24.1 \
 //y=0.175 //x2=24.585 //y2=1.76
cc_610 ( N_GND_c_333_n N_noxref_22_c_3206_n ) capacitor c=0.00181083f \
 //x=25.965 //y=0.18 //x2=24.585 //y2=1.76
cc_611 ( N_GND_M14_noxref_d N_noxref_22_c_3206_n ) capacitor c=0.00897392f \
 //x=23.995 //y=1.045 //x2=24.585 //y2=1.76
cc_612 ( N_GND_c_339_p N_noxref_22_c_3210_n ) capacitor c=0.00302993f \
 //x=25.965 //y=0.18 //x2=24.67 //y2=0.795
cc_613 ( N_GND_c_333_n N_noxref_22_c_3210_n ) capacitor c=0.014661f //x=25.965 \
 //y=0.18 //x2=24.67 //y2=0.795
cc_614 ( N_GND_M14_noxref_d N_noxref_22_c_3210_n ) capacitor c=0.033812f \
 //x=23.995 //y=1.045 //x2=24.67 //y2=0.795
cc_615 ( N_GND_c_338_n N_noxref_22_c_3213_n ) capacitor c=2.91423e-19 \
 //x=23.005 //y=0.175 //x2=24.67 //y2=1.675
cc_616 ( N_GND_c_339_p N_noxref_22_c_3214_n ) capacitor c=0.0124224f \
 //x=25.965 //y=0.18 //x2=25.555 //y2=0.71
cc_617 ( N_GND_c_333_n N_noxref_22_c_3214_n ) capacitor c=0.0391339f \
 //x=25.965 //y=0.18 //x2=25.555 //y2=0.71
cc_618 ( N_GND_c_339_p N_noxref_22_c_3216_n ) capacitor c=0.00302312f \
 //x=25.965 //y=0.18 //x2=25.64 //y2=0.795
cc_619 ( N_GND_c_333_n N_noxref_22_c_3216_n ) capacitor c=0.0584168f \
 //x=25.965 //y=0.18 //x2=25.64 //y2=0.795
cc_620 ( N_GND_c_339_p N_noxref_22_M14_noxref_s ) capacitor c=0.00293362f \
 //x=25.965 //y=0.18 //x2=23.565 //y2=0.545
cc_621 ( N_GND_c_443_p N_noxref_22_M14_noxref_s ) capacitor c=0.0149577f \
 //x=24.1 //y=0.175 //x2=23.565 //y2=0.545
cc_622 ( N_GND_c_333_n N_noxref_22_M14_noxref_s ) capacitor c=0.00198482f \
 //x=25.965 //y=0.18 //x2=23.565 //y2=0.545
cc_623 ( N_GND_c_338_n N_noxref_22_M14_noxref_s ) capacitor c=0.0583534f \
 //x=23.005 //y=0.175 //x2=23.565 //y2=0.545
cc_624 ( N_GND_M14_noxref_d N_noxref_22_M14_noxref_s ) capacitor c=0.0334197f \
 //x=23.995 //y=1.045 //x2=23.565 //y2=0.545
cc_625 ( N_noxref_3_c_680_n N_noxref_4_c_949_n ) capacitor c=0.011463f \
 //x=11.05 //y=3.51 //x2=12.76 //y2=3.51
cc_626 ( N_noxref_3_M29_noxref_g N_noxref_4_c_901_n ) capacitor c=0.0169521f \
 //x=11.505 //y=6.2 //x2=12.08 //y2=5.38
cc_627 ( N_noxref_3_c_648_n N_noxref_4_c_905_n ) capacitor c=0.00539951f \
 //x=11.165 //y=2.26 //x2=11.37 //y2=5.38
cc_628 ( N_noxref_3_M28_noxref_g N_noxref_4_c_905_n ) capacitor c=0.0177326f \
 //x=11.065 //y=6.2 //x2=11.37 //y2=5.38
cc_629 ( N_noxref_3_c_659_n N_noxref_4_c_905_n ) capacitor c=0.00581252f \
 //x=11.165 //y=4.88 //x2=11.37 //y2=5.38
cc_630 ( N_noxref_3_c_647_n N_noxref_4_c_910_n ) capacitor c=3.52729e-19 \
 //x=9.315 //y=3.51 //x2=12.645 //y2=3.51
cc_631 ( N_noxref_3_c_648_n N_noxref_4_c_910_n ) capacitor c=0.00292364f \
 //x=11.165 //y=2.26 //x2=12.645 //y2=3.51
cc_632 ( N_noxref_3_M29_noxref_g N_noxref_4_M28_noxref_d ) capacitor \
 c=0.0173476f //x=11.505 //y=6.2 //x2=11.14 //y2=5.2
cc_633 ( N_noxref_3_c_675_n N_CLK_c_1050_n ) capacitor c=0.00360213f //x=9.2 \
 //y=3.51 //x2=15.49 //y2=4.62
cc_634 ( N_noxref_3_c_679_n N_CLK_c_1050_n ) capacitor c=4.49102e-19 //x=3.88 \
 //y=3.51 //x2=15.49 //y2=4.62
cc_635 ( N_noxref_3_c_632_n N_CLK_c_1050_n ) capacitor c=0.0198958f //x=3.765 \
 //y=2.26 //x2=15.49 //y2=4.62
cc_636 ( N_noxref_3_c_633_n N_CLK_c_1050_n ) capacitor c=0.0317819f //x=7.57 \
 //y=5.335 //x2=15.49 //y2=4.62
cc_637 ( N_noxref_3_c_637_n N_CLK_c_1050_n ) capacitor c=0.0230136f //x=6.86 \
 //y=5.335 //x2=15.49 //y2=4.62
cc_638 ( N_noxref_3_c_643_n N_CLK_c_1050_n ) capacitor c=0.0178724f //x=9.23 \
 //y=5.335 //x2=15.49 //y2=4.62
cc_639 ( N_noxref_3_c_647_n N_CLK_c_1050_n ) capacitor c=0.0210274f //x=9.315 \
 //y=3.51 //x2=15.49 //y2=4.62
cc_640 ( N_noxref_3_c_648_n N_CLK_c_1050_n ) capacitor c=0.0198304f //x=11.165 \
 //y=2.26 //x2=15.49 //y2=4.62
cc_641 ( N_noxref_3_c_711_p N_CLK_c_1050_n ) capacitor c=0.0111881f //x=3.765 \
 //y=4.88 //x2=15.49 //y2=4.62
cc_642 ( N_noxref_3_c_659_n N_CLK_c_1050_n ) capacitor c=0.0107057f //x=11.165 \
 //y=4.88 //x2=15.49 //y2=4.62
cc_643 ( N_noxref_3_c_632_n N_CLK_c_1067_n ) capacitor c=0.00153281f //x=3.765 \
 //y=2.26 //x2=2.77 //y2=4.62
cc_644 ( N_noxref_3_c_632_n CLK ) capacitor c=0.00493712f //x=3.765 //y=2.26 \
 //x2=2.71 //y2=2.77
cc_645 ( N_noxref_3_c_632_n CLK ) capacitor c=0.00493712f //x=3.765 //y=2.26 \
 //x2=2.71 //y2=3.14
cc_646 ( N_noxref_3_c_679_n CLK ) capacitor c=0.00446435f //x=3.88 //y=3.51 \
 //x2=2.71 //y2=3.51
cc_647 ( N_noxref_3_c_632_n CLK ) capacitor c=0.00329813f //x=3.765 //y=2.26 \
 //x2=2.71 //y2=3.51
cc_648 ( N_noxref_3_c_632_n CLK ) capacitor c=0.00455774f //x=3.765 //y=2.26 \
 //x2=2.71 //y2=3.88
cc_649 ( N_noxref_3_c_632_n CLK ) capacitor c=0.00190929f //x=3.765 //y=2.26 \
 //x2=2.71 //y2=4.62
cc_650 ( N_noxref_3_c_632_n N_CLK_c_1080_n ) capacitor c=0.0102353f //x=3.765 \
 //y=2.26 //x2=2.655 //y2=2.26
cc_651 ( N_noxref_3_c_721_p N_CLK_c_1080_n ) capacitor c=0.00228632f //x=3.765 \
 //y=2.26 //x2=2.655 //y2=2.26
cc_652 ( N_noxref_3_c_632_n N_CLK_c_1068_n ) capacitor c=0.00467264f //x=3.765 \
 //y=2.26 //x2=2.655 //y2=4.88
cc_653 ( N_noxref_3_c_711_p N_CLK_c_1068_n ) capacitor c=0.00218014f //x=3.765 \
 //y=4.88 //x2=2.655 //y2=4.88
cc_654 ( N_noxref_3_c_632_n N_CLK_c_1103_n ) capacitor c=0.0042159f //x=3.765 \
 //y=2.26 //x2=2.682 //y2=3.055
cc_655 ( N_noxref_3_c_679_n N_CLK_c_1104_n ) capacitor c=6.33859e-19 //x=3.88 \
 //y=3.51 //x2=2.682 //y2=3.425
cc_656 ( N_noxref_3_c_632_n N_CLK_c_1104_n ) capacitor c=0.00395201f //x=3.765 \
 //y=2.26 //x2=2.682 //y2=3.425
cc_657 ( N_noxref_3_c_679_n N_CLK_c_1106_n ) capacitor c=6.33859e-19 //x=3.88 \
 //y=3.51 //x2=2.682 //y2=3.795
cc_658 ( N_noxref_3_c_632_n N_CLK_c_1106_n ) capacitor c=0.00391381f //x=3.765 \
 //y=2.26 //x2=2.682 //y2=3.795
cc_659 ( N_noxref_3_c_632_n N_CLK_c_1070_n ) capacitor c=0.00930728f //x=3.765 \
 //y=2.26 //x2=2.682 //y2=4.535
cc_660 ( N_noxref_3_M20_noxref_g N_CLK_M18_noxref_g ) capacitor c=0.0101598f \
 //x=3.505 //y=6.2 //x2=2.625 //y2=6.2
cc_661 ( N_noxref_3_M20_noxref_g N_CLK_M19_noxref_g ) capacitor c=0.0602553f \
 //x=3.505 //y=6.2 //x2=3.065 //y2=6.2
cc_662 ( N_noxref_3_M21_noxref_g N_CLK_M19_noxref_g ) capacitor c=0.0101598f \
 //x=3.945 //y=6.2 //x2=3.065 //y2=6.2
cc_663 ( N_noxref_3_c_733_p N_CLK_c_1112_n ) capacitor c=0.00456962f //x=3.755 \
 //y=1.095 //x2=2.745 //y2=1.09
cc_664 ( N_noxref_3_c_734_p N_CLK_c_1113_n ) capacitor c=0.00438372f //x=3.755 \
 //y=1.44 //x2=2.745 //y2=1.4
cc_665 ( N_noxref_3_c_735_p N_CLK_c_1114_n ) capacitor c=0.00438372f //x=3.755 \
 //y=1.75 //x2=2.745 //y2=1.63
cc_666 ( N_noxref_3_c_632_n N_CLK_c_1115_n ) capacitor c=0.0023343f //x=3.765 \
 //y=2.26 //x2=2.745 //y2=2.095
cc_667 ( N_noxref_3_c_721_p N_CLK_c_1115_n ) capacitor c=0.00933826f //x=3.765 \
 //y=2.26 //x2=2.745 //y2=2.095
cc_668 ( N_noxref_3_c_738_p N_CLK_c_1115_n ) capacitor c=0.00438372f //x=3.765 \
 //y=2.095 //x2=2.745 //y2=2.095
cc_669 ( N_noxref_3_c_711_p N_CLK_c_1118_n ) capacitor c=0.0611812f //x=3.765 \
 //y=4.88 //x2=2.99 //y2=4.97
cc_670 ( N_noxref_3_c_632_n N_CLK_c_1119_n ) capacitor c=0.00142741f //x=3.765 \
 //y=2.26 //x2=2.655 //y2=4.88
cc_671 ( N_noxref_3_c_711_p N_CLK_c_1119_n ) capacitor c=0.00487508f //x=3.765 \
 //y=4.88 //x2=2.655 //y2=4.88
cc_672 ( N_noxref_3_c_675_n N_noxref_6_c_1375_n ) capacitor c=0.146539f \
 //x=9.2 //y=3.51 //x2=6.24 //y2=3.88
cc_673 ( N_noxref_3_c_675_n N_noxref_6_c_1376_n ) capacitor c=0.0294746f \
 //x=9.2 //y=3.51 //x2=4.62 //y2=3.88
cc_674 ( N_noxref_3_c_632_n N_noxref_6_c_1376_n ) capacitor c=0.00687545f \
 //x=3.765 //y=2.26 //x2=4.62 //y2=3.88
cc_675 ( N_noxref_3_c_675_n N_noxref_6_c_1350_n ) capacitor c=0.238127f \
 //x=9.2 //y=3.51 //x2=19.19 //y2=3.88
cc_676 ( N_noxref_3_c_680_n N_noxref_6_c_1350_n ) capacitor c=0.175734f \
 //x=11.05 //y=3.51 //x2=19.19 //y2=3.88
cc_677 ( N_noxref_3_c_747_p N_noxref_6_c_1350_n ) capacitor c=0.0268386f \
 //x=9.43 //y=3.51 //x2=19.19 //y2=3.88
cc_678 ( N_noxref_3_c_647_n N_noxref_6_c_1350_n ) capacitor c=0.0206044f \
 //x=9.315 //y=3.51 //x2=19.19 //y2=3.88
cc_679 ( N_noxref_3_c_648_n N_noxref_6_c_1350_n ) capacitor c=0.0205831f \
 //x=11.165 //y=2.26 //x2=19.19 //y2=3.88
cc_680 ( N_noxref_3_c_675_n N_noxref_6_c_1383_n ) capacitor c=0.0266966f \
 //x=9.2 //y=3.51 //x2=6.47 //y2=3.88
cc_681 ( N_noxref_3_M20_noxref_g N_noxref_6_c_1308_n ) capacitor c=0.01736f \
 //x=3.505 //y=6.2 //x2=3.64 //y2=5.335
cc_682 ( N_noxref_3_c_637_n N_noxref_6_c_1312_n ) capacitor c=3.10026e-19 \
 //x=6.86 //y=5.335 //x2=4.42 //y2=5.335
cc_683 ( N_noxref_3_M21_noxref_g N_noxref_6_c_1312_n ) capacitor c=0.0194981f \
 //x=3.945 //y=6.2 //x2=4.42 //y2=5.335
cc_684 ( N_noxref_3_c_711_p N_noxref_6_c_1312_n ) capacitor c=0.00201851f \
 //x=3.765 //y=4.88 //x2=4.42 //y2=5.335
cc_685 ( N_noxref_3_c_755_p N_noxref_6_c_1351_n ) capacitor c=0.00359704f \
 //x=4.13 //y=1.595 //x2=4.42 //y2=1.845
cc_686 ( N_noxref_3_c_756_p N_noxref_6_c_1351_n ) capacitor c=0.00457401f \
 //x=4.285 //y=1.44 //x2=4.42 //y2=1.845
cc_687 ( N_noxref_3_c_675_n N_noxref_6_c_1390_n ) capacitor c=0.00628992f \
 //x=9.2 //y=3.51 //x2=4.105 //y2=1.845
cc_688 ( N_noxref_3_c_675_n N_noxref_6_c_1316_n ) capacitor c=0.0260398f \
 //x=9.2 //y=3.51 //x2=4.505 //y2=3.88
cc_689 ( N_noxref_3_c_679_n N_noxref_6_c_1316_n ) capacitor c=0.00179385f \
 //x=3.88 //y=3.51 //x2=4.505 //y2=3.88
cc_690 ( N_noxref_3_c_632_n N_noxref_6_c_1316_n ) capacitor c=0.0831612f \
 //x=3.765 //y=2.26 //x2=4.505 //y2=3.88
cc_691 ( N_noxref_3_c_721_p N_noxref_6_c_1316_n ) capacitor c=0.00877984f \
 //x=3.765 //y=2.26 //x2=4.505 //y2=3.88
cc_692 ( N_noxref_3_c_738_p N_noxref_6_c_1316_n ) capacitor c=0.00283672f \
 //x=3.765 //y=2.095 //x2=4.505 //y2=3.88
cc_693 ( N_noxref_3_c_711_p N_noxref_6_c_1316_n ) capacitor c=0.013693f \
 //x=3.765 //y=4.88 //x2=4.505 //y2=3.88
cc_694 ( N_noxref_3_c_675_n N_noxref_6_c_1317_n ) capacitor c=0.0268062f \
 //x=9.2 //y=3.51 //x2=6.355 //y2=2.26
cc_695 ( N_noxref_3_c_632_n N_noxref_6_c_1317_n ) capacitor c=9.66956e-19 \
 //x=3.765 //y=2.26 //x2=6.355 //y2=2.26
cc_696 ( N_noxref_3_c_632_n N_noxref_6_c_1399_n ) capacitor c=0.0171303f \
 //x=3.765 //y=2.26 //x2=3.725 //y2=5.335
cc_697 ( N_noxref_3_c_711_p N_noxref_6_c_1399_n ) capacitor c=0.00475601f \
 //x=3.765 //y=4.88 //x2=3.725 //y2=5.335
cc_698 ( N_noxref_3_c_637_n N_noxref_6_M22_noxref_g ) capacitor c=0.0213876f \
 //x=6.86 //y=5.335 //x2=6.555 //y2=6.2
cc_699 ( N_noxref_3_c_633_n N_noxref_6_M23_noxref_g ) capacitor c=0.0168349f \
 //x=7.57 //y=5.335 //x2=6.995 //y2=6.2
cc_700 ( N_noxref_3_M22_noxref_d N_noxref_6_M23_noxref_g ) capacitor \
 c=0.0180032f //x=6.63 //y=5.2 //x2=6.995 //y2=6.2
cc_701 ( N_noxref_3_c_637_n N_noxref_6_c_1404_n ) capacitor c=0.00428486f \
 //x=6.86 //y=5.335 //x2=6.92 //y2=4.97
cc_702 ( N_noxref_3_c_733_p N_noxref_6_M2_noxref_d ) capacitor c=0.00217566f \
 //x=3.755 //y=1.095 //x2=3.83 //y2=1.095
cc_703 ( N_noxref_3_c_734_p N_noxref_6_M2_noxref_d ) capacitor c=0.0034598f \
 //x=3.755 //y=1.44 //x2=3.83 //y2=1.095
cc_704 ( N_noxref_3_c_735_p N_noxref_6_M2_noxref_d ) capacitor c=0.00544291f \
 //x=3.755 //y=1.75 //x2=3.83 //y2=1.095
cc_705 ( N_noxref_3_c_775_p N_noxref_6_M2_noxref_d ) capacitor c=0.00241102f \
 //x=4.13 //y=0.94 //x2=3.83 //y2=1.095
cc_706 ( N_noxref_3_c_755_p N_noxref_6_M2_noxref_d ) capacitor c=0.0140297f \
 //x=4.13 //y=1.595 //x2=3.83 //y2=1.095
cc_707 ( N_noxref_3_c_777_p N_noxref_6_M2_noxref_d ) capacitor c=0.00219619f \
 //x=4.285 //y=1.095 //x2=3.83 //y2=1.095
cc_708 ( N_noxref_3_c_756_p N_noxref_6_M2_noxref_d ) capacitor c=0.00603828f \
 //x=4.285 //y=1.44 //x2=3.83 //y2=1.095
cc_709 ( N_noxref_3_c_738_p N_noxref_6_M2_noxref_d ) capacitor c=0.00661782f \
 //x=3.765 //y=2.095 //x2=3.83 //y2=1.095
cc_710 ( N_noxref_3_M20_noxref_g N_noxref_6_M20_noxref_d ) capacitor \
 c=0.0180032f //x=3.505 //y=6.2 //x2=3.58 //y2=5.2
cc_711 ( N_noxref_3_M21_noxref_g N_noxref_6_M20_noxref_d ) capacitor \
 c=0.0194246f //x=3.945 //y=6.2 //x2=3.58 //y2=5.2
cc_712 ( N_noxref_3_c_675_n N_RN_c_1573_n ) capacitor c=0.0139288f //x=9.2 \
 //y=3.51 //x2=16.6 //y2=2.4
cc_713 ( N_noxref_3_c_680_n N_RN_c_1573_n ) capacitor c=0.0541047f //x=11.05 \
 //y=3.51 //x2=16.6 //y2=2.4
cc_714 ( N_noxref_3_c_747_p N_RN_c_1573_n ) capacitor c=0.00680007f //x=9.43 \
 //y=3.51 //x2=16.6 //y2=2.4
cc_715 ( N_noxref_3_c_785_p N_RN_c_1573_n ) capacitor c=0.016327f //x=8.915 \
 //y=1.845 //x2=16.6 //y2=2.4
cc_716 ( N_noxref_3_c_647_n N_RN_c_1573_n ) capacitor c=0.0234656f //x=9.315 \
 //y=3.51 //x2=16.6 //y2=2.4
cc_717 ( N_noxref_3_c_648_n N_RN_c_1573_n ) capacitor c=0.022454f //x=11.165 \
 //y=2.26 //x2=16.6 //y2=2.4
cc_718 ( N_noxref_3_c_688_n N_RN_c_1573_n ) capacitor c=0.00814985f //x=10.97 \
 //y=2.095 //x2=16.6 //y2=2.4
cc_719 ( N_noxref_3_c_675_n N_RN_c_1581_n ) capacitor c=0.00771742f //x=9.2 \
 //y=3.51 //x2=8.69 //y2=2.4
cc_720 ( N_noxref_3_c_647_n N_RN_c_1581_n ) capacitor c=0.00184436f //x=9.315 \
 //y=3.51 //x2=8.69 //y2=2.4
cc_721 ( N_noxref_3_c_647_n RN ) capacitor c=0.00777753f //x=9.315 //y=3.51 \
 //x2=8.63 //y2=2.77
cc_722 ( N_noxref_3_c_675_n RN ) capacitor c=0.00159045f //x=9.2 //y=3.51 \
 //x2=8.63 //y2=3.14
cc_723 ( N_noxref_3_c_643_n RN ) capacitor c=3.18632e-19 //x=9.23 //y=5.335 \
 //x2=8.63 //y2=3.14
cc_724 ( N_noxref_3_c_647_n RN ) capacitor c=0.00777753f //x=9.315 //y=3.51 \
 //x2=8.63 //y2=3.14
cc_725 ( N_noxref_3_c_647_n N_RN_c_1606_n ) capacitor c=0.00952708f //x=9.315 \
 //y=3.51 //x2=8.575 //y2=2.485
cc_726 ( N_noxref_3_c_675_n N_RN_c_1557_n ) capacitor c=0.0217783f //x=9.2 \
 //y=3.51 //x2=8.575 //y2=4.88
cc_727 ( N_noxref_3_c_747_p N_RN_c_1557_n ) capacitor c=0.00131333f //x=9.43 \
 //y=3.51 //x2=8.575 //y2=4.88
cc_728 ( N_noxref_3_c_647_n N_RN_c_1557_n ) capacitor c=0.0468912f //x=9.315 \
 //y=3.51 //x2=8.575 //y2=4.88
cc_729 ( N_noxref_3_c_648_n N_RN_c_1557_n ) capacitor c=5.12611e-19 //x=11.165 \
 //y=2.26 //x2=8.575 //y2=4.88
cc_730 ( N_noxref_3_c_800_p N_RN_c_1557_n ) capacitor c=0.0171303f //x=8.535 \
 //y=5.335 //x2=8.575 //y2=4.88
cc_731 ( N_noxref_3_c_647_n N_RN_c_1590_n ) capacitor c=0.00619366f //x=9.315 \
 //y=3.51 //x2=8.602 //y2=2.685
cc_732 ( N_noxref_3_c_647_n N_RN_c_1613_n ) capacitor c=0.0065098f //x=9.315 \
 //y=3.51 //x2=8.602 //y2=3.055
cc_733 ( N_noxref_3_c_639_n N_RN_M26_noxref_g ) capacitor c=0.01736f //x=8.45 \
 //y=5.335 //x2=8.315 //y2=6.2
cc_734 ( N_noxref_3_M26_noxref_d N_RN_M26_noxref_g ) capacitor c=0.0180032f \
 //x=8.39 //y=5.2 //x2=8.315 //y2=6.2
cc_735 ( N_noxref_3_c_643_n N_RN_M27_noxref_g ) capacitor c=0.0196497f \
 //x=9.23 //y=5.335 //x2=8.755 //y2=6.2
cc_736 ( N_noxref_3_M26_noxref_d N_RN_M27_noxref_g ) capacitor c=0.0194246f \
 //x=8.39 //y=5.2 //x2=8.755 //y2=6.2
cc_737 ( N_noxref_3_M5_noxref_d N_RN_c_1618_n ) capacitor c=0.00217566f \
 //x=8.64 //y=1.095 //x2=8.565 //y2=1.095
cc_738 ( N_noxref_3_M5_noxref_d N_RN_c_1619_n ) capacitor c=0.0034598f \
 //x=8.64 //y=1.095 //x2=8.565 //y2=1.44
cc_739 ( N_noxref_3_M5_noxref_d N_RN_c_1620_n ) capacitor c=0.00546784f \
 //x=8.64 //y=1.095 //x2=8.565 //y2=1.75
cc_740 ( N_noxref_3_M5_noxref_d N_RN_c_1621_n ) capacitor c=0.00241102f \
 //x=8.64 //y=1.095 //x2=8.94 //y2=0.94
cc_741 ( N_noxref_3_c_682_n N_RN_c_1622_n ) capacitor c=0.00371277f //x=9.23 \
 //y=1.845 //x2=8.94 //y2=1.595
cc_742 ( N_noxref_3_M5_noxref_d N_RN_c_1622_n ) capacitor c=0.0138621f \
 //x=8.64 //y=1.095 //x2=8.94 //y2=1.595
cc_743 ( N_noxref_3_M5_noxref_d N_RN_c_1624_n ) capacitor c=0.00219619f \
 //x=8.64 //y=1.095 //x2=9.095 //y2=1.095
cc_744 ( N_noxref_3_c_682_n N_RN_c_1625_n ) capacitor c=0.00457401f //x=9.23 \
 //y=1.845 //x2=9.095 //y2=1.44
cc_745 ( N_noxref_3_M5_noxref_d N_RN_c_1625_n ) capacitor c=0.00603828f \
 //x=8.64 //y=1.095 //x2=9.095 //y2=1.44
cc_746 ( N_noxref_3_c_647_n N_RN_c_1627_n ) capacitor c=0.00780434f //x=9.315 \
 //y=3.51 //x2=8.575 //y2=2.26
cc_747 ( N_noxref_3_c_647_n N_RN_c_1628_n ) capacitor c=0.00283672f //x=9.315 \
 //y=3.51 //x2=8.575 //y2=2.095
cc_748 ( N_noxref_3_M5_noxref_d N_RN_c_1628_n ) capacitor c=0.00661782f \
 //x=8.64 //y=1.095 //x2=8.575 //y2=2.095
cc_749 ( N_noxref_3_c_643_n N_RN_c_1630_n ) capacitor c=0.00201851f //x=9.23 \
 //y=5.335 //x2=8.575 //y2=4.88
cc_750 ( N_noxref_3_c_647_n N_RN_c_1630_n ) capacitor c=0.013844f //x=9.315 \
 //y=3.51 //x2=8.575 //y2=4.88
cc_751 ( N_noxref_3_c_800_p N_RN_c_1630_n ) capacitor c=0.00475601f //x=8.535 \
 //y=5.335 //x2=8.575 //y2=4.88
cc_752 ( N_noxref_3_c_675_n N_noxref_11_c_2240_n ) capacitor c=0.0559995f \
 //x=9.2 //y=3.51 //x2=11.79 //y2=4.25
cc_753 ( N_noxref_3_c_679_n N_noxref_11_c_2240_n ) capacitor c=0.0135672f \
 //x=3.88 //y=3.51 //x2=11.79 //y2=4.25
cc_754 ( N_noxref_3_c_680_n N_noxref_11_c_2240_n ) capacitor c=0.010979f \
 //x=11.05 //y=3.51 //x2=11.79 //y2=4.25
cc_755 ( N_noxref_3_c_747_p N_noxref_11_c_2240_n ) capacitor c=4.80262e-19 \
 //x=9.43 //y=3.51 //x2=11.79 //y2=4.25
cc_756 ( N_noxref_3_c_632_n N_noxref_11_c_2240_n ) capacitor c=0.0206302f \
 //x=3.765 //y=2.26 //x2=11.79 //y2=4.25
cc_757 ( N_noxref_3_c_647_n N_noxref_11_c_2240_n ) capacitor c=0.0181982f \
 //x=9.315 //y=3.51 //x2=11.79 //y2=4.25
cc_758 ( N_noxref_3_c_648_n N_noxref_11_c_2240_n ) capacitor c=0.0184765f \
 //x=11.165 //y=2.26 //x2=11.79 //y2=4.25
cc_759 ( N_noxref_3_c_648_n N_noxref_11_c_2343_n ) capacitor c=0.00179385f \
 //x=11.165 //y=2.26 //x2=12.02 //y2=4.25
cc_760 ( N_noxref_3_c_632_n N_noxref_11_c_2263_n ) capacitor c=0.0017677f \
 //x=3.765 //y=2.26 //x2=1.545 //y2=2.26
cc_761 ( N_noxref_3_c_648_n N_noxref_11_c_2345_n ) capacitor c=0.00400249f \
 //x=11.165 //y=2.26 //x2=11.905 //y2=4.715
cc_762 ( N_noxref_3_c_659_n N_noxref_11_c_2345_n ) capacitor c=0.00417994f \
 //x=11.165 //y=4.88 //x2=11.905 //y2=4.715
cc_763 ( N_noxref_3_c_680_n N_noxref_11_c_2266_n ) capacitor c=0.00318578f \
 //x=11.05 //y=3.51 //x2=11.905 //y2=2.26
cc_764 ( N_noxref_3_c_647_n N_noxref_11_c_2266_n ) capacitor c=9.69022e-19 \
 //x=9.315 //y=3.51 //x2=11.905 //y2=2.26
cc_765 ( N_noxref_3_c_648_n N_noxref_11_c_2266_n ) capacitor c=0.0771626f \
 //x=11.165 //y=2.26 //x2=11.905 //y2=2.26
cc_766 ( N_noxref_3_c_688_n N_noxref_11_c_2266_n ) capacitor c=0.00284029f \
 //x=10.97 //y=2.095 //x2=11.905 //y2=2.26
cc_767 ( N_noxref_3_M28_noxref_g N_noxref_11_M30_noxref_g ) capacitor \
 c=0.0104611f //x=11.065 //y=6.2 //x2=11.945 //y2=6.2
cc_768 ( N_noxref_3_M29_noxref_g N_noxref_11_M30_noxref_g ) capacitor \
 c=0.106811f //x=11.505 //y=6.2 //x2=11.945 //y2=6.2
cc_769 ( N_noxref_3_M29_noxref_g N_noxref_11_M31_noxref_g ) capacitor \
 c=0.0100341f //x=11.505 //y=6.2 //x2=12.385 //y2=6.2
cc_770 ( N_noxref_3_c_684_n N_noxref_11_c_2354_n ) capacitor c=4.86506e-19 \
 //x=10.97 //y=1.045 //x2=11.94 //y2=1.085
cc_771 ( N_noxref_3_c_686_n N_noxref_11_c_2354_n ) capacitor c=0.00152104f \
 //x=10.97 //y=1.39 //x2=11.94 //y2=1.085
cc_772 ( N_noxref_3_c_691_n N_noxref_11_c_2354_n ) capacitor c=0.0151475f \
 //x=11.5 //y=1.045 //x2=11.94 //y2=1.085
cc_773 ( N_noxref_3_c_687_n N_noxref_11_c_2357_n ) capacitor c=0.00109982f \
 //x=10.97 //y=1.7 //x2=11.94 //y2=1.43
cc_774 ( N_noxref_3_c_693_n N_noxref_11_c_2357_n ) capacitor c=0.0111064f \
 //x=11.5 //y=1.39 //x2=11.94 //y2=1.43
cc_775 ( N_noxref_3_c_687_n N_noxref_11_c_2359_n ) capacitor c=9.57794e-19 \
 //x=10.97 //y=1.7 //x2=11.94 //y2=1.74
cc_776 ( N_noxref_3_c_688_n N_noxref_11_c_2359_n ) capacitor c=0.00662747f \
 //x=10.97 //y=2.095 //x2=11.94 //y2=1.74
cc_777 ( N_noxref_3_c_693_n N_noxref_11_c_2359_n ) capacitor c=0.00862358f \
 //x=11.5 //y=1.39 //x2=11.94 //y2=1.74
cc_778 ( N_noxref_3_c_691_n N_noxref_11_c_2362_n ) capacitor c=0.00124821f \
 //x=11.5 //y=1.045 //x2=12.47 //y2=1.085
cc_779 ( N_noxref_3_c_693_n N_noxref_11_c_2363_n ) capacitor c=0.00200715f \
 //x=11.5 //y=1.39 //x2=12.47 //y2=1.43
cc_780 ( N_noxref_3_c_648_n N_noxref_11_c_2364_n ) capacitor c=0.00282278f \
 //x=11.165 //y=2.26 //x2=11.905 //y2=2.26
cc_781 ( N_noxref_3_c_688_n N_noxref_11_c_2364_n ) capacitor c=0.0172771f \
 //x=10.97 //y=2.095 //x2=11.905 //y2=2.26
cc_782 ( N_noxref_3_c_648_n N_noxref_11_c_2366_n ) capacitor c=0.00344981f \
 //x=11.165 //y=2.26 //x2=11.935 //y2=4.88
cc_783 ( N_noxref_3_c_659_n N_noxref_11_c_2366_n ) capacitor c=0.0293367f \
 //x=11.165 //y=4.88 //x2=11.935 //y2=4.88
cc_784 ( N_noxref_3_c_675_n N_noxref_13_c_2701_n ) capacitor c=2.45218e-19 \
 //x=9.2 //y=3.51 //x2=4.42 //y2=0.72
cc_785 ( N_noxref_3_c_632_n N_noxref_13_c_2701_n ) capacitor c=0.00208521f \
 //x=3.765 //y=2.26 //x2=4.42 //y2=0.72
cc_786 ( N_noxref_3_c_733_p N_noxref_13_c_2701_n ) capacitor c=0.0194423f \
 //x=3.755 //y=1.095 //x2=4.42 //y2=0.72
cc_787 ( N_noxref_3_c_777_p N_noxref_13_c_2701_n ) capacitor c=0.00656458f \
 //x=4.285 //y=1.095 //x2=4.42 //y2=0.72
cc_788 ( N_noxref_3_c_721_p N_noxref_13_c_2701_n ) capacitor c=2.20712e-19 \
 //x=3.765 //y=2.26 //x2=4.42 //y2=0.72
cc_789 ( N_noxref_3_c_734_p N_noxref_13_c_2715_n ) capacitor c=0.00538829f \
 //x=3.755 //y=1.44 //x2=3.535 //y2=1.175
cc_790 ( N_noxref_3_c_733_p N_noxref_13_M2_noxref_s ) capacitor c=0.00538829f \
 //x=3.755 //y=1.095 //x2=3.4 //y2=0.555
cc_791 ( N_noxref_3_c_735_p N_noxref_13_M2_noxref_s ) capacitor c=0.00538829f \
 //x=3.755 //y=1.75 //x2=3.4 //y2=0.555
cc_792 ( N_noxref_3_c_777_p N_noxref_13_M2_noxref_s ) capacitor c=0.0143002f \
 //x=4.285 //y=1.095 //x2=3.4 //y2=0.555
cc_793 ( N_noxref_3_c_756_p N_noxref_13_M2_noxref_s ) capacitor c=0.00290153f \
 //x=4.285 //y=1.44 //x2=3.4 //y2=0.555
cc_794 ( N_noxref_3_c_633_n D ) capacitor c=2.11075e-19 //x=7.57 //y=5.335 \
 //x2=7.52 //y2=2.77
cc_795 ( N_noxref_3_c_675_n D ) capacitor c=0.00210908f //x=9.2 //y=3.51 \
 //x2=7.52 //y2=3.14
cc_796 ( N_noxref_3_c_633_n D ) capacitor c=4.68359e-19 //x=7.57 //y=5.335 \
 //x2=7.52 //y2=3.14
cc_797 ( N_noxref_3_c_647_n N_D_c_2755_n ) capacitor c=6.69447e-19 //x=9.315 \
 //y=3.51 //x2=7.465 //y2=2.26
cc_798 ( N_noxref_3_c_675_n N_D_c_2749_n ) capacitor c=0.0242474f //x=9.2 \
 //y=3.51 //x2=7.465 //y2=4.88
cc_799 ( N_noxref_3_c_633_n N_D_c_2749_n ) capacitor c=0.0144268f //x=7.57 \
 //y=5.335 //x2=7.465 //y2=4.88
cc_800 ( N_noxref_3_c_647_n N_D_c_2749_n ) capacitor c=0.00138806f //x=9.315 \
 //y=3.51 //x2=7.465 //y2=4.88
cc_801 ( N_noxref_3_c_633_n N_D_M24_noxref_g ) capacitor c=0.0165266f //x=7.57 \
 //y=5.335 //x2=7.435 //y2=6.2
cc_802 ( N_noxref_3_M24_noxref_d N_D_M24_noxref_g ) capacitor c=0.0180032f \
 //x=7.51 //y=5.2 //x2=7.435 //y2=6.2
cc_803 ( N_noxref_3_c_639_n N_D_M25_noxref_g ) capacitor c=0.01736f //x=8.45 \
 //y=5.335 //x2=7.875 //y2=6.2
cc_804 ( N_noxref_3_M24_noxref_d N_D_M25_noxref_g ) capacitor c=0.0180032f \
 //x=7.51 //y=5.2 //x2=7.875 //y2=6.2
cc_805 ( N_noxref_3_c_875_p N_D_c_2767_n ) capacitor c=0.00424175f //x=7.655 \
 //y=5.335 //x2=7.8 //y2=4.97
cc_806 ( N_noxref_3_c_633_n N_D_c_2768_n ) capacitor c=0.00322054f //x=7.57 \
 //y=5.335 //x2=7.465 //y2=4.88
cc_807 ( N_noxref_3_c_675_n N_noxref_15_c_2854_n ) capacitor c=0.00243521f \
 //x=9.2 //y=3.51 //x2=5.835 //y2=1.685
cc_808 ( N_noxref_3_c_675_n N_noxref_15_c_2838_n ) capacitor c=0.0103731f \
 //x=9.2 //y=3.51 //x2=6.72 //y2=1.77
cc_809 ( N_noxref_3_c_675_n N_noxref_15_c_2856_n ) capacitor c=0.00713063f \
 //x=9.2 //y=3.51 //x2=7.69 //y2=1.77
cc_810 ( N_noxref_3_c_675_n N_noxref_15_M3_noxref_s ) capacitor c=0.00470578f \
 //x=9.2 //y=3.51 //x2=5.7 //y2=0.555
cc_811 ( N_noxref_3_M5_noxref_d N_noxref_15_M3_noxref_s ) capacitor \
 c=0.00309936f //x=8.64 //y=1.095 //x2=5.7 //y2=0.555
cc_812 ( N_noxref_3_c_675_n N_noxref_16_c_2889_n ) capacitor c=0.00306157f \
 //x=9.2 //y=3.51 //x2=8.26 //y2=1.175
cc_813 ( N_noxref_3_c_682_n N_noxref_16_c_2894_n ) capacitor c=0.00457167f \
 //x=9.23 //y=1.845 //x2=9.23 //y2=0.72
cc_814 ( N_noxref_3_M5_noxref_d N_noxref_16_c_2894_n ) capacitor c=0.0115903f \
 //x=8.64 //y=1.095 //x2=9.23 //y2=0.72
cc_815 ( N_noxref_3_c_785_p N_noxref_16_c_2906_n ) capacitor c=0.020048f \
 //x=8.915 //y=1.845 //x2=8.345 //y2=1.175
cc_816 ( N_noxref_3_M5_noxref_d N_noxref_16_M4_noxref_d ) capacitor \
 c=5.27807e-19 //x=8.64 //y=1.095 //x2=7.105 //y2=1.09
cc_817 ( N_noxref_3_c_675_n N_noxref_16_M5_noxref_s ) capacitor c=0.00243521f \
 //x=9.2 //y=3.51 //x2=8.21 //y2=0.555
cc_818 ( N_noxref_3_c_682_n N_noxref_16_M5_noxref_s ) capacitor c=0.0196084f \
 //x=9.23 //y=1.845 //x2=8.21 //y2=0.555
cc_819 ( N_noxref_3_M5_noxref_d N_noxref_16_M5_noxref_s ) capacitor \
 c=0.0426444f //x=8.64 //y=1.095 //x2=8.21 //y2=0.555
cc_820 ( N_noxref_3_c_682_n N_noxref_17_c_2962_n ) capacitor c=3.04182e-19 \
 //x=9.23 //y=1.845 //x2=10.75 //y2=1.675
cc_821 ( N_noxref_3_c_688_n N_noxref_17_c_2962_n ) capacitor c=0.0034165f \
 //x=10.97 //y=2.095 //x2=10.75 //y2=1.675
cc_822 ( N_noxref_3_c_648_n N_noxref_17_c_2943_n ) capacitor c=0.011618f \
 //x=11.165 //y=2.26 //x2=11.635 //y2=1.76
cc_823 ( N_noxref_3_c_687_n N_noxref_17_c_2943_n ) capacitor c=0.00696403f \
 //x=10.97 //y=1.7 //x2=11.635 //y2=1.76
cc_824 ( N_noxref_3_c_688_n N_noxref_17_c_2943_n ) capacitor c=0.0174694f \
 //x=10.97 //y=2.095 //x2=11.635 //y2=1.76
cc_825 ( N_noxref_3_c_690_n N_noxref_17_c_2943_n ) capacitor c=0.00776811f \
 //x=11.345 //y=1.545 //x2=11.635 //y2=1.76
cc_826 ( N_noxref_3_c_693_n N_noxref_17_c_2943_n ) capacitor c=0.00339872f \
 //x=11.5 //y=1.39 //x2=11.635 //y2=1.76
cc_827 ( N_noxref_3_c_688_n N_noxref_17_c_2950_n ) capacitor c=6.71402e-19 \
 //x=10.97 //y=2.095 //x2=11.72 //y2=1.675
cc_828 ( N_noxref_3_c_684_n N_noxref_17_M6_noxref_s ) capacitor c=0.0327502f \
 //x=10.97 //y=1.045 //x2=10.615 //y2=0.545
cc_829 ( N_noxref_3_c_687_n N_noxref_17_M6_noxref_s ) capacitor c=3.48408e-19 \
 //x=10.97 //y=1.7 //x2=10.615 //y2=0.545
cc_830 ( N_noxref_3_c_691_n N_noxref_17_M6_noxref_s ) capacitor c=0.0120759f \
 //x=11.5 //y=1.045 //x2=10.615 //y2=0.545
cc_831 ( N_noxref_4_c_901_n N_CLK_c_1050_n ) capacitor c=0.0185297f //x=12.08 \
 //y=5.38 //x2=15.49 //y2=4.62
cc_832 ( N_noxref_4_c_905_n N_CLK_c_1050_n ) capacitor c=0.018142f //x=11.37 \
 //y=5.38 //x2=15.49 //y2=4.62
cc_833 ( N_noxref_4_c_910_n N_CLK_c_1050_n ) capacitor c=0.0208321f //x=12.645 \
 //y=3.51 //x2=15.49 //y2=4.62
cc_834 ( N_noxref_4_c_912_n N_CLK_c_1050_n ) capacitor c=0.0224037f //x=14.495 \
 //y=2.26 //x2=15.49 //y2=4.62
cc_835 ( N_noxref_4_c_919_n N_CLK_c_1050_n ) capacitor c=0.0168539f //x=14.77 \
 //y=4.97 //x2=15.49 //y2=4.62
cc_836 ( N_noxref_4_c_932_n CLK ) capacitor c=0.00447621f //x=14.38 //y=3.51 \
 //x2=15.66 //y2=3.51
cc_837 ( N_noxref_4_c_912_n N_CLK_c_1081_n ) capacitor c=0.0467784f //x=14.495 \
 //y=2.26 //x2=15.605 //y2=2.26
cc_838 ( N_noxref_4_c_940_n N_CLK_c_1081_n ) capacitor c=0.00210802f \
 //x=14.195 //y=2.095 //x2=15.605 //y2=2.26
cc_839 ( N_noxref_4_c_965_p N_CLK_c_1069_n ) capacitor c=0.00147352f //x=15.06 \
 //y=4.97 //x2=15.605 //y2=4.88
cc_840 ( N_noxref_4_c_919_n N_CLK_c_1069_n ) capacitor c=0.00141297f //x=14.77 \
 //y=4.97 //x2=15.605 //y2=4.88
cc_841 ( N_noxref_4_c_910_n N_CLK_c_1131_n ) capacitor c=5.81655e-19 \
 //x=12.645 //y=3.51 //x2=15.632 //y2=3.055
cc_842 ( N_noxref_4_c_932_n N_CLK_c_1132_n ) capacitor c=4.93861e-19 //x=14.38 \
 //y=3.51 //x2=15.632 //y2=3.425
cc_843 ( N_noxref_4_c_932_n N_CLK_c_1071_n ) capacitor c=4.93861e-19 //x=14.38 \
 //y=3.51 //x2=15.632 //y2=4.535
cc_844 ( N_noxref_4_M32_noxref_g N_CLK_M34_noxref_g ) capacitor c=0.0105869f \
 //x=14.695 //y=6.2 //x2=15.575 //y2=6.2
cc_845 ( N_noxref_4_M33_noxref_g N_CLK_M34_noxref_g ) capacitor c=0.10632f \
 //x=15.135 //y=6.2 //x2=15.575 //y2=6.2
cc_846 ( N_noxref_4_M33_noxref_g N_CLK_M35_noxref_g ) capacitor c=0.0101598f \
 //x=15.135 //y=6.2 //x2=16.015 //y2=6.2
cc_847 ( N_noxref_4_c_936_n N_CLK_c_1137_n ) capacitor c=5.72482e-19 \
 //x=14.195 //y=1.055 //x2=15.17 //y2=1.09
cc_848 ( N_noxref_4_c_938_n N_CLK_c_1137_n ) capacitor c=0.00149976f \
 //x=14.195 //y=1.4 //x2=15.17 //y2=1.09
cc_849 ( N_noxref_4_c_943_n N_CLK_c_1137_n ) capacitor c=0.0160123f //x=14.725 \
 //y=1.055 //x2=15.17 //y2=1.09
cc_850 ( N_noxref_4_c_939_n N_CLK_c_1140_n ) capacitor c=0.00111227f \
 //x=14.195 //y=1.71 //x2=15.17 //y2=1.4
cc_851 ( N_noxref_4_c_945_n N_CLK_c_1140_n ) capacitor c=0.0124075f //x=14.725 \
 //y=1.4 //x2=15.17 //y2=1.4
cc_852 ( N_noxref_4_c_943_n N_CLK_c_1142_n ) capacitor c=0.00103227f \
 //x=14.725 //y=1.055 //x2=15.695 //y2=1.09
cc_853 ( N_noxref_4_c_945_n N_CLK_c_1143_n ) capacitor c=0.0010154f //x=14.725 \
 //y=1.4 //x2=15.695 //y2=1.4
cc_854 ( N_noxref_4_c_945_n N_CLK_c_1144_n ) capacitor c=9.23422e-19 \
 //x=14.725 //y=1.4 //x2=15.695 //y2=1.63
cc_855 ( N_noxref_4_c_912_n N_CLK_c_1145_n ) capacitor c=0.00203769f \
 //x=14.495 //y=2.26 //x2=15.695 //y2=2.095
cc_856 ( N_noxref_4_c_940_n N_CLK_c_1145_n ) capacitor c=0.00834532f \
 //x=14.195 //y=2.095 //x2=15.695 //y2=2.095
cc_857 ( N_noxref_4_c_912_n N_CLK_c_1147_n ) capacitor c=0.00183762f \
 //x=14.495 //y=2.26 //x2=15.605 //y2=4.88
cc_858 ( N_noxref_4_c_965_p N_CLK_c_1147_n ) capacitor c=0.0168581f //x=15.06 \
 //y=4.97 //x2=15.605 //y2=4.88
cc_859 ( N_noxref_4_c_919_n N_CLK_c_1147_n ) capacitor c=0.00484466f //x=14.77 \
 //y=4.97 //x2=15.605 //y2=4.88
cc_860 ( N_noxref_4_c_932_n N_noxref_6_c_1350_n ) capacitor c=0.176049f \
 //x=14.38 //y=3.51 //x2=19.19 //y2=3.88
cc_861 ( N_noxref_4_c_949_n N_noxref_6_c_1350_n ) capacitor c=0.0293967f \
 //x=12.76 //y=3.51 //x2=19.19 //y2=3.88
cc_862 ( N_noxref_4_c_910_n N_noxref_6_c_1350_n ) capacitor c=0.0206034f \
 //x=12.645 //y=3.51 //x2=19.19 //y2=3.88
cc_863 ( N_noxref_4_c_912_n N_noxref_6_c_1350_n ) capacitor c=0.0216236f \
 //x=14.495 //y=2.26 //x2=19.19 //y2=3.88
cc_864 ( N_noxref_4_c_932_n N_RN_c_1573_n ) capacitor c=0.0546488f //x=14.38 \
 //y=3.51 //x2=16.6 //y2=2.4
cc_865 ( N_noxref_4_c_949_n N_RN_c_1573_n ) capacitor c=0.00761783f //x=12.76 \
 //y=3.51 //x2=16.6 //y2=2.4
cc_866 ( N_noxref_4_c_992_p N_RN_c_1573_n ) capacitor c=0.0146822f //x=12.29 \
 //y=1.835 //x2=16.6 //y2=2.4
cc_867 ( N_noxref_4_c_910_n N_RN_c_1573_n ) capacitor c=0.0238578f //x=12.645 \
 //y=3.51 //x2=16.6 //y2=2.4
cc_868 ( N_noxref_4_c_912_n N_RN_c_1573_n ) capacitor c=0.0232222f //x=14.495 \
 //y=2.26 //x2=16.6 //y2=2.4
cc_869 ( N_noxref_4_c_940_n N_RN_c_1573_n ) capacitor c=0.0104117f //x=14.195 \
 //y=2.095 //x2=16.6 //y2=2.4
cc_870 ( N_noxref_4_c_912_n N_RN_c_1591_n ) capacitor c=0.00149389f //x=14.495 \
 //y=2.26 //x2=16.742 //y2=2.685
cc_871 ( N_noxref_4_c_932_n N_noxref_11_c_2247_n ) capacitor c=0.0107156f \
 //x=14.38 //y=3.51 //x2=17.34 //y2=4.25
cc_872 ( N_noxref_4_c_949_n N_noxref_11_c_2247_n ) capacitor c=8.88358e-19 \
 //x=12.76 //y=3.51 //x2=17.34 //y2=4.25
cc_873 ( N_noxref_4_c_910_n N_noxref_11_c_2247_n ) capacitor c=0.0181936f \
 //x=12.645 //y=3.51 //x2=17.34 //y2=4.25
cc_874 ( N_noxref_4_c_912_n N_noxref_11_c_2247_n ) capacitor c=0.019517f \
 //x=14.495 //y=2.26 //x2=17.34 //y2=4.25
cc_875 ( N_noxref_4_c_910_n N_noxref_11_c_2343_n ) capacitor c=0.00179385f \
 //x=12.645 //y=3.51 //x2=12.02 //y2=4.25
cc_876 ( N_noxref_4_c_901_n N_noxref_11_c_2345_n ) capacitor c=0.0127164f \
 //x=12.08 //y=5.38 //x2=11.905 //y2=4.715
cc_877 ( N_noxref_4_c_910_n N_noxref_11_c_2345_n ) capacitor c=0.0101115f \
 //x=12.645 //y=3.51 //x2=11.905 //y2=4.715
cc_878 ( N_noxref_4_c_949_n N_noxref_11_c_2266_n ) capacitor c=0.00329059f \
 //x=12.76 //y=3.51 //x2=11.905 //y2=2.26
cc_879 ( N_noxref_4_c_910_n N_noxref_11_c_2266_n ) capacitor c=0.0721848f \
 //x=12.645 //y=3.51 //x2=11.905 //y2=2.26
cc_880 ( N_noxref_4_c_912_n N_noxref_11_c_2266_n ) capacitor c=9.69022e-19 \
 //x=14.495 //y=2.26 //x2=11.905 //y2=2.26
cc_881 ( N_noxref_4_M33_noxref_g N_noxref_11_c_2268_n ) capacitor c=0.0168349f \
 //x=15.135 //y=6.2 //x2=15.71 //y2=5.335
cc_882 ( N_noxref_4_c_910_n N_noxref_11_c_2272_n ) capacitor c=2.97874e-19 \
 //x=12.645 //y=3.51 //x2=15 //y2=5.335
cc_883 ( N_noxref_4_M32_noxref_g N_noxref_11_c_2272_n ) capacitor c=0.0213876f \
 //x=14.695 //y=6.2 //x2=15 //y2=5.335
cc_884 ( N_noxref_4_c_965_p N_noxref_11_c_2272_n ) capacitor c=0.00428486f \
 //x=15.06 //y=4.97 //x2=15 //y2=5.335
cc_885 ( N_noxref_4_c_901_n N_noxref_11_M30_noxref_g ) capacitor c=0.0166421f \
 //x=12.08 //y=5.38 //x2=11.945 //y2=6.2
cc_886 ( N_noxref_4_M30_noxref_d N_noxref_11_M30_noxref_g ) capacitor \
 c=0.0173476f //x=12.02 //y=5.2 //x2=11.945 //y2=6.2
cc_887 ( N_noxref_4_c_907_n N_noxref_11_M31_noxref_g ) capacitor c=0.018922f \
 //x=12.56 //y=5.38 //x2=12.385 //y2=6.2
cc_888 ( N_noxref_4_M30_noxref_d N_noxref_11_M31_noxref_g ) capacitor \
 c=0.0179769f //x=12.02 //y=5.2 //x2=12.385 //y2=6.2
cc_889 ( N_noxref_4_M7_noxref_d N_noxref_11_c_2354_n ) capacitor c=0.00217566f \
 //x=12.015 //y=1.085 //x2=11.94 //y2=1.085
cc_890 ( N_noxref_4_M7_noxref_d N_noxref_11_c_2357_n ) capacitor c=0.0034598f \
 //x=12.015 //y=1.085 //x2=11.94 //y2=1.43
cc_891 ( N_noxref_4_M7_noxref_d N_noxref_11_c_2359_n ) capacitor c=0.00669531f \
 //x=12.015 //y=1.085 //x2=11.94 //y2=1.74
cc_892 ( N_noxref_4_c_910_n N_noxref_11_c_2389_n ) capacitor c=0.0142673f \
 //x=12.645 //y=3.51 //x2=12.31 //y2=4.97
cc_893 ( N_noxref_4_c_1019_p N_noxref_11_c_2389_n ) capacitor c=0.00407665f \
 //x=12.165 //y=5.38 //x2=12.31 //y2=4.97
cc_894 ( N_noxref_4_M7_noxref_d N_noxref_11_c_2391_n ) capacitor c=0.00241102f \
 //x=12.015 //y=1.085 //x2=12.315 //y2=0.93
cc_895 ( N_noxref_4_c_933_n N_noxref_11_c_2392_n ) capacitor c=0.00371277f \
 //x=12.56 //y=1.835 //x2=12.315 //y2=1.585
cc_896 ( N_noxref_4_M7_noxref_d N_noxref_11_c_2392_n ) capacitor c=0.0137169f \
 //x=12.015 //y=1.085 //x2=12.315 //y2=1.585
cc_897 ( N_noxref_4_M7_noxref_d N_noxref_11_c_2362_n ) capacitor c=0.00132245f \
 //x=12.015 //y=1.085 //x2=12.47 //y2=1.085
cc_898 ( N_noxref_4_c_933_n N_noxref_11_c_2363_n ) capacitor c=0.00457401f \
 //x=12.56 //y=1.835 //x2=12.47 //y2=1.43
cc_899 ( N_noxref_4_M7_noxref_d N_noxref_11_c_2363_n ) capacitor c=0.00566463f \
 //x=12.015 //y=1.085 //x2=12.47 //y2=1.43
cc_900 ( N_noxref_4_c_910_n N_noxref_11_c_2364_n ) capacitor c=0.00731987f \
 //x=12.645 //y=3.51 //x2=11.905 //y2=2.26
cc_901 ( N_noxref_4_c_910_n N_noxref_11_c_2398_n ) capacitor c=0.00306024f \
 //x=12.645 //y=3.51 //x2=11.905 //y2=2.095
cc_902 ( N_noxref_4_M7_noxref_d N_noxref_11_c_2398_n ) capacitor c=0.00660593f \
 //x=12.015 //y=1.085 //x2=11.905 //y2=2.095
cc_903 ( N_noxref_4_c_901_n N_noxref_11_c_2366_n ) capacitor c=0.00346527f \
 //x=12.08 //y=5.38 //x2=11.935 //y2=4.88
cc_904 ( N_noxref_4_c_910_n N_noxref_11_c_2366_n ) capacitor c=0.00517969f \
 //x=12.645 //y=3.51 //x2=11.935 //y2=4.88
cc_905 ( N_noxref_4_M33_noxref_g N_noxref_11_M32_noxref_d ) capacitor \
 c=0.0180032f //x=15.135 //y=6.2 //x2=14.77 //y2=5.2
cc_906 ( N_noxref_4_c_992_p N_noxref_17_c_2962_n ) capacitor c=3.15806e-19 \
 //x=12.29 //y=1.835 //x2=10.75 //y2=1.675
cc_907 ( N_noxref_4_c_992_p N_noxref_17_c_2950_n ) capacitor c=0.020324f \
 //x=12.29 //y=1.835 //x2=11.72 //y2=1.675
cc_908 ( N_noxref_4_c_933_n N_noxref_17_c_2951_n ) capacitor c=0.00457164f \
 //x=12.56 //y=1.835 //x2=12.605 //y2=0.71
cc_909 ( N_noxref_4_M7_noxref_d N_noxref_17_c_2951_n ) capacitor c=0.0115831f \
 //x=12.015 //y=1.085 //x2=12.605 //y2=0.71
cc_910 ( N_noxref_4_c_933_n N_noxref_17_M6_noxref_s ) capacitor c=0.013435f \
 //x=12.56 //y=1.835 //x2=10.615 //y2=0.545
cc_911 ( N_noxref_4_M7_noxref_d N_noxref_17_M6_noxref_s ) capacitor \
 c=0.0439476f //x=12.015 //y=1.085 //x2=10.615 //y2=0.545
cc_912 ( N_noxref_4_c_933_n N_noxref_18_c_3011_n ) capacitor c=4.08644e-19 \
 //x=12.56 //y=1.835 //x2=13.975 //y2=1.685
cc_913 ( N_noxref_4_c_940_n N_noxref_18_c_3011_n ) capacitor c=0.0034165f \
 //x=14.195 //y=2.095 //x2=13.975 //y2=1.685
cc_914 ( N_noxref_4_c_912_n N_noxref_18_c_2995_n ) capacitor c=0.0115578f \
 //x=14.495 //y=2.26 //x2=14.86 //y2=1.77
cc_915 ( N_noxref_4_c_939_n N_noxref_18_c_2995_n ) capacitor c=0.00697148f \
 //x=14.195 //y=1.71 //x2=14.86 //y2=1.77
cc_916 ( N_noxref_4_c_940_n N_noxref_18_c_2995_n ) capacitor c=0.0204849f \
 //x=14.195 //y=2.095 //x2=14.86 //y2=1.77
cc_917 ( N_noxref_4_c_942_n N_noxref_18_c_2995_n ) capacitor c=0.00610316f \
 //x=14.57 //y=1.555 //x2=14.86 //y2=1.77
cc_918 ( N_noxref_4_c_945_n N_noxref_18_c_2995_n ) capacitor c=0.00698822f \
 //x=14.725 //y=1.4 //x2=14.86 //y2=1.77
cc_919 ( N_noxref_4_c_936_n N_noxref_18_M8_noxref_s ) capacitor c=0.0327271f \
 //x=14.195 //y=1.055 //x2=13.84 //y2=0.555
cc_920 ( N_noxref_4_c_939_n N_noxref_18_M8_noxref_s ) capacitor c=7.99997e-19 \
 //x=14.195 //y=1.71 //x2=13.84 //y2=0.555
cc_921 ( N_noxref_4_c_940_n N_noxref_18_M8_noxref_s ) capacitor c=0.00122123f \
 //x=14.195 //y=2.095 //x2=13.84 //y2=0.555
cc_922 ( N_noxref_4_c_943_n N_noxref_18_M8_noxref_s ) capacitor c=0.0121427f \
 //x=14.725 //y=1.055 //x2=13.84 //y2=0.555
cc_923 ( N_noxref_4_M7_noxref_d N_noxref_18_M8_noxref_s ) capacitor \
 c=2.53688e-19 //x=12.015 //y=1.085 //x2=13.84 //y2=0.555
cc_924 ( N_CLK_c_1050_n N_noxref_6_c_1375_n ) capacitor c=0.00910993f \
 //x=15.49 //y=4.62 //x2=6.24 //y2=3.88
cc_925 ( N_CLK_c_1050_n N_noxref_6_c_1376_n ) capacitor c=7.95009e-19 \
 //x=15.49 //y=4.62 //x2=4.62 //y2=3.88
cc_926 ( N_CLK_c_1050_n N_noxref_6_c_1350_n ) capacitor c=0.0665157f //x=15.49 \
 //y=4.62 //x2=19.19 //y2=3.88
cc_927 ( CLK N_noxref_6_c_1350_n ) capacitor c=0.00139768f //x=15.66 //y=3.51 \
 //x2=19.19 //y2=3.88
cc_928 ( N_CLK_c_1071_n N_noxref_6_c_1350_n ) capacitor c=0.0238781f \
 //x=15.632 //y=4.535 //x2=19.19 //y2=3.88
cc_929 ( N_CLK_c_1050_n N_noxref_6_c_1383_n ) capacitor c=6.59178e-19 \
 //x=15.49 //y=4.62 //x2=6.47 //y2=3.88
cc_930 ( N_CLK_c_1067_n N_noxref_6_c_1302_n ) capacitor c=0.00283946f //x=2.77 \
 //y=4.62 //x2=2.76 //y2=5.335
cc_931 ( CLK N_noxref_6_c_1302_n ) capacitor c=0.00132827f //x=2.71 //y=4.62 \
 //x2=2.76 //y2=5.335
cc_932 ( N_CLK_c_1068_n N_noxref_6_c_1302_n ) capacitor c=0.014564f //x=2.655 \
 //y=4.88 //x2=2.76 //y2=5.335
cc_933 ( N_CLK_M18_noxref_g N_noxref_6_c_1302_n ) capacitor c=0.016514f \
 //x=2.625 //y=6.2 //x2=2.76 //y2=5.335
cc_934 ( N_CLK_c_1119_n N_noxref_6_c_1302_n ) capacitor c=0.00322046f \
 //x=2.655 //y=4.88 //x2=2.76 //y2=5.335
cc_935 ( N_CLK_M19_noxref_g N_noxref_6_c_1308_n ) capacitor c=0.01736f \
 //x=3.065 //y=6.2 //x2=3.64 //y2=5.335
cc_936 ( N_CLK_c_1050_n N_noxref_6_c_1312_n ) capacitor c=0.0183122f //x=15.49 \
 //y=4.62 //x2=4.42 //y2=5.335
cc_937 ( N_CLK_c_1050_n N_noxref_6_c_1316_n ) capacitor c=0.0210274f //x=15.49 \
 //y=4.62 //x2=4.505 //y2=3.88
cc_938 ( N_CLK_c_1080_n N_noxref_6_c_1316_n ) capacitor c=8.06137e-19 \
 //x=2.655 //y=2.26 //x2=4.505 //y2=3.88
cc_939 ( N_CLK_c_1104_n N_noxref_6_c_1316_n ) capacitor c=2.32128e-19 \
 //x=2.682 //y=3.425 //x2=4.505 //y2=3.88
cc_940 ( N_CLK_c_1106_n N_noxref_6_c_1316_n ) capacitor c=2.37933e-19 \
 //x=2.682 //y=3.795 //x2=4.505 //y2=3.88
cc_941 ( N_CLK_c_1070_n N_noxref_6_c_1316_n ) capacitor c=4.67028e-19 \
 //x=2.682 //y=4.535 //x2=4.505 //y2=3.88
cc_942 ( N_CLK_c_1050_n N_noxref_6_c_1317_n ) capacitor c=0.0208709f //x=15.49 \
 //y=4.62 //x2=6.355 //y2=2.26
cc_943 ( N_CLK_c_1050_n N_noxref_6_c_1438_n ) capacitor c=0.03056f //x=15.49 \
 //y=4.62 //x2=2.845 //y2=5.335
cc_944 ( N_CLK_c_1118_n N_noxref_6_c_1438_n ) capacitor c=0.00419184f //x=2.99 \
 //y=4.97 //x2=2.845 //y2=5.335
cc_945 ( N_CLK_c_1050_n N_noxref_6_c_1331_n ) capacitor c=0.0166984f //x=15.49 \
 //y=4.62 //x2=6.63 //y2=4.97
cc_946 ( N_CLK_M18_noxref_g N_noxref_6_M18_noxref_d ) capacitor c=0.0180032f \
 //x=2.625 //y=6.2 //x2=2.7 //y2=5.2
cc_947 ( N_CLK_M19_noxref_g N_noxref_6_M18_noxref_d ) capacitor c=0.0180032f \
 //x=3.065 //y=6.2 //x2=2.7 //y2=5.2
cc_948 ( CLK N_RN_c_1573_n ) capacitor c=0.0013444f //x=15.66 //y=2.77 \
 //x2=16.6 //y2=2.4
cc_949 ( N_CLK_c_1081_n N_RN_c_1573_n ) capacitor c=0.0242349f //x=15.605 \
 //y=2.26 //x2=16.6 //y2=2.4
cc_950 ( N_CLK_c_1145_n N_RN_c_1573_n ) capacitor c=0.00565213f //x=15.695 \
 //y=2.095 //x2=16.6 //y2=2.4
cc_951 ( N_CLK_c_1081_n N_RN_c_1587_n ) capacitor c=0.00165648f //x=15.605 \
 //y=2.26 //x2=16.83 //y2=2.4
cc_952 ( N_CLK_c_1145_n N_RN_c_1587_n ) capacitor c=2.3323e-19 //x=15.695 \
 //y=2.095 //x2=16.83 //y2=2.4
cc_953 ( CLK RN ) capacitor c=0.00505269f //x=15.66 //y=2.77 //x2=16.77 \
 //y2=2.77
cc_954 ( CLK RN ) capacitor c=0.00505269f //x=15.66 //y=3.14 //x2=16.77 \
 //y2=3.14
cc_955 ( CLK RN ) capacitor c=0.0048331f //x=15.66 //y=3.51 //x2=16.77 //y2=3.51
cc_956 ( N_CLK_c_1050_n N_RN_c_1557_n ) capacitor c=0.0200057f //x=15.49 \
 //y=4.62 //x2=8.575 //y2=4.88
cc_957 ( N_CLK_c_1081_n N_RN_c_1649_n ) capacitor c=0.00785277f //x=15.605 \
 //y=2.26 //x2=16.715 //y2=2.485
cc_958 ( N_CLK_c_1145_n N_RN_c_1649_n ) capacitor c=0.00204105f //x=15.695 \
 //y=2.095 //x2=16.715 //y2=2.485
cc_959 ( N_CLK_c_1050_n N_RN_c_1558_n ) capacitor c=0.00430541f //x=15.49 \
 //y=4.62 //x2=16.715 //y2=4.88
cc_960 ( CLK N_RN_c_1558_n ) capacitor c=0.00280887f //x=15.66 //y=4.62 \
 //x2=16.715 //y2=4.88
cc_961 ( N_CLK_c_1069_n N_RN_c_1558_n ) capacitor c=0.00467264f //x=15.605 \
 //y=4.88 //x2=16.715 //y2=4.88
cc_962 ( N_CLK_c_1071_n N_RN_c_1558_n ) capacitor c=0.0147513f //x=15.632 \
 //y=4.535 //x2=16.715 //y2=4.88
cc_963 ( N_CLK_c_1147_n N_RN_c_1558_n ) capacitor c=0.00142741f //x=15.605 \
 //y=4.88 //x2=16.715 //y2=4.88
cc_964 ( N_CLK_c_1131_n N_RN_c_1656_n ) capacitor c=0.00419471f //x=15.632 \
 //y=3.055 //x2=16.742 //y2=3.055
cc_965 ( N_CLK_c_1132_n N_RN_c_1657_n ) capacitor c=0.00416057f //x=15.632 \
 //y=3.425 //x2=16.742 //y2=3.425
cc_966 ( N_CLK_M34_noxref_g N_RN_M36_noxref_g ) capacitor c=0.0101598f \
 //x=15.575 //y=6.2 //x2=16.455 //y2=6.2
cc_967 ( N_CLK_M35_noxref_g N_RN_M36_noxref_g ) capacitor c=0.0602553f \
 //x=16.015 //y=6.2 //x2=16.455 //y2=6.2
cc_968 ( N_CLK_M35_noxref_g N_RN_M37_noxref_g ) capacitor c=0.0101598f \
 //x=16.015 //y=6.2 //x2=16.895 //y2=6.2
cc_969 ( N_CLK_c_1142_n N_RN_c_1661_n ) capacitor c=0.00456962f //x=15.695 \
 //y=1.09 //x2=16.705 //y2=1.095
cc_970 ( N_CLK_c_1143_n N_RN_c_1662_n ) capacitor c=0.00438372f //x=15.695 \
 //y=1.4 //x2=16.705 //y2=1.44
cc_971 ( N_CLK_c_1144_n N_RN_c_1663_n ) capacitor c=0.00438372f //x=15.695 \
 //y=1.63 //x2=16.705 //y2=1.75
cc_972 ( N_CLK_c_1050_n N_RN_c_1630_n ) capacitor c=0.0111881f //x=15.49 \
 //y=4.62 //x2=8.575 //y2=4.88
cc_973 ( N_CLK_c_1081_n N_RN_c_1665_n ) capacitor c=0.00201097f //x=15.605 \
 //y=2.26 //x2=16.715 //y2=2.26
cc_974 ( N_CLK_c_1145_n N_RN_c_1665_n ) capacitor c=0.00828003f //x=15.695 \
 //y=2.095 //x2=16.715 //y2=2.26
cc_975 ( N_CLK_c_1145_n N_RN_c_1667_n ) capacitor c=0.00438372f //x=15.695 \
 //y=2.095 //x2=16.715 //y2=2.095
cc_976 ( N_CLK_c_1069_n N_RN_c_1668_n ) capacitor c=0.00218014f //x=15.605 \
 //y=4.88 //x2=16.715 //y2=4.88
cc_977 ( N_CLK_c_1203_p N_RN_c_1668_n ) capacitor c=0.0611812f //x=15.94 \
 //y=4.97 //x2=16.715 //y2=4.88
cc_978 ( N_CLK_c_1147_n N_RN_c_1668_n ) capacitor c=0.00487508f //x=15.605 \
 //y=4.88 //x2=16.715 //y2=4.88
cc_979 ( N_CLK_c_1050_n N_noxref_11_c_2240_n ) capacitor c=0.784218f //x=15.49 \
 //y=4.62 //x2=11.79 //y2=4.25
cc_980 ( N_CLK_c_1067_n N_noxref_11_c_2240_n ) capacitor c=0.02921f //x=2.77 \
 //y=4.62 //x2=11.79 //y2=4.25
cc_981 ( CLK N_noxref_11_c_2240_n ) capacitor c=0.00161863f //x=2.71 //y=3.88 \
 //x2=11.79 //y2=4.25
cc_982 ( CLK N_noxref_11_c_2240_n ) capacitor c=0.00263824f //x=2.71 //y=4.62 \
 //x2=11.79 //y2=4.25
cc_983 ( N_CLK_c_1070_n N_noxref_11_c_2240_n ) capacitor c=0.0245142f \
 //x=2.682 //y=4.535 //x2=11.79 //y2=4.25
cc_984 ( N_CLK_c_1119_n N_noxref_11_c_2240_n ) capacitor c=3.07672e-19 \
 //x=2.655 //y=4.88 //x2=11.79 //y2=4.25
cc_985 ( N_CLK_c_1070_n N_noxref_11_c_2244_n ) capacitor c=0.00128547f \
 //x=2.682 //y=4.535 //x2=1.66 //y2=4.25
cc_986 ( N_CLK_c_1050_n N_noxref_11_c_2247_n ) capacitor c=0.331495f //x=15.49 \
 //y=4.62 //x2=17.34 //y2=4.25
cc_987 ( CLK N_noxref_11_c_2247_n ) capacitor c=0.00237739f //x=15.66 //y=4.62 \
 //x2=17.34 //y2=4.25
cc_988 ( N_CLK_c_1071_n N_noxref_11_c_2247_n ) capacitor c=0.0187802f \
 //x=15.632 //y=4.535 //x2=17.34 //y2=4.25
cc_989 ( N_CLK_c_1203_p N_noxref_11_c_2247_n ) capacitor c=0.00669203f \
 //x=15.94 //y=4.97 //x2=17.34 //y2=4.25
cc_990 ( N_CLK_c_1050_n N_noxref_11_c_2343_n ) capacitor c=0.0263375f \
 //x=15.49 //y=4.62 //x2=12.02 //y2=4.25
cc_991 ( N_CLK_c_1067_n N_noxref_11_c_2263_n ) capacitor c=0.00551083f \
 //x=2.77 //y=4.62 //x2=1.545 //y2=2.26
cc_992 ( N_CLK_c_1080_n N_noxref_11_c_2263_n ) capacitor c=0.0534679f \
 //x=2.655 //y=2.26 //x2=1.545 //y2=2.26
cc_993 ( N_CLK_c_1115_n N_noxref_11_c_2263_n ) capacitor c=0.00231304f \
 //x=2.745 //y=2.095 //x2=1.545 //y2=2.26
cc_994 ( N_CLK_c_1119_n N_noxref_11_c_2263_n ) capacitor c=0.00183762f \
 //x=2.655 //y=4.88 //x2=1.545 //y2=2.26
cc_995 ( N_CLK_c_1050_n N_noxref_11_c_2345_n ) capacitor c=0.0016972f \
 //x=15.49 //y=4.62 //x2=11.905 //y2=4.715
cc_996 ( N_CLK_c_1050_n N_noxref_11_c_2266_n ) capacitor c=0.0207534f \
 //x=15.49 //y=4.62 //x2=11.905 //y2=2.26
cc_997 ( N_CLK_c_1050_n N_noxref_11_c_2268_n ) capacitor c=0.00195615f \
 //x=15.49 //y=4.62 //x2=15.71 //y2=5.335
cc_998 ( CLK N_noxref_11_c_2268_n ) capacitor c=0.00133827f //x=15.66 //y=4.62 \
 //x2=15.71 //y2=5.335
cc_999 ( N_CLK_c_1069_n N_noxref_11_c_2268_n ) capacitor c=0.0143918f \
 //x=15.605 //y=4.88 //x2=15.71 //y2=5.335
cc_1000 ( N_CLK_M34_noxref_g N_noxref_11_c_2268_n ) capacitor c=0.016514f \
 //x=15.575 //y=6.2 //x2=15.71 //y2=5.335
cc_1001 ( N_CLK_c_1147_n N_noxref_11_c_2268_n ) capacitor c=0.00322046f \
 //x=15.605 //y=4.88 //x2=15.71 //y2=5.335
cc_1002 ( N_CLK_c_1050_n N_noxref_11_c_2272_n ) capacitor c=0.0219114f \
 //x=15.49 //y=4.62 //x2=15 //y2=5.335
cc_1003 ( N_CLK_M35_noxref_g N_noxref_11_c_2274_n ) capacitor c=0.0184045f \
 //x=16.015 //y=6.2 //x2=16.59 //y2=5.335
cc_1004 ( CLK N_noxref_11_c_2282_n ) capacitor c=3.93055e-19 //x=15.66 \
 //y=3.51 //x2=17.455 //y2=4.25
cc_1005 ( N_CLK_c_1081_n N_noxref_11_c_2282_n ) capacitor c=6.05878e-19 \
 //x=15.605 //y=2.26 //x2=17.455 //y2=4.25
cc_1006 ( N_CLK_c_1132_n N_noxref_11_c_2282_n ) capacitor c=2.17309e-19 \
 //x=15.632 //y=3.425 //x2=17.455 //y2=4.25
cc_1007 ( N_CLK_c_1071_n N_noxref_11_c_2282_n ) capacitor c=6.19878e-19 \
 //x=15.632 //y=4.535 //x2=17.455 //y2=4.25
cc_1008 ( N_CLK_c_1050_n N_noxref_11_c_2432_n ) capacitor c=2.77838e-19 \
 //x=15.49 //y=4.62 //x2=15.795 //y2=5.335
cc_1009 ( N_CLK_c_1203_p N_noxref_11_c_2432_n ) capacitor c=0.00420239f \
 //x=15.94 //y=4.97 //x2=15.795 //y2=5.335
cc_1010 ( N_CLK_M18_noxref_g N_noxref_11_M16_noxref_g ) capacitor c=0.0105869f \
 //x=2.625 //y=6.2 //x2=1.745 //y2=6.2
cc_1011 ( N_CLK_M18_noxref_g N_noxref_11_M17_noxref_g ) capacitor c=0.10632f \
 //x=2.625 //y=6.2 //x2=2.185 //y2=6.2
cc_1012 ( N_CLK_M19_noxref_g N_noxref_11_M17_noxref_g ) capacitor c=0.0101598f \
 //x=3.065 //y=6.2 //x2=2.185 //y2=6.2
cc_1013 ( N_CLK_c_1239_p N_noxref_11_c_2325_n ) capacitor c=5.72482e-19 \
 //x=2.22 //y=1.09 //x2=1.245 //y2=1.055
cc_1014 ( N_CLK_c_1239_p N_noxref_11_c_2327_n ) capacitor c=0.00149976f \
 //x=2.22 //y=1.09 //x2=1.245 //y2=1.4
cc_1015 ( N_CLK_c_1241_p N_noxref_11_c_2328_n ) capacitor c=0.00111227f \
 //x=2.22 //y=1.4 //x2=1.245 //y2=1.71
cc_1016 ( N_CLK_c_1080_n N_noxref_11_c_2329_n ) capacitor c=0.00238338f \
 //x=2.655 //y=2.26 //x2=1.245 //y2=2.095
cc_1017 ( N_CLK_c_1115_n N_noxref_11_c_2329_n ) capacitor c=0.00964411f \
 //x=2.745 //y=2.095 //x2=1.245 //y2=2.095
cc_1018 ( N_CLK_c_1239_p N_noxref_11_c_2332_n ) capacitor c=0.0160123f \
 //x=2.22 //y=1.09 //x2=1.775 //y2=1.055
cc_1019 ( N_CLK_c_1112_n N_noxref_11_c_2332_n ) capacitor c=0.00103227f \
 //x=2.745 //y=1.09 //x2=1.775 //y2=1.055
cc_1020 ( N_CLK_c_1241_p N_noxref_11_c_2334_n ) capacitor c=0.0124075f \
 //x=2.22 //y=1.4 //x2=1.775 //y2=1.4
cc_1021 ( N_CLK_c_1113_n N_noxref_11_c_2334_n ) capacitor c=0.0010154f \
 //x=2.745 //y=1.4 //x2=1.775 //y2=1.4
cc_1022 ( N_CLK_c_1114_n N_noxref_11_c_2334_n ) capacitor c=9.23422e-19 \
 //x=2.745 //y=1.63 //x2=1.775 //y2=1.4
cc_1023 ( N_CLK_c_1068_n N_noxref_11_c_2447_n ) capacitor c=0.00147352f \
 //x=2.655 //y=4.88 //x2=2.11 //y2=4.97
cc_1024 ( N_CLK_c_1119_n N_noxref_11_c_2447_n ) capacitor c=0.0168581f \
 //x=2.655 //y=4.88 //x2=2.11 //y2=4.97
cc_1025 ( N_CLK_c_1068_n N_noxref_11_c_2299_n ) capacitor c=0.00141297f \
 //x=2.655 //y=4.88 //x2=1.82 //y2=4.97
cc_1026 ( N_CLK_c_1119_n N_noxref_11_c_2299_n ) capacitor c=0.00484466f \
 //x=2.655 //y=4.88 //x2=1.82 //y2=4.97
cc_1027 ( N_CLK_c_1050_n N_noxref_11_c_2389_n ) capacitor c=0.00960248f \
 //x=15.49 //y=4.62 //x2=12.31 //y2=4.97
cc_1028 ( N_CLK_c_1050_n N_noxref_11_c_2366_n ) capacitor c=0.00203982f \
 //x=15.49 //y=4.62 //x2=11.935 //y2=4.88
cc_1029 ( N_CLK_M34_noxref_g N_noxref_11_M34_noxref_d ) capacitor c=0.0180032f \
 //x=15.575 //y=6.2 //x2=15.65 //y2=5.2
cc_1030 ( N_CLK_M35_noxref_g N_noxref_11_M34_noxref_d ) capacitor c=0.0180032f \
 //x=16.015 //y=6.2 //x2=15.65 //y2=5.2
cc_1031 ( N_CLK_c_1239_p N_noxref_12_c_2655_n ) capacitor c=0.0167228f \
 //x=2.22 //y=1.09 //x2=2.88 //y2=0.72
cc_1032 ( N_CLK_c_1112_n N_noxref_12_c_2655_n ) capacitor c=0.00534519f \
 //x=2.745 //y=1.09 //x2=2.88 //y2=0.72
cc_1033 ( CLK N_noxref_12_c_2666_n ) capacitor c=9.41371e-19 //x=2.71 //y=2.77 \
 //x2=2.88 //y2=1.77
cc_1034 ( N_CLK_c_1080_n N_noxref_12_c_2666_n ) capacitor c=0.012357f \
 //x=2.655 //y=2.26 //x2=2.88 //y2=1.77
cc_1035 ( N_CLK_c_1241_p N_noxref_12_c_2666_n ) capacitor c=0.0153476f \
 //x=2.22 //y=1.4 //x2=2.88 //y2=1.77
cc_1036 ( N_CLK_c_1115_n N_noxref_12_c_2666_n ) capacitor c=0.0221865f \
 //x=2.745 //y=2.095 //x2=2.88 //y2=1.77
cc_1037 ( N_CLK_c_1239_p N_noxref_12_M0_noxref_s ) capacitor c=0.00798959f \
 //x=2.22 //y=1.09 //x2=0.89 //y2=0.555
cc_1038 ( N_CLK_c_1114_n N_noxref_12_M0_noxref_s ) capacitor c=0.00212176f \
 //x=2.745 //y=1.63 //x2=0.89 //y2=0.555
cc_1039 ( N_CLK_c_1115_n N_noxref_12_M0_noxref_s ) capacitor c=0.00298115f \
 //x=2.745 //y=2.095 //x2=0.89 //y2=0.555
cc_1040 ( N_CLK_c_1266_p N_noxref_13_c_2696_n ) capacitor c=2.14837e-19 \
 //x=2.59 //y=0.935 //x2=3.45 //y2=1.175
cc_1041 ( N_CLK_c_1112_n N_noxref_13_c_2696_n ) capacitor c=0.00123426f \
 //x=2.745 //y=1.09 //x2=3.45 //y2=1.175
cc_1042 ( N_CLK_c_1113_n N_noxref_13_c_2696_n ) capacitor c=0.0129288f \
 //x=2.745 //y=1.4 //x2=3.45 //y2=1.175
cc_1043 ( N_CLK_c_1114_n N_noxref_13_c_2696_n ) capacitor c=0.00142359f \
 //x=2.745 //y=1.63 //x2=3.45 //y2=1.175
cc_1044 ( N_CLK_c_1239_p N_noxref_13_M1_noxref_d ) capacitor c=0.00223875f \
 //x=2.22 //y=1.09 //x2=2.295 //y2=1.09
cc_1045 ( N_CLK_c_1241_p N_noxref_13_M1_noxref_d ) capacitor c=0.00262485f \
 //x=2.22 //y=1.4 //x2=2.295 //y2=1.09
cc_1046 ( N_CLK_c_1266_p N_noxref_13_M1_noxref_d ) capacitor c=0.00220746f \
 //x=2.59 //y=0.935 //x2=2.295 //y2=1.09
cc_1047 ( N_CLK_c_1273_p N_noxref_13_M1_noxref_d ) capacitor c=0.00194798f \
 //x=2.59 //y=1.555 //x2=2.295 //y2=1.09
cc_1048 ( N_CLK_c_1112_n N_noxref_13_M1_noxref_d ) capacitor c=0.00198465f \
 //x=2.745 //y=1.09 //x2=2.295 //y2=1.09
cc_1049 ( N_CLK_c_1113_n N_noxref_13_M1_noxref_d ) capacitor c=0.00128384f \
 //x=2.745 //y=1.4 //x2=2.295 //y2=1.09
cc_1050 ( N_CLK_c_1112_n N_noxref_13_M2_noxref_s ) capacitor c=7.21316e-19 \
 //x=2.745 //y=1.09 //x2=3.4 //y2=0.555
cc_1051 ( N_CLK_c_1113_n N_noxref_13_M2_noxref_s ) capacitor c=0.00348171f \
 //x=2.745 //y=1.4 //x2=3.4 //y2=0.555
cc_1052 ( N_CLK_c_1050_n N_D_c_2749_n ) capacitor c=0.0210462f //x=15.49 \
 //y=4.62 //x2=7.465 //y2=4.88
cc_1053 ( N_CLK_c_1050_n N_D_c_2767_n ) capacitor c=0.0085986f //x=15.49 \
 //y=4.62 //x2=7.8 //y2=4.97
cc_1054 ( N_CLK_c_1050_n N_D_c_2768_n ) capacitor c=0.00293313f //x=15.49 \
 //y=4.62 //x2=7.465 //y2=4.88
cc_1055 ( N_CLK_c_1137_n N_noxref_18_c_3002_n ) capacitor c=0.0167228f \
 //x=15.17 //y=1.09 //x2=15.83 //y2=0.72
cc_1056 ( N_CLK_c_1142_n N_noxref_18_c_3002_n ) capacitor c=0.00534519f \
 //x=15.695 //y=1.09 //x2=15.83 //y2=0.72
cc_1057 ( CLK N_noxref_18_c_3025_n ) capacitor c=6.5012e-19 //x=15.66 //y=2.77 \
 //x2=15.83 //y2=1.77
cc_1058 ( N_CLK_c_1081_n N_noxref_18_c_3025_n ) capacitor c=0.0120267f \
 //x=15.605 //y=2.26 //x2=15.83 //y2=1.77
cc_1059 ( N_CLK_c_1140_n N_noxref_18_c_3025_n ) capacitor c=0.0157358f \
 //x=15.17 //y=1.4 //x2=15.83 //y2=1.77
cc_1060 ( N_CLK_c_1145_n N_noxref_18_c_3025_n ) capacitor c=0.0216136f \
 //x=15.695 //y=2.095 //x2=15.83 //y2=1.77
cc_1061 ( N_CLK_c_1137_n N_noxref_18_M8_noxref_s ) capacitor c=0.00798959f \
 //x=15.17 //y=1.09 //x2=13.84 //y2=0.555
cc_1062 ( N_CLK_c_1144_n N_noxref_18_M8_noxref_s ) capacitor c=0.00212176f \
 //x=15.695 //y=1.63 //x2=13.84 //y2=0.555
cc_1063 ( N_CLK_c_1145_n N_noxref_18_M8_noxref_s ) capacitor c=0.00298115f \
 //x=15.695 //y=2.095 //x2=13.84 //y2=0.555
cc_1064 ( N_CLK_c_1290_p N_noxref_19_c_3046_n ) capacitor c=2.14837e-19 \
 //x=15.54 //y=0.935 //x2=16.4 //y2=1.175
cc_1065 ( N_CLK_c_1142_n N_noxref_19_c_3046_n ) capacitor c=0.00123426f \
 //x=15.695 //y=1.09 //x2=16.4 //y2=1.175
cc_1066 ( N_CLK_c_1143_n N_noxref_19_c_3046_n ) capacitor c=0.0129288f \
 //x=15.695 //y=1.4 //x2=16.4 //y2=1.175
cc_1067 ( N_CLK_c_1144_n N_noxref_19_c_3046_n ) capacitor c=0.00142359f \
 //x=15.695 //y=1.63 //x2=16.4 //y2=1.175
cc_1068 ( N_CLK_c_1137_n N_noxref_19_M9_noxref_d ) capacitor c=0.00223875f \
 //x=15.17 //y=1.09 //x2=15.245 //y2=1.09
cc_1069 ( N_CLK_c_1140_n N_noxref_19_M9_noxref_d ) capacitor c=0.00262485f \
 //x=15.17 //y=1.4 //x2=15.245 //y2=1.09
cc_1070 ( N_CLK_c_1290_p N_noxref_19_M9_noxref_d ) capacitor c=0.00220746f \
 //x=15.54 //y=0.935 //x2=15.245 //y2=1.09
cc_1071 ( N_CLK_c_1297_p N_noxref_19_M9_noxref_d ) capacitor c=0.00194798f \
 //x=15.54 //y=1.555 //x2=15.245 //y2=1.09
cc_1072 ( N_CLK_c_1142_n N_noxref_19_M9_noxref_d ) capacitor c=0.00198465f \
 //x=15.695 //y=1.09 //x2=15.245 //y2=1.09
cc_1073 ( N_CLK_c_1143_n N_noxref_19_M9_noxref_d ) capacitor c=0.00128384f \
 //x=15.695 //y=1.4 //x2=15.245 //y2=1.09
cc_1074 ( N_CLK_c_1142_n N_noxref_19_M10_noxref_s ) capacitor c=7.21316e-19 \
 //x=15.695 //y=1.09 //x2=16.35 //y2=0.555
cc_1075 ( N_CLK_c_1143_n N_noxref_19_M10_noxref_s ) capacitor c=0.00348171f \
 //x=15.695 //y=1.4 //x2=16.35 //y2=0.555
cc_1076 ( N_noxref_6_c_1350_n N_RN_c_1573_n ) capacitor c=0.0822363f //x=19.19 \
 //y=3.88 //x2=16.6 //y2=2.4
cc_1077 ( N_noxref_6_c_1350_n N_RN_c_1581_n ) capacitor c=4.37145e-19 \
 //x=19.19 //y=3.88 //x2=8.69 //y2=2.4
cc_1078 ( N_noxref_6_c_1350_n N_RN_c_1583_n ) capacitor c=0.0555029f //x=19.19 \
 //y=3.88 //x2=20.3 //y2=2.4
cc_1079 ( N_noxref_6_c_1320_n N_RN_c_1583_n ) capacitor c=0.0251492f \
 //x=19.305 //y=2.26 //x2=20.3 //y2=2.4
cc_1080 ( N_noxref_6_c_1368_n N_RN_c_1583_n ) capacitor c=0.0106236f \
 //x=19.005 //y=2.095 //x2=20.3 //y2=2.4
cc_1081 ( N_noxref_6_c_1350_n N_RN_c_1587_n ) capacitor c=0.00455812f \
 //x=19.19 //y=3.88 //x2=16.83 //y2=2.4
cc_1082 ( N_noxref_6_c_1350_n RN ) capacitor c=0.00165265f //x=19.19 //y=3.88 \
 //x2=16.77 //y2=3.51
cc_1083 ( N_noxref_6_c_1350_n RN ) capacitor c=0.00220604f //x=19.19 //y=3.88 \
 //x2=20.47 //y2=3.88
cc_1084 ( N_noxref_6_c_1350_n N_RN_c_1557_n ) capacitor c=0.0179999f //x=19.19 \
 //y=3.88 //x2=8.575 //y2=4.88
cc_1085 ( N_noxref_6_c_1350_n N_RN_c_1558_n ) capacitor c=0.0227816f //x=19.19 \
 //y=3.88 //x2=16.715 //y2=4.88
cc_1086 ( N_noxref_6_c_1320_n N_RN_c_1558_n ) capacitor c=3.92486e-19 \
 //x=19.305 //y=2.26 //x2=16.715 //y2=4.88
cc_1087 ( N_noxref_6_c_1320_n N_RN_c_1682_n ) capacitor c=0.052173f //x=19.305 \
 //y=2.26 //x2=20.415 //y2=2.485
cc_1088 ( N_noxref_6_c_1368_n N_RN_c_1682_n ) capacitor c=0.00209012f \
 //x=19.005 //y=2.095 //x2=20.415 //y2=2.485
cc_1089 ( N_noxref_6_c_1456_p N_RN_c_1559_n ) capacitor c=0.00147352f \
 //x=19.87 //y=4.97 //x2=20.415 //y2=4.88
cc_1090 ( N_noxref_6_c_1333_n N_RN_c_1559_n ) capacitor c=0.00142741f \
 //x=19.58 //y=4.97 //x2=20.415 //y2=4.88
cc_1091 ( N_noxref_6_c_1317_n N_RN_c_1590_n ) capacitor c=0.00110012f \
 //x=6.355 //y=2.26 //x2=8.602 //y2=2.685
cc_1092 ( N_noxref_6_c_1350_n N_RN_c_1687_n ) capacitor c=3.28865e-19 \
 //x=19.19 //y=3.88 //x2=20.442 //y2=3.795
cc_1093 ( N_noxref_6_c_1350_n N_RN_c_1560_n ) capacitor c=3.28865e-19 \
 //x=19.19 //y=3.88 //x2=20.442 //y2=4.535
cc_1094 ( N_noxref_6_M38_noxref_g N_RN_M40_noxref_g ) capacitor c=0.0105869f \
 //x=19.505 //y=6.2 //x2=20.385 //y2=6.2
cc_1095 ( N_noxref_6_M39_noxref_g N_RN_M40_noxref_g ) capacitor c=0.10632f \
 //x=19.945 //y=6.2 //x2=20.385 //y2=6.2
cc_1096 ( N_noxref_6_M39_noxref_g N_RN_M41_noxref_g ) capacitor c=0.0101598f \
 //x=19.945 //y=6.2 //x2=20.825 //y2=6.2
cc_1097 ( N_noxref_6_c_1364_n N_RN_c_1692_n ) capacitor c=5.72482e-19 \
 //x=19.005 //y=1.055 //x2=19.98 //y2=1.09
cc_1098 ( N_noxref_6_c_1366_n N_RN_c_1692_n ) capacitor c=0.00149976f \
 //x=19.005 //y=1.4 //x2=19.98 //y2=1.09
cc_1099 ( N_noxref_6_c_1371_n N_RN_c_1692_n ) capacitor c=0.0160123f \
 //x=19.535 //y=1.055 //x2=19.98 //y2=1.09
cc_1100 ( N_noxref_6_c_1367_n N_RN_c_1695_n ) capacitor c=0.00111227f \
 //x=19.005 //y=1.71 //x2=19.98 //y2=1.4
cc_1101 ( N_noxref_6_c_1373_n N_RN_c_1695_n ) capacitor c=0.0124075f \
 //x=19.535 //y=1.4 //x2=19.98 //y2=1.4
cc_1102 ( N_noxref_6_c_1371_n N_RN_c_1697_n ) capacitor c=0.00103227f \
 //x=19.535 //y=1.055 //x2=20.505 //y2=1.09
cc_1103 ( N_noxref_6_c_1373_n N_RN_c_1698_n ) capacitor c=0.0010154f \
 //x=19.535 //y=1.4 //x2=20.505 //y2=1.4
cc_1104 ( N_noxref_6_c_1373_n N_RN_c_1699_n ) capacitor c=9.23422e-19 \
 //x=19.535 //y=1.4 //x2=20.505 //y2=1.63
cc_1105 ( N_noxref_6_c_1320_n N_RN_c_1700_n ) capacitor c=0.00203769f \
 //x=19.305 //y=2.26 //x2=20.505 //y2=2.095
cc_1106 ( N_noxref_6_c_1368_n N_RN_c_1700_n ) capacitor c=0.00834532f \
 //x=19.005 //y=2.095 //x2=20.505 //y2=2.095
cc_1107 ( N_noxref_6_c_1320_n N_RN_c_1702_n ) capacitor c=0.00183762f \
 //x=19.305 //y=2.26 //x2=20.415 //y2=4.88
cc_1108 ( N_noxref_6_c_1456_p N_RN_c_1702_n ) capacitor c=0.0168581f //x=19.87 \
 //y=4.97 //x2=20.415 //y2=4.88
cc_1109 ( N_noxref_6_c_1333_n N_RN_c_1702_n ) capacitor c=0.00484466f \
 //x=19.58 //y=4.97 //x2=20.415 //y2=4.88
cc_1110 ( N_noxref_6_c_1350_n Q ) capacitor c=0.00738475f //x=19.19 //y=3.88 \
 //x2=21.58 //y2=3.88
cc_1111 ( N_noxref_6_c_1350_n Q ) capacitor c=0.00124242f //x=19.19 //y=3.88 \
 //x2=25.65 //y2=3.88
cc_1112 ( N_noxref_6_c_1320_n N_Q_c_1919_n ) capacitor c=0.00135434f \
 //x=19.305 //y=2.26 //x2=21.525 //y2=2.26
cc_1113 ( N_noxref_6_M39_noxref_g N_noxref_9_c_2066_n ) capacitor c=0.0178794f \
 //x=19.945 //y=6.2 //x2=20.52 //y2=5.335
cc_1114 ( N_noxref_6_M38_noxref_g N_noxref_9_c_2070_n ) capacitor c=0.0213876f \
 //x=19.505 //y=6.2 //x2=19.81 //y2=5.335
cc_1115 ( N_noxref_6_c_1456_p N_noxref_9_c_2070_n ) capacitor c=0.00429591f \
 //x=19.87 //y=4.97 //x2=19.81 //y2=5.335
cc_1116 ( N_noxref_6_M39_noxref_g N_noxref_9_M38_noxref_d ) capacitor \
 c=0.0180032f //x=19.945 //y=6.2 //x2=19.58 //y2=5.2
cc_1117 ( N_noxref_6_c_1375_n N_noxref_11_c_2240_n ) capacitor c=0.147447f \
 //x=6.24 //y=3.88 //x2=11.79 //y2=4.25
cc_1118 ( N_noxref_6_c_1376_n N_noxref_11_c_2240_n ) capacitor c=0.0294294f \
 //x=4.62 //y=3.88 //x2=11.79 //y2=4.25
cc_1119 ( N_noxref_6_c_1350_n N_noxref_11_c_2240_n ) capacitor c=0.467229f \
 //x=19.19 //y=3.88 //x2=11.79 //y2=4.25
cc_1120 ( N_noxref_6_c_1383_n N_noxref_11_c_2240_n ) capacitor c=0.0264476f \
 //x=6.47 //y=3.88 //x2=11.79 //y2=4.25
cc_1121 ( N_noxref_6_c_1306_n N_noxref_11_c_2240_n ) capacitor c=0.0154449f \
 //x=2.05 //y=5.335 //x2=11.79 //y2=4.25
cc_1122 ( N_noxref_6_c_1316_n N_noxref_11_c_2240_n ) capacitor c=0.0200328f \
 //x=4.505 //y=3.88 //x2=11.79 //y2=4.25
cc_1123 ( N_noxref_6_c_1317_n N_noxref_11_c_2240_n ) capacitor c=0.0213516f \
 //x=6.355 //y=2.26 //x2=11.79 //y2=4.25
cc_1124 ( N_noxref_6_c_1350_n N_noxref_11_c_2247_n ) capacitor c=0.467529f \
 //x=19.19 //y=3.88 //x2=17.34 //y2=4.25
cc_1125 ( N_noxref_6_c_1350_n N_noxref_11_c_2343_n ) capacitor c=0.0267832f \
 //x=19.19 //y=3.88 //x2=12.02 //y2=4.25
cc_1126 ( N_noxref_6_c_1350_n N_noxref_11_c_2249_n ) capacitor c=0.176507f \
 //x=19.19 //y=3.88 //x2=24.74 //y2=4.25
cc_1127 ( N_noxref_6_c_1320_n N_noxref_11_c_2249_n ) capacitor c=0.0252746f \
 //x=19.305 //y=2.26 //x2=24.74 //y2=4.25
cc_1128 ( N_noxref_6_c_1333_n N_noxref_11_c_2249_n ) capacitor c=0.0115418f \
 //x=19.58 //y=4.97 //x2=24.74 //y2=4.25
cc_1129 ( N_noxref_6_c_1350_n N_noxref_11_c_2260_n ) capacitor c=0.0268461f \
 //x=19.19 //y=3.88 //x2=17.57 //y2=4.25
cc_1130 ( N_noxref_6_c_1320_n N_noxref_11_c_2260_n ) capacitor c=3.50683e-19 \
 //x=19.305 //y=2.26 //x2=17.57 //y2=4.25
cc_1131 ( N_noxref_6_c_1350_n N_noxref_11_c_2266_n ) capacitor c=0.0236433f \
 //x=19.19 //y=3.88 //x2=11.905 //y2=2.26
cc_1132 ( N_noxref_6_c_1350_n N_noxref_11_c_2282_n ) capacitor c=0.0261231f \
 //x=19.19 //y=3.88 //x2=17.455 //y2=4.25
cc_1133 ( N_noxref_6_c_1320_n N_noxref_11_c_2282_n ) capacitor c=0.0144739f \
 //x=19.305 //y=2.26 //x2=17.455 //y2=4.25
cc_1134 ( N_noxref_6_c_1306_n N_noxref_11_M16_noxref_g ) capacitor \
 c=0.0213876f //x=2.05 //y=5.335 //x2=1.745 //y2=6.2
cc_1135 ( N_noxref_6_c_1302_n N_noxref_11_M17_noxref_g ) capacitor \
 c=0.0178794f //x=2.76 //y=5.335 //x2=2.185 //y2=6.2
cc_1136 ( N_noxref_6_M16_noxref_d N_noxref_11_M17_noxref_g ) capacitor \
 c=0.0180032f //x=1.82 //y=5.2 //x2=2.185 //y2=6.2
cc_1137 ( N_noxref_6_c_1306_n N_noxref_11_c_2447_n ) capacitor c=0.00429591f \
 //x=2.05 //y=5.335 //x2=2.11 //y2=4.97
cc_1138 ( N_noxref_6_M2_noxref_d N_noxref_12_M0_noxref_s ) capacitor \
 c=0.00309936f //x=3.83 //y=1.095 //x2=0.89 //y2=0.555
cc_1139 ( N_noxref_6_c_1351_n N_noxref_13_c_2701_n ) capacitor c=0.00466084f \
 //x=4.42 //y=1.845 //x2=4.42 //y2=0.72
cc_1140 ( N_noxref_6_M2_noxref_d N_noxref_13_c_2701_n ) capacitor c=0.0117786f \
 //x=3.83 //y=1.095 //x2=4.42 //y2=0.72
cc_1141 ( N_noxref_6_c_1390_n N_noxref_13_c_2715_n ) capacitor c=0.0200405f \
 //x=4.105 //y=1.845 //x2=3.535 //y2=1.175
cc_1142 ( N_noxref_6_M2_noxref_d N_noxref_13_M1_noxref_d ) capacitor \
 c=5.27807e-19 //x=3.83 //y=1.095 //x2=2.295 //y2=1.09
cc_1143 ( N_noxref_6_c_1351_n N_noxref_13_M2_noxref_s ) capacitor c=0.0207678f \
 //x=4.42 //y=1.845 //x2=3.4 //y2=0.555
cc_1144 ( N_noxref_6_M2_noxref_d N_noxref_13_M2_noxref_s ) capacitor \
 c=0.0426368f //x=3.83 //y=1.095 //x2=3.4 //y2=0.555
cc_1145 ( N_noxref_6_c_1317_n N_D_c_2755_n ) capacitor c=0.0482383f //x=6.355 \
 //y=2.26 //x2=7.465 //y2=2.26
cc_1146 ( N_noxref_6_c_1358_n N_D_c_2755_n ) capacitor c=0.00238338f //x=6.055 \
 //y=2.095 //x2=7.465 //y2=2.26
cc_1147 ( N_noxref_6_c_1350_n N_D_c_2749_n ) capacitor c=0.0190398f //x=19.19 \
 //y=3.88 //x2=7.465 //y2=4.88
cc_1148 ( N_noxref_6_c_1383_n N_D_c_2749_n ) capacitor c=9.95819e-19 //x=6.47 \
 //y=3.88 //x2=7.465 //y2=4.88
cc_1149 ( N_noxref_6_c_1404_n N_D_c_2749_n ) capacitor c=0.00147352f //x=6.92 \
 //y=4.97 //x2=7.465 //y2=4.88
cc_1150 ( N_noxref_6_c_1331_n N_D_c_2749_n ) capacitor c=0.00142741f //x=6.63 \
 //y=4.97 //x2=7.465 //y2=4.88
cc_1151 ( N_noxref_6_c_1316_n N_D_c_2778_n ) capacitor c=4.03171e-19 //x=4.505 \
 //y=3.88 //x2=7.492 //y2=3.055
cc_1152 ( N_noxref_6_M22_noxref_g N_D_M24_noxref_g ) capacitor c=0.0105869f \
 //x=6.555 //y=6.2 //x2=7.435 //y2=6.2
cc_1153 ( N_noxref_6_M23_noxref_g N_D_M24_noxref_g ) capacitor c=0.10632f \
 //x=6.995 //y=6.2 //x2=7.435 //y2=6.2
cc_1154 ( N_noxref_6_M23_noxref_g N_D_M25_noxref_g ) capacitor c=0.0101598f \
 //x=6.995 //y=6.2 //x2=7.875 //y2=6.2
cc_1155 ( N_noxref_6_c_1354_n N_D_c_2782_n ) capacitor c=5.72482e-19 //x=6.055 \
 //y=1.055 //x2=7.03 //y2=1.09
cc_1156 ( N_noxref_6_c_1356_n N_D_c_2782_n ) capacitor c=0.00149976f //x=6.055 \
 //y=1.4 //x2=7.03 //y2=1.09
cc_1157 ( N_noxref_6_c_1361_n N_D_c_2782_n ) capacitor c=0.0160123f //x=6.585 \
 //y=1.055 //x2=7.03 //y2=1.09
cc_1158 ( N_noxref_6_c_1357_n N_D_c_2785_n ) capacitor c=0.00111227f //x=6.055 \
 //y=1.71 //x2=7.03 //y2=1.4
cc_1159 ( N_noxref_6_c_1363_n N_D_c_2785_n ) capacitor c=0.0124075f //x=6.585 \
 //y=1.4 //x2=7.03 //y2=1.4
cc_1160 ( N_noxref_6_c_1361_n N_D_c_2787_n ) capacitor c=0.00103227f //x=6.585 \
 //y=1.055 //x2=7.555 //y2=1.09
cc_1161 ( N_noxref_6_c_1363_n N_D_c_2788_n ) capacitor c=0.0010154f //x=6.585 \
 //y=1.4 //x2=7.555 //y2=1.4
cc_1162 ( N_noxref_6_c_1363_n N_D_c_2789_n ) capacitor c=9.23422e-19 //x=6.585 \
 //y=1.4 //x2=7.555 //y2=1.63
cc_1163 ( N_noxref_6_c_1317_n N_D_c_2790_n ) capacitor c=0.00231304f //x=6.355 \
 //y=2.26 //x2=7.555 //y2=2.095
cc_1164 ( N_noxref_6_c_1358_n N_D_c_2790_n ) capacitor c=0.00964411f //x=6.055 \
 //y=2.095 //x2=7.555 //y2=2.095
cc_1165 ( N_noxref_6_c_1317_n N_D_c_2768_n ) capacitor c=0.00183762f //x=6.355 \
 //y=2.26 //x2=7.465 //y2=4.88
cc_1166 ( N_noxref_6_c_1404_n N_D_c_2768_n ) capacitor c=0.0168581f //x=6.92 \
 //y=4.97 //x2=7.465 //y2=4.88
cc_1167 ( N_noxref_6_c_1331_n N_D_c_2768_n ) capacitor c=0.00484466f //x=6.63 \
 //y=4.97 //x2=7.465 //y2=4.88
cc_1168 ( N_noxref_6_c_1351_n N_noxref_15_c_2854_n ) capacitor c=3.84569e-19 \
 //x=4.42 //y=1.845 //x2=5.835 //y2=1.685
cc_1169 ( N_noxref_6_c_1358_n N_noxref_15_c_2854_n ) capacitor c=0.0034165f \
 //x=6.055 //y=2.095 //x2=5.835 //y2=1.685
cc_1170 ( N_noxref_6_c_1317_n N_noxref_15_c_2838_n ) capacitor c=0.0125801f \
 //x=6.355 //y=2.26 //x2=6.72 //y2=1.77
cc_1171 ( N_noxref_6_c_1357_n N_noxref_15_c_2838_n ) capacitor c=0.00703864f \
 //x=6.055 //y=1.71 //x2=6.72 //y2=1.77
cc_1172 ( N_noxref_6_c_1358_n N_noxref_15_c_2838_n ) capacitor c=0.0245895f \
 //x=6.055 //y=2.095 //x2=6.72 //y2=1.77
cc_1173 ( N_noxref_6_c_1360_n N_noxref_15_c_2838_n ) capacitor c=0.00708583f \
 //x=6.43 //y=1.555 //x2=6.72 //y2=1.77
cc_1174 ( N_noxref_6_c_1363_n N_noxref_15_c_2838_n ) capacitor c=0.00698822f \
 //x=6.585 //y=1.4 //x2=6.72 //y2=1.77
cc_1175 ( N_noxref_6_c_1354_n N_noxref_15_M3_noxref_s ) capacitor c=0.0327271f \
 //x=6.055 //y=1.055 //x2=5.7 //y2=0.555
cc_1176 ( N_noxref_6_c_1357_n N_noxref_15_M3_noxref_s ) capacitor \
 c=7.99997e-19 //x=6.055 //y=1.71 //x2=5.7 //y2=0.555
cc_1177 ( N_noxref_6_c_1358_n N_noxref_15_M3_noxref_s ) capacitor \
 c=0.00122123f //x=6.055 //y=2.095 //x2=5.7 //y2=0.555
cc_1178 ( N_noxref_6_c_1361_n N_noxref_15_M3_noxref_s ) capacitor c=0.0121427f \
 //x=6.585 //y=1.055 //x2=5.7 //y2=0.555
cc_1179 ( N_noxref_6_M2_noxref_d N_noxref_15_M3_noxref_s ) capacitor \
 c=2.55333e-19 //x=3.83 //y=1.095 //x2=5.7 //y2=0.555
cc_1180 ( N_noxref_6_c_1368_n N_noxref_20_c_3116_n ) capacitor c=0.0034165f \
 //x=19.005 //y=2.095 //x2=18.785 //y2=1.685
cc_1181 ( N_noxref_6_c_1320_n N_noxref_20_c_3100_n ) capacitor c=0.0119952f \
 //x=19.305 //y=2.26 //x2=19.67 //y2=1.77
cc_1182 ( N_noxref_6_c_1367_n N_noxref_20_c_3100_n ) capacitor c=0.00697148f \
 //x=19.005 //y=1.71 //x2=19.67 //y2=1.77
cc_1183 ( N_noxref_6_c_1368_n N_noxref_20_c_3100_n ) capacitor c=0.0204849f \
 //x=19.005 //y=2.095 //x2=19.67 //y2=1.77
cc_1184 ( N_noxref_6_c_1370_n N_noxref_20_c_3100_n ) capacitor c=0.00610316f \
 //x=19.38 //y=1.555 //x2=19.67 //y2=1.77
cc_1185 ( N_noxref_6_c_1373_n N_noxref_20_c_3100_n ) capacitor c=0.00698822f \
 //x=19.535 //y=1.4 //x2=19.67 //y2=1.77
cc_1186 ( N_noxref_6_c_1364_n N_noxref_20_M11_noxref_s ) capacitor \
 c=0.0327271f //x=19.005 //y=1.055 //x2=18.65 //y2=0.555
cc_1187 ( N_noxref_6_c_1367_n N_noxref_20_M11_noxref_s ) capacitor \
 c=7.99997e-19 //x=19.005 //y=1.71 //x2=18.65 //y2=0.555
cc_1188 ( N_noxref_6_c_1368_n N_noxref_20_M11_noxref_s ) capacitor \
 c=0.00122123f //x=19.005 //y=2.095 //x2=18.65 //y2=0.555
cc_1189 ( N_noxref_6_c_1371_n N_noxref_20_M11_noxref_s ) capacitor \
 c=0.0121427f //x=19.535 //y=1.055 //x2=18.65 //y2=0.555
cc_1190 ( RN Q ) capacitor c=0.00505269f //x=20.47 //y=2.77 //x2=21.58 //y2=2.77
cc_1191 ( RN Q ) capacitor c=0.00505269f //x=20.47 //y=3.14 //x2=21.58 //y2=3.14
cc_1192 ( RN Q ) capacitor c=0.00466444f //x=20.47 //y=3.51 //x2=21.58 //y2=3.51
cc_1193 ( RN Q ) capacitor c=0.00599562f //x=20.47 //y=3.88 //x2=21.58 //y2=3.88
cc_1194 ( N_RN_c_1687_n Q ) capacitor c=3.28865e-19 //x=20.442 //y=3.795 \
 //x2=21.58 //y2=3.88
cc_1195 ( N_RN_c_1560_n Q ) capacitor c=3.28865e-19 //x=20.442 //y=4.535 \
 //x2=21.58 //y2=3.88
cc_1196 ( RN Q ) capacitor c=0.00505269f //x=20.47 //y=4.62 //x2=21.58 //y2=4.62
cc_1197 ( N_RN_c_1583_n N_Q_c_1919_n ) capacitor c=0.00510792f //x=20.3 \
 //y=2.4 //x2=21.525 //y2=2.26
cc_1198 ( N_RN_c_1682_n N_Q_c_1919_n ) capacitor c=0.00486306f //x=20.415 \
 //y=2.485 //x2=21.525 //y2=2.26
cc_1199 ( N_RN_c_1592_n N_Q_c_1919_n ) capacitor c=0.00394656f //x=20.442 \
 //y=2.685 //x2=21.525 //y2=2.26
cc_1200 ( N_RN_c_1700_n N_Q_c_1919_n ) capacitor c=0.00265785f //x=20.505 \
 //y=2.095 //x2=21.525 //y2=2.26
cc_1201 ( N_RN_c_1559_n N_Q_c_1886_n ) capacitor c=0.0048991f //x=20.415 \
 //y=4.88 //x2=21.525 //y2=4.88
cc_1202 ( N_RN_c_1702_n N_Q_c_1886_n ) capacitor c=0.00142741f //x=20.415 \
 //y=4.88 //x2=21.525 //y2=4.88
cc_1203 ( N_RN_c_1718_p N_Q_c_1943_n ) capacitor c=0.00419471f //x=20.442 \
 //y=3.055 //x2=21.552 //y2=3.055
cc_1204 ( N_RN_c_1719_p N_Q_c_1944_n ) capacitor c=0.00415652f //x=20.442 \
 //y=3.425 //x2=21.552 //y2=3.425
cc_1205 ( N_RN_c_1687_n N_Q_c_1945_n ) capacitor c=0.00396935f //x=20.442 \
 //y=3.795 //x2=21.552 //y2=3.795
cc_1206 ( N_RN_c_1560_n N_Q_c_1897_n ) capacitor c=0.00946652f //x=20.442 \
 //y=4.535 //x2=21.552 //y2=4.535
cc_1207 ( N_RN_M40_noxref_g N_Q_M42_noxref_g ) capacitor c=0.0101598f \
 //x=20.385 //y=6.2 //x2=21.265 //y2=6.2
cc_1208 ( N_RN_M41_noxref_g N_Q_M42_noxref_g ) capacitor c=0.0602553f \
 //x=20.825 //y=6.2 //x2=21.265 //y2=6.2
cc_1209 ( N_RN_M41_noxref_g N_Q_M43_noxref_g ) capacitor c=0.0101598f \
 //x=20.825 //y=6.2 //x2=21.705 //y2=6.2
cc_1210 ( N_RN_c_1697_n N_Q_c_1950_n ) capacitor c=0.00456962f //x=20.505 \
 //y=1.09 //x2=21.515 //y2=1.095
cc_1211 ( N_RN_c_1698_n N_Q_c_1951_n ) capacitor c=0.00438372f //x=20.505 \
 //y=1.4 //x2=21.515 //y2=1.44
cc_1212 ( N_RN_c_1699_n N_Q_c_1952_n ) capacitor c=0.00438372f //x=20.505 \
 //y=1.63 //x2=21.515 //y2=1.75
cc_1213 ( N_RN_c_1583_n N_Q_c_1953_n ) capacitor c=0.0034041f //x=20.3 //y=2.4 \
 //x2=21.525 //y2=2.26
cc_1214 ( N_RN_c_1682_n N_Q_c_1953_n ) capacitor c=0.00264042f //x=20.415 \
 //y=2.485 //x2=21.525 //y2=2.26
cc_1215 ( N_RN_c_1700_n N_Q_c_1953_n ) capacitor c=0.00872421f //x=20.505 \
 //y=2.095 //x2=21.525 //y2=2.26
cc_1216 ( N_RN_c_1700_n N_Q_c_1956_n ) capacitor c=0.00438372f //x=20.505 \
 //y=2.095 //x2=21.525 //y2=2.095
cc_1217 ( N_RN_c_1559_n N_Q_c_1957_n ) capacitor c=0.00219458f //x=20.415 \
 //y=4.88 //x2=21.525 //y2=4.88
cc_1218 ( N_RN_c_1733_p N_Q_c_1957_n ) capacitor c=0.0611812f //x=20.75 \
 //y=4.97 //x2=21.525 //y2=4.88
cc_1219 ( N_RN_c_1702_n N_Q_c_1957_n ) capacitor c=0.00487508f //x=20.415 \
 //y=4.88 //x2=21.525 //y2=4.88
cc_1220 ( RN N_noxref_9_c_2066_n ) capacitor c=2.03999e-19 //x=20.47 //y=3.88 \
 //x2=20.52 //y2=5.335
cc_1221 ( RN N_noxref_9_c_2066_n ) capacitor c=0.00167542f //x=20.47 //y=4.62 \
 //x2=20.52 //y2=5.335
cc_1222 ( N_RN_c_1559_n N_noxref_9_c_2066_n ) capacitor c=0.0148665f \
 //x=20.415 //y=4.88 //x2=20.52 //y2=5.335
cc_1223 ( N_RN_M40_noxref_g N_noxref_9_c_2066_n ) capacitor c=0.0166659f \
 //x=20.385 //y=6.2 //x2=20.52 //y2=5.335
cc_1224 ( N_RN_c_1702_n N_noxref_9_c_2066_n ) capacitor c=0.00322396f \
 //x=20.415 //y=4.88 //x2=20.52 //y2=5.335
cc_1225 ( N_RN_M41_noxref_g N_noxref_9_c_2072_n ) capacitor c=0.0184045f \
 //x=20.825 //y=6.2 //x2=21.4 //y2=5.335
cc_1226 ( N_RN_c_1559_n N_noxref_9_c_2080_n ) capacitor c=5.75692e-19 \
 //x=20.415 //y=4.88 //x2=22.265 //y2=3.51
cc_1227 ( N_RN_c_1592_n N_noxref_9_c_2080_n ) capacitor c=2.07059e-19 \
 //x=20.442 //y=2.685 //x2=22.265 //y2=3.51
cc_1228 ( N_RN_c_1687_n N_noxref_9_c_2080_n ) capacitor c=2.37933e-19 \
 //x=20.442 //y=3.795 //x2=22.265 //y2=3.51
cc_1229 ( N_RN_c_1560_n N_noxref_9_c_2080_n ) capacitor c=4.13769e-19 \
 //x=20.442 //y=4.535 //x2=22.265 //y2=3.51
cc_1230 ( N_RN_c_1733_p N_noxref_9_c_2114_n ) capacitor c=0.00420239f \
 //x=20.75 //y=4.97 //x2=20.605 //y2=5.335
cc_1231 ( N_RN_M40_noxref_g N_noxref_9_M40_noxref_d ) capacitor c=0.0180032f \
 //x=20.385 //y=6.2 //x2=20.46 //y2=5.2
cc_1232 ( N_RN_M41_noxref_g N_noxref_9_M40_noxref_d ) capacitor c=0.0180032f \
 //x=20.825 //y=6.2 //x2=20.46 //y2=5.2
cc_1233 ( N_RN_c_1573_n N_noxref_11_c_2240_n ) capacitor c=0.00314955f \
 //x=16.6 //y=2.4 //x2=11.79 //y2=4.25
cc_1234 ( N_RN_c_1557_n N_noxref_11_c_2240_n ) capacitor c=0.0179722f \
 //x=8.575 //y=4.88 //x2=11.79 //y2=4.25
cc_1235 ( N_RN_c_1573_n N_noxref_11_c_2247_n ) capacitor c=0.0143182f //x=16.6 \
 //y=2.4 //x2=17.34 //y2=4.25
cc_1236 ( N_RN_c_1583_n N_noxref_11_c_2247_n ) capacitor c=0.00321562f \
 //x=20.3 //y=2.4 //x2=17.34 //y2=4.25
cc_1237 ( N_RN_c_1587_n N_noxref_11_c_2247_n ) capacitor c=2.67586e-19 \
 //x=16.83 //y=2.4 //x2=17.34 //y2=4.25
cc_1238 ( N_RN_c_1558_n N_noxref_11_c_2247_n ) capacitor c=0.0219145f \
 //x=16.715 //y=4.88 //x2=17.34 //y2=4.25
cc_1239 ( N_RN_c_1668_n N_noxref_11_c_2247_n ) capacitor c=0.00881004f \
 //x=16.715 //y=4.88 //x2=17.34 //y2=4.25
cc_1240 ( N_RN_c_1573_n N_noxref_11_c_2343_n ) capacitor c=2.80052e-19 \
 //x=16.6 //y=2.4 //x2=12.02 //y2=4.25
cc_1241 ( N_RN_c_1583_n N_noxref_11_c_2249_n ) capacitor c=0.0252231f //x=20.3 \
 //y=2.4 //x2=24.74 //y2=4.25
cc_1242 ( RN N_noxref_11_c_2249_n ) capacitor c=0.0013124f //x=20.47 //y=3.88 \
 //x2=24.74 //y2=4.25
cc_1243 ( RN N_noxref_11_c_2249_n ) capacitor c=0.00156006f //x=20.47 //y=4.62 \
 //x2=24.74 //y2=4.25
cc_1244 ( N_RN_c_1560_n N_noxref_11_c_2249_n ) capacitor c=0.0283962f \
 //x=20.442 //y=4.535 //x2=24.74 //y2=4.25
cc_1245 ( N_RN_c_1733_p N_noxref_11_c_2249_n ) capacitor c=0.00489617f \
 //x=20.75 //y=4.97 //x2=24.74 //y2=4.25
cc_1246 ( N_RN_c_1702_n N_noxref_11_c_2249_n ) capacitor c=9.0988e-19 \
 //x=20.415 //y=4.88 //x2=24.74 //y2=4.25
cc_1247 ( N_RN_c_1583_n N_noxref_11_c_2260_n ) capacitor c=2.98411e-19 \
 //x=20.3 //y=2.4 //x2=17.57 //y2=4.25
cc_1248 ( N_RN_c_1558_n N_noxref_11_c_2260_n ) capacitor c=0.00179385f \
 //x=16.715 //y=4.88 //x2=17.57 //y2=4.25
cc_1249 ( N_RN_c_1573_n N_noxref_11_c_2266_n ) capacitor c=0.0226984f //x=16.6 \
 //y=2.4 //x2=11.905 //y2=2.26
cc_1250 ( N_RN_M36_noxref_g N_noxref_11_c_2274_n ) capacitor c=0.0184045f \
 //x=16.455 //y=6.2 //x2=16.59 //y2=5.335
cc_1251 ( RN N_noxref_11_c_2278_n ) capacitor c=4.16404e-19 //x=16.77 //y=3.51 \
 //x2=17.37 //y2=5.335
cc_1252 ( N_RN_M37_noxref_g N_noxref_11_c_2278_n ) capacitor c=0.0205615f \
 //x=16.895 //y=6.2 //x2=17.37 //y2=5.335
cc_1253 ( N_RN_c_1668_n N_noxref_11_c_2278_n ) capacitor c=0.00201851f \
 //x=16.715 //y=4.88 //x2=17.37 //y2=5.335
cc_1254 ( N_RN_c_1769_p N_noxref_11_c_2322_n ) capacitor c=0.00371277f \
 //x=17.08 //y=1.595 //x2=17.37 //y2=1.845
cc_1255 ( N_RN_c_1770_p N_noxref_11_c_2322_n ) capacitor c=0.00457401f \
 //x=17.235 //y=1.44 //x2=17.37 //y2=1.845
cc_1256 ( N_RN_c_1583_n N_noxref_11_c_2499_n ) capacitor c=0.016327f //x=20.3 \
 //y=2.4 //x2=17.055 //y2=1.845
cc_1257 ( N_RN_c_1583_n N_noxref_11_c_2282_n ) capacitor c=0.0243598f //x=20.3 \
 //y=2.4 //x2=17.455 //y2=4.25
cc_1258 ( N_RN_c_1587_n N_noxref_11_c_2282_n ) capacitor c=0.0012045f \
 //x=16.83 //y=2.4 //x2=17.455 //y2=4.25
cc_1259 ( RN N_noxref_11_c_2282_n ) capacitor c=0.00777753f //x=16.77 //y=2.77 \
 //x2=17.455 //y2=4.25
cc_1260 ( RN N_noxref_11_c_2282_n ) capacitor c=0.00777753f //x=16.77 //y=3.14 \
 //x2=17.455 //y2=4.25
cc_1261 ( RN N_noxref_11_c_2282_n ) capacitor c=0.00752038f //x=16.77 //y=3.51 \
 //x2=17.455 //y2=4.25
cc_1262 ( N_RN_c_1649_n N_noxref_11_c_2282_n ) capacitor c=0.00952708f \
 //x=16.715 //y=2.485 //x2=17.455 //y2=4.25
cc_1263 ( N_RN_c_1558_n N_noxref_11_c_2282_n ) capacitor c=0.0394101f \
 //x=16.715 //y=4.88 //x2=17.455 //y2=4.25
cc_1264 ( N_RN_c_1591_n N_noxref_11_c_2282_n ) capacitor c=0.00619366f \
 //x=16.742 //y=2.685 //x2=17.455 //y2=4.25
cc_1265 ( N_RN_c_1656_n N_noxref_11_c_2282_n ) capacitor c=0.0065098f \
 //x=16.742 //y=3.055 //x2=17.455 //y2=4.25
cc_1266 ( N_RN_c_1657_n N_noxref_11_c_2282_n ) capacitor c=0.00646753f \
 //x=16.742 //y=3.425 //x2=17.455 //y2=4.25
cc_1267 ( N_RN_c_1718_p N_noxref_11_c_2282_n ) capacitor c=7.08595e-19 \
 //x=20.442 //y=3.055 //x2=17.455 //y2=4.25
cc_1268 ( N_RN_c_1665_n N_noxref_11_c_2282_n ) capacitor c=0.00780434f \
 //x=16.715 //y=2.26 //x2=17.455 //y2=4.25
cc_1269 ( N_RN_c_1667_n N_noxref_11_c_2282_n ) capacitor c=0.00283672f \
 //x=16.715 //y=2.095 //x2=17.455 //y2=4.25
cc_1270 ( N_RN_c_1668_n N_noxref_11_c_2282_n ) capacitor c=0.013693f \
 //x=16.715 //y=4.88 //x2=17.455 //y2=4.25
cc_1271 ( N_RN_c_1558_n N_noxref_11_c_2514_n ) capacitor c=0.0169409f \
 //x=16.715 //y=4.88 //x2=16.675 //y2=5.335
cc_1272 ( N_RN_c_1668_n N_noxref_11_c_2514_n ) capacitor c=0.00475729f \
 //x=16.715 //y=4.88 //x2=16.675 //y2=5.335
cc_1273 ( N_RN_c_1573_n N_noxref_11_c_2392_n ) capacitor c=3.11115e-19 \
 //x=16.6 //y=2.4 //x2=12.315 //y2=1.585
cc_1274 ( N_RN_c_1573_n N_noxref_11_c_2364_n ) capacitor c=0.00571486f \
 //x=16.6 //y=2.4 //x2=11.905 //y2=2.26
cc_1275 ( N_RN_c_1661_n N_noxref_11_M10_noxref_d ) capacitor c=0.00217566f \
 //x=16.705 //y=1.095 //x2=16.78 //y2=1.095
cc_1276 ( N_RN_c_1662_n N_noxref_11_M10_noxref_d ) capacitor c=0.0034598f \
 //x=16.705 //y=1.44 //x2=16.78 //y2=1.095
cc_1277 ( N_RN_c_1663_n N_noxref_11_M10_noxref_d ) capacitor c=0.00546784f \
 //x=16.705 //y=1.75 //x2=16.78 //y2=1.095
cc_1278 ( N_RN_c_1793_p N_noxref_11_M10_noxref_d ) capacitor c=0.00241102f \
 //x=17.08 //y=0.94 //x2=16.78 //y2=1.095
cc_1279 ( N_RN_c_1769_p N_noxref_11_M10_noxref_d ) capacitor c=0.0138621f \
 //x=17.08 //y=1.595 //x2=16.78 //y2=1.095
cc_1280 ( N_RN_c_1795_p N_noxref_11_M10_noxref_d ) capacitor c=0.00219619f \
 //x=17.235 //y=1.095 //x2=16.78 //y2=1.095
cc_1281 ( N_RN_c_1770_p N_noxref_11_M10_noxref_d ) capacitor c=0.00603828f \
 //x=17.235 //y=1.44 //x2=16.78 //y2=1.095
cc_1282 ( N_RN_c_1667_n N_noxref_11_M10_noxref_d ) capacitor c=0.00661782f \
 //x=16.715 //y=2.095 //x2=16.78 //y2=1.095
cc_1283 ( N_RN_M36_noxref_g N_noxref_11_M36_noxref_d ) capacitor c=0.0180032f \
 //x=16.455 //y=6.2 //x2=16.53 //y2=5.2
cc_1284 ( N_RN_M37_noxref_g N_noxref_11_M36_noxref_d ) capacitor c=0.0194246f \
 //x=16.895 //y=6.2 //x2=16.53 //y2=5.2
cc_1285 ( RN D ) capacitor c=0.00505269f //x=8.63 //y=2.77 //x2=7.52 //y2=2.77
cc_1286 ( RN D ) capacitor c=0.00505269f //x=8.63 //y=3.14 //x2=7.52 //y2=3.14
cc_1287 ( N_RN_c_1581_n N_D_c_2755_n ) capacitor c=0.00558344f //x=8.69 \
 //y=2.4 //x2=7.465 //y2=2.26
cc_1288 ( N_RN_c_1606_n N_D_c_2755_n ) capacitor c=0.00847578f //x=8.575 \
 //y=2.485 //x2=7.465 //y2=2.26
cc_1289 ( N_RN_c_1627_n N_D_c_2755_n ) capacitor c=0.00209043f //x=8.575 \
 //y=2.26 //x2=7.465 //y2=2.26
cc_1290 ( N_RN_c_1557_n N_D_c_2749_n ) capacitor c=0.0265853f //x=8.575 \
 //y=4.88 //x2=7.465 //y2=4.88
cc_1291 ( N_RN_c_1630_n N_D_c_2749_n ) capacitor c=0.00219458f //x=8.575 \
 //y=4.88 //x2=7.465 //y2=4.88
cc_1292 ( N_RN_c_1613_n N_D_c_2778_n ) capacitor c=0.00419471f //x=8.602 \
 //y=3.055 //x2=7.492 //y2=3.055
cc_1293 ( N_RN_M26_noxref_g N_D_M24_noxref_g ) capacitor c=0.0101598f \
 //x=8.315 //y=6.2 //x2=7.435 //y2=6.2
cc_1294 ( N_RN_M26_noxref_g N_D_M25_noxref_g ) capacitor c=0.0602553f \
 //x=8.315 //y=6.2 //x2=7.875 //y2=6.2
cc_1295 ( N_RN_M27_noxref_g N_D_M25_noxref_g ) capacitor c=0.0101598f \
 //x=8.755 //y=6.2 //x2=7.875 //y2=6.2
cc_1296 ( N_RN_c_1618_n N_D_c_2787_n ) capacitor c=0.00456962f //x=8.565 \
 //y=1.095 //x2=7.555 //y2=1.09
cc_1297 ( N_RN_c_1619_n N_D_c_2788_n ) capacitor c=0.00438372f //x=8.565 \
 //y=1.44 //x2=7.555 //y2=1.4
cc_1298 ( N_RN_c_1620_n N_D_c_2789_n ) capacitor c=0.00438372f //x=8.565 \
 //y=1.75 //x2=7.555 //y2=1.63
cc_1299 ( N_RN_c_1581_n N_D_c_2790_n ) capacitor c=0.00341397f //x=8.69 \
 //y=2.4 //x2=7.555 //y2=2.095
cc_1300 ( N_RN_c_1606_n N_D_c_2790_n ) capacitor c=0.00223694f //x=8.575 \
 //y=2.485 //x2=7.555 //y2=2.095
cc_1301 ( N_RN_c_1627_n N_D_c_2790_n ) capacitor c=0.00881982f //x=8.575 \
 //y=2.26 //x2=7.555 //y2=2.095
cc_1302 ( N_RN_c_1628_n N_D_c_2790_n ) capacitor c=0.00438372f //x=8.575 \
 //y=2.095 //x2=7.555 //y2=2.095
cc_1303 ( N_RN_c_1630_n N_D_c_2767_n ) capacitor c=0.0611812f //x=8.575 \
 //y=4.88 //x2=7.8 //y2=4.97
cc_1304 ( N_RN_c_1557_n N_D_c_2768_n ) capacitor c=0.00142741f //x=8.575 \
 //y=4.88 //x2=7.465 //y2=4.88
cc_1305 ( N_RN_c_1630_n N_D_c_2768_n ) capacitor c=0.00487508f //x=8.575 \
 //y=4.88 //x2=7.465 //y2=4.88
cc_1306 ( N_RN_c_1573_n N_noxref_16_c_2894_n ) capacitor c=4.68462e-19 \
 //x=16.6 //y=2.4 //x2=9.23 //y2=0.72
cc_1307 ( N_RN_c_1581_n N_noxref_16_c_2894_n ) capacitor c=4.26424e-19 \
 //x=8.69 //y=2.4 //x2=9.23 //y2=0.72
cc_1308 ( N_RN_c_1606_n N_noxref_16_c_2894_n ) capacitor c=0.00234129f \
 //x=8.575 //y=2.485 //x2=9.23 //y2=0.72
cc_1309 ( N_RN_c_1618_n N_noxref_16_c_2894_n ) capacitor c=0.0190866f \
 //x=8.565 //y=1.095 //x2=9.23 //y2=0.72
cc_1310 ( N_RN_c_1624_n N_noxref_16_c_2894_n ) capacitor c=0.00656458f \
 //x=9.095 //y=1.095 //x2=9.23 //y2=0.72
cc_1311 ( N_RN_c_1627_n N_noxref_16_c_2894_n ) capacitor c=2.20712e-19 \
 //x=8.575 //y=2.26 //x2=9.23 //y2=0.72
cc_1312 ( N_RN_c_1619_n N_noxref_16_c_2906_n ) capacitor c=0.00538829f \
 //x=8.565 //y=1.44 //x2=8.345 //y2=1.175
cc_1313 ( N_RN_c_1618_n N_noxref_16_M5_noxref_s ) capacitor c=0.00538829f \
 //x=8.565 //y=1.095 //x2=8.21 //y2=0.555
cc_1314 ( N_RN_c_1620_n N_noxref_16_M5_noxref_s ) capacitor c=0.00538829f \
 //x=8.565 //y=1.75 //x2=8.21 //y2=0.555
cc_1315 ( N_RN_c_1624_n N_noxref_16_M5_noxref_s ) capacitor c=0.0143002f \
 //x=9.095 //y=1.095 //x2=8.21 //y2=0.555
cc_1316 ( N_RN_c_1625_n N_noxref_16_M5_noxref_s ) capacitor c=0.00290153f \
 //x=9.095 //y=1.44 //x2=8.21 //y2=0.555
cc_1317 ( N_RN_c_1573_n N_noxref_17_c_2962_n ) capacitor c=0.00635755f \
 //x=16.6 //y=2.4 //x2=10.75 //y2=1.675
cc_1318 ( N_RN_c_1573_n N_noxref_17_c_2943_n ) capacitor c=0.0223494f //x=16.6 \
 //y=2.4 //x2=11.635 //y2=1.76
cc_1319 ( N_RN_c_1573_n N_noxref_17_c_2950_n ) capacitor c=0.00649228f \
 //x=16.6 //y=2.4 //x2=11.72 //y2=1.675
cc_1320 ( N_RN_c_1573_n N_noxref_17_c_2951_n ) capacitor c=0.00178534f \
 //x=16.6 //y=2.4 //x2=12.605 //y2=0.71
cc_1321 ( N_RN_c_1573_n N_noxref_17_M6_noxref_s ) capacitor c=0.00113237f \
 //x=16.6 //y=2.4 //x2=10.615 //y2=0.545
cc_1322 ( N_RN_c_1573_n N_noxref_18_c_3011_n ) capacitor c=0.00642985f \
 //x=16.6 //y=2.4 //x2=13.975 //y2=1.685
cc_1323 ( N_RN_c_1573_n N_noxref_18_c_2995_n ) capacitor c=0.0225733f //x=16.6 \
 //y=2.4 //x2=14.86 //y2=1.77
cc_1324 ( N_RN_c_1573_n N_noxref_18_c_3025_n ) capacitor c=0.0193312f //x=16.6 \
 //y=2.4 //x2=15.83 //y2=1.77
cc_1325 ( N_RN_c_1573_n N_noxref_18_M8_noxref_s ) capacitor c=0.012425f \
 //x=16.6 //y=2.4 //x2=13.84 //y2=0.555
cc_1326 ( N_RN_c_1573_n N_noxref_19_c_3046_n ) capacitor c=0.00657782f \
 //x=16.6 //y=2.4 //x2=16.4 //y2=1.175
cc_1327 ( N_RN_c_1583_n N_noxref_19_c_3051_n ) capacitor c=4.68462e-19 \
 //x=20.3 //y=2.4 //x2=17.37 //y2=0.72
cc_1328 ( N_RN_c_1587_n N_noxref_19_c_3051_n ) capacitor c=4.26424e-19 \
 //x=16.83 //y=2.4 //x2=17.37 //y2=0.72
cc_1329 ( N_RN_c_1649_n N_noxref_19_c_3051_n ) capacitor c=0.00234129f \
 //x=16.715 //y=2.485 //x2=17.37 //y2=0.72
cc_1330 ( N_RN_c_1661_n N_noxref_19_c_3051_n ) capacitor c=0.0190866f \
 //x=16.705 //y=1.095 //x2=17.37 //y2=0.72
cc_1331 ( N_RN_c_1795_p N_noxref_19_c_3051_n ) capacitor c=0.00656458f \
 //x=17.235 //y=1.095 //x2=17.37 //y2=0.72
cc_1332 ( N_RN_c_1665_n N_noxref_19_c_3051_n ) capacitor c=2.20712e-19 \
 //x=16.715 //y=2.26 //x2=17.37 //y2=0.72
cc_1333 ( N_RN_c_1662_n N_noxref_19_c_3079_n ) capacitor c=0.00538829f \
 //x=16.705 //y=1.44 //x2=16.485 //y2=1.175
cc_1334 ( N_RN_c_1573_n N_noxref_19_M10_noxref_s ) capacitor c=0.00642985f \
 //x=16.6 //y=2.4 //x2=16.35 //y2=0.555
cc_1335 ( N_RN_c_1661_n N_noxref_19_M10_noxref_s ) capacitor c=0.00538829f \
 //x=16.705 //y=1.095 //x2=16.35 //y2=0.555
cc_1336 ( N_RN_c_1663_n N_noxref_19_M10_noxref_s ) capacitor c=0.00538829f \
 //x=16.705 //y=1.75 //x2=16.35 //y2=0.555
cc_1337 ( N_RN_c_1795_p N_noxref_19_M10_noxref_s ) capacitor c=0.0143002f \
 //x=17.235 //y=1.095 //x2=16.35 //y2=0.555
cc_1338 ( N_RN_c_1770_p N_noxref_19_M10_noxref_s ) capacitor c=0.00290153f \
 //x=17.235 //y=1.44 //x2=16.35 //y2=0.555
cc_1339 ( N_RN_c_1583_n N_noxref_20_c_3116_n ) capacitor c=0.00642985f \
 //x=20.3 //y=2.4 //x2=18.785 //y2=1.685
cc_1340 ( N_RN_c_1583_n N_noxref_20_c_3100_n ) capacitor c=0.0225733f //x=20.3 \
 //y=2.4 //x2=19.67 //y2=1.77
cc_1341 ( N_RN_c_1692_n N_noxref_20_c_3107_n ) capacitor c=0.0167228f \
 //x=19.98 //y=1.09 //x2=20.64 //y2=0.72
cc_1342 ( N_RN_c_1697_n N_noxref_20_c_3107_n ) capacitor c=0.00534519f \
 //x=20.505 //y=1.09 //x2=20.64 //y2=0.72
cc_1343 ( N_RN_c_1583_n N_noxref_20_c_3130_n ) capacitor c=0.0161937f //x=20.3 \
 //y=2.4 //x2=20.64 //y2=1.77
cc_1344 ( N_RN_c_1682_n N_noxref_20_c_3130_n ) capacitor c=0.0130142f \
 //x=20.415 //y=2.485 //x2=20.64 //y2=1.77
cc_1345 ( N_RN_c_1695_n N_noxref_20_c_3130_n ) capacitor c=0.0157358f \
 //x=19.98 //y=1.4 //x2=20.64 //y2=1.77
cc_1346 ( N_RN_c_1700_n N_noxref_20_c_3130_n ) capacitor c=0.0221109f \
 //x=20.505 //y=2.095 //x2=20.64 //y2=1.77
cc_1347 ( N_RN_c_1583_n N_noxref_20_M11_noxref_s ) capacitor c=0.00642985f \
 //x=20.3 //y=2.4 //x2=18.65 //y2=0.555
cc_1348 ( N_RN_c_1692_n N_noxref_20_M11_noxref_s ) capacitor c=0.00798959f \
 //x=19.98 //y=1.09 //x2=18.65 //y2=0.555
cc_1349 ( N_RN_c_1699_n N_noxref_20_M11_noxref_s ) capacitor c=0.00212176f \
 //x=20.505 //y=1.63 //x2=18.65 //y2=0.555
cc_1350 ( N_RN_c_1700_n N_noxref_20_M11_noxref_s ) capacitor c=0.00298115f \
 //x=20.505 //y=2.095 //x2=18.65 //y2=0.555
cc_1351 ( N_RN_c_1866_p N_noxref_21_c_3152_n ) capacitor c=2.14837e-19 \
 //x=20.35 //y=0.935 //x2=21.21 //y2=1.175
cc_1352 ( N_RN_c_1697_n N_noxref_21_c_3152_n ) capacitor c=0.00123426f \
 //x=20.505 //y=1.09 //x2=21.21 //y2=1.175
cc_1353 ( N_RN_c_1698_n N_noxref_21_c_3152_n ) capacitor c=0.0129288f \
 //x=20.505 //y=1.4 //x2=21.21 //y2=1.175
cc_1354 ( N_RN_c_1699_n N_noxref_21_c_3152_n ) capacitor c=0.00142359f \
 //x=20.505 //y=1.63 //x2=21.21 //y2=1.175
cc_1355 ( N_RN_c_1692_n N_noxref_21_M12_noxref_d ) capacitor c=0.00223875f \
 //x=19.98 //y=1.09 //x2=20.055 //y2=1.09
cc_1356 ( N_RN_c_1695_n N_noxref_21_M12_noxref_d ) capacitor c=0.00262485f \
 //x=19.98 //y=1.4 //x2=20.055 //y2=1.09
cc_1357 ( N_RN_c_1866_p N_noxref_21_M12_noxref_d ) capacitor c=0.00220746f \
 //x=20.35 //y=0.935 //x2=20.055 //y2=1.09
cc_1358 ( N_RN_c_1873_p N_noxref_21_M12_noxref_d ) capacitor c=0.00194798f \
 //x=20.35 //y=1.555 //x2=20.055 //y2=1.09
cc_1359 ( N_RN_c_1697_n N_noxref_21_M12_noxref_d ) capacitor c=0.00198465f \
 //x=20.505 //y=1.09 //x2=20.055 //y2=1.09
cc_1360 ( N_RN_c_1698_n N_noxref_21_M12_noxref_d ) capacitor c=0.00128384f \
 //x=20.505 //y=1.4 //x2=20.055 //y2=1.09
cc_1361 ( N_RN_c_1697_n N_noxref_21_M13_noxref_s ) capacitor c=7.21316e-19 \
 //x=20.505 //y=1.09 //x2=21.16 //y2=0.555
cc_1362 ( N_RN_c_1698_n N_noxref_21_M13_noxref_s ) capacitor c=0.00348171f \
 //x=20.505 //y=1.4 //x2=21.16 //y2=0.555
cc_1363 ( N_Q_M42_noxref_g N_noxref_9_c_2072_n ) capacitor c=0.0184045f \
 //x=21.265 //y=6.2 //x2=21.4 //y2=5.335
cc_1364 ( Q N_noxref_9_c_2076_n ) capacitor c=0.00140847f //x=21.58 //y=4.62 \
 //x2=22.18 //y2=5.335
cc_1365 ( N_Q_M43_noxref_g N_noxref_9_c_2076_n ) capacitor c=0.0202764f \
 //x=21.705 //y=6.2 //x2=22.18 //y2=5.335
cc_1366 ( N_Q_c_1957_n N_noxref_9_c_2076_n ) capacitor c=0.00201851f \
 //x=21.525 //y=4.88 //x2=22.18 //y2=5.335
cc_1367 ( N_Q_c_1964_p N_noxref_9_c_2096_n ) capacitor c=0.00359704f //x=21.89 \
 //y=1.595 //x2=22.18 //y2=1.845
cc_1368 ( N_Q_c_1965_p N_noxref_9_c_2096_n ) capacitor c=0.00457401f \
 //x=22.045 //y=1.44 //x2=22.18 //y2=1.845
cc_1369 ( Q N_noxref_9_c_2123_n ) capacitor c=0.00103639f //x=21.58 //y=3.88 \
 //x2=21.865 //y2=1.845
cc_1370 ( Q N_noxref_9_c_2123_n ) capacitor c=0.00266554f //x=25.65 //y=3.88 \
 //x2=21.865 //y2=1.845
cc_1371 ( Q N_noxref_9_c_2080_n ) capacitor c=0.00777753f //x=21.58 //y=2.77 \
 //x2=22.265 //y2=3.51
cc_1372 ( Q N_noxref_9_c_2080_n ) capacitor c=0.00777753f //x=21.58 //y=3.14 \
 //x2=22.265 //y2=3.51
cc_1373 ( Q N_noxref_9_c_2080_n ) capacitor c=0.010353f //x=21.58 //y=3.51 \
 //x2=22.265 //y2=3.51
cc_1374 ( Q N_noxref_9_c_2080_n ) capacitor c=0.00646802f //x=21.58 //y=3.88 \
 //x2=22.265 //y2=3.51
cc_1375 ( Q N_noxref_9_c_2080_n ) capacitor c=0.00777753f //x=21.58 //y=4.62 \
 //x2=22.265 //y2=3.51
cc_1376 ( Q N_noxref_9_c_2080_n ) capacitor c=0.0631627f //x=25.65 //y=3.88 \
 //x2=22.265 //y2=3.51
cc_1377 ( N_Q_c_1919_n N_noxref_9_c_2080_n ) capacitor c=0.0168311f //x=21.525 \
 //y=2.26 //x2=22.265 //y2=3.51
cc_1378 ( N_Q_c_1886_n N_noxref_9_c_2080_n ) capacitor c=0.00887549f \
 //x=21.525 //y=4.88 //x2=22.265 //y2=3.51
cc_1379 ( N_Q_c_1943_n N_noxref_9_c_2080_n ) capacitor c=0.0065098f //x=21.552 \
 //y=3.055 //x2=22.265 //y2=3.51
cc_1380 ( N_Q_c_1944_n N_noxref_9_c_2080_n ) capacitor c=0.0068419f //x=21.552 \
 //y=3.425 //x2=22.265 //y2=3.51
cc_1381 ( N_Q_c_1945_n N_noxref_9_c_2080_n ) capacitor c=0.00652576f \
 //x=21.552 //y=3.795 //x2=22.265 //y2=3.51
cc_1382 ( N_Q_c_1897_n N_noxref_9_c_2080_n ) capacitor c=0.0157192f //x=21.552 \
 //y=4.535 //x2=22.265 //y2=3.51
cc_1383 ( N_Q_c_1921_n N_noxref_9_c_2080_n ) capacitor c=3.52856e-19 \
 //x=25.622 //y=2.315 //x2=22.265 //y2=3.51
cc_1384 ( N_Q_c_1953_n N_noxref_9_c_2080_n ) capacitor c=0.00772308f \
 //x=21.525 //y=2.26 //x2=22.265 //y2=3.51
cc_1385 ( N_Q_c_1956_n N_noxref_9_c_2080_n ) capacitor c=0.00283672f \
 //x=21.525 //y=2.095 //x2=22.265 //y2=3.51
cc_1386 ( N_Q_c_1957_n N_noxref_9_c_2080_n ) capacitor c=0.013844f //x=21.525 \
 //y=4.88 //x2=22.265 //y2=3.51
cc_1387 ( N_Q_c_1886_n N_noxref_9_c_2141_n ) capacitor c=0.0168082f //x=21.525 \
 //y=4.88 //x2=21.485 //y2=5.335
cc_1388 ( N_Q_c_1957_n N_noxref_9_c_2141_n ) capacitor c=0.00475729f \
 //x=21.525 //y=4.88 //x2=21.485 //y2=5.335
cc_1389 ( N_Q_c_1950_n N_noxref_9_M13_noxref_d ) capacitor c=0.00217566f \
 //x=21.515 //y=1.095 //x2=21.59 //y2=1.095
cc_1390 ( N_Q_c_1951_n N_noxref_9_M13_noxref_d ) capacitor c=0.0034598f \
 //x=21.515 //y=1.44 //x2=21.59 //y2=1.095
cc_1391 ( N_Q_c_1952_n N_noxref_9_M13_noxref_d ) capacitor c=0.00544291f \
 //x=21.515 //y=1.75 //x2=21.59 //y2=1.095
cc_1392 ( N_Q_c_1989_p N_noxref_9_M13_noxref_d ) capacitor c=0.00241102f \
 //x=21.89 //y=0.94 //x2=21.59 //y2=1.095
cc_1393 ( N_Q_c_1964_p N_noxref_9_M13_noxref_d ) capacitor c=0.0140297f \
 //x=21.89 //y=1.595 //x2=21.59 //y2=1.095
cc_1394 ( N_Q_c_1991_p N_noxref_9_M13_noxref_d ) capacitor c=0.00219619f \
 //x=22.045 //y=1.095 //x2=21.59 //y2=1.095
cc_1395 ( N_Q_c_1965_p N_noxref_9_M13_noxref_d ) capacitor c=0.00603828f \
 //x=22.045 //y=1.44 //x2=21.59 //y2=1.095
cc_1396 ( N_Q_c_1956_n N_noxref_9_M13_noxref_d ) capacitor c=0.00661782f \
 //x=21.525 //y=2.095 //x2=21.59 //y2=1.095
cc_1397 ( N_Q_M42_noxref_g N_noxref_9_M42_noxref_d ) capacitor c=0.0180032f \
 //x=21.265 //y=6.2 //x2=21.34 //y2=5.2
cc_1398 ( N_Q_M43_noxref_g N_noxref_9_M42_noxref_d ) capacitor c=0.0194246f \
 //x=21.705 //y=6.2 //x2=21.34 //y2=5.2
cc_1399 ( Q N_noxref_10_c_2170_n ) capacitor c=0.0205569f //x=25.65 //y=3.88 \
 //x2=24.115 //y2=2.26
cc_1400 ( N_Q_c_1891_n N_noxref_10_c_2170_n ) capacitor c=0.00549854f \
 //x=24.32 //y=5.38 //x2=24.115 //y2=2.26
cc_1401 ( N_Q_c_1921_n N_noxref_10_c_2170_n ) capacitor c=0.00411451f \
 //x=25.622 //y=2.315 //x2=24.115 //y2=2.26
cc_1402 ( Q N_noxref_10_c_2179_n ) capacitor c=0.156671f //x=25.65 //y=3.88 \
 //x2=24.115 //y2=3.51
cc_1403 ( N_Q_c_1891_n N_noxref_10_M44_noxref_g ) capacitor c=0.0177326f \
 //x=24.32 //y=5.38 //x2=24.015 //y2=6.2
cc_1404 ( N_Q_c_1887_n N_noxref_10_M45_noxref_g ) capacitor c=0.017965f \
 //x=25.03 //y=5.38 //x2=24.455 //y2=6.2
cc_1405 ( N_Q_M44_noxref_d N_noxref_10_M45_noxref_g ) capacitor c=0.0173476f \
 //x=24.09 //y=5.2 //x2=24.455 //y2=6.2
cc_1406 ( N_Q_c_1891_n N_noxref_10_c_2177_n ) capacitor c=0.00582246f \
 //x=24.32 //y=5.38 //x2=24.115 //y2=4.88
cc_1407 ( Q N_noxref_11_c_2249_n ) capacitor c=0.045019f //x=21.58 //y=3.88 \
 //x2=24.74 //y2=4.25
cc_1408 ( Q N_noxref_11_c_2249_n ) capacitor c=0.00156006f //x=21.58 //y=4.62 \
 //x2=24.74 //y2=4.25
cc_1409 ( Q N_noxref_11_c_2249_n ) capacitor c=0.286517f //x=25.65 //y=3.88 \
 //x2=24.74 //y2=4.25
cc_1410 ( Q N_noxref_11_c_2249_n ) capacitor c=0.00513504f //x=25.65 //y=4.25 \
 //x2=24.74 //y2=4.25
cc_1411 ( N_Q_c_1887_n N_noxref_11_c_2249_n ) capacitor c=0.00208151f \
 //x=25.03 //y=5.38 //x2=24.74 //y2=4.25
cc_1412 ( N_Q_c_1891_n N_noxref_11_c_2249_n ) capacitor c=0.01319f //x=24.32 \
 //y=5.38 //x2=24.74 //y2=4.25
cc_1413 ( N_Q_c_1897_n N_noxref_11_c_2249_n ) capacitor c=0.0216766f \
 //x=21.552 //y=4.535 //x2=24.74 //y2=4.25
cc_1414 ( N_Q_c_2011_p N_noxref_11_c_2249_n ) capacitor c=7.21907e-19 \
 //x=25.622 //y=4.165 //x2=24.74 //y2=4.25
cc_1415 ( N_Q_c_1898_n N_noxref_11_c_2249_n ) capacitor c=8.84388e-19 \
 //x=25.622 //y=4.535 //x2=24.74 //y2=4.25
cc_1416 ( N_Q_c_1957_n N_noxref_11_c_2249_n ) capacitor c=0.00650059f \
 //x=21.525 //y=4.88 //x2=24.74 //y2=4.25
cc_1417 ( N_Q_c_1887_n N_noxref_11_c_2538_n ) capacitor c=0.0129205f //x=25.03 \
 //y=5.38 //x2=24.855 //y2=4.715
cc_1418 ( N_Q_c_1899_n N_noxref_11_c_2538_n ) capacitor c=0.0101588f \
 //x=25.622 //y=4.905 //x2=24.855 //y2=4.715
cc_1419 ( Q N_noxref_11_c_2283_n ) capacitor c=0.0259687f //x=25.65 //y=3.88 \
 //x2=24.855 //y2=2.26
cc_1420 ( Q N_noxref_11_c_2283_n ) capacitor c=4.03999e-19 //x=25.65 //y=4.25 \
 //x2=24.855 //y2=2.26
cc_1421 ( N_Q_c_1921_n N_noxref_11_c_2283_n ) capacitor c=0.0782483f \
 //x=25.622 //y=2.315 //x2=24.855 //y2=2.26
cc_1422 ( N_Q_c_1887_n N_noxref_11_M46_noxref_g ) capacitor c=0.0166421f \
 //x=25.03 //y=5.38 //x2=24.895 //y2=6.2
cc_1423 ( N_Q_M46_noxref_d N_noxref_11_M46_noxref_g ) capacitor c=0.0173476f \
 //x=24.97 //y=5.2 //x2=24.895 //y2=6.2
cc_1424 ( Q N_noxref_11_M47_noxref_g ) capacitor c=0.00728936f //x=25.65 \
 //y=4.99 //x2=25.335 //y2=6.2
cc_1425 ( N_Q_c_1893_n N_noxref_11_M47_noxref_g ) capacitor c=0.0206783f \
 //x=25.51 //y=5.38 //x2=25.335 //y2=6.2
cc_1426 ( N_Q_M46_noxref_d N_noxref_11_M47_noxref_g ) capacitor c=0.0179769f \
 //x=24.97 //y=5.2 //x2=25.335 //y2=6.2
cc_1427 ( N_Q_M15_noxref_d N_noxref_11_c_2548_n ) capacitor c=0.00217566f \
 //x=24.965 //y=1.085 //x2=24.89 //y2=1.085
cc_1428 ( N_Q_M15_noxref_d N_noxref_11_c_2549_n ) capacitor c=0.0034598f \
 //x=24.965 //y=1.085 //x2=24.89 //y2=1.43
cc_1429 ( N_Q_M15_noxref_d N_noxref_11_c_2550_n ) capacitor c=0.0065582f \
 //x=24.965 //y=1.085 //x2=24.89 //y2=1.74
cc_1430 ( Q N_noxref_11_c_2551_n ) capacitor c=0.00624857f //x=25.65 //y=3.88 \
 //x2=25.26 //y2=4.97
cc_1431 ( N_Q_c_2028_p N_noxref_11_c_2551_n ) capacitor c=0.00421574f \
 //x=25.115 //y=5.38 //x2=25.26 //y2=4.97
cc_1432 ( N_Q_c_1899_n N_noxref_11_c_2551_n ) capacitor c=0.00728936f \
 //x=25.622 //y=4.905 //x2=25.26 //y2=4.97
cc_1433 ( N_Q_M15_noxref_d N_noxref_11_c_2554_n ) capacitor c=0.00241102f \
 //x=24.965 //y=1.085 //x2=25.265 //y2=0.93
cc_1434 ( N_Q_c_1920_n N_noxref_11_c_2555_n ) capacitor c=0.00359704f \
 //x=25.51 //y=1.835 //x2=25.265 //y2=1.585
cc_1435 ( N_Q_M15_noxref_d N_noxref_11_c_2555_n ) capacitor c=0.0138845f \
 //x=24.965 //y=1.085 //x2=25.265 //y2=1.585
cc_1436 ( N_Q_M15_noxref_d N_noxref_11_c_2557_n ) capacitor c=0.00132245f \
 //x=24.965 //y=1.085 //x2=25.42 //y2=1.085
cc_1437 ( N_Q_c_1920_n N_noxref_11_c_2558_n ) capacitor c=0.00457401f \
 //x=25.51 //y=1.835 //x2=25.42 //y2=1.43
cc_1438 ( N_Q_M15_noxref_d N_noxref_11_c_2558_n ) capacitor c=0.00566463f \
 //x=24.965 //y=1.085 //x2=25.42 //y2=1.43
cc_1439 ( Q N_noxref_11_c_2560_n ) capacitor c=7.75607e-19 //x=25.65 //y=2.4 \
 //x2=24.855 //y2=2.26
cc_1440 ( N_Q_c_1921_n N_noxref_11_c_2560_n ) capacitor c=0.00885723f \
 //x=25.622 //y=2.315 //x2=24.855 //y2=2.26
cc_1441 ( N_Q_c_1921_n N_noxref_11_c_2562_n ) capacitor c=0.00306024f \
 //x=25.622 //y=2.315 //x2=24.855 //y2=2.095
cc_1442 ( N_Q_M15_noxref_d N_noxref_11_c_2562_n ) capacitor c=0.00660593f \
 //x=24.965 //y=1.085 //x2=24.855 //y2=2.095
cc_1443 ( Q N_noxref_11_c_2564_n ) capacitor c=3.27069e-19 //x=25.65 //y=3.88 \
 //x2=24.885 //y2=4.88
cc_1444 ( Q N_noxref_11_c_2564_n ) capacitor c=8.36577e-19 //x=25.65 //y=4.99 \
 //x2=24.885 //y2=4.88
cc_1445 ( N_Q_c_1887_n N_noxref_11_c_2564_n ) capacitor c=0.00346627f \
 //x=25.03 //y=5.38 //x2=24.885 //y2=4.88
cc_1446 ( N_Q_c_1899_n N_noxref_11_c_2564_n ) capacitor c=0.00533692f \
 //x=25.622 //y=4.905 //x2=24.885 //y2=4.88
cc_1447 ( Q N_noxref_21_c_3157_n ) capacitor c=4.78719e-19 //x=21.58 //y=2.77 \
 //x2=22.18 //y2=0.72
cc_1448 ( Q N_noxref_21_c_3157_n ) capacitor c=2.24938e-19 //x=21.58 //y=3.14 \
 //x2=22.18 //y2=0.72
cc_1449 ( N_Q_c_1919_n N_noxref_21_c_3157_n ) capacitor c=0.00209081f \
 //x=21.525 //y=2.26 //x2=22.18 //y2=0.72
cc_1450 ( N_Q_c_1950_n N_noxref_21_c_3157_n ) capacitor c=0.0191785f \
 //x=21.515 //y=1.095 //x2=22.18 //y2=0.72
cc_1451 ( N_Q_c_1991_p N_noxref_21_c_3157_n ) capacitor c=0.00656458f \
 //x=22.045 //y=1.095 //x2=22.18 //y2=0.72
cc_1452 ( N_Q_c_1953_n N_noxref_21_c_3157_n ) capacitor c=2.20712e-19 \
 //x=21.525 //y=2.26 //x2=22.18 //y2=0.72
cc_1453 ( N_Q_c_1951_n N_noxref_21_c_3184_n ) capacitor c=0.00538829f \
 //x=21.515 //y=1.44 //x2=21.295 //y2=1.175
cc_1454 ( N_Q_c_1950_n N_noxref_21_M13_noxref_s ) capacitor c=0.00538829f \
 //x=21.515 //y=1.095 //x2=21.16 //y2=0.555
cc_1455 ( N_Q_c_1952_n N_noxref_21_M13_noxref_s ) capacitor c=0.00538829f \
 //x=21.515 //y=1.75 //x2=21.16 //y2=0.555
cc_1456 ( N_Q_c_1991_p N_noxref_21_M13_noxref_s ) capacitor c=0.0143002f \
 //x=22.045 //y=1.095 //x2=21.16 //y2=0.555
cc_1457 ( N_Q_c_1965_p N_noxref_21_M13_noxref_s ) capacitor c=0.00290153f \
 //x=22.045 //y=1.44 //x2=21.16 //y2=0.555
cc_1458 ( N_Q_c_2055_p N_noxref_22_c_3223_n ) capacitor c=3.15806e-19 \
 //x=25.24 //y=1.835 //x2=23.7 //y2=1.675
cc_1459 ( Q N_noxref_22_c_3206_n ) capacitor c=0.00299723f //x=25.65 //y=3.88 \
 //x2=24.585 //y2=1.76
cc_1460 ( Q N_noxref_22_c_3213_n ) capacitor c=0.00187232f //x=25.65 //y=3.88 \
 //x2=24.67 //y2=1.675
cc_1461 ( N_Q_c_2055_p N_noxref_22_c_3213_n ) capacitor c=0.020324f //x=25.24 \
 //y=1.835 //x2=24.67 //y2=1.675
cc_1462 ( Q N_noxref_22_c_3214_n ) capacitor c=4.7198e-19 //x=25.65 //y=3.88 \
 //x2=25.555 //y2=0.71
cc_1463 ( N_Q_c_1920_n N_noxref_22_c_3214_n ) capacitor c=0.00467104f \
 //x=25.51 //y=1.835 //x2=25.555 //y2=0.71
cc_1464 ( N_Q_M15_noxref_d N_noxref_22_c_3214_n ) capacitor c=0.0117932f \
 //x=24.965 //y=1.085 //x2=25.555 //y2=0.71
cc_1465 ( Q N_noxref_22_M14_noxref_s ) capacitor c=0.00172479f //x=25.65 \
 //y=2.4 //x2=23.565 //y2=0.545
cc_1466 ( Q N_noxref_22_M14_noxref_s ) capacitor c=2.50009e-19 //x=25.65 \
 //y=2.77 //x2=23.565 //y2=0.545
cc_1467 ( N_Q_c_1920_n N_noxref_22_M14_noxref_s ) capacitor c=0.0142774f \
 //x=25.51 //y=1.835 //x2=23.565 //y2=0.545
cc_1468 ( N_Q_M15_noxref_d N_noxref_22_M14_noxref_s ) capacitor c=0.0439476f \
 //x=24.965 //y=1.085 //x2=23.565 //y2=0.545
cc_1469 ( N_noxref_9_c_2080_n N_noxref_10_c_2170_n ) capacitor c=0.013607f \
 //x=22.265 //y=3.51 //x2=24.115 //y2=2.26
cc_1470 ( N_noxref_9_c_2080_n N_noxref_10_c_2179_n ) capacitor c=0.0401585f \
 //x=22.265 //y=3.51 //x2=24.115 //y2=3.51
cc_1471 ( N_noxref_9_c_2070_n N_noxref_11_c_2249_n ) capacitor c=0.0173f \
 //x=19.81 //y=5.335 //x2=24.74 //y2=4.25
cc_1472 ( N_noxref_9_c_2076_n N_noxref_11_c_2249_n ) capacitor c=0.012188f \
 //x=22.18 //y=5.335 //x2=24.74 //y2=4.25
cc_1473 ( N_noxref_9_c_2123_n N_noxref_11_c_2249_n ) capacitor c=5.76262e-19 \
 //x=21.865 //y=1.845 //x2=24.74 //y2=4.25
cc_1474 ( N_noxref_9_c_2080_n N_noxref_11_c_2249_n ) capacitor c=0.0247663f \
 //x=22.265 //y=3.51 //x2=24.74 //y2=4.25
cc_1475 ( N_noxref_9_c_2114_n N_noxref_11_c_2249_n ) capacitor c=0.0226739f \
 //x=20.605 //y=5.335 //x2=24.74 //y2=4.25
cc_1476 ( N_noxref_9_c_2070_n N_noxref_11_c_2278_n ) capacitor c=3.10026e-19 \
 //x=19.81 //y=5.335 //x2=17.37 //y2=5.335
cc_1477 ( N_noxref_9_c_2080_n N_noxref_11_c_2283_n ) capacitor c=0.00107361f \
 //x=22.265 //y=3.51 //x2=24.855 //y2=2.26
cc_1478 ( N_noxref_9_M13_noxref_d N_noxref_20_M11_noxref_s ) capacitor \
 c=0.00309936f //x=21.59 //y=1.095 //x2=18.65 //y2=0.555
cc_1479 ( N_noxref_9_c_2096_n N_noxref_21_c_3157_n ) capacitor c=0.00467185f \
 //x=22.18 //y=1.845 //x2=22.18 //y2=0.72
cc_1480 ( N_noxref_9_M13_noxref_d N_noxref_21_c_3157_n ) capacitor \
 c=0.0118167f //x=21.59 //y=1.095 //x2=22.18 //y2=0.72
cc_1481 ( N_noxref_9_c_2123_n N_noxref_21_c_3184_n ) capacitor c=0.020048f \
 //x=21.865 //y=1.845 //x2=21.295 //y2=1.175
cc_1482 ( N_noxref_9_M13_noxref_d N_noxref_21_M12_noxref_d ) capacitor \
 c=5.27807e-19 //x=21.59 //y=1.095 //x2=20.055 //y2=1.09
cc_1483 ( N_noxref_9_c_2096_n N_noxref_21_M13_noxref_s ) capacitor c=0.020752f \
 //x=22.18 //y=1.845 //x2=21.16 //y2=0.555
cc_1484 ( N_noxref_9_M13_noxref_d N_noxref_21_M13_noxref_s ) capacitor \
 c=0.0426444f //x=21.59 //y=1.095 //x2=21.16 //y2=0.555
cc_1485 ( N_noxref_9_c_2096_n N_noxref_22_c_3223_n ) capacitor c=3.04182e-19 \
 //x=22.18 //y=1.845 //x2=23.7 //y2=1.675
cc_1486 ( N_noxref_10_c_2170_n N_noxref_11_c_2249_n ) capacitor c=0.0241934f \
 //x=24.115 //y=2.26 //x2=24.74 //y2=4.25
cc_1487 ( N_noxref_10_c_2179_n N_noxref_11_c_2249_n ) capacitor c=0.0100303f \
 //x=24.115 //y=3.51 //x2=24.74 //y2=4.25
cc_1488 ( N_noxref_10_c_2177_n N_noxref_11_c_2249_n ) capacitor c=0.00844647f \
 //x=24.115 //y=4.88 //x2=24.74 //y2=4.25
cc_1489 ( N_noxref_10_c_2170_n N_noxref_11_c_2538_n ) capacitor c=0.00400249f \
 //x=24.115 //y=2.26 //x2=24.855 //y2=4.715
cc_1490 ( N_noxref_10_c_2177_n N_noxref_11_c_2538_n ) capacitor c=0.00417994f \
 //x=24.115 //y=4.88 //x2=24.855 //y2=4.715
cc_1491 ( N_noxref_10_c_2170_n N_noxref_11_c_2283_n ) capacitor c=0.0810987f \
 //x=24.115 //y=2.26 //x2=24.855 //y2=2.26
cc_1492 ( N_noxref_10_c_2179_n N_noxref_11_c_2283_n ) capacitor c=0.0055871f \
 //x=24.115 //y=3.51 //x2=24.855 //y2=2.26
cc_1493 ( N_noxref_10_c_2187_n N_noxref_11_c_2283_n ) capacitor c=0.00308814f \
 //x=23.92 //y=2.095 //x2=24.855 //y2=2.26
cc_1494 ( N_noxref_10_M44_noxref_g N_noxref_11_M46_noxref_g ) capacitor \
 c=0.0104611f //x=24.015 //y=6.2 //x2=24.895 //y2=6.2
cc_1495 ( N_noxref_10_M45_noxref_g N_noxref_11_M46_noxref_g ) capacitor \
 c=0.106811f //x=24.455 //y=6.2 //x2=24.895 //y2=6.2
cc_1496 ( N_noxref_10_M45_noxref_g N_noxref_11_M47_noxref_g ) capacitor \
 c=0.0100341f //x=24.455 //y=6.2 //x2=25.335 //y2=6.2
cc_1497 ( N_noxref_10_c_2183_n N_noxref_11_c_2548_n ) capacitor c=4.86506e-19 \
 //x=23.92 //y=1.045 //x2=24.89 //y2=1.085
cc_1498 ( N_noxref_10_c_2185_n N_noxref_11_c_2548_n ) capacitor c=0.00152104f \
 //x=23.92 //y=1.39 //x2=24.89 //y2=1.085
cc_1499 ( N_noxref_10_c_2190_n N_noxref_11_c_2548_n ) capacitor c=0.0151475f \
 //x=24.45 //y=1.045 //x2=24.89 //y2=1.085
cc_1500 ( N_noxref_10_c_2186_n N_noxref_11_c_2549_n ) capacitor c=0.00109982f \
 //x=23.92 //y=1.7 //x2=24.89 //y2=1.43
cc_1501 ( N_noxref_10_c_2192_n N_noxref_11_c_2549_n ) capacitor c=0.0111064f \
 //x=24.45 //y=1.39 //x2=24.89 //y2=1.43
cc_1502 ( N_noxref_10_c_2186_n N_noxref_11_c_2550_n ) capacitor c=9.57794e-19 \
 //x=23.92 //y=1.7 //x2=24.89 //y2=1.74
cc_1503 ( N_noxref_10_c_2187_n N_noxref_11_c_2550_n ) capacitor c=0.00662747f \
 //x=23.92 //y=2.095 //x2=24.89 //y2=1.74
cc_1504 ( N_noxref_10_c_2192_n N_noxref_11_c_2550_n ) capacitor c=0.00862358f \
 //x=24.45 //y=1.39 //x2=24.89 //y2=1.74
cc_1505 ( N_noxref_10_c_2190_n N_noxref_11_c_2557_n ) capacitor c=0.00124821f \
 //x=24.45 //y=1.045 //x2=25.42 //y2=1.085
cc_1506 ( N_noxref_10_c_2192_n N_noxref_11_c_2558_n ) capacitor c=0.00200715f \
 //x=24.45 //y=1.39 //x2=25.42 //y2=1.43
cc_1507 ( N_noxref_10_c_2170_n N_noxref_11_c_2560_n ) capacitor c=0.00307062f \
 //x=24.115 //y=2.26 //x2=24.855 //y2=2.26
cc_1508 ( N_noxref_10_c_2187_n N_noxref_11_c_2560_n ) capacitor c=0.0179092f \
 //x=23.92 //y=2.095 //x2=24.855 //y2=2.26
cc_1509 ( N_noxref_10_c_2170_n N_noxref_11_c_2564_n ) capacitor c=0.00344981f \
 //x=24.115 //y=2.26 //x2=24.885 //y2=4.88
cc_1510 ( N_noxref_10_c_2177_n N_noxref_11_c_2564_n ) capacitor c=0.0293367f \
 //x=24.115 //y=4.88 //x2=24.885 //y2=4.88
cc_1511 ( N_noxref_10_c_2179_n N_noxref_22_c_3223_n ) capacitor c=0.00241565f \
 //x=24.115 //y=3.51 //x2=23.7 //y2=1.675
cc_1512 ( N_noxref_10_c_2187_n N_noxref_22_c_3223_n ) capacitor c=0.0034165f \
 //x=23.92 //y=2.095 //x2=23.7 //y2=1.675
cc_1513 ( N_noxref_10_c_2170_n N_noxref_22_c_3206_n ) capacitor c=0.011692f \
 //x=24.115 //y=2.26 //x2=24.585 //y2=1.76
cc_1514 ( N_noxref_10_c_2179_n N_noxref_22_c_3206_n ) capacitor c=0.00649414f \
 //x=24.115 //y=3.51 //x2=24.585 //y2=1.76
cc_1515 ( N_noxref_10_c_2186_n N_noxref_22_c_3206_n ) capacitor c=0.00703567f \
 //x=23.92 //y=1.7 //x2=24.585 //y2=1.76
cc_1516 ( N_noxref_10_c_2187_n N_noxref_22_c_3206_n ) capacitor c=0.0203514f \
 //x=23.92 //y=2.095 //x2=24.585 //y2=1.76
cc_1517 ( N_noxref_10_c_2189_n N_noxref_22_c_3206_n ) capacitor c=0.00780629f \
 //x=24.295 //y=1.545 //x2=24.585 //y2=1.76
cc_1518 ( N_noxref_10_c_2192_n N_noxref_22_c_3206_n ) capacitor c=0.00339872f \
 //x=24.45 //y=1.39 //x2=24.585 //y2=1.76
cc_1519 ( N_noxref_10_c_2187_n N_noxref_22_c_3213_n ) capacitor c=6.71402e-19 \
 //x=23.92 //y=2.095 //x2=24.67 //y2=1.675
cc_1520 ( N_noxref_10_c_2183_n N_noxref_22_M14_noxref_s ) capacitor \
 c=0.0327502f //x=23.92 //y=1.045 //x2=23.565 //y2=0.545
cc_1521 ( N_noxref_10_c_2186_n N_noxref_22_M14_noxref_s ) capacitor \
 c=3.48408e-19 //x=23.92 //y=1.7 //x2=23.565 //y2=0.545
cc_1522 ( N_noxref_10_c_2190_n N_noxref_22_M14_noxref_s ) capacitor \
 c=0.0120759f //x=24.45 //y=1.045 //x2=23.565 //y2=0.545
cc_1523 ( N_noxref_11_c_2329_n N_noxref_12_c_2674_n ) capacitor c=0.0034165f \
 //x=1.245 //y=2.095 //x2=1.025 //y2=1.685
cc_1524 ( N_noxref_11_c_2240_n N_noxref_12_c_2648_n ) capacitor c=0.00179505f \
 //x=11.79 //y=4.25 //x2=1.91 //y2=1.77
cc_1525 ( N_noxref_11_c_2244_n N_noxref_12_c_2648_n ) capacitor c=0.00102628f \
 //x=1.66 //y=4.25 //x2=1.91 //y2=1.77
cc_1526 ( N_noxref_11_c_2263_n N_noxref_12_c_2648_n ) capacitor c=0.0122033f \
 //x=1.545 //y=2.26 //x2=1.91 //y2=1.77
cc_1527 ( N_noxref_11_c_2328_n N_noxref_12_c_2648_n ) capacitor c=0.00703864f \
 //x=1.245 //y=1.71 //x2=1.91 //y2=1.77
cc_1528 ( N_noxref_11_c_2329_n N_noxref_12_c_2648_n ) capacitor c=0.0259045f \
 //x=1.245 //y=2.095 //x2=1.91 //y2=1.77
cc_1529 ( N_noxref_11_c_2331_n N_noxref_12_c_2648_n ) capacitor c=0.00708583f \
 //x=1.62 //y=1.555 //x2=1.91 //y2=1.77
cc_1530 ( N_noxref_11_c_2334_n N_noxref_12_c_2648_n ) capacitor c=0.00698822f \
 //x=1.775 //y=1.4 //x2=1.91 //y2=1.77
cc_1531 ( N_noxref_11_c_2240_n N_noxref_12_c_2666_n ) capacitor c=0.00453743f \
 //x=11.79 //y=4.25 //x2=2.88 //y2=1.77
cc_1532 ( N_noxref_11_c_2240_n N_noxref_12_M0_noxref_s ) capacitor \
 c=0.00262629f //x=11.79 //y=4.25 //x2=0.89 //y2=0.555
cc_1533 ( N_noxref_11_c_2325_n N_noxref_12_M0_noxref_s ) capacitor \
 c=0.0327271f //x=1.245 //y=1.055 //x2=0.89 //y2=0.555
cc_1534 ( N_noxref_11_c_2328_n N_noxref_12_M0_noxref_s ) capacitor \
 c=7.99997e-19 //x=1.245 //y=1.71 //x2=0.89 //y2=0.555
cc_1535 ( N_noxref_11_c_2329_n N_noxref_12_M0_noxref_s ) capacitor \
 c=0.00122123f //x=1.245 //y=2.095 //x2=0.89 //y2=0.555
cc_1536 ( N_noxref_11_c_2332_n N_noxref_12_M0_noxref_s ) capacitor \
 c=0.0121427f //x=1.775 //y=1.055 //x2=0.89 //y2=0.555
cc_1537 ( N_noxref_11_c_2240_n N_noxref_13_c_2696_n ) capacitor c=0.0020922f \
 //x=11.79 //y=4.25 //x2=3.45 //y2=1.175
cc_1538 ( N_noxref_11_c_2240_n N_noxref_13_M2_noxref_s ) capacitor \
 c=0.00143334f //x=11.79 //y=4.25 //x2=3.4 //y2=0.555
cc_1539 ( N_noxref_11_c_2240_n N_D_c_2749_n ) capacitor c=0.0190126f //x=11.79 \
 //y=4.25 //x2=7.465 //y2=4.88
cc_1540 ( N_noxref_11_c_2359_n N_noxref_17_c_2950_n ) capacitor c=0.00623646f \
 //x=11.94 //y=1.74 //x2=11.72 //y2=1.675
cc_1541 ( N_noxref_11_c_2364_n N_noxref_17_c_2950_n ) capacitor c=0.00173579f \
 //x=11.905 //y=2.26 //x2=11.72 //y2=1.675
cc_1542 ( N_noxref_11_c_2266_n N_noxref_17_c_2951_n ) capacitor c=0.00156605f \
 //x=11.905 //y=2.26 //x2=12.605 //y2=0.71
cc_1543 ( N_noxref_11_c_2354_n N_noxref_17_c_2951_n ) capacitor c=0.0188655f \
 //x=11.94 //y=1.085 //x2=12.605 //y2=0.71
cc_1544 ( N_noxref_11_c_2362_n N_noxref_17_c_2951_n ) capacitor c=0.00656458f \
 //x=12.47 //y=1.085 //x2=12.605 //y2=0.71
cc_1545 ( N_noxref_11_c_2364_n N_noxref_17_c_2951_n ) capacitor c=2.1838e-19 \
 //x=11.905 //y=2.26 //x2=12.605 //y2=0.71
cc_1546 ( N_noxref_11_c_2354_n N_noxref_17_M6_noxref_s ) capacitor \
 c=0.00623646f //x=11.94 //y=1.085 //x2=10.615 //y2=0.545
cc_1547 ( N_noxref_11_c_2362_n N_noxref_17_M6_noxref_s ) capacitor \
 c=0.0143002f //x=12.47 //y=1.085 //x2=10.615 //y2=0.545
cc_1548 ( N_noxref_11_c_2363_n N_noxref_17_M6_noxref_s ) capacitor \
 c=0.00290153f //x=12.47 //y=1.43 //x2=10.615 //y2=0.545
cc_1549 ( N_noxref_11_M10_noxref_d N_noxref_18_M8_noxref_s ) capacitor \
 c=0.00309936f //x=16.78 //y=1.095 //x2=13.84 //y2=0.555
cc_1550 ( N_noxref_11_c_2322_n N_noxref_19_c_3051_n ) capacitor c=0.00457167f \
 //x=17.37 //y=1.845 //x2=17.37 //y2=0.72
cc_1551 ( N_noxref_11_M10_noxref_d N_noxref_19_c_3051_n ) capacitor \
 c=0.0115903f //x=16.78 //y=1.095 //x2=17.37 //y2=0.72
cc_1552 ( N_noxref_11_c_2499_n N_noxref_19_c_3079_n ) capacitor c=0.0200405f \
 //x=17.055 //y=1.845 //x2=16.485 //y2=1.175
cc_1553 ( N_noxref_11_M10_noxref_d N_noxref_19_M9_noxref_d ) capacitor \
 c=5.27807e-19 //x=16.78 //y=1.095 //x2=15.245 //y2=1.09
cc_1554 ( N_noxref_11_c_2322_n N_noxref_19_M10_noxref_s ) capacitor \
 c=0.0196084f //x=17.37 //y=1.845 //x2=16.35 //y2=0.555
cc_1555 ( N_noxref_11_M10_noxref_d N_noxref_19_M10_noxref_s ) capacitor \
 c=0.0426368f //x=16.78 //y=1.095 //x2=16.35 //y2=0.555
cc_1556 ( N_noxref_11_c_2322_n N_noxref_20_c_3116_n ) capacitor c=3.84569e-19 \
 //x=17.37 //y=1.845 //x2=18.785 //y2=1.685
cc_1557 ( N_noxref_11_c_2249_n N_noxref_20_c_3130_n ) capacitor c=9.46602e-19 \
 //x=24.74 //y=4.25 //x2=20.64 //y2=1.77
cc_1558 ( N_noxref_11_c_2249_n N_noxref_20_M11_noxref_s ) capacitor \
 c=0.00119468f //x=24.74 //y=4.25 //x2=18.65 //y2=0.555
cc_1559 ( N_noxref_11_M10_noxref_d N_noxref_20_M11_noxref_s ) capacitor \
 c=2.55333e-19 //x=16.78 //y=1.095 //x2=18.65 //y2=0.555
cc_1560 ( N_noxref_11_c_2249_n N_noxref_21_c_3152_n ) capacitor c=0.00161795f \
 //x=24.74 //y=4.25 //x2=21.21 //y2=1.175
cc_1561 ( N_noxref_11_c_2249_n N_noxref_21_M13_noxref_s ) capacitor \
 c=0.00122424f //x=24.74 //y=4.25 //x2=21.16 //y2=0.555
cc_1562 ( N_noxref_11_c_2550_n N_noxref_22_c_3213_n ) capacitor c=0.00623646f \
 //x=24.89 //y=1.74 //x2=24.67 //y2=1.675
cc_1563 ( N_noxref_11_c_2560_n N_noxref_22_c_3213_n ) capacitor c=0.00176439f \
 //x=24.855 //y=2.26 //x2=24.67 //y2=1.675
cc_1564 ( N_noxref_11_c_2283_n N_noxref_22_c_3214_n ) capacitor c=0.0016032f \
 //x=24.855 //y=2.26 //x2=25.555 //y2=0.71
cc_1565 ( N_noxref_11_c_2548_n N_noxref_22_c_3214_n ) capacitor c=0.0188655f \
 //x=24.89 //y=1.085 //x2=25.555 //y2=0.71
cc_1566 ( N_noxref_11_c_2557_n N_noxref_22_c_3214_n ) capacitor c=0.00656458f \
 //x=25.42 //y=1.085 //x2=25.555 //y2=0.71
cc_1567 ( N_noxref_11_c_2560_n N_noxref_22_c_3214_n ) capacitor c=2.1838e-19 \
 //x=24.855 //y=2.26 //x2=25.555 //y2=0.71
cc_1568 ( N_noxref_11_c_2548_n N_noxref_22_M14_noxref_s ) capacitor \
 c=0.00623646f //x=24.89 //y=1.085 //x2=23.565 //y2=0.545
cc_1569 ( N_noxref_11_c_2557_n N_noxref_22_M14_noxref_s ) capacitor \
 c=0.0143002f //x=25.42 //y=1.085 //x2=23.565 //y2=0.545
cc_1570 ( N_noxref_11_c_2558_n N_noxref_22_M14_noxref_s ) capacitor \
 c=0.00290153f //x=25.42 //y=1.43 //x2=23.565 //y2=0.545
cc_1571 ( N_noxref_12_c_2655_n N_noxref_13_c_2696_n ) capacitor c=0.0136048f \
 //x=2.88 //y=0.72 //x2=3.45 //y2=1.175
cc_1572 ( N_noxref_12_c_2666_n N_noxref_13_c_2696_n ) capacitor c=0.0102225f \
 //x=2.88 //y=1.77 //x2=3.45 //y2=1.175
cc_1573 ( N_noxref_12_M0_noxref_s N_noxref_13_c_2696_n ) capacitor \
 c=0.0228676f //x=0.89 //y=0.555 //x2=3.45 //y2=1.175
cc_1574 ( N_noxref_12_M0_noxref_s N_noxref_13_c_2698_n ) capacitor \
 c=0.0180035f //x=0.89 //y=0.555 //x2=3.535 //y2=0.805
cc_1575 ( N_noxref_12_c_2655_n N_noxref_13_M1_noxref_d ) capacitor \
 c=0.0129526f //x=2.88 //y=0.72 //x2=2.295 //y2=1.09
cc_1576 ( N_noxref_12_c_2666_n N_noxref_13_M1_noxref_d ) capacitor \
 c=0.00908243f //x=2.88 //y=1.77 //x2=2.295 //y2=1.09
cc_1577 ( N_noxref_12_M0_noxref_s N_noxref_13_M1_noxref_d ) capacitor \
 c=0.0159202f //x=0.89 //y=0.555 //x2=2.295 //y2=1.09
cc_1578 ( N_noxref_12_M0_noxref_s N_noxref_13_M2_noxref_s ) capacitor \
 c=0.0213553f //x=0.89 //y=0.555 //x2=3.4 //y2=0.555
cc_1579 ( N_noxref_13_c_2704_n N_noxref_15_M3_noxref_s ) capacitor \
 c=0.00191848f //x=4.505 //y=0.805 //x2=5.7 //y2=0.555
cc_1580 ( N_D_c_2782_n N_noxref_15_c_2845_n ) capacitor c=0.0167228f //x=7.03 \
 //y=1.09 //x2=7.69 //y2=0.72
cc_1581 ( N_D_c_2787_n N_noxref_15_c_2845_n ) capacitor c=0.00534519f \
 //x=7.555 //y=1.09 //x2=7.69 //y2=0.72
cc_1582 ( D N_noxref_15_c_2856_n ) capacitor c=9.03008e-19 //x=7.52 //y=2.77 \
 //x2=7.69 //y2=1.77
cc_1583 ( N_D_c_2755_n N_noxref_15_c_2856_n ) capacitor c=0.012282f //x=7.465 \
 //y=2.26 //x2=7.69 //y2=1.77
cc_1584 ( N_D_c_2785_n N_noxref_15_c_2856_n ) capacitor c=0.0153476f //x=7.03 \
 //y=1.4 //x2=7.69 //y2=1.77
cc_1585 ( N_D_c_2790_n N_noxref_15_c_2856_n ) capacitor c=0.0220703f //x=7.555 \
 //y=2.095 //x2=7.69 //y2=1.77
cc_1586 ( N_D_c_2782_n N_noxref_15_M3_noxref_s ) capacitor c=0.00798959f \
 //x=7.03 //y=1.09 //x2=5.7 //y2=0.555
cc_1587 ( N_D_c_2789_n N_noxref_15_M3_noxref_s ) capacitor c=0.00212176f \
 //x=7.555 //y=1.63 //x2=5.7 //y2=0.555
cc_1588 ( N_D_c_2790_n N_noxref_15_M3_noxref_s ) capacitor c=0.00298115f \
 //x=7.555 //y=2.095 //x2=5.7 //y2=0.555
cc_1589 ( N_D_c_2826_p N_noxref_16_c_2889_n ) capacitor c=2.14837e-19 //x=7.4 \
 //y=0.935 //x2=8.26 //y2=1.175
cc_1590 ( N_D_c_2787_n N_noxref_16_c_2889_n ) capacitor c=0.00123426f \
 //x=7.555 //y=1.09 //x2=8.26 //y2=1.175
cc_1591 ( N_D_c_2788_n N_noxref_16_c_2889_n ) capacitor c=0.0129288f //x=7.555 \
 //y=1.4 //x2=8.26 //y2=1.175
cc_1592 ( N_D_c_2789_n N_noxref_16_c_2889_n ) capacitor c=0.00142359f \
 //x=7.555 //y=1.63 //x2=8.26 //y2=1.175
cc_1593 ( N_D_c_2782_n N_noxref_16_M4_noxref_d ) capacitor c=0.00223875f \
 //x=7.03 //y=1.09 //x2=7.105 //y2=1.09
cc_1594 ( N_D_c_2785_n N_noxref_16_M4_noxref_d ) capacitor c=0.00262485f \
 //x=7.03 //y=1.4 //x2=7.105 //y2=1.09
cc_1595 ( N_D_c_2826_p N_noxref_16_M4_noxref_d ) capacitor c=0.00220746f \
 //x=7.4 //y=0.935 //x2=7.105 //y2=1.09
cc_1596 ( N_D_c_2833_p N_noxref_16_M4_noxref_d ) capacitor c=0.00194798f \
 //x=7.4 //y=1.555 //x2=7.105 //y2=1.09
cc_1597 ( N_D_c_2787_n N_noxref_16_M4_noxref_d ) capacitor c=0.00198465f \
 //x=7.555 //y=1.09 //x2=7.105 //y2=1.09
cc_1598 ( N_D_c_2788_n N_noxref_16_M4_noxref_d ) capacitor c=0.00128384f \
 //x=7.555 //y=1.4 //x2=7.105 //y2=1.09
cc_1599 ( N_D_c_2787_n N_noxref_16_M5_noxref_s ) capacitor c=7.21316e-19 \
 //x=7.555 //y=1.09 //x2=8.21 //y2=0.555
cc_1600 ( N_D_c_2788_n N_noxref_16_M5_noxref_s ) capacitor c=0.00348171f \
 //x=7.555 //y=1.4 //x2=8.21 //y2=0.555
cc_1601 ( N_noxref_15_c_2845_n N_noxref_16_c_2889_n ) capacitor c=0.0134311f \
 //x=7.69 //y=0.72 //x2=8.26 //y2=1.175
cc_1602 ( N_noxref_15_c_2856_n N_noxref_16_c_2889_n ) capacitor c=0.0101712f \
 //x=7.69 //y=1.77 //x2=8.26 //y2=1.175
cc_1603 ( N_noxref_15_M3_noxref_s N_noxref_16_c_2889_n ) capacitor \
 c=0.0227445f //x=5.7 //y=0.555 //x2=8.26 //y2=1.175
cc_1604 ( N_noxref_15_M3_noxref_s N_noxref_16_c_2891_n ) capacitor \
 c=0.0180035f //x=5.7 //y=0.555 //x2=8.345 //y2=0.805
cc_1605 ( N_noxref_15_c_2845_n N_noxref_16_M4_noxref_d ) capacitor \
 c=0.0128913f //x=7.69 //y=0.72 //x2=7.105 //y2=1.09
cc_1606 ( N_noxref_15_c_2856_n N_noxref_16_M4_noxref_d ) capacitor \
 c=0.00899889f //x=7.69 //y=1.77 //x2=7.105 //y2=1.09
cc_1607 ( N_noxref_15_M3_noxref_s N_noxref_16_M4_noxref_d ) capacitor \
 c=0.0159202f //x=5.7 //y=0.555 //x2=7.105 //y2=1.09
cc_1608 ( N_noxref_15_M3_noxref_s N_noxref_16_M5_noxref_s ) capacitor \
 c=0.0213553f //x=5.7 //y=0.555 //x2=8.21 //y2=0.555
cc_1609 ( N_noxref_16_c_2897_n N_noxref_17_M6_noxref_s ) capacitor \
 c=0.00164795f //x=9.315 //y=0.805 //x2=10.615 //y2=0.545
cc_1610 ( N_noxref_17_c_2954_n N_noxref_18_M8_noxref_s ) capacitor \
 c=0.00199452f //x=12.69 //y=0.795 //x2=13.84 //y2=0.555
cc_1611 ( N_noxref_18_c_3002_n N_noxref_19_c_3046_n ) capacitor c=0.0131877f \
 //x=15.83 //y=0.72 //x2=16.4 //y2=1.175
cc_1612 ( N_noxref_18_c_3025_n N_noxref_19_c_3046_n ) capacitor c=0.00981707f \
 //x=15.83 //y=1.77 //x2=16.4 //y2=1.175
cc_1613 ( N_noxref_18_M8_noxref_s N_noxref_19_c_3046_n ) capacitor \
 c=0.0221661f //x=13.84 //y=0.555 //x2=16.4 //y2=1.175
cc_1614 ( N_noxref_18_M8_noxref_s N_noxref_19_c_3048_n ) capacitor \
 c=0.0180035f //x=13.84 //y=0.555 //x2=16.485 //y2=0.805
cc_1615 ( N_noxref_18_c_3002_n N_noxref_19_M9_noxref_d ) capacitor \
 c=0.0127191f //x=15.83 //y=0.72 //x2=15.245 //y2=1.09
cc_1616 ( N_noxref_18_c_3025_n N_noxref_19_M9_noxref_d ) capacitor \
 c=0.00861161f //x=15.83 //y=1.77 //x2=15.245 //y2=1.09
cc_1617 ( N_noxref_18_M8_noxref_s N_noxref_19_M9_noxref_d ) capacitor \
 c=0.0159202f //x=13.84 //y=0.555 //x2=15.245 //y2=1.09
cc_1618 ( N_noxref_18_M8_noxref_s N_noxref_19_M10_noxref_s ) capacitor \
 c=0.0213553f //x=13.84 //y=0.555 //x2=16.35 //y2=0.555
cc_1619 ( N_noxref_19_c_3054_n N_noxref_20_M11_noxref_s ) capacitor \
 c=0.00191848f //x=17.455 //y=0.805 //x2=18.65 //y2=0.555
cc_1620 ( N_noxref_20_c_3107_n N_noxref_21_c_3152_n ) capacitor c=0.0133619f \
 //x=20.64 //y=0.72 //x2=21.21 //y2=1.175
cc_1621 ( N_noxref_20_c_3130_n N_noxref_21_c_3152_n ) capacitor c=0.00992648f \
 //x=20.64 //y=1.77 //x2=21.21 //y2=1.175
cc_1622 ( N_noxref_20_M11_noxref_s N_noxref_21_c_3152_n ) capacitor \
 c=0.0228676f //x=18.65 //y=0.555 //x2=21.21 //y2=1.175
cc_1623 ( N_noxref_20_M11_noxref_s N_noxref_21_c_3154_n ) capacitor \
 c=0.0180035f //x=18.65 //y=0.555 //x2=21.295 //y2=0.805
cc_1624 ( N_noxref_20_c_3107_n N_noxref_21_M12_noxref_d ) capacitor \
 c=0.0127176f //x=20.64 //y=0.72 //x2=20.055 //y2=1.09
cc_1625 ( N_noxref_20_c_3130_n N_noxref_21_M12_noxref_d ) capacitor \
 c=0.0086073f //x=20.64 //y=1.77 //x2=20.055 //y2=1.09
cc_1626 ( N_noxref_20_M11_noxref_s N_noxref_21_M12_noxref_d ) capacitor \
 c=0.0159202f //x=18.65 //y=0.555 //x2=20.055 //y2=1.09
cc_1627 ( N_noxref_20_M11_noxref_s N_noxref_21_M13_noxref_s ) capacitor \
 c=0.0213553f //x=18.65 //y=0.555 //x2=21.16 //y2=0.555
cc_1628 ( N_noxref_21_c_3160_n N_noxref_22_M14_noxref_s ) capacitor \
 c=0.00164795f //x=22.265 //y=0.805 //x2=23.565 //y2=0.545
