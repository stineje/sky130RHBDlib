// File: DFFRNQNX1.spi.pex
// Created: Tue Apr 29 10:39:49 2025
// Program "Calibre xRC"
// Version "v2023.2_27.15"
// Nominal Temperature: 30C
// Circuit Temperature: 30C
//
simulator lang=spectre
subckt PM_DFFRNQNX1\%GND ( 1 47 51 54 59 69 77 87 95 103 109 119 125 135 146 \
 152 154 156 159 162 166 167 168 169 170 171 )
c301 ( 171 0 ) capacitor c=0.0208241f //x=23.995 //y=1.045
c302 ( 170 0 ) capacitor c=0.0225954f //x=19.08 //y=1.055
c303 ( 169 0 ) capacitor c=0.0226075f //x=14.27 //y=1.055
c304 ( 168 0 ) capacitor c=0.0207408f //x=11.045 //y=1.045
c305 ( 167 0 ) capacitor c=0.0226571f //x=6.13 //y=1.055
c306 ( 166 0 ) capacitor c=0.022675f //x=1.32 //y=1.055
c307 ( 164 0 ) capacitor c=0.00446416f //x=24.115 //y=0.18
c308 ( 162 0 ) capacitor c=0.109696f //x=23.005 //y=0.175
c309 ( 161 0 ) capacitor c=0.00446464f //x=19.305 //y=0.18
c310 ( 159 0 ) capacitor c=0.108144f //x=18.195 //y=0.175
c311 ( 158 0 ) capacitor c=0.00446464f //x=14.495 //y=0.18
c312 ( 156 0 ) capacitor c=0.104775f //x=13.385 //y=0.175
c313 ( 155 0 ) capacitor c=0.00446416f //x=11.235 //y=0.175
c314 ( 154 0 ) capacitor c=0.108895f //x=10.055 //y=0.175
c315 ( 153 0 ) capacitor c=0.00446464f //x=6.32 //y=0.175
c316 ( 152 0 ) capacitor c=0.108816f //x=5.245 //y=0.175
c317 ( 151 0 ) capacitor c=0.00446464f //x=1.51 //y=0.175
c318 ( 146 0 ) capacitor c=0.282531f //x=25.965 //y=0.18
c319 ( 135 0 ) capacitor c=0.0392803f //x=24.1 //y=0.175
c320 ( 125 0 ) capacitor c=0.134019f //x=22.835 //y=0.175
c321 ( 119 0 ) capacitor c=0.0342713f //x=19.185 //y=0.175
c322 ( 109 0 ) capacitor c=0.135264f //x=18.025 //y=0.175
c323 ( 103 0 ) capacitor c=0.0342713f //x=14.375 //y=0.175
c324 ( 95 0 ) capacitor c=0.0727058f //x=13.215 //y=0.175
c325 ( 87 0 ) capacitor c=0.0392405f //x=11.15 //y=0.175
c326 ( 77 0 ) capacitor c=0.135402f //x=9.885 //y=0.175
c327 ( 69 0 ) capacitor c=0.0343125f //x=6.235 //y=0.175
c328 ( 59 0 ) capacitor c=0.133468f //x=5.075 //y=0.175
c329 ( 54 0 ) capacitor c=0.193806f //x=1.175 //y=0.18
c330 ( 51 0 ) capacitor c=0.0370791f //x=1.425 //y=0.175
c331 ( 47 0 ) capacitor c=0.853457f //x=25.965 //y=0.18
r332 (  144 146 ) resistor r=25.8093 //w=0.367 //l=0.74 //layer=li \
 //thickness=0.1 //x=25.225 //y=0.175 //x2=25.965 //y2=0.175
r333 (  142 164 ) resistor r=2.87058 //w=0.35 //l=0.085 //layer=li \
 //thickness=0.1 //x=24.27 //y=0.175 //x2=24.185 //y2=0.175
r334 (  142 144 ) resistor r=33.3079 //w=0.367 //l=0.955 //layer=li \
 //thickness=0.1 //x=24.27 //y=0.175 //x2=25.225 //y2=0.175
r335 (  137 164 ) resistor r=4.23183 //w=0.7 //l=0.175 //layer=li \
 //thickness=0.1 //x=24.185 //y=0.35 //x2=24.185 //y2=0.175
r336 (  137 171 ) resistor r=53.7326 //w=0.187 //l=0.785 //layer=li \
 //thickness=0.1 //x=24.185 //y=0.35 //x2=24.185 //y2=1.135
r337 (  136 162 ) resistor r=5.29055 //w=0.35 //l=0.17 //layer=li \
 //thickness=0.1 //x=23.175 //y=0.175 //x2=23.005 //y2=0.175
r338 (  135 164 ) resistor r=2.87058 //w=0.35 //l=0.085 //layer=li \
 //thickness=0.1 //x=24.1 //y=0.175 //x2=24.185 //y2=0.175
r339 (  135 136 ) resistor r=32.2616 //w=0.367 //l=0.925 //layer=li \
 //thickness=0.1 //x=24.1 //y=0.175 //x2=23.175 //y2=0.175
r340 (  130 132 ) resistor r=38.7139 //w=0.367 //l=1.11 //layer=li \
 //thickness=0.1 //x=21.525 //y=0.175 //x2=22.635 //y2=0.175
r341 (  128 130 ) resistor r=38.7139 //w=0.367 //l=1.11 //layer=li \
 //thickness=0.1 //x=20.415 //y=0.175 //x2=21.525 //y2=0.175
r342 (  126 161 ) resistor r=2.87058 //w=0.35 //l=0.085 //layer=li \
 //thickness=0.1 //x=19.355 //y=0.175 //x2=19.27 //y2=0.175
r343 (  126 128 ) resistor r=36.97 //w=0.367 //l=1.06 //layer=li \
 //thickness=0.1 //x=19.355 //y=0.175 //x2=20.415 //y2=0.175
r344 (  125 162 ) resistor r=5.29055 //w=0.35 //l=0.17 //layer=li \
 //thickness=0.1 //x=22.835 //y=0.175 //x2=23.005 //y2=0.175
r345 (  125 132 ) resistor r=6.97548 //w=0.367 //l=0.2 //layer=li \
 //thickness=0.1 //x=22.835 //y=0.175 //x2=22.635 //y2=0.175
r346 (  121 161 ) resistor r=4.23183 //w=0.7 //l=0.175 //layer=li \
 //thickness=0.1 //x=19.27 //y=0.35 //x2=19.27 //y2=0.175
r347 (  121 170 ) resistor r=54.4171 //w=0.187 //l=0.795 //layer=li \
 //thickness=0.1 //x=19.27 //y=0.35 //x2=19.27 //y2=1.145
r348 (  120 159 ) resistor r=5.29055 //w=0.35 //l=0.17 //layer=li \
 //thickness=0.1 //x=18.365 //y=0.175 //x2=18.195 //y2=0.175
r349 (  119 161 ) resistor r=2.87058 //w=0.35 //l=0.085 //layer=li \
 //thickness=0.1 //x=19.185 //y=0.175 //x2=19.27 //y2=0.175
r350 (  119 120 ) resistor r=28.5995 //w=0.367 //l=0.82 //layer=li \
 //thickness=0.1 //x=19.185 //y=0.175 //x2=18.365 //y2=0.175
r351 (  114 116 ) resistor r=38.7139 //w=0.367 //l=1.11 //layer=li \
 //thickness=0.1 //x=16.715 //y=0.175 //x2=17.825 //y2=0.175
r352 (  112 114 ) resistor r=38.7139 //w=0.367 //l=1.11 //layer=li \
 //thickness=0.1 //x=15.605 //y=0.175 //x2=16.715 //y2=0.175
r353 (  110 158 ) resistor r=2.87058 //w=0.35 //l=0.085 //layer=li \
 //thickness=0.1 //x=14.545 //y=0.175 //x2=14.46 //y2=0.175
r354 (  110 112 ) resistor r=36.97 //w=0.367 //l=1.06 //layer=li \
 //thickness=0.1 //x=14.545 //y=0.175 //x2=15.605 //y2=0.175
r355 (  109 159 ) resistor r=5.29055 //w=0.35 //l=0.17 //layer=li \
 //thickness=0.1 //x=18.025 //y=0.175 //x2=18.195 //y2=0.175
r356 (  109 116 ) resistor r=6.97548 //w=0.367 //l=0.2 //layer=li \
 //thickness=0.1 //x=18.025 //y=0.175 //x2=17.825 //y2=0.175
r357 (  105 158 ) resistor r=4.23183 //w=0.7 //l=0.175 //layer=li \
 //thickness=0.1 //x=14.46 //y=0.35 //x2=14.46 //y2=0.175
r358 (  105 169 ) resistor r=54.4171 //w=0.187 //l=0.795 //layer=li \
 //thickness=0.1 //x=14.46 //y=0.35 //x2=14.46 //y2=1.145
r359 (  104 156 ) resistor r=5.29055 //w=0.35 //l=0.17 //layer=li \
 //thickness=0.1 //x=13.555 //y=0.175 //x2=13.385 //y2=0.175
r360 (  103 158 ) resistor r=2.87058 //w=0.35 //l=0.085 //layer=li \
 //thickness=0.1 //x=14.375 //y=0.175 //x2=14.46 //y2=0.175
r361 (  103 104 ) resistor r=28.5995 //w=0.367 //l=0.82 //layer=li \
 //thickness=0.1 //x=14.375 //y=0.175 //x2=13.555 //y2=0.175
r362 (  98 100 ) resistor r=38.7139 //w=0.367 //l=1.11 //layer=li \
 //thickness=0.1 //x=11.905 //y=0.175 //x2=13.015 //y2=0.175
r363 (  96 155 ) resistor r=2.87058 //w=0.35 //l=0.085 //layer=li \
 //thickness=0.1 //x=11.32 //y=0.175 //x2=11.235 //y2=0.175
r364 (  96 98 ) resistor r=20.4033 //w=0.367 //l=0.585 //layer=li \
 //thickness=0.1 //x=11.32 //y=0.175 //x2=11.905 //y2=0.175
r365 (  95 156 ) resistor r=5.29055 //w=0.35 //l=0.17 //layer=li \
 //thickness=0.1 //x=13.215 //y=0.175 //x2=13.385 //y2=0.175
r366 (  95 100 ) resistor r=6.97548 //w=0.367 //l=0.2 //layer=li \
 //thickness=0.1 //x=13.215 //y=0.175 //x2=13.015 //y2=0.175
r367 (  91 155 ) resistor r=4.23183 //w=0.7 //l=0.175 //layer=li \
 //thickness=0.1 //x=11.235 //y=0.35 //x2=11.235 //y2=0.175
r368 (  91 168 ) resistor r=53.7326 //w=0.187 //l=0.785 //layer=li \
 //thickness=0.1 //x=11.235 //y=0.35 //x2=11.235 //y2=1.135
r369 (  88 154 ) resistor r=5.29055 //w=0.35 //l=0.17 //layer=li \
 //thickness=0.1 //x=10.225 //y=0.175 //x2=10.055 //y2=0.175
r370 (  88 90 ) resistor r=19.8801 //w=0.367 //l=0.57 //layer=li \
 //thickness=0.1 //x=10.225 //y=0.175 //x2=10.795 //y2=0.175
r371 (  87 155 ) resistor r=2.87058 //w=0.35 //l=0.085 //layer=li \
 //thickness=0.1 //x=11.15 //y=0.175 //x2=11.235 //y2=0.175
r372 (  87 90 ) resistor r=12.3815 //w=0.367 //l=0.355 //layer=li \
 //thickness=0.1 //x=11.15 //y=0.175 //x2=10.795 //y2=0.175
r373 (  82 84 ) resistor r=38.7139 //w=0.367 //l=1.11 //layer=li \
 //thickness=0.1 //x=8.205 //y=0.175 //x2=9.315 //y2=0.175
r374 (  80 82 ) resistor r=38.7139 //w=0.367 //l=1.11 //layer=li \
 //thickness=0.1 //x=7.095 //y=0.175 //x2=8.205 //y2=0.175
r375 (  78 153 ) resistor r=2.87058 //w=0.35 //l=0.085 //layer=li \
 //thickness=0.1 //x=6.405 //y=0.175 //x2=6.32 //y2=0.175
r376 (  78 80 ) resistor r=24.0654 //w=0.367 //l=0.69 //layer=li \
 //thickness=0.1 //x=6.405 //y=0.175 //x2=7.095 //y2=0.175
r377 (  77 154 ) resistor r=5.29055 //w=0.35 //l=0.17 //layer=li \
 //thickness=0.1 //x=9.885 //y=0.175 //x2=10.055 //y2=0.175
r378 (  77 84 ) resistor r=19.8801 //w=0.367 //l=0.57 //layer=li \
 //thickness=0.1 //x=9.885 //y=0.175 //x2=9.315 //y2=0.175
r379 (  73 153 ) resistor r=4.23183 //w=0.7 //l=0.175 //layer=li \
 //thickness=0.1 //x=6.32 //y=0.35 //x2=6.32 //y2=0.175
r380 (  73 167 ) resistor r=54.4171 //w=0.187 //l=0.795 //layer=li \
 //thickness=0.1 //x=6.32 //y=0.35 //x2=6.32 //y2=1.145
r381 (  70 152 ) resistor r=5.29055 //w=0.35 //l=0.17 //layer=li \
 //thickness=0.1 //x=5.415 //y=0.175 //x2=5.245 //y2=0.175
r382 (  70 72 ) resistor r=19.8801 //w=0.367 //l=0.57 //layer=li \
 //thickness=0.1 //x=5.415 //y=0.175 //x2=5.985 //y2=0.175
r383 (  69 153 ) resistor r=2.87058 //w=0.35 //l=0.085 //layer=li \
 //thickness=0.1 //x=6.235 //y=0.175 //x2=6.32 //y2=0.175
r384 (  69 72 ) resistor r=8.71935 //w=0.367 //l=0.25 //layer=li \
 //thickness=0.1 //x=6.235 //y=0.175 //x2=5.985 //y2=0.175
r385 (  64 66 ) resistor r=38.7139 //w=0.367 //l=1.11 //layer=li \
 //thickness=0.1 //x=3.395 //y=0.175 //x2=4.505 //y2=0.175
r386 (  62 64 ) resistor r=38.7139 //w=0.367 //l=1.11 //layer=li \
 //thickness=0.1 //x=2.285 //y=0.175 //x2=3.395 //y2=0.175
r387 (  60 151 ) resistor r=2.87058 //w=0.35 //l=0.085 //layer=li \
 //thickness=0.1 //x=1.595 //y=0.175 //x2=1.51 //y2=0.175
r388 (  60 62 ) resistor r=24.0654 //w=0.367 //l=0.69 //layer=li \
 //thickness=0.1 //x=1.595 //y=0.175 //x2=2.285 //y2=0.175
r389 (  59 152 ) resistor r=5.29055 //w=0.35 //l=0.17 //layer=li \
 //thickness=0.1 //x=5.075 //y=0.175 //x2=5.245 //y2=0.175
r390 (  59 66 ) resistor r=19.8801 //w=0.367 //l=0.57 //layer=li \
 //thickness=0.1 //x=5.075 //y=0.175 //x2=4.505 //y2=0.175
r391 (  55 151 ) resistor r=4.23183 //w=0.7 //l=0.175 //layer=li \
 //thickness=0.1 //x=1.51 //y=0.35 //x2=1.51 //y2=0.175
r392 (  55 166 ) resistor r=54.4171 //w=0.187 //l=0.795 //layer=li \
 //thickness=0.1 //x=1.51 //y=0.35 //x2=1.51 //y2=1.145
r393 (  51 151 ) resistor r=2.87058 //w=0.35 //l=0.085 //layer=li \
 //thickness=0.1 //x=1.425 //y=0.175 //x2=1.51 //y2=0.175
r394 (  51 54 ) resistor r=8.71935 //w=0.367 //l=0.25 //layer=li \
 //thickness=0.1 //x=1.425 //y=0.175 //x2=1.175 //y2=0.175
r395 (  47 146 ) resistor r=9.3 //w=0.17 //l=0.17 //layer=mcon //count=1 \
 //x=25.965 //y=0.18 //x2=25.965 //y2=0.18
r396 (  45 144 ) resistor r=3.1 //w=0.17 //l=0.51 //layer=mcon //count=3 \
 //x=25.225 //y=0.18 //x2=25.225 //y2=0.18
r397 (  45 47 ) resistor r=0.297428 //w=0.311 //l=0.74 //layer=m1 \
 //thickness=0.36 //x=25.225 //y=0.175 //x2=25.965 //y2=0.175
r398 (  43 164 ) resistor r=3.1 //w=0.17 //l=0.51 //layer=mcon //count=3 \
 //x=24.115 //y=0.18 //x2=24.115 //y2=0.18
r399 (  43 45 ) resistor r=0.446141 //w=0.311 //l=1.11 //layer=m1 \
 //thickness=0.36 //x=24.115 //y=0.175 //x2=25.225 //y2=0.175
r400 (  41 132 ) resistor r=3.1 //w=0.17 //l=0.51 //layer=mcon //count=3 \
 //x=22.635 //y=0.18 //x2=22.635 //y2=0.18
r401 (  41 43 ) resistor r=0.594855 //w=0.311 //l=1.48 //layer=m1 \
 //thickness=0.36 //x=22.635 //y=0.175 //x2=24.115 //y2=0.175
r402 (  39 130 ) resistor r=3.1 //w=0.17 //l=0.51 //layer=mcon //count=3 \
 //x=21.525 //y=0.18 //x2=21.525 //y2=0.18
r403 (  39 41 ) resistor r=0.446141 //w=0.311 //l=1.11 //layer=m1 \
 //thickness=0.36 //x=21.525 //y=0.175 //x2=22.635 //y2=0.175
r404 (  37 128 ) resistor r=3.1 //w=0.17 //l=0.51 //layer=mcon //count=3 \
 //x=20.415 //y=0.18 //x2=20.415 //y2=0.18
r405 (  37 39 ) resistor r=0.446141 //w=0.311 //l=1.11 //layer=m1 \
 //thickness=0.36 //x=20.415 //y=0.175 //x2=21.525 //y2=0.175
r406 (  35 161 ) resistor r=3.1 //w=0.17 //l=0.51 //layer=mcon //count=3 \
 //x=19.305 //y=0.18 //x2=19.305 //y2=0.18
r407 (  35 37 ) resistor r=0.446141 //w=0.311 //l=1.11 //layer=m1 \
 //thickness=0.36 //x=19.305 //y=0.175 //x2=20.415 //y2=0.175
r408 (  33 116 ) resistor r=3.1 //w=0.17 //l=0.51 //layer=mcon //count=3 \
 //x=17.825 //y=0.18 //x2=17.825 //y2=0.18
r409 (  33 35 ) resistor r=0.594855 //w=0.311 //l=1.48 //layer=m1 \
 //thickness=0.36 //x=17.825 //y=0.175 //x2=19.305 //y2=0.175
r410 (  31 114 ) resistor r=3.1 //w=0.17 //l=0.51 //layer=mcon //count=3 \
 //x=16.715 //y=0.18 //x2=16.715 //y2=0.18
r411 (  31 33 ) resistor r=0.446141 //w=0.311 //l=1.11 //layer=m1 \
 //thickness=0.36 //x=16.715 //y=0.175 //x2=17.825 //y2=0.175
r412 (  29 112 ) resistor r=3.1 //w=0.17 //l=0.51 //layer=mcon //count=3 \
 //x=15.605 //y=0.18 //x2=15.605 //y2=0.18
r413 (  29 31 ) resistor r=0.446141 //w=0.311 //l=1.11 //layer=m1 \
 //thickness=0.36 //x=15.605 //y=0.175 //x2=16.715 //y2=0.175
r414 (  27 158 ) resistor r=3.1 //w=0.17 //l=0.51 //layer=mcon //count=3 \
 //x=14.495 //y=0.18 //x2=14.495 //y2=0.18
r415 (  27 29 ) resistor r=0.446141 //w=0.311 //l=1.11 //layer=m1 \
 //thickness=0.36 //x=14.495 //y=0.175 //x2=15.605 //y2=0.175
r416 (  24 100 ) resistor r=3.1 //w=0.17 //l=0.51 //layer=mcon //count=3 \
 //x=13.015 //y=0.18 //x2=13.015 //y2=0.18
r417 (  22 98 ) resistor r=3.1 //w=0.17 //l=0.51 //layer=mcon //count=3 \
 //x=11.905 //y=0.18 //x2=11.905 //y2=0.18
r418 (  22 24 ) resistor r=0.446141 //w=0.311 //l=1.11 //layer=m1 \
 //thickness=0.36 //x=11.905 //y=0.175 //x2=13.015 //y2=0.175
r419 (  20 90 ) resistor r=3.1 //w=0.17 //l=0.51 //layer=mcon //count=3 \
 //x=10.795 //y=0.18 //x2=10.795 //y2=0.18
r420 (  20 22 ) resistor r=0.446141 //w=0.311 //l=1.11 //layer=m1 \
 //thickness=0.36 //x=10.795 //y=0.175 //x2=11.905 //y2=0.175
r421 (  18 84 ) resistor r=3.1 //w=0.17 //l=0.51 //layer=mcon //count=3 \
 //x=9.315 //y=0.18 //x2=9.315 //y2=0.18
r422 (  18 20 ) resistor r=0.594855 //w=0.311 //l=1.48 //layer=m1 \
 //thickness=0.36 //x=9.315 //y=0.175 //x2=10.795 //y2=0.175
r423 (  16 82 ) resistor r=3.1 //w=0.17 //l=0.51 //layer=mcon //count=3 \
 //x=8.205 //y=0.18 //x2=8.205 //y2=0.18
r424 (  16 18 ) resistor r=0.446141 //w=0.311 //l=1.11 //layer=m1 \
 //thickness=0.36 //x=8.205 //y=0.175 //x2=9.315 //y2=0.175
r425 (  14 80 ) resistor r=3.1 //w=0.17 //l=0.51 //layer=mcon //count=3 \
 //x=7.095 //y=0.18 //x2=7.095 //y2=0.18
r426 (  14 16 ) resistor r=0.446141 //w=0.311 //l=1.11 //layer=m1 \
 //thickness=0.36 //x=7.095 //y=0.175 //x2=8.205 //y2=0.175
r427 (  12 72 ) resistor r=3.1 //w=0.17 //l=0.51 //layer=mcon //count=3 \
 //x=5.985 //y=0.18 //x2=5.985 //y2=0.18
r428 (  12 14 ) resistor r=0.446141 //w=0.311 //l=1.11 //layer=m1 \
 //thickness=0.36 //x=5.985 //y=0.175 //x2=7.095 //y2=0.175
r429 (  10 66 ) resistor r=3.1 //w=0.17 //l=0.51 //layer=mcon //count=3 \
 //x=4.505 //y=0.18 //x2=4.505 //y2=0.18
r430 (  10 12 ) resistor r=0.594855 //w=0.311 //l=1.48 //layer=m1 \
 //thickness=0.36 //x=4.505 //y=0.175 //x2=5.985 //y2=0.175
r431 (  8 64 ) resistor r=3.1 //w=0.17 //l=0.51 //layer=mcon //count=3 \
 //x=3.395 //y=0.18 //x2=3.395 //y2=0.18
r432 (  8 10 ) resistor r=0.446141 //w=0.311 //l=1.11 //layer=m1 \
 //thickness=0.36 //x=3.395 //y=0.175 //x2=4.505 //y2=0.175
r433 (  6 62 ) resistor r=3.1 //w=0.17 //l=0.51 //layer=mcon //count=3 \
 //x=2.285 //y=0.18 //x2=2.285 //y2=0.18
r434 (  6 8 ) resistor r=0.446141 //w=0.311 //l=1.11 //layer=m1 \
 //thickness=0.36 //x=2.285 //y=0.175 //x2=3.395 //y2=0.175
r435 (  3 54 ) resistor r=3.1 //w=0.17 //l=0.51 //layer=mcon //count=3 \
 //x=1.175 //y=0.18 //x2=1.175 //y2=0.18
r436 (  3 6 ) resistor r=0.446141 //w=0.311 //l=1.11 //layer=m1 \
 //thickness=0.36 //x=1.175 //y=0.175 //x2=2.285 //y2=0.175
r437 (  1 27 ) resistor r=0.424035 //w=0.311 //l=1.055 //layer=m1 \
 //thickness=0.36 //x=13.44 //y=0.175 //x2=14.495 //y2=0.175
r438 (  1 24 ) resistor r=0.17082 //w=0.311 //l=0.425 //layer=m1 \
 //thickness=0.36 //x=13.44 //y=0.175 //x2=13.015 //y2=0.175
ends PM_DFFRNQNX1\%GND

subckt PM_DFFRNQNX1\%VDD ( 1 47 54 61 71 79 89 95 105 115 123 133 139 147 155 \
 165 171 179 187 197 207 213 221 229 239 249 255 263 273 286 295 300 305 311 \
 317 322 323 324 325 326 327 328 329 330 331 332 333 334 335 336 337 338 339 \
 340 341 342 343 )
c331 ( 343 0 ) capacitor c=0.0382077f //x=25.41 //y=5.2
c332 ( 342 0 ) capacitor c=0.0240874f //x=24.53 //y=5.2
c333 ( 341 0 ) capacitor c=0.0495447f //x=23.66 //y=5.2
c334 ( 340 0 ) capacitor c=0.045306f //x=21.78 //y=5.2
c335 ( 339 0 ) capacitor c=0.0242401f //x=20.9 //y=5.2
c336 ( 338 0 ) capacitor c=0.0242401f //x=20.02 //y=5.2
c337 ( 337 0 ) capacitor c=0.0531794f //x=19.15 //y=5.2
c338 ( 336 0 ) capacitor c=0.045306f //x=16.97 //y=5.2
c339 ( 335 0 ) capacitor c=0.0242401f //x=16.09 //y=5.2
c340 ( 334 0 ) capacitor c=0.0241521f //x=15.21 //y=5.2
c341 ( 333 0 ) capacitor c=0.0531894f //x=14.34 //y=5.2
c342 ( 332 0 ) capacitor c=0.038068f //x=12.46 //y=5.2
c343 ( 331 0 ) capacitor c=0.0240081f //x=11.58 //y=5.2
c344 ( 330 0 ) capacitor c=0.0492093f //x=10.71 //y=5.2
c345 ( 329 0 ) capacitor c=0.045218f //x=8.83 //y=5.2
c346 ( 328 0 ) capacitor c=0.0241521f //x=7.95 //y=5.2
c347 ( 327 0 ) capacitor c=0.0241521f //x=7.07 //y=5.2
c348 ( 326 0 ) capacitor c=0.053132f //x=6.2 //y=5.2
c349 ( 325 0 ) capacitor c=0.045218f //x=4.02 //y=5.2
c350 ( 324 0 ) capacitor c=0.0241521f //x=3.14 //y=5.2
c351 ( 323 0 ) capacitor c=0.0242401f //x=2.26 //y=5.2
c352 ( 322 0 ) capacitor c=0.0531407f //x=1.39 //y=5.2
c353 ( 320 0 ) capacitor c=0.00597439f //x=25.555 //y=7.585
c354 ( 319 0 ) capacitor c=0.00597439f //x=24.675 //y=7.585
c355 ( 318 0 ) capacitor c=0.00597439f //x=23.795 //y=7.585
c356 ( 317 0 ) capacitor c=0.136622f //x=23.005 //y=7.585
c357 ( 316 0 ) capacitor c=0.00597439f //x=21.925 //y=7.585
c358 ( 315 0 ) capacitor c=0.00597439f //x=21.045 //y=7.585
c359 ( 314 0 ) capacitor c=0.00597439f //x=20.165 //y=7.585
c360 ( 313 0 ) capacitor c=0.00597439f //x=19.305 //y=7.58
c361 ( 311 0 ) capacitor c=0.157264f //x=18.195 //y=7.585
c362 ( 310 0 ) capacitor c=0.00597439f //x=17.115 //y=7.585
c363 ( 309 0 ) capacitor c=0.00597439f //x=16.235 //y=7.585
c364 ( 308 0 ) capacitor c=0.00597439f //x=15.355 //y=7.585
c365 ( 307 0 ) capacitor c=0.00597439f //x=14.495 //y=7.58
c366 ( 305 0 ) capacitor c=0.135162f //x=13.385 //y=7.585
c367 ( 304 0 ) capacitor c=0.00597439f //x=12.605 //y=7.585
c368 ( 303 0 ) capacitor c=0.00597439f //x=11.725 //y=7.585
c369 ( 302 0 ) capacitor c=0.00597439f //x=10.795 //y=7.58
c370 ( 300 0 ) capacitor c=0.134682f //x=10.055 //y=7.585
c371 ( 299 0 ) capacitor c=0.00597439f //x=8.975 //y=7.585
c372 ( 298 0 ) capacitor c=0.00597439f //x=8.095 //y=7.585
c373 ( 297 0 ) capacitor c=0.00597439f //x=7.215 //y=7.585
c374 ( 296 0 ) capacitor c=0.00597439f //x=6.335 //y=7.585
c375 ( 295 0 ) capacitor c=0.155314f //x=5.245 //y=7.585
c376 ( 294 0 ) capacitor c=0.00597439f //x=4.165 //y=7.585
c377 ( 293 0 ) capacitor c=0.00597439f //x=3.285 //y=7.585
c378 ( 292 0 ) capacitor c=0.00597439f //x=2.405 //y=7.585
c379 ( 291 0 ) capacitor c=0.00597439f //x=1.525 //y=7.585
c380 ( 286 0 ) capacitor c=0.259672f //x=25.965 //y=7.58
c381 ( 273 0 ) capacitor c=0.028702f //x=25.47 //y=7.585
c382 ( 263 0 ) capacitor c=0.0291291f //x=24.59 //y=7.585
c383 ( 255 0 ) capacitor c=0.024303f //x=23.71 //y=7.585
c384 ( 249 0 ) capacitor c=0.0401574f //x=22.835 //y=7.585
c385 ( 239 0 ) capacitor c=0.0291418f //x=21.84 //y=7.585
c386 ( 229 0 ) capacitor c=0.0292658f //x=20.96 //y=7.585
c387 ( 221 0 ) capacitor c=0.0287792f //x=20.08 //y=7.585
c388 ( 213 0 ) capacitor c=0.0386886f //x=19.2 //y=7.585
c389 ( 207 0 ) capacitor c=0.0398272f //x=18.025 //y=7.585
c390 ( 197 0 ) capacitor c=0.0291418f //x=17.03 //y=7.585
c391 ( 187 0 ) capacitor c=0.029147f //x=16.15 //y=7.585
c392 ( 179 0 ) capacitor c=0.0287649f //x=15.27 //y=7.585
c393 ( 171 0 ) capacitor c=0.0386886f //x=14.39 //y=7.585
c394 ( 165 0 ) capacitor c=0.0238235f //x=13.215 //y=7.585
c395 ( 155 0 ) capacitor c=0.0291008f //x=12.52 //y=7.585
c396 ( 147 0 ) capacitor c=0.0291028f //x=11.64 //y=7.585
c397 ( 139 0 ) capacitor c=0.024303f //x=10.76 //y=7.585
c398 ( 133 0 ) capacitor c=0.0397734f //x=9.885 //y=7.585
c399 ( 123 0 ) capacitor c=0.0291138f //x=8.89 //y=7.585
c400 ( 115 0 ) capacitor c=0.0290172f //x=8.01 //y=7.585
c401 ( 105 0 ) capacitor c=0.0287649f //x=7.13 //y=7.585
c402 ( 95 0 ) capacitor c=0.0386886f //x=6.25 //y=7.585
c403 ( 89 0 ) capacitor c=0.0397734f //x=5.075 //y=7.585
c404 ( 79 0 ) capacitor c=0.0291138f //x=4.08 //y=7.585
c405 ( 71 0 ) capacitor c=0.0291349f //x=3.2 //y=7.585
c406 ( 61 0 ) capacitor c=0.0287792f //x=2.32 //y=7.585
c407 ( 54 0 ) capacitor c=0.249947f //x=1.175 //y=7.58
c408 ( 51 0 ) capacitor c=0.0455283f //x=1.44 //y=7.585
c409 ( 47 0 ) capacitor c=0.936739f //x=25.965 //y=7.58
r410 (  284 320 ) resistor r=2.87058 //w=0.35 //l=0.085 //layer=li \
 //thickness=0.1 //x=25.64 //y=7.585 //x2=25.555 //y2=7.585
r411 (  284 286 ) resistor r=11.3351 //w=0.367 //l=0.325 //layer=li \
 //thickness=0.1 //x=25.64 //y=7.585 //x2=25.965 //y2=7.585
r412 (  277 320 ) resistor r=4.23183 //w=0.7 //l=0.175 //layer=li \
 //thickness=0.1 //x=25.555 //y=7.41 //x2=25.555 //y2=7.585
r413 (  277 343 ) resistor r=33.1979 //w=0.187 //l=0.485 //layer=li \
 //thickness=0.1 //x=25.555 //y=7.41 //x2=25.555 //y2=6.925
r414 (  274 319 ) resistor r=2.87058 //w=0.35 //l=0.085 //layer=li \
 //thickness=0.1 //x=24.76 //y=7.585 //x2=24.675 //y2=7.585
r415 (  274 276 ) resistor r=16.218 //w=0.367 //l=0.465 //layer=li \
 //thickness=0.1 //x=24.76 //y=7.585 //x2=25.225 //y2=7.585
r416 (  273 320 ) resistor r=2.87058 //w=0.35 //l=0.085 //layer=li \
 //thickness=0.1 //x=25.47 //y=7.585 //x2=25.555 //y2=7.585
r417 (  273 276 ) resistor r=8.54496 //w=0.367 //l=0.245 //layer=li \
 //thickness=0.1 //x=25.47 //y=7.585 //x2=25.225 //y2=7.585
r418 (  267 319 ) resistor r=4.23183 //w=0.7 //l=0.175 //layer=li \
 //thickness=0.1 //x=24.675 //y=7.41 //x2=24.675 //y2=7.585
r419 (  267 342 ) resistor r=33.1979 //w=0.187 //l=0.485 //layer=li \
 //thickness=0.1 //x=24.675 //y=7.41 //x2=24.675 //y2=6.925
r420 (  264 318 ) resistor r=2.87058 //w=0.35 //l=0.085 //layer=li \
 //thickness=0.1 //x=23.88 //y=7.585 //x2=23.795 //y2=7.585
r421 (  264 266 ) resistor r=8.19619 //w=0.367 //l=0.235 //layer=li \
 //thickness=0.1 //x=23.88 //y=7.585 //x2=24.115 //y2=7.585
r422 (  263 319 ) resistor r=2.87058 //w=0.35 //l=0.085 //layer=li \
 //thickness=0.1 //x=24.59 //y=7.585 //x2=24.675 //y2=7.585
r423 (  263 266 ) resistor r=16.5668 //w=0.367 //l=0.475 //layer=li \
 //thickness=0.1 //x=24.59 //y=7.585 //x2=24.115 //y2=7.585
r424 (  257 318 ) resistor r=4.23183 //w=0.7 //l=0.175 //layer=li \
 //thickness=0.1 //x=23.795 //y=7.41 //x2=23.795 //y2=7.585
r425 (  257 341 ) resistor r=56.4706 //w=0.187 //l=0.825 //layer=li \
 //thickness=0.1 //x=23.795 //y=7.41 //x2=23.795 //y2=6.585
r426 (  256 317 ) resistor r=5.29055 //w=0.35 //l=0.17 //layer=li \
 //thickness=0.1 //x=23.175 //y=7.585 //x2=23.005 //y2=7.585
r427 (  255 318 ) resistor r=2.87058 //w=0.35 //l=0.085 //layer=li \
 //thickness=0.1 //x=23.71 //y=7.585 //x2=23.795 //y2=7.585
r428 (  255 256 ) resistor r=18.6594 //w=0.367 //l=0.535 //layer=li \
 //thickness=0.1 //x=23.71 //y=7.585 //x2=23.175 //y2=7.585
r429 (  250 316 ) resistor r=2.87058 //w=0.35 //l=0.085 //layer=li \
 //thickness=0.1 //x=22.01 //y=7.585 //x2=21.925 //y2=7.585
r430 (  250 252 ) resistor r=21.7984 //w=0.367 //l=0.625 //layer=li \
 //thickness=0.1 //x=22.01 //y=7.585 //x2=22.635 //y2=7.585
r431 (  249 317 ) resistor r=5.29055 //w=0.35 //l=0.17 //layer=li \
 //thickness=0.1 //x=22.835 //y=7.585 //x2=23.005 //y2=7.585
r432 (  249 252 ) resistor r=6.97548 //w=0.367 //l=0.2 //layer=li \
 //thickness=0.1 //x=22.835 //y=7.585 //x2=22.635 //y2=7.585
r433 (  243 316 ) resistor r=4.23183 //w=0.7 //l=0.175 //layer=li \
 //thickness=0.1 //x=21.925 //y=7.41 //x2=21.925 //y2=7.585
r434 (  243 340 ) resistor r=33.1979 //w=0.187 //l=0.485 //layer=li \
 //thickness=0.1 //x=21.925 //y=7.41 //x2=21.925 //y2=6.925
r435 (  240 315 ) resistor r=2.87058 //w=0.35 //l=0.085 //layer=li \
 //thickness=0.1 //x=21.13 //y=7.585 //x2=21.045 //y2=7.585
r436 (  240 242 ) resistor r=13.7766 //w=0.367 //l=0.395 //layer=li \
 //thickness=0.1 //x=21.13 //y=7.585 //x2=21.525 //y2=7.585
r437 (  239 316 ) resistor r=2.87058 //w=0.35 //l=0.085 //layer=li \
 //thickness=0.1 //x=21.84 //y=7.585 //x2=21.925 //y2=7.585
r438 (  239 242 ) resistor r=10.9864 //w=0.367 //l=0.315 //layer=li \
 //thickness=0.1 //x=21.84 //y=7.585 //x2=21.525 //y2=7.585
r439 (  233 315 ) resistor r=4.23183 //w=0.7 //l=0.175 //layer=li \
 //thickness=0.1 //x=21.045 //y=7.41 //x2=21.045 //y2=7.585
r440 (  233 339 ) resistor r=33.1979 //w=0.187 //l=0.485 //layer=li \
 //thickness=0.1 //x=21.045 //y=7.41 //x2=21.045 //y2=6.925
r441 (  230 314 ) resistor r=2.87058 //w=0.35 //l=0.085 //layer=li \
 //thickness=0.1 //x=20.25 //y=7.585 //x2=20.165 //y2=7.585
r442 (  230 232 ) resistor r=5.75477 //w=0.367 //l=0.165 //layer=li \
 //thickness=0.1 //x=20.25 //y=7.585 //x2=20.415 //y2=7.585
r443 (  229 315 ) resistor r=2.87058 //w=0.35 //l=0.085 //layer=li \
 //thickness=0.1 //x=20.96 //y=7.585 //x2=21.045 //y2=7.585
r444 (  229 232 ) resistor r=19.0082 //w=0.367 //l=0.545 //layer=li \
 //thickness=0.1 //x=20.96 //y=7.585 //x2=20.415 //y2=7.585
r445 (  223 314 ) resistor r=4.23183 //w=0.7 //l=0.175 //layer=li \
 //thickness=0.1 //x=20.165 //y=7.41 //x2=20.165 //y2=7.585
r446 (  223 338 ) resistor r=33.1979 //w=0.187 //l=0.485 //layer=li \
 //thickness=0.1 //x=20.165 //y=7.41 //x2=20.165 //y2=6.925
r447 (  222 313 ) resistor r=2.87058 //w=0.35 //l=0.085 //layer=li \
 //thickness=0.1 //x=19.37 //y=7.585 //x2=19.285 //y2=7.585
r448 (  221 314 ) resistor r=2.87058 //w=0.35 //l=0.085 //layer=li \
 //thickness=0.1 //x=20.08 //y=7.585 //x2=20.165 //y2=7.585
r449 (  221 222 ) resistor r=24.7629 //w=0.367 //l=0.71 //layer=li \
 //thickness=0.1 //x=20.08 //y=7.585 //x2=19.37 //y2=7.585
r450 (  215 313 ) resistor r=4.23183 //w=0.7 //l=0.175 //layer=li \
 //thickness=0.1 //x=19.285 //y=7.41 //x2=19.285 //y2=7.585
r451 (  215 337 ) resistor r=56.4706 //w=0.187 //l=0.825 //layer=li \
 //thickness=0.1 //x=19.285 //y=7.41 //x2=19.285 //y2=6.585
r452 (  214 311 ) resistor r=5.29055 //w=0.35 //l=0.17 //layer=li \
 //thickness=0.1 //x=18.365 //y=7.585 //x2=18.195 //y2=7.585
r453 (  213 313 ) resistor r=2.87058 //w=0.35 //l=0.085 //layer=li \
 //thickness=0.1 //x=19.2 //y=7.585 //x2=19.285 //y2=7.585
r454 (  213 214 ) resistor r=29.1226 //w=0.367 //l=0.835 //layer=li \
 //thickness=0.1 //x=19.2 //y=7.585 //x2=18.365 //y2=7.585
r455 (  208 310 ) resistor r=2.87058 //w=0.35 //l=0.085 //layer=li \
 //thickness=0.1 //x=17.2 //y=7.585 //x2=17.115 //y2=7.585
r456 (  208 210 ) resistor r=21.7984 //w=0.367 //l=0.625 //layer=li \
 //thickness=0.1 //x=17.2 //y=7.585 //x2=17.825 //y2=7.585
r457 (  207 311 ) resistor r=5.29055 //w=0.35 //l=0.17 //layer=li \
 //thickness=0.1 //x=18.025 //y=7.585 //x2=18.195 //y2=7.585
r458 (  207 210 ) resistor r=6.97548 //w=0.367 //l=0.2 //layer=li \
 //thickness=0.1 //x=18.025 //y=7.585 //x2=17.825 //y2=7.585
r459 (  201 310 ) resistor r=4.23183 //w=0.7 //l=0.175 //layer=li \
 //thickness=0.1 //x=17.115 //y=7.41 //x2=17.115 //y2=7.585
r460 (  201 336 ) resistor r=33.1979 //w=0.187 //l=0.485 //layer=li \
 //thickness=0.1 //x=17.115 //y=7.41 //x2=17.115 //y2=6.925
r461 (  198 309 ) resistor r=2.87058 //w=0.35 //l=0.085 //layer=li \
 //thickness=0.1 //x=16.32 //y=7.585 //x2=16.235 //y2=7.585
r462 (  198 200 ) resistor r=13.7766 //w=0.367 //l=0.395 //layer=li \
 //thickness=0.1 //x=16.32 //y=7.585 //x2=16.715 //y2=7.585
r463 (  197 310 ) resistor r=2.87058 //w=0.35 //l=0.085 //layer=li \
 //thickness=0.1 //x=17.03 //y=7.585 //x2=17.115 //y2=7.585
r464 (  197 200 ) resistor r=10.9864 //w=0.367 //l=0.315 //layer=li \
 //thickness=0.1 //x=17.03 //y=7.585 //x2=16.715 //y2=7.585
r465 (  191 309 ) resistor r=4.23183 //w=0.7 //l=0.175 //layer=li \
 //thickness=0.1 //x=16.235 //y=7.41 //x2=16.235 //y2=7.585
r466 (  191 335 ) resistor r=33.1979 //w=0.187 //l=0.485 //layer=li \
 //thickness=0.1 //x=16.235 //y=7.41 //x2=16.235 //y2=6.925
r467 (  188 308 ) resistor r=2.87058 //w=0.35 //l=0.085 //layer=li \
 //thickness=0.1 //x=15.44 //y=7.585 //x2=15.355 //y2=7.585
r468 (  188 190 ) resistor r=5.75477 //w=0.367 //l=0.165 //layer=li \
 //thickness=0.1 //x=15.44 //y=7.585 //x2=15.605 //y2=7.585
r469 (  187 309 ) resistor r=2.87058 //w=0.35 //l=0.085 //layer=li \
 //thickness=0.1 //x=16.15 //y=7.585 //x2=16.235 //y2=7.585
r470 (  187 190 ) resistor r=19.0082 //w=0.367 //l=0.545 //layer=li \
 //thickness=0.1 //x=16.15 //y=7.585 //x2=15.605 //y2=7.585
r471 (  181 308 ) resistor r=4.23183 //w=0.7 //l=0.175 //layer=li \
 //thickness=0.1 //x=15.355 //y=7.41 //x2=15.355 //y2=7.585
r472 (  181 334 ) resistor r=33.1979 //w=0.187 //l=0.485 //layer=li \
 //thickness=0.1 //x=15.355 //y=7.41 //x2=15.355 //y2=6.925
r473 (  180 307 ) resistor r=2.87058 //w=0.35 //l=0.085 //layer=li \
 //thickness=0.1 //x=14.56 //y=7.585 //x2=14.475 //y2=7.585
r474 (  179 308 ) resistor r=2.87058 //w=0.35 //l=0.085 //layer=li \
 //thickness=0.1 //x=15.27 //y=7.585 //x2=15.355 //y2=7.585
r475 (  179 180 ) resistor r=24.7629 //w=0.367 //l=0.71 //layer=li \
 //thickness=0.1 //x=15.27 //y=7.585 //x2=14.56 //y2=7.585
r476 (  173 307 ) resistor r=4.23183 //w=0.7 //l=0.175 //layer=li \
 //thickness=0.1 //x=14.475 //y=7.41 //x2=14.475 //y2=7.585
r477 (  173 333 ) resistor r=56.4706 //w=0.187 //l=0.825 //layer=li \
 //thickness=0.1 //x=14.475 //y=7.41 //x2=14.475 //y2=6.585
r478 (  172 305 ) resistor r=5.29055 //w=0.35 //l=0.17 //layer=li \
 //thickness=0.1 //x=13.555 //y=7.585 //x2=13.385 //y2=7.585
r479 (  171 307 ) resistor r=2.87058 //w=0.35 //l=0.085 //layer=li \
 //thickness=0.1 //x=14.39 //y=7.585 //x2=14.475 //y2=7.585
r480 (  171 172 ) resistor r=29.1226 //w=0.367 //l=0.835 //layer=li \
 //thickness=0.1 //x=14.39 //y=7.585 //x2=13.555 //y2=7.585
r481 (  166 304 ) resistor r=2.87058 //w=0.35 //l=0.085 //layer=li \
 //thickness=0.1 //x=12.69 //y=7.585 //x2=12.605 //y2=7.585
r482 (  166 168 ) resistor r=11.3351 //w=0.367 //l=0.325 //layer=li \
 //thickness=0.1 //x=12.69 //y=7.585 //x2=13.015 //y2=7.585
r483 (  165 305 ) resistor r=5.29055 //w=0.35 //l=0.17 //layer=li \
 //thickness=0.1 //x=13.215 //y=7.585 //x2=13.385 //y2=7.585
r484 (  165 168 ) resistor r=6.97548 //w=0.367 //l=0.2 //layer=li \
 //thickness=0.1 //x=13.215 //y=7.585 //x2=13.015 //y2=7.585
r485 (  159 304 ) resistor r=4.23183 //w=0.7 //l=0.175 //layer=li \
 //thickness=0.1 //x=12.605 //y=7.41 //x2=12.605 //y2=7.585
r486 (  159 332 ) resistor r=33.1979 //w=0.187 //l=0.485 //layer=li \
 //thickness=0.1 //x=12.605 //y=7.41 //x2=12.605 //y2=6.925
r487 (  156 303 ) resistor r=2.87058 //w=0.35 //l=0.085 //layer=li \
 //thickness=0.1 //x=11.81 //y=7.585 //x2=11.725 //y2=7.585
r488 (  156 158 ) resistor r=3.31335 //w=0.367 //l=0.095 //layer=li \
 //thickness=0.1 //x=11.81 //y=7.585 //x2=11.905 //y2=7.585
r489 (  155 304 ) resistor r=2.87058 //w=0.35 //l=0.085 //layer=li \
 //thickness=0.1 //x=12.52 //y=7.585 //x2=12.605 //y2=7.585
r490 (  155 158 ) resistor r=21.4496 //w=0.367 //l=0.615 //layer=li \
 //thickness=0.1 //x=12.52 //y=7.585 //x2=11.905 //y2=7.585
r491 (  149 303 ) resistor r=4.23183 //w=0.7 //l=0.175 //layer=li \
 //thickness=0.1 //x=11.725 //y=7.41 //x2=11.725 //y2=7.585
r492 (  149 331 ) resistor r=33.1979 //w=0.187 //l=0.485 //layer=li \
 //thickness=0.1 //x=11.725 //y=7.41 //x2=11.725 //y2=6.925
r493 (  148 302 ) resistor r=2.87058 //w=0.35 //l=0.085 //layer=li \
 //thickness=0.1 //x=10.93 //y=7.585 //x2=10.845 //y2=7.585
r494 (  147 303 ) resistor r=2.87058 //w=0.35 //l=0.085 //layer=li \
 //thickness=0.1 //x=11.64 //y=7.585 //x2=11.725 //y2=7.585
r495 (  147 148 ) resistor r=24.7629 //w=0.367 //l=0.71 //layer=li \
 //thickness=0.1 //x=11.64 //y=7.585 //x2=10.93 //y2=7.585
r496 (  141 302 ) resistor r=4.23183 //w=0.7 //l=0.175 //layer=li \
 //thickness=0.1 //x=10.845 //y=7.41 //x2=10.845 //y2=7.585
r497 (  141 330 ) resistor r=56.4706 //w=0.187 //l=0.825 //layer=li \
 //thickness=0.1 //x=10.845 //y=7.41 //x2=10.845 //y2=6.585
r498 (  140 300 ) resistor r=5.29055 //w=0.35 //l=0.17 //layer=li \
 //thickness=0.1 //x=10.225 //y=7.585 //x2=10.055 //y2=7.585
r499 (  139 302 ) resistor r=2.87058 //w=0.35 //l=0.085 //layer=li \
 //thickness=0.1 //x=10.76 //y=7.585 //x2=10.845 //y2=7.585
r500 (  139 140 ) resistor r=18.6594 //w=0.367 //l=0.535 //layer=li \
 //thickness=0.1 //x=10.76 //y=7.585 //x2=10.225 //y2=7.585
r501 (  134 299 ) resistor r=2.87058 //w=0.35 //l=0.085 //layer=li \
 //thickness=0.1 //x=9.06 //y=7.585 //x2=8.975 //y2=7.585
r502 (  134 136 ) resistor r=8.89373 //w=0.367 //l=0.255 //layer=li \
 //thickness=0.1 //x=9.06 //y=7.585 //x2=9.315 //y2=7.585
r503 (  133 300 ) resistor r=5.29055 //w=0.35 //l=0.17 //layer=li \
 //thickness=0.1 //x=9.885 //y=7.585 //x2=10.055 //y2=7.585
r504 (  133 136 ) resistor r=19.8801 //w=0.367 //l=0.57 //layer=li \
 //thickness=0.1 //x=9.885 //y=7.585 //x2=9.315 //y2=7.585
r505 (  127 299 ) resistor r=4.23183 //w=0.7 //l=0.175 //layer=li \
 //thickness=0.1 //x=8.975 //y=7.41 //x2=8.975 //y2=7.585
r506 (  127 329 ) resistor r=33.1979 //w=0.187 //l=0.485 //layer=li \
 //thickness=0.1 //x=8.975 //y=7.41 //x2=8.975 //y2=6.925
r507 (  124 298 ) resistor r=2.87058 //w=0.35 //l=0.085 //layer=li \
 //thickness=0.1 //x=8.18 //y=7.585 //x2=8.095 //y2=7.585
r508 (  124 126 ) resistor r=0.871935 //w=0.367 //l=0.025 //layer=li \
 //thickness=0.1 //x=8.18 //y=7.585 //x2=8.205 //y2=7.585
r509 (  123 299 ) resistor r=2.87058 //w=0.35 //l=0.085 //layer=li \
 //thickness=0.1 //x=8.89 //y=7.585 //x2=8.975 //y2=7.585
r510 (  123 126 ) resistor r=23.891 //w=0.367 //l=0.685 //layer=li \
 //thickness=0.1 //x=8.89 //y=7.585 //x2=8.205 //y2=7.585
r511 (  117 298 ) resistor r=4.23183 //w=0.7 //l=0.175 //layer=li \
 //thickness=0.1 //x=8.095 //y=7.41 //x2=8.095 //y2=7.585
r512 (  117 328 ) resistor r=33.1979 //w=0.187 //l=0.485 //layer=li \
 //thickness=0.1 //x=8.095 //y=7.41 //x2=8.095 //y2=6.925
r513 (  116 297 ) resistor r=2.87058 //w=0.35 //l=0.085 //layer=li \
 //thickness=0.1 //x=7.3 //y=7.585 //x2=7.215 //y2=7.585
r514 (  115 298 ) resistor r=2.87058 //w=0.35 //l=0.085 //layer=li \
 //thickness=0.1 //x=8.01 //y=7.585 //x2=8.095 //y2=7.585
r515 (  115 116 ) resistor r=24.7629 //w=0.367 //l=0.71 //layer=li \
 //thickness=0.1 //x=8.01 //y=7.585 //x2=7.3 //y2=7.585
r516 (  109 297 ) resistor r=4.23183 //w=0.7 //l=0.175 //layer=li \
 //thickness=0.1 //x=7.215 //y=7.41 //x2=7.215 //y2=7.585
r517 (  109 327 ) resistor r=33.1979 //w=0.187 //l=0.485 //layer=li \
 //thickness=0.1 //x=7.215 //y=7.41 //x2=7.215 //y2=6.925
r518 (  106 296 ) resistor r=2.87058 //w=0.35 //l=0.085 //layer=li \
 //thickness=0.1 //x=6.42 //y=7.585 //x2=6.335 //y2=7.585
r519 (  106 108 ) resistor r=23.5422 //w=0.367 //l=0.675 //layer=li \
 //thickness=0.1 //x=6.42 //y=7.585 //x2=7.095 //y2=7.585
r520 (  105 297 ) resistor r=2.87058 //w=0.35 //l=0.085 //layer=li \
 //thickness=0.1 //x=7.13 //y=7.585 //x2=7.215 //y2=7.585
r521 (  105 108 ) resistor r=1.22071 //w=0.367 //l=0.035 //layer=li \
 //thickness=0.1 //x=7.13 //y=7.585 //x2=7.095 //y2=7.585
r522 (  99 296 ) resistor r=4.23183 //w=0.7 //l=0.175 //layer=li \
 //thickness=0.1 //x=6.335 //y=7.41 //x2=6.335 //y2=7.585
r523 (  99 326 ) resistor r=56.4706 //w=0.187 //l=0.825 //layer=li \
 //thickness=0.1 //x=6.335 //y=7.41 //x2=6.335 //y2=6.585
r524 (  96 295 ) resistor r=5.29055 //w=0.35 //l=0.17 //layer=li \
 //thickness=0.1 //x=5.415 //y=7.585 //x2=5.245 //y2=7.585
r525 (  96 98 ) resistor r=19.8801 //w=0.367 //l=0.57 //layer=li \
 //thickness=0.1 //x=5.415 //y=7.585 //x2=5.985 //y2=7.585
r526 (  95 296 ) resistor r=2.87058 //w=0.35 //l=0.085 //layer=li \
 //thickness=0.1 //x=6.25 //y=7.585 //x2=6.335 //y2=7.585
r527 (  95 98 ) resistor r=9.24251 //w=0.367 //l=0.265 //layer=li \
 //thickness=0.1 //x=6.25 //y=7.585 //x2=5.985 //y2=7.585
r528 (  90 294 ) resistor r=2.87058 //w=0.35 //l=0.085 //layer=li \
 //thickness=0.1 //x=4.25 //y=7.585 //x2=4.165 //y2=7.585
r529 (  90 92 ) resistor r=8.89373 //w=0.367 //l=0.255 //layer=li \
 //thickness=0.1 //x=4.25 //y=7.585 //x2=4.505 //y2=7.585
r530 (  89 295 ) resistor r=5.29055 //w=0.35 //l=0.17 //layer=li \
 //thickness=0.1 //x=5.075 //y=7.585 //x2=5.245 //y2=7.585
r531 (  89 92 ) resistor r=19.8801 //w=0.367 //l=0.57 //layer=li \
 //thickness=0.1 //x=5.075 //y=7.585 //x2=4.505 //y2=7.585
r532 (  83 294 ) resistor r=4.23183 //w=0.7 //l=0.175 //layer=li \
 //thickness=0.1 //x=4.165 //y=7.41 //x2=4.165 //y2=7.585
r533 (  83 325 ) resistor r=33.1979 //w=0.187 //l=0.485 //layer=li \
 //thickness=0.1 //x=4.165 //y=7.41 //x2=4.165 //y2=6.925
r534 (  80 293 ) resistor r=2.87058 //w=0.35 //l=0.085 //layer=li \
 //thickness=0.1 //x=3.37 //y=7.585 //x2=3.285 //y2=7.585
r535 (  80 82 ) resistor r=0.871935 //w=0.367 //l=0.025 //layer=li \
 //thickness=0.1 //x=3.37 //y=7.585 //x2=3.395 //y2=7.585
r536 (  79 294 ) resistor r=2.87058 //w=0.35 //l=0.085 //layer=li \
 //thickness=0.1 //x=4.08 //y=7.585 //x2=4.165 //y2=7.585
r537 (  79 82 ) resistor r=23.891 //w=0.367 //l=0.685 //layer=li \
 //thickness=0.1 //x=4.08 //y=7.585 //x2=3.395 //y2=7.585
r538 (  73 293 ) resistor r=4.23183 //w=0.7 //l=0.175 //layer=li \
 //thickness=0.1 //x=3.285 //y=7.41 //x2=3.285 //y2=7.585
r539 (  73 324 ) resistor r=33.1979 //w=0.187 //l=0.485 //layer=li \
 //thickness=0.1 //x=3.285 //y=7.41 //x2=3.285 //y2=6.925
r540 (  72 292 ) resistor r=2.87058 //w=0.35 //l=0.085 //layer=li \
 //thickness=0.1 //x=2.49 //y=7.585 //x2=2.405 //y2=7.585
r541 (  71 293 ) resistor r=2.87058 //w=0.35 //l=0.085 //layer=li \
 //thickness=0.1 //x=3.2 //y=7.585 //x2=3.285 //y2=7.585
r542 (  71 72 ) resistor r=24.7629 //w=0.367 //l=0.71 //layer=li \
 //thickness=0.1 //x=3.2 //y=7.585 //x2=2.49 //y2=7.585
r543 (  65 292 ) resistor r=4.23183 //w=0.7 //l=0.175 //layer=li \
 //thickness=0.1 //x=2.405 //y=7.41 //x2=2.405 //y2=7.585
r544 (  65 323 ) resistor r=33.1979 //w=0.187 //l=0.485 //layer=li \
 //thickness=0.1 //x=2.405 //y=7.41 //x2=2.405 //y2=6.925
r545 (  62 291 ) resistor r=2.87058 //w=0.35 //l=0.085 //layer=li \
 //thickness=0.1 //x=1.61 //y=7.585 //x2=1.525 //y2=7.585
r546 (  62 64 ) resistor r=23.5422 //w=0.367 //l=0.675 //layer=li \
 //thickness=0.1 //x=1.61 //y=7.585 //x2=2.285 //y2=7.585
r547 (  61 292 ) resistor r=2.87058 //w=0.35 //l=0.085 //layer=li \
 //thickness=0.1 //x=2.32 //y=7.585 //x2=2.405 //y2=7.585
r548 (  61 64 ) resistor r=1.22071 //w=0.367 //l=0.035 //layer=li \
 //thickness=0.1 //x=2.32 //y=7.585 //x2=2.285 //y2=7.585
r549 (  55 291 ) resistor r=4.23183 //w=0.7 //l=0.175 //layer=li \
 //thickness=0.1 //x=1.525 //y=7.41 //x2=1.525 //y2=7.585
r550 (  55 322 ) resistor r=56.4706 //w=0.187 //l=0.825 //layer=li \
 //thickness=0.1 //x=1.525 //y=7.41 //x2=1.525 //y2=6.585
r551 (  51 291 ) resistor r=2.87058 //w=0.35 //l=0.085 //layer=li \
 //thickness=0.1 //x=1.44 //y=7.585 //x2=1.525 //y2=7.585
r552 (  51 54 ) resistor r=9.24251 //w=0.367 //l=0.265 //layer=li \
 //thickness=0.1 //x=1.44 //y=7.585 //x2=1.175 //y2=7.585
r553 (  47 286 ) resistor r=9.3 //w=0.17 //l=0.17 //layer=mcon //count=1 \
 //x=25.965 //y=7.58 //x2=25.965 //y2=7.58
r554 (  45 276 ) resistor r=3.1 //w=0.17 //l=0.51 //layer=mcon //count=3 \
 //x=25.225 //y=7.58 //x2=25.225 //y2=7.58
r555 (  45 47 ) resistor r=0.297428 //w=0.311 //l=0.74 //layer=m1 \
 //thickness=0.36 //x=25.225 //y=7.585 //x2=25.965 //y2=7.585
r556 (  43 266 ) resistor r=3.1 //w=0.17 //l=0.51 //layer=mcon //count=3 \
 //x=24.115 //y=7.58 //x2=24.115 //y2=7.58
r557 (  43 45 ) resistor r=0.446141 //w=0.311 //l=1.11 //layer=m1 \
 //thickness=0.36 //x=24.115 //y=7.585 //x2=25.225 //y2=7.585
r558 (  41 252 ) resistor r=3.1 //w=0.17 //l=0.51 //layer=mcon //count=3 \
 //x=22.635 //y=7.58 //x2=22.635 //y2=7.58
r559 (  41 43 ) resistor r=0.594855 //w=0.311 //l=1.48 //layer=m1 \
 //thickness=0.36 //x=22.635 //y=7.585 //x2=24.115 //y2=7.585
r560 (  39 242 ) resistor r=3.1 //w=0.17 //l=0.51 //layer=mcon //count=3 \
 //x=21.525 //y=7.58 //x2=21.525 //y2=7.58
r561 (  39 41 ) resistor r=0.446141 //w=0.311 //l=1.11 //layer=m1 \
 //thickness=0.36 //x=21.525 //y=7.585 //x2=22.635 //y2=7.585
r562 (  37 232 ) resistor r=3.1 //w=0.17 //l=0.51 //layer=mcon //count=3 \
 //x=20.415 //y=7.58 //x2=20.415 //y2=7.58
r563 (  37 39 ) resistor r=0.446141 //w=0.311 //l=1.11 //layer=m1 \
 //thickness=0.36 //x=20.415 //y=7.585 //x2=21.525 //y2=7.585
r564 (  35 313 ) resistor r=3.1 //w=0.17 //l=0.51 //layer=mcon //count=3 \
 //x=19.305 //y=7.58 //x2=19.305 //y2=7.58
r565 (  35 37 ) resistor r=0.446141 //w=0.311 //l=1.11 //layer=m1 \
 //thickness=0.36 //x=19.305 //y=7.585 //x2=20.415 //y2=7.585
r566 (  33 210 ) resistor r=3.1 //w=0.17 //l=0.51 //layer=mcon //count=3 \
 //x=17.825 //y=7.58 //x2=17.825 //y2=7.58
r567 (  33 35 ) resistor r=0.594855 //w=0.311 //l=1.48 //layer=m1 \
 //thickness=0.36 //x=17.825 //y=7.585 //x2=19.305 //y2=7.585
r568 (  31 200 ) resistor r=3.1 //w=0.17 //l=0.51 //layer=mcon //count=3 \
 //x=16.715 //y=7.58 //x2=16.715 //y2=7.58
r569 (  31 33 ) resistor r=0.446141 //w=0.311 //l=1.11 //layer=m1 \
 //thickness=0.36 //x=16.715 //y=7.585 //x2=17.825 //y2=7.585
r570 (  29 190 ) resistor r=3.1 //w=0.17 //l=0.51 //layer=mcon //count=3 \
 //x=15.605 //y=7.58 //x2=15.605 //y2=7.58
r571 (  29 31 ) resistor r=0.446141 //w=0.311 //l=1.11 //layer=m1 \
 //thickness=0.36 //x=15.605 //y=7.585 //x2=16.715 //y2=7.585
r572 (  27 307 ) resistor r=3.1 //w=0.17 //l=0.51 //layer=mcon //count=3 \
 //x=14.495 //y=7.58 //x2=14.495 //y2=7.58
r573 (  27 29 ) resistor r=0.446141 //w=0.311 //l=1.11 //layer=m1 \
 //thickness=0.36 //x=14.495 //y=7.585 //x2=15.605 //y2=7.585
r574 (  24 168 ) resistor r=3.1 //w=0.17 //l=0.51 //layer=mcon //count=3 \
 //x=13.015 //y=7.58 //x2=13.015 //y2=7.58
r575 (  22 158 ) resistor r=3.1 //w=0.17 //l=0.51 //layer=mcon //count=3 \
 //x=11.905 //y=7.58 //x2=11.905 //y2=7.58
r576 (  22 24 ) resistor r=0.446141 //w=0.311 //l=1.11 //layer=m1 \
 //thickness=0.36 //x=11.905 //y=7.585 //x2=13.015 //y2=7.585
r577 (  20 302 ) resistor r=3.1 //w=0.17 //l=0.51 //layer=mcon //count=3 \
 //x=10.795 //y=7.58 //x2=10.795 //y2=7.58
r578 (  20 22 ) resistor r=0.446141 //w=0.311 //l=1.11 //layer=m1 \
 //thickness=0.36 //x=10.795 //y=7.585 //x2=11.905 //y2=7.585
r579 (  18 136 ) resistor r=3.1 //w=0.17 //l=0.51 //layer=mcon //count=3 \
 //x=9.315 //y=7.58 //x2=9.315 //y2=7.58
r580 (  18 20 ) resistor r=0.594855 //w=0.311 //l=1.48 //layer=m1 \
 //thickness=0.36 //x=9.315 //y=7.585 //x2=10.795 //y2=7.585
r581 (  16 126 ) resistor r=3.1 //w=0.17 //l=0.51 //layer=mcon //count=3 \
 //x=8.205 //y=7.58 //x2=8.205 //y2=7.58
r582 (  16 18 ) resistor r=0.446141 //w=0.311 //l=1.11 //layer=m1 \
 //thickness=0.36 //x=8.205 //y=7.585 //x2=9.315 //y2=7.585
r583 (  14 108 ) resistor r=3.1 //w=0.17 //l=0.51 //layer=mcon //count=3 \
 //x=7.095 //y=7.58 //x2=7.095 //y2=7.58
r584 (  14 16 ) resistor r=0.446141 //w=0.311 //l=1.11 //layer=m1 \
 //thickness=0.36 //x=7.095 //y=7.585 //x2=8.205 //y2=7.585
r585 (  12 98 ) resistor r=3.1 //w=0.17 //l=0.51 //layer=mcon //count=3 \
 //x=5.985 //y=7.58 //x2=5.985 //y2=7.58
r586 (  12 14 ) resistor r=0.446141 //w=0.311 //l=1.11 //layer=m1 \
 //thickness=0.36 //x=5.985 //y=7.585 //x2=7.095 //y2=7.585
r587 (  10 92 ) resistor r=3.1 //w=0.17 //l=0.51 //layer=mcon //count=3 \
 //x=4.505 //y=7.58 //x2=4.505 //y2=7.58
r588 (  10 12 ) resistor r=0.594855 //w=0.311 //l=1.48 //layer=m1 \
 //thickness=0.36 //x=4.505 //y=7.585 //x2=5.985 //y2=7.585
r589 (  8 82 ) resistor r=3.1 //w=0.17 //l=0.51 //layer=mcon //count=3 \
 //x=3.395 //y=7.58 //x2=3.395 //y2=7.58
r590 (  8 10 ) resistor r=0.446141 //w=0.311 //l=1.11 //layer=m1 \
 //thickness=0.36 //x=3.395 //y=7.585 //x2=4.505 //y2=7.585
r591 (  6 64 ) resistor r=3.1 //w=0.17 //l=0.51 //layer=mcon //count=3 \
 //x=2.285 //y=7.58 //x2=2.285 //y2=7.58
r592 (  6 8 ) resistor r=0.446141 //w=0.311 //l=1.11 //layer=m1 \
 //thickness=0.36 //x=2.285 //y=7.585 //x2=3.395 //y2=7.585
r593 (  3 54 ) resistor r=3.1 //w=0.17 //l=0.51 //layer=mcon //count=3 \
 //x=1.175 //y=7.58 //x2=1.175 //y2=7.58
r594 (  3 6 ) resistor r=0.446141 //w=0.311 //l=1.11 //layer=m1 \
 //thickness=0.36 //x=1.175 //y=7.585 //x2=2.285 //y2=7.585
r595 (  1 27 ) resistor r=0.424035 //w=0.311 //l=1.055 //layer=m1 \
 //thickness=0.36 //x=13.44 //y=7.585 //x2=14.495 //y2=7.585
r596 (  1 24 ) resistor r=0.17082 //w=0.311 //l=0.425 //layer=m1 \
 //thickness=0.36 //x=13.44 //y=7.585 //x2=13.015 //y2=7.585
ends PM_DFFRNQNX1\%VDD

subckt PM_DFFRNQNX1\%noxref_3 ( 1 2 3 4 12 25 26 33 41 47 48 52 54 61 62 63 64 \
 65 66 67 68 72 73 74 79 81 84 85 86 87 88 89 93 95 98 99 104 105 110 119 122 \
 124 125 126 )
c269 ( 126 0 ) capacitor c=0.023087f //x=8.39 //y=5.2
c270 ( 125 0 ) capacitor c=0.023519f //x=7.51 //y=5.2
c271 ( 124 0 ) capacitor c=0.0224735f //x=6.63 //y=5.2
c272 ( 122 0 ) capacitor c=0.00872971f //x=8.64 //y=1.095
c273 ( 119 0 ) capacitor c=0.0588816f //x=11.165 //y=4.88
c274 ( 110 0 ) capacitor c=0.058931f //x=3.765 //y=4.88
c275 ( 105 0 ) capacitor c=0.0273931f //x=3.765 //y=2.095
c276 ( 104 0 ) capacitor c=0.0464411f //x=3.765 //y=2.26
c277 ( 99 0 ) capacitor c=0.0318948f //x=11.5 //y=1.39
c278 ( 98 0 ) capacitor c=0.0187384f //x=11.5 //y=1.045
c279 ( 95 0 ) capacitor c=0.0141798f //x=11.345 //y=1.545
c280 ( 93 0 ) capacitor c=0.0149844f //x=11.345 //y=0.89
c281 ( 89 0 ) capacitor c=0.0813322f //x=10.97 //y=2.095
c282 ( 88 0 ) capacitor c=0.0229267f //x=10.97 //y=1.7
c283 ( 87 0 ) capacitor c=0.0234352f //x=10.97 //y=1.39
c284 ( 86 0 ) capacitor c=0.0199343f //x=10.97 //y=1.045
c285 ( 85 0 ) capacitor c=0.0432517f //x=4.285 //y=1.44
c286 ( 84 0 ) capacitor c=0.0200379f //x=4.285 //y=1.095
c287 ( 81 0 ) capacitor c=0.0158629f //x=4.13 //y=1.595
c288 ( 79 0 ) capacitor c=0.0157803f //x=4.13 //y=0.94
c289 ( 74 0 ) capacitor c=0.0218028f //x=3.755 //y=1.75
c290 ( 73 0 ) capacitor c=0.0207459f //x=3.755 //y=1.44
c291 ( 72 0 ) capacitor c=0.0194308f //x=3.755 //y=1.095
c292 ( 68 0 ) capacitor c=0.110275f //x=11.505 //y=6.2
c293 ( 67 0 ) capacitor c=0.154305f //x=11.065 //y=6.2
c294 ( 66 0 ) capacitor c=0.158794f //x=3.945 //y=6.2
c295 ( 65 0 ) capacitor c=0.110114f //x=3.505 //y=6.2
c296 ( 62 0 ) capacitor c=0.00106608f //x=8.535 //y=5.335
c297 ( 61 0 ) capacitor c=0.00212756f //x=7.655 //y=5.335
c298 ( 54 0 ) capacitor c=0.0897272f //x=11.165 //y=2.26
c299 ( 52 0 ) capacitor c=0.109027f //x=9.315 //y=3.51
c300 ( 48 0 ) capacitor c=0.00398962f //x=8.915 //y=1.845
c301 ( 47 0 ) capacitor c=0.0137288f //x=9.23 //y=1.845
c302 ( 41 0 ) capacitor c=0.0285553f //x=9.23 //y=5.335
c303 ( 33 0 ) capacitor c=0.0176454f //x=8.45 //y=5.335
c304 ( 26 0 ) capacitor c=0.00332903f //x=6.86 //y=5.335
c305 ( 25 0 ) capacitor c=0.0148863f //x=7.57 //y=5.335
c306 ( 12 0 ) capacitor c=0.0879612f //x=3.765 //y=2.26
c307 ( 4 0 ) capacitor c=0.00479603f //x=9.43 //y=3.51
c308 ( 3 0 ) capacitor c=0.0449509f //x=11.05 //y=3.51
c309 ( 2 0 ) capacitor c=0.0164246f //x=3.88 //y=3.51
c310 ( 1 0 ) capacitor c=0.14326f //x=9.2 //y=3.51
r311 (  117 119 ) resistor r=20.6867 //w=0.233 //l=0.1 //layer=ply \
 //thickness=0.18 //x=11.065 //y=4.88 //x2=11.165 //y2=4.88
r312 (  104 105 ) resistor r=52.7279 //w=0.214 //l=0.165 //layer=ply \
 //thickness=0.18 //x=3.765 //y=2.26 //x2=3.765 //y2=2.095
r313 (  100 119 ) resistor r=70.3348 //w=0.233 //l=0.414367 //layer=ply \
 //thickness=0.18 //x=11.505 //y=5.045 //x2=11.165 //y2=4.88
r314 (  99 121 ) resistor r=45.1352 //w=0.168 //l=0.173853 //layer=ply \
 //thickness=0.18 //x=11.5 //y=1.39 //x2=11.46 //y2=1.545
r315 (  98 120 ) resistor r=45.1352 //w=0.168 //l=0.173853 //layer=ply \
 //thickness=0.18 //x=11.5 //y=1.045 //x2=11.46 //y2=0.89
r316 (  98 99 ) resistor r=176.904 //w=0.094 //l=0.345 //layer=ply \
 //thickness=0.18 //x=11.5 //y=1.045 //x2=11.5 //y2=1.39
r317 (  96 116 ) resistor r=10.701 //w=0.21 //l=0.115 //layer=ply \
 //thickness=0.18 //x=11.125 //y=1.545 //x2=11.01 //y2=1.545
r318 (  95 121 ) resistor r=5.52526 //w=0.168 //l=0.115 //layer=ply \
 //thickness=0.18 //x=11.345 //y=1.545 //x2=11.46 //y2=1.545
r319 (  94 115 ) resistor r=5.52526 //w=0.168 //l=0.115 //layer=ply \
 //thickness=0.18 //x=11.125 //y=0.89 //x2=11.01 //y2=0.89
r320 (  93 120 ) resistor r=5.52526 //w=0.168 //l=0.115 //layer=ply \
 //thickness=0.18 //x=11.345 //y=0.89 //x2=11.46 //y2=0.89
r321 (  93 94 ) resistor r=112.809 //w=0.094 //l=0.22 //layer=ply \
 //thickness=0.18 //x=11.345 //y=0.89 //x2=11.125 //y2=0.89
r322 (  90 117 ) resistor r=13.0941 //w=0.233 //l=0.165 //layer=ply \
 //thickness=0.18 //x=11.065 //y=5.045 //x2=11.065 //y2=4.88
r323 (  89 114 ) resistor r=34.8111 //w=0.27 //l=0.264953 //layer=ply \
 //thickness=0.18 //x=10.97 //y=2.095 //x2=11.165 //y2=2.26
r324 (  88 116 ) resistor r=39.5823 //w=0.21 //l=0.173853 //layer=ply \
 //thickness=0.18 //x=10.97 //y=1.7 //x2=11.01 //y2=1.545
r325 (  88 89 ) resistor r=202.543 //w=0.094 //l=0.395 //layer=ply \
 //thickness=0.18 //x=10.97 //y=1.7 //x2=10.97 //y2=2.095
r326 (  87 116 ) resistor r=39.5823 //w=0.21 //l=0.173853 //layer=ply \
 //thickness=0.18 //x=10.97 //y=1.39 //x2=11.01 //y2=1.545
r327 (  86 115 ) resistor r=45.1352 //w=0.168 //l=0.173853 //layer=ply \
 //thickness=0.18 //x=10.97 //y=1.045 //x2=11.01 //y2=0.89
r328 (  86 87 ) resistor r=176.904 //w=0.094 //l=0.345 //layer=ply \
 //thickness=0.18 //x=10.97 //y=1.045 //x2=10.97 //y2=1.39
r329 (  85 112 ) resistor r=45.1352 //w=0.168 //l=0.173853 //layer=ply \
 //thickness=0.18 //x=4.285 //y=1.44 //x2=4.245 //y2=1.595
r330 (  84 111 ) resistor r=45.1352 //w=0.168 //l=0.173853 //layer=ply \
 //thickness=0.18 //x=4.285 //y=1.095 //x2=4.245 //y2=0.94
r331 (  84 85 ) resistor r=176.904 //w=0.094 //l=0.345 //layer=ply \
 //thickness=0.18 //x=4.285 //y=1.095 //x2=4.285 //y2=1.44
r332 (  82 108 ) resistor r=10.701 //w=0.21 //l=0.115 //layer=ply \
 //thickness=0.18 //x=3.91 //y=1.595 //x2=3.795 //y2=1.595
r333 (  81 112 ) resistor r=5.52526 //w=0.168 //l=0.115 //layer=ply \
 //thickness=0.18 //x=4.13 //y=1.595 //x2=4.245 //y2=1.595
r334 (  80 107 ) resistor r=5.52526 //w=0.168 //l=0.115 //layer=ply \
 //thickness=0.18 //x=3.91 //y=0.94 //x2=3.795 //y2=0.94
r335 (  79 111 ) resistor r=5.52526 //w=0.168 //l=0.115 //layer=ply \
 //thickness=0.18 //x=4.13 //y=0.94 //x2=4.245 //y2=0.94
r336 (  79 80 ) resistor r=112.809 //w=0.094 //l=0.22 //layer=ply \
 //thickness=0.18 //x=4.13 //y=0.94 //x2=3.91 //y2=0.94
r337 (  76 110 ) resistor r=37.236 //w=0.233 //l=0.249199 //layer=ply \
 //thickness=0.18 //x=3.945 //y=5.045 //x2=3.765 //y2=4.88
r338 (  74 108 ) resistor r=39.5823 //w=0.21 //l=0.173853 //layer=ply \
 //thickness=0.18 //x=3.755 //y=1.75 //x2=3.795 //y2=1.595
r339 (  74 105 ) resistor r=176.904 //w=0.094 //l=0.345 //layer=ply \
 //thickness=0.18 //x=3.755 //y=1.75 //x2=3.755 //y2=2.095
r340 (  73 108 ) resistor r=39.5823 //w=0.21 //l=0.173853 //layer=ply \
 //thickness=0.18 //x=3.755 //y=1.44 //x2=3.795 //y2=1.595
r341 (  72 107 ) resistor r=45.1352 //w=0.168 //l=0.173853 //layer=ply \
 //thickness=0.18 //x=3.755 //y=1.095 //x2=3.795 //y2=0.94
r342 (  72 73 ) resistor r=176.904 //w=0.094 //l=0.345 //layer=ply \
 //thickness=0.18 //x=3.755 //y=1.095 //x2=3.755 //y2=1.44
r343 (  69 110 ) resistor r=53.7854 //w=0.233 //l=0.332415 //layer=ply \
 //thickness=0.18 //x=3.505 //y=5.045 //x2=3.765 //y2=4.88
r344 (  68 100 ) resistor r=592.245 //w=0.094 //l=1.155 //layer=ply \
 //thickness=0.18 //x=11.505 //y=6.2 //x2=11.505 //y2=5.045
r345 (  67 90 ) resistor r=592.245 //w=0.094 //l=1.155 //layer=ply \
 //thickness=0.18 //x=11.065 //y=6.2 //x2=11.065 //y2=5.045
r346 (  66 76 ) resistor r=592.245 //w=0.094 //l=1.155 //layer=ply \
 //thickness=0.18 //x=3.945 //y=6.2 //x2=3.945 //y2=5.045
r347 (  65 69 ) resistor r=592.245 //w=0.094 //l=1.155 //layer=ply \
 //thickness=0.18 //x=3.505 //y=6.2 //x2=3.505 //y2=5.045
r348 (  64 95 ) resistor r=56.4043 //w=0.094 //l=0.11 //layer=ply \
 //thickness=0.18 //x=11.235 //y=1.545 //x2=11.345 //y2=1.545
r349 (  64 96 ) resistor r=56.4043 //w=0.094 //l=0.11 //layer=ply \
 //thickness=0.18 //x=11.235 //y=1.545 //x2=11.125 //y2=1.545
r350 (  63 81 ) resistor r=56.4043 //w=0.094 //l=0.11 //layer=ply \
 //thickness=0.18 //x=4.02 //y=1.595 //x2=4.13 //y2=1.595
r351 (  63 82 ) resistor r=56.4043 //w=0.094 //l=0.11 //layer=ply \
 //thickness=0.18 //x=4.02 //y=1.595 //x2=3.91 //y2=1.595
r352 (  59 119 ) resistor r=152 //w=0.17 //l=0.17 //layer=licon //count=1 \
 //x=11.165 //y=4.88 //x2=11.165 //y2=4.88
r353 (  57 59 ) resistor r=93.7754 //w=0.187 //l=1.37 //layer=li \
 //thickness=0.1 //x=11.165 //y=3.51 //x2=11.165 //y2=4.88
r354 (  54 114 ) resistor r=152 //w=0.17 //l=0.17 //layer=licon //count=1 \
 //x=11.165 //y=2.26 //x2=11.165 //y2=2.26
r355 (  54 57 ) resistor r=85.5615 //w=0.187 //l=1.25 //layer=li \
 //thickness=0.1 //x=11.165 //y=2.26 //x2=11.165 //y2=3.51
r356 (  50 52 ) resistor r=119.102 //w=0.187 //l=1.74 //layer=li \
 //thickness=0.1 //x=9.315 //y=5.25 //x2=9.315 //y2=3.51
r357 (  49 52 ) resistor r=108.15 //w=0.187 //l=1.58 //layer=li \
 //thickness=0.1 //x=9.315 //y=1.93 //x2=9.315 //y2=3.51
r358 (  47 49 ) resistor r=7.15173 //w=0.17 //l=0.120208 //layer=li \
 //thickness=0.1 //x=9.23 //y=1.845 //x2=9.315 //y2=1.93
r359 (  47 48 ) resistor r=21.5615 //w=0.187 //l=0.315 //layer=li \
 //thickness=0.1 //x=9.23 //y=1.845 //x2=8.915 //y2=1.845
r360 (  43 48 ) resistor r=7.15173 //w=0.17 //l=0.120208 //layer=li \
 //thickness=0.1 //x=8.83 //y=1.76 //x2=8.915 //y2=1.845
r361 (  43 122 ) resistor r=39.016 //w=0.187 //l=0.57 //layer=li \
 //thickness=0.1 //x=8.83 //y=1.76 //x2=8.83 //y2=1.19
r362 (  42 62 ) resistor r=5.4201 //w=0.17 //l=0.085 //layer=li \
 //thickness=0.1 //x=8.62 //y=5.335 //x2=8.535 //y2=5.335
r363 (  41 50 ) resistor r=7.15173 //w=0.17 //l=0.120208 //layer=li \
 //thickness=0.1 //x=9.23 //y=5.335 //x2=9.315 //y2=5.25
r364 (  41 42 ) resistor r=41.754 //w=0.187 //l=0.61 //layer=li \
 //thickness=0.1 //x=9.23 //y=5.335 //x2=8.62 //y2=5.335
r365 (  35 62 ) resistor r=1.40859 //w=0.34 //l=0.085 //layer=li \
 //thickness=0.1 //x=8.535 //y=5.42 //x2=8.535 //y2=5.335
r366 (  35 126 ) resistor r=33.1979 //w=0.187 //l=0.485 //layer=li \
 //thickness=0.1 //x=8.535 //y=5.42 //x2=8.535 //y2=5.905
r367 (  34 61 ) resistor r=5.4201 //w=0.17 //l=0.085 //layer=li \
 //thickness=0.1 //x=7.74 //y=5.335 //x2=7.655 //y2=5.335
r368 (  33 62 ) resistor r=5.4201 //w=0.17 //l=0.085 //layer=li \
 //thickness=0.1 //x=8.45 //y=5.335 //x2=8.535 //y2=5.335
r369 (  33 34 ) resistor r=48.5989 //w=0.187 //l=0.71 //layer=li \
 //thickness=0.1 //x=8.45 //y=5.335 //x2=7.74 //y2=5.335
r370 (  27 61 ) resistor r=1.40859 //w=0.34 //l=0.085 //layer=li \
 //thickness=0.1 //x=7.655 //y=5.42 //x2=7.655 //y2=5.335
r371 (  27 125 ) resistor r=33.1979 //w=0.187 //l=0.485 //layer=li \
 //thickness=0.1 //x=7.655 //y=5.42 //x2=7.655 //y2=5.905
r372 (  25 61 ) resistor r=5.4201 //w=0.17 //l=0.085 //layer=li \
 //thickness=0.1 //x=7.57 //y=5.335 //x2=7.655 //y2=5.335
r373 (  25 26 ) resistor r=48.5989 //w=0.187 //l=0.71 //layer=li \
 //thickness=0.1 //x=7.57 //y=5.335 //x2=6.86 //y2=5.335
r374 (  19 26 ) resistor r=7.15173 //w=0.17 //l=0.120208 //layer=li \
 //thickness=0.1 //x=6.775 //y=5.42 //x2=6.86 //y2=5.335
r375 (  19 124 ) resistor r=33.1979 //w=0.187 //l=0.485 //layer=li \
 //thickness=0.1 //x=6.775 //y=5.42 //x2=6.775 //y2=5.905
r376 (  17 110 ) resistor r=152 //w=0.17 //l=0.17 //layer=licon //count=1 \
 //x=3.765 //y=4.88 //x2=3.765 //y2=4.88
r377 (  15 17 ) resistor r=93.7754 //w=0.187 //l=1.37 //layer=li \
 //thickness=0.1 //x=3.765 //y=3.51 //x2=3.765 //y2=4.88
r378 (  12 104 ) resistor r=152 //w=0.17 //l=0.17 //layer=licon //count=1 \
 //x=3.765 //y=2.26 //x2=3.765 //y2=2.26
r379 (  12 15 ) resistor r=85.5615 //w=0.187 //l=1.25 //layer=li \
 //thickness=0.1 //x=3.765 //y=2.26 //x2=3.765 //y2=3.51
r380 (  10 57 ) resistor r=9.3 //w=0.17 //l=0.17 //layer=mcon //count=1 \
 //x=11.165 //y=3.51 //x2=11.165 //y2=3.51
r381 (  8 52 ) resistor r=9.3 //w=0.17 //l=0.17 //layer=mcon //count=1 \
 //x=9.315 //y=3.51 //x2=9.315 //y2=3.51
r382 (  6 15 ) resistor r=9.3 //w=0.17 //l=0.17 //layer=mcon //count=1 \
 //x=3.765 //y=3.51 //x2=3.765 //y2=3.51
r383 (  4 8 ) resistor r=0.0880901 //w=0.191 //l=0.115 //layer=m1 \
 //thickness=0.36 //x=9.43 //y=3.51 //x2=9.315 //y2=3.51
r384 (  3 10 ) resistor r=0.0717383 //w=0.224 //l=0.115 //layer=m1 \
 //thickness=0.36 //x=11.05 //y=3.51 //x2=11.165 //y2=3.51
r385 (  3 4 ) resistor r=1.5458 //w=0.131 //l=1.62 //layer=m1 //thickness=0.36 \
 //x=11.05 //y=3.51 //x2=9.43 //y2=3.51
r386 (  2 6 ) resistor r=0.0717383 //w=0.224 //l=0.115 //layer=m1 \
 //thickness=0.36 //x=3.88 //y=3.51 //x2=3.765 //y2=3.51
r387 (  1 8 ) resistor r=0.0880901 //w=0.191 //l=0.115 //layer=m1 \
 //thickness=0.36 //x=9.2 //y=3.51 //x2=9.315 //y2=3.51
r388 (  1 2 ) resistor r=5.07634 //w=0.131 //l=5.32 //layer=m1 \
 //thickness=0.36 //x=9.2 //y=3.51 //x2=3.88 //y2=3.51
ends PM_DFFRNQNX1\%noxref_3

subckt PM_DFFRNQNX1\%noxref_4 ( 1 2 13 14 25 27 28 32 34 41 42 43 44 45 46 47 \
 48 49 51 57 58 59 60 72 74 75 )
c149 ( 75 0 ) capacitor c=0.0220291f //x=12.02 //y=5.2
c150 ( 74 0 ) capacitor c=0.0217503f //x=11.14 //y=5.2
c151 ( 72 0 ) capacitor c=0.0084702f //x=12.015 //y=1.085
c152 ( 60 0 ) capacitor c=0.0556143f //x=14.77 //y=4.97
c153 ( 59 0 ) capacitor c=0.0293157f //x=15.06 //y=4.97
c154 ( 58 0 ) capacitor c=0.0347816f //x=14.725 //y=1.4
c155 ( 57 0 ) capacitor c=0.0187487f //x=14.725 //y=1.055
c156 ( 51 0 ) capacitor c=0.0137055f //x=14.57 //y=1.555
c157 ( 49 0 ) capacitor c=0.0149861f //x=14.57 //y=0.9
c158 ( 48 0 ) capacitor c=0.096037f //x=14.195 //y=2.095
c159 ( 47 0 ) capacitor c=0.0228993f //x=14.195 //y=1.71
c160 ( 46 0 ) capacitor c=0.0234352f //x=14.195 //y=1.4
c161 ( 45 0 ) capacitor c=0.0198724f //x=14.195 //y=1.055
c162 ( 44 0 ) capacitor c=0.110114f //x=15.135 //y=6.2
c163 ( 43 0 ) capacitor c=0.158956f //x=14.695 //y=6.2
c164 ( 41 0 ) capacitor c=0.00211606f //x=12.165 //y=5.38
c165 ( 34 0 ) capacitor c=0.0998491f //x=14.495 //y=2.26
c166 ( 32 0 ) capacitor c=0.10775f //x=12.645 //y=3.51
c167 ( 28 0 ) capacitor c=0.00404073f //x=12.29 //y=1.835
c168 ( 27 0 ) capacitor c=0.0122201f //x=12.56 //y=1.835
c169 ( 25 0 ) capacitor c=0.0137995f //x=12.56 //y=5.38
c170 ( 14 0 ) capacitor c=0.00251635f //x=11.37 //y=5.38
c171 ( 13 0 ) capacitor c=0.0143649f //x=12.08 //y=5.38
c172 ( 2 0 ) capacitor c=0.00733653f //x=12.76 //y=3.51
c173 ( 1 0 ) capacitor c=0.0503252f //x=14.38 //y=3.51
r174 (  59 61 ) resistor r=26.9307 //w=0.15 //l=0.106066 //layer=ply \
 //thickness=0.18 //x=15.06 //y=4.97 //x2=15.135 //y2=5.045
r175 (  59 60 ) resistor r=148.702 //w=0.094 //l=0.29 //layer=ply \
 //thickness=0.18 //x=15.06 //y=4.97 //x2=14.77 //y2=4.97
r176 (  58 71 ) resistor r=45.1352 //w=0.168 //l=0.173853 //layer=ply \
 //thickness=0.18 //x=14.725 //y=1.4 //x2=14.685 //y2=1.555
r177 (  57 70 ) resistor r=45.1352 //w=0.168 //l=0.173853 //layer=ply \
 //thickness=0.18 //x=14.725 //y=1.055 //x2=14.685 //y2=0.9
r178 (  57 58 ) resistor r=176.904 //w=0.094 //l=0.345 //layer=ply \
 //thickness=0.18 //x=14.725 //y=1.055 //x2=14.725 //y2=1.4
r179 (  54 60 ) resistor r=22.7971 //w=0.269 //l=0.106066 //layer=ply \
 //thickness=0.18 //x=14.695 //y=5.045 //x2=14.77 //y2=4.97
r180 (  54 69 ) resistor r=35.8364 //w=0.269 //l=0.270185 //layer=ply \
 //thickness=0.18 //x=14.695 //y=5.045 //x2=14.495 //y2=4.88
r181 (  52 65 ) resistor r=10.701 //w=0.21 //l=0.115 //layer=ply \
 //thickness=0.18 //x=14.35 //y=1.555 //x2=14.235 //y2=1.555
r182 (  51 71 ) resistor r=5.52526 //w=0.168 //l=0.115 //layer=ply \
 //thickness=0.18 //x=14.57 //y=1.555 //x2=14.685 //y2=1.555
r183 (  50 64 ) resistor r=5.52526 //w=0.168 //l=0.115 //layer=ply \
 //thickness=0.18 //x=14.35 //y=0.9 //x2=14.235 //y2=0.9
r184 (  49 70 ) resistor r=5.52526 //w=0.168 //l=0.115 //layer=ply \
 //thickness=0.18 //x=14.57 //y=0.9 //x2=14.685 //y2=0.9
r185 (  49 50 ) resistor r=112.809 //w=0.094 //l=0.22 //layer=ply \
 //thickness=0.18 //x=14.57 //y=0.9 //x2=14.35 //y2=0.9
r186 (  48 67 ) resistor r=58.7805 //w=0.246 //l=0.373497 //layer=ply \
 //thickness=0.18 //x=14.195 //y=2.095 //x2=14.495 //y2=2.26
r187 (  47 65 ) resistor r=39.5823 //w=0.21 //l=0.173853 //layer=ply \
 //thickness=0.18 //x=14.195 //y=1.71 //x2=14.235 //y2=1.555
r188 (  47 48 ) resistor r=197.415 //w=0.094 //l=0.385 //layer=ply \
 //thickness=0.18 //x=14.195 //y=1.71 //x2=14.195 //y2=2.095
r189 (  46 65 ) resistor r=39.5823 //w=0.21 //l=0.173853 //layer=ply \
 //thickness=0.18 //x=14.195 //y=1.4 //x2=14.235 //y2=1.555
r190 (  45 64 ) resistor r=45.1352 //w=0.168 //l=0.173853 //layer=ply \
 //thickness=0.18 //x=14.195 //y=1.055 //x2=14.235 //y2=0.9
r191 (  45 46 ) resistor r=176.904 //w=0.094 //l=0.345 //layer=ply \
 //thickness=0.18 //x=14.195 //y=1.055 //x2=14.195 //y2=1.4
r192 (  44 61 ) resistor r=592.245 //w=0.094 //l=1.155 //layer=ply \
 //thickness=0.18 //x=15.135 //y=6.2 //x2=15.135 //y2=5.045
r193 (  43 54 ) resistor r=592.245 //w=0.094 //l=1.155 //layer=ply \
 //thickness=0.18 //x=14.695 //y=6.2 //x2=14.695 //y2=5.045
r194 (  42 51 ) resistor r=56.4043 //w=0.094 //l=0.11 //layer=ply \
 //thickness=0.18 //x=14.46 //y=1.555 //x2=14.57 //y2=1.555
r195 (  42 52 ) resistor r=56.4043 //w=0.094 //l=0.11 //layer=ply \
 //thickness=0.18 //x=14.46 //y=1.555 //x2=14.35 //y2=1.555
r196 (  39 69 ) resistor r=152 //w=0.17 //l=0.17 //layer=licon //count=1 \
 //x=14.495 //y=4.88 //x2=14.495 //y2=4.88
r197 (  37 39 ) resistor r=93.7754 //w=0.187 //l=1.37 //layer=li \
 //thickness=0.1 //x=14.495 //y=3.51 //x2=14.495 //y2=4.88
r198 (  34 67 ) resistor r=152 //w=0.17 //l=0.17 //layer=licon //count=1 \
 //x=14.495 //y=2.26 //x2=14.495 //y2=2.26
r199 (  34 37 ) resistor r=85.5615 //w=0.187 //l=1.25 //layer=li \
 //thickness=0.1 //x=14.495 //y=2.26 //x2=14.495 //y2=3.51
r200 (  30 32 ) resistor r=122.182 //w=0.187 //l=1.785 //layer=li \
 //thickness=0.1 //x=12.645 //y=5.295 //x2=12.645 //y2=3.51
r201 (  29 32 ) resistor r=108.834 //w=0.187 //l=1.59 //layer=li \
 //thickness=0.1 //x=12.645 //y=1.92 //x2=12.645 //y2=3.51
r202 (  27 29 ) resistor r=7.15173 //w=0.17 //l=0.120208 //layer=li \
 //thickness=0.1 //x=12.56 //y=1.835 //x2=12.645 //y2=1.92
r203 (  27 28 ) resistor r=18.4813 //w=0.187 //l=0.27 //layer=li \
 //thickness=0.1 //x=12.56 //y=1.835 //x2=12.29 //y2=1.835
r204 (  26 41 ) resistor r=5.4201 //w=0.17 //l=0.085 //layer=li \
 //thickness=0.1 //x=12.25 //y=5.38 //x2=12.165 //y2=5.38
r205 (  25 30 ) resistor r=7.15173 //w=0.17 //l=0.120208 //layer=li \
 //thickness=0.1 //x=12.56 //y=5.38 //x2=12.645 //y2=5.295
r206 (  25 26 ) resistor r=21.2193 //w=0.187 //l=0.31 //layer=li \
 //thickness=0.1 //x=12.56 //y=5.38 //x2=12.25 //y2=5.38
r207 (  21 28 ) resistor r=7.15173 //w=0.17 //l=0.120208 //layer=li \
 //thickness=0.1 //x=12.205 //y=1.75 //x2=12.29 //y2=1.835
r208 (  21 72 ) resistor r=39.016 //w=0.187 //l=0.57 //layer=li \
 //thickness=0.1 //x=12.205 //y=1.75 //x2=12.205 //y2=1.18
r209 (  15 41 ) resistor r=1.40859 //w=0.34 //l=0.085 //layer=li \
 //thickness=0.1 //x=12.165 //y=5.465 //x2=12.165 //y2=5.38
r210 (  15 75 ) resistor r=30.1176 //w=0.187 //l=0.44 //layer=li \
 //thickness=0.1 //x=12.165 //y=5.465 //x2=12.165 //y2=5.905
r211 (  13 41 ) resistor r=5.4201 //w=0.17 //l=0.085 //layer=li \
 //thickness=0.1 //x=12.08 //y=5.38 //x2=12.165 //y2=5.38
r212 (  13 14 ) resistor r=48.5989 //w=0.187 //l=0.71 //layer=li \
 //thickness=0.1 //x=12.08 //y=5.38 //x2=11.37 //y2=5.38
r213 (  7 14 ) resistor r=7.15173 //w=0.17 //l=0.120208 //layer=li \
 //thickness=0.1 //x=11.285 //y=5.465 //x2=11.37 //y2=5.38
r214 (  7 74 ) resistor r=30.1176 //w=0.187 //l=0.44 //layer=li \
 //thickness=0.1 //x=11.285 //y=5.465 //x2=11.285 //y2=5.905
r215 (  6 37 ) resistor r=9.3 //w=0.17 //l=0.17 //layer=mcon //count=1 \
 //x=14.495 //y=3.51 //x2=14.495 //y2=3.51
r216 (  4 32 ) resistor r=9.3 //w=0.17 //l=0.17 //layer=mcon //count=1 \
 //x=12.645 //y=3.51 //x2=12.645 //y2=3.51
r217 (  2 4 ) resistor r=0.0717383 //w=0.224 //l=0.115 //layer=m1 \
 //thickness=0.36 //x=12.76 //y=3.51 //x2=12.645 //y2=3.51
r218 (  1 6 ) resistor r=0.0717383 //w=0.224 //l=0.115 //layer=m1 \
 //thickness=0.36 //x=14.38 //y=3.51 //x2=14.495 //y2=3.51
r219 (  1 2 ) resistor r=1.5458 //w=0.131 //l=1.62 //layer=m1 //thickness=0.36 \
 //x=14.38 //y=3.51 //x2=12.76 //y2=3.51
ends PM_DFFRNQNX1\%noxref_4

subckt PM_DFFRNQNX1\%CLK ( 1 2 7 8 9 10 11 12 13 14 15 18 30 34 44 50 53 56 60 \
 66 69 73 75 76 77 78 79 80 81 82 83 85 91 92 93 94 95 100 101 102 104 110 111 \
 112 113 114 122 133 )
c254 ( 133 0 ) capacitor c=0.0334004f //x=15.605 //y=4.88
c255 ( 122 0 ) capacitor c=0.0334004f //x=2.655 //y=4.88
c256 ( 114 0 ) capacitor c=0.0246513f //x=15.94 //y=4.97
c257 ( 113 0 ) capacitor c=0.0825646f //x=15.695 //y=2.095
c258 ( 112 0 ) capacitor c=0.0170266f //x=15.695 //y=1.63
c259 ( 111 0 ) capacitor c=0.018609f //x=15.695 //y=1.4
c260 ( 110 0 ) capacitor c=0.0187309f //x=15.695 //y=1.09
c261 ( 104 0 ) capacitor c=0.014725f //x=15.54 //y=1.555
c262 ( 102 0 ) capacitor c=0.0146567f //x=15.54 //y=0.935
c263 ( 101 0 ) capacitor c=0.0335408f //x=15.17 //y=1.4
c264 ( 100 0 ) capacitor c=0.0173761f //x=15.17 //y=1.09
c265 ( 95 0 ) capacitor c=0.0242579f //x=2.99 //y=4.97
c266 ( 94 0 ) capacitor c=0.0836699f //x=2.745 //y=2.095
c267 ( 93 0 ) capacitor c=0.0170266f //x=2.745 //y=1.63
c268 ( 92 0 ) capacitor c=0.018609f //x=2.745 //y=1.4
c269 ( 91 0 ) capacitor c=0.0187309f //x=2.745 //y=1.09
c270 ( 85 0 ) capacitor c=0.014725f //x=2.59 //y=1.555
c271 ( 83 0 ) capacitor c=0.0146567f //x=2.59 //y=0.935
c272 ( 82 0 ) capacitor c=0.0335408f //x=2.22 //y=1.4
c273 ( 81 0 ) capacitor c=0.0173761f //x=2.22 //y=1.09
c274 ( 80 0 ) capacitor c=0.110114f //x=16.015 //y=6.2
c275 ( 79 0 ) capacitor c=0.11012f //x=15.575 //y=6.2
c276 ( 78 0 ) capacitor c=0.110114f //x=3.065 //y=6.2
c277 ( 77 0 ) capacitor c=0.11012f //x=2.625 //y=6.2
c278 ( 73 0 ) capacitor c=0.0346129f //x=15.632 //y=4.535
c279 ( 69 0 ) capacitor c=0.00846054f //x=15.632 //y=3.425
c280 ( 66 0 ) capacitor c=0.00874422f //x=15.632 //y=3.055
c281 ( 60 0 ) capacitor c=0.021333f //x=2.682 //y=4.535
c282 ( 56 0 ) capacitor c=0.00840571f //x=2.682 //y=3.795
c283 ( 53 0 ) capacitor c=0.00846054f //x=2.682 //y=3.425
c284 ( 50 0 ) capacitor c=0.00874422f //x=2.682 //y=3.055
c285 ( 44 0 ) capacitor c=0.00474631f //x=15.605 //y=4.88
c286 ( 34 0 ) capacitor c=0.0125579f //x=15.605 //y=2.26
c287 ( 30 0 ) capacitor c=0.00474631f //x=2.655 //y=4.88
c288 ( 18 0 ) capacitor c=0.0153402f //x=2.655 //y=2.26
c289 ( 15 0 ) capacitor c=0.00589586f //x=15.66 //y=4.62
c290 ( 14 0 ) capacitor c=0.00852122f //x=15.66 //y=3.51
c291 ( 13 0 ) capacitor c=0.00839732f //x=15.66 //y=3.14
c292 ( 12 0 ) capacitor c=0.00834842f //x=15.66 //y=2.77
c293 ( 11 0 ) capacitor c=0.00579039f //x=2.71 //y=4.62
c294 ( 10 0 ) capacitor c=0.00833816f //x=2.71 //y=3.88
c295 ( 9 0 ) capacitor c=0.00769643f //x=2.71 //y=3.51
c296 ( 8 0 ) capacitor c=0.00838372f //x=2.71 //y=3.14
c297 ( 7 0 ) capacitor c=0.00841072f //x=2.71 //y=2.77
c298 ( 2 0 ) capacitor c=0.0154682f //x=2.77 //y=4.62
c299 ( 1 0 ) capacitor c=0.292284f //x=15.49 //y=4.62
r300 (  135 136 ) resistor r=32.4568 //w=0.214 //l=0.075 //layer=ply \
 //thickness=0.18 //x=15.605 //y=4.97 //x2=15.605 //y2=5.045
r301 (  133 135 ) resistor r=20.271 //w=0.214 //l=0.09 //layer=ply \
 //thickness=0.18 //x=15.605 //y=4.88 //x2=15.605 //y2=4.97
r302 (  124 125 ) resistor r=32.4568 //w=0.214 //l=0.075 //layer=ply \
 //thickness=0.18 //x=2.655 //y=4.97 //x2=2.655 //y2=5.045
r303 (  122 124 ) resistor r=20.271 //w=0.214 //l=0.09 //layer=ply \
 //thickness=0.18 //x=2.655 //y=4.88 //x2=2.655 //y2=4.97
r304 (  115 135 ) resistor r=16.5046 //w=0.27 //l=0.135 //layer=ply \
 //thickness=0.18 //x=15.74 //y=4.97 //x2=15.605 //y2=4.97
r305 (  114 116 ) resistor r=26.9307 //w=0.15 //l=0.106066 //layer=ply \
 //thickness=0.18 //x=15.94 //y=4.97 //x2=16.015 //y2=5.045
r306 (  114 115 ) resistor r=102.553 //w=0.094 //l=0.2 //layer=ply \
 //thickness=0.18 //x=15.94 //y=4.97 //x2=15.74 //y2=4.97
r307 (  113 140 ) resistor r=38.6777 //w=0.284 //l=0.198997 //layer=ply \
 //thickness=0.18 //x=15.695 //y=2.095 //x2=15.62 //y2=2.26
r308 (  112 138 ) resistor r=21.2976 //w=0.217 //l=0.0928709 //layer=ply \
 //thickness=0.18 //x=15.695 //y=1.63 //x2=15.655 //y2=1.555
r309 (  112 113 ) resistor r=238.436 //w=0.094 //l=0.465 //layer=ply \
 //thickness=0.18 //x=15.695 //y=1.63 //x2=15.695 //y2=2.095
r310 (  111 138 ) resistor r=39.0671 //w=0.217 //l=0.173853 //layer=ply \
 //thickness=0.18 //x=15.695 //y=1.4 //x2=15.655 //y2=1.555
r311 (  110 137 ) resistor r=45.1352 //w=0.168 //l=0.173853 //layer=ply \
 //thickness=0.18 //x=15.695 //y=1.09 //x2=15.655 //y2=0.935
r312 (  110 111 ) resistor r=158.957 //w=0.094 //l=0.31 //layer=ply \
 //thickness=0.18 //x=15.695 //y=1.09 //x2=15.695 //y2=1.4
r313 (  105 131 ) resistor r=5.52526 //w=0.168 //l=0.115 //layer=ply \
 //thickness=0.18 //x=15.325 //y=1.555 //x2=15.21 //y2=1.555
r314 (  104 138 ) resistor r=11.4558 //w=0.217 //l=0.115 //layer=ply \
 //thickness=0.18 //x=15.54 //y=1.555 //x2=15.655 //y2=1.555
r315 (  103 130 ) resistor r=5.52526 //w=0.168 //l=0.115 //layer=ply \
 //thickness=0.18 //x=15.325 //y=0.935 //x2=15.21 //y2=0.935
r316 (  102 137 ) resistor r=5.52526 //w=0.168 //l=0.115 //layer=ply \
 //thickness=0.18 //x=15.54 //y=0.935 //x2=15.655 //y2=0.935
r317 (  102 103 ) resistor r=110.245 //w=0.094 //l=0.215 //layer=ply \
 //thickness=0.18 //x=15.54 //y=0.935 //x2=15.325 //y2=0.935
r318 (  101 131 ) resistor r=45.1352 //w=0.168 //l=0.173853 //layer=ply \
 //thickness=0.18 //x=15.17 //y=1.4 //x2=15.21 //y2=1.555
r319 (  100 130 ) resistor r=45.1352 //w=0.168 //l=0.173853 //layer=ply \
 //thickness=0.18 //x=15.17 //y=1.09 //x2=15.21 //y2=0.935
r320 (  100 101 ) resistor r=158.957 //w=0.094 //l=0.31 //layer=ply \
 //thickness=0.18 //x=15.17 //y=1.09 //x2=15.17 //y2=1.4
r321 (  96 124 ) resistor r=16.5046 //w=0.27 //l=0.135 //layer=ply \
 //thickness=0.18 //x=2.79 //y=4.97 //x2=2.655 //y2=4.97
r322 (  95 97 ) resistor r=26.9307 //w=0.15 //l=0.106066 //layer=ply \
 //thickness=0.18 //x=2.99 //y=4.97 //x2=3.065 //y2=5.045
r323 (  95 96 ) resistor r=102.553 //w=0.094 //l=0.2 //layer=ply \
 //thickness=0.18 //x=2.99 //y=4.97 //x2=2.79 //y2=4.97
r324 (  94 129 ) resistor r=38.6777 //w=0.284 //l=0.198997 //layer=ply \
 //thickness=0.18 //x=2.745 //y=2.095 //x2=2.67 //y2=2.26
r325 (  93 127 ) resistor r=21.2976 //w=0.217 //l=0.0928709 //layer=ply \
 //thickness=0.18 //x=2.745 //y=1.63 //x2=2.705 //y2=1.555
r326 (  93 94 ) resistor r=238.436 //w=0.094 //l=0.465 //layer=ply \
 //thickness=0.18 //x=2.745 //y=1.63 //x2=2.745 //y2=2.095
r327 (  92 127 ) resistor r=39.0671 //w=0.217 //l=0.173853 //layer=ply \
 //thickness=0.18 //x=2.745 //y=1.4 //x2=2.705 //y2=1.555
r328 (  91 126 ) resistor r=45.1352 //w=0.168 //l=0.173853 //layer=ply \
 //thickness=0.18 //x=2.745 //y=1.09 //x2=2.705 //y2=0.935
r329 (  91 92 ) resistor r=158.957 //w=0.094 //l=0.31 //layer=ply \
 //thickness=0.18 //x=2.745 //y=1.09 //x2=2.745 //y2=1.4
r330 (  86 120 ) resistor r=5.52526 //w=0.168 //l=0.115 //layer=ply \
 //thickness=0.18 //x=2.375 //y=1.555 //x2=2.26 //y2=1.555
r331 (  85 127 ) resistor r=11.4558 //w=0.217 //l=0.115 //layer=ply \
 //thickness=0.18 //x=2.59 //y=1.555 //x2=2.705 //y2=1.555
r332 (  84 119 ) resistor r=5.52526 //w=0.168 //l=0.115 //layer=ply \
 //thickness=0.18 //x=2.375 //y=0.935 //x2=2.26 //y2=0.935
r333 (  83 126 ) resistor r=5.52526 //w=0.168 //l=0.115 //layer=ply \
 //thickness=0.18 //x=2.59 //y=0.935 //x2=2.705 //y2=0.935
r334 (  83 84 ) resistor r=110.245 //w=0.094 //l=0.215 //layer=ply \
 //thickness=0.18 //x=2.59 //y=0.935 //x2=2.375 //y2=0.935
r335 (  82 120 ) resistor r=45.1352 //w=0.168 //l=0.173853 //layer=ply \
 //thickness=0.18 //x=2.22 //y=1.4 //x2=2.26 //y2=1.555
r336 (  81 119 ) resistor r=45.1352 //w=0.168 //l=0.173853 //layer=ply \
 //thickness=0.18 //x=2.22 //y=1.09 //x2=2.26 //y2=0.935
r337 (  81 82 ) resistor r=158.957 //w=0.094 //l=0.31 //layer=ply \
 //thickness=0.18 //x=2.22 //y=1.09 //x2=2.22 //y2=1.4
r338 (  80 116 ) resistor r=592.245 //w=0.094 //l=1.155 //layer=ply \
 //thickness=0.18 //x=16.015 //y=6.2 //x2=16.015 //y2=5.045
r339 (  79 136 ) resistor r=592.245 //w=0.094 //l=1.155 //layer=ply \
 //thickness=0.18 //x=15.575 //y=6.2 //x2=15.575 //y2=5.045
r340 (  78 97 ) resistor r=592.245 //w=0.094 //l=1.155 //layer=ply \
 //thickness=0.18 //x=3.065 //y=6.2 //x2=3.065 //y2=5.045
r341 (  77 125 ) resistor r=592.245 //w=0.094 //l=1.155 //layer=ply \
 //thickness=0.18 //x=2.625 //y=6.2 //x2=2.625 //y2=5.045
r342 (  76 104 ) resistor r=55.3787 //w=0.094 //l=0.108 //layer=ply \
 //thickness=0.18 //x=15.432 //y=1.555 //x2=15.54 //y2=1.555
r343 (  76 105 ) resistor r=54.866 //w=0.094 //l=0.107 //layer=ply \
 //thickness=0.18 //x=15.432 //y=1.555 //x2=15.325 //y2=1.555
r344 (  75 85 ) resistor r=55.3787 //w=0.094 //l=0.108 //layer=ply \
 //thickness=0.18 //x=2.482 //y=1.555 //x2=2.59 //y2=1.555
r345 (  75 86 ) resistor r=54.866 //w=0.094 //l=0.107 //layer=ply \
 //thickness=0.18 //x=2.482 //y=1.555 //x2=2.375 //y2=1.555
r346 (  70 73 ) resistor r=64.3422 //w=0.187 //l=0.94 //layer=li \
 //thickness=0.1 //x=15.605 //y=3.595 //x2=15.605 //y2=4.535
r347 (  67 69 ) resistor r=13.6898 //w=0.187 //l=0.2 //layer=li \
 //thickness=0.1 //x=15.605 //y=3.225 //x2=15.605 //y2=3.425
r348 (  64 66 ) resistor r=13.6898 //w=0.187 //l=0.2 //layer=li \
 //thickness=0.1 //x=15.605 //y=2.855 //x2=15.605 //y2=3.055
r349 (  57 60 ) resistor r=39.016 //w=0.187 //l=0.57 //layer=li \
 //thickness=0.1 //x=2.655 //y=3.965 //x2=2.655 //y2=4.535
r350 (  54 56 ) resistor r=13.6898 //w=0.187 //l=0.2 //layer=li \
 //thickness=0.1 //x=2.655 //y=3.595 //x2=2.655 //y2=3.795
r351 (  51 53 ) resistor r=13.6898 //w=0.187 //l=0.2 //layer=li \
 //thickness=0.1 //x=2.655 //y=3.225 //x2=2.655 //y2=3.425
r352 (  48 50 ) resistor r=13.6898 //w=0.187 //l=0.2 //layer=li \
 //thickness=0.1 //x=2.655 //y=2.855 //x2=2.655 //y2=3.055
r353 (  44 133 ) resistor r=152 //w=0.17 //l=0.17 //layer=licon //count=1 \
 //x=15.605 //y=4.88 //x2=15.605 //y2=4.88
r354 (  44 74 ) resistor r=11.9786 //w=0.187 //l=0.175 //layer=li \
 //thickness=0.1 //x=15.605 //y=4.88 //x2=15.605 //y2=4.705
r355 (  34 140 ) resistor r=152 //w=0.17 //l=0.17 //layer=licon //count=1 \
 //x=15.605 //y=2.26 //x2=15.605 //y2=2.26
r356 (  34 63 ) resistor r=29.0909 //w=0.187 //l=0.425 //layer=li \
 //thickness=0.1 //x=15.605 //y=2.26 //x2=15.605 //y2=2.685
r357 (  30 122 ) resistor r=152 //w=0.17 //l=0.17 //layer=licon //count=1 \
 //x=2.655 //y=4.88 //x2=2.655 //y2=4.88
r358 (  30 61 ) resistor r=11.9786 //w=0.187 //l=0.175 //layer=li \
 //thickness=0.1 //x=2.655 //y=4.88 //x2=2.655 //y2=4.705
r359 (  18 129 ) resistor r=152 //w=0.17 //l=0.17 //layer=licon //count=1 \
 //x=2.655 //y=2.26 //x2=2.655 //y2=2.26
r360 (  18 47 ) resistor r=29.0909 //w=0.187 //l=0.425 //layer=li \
 //thickness=0.1 //x=2.655 //y=2.26 //x2=2.655 //y2=2.685
r361 (  15 74 ) resistor r=5.1957 //w=0.242 //l=0.085 //layer=li \
 //thickness=0.1 //x=15.632 //y=4.62 //x2=15.632 //y2=4.705
r362 (  15 73 ) resistor r=5.1957 //w=0.242 //l=0.085 //layer=li \
 //thickness=0.1 //x=15.632 //y=4.62 //x2=15.632 //y2=4.535
r363 (  14 70 ) resistor r=5.1957 //w=0.242 //l=0.085 //layer=li \
 //thickness=0.1 //x=15.632 //y=3.51 //x2=15.632 //y2=3.595
r364 (  14 69 ) resistor r=5.1957 //w=0.242 //l=0.085 //layer=li \
 //thickness=0.1 //x=15.632 //y=3.51 //x2=15.632 //y2=3.425
r365 (  13 67 ) resistor r=5.1957 //w=0.242 //l=0.085 //layer=li \
 //thickness=0.1 //x=15.632 //y=3.14 //x2=15.632 //y2=3.225
r366 (  13 66 ) resistor r=5.1957 //w=0.242 //l=0.085 //layer=li \
 //thickness=0.1 //x=15.632 //y=3.14 //x2=15.632 //y2=3.055
r367 (  12 64 ) resistor r=5.1957 //w=0.242 //l=0.085 //layer=li \
 //thickness=0.1 //x=15.632 //y=2.77 //x2=15.632 //y2=2.855
r368 (  12 63 ) resistor r=5.1957 //w=0.242 //l=0.085 //layer=li \
 //thickness=0.1 //x=15.632 //y=2.77 //x2=15.632 //y2=2.685
r369 (  11 61 ) resistor r=5.1957 //w=0.242 //l=0.085 //layer=li \
 //thickness=0.1 //x=2.682 //y=4.62 //x2=2.682 //y2=4.705
r370 (  11 60 ) resistor r=5.1957 //w=0.242 //l=0.085 //layer=li \
 //thickness=0.1 //x=2.682 //y=4.62 //x2=2.682 //y2=4.535
r371 (  10 57 ) resistor r=5.1957 //w=0.242 //l=0.085 //layer=li \
 //thickness=0.1 //x=2.682 //y=3.88 //x2=2.682 //y2=3.965
r372 (  10 56 ) resistor r=5.1957 //w=0.242 //l=0.085 //layer=li \
 //thickness=0.1 //x=2.682 //y=3.88 //x2=2.682 //y2=3.795
r373 (  9 54 ) resistor r=5.1957 //w=0.242 //l=0.085 //layer=li \
 //thickness=0.1 //x=2.682 //y=3.51 //x2=2.682 //y2=3.595
r374 (  9 53 ) resistor r=5.1957 //w=0.242 //l=0.085 //layer=li \
 //thickness=0.1 //x=2.682 //y=3.51 //x2=2.682 //y2=3.425
r375 (  8 51 ) resistor r=5.1957 //w=0.242 //l=0.085 //layer=li \
 //thickness=0.1 //x=2.682 //y=3.14 //x2=2.682 //y2=3.225
r376 (  8 50 ) resistor r=5.1957 //w=0.242 //l=0.085 //layer=li \
 //thickness=0.1 //x=2.682 //y=3.14 //x2=2.682 //y2=3.055
r377 (  7 48 ) resistor r=5.1957 //w=0.242 //l=0.085 //layer=li \
 //thickness=0.1 //x=2.682 //y=2.77 //x2=2.682 //y2=2.855
r378 (  7 47 ) resistor r=5.1957 //w=0.242 //l=0.085 //layer=li \
 //thickness=0.1 //x=2.682 //y=2.77 //x2=2.682 //y2=2.685
r379 (  6 15 ) resistor r=9.3 //w=0.17 //l=0.17 //layer=mcon //count=1 \
 //x=15.605 //y=4.62 //x2=15.605 //y2=4.62
r380 (  4 11 ) resistor r=9.3 //w=0.17 //l=0.17 //layer=mcon //count=1 \
 //x=2.655 //y=4.62 //x2=2.655 //y2=4.62
r381 (  2 4 ) resistor r=0.0717383 //w=0.224 //l=0.115 //layer=m1 \
 //thickness=0.36 //x=2.77 //y=4.62 //x2=2.655 //y2=4.62
r382 (  1 6 ) resistor r=0.0717383 //w=0.224 //l=0.115 //layer=m1 \
 //thickness=0.36 //x=15.49 //y=4.62 //x2=15.605 //y2=4.62
r383 (  1 2 ) resistor r=12.1374 //w=0.131 //l=12.72 //layer=m1 \
 //thickness=0.36 //x=15.49 //y=4.62 //x2=2.77 //y2=4.62
ends PM_DFFRNQNX1\%CLK

subckt PM_DFFRNQNX1\%noxref_6 ( 1 2 3 4 17 18 25 33 39 40 44 46 54 61 62 63 64 \
 65 66 67 68 69 70 71 72 73 75 81 82 83 84 88 89 90 91 92 94 100 101 102 103 \
 123 125 126 127 )
c255 ( 127 0 ) capacitor c=0.023087f //x=3.58 //y=5.2
c256 ( 126 0 ) capacitor c=0.023519f //x=2.7 //y=5.2
c257 ( 125 0 ) capacitor c=0.0224735f //x=1.82 //y=5.2
c258 ( 123 0 ) capacitor c=0.00853354f //x=3.83 //y=1.095
c259 ( 103 0 ) capacitor c=0.0558396f //x=19.58 //y=4.97
c260 ( 102 0 ) capacitor c=0.0298189f //x=19.87 //y=4.97
c261 ( 101 0 ) capacitor c=0.0347816f //x=19.535 //y=1.4
c262 ( 100 0 ) capacitor c=0.0187487f //x=19.535 //y=1.055
c263 ( 94 0 ) capacitor c=0.0137055f //x=19.38 //y=1.555
c264 ( 92 0 ) capacitor c=0.0149861f //x=19.38 //y=0.9
c265 ( 91 0 ) capacitor c=0.096037f //x=19.005 //y=2.095
c266 ( 90 0 ) capacitor c=0.0228993f //x=19.005 //y=1.71
c267 ( 89 0 ) capacitor c=0.0234352f //x=19.005 //y=1.4
c268 ( 88 0 ) capacitor c=0.0198724f //x=19.005 //y=1.055
c269 ( 84 0 ) capacitor c=0.0556143f //x=6.63 //y=4.97
c270 ( 83 0 ) capacitor c=0.0293157f //x=6.92 //y=4.97
c271 ( 82 0 ) capacitor c=0.0347816f //x=6.585 //y=1.4
c272 ( 81 0 ) capacitor c=0.0187487f //x=6.585 //y=1.055
c273 ( 75 0 ) capacitor c=0.0137055f //x=6.43 //y=1.555
c274 ( 73 0 ) capacitor c=0.0149861f //x=6.43 //y=0.9
c275 ( 72 0 ) capacitor c=0.102158f //x=6.055 //y=2.095
c276 ( 71 0 ) capacitor c=0.0229444f //x=6.055 //y=1.71
c277 ( 70 0 ) capacitor c=0.0234352f //x=6.055 //y=1.4
c278 ( 69 0 ) capacitor c=0.0198724f //x=6.055 //y=1.055
c279 ( 68 0 ) capacitor c=0.110114f //x=19.945 //y=6.2
c280 ( 67 0 ) capacitor c=0.158956f //x=19.505 //y=6.2
c281 ( 66 0 ) capacitor c=0.110114f //x=6.995 //y=6.2
c282 ( 65 0 ) capacitor c=0.158956f //x=6.555 //y=6.2
c283 ( 62 0 ) capacitor c=0.00106608f //x=3.725 //y=5.335
c284 ( 61 0 ) capacitor c=0.00179642f //x=2.845 //y=5.335
c285 ( 54 0 ) capacitor c=0.106682f //x=19.305 //y=2.26
c286 ( 46 0 ) capacitor c=0.102391f //x=6.355 //y=2.26
c287 ( 44 0 ) capacitor c=0.110215f //x=4.505 //y=3.88
c288 ( 40 0 ) capacitor c=0.00493499f //x=4.105 //y=1.845
c289 ( 39 0 ) capacitor c=0.0154052f //x=4.42 //y=1.845
c290 ( 33 0 ) capacitor c=0.0283082f //x=4.42 //y=5.335
c291 ( 25 0 ) capacitor c=0.0176454f //x=3.64 //y=5.335
c292 ( 18 0 ) capacitor c=0.00351598f //x=2.05 //y=5.335
c293 ( 17 0 ) capacitor c=0.0154549f //x=2.76 //y=5.335
c294 ( 4 0 ) capacitor c=0.00424246f //x=6.47 //y=3.88
c295 ( 3 0 ) capacitor c=0.236093f //x=19.19 //y=3.88
c296 ( 2 0 ) capacitor c=0.0125346f //x=4.62 //y=3.88
c297 ( 1 0 ) capacitor c=0.0288301f //x=6.24 //y=3.88
r298 (  102 104 ) resistor r=26.9307 //w=0.15 //l=0.106066 //layer=ply \
 //thickness=0.18 //x=19.87 //y=4.97 //x2=19.945 //y2=5.045
r299 (  102 103 ) resistor r=148.702 //w=0.094 //l=0.29 //layer=ply \
 //thickness=0.18 //x=19.87 //y=4.97 //x2=19.58 //y2=4.97
r300 (  101 122 ) resistor r=45.1352 //w=0.168 //l=0.173853 //layer=ply \
 //thickness=0.18 //x=19.535 //y=1.4 //x2=19.495 //y2=1.555
r301 (  100 121 ) resistor r=45.1352 //w=0.168 //l=0.173853 //layer=ply \
 //thickness=0.18 //x=19.535 //y=1.055 //x2=19.495 //y2=0.9
r302 (  100 101 ) resistor r=176.904 //w=0.094 //l=0.345 //layer=ply \
 //thickness=0.18 //x=19.535 //y=1.055 //x2=19.535 //y2=1.4
r303 (  97 103 ) resistor r=22.7971 //w=0.269 //l=0.106066 //layer=ply \
 //thickness=0.18 //x=19.505 //y=5.045 //x2=19.58 //y2=4.97
r304 (  97 120 ) resistor r=35.8364 //w=0.269 //l=0.270185 //layer=ply \
 //thickness=0.18 //x=19.505 //y=5.045 //x2=19.305 //y2=4.88
r305 (  95 116 ) resistor r=10.701 //w=0.21 //l=0.115 //layer=ply \
 //thickness=0.18 //x=19.16 //y=1.555 //x2=19.045 //y2=1.555
r306 (  94 122 ) resistor r=5.52526 //w=0.168 //l=0.115 //layer=ply \
 //thickness=0.18 //x=19.38 //y=1.555 //x2=19.495 //y2=1.555
r307 (  93 115 ) resistor r=5.52526 //w=0.168 //l=0.115 //layer=ply \
 //thickness=0.18 //x=19.16 //y=0.9 //x2=19.045 //y2=0.9
r308 (  92 121 ) resistor r=5.52526 //w=0.168 //l=0.115 //layer=ply \
 //thickness=0.18 //x=19.38 //y=0.9 //x2=19.495 //y2=0.9
r309 (  92 93 ) resistor r=112.809 //w=0.094 //l=0.22 //layer=ply \
 //thickness=0.18 //x=19.38 //y=0.9 //x2=19.16 //y2=0.9
r310 (  91 118 ) resistor r=58.7805 //w=0.246 //l=0.373497 //layer=ply \
 //thickness=0.18 //x=19.005 //y=2.095 //x2=19.305 //y2=2.26
r311 (  90 116 ) resistor r=39.5823 //w=0.21 //l=0.173853 //layer=ply \
 //thickness=0.18 //x=19.005 //y=1.71 //x2=19.045 //y2=1.555
r312 (  90 91 ) resistor r=197.415 //w=0.094 //l=0.385 //layer=ply \
 //thickness=0.18 //x=19.005 //y=1.71 //x2=19.005 //y2=2.095
r313 (  89 116 ) resistor r=39.5823 //w=0.21 //l=0.173853 //layer=ply \
 //thickness=0.18 //x=19.005 //y=1.4 //x2=19.045 //y2=1.555
r314 (  88 115 ) resistor r=45.1352 //w=0.168 //l=0.173853 //layer=ply \
 //thickness=0.18 //x=19.005 //y=1.055 //x2=19.045 //y2=0.9
r315 (  88 89 ) resistor r=176.904 //w=0.094 //l=0.345 //layer=ply \
 //thickness=0.18 //x=19.005 //y=1.055 //x2=19.005 //y2=1.4
r316 (  83 85 ) resistor r=26.9307 //w=0.15 //l=0.106066 //layer=ply \
 //thickness=0.18 //x=6.92 //y=4.97 //x2=6.995 //y2=5.045
r317 (  83 84 ) resistor r=148.702 //w=0.094 //l=0.29 //layer=ply \
 //thickness=0.18 //x=6.92 //y=4.97 //x2=6.63 //y2=4.97
r318 (  82 114 ) resistor r=45.1352 //w=0.168 //l=0.173853 //layer=ply \
 //thickness=0.18 //x=6.585 //y=1.4 //x2=6.545 //y2=1.555
r319 (  81 113 ) resistor r=45.1352 //w=0.168 //l=0.173853 //layer=ply \
 //thickness=0.18 //x=6.585 //y=1.055 //x2=6.545 //y2=0.9
r320 (  81 82 ) resistor r=176.904 //w=0.094 //l=0.345 //layer=ply \
 //thickness=0.18 //x=6.585 //y=1.055 //x2=6.585 //y2=1.4
r321 (  78 84 ) resistor r=22.7971 //w=0.269 //l=0.106066 //layer=ply \
 //thickness=0.18 //x=6.555 //y=5.045 //x2=6.63 //y2=4.97
r322 (  78 112 ) resistor r=35.8364 //w=0.269 //l=0.270185 //layer=ply \
 //thickness=0.18 //x=6.555 //y=5.045 //x2=6.355 //y2=4.88
r323 (  76 108 ) resistor r=10.701 //w=0.21 //l=0.115 //layer=ply \
 //thickness=0.18 //x=6.21 //y=1.555 //x2=6.095 //y2=1.555
r324 (  75 114 ) resistor r=5.52526 //w=0.168 //l=0.115 //layer=ply \
 //thickness=0.18 //x=6.43 //y=1.555 //x2=6.545 //y2=1.555
r325 (  74 107 ) resistor r=5.52526 //w=0.168 //l=0.115 //layer=ply \
 //thickness=0.18 //x=6.21 //y=0.9 //x2=6.095 //y2=0.9
r326 (  73 113 ) resistor r=5.52526 //w=0.168 //l=0.115 //layer=ply \
 //thickness=0.18 //x=6.43 //y=0.9 //x2=6.545 //y2=0.9
r327 (  73 74 ) resistor r=112.809 //w=0.094 //l=0.22 //layer=ply \
 //thickness=0.18 //x=6.43 //y=0.9 //x2=6.21 //y2=0.9
r328 (  72 110 ) resistor r=58.7805 //w=0.246 //l=0.373497 //layer=ply \
 //thickness=0.18 //x=6.055 //y=2.095 //x2=6.355 //y2=2.26
r329 (  71 108 ) resistor r=39.5823 //w=0.21 //l=0.173853 //layer=ply \
 //thickness=0.18 //x=6.055 //y=1.71 //x2=6.095 //y2=1.555
r330 (  71 72 ) resistor r=197.415 //w=0.094 //l=0.385 //layer=ply \
 //thickness=0.18 //x=6.055 //y=1.71 //x2=6.055 //y2=2.095
r331 (  70 108 ) resistor r=39.5823 //w=0.21 //l=0.173853 //layer=ply \
 //thickness=0.18 //x=6.055 //y=1.4 //x2=6.095 //y2=1.555
r332 (  69 107 ) resistor r=45.1352 //w=0.168 //l=0.173853 //layer=ply \
 //thickness=0.18 //x=6.055 //y=1.055 //x2=6.095 //y2=0.9
r333 (  69 70 ) resistor r=176.904 //w=0.094 //l=0.345 //layer=ply \
 //thickness=0.18 //x=6.055 //y=1.055 //x2=6.055 //y2=1.4
r334 (  68 104 ) resistor r=592.245 //w=0.094 //l=1.155 //layer=ply \
 //thickness=0.18 //x=19.945 //y=6.2 //x2=19.945 //y2=5.045
r335 (  67 97 ) resistor r=592.245 //w=0.094 //l=1.155 //layer=ply \
 //thickness=0.18 //x=19.505 //y=6.2 //x2=19.505 //y2=5.045
r336 (  66 85 ) resistor r=592.245 //w=0.094 //l=1.155 //layer=ply \
 //thickness=0.18 //x=6.995 //y=6.2 //x2=6.995 //y2=5.045
r337 (  65 78 ) resistor r=592.245 //w=0.094 //l=1.155 //layer=ply \
 //thickness=0.18 //x=6.555 //y=6.2 //x2=6.555 //y2=5.045
r338 (  64 94 ) resistor r=56.4043 //w=0.094 //l=0.11 //layer=ply \
 //thickness=0.18 //x=19.27 //y=1.555 //x2=19.38 //y2=1.555
r339 (  64 95 ) resistor r=56.4043 //w=0.094 //l=0.11 //layer=ply \
 //thickness=0.18 //x=19.27 //y=1.555 //x2=19.16 //y2=1.555
r340 (  63 75 ) resistor r=56.4043 //w=0.094 //l=0.11 //layer=ply \
 //thickness=0.18 //x=6.32 //y=1.555 //x2=6.43 //y2=1.555
r341 (  63 76 ) resistor r=56.4043 //w=0.094 //l=0.11 //layer=ply \
 //thickness=0.18 //x=6.32 //y=1.555 //x2=6.21 //y2=1.555
r342 (  59 120 ) resistor r=152 //w=0.17 //l=0.17 //layer=licon //count=1 \
 //x=19.305 //y=4.88 //x2=19.305 //y2=4.88
r343 (  57 59 ) resistor r=68.4492 //w=0.187 //l=1 //layer=li //thickness=0.1 \
 //x=19.305 //y=3.88 //x2=19.305 //y2=4.88
r344 (  54 118 ) resistor r=152 //w=0.17 //l=0.17 //layer=licon //count=1 \
 //x=19.305 //y=2.26 //x2=19.305 //y2=2.26
r345 (  54 57 ) resistor r=110.888 //w=0.187 //l=1.62 //layer=li \
 //thickness=0.1 //x=19.305 //y=2.26 //x2=19.305 //y2=3.88
r346 (  51 112 ) resistor r=152 //w=0.17 //l=0.17 //layer=licon //count=1 \
 //x=6.355 //y=4.88 //x2=6.355 //y2=4.88
r347 (  49 51 ) resistor r=68.4492 //w=0.187 //l=1 //layer=li //thickness=0.1 \
 //x=6.355 //y=3.88 //x2=6.355 //y2=4.88
r348 (  46 110 ) resistor r=152 //w=0.17 //l=0.17 //layer=licon //count=1 \
 //x=6.355 //y=2.26 //x2=6.355 //y2=2.26
r349 (  46 49 ) resistor r=110.888 //w=0.187 //l=1.62 //layer=li \
 //thickness=0.1 //x=6.355 //y=2.26 //x2=6.355 //y2=3.88
r350 (  42 44 ) resistor r=93.7754 //w=0.187 //l=1.37 //layer=li \
 //thickness=0.1 //x=4.505 //y=5.25 //x2=4.505 //y2=3.88
r351 (  41 44 ) resistor r=133.476 //w=0.187 //l=1.95 //layer=li \
 //thickness=0.1 //x=4.505 //y=1.93 //x2=4.505 //y2=3.88
r352 (  39 41 ) resistor r=7.15173 //w=0.17 //l=0.120208 //layer=li \
 //thickness=0.1 //x=4.42 //y=1.845 //x2=4.505 //y2=1.93
r353 (  39 40 ) resistor r=21.5615 //w=0.187 //l=0.315 //layer=li \
 //thickness=0.1 //x=4.42 //y=1.845 //x2=4.105 //y2=1.845
r354 (  35 40 ) resistor r=7.15173 //w=0.17 //l=0.120208 //layer=li \
 //thickness=0.1 //x=4.02 //y=1.76 //x2=4.105 //y2=1.845
r355 (  35 123 ) resistor r=39.016 //w=0.187 //l=0.57 //layer=li \
 //thickness=0.1 //x=4.02 //y=1.76 //x2=4.02 //y2=1.19
r356 (  34 62 ) resistor r=5.4201 //w=0.17 //l=0.085 //layer=li \
 //thickness=0.1 //x=3.81 //y=5.335 //x2=3.725 //y2=5.335
r357 (  33 42 ) resistor r=7.15173 //w=0.17 //l=0.120208 //layer=li \
 //thickness=0.1 //x=4.42 //y=5.335 //x2=4.505 //y2=5.25
r358 (  33 34 ) resistor r=41.754 //w=0.187 //l=0.61 //layer=li \
 //thickness=0.1 //x=4.42 //y=5.335 //x2=3.81 //y2=5.335
r359 (  27 62 ) resistor r=1.40859 //w=0.34 //l=0.085 //layer=li \
 //thickness=0.1 //x=3.725 //y=5.42 //x2=3.725 //y2=5.335
r360 (  27 127 ) resistor r=33.1979 //w=0.187 //l=0.485 //layer=li \
 //thickness=0.1 //x=3.725 //y=5.42 //x2=3.725 //y2=5.905
r361 (  26 61 ) resistor r=5.4201 //w=0.17 //l=0.085 //layer=li \
 //thickness=0.1 //x=2.93 //y=5.335 //x2=2.845 //y2=5.335
r362 (  25 62 ) resistor r=5.4201 //w=0.17 //l=0.085 //layer=li \
 //thickness=0.1 //x=3.64 //y=5.335 //x2=3.725 //y2=5.335
r363 (  25 26 ) resistor r=48.5989 //w=0.187 //l=0.71 //layer=li \
 //thickness=0.1 //x=3.64 //y=5.335 //x2=2.93 //y2=5.335
r364 (  19 61 ) resistor r=1.40859 //w=0.34 //l=0.085 //layer=li \
 //thickness=0.1 //x=2.845 //y=5.42 //x2=2.845 //y2=5.335
r365 (  19 126 ) resistor r=33.1979 //w=0.187 //l=0.485 //layer=li \
 //thickness=0.1 //x=2.845 //y=5.42 //x2=2.845 //y2=5.905
r366 (  17 61 ) resistor r=5.4201 //w=0.17 //l=0.085 //layer=li \
 //thickness=0.1 //x=2.76 //y=5.335 //x2=2.845 //y2=5.335
r367 (  17 18 ) resistor r=48.5989 //w=0.187 //l=0.71 //layer=li \
 //thickness=0.1 //x=2.76 //y=5.335 //x2=2.05 //y2=5.335
r368 (  11 18 ) resistor r=7.15173 //w=0.17 //l=0.120208 //layer=li \
 //thickness=0.1 //x=1.965 //y=5.42 //x2=2.05 //y2=5.335
r369 (  11 125 ) resistor r=33.1979 //w=0.187 //l=0.485 //layer=li \
 //thickness=0.1 //x=1.965 //y=5.42 //x2=1.965 //y2=5.905
r370 (  10 57 ) resistor r=9.3 //w=0.17 //l=0.17 //layer=mcon //count=1 \
 //x=19.305 //y=3.88 //x2=19.305 //y2=3.88
r371 (  8 49 ) resistor r=9.3 //w=0.17 //l=0.17 //layer=mcon //count=1 \
 //x=6.355 //y=3.88 //x2=6.355 //y2=3.88
r372 (  6 44 ) resistor r=9.3 //w=0.17 //l=0.17 //layer=mcon //count=1 \
 //x=4.505 //y=3.88 //x2=4.505 //y2=3.88
r373 (  4 8 ) resistor r=0.0880901 //w=0.191 //l=0.115 //layer=m1 \
 //thickness=0.36 //x=6.47 //y=3.88 //x2=6.355 //y2=3.88
r374 (  3 10 ) resistor r=0.0717383 //w=0.224 //l=0.115 //layer=m1 \
 //thickness=0.36 //x=19.19 //y=3.88 //x2=19.305 //y2=3.88
r375 (  3 4 ) resistor r=12.1374 //w=0.131 //l=12.72 //layer=m1 \
 //thickness=0.36 //x=19.19 //y=3.88 //x2=6.47 //y2=3.88
r376 (  2 6 ) resistor r=0.0717383 //w=0.224 //l=0.115 //layer=m1 \
 //thickness=0.36 //x=4.62 //y=3.88 //x2=4.505 //y2=3.88
r377 (  1 8 ) resistor r=0.0880901 //w=0.191 //l=0.115 //layer=m1 \
 //thickness=0.36 //x=6.24 //y=3.88 //x2=6.355 //y2=3.88
r378 (  1 2 ) resistor r=1.5458 //w=0.131 //l=1.62 //layer=m1 //thickness=0.36 \
 //x=6.24 //y=3.88 //x2=4.62 //y2=3.88
ends PM_DFFRNQNX1\%noxref_6

subckt PM_DFFRNQNX1\%RN ( 1 2 3 4 11 12 13 14 15 16 17 18 19 20 21 22 23 24 25 \
 31 33 43 45 57 60 63 70 73 76 79 86 89 92 95 98 104 105 106 107 108 109 110 \
 111 112 116 117 118 123 125 128 129 133 134 135 140 142 145 146 147 148 149 \
 151 157 158 159 160 161 167 168 173 177 178 183 189 )
c329 ( 189 0 ) capacitor c=0.0333776f //x=20.415 //y=4.88
c330 ( 183 0 ) capacitor c=0.0591013f //x=16.715 //y=4.88
c331 ( 178 0 ) capacitor c=0.0273931f //x=16.715 //y=2.095
c332 ( 177 0 ) capacitor c=0.045007f //x=16.715 //y=2.26
c333 ( 173 0 ) capacitor c=0.0587755f //x=8.575 //y=4.88
c334 ( 168 0 ) capacitor c=0.0273931f //x=8.575 //y=2.095
c335 ( 167 0 ) capacitor c=0.0451854f //x=8.575 //y=2.26
c336 ( 161 0 ) capacitor c=0.0246513f //x=20.75 //y=4.97
c337 ( 160 0 ) capacitor c=0.0826449f //x=20.505 //y=2.095
c338 ( 159 0 ) capacitor c=0.0170266f //x=20.505 //y=1.63
c339 ( 158 0 ) capacitor c=0.018609f //x=20.505 //y=1.4
c340 ( 157 0 ) capacitor c=0.0187309f //x=20.505 //y=1.09
c341 ( 151 0 ) capacitor c=0.014725f //x=20.35 //y=1.555
c342 ( 149 0 ) capacitor c=0.0146567f //x=20.35 //y=0.935
c343 ( 148 0 ) capacitor c=0.0335408f //x=19.98 //y=1.4
c344 ( 147 0 ) capacitor c=0.0173761f //x=19.98 //y=1.09
c345 ( 146 0 ) capacitor c=0.0432517f //x=17.235 //y=1.44
c346 ( 145 0 ) capacitor c=0.0200379f //x=17.235 //y=1.095
c347 ( 142 0 ) capacitor c=0.0148873f //x=17.08 //y=1.595
c348 ( 140 0 ) capacitor c=0.0157803f //x=17.08 //y=0.94
c349 ( 135 0 ) capacitor c=0.0218028f //x=16.705 //y=1.75
c350 ( 134 0 ) capacitor c=0.0207459f //x=16.705 //y=1.44
c351 ( 133 0 ) capacitor c=0.0194308f //x=16.705 //y=1.095
c352 ( 129 0 ) capacitor c=0.0432517f //x=9.095 //y=1.44
c353 ( 128 0 ) capacitor c=0.0200379f //x=9.095 //y=1.095
c354 ( 125 0 ) capacitor c=0.0148873f //x=8.94 //y=1.595
c355 ( 123 0 ) capacitor c=0.0157803f //x=8.94 //y=0.94
c356 ( 118 0 ) capacitor c=0.0218028f //x=8.565 //y=1.75
c357 ( 117 0 ) capacitor c=0.0207459f //x=8.565 //y=1.44
c358 ( 116 0 ) capacitor c=0.0194308f //x=8.565 //y=1.095
c359 ( 112 0 ) capacitor c=0.110114f //x=20.825 //y=6.2
c360 ( 111 0 ) capacitor c=0.11012f //x=20.385 //y=6.2
c361 ( 110 0 ) capacitor c=0.158794f //x=16.895 //y=6.2
c362 ( 109 0 ) capacitor c=0.110114f //x=16.455 //y=6.2
c363 ( 108 0 ) capacitor c=0.158794f //x=8.755 //y=6.2
c364 ( 107 0 ) capacitor c=0.110114f //x=8.315 //y=6.2
c365 ( 98 0 ) capacitor c=0.021673f //x=20.442 //y=4.535
c366 ( 95 0 ) capacitor c=0.00830308f //x=20.442 //y=3.795
c367 ( 92 0 ) capacitor c=0.00869458f //x=20.442 //y=3.425
c368 ( 89 0 ) capacitor c=0.008743f //x=20.442 //y=3.055
c369 ( 86 0 ) capacitor c=0.00736593f //x=20.442 //y=2.685
c370 ( 79 0 ) capacitor c=0.0315911f //x=16.742 //y=4.535
c371 ( 76 0 ) capacitor c=0.00783245f //x=16.742 //y=3.425
c372 ( 73 0 ) capacitor c=0.00790488f //x=16.742 //y=3.055
c373 ( 70 0 ) capacitor c=0.0065904f //x=16.742 //y=2.685
c374 ( 63 0 ) capacitor c=0.00790488f //x=8.602 //y=3.055
c375 ( 60 0 ) capacitor c=0.0065904f //x=8.602 //y=2.685
c376 ( 57 0 ) capacitor c=0.00520319f //x=20.415 //y=4.88
c377 ( 45 0 ) capacitor c=0.00589947f //x=20.415 //y=2.485
c378 ( 43 0 ) capacitor c=0.00487542f //x=16.715 //y=4.88
c379 ( 33 0 ) capacitor c=0.00556841f //x=16.715 //y=2.485
c380 ( 31 0 ) capacitor c=0.052045f //x=8.575 //y=4.88
c381 ( 25 0 ) capacitor c=0.00565956f //x=8.575 //y=2.485
c382 ( 24 0 ) capacitor c=0.00735667f //x=20.47 //y=4.62
c383 ( 23 0 ) capacitor c=0.00736127f //x=20.47 //y=3.88
c384 ( 22 0 ) capacitor c=0.00798743f //x=20.47 //y=3.51
c385 ( 21 0 ) capacitor c=0.00838782f //x=20.47 //y=3.14
c386 ( 20 0 ) capacitor c=0.00833482f //x=20.47 //y=2.77
c387 ( 18 0 ) capacitor c=0.005839f //x=16.77 //y=4.62
c388 ( 17 0 ) capacitor c=0.0079939f //x=16.77 //y=3.51
c389 ( 16 0 ) capacitor c=0.0075287f //x=16.77 //y=3.14
c390 ( 15 0 ) capacitor c=0.00753048f //x=16.77 //y=2.77
c391 ( 13 0 ) capacitor c=0.00818692f //x=8.63 //y=3.14
c392 ( 12 0 ) capacitor c=0.0077179f //x=8.63 //y=2.77
c393 ( 4 0 ) capacitor c=0.00675464f //x=16.83 //y=2.4
c394 ( 3 0 ) capacitor c=0.111786f //x=20.3 //y=2.4
c395 ( 2 0 ) capacitor c=0.0161417f //x=8.69 //y=2.4
c396 ( 1 0 ) capacitor c=0.208691f //x=16.6 //y=2.4
r397 (  191 192 ) resistor r=32.4568 //w=0.214 //l=0.075 //layer=ply \
 //thickness=0.18 //x=20.415 //y=4.97 //x2=20.415 //y2=5.045
r398 (  189 191 ) resistor r=20.271 //w=0.214 //l=0.09 //layer=ply \
 //thickness=0.18 //x=20.415 //y=4.88 //x2=20.415 //y2=4.97
r399 (  177 178 ) resistor r=52.7279 //w=0.214 //l=0.165 //layer=ply \
 //thickness=0.18 //x=16.715 //y=2.26 //x2=16.715 //y2=2.095
r400 (  167 168 ) resistor r=52.7279 //w=0.214 //l=0.165 //layer=ply \
 //thickness=0.18 //x=8.575 //y=2.26 //x2=8.575 //y2=2.095
r401 (  162 191 ) resistor r=16.5046 //w=0.27 //l=0.135 //layer=ply \
 //thickness=0.18 //x=20.55 //y=4.97 //x2=20.415 //y2=4.97
r402 (  161 163 ) resistor r=26.9307 //w=0.15 //l=0.106066 //layer=ply \
 //thickness=0.18 //x=20.75 //y=4.97 //x2=20.825 //y2=5.045
r403 (  161 162 ) resistor r=102.553 //w=0.094 //l=0.2 //layer=ply \
 //thickness=0.18 //x=20.75 //y=4.97 //x2=20.55 //y2=4.97
r404 (  160 196 ) resistor r=38.6777 //w=0.284 //l=0.198997 //layer=ply \
 //thickness=0.18 //x=20.505 //y=2.095 //x2=20.43 //y2=2.26
r405 (  159 194 ) resistor r=21.2976 //w=0.217 //l=0.0928709 //layer=ply \
 //thickness=0.18 //x=20.505 //y=1.63 //x2=20.465 //y2=1.555
r406 (  159 160 ) resistor r=238.436 //w=0.094 //l=0.465 //layer=ply \
 //thickness=0.18 //x=20.505 //y=1.63 //x2=20.505 //y2=2.095
r407 (  158 194 ) resistor r=39.0671 //w=0.217 //l=0.173853 //layer=ply \
 //thickness=0.18 //x=20.505 //y=1.4 //x2=20.465 //y2=1.555
r408 (  157 193 ) resistor r=45.1352 //w=0.168 //l=0.173853 //layer=ply \
 //thickness=0.18 //x=20.505 //y=1.09 //x2=20.465 //y2=0.935
r409 (  157 158 ) resistor r=158.957 //w=0.094 //l=0.31 //layer=ply \
 //thickness=0.18 //x=20.505 //y=1.09 //x2=20.505 //y2=1.4
r410 (  152 187 ) resistor r=5.52526 //w=0.168 //l=0.115 //layer=ply \
 //thickness=0.18 //x=20.135 //y=1.555 //x2=20.02 //y2=1.555
r411 (  151 194 ) resistor r=11.4558 //w=0.217 //l=0.115 //layer=ply \
 //thickness=0.18 //x=20.35 //y=1.555 //x2=20.465 //y2=1.555
r412 (  150 186 ) resistor r=5.52526 //w=0.168 //l=0.115 //layer=ply \
 //thickness=0.18 //x=20.135 //y=0.935 //x2=20.02 //y2=0.935
r413 (  149 193 ) resistor r=5.52526 //w=0.168 //l=0.115 //layer=ply \
 //thickness=0.18 //x=20.35 //y=0.935 //x2=20.465 //y2=0.935
r414 (  149 150 ) resistor r=110.245 //w=0.094 //l=0.215 //layer=ply \
 //thickness=0.18 //x=20.35 //y=0.935 //x2=20.135 //y2=0.935
r415 (  148 187 ) resistor r=45.1352 //w=0.168 //l=0.173853 //layer=ply \
 //thickness=0.18 //x=19.98 //y=1.4 //x2=20.02 //y2=1.555
r416 (  147 186 ) resistor r=45.1352 //w=0.168 //l=0.173853 //layer=ply \
 //thickness=0.18 //x=19.98 //y=1.09 //x2=20.02 //y2=0.935
r417 (  147 148 ) resistor r=158.957 //w=0.094 //l=0.31 //layer=ply \
 //thickness=0.18 //x=19.98 //y=1.09 //x2=19.98 //y2=1.4
r418 (  146 185 ) resistor r=45.1352 //w=0.168 //l=0.173853 //layer=ply \
 //thickness=0.18 //x=17.235 //y=1.44 //x2=17.195 //y2=1.595
r419 (  145 184 ) resistor r=45.1352 //w=0.168 //l=0.173853 //layer=ply \
 //thickness=0.18 //x=17.235 //y=1.095 //x2=17.195 //y2=0.94
r420 (  145 146 ) resistor r=176.904 //w=0.094 //l=0.345 //layer=ply \
 //thickness=0.18 //x=17.235 //y=1.095 //x2=17.235 //y2=1.44
r421 (  143 181 ) resistor r=10.701 //w=0.21 //l=0.115 //layer=ply \
 //thickness=0.18 //x=16.86 //y=1.595 //x2=16.745 //y2=1.595
r422 (  142 185 ) resistor r=5.52526 //w=0.168 //l=0.115 //layer=ply \
 //thickness=0.18 //x=17.08 //y=1.595 //x2=17.195 //y2=1.595
r423 (  141 180 ) resistor r=5.52526 //w=0.168 //l=0.115 //layer=ply \
 //thickness=0.18 //x=16.86 //y=0.94 //x2=16.745 //y2=0.94
r424 (  140 184 ) resistor r=5.52526 //w=0.168 //l=0.115 //layer=ply \
 //thickness=0.18 //x=17.08 //y=0.94 //x2=17.195 //y2=0.94
r425 (  140 141 ) resistor r=112.809 //w=0.094 //l=0.22 //layer=ply \
 //thickness=0.18 //x=17.08 //y=0.94 //x2=16.86 //y2=0.94
r426 (  137 183 ) resistor r=37.236 //w=0.233 //l=0.249199 //layer=ply \
 //thickness=0.18 //x=16.895 //y=5.045 //x2=16.715 //y2=4.88
r427 (  135 181 ) resistor r=39.5823 //w=0.21 //l=0.173853 //layer=ply \
 //thickness=0.18 //x=16.705 //y=1.75 //x2=16.745 //y2=1.595
r428 (  135 178 ) resistor r=176.904 //w=0.094 //l=0.345 //layer=ply \
 //thickness=0.18 //x=16.705 //y=1.75 //x2=16.705 //y2=2.095
r429 (  134 181 ) resistor r=39.5823 //w=0.21 //l=0.173853 //layer=ply \
 //thickness=0.18 //x=16.705 //y=1.44 //x2=16.745 //y2=1.595
r430 (  133 180 ) resistor r=45.1352 //w=0.168 //l=0.173853 //layer=ply \
 //thickness=0.18 //x=16.705 //y=1.095 //x2=16.745 //y2=0.94
r431 (  133 134 ) resistor r=176.904 //w=0.094 //l=0.345 //layer=ply \
 //thickness=0.18 //x=16.705 //y=1.095 //x2=16.705 //y2=1.44
r432 (  130 183 ) resistor r=53.7854 //w=0.233 //l=0.332415 //layer=ply \
 //thickness=0.18 //x=16.455 //y=5.045 //x2=16.715 //y2=4.88
r433 (  129 175 ) resistor r=45.1352 //w=0.168 //l=0.173853 //layer=ply \
 //thickness=0.18 //x=9.095 //y=1.44 //x2=9.055 //y2=1.595
r434 (  128 174 ) resistor r=45.1352 //w=0.168 //l=0.173853 //layer=ply \
 //thickness=0.18 //x=9.095 //y=1.095 //x2=9.055 //y2=0.94
r435 (  128 129 ) resistor r=176.904 //w=0.094 //l=0.345 //layer=ply \
 //thickness=0.18 //x=9.095 //y=1.095 //x2=9.095 //y2=1.44
r436 (  126 171 ) resistor r=10.701 //w=0.21 //l=0.115 //layer=ply \
 //thickness=0.18 //x=8.72 //y=1.595 //x2=8.605 //y2=1.595
r437 (  125 175 ) resistor r=5.52526 //w=0.168 //l=0.115 //layer=ply \
 //thickness=0.18 //x=8.94 //y=1.595 //x2=9.055 //y2=1.595
r438 (  124 170 ) resistor r=5.52526 //w=0.168 //l=0.115 //layer=ply \
 //thickness=0.18 //x=8.72 //y=0.94 //x2=8.605 //y2=0.94
r439 (  123 174 ) resistor r=5.52526 //w=0.168 //l=0.115 //layer=ply \
 //thickness=0.18 //x=8.94 //y=0.94 //x2=9.055 //y2=0.94
r440 (  123 124 ) resistor r=112.809 //w=0.094 //l=0.22 //layer=ply \
 //thickness=0.18 //x=8.94 //y=0.94 //x2=8.72 //y2=0.94
r441 (  120 173 ) resistor r=37.236 //w=0.233 //l=0.249199 //layer=ply \
 //thickness=0.18 //x=8.755 //y=5.045 //x2=8.575 //y2=4.88
r442 (  118 171 ) resistor r=39.5823 //w=0.21 //l=0.173853 //layer=ply \
 //thickness=0.18 //x=8.565 //y=1.75 //x2=8.605 //y2=1.595
r443 (  118 168 ) resistor r=176.904 //w=0.094 //l=0.345 //layer=ply \
 //thickness=0.18 //x=8.565 //y=1.75 //x2=8.565 //y2=2.095
r444 (  117 171 ) resistor r=39.5823 //w=0.21 //l=0.173853 //layer=ply \
 //thickness=0.18 //x=8.565 //y=1.44 //x2=8.605 //y2=1.595
r445 (  116 170 ) resistor r=45.1352 //w=0.168 //l=0.173853 //layer=ply \
 //thickness=0.18 //x=8.565 //y=1.095 //x2=8.605 //y2=0.94
r446 (  116 117 ) resistor r=176.904 //w=0.094 //l=0.345 //layer=ply \
 //thickness=0.18 //x=8.565 //y=1.095 //x2=8.565 //y2=1.44
r447 (  113 173 ) resistor r=53.7854 //w=0.233 //l=0.332415 //layer=ply \
 //thickness=0.18 //x=8.315 //y=5.045 //x2=8.575 //y2=4.88
r448 (  112 163 ) resistor r=592.245 //w=0.094 //l=1.155 //layer=ply \
 //thickness=0.18 //x=20.825 //y=6.2 //x2=20.825 //y2=5.045
r449 (  111 192 ) resistor r=592.245 //w=0.094 //l=1.155 //layer=ply \
 //thickness=0.18 //x=20.385 //y=6.2 //x2=20.385 //y2=5.045
r450 (  110 137 ) resistor r=592.245 //w=0.094 //l=1.155 //layer=ply \
 //thickness=0.18 //x=16.895 //y=6.2 //x2=16.895 //y2=5.045
r451 (  109 130 ) resistor r=592.245 //w=0.094 //l=1.155 //layer=ply \
 //thickness=0.18 //x=16.455 //y=6.2 //x2=16.455 //y2=5.045
r452 (  108 120 ) resistor r=592.245 //w=0.094 //l=1.155 //layer=ply \
 //thickness=0.18 //x=8.755 //y=6.2 //x2=8.755 //y2=5.045
r453 (  107 113 ) resistor r=592.245 //w=0.094 //l=1.155 //layer=ply \
 //thickness=0.18 //x=8.315 //y=6.2 //x2=8.315 //y2=5.045
r454 (  106 151 ) resistor r=55.3787 //w=0.094 //l=0.108 //layer=ply \
 //thickness=0.18 //x=20.242 //y=1.555 //x2=20.35 //y2=1.555
r455 (  106 152 ) resistor r=54.866 //w=0.094 //l=0.107 //layer=ply \
 //thickness=0.18 //x=20.242 //y=1.555 //x2=20.135 //y2=1.555
r456 (  105 142 ) resistor r=56.4043 //w=0.094 //l=0.11 //layer=ply \
 //thickness=0.18 //x=16.97 //y=1.595 //x2=17.08 //y2=1.595
r457 (  105 143 ) resistor r=56.4043 //w=0.094 //l=0.11 //layer=ply \
 //thickness=0.18 //x=16.97 //y=1.595 //x2=16.86 //y2=1.595
r458 (  104 125 ) resistor r=56.4043 //w=0.094 //l=0.11 //layer=ply \
 //thickness=0.18 //x=8.83 //y=1.595 //x2=8.94 //y2=1.595
r459 (  104 126 ) resistor r=56.4043 //w=0.094 //l=0.11 //layer=ply \
 //thickness=0.18 //x=8.83 //y=1.595 //x2=8.72 //y2=1.595
r460 (  101 196 ) resistor r=152 //w=0.17 //l=0.17 //layer=licon //count=1 \
 //x=20.415 //y=2.26 //x2=20.415 //y2=2.26
r461 (  96 98 ) resistor r=39.016 //w=0.187 //l=0.57 //layer=li \
 //thickness=0.1 //x=20.415 //y=3.965 //x2=20.415 //y2=4.535
r462 (  93 95 ) resistor r=13.6898 //w=0.187 //l=0.2 //layer=li \
 //thickness=0.1 //x=20.415 //y=3.595 //x2=20.415 //y2=3.795
r463 (  90 92 ) resistor r=13.6898 //w=0.187 //l=0.2 //layer=li \
 //thickness=0.1 //x=20.415 //y=3.225 //x2=20.415 //y2=3.425
r464 (  87 89 ) resistor r=13.6898 //w=0.187 //l=0.2 //layer=li \
 //thickness=0.1 //x=20.415 //y=2.855 //x2=20.415 //y2=3.055
r465 (  82 177 ) resistor r=152 //w=0.17 //l=0.17 //layer=licon //count=1 \
 //x=16.715 //y=2.26 //x2=16.715 //y2=2.26
r466 (  77 79 ) resistor r=64.3422 //w=0.187 //l=0.94 //layer=li \
 //thickness=0.1 //x=16.715 //y=3.595 //x2=16.715 //y2=4.535
r467 (  74 76 ) resistor r=13.6898 //w=0.187 //l=0.2 //layer=li \
 //thickness=0.1 //x=16.715 //y=3.225 //x2=16.715 //y2=3.425
r468 (  71 73 ) resistor r=13.6898 //w=0.187 //l=0.2 //layer=li \
 //thickness=0.1 //x=16.715 //y=2.855 //x2=16.715 //y2=3.055
r469 (  66 167 ) resistor r=152 //w=0.17 //l=0.17 //layer=licon //count=1 \
 //x=8.575 //y=2.26 //x2=8.575 //y2=2.26
r470 (  61 63 ) resistor r=13.6898 //w=0.187 //l=0.2 //layer=li \
 //thickness=0.1 //x=8.575 //y=2.855 //x2=8.575 //y2=3.055
r471 (  57 189 ) resistor r=152 //w=0.17 //l=0.17 //layer=licon //count=1 \
 //x=20.415 //y=4.88 //x2=20.415 //y2=4.88
r472 (  57 99 ) resistor r=11.9786 //w=0.187 //l=0.175 //layer=li \
 //thickness=0.1 //x=20.415 //y=4.88 //x2=20.415 //y2=4.705
r473 (  45 86 ) resistor r=13.6898 //w=0.187 //l=0.2 //layer=li \
 //thickness=0.1 //x=20.415 //y=2.485 //x2=20.415 //y2=2.685
r474 (  43 183 ) resistor r=152 //w=0.17 //l=0.17 //layer=licon //count=1 \
 //x=16.715 //y=4.88 //x2=16.715 //y2=4.88
r475 (  43 80 ) resistor r=11.9786 //w=0.187 //l=0.175 //layer=li \
 //thickness=0.1 //x=16.715 //y=4.88 //x2=16.715 //y2=4.705
r476 (  33 70 ) resistor r=13.6898 //w=0.187 //l=0.2 //layer=li \
 //thickness=0.1 //x=16.715 //y=2.485 //x2=16.715 //y2=2.685
r477 (  31 173 ) resistor r=152 //w=0.17 //l=0.17 //layer=licon //count=1 \
 //x=8.575 //y=4.88 //x2=8.575 //y2=4.88
r478 (  31 64 ) resistor r=113.283 //w=0.187 //l=1.655 //layer=li \
 //thickness=0.1 //x=8.575 //y=4.88 //x2=8.575 //y2=3.225
r479 (  25 60 ) resistor r=13.6898 //w=0.187 //l=0.2 //layer=li \
 //thickness=0.1 //x=8.575 //y=2.485 //x2=8.575 //y2=2.685
r480 (  24 99 ) resistor r=5.1957 //w=0.242 //l=0.085 //layer=li \
 //thickness=0.1 //x=20.442 //y=4.62 //x2=20.442 //y2=4.705
r481 (  24 98 ) resistor r=5.1957 //w=0.242 //l=0.085 //layer=li \
 //thickness=0.1 //x=20.442 //y=4.62 //x2=20.442 //y2=4.535
r482 (  23 96 ) resistor r=5.1957 //w=0.242 //l=0.085 //layer=li \
 //thickness=0.1 //x=20.442 //y=3.88 //x2=20.442 //y2=3.965
r483 (  23 95 ) resistor r=5.1957 //w=0.242 //l=0.085 //layer=li \
 //thickness=0.1 //x=20.442 //y=3.88 //x2=20.442 //y2=3.795
r484 (  22 93 ) resistor r=5.1957 //w=0.242 //l=0.085 //layer=li \
 //thickness=0.1 //x=20.442 //y=3.51 //x2=20.442 //y2=3.595
r485 (  22 92 ) resistor r=5.1957 //w=0.242 //l=0.085 //layer=li \
 //thickness=0.1 //x=20.442 //y=3.51 //x2=20.442 //y2=3.425
r486 (  21 90 ) resistor r=5.1957 //w=0.242 //l=0.085 //layer=li \
 //thickness=0.1 //x=20.442 //y=3.14 //x2=20.442 //y2=3.225
r487 (  21 89 ) resistor r=5.1957 //w=0.242 //l=0.085 //layer=li \
 //thickness=0.1 //x=20.442 //y=3.14 //x2=20.442 //y2=3.055
r488 (  20 87 ) resistor r=5.1957 //w=0.242 //l=0.085 //layer=li \
 //thickness=0.1 //x=20.442 //y=2.77 //x2=20.442 //y2=2.855
r489 (  20 86 ) resistor r=5.1957 //w=0.242 //l=0.085 //layer=li \
 //thickness=0.1 //x=20.442 //y=2.77 //x2=20.442 //y2=2.685
r490 (  19 45 ) resistor r=5.83724 //w=0.194 //l=0.0975705 //layer=li \
 //thickness=0.1 //x=20.442 //y=2.4 //x2=20.415 //y2=2.485
r491 (  19 101 ) resistor r=9.23711 //w=0.194 //l=0.14 //layer=li \
 //thickness=0.1 //x=20.442 //y=2.4 //x2=20.442 //y2=2.26
r492 (  18 80 ) resistor r=5.1957 //w=0.242 //l=0.085 //layer=li \
 //thickness=0.1 //x=16.742 //y=4.62 //x2=16.742 //y2=4.705
r493 (  18 79 ) resistor r=5.1957 //w=0.242 //l=0.085 //layer=li \
 //thickness=0.1 //x=16.742 //y=4.62 //x2=16.742 //y2=4.535
r494 (  17 77 ) resistor r=5.1957 //w=0.242 //l=0.085 //layer=li \
 //thickness=0.1 //x=16.742 //y=3.51 //x2=16.742 //y2=3.595
r495 (  17 76 ) resistor r=5.1957 //w=0.242 //l=0.085 //layer=li \
 //thickness=0.1 //x=16.742 //y=3.51 //x2=16.742 //y2=3.425
r496 (  16 74 ) resistor r=5.1957 //w=0.242 //l=0.085 //layer=li \
 //thickness=0.1 //x=16.742 //y=3.14 //x2=16.742 //y2=3.225
r497 (  16 73 ) resistor r=5.1957 //w=0.242 //l=0.085 //layer=li \
 //thickness=0.1 //x=16.742 //y=3.14 //x2=16.742 //y2=3.055
r498 (  15 71 ) resistor r=5.1957 //w=0.242 //l=0.085 //layer=li \
 //thickness=0.1 //x=16.742 //y=2.77 //x2=16.742 //y2=2.855
r499 (  15 70 ) resistor r=5.1957 //w=0.242 //l=0.085 //layer=li \
 //thickness=0.1 //x=16.742 //y=2.77 //x2=16.742 //y2=2.685
r500 (  14 33 ) resistor r=5.83724 //w=0.194 //l=0.0975705 //layer=li \
 //thickness=0.1 //x=16.742 //y=2.4 //x2=16.715 //y2=2.485
r501 (  14 82 ) resistor r=9.23711 //w=0.194 //l=0.14 //layer=li \
 //thickness=0.1 //x=16.742 //y=2.4 //x2=16.742 //y2=2.26
r502 (  13 64 ) resistor r=5.1957 //w=0.242 //l=0.085 //layer=li \
 //thickness=0.1 //x=8.602 //y=3.14 //x2=8.602 //y2=3.225
r503 (  13 63 ) resistor r=5.1957 //w=0.242 //l=0.085 //layer=li \
 //thickness=0.1 //x=8.602 //y=3.14 //x2=8.602 //y2=3.055
r504 (  12 61 ) resistor r=5.1957 //w=0.242 //l=0.085 //layer=li \
 //thickness=0.1 //x=8.602 //y=2.77 //x2=8.602 //y2=2.855
r505 (  12 60 ) resistor r=5.1957 //w=0.242 //l=0.085 //layer=li \
 //thickness=0.1 //x=8.602 //y=2.77 //x2=8.602 //y2=2.685
r506 (  11 25 ) resistor r=5.83724 //w=0.194 //l=0.0975705 //layer=li \
 //thickness=0.1 //x=8.602 //y=2.4 //x2=8.575 //y2=2.485
r507 (  11 66 ) resistor r=9.23711 //w=0.194 //l=0.14 //layer=li \
 //thickness=0.1 //x=8.602 //y=2.4 //x2=8.602 //y2=2.26
r508 (  10 19 ) resistor r=9.3 //w=0.17 //l=0.17 //layer=mcon //count=1 \
 //x=20.415 //y=2.4 //x2=20.415 //y2=2.4
r509 (  8 14 ) resistor r=9.3 //w=0.17 //l=0.17 //layer=mcon //count=1 \
 //x=16.715 //y=2.4 //x2=16.715 //y2=2.4
r510 (  6 11 ) resistor r=9.3 //w=0.17 //l=0.17 //layer=mcon //count=1 \
 //x=8.575 //y=2.4 //x2=8.575 //y2=2.4
r511 (  4 8 ) resistor r=0.0880901 //w=0.191 //l=0.115 //layer=m1 \
 //thickness=0.36 //x=16.83 //y=2.4 //x2=16.715 //y2=2.4
r512 (  3 10 ) resistor r=0.0717383 //w=0.224 //l=0.115 //layer=m1 \
 //thickness=0.36 //x=20.3 //y=2.4 //x2=20.415 //y2=2.4
r513 (  3 4 ) resistor r=3.31107 //w=0.131 //l=3.47 //layer=m1 \
 //thickness=0.36 //x=20.3 //y=2.4 //x2=16.83 //y2=2.4
r514 (  2 6 ) resistor r=0.0717383 //w=0.224 //l=0.115 //layer=m1 \
 //thickness=0.36 //x=8.69 //y=2.4 //x2=8.575 //y2=2.4
r515 (  1 8 ) resistor r=0.0880901 //w=0.191 //l=0.115 //layer=m1 \
 //thickness=0.36 //x=16.6 //y=2.4 //x2=16.715 //y2=2.4
r516 (  1 2 ) resistor r=7.54771 //w=0.131 //l=7.91 //layer=m1 \
 //thickness=0.36 //x=16.6 //y=2.4 //x2=8.69 //y2=2.4
ends PM_DFFRNQNX1\%RN

subckt PM_DFFRNQNX1\%noxref_8 ( 4 7 11 12 13 17 18 19 24 26 29 30 32 33 38 )
c84 ( 38 0 ) capacitor c=0.059212f //x=21.525 //y=4.88
c85 ( 33 0 ) capacitor c=0.0273931f //x=21.525 //y=2.095
c86 ( 32 0 ) capacitor c=0.0470973f //x=21.525 //y=2.26
c87 ( 30 0 ) capacitor c=0.0432517f //x=22.045 //y=1.44
c88 ( 29 0 ) capacitor c=0.0200379f //x=22.045 //y=1.095
c89 ( 26 0 ) capacitor c=0.0158629f //x=21.89 //y=1.595
c90 ( 24 0 ) capacitor c=0.0157803f //x=21.89 //y=0.94
c91 ( 19 0 ) capacitor c=0.0218028f //x=21.515 //y=1.75
c92 ( 18 0 ) capacitor c=0.0207459f //x=21.515 //y=1.44
c93 ( 17 0 ) capacitor c=0.0194308f //x=21.515 //y=1.095
c94 ( 13 0 ) capacitor c=0.158794f //x=21.705 //y=6.2
c95 ( 12 0 ) capacitor c=0.110114f //x=21.265 //y=6.2
c96 ( 7 0 ) capacitor c=0.0162631f //x=21.525 //y=3.88
c97 ( 4 0 ) capacitor c=0.0905785f //x=21.525 //y=2.26
r98 (  32 33 ) resistor r=52.7279 //w=0.214 //l=0.165 //layer=ply \
 //thickness=0.18 //x=21.525 //y=2.26 //x2=21.525 //y2=2.095
r99 (  30 40 ) resistor r=45.1352 //w=0.168 //l=0.173853 //layer=ply \
 //thickness=0.18 //x=22.045 //y=1.44 //x2=22.005 //y2=1.595
r100 (  29 39 ) resistor r=45.1352 //w=0.168 //l=0.173853 //layer=ply \
 //thickness=0.18 //x=22.045 //y=1.095 //x2=22.005 //y2=0.94
r101 (  29 30 ) resistor r=176.904 //w=0.094 //l=0.345 //layer=ply \
 //thickness=0.18 //x=22.045 //y=1.095 //x2=22.045 //y2=1.44
r102 (  27 36 ) resistor r=10.701 //w=0.21 //l=0.115 //layer=ply \
 //thickness=0.18 //x=21.67 //y=1.595 //x2=21.555 //y2=1.595
r103 (  26 40 ) resistor r=5.52526 //w=0.168 //l=0.115 //layer=ply \
 //thickness=0.18 //x=21.89 //y=1.595 //x2=22.005 //y2=1.595
r104 (  25 35 ) resistor r=5.52526 //w=0.168 //l=0.115 //layer=ply \
 //thickness=0.18 //x=21.67 //y=0.94 //x2=21.555 //y2=0.94
r105 (  24 39 ) resistor r=5.52526 //w=0.168 //l=0.115 //layer=ply \
 //thickness=0.18 //x=21.89 //y=0.94 //x2=22.005 //y2=0.94
r106 (  24 25 ) resistor r=112.809 //w=0.094 //l=0.22 //layer=ply \
 //thickness=0.18 //x=21.89 //y=0.94 //x2=21.67 //y2=0.94
r107 (  21 38 ) resistor r=37.236 //w=0.233 //l=0.249199 //layer=ply \
 //thickness=0.18 //x=21.705 //y=5.045 //x2=21.525 //y2=4.88
r108 (  19 36 ) resistor r=39.5823 //w=0.21 //l=0.173853 //layer=ply \
 //thickness=0.18 //x=21.515 //y=1.75 //x2=21.555 //y2=1.595
r109 (  19 33 ) resistor r=176.904 //w=0.094 //l=0.345 //layer=ply \
 //thickness=0.18 //x=21.515 //y=1.75 //x2=21.515 //y2=2.095
r110 (  18 36 ) resistor r=39.5823 //w=0.21 //l=0.173853 //layer=ply \
 //thickness=0.18 //x=21.515 //y=1.44 //x2=21.555 //y2=1.595
r111 (  17 35 ) resistor r=45.1352 //w=0.168 //l=0.173853 //layer=ply \
 //thickness=0.18 //x=21.515 //y=1.095 //x2=21.555 //y2=0.94
r112 (  17 18 ) resistor r=176.904 //w=0.094 //l=0.345 //layer=ply \
 //thickness=0.18 //x=21.515 //y=1.095 //x2=21.515 //y2=1.44
r113 (  14 38 ) resistor r=53.7854 //w=0.233 //l=0.332415 //layer=ply \
 //thickness=0.18 //x=21.265 //y=5.045 //x2=21.525 //y2=4.88
r114 (  13 21 ) resistor r=592.245 //w=0.094 //l=1.155 //layer=ply \
 //thickness=0.18 //x=21.705 //y=6.2 //x2=21.705 //y2=5.045
r115 (  12 14 ) resistor r=592.245 //w=0.094 //l=1.155 //layer=ply \
 //thickness=0.18 //x=21.265 //y=6.2 //x2=21.265 //y2=5.045
r116 (  11 26 ) resistor r=56.4043 //w=0.094 //l=0.11 //layer=ply \
 //thickness=0.18 //x=21.78 //y=1.595 //x2=21.89 //y2=1.595
r117 (  11 27 ) resistor r=56.4043 //w=0.094 //l=0.11 //layer=ply \
 //thickness=0.18 //x=21.78 //y=1.595 //x2=21.67 //y2=1.595
r118 (  9 38 ) resistor r=152 //w=0.17 //l=0.17 //layer=licon //count=1 \
 //x=21.525 //y=4.88 //x2=21.525 //y2=4.88
r119 (  7 9 ) resistor r=68.4492 //w=0.187 //l=1 //layer=li //thickness=0.1 \
 //x=21.525 //y=3.88 //x2=21.525 //y2=4.88
r120 (  4 32 ) resistor r=152 //w=0.17 //l=0.17 //layer=licon //count=1 \
 //x=21.525 //y=2.26 //x2=21.525 //y2=2.26
r121 (  4 7 ) resistor r=110.888 //w=0.187 //l=1.62 //layer=li //thickness=0.1 \
 //x=21.525 //y=2.26 //x2=21.525 //y2=3.88
ends PM_DFFRNQNX1\%noxref_8

subckt PM_DFFRNQNX1\%QN ( 7 8 9 10 11 12 13 14 15 16 17 24 25 32 40 46 47 61 \
 62 72 74 75 77 80 83 90 93 96 99 103 106 111 112 113 114 115 116 117 121 123 \
 126 127 137 140 142 143 144 )
c197 ( 144 0 ) capacitor c=0.023087f //x=21.34 //y=5.2
c198 ( 143 0 ) capacitor c=0.023519f //x=20.46 //y=5.2
c199 ( 142 0 ) capacitor c=0.0224735f //x=19.58 //y=5.2
c200 ( 140 0 ) capacitor c=0.00872971f //x=21.59 //y=1.095
c201 ( 137 0 ) capacitor c=0.0590598f //x=24.115 //y=4.88
c202 ( 127 0 ) capacitor c=0.0318948f //x=24.45 //y=1.39
c203 ( 126 0 ) capacitor c=0.0187384f //x=24.45 //y=1.045
c204 ( 123 0 ) capacitor c=0.0141798f //x=24.295 //y=1.545
c205 ( 121 0 ) capacitor c=0.0149844f //x=24.295 //y=0.89
c206 ( 117 0 ) capacitor c=0.0845297f //x=23.92 //y=2.095
c207 ( 116 0 ) capacitor c=0.0229722f //x=23.92 //y=1.7
c208 ( 115 0 ) capacitor c=0.0234352f //x=23.92 //y=1.39
c209 ( 114 0 ) capacitor c=0.0199343f //x=23.92 //y=1.045
c210 ( 113 0 ) capacitor c=0.110275f //x=24.455 //y=6.2
c211 ( 112 0 ) capacitor c=0.154305f //x=24.015 //y=6.2
c212 ( 106 0 ) capacitor c=0.0339024f //x=24.142 //y=4.535
c213 ( 103 0 ) capacitor c=0.00847711f //x=24.142 //y=3.425
c214 ( 99 0 ) capacitor c=0.00861118f //x=24.142 //y=3.055
c215 ( 96 0 ) capacitor c=0.00680842f //x=24.142 //y=2.685
c216 ( 93 0 ) capacitor c=0.0050058f //x=22.292 //y=4.905
c217 ( 90 0 ) capacitor c=0.0330059f //x=22.292 //y=4.535
c218 ( 87 0 ) capacitor c=0.00883074f //x=22.292 //y=3.425
c219 ( 83 0 ) capacitor c=0.00870751f //x=22.292 //y=3.055
c220 ( 80 0 ) capacitor c=0.00664124f //x=22.292 //y=2.685
c221 ( 77 0 ) capacitor c=0.0108995f //x=22.292 //y=2.315
c222 ( 75 0 ) capacitor c=0.00116729f //x=21.485 //y=5.335
c223 ( 74 0 ) capacitor c=0.00195139f //x=20.605 //y=5.335
c224 ( 72 0 ) capacitor c=0.004519f //x=24.115 //y=4.88
c225 ( 62 0 ) capacitor c=0.00612685f //x=24.115 //y=2.485
c226 ( 61 0 ) capacitor c=0.00560512f //x=22.265 //y=5.25
c227 ( 47 0 ) capacitor c=0.00528754f //x=21.865 //y=1.845
c228 ( 46 0 ) capacitor c=0.015794f //x=22.18 //y=1.845
c229 ( 40 0 ) capacitor c=0.0293025f //x=22.18 //y=5.335
c230 ( 32 0 ) capacitor c=0.0184197f //x=21.4 //y=5.335
c231 ( 25 0 ) capacitor c=0.00351598f //x=19.81 //y=5.335
c232 ( 24 0 ) capacitor c=0.0153421f //x=20.52 //y=5.335
c233 ( 17 0 ) capacitor c=0.0063896f //x=24.17 //y=4.62
c234 ( 16 0 ) capacitor c=0.0579393f //x=24.17 //y=3.51
c235 ( 15 0 ) capacitor c=0.0084215f //x=24.17 //y=3.14
c236 ( 14 0 ) capacitor c=0.00728678f //x=24.17 //y=2.77
c237 ( 12 0 ) capacitor c=0.00658645f //x=22.32 //y=4.99
c238 ( 11 0 ) capacitor c=0.00735492f //x=22.32 //y=4.62
c239 ( 10 0 ) capacitor c=0.0239497f //x=22.32 //y=3.51
c240 ( 9 0 ) capacitor c=0.00893896f //x=22.32 //y=3.14
c241 ( 8 0 ) capacitor c=0.00683809f //x=22.32 //y=2.77
c242 ( 7 0 ) capacitor c=0.00653774f //x=22.32 //y=2.4
r243 (  135 137 ) resistor r=20.6867 //w=0.233 //l=0.1 //layer=ply \
 //thickness=0.18 //x=24.015 //y=4.88 //x2=24.115 //y2=4.88
r244 (  128 137 ) resistor r=70.3348 //w=0.233 //l=0.414367 //layer=ply \
 //thickness=0.18 //x=24.455 //y=5.045 //x2=24.115 //y2=4.88
r245 (  127 139 ) resistor r=45.1352 //w=0.168 //l=0.173853 //layer=ply \
 //thickness=0.18 //x=24.45 //y=1.39 //x2=24.41 //y2=1.545
r246 (  126 138 ) resistor r=45.1352 //w=0.168 //l=0.173853 //layer=ply \
 //thickness=0.18 //x=24.45 //y=1.045 //x2=24.41 //y2=0.89
r247 (  126 127 ) resistor r=176.904 //w=0.094 //l=0.345 //layer=ply \
 //thickness=0.18 //x=24.45 //y=1.045 //x2=24.45 //y2=1.39
r248 (  124 134 ) resistor r=10.701 //w=0.21 //l=0.115 //layer=ply \
 //thickness=0.18 //x=24.075 //y=1.545 //x2=23.96 //y2=1.545
r249 (  123 139 ) resistor r=5.52526 //w=0.168 //l=0.115 //layer=ply \
 //thickness=0.18 //x=24.295 //y=1.545 //x2=24.41 //y2=1.545
r250 (  122 133 ) resistor r=5.52526 //w=0.168 //l=0.115 //layer=ply \
 //thickness=0.18 //x=24.075 //y=0.89 //x2=23.96 //y2=0.89
r251 (  121 138 ) resistor r=5.52526 //w=0.168 //l=0.115 //layer=ply \
 //thickness=0.18 //x=24.295 //y=0.89 //x2=24.41 //y2=0.89
r252 (  121 122 ) resistor r=112.809 //w=0.094 //l=0.22 //layer=ply \
 //thickness=0.18 //x=24.295 //y=0.89 //x2=24.075 //y2=0.89
r253 (  118 135 ) resistor r=13.0941 //w=0.233 //l=0.165 //layer=ply \
 //thickness=0.18 //x=24.015 //y=5.045 //x2=24.015 //y2=4.88
r254 (  117 132 ) resistor r=34.8111 //w=0.27 //l=0.264953 //layer=ply \
 //thickness=0.18 //x=23.92 //y=2.095 //x2=24.115 //y2=2.26
r255 (  116 134 ) resistor r=39.5823 //w=0.21 //l=0.173853 //layer=ply \
 //thickness=0.18 //x=23.92 //y=1.7 //x2=23.96 //y2=1.545
r256 (  116 117 ) resistor r=202.543 //w=0.094 //l=0.395 //layer=ply \
 //thickness=0.18 //x=23.92 //y=1.7 //x2=23.92 //y2=2.095
r257 (  115 134 ) resistor r=39.5823 //w=0.21 //l=0.173853 //layer=ply \
 //thickness=0.18 //x=23.92 //y=1.39 //x2=23.96 //y2=1.545
r258 (  114 133 ) resistor r=45.1352 //w=0.168 //l=0.173853 //layer=ply \
 //thickness=0.18 //x=23.92 //y=1.045 //x2=23.96 //y2=0.89
r259 (  114 115 ) resistor r=176.904 //w=0.094 //l=0.345 //layer=ply \
 //thickness=0.18 //x=23.92 //y=1.045 //x2=23.92 //y2=1.39
r260 (  113 128 ) resistor r=592.245 //w=0.094 //l=1.155 //layer=ply \
 //thickness=0.18 //x=24.455 //y=6.2 //x2=24.455 //y2=5.045
r261 (  112 118 ) resistor r=592.245 //w=0.094 //l=1.155 //layer=ply \
 //thickness=0.18 //x=24.015 //y=6.2 //x2=24.015 //y2=5.045
r262 (  111 123 ) resistor r=56.4043 //w=0.094 //l=0.11 //layer=ply \
 //thickness=0.18 //x=24.185 //y=1.545 //x2=24.295 //y2=1.545
r263 (  111 124 ) resistor r=56.4043 //w=0.094 //l=0.11 //layer=ply \
 //thickness=0.18 //x=24.185 //y=1.545 //x2=24.075 //y2=1.545
r264 (  109 132 ) resistor r=152 //w=0.17 //l=0.17 //layer=licon //count=1 \
 //x=24.115 //y=2.26 //x2=24.115 //y2=2.26
r265 (  104 106 ) resistor r=64.3422 //w=0.187 //l=0.94 //layer=li \
 //thickness=0.1 //x=24.115 //y=3.595 //x2=24.115 //y2=4.535
r266 (  100 103 ) resistor r=13.6898 //w=0.187 //l=0.2 //layer=li \
 //thickness=0.1 //x=24.115 //y=3.225 //x2=24.115 //y2=3.425
r267 (  97 99 ) resistor r=13.6898 //w=0.187 //l=0.2 //layer=li \
 //thickness=0.1 //x=24.115 //y=2.855 //x2=24.115 //y2=3.055
r268 (  91 93 ) resistor r=13.6898 //w=0.187 //l=0.2 //layer=li \
 //thickness=0.1 //x=22.265 //y=4.705 //x2=22.265 //y2=4.905
r269 (  88 90 ) resistor r=64.3422 //w=0.187 //l=0.94 //layer=li \
 //thickness=0.1 //x=22.265 //y=3.595 //x2=22.265 //y2=4.535
r270 (  84 87 ) resistor r=13.6898 //w=0.187 //l=0.2 //layer=li \
 //thickness=0.1 //x=22.265 //y=3.225 //x2=22.265 //y2=3.425
r271 (  81 83 ) resistor r=13.6898 //w=0.187 //l=0.2 //layer=li \
 //thickness=0.1 //x=22.265 //y=2.855 //x2=22.265 //y2=3.055
r272 (  78 80 ) resistor r=13.6898 //w=0.187 //l=0.2 //layer=li \
 //thickness=0.1 //x=22.265 //y=2.485 //x2=22.265 //y2=2.685
r273 (  72 137 ) resistor r=152 //w=0.17 //l=0.17 //layer=licon //count=1 \
 //x=24.115 //y=4.88 //x2=24.115 //y2=4.88
r274 (  72 107 ) resistor r=11.9786 //w=0.187 //l=0.175 //layer=li \
 //thickness=0.1 //x=24.115 //y=4.88 //x2=24.115 //y2=4.705
r275 (  62 96 ) resistor r=13.6898 //w=0.187 //l=0.2 //layer=li \
 //thickness=0.1 //x=24.115 //y=2.485 //x2=24.115 //y2=2.685
r276 (  61 94 ) resistor r=11.9786 //w=0.187 //l=0.175 //layer=li \
 //thickness=0.1 //x=22.265 //y=5.25 //x2=22.265 //y2=5.075
r277 (  48 77 ) resistor r=26.3529 //w=0.187 //l=0.385 //layer=li \
 //thickness=0.1 //x=22.265 //y=1.93 //x2=22.265 //y2=2.315
r278 (  46 48 ) resistor r=7.15173 //w=0.17 //l=0.120208 //layer=li \
 //thickness=0.1 //x=22.18 //y=1.845 //x2=22.265 //y2=1.93
r279 (  46 47 ) resistor r=21.5615 //w=0.187 //l=0.315 //layer=li \
 //thickness=0.1 //x=22.18 //y=1.845 //x2=21.865 //y2=1.845
r280 (  42 47 ) resistor r=7.15173 //w=0.17 //l=0.120208 //layer=li \
 //thickness=0.1 //x=21.78 //y=1.76 //x2=21.865 //y2=1.845
r281 (  42 140 ) resistor r=39.016 //w=0.187 //l=0.57 //layer=li \
 //thickness=0.1 //x=21.78 //y=1.76 //x2=21.78 //y2=1.19
r282 (  41 75 ) resistor r=5.4201 //w=0.17 //l=0.085 //layer=li \
 //thickness=0.1 //x=21.57 //y=5.335 //x2=21.485 //y2=5.335
r283 (  40 61 ) resistor r=7.15173 //w=0.17 //l=0.120208 //layer=li \
 //thickness=0.1 //x=22.18 //y=5.335 //x2=22.265 //y2=5.25
r284 (  40 41 ) resistor r=41.754 //w=0.187 //l=0.61 //layer=li \
 //thickness=0.1 //x=22.18 //y=5.335 //x2=21.57 //y2=5.335
r285 (  34 75 ) resistor r=1.40859 //w=0.34 //l=0.085 //layer=li \
 //thickness=0.1 //x=21.485 //y=5.42 //x2=21.485 //y2=5.335
r286 (  34 144 ) resistor r=33.1979 //w=0.187 //l=0.485 //layer=li \
 //thickness=0.1 //x=21.485 //y=5.42 //x2=21.485 //y2=5.905
r287 (  33 74 ) resistor r=5.4201 //w=0.17 //l=0.085 //layer=li \
 //thickness=0.1 //x=20.69 //y=5.335 //x2=20.605 //y2=5.335
r288 (  32 75 ) resistor r=5.4201 //w=0.17 //l=0.085 //layer=li \
 //thickness=0.1 //x=21.4 //y=5.335 //x2=21.485 //y2=5.335
r289 (  32 33 ) resistor r=48.5989 //w=0.187 //l=0.71 //layer=li \
 //thickness=0.1 //x=21.4 //y=5.335 //x2=20.69 //y2=5.335
r290 (  26 74 ) resistor r=1.40859 //w=0.34 //l=0.085 //layer=li \
 //thickness=0.1 //x=20.605 //y=5.42 //x2=20.605 //y2=5.335
r291 (  26 143 ) resistor r=33.1979 //w=0.187 //l=0.485 //layer=li \
 //thickness=0.1 //x=20.605 //y=5.42 //x2=20.605 //y2=5.905
r292 (  24 74 ) resistor r=5.4201 //w=0.17 //l=0.085 //layer=li \
 //thickness=0.1 //x=20.52 //y=5.335 //x2=20.605 //y2=5.335
r293 (  24 25 ) resistor r=48.5989 //w=0.187 //l=0.71 //layer=li \
 //thickness=0.1 //x=20.52 //y=5.335 //x2=19.81 //y2=5.335
r294 (  18 25 ) resistor r=7.15173 //w=0.17 //l=0.120208 //layer=li \
 //thickness=0.1 //x=19.725 //y=5.42 //x2=19.81 //y2=5.335
r295 (  18 142 ) resistor r=33.1979 //w=0.187 //l=0.485 //layer=li \
 //thickness=0.1 //x=19.725 //y=5.42 //x2=19.725 //y2=5.905
r296 (  17 107 ) resistor r=5.1957 //w=0.242 //l=0.085 //layer=li \
 //thickness=0.1 //x=24.142 //y=4.62 //x2=24.142 //y2=4.705
r297 (  17 106 ) resistor r=5.1957 //w=0.242 //l=0.085 //layer=li \
 //thickness=0.1 //x=24.142 //y=4.62 //x2=24.142 //y2=4.535
r298 (  16 104 ) resistor r=5.1957 //w=0.242 //l=0.085 //layer=li \
 //thickness=0.1 //x=24.142 //y=3.51 //x2=24.142 //y2=3.595
r299 (  16 103 ) resistor r=5.1957 //w=0.242 //l=0.085 //layer=li \
 //thickness=0.1 //x=24.142 //y=3.51 //x2=24.142 //y2=3.425
r300 (  15 100 ) resistor r=5.1957 //w=0.242 //l=0.085 //layer=li \
 //thickness=0.1 //x=24.142 //y=3.14 //x2=24.142 //y2=3.225
r301 (  15 99 ) resistor r=5.1957 //w=0.242 //l=0.085 //layer=li \
 //thickness=0.1 //x=24.142 //y=3.14 //x2=24.142 //y2=3.055
r302 (  14 97 ) resistor r=5.1957 //w=0.242 //l=0.085 //layer=li \
 //thickness=0.1 //x=24.142 //y=2.77 //x2=24.142 //y2=2.855
r303 (  14 96 ) resistor r=5.1957 //w=0.242 //l=0.085 //layer=li \
 //thickness=0.1 //x=24.142 //y=2.77 //x2=24.142 //y2=2.685
r304 (  13 62 ) resistor r=5.83724 //w=0.194 //l=0.0975705 //layer=li \
 //thickness=0.1 //x=24.142 //y=2.4 //x2=24.115 //y2=2.485
r305 (  13 109 ) resistor r=9.23711 //w=0.194 //l=0.14 //layer=li \
 //thickness=0.1 //x=24.142 //y=2.4 //x2=24.142 //y2=2.26
r306 (  12 94 ) resistor r=5.1957 //w=0.242 //l=0.085 //layer=li \
 //thickness=0.1 //x=22.292 //y=4.99 //x2=22.292 //y2=5.075
r307 (  12 93 ) resistor r=5.1957 //w=0.242 //l=0.085 //layer=li \
 //thickness=0.1 //x=22.292 //y=4.99 //x2=22.292 //y2=4.905
r308 (  11 91 ) resistor r=5.1957 //w=0.242 //l=0.085 //layer=li \
 //thickness=0.1 //x=22.292 //y=4.62 //x2=22.292 //y2=4.705
r309 (  11 90 ) resistor r=5.1957 //w=0.242 //l=0.085 //layer=li \
 //thickness=0.1 //x=22.292 //y=4.62 //x2=22.292 //y2=4.535
r310 (  10 88 ) resistor r=5.1957 //w=0.242 //l=0.085 //layer=li \
 //thickness=0.1 //x=22.292 //y=3.51 //x2=22.292 //y2=3.595
r311 (  10 87 ) resistor r=5.1957 //w=0.242 //l=0.085 //layer=li \
 //thickness=0.1 //x=22.292 //y=3.51 //x2=22.292 //y2=3.425
r312 (  9 84 ) resistor r=5.1957 //w=0.242 //l=0.085 //layer=li \
 //thickness=0.1 //x=22.292 //y=3.14 //x2=22.292 //y2=3.225
r313 (  9 83 ) resistor r=5.1957 //w=0.242 //l=0.085 //layer=li \
 //thickness=0.1 //x=22.292 //y=3.14 //x2=22.292 //y2=3.055
r314 (  8 81 ) resistor r=5.1957 //w=0.242 //l=0.085 //layer=li \
 //thickness=0.1 //x=22.292 //y=2.77 //x2=22.292 //y2=2.855
r315 (  8 80 ) resistor r=5.1957 //w=0.242 //l=0.085 //layer=li \
 //thickness=0.1 //x=22.292 //y=2.77 //x2=22.292 //y2=2.685
r316 (  7 78 ) resistor r=5.1957 //w=0.242 //l=0.085 //layer=li \
 //thickness=0.1 //x=22.292 //y=2.4 //x2=22.292 //y2=2.485
r317 (  7 77 ) resistor r=5.1957 //w=0.242 //l=0.085 //layer=li \
 //thickness=0.1 //x=22.292 //y=2.4 //x2=22.292 //y2=2.315
ends PM_DFFRNQNX1\%QN

subckt PM_DFFRNQNX1\%noxref_10 ( 1 2 3 4 5 6 16 23 25 35 36 43 51 57 58 62 63 \
 65 71 72 75 76 77 78 79 80 81 82 83 84 85 86 87 88 90 96 97 98 99 103 104 105 \
 110 112 114 120 121 122 123 124 129 131 133 139 140 150 151 154 163 164 167 \
 175 177 178 179 )
c411 ( 179 0 ) capacitor c=0.023087f //x=16.53 //y=5.2
c412 ( 178 0 ) capacitor c=0.023519f //x=15.65 //y=5.2
c413 ( 177 0 ) capacitor c=0.0224735f //x=14.77 //y=5.2
c414 ( 175 0 ) capacitor c=0.00853354f //x=16.78 //y=1.095
c415 ( 167 0 ) capacitor c=0.0331844f //x=24.885 //y=4.88
c416 ( 164 0 ) capacitor c=0.0279499f //x=24.855 //y=2.095
c417 ( 163 0 ) capacitor c=0.0437152f //x=24.855 //y=2.26
c418 ( 154 0 ) capacitor c=0.0331095f //x=11.935 //y=4.88
c419 ( 151 0 ) capacitor c=0.0279499f //x=11.905 //y=2.095
c420 ( 150 0 ) capacitor c=0.0425269f //x=11.905 //y=2.26
c421 ( 140 0 ) capacitor c=0.0429696f //x=25.42 //y=1.43
c422 ( 139 0 ) capacitor c=0.0192208f //x=25.42 //y=1.085
c423 ( 133 0 ) capacitor c=0.0158629f //x=25.265 //y=1.585
c424 ( 131 0 ) capacitor c=0.0157803f //x=25.265 //y=0.93
c425 ( 129 0 ) capacitor c=0.0306375f //x=25.26 //y=4.97
c426 ( 124 0 ) capacitor c=0.0205163f //x=24.89 //y=1.74
c427 ( 123 0 ) capacitor c=0.0168481f //x=24.89 //y=1.43
c428 ( 122 0 ) capacitor c=0.0174783f //x=24.89 //y=1.085
c429 ( 121 0 ) capacitor c=0.0429696f //x=12.47 //y=1.43
c430 ( 120 0 ) capacitor c=0.0192208f //x=12.47 //y=1.085
c431 ( 114 0 ) capacitor c=0.0148884f //x=12.315 //y=1.585
c432 ( 112 0 ) capacitor c=0.0157803f //x=12.315 //y=0.93
c433 ( 110 0 ) capacitor c=0.0295235f //x=12.31 //y=4.97
c434 ( 105 0 ) capacitor c=0.0205163f //x=11.94 //y=1.74
c435 ( 104 0 ) capacitor c=0.0168481f //x=11.94 //y=1.43
c436 ( 103 0 ) capacitor c=0.0174783f //x=11.94 //y=1.085
c437 ( 99 0 ) capacitor c=0.0559896f //x=1.82 //y=4.97
c438 ( 98 0 ) capacitor c=0.0298189f //x=2.11 //y=4.97
c439 ( 97 0 ) capacitor c=0.0347816f //x=1.775 //y=1.4
c440 ( 96 0 ) capacitor c=0.0187487f //x=1.775 //y=1.055
c441 ( 90 0 ) capacitor c=0.0137055f //x=1.62 //y=1.555
c442 ( 88 0 ) capacitor c=0.0149861f //x=1.62 //y=0.9
c443 ( 87 0 ) capacitor c=0.102158f //x=1.245 //y=2.095
c444 ( 86 0 ) capacitor c=0.0229444f //x=1.245 //y=1.71
c445 ( 85 0 ) capacitor c=0.0234352f //x=1.245 //y=1.4
c446 ( 84 0 ) capacitor c=0.0198724f //x=1.245 //y=1.055
c447 ( 83 0 ) capacitor c=0.15358f //x=25.335 //y=6.2
c448 ( 82 0 ) capacitor c=0.110281f //x=24.895 //y=6.2
c449 ( 81 0 ) capacitor c=0.15358f //x=12.385 //y=6.2
c450 ( 80 0 ) capacitor c=0.110281f //x=11.945 //y=6.2
c451 ( 79 0 ) capacitor c=0.110114f //x=2.185 //y=6.2
c452 ( 78 0 ) capacitor c=0.158956f //x=1.745 //y=6.2
c453 ( 72 0 ) capacitor c=0.00116729f //x=16.675 //y=5.335
c454 ( 71 0 ) capacitor c=0.00192123f //x=15.795 //y=5.335
c455 ( 65 0 ) capacitor c=0.0764694f //x=24.855 //y=2.26
c456 ( 63 0 ) capacitor c=0.00453889f //x=24.855 //y=4.715
c457 ( 62 0 ) capacitor c=0.113065f //x=17.455 //y=4.25
c458 ( 58 0 ) capacitor c=0.00398962f //x=17.055 //y=1.845
c459 ( 57 0 ) capacitor c=0.0137288f //x=17.37 //y=1.845
c460 ( 51 0 ) capacitor c=0.0286907f //x=17.37 //y=5.335
c461 ( 43 0 ) capacitor c=0.0184197f //x=16.59 //y=5.335
c462 ( 36 0 ) capacitor c=0.00332903f //x=15 //y=5.335
c463 ( 35 0 ) capacitor c=0.0148447f //x=15.71 //y=5.335
c464 ( 25 0 ) capacitor c=0.0719943f //x=11.905 //y=2.26
c465 ( 23 0 ) capacitor c=0.00453889f //x=11.905 //y=4.715
c466 ( 16 0 ) capacitor c=0.12442f //x=1.545 //y=2.26
c467 ( 6 0 ) capacitor c=0.00720076f //x=17.57 //y=4.25
c468 ( 5 0 ) capacitor c=0.22651f //x=24.74 //y=4.25
c469 ( 4 0 ) capacitor c=0.00557292f //x=12.02 //y=4.25
c470 ( 3 0 ) capacitor c=0.0888461f //x=17.34 //y=4.25
c471 ( 2 0 ) capacitor c=0.0160831f //x=1.66 //y=4.25
c472 ( 1 0 ) capacitor c=0.182607f //x=11.79 //y=4.25
r473 (  169 170 ) resistor r=32.4568 //w=0.214 //l=0.075 //layer=ply \
 //thickness=0.18 //x=24.885 //y=4.97 //x2=24.885 //y2=5.045
r474 (  167 169 ) resistor r=20.271 //w=0.214 //l=0.09 //layer=ply \
 //thickness=0.18 //x=24.885 //y=4.88 //x2=24.885 //y2=4.97
r475 (  163 164 ) resistor r=52.7279 //w=0.214 //l=0.165 //layer=ply \
 //thickness=0.18 //x=24.855 //y=2.26 //x2=24.855 //y2=2.095
r476 (  156 157 ) resistor r=32.4568 //w=0.214 //l=0.075 //layer=ply \
 //thickness=0.18 //x=11.935 //y=4.97 //x2=11.935 //y2=5.045
r477 (  154 156 ) resistor r=20.271 //w=0.214 //l=0.09 //layer=ply \
 //thickness=0.18 //x=11.935 //y=4.88 //x2=11.935 //y2=4.97
r478 (  150 151 ) resistor r=52.7279 //w=0.214 //l=0.165 //layer=ply \
 //thickness=0.18 //x=11.905 //y=2.26 //x2=11.905 //y2=2.095
r479 (  140 174 ) resistor r=45.1352 //w=0.168 //l=0.173853 //layer=ply \
 //thickness=0.18 //x=25.42 //y=1.43 //x2=25.38 //y2=1.585
r480 (  139 173 ) resistor r=45.1352 //w=0.168 //l=0.173853 //layer=ply \
 //thickness=0.18 //x=25.42 //y=1.085 //x2=25.38 //y2=0.93
r481 (  139 140 ) resistor r=176.904 //w=0.094 //l=0.345 //layer=ply \
 //thickness=0.18 //x=25.42 //y=1.085 //x2=25.42 //y2=1.43
r482 (  134 172 ) resistor r=10.701 //w=0.21 //l=0.115 //layer=ply \
 //thickness=0.18 //x=25.045 //y=1.585 //x2=24.93 //y2=1.585
r483 (  133 174 ) resistor r=5.52526 //w=0.168 //l=0.115 //layer=ply \
 //thickness=0.18 //x=25.265 //y=1.585 //x2=25.38 //y2=1.585
r484 (  132 171 ) resistor r=5.52526 //w=0.168 //l=0.115 //layer=ply \
 //thickness=0.18 //x=25.045 //y=0.93 //x2=24.93 //y2=0.93
r485 (  131 173 ) resistor r=5.52526 //w=0.168 //l=0.115 //layer=ply \
 //thickness=0.18 //x=25.265 //y=0.93 //x2=25.38 //y2=0.93
r486 (  131 132 ) resistor r=112.809 //w=0.094 //l=0.22 //layer=ply \
 //thickness=0.18 //x=25.265 //y=0.93 //x2=25.045 //y2=0.93
r487 (  130 169 ) resistor r=16.5046 //w=0.27 //l=0.135 //layer=ply \
 //thickness=0.18 //x=25.02 //y=4.97 //x2=24.885 //y2=4.97
r488 (  129 136 ) resistor r=26.9307 //w=0.15 //l=0.106066 //layer=ply \
 //thickness=0.18 //x=25.26 //y=4.97 //x2=25.335 //y2=5.045
r489 (  129 130 ) resistor r=123.064 //w=0.094 //l=0.24 //layer=ply \
 //thickness=0.18 //x=25.26 //y=4.97 //x2=25.02 //y2=4.97
r490 (  124 172 ) resistor r=39.5823 //w=0.21 //l=0.173853 //layer=ply \
 //thickness=0.18 //x=24.89 //y=1.74 //x2=24.93 //y2=1.585
r491 (  124 164 ) resistor r=182.032 //w=0.094 //l=0.355 //layer=ply \
 //thickness=0.18 //x=24.89 //y=1.74 //x2=24.89 //y2=2.095
r492 (  123 172 ) resistor r=39.5823 //w=0.21 //l=0.173853 //layer=ply \
 //thickness=0.18 //x=24.89 //y=1.43 //x2=24.93 //y2=1.585
r493 (  122 171 ) resistor r=45.1352 //w=0.168 //l=0.173853 //layer=ply \
 //thickness=0.18 //x=24.89 //y=1.085 //x2=24.93 //y2=0.93
r494 (  122 123 ) resistor r=176.904 //w=0.094 //l=0.345 //layer=ply \
 //thickness=0.18 //x=24.89 //y=1.085 //x2=24.89 //y2=1.43
r495 (  121 161 ) resistor r=45.1352 //w=0.168 //l=0.173853 //layer=ply \
 //thickness=0.18 //x=12.47 //y=1.43 //x2=12.43 //y2=1.585
r496 (  120 160 ) resistor r=45.1352 //w=0.168 //l=0.173853 //layer=ply \
 //thickness=0.18 //x=12.47 //y=1.085 //x2=12.43 //y2=0.93
r497 (  120 121 ) resistor r=176.904 //w=0.094 //l=0.345 //layer=ply \
 //thickness=0.18 //x=12.47 //y=1.085 //x2=12.47 //y2=1.43
r498 (  115 159 ) resistor r=10.701 //w=0.21 //l=0.115 //layer=ply \
 //thickness=0.18 //x=12.095 //y=1.585 //x2=11.98 //y2=1.585
r499 (  114 161 ) resistor r=5.52526 //w=0.168 //l=0.115 //layer=ply \
 //thickness=0.18 //x=12.315 //y=1.585 //x2=12.43 //y2=1.585
r500 (  113 158 ) resistor r=5.52526 //w=0.168 //l=0.115 //layer=ply \
 //thickness=0.18 //x=12.095 //y=0.93 //x2=11.98 //y2=0.93
r501 (  112 160 ) resistor r=5.52526 //w=0.168 //l=0.115 //layer=ply \
 //thickness=0.18 //x=12.315 //y=0.93 //x2=12.43 //y2=0.93
r502 (  112 113 ) resistor r=112.809 //w=0.094 //l=0.22 //layer=ply \
 //thickness=0.18 //x=12.315 //y=0.93 //x2=12.095 //y2=0.93
r503 (  111 156 ) resistor r=16.5046 //w=0.27 //l=0.135 //layer=ply \
 //thickness=0.18 //x=12.07 //y=4.97 //x2=11.935 //y2=4.97
r504 (  110 117 ) resistor r=26.9307 //w=0.15 //l=0.106066 //layer=ply \
 //thickness=0.18 //x=12.31 //y=4.97 //x2=12.385 //y2=5.045
r505 (  110 111 ) resistor r=123.064 //w=0.094 //l=0.24 //layer=ply \
 //thickness=0.18 //x=12.31 //y=4.97 //x2=12.07 //y2=4.97
r506 (  105 159 ) resistor r=39.5823 //w=0.21 //l=0.173853 //layer=ply \
 //thickness=0.18 //x=11.94 //y=1.74 //x2=11.98 //y2=1.585
r507 (  105 151 ) resistor r=182.032 //w=0.094 //l=0.355 //layer=ply \
 //thickness=0.18 //x=11.94 //y=1.74 //x2=11.94 //y2=2.095
r508 (  104 159 ) resistor r=39.5823 //w=0.21 //l=0.173853 //layer=ply \
 //thickness=0.18 //x=11.94 //y=1.43 //x2=11.98 //y2=1.585
r509 (  103 158 ) resistor r=45.1352 //w=0.168 //l=0.173853 //layer=ply \
 //thickness=0.18 //x=11.94 //y=1.085 //x2=11.98 //y2=0.93
r510 (  103 104 ) resistor r=176.904 //w=0.094 //l=0.345 //layer=ply \
 //thickness=0.18 //x=11.94 //y=1.085 //x2=11.94 //y2=1.43
r511 (  98 100 ) resistor r=26.9307 //w=0.15 //l=0.106066 //layer=ply \
 //thickness=0.18 //x=2.11 //y=4.97 //x2=2.185 //y2=5.045
r512 (  98 99 ) resistor r=148.702 //w=0.094 //l=0.29 //layer=ply \
 //thickness=0.18 //x=2.11 //y=4.97 //x2=1.82 //y2=4.97
r513 (  97 148 ) resistor r=45.1352 //w=0.168 //l=0.173853 //layer=ply \
 //thickness=0.18 //x=1.775 //y=1.4 //x2=1.735 //y2=1.555
r514 (  96 147 ) resistor r=45.1352 //w=0.168 //l=0.173853 //layer=ply \
 //thickness=0.18 //x=1.775 //y=1.055 //x2=1.735 //y2=0.9
r515 (  96 97 ) resistor r=176.904 //w=0.094 //l=0.345 //layer=ply \
 //thickness=0.18 //x=1.775 //y=1.055 //x2=1.775 //y2=1.4
r516 (  93 99 ) resistor r=22.7971 //w=0.269 //l=0.106066 //layer=ply \
 //thickness=0.18 //x=1.745 //y=5.045 //x2=1.82 //y2=4.97
r517 (  93 146 ) resistor r=35.8364 //w=0.269 //l=0.270185 //layer=ply \
 //thickness=0.18 //x=1.745 //y=5.045 //x2=1.545 //y2=4.88
r518 (  91 142 ) resistor r=10.701 //w=0.21 //l=0.115 //layer=ply \
 //thickness=0.18 //x=1.4 //y=1.555 //x2=1.285 //y2=1.555
r519 (  90 148 ) resistor r=5.52526 //w=0.168 //l=0.115 //layer=ply \
 //thickness=0.18 //x=1.62 //y=1.555 //x2=1.735 //y2=1.555
r520 (  89 141 ) resistor r=5.52526 //w=0.168 //l=0.115 //layer=ply \
 //thickness=0.18 //x=1.4 //y=0.9 //x2=1.285 //y2=0.9
r521 (  88 147 ) resistor r=5.52526 //w=0.168 //l=0.115 //layer=ply \
 //thickness=0.18 //x=1.62 //y=0.9 //x2=1.735 //y2=0.9
r522 (  88 89 ) resistor r=112.809 //w=0.094 //l=0.22 //layer=ply \
 //thickness=0.18 //x=1.62 //y=0.9 //x2=1.4 //y2=0.9
r523 (  87 144 ) resistor r=58.7805 //w=0.246 //l=0.373497 //layer=ply \
 //thickness=0.18 //x=1.245 //y=2.095 //x2=1.545 //y2=2.26
r524 (  86 142 ) resistor r=39.5823 //w=0.21 //l=0.173853 //layer=ply \
 //thickness=0.18 //x=1.245 //y=1.71 //x2=1.285 //y2=1.555
r525 (  86 87 ) resistor r=197.415 //w=0.094 //l=0.385 //layer=ply \
 //thickness=0.18 //x=1.245 //y=1.71 //x2=1.245 //y2=2.095
r526 (  85 142 ) resistor r=39.5823 //w=0.21 //l=0.173853 //layer=ply \
 //thickness=0.18 //x=1.245 //y=1.4 //x2=1.285 //y2=1.555
r527 (  84 141 ) resistor r=45.1352 //w=0.168 //l=0.173853 //layer=ply \
 //thickness=0.18 //x=1.245 //y=1.055 //x2=1.285 //y2=0.9
r528 (  84 85 ) resistor r=176.904 //w=0.094 //l=0.345 //layer=ply \
 //thickness=0.18 //x=1.245 //y=1.055 //x2=1.245 //y2=1.4
r529 (  83 136 ) resistor r=592.245 //w=0.094 //l=1.155 //layer=ply \
 //thickness=0.18 //x=25.335 //y=6.2 //x2=25.335 //y2=5.045
r530 (  82 170 ) resistor r=592.245 //w=0.094 //l=1.155 //layer=ply \
 //thickness=0.18 //x=24.895 //y=6.2 //x2=24.895 //y2=5.045
r531 (  81 117 ) resistor r=592.245 //w=0.094 //l=1.155 //layer=ply \
 //thickness=0.18 //x=12.385 //y=6.2 //x2=12.385 //y2=5.045
r532 (  80 157 ) resistor r=592.245 //w=0.094 //l=1.155 //layer=ply \
 //thickness=0.18 //x=11.945 //y=6.2 //x2=11.945 //y2=5.045
r533 (  79 100 ) resistor r=592.245 //w=0.094 //l=1.155 //layer=ply \
 //thickness=0.18 //x=2.185 //y=6.2 //x2=2.185 //y2=5.045
r534 (  78 93 ) resistor r=592.245 //w=0.094 //l=1.155 //layer=ply \
 //thickness=0.18 //x=1.745 //y=6.2 //x2=1.745 //y2=5.045
r535 (  77 133 ) resistor r=56.4043 //w=0.094 //l=0.11 //layer=ply \
 //thickness=0.18 //x=25.155 //y=1.585 //x2=25.265 //y2=1.585
r536 (  77 134 ) resistor r=56.4043 //w=0.094 //l=0.11 //layer=ply \
 //thickness=0.18 //x=25.155 //y=1.585 //x2=25.045 //y2=1.585
r537 (  76 114 ) resistor r=56.4043 //w=0.094 //l=0.11 //layer=ply \
 //thickness=0.18 //x=12.205 //y=1.585 //x2=12.315 //y2=1.585
r538 (  76 115 ) resistor r=56.4043 //w=0.094 //l=0.11 //layer=ply \
 //thickness=0.18 //x=12.205 //y=1.585 //x2=12.095 //y2=1.585
r539 (  75 90 ) resistor r=56.4043 //w=0.094 //l=0.11 //layer=ply \
 //thickness=0.18 //x=1.51 //y=1.555 //x2=1.62 //y2=1.555
r540 (  75 91 ) resistor r=56.4043 //w=0.094 //l=0.11 //layer=ply \
 //thickness=0.18 //x=1.51 //y=1.555 //x2=1.4 //y2=1.555
r541 (  74 167 ) resistor r=152 //w=0.17 //l=0.17 //layer=licon //count=1 \
 //x=24.885 //y=4.88 //x2=24.885 //y2=4.88
r542 (  70 154 ) resistor r=152 //w=0.17 //l=0.17 //layer=licon //count=1 \
 //x=11.935 //y=4.88 //x2=11.935 //y2=4.88
r543 (  65 163 ) resistor r=152 //w=0.17 //l=0.17 //layer=licon //count=1 \
 //x=24.855 //y=2.26 //x2=24.855 //y2=2.26
r544 (  65 68 ) resistor r=136.214 //w=0.187 //l=1.99 //layer=li \
 //thickness=0.1 //x=24.855 //y=2.26 //x2=24.855 //y2=4.25
r545 (  63 74 ) resistor r=11.4737 //w=0.186 //l=0.172337 //layer=li \
 //thickness=0.1 //x=24.855 //y=4.715 //x2=24.87 //y2=4.88
r546 (  63 68 ) resistor r=31.8289 //w=0.187 //l=0.465 //layer=li \
 //thickness=0.1 //x=24.855 //y=4.715 //x2=24.855 //y2=4.25
r547 (  60 62 ) resistor r=68.4492 //w=0.187 //l=1 //layer=li //thickness=0.1 \
 //x=17.455 //y=5.25 //x2=17.455 //y2=4.25
r548 (  59 62 ) resistor r=158.802 //w=0.187 //l=2.32 //layer=li \
 //thickness=0.1 //x=17.455 //y=1.93 //x2=17.455 //y2=4.25
r549 (  57 59 ) resistor r=7.15173 //w=0.17 //l=0.120208 //layer=li \
 //thickness=0.1 //x=17.37 //y=1.845 //x2=17.455 //y2=1.93
r550 (  57 58 ) resistor r=21.5615 //w=0.187 //l=0.315 //layer=li \
 //thickness=0.1 //x=17.37 //y=1.845 //x2=17.055 //y2=1.845
r551 (  53 58 ) resistor r=7.15173 //w=0.17 //l=0.120208 //layer=li \
 //thickness=0.1 //x=16.97 //y=1.76 //x2=17.055 //y2=1.845
r552 (  53 175 ) resistor r=39.016 //w=0.187 //l=0.57 //layer=li \
 //thickness=0.1 //x=16.97 //y=1.76 //x2=16.97 //y2=1.19
r553 (  52 72 ) resistor r=5.4201 //w=0.17 //l=0.085 //layer=li \
 //thickness=0.1 //x=16.76 //y=5.335 //x2=16.675 //y2=5.335
r554 (  51 60 ) resistor r=7.15173 //w=0.17 //l=0.120208 //layer=li \
 //thickness=0.1 //x=17.37 //y=5.335 //x2=17.455 //y2=5.25
r555 (  51 52 ) resistor r=41.754 //w=0.187 //l=0.61 //layer=li \
 //thickness=0.1 //x=17.37 //y=5.335 //x2=16.76 //y2=5.335
r556 (  45 72 ) resistor r=1.40859 //w=0.34 //l=0.085 //layer=li \
 //thickness=0.1 //x=16.675 //y=5.42 //x2=16.675 //y2=5.335
r557 (  45 179 ) resistor r=33.1979 //w=0.187 //l=0.485 //layer=li \
 //thickness=0.1 //x=16.675 //y=5.42 //x2=16.675 //y2=5.905
r558 (  44 71 ) resistor r=5.4201 //w=0.17 //l=0.085 //layer=li \
 //thickness=0.1 //x=15.88 //y=5.335 //x2=15.795 //y2=5.335
r559 (  43 72 ) resistor r=5.4201 //w=0.17 //l=0.085 //layer=li \
 //thickness=0.1 //x=16.59 //y=5.335 //x2=16.675 //y2=5.335
r560 (  43 44 ) resistor r=48.5989 //w=0.187 //l=0.71 //layer=li \
 //thickness=0.1 //x=16.59 //y=5.335 //x2=15.88 //y2=5.335
r561 (  37 71 ) resistor r=1.40859 //w=0.34 //l=0.085 //layer=li \
 //thickness=0.1 //x=15.795 //y=5.42 //x2=15.795 //y2=5.335
r562 (  37 178 ) resistor r=33.1979 //w=0.187 //l=0.485 //layer=li \
 //thickness=0.1 //x=15.795 //y=5.42 //x2=15.795 //y2=5.905
r563 (  35 71 ) resistor r=5.4201 //w=0.17 //l=0.085 //layer=li \
 //thickness=0.1 //x=15.71 //y=5.335 //x2=15.795 //y2=5.335
r564 (  35 36 ) resistor r=48.5989 //w=0.187 //l=0.71 //layer=li \
 //thickness=0.1 //x=15.71 //y=5.335 //x2=15 //y2=5.335
r565 (  29 36 ) resistor r=7.15173 //w=0.17 //l=0.120208 //layer=li \
 //thickness=0.1 //x=14.915 //y=5.42 //x2=15 //y2=5.335
r566 (  29 177 ) resistor r=33.1979 //w=0.187 //l=0.485 //layer=li \
 //thickness=0.1 //x=14.915 //y=5.42 //x2=14.915 //y2=5.905
r567 (  25 150 ) resistor r=152 //w=0.17 //l=0.17 //layer=licon //count=1 \
 //x=11.905 //y=2.26 //x2=11.905 //y2=2.26
r568 (  25 28 ) resistor r=136.214 //w=0.187 //l=1.99 //layer=li \
 //thickness=0.1 //x=11.905 //y=2.26 //x2=11.905 //y2=4.25
r569 (  23 70 ) resistor r=11.4737 //w=0.186 //l=0.172337 //layer=li \
 //thickness=0.1 //x=11.905 //y=4.715 //x2=11.92 //y2=4.88
r570 (  23 28 ) resistor r=31.8289 //w=0.187 //l=0.465 //layer=li \
 //thickness=0.1 //x=11.905 //y=4.715 //x2=11.905 //y2=4.25
r571 (  21 146 ) resistor r=152 //w=0.17 //l=0.17 //layer=licon //count=1 \
 //x=1.545 //y=4.88 //x2=1.545 //y2=4.88
r572 (  19 21 ) resistor r=43.123 //w=0.187 //l=0.63 //layer=li \
 //thickness=0.1 //x=1.545 //y=4.25 //x2=1.545 //y2=4.88
r573 (  16 144 ) resistor r=152 //w=0.17 //l=0.17 //layer=licon //count=1 \
 //x=1.545 //y=2.26 //x2=1.545 //y2=2.26
r574 (  16 19 ) resistor r=136.214 //w=0.187 //l=1.99 //layer=li \
 //thickness=0.1 //x=1.545 //y=2.26 //x2=1.545 //y2=4.25
r575 (  14 68 ) resistor r=9.3 //w=0.17 //l=0.17 //layer=mcon //count=1 \
 //x=24.855 //y=4.25 //x2=24.855 //y2=4.25
r576 (  12 62 ) resistor r=9.3 //w=0.17 //l=0.17 //layer=mcon //count=1 \
 //x=17.455 //y=4.25 //x2=17.455 //y2=4.25
r577 (  10 28 ) resistor r=9.3 //w=0.17 //l=0.17 //layer=mcon //count=1 \
 //x=11.905 //y=4.25 //x2=11.905 //y2=4.25
r578 (  8 19 ) resistor r=9.3 //w=0.17 //l=0.17 //layer=mcon //count=1 \
 //x=1.545 //y=4.25 //x2=1.545 //y2=4.25
r579 (  6 12 ) resistor r=0.0880901 //w=0.191 //l=0.115 //layer=m1 \
 //thickness=0.36 //x=17.57 //y=4.25 //x2=17.455 //y2=4.25
r580 (  5 14 ) resistor r=0.0717383 //w=0.224 //l=0.115 //layer=m1 \
 //thickness=0.36 //x=24.74 //y=4.25 //x2=24.855 //y2=4.25
r581 (  5 6 ) resistor r=6.8416 //w=0.131 //l=7.17 //layer=m1 //thickness=0.36 \
 //x=24.74 //y=4.25 //x2=17.57 //y2=4.25
r582 (  4 10 ) resistor r=0.0880901 //w=0.191 //l=0.115 //layer=m1 \
 //thickness=0.36 //x=12.02 //y=4.25 //x2=11.905 //y2=4.25
r583 (  3 12 ) resistor r=0.0880901 //w=0.191 //l=0.115 //layer=m1 \
 //thickness=0.36 //x=17.34 //y=4.25 //x2=17.455 //y2=4.25
r584 (  3 4 ) resistor r=5.07634 //w=0.131 //l=5.32 //layer=m1 \
 //thickness=0.36 //x=17.34 //y=4.25 //x2=12.02 //y2=4.25
r585 (  2 8 ) resistor r=0.0717383 //w=0.224 //l=0.115 //layer=m1 \
 //thickness=0.36 //x=1.66 //y=4.25 //x2=1.545 //y2=4.25
r586 (  1 10 ) resistor r=0.0880901 //w=0.191 //l=0.115 //layer=m1 \
 //thickness=0.36 //x=11.79 //y=4.25 //x2=11.905 //y2=4.25
r587 (  1 2 ) resistor r=9.66603 //w=0.131 //l=10.13 //layer=m1 \
 //thickness=0.36 //x=11.79 //y=4.25 //x2=1.66 //y2=4.25
ends PM_DFFRNQNX1\%noxref_10

subckt PM_DFFRNQNX1\%noxref_11 ( 11 12 23 25 26 30 31 32 34 35 )
c86 ( 35 0 ) capacitor c=0.0220291f //x=24.97 //y=5.2
c87 ( 34 0 ) capacitor c=0.0217503f //x=24.09 //y=5.2
c88 ( 32 0 ) capacitor c=0.0084702f //x=24.965 //y=1.085
c89 ( 31 0 ) capacitor c=0.0024826f //x=25.115 //y=5.38
c90 ( 30 0 ) capacitor c=0.225846f //x=25.595 //y=3.88
c91 ( 26 0 ) capacitor c=0.00525782f //x=25.24 //y=1.835
c92 ( 25 0 ) capacitor c=0.0140375f //x=25.51 //y=1.835
c93 ( 23 0 ) capacitor c=0.0142754f //x=25.51 //y=5.38
c94 ( 12 0 ) capacitor c=0.00233874f //x=24.32 //y=5.38
c95 ( 11 0 ) capacitor c=0.0150834f //x=25.03 //y=5.38
r96 (  28 30 ) resistor r=96.8556 //w=0.187 //l=1.415 //layer=li \
 //thickness=0.1 //x=25.595 //y=5.295 //x2=25.595 //y2=3.88
r97 (  27 30 ) resistor r=134.16 //w=0.187 //l=1.96 //layer=li //thickness=0.1 \
 //x=25.595 //y=1.92 //x2=25.595 //y2=3.88
r98 (  25 27 ) resistor r=7.15173 //w=0.17 //l=0.120208 //layer=li \
 //thickness=0.1 //x=25.51 //y=1.835 //x2=25.595 //y2=1.92
r99 (  25 26 ) resistor r=18.4813 //w=0.187 //l=0.27 //layer=li \
 //thickness=0.1 //x=25.51 //y=1.835 //x2=25.24 //y2=1.835
r100 (  24 31 ) resistor r=5.4201 //w=0.17 //l=0.085 //layer=li \
 //thickness=0.1 //x=25.2 //y=5.38 //x2=25.115 //y2=5.38
r101 (  23 28 ) resistor r=7.15173 //w=0.17 //l=0.120208 //layer=li \
 //thickness=0.1 //x=25.51 //y=5.38 //x2=25.595 //y2=5.295
r102 (  23 24 ) resistor r=21.2193 //w=0.187 //l=0.31 //layer=li \
 //thickness=0.1 //x=25.51 //y=5.38 //x2=25.2 //y2=5.38
r103 (  19 26 ) resistor r=7.15173 //w=0.17 //l=0.120208 //layer=li \
 //thickness=0.1 //x=25.155 //y=1.75 //x2=25.24 //y2=1.835
r104 (  19 32 ) resistor r=39.016 //w=0.187 //l=0.57 //layer=li \
 //thickness=0.1 //x=25.155 //y=1.75 //x2=25.155 //y2=1.18
r105 (  13 31 ) resistor r=1.40859 //w=0.34 //l=0.085 //layer=li \
 //thickness=0.1 //x=25.115 //y=5.465 //x2=25.115 //y2=5.38
r106 (  13 35 ) resistor r=30.1176 //w=0.187 //l=0.44 //layer=li \
 //thickness=0.1 //x=25.115 //y=5.465 //x2=25.115 //y2=5.905
r107 (  11 31 ) resistor r=5.4201 //w=0.17 //l=0.085 //layer=li \
 //thickness=0.1 //x=25.03 //y=5.38 //x2=25.115 //y2=5.38
r108 (  11 12 ) resistor r=48.5989 //w=0.187 //l=0.71 //layer=li \
 //thickness=0.1 //x=25.03 //y=5.38 //x2=24.32 //y2=5.38
r109 (  5 12 ) resistor r=7.15173 //w=0.17 //l=0.120208 //layer=li \
 //thickness=0.1 //x=24.235 //y=5.465 //x2=24.32 //y2=5.38
r110 (  5 34 ) resistor r=30.1176 //w=0.187 //l=0.44 //layer=li \
 //thickness=0.1 //x=24.235 //y=5.465 //x2=24.235 //y2=5.905
ends PM_DFFRNQNX1\%noxref_11

subckt PM_DFFRNQNX1\%noxref_12 ( 1 5 9 13 17 35 )
c48 ( 35 0 ) capacitor c=0.0703709f //x=0.89 //y=0.555
c49 ( 17 0 ) capacitor c=0.0216756f //x=2.88 //y=1.77
c50 ( 13 0 ) capacitor c=0.0156939f //x=2.88 //y=0.72
c51 ( 9 0 ) capacitor c=0.00678203f //x=1.995 //y=0.805
c52 ( 5 0 ) capacitor c=0.0206412f //x=1.91 //y=1.77
c53 ( 1 0 ) capacitor c=0.0109947f //x=1.025 //y=1.685
r54 (  18 35 ) resistor r=5.4201 //w=0.17 //l=0.103078 //layer=li \
 //thickness=0.1 //x=2.08 //y=1.77 //x2=1.995 //y2=1.81
r55 (  18 35 ) resistor r=27.3797 //w=0.187 //l=0.4 //layer=li //thickness=0.1 \
 //x=2.08 //y=1.77 //x2=2.48 //y2=1.77
r56 (  17 35 ) resistor r=0.751729 //w=0.17 //l=0.085 //layer=li \
 //thickness=0.1 //x=2.88 //y=1.77 //x2=2.965 //y2=1.77
r57 (  17 35 ) resistor r=27.3797 //w=0.187 //l=0.4 //layer=li //thickness=0.1 \
 //x=2.88 //y=1.77 //x2=2.48 //y2=1.77
r58 (  14 35 ) resistor r=3.57586 //w=0.17 //l=0.103078 //layer=li \
 //thickness=0.1 //x=2.08 //y=0.72 //x2=1.995 //y2=0.68
r59 (  14 35 ) resistor r=27.3797 //w=0.187 //l=0.4 //layer=li //thickness=0.1 \
 //x=2.08 //y=0.72 //x2=2.48 //y2=0.72
r60 (  13 35 ) resistor r=0.751729 //w=0.17 //l=0.085 //layer=li \
 //thickness=0.1 //x=2.88 //y=0.72 //x2=2.965 //y2=0.72
r61 (  13 35 ) resistor r=27.3797 //w=0.187 //l=0.4 //layer=li //thickness=0.1 \
 //x=2.88 //y=0.72 //x2=2.48 //y2=0.72
r62 (  10 35 ) resistor r=1.40859 //w=0.34 //l=0.125 //layer=li \
 //thickness=0.1 //x=1.995 //y=1.685 //x2=1.995 //y2=1.81
r63 (  10 35 ) resistor r=42.0963 //w=0.187 //l=0.615 //layer=li \
 //thickness=0.1 //x=1.995 //y=1.685 //x2=1.995 //y2=1.07
r64 (  9 35 ) resistor r=3.57586 //w=0.17 //l=0.125 //layer=li //thickness=0.1 \
 //x=1.995 //y=0.805 //x2=1.995 //y2=0.68
r65 (  9 35 ) resistor r=18.139 //w=0.187 //l=0.265 //layer=li //thickness=0.1 \
 //x=1.995 //y=0.805 //x2=1.995 //y2=1.07
r66 (  6 35 ) resistor r=3.57586 //w=0.17 //l=0.103078 //layer=li \
 //thickness=0.1 //x=1.11 //y=1.77 //x2=1.025 //y2=1.81
r67 (  6 35 ) resistor r=27.3797 //w=0.187 //l=0.4 //layer=li //thickness=0.1 \
 //x=1.11 //y=1.77 //x2=1.51 //y2=1.77
r68 (  5 35 ) resistor r=5.4201 //w=0.17 //l=0.103078 //layer=li \
 //thickness=0.1 //x=1.91 //y=1.77 //x2=1.995 //y2=1.81
r69 (  5 35 ) resistor r=27.3797 //w=0.187 //l=0.4 //layer=li //thickness=0.1 \
 //x=1.91 //y=1.77 //x2=1.51 //y2=1.77
r70 (  1 35 ) resistor r=3.57586 //w=0.17 //l=0.125 //layer=li //thickness=0.1 \
 //x=1.025 //y=1.685 //x2=1.025 //y2=1.81
r71 (  1 35 ) resistor r=42.0963 //w=0.187 //l=0.615 //layer=li \
 //thickness=0.1 //x=1.025 //y=1.685 //x2=1.025 //y2=1.07
ends PM_DFFRNQNX1\%noxref_12

subckt PM_DFFRNQNX1\%noxref_13 ( 1 3 11 15 25 28 29 )
c53 ( 29 0 ) capacitor c=0.043074f //x=3.4 //y=0.555
c54 ( 28 0 ) capacitor c=0.00465142f //x=2.295 //y=1.09
c55 ( 25 0 ) capacitor c=0.00156479f //x=3.535 //y=1.175
c56 ( 15 0 ) capacitor c=0.00737666f //x=4.505 //y=0.805
c57 ( 11 0 ) capacitor c=0.0149771f //x=4.42 //y=0.72
c58 ( 3 0 ) capacitor c=0.00718386f //x=3.535 //y=0.805
c59 ( 1 0 ) capacitor c=0.0253322f //x=3.45 //y=1.175
r60 (  15 29 ) resistor r=3.57586 //w=0.17 //l=0.125 //layer=li \
 //thickness=0.1 //x=4.505 //y=0.805 //x2=4.505 //y2=0.68
r61 (  15 29 ) resistor r=18.139 //w=0.187 //l=0.265 //layer=li \
 //thickness=0.1 //x=4.505 //y=0.805 //x2=4.505 //y2=1.07
r62 (  12 29 ) resistor r=3.57586 //w=0.17 //l=0.103078 //layer=li \
 //thickness=0.1 //x=3.62 //y=0.72 //x2=3.535 //y2=0.68
r63 (  12 29 ) resistor r=27.3797 //w=0.187 //l=0.4 //layer=li //thickness=0.1 \
 //x=3.62 //y=0.72 //x2=4.02 //y2=0.72
r64 (  11 29 ) resistor r=3.57586 //w=0.17 //l=0.103078 //layer=li \
 //thickness=0.1 //x=4.42 //y=0.72 //x2=4.505 //y2=0.68
r65 (  11 29 ) resistor r=27.3797 //w=0.187 //l=0.4 //layer=li //thickness=0.1 \
 //x=4.42 //y=0.72 //x2=4.02 //y2=0.72
r66 (  7 25 ) resistor r=5.4201 //w=0.17 //l=0.085 //layer=li //thickness=0.1 \
 //x=3.535 //y=1.26 //x2=3.535 //y2=1.175
r67 (  7 29 ) resistor r=10.2674 //w=0.187 //l=0.15 //layer=li //thickness=0.1 \
 //x=3.535 //y=1.26 //x2=3.535 //y2=1.41
r68 (  4 25 ) resistor r=5.4201 //w=0.17 //l=0.085 //layer=li //thickness=0.1 \
 //x=3.535 //y=1.09 //x2=3.535 //y2=1.175
r69 (  4 29 ) resistor r=1.36898 //w=0.187 //l=0.02 //layer=li //thickness=0.1 \
 //x=3.535 //y=1.09 //x2=3.535 //y2=1.07
r70 (  3 29 ) resistor r=3.57586 //w=0.17 //l=0.125 //layer=li //thickness=0.1 \
 //x=3.535 //y=0.805 //x2=3.535 //y2=0.68
r71 (  3 29 ) resistor r=18.139 //w=0.187 //l=0.265 //layer=li //thickness=0.1 \
 //x=3.535 //y=0.805 //x2=3.535 //y2=1.07
r72 (  2 28 ) resistor r=0.751729 //w=0.17 //l=0.085 //layer=li \
 //thickness=0.1 //x=2.57 //y=1.175 //x2=2.485 //y2=1.175
r73 (  1 25 ) resistor r=1.40859 //w=0.34 //l=0.085 //layer=li //thickness=0.1 \
 //x=3.45 //y=1.175 //x2=3.535 //y2=1.175
r74 (  1 2 ) resistor r=60.2353 //w=0.187 //l=0.88 //layer=li //thickness=0.1 \
 //x=3.45 //y=1.175 //x2=2.57 //y2=1.175
ends PM_DFFRNQNX1\%noxref_13

subckt PM_DFFRNQNX1\%D ( 1 2 5 11 17 19 20 21 22 23 24 26 32 33 34 35 36 44 )
c89 ( 44 0 ) capacitor c=0.0335551f //x=7.465 //y=4.88
c90 ( 36 0 ) capacitor c=0.0245352f //x=7.8 //y=4.97
c91 ( 35 0 ) capacitor c=0.0836699f //x=7.555 //y=2.095
c92 ( 34 0 ) capacitor c=0.0170266f //x=7.555 //y=1.63
c93 ( 33 0 ) capacitor c=0.018609f //x=7.555 //y=1.4
c94 ( 32 0 ) capacitor c=0.0187309f //x=7.555 //y=1.09
c95 ( 26 0 ) capacitor c=0.014725f //x=7.4 //y=1.555
c96 ( 24 0 ) capacitor c=0.0146567f //x=7.4 //y=0.935
c97 ( 23 0 ) capacitor c=0.0335408f //x=7.03 //y=1.4
c98 ( 22 0 ) capacitor c=0.0173761f //x=7.03 //y=1.09
c99 ( 21 0 ) capacitor c=0.110114f //x=7.875 //y=6.2
c100 ( 20 0 ) capacitor c=0.11012f //x=7.435 //y=6.2
c101 ( 17 0 ) capacitor c=0.00874422f //x=7.492 //y=3.055
c102 ( 11 0 ) capacitor c=0.0573681f //x=7.465 //y=4.88
c103 ( 5 0 ) capacitor c=0.0150164f //x=7.465 //y=2.26
c104 ( 2 0 ) capacitor c=0.00905554f //x=7.52 //y=3.14
c105 ( 1 0 ) capacitor c=0.00842433f //x=7.52 //y=2.77
r106 (  46 47 ) resistor r=32.4568 //w=0.214 //l=0.075 //layer=ply \
 //thickness=0.18 //x=7.465 //y=4.97 //x2=7.465 //y2=5.045
r107 (  44 46 ) resistor r=20.271 //w=0.214 //l=0.09 //layer=ply \
 //thickness=0.18 //x=7.465 //y=4.88 //x2=7.465 //y2=4.97
r108 (  37 46 ) resistor r=16.5046 //w=0.27 //l=0.135 //layer=ply \
 //thickness=0.18 //x=7.6 //y=4.97 //x2=7.465 //y2=4.97
r109 (  36 38 ) resistor r=26.9307 //w=0.15 //l=0.106066 //layer=ply \
 //thickness=0.18 //x=7.8 //y=4.97 //x2=7.875 //y2=5.045
r110 (  36 37 ) resistor r=102.553 //w=0.094 //l=0.2 //layer=ply \
 //thickness=0.18 //x=7.8 //y=4.97 //x2=7.6 //y2=4.97
r111 (  35 51 ) resistor r=38.6777 //w=0.284 //l=0.198997 //layer=ply \
 //thickness=0.18 //x=7.555 //y=2.095 //x2=7.48 //y2=2.26
r112 (  34 49 ) resistor r=21.2976 //w=0.217 //l=0.0928709 //layer=ply \
 //thickness=0.18 //x=7.555 //y=1.63 //x2=7.515 //y2=1.555
r113 (  34 35 ) resistor r=238.436 //w=0.094 //l=0.465 //layer=ply \
 //thickness=0.18 //x=7.555 //y=1.63 //x2=7.555 //y2=2.095
r114 (  33 49 ) resistor r=39.0671 //w=0.217 //l=0.173853 //layer=ply \
 //thickness=0.18 //x=7.555 //y=1.4 //x2=7.515 //y2=1.555
r115 (  32 48 ) resistor r=45.1352 //w=0.168 //l=0.173853 //layer=ply \
 //thickness=0.18 //x=7.555 //y=1.09 //x2=7.515 //y2=0.935
r116 (  32 33 ) resistor r=158.957 //w=0.094 //l=0.31 //layer=ply \
 //thickness=0.18 //x=7.555 //y=1.09 //x2=7.555 //y2=1.4
r117 (  27 42 ) resistor r=5.52526 //w=0.168 //l=0.115 //layer=ply \
 //thickness=0.18 //x=7.185 //y=1.555 //x2=7.07 //y2=1.555
r118 (  26 49 ) resistor r=11.4558 //w=0.217 //l=0.115 //layer=ply \
 //thickness=0.18 //x=7.4 //y=1.555 //x2=7.515 //y2=1.555
r119 (  25 41 ) resistor r=5.52526 //w=0.168 //l=0.115 //layer=ply \
 //thickness=0.18 //x=7.185 //y=0.935 //x2=7.07 //y2=0.935
r120 (  24 48 ) resistor r=5.52526 //w=0.168 //l=0.115 //layer=ply \
 //thickness=0.18 //x=7.4 //y=0.935 //x2=7.515 //y2=0.935
r121 (  24 25 ) resistor r=110.245 //w=0.094 //l=0.215 //layer=ply \
 //thickness=0.18 //x=7.4 //y=0.935 //x2=7.185 //y2=0.935
r122 (  23 42 ) resistor r=45.1352 //w=0.168 //l=0.173853 //layer=ply \
 //thickness=0.18 //x=7.03 //y=1.4 //x2=7.07 //y2=1.555
r123 (  22 41 ) resistor r=45.1352 //w=0.168 //l=0.173853 //layer=ply \
 //thickness=0.18 //x=7.03 //y=1.09 //x2=7.07 //y2=0.935
r124 (  22 23 ) resistor r=158.957 //w=0.094 //l=0.31 //layer=ply \
 //thickness=0.18 //x=7.03 //y=1.09 //x2=7.03 //y2=1.4
r125 (  21 38 ) resistor r=592.245 //w=0.094 //l=1.155 //layer=ply \
 //thickness=0.18 //x=7.875 //y=6.2 //x2=7.875 //y2=5.045
r126 (  20 47 ) resistor r=592.245 //w=0.094 //l=1.155 //layer=ply \
 //thickness=0.18 //x=7.435 //y=6.2 //x2=7.435 //y2=5.045
r127 (  19 26 ) resistor r=55.3787 //w=0.094 //l=0.108 //layer=ply \
 //thickness=0.18 //x=7.292 //y=1.555 //x2=7.4 //y2=1.555
r128 (  19 27 ) resistor r=54.866 //w=0.094 //l=0.107 //layer=ply \
 //thickness=0.18 //x=7.292 //y=1.555 //x2=7.185 //y2=1.555
r129 (  15 17 ) resistor r=13.6898 //w=0.187 //l=0.2 //layer=li \
 //thickness=0.1 //x=7.465 //y=2.855 //x2=7.465 //y2=3.055
r130 (  11 44 ) resistor r=152 //w=0.17 //l=0.17 //layer=licon //count=1 \
 //x=7.465 //y=4.88 //x2=7.465 //y2=4.88
r131 (  11 18 ) resistor r=113.283 //w=0.187 //l=1.655 //layer=li \
 //thickness=0.1 //x=7.465 //y=4.88 //x2=7.465 //y2=3.225
r132 (  5 51 ) resistor r=152 //w=0.17 //l=0.17 //layer=licon //count=1 \
 //x=7.465 //y=2.26 //x2=7.465 //y2=2.26
r133 (  5 14 ) resistor r=29.0909 //w=0.187 //l=0.425 //layer=li \
 //thickness=0.1 //x=7.465 //y=2.26 //x2=7.465 //y2=2.685
r134 (  2 18 ) resistor r=5.1957 //w=0.242 //l=0.085 //layer=li \
 //thickness=0.1 //x=7.492 //y=3.14 //x2=7.492 //y2=3.225
r135 (  2 17 ) resistor r=5.1957 //w=0.242 //l=0.085 //layer=li \
 //thickness=0.1 //x=7.492 //y=3.14 //x2=7.492 //y2=3.055
r136 (  1 15 ) resistor r=5.1957 //w=0.242 //l=0.085 //layer=li \
 //thickness=0.1 //x=7.492 //y=2.77 //x2=7.492 //y2=2.855
r137 (  1 14 ) resistor r=5.1957 //w=0.242 //l=0.085 //layer=li \
 //thickness=0.1 //x=7.492 //y=2.77 //x2=7.492 //y2=2.685
ends PM_DFFRNQNX1\%D

subckt PM_DFFRNQNX1\%noxref_15 ( 1 5 9 13 17 35 )
c51 ( 35 0 ) capacitor c=0.0693021f //x=5.7 //y=0.555
c52 ( 17 0 ) capacitor c=0.0201762f //x=7.69 //y=1.77
c53 ( 13 0 ) capacitor c=0.0156174f //x=7.69 //y=0.72
c54 ( 9 0 ) capacitor c=0.00678203f //x=6.805 //y=0.805
c55 ( 5 0 ) capacitor c=0.0183576f //x=6.72 //y=1.77
c56 ( 1 0 ) capacitor c=0.00791969f //x=5.835 //y=1.685
r57 (  18 35 ) resistor r=5.4201 //w=0.17 //l=0.103078 //layer=li \
 //thickness=0.1 //x=6.89 //y=1.77 //x2=6.805 //y2=1.81
r58 (  18 35 ) resistor r=27.3797 //w=0.187 //l=0.4 //layer=li //thickness=0.1 \
 //x=6.89 //y=1.77 //x2=7.29 //y2=1.77
r59 (  17 35 ) resistor r=0.751729 //w=0.17 //l=0.085 //layer=li \
 //thickness=0.1 //x=7.69 //y=1.77 //x2=7.775 //y2=1.77
r60 (  17 35 ) resistor r=27.3797 //w=0.187 //l=0.4 //layer=li //thickness=0.1 \
 //x=7.69 //y=1.77 //x2=7.29 //y2=1.77
r61 (  14 35 ) resistor r=3.57586 //w=0.17 //l=0.103078 //layer=li \
 //thickness=0.1 //x=6.89 //y=0.72 //x2=6.805 //y2=0.68
r62 (  14 35 ) resistor r=27.3797 //w=0.187 //l=0.4 //layer=li //thickness=0.1 \
 //x=6.89 //y=0.72 //x2=7.29 //y2=0.72
r63 (  13 35 ) resistor r=0.751729 //w=0.17 //l=0.085 //layer=li \
 //thickness=0.1 //x=7.69 //y=0.72 //x2=7.775 //y2=0.72
r64 (  13 35 ) resistor r=27.3797 //w=0.187 //l=0.4 //layer=li //thickness=0.1 \
 //x=7.69 //y=0.72 //x2=7.29 //y2=0.72
r65 (  10 35 ) resistor r=1.40859 //w=0.34 //l=0.125 //layer=li \
 //thickness=0.1 //x=6.805 //y=1.685 //x2=6.805 //y2=1.81
r66 (  10 35 ) resistor r=42.0963 //w=0.187 //l=0.615 //layer=li \
 //thickness=0.1 //x=6.805 //y=1.685 //x2=6.805 //y2=1.07
r67 (  9 35 ) resistor r=3.57586 //w=0.17 //l=0.125 //layer=li //thickness=0.1 \
 //x=6.805 //y=0.805 //x2=6.805 //y2=0.68
r68 (  9 35 ) resistor r=18.139 //w=0.187 //l=0.265 //layer=li //thickness=0.1 \
 //x=6.805 //y=0.805 //x2=6.805 //y2=1.07
r69 (  6 35 ) resistor r=3.57586 //w=0.17 //l=0.103078 //layer=li \
 //thickness=0.1 //x=5.92 //y=1.77 //x2=5.835 //y2=1.81
r70 (  6 35 ) resistor r=27.3797 //w=0.187 //l=0.4 //layer=li //thickness=0.1 \
 //x=5.92 //y=1.77 //x2=6.32 //y2=1.77
r71 (  5 35 ) resistor r=5.4201 //w=0.17 //l=0.103078 //layer=li \
 //thickness=0.1 //x=6.72 //y=1.77 //x2=6.805 //y2=1.81
r72 (  5 35 ) resistor r=27.3797 //w=0.187 //l=0.4 //layer=li //thickness=0.1 \
 //x=6.72 //y=1.77 //x2=6.32 //y2=1.77
r73 (  1 35 ) resistor r=3.57586 //w=0.17 //l=0.125 //layer=li //thickness=0.1 \
 //x=5.835 //y=1.685 //x2=5.835 //y2=1.81
r74 (  1 35 ) resistor r=42.0963 //w=0.187 //l=0.615 //layer=li \
 //thickness=0.1 //x=5.835 //y=1.685 //x2=5.835 //y2=1.07
ends PM_DFFRNQNX1\%noxref_15

subckt PM_DFFRNQNX1\%noxref_16 ( 1 3 11 15 25 28 29 )
c54 ( 29 0 ) capacitor c=0.0423432f //x=8.21 //y=0.555
c55 ( 28 0 ) capacitor c=0.00463374f //x=7.105 //y=1.09
c56 ( 25 0 ) capacitor c=0.00156479f //x=8.345 //y=1.175
c57 ( 15 0 ) capacitor c=0.00737666f //x=9.315 //y=0.805
c58 ( 11 0 ) capacitor c=0.0143878f //x=9.23 //y=0.72
c59 ( 3 0 ) capacitor c=0.00718386f //x=8.345 //y=0.805
c60 ( 1 0 ) capacitor c=0.0242666f //x=8.26 //y=1.175
r61 (  15 29 ) resistor r=3.57586 //w=0.17 //l=0.125 //layer=li \
 //thickness=0.1 //x=9.315 //y=0.805 //x2=9.315 //y2=0.68
r62 (  15 29 ) resistor r=18.139 //w=0.187 //l=0.265 //layer=li \
 //thickness=0.1 //x=9.315 //y=0.805 //x2=9.315 //y2=1.07
r63 (  12 29 ) resistor r=3.57586 //w=0.17 //l=0.103078 //layer=li \
 //thickness=0.1 //x=8.43 //y=0.72 //x2=8.345 //y2=0.68
r64 (  12 29 ) resistor r=27.3797 //w=0.187 //l=0.4 //layer=li //thickness=0.1 \
 //x=8.43 //y=0.72 //x2=8.83 //y2=0.72
r65 (  11 29 ) resistor r=3.57586 //w=0.17 //l=0.103078 //layer=li \
 //thickness=0.1 //x=9.23 //y=0.72 //x2=9.315 //y2=0.68
r66 (  11 29 ) resistor r=27.3797 //w=0.187 //l=0.4 //layer=li //thickness=0.1 \
 //x=9.23 //y=0.72 //x2=8.83 //y2=0.72
r67 (  7 25 ) resistor r=5.4201 //w=0.17 //l=0.085 //layer=li //thickness=0.1 \
 //x=8.345 //y=1.26 //x2=8.345 //y2=1.175
r68 (  7 29 ) resistor r=10.2674 //w=0.187 //l=0.15 //layer=li //thickness=0.1 \
 //x=8.345 //y=1.26 //x2=8.345 //y2=1.41
r69 (  4 25 ) resistor r=5.4201 //w=0.17 //l=0.085 //layer=li //thickness=0.1 \
 //x=8.345 //y=1.09 //x2=8.345 //y2=1.175
r70 (  4 29 ) resistor r=1.36898 //w=0.187 //l=0.02 //layer=li //thickness=0.1 \
 //x=8.345 //y=1.09 //x2=8.345 //y2=1.07
r71 (  3 29 ) resistor r=3.57586 //w=0.17 //l=0.125 //layer=li //thickness=0.1 \
 //x=8.345 //y=0.805 //x2=8.345 //y2=0.68
r72 (  3 29 ) resistor r=18.139 //w=0.187 //l=0.265 //layer=li //thickness=0.1 \
 //x=8.345 //y=0.805 //x2=8.345 //y2=1.07
r73 (  2 28 ) resistor r=0.751729 //w=0.17 //l=0.085 //layer=li \
 //thickness=0.1 //x=7.38 //y=1.175 //x2=7.295 //y2=1.175
r74 (  1 25 ) resistor r=1.40859 //w=0.34 //l=0.085 //layer=li //thickness=0.1 \
 //x=8.26 //y=1.175 //x2=8.345 //y2=1.175
r75 (  1 2 ) resistor r=60.2353 //w=0.187 //l=0.88 //layer=li //thickness=0.1 \
 //x=8.26 //y=1.175 //x2=7.38 //y2=1.175
ends PM_DFFRNQNX1\%noxref_16

subckt PM_DFFRNQNX1\%noxref_17 ( 1 5 9 10 13 17 29 )
c52 ( 29 0 ) capacitor c=0.0632682f //x=10.615 //y=0.545
c53 ( 17 0 ) capacitor c=0.0072343f //x=12.69 //y=0.795
c54 ( 13 0 ) capacitor c=0.0145084f //x=12.605 //y=0.71
c55 ( 10 0 ) capacitor c=0.00582081f //x=11.72 //y=1.675
c56 ( 9 0 ) capacitor c=0.006761f //x=11.72 //y=0.795
c57 ( 5 0 ) capacitor c=0.0173046f //x=11.635 //y=1.76
c58 ( 1 0 ) capacitor c=0.00733328f //x=10.75 //y=1.675
r59 (  17 29 ) resistor r=3.57586 //w=0.17 //l=0.125 //layer=li \
 //thickness=0.1 //x=12.69 //y=0.795 //x2=12.69 //y2=0.67
r60 (  17 29 ) resistor r=18.139 //w=0.187 //l=0.265 //layer=li \
 //thickness=0.1 //x=12.69 //y=0.795 //x2=12.69 //y2=1.06
r61 (  14 29 ) resistor r=3.57586 //w=0.17 //l=0.103078 //layer=li \
 //thickness=0.1 //x=11.805 //y=0.71 //x2=11.72 //y2=0.67
r62 (  14 29 ) resistor r=27.3797 //w=0.187 //l=0.4 //layer=li //thickness=0.1 \
 //x=11.805 //y=0.71 //x2=12.205 //y2=0.71
r63 (  13 29 ) resistor r=3.57586 //w=0.17 //l=0.103078 //layer=li \
 //thickness=0.1 //x=12.605 //y=0.71 //x2=12.69 //y2=0.67
r64 (  13 29 ) resistor r=27.3797 //w=0.187 //l=0.4 //layer=li //thickness=0.1 \
 //x=12.605 //y=0.71 //x2=12.205 //y2=0.71
r65 (  10 29 ) resistor r=3.57586 //w=0.17 //l=0.125 //layer=li \
 //thickness=0.1 //x=11.72 //y=1.675 //x2=11.72 //y2=1.8
r66 (  10 29 ) resistor r=42.0963 //w=0.187 //l=0.615 //layer=li \
 //thickness=0.1 //x=11.72 //y=1.675 //x2=11.72 //y2=1.06
r67 (  9 29 ) resistor r=3.57586 //w=0.17 //l=0.125 //layer=li //thickness=0.1 \
 //x=11.72 //y=0.795 //x2=11.72 //y2=0.67
r68 (  9 29 ) resistor r=18.139 //w=0.187 //l=0.265 //layer=li //thickness=0.1 \
 //x=11.72 //y=0.795 //x2=11.72 //y2=1.06
r69 (  6 29 ) resistor r=3.57586 //w=0.17 //l=0.103078 //layer=li \
 //thickness=0.1 //x=10.835 //y=1.76 //x2=10.75 //y2=1.8
r70 (  6 29 ) resistor r=27.3797 //w=0.187 //l=0.4 //layer=li //thickness=0.1 \
 //x=10.835 //y=1.76 //x2=11.235 //y2=1.76
r71 (  5 29 ) resistor r=3.57586 //w=0.17 //l=0.103078 //layer=li \
 //thickness=0.1 //x=11.635 //y=1.76 //x2=11.72 //y2=1.8
r72 (  5 29 ) resistor r=27.3797 //w=0.187 //l=0.4 //layer=li //thickness=0.1 \
 //x=11.635 //y=1.76 //x2=11.235 //y2=1.76
r73 (  1 29 ) resistor r=3.57586 //w=0.17 //l=0.125 //layer=li //thickness=0.1 \
 //x=10.75 //y=1.675 //x2=10.75 //y2=1.8
r74 (  1 29 ) resistor r=42.0963 //w=0.187 //l=0.615 //layer=li \
 //thickness=0.1 //x=10.75 //y=1.675 //x2=10.75 //y2=1.06
ends PM_DFFRNQNX1\%noxref_17

subckt PM_DFFRNQNX1\%noxref_18 ( 1 5 9 13 17 35 )
c51 ( 35 0 ) capacitor c=0.0673029f //x=13.84 //y=0.555
c52 ( 17 0 ) capacitor c=0.0173844f //x=15.83 //y=1.77
c53 ( 13 0 ) capacitor c=0.0154936f //x=15.83 //y=0.72
c54 ( 9 0 ) capacitor c=0.00678203f //x=14.945 //y=0.805
c55 ( 5 0 ) capacitor c=0.0164013f //x=14.86 //y=1.77
c56 ( 1 0 ) capacitor c=0.00696517f //x=13.975 //y=1.685
r57 (  18 35 ) resistor r=5.4201 //w=0.17 //l=0.103078 //layer=li \
 //thickness=0.1 //x=15.03 //y=1.77 //x2=14.945 //y2=1.81
r58 (  18 35 ) resistor r=27.3797 //w=0.187 //l=0.4 //layer=li //thickness=0.1 \
 //x=15.03 //y=1.77 //x2=15.43 //y2=1.77
r59 (  17 35 ) resistor r=0.751729 //w=0.17 //l=0.085 //layer=li \
 //thickness=0.1 //x=15.83 //y=1.77 //x2=15.915 //y2=1.77
r60 (  17 35 ) resistor r=27.3797 //w=0.187 //l=0.4 //layer=li //thickness=0.1 \
 //x=15.83 //y=1.77 //x2=15.43 //y2=1.77
r61 (  14 35 ) resistor r=3.57586 //w=0.17 //l=0.103078 //layer=li \
 //thickness=0.1 //x=15.03 //y=0.72 //x2=14.945 //y2=0.68
r62 (  14 35 ) resistor r=27.3797 //w=0.187 //l=0.4 //layer=li //thickness=0.1 \
 //x=15.03 //y=0.72 //x2=15.43 //y2=0.72
r63 (  13 35 ) resistor r=0.751729 //w=0.17 //l=0.085 //layer=li \
 //thickness=0.1 //x=15.83 //y=0.72 //x2=15.915 //y2=0.72
r64 (  13 35 ) resistor r=27.3797 //w=0.187 //l=0.4 //layer=li //thickness=0.1 \
 //x=15.83 //y=0.72 //x2=15.43 //y2=0.72
r65 (  10 35 ) resistor r=1.40859 //w=0.34 //l=0.125 //layer=li \
 //thickness=0.1 //x=14.945 //y=1.685 //x2=14.945 //y2=1.81
r66 (  10 35 ) resistor r=42.0963 //w=0.187 //l=0.615 //layer=li \
 //thickness=0.1 //x=14.945 //y=1.685 //x2=14.945 //y2=1.07
r67 (  9 35 ) resistor r=3.57586 //w=0.17 //l=0.125 //layer=li //thickness=0.1 \
 //x=14.945 //y=0.805 //x2=14.945 //y2=0.68
r68 (  9 35 ) resistor r=18.139 //w=0.187 //l=0.265 //layer=li //thickness=0.1 \
 //x=14.945 //y=0.805 //x2=14.945 //y2=1.07
r69 (  6 35 ) resistor r=3.57586 //w=0.17 //l=0.103078 //layer=li \
 //thickness=0.1 //x=14.06 //y=1.77 //x2=13.975 //y2=1.81
r70 (  6 35 ) resistor r=27.3797 //w=0.187 //l=0.4 //layer=li //thickness=0.1 \
 //x=14.06 //y=1.77 //x2=14.46 //y2=1.77
r71 (  5 35 ) resistor r=5.4201 //w=0.17 //l=0.103078 //layer=li \
 //thickness=0.1 //x=14.86 //y=1.77 //x2=14.945 //y2=1.81
r72 (  5 35 ) resistor r=27.3797 //w=0.187 //l=0.4 //layer=li //thickness=0.1 \
 //x=14.86 //y=1.77 //x2=14.46 //y2=1.77
r73 (  1 35 ) resistor r=3.57586 //w=0.17 //l=0.125 //layer=li //thickness=0.1 \
 //x=13.975 //y=1.685 //x2=13.975 //y2=1.81
r74 (  1 35 ) resistor r=42.0963 //w=0.187 //l=0.615 //layer=li \
 //thickness=0.1 //x=13.975 //y=1.685 //x2=13.975 //y2=1.07
ends PM_DFFRNQNX1\%noxref_18

subckt PM_DFFRNQNX1\%noxref_19 ( 1 3 11 15 25 28 29 )
c54 ( 29 0 ) capacitor c=0.0413887f //x=16.35 //y=0.555
c55 ( 28 0 ) capacitor c=0.0045748f //x=15.245 //y=1.09
c56 ( 25 0 ) capacitor c=0.00156479f //x=16.485 //y=1.175
c57 ( 15 0 ) capacitor c=0.00737666f //x=17.455 //y=0.805
c58 ( 11 0 ) capacitor c=0.0143878f //x=17.37 //y=0.72
c59 ( 3 0 ) capacitor c=0.00718386f //x=16.485 //y=0.805
c60 ( 1 0 ) capacitor c=0.0220678f //x=16.4 //y=1.175
r61 (  15 29 ) resistor r=3.57586 //w=0.17 //l=0.125 //layer=li \
 //thickness=0.1 //x=17.455 //y=0.805 //x2=17.455 //y2=0.68
r62 (  15 29 ) resistor r=18.139 //w=0.187 //l=0.265 //layer=li \
 //thickness=0.1 //x=17.455 //y=0.805 //x2=17.455 //y2=1.07
r63 (  12 29 ) resistor r=3.57586 //w=0.17 //l=0.103078 //layer=li \
 //thickness=0.1 //x=16.57 //y=0.72 //x2=16.485 //y2=0.68
r64 (  12 29 ) resistor r=27.3797 //w=0.187 //l=0.4 //layer=li //thickness=0.1 \
 //x=16.57 //y=0.72 //x2=16.97 //y2=0.72
r65 (  11 29 ) resistor r=3.57586 //w=0.17 //l=0.103078 //layer=li \
 //thickness=0.1 //x=17.37 //y=0.72 //x2=17.455 //y2=0.68
r66 (  11 29 ) resistor r=27.3797 //w=0.187 //l=0.4 //layer=li //thickness=0.1 \
 //x=17.37 //y=0.72 //x2=16.97 //y2=0.72
r67 (  7 25 ) resistor r=5.4201 //w=0.17 //l=0.085 //layer=li //thickness=0.1 \
 //x=16.485 //y=1.26 //x2=16.485 //y2=1.175
r68 (  7 29 ) resistor r=10.2674 //w=0.187 //l=0.15 //layer=li //thickness=0.1 \
 //x=16.485 //y=1.26 //x2=16.485 //y2=1.41
r69 (  4 25 ) resistor r=5.4201 //w=0.17 //l=0.085 //layer=li //thickness=0.1 \
 //x=16.485 //y=1.09 //x2=16.485 //y2=1.175
r70 (  4 29 ) resistor r=1.36898 //w=0.187 //l=0.02 //layer=li //thickness=0.1 \
 //x=16.485 //y=1.09 //x2=16.485 //y2=1.07
r71 (  3 29 ) resistor r=3.57586 //w=0.17 //l=0.125 //layer=li //thickness=0.1 \
 //x=16.485 //y=0.805 //x2=16.485 //y2=0.68
r72 (  3 29 ) resistor r=18.139 //w=0.187 //l=0.265 //layer=li //thickness=0.1 \
 //x=16.485 //y=0.805 //x2=16.485 //y2=1.07
r73 (  2 28 ) resistor r=0.751729 //w=0.17 //l=0.085 //layer=li \
 //thickness=0.1 //x=15.52 //y=1.175 //x2=15.435 //y2=1.175
r74 (  1 25 ) resistor r=1.40859 //w=0.34 //l=0.085 //layer=li //thickness=0.1 \
 //x=16.4 //y=1.175 //x2=16.485 //y2=1.175
r75 (  1 2 ) resistor r=60.2353 //w=0.187 //l=0.88 //layer=li //thickness=0.1 \
 //x=16.4 //y=1.175 //x2=15.52 //y2=1.175
ends PM_DFFRNQNX1\%noxref_19

subckt PM_DFFRNQNX1\%noxref_20 ( 1 5 9 13 17 35 )
c52 ( 35 0 ) capacitor c=0.0688914f //x=18.65 //y=0.555
c53 ( 17 0 ) capacitor c=0.017663f //x=20.64 //y=1.77
c54 ( 13 0 ) capacitor c=0.0155709f //x=20.64 //y=0.72
c55 ( 9 0 ) capacitor c=0.00678203f //x=19.755 //y=0.805
c56 ( 5 0 ) capacitor c=0.0164013f //x=19.67 //y=1.77
c57 ( 1 0 ) capacitor c=0.00696517f //x=18.785 //y=1.685
r58 (  18 35 ) resistor r=5.4201 //w=0.17 //l=0.103078 //layer=li \
 //thickness=0.1 //x=19.84 //y=1.77 //x2=19.755 //y2=1.81
r59 (  18 35 ) resistor r=27.3797 //w=0.187 //l=0.4 //layer=li //thickness=0.1 \
 //x=19.84 //y=1.77 //x2=20.24 //y2=1.77
r60 (  17 35 ) resistor r=0.751729 //w=0.17 //l=0.085 //layer=li \
 //thickness=0.1 //x=20.64 //y=1.77 //x2=20.725 //y2=1.77
r61 (  17 35 ) resistor r=27.3797 //w=0.187 //l=0.4 //layer=li //thickness=0.1 \
 //x=20.64 //y=1.77 //x2=20.24 //y2=1.77
r62 (  14 35 ) resistor r=3.57586 //w=0.17 //l=0.103078 //layer=li \
 //thickness=0.1 //x=19.84 //y=0.72 //x2=19.755 //y2=0.68
r63 (  14 35 ) resistor r=27.3797 //w=0.187 //l=0.4 //layer=li //thickness=0.1 \
 //x=19.84 //y=0.72 //x2=20.24 //y2=0.72
r64 (  13 35 ) resistor r=0.751729 //w=0.17 //l=0.085 //layer=li \
 //thickness=0.1 //x=20.64 //y=0.72 //x2=20.725 //y2=0.72
r65 (  13 35 ) resistor r=27.3797 //w=0.187 //l=0.4 //layer=li //thickness=0.1 \
 //x=20.64 //y=0.72 //x2=20.24 //y2=0.72
r66 (  10 35 ) resistor r=1.40859 //w=0.34 //l=0.125 //layer=li \
 //thickness=0.1 //x=19.755 //y=1.685 //x2=19.755 //y2=1.81
r67 (  10 35 ) resistor r=42.0963 //w=0.187 //l=0.615 //layer=li \
 //thickness=0.1 //x=19.755 //y=1.685 //x2=19.755 //y2=1.07
r68 (  9 35 ) resistor r=3.57586 //w=0.17 //l=0.125 //layer=li //thickness=0.1 \
 //x=19.755 //y=0.805 //x2=19.755 //y2=0.68
r69 (  9 35 ) resistor r=18.139 //w=0.187 //l=0.265 //layer=li //thickness=0.1 \
 //x=19.755 //y=0.805 //x2=19.755 //y2=1.07
r70 (  6 35 ) resistor r=3.57586 //w=0.17 //l=0.103078 //layer=li \
 //thickness=0.1 //x=18.87 //y=1.77 //x2=18.785 //y2=1.81
r71 (  6 35 ) resistor r=27.3797 //w=0.187 //l=0.4 //layer=li //thickness=0.1 \
 //x=18.87 //y=1.77 //x2=19.27 //y2=1.77
r72 (  5 35 ) resistor r=5.4201 //w=0.17 //l=0.103078 //layer=li \
 //thickness=0.1 //x=19.67 //y=1.77 //x2=19.755 //y2=1.81
r73 (  5 35 ) resistor r=27.3797 //w=0.187 //l=0.4 //layer=li //thickness=0.1 \
 //x=19.67 //y=1.77 //x2=19.27 //y2=1.77
r74 (  1 35 ) resistor r=3.57586 //w=0.17 //l=0.125 //layer=li //thickness=0.1 \
 //x=18.785 //y=1.685 //x2=18.785 //y2=1.81
r75 (  1 35 ) resistor r=42.0963 //w=0.187 //l=0.615 //layer=li \
 //thickness=0.1 //x=18.785 //y=1.685 //x2=18.785 //y2=1.07
ends PM_DFFRNQNX1\%noxref_20

subckt PM_DFFRNQNX1\%noxref_21 ( 1 3 11 15 25 28 29 )
c53 ( 29 0 ) capacitor c=0.0430705f //x=21.16 //y=0.555
c54 ( 28 0 ) capacitor c=0.00457437f //x=20.055 //y=1.09
c55 ( 25 0 ) capacitor c=0.00156479f //x=21.295 //y=1.175
c56 ( 15 0 ) capacitor c=0.00737666f //x=22.265 //y=0.805
c57 ( 11 0 ) capacitor c=0.0148671f //x=22.18 //y=0.72
c58 ( 3 0 ) capacitor c=0.00718386f //x=21.295 //y=0.805
c59 ( 1 0 ) capacitor c=0.0252161f //x=21.21 //y=1.175
r60 (  15 29 ) resistor r=3.57586 //w=0.17 //l=0.125 //layer=li \
 //thickness=0.1 //x=22.265 //y=0.805 //x2=22.265 //y2=0.68
r61 (  15 29 ) resistor r=18.139 //w=0.187 //l=0.265 //layer=li \
 //thickness=0.1 //x=22.265 //y=0.805 //x2=22.265 //y2=1.07
r62 (  12 29 ) resistor r=3.57586 //w=0.17 //l=0.103078 //layer=li \
 //thickness=0.1 //x=21.38 //y=0.72 //x2=21.295 //y2=0.68
r63 (  12 29 ) resistor r=27.3797 //w=0.187 //l=0.4 //layer=li //thickness=0.1 \
 //x=21.38 //y=0.72 //x2=21.78 //y2=0.72
r64 (  11 29 ) resistor r=3.57586 //w=0.17 //l=0.103078 //layer=li \
 //thickness=0.1 //x=22.18 //y=0.72 //x2=22.265 //y2=0.68
r65 (  11 29 ) resistor r=27.3797 //w=0.187 //l=0.4 //layer=li //thickness=0.1 \
 //x=22.18 //y=0.72 //x2=21.78 //y2=0.72
r66 (  7 25 ) resistor r=5.4201 //w=0.17 //l=0.085 //layer=li //thickness=0.1 \
 //x=21.295 //y=1.26 //x2=21.295 //y2=1.175
r67 (  7 29 ) resistor r=10.2674 //w=0.187 //l=0.15 //layer=li //thickness=0.1 \
 //x=21.295 //y=1.26 //x2=21.295 //y2=1.41
r68 (  4 25 ) resistor r=5.4201 //w=0.17 //l=0.085 //layer=li //thickness=0.1 \
 //x=21.295 //y=1.09 //x2=21.295 //y2=1.175
r69 (  4 29 ) resistor r=1.36898 //w=0.187 //l=0.02 //layer=li //thickness=0.1 \
 //x=21.295 //y=1.09 //x2=21.295 //y2=1.07
r70 (  3 29 ) resistor r=3.57586 //w=0.17 //l=0.125 //layer=li //thickness=0.1 \
 //x=21.295 //y=0.805 //x2=21.295 //y2=0.68
r71 (  3 29 ) resistor r=18.139 //w=0.187 //l=0.265 //layer=li //thickness=0.1 \
 //x=21.295 //y=0.805 //x2=21.295 //y2=1.07
r72 (  2 28 ) resistor r=0.751729 //w=0.17 //l=0.085 //layer=li \
 //thickness=0.1 //x=20.33 //y=1.175 //x2=20.245 //y2=1.175
r73 (  1 25 ) resistor r=1.40859 //w=0.34 //l=0.085 //layer=li //thickness=0.1 \
 //x=21.21 //y=1.175 //x2=21.295 //y2=1.175
r74 (  1 2 ) resistor r=60.2353 //w=0.187 //l=0.88 //layer=li //thickness=0.1 \
 //x=21.21 //y=1.175 //x2=20.33 //y2=1.175
ends PM_DFFRNQNX1\%noxref_21

subckt PM_DFFRNQNX1\%noxref_22 ( 1 5 9 10 13 17 29 )
c51 ( 29 0 ) capacitor c=0.0637432f //x=23.565 //y=0.545
c52 ( 17 0 ) capacitor c=0.00722223f //x=25.64 //y=0.795
c53 ( 13 0 ) capacitor c=0.0149664f //x=25.555 //y=0.71
c54 ( 10 0 ) capacitor c=0.00687696f //x=24.67 //y=1.675
c55 ( 9 0 ) capacitor c=0.006761f //x=24.67 //y=0.795
c56 ( 5 0 ) capacitor c=0.0197321f //x=24.585 //y=1.76
c57 ( 1 0 ) capacitor c=0.00828748f //x=23.7 //y=1.675
r58 (  17 29 ) resistor r=3.57586 //w=0.17 //l=0.125 //layer=li \
 //thickness=0.1 //x=25.64 //y=0.795 //x2=25.64 //y2=0.67
r59 (  17 29 ) resistor r=18.139 //w=0.187 //l=0.265 //layer=li \
 //thickness=0.1 //x=25.64 //y=0.795 //x2=25.64 //y2=1.06
r60 (  14 29 ) resistor r=3.57586 //w=0.17 //l=0.103078 //layer=li \
 //thickness=0.1 //x=24.755 //y=0.71 //x2=24.67 //y2=0.67
r61 (  14 29 ) resistor r=27.3797 //w=0.187 //l=0.4 //layer=li //thickness=0.1 \
 //x=24.755 //y=0.71 //x2=25.155 //y2=0.71
r62 (  13 29 ) resistor r=3.57586 //w=0.17 //l=0.103078 //layer=li \
 //thickness=0.1 //x=25.555 //y=0.71 //x2=25.64 //y2=0.67
r63 (  13 29 ) resistor r=27.3797 //w=0.187 //l=0.4 //layer=li //thickness=0.1 \
 //x=25.555 //y=0.71 //x2=25.155 //y2=0.71
r64 (  10 29 ) resistor r=3.57586 //w=0.17 //l=0.125 //layer=li \
 //thickness=0.1 //x=24.67 //y=1.675 //x2=24.67 //y2=1.8
r65 (  10 29 ) resistor r=42.0963 //w=0.187 //l=0.615 //layer=li \
 //thickness=0.1 //x=24.67 //y=1.675 //x2=24.67 //y2=1.06
r66 (  9 29 ) resistor r=3.57586 //w=0.17 //l=0.125 //layer=li //thickness=0.1 \
 //x=24.67 //y=0.795 //x2=24.67 //y2=0.67
r67 (  9 29 ) resistor r=18.139 //w=0.187 //l=0.265 //layer=li //thickness=0.1 \
 //x=24.67 //y=0.795 //x2=24.67 //y2=1.06
r68 (  6 29 ) resistor r=3.57586 //w=0.17 //l=0.103078 //layer=li \
 //thickness=0.1 //x=23.785 //y=1.76 //x2=23.7 //y2=1.8
r69 (  6 29 ) resistor r=27.3797 //w=0.187 //l=0.4 //layer=li //thickness=0.1 \
 //x=23.785 //y=1.76 //x2=24.185 //y2=1.76
r70 (  5 29 ) resistor r=3.57586 //w=0.17 //l=0.103078 //layer=li \
 //thickness=0.1 //x=24.585 //y=1.76 //x2=24.67 //y2=1.8
r71 (  5 29 ) resistor r=27.3797 //w=0.187 //l=0.4 //layer=li //thickness=0.1 \
 //x=24.585 //y=1.76 //x2=24.185 //y2=1.76
r72 (  1 29 ) resistor r=3.57586 //w=0.17 //l=0.125 //layer=li //thickness=0.1 \
 //x=23.7 //y=1.675 //x2=23.7 //y2=1.8
r73 (  1 29 ) resistor r=42.0963 //w=0.187 //l=0.615 //layer=li \
 //thickness=0.1 //x=23.7 //y=1.675 //x2=23.7 //y2=1.06
ends PM_DFFRNQNX1\%noxref_22
