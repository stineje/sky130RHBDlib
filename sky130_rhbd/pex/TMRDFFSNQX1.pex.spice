// File: TMRDFFSNQX1.spi.pex
// Created: Fri Feb 20 10:16:23 2026
// Program "Calibre xRC"
// Version "v2023.2_27.15"
// Nominal Temperature: 30C
// Circuit Temperature: 30C
//
simulator lang=spectre
subckt PM_TMRDFFSNQX1\%noxref_1 ( 3 8 9 11 12 14 15 16 17 18 19 20 21 22 23 24 \
 27 28 31 33 36 43 47 54 55 57 64 65 68 76 93 102 107 116 120 121 122 123 124 \
 125 126 127 128 129 130 132 138 139 140 141 145 146 147 148 149 151 157 158 \
 159 160 180 182 183 )
c413 ( 180 0 ) capacitor c=0.00878249f //x=2.45 //y=1.085
c414 ( 160 0 ) capacitor c=0.0612936f //x=10.015 //y=4.97
c415 ( 159 0 ) capacitor c=0.0376642f //x=10.305 //y=4.97
c416 ( 158 0 ) capacitor c=0.0346489f //x=9.97 //y=1.4
c417 ( 157 0 ) capacitor c=0.018692f //x=9.97 //y=1.055
c418 ( 151 0 ) capacitor c=0.0137077f //x=9.815 //y=1.555
c419 ( 149 0 ) capacitor c=0.0158585f //x=9.815 //y=0.9
c420 ( 148 0 ) capacitor c=0.0979511f //x=9.44 //y=2.095
c421 ( 147 0 ) capacitor c=0.0229444f //x=9.44 //y=1.71
c422 ( 146 0 ) capacitor c=0.0234359f //x=9.44 //y=1.4
c423 ( 145 0 ) capacitor c=0.019815f //x=9.44 //y=1.055
c424 ( 141 0 ) capacitor c=0.0612936f //x=5.205 //y=4.97
c425 ( 140 0 ) capacitor c=0.0376642f //x=5.495 //y=4.97
c426 ( 139 0 ) capacitor c=0.0346489f //x=5.16 //y=1.4
c427 ( 138 0 ) capacitor c=0.018692f //x=5.16 //y=1.055
c428 ( 132 0 ) capacitor c=0.0137077f //x=5.005 //y=1.555
c429 ( 130 0 ) capacitor c=0.0158585f //x=5.005 //y=0.9
c430 ( 129 0 ) capacitor c=0.099553f //x=4.63 //y=2.095
c431 ( 128 0 ) capacitor c=0.0229444f //x=4.63 //y=1.71
c432 ( 127 0 ) capacitor c=0.0234359f //x=4.63 //y=1.4
c433 ( 126 0 ) capacitor c=0.019815f //x=4.63 //y=1.055
c434 ( 125 0 ) capacitor c=0.110208f //x=10.38 //y=6.2
c435 ( 124 0 ) capacitor c=0.158957f //x=9.94 //y=6.2
c436 ( 123 0 ) capacitor c=0.110208f //x=5.57 //y=6.2
c437 ( 122 0 ) capacitor c=0.158957f //x=5.13 //y=6.2
c438 ( 116 0 ) capacitor c=0.0014751f //x=9.74 //y=4.88
c439 ( 107 0 ) capacitor c=9.93222e-19 //x=9.74 //y=2.26
c440 ( 102 0 ) capacitor c=0.0014751f //x=4.93 //y=4.88
c441 ( 93 0 ) capacitor c=9.93222e-19 //x=4.93 //y=2.26
c442 ( 76 0 ) capacitor c=0.0322017f //x=2.6 //y=5.56
c443 ( 68 0 ) capacitor c=0.0291338f //x=1.72 //y=5.56
c444 ( 65 0 ) capacitor c=0.0936548f //x=9.58 //y=2.775
c445 ( 64 0 ) capacitor c=0.00250142f //x=9.74 //y=2.775
c446 ( 57 0 ) capacitor c=0.0025105f //x=5.09 //y=2.77
c447 ( 55 0 ) capacitor c=0.00278714f //x=3.24 //y=2.77
c448 ( 54 0 ) capacitor c=0.0351844f //x=4.77 //y=2.77
c449 ( 47 0 ) capacitor c=0.0154699f //x=9.74 //y=2.77
c450 ( 43 0 ) capacitor c=0.0146914f //x=4.93 //y=2.765
c451 ( 36 0 ) capacitor c=0.0146635f //x=3.08 //y=2.77
c452 ( 33 0 ) capacitor c=0.0115709f //x=2.64 //y=1.18
c453 ( 31 0 ) capacitor c=5.78613e-19 //x=2.6 //y=5.56
c454 ( 28 0 ) capacitor c=0.0112565f //x=2.6 //y=5.38
c455 ( 27 0 ) capacitor c=0.00938035f //x=1.72 //y=5.56
c456 ( 24 0 ) capacitor c=0.0642737f //x=9.74 //y=4.755
c457 ( 23 0 ) capacitor c=0.0130124f //x=9.74 //y=2.935
c458 ( 22 0 ) capacitor c=0.0052305f //x=9.74 //y=2.615
c459 ( 21 0 ) capacitor c=0.00635496f //x=9.74 //y=2.375
c460 ( 20 0 ) capacitor c=0.0669671f //x=4.93 //y=4.755
c461 ( 19 0 ) capacitor c=0.0130093f //x=4.93 //y=2.93
c462 ( 18 0 ) capacitor c=0.00604005f //x=4.93 //y=2.61
c463 ( 17 0 ) capacitor c=0.00638932f //x=4.93 //y=2.375
c464 ( 16 0 ) capacitor c=0.0706561f //x=3.08 //y=5.295
c465 ( 15 0 ) capacitor c=0.0120692f //x=3.08 //y=2.93
c466 ( 14 0 ) capacitor c=0.0182566f //x=3.08 //y=2.61
c467 ( 12 0 ) capacitor c=0.00727246f //x=2.725 //y=1.835
c468 ( 11 0 ) capacitor c=0.0135366f //x=2.995 //y=1.835
c469 ( 9 0 ) capacitor c=0.0122194f //x=2.995 //y=5.38
c470 ( 8 0 ) capacitor c=0.0167748f //x=2.64 //y=1.75
c471 ( 3 0 ) capacitor c=0.015247f //x=2.485 //y=5.38
r472 (  159 161 ) resistor r=26.9307 //w=0.15 //l=0.106066 //layer=ply \
 //thickness=0.18 //x=10.305 //y=4.97 //x2=10.38 //y2=5.045
r473 (  159 160 ) resistor r=148.702 //w=0.094 //l=0.29 //layer=ply \
 //thickness=0.18 //x=10.305 //y=4.97 //x2=10.015 //y2=4.97
r474 (  158 179 ) resistor r=45.1352 //w=0.168 //l=0.173853 //layer=ply \
 //thickness=0.18 //x=9.97 //y=1.4 //x2=9.93 //y2=1.555
r475 (  157 178 ) resistor r=45.1352 //w=0.168 //l=0.173853 //layer=ply \
 //thickness=0.18 //x=9.97 //y=1.055 //x2=9.93 //y2=0.9
r476 (  157 158 ) resistor r=176.904 //w=0.094 //l=0.345 //layer=ply \
 //thickness=0.18 //x=9.97 //y=1.055 //x2=9.97 //y2=1.4
r477 (  154 160 ) resistor r=22.7971 //w=0.269 //l=0.106066 //layer=ply \
 //thickness=0.18 //x=9.94 //y=5.045 //x2=10.015 //y2=4.97
r478 (  154 177 ) resistor r=35.8364 //w=0.269 //l=0.270185 //layer=ply \
 //thickness=0.18 //x=9.94 //y=5.045 //x2=9.74 //y2=4.88
r479 (  152 173 ) resistor r=10.701 //w=0.21 //l=0.115 //layer=ply \
 //thickness=0.18 //x=9.595 //y=1.555 //x2=9.48 //y2=1.555
r480 (  151 179 ) resistor r=5.52526 //w=0.168 //l=0.115 //layer=ply \
 //thickness=0.18 //x=9.815 //y=1.555 //x2=9.93 //y2=1.555
r481 (  150 172 ) resistor r=5.52526 //w=0.168 //l=0.115 //layer=ply \
 //thickness=0.18 //x=9.595 //y=0.9 //x2=9.48 //y2=0.9
r482 (  149 178 ) resistor r=5.52526 //w=0.168 //l=0.115 //layer=ply \
 //thickness=0.18 //x=9.815 //y=0.9 //x2=9.93 //y2=0.9
r483 (  149 150 ) resistor r=112.809 //w=0.094 //l=0.22 //layer=ply \
 //thickness=0.18 //x=9.815 //y=0.9 //x2=9.595 //y2=0.9
r484 (  148 175 ) resistor r=58.7805 //w=0.246 //l=0.373497 //layer=ply \
 //thickness=0.18 //x=9.44 //y=2.095 //x2=9.74 //y2=2.26
r485 (  147 173 ) resistor r=39.5823 //w=0.21 //l=0.173853 //layer=ply \
 //thickness=0.18 //x=9.44 //y=1.71 //x2=9.48 //y2=1.555
r486 (  147 148 ) resistor r=197.415 //w=0.094 //l=0.385 //layer=ply \
 //thickness=0.18 //x=9.44 //y=1.71 //x2=9.44 //y2=2.095
r487 (  146 173 ) resistor r=39.5823 //w=0.21 //l=0.173853 //layer=ply \
 //thickness=0.18 //x=9.44 //y=1.4 //x2=9.48 //y2=1.555
r488 (  145 172 ) resistor r=45.1352 //w=0.168 //l=0.173853 //layer=ply \
 //thickness=0.18 //x=9.44 //y=1.055 //x2=9.48 //y2=0.9
r489 (  145 146 ) resistor r=176.904 //w=0.094 //l=0.345 //layer=ply \
 //thickness=0.18 //x=9.44 //y=1.055 //x2=9.44 //y2=1.4
r490 (  140 142 ) resistor r=26.9307 //w=0.15 //l=0.106066 //layer=ply \
 //thickness=0.18 //x=5.495 //y=4.97 //x2=5.57 //y2=5.045
r491 (  140 141 ) resistor r=148.702 //w=0.094 //l=0.29 //layer=ply \
 //thickness=0.18 //x=5.495 //y=4.97 //x2=5.205 //y2=4.97
r492 (  139 171 ) resistor r=45.1352 //w=0.168 //l=0.173853 //layer=ply \
 //thickness=0.18 //x=5.16 //y=1.4 //x2=5.12 //y2=1.555
r493 (  138 170 ) resistor r=45.1352 //w=0.168 //l=0.173853 //layer=ply \
 //thickness=0.18 //x=5.16 //y=1.055 //x2=5.12 //y2=0.9
r494 (  138 139 ) resistor r=176.904 //w=0.094 //l=0.345 //layer=ply \
 //thickness=0.18 //x=5.16 //y=1.055 //x2=5.16 //y2=1.4
r495 (  135 141 ) resistor r=22.7971 //w=0.269 //l=0.106066 //layer=ply \
 //thickness=0.18 //x=5.13 //y=5.045 //x2=5.205 //y2=4.97
r496 (  135 169 ) resistor r=35.8364 //w=0.269 //l=0.270185 //layer=ply \
 //thickness=0.18 //x=5.13 //y=5.045 //x2=4.93 //y2=4.88
r497 (  133 165 ) resistor r=10.701 //w=0.21 //l=0.115 //layer=ply \
 //thickness=0.18 //x=4.785 //y=1.555 //x2=4.67 //y2=1.555
r498 (  132 171 ) resistor r=5.52526 //w=0.168 //l=0.115 //layer=ply \
 //thickness=0.18 //x=5.005 //y=1.555 //x2=5.12 //y2=1.555
r499 (  131 164 ) resistor r=5.52526 //w=0.168 //l=0.115 //layer=ply \
 //thickness=0.18 //x=4.785 //y=0.9 //x2=4.67 //y2=0.9
r500 (  130 170 ) resistor r=5.52526 //w=0.168 //l=0.115 //layer=ply \
 //thickness=0.18 //x=5.005 //y=0.9 //x2=5.12 //y2=0.9
r501 (  130 131 ) resistor r=112.809 //w=0.094 //l=0.22 //layer=ply \
 //thickness=0.18 //x=5.005 //y=0.9 //x2=4.785 //y2=0.9
r502 (  129 167 ) resistor r=58.7805 //w=0.246 //l=0.373497 //layer=ply \
 //thickness=0.18 //x=4.63 //y=2.095 //x2=4.93 //y2=2.26
r503 (  128 165 ) resistor r=39.5823 //w=0.21 //l=0.173853 //layer=ply \
 //thickness=0.18 //x=4.63 //y=1.71 //x2=4.67 //y2=1.555
r504 (  128 129 ) resistor r=197.415 //w=0.094 //l=0.385 //layer=ply \
 //thickness=0.18 //x=4.63 //y=1.71 //x2=4.63 //y2=2.095
r505 (  127 165 ) resistor r=39.5823 //w=0.21 //l=0.173853 //layer=ply \
 //thickness=0.18 //x=4.63 //y=1.4 //x2=4.67 //y2=1.555
r506 (  126 164 ) resistor r=45.1352 //w=0.168 //l=0.173853 //layer=ply \
 //thickness=0.18 //x=4.63 //y=1.055 //x2=4.67 //y2=0.9
r507 (  126 127 ) resistor r=176.904 //w=0.094 //l=0.345 //layer=ply \
 //thickness=0.18 //x=4.63 //y=1.055 //x2=4.63 //y2=1.4
r508 (  125 161 ) resistor r=592.245 //w=0.094 //l=1.155 //layer=ply \
 //thickness=0.18 //x=10.38 //y=6.2 //x2=10.38 //y2=5.045
r509 (  124 154 ) resistor r=592.245 //w=0.094 //l=1.155 //layer=ply \
 //thickness=0.18 //x=9.94 //y=6.2 //x2=9.94 //y2=5.045
r510 (  123 142 ) resistor r=592.245 //w=0.094 //l=1.155 //layer=ply \
 //thickness=0.18 //x=5.57 //y=6.2 //x2=5.57 //y2=5.045
r511 (  122 135 ) resistor r=592.245 //w=0.094 //l=1.155 //layer=ply \
 //thickness=0.18 //x=5.13 //y=6.2 //x2=5.13 //y2=5.045
r512 (  121 151 ) resistor r=56.4043 //w=0.094 //l=0.11 //layer=ply \
 //thickness=0.18 //x=9.705 //y=1.555 //x2=9.815 //y2=1.555
r513 (  121 152 ) resistor r=56.4043 //w=0.094 //l=0.11 //layer=ply \
 //thickness=0.18 //x=9.705 //y=1.555 //x2=9.595 //y2=1.555
r514 (  120 132 ) resistor r=56.4043 //w=0.094 //l=0.11 //layer=ply \
 //thickness=0.18 //x=4.895 //y=1.555 //x2=5.005 //y2=1.555
r515 (  120 133 ) resistor r=56.4043 //w=0.094 //l=0.11 //layer=ply \
 //thickness=0.18 //x=4.895 //y=1.555 //x2=4.785 //y2=1.555
r516 (  116 177 ) resistor r=152 //w=0.17 //l=0.17 //layer=licon //count=1 \
 //x=9.74 //y=4.88 //x2=9.74 //y2=4.88
r517 (  107 175 ) resistor r=152 //w=0.17 //l=0.17 //layer=licon //count=1 \
 //x=9.74 //y=2.26 //x2=9.74 //y2=2.26
r518 (  102 169 ) resistor r=152 //w=0.17 //l=0.17 //layer=licon //count=1 \
 //x=4.93 //y=4.88 //x2=4.93 //y2=4.88
r519 (  93 167 ) resistor r=152 //w=0.17 //l=0.17 //layer=licon //count=1 \
 //x=4.93 //y=2.26 //x2=4.93 //y2=2.26
r520 (  76 183 ) resistor r=23.615 //w=0.187 //l=0.345 //layer=li \
 //thickness=0.1 //x=2.6 //y=5.56 //x2=2.6 //y2=5.905
r521 (  68 182 ) resistor r=23.615 //w=0.187 //l=0.345 //layer=li \
 //thickness=0.1 //x=1.72 //y=5.56 //x2=1.72 //y2=5.905
r522 (  64 65 ) resistor r=0.10734 //w=0.281 //l=0.16 //layer=m2 \
 //thickness=0.36 //x=9.74 //y=2.775 //x2=9.58 //y2=2.775
r523 (  57 62 ) resistor r=0.10734 //w=0.281 //l=0.16 //layer=m2 \
 //thickness=0.36 //x=5.09 //y=2.77 //x2=4.93 //y2=2.77
r524 (  57 65 ) resistor r=4.28435 //w=0.131 //l=4.49 //layer=m2 \
 //thickness=0.36 //x=5.09 //y=2.77 //x2=9.58 //y2=2.77
r525 (  55 59 ) resistor r=0.10734 //w=0.281 //l=0.16 //layer=m2 \
 //thickness=0.36 //x=3.24 //y=2.77 //x2=3.08 //y2=2.77
r526 (  54 62 ) resistor r=0.10734 //w=0.281 //l=0.16 //layer=m2 \
 //thickness=0.36 //x=4.77 //y=2.77 //x2=4.93 //y2=2.77
r527 (  54 55 ) resistor r=1.45992 //w=0.131 //l=1.53 //layer=m2 \
 //thickness=0.36 //x=4.77 //y=2.77 //x2=3.24 //y2=2.77
r528 (  53 116 ) resistor r=9.3 //w=0.17 //l=0.17 //layer=mcon //count=1 \
 //x=9.74 //y=4.88 //x2=9.74 //y2=4.88
r529 (  51 107 ) resistor r=9.3 //w=0.17 //l=0.17 //layer=mcon //count=1 \
 //x=9.74 //y=2.26 //x2=9.74 //y2=2.26
r530 (  49 64 ) resistor r=4.5 //w=0.15 //l=0.15 //layer=via1 //count=1 \
 //x=9.74 //y=2.775 //x2=9.74 //y2=2.775
r531 (  47 49 ) resistor r=0.00166223 //w=0.376 //l=0.005 //layer=m1 \
 //thickness=0.36 //x=9.687 //y=2.77 //x2=9.687 //y2=2.775
r532 (  45 62 ) resistor r=4.5 //w=0.15 //l=0.15 //layer=via1 //count=1 \
 //x=4.93 //y=2.77 //x2=4.93 //y2=2.77
r533 (  43 45 ) resistor r=0.00166223 //w=0.376 //l=0.005 //layer=m1 \
 //thickness=0.36 //x=4.982 //y=2.765 //x2=4.982 //y2=2.77
r534 (  41 102 ) resistor r=9.3 //w=0.17 //l=0.17 //layer=mcon //count=1 \
 //x=4.93 //y=4.88 //x2=4.93 //y2=4.88
r535 (  39 93 ) resistor r=9.3 //w=0.17 //l=0.17 //layer=mcon //count=1 \
 //x=4.93 //y=2.26 //x2=4.93 //y2=2.26
r536 (  36 59 ) resistor r=4.5 //w=0.15 //l=0.15 //layer=via1 //count=1 \
 //x=3.08 //y=2.77 //x2=3.08 //y2=2.77
r537 (  33 180 ) resistor r=9.3 //w=0.17 //l=0.17 //layer=mcon //count=1 \
 //x=2.64 //y=1.18 //x2=2.64 //y2=1.18
r538 (  31 76 ) resistor r=9.3 //w=0.17 //l=0.17 //layer=mcon //count=1 \
 //x=2.6 //y=5.56 //x2=2.6 //y2=5.56
r539 (  28 31 ) resistor r=0.117801 //w=0.191 //l=0.18 //layer=m1 \
 //thickness=0.36 //x=2.6 //y=5.38 //x2=2.6 //y2=5.56
r540 (  27 68 ) resistor r=9.3 //w=0.17 //l=0.17 //layer=mcon //count=1 \
 //x=1.72 //y=5.56 //x2=1.72 //y2=5.56
r541 (  25 27 ) resistor r=0.10274 //w=0.219 //l=0.18 //layer=m1 \
 //thickness=0.36 //x=1.72 //y=5.38 //x2=1.72 //y2=5.56
r542 (  24 53 ) resistor r=0.0760407 //w=0.238 //l=0.125 //layer=m1 \
 //thickness=0.36 //x=9.74 //y=4.755 //x2=9.74 //y2=4.88
r543 (  23 49 ) resistor r=0.0911593 //w=0.376 //l=0.184608 //layer=m1 \
 //thickness=0.36 //x=9.74 //y=2.935 //x2=9.687 //y2=2.775
r544 (  23 24 ) resistor r=1.73664 //w=0.131 //l=1.82 //layer=m1 \
 //thickness=0.36 //x=9.74 //y=2.935 //x2=9.74 //y2=4.755
r545 (  22 47 ) resistor r=0.0894971 //w=0.376 //l=0.179555 //layer=m1 \
 //thickness=0.36 //x=9.74 //y=2.615 //x2=9.687 //y2=2.77
r546 (  21 51 ) resistor r=0.0719237 //w=0.222 //l=0.115 //layer=m1 \
 //thickness=0.36 //x=9.74 //y=2.375 //x2=9.74 //y2=2.26
r547 (  21 22 ) resistor r=0.229008 //w=0.131 //l=0.24 //layer=m1 \
 //thickness=0.36 //x=9.74 //y=2.375 //x2=9.74 //y2=2.615
r548 (  20 41 ) resistor r=0.0760407 //w=0.238 //l=0.125 //layer=m1 \
 //thickness=0.36 //x=4.93 //y=4.755 //x2=4.93 //y2=4.88
r549 (  19 45 ) resistor r=0.0911593 //w=0.376 //l=0.184174 //layer=m1 \
 //thickness=0.36 //x=4.93 //y=2.93 //x2=4.982 //y2=2.77
r550 (  19 20 ) resistor r=1.74141 //w=0.131 //l=1.825 //layer=m1 \
 //thickness=0.36 //x=4.93 //y=2.93 //x2=4.93 //y2=4.755
r551 (  18 43 ) resistor r=0.0894971 //w=0.376 //l=0.179123 //layer=m1 \
 //thickness=0.36 //x=4.93 //y=2.61 //x2=4.982 //y2=2.765
r552 (  17 39 ) resistor r=0.0719237 //w=0.222 //l=0.115 //layer=m1 \
 //thickness=0.36 //x=4.93 //y=2.375 //x2=4.93 //y2=2.26
r553 (  17 18 ) resistor r=0.224237 //w=0.131 //l=0.235 //layer=m1 \
 //thickness=0.36 //x=4.93 //y=2.375 //x2=4.93 //y2=2.61
r554 (  15 36 ) resistor r=0.0911593 //w=0.376 //l=0.184174 //layer=m1 \
 //thickness=0.36 //x=3.08 //y=2.93 //x2=3.132 //y2=2.77
r555 (  15 16 ) resistor r=2.25668 //w=0.131 //l=2.365 //layer=m1 \
 //thickness=0.36 //x=3.08 //y=2.93 //x2=3.08 //y2=5.295
r556 (  14 36 ) resistor r=0.0911593 //w=0.376 //l=0.184174 //layer=m1 \
 //thickness=0.36 //x=3.08 //y=2.61 //x2=3.132 //y2=2.77
r557 (  13 14 ) resistor r=0.658397 //w=0.131 //l=0.69 //layer=m1 \
 //thickness=0.36 //x=3.08 //y=1.92 //x2=3.08 //y2=2.61
r558 (  11 13 ) resistor r=0.0698411 //w=0.17 //l=0.120208 //layer=m1 \
 //thickness=0.36 //x=2.995 //y=1.835 //x2=3.08 //y2=1.92
r559 (  11 12 ) resistor r=0.257634 //w=0.131 //l=0.27 //layer=m1 \
 //thickness=0.36 //x=2.995 //y=1.835 //x2=2.725 //y2=1.835
r560 (  10 28 ) resistor r=0.0257089 //w=0.23 //l=0.115 //layer=m1 \
 //thickness=0.36 //x=2.715 //y=5.38 //x2=2.6 //y2=5.38
r561 (  9 16 ) resistor r=0.0698411 //w=0.17 //l=0.120208 //layer=m1 \
 //thickness=0.36 //x=2.995 //y=5.38 //x2=3.08 //y2=5.295
r562 (  9 10 ) resistor r=0.267176 //w=0.131 //l=0.28 //layer=m1 \
 //thickness=0.36 //x=2.995 //y=5.38 //x2=2.715 //y2=5.38
r563 (  8 12 ) resistor r=0.0698411 //w=0.17 //l=0.120208 //layer=m1 \
 //thickness=0.36 //x=2.64 //y=1.75 //x2=2.725 //y2=1.835
r564 (  7 33 ) resistor r=0.0913624 //w=0.191 //l=0.12 //layer=m1 \
 //thickness=0.36 //x=2.64 //y=1.3 //x2=2.64 //y2=1.18
r565 (  7 8 ) resistor r=0.429389 //w=0.131 //l=0.45 //layer=m1 \
 //thickness=0.36 //x=2.64 //y=1.3 //x2=2.64 //y2=1.75
r566 (  4 25 ) resistor r=0.0227762 //w=0.219 //l=0.115 //layer=m1 \
 //thickness=0.36 //x=1.835 //y=5.38 //x2=1.72 //y2=5.38
r567 (  3 28 ) resistor r=0.0257089 //w=0.23 //l=0.115 //layer=m1 \
 //thickness=0.36 //x=2.485 //y=5.38 //x2=2.6 //y2=5.38
r568 (  3 4 ) resistor r=0.620229 //w=0.131 //l=0.65 //layer=m1 \
 //thickness=0.36 //x=2.485 //y=5.38 //x2=1.835 //y2=5.38
ends PM_TMRDFFSNQX1\%noxref_1

subckt PM_TMRDFFSNQX1\%noxref_2 ( 1 3 6 7 9 10 11 12 14 15 16 18 19 21 24 27 \
 33 37 41 44 45 52 54 55 58 66 74 91 100 104 105 106 107 108 109 110 114 116 \
 119 120 130 133 135 136 137 )
c297 ( 133 0 ) capacitor c=0.00885916f //x=12.025 //y=1.095
c298 ( 130 0 ) capacitor c=0.0682508f //x=14.55 //y=4.88
c299 ( 120 0 ) capacitor c=0.0318956f //x=14.885 //y=1.39
c300 ( 119 0 ) capacitor c=0.0186809f //x=14.885 //y=1.045
c301 ( 116 0 ) capacitor c=0.0141821f //x=14.73 //y=1.545
c302 ( 114 0 ) capacitor c=0.0158553f //x=14.73 //y=0.89
c303 ( 110 0 ) capacitor c=0.0815114f //x=14.355 //y=2.095
c304 ( 109 0 ) capacitor c=0.0229235f //x=14.355 //y=1.7
c305 ( 108 0 ) capacitor c=0.0234359f //x=14.355 //y=1.39
c306 ( 107 0 ) capacitor c=0.0198759f //x=14.355 //y=1.045
c307 ( 106 0 ) capacitor c=0.110369f //x=14.89 //y=6.2
c308 ( 105 0 ) capacitor c=0.154619f //x=14.45 //y=6.2
c309 ( 100 0 ) capacitor c=8.13425e-19 //x=14.55 //y=4.88
c310 ( 91 0 ) capacitor c=5.17312e-19 //x=14.55 //y=2.26
c311 ( 74 0 ) capacitor c=0.0293219f //x=11.92 //y=5.56
c312 ( 66 0 ) capacitor c=0.029137f //x=11.04 //y=5.56
c313 ( 58 0 ) capacitor c=0.0278099f //x=10.16 //y=5.56
c314 ( 55 0 ) capacitor c=0.0156383f //x=14.385 //y=2.785
c315 ( 54 0 ) capacitor c=6.75833e-19 //x=14.545 //y=2.785
c316 ( 52 0 ) capacitor c=9.41304e-19 //x=12.86 //y=2.785
c317 ( 45 0 ) capacitor c=0.0515599f //x=14.552 //y=4.74
c318 ( 44 0 ) capacitor c=0.00631721f //x=14.55 //y=4.88
c319 ( 41 0 ) capacitor c=0.00463527f //x=14.55 //y=2.26
c320 ( 37 0 ) capacitor c=0.0145985f //x=14.55 //y=2.77
c321 ( 33 0 ) capacitor c=0.0149529f //x=12.7 //y=2.77
c322 ( 27 0 ) capacitor c=8.88597e-19 //x=11.92 //y=5.335
c323 ( 24 0 ) capacitor c=0.00796615f //x=11.04 //y=5.335
c324 ( 21 0 ) capacitor c=0.0111234f //x=10.162 //y=5.335
c325 ( 19 0 ) capacitor c=0.0120345f //x=14.55 //y=2.945
c326 ( 18 0 ) capacitor c=0.00384658f //x=14.55 //y=2.625
c327 ( 16 0 ) capacitor c=0.0658347f //x=12.7 //y=5.25
c328 ( 15 0 ) capacitor c=0.0123676f //x=12.7 //y=2.945
c329 ( 14 0 ) capacitor c=0.0168574f //x=12.7 //y=2.625
c330 ( 12 0 ) capacitor c=0.00493487f //x=12.3 //y=1.845
c331 ( 11 0 ) capacitor c=0.0126211f //x=12.615 //y=1.845
c332 ( 10 0 ) capacitor c=0.0136149f //x=12.215 //y=1.76
c333 ( 9 0 ) capacitor c=0.0113786f //x=12.215 //y=1.305
c334 ( 7 0 ) capacitor c=0.0235567f //x=12.615 //y=5.335
c335 ( 6 0 ) capacitor c=0.00906713f //x=11.92 //y=5.56
c336 ( 3 0 ) capacitor c=0.0180822f //x=11.805 //y=5.335
c337 ( 1 0 ) capacitor c=0.0152149f //x=10.92 //y=5.335
r338 (  128 130 ) resistor r=20.6867 //w=0.233 //l=0.1 //layer=ply \
 //thickness=0.18 //x=14.45 //y=4.88 //x2=14.55 //y2=4.88
r339 (  121 130 ) resistor r=70.3348 //w=0.233 //l=0.414367 //layer=ply \
 //thickness=0.18 //x=14.89 //y=5.045 //x2=14.55 //y2=4.88
r340 (  120 132 ) resistor r=45.1352 //w=0.168 //l=0.173853 //layer=ply \
 //thickness=0.18 //x=14.885 //y=1.39 //x2=14.845 //y2=1.545
r341 (  119 131 ) resistor r=45.1352 //w=0.168 //l=0.173853 //layer=ply \
 //thickness=0.18 //x=14.885 //y=1.045 //x2=14.845 //y2=0.89
r342 (  119 120 ) resistor r=176.904 //w=0.094 //l=0.345 //layer=ply \
 //thickness=0.18 //x=14.885 //y=1.045 //x2=14.885 //y2=1.39
r343 (  117 127 ) resistor r=10.701 //w=0.21 //l=0.115 //layer=ply \
 //thickness=0.18 //x=14.51 //y=1.545 //x2=14.395 //y2=1.545
r344 (  116 132 ) resistor r=5.52526 //w=0.168 //l=0.115 //layer=ply \
 //thickness=0.18 //x=14.73 //y=1.545 //x2=14.845 //y2=1.545
r345 (  115 126 ) resistor r=5.52526 //w=0.168 //l=0.115 //layer=ply \
 //thickness=0.18 //x=14.51 //y=0.89 //x2=14.395 //y2=0.89
r346 (  114 131 ) resistor r=5.52526 //w=0.168 //l=0.115 //layer=ply \
 //thickness=0.18 //x=14.73 //y=0.89 //x2=14.845 //y2=0.89
r347 (  114 115 ) resistor r=112.809 //w=0.094 //l=0.22 //layer=ply \
 //thickness=0.18 //x=14.73 //y=0.89 //x2=14.51 //y2=0.89
r348 (  111 128 ) resistor r=13.0941 //w=0.233 //l=0.165 //layer=ply \
 //thickness=0.18 //x=14.45 //y=5.045 //x2=14.45 //y2=4.88
r349 (  110 125 ) resistor r=34.8111 //w=0.27 //l=0.264953 //layer=ply \
 //thickness=0.18 //x=14.355 //y=2.095 //x2=14.55 //y2=2.26
r350 (  109 127 ) resistor r=39.5823 //w=0.21 //l=0.173853 //layer=ply \
 //thickness=0.18 //x=14.355 //y=1.7 //x2=14.395 //y2=1.545
r351 (  109 110 ) resistor r=202.543 //w=0.094 //l=0.395 //layer=ply \
 //thickness=0.18 //x=14.355 //y=1.7 //x2=14.355 //y2=2.095
r352 (  108 127 ) resistor r=39.5823 //w=0.21 //l=0.173853 //layer=ply \
 //thickness=0.18 //x=14.355 //y=1.39 //x2=14.395 //y2=1.545
r353 (  107 126 ) resistor r=45.1352 //w=0.168 //l=0.173853 //layer=ply \
 //thickness=0.18 //x=14.355 //y=1.045 //x2=14.395 //y2=0.89
r354 (  107 108 ) resistor r=176.904 //w=0.094 //l=0.345 //layer=ply \
 //thickness=0.18 //x=14.355 //y=1.045 //x2=14.355 //y2=1.39
r355 (  106 121 ) resistor r=592.245 //w=0.094 //l=1.155 //layer=ply \
 //thickness=0.18 //x=14.89 //y=6.2 //x2=14.89 //y2=5.045
r356 (  105 111 ) resistor r=592.245 //w=0.094 //l=1.155 //layer=ply \
 //thickness=0.18 //x=14.45 //y=6.2 //x2=14.45 //y2=5.045
r357 (  104 116 ) resistor r=56.4043 //w=0.094 //l=0.11 //layer=ply \
 //thickness=0.18 //x=14.62 //y=1.545 //x2=14.73 //y2=1.545
r358 (  104 117 ) resistor r=56.4043 //w=0.094 //l=0.11 //layer=ply \
 //thickness=0.18 //x=14.62 //y=1.545 //x2=14.51 //y2=1.545
r359 (  100 130 ) resistor r=152 //w=0.17 //l=0.17 //layer=licon //count=1 \
 //x=14.55 //y=4.88 //x2=14.55 //y2=4.88
r360 (  91 125 ) resistor r=152 //w=0.17 //l=0.17 //layer=licon //count=1 \
 //x=14.55 //y=2.26 //x2=14.55 //y2=2.26
r361 (  74 137 ) resistor r=23.615 //w=0.187 //l=0.345 //layer=li \
 //thickness=0.1 //x=11.92 //y=5.56 //x2=11.92 //y2=5.905
r362 (  66 136 ) resistor r=23.615 //w=0.187 //l=0.345 //layer=li \
 //thickness=0.1 //x=11.04 //y=5.56 //x2=11.04 //y2=5.905
r363 (  58 135 ) resistor r=23.615 //w=0.187 //l=0.345 //layer=li \
 //thickness=0.1 //x=10.16 //y=5.56 //x2=10.16 //y2=5.905
r364 (  54 55 ) resistor r=0.10734 //w=0.281 //l=0.16 //layer=m2 \
 //thickness=0.36 //x=14.545 //y=2.785 //x2=14.385 //y2=2.785
r365 (  52 55 ) resistor r=1.45515 //w=0.131 //l=1.525 //layer=m2 \
 //thickness=0.36 //x=12.86 //y=2.77 //x2=14.385 //y2=2.77
r366 (  50 52 ) resistor r=0.10734 //w=0.281 //l=0.16 //layer=m2 \
 //thickness=0.36 //x=12.7 //y=2.785 //x2=12.86 //y2=2.785
r367 (  44 100 ) resistor r=9.3 //w=0.17 //l=0.17 //layer=mcon //count=1 \
 //x=14.55 //y=4.88 //x2=14.55 //y2=4.88
r368 (  44 45 ) resistor r=0.103207 //w=0.196 //l=0.14 //layer=m1 \
 //thickness=0.36 //x=14.552 //y=4.88 //x2=14.552 //y2=4.74
r369 (  41 91 ) resistor r=9.3 //w=0.17 //l=0.17 //layer=mcon //count=1 \
 //x=14.55 //y=2.26 //x2=14.55 //y2=2.26
r370 (  39 54 ) resistor r=4.5 //w=0.15 //l=0.15 //layer=via1 //count=1 \
 //x=14.545 //y=2.785 //x2=14.545 //y2=2.785
r371 (  37 39 ) resistor r=0.00501337 //w=0.374 //l=0.015 //layer=m1 \
 //thickness=0.36 //x=14.495 //y=2.77 //x2=14.495 //y2=2.785
r372 (  35 50 ) resistor r=4.5 //w=0.15 //l=0.15 //layer=via1 //count=1 \
 //x=12.7 //y=2.785 //x2=12.7 //y2=2.785
r373 (  33 35 ) resistor r=0.0049867 //w=0.376 //l=0.015 //layer=m1 \
 //thickness=0.36 //x=12.752 //y=2.77 //x2=12.752 //y2=2.785
r374 (  31 133 ) resistor r=9.3 //w=0.17 //l=0.17 //layer=mcon //count=1 \
 //x=12.215 //y=1.19 //x2=12.215 //y2=1.19
r375 (  29 74 ) resistor r=9.3 //w=0.17 //l=0.17 //layer=mcon //count=1 \
 //x=11.92 //y=5.56 //x2=11.92 //y2=5.56
r376 (  26 66 ) resistor r=9.3 //w=0.17 //l=0.17 //layer=mcon //count=1 \
 //x=11.04 //y=5.56 //x2=11.04 //y2=5.56
r377 (  24 26 ) resistor r=0.121228 //w=0.232 //l=0.225 //layer=m1 \
 //thickness=0.36 //x=11.04 //y=5.335 //x2=11.04 //y2=5.56
r378 (  23 58 ) resistor r=9.3 //w=0.17 //l=0.17 //layer=mcon //count=1 \
 //x=10.16 //y=5.56 //x2=10.16 //y2=5.56
r379 (  21 23 ) resistor r=0.129608 //w=0.217 //l=0.225 //layer=m1 \
 //thickness=0.36 //x=10.162 //y=5.335 //x2=10.162 //y2=5.56
r380 (  19 39 ) resistor r=0.0910802 //w=0.374 //l=0.185472 //layer=m1 \
 //thickness=0.36 //x=14.55 //y=2.945 //x2=14.495 //y2=2.785
r381 (  19 45 ) resistor r=1.71279 //w=0.131 //l=1.795 //layer=m1 \
 //thickness=0.36 //x=14.55 //y=2.945 //x2=14.55 //y2=4.74
r382 (  18 37 ) resistor r=0.0860668 //w=0.374 //l=0.170294 //layer=m1 \
 //thickness=0.36 //x=14.55 //y=2.625 //x2=14.495 //y2=2.77
r383 (  17 41 ) resistor r=0.0933015 //w=0.201 //l=0.125 //layer=m1 \
 //thickness=0.36 //x=14.55 //y=2.385 //x2=14.55 //y2=2.26
r384 (  17 18 ) resistor r=0.229008 //w=0.131 //l=0.24 //layer=m1 \
 //thickness=0.36 //x=14.55 //y=2.385 //x2=14.55 //y2=2.625
r385 (  15 35 ) resistor r=0.0911593 //w=0.376 //l=0.184174 //layer=m1 \
 //thickness=0.36 //x=12.7 //y=2.945 //x2=12.752 //y2=2.785
r386 (  15 16 ) resistor r=2.19943 //w=0.131 //l=2.305 //layer=m1 \
 //thickness=0.36 //x=12.7 //y=2.945 //x2=12.7 //y2=5.25
r387 (  14 33 ) resistor r=0.0861726 //w=0.376 //l=0.169012 //layer=m1 \
 //thickness=0.36 //x=12.7 //y=2.625 //x2=12.752 //y2=2.77
r388 (  13 14 ) resistor r=0.663168 //w=0.131 //l=0.695 //layer=m1 \
 //thickness=0.36 //x=12.7 //y=1.93 //x2=12.7 //y2=2.625
r389 (  11 13 ) resistor r=0.0698411 //w=0.17 //l=0.120208 //layer=m1 \
 //thickness=0.36 //x=12.615 //y=1.845 //x2=12.7 //y2=1.93
r390 (  11 12 ) resistor r=0.300573 //w=0.131 //l=0.315 //layer=m1 \
 //thickness=0.36 //x=12.615 //y=1.845 //x2=12.3 //y2=1.845
r391 (  10 12 ) resistor r=0.0698411 //w=0.17 //l=0.120208 //layer=m1 \
 //thickness=0.36 //x=12.215 //y=1.76 //x2=12.3 //y2=1.845
r392 (  9 31 ) resistor r=0.0717383 //w=0.224 //l=0.115 //layer=m1 \
 //thickness=0.36 //x=12.215 //y=1.305 //x2=12.215 //y2=1.19
r393 (  9 10 ) resistor r=0.43416 //w=0.131 //l=0.455 //layer=m1 \
 //thickness=0.36 //x=12.215 //y=1.305 //x2=12.215 //y2=1.76
r394 (  8 27 ) resistor r=0.0675342 //w=0.23 //l=0.115 //layer=m1 \
 //thickness=0.36 //x=12.035 //y=5.335 //x2=11.92 //y2=5.335
r395 (  7 16 ) resistor r=0.0698411 //w=0.17 //l=0.120208 //layer=m1 \
 //thickness=0.36 //x=12.615 //y=5.335 //x2=12.7 //y2=5.25
r396 (  7 8 ) resistor r=0.553435 //w=0.131 //l=0.58 //layer=m1 \
 //thickness=0.36 //x=12.615 //y=5.335 //x2=12.035 //y2=5.335
r397 (  6 29 ) resistor r=0.00118313 //w=0.23 //layer=m1 //thickness=0.36 \
 //x=11.92 //y=5.56 //x2=11.92 //y2=5.56
r398 (  5 27 ) resistor r=0.002872 //w=0.34 //l=0.085 //layer=m1 \
 //thickness=0.36 //x=11.92 //y=5.42 //x2=11.92 //y2=5.335
r399 (  5 6 ) resistor r=0.091623 //w=0.191 //l=0.14 //layer=m1 \
 //thickness=0.36 //x=11.92 //y=5.42 //x2=11.92 //y2=5.56
r400 (  4 24 ) resistor r=0.0262263 //w=0.232 //l=0.12 //layer=m1 \
 //thickness=0.36 //x=11.16 //y=5.335 //x2=11.04 //y2=5.335
r401 (  3 27 ) resistor r=0.0675342 //w=0.23 //l=0.115 //layer=m1 \
 //thickness=0.36 //x=11.805 //y=5.335 //x2=11.92 //y2=5.335
r402 (  3 4 ) resistor r=0.615458 //w=0.131 //l=0.645 //layer=m1 \
 //thickness=0.36 //x=11.805 //y=5.335 //x2=11.16 //y2=5.335
r403 (  2 21 ) resistor r=0.0222262 //w=0.217 //l=0.118 //layer=m1 \
 //thickness=0.36 //x=10.28 //y=5.335 //x2=10.162 //y2=5.335
r404 (  1 24 ) resistor r=0.0262263 //w=0.232 //l=0.12 //layer=m1 \
 //thickness=0.36 //x=10.92 //y=5.335 //x2=11.04 //y2=5.335
r405 (  1 2 ) resistor r=0.610687 //w=0.131 //l=0.64 //layer=m1 \
 //thickness=0.36 //x=10.92 //y=5.335 //x2=10.28 //y2=5.335
ends PM_TMRDFFSNQX1\%noxref_2

subckt PM_TMRDFFSNQX1\%noxref_3 ( 2 3 4 5 7 10 11 13 14 15 16 18 19 20 22 23 \
 26 34 35 38 41 47 50 54 57 58 60 63 67 71 72 75 84 89 97 105 122 131 135 136 \
 137 138 139 140 141 142 143 148 150 152 158 159 160 161 162 163 167 169 172 \
 173 178 179 182 196 199 201 202 203 )
c488 ( 199 0 ) capacitor c=0.00885916f //x=7.215 //y=1.095
c489 ( 196 0 ) capacitor c=0.0635976f //x=17.88 //y=4.88
c490 ( 182 0 ) capacitor c=0.0354953f //x=2.37 //y=4.88
c491 ( 179 0 ) capacitor c=0.0284095f //x=2.34 //y=2.095
c492 ( 178 0 ) capacitor c=0.0476356f //x=2.34 //y=2.26
c493 ( 173 0 ) capacitor c=0.0318956f //x=18.215 //y=1.39
c494 ( 172 0 ) capacitor c=0.0186809f //x=18.215 //y=1.045
c495 ( 169 0 ) capacitor c=0.0141821f //x=18.06 //y=1.545
c496 ( 167 0 ) capacitor c=0.0158553f //x=18.06 //y=0.89
c497 ( 163 0 ) capacitor c=0.088055f //x=17.685 //y=2.095
c498 ( 162 0 ) capacitor c=0.0229235f //x=17.685 //y=1.7
c499 ( 161 0 ) capacitor c=0.0234359f //x=17.685 //y=1.39
c500 ( 160 0 ) capacitor c=0.0198759f //x=17.685 //y=1.045
c501 ( 159 0 ) capacitor c=0.0439708f //x=2.905 //y=1.43
c502 ( 158 0 ) capacitor c=0.0192582f //x=2.905 //y=1.085
c503 ( 152 0 ) capacitor c=0.0162526f //x=2.75 //y=1.585
c504 ( 150 0 ) capacitor c=0.0157807f //x=2.75 //y=0.93
c505 ( 148 0 ) capacitor c=0.0357885f //x=2.745 //y=4.97
c506 ( 143 0 ) capacitor c=0.0210762f //x=2.375 //y=1.74
c507 ( 142 0 ) capacitor c=0.0168511f //x=2.375 //y=1.43
c508 ( 141 0 ) capacitor c=0.0175485f //x=2.375 //y=1.085
c509 ( 140 0 ) capacitor c=0.110369f //x=18.22 //y=6.2
c510 ( 139 0 ) capacitor c=0.154619f //x=17.78 //y=6.2
c511 ( 138 0 ) capacitor c=0.155269f //x=2.82 //y=6.2
c512 ( 137 0 ) capacitor c=0.110375f //x=2.38 //y=6.2
c513 ( 131 0 ) capacitor c=6.0732e-19 //x=17.88 //y=4.88
c514 ( 122 0 ) capacitor c=7.85889e-19 //x=17.88 //y=2.26
c515 ( 105 0 ) capacitor c=0.0293709f //x=7.11 //y=5.56
c516 ( 97 0 ) capacitor c=0.029137f //x=6.23 //y=5.56
c517 ( 89 0 ) capacitor c=0.0277605f //x=5.35 //y=5.56
c518 ( 84 0 ) capacitor c=5.80994e-19 //x=2.37 //y=4.88
c519 ( 75 0 ) capacitor c=5.78095e-19 //x=2.34 //y=2.26
c520 ( 72 0 ) capacitor c=0.0941143f //x=17.72 //y=4.265
c521 ( 71 0 ) capacitor c=7.81013e-19 //x=17.88 //y=4.265
c522 ( 67 0 ) capacitor c=0.00262261f //x=2.5 //y=4.245
c523 ( 63 0 ) capacitor c=9.81648e-19 //x=8.045 //y=4.25
c524 ( 60 0 ) capacitor c=0.122114f //x=7.725 //y=4.25
c525 ( 58 0 ) capacitor c=0.00587816f //x=17.882 //y=4.74
c526 ( 57 0 ) capacitor c=0.00587099f //x=17.88 //y=4.88
c527 ( 54 0 ) capacitor c=0.00463527f //x=17.88 //y=2.26
c528 ( 50 0 ) capacitor c=0.0149275f //x=17.88 //y=4.25
c529 ( 47 0 ) capacitor c=0.0149922f //x=7.885 //y=4.25
c530 ( 41 0 ) capacitor c=8.88597e-19 //x=7.11 //y=5.335
c531 ( 38 0 ) capacitor c=0.0073827f //x=6.23 //y=5.335
c532 ( 35 0 ) capacitor c=0.0115084f //x=5.352 //y=5.335
c533 ( 34 0 ) capacitor c=0.0143718f //x=2.34 //y=4.25
c534 ( 26 0 ) capacitor c=0.00662206f //x=2.34 //y=2.26
c535 ( 23 0 ) capacitor c=0.0122086f //x=17.88 //y=4.425
c536 ( 22 0 ) capacitor c=0.046988f //x=17.88 //y=4.105
c537 ( 20 0 ) capacitor c=0.0222419f //x=7.89 //y=5.25
c538 ( 19 0 ) capacitor c=0.0128722f //x=7.89 //y=4.41
c539 ( 18 0 ) capacitor c=0.0622725f //x=7.89 //y=4.09
c540 ( 16 0 ) capacitor c=0.00537187f //x=7.49 //y=1.845
c541 ( 15 0 ) capacitor c=0.0148432f //x=7.805 //y=1.845
c542 ( 14 0 ) capacitor c=0.0167333f //x=7.405 //y=1.76
c543 ( 13 0 ) capacitor c=0.0111291f //x=7.405 //y=1.305
c544 ( 11 0 ) capacitor c=0.0223199f //x=7.805 //y=5.335
c545 ( 10 0 ) capacitor c=0.00933983f //x=7.11 //y=5.56
c546 ( 7 0 ) capacitor c=0.019596f //x=6.995 //y=5.335
c547 ( 5 0 ) capacitor c=0.0150448f //x=6.11 //y=5.335
c548 ( 4 0 ) capacitor c=0.00990813f //x=2.34 //y=4.735
c549 ( 3 0 ) capacitor c=0.0102989f //x=2.34 //y=4.405
c550 ( 2 0 ) capacitor c=0.0396155f //x=2.34 //y=4.085
r551 (  194 196 ) resistor r=20.6867 //w=0.233 //l=0.1 //layer=ply \
 //thickness=0.18 //x=17.78 //y=4.88 //x2=17.88 //y2=4.88
r552 (  184 185 ) resistor r=32.4568 //w=0.214 //l=0.075 //layer=ply \
 //thickness=0.18 //x=2.37 //y=4.97 //x2=2.37 //y2=5.045
r553 (  182 184 ) resistor r=20.271 //w=0.214 //l=0.09 //layer=ply \
 //thickness=0.18 //x=2.37 //y=4.88 //x2=2.37 //y2=4.97
r554 (  178 179 ) resistor r=52.7279 //w=0.214 //l=0.165 //layer=ply \
 //thickness=0.18 //x=2.34 //y=2.26 //x2=2.34 //y2=2.095
r555 (  174 196 ) resistor r=70.3348 //w=0.233 //l=0.414367 //layer=ply \
 //thickness=0.18 //x=18.22 //y=5.045 //x2=17.88 //y2=4.88
r556 (  173 198 ) resistor r=45.1352 //w=0.168 //l=0.173853 //layer=ply \
 //thickness=0.18 //x=18.215 //y=1.39 //x2=18.175 //y2=1.545
r557 (  172 197 ) resistor r=45.1352 //w=0.168 //l=0.173853 //layer=ply \
 //thickness=0.18 //x=18.215 //y=1.045 //x2=18.175 //y2=0.89
r558 (  172 173 ) resistor r=176.904 //w=0.094 //l=0.345 //layer=ply \
 //thickness=0.18 //x=18.215 //y=1.045 //x2=18.215 //y2=1.39
r559 (  170 193 ) resistor r=10.701 //w=0.21 //l=0.115 //layer=ply \
 //thickness=0.18 //x=17.84 //y=1.545 //x2=17.725 //y2=1.545
r560 (  169 198 ) resistor r=5.52526 //w=0.168 //l=0.115 //layer=ply \
 //thickness=0.18 //x=18.06 //y=1.545 //x2=18.175 //y2=1.545
r561 (  168 192 ) resistor r=5.52526 //w=0.168 //l=0.115 //layer=ply \
 //thickness=0.18 //x=17.84 //y=0.89 //x2=17.725 //y2=0.89
r562 (  167 197 ) resistor r=5.52526 //w=0.168 //l=0.115 //layer=ply \
 //thickness=0.18 //x=18.06 //y=0.89 //x2=18.175 //y2=0.89
r563 (  167 168 ) resistor r=112.809 //w=0.094 //l=0.22 //layer=ply \
 //thickness=0.18 //x=18.06 //y=0.89 //x2=17.84 //y2=0.89
r564 (  164 194 ) resistor r=13.0941 //w=0.233 //l=0.165 //layer=ply \
 //thickness=0.18 //x=17.78 //y=5.045 //x2=17.78 //y2=4.88
r565 (  163 191 ) resistor r=34.8111 //w=0.27 //l=0.264953 //layer=ply \
 //thickness=0.18 //x=17.685 //y=2.095 //x2=17.88 //y2=2.26
r566 (  162 193 ) resistor r=39.5823 //w=0.21 //l=0.173853 //layer=ply \
 //thickness=0.18 //x=17.685 //y=1.7 //x2=17.725 //y2=1.545
r567 (  162 163 ) resistor r=202.543 //w=0.094 //l=0.395 //layer=ply \
 //thickness=0.18 //x=17.685 //y=1.7 //x2=17.685 //y2=2.095
r568 (  161 193 ) resistor r=39.5823 //w=0.21 //l=0.173853 //layer=ply \
 //thickness=0.18 //x=17.685 //y=1.39 //x2=17.725 //y2=1.545
r569 (  160 192 ) resistor r=45.1352 //w=0.168 //l=0.173853 //layer=ply \
 //thickness=0.18 //x=17.685 //y=1.045 //x2=17.725 //y2=0.89
r570 (  160 161 ) resistor r=176.904 //w=0.094 //l=0.345 //layer=ply \
 //thickness=0.18 //x=17.685 //y=1.045 //x2=17.685 //y2=1.39
r571 (  159 189 ) resistor r=45.1352 //w=0.168 //l=0.173853 //layer=ply \
 //thickness=0.18 //x=2.905 //y=1.43 //x2=2.865 //y2=1.585
r572 (  158 188 ) resistor r=45.1352 //w=0.168 //l=0.173853 //layer=ply \
 //thickness=0.18 //x=2.905 //y=1.085 //x2=2.865 //y2=0.93
r573 (  158 159 ) resistor r=176.904 //w=0.094 //l=0.345 //layer=ply \
 //thickness=0.18 //x=2.905 //y=1.085 //x2=2.905 //y2=1.43
r574 (  153 187 ) resistor r=10.701 //w=0.21 //l=0.115 //layer=ply \
 //thickness=0.18 //x=2.53 //y=1.585 //x2=2.415 //y2=1.585
r575 (  152 189 ) resistor r=5.52526 //w=0.168 //l=0.115 //layer=ply \
 //thickness=0.18 //x=2.75 //y=1.585 //x2=2.865 //y2=1.585
r576 (  151 186 ) resistor r=5.52526 //w=0.168 //l=0.115 //layer=ply \
 //thickness=0.18 //x=2.53 //y=0.93 //x2=2.415 //y2=0.93
r577 (  150 188 ) resistor r=5.52526 //w=0.168 //l=0.115 //layer=ply \
 //thickness=0.18 //x=2.75 //y=0.93 //x2=2.865 //y2=0.93
r578 (  150 151 ) resistor r=112.809 //w=0.094 //l=0.22 //layer=ply \
 //thickness=0.18 //x=2.75 //y=0.93 //x2=2.53 //y2=0.93
r579 (  149 184 ) resistor r=16.5046 //w=0.27 //l=0.135 //layer=ply \
 //thickness=0.18 //x=2.505 //y=4.97 //x2=2.37 //y2=4.97
r580 (  148 155 ) resistor r=26.9307 //w=0.15 //l=0.106066 //layer=ply \
 //thickness=0.18 //x=2.745 //y=4.97 //x2=2.82 //y2=5.045
r581 (  148 149 ) resistor r=123.064 //w=0.094 //l=0.24 //layer=ply \
 //thickness=0.18 //x=2.745 //y=4.97 //x2=2.505 //y2=4.97
r582 (  143 187 ) resistor r=39.5823 //w=0.21 //l=0.173853 //layer=ply \
 //thickness=0.18 //x=2.375 //y=1.74 //x2=2.415 //y2=1.585
r583 (  143 179 ) resistor r=182.032 //w=0.094 //l=0.355 //layer=ply \
 //thickness=0.18 //x=2.375 //y=1.74 //x2=2.375 //y2=2.095
r584 (  142 187 ) resistor r=39.5823 //w=0.21 //l=0.173853 //layer=ply \
 //thickness=0.18 //x=2.375 //y=1.43 //x2=2.415 //y2=1.585
r585 (  141 186 ) resistor r=45.1352 //w=0.168 //l=0.173853 //layer=ply \
 //thickness=0.18 //x=2.375 //y=1.085 //x2=2.415 //y2=0.93
r586 (  141 142 ) resistor r=176.904 //w=0.094 //l=0.345 //layer=ply \
 //thickness=0.18 //x=2.375 //y=1.085 //x2=2.375 //y2=1.43
r587 (  140 174 ) resistor r=592.245 //w=0.094 //l=1.155 //layer=ply \
 //thickness=0.18 //x=18.22 //y=6.2 //x2=18.22 //y2=5.045
r588 (  139 164 ) resistor r=592.245 //w=0.094 //l=1.155 //layer=ply \
 //thickness=0.18 //x=17.78 //y=6.2 //x2=17.78 //y2=5.045
r589 (  138 155 ) resistor r=592.245 //w=0.094 //l=1.155 //layer=ply \
 //thickness=0.18 //x=2.82 //y=6.2 //x2=2.82 //y2=5.045
r590 (  137 185 ) resistor r=592.245 //w=0.094 //l=1.155 //layer=ply \
 //thickness=0.18 //x=2.38 //y=6.2 //x2=2.38 //y2=5.045
r591 (  136 169 ) resistor r=56.4043 //w=0.094 //l=0.11 //layer=ply \
 //thickness=0.18 //x=17.95 //y=1.545 //x2=18.06 //y2=1.545
r592 (  136 170 ) resistor r=56.4043 //w=0.094 //l=0.11 //layer=ply \
 //thickness=0.18 //x=17.95 //y=1.545 //x2=17.84 //y2=1.545
r593 (  135 152 ) resistor r=56.4043 //w=0.094 //l=0.11 //layer=ply \
 //thickness=0.18 //x=2.64 //y=1.585 //x2=2.75 //y2=1.585
r594 (  135 153 ) resistor r=56.4043 //w=0.094 //l=0.11 //layer=ply \
 //thickness=0.18 //x=2.64 //y=1.585 //x2=2.53 //y2=1.585
r595 (  131 196 ) resistor r=152 //w=0.17 //l=0.17 //layer=licon //count=1 \
 //x=17.88 //y=4.88 //x2=17.88 //y2=4.88
r596 (  122 191 ) resistor r=152 //w=0.17 //l=0.17 //layer=licon //count=1 \
 //x=17.88 //y=2.26 //x2=17.88 //y2=2.26
r597 (  105 203 ) resistor r=23.615 //w=0.187 //l=0.345 //layer=li \
 //thickness=0.1 //x=7.11 //y=5.56 //x2=7.11 //y2=5.905
r598 (  97 202 ) resistor r=23.615 //w=0.187 //l=0.345 //layer=li \
 //thickness=0.1 //x=6.23 //y=5.56 //x2=6.23 //y2=5.905
r599 (  89 201 ) resistor r=23.615 //w=0.187 //l=0.345 //layer=li \
 //thickness=0.1 //x=5.35 //y=5.56 //x2=5.35 //y2=5.905
r600 (  84 182 ) resistor r=152 //w=0.17 //l=0.17 //layer=licon //count=1 \
 //x=2.37 //y=4.88 //x2=2.37 //y2=4.88
r601 (  75 178 ) resistor r=152 //w=0.17 //l=0.17 //layer=licon //count=1 \
 //x=2.34 //y=2.26 //x2=2.34 //y2=2.26
r602 (  71 72 ) resistor r=0.10734 //w=0.281 //l=0.16 //layer=m2 \
 //thickness=0.36 //x=17.88 //y=4.265 //x2=17.72 //y2=4.265
r603 (  65 67 ) resistor r=0.10734 //w=0.281 //l=0.16 //layer=m2 \
 //thickness=0.36 //x=2.34 //y=4.245 //x2=2.5 //y2=4.245
r604 (  63 69 ) resistor r=0.10734 //w=0.281 //l=0.16 //layer=m2 \
 //thickness=0.36 //x=8.045 //y=4.25 //x2=7.885 //y2=4.25
r605 (  63 72 ) resistor r=9.23187 //w=0.131 //l=9.675 //layer=m2 \
 //thickness=0.36 //x=8.045 //y=4.25 //x2=17.72 //y2=4.25
r606 (  60 69 ) resistor r=0.10734 //w=0.281 //l=0.16 //layer=m2 \
 //thickness=0.36 //x=7.725 //y=4.25 //x2=7.885 //y2=4.25
r607 (  60 67 ) resistor r=4.98569 //w=0.131 //l=5.225 //layer=m2 \
 //thickness=0.36 //x=7.725 //y=4.25 //x2=2.5 //y2=4.25
r608 (  57 131 ) resistor r=9.3 //w=0.17 //l=0.17 //layer=mcon //count=1 \
 //x=17.88 //y=4.88 //x2=17.88 //y2=4.88
r609 (  57 58 ) resistor r=0.103207 //w=0.196 //l=0.14 //layer=m1 \
 //thickness=0.36 //x=17.882 //y=4.88 //x2=17.882 //y2=4.74
r610 (  54 122 ) resistor r=9.3 //w=0.17 //l=0.17 //layer=mcon //count=1 \
 //x=17.88 //y=2.26 //x2=17.88 //y2=2.26
r611 (  52 71 ) resistor r=4.5 //w=0.15 //l=0.15 //layer=via1 //count=1 \
 //x=17.88 //y=4.265 //x2=17.88 //y2=4.265
r612 (  50 52 ) resistor r=0.0049867 //w=0.376 //l=0.015 //layer=m1 \
 //thickness=0.36 //x=17.827 //y=4.25 //x2=17.827 //y2=4.265
r613 (  47 69 ) resistor r=4.5 //w=0.15 //l=0.15 //layer=via1 //count=1 \
 //x=7.885 //y=4.25 //x2=7.885 //y2=4.25
r614 (  45 199 ) resistor r=9.3 //w=0.17 //l=0.17 //layer=mcon //count=1 \
 //x=7.405 //y=1.19 //x2=7.405 //y2=1.19
r615 (  43 105 ) resistor r=9.3 //w=0.17 //l=0.17 //layer=mcon //count=1 \
 //x=7.11 //y=5.56 //x2=7.11 //y2=5.56
r616 (  40 97 ) resistor r=9.3 //w=0.17 //l=0.17 //layer=mcon //count=1 \
 //x=6.23 //y=5.56 //x2=6.23 //y2=5.56
r617 (  38 40 ) resistor r=0.121228 //w=0.232 //l=0.225 //layer=m1 \
 //thickness=0.36 //x=6.23 //y=5.335 //x2=6.23 //y2=5.56
r618 (  37 89 ) resistor r=9.3 //w=0.17 //l=0.17 //layer=mcon //count=1 \
 //x=5.35 //y=5.56 //x2=5.35 //y2=5.56
r619 (  35 37 ) resistor r=0.129608 //w=0.217 //l=0.225 //layer=m1 \
 //thickness=0.36 //x=5.352 //y=5.335 //x2=5.352 //y2=5.56
r620 (  32 65 ) resistor r=4.5 //w=0.15 //l=0.15 //layer=via1 //count=1 \
 //x=2.34 //y=4.245 //x2=2.34 //y2=4.245
r621 (  32 34 ) resistor r=0.00166223 //w=0.376 //l=0.005 //layer=m1 \
 //thickness=0.36 //x=2.392 //y=4.245 //x2=2.392 //y2=4.25
r622 (  30 84 ) resistor r=9.3 //w=0.17 //l=0.17 //layer=mcon //count=1 \
 //x=2.37 //y=4.88 //x2=2.37 //y2=4.88
r623 (  26 75 ) resistor r=9.3 //w=0.17 //l=0.17 //layer=mcon //count=1 \
 //x=2.34 //y=2.26 //x2=2.34 //y2=2.26
r624 (  26 28 ) resistor r=0.0936408 //w=0.196 //l=0.125 //layer=m1 \
 //thickness=0.36 //x=2.342 //y=2.26 //x2=2.342 //y2=2.385
r625 (  23 52 ) resistor r=0.0911593 //w=0.376 //l=0.184608 //layer=m1 \
 //thickness=0.36 //x=17.88 //y=4.425 //x2=17.827 //y2=4.265
r626 (  23 58 ) resistor r=0.300573 //w=0.131 //l=0.315 //layer=m1 \
 //thickness=0.36 //x=17.88 //y=4.425 //x2=17.88 //y2=4.74
r627 (  22 50 ) resistor r=0.0861726 //w=0.376 //l=0.16944 //layer=m1 \
 //thickness=0.36 //x=17.88 //y=4.105 //x2=17.827 //y2=4.25
r628 (  21 54 ) resistor r=0.0933015 //w=0.201 //l=0.125 //layer=m1 \
 //thickness=0.36 //x=17.88 //y=2.385 //x2=17.88 //y2=2.26
r629 (  21 22 ) resistor r=1.64122 //w=0.131 //l=1.72 //layer=m1 \
 //thickness=0.36 //x=17.88 //y=2.385 //x2=17.88 //y2=4.105
r630 (  19 47 ) resistor r=0.0911593 //w=0.376 //l=0.181989 //layer=m1 \
 //thickness=0.36 //x=7.89 //y=4.41 //x2=7.937 //y2=4.25
r631 (  19 20 ) resistor r=0.801527 //w=0.131 //l=0.84 //layer=m1 \
 //thickness=0.36 //x=7.89 //y=4.41 //x2=7.89 //y2=5.25
r632 (  18 47 ) resistor r=0.0911593 //w=0.376 //l=0.181989 //layer=m1 \
 //thickness=0.36 //x=7.89 //y=4.09 //x2=7.937 //y2=4.25
r633 (  17 18 ) resistor r=2.06107 //w=0.131 //l=2.16 //layer=m1 \
 //thickness=0.36 //x=7.89 //y=1.93 //x2=7.89 //y2=4.09
r634 (  15 17 ) resistor r=0.0698411 //w=0.17 //l=0.120208 //layer=m1 \
 //thickness=0.36 //x=7.805 //y=1.845 //x2=7.89 //y2=1.93
r635 (  15 16 ) resistor r=0.300573 //w=0.131 //l=0.315 //layer=m1 \
 //thickness=0.36 //x=7.805 //y=1.845 //x2=7.49 //y2=1.845
r636 (  14 16 ) resistor r=0.0698411 //w=0.17 //l=0.120208 //layer=m1 \
 //thickness=0.36 //x=7.405 //y=1.76 //x2=7.49 //y2=1.845
r637 (  13 45 ) resistor r=0.0717383 //w=0.224 //l=0.115 //layer=m1 \
 //thickness=0.36 //x=7.405 //y=1.305 //x2=7.405 //y2=1.19
r638 (  13 14 ) resistor r=0.43416 //w=0.131 //l=0.455 //layer=m1 \
 //thickness=0.36 //x=7.405 //y=1.305 //x2=7.405 //y2=1.76
r639 (  12 41 ) resistor r=0.0675342 //w=0.23 //l=0.115 //layer=m1 \
 //thickness=0.36 //x=7.225 //y=5.335 //x2=7.11 //y2=5.335
r640 (  11 20 ) resistor r=0.0698411 //w=0.17 //l=0.120208 //layer=m1 \
 //thickness=0.36 //x=7.805 //y=5.335 //x2=7.89 //y2=5.25
r641 (  11 12 ) resistor r=0.553435 //w=0.131 //l=0.58 //layer=m1 \
 //thickness=0.36 //x=7.805 //y=5.335 //x2=7.225 //y2=5.335
r642 (  10 43 ) resistor r=0.00118313 //w=0.23 //layer=m1 //thickness=0.36 \
 //x=7.11 //y=5.56 //x2=7.11 //y2=5.56
r643 (  9 41 ) resistor r=0.002872 //w=0.34 //l=0.085 //layer=m1 \
 //thickness=0.36 //x=7.11 //y=5.42 //x2=7.11 //y2=5.335
r644 (  9 10 ) resistor r=0.091623 //w=0.191 //l=0.14 //layer=m1 \
 //thickness=0.36 //x=7.11 //y=5.42 //x2=7.11 //y2=5.56
r645 (  8 38 ) resistor r=0.0262263 //w=0.232 //l=0.12 //layer=m1 \
 //thickness=0.36 //x=6.35 //y=5.335 //x2=6.23 //y2=5.335
r646 (  7 41 ) resistor r=0.0675342 //w=0.23 //l=0.115 //layer=m1 \
 //thickness=0.36 //x=6.995 //y=5.335 //x2=7.11 //y2=5.335
r647 (  7 8 ) resistor r=0.615458 //w=0.131 //l=0.645 //layer=m1 \
 //thickness=0.36 //x=6.995 //y=5.335 //x2=6.35 //y2=5.335
r648 (  6 35 ) resistor r=0.0222262 //w=0.217 //l=0.118 //layer=m1 \
 //thickness=0.36 //x=5.47 //y=5.335 //x2=5.352 //y2=5.335
r649 (  5 38 ) resistor r=0.0262263 //w=0.232 //l=0.12 //layer=m1 \
 //thickness=0.36 //x=6.11 //y=5.335 //x2=6.23 //y2=5.335
r650 (  5 6 ) resistor r=0.610687 //w=0.131 //l=0.64 //layer=m1 \
 //thickness=0.36 //x=6.11 //y=5.335 //x2=5.47 //y2=5.335
r651 (  4 30 ) resistor r=0.0878548 //w=0.228 //l=0.159295 //layer=m1 \
 //thickness=0.36 //x=2.34 //y=4.735 //x2=2.37 //y2=4.88
r652 (  3 34 ) resistor r=0.0894971 //w=0.376 //l=0.179123 //layer=m1 \
 //thickness=0.36 //x=2.34 //y=4.405 //x2=2.392 //y2=4.25
r653 (  3 4 ) resistor r=0.314885 //w=0.131 //l=0.33 //layer=m1 \
 //thickness=0.36 //x=2.34 //y=4.405 //x2=2.34 //y2=4.735
r654 (  2 32 ) resistor r=0.0911593 //w=0.376 //l=0.184174 //layer=m1 \
 //thickness=0.36 //x=2.34 //y=4.085 //x2=2.392 //y2=4.245
r655 (  2 28 ) resistor r=1.62214 //w=0.131 //l=1.7 //layer=m1 \
 //thickness=0.36 //x=2.34 //y=4.085 //x2=2.34 //y2=2.385
ends PM_TMRDFFSNQX1\%noxref_3

subckt PM_TMRDFFSNQX1\%noxref_4 ( 3 8 9 11 12 14 15 16 17 18 19 20 23 24 27 29 \
 32 36 48 50 51 54 62 79 88 92 93 94 95 96 97 98 99 101 107 108 109 110 122 \
 124 125 )
c292 ( 122 0 ) capacitor c=0.00878249f //x=18.73 //y=1.085
c293 ( 110 0 ) capacitor c=0.0571477f //x=21.485 //y=4.97
c294 ( 109 0 ) capacitor c=0.0376642f //x=21.775 //y=4.97
c295 ( 108 0 ) capacitor c=0.0346489f //x=21.44 //y=1.4
c296 ( 107 0 ) capacitor c=0.018692f //x=21.44 //y=1.055
c297 ( 101 0 ) capacitor c=0.0137077f //x=21.285 //y=1.555
c298 ( 99 0 ) capacitor c=0.0158585f //x=21.285 //y=0.9
c299 ( 98 0 ) capacitor c=0.103534f //x=20.91 //y=2.095
c300 ( 97 0 ) capacitor c=0.0229444f //x=20.91 //y=1.71
c301 ( 96 0 ) capacitor c=0.0234359f //x=20.91 //y=1.4
c302 ( 95 0 ) capacitor c=0.019815f //x=20.91 //y=1.055
c303 ( 94 0 ) capacitor c=0.110208f //x=21.85 //y=6.2
c304 ( 93 0 ) capacitor c=0.158957f //x=21.41 //y=6.2
c305 ( 88 0 ) capacitor c=0.00133527f //x=21.21 //y=4.88
c306 ( 79 0 ) capacitor c=0.0012618f //x=21.21 //y=2.26
c307 ( 62 0 ) capacitor c=0.0322017f //x=18.88 //y=5.56
c308 ( 54 0 ) capacitor c=0.0290435f //x=18 //y=5.56
c309 ( 51 0 ) capacitor c=0.017856f //x=21.05 //y=4.265
c310 ( 50 0 ) capacitor c=8.41811e-19 //x=21.21 //y=4.265
c311 ( 48 0 ) capacitor c=9.66964e-19 //x=19.52 //y=4.265
c312 ( 36 0 ) capacitor c=0.0158115f //x=21.21 //y=4.25
c313 ( 32 0 ) capacitor c=0.0156319f //x=19.36 //y=4.25
c314 ( 29 0 ) capacitor c=0.0111172f //x=18.92 //y=1.18
c315 ( 27 0 ) capacitor c=5.78613e-19 //x=18.88 //y=5.56
c316 ( 24 0 ) capacitor c=0.0114832f //x=18.88 //y=5.38
c317 ( 23 0 ) capacitor c=0.00902159f //x=18 //y=5.56
c318 ( 20 0 ) capacitor c=0.0136835f //x=21.21 //y=4.755
c319 ( 19 0 ) capacitor c=0.0126319f //x=21.21 //y=4.425
c320 ( 18 0 ) capacitor c=0.0530814f //x=21.21 //y=4.105
c321 ( 17 0 ) capacitor c=0.00492791f //x=21.21 //y=2.375
c322 ( 16 0 ) capacitor c=0.0215103f //x=19.36 //y=5.295
c323 ( 15 0 ) capacitor c=0.0132133f //x=19.36 //y=4.425
c324 ( 14 0 ) capacitor c=0.0594488f //x=19.36 //y=4.105
c325 ( 12 0 ) capacitor c=0.00454594f //x=19.005 //y=1.835
c326 ( 11 0 ) capacitor c=0.0121325f //x=19.275 //y=1.835
c327 ( 9 0 ) capacitor c=0.0112926f //x=19.275 //y=5.38
c328 ( 8 0 ) capacitor c=0.0133876f //x=18.92 //y=1.75
c329 ( 3 0 ) capacitor c=0.0145173f //x=18.765 //y=5.38
r330 (  109 111 ) resistor r=26.9307 //w=0.15 //l=0.106066 //layer=ply \
 //thickness=0.18 //x=21.775 //y=4.97 //x2=21.85 //y2=5.045
r331 (  109 110 ) resistor r=148.702 //w=0.094 //l=0.29 //layer=ply \
 //thickness=0.18 //x=21.775 //y=4.97 //x2=21.485 //y2=4.97
r332 (  108 121 ) resistor r=45.1352 //w=0.168 //l=0.173853 //layer=ply \
 //thickness=0.18 //x=21.44 //y=1.4 //x2=21.4 //y2=1.555
r333 (  107 120 ) resistor r=45.1352 //w=0.168 //l=0.173853 //layer=ply \
 //thickness=0.18 //x=21.44 //y=1.055 //x2=21.4 //y2=0.9
r334 (  107 108 ) resistor r=176.904 //w=0.094 //l=0.345 //layer=ply \
 //thickness=0.18 //x=21.44 //y=1.055 //x2=21.44 //y2=1.4
r335 (  104 110 ) resistor r=22.7971 //w=0.269 //l=0.106066 //layer=ply \
 //thickness=0.18 //x=21.41 //y=5.045 //x2=21.485 //y2=4.97
r336 (  104 119 ) resistor r=35.8364 //w=0.269 //l=0.270185 //layer=ply \
 //thickness=0.18 //x=21.41 //y=5.045 //x2=21.21 //y2=4.88
r337 (  102 115 ) resistor r=10.701 //w=0.21 //l=0.115 //layer=ply \
 //thickness=0.18 //x=21.065 //y=1.555 //x2=20.95 //y2=1.555
r338 (  101 121 ) resistor r=5.52526 //w=0.168 //l=0.115 //layer=ply \
 //thickness=0.18 //x=21.285 //y=1.555 //x2=21.4 //y2=1.555
r339 (  100 114 ) resistor r=5.52526 //w=0.168 //l=0.115 //layer=ply \
 //thickness=0.18 //x=21.065 //y=0.9 //x2=20.95 //y2=0.9
r340 (  99 120 ) resistor r=5.52526 //w=0.168 //l=0.115 //layer=ply \
 //thickness=0.18 //x=21.285 //y=0.9 //x2=21.4 //y2=0.9
r341 (  99 100 ) resistor r=112.809 //w=0.094 //l=0.22 //layer=ply \
 //thickness=0.18 //x=21.285 //y=0.9 //x2=21.065 //y2=0.9
r342 (  98 117 ) resistor r=58.7805 //w=0.246 //l=0.373497 //layer=ply \
 //thickness=0.18 //x=20.91 //y=2.095 //x2=21.21 //y2=2.26
r343 (  97 115 ) resistor r=39.5823 //w=0.21 //l=0.173853 //layer=ply \
 //thickness=0.18 //x=20.91 //y=1.71 //x2=20.95 //y2=1.555
r344 (  97 98 ) resistor r=197.415 //w=0.094 //l=0.385 //layer=ply \
 //thickness=0.18 //x=20.91 //y=1.71 //x2=20.91 //y2=2.095
r345 (  96 115 ) resistor r=39.5823 //w=0.21 //l=0.173853 //layer=ply \
 //thickness=0.18 //x=20.91 //y=1.4 //x2=20.95 //y2=1.555
r346 (  95 114 ) resistor r=45.1352 //w=0.168 //l=0.173853 //layer=ply \
 //thickness=0.18 //x=20.91 //y=1.055 //x2=20.95 //y2=0.9
r347 (  95 96 ) resistor r=176.904 //w=0.094 //l=0.345 //layer=ply \
 //thickness=0.18 //x=20.91 //y=1.055 //x2=20.91 //y2=1.4
r348 (  94 111 ) resistor r=592.245 //w=0.094 //l=1.155 //layer=ply \
 //thickness=0.18 //x=21.85 //y=6.2 //x2=21.85 //y2=5.045
r349 (  93 104 ) resistor r=592.245 //w=0.094 //l=1.155 //layer=ply \
 //thickness=0.18 //x=21.41 //y=6.2 //x2=21.41 //y2=5.045
r350 (  92 101 ) resistor r=56.4043 //w=0.094 //l=0.11 //layer=ply \
 //thickness=0.18 //x=21.175 //y=1.555 //x2=21.285 //y2=1.555
r351 (  92 102 ) resistor r=56.4043 //w=0.094 //l=0.11 //layer=ply \
 //thickness=0.18 //x=21.175 //y=1.555 //x2=21.065 //y2=1.555
r352 (  88 119 ) resistor r=152 //w=0.17 //l=0.17 //layer=licon //count=1 \
 //x=21.21 //y=4.88 //x2=21.21 //y2=4.88
r353 (  79 117 ) resistor r=152 //w=0.17 //l=0.17 //layer=licon //count=1 \
 //x=21.21 //y=2.26 //x2=21.21 //y2=2.26
r354 (  62 125 ) resistor r=23.615 //w=0.187 //l=0.345 //layer=li \
 //thickness=0.1 //x=18.88 //y=5.56 //x2=18.88 //y2=5.905
r355 (  54 124 ) resistor r=23.615 //w=0.187 //l=0.345 //layer=li \
 //thickness=0.1 //x=18 //y=5.56 //x2=18 //y2=5.905
r356 (  50 51 ) resistor r=0.10734 //w=0.281 //l=0.16 //layer=m2 \
 //thickness=0.36 //x=21.21 //y=4.265 //x2=21.05 //y2=4.265
r357 (  48 51 ) resistor r=1.45992 //w=0.131 //l=1.53 //layer=m2 \
 //thickness=0.36 //x=19.52 //y=4.25 //x2=21.05 //y2=4.25
r358 (  46 48 ) resistor r=0.10734 //w=0.281 //l=0.16 //layer=m2 \
 //thickness=0.36 //x=19.36 //y=4.265 //x2=19.52 //y2=4.265
r359 (  42 88 ) resistor r=9.3 //w=0.17 //l=0.17 //layer=mcon //count=1 \
 //x=21.21 //y=4.88 //x2=21.21 //y2=4.88
r360 (  40 79 ) resistor r=9.3 //w=0.17 //l=0.17 //layer=mcon //count=1 \
 //x=21.21 //y=2.26 //x2=21.21 //y2=2.26
r361 (  38 50 ) resistor r=4.5 //w=0.15 //l=0.15 //layer=via1 //count=1 \
 //x=21.21 //y=4.265 //x2=21.21 //y2=4.265
r362 (  36 38 ) resistor r=0.0049867 //w=0.376 //l=0.015 //layer=m1 \
 //thickness=0.36 //x=21.157 //y=4.25 //x2=21.157 //y2=4.265
r363 (  34 46 ) resistor r=4.5 //w=0.15 //l=0.15 //layer=via1 //count=1 \
 //x=19.36 //y=4.265 //x2=19.36 //y2=4.265
r364 (  32 34 ) resistor r=0.0049867 //w=0.376 //l=0.015 //layer=m1 \
 //thickness=0.36 //x=19.412 //y=4.25 //x2=19.412 //y2=4.265
r365 (  29 122 ) resistor r=9.3 //w=0.17 //l=0.17 //layer=mcon //count=1 \
 //x=18.92 //y=1.18 //x2=18.92 //y2=1.18
r366 (  27 62 ) resistor r=9.3 //w=0.17 //l=0.17 //layer=mcon //count=1 \
 //x=18.88 //y=5.56 //x2=18.88 //y2=5.56
r367 (  24 27 ) resistor r=0.117801 //w=0.191 //l=0.18 //layer=m1 \
 //thickness=0.36 //x=18.88 //y=5.38 //x2=18.88 //y2=5.56
r368 (  23 54 ) resistor r=9.3 //w=0.17 //l=0.17 //layer=mcon //count=1 //x=18 \
 //y=5.56 //x2=18 //y2=5.56
r369 (  21 23 ) resistor r=0.10274 //w=0.219 //l=0.18 //layer=m1 \
 //thickness=0.36 //x=18 //y=5.38 //x2=18 //y2=5.56
r370 (  20 42 ) resistor r=0.0760407 //w=0.238 //l=0.125 //layer=m1 \
 //thickness=0.36 //x=21.21 //y=4.755 //x2=21.21 //y2=4.88
r371 (  19 38 ) resistor r=0.0911593 //w=0.376 //l=0.184608 //layer=m1 \
 //thickness=0.36 //x=21.21 //y=4.425 //x2=21.157 //y2=4.265
r372 (  19 20 ) resistor r=0.314885 //w=0.131 //l=0.33 //layer=m1 \
 //thickness=0.36 //x=21.21 //y=4.425 //x2=21.21 //y2=4.755
r373 (  18 36 ) resistor r=0.0861726 //w=0.376 //l=0.16944 //layer=m1 \
 //thickness=0.36 //x=21.21 //y=4.105 //x2=21.157 //y2=4.25
r374 (  17 40 ) resistor r=0.0719237 //w=0.222 //l=0.115 //layer=m1 \
 //thickness=0.36 //x=21.21 //y=2.375 //x2=21.21 //y2=2.26
r375 (  17 18 ) resistor r=1.65076 //w=0.131 //l=1.73 //layer=m1 \
 //thickness=0.36 //x=21.21 //y=2.375 //x2=21.21 //y2=4.105
r376 (  15 34 ) resistor r=0.0911593 //w=0.376 //l=0.184174 //layer=m1 \
 //thickness=0.36 //x=19.36 //y=4.425 //x2=19.412 //y2=4.265
r377 (  15 16 ) resistor r=0.830153 //w=0.131 //l=0.87 //layer=m1 \
 //thickness=0.36 //x=19.36 //y=4.425 //x2=19.36 //y2=5.295
r378 (  14 32 ) resistor r=0.0861726 //w=0.376 //l=0.169012 //layer=m1 \
 //thickness=0.36 //x=19.36 //y=4.105 //x2=19.412 //y2=4.25
r379 (  13 14 ) resistor r=2.08492 //w=0.131 //l=2.185 //layer=m1 \
 //thickness=0.36 //x=19.36 //y=1.92 //x2=19.36 //y2=4.105
r380 (  11 13 ) resistor r=0.0698411 //w=0.17 //l=0.120208 //layer=m1 \
 //thickness=0.36 //x=19.275 //y=1.835 //x2=19.36 //y2=1.92
r381 (  11 12 ) resistor r=0.257634 //w=0.131 //l=0.27 //layer=m1 \
 //thickness=0.36 //x=19.275 //y=1.835 //x2=19.005 //y2=1.835
r382 (  10 24 ) resistor r=0.0257089 //w=0.23 //l=0.115 //layer=m1 \
 //thickness=0.36 //x=18.995 //y=5.38 //x2=18.88 //y2=5.38
r383 (  9 16 ) resistor r=0.0698411 //w=0.17 //l=0.120208 //layer=m1 \
 //thickness=0.36 //x=19.275 //y=5.38 //x2=19.36 //y2=5.295
r384 (  9 10 ) resistor r=0.267176 //w=0.131 //l=0.28 //layer=m1 \
 //thickness=0.36 //x=19.275 //y=5.38 //x2=18.995 //y2=5.38
r385 (  8 12 ) resistor r=0.0698411 //w=0.17 //l=0.120208 //layer=m1 \
 //thickness=0.36 //x=18.92 //y=1.75 //x2=19.005 //y2=1.835
r386 (  7 29 ) resistor r=0.0913624 //w=0.191 //l=0.12 //layer=m1 \
 //thickness=0.36 //x=18.92 //y=1.3 //x2=18.92 //y2=1.18
r387 (  7 8 ) resistor r=0.429389 //w=0.131 //l=0.45 //layer=m1 \
 //thickness=0.36 //x=18.92 //y=1.3 //x2=18.92 //y2=1.75
r388 (  4 21 ) resistor r=0.0227762 //w=0.219 //l=0.115 //layer=m1 \
 //thickness=0.36 //x=18.115 //y=5.38 //x2=18 //y2=5.38
r389 (  3 24 ) resistor r=0.0257089 //w=0.23 //l=0.115 //layer=m1 \
 //thickness=0.36 //x=18.765 //y=5.38 //x2=18.88 //y2=5.38
r390 (  3 4 ) resistor r=0.620229 //w=0.131 //l=0.65 //layer=m1 \
 //thickness=0.36 //x=18.765 //y=5.38 //x2=18.115 //y2=5.38
ends PM_TMRDFFSNQX1\%noxref_4

subckt PM_TMRDFFSNQX1\%noxref_5 ( 1 2 3 4 5 6 7 8 11 16 17 19 20 22 23 24 25 \
 26 27 28 36 40 47 48 51 53 58 60 67 69 72 78 83 84 86 87 90 99 104 113 118 \
 126 143 152 156 157 158 159 160 161 162 163 164 168 169 170 175 177 180 181 \
 185 186 187 192 194 197 198 202 203 204 209 211 214 215 217 218 223 227 228 \
 233 237 238 243 246 248 249 )
c576 ( 246 0 ) capacitor c=0.00878249f //x=15.4 //y=1.085
c577 ( 243 0 ) capacitor c=0.0651477f //x=23.43 //y=4.88
c578 ( 238 0 ) capacitor c=0.0278202f //x=23.43 //y=2.095
c579 ( 237 0 ) capacitor c=0.0503043f //x=23.43 //y=2.26
c580 ( 233 0 ) capacitor c=0.0651619f //x=11.96 //y=4.88
c581 ( 228 0 ) capacitor c=0.0278202f //x=11.96 //y=2.095
c582 ( 227 0 ) capacitor c=0.0503043f //x=11.96 //y=2.26
c583 ( 223 0 ) capacitor c=0.0654765f //x=7.15 //y=4.88
c584 ( 218 0 ) capacitor c=0.0278202f //x=7.15 //y=2.095
c585 ( 217 0 ) capacitor c=0.0503043f //x=7.15 //y=2.26
c586 ( 215 0 ) capacitor c=0.0443175f //x=23.95 //y=1.44
c587 ( 214 0 ) capacitor c=0.0199703f //x=23.95 //y=1.095
c588 ( 211 0 ) capacitor c=0.0162526f //x=23.795 //y=1.595
c589 ( 209 0 ) capacitor c=0.0157807f //x=23.795 //y=0.94
c590 ( 204 0 ) capacitor c=0.0220935f //x=23.42 //y=1.75
c591 ( 203 0 ) capacitor c=0.0207489f //x=23.42 //y=1.44
c592 ( 202 0 ) capacitor c=0.0194091f //x=23.42 //y=1.095
c593 ( 198 0 ) capacitor c=0.0443175f //x=12.48 //y=1.44
c594 ( 197 0 ) capacitor c=0.0199703f //x=12.48 //y=1.095
c595 ( 194 0 ) capacitor c=0.0162526f //x=12.325 //y=1.595
c596 ( 192 0 ) capacitor c=0.0157807f //x=12.325 //y=0.94
c597 ( 187 0 ) capacitor c=0.0220935f //x=11.95 //y=1.75
c598 ( 186 0 ) capacitor c=0.0207489f //x=11.95 //y=1.44
c599 ( 185 0 ) capacitor c=0.0194091f //x=11.95 //y=1.095
c600 ( 181 0 ) capacitor c=0.0443175f //x=7.67 //y=1.44
c601 ( 180 0 ) capacitor c=0.0199703f //x=7.67 //y=1.095
c602 ( 177 0 ) capacitor c=0.0162526f //x=7.515 //y=1.595
c603 ( 175 0 ) capacitor c=0.0157807f //x=7.515 //y=0.94
c604 ( 170 0 ) capacitor c=0.0220935f //x=7.14 //y=1.75
c605 ( 169 0 ) capacitor c=0.0207489f //x=7.14 //y=1.44
c606 ( 168 0 ) capacitor c=0.0194091f //x=7.14 //y=1.095
c607 ( 164 0 ) capacitor c=0.159671f //x=23.61 //y=6.2
c608 ( 163 0 ) capacitor c=0.110208f //x=23.17 //y=6.2
c609 ( 162 0 ) capacitor c=0.159671f //x=12.14 //y=6.2
c610 ( 161 0 ) capacitor c=0.110208f //x=11.7 //y=6.2
c611 ( 160 0 ) capacitor c=0.159671f //x=7.33 //y=6.2
c612 ( 159 0 ) capacitor c=0.110208f //x=6.89 //y=6.2
c613 ( 152 0 ) capacitor c=7.7417e-19 //x=23.43 //y=4.88
c614 ( 143 0 ) capacitor c=0.00101179f //x=23.43 //y=2.26
c615 ( 126 0 ) capacitor c=0.0319332f //x=15.55 //y=5.56
c616 ( 118 0 ) capacitor c=0.0290186f //x=14.67 //y=5.56
c617 ( 113 0 ) capacitor c=7.7417e-19 //x=11.96 //y=4.88
c618 ( 104 0 ) capacitor c=0.00101179f //x=11.96 //y=2.26
c619 ( 99 0 ) capacitor c=7.7417e-19 //x=7.15 //y=4.88
c620 ( 90 0 ) capacitor c=0.00101179f //x=7.15 //y=2.26
c621 ( 87 0 ) capacitor c=0.082378f //x=23.27 //y=3.885
c622 ( 86 0 ) capacitor c=7.01701e-19 //x=23.43 //y=3.885
c623 ( 84 0 ) capacitor c=7.85706e-19 //x=16.185 //y=3.865
c624 ( 83 0 ) capacitor c=0.0445493f //x=15.865 //y=3.865
c625 ( 78 0 ) capacitor c=7.70073e-19 //x=7.315 //y=3.865
c626 ( 72 0 ) capacitor c=0.0499276f //x=12.12 //y=3.88
c627 ( 69 0 ) capacitor c=0.00318287f //x=8.1 //y=3.865
c628 ( 67 0 ) capacitor c=0.00289159f //x=7.5 //y=3.88
c629 ( 60 0 ) capacitor c=0.0149589f //x=23.43 //y=3.88
c630 ( 58 0 ) capacitor c=0.0158493f //x=16.03 //y=3.88
c631 ( 53 0 ) capacitor c=0.0113632f //x=15.59 //y=1.18
c632 ( 51 0 ) capacitor c=5.78613e-19 //x=15.55 //y=5.56
c633 ( 48 0 ) capacitor c=0.00996089f //x=15.55 //y=5.38
c634 ( 47 0 ) capacitor c=0.00947836f //x=14.67 //y=5.56
c635 ( 40 0 ) capacitor c=0.0149589f //x=11.96 //y=3.88
c636 ( 36 0 ) capacitor c=0.0149589f //x=7.15 //y=3.88
c637 ( 28 0 ) capacitor c=0.0198373f //x=23.43 //y=4.75
c638 ( 27 0 ) capacitor c=0.0114437f //x=23.43 //y=4.045
c639 ( 26 0 ) capacitor c=0.0316099f //x=23.43 //y=3.725
c640 ( 25 0 ) capacitor c=0.0055474f //x=23.43 //y=2.375
c641 ( 24 0 ) capacitor c=0.0292358f //x=16.03 //y=5.295
c642 ( 23 0 ) capacitor c=0.0126782f //x=16.03 //y=4.025
c643 ( 22 0 ) capacitor c=0.0472645f //x=16.03 //y=3.705
c644 ( 20 0 ) capacitor c=0.00466468f //x=15.675 //y=1.835
c645 ( 19 0 ) capacitor c=0.0118534f //x=15.945 //y=1.835
c646 ( 17 0 ) capacitor c=0.0105341f //x=15.945 //y=5.38
c647 ( 16 0 ) capacitor c=0.0102514f //x=15.59 //y=1.75
c648 ( 11 0 ) capacitor c=0.0144196f //x=15.435 //y=5.38
c649 ( 8 0 ) capacitor c=0.0205242f //x=11.96 //y=4.75
c650 ( 7 0 ) capacitor c=0.0115579f //x=11.96 //y=4.025
c651 ( 6 0 ) capacitor c=0.0322912f //x=11.96 //y=3.705
c652 ( 5 0 ) capacitor c=0.00554287f //x=11.96 //y=2.375
c653 ( 4 0 ) capacitor c=0.0190807f //x=7.15 //y=4.75
c654 ( 3 0 ) capacitor c=0.0113742f //x=7.15 //y=4.025
c655 ( 2 0 ) capacitor c=0.0350104f //x=7.15 //y=3.705
c656 ( 1 0 ) capacitor c=0.00696087f //x=7.15 //y=2.375
r657 (  237 238 ) resistor r=52.7279 //w=0.214 //l=0.165 //layer=ply \
 //thickness=0.18 //x=23.43 //y=2.26 //x2=23.43 //y2=2.095
r658 (  227 228 ) resistor r=52.7279 //w=0.214 //l=0.165 //layer=ply \
 //thickness=0.18 //x=11.96 //y=2.26 //x2=11.96 //y2=2.095
r659 (  217 218 ) resistor r=52.7279 //w=0.214 //l=0.165 //layer=ply \
 //thickness=0.18 //x=7.15 //y=2.26 //x2=7.15 //y2=2.095
r660 (  215 245 ) resistor r=45.1352 //w=0.168 //l=0.173853 //layer=ply \
 //thickness=0.18 //x=23.95 //y=1.44 //x2=23.91 //y2=1.595
r661 (  214 244 ) resistor r=45.1352 //w=0.168 //l=0.173853 //layer=ply \
 //thickness=0.18 //x=23.95 //y=1.095 //x2=23.91 //y2=0.94
r662 (  214 215 ) resistor r=176.904 //w=0.094 //l=0.345 //layer=ply \
 //thickness=0.18 //x=23.95 //y=1.095 //x2=23.95 //y2=1.44
r663 (  212 241 ) resistor r=10.701 //w=0.21 //l=0.115 //layer=ply \
 //thickness=0.18 //x=23.575 //y=1.595 //x2=23.46 //y2=1.595
r664 (  211 245 ) resistor r=5.52526 //w=0.168 //l=0.115 //layer=ply \
 //thickness=0.18 //x=23.795 //y=1.595 //x2=23.91 //y2=1.595
r665 (  210 240 ) resistor r=5.52526 //w=0.168 //l=0.115 //layer=ply \
 //thickness=0.18 //x=23.575 //y=0.94 //x2=23.46 //y2=0.94
r666 (  209 244 ) resistor r=5.52526 //w=0.168 //l=0.115 //layer=ply \
 //thickness=0.18 //x=23.795 //y=0.94 //x2=23.91 //y2=0.94
r667 (  209 210 ) resistor r=112.809 //w=0.094 //l=0.22 //layer=ply \
 //thickness=0.18 //x=23.795 //y=0.94 //x2=23.575 //y2=0.94
r668 (  206 243 ) resistor r=37.236 //w=0.233 //l=0.249199 //layer=ply \
 //thickness=0.18 //x=23.61 //y=5.045 //x2=23.43 //y2=4.88
r669 (  204 241 ) resistor r=39.5823 //w=0.21 //l=0.173853 //layer=ply \
 //thickness=0.18 //x=23.42 //y=1.75 //x2=23.46 //y2=1.595
r670 (  204 238 ) resistor r=176.904 //w=0.094 //l=0.345 //layer=ply \
 //thickness=0.18 //x=23.42 //y=1.75 //x2=23.42 //y2=2.095
r671 (  203 241 ) resistor r=39.5823 //w=0.21 //l=0.173853 //layer=ply \
 //thickness=0.18 //x=23.42 //y=1.44 //x2=23.46 //y2=1.595
r672 (  202 240 ) resistor r=45.1352 //w=0.168 //l=0.173853 //layer=ply \
 //thickness=0.18 //x=23.42 //y=1.095 //x2=23.46 //y2=0.94
r673 (  202 203 ) resistor r=176.904 //w=0.094 //l=0.345 //layer=ply \
 //thickness=0.18 //x=23.42 //y=1.095 //x2=23.42 //y2=1.44
r674 (  199 243 ) resistor r=53.7854 //w=0.233 //l=0.332415 //layer=ply \
 //thickness=0.18 //x=23.17 //y=5.045 //x2=23.43 //y2=4.88
r675 (  198 235 ) resistor r=45.1352 //w=0.168 //l=0.173853 //layer=ply \
 //thickness=0.18 //x=12.48 //y=1.44 //x2=12.44 //y2=1.595
r676 (  197 234 ) resistor r=45.1352 //w=0.168 //l=0.173853 //layer=ply \
 //thickness=0.18 //x=12.48 //y=1.095 //x2=12.44 //y2=0.94
r677 (  197 198 ) resistor r=176.904 //w=0.094 //l=0.345 //layer=ply \
 //thickness=0.18 //x=12.48 //y=1.095 //x2=12.48 //y2=1.44
r678 (  195 231 ) resistor r=10.701 //w=0.21 //l=0.115 //layer=ply \
 //thickness=0.18 //x=12.105 //y=1.595 //x2=11.99 //y2=1.595
r679 (  194 235 ) resistor r=5.52526 //w=0.168 //l=0.115 //layer=ply \
 //thickness=0.18 //x=12.325 //y=1.595 //x2=12.44 //y2=1.595
r680 (  193 230 ) resistor r=5.52526 //w=0.168 //l=0.115 //layer=ply \
 //thickness=0.18 //x=12.105 //y=0.94 //x2=11.99 //y2=0.94
r681 (  192 234 ) resistor r=5.52526 //w=0.168 //l=0.115 //layer=ply \
 //thickness=0.18 //x=12.325 //y=0.94 //x2=12.44 //y2=0.94
r682 (  192 193 ) resistor r=112.809 //w=0.094 //l=0.22 //layer=ply \
 //thickness=0.18 //x=12.325 //y=0.94 //x2=12.105 //y2=0.94
r683 (  189 233 ) resistor r=37.236 //w=0.233 //l=0.249199 //layer=ply \
 //thickness=0.18 //x=12.14 //y=5.045 //x2=11.96 //y2=4.88
r684 (  187 231 ) resistor r=39.5823 //w=0.21 //l=0.173853 //layer=ply \
 //thickness=0.18 //x=11.95 //y=1.75 //x2=11.99 //y2=1.595
r685 (  187 228 ) resistor r=176.904 //w=0.094 //l=0.345 //layer=ply \
 //thickness=0.18 //x=11.95 //y=1.75 //x2=11.95 //y2=2.095
r686 (  186 231 ) resistor r=39.5823 //w=0.21 //l=0.173853 //layer=ply \
 //thickness=0.18 //x=11.95 //y=1.44 //x2=11.99 //y2=1.595
r687 (  185 230 ) resistor r=45.1352 //w=0.168 //l=0.173853 //layer=ply \
 //thickness=0.18 //x=11.95 //y=1.095 //x2=11.99 //y2=0.94
r688 (  185 186 ) resistor r=176.904 //w=0.094 //l=0.345 //layer=ply \
 //thickness=0.18 //x=11.95 //y=1.095 //x2=11.95 //y2=1.44
r689 (  182 233 ) resistor r=53.7854 //w=0.233 //l=0.332415 //layer=ply \
 //thickness=0.18 //x=11.7 //y=5.045 //x2=11.96 //y2=4.88
r690 (  181 225 ) resistor r=45.1352 //w=0.168 //l=0.173853 //layer=ply \
 //thickness=0.18 //x=7.67 //y=1.44 //x2=7.63 //y2=1.595
r691 (  180 224 ) resistor r=45.1352 //w=0.168 //l=0.173853 //layer=ply \
 //thickness=0.18 //x=7.67 //y=1.095 //x2=7.63 //y2=0.94
r692 (  180 181 ) resistor r=176.904 //w=0.094 //l=0.345 //layer=ply \
 //thickness=0.18 //x=7.67 //y=1.095 //x2=7.67 //y2=1.44
r693 (  178 221 ) resistor r=10.701 //w=0.21 //l=0.115 //layer=ply \
 //thickness=0.18 //x=7.295 //y=1.595 //x2=7.18 //y2=1.595
r694 (  177 225 ) resistor r=5.52526 //w=0.168 //l=0.115 //layer=ply \
 //thickness=0.18 //x=7.515 //y=1.595 //x2=7.63 //y2=1.595
r695 (  176 220 ) resistor r=5.52526 //w=0.168 //l=0.115 //layer=ply \
 //thickness=0.18 //x=7.295 //y=0.94 //x2=7.18 //y2=0.94
r696 (  175 224 ) resistor r=5.52526 //w=0.168 //l=0.115 //layer=ply \
 //thickness=0.18 //x=7.515 //y=0.94 //x2=7.63 //y2=0.94
r697 (  175 176 ) resistor r=112.809 //w=0.094 //l=0.22 //layer=ply \
 //thickness=0.18 //x=7.515 //y=0.94 //x2=7.295 //y2=0.94
r698 (  172 223 ) resistor r=37.236 //w=0.233 //l=0.249199 //layer=ply \
 //thickness=0.18 //x=7.33 //y=5.045 //x2=7.15 //y2=4.88
r699 (  170 221 ) resistor r=39.5823 //w=0.21 //l=0.173853 //layer=ply \
 //thickness=0.18 //x=7.14 //y=1.75 //x2=7.18 //y2=1.595
r700 (  170 218 ) resistor r=176.904 //w=0.094 //l=0.345 //layer=ply \
 //thickness=0.18 //x=7.14 //y=1.75 //x2=7.14 //y2=2.095
r701 (  169 221 ) resistor r=39.5823 //w=0.21 //l=0.173853 //layer=ply \
 //thickness=0.18 //x=7.14 //y=1.44 //x2=7.18 //y2=1.595
r702 (  168 220 ) resistor r=45.1352 //w=0.168 //l=0.173853 //layer=ply \
 //thickness=0.18 //x=7.14 //y=1.095 //x2=7.18 //y2=0.94
r703 (  168 169 ) resistor r=176.904 //w=0.094 //l=0.345 //layer=ply \
 //thickness=0.18 //x=7.14 //y=1.095 //x2=7.14 //y2=1.44
r704 (  165 223 ) resistor r=53.7854 //w=0.233 //l=0.332415 //layer=ply \
 //thickness=0.18 //x=6.89 //y=5.045 //x2=7.15 //y2=4.88
r705 (  164 206 ) resistor r=592.245 //w=0.094 //l=1.155 //layer=ply \
 //thickness=0.18 //x=23.61 //y=6.2 //x2=23.61 //y2=5.045
r706 (  163 199 ) resistor r=592.245 //w=0.094 //l=1.155 //layer=ply \
 //thickness=0.18 //x=23.17 //y=6.2 //x2=23.17 //y2=5.045
r707 (  162 189 ) resistor r=592.245 //w=0.094 //l=1.155 //layer=ply \
 //thickness=0.18 //x=12.14 //y=6.2 //x2=12.14 //y2=5.045
r708 (  161 182 ) resistor r=592.245 //w=0.094 //l=1.155 //layer=ply \
 //thickness=0.18 //x=11.7 //y=6.2 //x2=11.7 //y2=5.045
r709 (  160 172 ) resistor r=592.245 //w=0.094 //l=1.155 //layer=ply \
 //thickness=0.18 //x=7.33 //y=6.2 //x2=7.33 //y2=5.045
r710 (  159 165 ) resistor r=592.245 //w=0.094 //l=1.155 //layer=ply \
 //thickness=0.18 //x=6.89 //y=6.2 //x2=6.89 //y2=5.045
r711 (  158 211 ) resistor r=56.4043 //w=0.094 //l=0.11 //layer=ply \
 //thickness=0.18 //x=23.685 //y=1.595 //x2=23.795 //y2=1.595
r712 (  158 212 ) resistor r=56.4043 //w=0.094 //l=0.11 //layer=ply \
 //thickness=0.18 //x=23.685 //y=1.595 //x2=23.575 //y2=1.595
r713 (  157 194 ) resistor r=56.4043 //w=0.094 //l=0.11 //layer=ply \
 //thickness=0.18 //x=12.215 //y=1.595 //x2=12.325 //y2=1.595
r714 (  157 195 ) resistor r=56.4043 //w=0.094 //l=0.11 //layer=ply \
 //thickness=0.18 //x=12.215 //y=1.595 //x2=12.105 //y2=1.595
r715 (  156 177 ) resistor r=56.4043 //w=0.094 //l=0.11 //layer=ply \
 //thickness=0.18 //x=7.405 //y=1.595 //x2=7.515 //y2=1.595
r716 (  156 178 ) resistor r=56.4043 //w=0.094 //l=0.11 //layer=ply \
 //thickness=0.18 //x=7.405 //y=1.595 //x2=7.295 //y2=1.595
r717 (  152 243 ) resistor r=152 //w=0.17 //l=0.17 //layer=licon //count=1 \
 //x=23.43 //y=4.88 //x2=23.43 //y2=4.88
r718 (  143 237 ) resistor r=152 //w=0.17 //l=0.17 //layer=licon //count=1 \
 //x=23.43 //y=2.26 //x2=23.43 //y2=2.26
r719 (  126 249 ) resistor r=23.615 //w=0.187 //l=0.345 //layer=li \
 //thickness=0.1 //x=15.55 //y=5.56 //x2=15.55 //y2=5.905
r720 (  118 248 ) resistor r=23.615 //w=0.187 //l=0.345 //layer=li \
 //thickness=0.1 //x=14.67 //y=5.56 //x2=14.67 //y2=5.905
r721 (  113 233 ) resistor r=152 //w=0.17 //l=0.17 //layer=licon //count=1 \
 //x=11.96 //y=4.88 //x2=11.96 //y2=4.88
r722 (  104 227 ) resistor r=152 //w=0.17 //l=0.17 //layer=licon //count=1 \
 //x=11.96 //y=2.26 //x2=11.96 //y2=2.26
r723 (  99 223 ) resistor r=152 //w=0.17 //l=0.17 //layer=licon //count=1 \
 //x=7.15 //y=4.88 //x2=7.15 //y2=4.88
r724 (  90 217 ) resistor r=152 //w=0.17 //l=0.17 //layer=licon //count=1 \
 //x=7.15 //y=2.26 //x2=7.15 //y2=2.26
r725 (  86 87 ) resistor r=0.10734 //w=0.281 //l=0.16 //layer=m2 \
 //thickness=0.36 //x=23.43 //y=3.885 //x2=23.27 //y2=3.885
r726 (  84 87 ) resistor r=6.7605 //w=0.131 //l=7.085 //layer=m2 \
 //thickness=0.36 //x=16.185 //y=3.88 //x2=23.27 //y2=3.88
r727 (  82 84 ) resistor r=0.10734 //w=0.281 //l=0.16 //layer=m2 \
 //thickness=0.36 //x=16.025 //y=3.865 //x2=16.185 //y2=3.865
r728 (  82 83 ) resistor r=0.10734 //w=0.281 //l=0.16 //layer=m2 \
 //thickness=0.36 //x=16.025 //y=3.865 //x2=15.865 //y2=3.865
r729 (  76 78 ) resistor r=0.10734 //w=0.281 //l=0.16 //layer=m2 \
 //thickness=0.36 //x=7.155 //y=3.865 //x2=7.315 //y2=3.865
r730 (  72 80 ) resistor r=0.110608 //w=0.182 //l=0.167332 //layer=m2 \
 //thickness=0.36 //x=12.12 //y=3.88 //x2=11.96 //y2=3.865
r731 (  72 83 ) resistor r=3.57347 //w=0.131 //l=3.745 //layer=m2 \
 //thickness=0.36 //x=12.12 //y=3.88 //x2=15.865 //y2=3.88
r732 (  69 80 ) resistor r=2.65182 //w=0.182 //l=3.86 //layer=m2 \
 //thickness=0.36 //x=8.1 //y=3.865 //x2=11.96 //y2=3.865
r733 (  69 70 ) resistor r=0.410305 //w=0.131 //l=0.43 //layer=m2 \
 //thickness=0.36 //x=8.1 //y=3.865 //x2=7.67 //y2=3.865
r734 (  67 70 ) resistor r=0.125 //w=0.17 //l=0.177341 //layer=m2 \
 //thickness=0.36 //x=7.5 //y=3.88 //x2=7.67 //y2=3.865
r735 (  67 78 ) resistor r=0.176527 //w=0.131 //l=0.185 //layer=m2 \
 //thickness=0.36 //x=7.5 //y=3.88 //x2=7.315 //y2=3.88
r736 (  66 152 ) resistor r=9.3 //w=0.17 //l=0.17 //layer=mcon //count=1 \
 //x=23.43 //y=4.88 //x2=23.43 //y2=4.88
r737 (  64 143 ) resistor r=9.3 //w=0.17 //l=0.17 //layer=mcon //count=1 \
 //x=23.43 //y=2.26 //x2=23.43 //y2=2.26
r738 (  62 86 ) resistor r=4.5 //w=0.15 //l=0.15 //layer=via1 //count=1 \
 //x=23.43 //y=3.885 //x2=23.43 //y2=3.885
r739 (  60 62 ) resistor r=0.00166223 //w=0.376 //l=0.005 //layer=m1 \
 //thickness=0.36 //x=23.377 //y=3.88 //x2=23.377 //y2=3.885
r740 (  56 82 ) resistor r=4.5 //w=0.15 //l=0.15 //layer=via1 //count=1 \
 //x=16.025 //y=3.865 //x2=16.025 //y2=3.865
r741 (  56 58 ) resistor r=0.00501337 //w=0.374 //l=0.015 //layer=m1 \
 //thickness=0.36 //x=15.975 //y=3.865 //x2=15.975 //y2=3.88
r742 (  53 246 ) resistor r=9.3 //w=0.17 //l=0.17 //layer=mcon //count=1 \
 //x=15.59 //y=1.18 //x2=15.59 //y2=1.18
r743 (  51 126 ) resistor r=9.3 //w=0.17 //l=0.17 //layer=mcon //count=1 \
 //x=15.55 //y=5.56 //x2=15.55 //y2=5.56
r744 (  48 51 ) resistor r=0.117801 //w=0.191 //l=0.18 //layer=m1 \
 //thickness=0.36 //x=15.55 //y=5.38 //x2=15.55 //y2=5.56
r745 (  47 118 ) resistor r=9.3 //w=0.17 //l=0.17 //layer=mcon //count=1 \
 //x=14.67 //y=5.56 //x2=14.67 //y2=5.56
r746 (  45 47 ) resistor r=0.10274 //w=0.219 //l=0.18 //layer=m1 \
 //thickness=0.36 //x=14.67 //y=5.38 //x2=14.67 //y2=5.56
r747 (  44 113 ) resistor r=9.3 //w=0.17 //l=0.17 //layer=mcon //count=1 \
 //x=11.96 //y=4.88 //x2=11.96 //y2=4.88
r748 (  42 104 ) resistor r=9.3 //w=0.17 //l=0.17 //layer=mcon //count=1 \
 //x=11.96 //y=2.26 //x2=11.96 //y2=2.26
r749 (  38 80 ) resistor r=4.5 //w=0.15 //l=0.15 //layer=via1 //count=1 \
 //x=11.96 //y=3.865 //x2=11.96 //y2=3.865
r750 (  38 40 ) resistor r=0.0049867 //w=0.376 //l=0.015 //layer=m1 \
 //thickness=0.36 //x=11.907 //y=3.865 //x2=11.907 //y2=3.88
r751 (  34 76 ) resistor r=4.5 //w=0.15 //l=0.15 //layer=via1 //count=1 \
 //x=7.155 //y=3.865 //x2=7.155 //y2=3.865
r752 (  34 36 ) resistor r=0.00501337 //w=0.374 //l=0.015 //layer=m1 \
 //thickness=0.36 //x=7.205 //y=3.865 //x2=7.205 //y2=3.88
r753 (  32 99 ) resistor r=9.3 //w=0.17 //l=0.17 //layer=mcon //count=1 \
 //x=7.15 //y=4.88 //x2=7.15 //y2=4.88
r754 (  30 90 ) resistor r=9.3 //w=0.17 //l=0.17 //layer=mcon //count=1 \
 //x=7.15 //y=2.26 //x2=7.15 //y2=2.26
r755 (  28 66 ) resistor r=0.0801089 //w=0.224 //l=0.13 //layer=m1 \
 //thickness=0.36 //x=23.43 //y=4.75 //x2=23.43 //y2=4.88
r756 (  27 62 ) resistor r=0.0911593 //w=0.376 //l=0.184608 //layer=m1 \
 //thickness=0.36 //x=23.43 //y=4.045 //x2=23.377 //y2=3.885
r757 (  27 28 ) resistor r=0.67271 //w=0.131 //l=0.705 //layer=m1 \
 //thickness=0.36 //x=23.43 //y=4.045 //x2=23.43 //y2=4.75
r758 (  26 60 ) resistor r=0.0894971 //w=0.376 //l=0.179555 //layer=m1 \
 //thickness=0.36 //x=23.43 //y=3.725 //x2=23.377 //y2=3.88
r759 (  25 64 ) resistor r=0.0719237 //w=0.222 //l=0.115 //layer=m1 \
 //thickness=0.36 //x=23.43 //y=2.375 //x2=23.43 //y2=2.26
r760 (  25 26 ) resistor r=1.28817 //w=0.131 //l=1.35 //layer=m1 \
 //thickness=0.36 //x=23.43 //y=2.375 //x2=23.43 //y2=3.725
r761 (  23 58 ) resistor r=0.0860668 //w=0.374 //l=0.170294 //layer=m1 \
 //thickness=0.36 //x=16.03 //y=4.025 //x2=15.975 //y2=3.88
r762 (  23 24 ) resistor r=1.21183 //w=0.131 //l=1.27 //layer=m1 \
 //thickness=0.36 //x=16.03 //y=4.025 //x2=16.03 //y2=5.295
r763 (  22 56 ) resistor r=0.0910802 //w=0.374 //l=0.185472 //layer=m1 \
 //thickness=0.36 //x=16.03 //y=3.705 //x2=15.975 //y2=3.865
r764 (  21 22 ) resistor r=1.70324 //w=0.131 //l=1.785 //layer=m1 \
 //thickness=0.36 //x=16.03 //y=1.92 //x2=16.03 //y2=3.705
r765 (  19 21 ) resistor r=0.0698411 //w=0.17 //l=0.120208 //layer=m1 \
 //thickness=0.36 //x=15.945 //y=1.835 //x2=16.03 //y2=1.92
r766 (  19 20 ) resistor r=0.257634 //w=0.131 //l=0.27 //layer=m1 \
 //thickness=0.36 //x=15.945 //y=1.835 //x2=15.675 //y2=1.835
r767 (  18 48 ) resistor r=0.0257089 //w=0.23 //l=0.115 //layer=m1 \
 //thickness=0.36 //x=15.665 //y=5.38 //x2=15.55 //y2=5.38
r768 (  17 24 ) resistor r=0.0698411 //w=0.17 //l=0.120208 //layer=m1 \
 //thickness=0.36 //x=15.945 //y=5.38 //x2=16.03 //y2=5.295
r769 (  17 18 ) resistor r=0.267176 //w=0.131 //l=0.28 //layer=m1 \
 //thickness=0.36 //x=15.945 //y=5.38 //x2=15.665 //y2=5.38
r770 (  16 20 ) resistor r=0.0698411 //w=0.17 //l=0.120208 //layer=m1 \
 //thickness=0.36 //x=15.59 //y=1.75 //x2=15.675 //y2=1.835
r771 (  15 53 ) resistor r=0.0913624 //w=0.191 //l=0.12 //layer=m1 \
 //thickness=0.36 //x=15.59 //y=1.3 //x2=15.59 //y2=1.18
r772 (  15 16 ) resistor r=0.429389 //w=0.131 //l=0.45 //layer=m1 \
 //thickness=0.36 //x=15.59 //y=1.3 //x2=15.59 //y2=1.75
r773 (  12 45 ) resistor r=0.0227762 //w=0.219 //l=0.115 //layer=m1 \
 //thickness=0.36 //x=14.785 //y=5.38 //x2=14.67 //y2=5.38
r774 (  11 48 ) resistor r=0.0257089 //w=0.23 //l=0.115 //layer=m1 \
 //thickness=0.36 //x=15.435 //y=5.38 //x2=15.55 //y2=5.38
r775 (  11 12 ) resistor r=0.620229 //w=0.131 //l=0.65 //layer=m1 \
 //thickness=0.36 //x=15.435 //y=5.38 //x2=14.785 //y2=5.38
r776 (  8 44 ) resistor r=0.0801089 //w=0.224 //l=0.13 //layer=m1 \
 //thickness=0.36 //x=11.96 //y=4.75 //x2=11.96 //y2=4.88
r777 (  7 40 ) resistor r=0.0861726 //w=0.376 //l=0.16944 //layer=m1 \
 //thickness=0.36 //x=11.96 //y=4.025 //x2=11.907 //y2=3.88
r778 (  7 8 ) resistor r=0.691794 //w=0.131 //l=0.725 //layer=m1 \
 //thickness=0.36 //x=11.96 //y=4.025 //x2=11.96 //y2=4.75
r779 (  6 38 ) resistor r=0.0911593 //w=0.376 //l=0.184608 //layer=m1 \
 //thickness=0.36 //x=11.96 //y=3.705 //x2=11.907 //y2=3.865
r780 (  5 42 ) resistor r=0.0719237 //w=0.222 //l=0.115 //layer=m1 \
 //thickness=0.36 //x=11.96 //y=2.375 //x2=11.96 //y2=2.26
r781 (  5 6 ) resistor r=1.26908 //w=0.131 //l=1.33 //layer=m1 \
 //thickness=0.36 //x=11.96 //y=2.375 //x2=11.96 //y2=3.705
r782 (  4 32 ) resistor r=0.0801089 //w=0.224 //l=0.13 //layer=m1 \
 //thickness=0.36 //x=7.15 //y=4.75 //x2=7.15 //y2=4.88
r783 (  3 36 ) resistor r=0.0860668 //w=0.374 //l=0.170294 //layer=m1 \
 //thickness=0.36 //x=7.15 //y=4.025 //x2=7.205 //y2=3.88
r784 (  3 4 ) resistor r=0.691794 //w=0.131 //l=0.725 //layer=m1 \
 //thickness=0.36 //x=7.15 //y=4.025 //x2=7.15 //y2=4.75
r785 (  2 34 ) resistor r=0.0910802 //w=0.374 //l=0.185472 //layer=m1 \
 //thickness=0.36 //x=7.15 //y=3.705 //x2=7.205 //y2=3.865
r786 (  1 30 ) resistor r=0.0719237 //w=0.222 //l=0.115 //layer=m1 \
 //thickness=0.36 //x=7.15 //y=2.375 //x2=7.15 //y2=2.26
r787 (  1 2 ) resistor r=1.26908 //w=0.131 //l=1.33 //layer=m1 \
 //thickness=0.36 //x=7.15 //y=2.375 //x2=7.15 //y2=3.705
ends PM_TMRDFFSNQX1\%noxref_5

subckt PM_TMRDFFSNQX1\%noxref_6 ( 3 8 9 11 12 14 15 16 17 18 19 20 21 22 23 24 \
 27 28 31 33 36 43 47 54 55 57 64 65 68 76 93 102 107 116 120 121 122 123 124 \
 125 126 127 128 129 130 132 138 139 140 141 145 146 147 148 149 151 157 158 \
 159 160 180 182 183 )
c422 ( 180 0 ) capacitor c=0.00878249f //x=26.87 //y=1.085
c423 ( 160 0 ) capacitor c=0.0612936f //x=34.435 //y=4.97
c424 ( 159 0 ) capacitor c=0.0376642f //x=34.725 //y=4.97
c425 ( 158 0 ) capacitor c=0.0346489f //x=34.39 //y=1.4
c426 ( 157 0 ) capacitor c=0.018692f //x=34.39 //y=1.055
c427 ( 151 0 ) capacitor c=0.0137077f //x=34.235 //y=1.555
c428 ( 149 0 ) capacitor c=0.0158585f //x=34.235 //y=0.9
c429 ( 148 0 ) capacitor c=0.0979511f //x=33.86 //y=2.095
c430 ( 147 0 ) capacitor c=0.0229444f //x=33.86 //y=1.71
c431 ( 146 0 ) capacitor c=0.0234359f //x=33.86 //y=1.4
c432 ( 145 0 ) capacitor c=0.019815f //x=33.86 //y=1.055
c433 ( 141 0 ) capacitor c=0.0612936f //x=29.625 //y=4.97
c434 ( 140 0 ) capacitor c=0.0376642f //x=29.915 //y=4.97
c435 ( 139 0 ) capacitor c=0.0346489f //x=29.58 //y=1.4
c436 ( 138 0 ) capacitor c=0.018692f //x=29.58 //y=1.055
c437 ( 132 0 ) capacitor c=0.0137077f //x=29.425 //y=1.555
c438 ( 130 0 ) capacitor c=0.0158585f //x=29.425 //y=0.9
c439 ( 129 0 ) capacitor c=0.099553f //x=29.05 //y=2.095
c440 ( 128 0 ) capacitor c=0.0229444f //x=29.05 //y=1.71
c441 ( 127 0 ) capacitor c=0.0234359f //x=29.05 //y=1.4
c442 ( 126 0 ) capacitor c=0.019815f //x=29.05 //y=1.055
c443 ( 125 0 ) capacitor c=0.110208f //x=34.8 //y=6.2
c444 ( 124 0 ) capacitor c=0.158957f //x=34.36 //y=6.2
c445 ( 123 0 ) capacitor c=0.110208f //x=29.99 //y=6.2
c446 ( 122 0 ) capacitor c=0.158957f //x=29.55 //y=6.2
c447 ( 116 0 ) capacitor c=0.0014751f //x=34.16 //y=4.88
c448 ( 107 0 ) capacitor c=9.93222e-19 //x=34.16 //y=2.26
c449 ( 102 0 ) capacitor c=0.0014751f //x=29.35 //y=4.88
c450 ( 93 0 ) capacitor c=9.93222e-19 //x=29.35 //y=2.26
c451 ( 76 0 ) capacitor c=0.0322017f //x=27.02 //y=5.56
c452 ( 68 0 ) capacitor c=0.0291338f //x=26.14 //y=5.56
c453 ( 65 0 ) capacitor c=0.0398037f //x=34 //y=2.775
c454 ( 64 0 ) capacitor c=6.56496e-19 //x=34.16 //y=2.775
c455 ( 57 0 ) capacitor c=6.57651e-19 //x=29.51 //y=2.77
c456 ( 55 0 ) capacitor c=8.02114e-19 //x=27.66 //y=2.77
c457 ( 54 0 ) capacitor c=0.0166477f //x=29.19 //y=2.77
c458 ( 47 0 ) capacitor c=0.0154699f //x=34.16 //y=2.77
c459 ( 43 0 ) capacitor c=0.0146914f //x=29.35 //y=2.765
c460 ( 36 0 ) capacitor c=0.0146635f //x=27.5 //y=2.77
c461 ( 33 0 ) capacitor c=0.011349f //x=27.06 //y=1.18
c462 ( 31 0 ) capacitor c=5.78613e-19 //x=27.02 //y=5.56
c463 ( 28 0 ) capacitor c=0.0108509f //x=27.02 //y=5.38
c464 ( 27 0 ) capacitor c=0.0091206f //x=26.14 //y=5.56
c465 ( 24 0 ) capacitor c=0.0609582f //x=34.16 //y=4.755
c466 ( 23 0 ) capacitor c=0.0130119f //x=34.16 //y=2.935
c467 ( 22 0 ) capacitor c=0.00415551f //x=34.16 //y=2.615
c468 ( 21 0 ) capacitor c=0.00474211f //x=34.16 //y=2.375
c469 ( 20 0 ) capacitor c=0.0637256f //x=29.35 //y=4.755
c470 ( 19 0 ) capacitor c=0.0130033f //x=29.35 //y=2.93
c471 ( 18 0 ) capacitor c=0.00452361f //x=29.35 //y=2.61
c472 ( 17 0 ) capacitor c=0.00485545f //x=29.35 //y=2.375
c473 ( 16 0 ) capacitor c=0.0658406f //x=27.5 //y=5.295
c474 ( 15 0 ) capacitor c=0.0120687f //x=27.5 //y=2.93
c475 ( 14 0 ) capacitor c=0.0175872f //x=27.5 //y=2.61
c476 ( 12 0 ) capacitor c=0.0046997f //x=27.145 //y=1.835
c477 ( 11 0 ) capacitor c=0.0117163f //x=27.415 //y=1.835
c478 ( 9 0 ) capacitor c=0.011753f //x=27.415 //y=5.38
c479 ( 8 0 ) capacitor c=0.0134844f //x=27.06 //y=1.75
c480 ( 3 0 ) capacitor c=0.0143226f //x=26.905 //y=5.38
r481 (  159 161 ) resistor r=26.9307 //w=0.15 //l=0.106066 //layer=ply \
 //thickness=0.18 //x=34.725 //y=4.97 //x2=34.8 //y2=5.045
r482 (  159 160 ) resistor r=148.702 //w=0.094 //l=0.29 //layer=ply \
 //thickness=0.18 //x=34.725 //y=4.97 //x2=34.435 //y2=4.97
r483 (  158 179 ) resistor r=45.1352 //w=0.168 //l=0.173853 //layer=ply \
 //thickness=0.18 //x=34.39 //y=1.4 //x2=34.35 //y2=1.555
r484 (  157 178 ) resistor r=45.1352 //w=0.168 //l=0.173853 //layer=ply \
 //thickness=0.18 //x=34.39 //y=1.055 //x2=34.35 //y2=0.9
r485 (  157 158 ) resistor r=176.904 //w=0.094 //l=0.345 //layer=ply \
 //thickness=0.18 //x=34.39 //y=1.055 //x2=34.39 //y2=1.4
r486 (  154 160 ) resistor r=22.7971 //w=0.269 //l=0.106066 //layer=ply \
 //thickness=0.18 //x=34.36 //y=5.045 //x2=34.435 //y2=4.97
r487 (  154 177 ) resistor r=35.8364 //w=0.269 //l=0.270185 //layer=ply \
 //thickness=0.18 //x=34.36 //y=5.045 //x2=34.16 //y2=4.88
r488 (  152 173 ) resistor r=10.701 //w=0.21 //l=0.115 //layer=ply \
 //thickness=0.18 //x=34.015 //y=1.555 //x2=33.9 //y2=1.555
r489 (  151 179 ) resistor r=5.52526 //w=0.168 //l=0.115 //layer=ply \
 //thickness=0.18 //x=34.235 //y=1.555 //x2=34.35 //y2=1.555
r490 (  150 172 ) resistor r=5.52526 //w=0.168 //l=0.115 //layer=ply \
 //thickness=0.18 //x=34.015 //y=0.9 //x2=33.9 //y2=0.9
r491 (  149 178 ) resistor r=5.52526 //w=0.168 //l=0.115 //layer=ply \
 //thickness=0.18 //x=34.235 //y=0.9 //x2=34.35 //y2=0.9
r492 (  149 150 ) resistor r=112.809 //w=0.094 //l=0.22 //layer=ply \
 //thickness=0.18 //x=34.235 //y=0.9 //x2=34.015 //y2=0.9
r493 (  148 175 ) resistor r=58.7805 //w=0.246 //l=0.373497 //layer=ply \
 //thickness=0.18 //x=33.86 //y=2.095 //x2=34.16 //y2=2.26
r494 (  147 173 ) resistor r=39.5823 //w=0.21 //l=0.173853 //layer=ply \
 //thickness=0.18 //x=33.86 //y=1.71 //x2=33.9 //y2=1.555
r495 (  147 148 ) resistor r=197.415 //w=0.094 //l=0.385 //layer=ply \
 //thickness=0.18 //x=33.86 //y=1.71 //x2=33.86 //y2=2.095
r496 (  146 173 ) resistor r=39.5823 //w=0.21 //l=0.173853 //layer=ply \
 //thickness=0.18 //x=33.86 //y=1.4 //x2=33.9 //y2=1.555
r497 (  145 172 ) resistor r=45.1352 //w=0.168 //l=0.173853 //layer=ply \
 //thickness=0.18 //x=33.86 //y=1.055 //x2=33.9 //y2=0.9
r498 (  145 146 ) resistor r=176.904 //w=0.094 //l=0.345 //layer=ply \
 //thickness=0.18 //x=33.86 //y=1.055 //x2=33.86 //y2=1.4
r499 (  140 142 ) resistor r=26.9307 //w=0.15 //l=0.106066 //layer=ply \
 //thickness=0.18 //x=29.915 //y=4.97 //x2=29.99 //y2=5.045
r500 (  140 141 ) resistor r=148.702 //w=0.094 //l=0.29 //layer=ply \
 //thickness=0.18 //x=29.915 //y=4.97 //x2=29.625 //y2=4.97
r501 (  139 171 ) resistor r=45.1352 //w=0.168 //l=0.173853 //layer=ply \
 //thickness=0.18 //x=29.58 //y=1.4 //x2=29.54 //y2=1.555
r502 (  138 170 ) resistor r=45.1352 //w=0.168 //l=0.173853 //layer=ply \
 //thickness=0.18 //x=29.58 //y=1.055 //x2=29.54 //y2=0.9
r503 (  138 139 ) resistor r=176.904 //w=0.094 //l=0.345 //layer=ply \
 //thickness=0.18 //x=29.58 //y=1.055 //x2=29.58 //y2=1.4
r504 (  135 141 ) resistor r=22.7971 //w=0.269 //l=0.106066 //layer=ply \
 //thickness=0.18 //x=29.55 //y=5.045 //x2=29.625 //y2=4.97
r505 (  135 169 ) resistor r=35.8364 //w=0.269 //l=0.270185 //layer=ply \
 //thickness=0.18 //x=29.55 //y=5.045 //x2=29.35 //y2=4.88
r506 (  133 165 ) resistor r=10.701 //w=0.21 //l=0.115 //layer=ply \
 //thickness=0.18 //x=29.205 //y=1.555 //x2=29.09 //y2=1.555
r507 (  132 171 ) resistor r=5.52526 //w=0.168 //l=0.115 //layer=ply \
 //thickness=0.18 //x=29.425 //y=1.555 //x2=29.54 //y2=1.555
r508 (  131 164 ) resistor r=5.52526 //w=0.168 //l=0.115 //layer=ply \
 //thickness=0.18 //x=29.205 //y=0.9 //x2=29.09 //y2=0.9
r509 (  130 170 ) resistor r=5.52526 //w=0.168 //l=0.115 //layer=ply \
 //thickness=0.18 //x=29.425 //y=0.9 //x2=29.54 //y2=0.9
r510 (  130 131 ) resistor r=112.809 //w=0.094 //l=0.22 //layer=ply \
 //thickness=0.18 //x=29.425 //y=0.9 //x2=29.205 //y2=0.9
r511 (  129 167 ) resistor r=58.7805 //w=0.246 //l=0.373497 //layer=ply \
 //thickness=0.18 //x=29.05 //y=2.095 //x2=29.35 //y2=2.26
r512 (  128 165 ) resistor r=39.5823 //w=0.21 //l=0.173853 //layer=ply \
 //thickness=0.18 //x=29.05 //y=1.71 //x2=29.09 //y2=1.555
r513 (  128 129 ) resistor r=197.415 //w=0.094 //l=0.385 //layer=ply \
 //thickness=0.18 //x=29.05 //y=1.71 //x2=29.05 //y2=2.095
r514 (  127 165 ) resistor r=39.5823 //w=0.21 //l=0.173853 //layer=ply \
 //thickness=0.18 //x=29.05 //y=1.4 //x2=29.09 //y2=1.555
r515 (  126 164 ) resistor r=45.1352 //w=0.168 //l=0.173853 //layer=ply \
 //thickness=0.18 //x=29.05 //y=1.055 //x2=29.09 //y2=0.9
r516 (  126 127 ) resistor r=176.904 //w=0.094 //l=0.345 //layer=ply \
 //thickness=0.18 //x=29.05 //y=1.055 //x2=29.05 //y2=1.4
r517 (  125 161 ) resistor r=592.245 //w=0.094 //l=1.155 //layer=ply \
 //thickness=0.18 //x=34.8 //y=6.2 //x2=34.8 //y2=5.045
r518 (  124 154 ) resistor r=592.245 //w=0.094 //l=1.155 //layer=ply \
 //thickness=0.18 //x=34.36 //y=6.2 //x2=34.36 //y2=5.045
r519 (  123 142 ) resistor r=592.245 //w=0.094 //l=1.155 //layer=ply \
 //thickness=0.18 //x=29.99 //y=6.2 //x2=29.99 //y2=5.045
r520 (  122 135 ) resistor r=592.245 //w=0.094 //l=1.155 //layer=ply \
 //thickness=0.18 //x=29.55 //y=6.2 //x2=29.55 //y2=5.045
r521 (  121 151 ) resistor r=56.4043 //w=0.094 //l=0.11 //layer=ply \
 //thickness=0.18 //x=34.125 //y=1.555 //x2=34.235 //y2=1.555
r522 (  121 152 ) resistor r=56.4043 //w=0.094 //l=0.11 //layer=ply \
 //thickness=0.18 //x=34.125 //y=1.555 //x2=34.015 //y2=1.555
r523 (  120 132 ) resistor r=56.4043 //w=0.094 //l=0.11 //layer=ply \
 //thickness=0.18 //x=29.315 //y=1.555 //x2=29.425 //y2=1.555
r524 (  120 133 ) resistor r=56.4043 //w=0.094 //l=0.11 //layer=ply \
 //thickness=0.18 //x=29.315 //y=1.555 //x2=29.205 //y2=1.555
r525 (  116 177 ) resistor r=152 //w=0.17 //l=0.17 //layer=licon //count=1 \
 //x=34.16 //y=4.88 //x2=34.16 //y2=4.88
r526 (  107 175 ) resistor r=152 //w=0.17 //l=0.17 //layer=licon //count=1 \
 //x=34.16 //y=2.26 //x2=34.16 //y2=2.26
r527 (  102 169 ) resistor r=152 //w=0.17 //l=0.17 //layer=licon //count=1 \
 //x=29.35 //y=4.88 //x2=29.35 //y2=4.88
r528 (  93 167 ) resistor r=152 //w=0.17 //l=0.17 //layer=licon //count=1 \
 //x=29.35 //y=2.26 //x2=29.35 //y2=2.26
r529 (  76 183 ) resistor r=23.615 //w=0.187 //l=0.345 //layer=li \
 //thickness=0.1 //x=27.02 //y=5.56 //x2=27.02 //y2=5.905
r530 (  68 182 ) resistor r=23.615 //w=0.187 //l=0.345 //layer=li \
 //thickness=0.1 //x=26.14 //y=5.56 //x2=26.14 //y2=5.905
r531 (  64 65 ) resistor r=0.10734 //w=0.281 //l=0.16 //layer=m2 \
 //thickness=0.36 //x=34.16 //y=2.775 //x2=34 //y2=2.775
r532 (  57 62 ) resistor r=0.10734 //w=0.281 //l=0.16 //layer=m2 \
 //thickness=0.36 //x=29.51 //y=2.77 //x2=29.35 //y2=2.77
r533 (  57 65 ) resistor r=4.28435 //w=0.131 //l=4.49 //layer=m2 \
 //thickness=0.36 //x=29.51 //y=2.77 //x2=34 //y2=2.77
r534 (  55 59 ) resistor r=0.10734 //w=0.281 //l=0.16 //layer=m2 \
 //thickness=0.36 //x=27.66 //y=2.77 //x2=27.5 //y2=2.77
r535 (  54 62 ) resistor r=0.10734 //w=0.281 //l=0.16 //layer=m2 \
 //thickness=0.36 //x=29.19 //y=2.77 //x2=29.35 //y2=2.77
r536 (  54 55 ) resistor r=1.45992 //w=0.131 //l=1.53 //layer=m2 \
 //thickness=0.36 //x=29.19 //y=2.77 //x2=27.66 //y2=2.77
r537 (  53 116 ) resistor r=9.3 //w=0.17 //l=0.17 //layer=mcon //count=1 \
 //x=34.16 //y=4.88 //x2=34.16 //y2=4.88
r538 (  51 107 ) resistor r=9.3 //w=0.17 //l=0.17 //layer=mcon //count=1 \
 //x=34.16 //y=2.26 //x2=34.16 //y2=2.26
r539 (  49 64 ) resistor r=4.5 //w=0.15 //l=0.15 //layer=via1 //count=1 \
 //x=34.16 //y=2.775 //x2=34.16 //y2=2.775
r540 (  47 49 ) resistor r=0.00166223 //w=0.376 //l=0.005 //layer=m1 \
 //thickness=0.36 //x=34.107 //y=2.77 //x2=34.107 //y2=2.775
r541 (  45 62 ) resistor r=4.5 //w=0.15 //l=0.15 //layer=via1 //count=1 \
 //x=29.35 //y=2.77 //x2=29.35 //y2=2.77
r542 (  43 45 ) resistor r=0.00166223 //w=0.376 //l=0.005 //layer=m1 \
 //thickness=0.36 //x=29.402 //y=2.765 //x2=29.402 //y2=2.77
r543 (  41 102 ) resistor r=9.3 //w=0.17 //l=0.17 //layer=mcon //count=1 \
 //x=29.35 //y=4.88 //x2=29.35 //y2=4.88
r544 (  39 93 ) resistor r=9.3 //w=0.17 //l=0.17 //layer=mcon //count=1 \
 //x=29.35 //y=2.26 //x2=29.35 //y2=2.26
r545 (  36 59 ) resistor r=4.5 //w=0.15 //l=0.15 //layer=via1 //count=1 \
 //x=27.5 //y=2.77 //x2=27.5 //y2=2.77
r546 (  33 180 ) resistor r=9.3 //w=0.17 //l=0.17 //layer=mcon //count=1 \
 //x=27.06 //y=1.18 //x2=27.06 //y2=1.18
r547 (  31 76 ) resistor r=9.3 //w=0.17 //l=0.17 //layer=mcon //count=1 \
 //x=27.02 //y=5.56 //x2=27.02 //y2=5.56
r548 (  28 31 ) resistor r=0.117801 //w=0.191 //l=0.18 //layer=m1 \
 //thickness=0.36 //x=27.02 //y=5.38 //x2=27.02 //y2=5.56
r549 (  27 68 ) resistor r=9.3 //w=0.17 //l=0.17 //layer=mcon //count=1 \
 //x=26.14 //y=5.56 //x2=26.14 //y2=5.56
r550 (  25 27 ) resistor r=0.10274 //w=0.219 //l=0.18 //layer=m1 \
 //thickness=0.36 //x=26.14 //y=5.38 //x2=26.14 //y2=5.56
r551 (  24 53 ) resistor r=0.0760407 //w=0.238 //l=0.125 //layer=m1 \
 //thickness=0.36 //x=34.16 //y=4.755 //x2=34.16 //y2=4.88
r552 (  23 49 ) resistor r=0.0911593 //w=0.376 //l=0.184608 //layer=m1 \
 //thickness=0.36 //x=34.16 //y=2.935 //x2=34.107 //y2=2.775
r553 (  23 24 ) resistor r=1.73664 //w=0.131 //l=1.82 //layer=m1 \
 //thickness=0.36 //x=34.16 //y=2.935 //x2=34.16 //y2=4.755
r554 (  22 47 ) resistor r=0.0894971 //w=0.376 //l=0.179555 //layer=m1 \
 //thickness=0.36 //x=34.16 //y=2.615 //x2=34.107 //y2=2.77
r555 (  21 51 ) resistor r=0.0719237 //w=0.222 //l=0.115 //layer=m1 \
 //thickness=0.36 //x=34.16 //y=2.375 //x2=34.16 //y2=2.26
r556 (  21 22 ) resistor r=0.229008 //w=0.131 //l=0.24 //layer=m1 \
 //thickness=0.36 //x=34.16 //y=2.375 //x2=34.16 //y2=2.615
r557 (  20 41 ) resistor r=0.0760407 //w=0.238 //l=0.125 //layer=m1 \
 //thickness=0.36 //x=29.35 //y=4.755 //x2=29.35 //y2=4.88
r558 (  19 45 ) resistor r=0.0911593 //w=0.376 //l=0.184174 //layer=m1 \
 //thickness=0.36 //x=29.35 //y=2.93 //x2=29.402 //y2=2.77
r559 (  19 20 ) resistor r=1.74141 //w=0.131 //l=1.825 //layer=m1 \
 //thickness=0.36 //x=29.35 //y=2.93 //x2=29.35 //y2=4.755
r560 (  18 43 ) resistor r=0.0894971 //w=0.376 //l=0.179123 //layer=m1 \
 //thickness=0.36 //x=29.35 //y=2.61 //x2=29.402 //y2=2.765
r561 (  17 39 ) resistor r=0.0719237 //w=0.222 //l=0.115 //layer=m1 \
 //thickness=0.36 //x=29.35 //y=2.375 //x2=29.35 //y2=2.26
r562 (  17 18 ) resistor r=0.224237 //w=0.131 //l=0.235 //layer=m1 \
 //thickness=0.36 //x=29.35 //y=2.375 //x2=29.35 //y2=2.61
r563 (  15 36 ) resistor r=0.0911593 //w=0.376 //l=0.184174 //layer=m1 \
 //thickness=0.36 //x=27.5 //y=2.93 //x2=27.552 //y2=2.77
r564 (  15 16 ) resistor r=2.25668 //w=0.131 //l=2.365 //layer=m1 \
 //thickness=0.36 //x=27.5 //y=2.93 //x2=27.5 //y2=5.295
r565 (  14 36 ) resistor r=0.0911593 //w=0.376 //l=0.184174 //layer=m1 \
 //thickness=0.36 //x=27.5 //y=2.61 //x2=27.552 //y2=2.77
r566 (  13 14 ) resistor r=0.658397 //w=0.131 //l=0.69 //layer=m1 \
 //thickness=0.36 //x=27.5 //y=1.92 //x2=27.5 //y2=2.61
r567 (  11 13 ) resistor r=0.0698411 //w=0.17 //l=0.120208 //layer=m1 \
 //thickness=0.36 //x=27.415 //y=1.835 //x2=27.5 //y2=1.92
r568 (  11 12 ) resistor r=0.257634 //w=0.131 //l=0.27 //layer=m1 \
 //thickness=0.36 //x=27.415 //y=1.835 //x2=27.145 //y2=1.835
r569 (  10 28 ) resistor r=0.0257089 //w=0.23 //l=0.115 //layer=m1 \
 //thickness=0.36 //x=27.135 //y=5.38 //x2=27.02 //y2=5.38
r570 (  9 16 ) resistor r=0.0698411 //w=0.17 //l=0.120208 //layer=m1 \
 //thickness=0.36 //x=27.415 //y=5.38 //x2=27.5 //y2=5.295
r571 (  9 10 ) resistor r=0.267176 //w=0.131 //l=0.28 //layer=m1 \
 //thickness=0.36 //x=27.415 //y=5.38 //x2=27.135 //y2=5.38
r572 (  8 12 ) resistor r=0.0698411 //w=0.17 //l=0.120208 //layer=m1 \
 //thickness=0.36 //x=27.06 //y=1.75 //x2=27.145 //y2=1.835
r573 (  7 33 ) resistor r=0.0913624 //w=0.191 //l=0.12 //layer=m1 \
 //thickness=0.36 //x=27.06 //y=1.3 //x2=27.06 //y2=1.18
r574 (  7 8 ) resistor r=0.429389 //w=0.131 //l=0.45 //layer=m1 \
 //thickness=0.36 //x=27.06 //y=1.3 //x2=27.06 //y2=1.75
r575 (  4 25 ) resistor r=0.0227762 //w=0.219 //l=0.115 //layer=m1 \
 //thickness=0.36 //x=26.255 //y=5.38 //x2=26.14 //y2=5.38
r576 (  3 28 ) resistor r=0.0257089 //w=0.23 //l=0.115 //layer=m1 \
 //thickness=0.36 //x=26.905 //y=5.38 //x2=27.02 //y2=5.38
r577 (  3 4 ) resistor r=0.620229 //w=0.131 //l=0.65 //layer=m1 \
 //thickness=0.36 //x=26.905 //y=5.38 //x2=26.255 //y2=5.38
ends PM_TMRDFFSNQX1\%noxref_6

subckt PM_TMRDFFSNQX1\%noxref_7 ( 1 3 6 7 9 10 11 12 14 15 16 18 19 21 24 27 \
 33 37 41 44 45 52 54 55 58 66 74 91 100 104 105 106 107 108 109 110 114 116 \
 119 120 130 133 135 136 137 )
c300 ( 133 0 ) capacitor c=0.00885916f //x=36.445 //y=1.095
c301 ( 130 0 ) capacitor c=0.0682508f //x=38.97 //y=4.88
c302 ( 120 0 ) capacitor c=0.0318956f //x=39.305 //y=1.39
c303 ( 119 0 ) capacitor c=0.0186809f //x=39.305 //y=1.045
c304 ( 116 0 ) capacitor c=0.0141821f //x=39.15 //y=1.545
c305 ( 114 0 ) capacitor c=0.0158553f //x=39.15 //y=0.89
c306 ( 110 0 ) capacitor c=0.0815114f //x=38.775 //y=2.095
c307 ( 109 0 ) capacitor c=0.0229235f //x=38.775 //y=1.7
c308 ( 108 0 ) capacitor c=0.0234359f //x=38.775 //y=1.39
c309 ( 107 0 ) capacitor c=0.0198759f //x=38.775 //y=1.045
c310 ( 106 0 ) capacitor c=0.110369f //x=39.31 //y=6.2
c311 ( 105 0 ) capacitor c=0.154619f //x=38.87 //y=6.2
c312 ( 100 0 ) capacitor c=8.13425e-19 //x=38.97 //y=4.88
c313 ( 91 0 ) capacitor c=5.17312e-19 //x=38.97 //y=2.26
c314 ( 74 0 ) capacitor c=0.0293219f //x=36.34 //y=5.56
c315 ( 66 0 ) capacitor c=0.029137f //x=35.46 //y=5.56
c316 ( 58 0 ) capacitor c=0.0278099f //x=34.58 //y=5.56
c317 ( 55 0 ) capacitor c=0.0156383f //x=38.805 //y=2.785
c318 ( 54 0 ) capacitor c=6.75833e-19 //x=38.965 //y=2.785
c319 ( 52 0 ) capacitor c=9.41304e-19 //x=37.28 //y=2.785
c320 ( 45 0 ) capacitor c=0.048855f //x=38.972 //y=4.74
c321 ( 44 0 ) capacitor c=0.00631721f //x=38.97 //y=4.88
c322 ( 41 0 ) capacitor c=0.00463527f //x=38.97 //y=2.26
c323 ( 37 0 ) capacitor c=0.0145985f //x=38.97 //y=2.77
c324 ( 33 0 ) capacitor c=0.0149529f //x=37.12 //y=2.77
c325 ( 27 0 ) capacitor c=8.88597e-19 //x=36.34 //y=5.335
c326 ( 24 0 ) capacitor c=0.00796615f //x=35.46 //y=5.335
c327 ( 21 0 ) capacitor c=0.0111234f //x=34.582 //y=5.335
c328 ( 19 0 ) capacitor c=0.0120345f //x=38.97 //y=2.945
c329 ( 18 0 ) capacitor c=0.00384658f //x=38.97 //y=2.625
c330 ( 16 0 ) capacitor c=0.0631071f //x=37.12 //y=5.25
c331 ( 15 0 ) capacitor c=0.0123676f //x=37.12 //y=2.945
c332 ( 14 0 ) capacitor c=0.0168574f //x=37.12 //y=2.625
c333 ( 12 0 ) capacitor c=0.00493487f //x=36.72 //y=1.845
c334 ( 11 0 ) capacitor c=0.0126211f //x=37.035 //y=1.845
c335 ( 10 0 ) capacitor c=0.0136149f //x=36.635 //y=1.76
c336 ( 9 0 ) capacitor c=0.0113786f //x=36.635 //y=1.305
c337 ( 7 0 ) capacitor c=0.0235567f //x=37.035 //y=5.335
c338 ( 6 0 ) capacitor c=0.00906713f //x=36.34 //y=5.56
c339 ( 3 0 ) capacitor c=0.0180822f //x=36.225 //y=5.335
c340 ( 1 0 ) capacitor c=0.0152149f //x=35.34 //y=5.335
r341 (  128 130 ) resistor r=20.6867 //w=0.233 //l=0.1 //layer=ply \
 //thickness=0.18 //x=38.87 //y=4.88 //x2=38.97 //y2=4.88
r342 (  121 130 ) resistor r=70.3348 //w=0.233 //l=0.414367 //layer=ply \
 //thickness=0.18 //x=39.31 //y=5.045 //x2=38.97 //y2=4.88
r343 (  120 132 ) resistor r=45.1352 //w=0.168 //l=0.173853 //layer=ply \
 //thickness=0.18 //x=39.305 //y=1.39 //x2=39.265 //y2=1.545
r344 (  119 131 ) resistor r=45.1352 //w=0.168 //l=0.173853 //layer=ply \
 //thickness=0.18 //x=39.305 //y=1.045 //x2=39.265 //y2=0.89
r345 (  119 120 ) resistor r=176.904 //w=0.094 //l=0.345 //layer=ply \
 //thickness=0.18 //x=39.305 //y=1.045 //x2=39.305 //y2=1.39
r346 (  117 127 ) resistor r=10.701 //w=0.21 //l=0.115 //layer=ply \
 //thickness=0.18 //x=38.93 //y=1.545 //x2=38.815 //y2=1.545
r347 (  116 132 ) resistor r=5.52526 //w=0.168 //l=0.115 //layer=ply \
 //thickness=0.18 //x=39.15 //y=1.545 //x2=39.265 //y2=1.545
r348 (  115 126 ) resistor r=5.52526 //w=0.168 //l=0.115 //layer=ply \
 //thickness=0.18 //x=38.93 //y=0.89 //x2=38.815 //y2=0.89
r349 (  114 131 ) resistor r=5.52526 //w=0.168 //l=0.115 //layer=ply \
 //thickness=0.18 //x=39.15 //y=0.89 //x2=39.265 //y2=0.89
r350 (  114 115 ) resistor r=112.809 //w=0.094 //l=0.22 //layer=ply \
 //thickness=0.18 //x=39.15 //y=0.89 //x2=38.93 //y2=0.89
r351 (  111 128 ) resistor r=13.0941 //w=0.233 //l=0.165 //layer=ply \
 //thickness=0.18 //x=38.87 //y=5.045 //x2=38.87 //y2=4.88
r352 (  110 125 ) resistor r=34.8111 //w=0.27 //l=0.264953 //layer=ply \
 //thickness=0.18 //x=38.775 //y=2.095 //x2=38.97 //y2=2.26
r353 (  109 127 ) resistor r=39.5823 //w=0.21 //l=0.173853 //layer=ply \
 //thickness=0.18 //x=38.775 //y=1.7 //x2=38.815 //y2=1.545
r354 (  109 110 ) resistor r=202.543 //w=0.094 //l=0.395 //layer=ply \
 //thickness=0.18 //x=38.775 //y=1.7 //x2=38.775 //y2=2.095
r355 (  108 127 ) resistor r=39.5823 //w=0.21 //l=0.173853 //layer=ply \
 //thickness=0.18 //x=38.775 //y=1.39 //x2=38.815 //y2=1.545
r356 (  107 126 ) resistor r=45.1352 //w=0.168 //l=0.173853 //layer=ply \
 //thickness=0.18 //x=38.775 //y=1.045 //x2=38.815 //y2=0.89
r357 (  107 108 ) resistor r=176.904 //w=0.094 //l=0.345 //layer=ply \
 //thickness=0.18 //x=38.775 //y=1.045 //x2=38.775 //y2=1.39
r358 (  106 121 ) resistor r=592.245 //w=0.094 //l=1.155 //layer=ply \
 //thickness=0.18 //x=39.31 //y=6.2 //x2=39.31 //y2=5.045
r359 (  105 111 ) resistor r=592.245 //w=0.094 //l=1.155 //layer=ply \
 //thickness=0.18 //x=38.87 //y=6.2 //x2=38.87 //y2=5.045
r360 (  104 116 ) resistor r=56.4043 //w=0.094 //l=0.11 //layer=ply \
 //thickness=0.18 //x=39.04 //y=1.545 //x2=39.15 //y2=1.545
r361 (  104 117 ) resistor r=56.4043 //w=0.094 //l=0.11 //layer=ply \
 //thickness=0.18 //x=39.04 //y=1.545 //x2=38.93 //y2=1.545
r362 (  100 130 ) resistor r=152 //w=0.17 //l=0.17 //layer=licon //count=1 \
 //x=38.97 //y=4.88 //x2=38.97 //y2=4.88
r363 (  91 125 ) resistor r=152 //w=0.17 //l=0.17 //layer=licon //count=1 \
 //x=38.97 //y=2.26 //x2=38.97 //y2=2.26
r364 (  74 137 ) resistor r=23.615 //w=0.187 //l=0.345 //layer=li \
 //thickness=0.1 //x=36.34 //y=5.56 //x2=36.34 //y2=5.905
r365 (  66 136 ) resistor r=23.615 //w=0.187 //l=0.345 //layer=li \
 //thickness=0.1 //x=35.46 //y=5.56 //x2=35.46 //y2=5.905
r366 (  58 135 ) resistor r=23.615 //w=0.187 //l=0.345 //layer=li \
 //thickness=0.1 //x=34.58 //y=5.56 //x2=34.58 //y2=5.905
r367 (  54 55 ) resistor r=0.10734 //w=0.281 //l=0.16 //layer=m2 \
 //thickness=0.36 //x=38.965 //y=2.785 //x2=38.805 //y2=2.785
r368 (  52 55 ) resistor r=1.45515 //w=0.131 //l=1.525 //layer=m2 \
 //thickness=0.36 //x=37.28 //y=2.77 //x2=38.805 //y2=2.77
r369 (  50 52 ) resistor r=0.10734 //w=0.281 //l=0.16 //layer=m2 \
 //thickness=0.36 //x=37.12 //y=2.785 //x2=37.28 //y2=2.785
r370 (  44 100 ) resistor r=9.3 //w=0.17 //l=0.17 //layer=mcon //count=1 \
 //x=38.97 //y=4.88 //x2=38.97 //y2=4.88
r371 (  44 45 ) resistor r=0.103207 //w=0.196 //l=0.14 //layer=m1 \
 //thickness=0.36 //x=38.972 //y=4.88 //x2=38.972 //y2=4.74
r372 (  41 91 ) resistor r=9.3 //w=0.17 //l=0.17 //layer=mcon //count=1 \
 //x=38.97 //y=2.26 //x2=38.97 //y2=2.26
r373 (  39 54 ) resistor r=4.5 //w=0.15 //l=0.15 //layer=via1 //count=1 \
 //x=38.965 //y=2.785 //x2=38.965 //y2=2.785
r374 (  37 39 ) resistor r=0.00501337 //w=0.374 //l=0.015 //layer=m1 \
 //thickness=0.36 //x=38.915 //y=2.77 //x2=38.915 //y2=2.785
r375 (  35 50 ) resistor r=4.5 //w=0.15 //l=0.15 //layer=via1 //count=1 \
 //x=37.12 //y=2.785 //x2=37.12 //y2=2.785
r376 (  33 35 ) resistor r=0.0049867 //w=0.376 //l=0.015 //layer=m1 \
 //thickness=0.36 //x=37.172 //y=2.77 //x2=37.172 //y2=2.785
r377 (  31 133 ) resistor r=9.3 //w=0.17 //l=0.17 //layer=mcon //count=1 \
 //x=36.635 //y=1.19 //x2=36.635 //y2=1.19
r378 (  29 74 ) resistor r=9.3 //w=0.17 //l=0.17 //layer=mcon //count=1 \
 //x=36.34 //y=5.56 //x2=36.34 //y2=5.56
r379 (  26 66 ) resistor r=9.3 //w=0.17 //l=0.17 //layer=mcon //count=1 \
 //x=35.46 //y=5.56 //x2=35.46 //y2=5.56
r380 (  24 26 ) resistor r=0.121228 //w=0.232 //l=0.225 //layer=m1 \
 //thickness=0.36 //x=35.46 //y=5.335 //x2=35.46 //y2=5.56
r381 (  23 58 ) resistor r=9.3 //w=0.17 //l=0.17 //layer=mcon //count=1 \
 //x=34.58 //y=5.56 //x2=34.58 //y2=5.56
r382 (  21 23 ) resistor r=0.129608 //w=0.217 //l=0.225 //layer=m1 \
 //thickness=0.36 //x=34.582 //y=5.335 //x2=34.582 //y2=5.56
r383 (  19 39 ) resistor r=0.0910802 //w=0.374 //l=0.185472 //layer=m1 \
 //thickness=0.36 //x=38.97 //y=2.945 //x2=38.915 //y2=2.785
r384 (  19 45 ) resistor r=1.71279 //w=0.131 //l=1.795 //layer=m1 \
 //thickness=0.36 //x=38.97 //y=2.945 //x2=38.97 //y2=4.74
r385 (  18 37 ) resistor r=0.0860668 //w=0.374 //l=0.170294 //layer=m1 \
 //thickness=0.36 //x=38.97 //y=2.625 //x2=38.915 //y2=2.77
r386 (  17 41 ) resistor r=0.0933015 //w=0.201 //l=0.125 //layer=m1 \
 //thickness=0.36 //x=38.97 //y=2.385 //x2=38.97 //y2=2.26
r387 (  17 18 ) resistor r=0.229008 //w=0.131 //l=0.24 //layer=m1 \
 //thickness=0.36 //x=38.97 //y=2.385 //x2=38.97 //y2=2.625
r388 (  15 35 ) resistor r=0.0911593 //w=0.376 //l=0.184174 //layer=m1 \
 //thickness=0.36 //x=37.12 //y=2.945 //x2=37.172 //y2=2.785
r389 (  15 16 ) resistor r=2.19943 //w=0.131 //l=2.305 //layer=m1 \
 //thickness=0.36 //x=37.12 //y=2.945 //x2=37.12 //y2=5.25
r390 (  14 33 ) resistor r=0.0861726 //w=0.376 //l=0.169012 //layer=m1 \
 //thickness=0.36 //x=37.12 //y=2.625 //x2=37.172 //y2=2.77
r391 (  13 14 ) resistor r=0.663168 //w=0.131 //l=0.695 //layer=m1 \
 //thickness=0.36 //x=37.12 //y=1.93 //x2=37.12 //y2=2.625
r392 (  11 13 ) resistor r=0.0698411 //w=0.17 //l=0.120208 //layer=m1 \
 //thickness=0.36 //x=37.035 //y=1.845 //x2=37.12 //y2=1.93
r393 (  11 12 ) resistor r=0.300573 //w=0.131 //l=0.315 //layer=m1 \
 //thickness=0.36 //x=37.035 //y=1.845 //x2=36.72 //y2=1.845
r394 (  10 12 ) resistor r=0.0698411 //w=0.17 //l=0.120208 //layer=m1 \
 //thickness=0.36 //x=36.635 //y=1.76 //x2=36.72 //y2=1.845
r395 (  9 31 ) resistor r=0.0717383 //w=0.224 //l=0.115 //layer=m1 \
 //thickness=0.36 //x=36.635 //y=1.305 //x2=36.635 //y2=1.19
r396 (  9 10 ) resistor r=0.43416 //w=0.131 //l=0.455 //layer=m1 \
 //thickness=0.36 //x=36.635 //y=1.305 //x2=36.635 //y2=1.76
r397 (  8 27 ) resistor r=0.0675342 //w=0.23 //l=0.115 //layer=m1 \
 //thickness=0.36 //x=36.455 //y=5.335 //x2=36.34 //y2=5.335
r398 (  7 16 ) resistor r=0.0698411 //w=0.17 //l=0.120208 //layer=m1 \
 //thickness=0.36 //x=37.035 //y=5.335 //x2=37.12 //y2=5.25
r399 (  7 8 ) resistor r=0.553435 //w=0.131 //l=0.58 //layer=m1 \
 //thickness=0.36 //x=37.035 //y=5.335 //x2=36.455 //y2=5.335
r400 (  6 29 ) resistor r=0.00118313 //w=0.23 //layer=m1 //thickness=0.36 \
 //x=36.34 //y=5.56 //x2=36.34 //y2=5.56
r401 (  5 27 ) resistor r=0.002872 //w=0.34 //l=0.085 //layer=m1 \
 //thickness=0.36 //x=36.34 //y=5.42 //x2=36.34 //y2=5.335
r402 (  5 6 ) resistor r=0.091623 //w=0.191 //l=0.14 //layer=m1 \
 //thickness=0.36 //x=36.34 //y=5.42 //x2=36.34 //y2=5.56
r403 (  4 24 ) resistor r=0.0262263 //w=0.232 //l=0.12 //layer=m1 \
 //thickness=0.36 //x=35.58 //y=5.335 //x2=35.46 //y2=5.335
r404 (  3 27 ) resistor r=0.0675342 //w=0.23 //l=0.115 //layer=m1 \
 //thickness=0.36 //x=36.225 //y=5.335 //x2=36.34 //y2=5.335
r405 (  3 4 ) resistor r=0.615458 //w=0.131 //l=0.645 //layer=m1 \
 //thickness=0.36 //x=36.225 //y=5.335 //x2=35.58 //y2=5.335
r406 (  2 21 ) resistor r=0.0222262 //w=0.217 //l=0.118 //layer=m1 \
 //thickness=0.36 //x=34.7 //y=5.335 //x2=34.582 //y2=5.335
r407 (  1 24 ) resistor r=0.0262263 //w=0.232 //l=0.12 //layer=m1 \
 //thickness=0.36 //x=35.34 //y=5.335 //x2=35.46 //y2=5.335
r408 (  1 2 ) resistor r=0.610687 //w=0.131 //l=0.64 //layer=m1 \
 //thickness=0.36 //x=35.34 //y=5.335 //x2=34.7 //y2=5.335
ends PM_TMRDFFSNQX1\%noxref_7

subckt PM_TMRDFFSNQX1\%noxref_8 ( 2 3 4 5 7 10 11 13 14 15 16 18 19 20 22 23 \
 26 34 35 38 41 47 50 54 57 58 60 63 67 71 72 75 84 89 97 105 122 131 135 136 \
 137 138 139 140 141 142 143 148 150 152 158 159 160 161 162 163 167 169 172 \
 173 178 179 182 196 199 201 202 203 )
c497 ( 199 0 ) capacitor c=0.00885916f //x=31.635 //y=1.095
c498 ( 196 0 ) capacitor c=0.0635976f //x=42.3 //y=4.88
c499 ( 182 0 ) capacitor c=0.0354953f //x=26.79 //y=4.88
c500 ( 179 0 ) capacitor c=0.0284095f //x=26.76 //y=2.095
c501 ( 178 0 ) capacitor c=0.0476356f //x=26.76 //y=2.26
c502 ( 173 0 ) capacitor c=0.0318956f //x=42.635 //y=1.39
c503 ( 172 0 ) capacitor c=0.0186809f //x=42.635 //y=1.045
c504 ( 169 0 ) capacitor c=0.0141821f //x=42.48 //y=1.545
c505 ( 167 0 ) capacitor c=0.0158553f //x=42.48 //y=0.89
c506 ( 163 0 ) capacitor c=0.088055f //x=42.105 //y=2.095
c507 ( 162 0 ) capacitor c=0.0229235f //x=42.105 //y=1.7
c508 ( 161 0 ) capacitor c=0.0234359f //x=42.105 //y=1.39
c509 ( 160 0 ) capacitor c=0.0198759f //x=42.105 //y=1.045
c510 ( 159 0 ) capacitor c=0.0439708f //x=27.325 //y=1.43
c511 ( 158 0 ) capacitor c=0.0192582f //x=27.325 //y=1.085
c512 ( 152 0 ) capacitor c=0.0162526f //x=27.17 //y=1.585
c513 ( 150 0 ) capacitor c=0.0157807f //x=27.17 //y=0.93
c514 ( 148 0 ) capacitor c=0.0357885f //x=27.165 //y=4.97
c515 ( 143 0 ) capacitor c=0.0210762f //x=26.795 //y=1.74
c516 ( 142 0 ) capacitor c=0.0168511f //x=26.795 //y=1.43
c517 ( 141 0 ) capacitor c=0.0175485f //x=26.795 //y=1.085
c518 ( 140 0 ) capacitor c=0.110369f //x=42.64 //y=6.2
c519 ( 139 0 ) capacitor c=0.154619f //x=42.2 //y=6.2
c520 ( 138 0 ) capacitor c=0.155269f //x=27.24 //y=6.2
c521 ( 137 0 ) capacitor c=0.110375f //x=26.8 //y=6.2
c522 ( 131 0 ) capacitor c=6.0732e-19 //x=42.3 //y=4.88
c523 ( 122 0 ) capacitor c=7.85889e-19 //x=42.3 //y=2.26
c524 ( 105 0 ) capacitor c=0.0293709f //x=31.53 //y=5.56
c525 ( 97 0 ) capacitor c=0.029137f //x=30.65 //y=5.56
c526 ( 89 0 ) capacitor c=0.0277605f //x=29.77 //y=5.56
c527 ( 84 0 ) capacitor c=5.80994e-19 //x=26.79 //y=4.88
c528 ( 75 0 ) capacitor c=5.78095e-19 //x=26.76 //y=2.26
c529 ( 72 0 ) capacitor c=0.0941143f //x=42.14 //y=4.265
c530 ( 71 0 ) capacitor c=7.81013e-19 //x=42.3 //y=4.265
c531 ( 67 0 ) capacitor c=7.93125e-19 //x=26.92 //y=4.245
c532 ( 63 0 ) capacitor c=9.81648e-19 //x=32.465 //y=4.25
c533 ( 60 0 ) capacitor c=0.0589187f //x=32.145 //y=4.25
c534 ( 58 0 ) capacitor c=0.00589655f //x=42.302 //y=4.74
c535 ( 57 0 ) capacitor c=0.00587099f //x=42.3 //y=4.88
c536 ( 54 0 ) capacitor c=0.00463527f //x=42.3 //y=2.26
c537 ( 50 0 ) capacitor c=0.0134728f //x=42.3 //y=4.25
c538 ( 47 0 ) capacitor c=0.0149922f //x=32.305 //y=4.25
c539 ( 41 0 ) capacitor c=8.88597e-19 //x=31.53 //y=5.335
c540 ( 38 0 ) capacitor c=0.0073827f //x=30.65 //y=5.335
c541 ( 35 0 ) capacitor c=0.0112819f //x=29.772 //y=5.335
c542 ( 34 0 ) capacitor c=0.0143718f //x=26.76 //y=4.25
c543 ( 26 0 ) capacitor c=0.00504845f //x=26.76 //y=2.26
c544 ( 23 0 ) capacitor c=0.0119529f //x=42.3 //y=4.425
c545 ( 22 0 ) capacitor c=0.0459554f //x=42.3 //y=4.105
c546 ( 20 0 ) capacitor c=0.0222419f //x=32.31 //y=5.25
c547 ( 19 0 ) capacitor c=0.0128722f //x=32.31 //y=4.41
c548 ( 18 0 ) capacitor c=0.0595446f //x=32.31 //y=4.09
c549 ( 16 0 ) capacitor c=0.0048771f //x=31.91 //y=1.845
c550 ( 15 0 ) capacitor c=0.0132264f //x=32.225 //y=1.845
c551 ( 14 0 ) capacitor c=0.0167333f //x=31.825 //y=1.76
c552 ( 13 0 ) capacitor c=0.0111164f //x=31.825 //y=1.305
c553 ( 11 0 ) capacitor c=0.0223199f //x=32.225 //y=5.335
c554 ( 10 0 ) capacitor c=0.00933983f //x=31.53 //y=5.56
c555 ( 7 0 ) capacitor c=0.019596f //x=31.415 //y=5.335
c556 ( 5 0 ) capacitor c=0.0147581f //x=30.53 //y=5.335
c557 ( 4 0 ) capacitor c=0.00931067f //x=26.76 //y=4.735
c558 ( 3 0 ) capacitor c=0.0102157f //x=26.76 //y=4.405
c559 ( 2 0 ) capacitor c=0.0357133f //x=26.76 //y=4.085
r560 (  194 196 ) resistor r=20.6867 //w=0.233 //l=0.1 //layer=ply \
 //thickness=0.18 //x=42.2 //y=4.88 //x2=42.3 //y2=4.88
r561 (  184 185 ) resistor r=32.4568 //w=0.214 //l=0.075 //layer=ply \
 //thickness=0.18 //x=26.79 //y=4.97 //x2=26.79 //y2=5.045
r562 (  182 184 ) resistor r=20.271 //w=0.214 //l=0.09 //layer=ply \
 //thickness=0.18 //x=26.79 //y=4.88 //x2=26.79 //y2=4.97
r563 (  178 179 ) resistor r=52.7279 //w=0.214 //l=0.165 //layer=ply \
 //thickness=0.18 //x=26.76 //y=2.26 //x2=26.76 //y2=2.095
r564 (  174 196 ) resistor r=70.3348 //w=0.233 //l=0.414367 //layer=ply \
 //thickness=0.18 //x=42.64 //y=5.045 //x2=42.3 //y2=4.88
r565 (  173 198 ) resistor r=45.1352 //w=0.168 //l=0.173853 //layer=ply \
 //thickness=0.18 //x=42.635 //y=1.39 //x2=42.595 //y2=1.545
r566 (  172 197 ) resistor r=45.1352 //w=0.168 //l=0.173853 //layer=ply \
 //thickness=0.18 //x=42.635 //y=1.045 //x2=42.595 //y2=0.89
r567 (  172 173 ) resistor r=176.904 //w=0.094 //l=0.345 //layer=ply \
 //thickness=0.18 //x=42.635 //y=1.045 //x2=42.635 //y2=1.39
r568 (  170 193 ) resistor r=10.701 //w=0.21 //l=0.115 //layer=ply \
 //thickness=0.18 //x=42.26 //y=1.545 //x2=42.145 //y2=1.545
r569 (  169 198 ) resistor r=5.52526 //w=0.168 //l=0.115 //layer=ply \
 //thickness=0.18 //x=42.48 //y=1.545 //x2=42.595 //y2=1.545
r570 (  168 192 ) resistor r=5.52526 //w=0.168 //l=0.115 //layer=ply \
 //thickness=0.18 //x=42.26 //y=0.89 //x2=42.145 //y2=0.89
r571 (  167 197 ) resistor r=5.52526 //w=0.168 //l=0.115 //layer=ply \
 //thickness=0.18 //x=42.48 //y=0.89 //x2=42.595 //y2=0.89
r572 (  167 168 ) resistor r=112.809 //w=0.094 //l=0.22 //layer=ply \
 //thickness=0.18 //x=42.48 //y=0.89 //x2=42.26 //y2=0.89
r573 (  164 194 ) resistor r=13.0941 //w=0.233 //l=0.165 //layer=ply \
 //thickness=0.18 //x=42.2 //y=5.045 //x2=42.2 //y2=4.88
r574 (  163 191 ) resistor r=34.8111 //w=0.27 //l=0.264953 //layer=ply \
 //thickness=0.18 //x=42.105 //y=2.095 //x2=42.3 //y2=2.26
r575 (  162 193 ) resistor r=39.5823 //w=0.21 //l=0.173853 //layer=ply \
 //thickness=0.18 //x=42.105 //y=1.7 //x2=42.145 //y2=1.545
r576 (  162 163 ) resistor r=202.543 //w=0.094 //l=0.395 //layer=ply \
 //thickness=0.18 //x=42.105 //y=1.7 //x2=42.105 //y2=2.095
r577 (  161 193 ) resistor r=39.5823 //w=0.21 //l=0.173853 //layer=ply \
 //thickness=0.18 //x=42.105 //y=1.39 //x2=42.145 //y2=1.545
r578 (  160 192 ) resistor r=45.1352 //w=0.168 //l=0.173853 //layer=ply \
 //thickness=0.18 //x=42.105 //y=1.045 //x2=42.145 //y2=0.89
r579 (  160 161 ) resistor r=176.904 //w=0.094 //l=0.345 //layer=ply \
 //thickness=0.18 //x=42.105 //y=1.045 //x2=42.105 //y2=1.39
r580 (  159 189 ) resistor r=45.1352 //w=0.168 //l=0.173853 //layer=ply \
 //thickness=0.18 //x=27.325 //y=1.43 //x2=27.285 //y2=1.585
r581 (  158 188 ) resistor r=45.1352 //w=0.168 //l=0.173853 //layer=ply \
 //thickness=0.18 //x=27.325 //y=1.085 //x2=27.285 //y2=0.93
r582 (  158 159 ) resistor r=176.904 //w=0.094 //l=0.345 //layer=ply \
 //thickness=0.18 //x=27.325 //y=1.085 //x2=27.325 //y2=1.43
r583 (  153 187 ) resistor r=10.701 //w=0.21 //l=0.115 //layer=ply \
 //thickness=0.18 //x=26.95 //y=1.585 //x2=26.835 //y2=1.585
r584 (  152 189 ) resistor r=5.52526 //w=0.168 //l=0.115 //layer=ply \
 //thickness=0.18 //x=27.17 //y=1.585 //x2=27.285 //y2=1.585
r585 (  151 186 ) resistor r=5.52526 //w=0.168 //l=0.115 //layer=ply \
 //thickness=0.18 //x=26.95 //y=0.93 //x2=26.835 //y2=0.93
r586 (  150 188 ) resistor r=5.52526 //w=0.168 //l=0.115 //layer=ply \
 //thickness=0.18 //x=27.17 //y=0.93 //x2=27.285 //y2=0.93
r587 (  150 151 ) resistor r=112.809 //w=0.094 //l=0.22 //layer=ply \
 //thickness=0.18 //x=27.17 //y=0.93 //x2=26.95 //y2=0.93
r588 (  149 184 ) resistor r=16.5046 //w=0.27 //l=0.135 //layer=ply \
 //thickness=0.18 //x=26.925 //y=4.97 //x2=26.79 //y2=4.97
r589 (  148 155 ) resistor r=26.9307 //w=0.15 //l=0.106066 //layer=ply \
 //thickness=0.18 //x=27.165 //y=4.97 //x2=27.24 //y2=5.045
r590 (  148 149 ) resistor r=123.064 //w=0.094 //l=0.24 //layer=ply \
 //thickness=0.18 //x=27.165 //y=4.97 //x2=26.925 //y2=4.97
r591 (  143 187 ) resistor r=39.5823 //w=0.21 //l=0.173853 //layer=ply \
 //thickness=0.18 //x=26.795 //y=1.74 //x2=26.835 //y2=1.585
r592 (  143 179 ) resistor r=182.032 //w=0.094 //l=0.355 //layer=ply \
 //thickness=0.18 //x=26.795 //y=1.74 //x2=26.795 //y2=2.095
r593 (  142 187 ) resistor r=39.5823 //w=0.21 //l=0.173853 //layer=ply \
 //thickness=0.18 //x=26.795 //y=1.43 //x2=26.835 //y2=1.585
r594 (  141 186 ) resistor r=45.1352 //w=0.168 //l=0.173853 //layer=ply \
 //thickness=0.18 //x=26.795 //y=1.085 //x2=26.835 //y2=0.93
r595 (  141 142 ) resistor r=176.904 //w=0.094 //l=0.345 //layer=ply \
 //thickness=0.18 //x=26.795 //y=1.085 //x2=26.795 //y2=1.43
r596 (  140 174 ) resistor r=592.245 //w=0.094 //l=1.155 //layer=ply \
 //thickness=0.18 //x=42.64 //y=6.2 //x2=42.64 //y2=5.045
r597 (  139 164 ) resistor r=592.245 //w=0.094 //l=1.155 //layer=ply \
 //thickness=0.18 //x=42.2 //y=6.2 //x2=42.2 //y2=5.045
r598 (  138 155 ) resistor r=592.245 //w=0.094 //l=1.155 //layer=ply \
 //thickness=0.18 //x=27.24 //y=6.2 //x2=27.24 //y2=5.045
r599 (  137 185 ) resistor r=592.245 //w=0.094 //l=1.155 //layer=ply \
 //thickness=0.18 //x=26.8 //y=6.2 //x2=26.8 //y2=5.045
r600 (  136 169 ) resistor r=56.4043 //w=0.094 //l=0.11 //layer=ply \
 //thickness=0.18 //x=42.37 //y=1.545 //x2=42.48 //y2=1.545
r601 (  136 170 ) resistor r=56.4043 //w=0.094 //l=0.11 //layer=ply \
 //thickness=0.18 //x=42.37 //y=1.545 //x2=42.26 //y2=1.545
r602 (  135 152 ) resistor r=56.4043 //w=0.094 //l=0.11 //layer=ply \
 //thickness=0.18 //x=27.06 //y=1.585 //x2=27.17 //y2=1.585
r603 (  135 153 ) resistor r=56.4043 //w=0.094 //l=0.11 //layer=ply \
 //thickness=0.18 //x=27.06 //y=1.585 //x2=26.95 //y2=1.585
r604 (  131 196 ) resistor r=152 //w=0.17 //l=0.17 //layer=licon //count=1 \
 //x=42.3 //y=4.88 //x2=42.3 //y2=4.88
r605 (  122 191 ) resistor r=152 //w=0.17 //l=0.17 //layer=licon //count=1 \
 //x=42.3 //y=2.26 //x2=42.3 //y2=2.26
r606 (  105 203 ) resistor r=23.615 //w=0.187 //l=0.345 //layer=li \
 //thickness=0.1 //x=31.53 //y=5.56 //x2=31.53 //y2=5.905
r607 (  97 202 ) resistor r=23.615 //w=0.187 //l=0.345 //layer=li \
 //thickness=0.1 //x=30.65 //y=5.56 //x2=30.65 //y2=5.905
r608 (  89 201 ) resistor r=23.615 //w=0.187 //l=0.345 //layer=li \
 //thickness=0.1 //x=29.77 //y=5.56 //x2=29.77 //y2=5.905
r609 (  84 182 ) resistor r=152 //w=0.17 //l=0.17 //layer=licon //count=1 \
 //x=26.79 //y=4.88 //x2=26.79 //y2=4.88
r610 (  75 178 ) resistor r=152 //w=0.17 //l=0.17 //layer=licon //count=1 \
 //x=26.76 //y=2.26 //x2=26.76 //y2=2.26
r611 (  71 72 ) resistor r=0.10734 //w=0.281 //l=0.16 //layer=m2 \
 //thickness=0.36 //x=42.3 //y=4.265 //x2=42.14 //y2=4.265
r612 (  65 67 ) resistor r=0.10734 //w=0.281 //l=0.16 //layer=m2 \
 //thickness=0.36 //x=26.76 //y=4.245 //x2=26.92 //y2=4.245
r613 (  63 69 ) resistor r=0.10734 //w=0.281 //l=0.16 //layer=m2 \
 //thickness=0.36 //x=32.465 //y=4.25 //x2=32.305 //y2=4.25
r614 (  63 72 ) resistor r=9.23187 //w=0.131 //l=9.675 //layer=m2 \
 //thickness=0.36 //x=32.465 //y=4.25 //x2=42.14 //y2=4.25
r615 (  60 69 ) resistor r=0.10734 //w=0.281 //l=0.16 //layer=m2 \
 //thickness=0.36 //x=32.145 //y=4.25 //x2=32.305 //y2=4.25
r616 (  60 67 ) resistor r=4.98569 //w=0.131 //l=5.225 //layer=m2 \
 //thickness=0.36 //x=32.145 //y=4.25 //x2=26.92 //y2=4.25
r617 (  57 131 ) resistor r=9.3 //w=0.17 //l=0.17 //layer=mcon //count=1 \
 //x=42.3 //y=4.88 //x2=42.3 //y2=4.88
r618 (  57 58 ) resistor r=0.103207 //w=0.196 //l=0.14 //layer=m1 \
 //thickness=0.36 //x=42.302 //y=4.88 //x2=42.302 //y2=4.74
r619 (  54 122 ) resistor r=9.3 //w=0.17 //l=0.17 //layer=mcon //count=1 \
 //x=42.3 //y=2.26 //x2=42.3 //y2=2.26
r620 (  52 71 ) resistor r=4.5 //w=0.15 //l=0.15 //layer=via1 //count=1 \
 //x=42.3 //y=4.265 //x2=42.3 //y2=4.265
r621 (  50 52 ) resistor r=0.0049867 //w=0.376 //l=0.015 //layer=m1 \
 //thickness=0.36 //x=42.247 //y=4.25 //x2=42.247 //y2=4.265
r622 (  47 69 ) resistor r=4.5 //w=0.15 //l=0.15 //layer=via1 //count=1 \
 //x=32.305 //y=4.25 //x2=32.305 //y2=4.25
r623 (  45 199 ) resistor r=9.3 //w=0.17 //l=0.17 //layer=mcon //count=1 \
 //x=31.825 //y=1.19 //x2=31.825 //y2=1.19
r624 (  43 105 ) resistor r=9.3 //w=0.17 //l=0.17 //layer=mcon //count=1 \
 //x=31.53 //y=5.56 //x2=31.53 //y2=5.56
r625 (  40 97 ) resistor r=9.3 //w=0.17 //l=0.17 //layer=mcon //count=1 \
 //x=30.65 //y=5.56 //x2=30.65 //y2=5.56
r626 (  38 40 ) resistor r=0.121228 //w=0.232 //l=0.225 //layer=m1 \
 //thickness=0.36 //x=30.65 //y=5.335 //x2=30.65 //y2=5.56
r627 (  37 89 ) resistor r=9.3 //w=0.17 //l=0.17 //layer=mcon //count=1 \
 //x=29.77 //y=5.56 //x2=29.77 //y2=5.56
r628 (  35 37 ) resistor r=0.129608 //w=0.217 //l=0.225 //layer=m1 \
 //thickness=0.36 //x=29.772 //y=5.335 //x2=29.772 //y2=5.56
r629 (  32 65 ) resistor r=4.5 //w=0.15 //l=0.15 //layer=via1 //count=1 \
 //x=26.76 //y=4.245 //x2=26.76 //y2=4.245
r630 (  32 34 ) resistor r=0.00166223 //w=0.376 //l=0.005 //layer=m1 \
 //thickness=0.36 //x=26.812 //y=4.245 //x2=26.812 //y2=4.25
r631 (  30 84 ) resistor r=9.3 //w=0.17 //l=0.17 //layer=mcon //count=1 \
 //x=26.79 //y=4.88 //x2=26.79 //y2=4.88
r632 (  26 75 ) resistor r=9.3 //w=0.17 //l=0.17 //layer=mcon //count=1 \
 //x=26.76 //y=2.26 //x2=26.76 //y2=2.26
r633 (  26 28 ) resistor r=0.0936408 //w=0.196 //l=0.125 //layer=m1 \
 //thickness=0.36 //x=26.762 //y=2.26 //x2=26.762 //y2=2.385
r634 (  23 52 ) resistor r=0.0911593 //w=0.376 //l=0.184608 //layer=m1 \
 //thickness=0.36 //x=42.3 //y=4.425 //x2=42.247 //y2=4.265
r635 (  23 58 ) resistor r=0.300573 //w=0.131 //l=0.315 //layer=m1 \
 //thickness=0.36 //x=42.3 //y=4.425 //x2=42.3 //y2=4.74
r636 (  22 50 ) resistor r=0.0861726 //w=0.376 //l=0.16944 //layer=m1 \
 //thickness=0.36 //x=42.3 //y=4.105 //x2=42.247 //y2=4.25
r637 (  21 54 ) resistor r=0.0933015 //w=0.201 //l=0.125 //layer=m1 \
 //thickness=0.36 //x=42.3 //y=2.385 //x2=42.3 //y2=2.26
r638 (  21 22 ) resistor r=1.64122 //w=0.131 //l=1.72 //layer=m1 \
 //thickness=0.36 //x=42.3 //y=2.385 //x2=42.3 //y2=4.105
r639 (  19 47 ) resistor r=0.0911593 //w=0.376 //l=0.181989 //layer=m1 \
 //thickness=0.36 //x=32.31 //y=4.41 //x2=32.357 //y2=4.25
r640 (  19 20 ) resistor r=0.801527 //w=0.131 //l=0.84 //layer=m1 \
 //thickness=0.36 //x=32.31 //y=4.41 //x2=32.31 //y2=5.25
r641 (  18 47 ) resistor r=0.0911593 //w=0.376 //l=0.181989 //layer=m1 \
 //thickness=0.36 //x=32.31 //y=4.09 //x2=32.357 //y2=4.25
r642 (  17 18 ) resistor r=2.06107 //w=0.131 //l=2.16 //layer=m1 \
 //thickness=0.36 //x=32.31 //y=1.93 //x2=32.31 //y2=4.09
r643 (  15 17 ) resistor r=0.0698411 //w=0.17 //l=0.120208 //layer=m1 \
 //thickness=0.36 //x=32.225 //y=1.845 //x2=32.31 //y2=1.93
r644 (  15 16 ) resistor r=0.300573 //w=0.131 //l=0.315 //layer=m1 \
 //thickness=0.36 //x=32.225 //y=1.845 //x2=31.91 //y2=1.845
r645 (  14 16 ) resistor r=0.0698411 //w=0.17 //l=0.120208 //layer=m1 \
 //thickness=0.36 //x=31.825 //y=1.76 //x2=31.91 //y2=1.845
r646 (  13 45 ) resistor r=0.0717383 //w=0.224 //l=0.115 //layer=m1 \
 //thickness=0.36 //x=31.825 //y=1.305 //x2=31.825 //y2=1.19
r647 (  13 14 ) resistor r=0.43416 //w=0.131 //l=0.455 //layer=m1 \
 //thickness=0.36 //x=31.825 //y=1.305 //x2=31.825 //y2=1.76
r648 (  12 41 ) resistor r=0.0675342 //w=0.23 //l=0.115 //layer=m1 \
 //thickness=0.36 //x=31.645 //y=5.335 //x2=31.53 //y2=5.335
r649 (  11 20 ) resistor r=0.0698411 //w=0.17 //l=0.120208 //layer=m1 \
 //thickness=0.36 //x=32.225 //y=5.335 //x2=32.31 //y2=5.25
r650 (  11 12 ) resistor r=0.553435 //w=0.131 //l=0.58 //layer=m1 \
 //thickness=0.36 //x=32.225 //y=5.335 //x2=31.645 //y2=5.335
r651 (  10 43 ) resistor r=0.00118313 //w=0.23 //layer=m1 //thickness=0.36 \
 //x=31.53 //y=5.56 //x2=31.53 //y2=5.56
r652 (  9 41 ) resistor r=0.002872 //w=0.34 //l=0.085 //layer=m1 \
 //thickness=0.36 //x=31.53 //y=5.42 //x2=31.53 //y2=5.335
r653 (  9 10 ) resistor r=0.091623 //w=0.191 //l=0.14 //layer=m1 \
 //thickness=0.36 //x=31.53 //y=5.42 //x2=31.53 //y2=5.56
r654 (  8 38 ) resistor r=0.0262263 //w=0.232 //l=0.12 //layer=m1 \
 //thickness=0.36 //x=30.77 //y=5.335 //x2=30.65 //y2=5.335
r655 (  7 41 ) resistor r=0.0675342 //w=0.23 //l=0.115 //layer=m1 \
 //thickness=0.36 //x=31.415 //y=5.335 //x2=31.53 //y2=5.335
r656 (  7 8 ) resistor r=0.615458 //w=0.131 //l=0.645 //layer=m1 \
 //thickness=0.36 //x=31.415 //y=5.335 //x2=30.77 //y2=5.335
r657 (  6 35 ) resistor r=0.0222262 //w=0.217 //l=0.118 //layer=m1 \
 //thickness=0.36 //x=29.89 //y=5.335 //x2=29.772 //y2=5.335
r658 (  5 38 ) resistor r=0.0262263 //w=0.232 //l=0.12 //layer=m1 \
 //thickness=0.36 //x=30.53 //y=5.335 //x2=30.65 //y2=5.335
r659 (  5 6 ) resistor r=0.610687 //w=0.131 //l=0.64 //layer=m1 \
 //thickness=0.36 //x=30.53 //y=5.335 //x2=29.89 //y2=5.335
r660 (  4 30 ) resistor r=0.0878548 //w=0.228 //l=0.159295 //layer=m1 \
 //thickness=0.36 //x=26.76 //y=4.735 //x2=26.79 //y2=4.88
r661 (  3 34 ) resistor r=0.0894971 //w=0.376 //l=0.179123 //layer=m1 \
 //thickness=0.36 //x=26.76 //y=4.405 //x2=26.812 //y2=4.25
r662 (  3 4 ) resistor r=0.314885 //w=0.131 //l=0.33 //layer=m1 \
 //thickness=0.36 //x=26.76 //y=4.405 //x2=26.76 //y2=4.735
r663 (  2 32 ) resistor r=0.0911593 //w=0.376 //l=0.184174 //layer=m1 \
 //thickness=0.36 //x=26.76 //y=4.085 //x2=26.812 //y2=4.245
r664 (  2 28 ) resistor r=1.62214 //w=0.131 //l=1.7 //layer=m1 \
 //thickness=0.36 //x=26.76 //y=4.085 //x2=26.76 //y2=2.385
ends PM_TMRDFFSNQX1\%noxref_8

subckt PM_TMRDFFSNQX1\%noxref_9 ( 3 8 9 11 12 14 15 16 17 18 19 20 23 24 27 29 \
 32 36 48 50 51 54 62 79 88 92 93 94 95 96 97 98 99 101 107 108 109 110 122 \
 124 125 )
c289 ( 122 0 ) capacitor c=0.00878249f //x=43.15 //y=1.085
c290 ( 110 0 ) capacitor c=0.0612936f //x=45.905 //y=4.97
c291 ( 109 0 ) capacitor c=0.0376642f //x=46.195 //y=4.97
c292 ( 108 0 ) capacitor c=0.0346489f //x=45.86 //y=1.4
c293 ( 107 0 ) capacitor c=0.018692f //x=45.86 //y=1.055
c294 ( 101 0 ) capacitor c=0.0137077f //x=45.705 //y=1.555
c295 ( 99 0 ) capacitor c=0.0158585f //x=45.705 //y=0.9
c296 ( 98 0 ) capacitor c=0.0979536f //x=45.33 //y=2.095
c297 ( 97 0 ) capacitor c=0.0229444f //x=45.33 //y=1.71
c298 ( 96 0 ) capacitor c=0.0234359f //x=45.33 //y=1.4
c299 ( 95 0 ) capacitor c=0.019815f //x=45.33 //y=1.055
c300 ( 94 0 ) capacitor c=0.110208f //x=46.27 //y=6.2
c301 ( 93 0 ) capacitor c=0.158957f //x=45.83 //y=6.2
c302 ( 88 0 ) capacitor c=0.0014751f //x=45.63 //y=4.88
c303 ( 79 0 ) capacitor c=9.93222e-19 //x=45.63 //y=2.26
c304 ( 62 0 ) capacitor c=0.0322017f //x=43.3 //y=5.56
c305 ( 54 0 ) capacitor c=0.0290435f //x=42.42 //y=5.56
c306 ( 51 0 ) capacitor c=0.0155215f //x=45.47 //y=2.785
c307 ( 50 0 ) capacitor c=6.54212e-19 //x=45.63 //y=2.785
c308 ( 48 0 ) capacitor c=7.83236e-19 //x=43.935 //y=2.785
c309 ( 36 0 ) capacitor c=0.0155125f //x=45.63 //y=2.77
c310 ( 32 0 ) capacitor c=0.0149031f //x=43.78 //y=2.77
c311 ( 29 0 ) capacitor c=0.0113436f //x=43.34 //y=1.18
c312 ( 27 0 ) capacitor c=5.78613e-19 //x=43.3 //y=5.56
c313 ( 24 0 ) capacitor c=0.01085f //x=43.3 //y=5.38
c314 ( 23 0 ) capacitor c=0.00902159f //x=42.42 //y=5.56
c315 ( 20 0 ) capacitor c=0.0618047f //x=45.63 //y=4.755
c316 ( 19 0 ) capacitor c=0.0129556f //x=45.63 //y=2.945
c317 ( 18 0 ) capacitor c=0.00435263f //x=45.63 //y=2.625
c318 ( 17 0 ) capacitor c=0.00492791f //x=45.63 //y=2.375
c319 ( 16 0 ) capacitor c=0.0636083f //x=43.78 //y=5.295
c320 ( 15 0 ) capacitor c=0.0122204f //x=43.78 //y=2.945
c321 ( 14 0 ) capacitor c=0.0177588f //x=43.78 //y=2.625
c322 ( 12 0 ) capacitor c=0.00469281f //x=43.425 //y=1.835
c323 ( 11 0 ) capacitor c=0.0117443f //x=43.695 //y=1.835
c324 ( 9 0 ) capacitor c=0.011754f //x=43.695 //y=5.38
c325 ( 8 0 ) capacitor c=0.0133876f //x=43.34 //y=1.75
c326 ( 3 0 ) capacitor c=0.0141497f //x=43.185 //y=5.38
r327 (  109 111 ) resistor r=26.9307 //w=0.15 //l=0.106066 //layer=ply \
 //thickness=0.18 //x=46.195 //y=4.97 //x2=46.27 //y2=5.045
r328 (  109 110 ) resistor r=148.702 //w=0.094 //l=0.29 //layer=ply \
 //thickness=0.18 //x=46.195 //y=4.97 //x2=45.905 //y2=4.97
r329 (  108 121 ) resistor r=45.1352 //w=0.168 //l=0.173853 //layer=ply \
 //thickness=0.18 //x=45.86 //y=1.4 //x2=45.82 //y2=1.555
r330 (  107 120 ) resistor r=45.1352 //w=0.168 //l=0.173853 //layer=ply \
 //thickness=0.18 //x=45.86 //y=1.055 //x2=45.82 //y2=0.9
r331 (  107 108 ) resistor r=176.904 //w=0.094 //l=0.345 //layer=ply \
 //thickness=0.18 //x=45.86 //y=1.055 //x2=45.86 //y2=1.4
r332 (  104 110 ) resistor r=22.7971 //w=0.269 //l=0.106066 //layer=ply \
 //thickness=0.18 //x=45.83 //y=5.045 //x2=45.905 //y2=4.97
r333 (  104 119 ) resistor r=35.8364 //w=0.269 //l=0.270185 //layer=ply \
 //thickness=0.18 //x=45.83 //y=5.045 //x2=45.63 //y2=4.88
r334 (  102 115 ) resistor r=10.701 //w=0.21 //l=0.115 //layer=ply \
 //thickness=0.18 //x=45.485 //y=1.555 //x2=45.37 //y2=1.555
r335 (  101 121 ) resistor r=5.52526 //w=0.168 //l=0.115 //layer=ply \
 //thickness=0.18 //x=45.705 //y=1.555 //x2=45.82 //y2=1.555
r336 (  100 114 ) resistor r=5.52526 //w=0.168 //l=0.115 //layer=ply \
 //thickness=0.18 //x=45.485 //y=0.9 //x2=45.37 //y2=0.9
r337 (  99 120 ) resistor r=5.52526 //w=0.168 //l=0.115 //layer=ply \
 //thickness=0.18 //x=45.705 //y=0.9 //x2=45.82 //y2=0.9
r338 (  99 100 ) resistor r=112.809 //w=0.094 //l=0.22 //layer=ply \
 //thickness=0.18 //x=45.705 //y=0.9 //x2=45.485 //y2=0.9
r339 (  98 117 ) resistor r=58.7805 //w=0.246 //l=0.373497 //layer=ply \
 //thickness=0.18 //x=45.33 //y=2.095 //x2=45.63 //y2=2.26
r340 (  97 115 ) resistor r=39.5823 //w=0.21 //l=0.173853 //layer=ply \
 //thickness=0.18 //x=45.33 //y=1.71 //x2=45.37 //y2=1.555
r341 (  97 98 ) resistor r=197.415 //w=0.094 //l=0.385 //layer=ply \
 //thickness=0.18 //x=45.33 //y=1.71 //x2=45.33 //y2=2.095
r342 (  96 115 ) resistor r=39.5823 //w=0.21 //l=0.173853 //layer=ply \
 //thickness=0.18 //x=45.33 //y=1.4 //x2=45.37 //y2=1.555
r343 (  95 114 ) resistor r=45.1352 //w=0.168 //l=0.173853 //layer=ply \
 //thickness=0.18 //x=45.33 //y=1.055 //x2=45.37 //y2=0.9
r344 (  95 96 ) resistor r=176.904 //w=0.094 //l=0.345 //layer=ply \
 //thickness=0.18 //x=45.33 //y=1.055 //x2=45.33 //y2=1.4
r345 (  94 111 ) resistor r=592.245 //w=0.094 //l=1.155 //layer=ply \
 //thickness=0.18 //x=46.27 //y=6.2 //x2=46.27 //y2=5.045
r346 (  93 104 ) resistor r=592.245 //w=0.094 //l=1.155 //layer=ply \
 //thickness=0.18 //x=45.83 //y=6.2 //x2=45.83 //y2=5.045
r347 (  92 101 ) resistor r=56.4043 //w=0.094 //l=0.11 //layer=ply \
 //thickness=0.18 //x=45.595 //y=1.555 //x2=45.705 //y2=1.555
r348 (  92 102 ) resistor r=56.4043 //w=0.094 //l=0.11 //layer=ply \
 //thickness=0.18 //x=45.595 //y=1.555 //x2=45.485 //y2=1.555
r349 (  88 119 ) resistor r=152 //w=0.17 //l=0.17 //layer=licon //count=1 \
 //x=45.63 //y=4.88 //x2=45.63 //y2=4.88
r350 (  79 117 ) resistor r=152 //w=0.17 //l=0.17 //layer=licon //count=1 \
 //x=45.63 //y=2.26 //x2=45.63 //y2=2.26
r351 (  62 125 ) resistor r=23.615 //w=0.187 //l=0.345 //layer=li \
 //thickness=0.1 //x=43.3 //y=5.56 //x2=43.3 //y2=5.905
r352 (  54 124 ) resistor r=23.615 //w=0.187 //l=0.345 //layer=li \
 //thickness=0.1 //x=42.42 //y=5.56 //x2=42.42 //y2=5.905
r353 (  50 51 ) resistor r=0.10734 //w=0.281 //l=0.16 //layer=m2 \
 //thickness=0.36 //x=45.63 //y=2.785 //x2=45.47 //y2=2.785
r354 (  48 51 ) resistor r=1.46469 //w=0.131 //l=1.535 //layer=m2 \
 //thickness=0.36 //x=43.935 //y=2.77 //x2=45.47 //y2=2.77
r355 (  46 48 ) resistor r=0.10734 //w=0.281 //l=0.16 //layer=m2 \
 //thickness=0.36 //x=43.775 //y=2.785 //x2=43.935 //y2=2.785
r356 (  42 88 ) resistor r=9.3 //w=0.17 //l=0.17 //layer=mcon //count=1 \
 //x=45.63 //y=4.88 //x2=45.63 //y2=4.88
r357 (  40 79 ) resistor r=9.3 //w=0.17 //l=0.17 //layer=mcon //count=1 \
 //x=45.63 //y=2.26 //x2=45.63 //y2=2.26
r358 (  38 50 ) resistor r=4.5 //w=0.15 //l=0.15 //layer=via1 //count=1 \
 //x=45.63 //y=2.785 //x2=45.63 //y2=2.785
r359 (  36 38 ) resistor r=0.0049867 //w=0.376 //l=0.015 //layer=m1 \
 //thickness=0.36 //x=45.577 //y=2.77 //x2=45.577 //y2=2.785
r360 (  34 46 ) resistor r=4.5 //w=0.15 //l=0.15 //layer=via1 //count=1 \
 //x=43.775 //y=2.785 //x2=43.775 //y2=2.785
r361 (  32 34 ) resistor r=0.00494723 //w=0.379 //l=0.015 //layer=m1 \
 //thickness=0.36 //x=43.83 //y=2.77 //x2=43.83 //y2=2.785
r362 (  29 122 ) resistor r=9.3 //w=0.17 //l=0.17 //layer=mcon //count=1 \
 //x=43.34 //y=1.18 //x2=43.34 //y2=1.18
r363 (  27 62 ) resistor r=9.3 //w=0.17 //l=0.17 //layer=mcon //count=1 \
 //x=43.3 //y=5.56 //x2=43.3 //y2=5.56
r364 (  24 27 ) resistor r=0.117801 //w=0.191 //l=0.18 //layer=m1 \
 //thickness=0.36 //x=43.3 //y=5.38 //x2=43.3 //y2=5.56
r365 (  23 54 ) resistor r=9.3 //w=0.17 //l=0.17 //layer=mcon //count=1 \
 //x=42.42 //y=5.56 //x2=42.42 //y2=5.56
r366 (  21 23 ) resistor r=0.10274 //w=0.219 //l=0.18 //layer=m1 \
 //thickness=0.36 //x=42.42 //y=5.38 //x2=42.42 //y2=5.56
r367 (  20 42 ) resistor r=0.0760407 //w=0.238 //l=0.125 //layer=m1 \
 //thickness=0.36 //x=45.63 //y=4.755 //x2=45.63 //y2=4.88
r368 (  19 38 ) resistor r=0.0911593 //w=0.376 //l=0.184608 //layer=m1 \
 //thickness=0.36 //x=45.63 //y=2.945 //x2=45.577 //y2=2.785
r369 (  19 20 ) resistor r=1.7271 //w=0.131 //l=1.81 //layer=m1 \
 //thickness=0.36 //x=45.63 //y=2.945 //x2=45.63 //y2=4.755
r370 (  18 36 ) resistor r=0.0861726 //w=0.376 //l=0.16944 //layer=m1 \
 //thickness=0.36 //x=45.63 //y=2.625 //x2=45.577 //y2=2.77
r371 (  17 40 ) resistor r=0.0719237 //w=0.222 //l=0.115 //layer=m1 \
 //thickness=0.36 //x=45.63 //y=2.375 //x2=45.63 //y2=2.26
r372 (  17 18 ) resistor r=0.23855 //w=0.131 //l=0.25 //layer=m1 \
 //thickness=0.36 //x=45.63 //y=2.375 //x2=45.63 //y2=2.625
r373 (  15 34 ) resistor r=0.0912814 //w=0.379 //l=0.183303 //layer=m1 \
 //thickness=0.36 //x=43.78 //y=2.945 //x2=43.83 //y2=2.785
r374 (  15 16 ) resistor r=2.24237 //w=0.131 //l=2.35 //layer=m1 \
 //thickness=0.36 //x=43.78 //y=2.945 //x2=43.78 //y2=5.295
r375 (  14 32 ) resistor r=0.0863342 //w=0.379 //l=0.168152 //layer=m1 \
 //thickness=0.36 //x=43.78 //y=2.625 //x2=43.83 //y2=2.77
r376 (  13 14 ) resistor r=0.67271 //w=0.131 //l=0.705 //layer=m1 \
 //thickness=0.36 //x=43.78 //y=1.92 //x2=43.78 //y2=2.625
r377 (  11 13 ) resistor r=0.0698411 //w=0.17 //l=0.120208 //layer=m1 \
 //thickness=0.36 //x=43.695 //y=1.835 //x2=43.78 //y2=1.92
r378 (  11 12 ) resistor r=0.257634 //w=0.131 //l=0.27 //layer=m1 \
 //thickness=0.36 //x=43.695 //y=1.835 //x2=43.425 //y2=1.835
r379 (  10 24 ) resistor r=0.0257089 //w=0.23 //l=0.115 //layer=m1 \
 //thickness=0.36 //x=43.415 //y=5.38 //x2=43.3 //y2=5.38
r380 (  9 16 ) resistor r=0.0698411 //w=0.17 //l=0.120208 //layer=m1 \
 //thickness=0.36 //x=43.695 //y=5.38 //x2=43.78 //y2=5.295
r381 (  9 10 ) resistor r=0.267176 //w=0.131 //l=0.28 //layer=m1 \
 //thickness=0.36 //x=43.695 //y=5.38 //x2=43.415 //y2=5.38
r382 (  8 12 ) resistor r=0.0698411 //w=0.17 //l=0.120208 //layer=m1 \
 //thickness=0.36 //x=43.34 //y=1.75 //x2=43.425 //y2=1.835
r383 (  7 29 ) resistor r=0.0913624 //w=0.191 //l=0.12 //layer=m1 \
 //thickness=0.36 //x=43.34 //y=1.3 //x2=43.34 //y2=1.18
r384 (  7 8 ) resistor r=0.429389 //w=0.131 //l=0.45 //layer=m1 \
 //thickness=0.36 //x=43.34 //y=1.3 //x2=43.34 //y2=1.75
r385 (  4 21 ) resistor r=0.0227762 //w=0.219 //l=0.115 //layer=m1 \
 //thickness=0.36 //x=42.535 //y=5.38 //x2=42.42 //y2=5.38
r386 (  3 24 ) resistor r=0.0257089 //w=0.23 //l=0.115 //layer=m1 \
 //thickness=0.36 //x=43.185 //y=5.38 //x2=43.3 //y2=5.38
r387 (  3 4 ) resistor r=0.620229 //w=0.131 //l=0.65 //layer=m1 \
 //thickness=0.36 //x=43.185 //y=5.38 //x2=42.535 //y2=5.38
ends PM_TMRDFFSNQX1\%noxref_9

subckt PM_TMRDFFSNQX1\%noxref_10 ( 1 2 3 4 5 6 7 8 11 16 17 19 20 22 23 24 25 \
 26 27 28 36 40 47 48 51 53 58 60 67 69 72 78 83 84 86 87 90 99 104 113 118 \
 126 143 152 156 157 158 159 160 161 162 163 164 168 169 170 175 177 180 181 \
 185 186 187 192 194 197 198 202 203 204 209 211 214 215 217 218 223 227 228 \
 233 237 238 243 246 248 249 )
c584 ( 246 0 ) capacitor c=0.00878249f //x=39.82 //y=1.085
c585 ( 243 0 ) capacitor c=0.0651477f //x=47.85 //y=4.88
c586 ( 238 0 ) capacitor c=0.0278202f //x=47.85 //y=2.095
c587 ( 237 0 ) capacitor c=0.0503043f //x=47.85 //y=2.26
c588 ( 233 0 ) capacitor c=0.0651619f //x=36.38 //y=4.88
c589 ( 228 0 ) capacitor c=0.0278202f //x=36.38 //y=2.095
c590 ( 227 0 ) capacitor c=0.0503043f //x=36.38 //y=2.26
c591 ( 223 0 ) capacitor c=0.0654765f //x=31.57 //y=4.88
c592 ( 218 0 ) capacitor c=0.0278202f //x=31.57 //y=2.095
c593 ( 217 0 ) capacitor c=0.0503043f //x=31.57 //y=2.26
c594 ( 215 0 ) capacitor c=0.0443175f //x=48.37 //y=1.44
c595 ( 214 0 ) capacitor c=0.0199703f //x=48.37 //y=1.095
c596 ( 211 0 ) capacitor c=0.0162526f //x=48.215 //y=1.595
c597 ( 209 0 ) capacitor c=0.0157807f //x=48.215 //y=0.94
c598 ( 204 0 ) capacitor c=0.0220935f //x=47.84 //y=1.75
c599 ( 203 0 ) capacitor c=0.0207489f //x=47.84 //y=1.44
c600 ( 202 0 ) capacitor c=0.0194091f //x=47.84 //y=1.095
c601 ( 198 0 ) capacitor c=0.0443175f //x=36.9 //y=1.44
c602 ( 197 0 ) capacitor c=0.0199703f //x=36.9 //y=1.095
c603 ( 194 0 ) capacitor c=0.0162526f //x=36.745 //y=1.595
c604 ( 192 0 ) capacitor c=0.0157807f //x=36.745 //y=0.94
c605 ( 187 0 ) capacitor c=0.0220935f //x=36.37 //y=1.75
c606 ( 186 0 ) capacitor c=0.0207489f //x=36.37 //y=1.44
c607 ( 185 0 ) capacitor c=0.0194091f //x=36.37 //y=1.095
c608 ( 181 0 ) capacitor c=0.0443175f //x=32.09 //y=1.44
c609 ( 180 0 ) capacitor c=0.0199703f //x=32.09 //y=1.095
c610 ( 177 0 ) capacitor c=0.0162526f //x=31.935 //y=1.595
c611 ( 175 0 ) capacitor c=0.0157807f //x=31.935 //y=0.94
c612 ( 170 0 ) capacitor c=0.0220935f //x=31.56 //y=1.75
c613 ( 169 0 ) capacitor c=0.0207489f //x=31.56 //y=1.44
c614 ( 168 0 ) capacitor c=0.0194091f //x=31.56 //y=1.095
c615 ( 164 0 ) capacitor c=0.159671f //x=48.03 //y=6.2
c616 ( 163 0 ) capacitor c=0.110208f //x=47.59 //y=6.2
c617 ( 162 0 ) capacitor c=0.159671f //x=36.56 //y=6.2
c618 ( 161 0 ) capacitor c=0.110208f //x=36.12 //y=6.2
c619 ( 160 0 ) capacitor c=0.159671f //x=31.75 //y=6.2
c620 ( 159 0 ) capacitor c=0.110208f //x=31.31 //y=6.2
c621 ( 152 0 ) capacitor c=7.7417e-19 //x=47.85 //y=4.88
c622 ( 143 0 ) capacitor c=0.00101179f //x=47.85 //y=2.26
c623 ( 126 0 ) capacitor c=0.0319332f //x=39.97 //y=5.56
c624 ( 118 0 ) capacitor c=0.0290186f //x=39.09 //y=5.56
c625 ( 113 0 ) capacitor c=7.7417e-19 //x=36.38 //y=4.88
c626 ( 104 0 ) capacitor c=0.00101179f //x=36.38 //y=2.26
c627 ( 99 0 ) capacitor c=7.7417e-19 //x=31.57 //y=4.88
c628 ( 90 0 ) capacitor c=0.00101179f //x=31.57 //y=2.26
c629 ( 87 0 ) capacitor c=0.0753482f //x=47.69 //y=3.885
c630 ( 86 0 ) capacitor c=6.17996e-19 //x=47.85 //y=3.885
c631 ( 84 0 ) capacitor c=6.66367e-19 //x=40.605 //y=3.865
c632 ( 83 0 ) capacitor c=0.0371579f //x=40.285 //y=3.865
c633 ( 78 0 ) capacitor c=6.13673e-19 //x=31.735 //y=3.865
c634 ( 72 0 ) capacitor c=0.0413042f //x=36.54 //y=3.88
c635 ( 69 0 ) capacitor c=0.00240665f //x=32.52 //y=3.865
c636 ( 67 0 ) capacitor c=0.00238969f //x=31.92 //y=3.88
c637 ( 60 0 ) capacitor c=0.0149589f //x=47.85 //y=3.88
c638 ( 58 0 ) capacitor c=0.0158493f //x=40.45 //y=3.88
c639 ( 53 0 ) capacitor c=0.0113632f //x=40.01 //y=1.18
c640 ( 51 0 ) capacitor c=5.78613e-19 //x=39.97 //y=5.56
c641 ( 48 0 ) capacitor c=0.00996089f //x=39.97 //y=5.38
c642 ( 47 0 ) capacitor c=0.00947836f //x=39.09 //y=5.56
c643 ( 40 0 ) capacitor c=0.0149589f //x=36.38 //y=3.88
c644 ( 36 0 ) capacitor c=0.0149589f //x=31.57 //y=3.88
c645 ( 28 0 ) capacitor c=0.0186795f //x=47.85 //y=4.75
c646 ( 27 0 ) capacitor c=0.011444f //x=47.85 //y=4.045
c647 ( 26 0 ) capacitor c=0.0294407f //x=47.85 //y=3.725
c648 ( 25 0 ) capacitor c=0.0055474f //x=47.85 //y=2.375
c649 ( 24 0 ) capacitor c=0.0293478f //x=40.45 //y=5.295
c650 ( 23 0 ) capacitor c=0.0126593f //x=40.45 //y=4.025
c651 ( 22 0 ) capacitor c=0.0465581f //x=40.45 //y=3.705
c652 ( 20 0 ) capacitor c=0.00466468f //x=40.095 //y=1.835
c653 ( 19 0 ) capacitor c=0.0118534f //x=40.365 //y=1.835
c654 ( 17 0 ) capacitor c=0.0105341f //x=40.365 //y=5.38
c655 ( 16 0 ) capacitor c=0.0102514f //x=40.01 //y=1.75
c656 ( 11 0 ) capacitor c=0.0144196f //x=39.855 //y=5.38
c657 ( 8 0 ) capacitor c=0.0205242f //x=36.38 //y=4.75
c658 ( 7 0 ) capacitor c=0.0115359f //x=36.38 //y=4.025
c659 ( 6 0 ) capacitor c=0.0296421f //x=36.38 //y=3.705
c660 ( 5 0 ) capacitor c=0.00554287f //x=36.38 //y=2.375
c661 ( 4 0 ) capacitor c=0.0190807f //x=31.57 //y=4.75
c662 ( 3 0 ) capacitor c=0.0113483f //x=31.57 //y=4.025
c663 ( 2 0 ) capacitor c=0.0312976f //x=31.57 //y=3.705
c664 ( 1 0 ) capacitor c=0.00556102f //x=31.57 //y=2.375
r665 (  237 238 ) resistor r=52.7279 //w=0.214 //l=0.165 //layer=ply \
 //thickness=0.18 //x=47.85 //y=2.26 //x2=47.85 //y2=2.095
r666 (  227 228 ) resistor r=52.7279 //w=0.214 //l=0.165 //layer=ply \
 //thickness=0.18 //x=36.38 //y=2.26 //x2=36.38 //y2=2.095
r667 (  217 218 ) resistor r=52.7279 //w=0.214 //l=0.165 //layer=ply \
 //thickness=0.18 //x=31.57 //y=2.26 //x2=31.57 //y2=2.095
r668 (  215 245 ) resistor r=45.1352 //w=0.168 //l=0.173853 //layer=ply \
 //thickness=0.18 //x=48.37 //y=1.44 //x2=48.33 //y2=1.595
r669 (  214 244 ) resistor r=45.1352 //w=0.168 //l=0.173853 //layer=ply \
 //thickness=0.18 //x=48.37 //y=1.095 //x2=48.33 //y2=0.94
r670 (  214 215 ) resistor r=176.904 //w=0.094 //l=0.345 //layer=ply \
 //thickness=0.18 //x=48.37 //y=1.095 //x2=48.37 //y2=1.44
r671 (  212 241 ) resistor r=10.701 //w=0.21 //l=0.115 //layer=ply \
 //thickness=0.18 //x=47.995 //y=1.595 //x2=47.88 //y2=1.595
r672 (  211 245 ) resistor r=5.52526 //w=0.168 //l=0.115 //layer=ply \
 //thickness=0.18 //x=48.215 //y=1.595 //x2=48.33 //y2=1.595
r673 (  210 240 ) resistor r=5.52526 //w=0.168 //l=0.115 //layer=ply \
 //thickness=0.18 //x=47.995 //y=0.94 //x2=47.88 //y2=0.94
r674 (  209 244 ) resistor r=5.52526 //w=0.168 //l=0.115 //layer=ply \
 //thickness=0.18 //x=48.215 //y=0.94 //x2=48.33 //y2=0.94
r675 (  209 210 ) resistor r=112.809 //w=0.094 //l=0.22 //layer=ply \
 //thickness=0.18 //x=48.215 //y=0.94 //x2=47.995 //y2=0.94
r676 (  206 243 ) resistor r=37.236 //w=0.233 //l=0.249199 //layer=ply \
 //thickness=0.18 //x=48.03 //y=5.045 //x2=47.85 //y2=4.88
r677 (  204 241 ) resistor r=39.5823 //w=0.21 //l=0.173853 //layer=ply \
 //thickness=0.18 //x=47.84 //y=1.75 //x2=47.88 //y2=1.595
r678 (  204 238 ) resistor r=176.904 //w=0.094 //l=0.345 //layer=ply \
 //thickness=0.18 //x=47.84 //y=1.75 //x2=47.84 //y2=2.095
r679 (  203 241 ) resistor r=39.5823 //w=0.21 //l=0.173853 //layer=ply \
 //thickness=0.18 //x=47.84 //y=1.44 //x2=47.88 //y2=1.595
r680 (  202 240 ) resistor r=45.1352 //w=0.168 //l=0.173853 //layer=ply \
 //thickness=0.18 //x=47.84 //y=1.095 //x2=47.88 //y2=0.94
r681 (  202 203 ) resistor r=176.904 //w=0.094 //l=0.345 //layer=ply \
 //thickness=0.18 //x=47.84 //y=1.095 //x2=47.84 //y2=1.44
r682 (  199 243 ) resistor r=53.7854 //w=0.233 //l=0.332415 //layer=ply \
 //thickness=0.18 //x=47.59 //y=5.045 //x2=47.85 //y2=4.88
r683 (  198 235 ) resistor r=45.1352 //w=0.168 //l=0.173853 //layer=ply \
 //thickness=0.18 //x=36.9 //y=1.44 //x2=36.86 //y2=1.595
r684 (  197 234 ) resistor r=45.1352 //w=0.168 //l=0.173853 //layer=ply \
 //thickness=0.18 //x=36.9 //y=1.095 //x2=36.86 //y2=0.94
r685 (  197 198 ) resistor r=176.904 //w=0.094 //l=0.345 //layer=ply \
 //thickness=0.18 //x=36.9 //y=1.095 //x2=36.9 //y2=1.44
r686 (  195 231 ) resistor r=10.701 //w=0.21 //l=0.115 //layer=ply \
 //thickness=0.18 //x=36.525 //y=1.595 //x2=36.41 //y2=1.595
r687 (  194 235 ) resistor r=5.52526 //w=0.168 //l=0.115 //layer=ply \
 //thickness=0.18 //x=36.745 //y=1.595 //x2=36.86 //y2=1.595
r688 (  193 230 ) resistor r=5.52526 //w=0.168 //l=0.115 //layer=ply \
 //thickness=0.18 //x=36.525 //y=0.94 //x2=36.41 //y2=0.94
r689 (  192 234 ) resistor r=5.52526 //w=0.168 //l=0.115 //layer=ply \
 //thickness=0.18 //x=36.745 //y=0.94 //x2=36.86 //y2=0.94
r690 (  192 193 ) resistor r=112.809 //w=0.094 //l=0.22 //layer=ply \
 //thickness=0.18 //x=36.745 //y=0.94 //x2=36.525 //y2=0.94
r691 (  189 233 ) resistor r=37.236 //w=0.233 //l=0.249199 //layer=ply \
 //thickness=0.18 //x=36.56 //y=5.045 //x2=36.38 //y2=4.88
r692 (  187 231 ) resistor r=39.5823 //w=0.21 //l=0.173853 //layer=ply \
 //thickness=0.18 //x=36.37 //y=1.75 //x2=36.41 //y2=1.595
r693 (  187 228 ) resistor r=176.904 //w=0.094 //l=0.345 //layer=ply \
 //thickness=0.18 //x=36.37 //y=1.75 //x2=36.37 //y2=2.095
r694 (  186 231 ) resistor r=39.5823 //w=0.21 //l=0.173853 //layer=ply \
 //thickness=0.18 //x=36.37 //y=1.44 //x2=36.41 //y2=1.595
r695 (  185 230 ) resistor r=45.1352 //w=0.168 //l=0.173853 //layer=ply \
 //thickness=0.18 //x=36.37 //y=1.095 //x2=36.41 //y2=0.94
r696 (  185 186 ) resistor r=176.904 //w=0.094 //l=0.345 //layer=ply \
 //thickness=0.18 //x=36.37 //y=1.095 //x2=36.37 //y2=1.44
r697 (  182 233 ) resistor r=53.7854 //w=0.233 //l=0.332415 //layer=ply \
 //thickness=0.18 //x=36.12 //y=5.045 //x2=36.38 //y2=4.88
r698 (  181 225 ) resistor r=45.1352 //w=0.168 //l=0.173853 //layer=ply \
 //thickness=0.18 //x=32.09 //y=1.44 //x2=32.05 //y2=1.595
r699 (  180 224 ) resistor r=45.1352 //w=0.168 //l=0.173853 //layer=ply \
 //thickness=0.18 //x=32.09 //y=1.095 //x2=32.05 //y2=0.94
r700 (  180 181 ) resistor r=176.904 //w=0.094 //l=0.345 //layer=ply \
 //thickness=0.18 //x=32.09 //y=1.095 //x2=32.09 //y2=1.44
r701 (  178 221 ) resistor r=10.701 //w=0.21 //l=0.115 //layer=ply \
 //thickness=0.18 //x=31.715 //y=1.595 //x2=31.6 //y2=1.595
r702 (  177 225 ) resistor r=5.52526 //w=0.168 //l=0.115 //layer=ply \
 //thickness=0.18 //x=31.935 //y=1.595 //x2=32.05 //y2=1.595
r703 (  176 220 ) resistor r=5.52526 //w=0.168 //l=0.115 //layer=ply \
 //thickness=0.18 //x=31.715 //y=0.94 //x2=31.6 //y2=0.94
r704 (  175 224 ) resistor r=5.52526 //w=0.168 //l=0.115 //layer=ply \
 //thickness=0.18 //x=31.935 //y=0.94 //x2=32.05 //y2=0.94
r705 (  175 176 ) resistor r=112.809 //w=0.094 //l=0.22 //layer=ply \
 //thickness=0.18 //x=31.935 //y=0.94 //x2=31.715 //y2=0.94
r706 (  172 223 ) resistor r=37.236 //w=0.233 //l=0.249199 //layer=ply \
 //thickness=0.18 //x=31.75 //y=5.045 //x2=31.57 //y2=4.88
r707 (  170 221 ) resistor r=39.5823 //w=0.21 //l=0.173853 //layer=ply \
 //thickness=0.18 //x=31.56 //y=1.75 //x2=31.6 //y2=1.595
r708 (  170 218 ) resistor r=176.904 //w=0.094 //l=0.345 //layer=ply \
 //thickness=0.18 //x=31.56 //y=1.75 //x2=31.56 //y2=2.095
r709 (  169 221 ) resistor r=39.5823 //w=0.21 //l=0.173853 //layer=ply \
 //thickness=0.18 //x=31.56 //y=1.44 //x2=31.6 //y2=1.595
r710 (  168 220 ) resistor r=45.1352 //w=0.168 //l=0.173853 //layer=ply \
 //thickness=0.18 //x=31.56 //y=1.095 //x2=31.6 //y2=0.94
r711 (  168 169 ) resistor r=176.904 //w=0.094 //l=0.345 //layer=ply \
 //thickness=0.18 //x=31.56 //y=1.095 //x2=31.56 //y2=1.44
r712 (  165 223 ) resistor r=53.7854 //w=0.233 //l=0.332415 //layer=ply \
 //thickness=0.18 //x=31.31 //y=5.045 //x2=31.57 //y2=4.88
r713 (  164 206 ) resistor r=592.245 //w=0.094 //l=1.155 //layer=ply \
 //thickness=0.18 //x=48.03 //y=6.2 //x2=48.03 //y2=5.045
r714 (  163 199 ) resistor r=592.245 //w=0.094 //l=1.155 //layer=ply \
 //thickness=0.18 //x=47.59 //y=6.2 //x2=47.59 //y2=5.045
r715 (  162 189 ) resistor r=592.245 //w=0.094 //l=1.155 //layer=ply \
 //thickness=0.18 //x=36.56 //y=6.2 //x2=36.56 //y2=5.045
r716 (  161 182 ) resistor r=592.245 //w=0.094 //l=1.155 //layer=ply \
 //thickness=0.18 //x=36.12 //y=6.2 //x2=36.12 //y2=5.045
r717 (  160 172 ) resistor r=592.245 //w=0.094 //l=1.155 //layer=ply \
 //thickness=0.18 //x=31.75 //y=6.2 //x2=31.75 //y2=5.045
r718 (  159 165 ) resistor r=592.245 //w=0.094 //l=1.155 //layer=ply \
 //thickness=0.18 //x=31.31 //y=6.2 //x2=31.31 //y2=5.045
r719 (  158 211 ) resistor r=56.4043 //w=0.094 //l=0.11 //layer=ply \
 //thickness=0.18 //x=48.105 //y=1.595 //x2=48.215 //y2=1.595
r720 (  158 212 ) resistor r=56.4043 //w=0.094 //l=0.11 //layer=ply \
 //thickness=0.18 //x=48.105 //y=1.595 //x2=47.995 //y2=1.595
r721 (  157 194 ) resistor r=56.4043 //w=0.094 //l=0.11 //layer=ply \
 //thickness=0.18 //x=36.635 //y=1.595 //x2=36.745 //y2=1.595
r722 (  157 195 ) resistor r=56.4043 //w=0.094 //l=0.11 //layer=ply \
 //thickness=0.18 //x=36.635 //y=1.595 //x2=36.525 //y2=1.595
r723 (  156 177 ) resistor r=56.4043 //w=0.094 //l=0.11 //layer=ply \
 //thickness=0.18 //x=31.825 //y=1.595 //x2=31.935 //y2=1.595
r724 (  156 178 ) resistor r=56.4043 //w=0.094 //l=0.11 //layer=ply \
 //thickness=0.18 //x=31.825 //y=1.595 //x2=31.715 //y2=1.595
r725 (  152 243 ) resistor r=152 //w=0.17 //l=0.17 //layer=licon //count=1 \
 //x=47.85 //y=4.88 //x2=47.85 //y2=4.88
r726 (  143 237 ) resistor r=152 //w=0.17 //l=0.17 //layer=licon //count=1 \
 //x=47.85 //y=2.26 //x2=47.85 //y2=2.26
r727 (  126 249 ) resistor r=23.615 //w=0.187 //l=0.345 //layer=li \
 //thickness=0.1 //x=39.97 //y=5.56 //x2=39.97 //y2=5.905
r728 (  118 248 ) resistor r=23.615 //w=0.187 //l=0.345 //layer=li \
 //thickness=0.1 //x=39.09 //y=5.56 //x2=39.09 //y2=5.905
r729 (  113 233 ) resistor r=152 //w=0.17 //l=0.17 //layer=licon //count=1 \
 //x=36.38 //y=4.88 //x2=36.38 //y2=4.88
r730 (  104 227 ) resistor r=152 //w=0.17 //l=0.17 //layer=licon //count=1 \
 //x=36.38 //y=2.26 //x2=36.38 //y2=2.26
r731 (  99 223 ) resistor r=152 //w=0.17 //l=0.17 //layer=licon //count=1 \
 //x=31.57 //y=4.88 //x2=31.57 //y2=4.88
r732 (  90 217 ) resistor r=152 //w=0.17 //l=0.17 //layer=licon //count=1 \
 //x=31.57 //y=2.26 //x2=31.57 //y2=2.26
r733 (  86 87 ) resistor r=0.10734 //w=0.281 //l=0.16 //layer=m2 \
 //thickness=0.36 //x=47.85 //y=3.885 //x2=47.69 //y2=3.885
r734 (  84 87 ) resistor r=6.7605 //w=0.131 //l=7.085 //layer=m2 \
 //thickness=0.36 //x=40.605 //y=3.88 //x2=47.69 //y2=3.88
r735 (  82 84 ) resistor r=0.10734 //w=0.281 //l=0.16 //layer=m2 \
 //thickness=0.36 //x=40.445 //y=3.865 //x2=40.605 //y2=3.865
r736 (  82 83 ) resistor r=0.10734 //w=0.281 //l=0.16 //layer=m2 \
 //thickness=0.36 //x=40.445 //y=3.865 //x2=40.285 //y2=3.865
r737 (  76 78 ) resistor r=0.10734 //w=0.281 //l=0.16 //layer=m2 \
 //thickness=0.36 //x=31.575 //y=3.865 //x2=31.735 //y2=3.865
r738 (  72 80 ) resistor r=0.110608 //w=0.182 //l=0.167332 //layer=m2 \
 //thickness=0.36 //x=36.54 //y=3.88 //x2=36.38 //y2=3.865
r739 (  72 83 ) resistor r=3.57347 //w=0.131 //l=3.745 //layer=m2 \
 //thickness=0.36 //x=36.54 //y=3.88 //x2=40.285 //y2=3.88
r740 (  69 80 ) resistor r=2.65182 //w=0.182 //l=3.86 //layer=m2 \
 //thickness=0.36 //x=32.52 //y=3.865 //x2=36.38 //y2=3.865
r741 (  69 70 ) resistor r=0.410305 //w=0.131 //l=0.43 //layer=m2 \
 //thickness=0.36 //x=32.52 //y=3.865 //x2=32.09 //y2=3.865
r742 (  67 70 ) resistor r=0.125 //w=0.17 //l=0.177341 //layer=m2 \
 //thickness=0.36 //x=31.92 //y=3.88 //x2=32.09 //y2=3.865
r743 (  67 78 ) resistor r=0.176527 //w=0.131 //l=0.185 //layer=m2 \
 //thickness=0.36 //x=31.92 //y=3.88 //x2=31.735 //y2=3.88
r744 (  66 152 ) resistor r=9.3 //w=0.17 //l=0.17 //layer=mcon //count=1 \
 //x=47.85 //y=4.88 //x2=47.85 //y2=4.88
r745 (  64 143 ) resistor r=9.3 //w=0.17 //l=0.17 //layer=mcon //count=1 \
 //x=47.85 //y=2.26 //x2=47.85 //y2=2.26
r746 (  62 86 ) resistor r=4.5 //w=0.15 //l=0.15 //layer=via1 //count=1 \
 //x=47.85 //y=3.885 //x2=47.85 //y2=3.885
r747 (  60 62 ) resistor r=0.00166223 //w=0.376 //l=0.005 //layer=m1 \
 //thickness=0.36 //x=47.797 //y=3.88 //x2=47.797 //y2=3.885
r748 (  56 82 ) resistor r=4.5 //w=0.15 //l=0.15 //layer=via1 //count=1 \
 //x=40.445 //y=3.865 //x2=40.445 //y2=3.865
r749 (  56 58 ) resistor r=0.00501337 //w=0.374 //l=0.015 //layer=m1 \
 //thickness=0.36 //x=40.395 //y=3.865 //x2=40.395 //y2=3.88
r750 (  53 246 ) resistor r=9.3 //w=0.17 //l=0.17 //layer=mcon //count=1 \
 //x=40.01 //y=1.18 //x2=40.01 //y2=1.18
r751 (  51 126 ) resistor r=9.3 //w=0.17 //l=0.17 //layer=mcon //count=1 \
 //x=39.97 //y=5.56 //x2=39.97 //y2=5.56
r752 (  48 51 ) resistor r=0.117801 //w=0.191 //l=0.18 //layer=m1 \
 //thickness=0.36 //x=39.97 //y=5.38 //x2=39.97 //y2=5.56
r753 (  47 118 ) resistor r=9.3 //w=0.17 //l=0.17 //layer=mcon //count=1 \
 //x=39.09 //y=5.56 //x2=39.09 //y2=5.56
r754 (  45 47 ) resistor r=0.10274 //w=0.219 //l=0.18 //layer=m1 \
 //thickness=0.36 //x=39.09 //y=5.38 //x2=39.09 //y2=5.56
r755 (  44 113 ) resistor r=9.3 //w=0.17 //l=0.17 //layer=mcon //count=1 \
 //x=36.38 //y=4.88 //x2=36.38 //y2=4.88
r756 (  42 104 ) resistor r=9.3 //w=0.17 //l=0.17 //layer=mcon //count=1 \
 //x=36.38 //y=2.26 //x2=36.38 //y2=2.26
r757 (  38 80 ) resistor r=4.5 //w=0.15 //l=0.15 //layer=via1 //count=1 \
 //x=36.38 //y=3.865 //x2=36.38 //y2=3.865
r758 (  38 40 ) resistor r=0.0049867 //w=0.376 //l=0.015 //layer=m1 \
 //thickness=0.36 //x=36.327 //y=3.865 //x2=36.327 //y2=3.88
r759 (  34 76 ) resistor r=4.5 //w=0.15 //l=0.15 //layer=via1 //count=1 \
 //x=31.575 //y=3.865 //x2=31.575 //y2=3.865
r760 (  34 36 ) resistor r=0.00501337 //w=0.374 //l=0.015 //layer=m1 \
 //thickness=0.36 //x=31.625 //y=3.865 //x2=31.625 //y2=3.88
r761 (  32 99 ) resistor r=9.3 //w=0.17 //l=0.17 //layer=mcon //count=1 \
 //x=31.57 //y=4.88 //x2=31.57 //y2=4.88
r762 (  30 90 ) resistor r=9.3 //w=0.17 //l=0.17 //layer=mcon //count=1 \
 //x=31.57 //y=2.26 //x2=31.57 //y2=2.26
r763 (  28 66 ) resistor r=0.0801089 //w=0.224 //l=0.13 //layer=m1 \
 //thickness=0.36 //x=47.85 //y=4.75 //x2=47.85 //y2=4.88
r764 (  27 62 ) resistor r=0.0911593 //w=0.376 //l=0.184608 //layer=m1 \
 //thickness=0.36 //x=47.85 //y=4.045 //x2=47.797 //y2=3.885
r765 (  27 28 ) resistor r=0.67271 //w=0.131 //l=0.705 //layer=m1 \
 //thickness=0.36 //x=47.85 //y=4.045 //x2=47.85 //y2=4.75
r766 (  26 60 ) resistor r=0.0894971 //w=0.376 //l=0.179555 //layer=m1 \
 //thickness=0.36 //x=47.85 //y=3.725 //x2=47.797 //y2=3.88
r767 (  25 64 ) resistor r=0.0719237 //w=0.222 //l=0.115 //layer=m1 \
 //thickness=0.36 //x=47.85 //y=2.375 //x2=47.85 //y2=2.26
r768 (  25 26 ) resistor r=1.28817 //w=0.131 //l=1.35 //layer=m1 \
 //thickness=0.36 //x=47.85 //y=2.375 //x2=47.85 //y2=3.725
r769 (  23 58 ) resistor r=0.0860668 //w=0.374 //l=0.170294 //layer=m1 \
 //thickness=0.36 //x=40.45 //y=4.025 //x2=40.395 //y2=3.88
r770 (  23 24 ) resistor r=1.21183 //w=0.131 //l=1.27 //layer=m1 \
 //thickness=0.36 //x=40.45 //y=4.025 //x2=40.45 //y2=5.295
r771 (  22 56 ) resistor r=0.0910802 //w=0.374 //l=0.185472 //layer=m1 \
 //thickness=0.36 //x=40.45 //y=3.705 //x2=40.395 //y2=3.865
r772 (  21 22 ) resistor r=1.70324 //w=0.131 //l=1.785 //layer=m1 \
 //thickness=0.36 //x=40.45 //y=1.92 //x2=40.45 //y2=3.705
r773 (  19 21 ) resistor r=0.0698411 //w=0.17 //l=0.120208 //layer=m1 \
 //thickness=0.36 //x=40.365 //y=1.835 //x2=40.45 //y2=1.92
r774 (  19 20 ) resistor r=0.257634 //w=0.131 //l=0.27 //layer=m1 \
 //thickness=0.36 //x=40.365 //y=1.835 //x2=40.095 //y2=1.835
r775 (  18 48 ) resistor r=0.0257089 //w=0.23 //l=0.115 //layer=m1 \
 //thickness=0.36 //x=40.085 //y=5.38 //x2=39.97 //y2=5.38
r776 (  17 24 ) resistor r=0.0698411 //w=0.17 //l=0.120208 //layer=m1 \
 //thickness=0.36 //x=40.365 //y=5.38 //x2=40.45 //y2=5.295
r777 (  17 18 ) resistor r=0.267176 //w=0.131 //l=0.28 //layer=m1 \
 //thickness=0.36 //x=40.365 //y=5.38 //x2=40.085 //y2=5.38
r778 (  16 20 ) resistor r=0.0698411 //w=0.17 //l=0.120208 //layer=m1 \
 //thickness=0.36 //x=40.01 //y=1.75 //x2=40.095 //y2=1.835
r779 (  15 53 ) resistor r=0.0913624 //w=0.191 //l=0.12 //layer=m1 \
 //thickness=0.36 //x=40.01 //y=1.3 //x2=40.01 //y2=1.18
r780 (  15 16 ) resistor r=0.429389 //w=0.131 //l=0.45 //layer=m1 \
 //thickness=0.36 //x=40.01 //y=1.3 //x2=40.01 //y2=1.75
r781 (  12 45 ) resistor r=0.0227762 //w=0.219 //l=0.115 //layer=m1 \
 //thickness=0.36 //x=39.205 //y=5.38 //x2=39.09 //y2=5.38
r782 (  11 48 ) resistor r=0.0257089 //w=0.23 //l=0.115 //layer=m1 \
 //thickness=0.36 //x=39.855 //y=5.38 //x2=39.97 //y2=5.38
r783 (  11 12 ) resistor r=0.620229 //w=0.131 //l=0.65 //layer=m1 \
 //thickness=0.36 //x=39.855 //y=5.38 //x2=39.205 //y2=5.38
r784 (  8 44 ) resistor r=0.0801089 //w=0.224 //l=0.13 //layer=m1 \
 //thickness=0.36 //x=36.38 //y=4.75 //x2=36.38 //y2=4.88
r785 (  7 40 ) resistor r=0.0861726 //w=0.376 //l=0.16944 //layer=m1 \
 //thickness=0.36 //x=36.38 //y=4.025 //x2=36.327 //y2=3.88
r786 (  7 8 ) resistor r=0.691794 //w=0.131 //l=0.725 //layer=m1 \
 //thickness=0.36 //x=36.38 //y=4.025 //x2=36.38 //y2=4.75
r787 (  6 38 ) resistor r=0.0911593 //w=0.376 //l=0.184608 //layer=m1 \
 //thickness=0.36 //x=36.38 //y=3.705 //x2=36.327 //y2=3.865
r788 (  5 42 ) resistor r=0.0719237 //w=0.222 //l=0.115 //layer=m1 \
 //thickness=0.36 //x=36.38 //y=2.375 //x2=36.38 //y2=2.26
r789 (  5 6 ) resistor r=1.26908 //w=0.131 //l=1.33 //layer=m1 \
 //thickness=0.36 //x=36.38 //y=2.375 //x2=36.38 //y2=3.705
r790 (  4 32 ) resistor r=0.0801089 //w=0.224 //l=0.13 //layer=m1 \
 //thickness=0.36 //x=31.57 //y=4.75 //x2=31.57 //y2=4.88
r791 (  3 36 ) resistor r=0.0860668 //w=0.374 //l=0.170294 //layer=m1 \
 //thickness=0.36 //x=31.57 //y=4.025 //x2=31.625 //y2=3.88
r792 (  3 4 ) resistor r=0.691794 //w=0.131 //l=0.725 //layer=m1 \
 //thickness=0.36 //x=31.57 //y=4.025 //x2=31.57 //y2=4.75
r793 (  2 34 ) resistor r=0.0910802 //w=0.374 //l=0.185472 //layer=m1 \
 //thickness=0.36 //x=31.57 //y=3.705 //x2=31.625 //y2=3.865
r794 (  1 30 ) resistor r=0.0719237 //w=0.222 //l=0.115 //layer=m1 \
 //thickness=0.36 //x=31.57 //y=2.375 //x2=31.57 //y2=2.26
r795 (  1 2 ) resistor r=1.26908 //w=0.131 //l=1.33 //layer=m1 \
 //thickness=0.36 //x=31.57 //y=2.375 //x2=31.57 //y2=3.705
ends PM_TMRDFFSNQX1\%noxref_10

subckt PM_TMRDFFSNQX1\%noxref_11 ( 2 3 4 5 7 10 11 13 14 15 16 18 19 20 21 22 \
 23 24 25 26 27 28 29 30 31 32 34 40 43 46 49 57 59 65 73 77 82 84 86 89 90 91 \
 92 94 96 98 100 102 104 106 108 115 121 127 129 130 133 142 147 155 163 184 \
 197 202 211 215 216 217 218 219 220 221 222 223 224 225 226 231 233 235 241 \
 242 243 244 245 250 252 254 260 261 262 263 264 269 271 273 279 280 282 283 \
 286 295 296 299 307 308 311 319 321 322 323 )
c775 ( 319 0 ) capacitor c=0.00885916f //x=47.915 //y=1.095
c776 ( 311 0 ) capacitor c=0.0370698f //x=82.28 //y=4.885
c777 ( 308 0 ) capacitor c=0.028421f //x=82.26 //y=2.095
c778 ( 307 0 ) capacitor c=0.0512002f //x=82.26 //y=2.26
c779 ( 299 0 ) capacitor c=0.0387879f //x=75.64 //y=4.885
c780 ( 296 0 ) capacitor c=0.0300885f //x=75.6 //y=2.095
c781 ( 295 0 ) capacitor c=0.0518094f //x=75.6 //y=2.26
c782 ( 286 0 ) capacitor c=0.0354929f //x=43.07 //y=4.88
c783 ( 283 0 ) capacitor c=0.0284095f //x=43.04 //y=2.095
c784 ( 282 0 ) capacitor c=0.0476356f //x=43.04 //y=2.26
c785 ( 280 0 ) capacitor c=0.0237734f //x=82.825 //y=1.435
c786 ( 279 0 ) capacitor c=0.0191782f //x=82.825 //y=1.085
c787 ( 273 0 ) capacitor c=0.0361171f //x=82.67 //y=1.585
c788 ( 271 0 ) capacitor c=0.0157803f //x=82.67 //y=0.93
c789 ( 269 0 ) capacitor c=0.0377178f //x=82.665 //y=4.975
c790 ( 264 0 ) capacitor c=0.020493f //x=82.295 //y=1.74
c791 ( 263 0 ) capacitor c=0.0167049f //x=82.295 //y=1.435
c792 ( 262 0 ) capacitor c=0.0174993f //x=82.295 //y=1.085
c793 ( 261 0 ) capacitor c=0.0443648f //x=76.165 //y=1.43
c794 ( 260 0 ) capacitor c=0.0192211f //x=76.165 //y=1.085
c795 ( 254 0 ) capacitor c=0.0186579f //x=76.01 //y=1.585
c796 ( 252 0 ) capacitor c=0.0157795f //x=76.01 //y=0.93
c797 ( 250 0 ) capacitor c=0.0351351f //x=76.005 //y=4.975
c798 ( 245 0 ) capacitor c=0.0209124f //x=75.635 //y=1.74
c799 ( 244 0 ) capacitor c=0.016848f //x=75.635 //y=1.43
c800 ( 243 0 ) capacitor c=0.0174777f //x=75.635 //y=1.085
c801 ( 242 0 ) capacitor c=0.0439708f //x=43.605 //y=1.43
c802 ( 241 0 ) capacitor c=0.0192582f //x=43.605 //y=1.085
c803 ( 235 0 ) capacitor c=0.0162526f //x=43.45 //y=1.585
c804 ( 233 0 ) capacitor c=0.0157807f //x=43.45 //y=0.93
c805 ( 231 0 ) capacitor c=0.0357885f //x=43.445 //y=4.97
c806 ( 226 0 ) capacitor c=0.0210762f //x=43.075 //y=1.74
c807 ( 225 0 ) capacitor c=0.0168511f //x=43.075 //y=1.43
c808 ( 224 0 ) capacitor c=0.0175485f //x=43.075 //y=1.085
c809 ( 223 0 ) capacitor c=0.155887f //x=82.74 //y=6.205
c810 ( 222 0 ) capacitor c=0.1106f //x=82.3 //y=6.205
c811 ( 221 0 ) capacitor c=0.154859f //x=76.08 //y=6.205
c812 ( 220 0 ) capacitor c=0.110573f //x=75.64 //y=6.205
c813 ( 219 0 ) capacitor c=0.155269f //x=43.52 //y=6.2
c814 ( 218 0 ) capacitor c=0.110375f //x=43.08 //y=6.2
c815 ( 211 0 ) capacitor c=8.10734e-19 //x=82.28 //y=4.885
c816 ( 202 0 ) capacitor c=0.00105273f //x=82.26 //y=2.26
c817 ( 197 0 ) capacitor c=0.00173056f //x=75.64 //y=4.885
c818 ( 184 0 ) capacitor c=0.0012588f //x=75.6 //y=2.26
c819 ( 163 0 ) capacitor c=0.0293228f //x=47.81 //y=5.56
c820 ( 155 0 ) capacitor c=0.029137f //x=46.93 //y=5.56
c821 ( 147 0 ) capacitor c=0.0277605f //x=46.05 //y=5.56
c822 ( 142 0 ) capacitor c=5.80994e-19 //x=43.07 //y=4.88
c823 ( 133 0 ) capacitor c=5.78095e-19 //x=43.04 //y=2.26
c824 ( 130 0 ) capacitor c=0.138695f //x=82.115 //y=4.21
c825 ( 129 0 ) capacitor c=0.00479868f //x=82.275 //y=4.21
c826 ( 127 0 ) capacitor c=0.00306797f //x=75.76 //y=4.205
c827 ( 121 0 ) capacitor c=4.73665e-19 //x=48.745 //y=2.785
c828 ( 115 0 ) capacitor c=6.56309e-19 //x=43.19 //y=4.265
c829 ( 108 0 ) capacitor c=0.211698f //x=63.6 //y=3.17
c830 ( 106 0 ) capacitor c=0.0177421f //x=63 //y=3.14
c831 ( 104 0 ) capacitor c=0.00425641f //x=61.755 //y=3.17
c832 ( 102 0 ) capacitor c=0.025331f //x=61.155 //y=3.14
c833 ( 100 0 ) capacitor c=0.00429096f //x=58.795 //y=3.16
c834 ( 98 0 ) capacitor c=0.0440107f //x=58.195 //y=3.14
c835 ( 96 0 ) capacitor c=0.00368608f //x=53.985 //y=3.155
c836 ( 94 0 ) capacitor c=0.0184713f //x=53.385 //y=3.14
c837 ( 92 0 ) capacitor c=0.00413336f //x=52.135 //y=3.155
c838 ( 91 0 ) capacitor c=1.09476e-19 //x=51.265 //y=3.14
c839 ( 90 0 ) capacitor c=0.00544879f //x=51.535 //y=3.14
c840 ( 86 0 ) capacitor c=0.0247168f //x=51.095 //y=2.77
c841 ( 84 0 ) capacitor c=0.00547566f //x=48.065 //y=4.27
c842 ( 82 0 ) capacitor c=0.044474f //x=47.465 //y=4.25
c843 ( 77 0 ) capacitor c=0.0138506f //x=82.26 //y=4.25
c844 ( 73 0 ) capacitor c=0.0149715f //x=75.6 //y=4.25
c845 ( 65 0 ) capacitor c=0.0147928f //x=75.6 //y=3.14
c846 ( 59 0 ) capacitor c=0.01489f //x=48.59 //y=2.77
c847 ( 57 0 ) capacitor c=0.0161096f //x=48.59 //y=4.25
c848 ( 49 0 ) capacitor c=8.84507e-19 //x=47.81 //y=5.335
c849 ( 46 0 ) capacitor c=0.00799482f //x=46.93 //y=5.335
c850 ( 43 0 ) capacitor c=0.0112819f //x=46.052 //y=5.335
c851 ( 40 0 ) capacitor c=0.0131807f //x=43.04 //y=4.25
c852 ( 34 0 ) capacitor c=0.00504845f //x=43.04 //y=2.26
c853 ( 32 0 ) capacitor c=0.0124358f //x=82.26 //y=4.74
c854 ( 31 0 ) capacitor c=0.0108569f //x=82.26 //y=4.37
c855 ( 30 0 ) capacitor c=0.0479887f //x=82.26 //y=4.05
c856 ( 29 0 ) capacitor c=0.00651439f //x=82.26 //y=2.38
c857 ( 28 0 ) capacitor c=0.0171489f //x=75.6 //y=4.71
c858 ( 27 0 ) capacitor c=0.0124114f //x=75.6 //y=4.365
c859 ( 26 0 ) capacitor c=0.0296262f //x=75.6 //y=4.045
c860 ( 25 0 ) capacitor c=0.012794f //x=75.6 //y=3.285
c861 ( 24 0 ) capacitor c=0.0188593f //x=75.6 //y=2.965
c862 ( 23 0 ) capacitor c=0.00887451f //x=75.6 //y=2.375
c863 ( 22 0 ) capacitor c=0.0210243f //x=48.59 //y=5.25
c864 ( 21 0 ) capacitor c=0.0123274f //x=48.59 //y=4.395
c865 ( 20 0 ) capacitor c=0.0320637f //x=48.59 //y=4.075
c866 ( 19 0 ) capacitor c=0.0127583f //x=48.59 //y=2.945
c867 ( 18 0 ) capacitor c=0.0167155f //x=48.59 //y=2.625
c868 ( 16 0 ) capacitor c=0.00493487f //x=48.19 //y=1.845
c869 ( 15 0 ) capacitor c=0.0126874f //x=48.505 //y=1.845
c870 ( 14 0 ) capacitor c=0.013549f //x=48.105 //y=1.76
c871 ( 13 0 ) capacitor c=0.0113783f //x=48.105 //y=1.305
c872 ( 11 0 ) capacitor c=0.0226348f //x=48.505 //y=5.335
c873 ( 10 0 ) capacitor c=0.00906713f //x=47.81 //y=5.56
c874 ( 7 0 ) capacitor c=0.0180822f //x=47.695 //y=5.335
c875 ( 5 0 ) capacitor c=0.0151888f //x=46.81 //y=5.335
c876 ( 4 0 ) capacitor c=0.00860704f //x=43.04 //y=4.735
c877 ( 3 0 ) capacitor c=0.0106862f //x=43.04 //y=4.425
c878 ( 2 0 ) capacitor c=0.0362813f //x=43.04 //y=4.105
r879 (  313 314 ) resistor r=32.4568 //w=0.214 //l=0.075 //layer=ply \
 //thickness=0.18 //x=82.28 //y=4.975 //x2=82.28 //y2=5.05
r880 (  311 313 ) resistor r=20.271 //w=0.214 //l=0.09 //layer=ply \
 //thickness=0.18 //x=82.28 //y=4.885 //x2=82.28 //y2=4.975
r881 (  307 308 ) resistor r=52.7279 //w=0.214 //l=0.165 //layer=ply \
 //thickness=0.18 //x=82.26 //y=2.26 //x2=82.26 //y2=2.095
r882 (  299 301 ) resistor r=20.271 //w=0.214 //l=0.09 //layer=ply \
 //thickness=0.18 //x=75.64 //y=4.885 //x2=75.64 //y2=4.975
r883 (  295 296 ) resistor r=52.7279 //w=0.214 //l=0.165 //layer=ply \
 //thickness=0.18 //x=75.6 //y=2.26 //x2=75.6 //y2=2.095
r884 (  288 289 ) resistor r=32.4568 //w=0.214 //l=0.075 //layer=ply \
 //thickness=0.18 //x=43.07 //y=4.97 //x2=43.07 //y2=5.045
r885 (  286 288 ) resistor r=20.271 //w=0.214 //l=0.09 //layer=ply \
 //thickness=0.18 //x=43.07 //y=4.88 //x2=43.07 //y2=4.97
r886 (  282 283 ) resistor r=52.7279 //w=0.214 //l=0.165 //layer=ply \
 //thickness=0.18 //x=43.04 //y=2.26 //x2=43.04 //y2=2.095
r887 (  280 318 ) resistor r=4.95774 //w=0.164 //l=0.112 //layer=ply \
 //thickness=0.18 //x=82.825 //y=1.435 //x2=82.825 //y2=1.547
r888 (  279 317 ) resistor r=45.1352 //w=0.168 //l=0.173853 //layer=ply \
 //thickness=0.18 //x=82.825 //y=1.085 //x2=82.785 //y2=0.93
r889 (  279 280 ) resistor r=179.468 //w=0.094 //l=0.35 //layer=ply \
 //thickness=0.18 //x=82.825 //y=1.085 //x2=82.825 //y2=1.435
r890 (  274 316 ) resistor r=10.8103 //w=0.211 //l=0.115 //layer=ply \
 //thickness=0.18 //x=82.45 //y=1.585 //x2=82.335 //y2=1.585
r891 (  273 318 ) resistor r=45.9962 //w=0.164 //l=0.17296 //layer=ply \
 //thickness=0.18 //x=82.67 //y=1.585 //x2=82.825 //y2=1.547
r892 (  272 315 ) resistor r=5.52526 //w=0.168 //l=0.115 //layer=ply \
 //thickness=0.18 //x=82.45 //y=0.93 //x2=82.335 //y2=0.93
r893 (  271 317 ) resistor r=5.52526 //w=0.168 //l=0.115 //layer=ply \
 //thickness=0.18 //x=82.67 //y=0.93 //x2=82.785 //y2=0.93
r894 (  271 272 ) resistor r=112.809 //w=0.094 //l=0.22 //layer=ply \
 //thickness=0.18 //x=82.67 //y=0.93 //x2=82.45 //y2=0.93
r895 (  270 313 ) resistor r=16.5046 //w=0.27 //l=0.135 //layer=ply \
 //thickness=0.18 //x=82.415 //y=4.975 //x2=82.28 //y2=4.975
r896 (  269 276 ) resistor r=26.9307 //w=0.15 //l=0.106066 //layer=ply \
 //thickness=0.18 //x=82.665 //y=4.975 //x2=82.74 //y2=5.05
r897 (  269 270 ) resistor r=128.191 //w=0.094 //l=0.25 //layer=ply \
 //thickness=0.18 //x=82.665 //y=4.975 //x2=82.415 //y2=4.975
r898 (  264 316 ) resistor r=39.5036 //w=0.211 //l=0.173853 //layer=ply \
 //thickness=0.18 //x=82.295 //y=1.74 //x2=82.335 //y2=1.585
r899 (  264 308 ) resistor r=182.032 //w=0.094 //l=0.355 //layer=ply \
 //thickness=0.18 //x=82.295 //y=1.74 //x2=82.295 //y2=2.095
r900 (  263 316 ) resistor r=38.3614 //w=0.211 //l=0.168819 //layer=ply \
 //thickness=0.18 //x=82.295 //y=1.435 //x2=82.335 //y2=1.585
r901 (  262 315 ) resistor r=45.1352 //w=0.168 //l=0.173853 //layer=ply \
 //thickness=0.18 //x=82.295 //y=1.085 //x2=82.335 //y2=0.93
r902 (  262 263 ) resistor r=179.468 //w=0.094 //l=0.35 //layer=ply \
 //thickness=0.18 //x=82.295 //y=1.085 //x2=82.295 //y2=1.435
r903 (  261 305 ) resistor r=45.1352 //w=0.168 //l=0.173853 //layer=ply \
 //thickness=0.18 //x=76.165 //y=1.43 //x2=76.125 //y2=1.585
r904 (  260 304 ) resistor r=45.1352 //w=0.168 //l=0.173853 //layer=ply \
 //thickness=0.18 //x=76.165 //y=1.085 //x2=76.125 //y2=0.93
r905 (  260 261 ) resistor r=176.904 //w=0.094 //l=0.345 //layer=ply \
 //thickness=0.18 //x=76.165 //y=1.085 //x2=76.165 //y2=1.43
r906 (  255 303 ) resistor r=10.701 //w=0.21 //l=0.115 //layer=ply \
 //thickness=0.18 //x=75.79 //y=1.585 //x2=75.675 //y2=1.585
r907 (  254 305 ) resistor r=5.52526 //w=0.168 //l=0.115 //layer=ply \
 //thickness=0.18 //x=76.01 //y=1.585 //x2=76.125 //y2=1.585
r908 (  253 302 ) resistor r=5.52526 //w=0.168 //l=0.115 //layer=ply \
 //thickness=0.18 //x=75.79 //y=0.93 //x2=75.675 //y2=0.93
r909 (  252 304 ) resistor r=5.52526 //w=0.168 //l=0.115 //layer=ply \
 //thickness=0.18 //x=76.01 //y=0.93 //x2=76.125 //y2=0.93
r910 (  252 253 ) resistor r=112.809 //w=0.094 //l=0.22 //layer=ply \
 //thickness=0.18 //x=76.01 //y=0.93 //x2=75.79 //y2=0.93
r911 (  251 301 ) resistor r=16.5046 //w=0.27 //l=0.135 //layer=ply \
 //thickness=0.18 //x=75.775 //y=4.975 //x2=75.64 //y2=4.975
r912 (  250 257 ) resistor r=26.9307 //w=0.15 //l=0.106066 //layer=ply \
 //thickness=0.18 //x=76.005 //y=4.975 //x2=76.08 //y2=5.05
r913 (  250 251 ) resistor r=117.936 //w=0.094 //l=0.23 //layer=ply \
 //thickness=0.18 //x=76.005 //y=4.975 //x2=75.775 //y2=4.975
r914 (  247 301 ) resistor r=32.4568 //w=0.214 //l=0.075 //layer=ply \
 //thickness=0.18 //x=75.64 //y=5.05 //x2=75.64 //y2=4.975
r915 (  245 303 ) resistor r=39.5823 //w=0.21 //l=0.173853 //layer=ply \
 //thickness=0.18 //x=75.635 //y=1.74 //x2=75.675 //y2=1.585
r916 (  245 296 ) resistor r=182.032 //w=0.094 //l=0.355 //layer=ply \
 //thickness=0.18 //x=75.635 //y=1.74 //x2=75.635 //y2=2.095
r917 (  244 303 ) resistor r=39.5823 //w=0.21 //l=0.173853 //layer=ply \
 //thickness=0.18 //x=75.635 //y=1.43 //x2=75.675 //y2=1.585
r918 (  243 302 ) resistor r=45.1352 //w=0.168 //l=0.173853 //layer=ply \
 //thickness=0.18 //x=75.635 //y=1.085 //x2=75.675 //y2=0.93
r919 (  243 244 ) resistor r=176.904 //w=0.094 //l=0.345 //layer=ply \
 //thickness=0.18 //x=75.635 //y=1.085 //x2=75.635 //y2=1.43
r920 (  242 293 ) resistor r=45.1352 //w=0.168 //l=0.173853 //layer=ply \
 //thickness=0.18 //x=43.605 //y=1.43 //x2=43.565 //y2=1.585
r921 (  241 292 ) resistor r=45.1352 //w=0.168 //l=0.173853 //layer=ply \
 //thickness=0.18 //x=43.605 //y=1.085 //x2=43.565 //y2=0.93
r922 (  241 242 ) resistor r=176.904 //w=0.094 //l=0.345 //layer=ply \
 //thickness=0.18 //x=43.605 //y=1.085 //x2=43.605 //y2=1.43
r923 (  236 291 ) resistor r=10.701 //w=0.21 //l=0.115 //layer=ply \
 //thickness=0.18 //x=43.23 //y=1.585 //x2=43.115 //y2=1.585
r924 (  235 293 ) resistor r=5.52526 //w=0.168 //l=0.115 //layer=ply \
 //thickness=0.18 //x=43.45 //y=1.585 //x2=43.565 //y2=1.585
r925 (  234 290 ) resistor r=5.52526 //w=0.168 //l=0.115 //layer=ply \
 //thickness=0.18 //x=43.23 //y=0.93 //x2=43.115 //y2=0.93
r926 (  233 292 ) resistor r=5.52526 //w=0.168 //l=0.115 //layer=ply \
 //thickness=0.18 //x=43.45 //y=0.93 //x2=43.565 //y2=0.93
r927 (  233 234 ) resistor r=112.809 //w=0.094 //l=0.22 //layer=ply \
 //thickness=0.18 //x=43.45 //y=0.93 //x2=43.23 //y2=0.93
r928 (  232 288 ) resistor r=16.5046 //w=0.27 //l=0.135 //layer=ply \
 //thickness=0.18 //x=43.205 //y=4.97 //x2=43.07 //y2=4.97
r929 (  231 238 ) resistor r=26.9307 //w=0.15 //l=0.106066 //layer=ply \
 //thickness=0.18 //x=43.445 //y=4.97 //x2=43.52 //y2=5.045
r930 (  231 232 ) resistor r=123.064 //w=0.094 //l=0.24 //layer=ply \
 //thickness=0.18 //x=43.445 //y=4.97 //x2=43.205 //y2=4.97
r931 (  226 291 ) resistor r=39.5823 //w=0.21 //l=0.173853 //layer=ply \
 //thickness=0.18 //x=43.075 //y=1.74 //x2=43.115 //y2=1.585
r932 (  226 283 ) resistor r=182.032 //w=0.094 //l=0.355 //layer=ply \
 //thickness=0.18 //x=43.075 //y=1.74 //x2=43.075 //y2=2.095
r933 (  225 291 ) resistor r=39.5823 //w=0.21 //l=0.173853 //layer=ply \
 //thickness=0.18 //x=43.075 //y=1.43 //x2=43.115 //y2=1.585
r934 (  224 290 ) resistor r=45.1352 //w=0.168 //l=0.173853 //layer=ply \
 //thickness=0.18 //x=43.075 //y=1.085 //x2=43.115 //y2=0.93
r935 (  224 225 ) resistor r=176.904 //w=0.094 //l=0.345 //layer=ply \
 //thickness=0.18 //x=43.075 //y=1.085 //x2=43.075 //y2=1.43
r936 (  223 276 ) resistor r=592.245 //w=0.094 //l=1.155 //layer=ply \
 //thickness=0.18 //x=82.74 //y=6.205 //x2=82.74 //y2=5.05
r937 (  222 314 ) resistor r=592.245 //w=0.094 //l=1.155 //layer=ply \
 //thickness=0.18 //x=82.3 //y=6.205 //x2=82.3 //y2=5.05
r938 (  221 257 ) resistor r=592.245 //w=0.094 //l=1.155 //layer=ply \
 //thickness=0.18 //x=76.08 //y=6.205 //x2=76.08 //y2=5.05
r939 (  220 247 ) resistor r=592.245 //w=0.094 //l=1.155 //layer=ply \
 //thickness=0.18 //x=75.64 //y=6.205 //x2=75.64 //y2=5.05
r940 (  219 238 ) resistor r=592.245 //w=0.094 //l=1.155 //layer=ply \
 //thickness=0.18 //x=43.52 //y=6.2 //x2=43.52 //y2=5.045
r941 (  218 289 ) resistor r=592.245 //w=0.094 //l=1.155 //layer=ply \
 //thickness=0.18 //x=43.08 //y=6.2 //x2=43.08 //y2=5.045
r942 (  217 273 ) resistor r=56.4043 //w=0.094 //l=0.11 //layer=ply \
 //thickness=0.18 //x=82.56 //y=1.585 //x2=82.67 //y2=1.585
r943 (  217 274 ) resistor r=56.4043 //w=0.094 //l=0.11 //layer=ply \
 //thickness=0.18 //x=82.56 //y=1.585 //x2=82.45 //y2=1.585
r944 (  216 254 ) resistor r=56.4043 //w=0.094 //l=0.11 //layer=ply \
 //thickness=0.18 //x=75.9 //y=1.585 //x2=76.01 //y2=1.585
r945 (  216 255 ) resistor r=56.4043 //w=0.094 //l=0.11 //layer=ply \
 //thickness=0.18 //x=75.9 //y=1.585 //x2=75.79 //y2=1.585
r946 (  215 235 ) resistor r=56.4043 //w=0.094 //l=0.11 //layer=ply \
 //thickness=0.18 //x=43.34 //y=1.585 //x2=43.45 //y2=1.585
r947 (  215 236 ) resistor r=56.4043 //w=0.094 //l=0.11 //layer=ply \
 //thickness=0.18 //x=43.34 //y=1.585 //x2=43.23 //y2=1.585
r948 (  211 311 ) resistor r=152 //w=0.17 //l=0.17 //layer=licon //count=1 \
 //x=82.28 //y=4.885 //x2=82.28 //y2=4.885
r949 (  202 307 ) resistor r=152 //w=0.17 //l=0.17 //layer=licon //count=1 \
 //x=82.26 //y=2.26 //x2=82.26 //y2=2.26
r950 (  197 299 ) resistor r=152 //w=0.17 //l=0.17 //layer=licon //count=1 \
 //x=75.64 //y=4.885 //x2=75.64 //y2=4.885
r951 (  184 295 ) resistor r=152 //w=0.17 //l=0.17 //layer=licon //count=1 \
 //x=75.6 //y=2.26 //x2=75.6 //y2=2.26
r952 (  163 323 ) resistor r=23.615 //w=0.187 //l=0.345 //layer=li \
 //thickness=0.1 //x=47.81 //y=5.56 //x2=47.81 //y2=5.905
r953 (  155 322 ) resistor r=23.615 //w=0.187 //l=0.345 //layer=li \
 //thickness=0.1 //x=46.93 //y=5.56 //x2=46.93 //y2=5.905
r954 (  147 321 ) resistor r=23.615 //w=0.187 //l=0.345 //layer=li \
 //thickness=0.1 //x=46.05 //y=5.56 //x2=46.05 //y2=5.905
r955 (  142 286 ) resistor r=152 //w=0.17 //l=0.17 //layer=licon //count=1 \
 //x=43.07 //y=4.88 //x2=43.07 //y2=4.88
r956 (  133 282 ) resistor r=152 //w=0.17 //l=0.17 //layer=licon //count=1 \
 //x=43.04 //y=2.26 //x2=43.04 //y2=2.26
r957 (  129 130 ) resistor r=0.104807 //w=0.281 //l=0.16 //layer=m2 \
 //thickness=0.36 //x=82.275 //y=4.21 //x2=82.115 //y2=4.21
r958 (  127 130 ) resistor r=5.84099 //w=0.136 //l=6.355 //layer=m2 \
 //thickness=0.36 //x=75.76 //y=4.252 //x2=82.115 //y2=4.252
r959 (  125 127 ) resistor r=0.104807 //w=0.281 //l=0.16 //layer=m2 \
 //thickness=0.36 //x=75.6 //y=4.205 //x2=75.76 //y2=4.205
r960 (  119 121 ) resistor r=0.10734 //w=0.281 //l=0.16 //layer=m2 \
 //thickness=0.36 //x=48.585 //y=2.785 //x2=48.745 //y2=2.785
r961 (  113 115 ) resistor r=0.10734 //w=0.281 //l=0.16 //layer=m2 \
 //thickness=0.36 //x=43.03 //y=4.265 //x2=43.19 //y2=4.265
r962 (  108 123 ) resistor r=8.61351 //w=0.174 //l=12.0125 //layer=m2 \
 //thickness=0.36 //x=63.6 //y=3.17 //x2=75.59 //y2=3.125
r963 (  108 109 ) resistor r=0.329198 //w=0.131 //l=0.345 //layer=m2 \
 //thickness=0.36 //x=63.6 //y=3.17 //x2=63.255 //y2=3.17
r964 (  106 109 ) resistor r=0.1875 //w=0.17 //l=0.269583 //layer=m2 \
 //thickness=0.36 //x=63 //y=3.14 //x2=63.255 //y2=3.17
r965 (  106 107 ) resistor r=1.02576 //w=0.131 //l=1.075 //layer=m2 \
 //thickness=0.36 //x=63 //y=3.14 //x2=61.925 //y2=3.14
r966 (  104 107 ) resistor r=0.125 //w=0.17 //l=0.184391 //layer=m2 \
 //thickness=0.36 //x=61.755 //y=3.17 //x2=61.925 //y2=3.14
r967 (  104 105 ) resistor r=0.329198 //w=0.131 //l=0.345 //layer=m2 \
 //thickness=0.36 //x=61.755 //y=3.17 //x2=61.41 //y2=3.17
r968 (  102 105 ) resistor r=0.1875 //w=0.17 //l=0.269583 //layer=m2 \
 //thickness=0.36 //x=61.155 //y=3.14 //x2=61.41 //y2=3.17
r969 (  102 103 ) resistor r=2.08969 //w=0.131 //l=2.19 //layer=m2 \
 //thickness=0.36 //x=61.155 //y=3.14 //x2=58.965 //y2=3.14
r970 (  100 103 ) resistor r=0.125 //w=0.17 //l=0.179722 //layer=m2 \
 //thickness=0.36 //x=58.795 //y=3.16 //x2=58.965 //y2=3.14
r971 (  100 101 ) resistor r=0.329198 //w=0.131 //l=0.345 //layer=m2 \
 //thickness=0.36 //x=58.795 //y=3.16 //x2=58.45 //y2=3.16
r972 (  98 101 ) resistor r=0.1875 //w=0.17 //l=0.264811 //layer=m2 \
 //thickness=0.36 //x=58.195 //y=3.14 //x2=58.45 //y2=3.16
r973 (  98 99 ) resistor r=3.85496 //w=0.131 //l=4.04 //layer=m2 \
 //thickness=0.36 //x=58.195 //y=3.14 //x2=54.155 //y2=3.14
r974 (  96 99 ) resistor r=0.125 //w=0.17 //l=0.177341 //layer=m2 \
 //thickness=0.36 //x=53.985 //y=3.155 //x2=54.155 //y2=3.14
r975 (  96 97 ) resistor r=0.329198 //w=0.131 //l=0.345 //layer=m2 \
 //thickness=0.36 //x=53.985 //y=3.155 //x2=53.64 //y2=3.155
r976 (  94 97 ) resistor r=0.1875 //w=0.17 //l=0.262393 //layer=m2 \
 //thickness=0.36 //x=53.385 //y=3.14 //x2=53.64 //y2=3.155
r977 (  94 95 ) resistor r=1.03053 //w=0.131 //l=1.08 //layer=m2 \
 //thickness=0.36 //x=53.385 //y=3.14 //x2=52.305 //y2=3.14
r978 (  92 95 ) resistor r=0.125 //w=0.17 //l=0.177341 //layer=m2 \
 //thickness=0.36 //x=52.135 //y=3.155 //x2=52.305 //y2=3.14
r979 (  92 93 ) resistor r=0.329198 //w=0.131 //l=0.345 //layer=m2 \
 //thickness=0.36 //x=52.135 //y=3.155 //x2=51.79 //y2=3.155
r980 (  90 93 ) resistor r=0.1875 //w=0.17 //l=0.262393 //layer=m2 \
 //thickness=0.36 //x=51.535 //y=3.14 //x2=51.79 //y2=3.155
r981 (  90 91 ) resistor r=0.257634 //w=0.131 //l=0.27 //layer=m2 \
 //thickness=0.36 //x=51.535 //y=3.14 //x2=51.265 //y2=3.14
r982 (  89 91 ) resistor r=0.0698411 //w=0.17 //l=0.120208 //layer=m2 \
 //thickness=0.36 //x=51.18 //y=3.055 //x2=51.265 //y2=3.14
r983 (  88 89 ) resistor r=0.19084 //w=0.131 //l=0.2 //layer=m2 \
 //thickness=0.36 //x=51.18 //y=2.855 //x2=51.18 //y2=3.055
r984 (  86 88 ) resistor r=0.0698411 //w=0.17 //l=0.120208 //layer=m2 \
 //thickness=0.36 //x=51.095 //y=2.77 //x2=51.18 //y2=2.855
r985 (  86 121 ) resistor r=2.24237 //w=0.131 //l=2.35 //layer=m2 \
 //thickness=0.36 //x=51.095 //y=2.77 //x2=48.745 //y2=2.77
r986 (  84 117 ) resistor r=0.277226 //w=0.242 //l=0.532212 //layer=m2 \
 //thickness=0.36 //x=48.065 //y=4.27 //x2=48.58 //y2=4.235
r987 (  84 85 ) resistor r=0.329198 //w=0.131 //l=0.345 //layer=m2 \
 //thickness=0.36 //x=48.065 //y=4.27 //x2=47.72 //y2=4.27
r988 (  82 85 ) resistor r=0.1875 //w=0.17 //l=0.264811 //layer=m2 \
 //thickness=0.36 //x=47.465 //y=4.25 //x2=47.72 //y2=4.27
r989 (  82 115 ) resistor r=4.0792 //w=0.131 //l=4.275 //layer=m2 \
 //thickness=0.36 //x=47.465 //y=4.25 //x2=43.19 //y2=4.25
r990 (  81 211 ) resistor r=9.3 //w=0.17 //l=0.17 //layer=mcon //count=1 \
 //x=82.28 //y=4.885 //x2=82.28 //y2=4.885
r991 (  79 202 ) resistor r=9.3 //w=0.17 //l=0.17 //layer=mcon //count=1 \
 //x=82.26 //y=2.26 //x2=82.26 //y2=2.26
r992 (  75 129 ) resistor r=4.5 //w=0.15 //l=0.15 //layer=via1 //count=1 \
 //x=82.275 //y=4.21 //x2=82.275 //y2=4.21
r993 (  75 77 ) resistor r=0.0130208 //w=0.384 //l=0.04 //layer=m1 \
 //thickness=0.36 //x=82.215 //y=4.21 //x2=82.215 //y2=4.25
r994 (  71 125 ) resistor r=4.5 //w=0.15 //l=0.15 //layer=via1 //count=1 \
 //x=75.6 //y=4.205 //x2=75.6 //y2=4.205
r995 (  71 73 ) resistor r=0.0149601 //w=0.376 //l=0.045 //layer=m1 \
 //thickness=0.36 //x=75.652 //y=4.205 //x2=75.652 //y2=4.25
r996 (  69 197 ) resistor r=9.3 //w=0.17 //l=0.17 //layer=mcon //count=1 \
 //x=75.64 //y=4.885 //x2=75.64 //y2=4.885
r997 (  67 184 ) resistor r=9.3 //w=0.17 //l=0.17 //layer=mcon //count=1 \
 //x=75.6 //y=2.26 //x2=75.6 //y2=2.26
r998 (  63 123 ) resistor r=4.5 //w=0.15 //l=0.15 //layer=via1 //count=1 \
 //x=75.59 //y=3.125 //x2=75.59 //y2=3.125
r999 (  63 65 ) resistor r=0.00505391 //w=0.371 //l=0.015 //layer=m1 \
 //thickness=0.36 //x=75.542 //y=3.125 //x2=75.542 //y2=3.14
r1000 (  61 119 ) resistor r=4.5 //w=0.15 //l=0.15 //layer=via1 //count=1 \
 //x=48.585 //y=2.785 //x2=48.585 //y2=2.785
r1001 (  59 61 ) resistor r=0.00494723 //w=0.379 //l=0.015 //layer=m1 \
 //thickness=0.36 //x=48.64 //y=2.77 //x2=48.64 //y2=2.785
r1002 (  55 117 ) resistor r=4.5 //w=0.15 //l=0.15 //layer=via1 //count=1 \
 //x=48.58 //y=4.235 //x2=48.58 //y2=4.235
r1003 (  55 57 ) resistor r=0.00505391 //w=0.371 //l=0.015 //layer=m1 \
 //thickness=0.36 //x=48.532 //y=4.235 //x2=48.532 //y2=4.25
r1004 (  53 319 ) resistor r=9.3 //w=0.17 //l=0.17 //layer=mcon //count=1 \
 //x=48.105 //y=1.19 //x2=48.105 //y2=1.19
r1005 (  51 163 ) resistor r=9.3 //w=0.17 //l=0.17 //layer=mcon //count=1 \
 //x=47.81 //y=5.56 //x2=47.81 //y2=5.56
r1006 (  48 155 ) resistor r=9.3 //w=0.17 //l=0.17 //layer=mcon //count=1 \
 //x=46.93 //y=5.56 //x2=46.93 //y2=5.56
r1007 (  46 48 ) resistor r=0.121228 //w=0.232 //l=0.225 //layer=m1 \
 //thickness=0.36 //x=46.93 //y=5.335 //x2=46.93 //y2=5.56
r1008 (  45 147 ) resistor r=9.3 //w=0.17 //l=0.17 //layer=mcon //count=1 \
 //x=46.05 //y=5.56 //x2=46.05 //y2=5.56
r1009 (  43 45 ) resistor r=0.129608 //w=0.217 //l=0.225 //layer=m1 \
 //thickness=0.36 //x=46.052 //y=5.335 //x2=46.052 //y2=5.56
r1010 (  42 113 ) resistor r=4.5 //w=0.15 //l=0.15 //layer=via1 //count=1 \
 //x=43.03 //y=4.265 //x2=43.03 //y2=4.265
r1011 (  40 42 ) resistor r=0.00490838 //w=0.382 //l=0.015 //layer=m1 \
 //thickness=0.36 //x=43.087 //y=4.25 //x2=43.087 //y2=4.265
r1012 (  38 142 ) resistor r=9.3 //w=0.17 //l=0.17 //layer=mcon //count=1 \
 //x=43.07 //y=4.88 //x2=43.07 //y2=4.88
r1013 (  34 133 ) resistor r=9.3 //w=0.17 //l=0.17 //layer=mcon //count=1 \
 //x=43.04 //y=2.26 //x2=43.04 //y2=2.26
r1014 (  34 36 ) resistor r=0.0936408 //w=0.196 //l=0.125 //layer=m1 \
 //thickness=0.36 //x=43.042 //y=2.26 //x2=43.042 //y2=2.385
r1015 (  32 81 ) resistor r=0.0893515 //w=0.219 //l=0.154677 //layer=m1 \
 //thickness=0.36 //x=82.26 //y=4.74 //x2=82.28 //y2=4.885
r1016 (  31 77 ) resistor r=0.0784723 //w=0.384 //l=0.140712 //layer=m1 \
 //thickness=0.36 //x=82.26 //y=4.37 //x2=82.215 //y2=4.25
r1017 (  31 32 ) resistor r=0.353053 //w=0.131 //l=0.37 //layer=m1 \
 //thickness=0.36 //x=82.26 //y=4.37 //x2=82.26 //y2=4.74
r1018 (  30 75 ) resistor r=0.0914932 //w=0.384 //l=0.181108 //layer=m1 \
 //thickness=0.36 //x=82.26 //y=4.05 //x2=82.215 //y2=4.21
r1019 (  29 79 ) resistor r=0.0744285 //w=0.225 //l=0.12 //layer=m1 \
 //thickness=0.36 //x=82.26 //y=2.38 //x2=82.26 //y2=2.26
r1020 (  29 30 ) resistor r=1.59351 //w=0.131 //l=1.67 //layer=m1 \
 //thickness=0.36 //x=82.26 //y=2.38 //x2=82.26 //y2=4.05
r1021 (  28 69 ) resistor r=0.100665 //w=0.248 //l=0.193972 //layer=m1 \
 //thickness=0.36 //x=75.6 //y=4.71 //x2=75.64 //y2=4.885
r1022 (  27 73 ) resistor r=0.0761992 //w=0.376 //l=0.138582 //layer=m1 \
 //thickness=0.36 //x=75.6 //y=4.365 //x2=75.652 //y2=4.25
r1023 (  27 28 ) resistor r=0.329198 //w=0.131 //l=0.345 //layer=m1 \
 //thickness=0.36 //x=75.6 //y=4.365 //x2=75.6 //y2=4.71
r1024 (  26 71 ) resistor r=0.0911593 //w=0.376 //l=0.184174 //layer=m1 \
 //thickness=0.36 //x=75.6 //y=4.045 //x2=75.652 //y2=4.205
r1025 (  25 65 ) resistor r=0.0859108 //w=0.371 //l=0.171566 //layer=m1 \
 //thickness=0.36 //x=75.6 //y=3.285 //x2=75.542 //y2=3.14
r1026 (  25 26 ) resistor r=0.725191 //w=0.131 //l=0.76 //layer=m1 \
 //thickness=0.36 //x=75.6 //y=3.285 //x2=75.6 //y2=4.045
r1027 (  24 63 ) resistor r=0.0909648 //w=0.371 //l=0.186762 //layer=m1 \
 //thickness=0.36 //x=75.6 //y=2.965 //x2=75.542 //y2=3.125
r1028 (  23 67 ) resistor r=0.0717383 //w=0.224 //l=0.115 //layer=m1 \
 //thickness=0.36 //x=75.6 //y=2.375 //x2=75.6 //y2=2.26
r1029 (  23 24 ) resistor r=0.562977 //w=0.131 //l=0.59 //layer=m1 \
 //thickness=0.36 //x=75.6 //y=2.375 //x2=75.6 //y2=2.965
r1030 (  21 57 ) resistor r=0.0859108 //w=0.371 //l=0.171566 //layer=m1 \
 //thickness=0.36 //x=48.59 //y=4.395 //x2=48.532 //y2=4.25
r1031 (  21 22 ) resistor r=0.81584 //w=0.131 //l=0.855 //layer=m1 \
 //thickness=0.36 //x=48.59 //y=4.395 //x2=48.59 //y2=5.25
r1032 (  20 55 ) resistor r=0.0909648 //w=0.371 //l=0.186762 //layer=m1 \
 //thickness=0.36 //x=48.59 //y=4.075 //x2=48.532 //y2=4.235
r1033 (  19 61 ) resistor r=0.0912814 //w=0.379 //l=0.183303 //layer=m1 \
 //thickness=0.36 //x=48.59 //y=2.945 //x2=48.64 //y2=2.785
r1034 (  19 20 ) resistor r=1.07824 //w=0.131 //l=1.13 //layer=m1 \
 //thickness=0.36 //x=48.59 //y=2.945 //x2=48.59 //y2=4.075
r1035 (  18 59 ) resistor r=0.0863342 //w=0.379 //l=0.168152 //layer=m1 \
 //thickness=0.36 //x=48.59 //y=2.625 //x2=48.64 //y2=2.77
r1036 (  17 18 ) resistor r=0.663168 //w=0.131 //l=0.695 //layer=m1 \
 //thickness=0.36 //x=48.59 //y=1.93 //x2=48.59 //y2=2.625
r1037 (  15 17 ) resistor r=0.0698411 //w=0.17 //l=0.120208 //layer=m1 \
 //thickness=0.36 //x=48.505 //y=1.845 //x2=48.59 //y2=1.93
r1038 (  15 16 ) resistor r=0.300573 //w=0.131 //l=0.315 //layer=m1 \
 //thickness=0.36 //x=48.505 //y=1.845 //x2=48.19 //y2=1.845
r1039 (  14 16 ) resistor r=0.0698411 //w=0.17 //l=0.120208 //layer=m1 \
 //thickness=0.36 //x=48.105 //y=1.76 //x2=48.19 //y2=1.845
r1040 (  13 53 ) resistor r=0.0717383 //w=0.224 //l=0.115 //layer=m1 \
 //thickness=0.36 //x=48.105 //y=1.305 //x2=48.105 //y2=1.19
r1041 (  13 14 ) resistor r=0.43416 //w=0.131 //l=0.455 //layer=m1 \
 //thickness=0.36 //x=48.105 //y=1.305 //x2=48.105 //y2=1.76
r1042 (  12 49 ) resistor r=0.0675342 //w=0.23 //l=0.115 //layer=m1 \
 //thickness=0.36 //x=47.925 //y=5.335 //x2=47.81 //y2=5.335
r1043 (  11 22 ) resistor r=0.0698411 //w=0.17 //l=0.120208 //layer=m1 \
 //thickness=0.36 //x=48.505 //y=5.335 //x2=48.59 //y2=5.25
r1044 (  11 12 ) resistor r=0.553435 //w=0.131 //l=0.58 //layer=m1 \
 //thickness=0.36 //x=48.505 //y=5.335 //x2=47.925 //y2=5.335
r1045 (  10 51 ) resistor r=0.00118313 //w=0.23 //layer=m1 //thickness=0.36 \
 //x=47.81 //y=5.56 //x2=47.81 //y2=5.56
r1046 (  9 49 ) resistor r=0.002872 //w=0.34 //l=0.085 //layer=m1 \
 //thickness=0.36 //x=47.81 //y=5.42 //x2=47.81 //y2=5.335
r1047 (  9 10 ) resistor r=0.091623 //w=0.191 //l=0.14 //layer=m1 \
 //thickness=0.36 //x=47.81 //y=5.42 //x2=47.81 //y2=5.56
r1048 (  8 46 ) resistor r=0.0262263 //w=0.232 //l=0.12 //layer=m1 \
 //thickness=0.36 //x=47.05 //y=5.335 //x2=46.93 //y2=5.335
r1049 (  7 49 ) resistor r=0.0675342 //w=0.23 //l=0.115 //layer=m1 \
 //thickness=0.36 //x=47.695 //y=5.335 //x2=47.81 //y2=5.335
r1050 (  7 8 ) resistor r=0.615458 //w=0.131 //l=0.645 //layer=m1 \
 //thickness=0.36 //x=47.695 //y=5.335 //x2=47.05 //y2=5.335
r1051 (  6 43 ) resistor r=0.0222262 //w=0.217 //l=0.118 //layer=m1 \
 //thickness=0.36 //x=46.17 //y=5.335 //x2=46.052 //y2=5.335
r1052 (  5 46 ) resistor r=0.0262263 //w=0.232 //l=0.12 //layer=m1 \
 //thickness=0.36 //x=46.81 //y=5.335 //x2=46.93 //y2=5.335
r1053 (  5 6 ) resistor r=0.610687 //w=0.131 //l=0.64 //layer=m1 \
 //thickness=0.36 //x=46.81 //y=5.335 //x2=46.17 //y2=5.335
r1054 (  4 38 ) resistor r=0.0878548 //w=0.228 //l=0.159295 //layer=m1 \
 //thickness=0.36 //x=43.04 //y=4.735 //x2=43.07 //y2=4.88
r1055 (  3 42 ) resistor r=0.0914072 //w=0.382 //l=0.181989 //layer=m1 \
 //thickness=0.36 //x=43.04 //y=4.425 //x2=43.087 //y2=4.265
r1056 (  3 4 ) resistor r=0.295802 //w=0.131 //l=0.31 //layer=m1 \
 //thickness=0.36 //x=43.04 //y=4.425 //x2=43.04 //y2=4.735
r1057 (  2 40 ) resistor r=0.0864989 //w=0.382 //l=0.166853 //layer=m1 \
 //thickness=0.36 //x=43.04 //y=4.105 //x2=43.087 //y2=4.25
r1058 (  2 36 ) resistor r=1.64122 //w=0.131 //l=1.72 //layer=m1 \
 //thickness=0.36 //x=43.04 //y=4.105 //x2=43.04 //y2=2.385
ends PM_TMRDFFSNQX1\%noxref_11

subckt PM_TMRDFFSNQX1\%D ( 1 2 3 4 5 6 7 8 9 10 11 12 13 17 26 31 32 37 40 48 \
 51 63 66 69 71 73 75 77 79 81 83 85 87 89 91 93 94 95 97 99 101 103 105 107 \
 109 111 113 115 117 119 121 126 132 141 146 155 160 169 173 174 175 176 177 \
 178 179 180 181 182 183 184 185 189 191 194 195 199 200 201 202 206 208 211 \
 212 216 217 218 219 223 225 228 229 239 248 257 )
c622 ( 257 0 ) capacitor c=0.0682508f //x=50.44 //y=4.88
c623 ( 248 0 ) capacitor c=0.0682508f //x=26.02 //y=4.88
c624 ( 239 0 ) capacitor c=0.0682508f //x=1.6 //y=4.88
c625 ( 229 0 ) capacitor c=0.0318956f //x=50.775 //y=1.39
c626 ( 228 0 ) capacitor c=0.0186809f //x=50.775 //y=1.045
c627 ( 225 0 ) capacitor c=0.0141821f //x=50.62 //y=1.545
c628 ( 223 0 ) capacitor c=0.0158553f //x=50.62 //y=0.89
c629 ( 219 0 ) capacitor c=0.0818349f //x=50.245 //y=2.095
c630 ( 218 0 ) capacitor c=0.0229235f //x=50.245 //y=1.7
c631 ( 217 0 ) capacitor c=0.0234359f //x=50.245 //y=1.39
c632 ( 216 0 ) capacitor c=0.0198759f //x=50.245 //y=1.045
c633 ( 212 0 ) capacitor c=0.0318956f //x=26.355 //y=1.39
c634 ( 211 0 ) capacitor c=0.0186809f //x=26.355 //y=1.045
c635 ( 208 0 ) capacitor c=0.0141821f //x=26.2 //y=1.545
c636 ( 206 0 ) capacitor c=0.0158553f //x=26.2 //y=0.89
c637 ( 202 0 ) capacitor c=0.0839634f //x=25.825 //y=2.095
c638 ( 201 0 ) capacitor c=0.0229235f //x=25.825 //y=1.7
c639 ( 200 0 ) capacitor c=0.0234359f //x=25.825 //y=1.39
c640 ( 199 0 ) capacitor c=0.0198759f //x=25.825 //y=1.045
c641 ( 195 0 ) capacitor c=0.0318956f //x=1.935 //y=1.39
c642 ( 194 0 ) capacitor c=0.0186809f //x=1.935 //y=1.045
c643 ( 191 0 ) capacitor c=0.0141821f //x=1.78 //y=1.545
c644 ( 189 0 ) capacitor c=0.0158553f //x=1.78 //y=0.89
c645 ( 185 0 ) capacitor c=0.0839759f //x=1.405 //y=2.095
c646 ( 184 0 ) capacitor c=0.0229235f //x=1.405 //y=1.7
c647 ( 183 0 ) capacitor c=0.0234359f //x=1.405 //y=1.39
c648 ( 182 0 ) capacitor c=0.0198759f //x=1.405 //y=1.045
c649 ( 181 0 ) capacitor c=0.110369f //x=50.78 //y=6.2
c650 ( 180 0 ) capacitor c=0.154619f //x=50.34 //y=6.2
c651 ( 179 0 ) capacitor c=0.110369f //x=26.36 //y=6.2
c652 ( 178 0 ) capacitor c=0.154619f //x=25.92 //y=6.2
c653 ( 177 0 ) capacitor c=0.110369f //x=1.94 //y=6.2
c654 ( 176 0 ) capacitor c=0.154619f //x=1.5 //y=6.2
c655 ( 169 0 ) capacitor c=8.13425e-19 //x=50.44 //y=4.88
c656 ( 160 0 ) capacitor c=5.17312e-19 //x=50.44 //y=2.26
c657 ( 155 0 ) capacitor c=8.13425e-19 //x=26.02 //y=4.88
c658 ( 146 0 ) capacitor c=5.17312e-19 //x=26.02 //y=2.26
c659 ( 141 0 ) capacitor c=8.13425e-19 //x=1.6 //y=4.88
c660 ( 132 0 ) capacitor c=5.17312e-19 //x=1.6 //y=2.26
c661 ( 126 0 ) capacitor c=0.0124948f //x=1.765 //y=3.145
c662 ( 121 0 ) capacitor c=0.0211835f //x=48.8 //y=3.17
c663 ( 119 0 ) capacitor c=0.0250105f //x=48.2 //y=3.14
c664 ( 117 0 ) capacitor c=0.00436074f //x=45.845 //y=3.17
c665 ( 115 0 ) capacitor c=0.018002f //x=45.245 //y=3.14
c666 ( 113 0 ) capacitor c=0.004217f //x=43.99 //y=3.17
c667 ( 111 0 ) capacitor c=0.0497442f //x=43.39 //y=3.14
c668 ( 109 0 ) capacitor c=0.00416317f //x=39.18 //y=3.17
c669 ( 107 0 ) capacitor c=0.0177421f //x=38.58 //y=3.14
c670 ( 105 0 ) capacitor c=0.00425641f //x=37.335 //y=3.17
c671 ( 103 0 ) capacitor c=0.025331f //x=36.735 //y=3.14
c672 ( 101 0 ) capacitor c=0.00429096f //x=34.375 //y=3.16
c673 ( 99 0 ) capacitor c=0.0440107f //x=33.775 //y=3.14
c674 ( 97 0 ) capacitor c=0.00368608f //x=29.565 //y=3.155
c675 ( 95 0 ) capacitor c=0.0184713f //x=28.965 //y=3.14
c676 ( 94 0 ) capacitor c=0.0994586f //x=27.37 //y=3.155
c677 ( 93 0 ) capacitor c=0.00413336f //x=27.715 //y=3.155
c678 ( 91 0 ) capacitor c=0.00278013f //x=18.835 //y=3.11
c679 ( 89 0 ) capacitor c=0.0500562f //x=18.235 //y=3.14
c680 ( 87 0 ) capacitor c=0.00493425f //x=14.76 //y=3.17
c681 ( 85 0 ) capacitor c=0.0216919f //x=14.16 //y=3.14
c682 ( 83 0 ) capacitor c=0.00552914f //x=12.915 //y=3.17
c683 ( 81 0 ) capacitor c=0.036695f //x=12.315 //y=3.14
c684 ( 79 0 ) capacitor c=0.0081917f //x=9.955 //y=3.16
c685 ( 77 0 ) capacitor c=0.0560227f //x=9.355 //y=3.14
c686 ( 75 0 ) capacitor c=0.00556621f //x=5.145 //y=3.155
c687 ( 73 0 ) capacitor c=0.0259961f //x=4.545 //y=3.14
c688 ( 71 0 ) capacitor c=0.00631336f //x=3.295 //y=3.155
c689 ( 69 0 ) capacitor c=0.0314162f //x=2.695 //y=3.14
c690 ( 66 0 ) capacitor c=0.00623128f //x=50.44 //y=4.88
c691 ( 63 0 ) capacitor c=0.00463527f //x=50.44 //y=2.26
c692 ( 51 0 ) capacitor c=0.00624278f //x=26.02 //y=4.88
c693 ( 48 0 ) capacitor c=0.00463527f //x=26.02 //y=2.26
c694 ( 40 0 ) capacitor c=0.0111203f //x=1.6 //y=4.88
c695 ( 37 0 ) capacitor c=0.0101947f //x=1.6 //y=2.26
c696 ( 32 0 ) capacitor c=0.0155458f //x=50.44 //y=3.315
c697 ( 31 0 ) capacitor c=0.0120068f //x=50.44 //y=2.995
c698 ( 26 0 ) capacitor c=0.0127727f //x=26.02 //y=3.28
c699 ( 17 0 ) capacitor c=0.0123502f //x=1.6 //y=3.305
c700 ( 13 0 ) capacitor c=0.0146996f //x=50.44 //y=3.14
c701 ( 12 0 ) capacitor c=0.0145644f //x=26.02 //y=3.14
c702 ( 11 0 ) capacitor c=0.0173037f //x=1.6 //y=3.14
c703 ( 9 0 ) capacitor c=0.0366342f //x=50.44 //y=3.88
c704 ( 7 0 ) capacitor c=0.0389707f //x=26.02 //y=3.88
c705 ( 6 0 ) capacitor c=0.0121443f //x=26.02 //y=2.77
c706 ( 2 0 ) capacitor c=0.0651614f //x=1.6 //y=3.51
c707 ( 1 0 ) capacitor c=0.0201611f //x=1.6 //y=2.77
r708 (  255 257 ) resistor r=20.6867 //w=0.233 //l=0.1 //layer=ply \
 //thickness=0.18 //x=50.34 //y=4.88 //x2=50.44 //y2=4.88
r709 (  246 248 ) resistor r=20.6867 //w=0.233 //l=0.1 //layer=ply \
 //thickness=0.18 //x=25.92 //y=4.88 //x2=26.02 //y2=4.88
r710 (  237 239 ) resistor r=20.6867 //w=0.233 //l=0.1 //layer=ply \
 //thickness=0.18 //x=1.5 //y=4.88 //x2=1.6 //y2=4.88
r711 (  230 257 ) resistor r=70.3348 //w=0.233 //l=0.414367 //layer=ply \
 //thickness=0.18 //x=50.78 //y=5.045 //x2=50.44 //y2=4.88
r712 (  229 259 ) resistor r=45.1352 //w=0.168 //l=0.173853 //layer=ply \
 //thickness=0.18 //x=50.775 //y=1.39 //x2=50.735 //y2=1.545
r713 (  228 258 ) resistor r=45.1352 //w=0.168 //l=0.173853 //layer=ply \
 //thickness=0.18 //x=50.775 //y=1.045 //x2=50.735 //y2=0.89
r714 (  228 229 ) resistor r=176.904 //w=0.094 //l=0.345 //layer=ply \
 //thickness=0.18 //x=50.775 //y=1.045 //x2=50.775 //y2=1.39
r715 (  226 254 ) resistor r=10.701 //w=0.21 //l=0.115 //layer=ply \
 //thickness=0.18 //x=50.4 //y=1.545 //x2=50.285 //y2=1.545
r716 (  225 259 ) resistor r=5.52526 //w=0.168 //l=0.115 //layer=ply \
 //thickness=0.18 //x=50.62 //y=1.545 //x2=50.735 //y2=1.545
r717 (  224 253 ) resistor r=5.52526 //w=0.168 //l=0.115 //layer=ply \
 //thickness=0.18 //x=50.4 //y=0.89 //x2=50.285 //y2=0.89
r718 (  223 258 ) resistor r=5.52526 //w=0.168 //l=0.115 //layer=ply \
 //thickness=0.18 //x=50.62 //y=0.89 //x2=50.735 //y2=0.89
r719 (  223 224 ) resistor r=112.809 //w=0.094 //l=0.22 //layer=ply \
 //thickness=0.18 //x=50.62 //y=0.89 //x2=50.4 //y2=0.89
r720 (  220 255 ) resistor r=13.0941 //w=0.233 //l=0.165 //layer=ply \
 //thickness=0.18 //x=50.34 //y=5.045 //x2=50.34 //y2=4.88
r721 (  219 252 ) resistor r=34.8111 //w=0.27 //l=0.264953 //layer=ply \
 //thickness=0.18 //x=50.245 //y=2.095 //x2=50.44 //y2=2.26
r722 (  218 254 ) resistor r=39.5823 //w=0.21 //l=0.173853 //layer=ply \
 //thickness=0.18 //x=50.245 //y=1.7 //x2=50.285 //y2=1.545
r723 (  218 219 ) resistor r=202.543 //w=0.094 //l=0.395 //layer=ply \
 //thickness=0.18 //x=50.245 //y=1.7 //x2=50.245 //y2=2.095
r724 (  217 254 ) resistor r=39.5823 //w=0.21 //l=0.173853 //layer=ply \
 //thickness=0.18 //x=50.245 //y=1.39 //x2=50.285 //y2=1.545
r725 (  216 253 ) resistor r=45.1352 //w=0.168 //l=0.173853 //layer=ply \
 //thickness=0.18 //x=50.245 //y=1.045 //x2=50.285 //y2=0.89
r726 (  216 217 ) resistor r=176.904 //w=0.094 //l=0.345 //layer=ply \
 //thickness=0.18 //x=50.245 //y=1.045 //x2=50.245 //y2=1.39
r727 (  213 248 ) resistor r=70.3348 //w=0.233 //l=0.414367 //layer=ply \
 //thickness=0.18 //x=26.36 //y=5.045 //x2=26.02 //y2=4.88
r728 (  212 250 ) resistor r=45.1352 //w=0.168 //l=0.173853 //layer=ply \
 //thickness=0.18 //x=26.355 //y=1.39 //x2=26.315 //y2=1.545
r729 (  211 249 ) resistor r=45.1352 //w=0.168 //l=0.173853 //layer=ply \
 //thickness=0.18 //x=26.355 //y=1.045 //x2=26.315 //y2=0.89
r730 (  211 212 ) resistor r=176.904 //w=0.094 //l=0.345 //layer=ply \
 //thickness=0.18 //x=26.355 //y=1.045 //x2=26.355 //y2=1.39
r731 (  209 245 ) resistor r=10.701 //w=0.21 //l=0.115 //layer=ply \
 //thickness=0.18 //x=25.98 //y=1.545 //x2=25.865 //y2=1.545
r732 (  208 250 ) resistor r=5.52526 //w=0.168 //l=0.115 //layer=ply \
 //thickness=0.18 //x=26.2 //y=1.545 //x2=26.315 //y2=1.545
r733 (  207 244 ) resistor r=5.52526 //w=0.168 //l=0.115 //layer=ply \
 //thickness=0.18 //x=25.98 //y=0.89 //x2=25.865 //y2=0.89
r734 (  206 249 ) resistor r=5.52526 //w=0.168 //l=0.115 //layer=ply \
 //thickness=0.18 //x=26.2 //y=0.89 //x2=26.315 //y2=0.89
r735 (  206 207 ) resistor r=112.809 //w=0.094 //l=0.22 //layer=ply \
 //thickness=0.18 //x=26.2 //y=0.89 //x2=25.98 //y2=0.89
r736 (  203 246 ) resistor r=13.0941 //w=0.233 //l=0.165 //layer=ply \
 //thickness=0.18 //x=25.92 //y=5.045 //x2=25.92 //y2=4.88
r737 (  202 243 ) resistor r=34.8111 //w=0.27 //l=0.264953 //layer=ply \
 //thickness=0.18 //x=25.825 //y=2.095 //x2=26.02 //y2=2.26
r738 (  201 245 ) resistor r=39.5823 //w=0.21 //l=0.173853 //layer=ply \
 //thickness=0.18 //x=25.825 //y=1.7 //x2=25.865 //y2=1.545
r739 (  201 202 ) resistor r=202.543 //w=0.094 //l=0.395 //layer=ply \
 //thickness=0.18 //x=25.825 //y=1.7 //x2=25.825 //y2=2.095
r740 (  200 245 ) resistor r=39.5823 //w=0.21 //l=0.173853 //layer=ply \
 //thickness=0.18 //x=25.825 //y=1.39 //x2=25.865 //y2=1.545
r741 (  199 244 ) resistor r=45.1352 //w=0.168 //l=0.173853 //layer=ply \
 //thickness=0.18 //x=25.825 //y=1.045 //x2=25.865 //y2=0.89
r742 (  199 200 ) resistor r=176.904 //w=0.094 //l=0.345 //layer=ply \
 //thickness=0.18 //x=25.825 //y=1.045 //x2=25.825 //y2=1.39
r743 (  196 239 ) resistor r=70.3348 //w=0.233 //l=0.414367 //layer=ply \
 //thickness=0.18 //x=1.94 //y=5.045 //x2=1.6 //y2=4.88
r744 (  195 241 ) resistor r=45.1352 //w=0.168 //l=0.173853 //layer=ply \
 //thickness=0.18 //x=1.935 //y=1.39 //x2=1.895 //y2=1.545
r745 (  194 240 ) resistor r=45.1352 //w=0.168 //l=0.173853 //layer=ply \
 //thickness=0.18 //x=1.935 //y=1.045 //x2=1.895 //y2=0.89
r746 (  194 195 ) resistor r=176.904 //w=0.094 //l=0.345 //layer=ply \
 //thickness=0.18 //x=1.935 //y=1.045 //x2=1.935 //y2=1.39
r747 (  192 236 ) resistor r=10.701 //w=0.21 //l=0.115 //layer=ply \
 //thickness=0.18 //x=1.56 //y=1.545 //x2=1.445 //y2=1.545
r748 (  191 241 ) resistor r=5.52526 //w=0.168 //l=0.115 //layer=ply \
 //thickness=0.18 //x=1.78 //y=1.545 //x2=1.895 //y2=1.545
r749 (  190 235 ) resistor r=5.52526 //w=0.168 //l=0.115 //layer=ply \
 //thickness=0.18 //x=1.56 //y=0.89 //x2=1.445 //y2=0.89
r750 (  189 240 ) resistor r=5.52526 //w=0.168 //l=0.115 //layer=ply \
 //thickness=0.18 //x=1.78 //y=0.89 //x2=1.895 //y2=0.89
r751 (  189 190 ) resistor r=112.809 //w=0.094 //l=0.22 //layer=ply \
 //thickness=0.18 //x=1.78 //y=0.89 //x2=1.56 //y2=0.89
r752 (  186 237 ) resistor r=13.0941 //w=0.233 //l=0.165 //layer=ply \
 //thickness=0.18 //x=1.5 //y=5.045 //x2=1.5 //y2=4.88
r753 (  185 234 ) resistor r=34.8111 //w=0.27 //l=0.264953 //layer=ply \
 //thickness=0.18 //x=1.405 //y=2.095 //x2=1.6 //y2=2.26
r754 (  184 236 ) resistor r=39.5823 //w=0.21 //l=0.173853 //layer=ply \
 //thickness=0.18 //x=1.405 //y=1.7 //x2=1.445 //y2=1.545
r755 (  184 185 ) resistor r=202.543 //w=0.094 //l=0.395 //layer=ply \
 //thickness=0.18 //x=1.405 //y=1.7 //x2=1.405 //y2=2.095
r756 (  183 236 ) resistor r=39.5823 //w=0.21 //l=0.173853 //layer=ply \
 //thickness=0.18 //x=1.405 //y=1.39 //x2=1.445 //y2=1.545
r757 (  182 235 ) resistor r=45.1352 //w=0.168 //l=0.173853 //layer=ply \
 //thickness=0.18 //x=1.405 //y=1.045 //x2=1.445 //y2=0.89
r758 (  182 183 ) resistor r=176.904 //w=0.094 //l=0.345 //layer=ply \
 //thickness=0.18 //x=1.405 //y=1.045 //x2=1.405 //y2=1.39
r759 (  181 230 ) resistor r=592.245 //w=0.094 //l=1.155 //layer=ply \
 //thickness=0.18 //x=50.78 //y=6.2 //x2=50.78 //y2=5.045
r760 (  180 220 ) resistor r=592.245 //w=0.094 //l=1.155 //layer=ply \
 //thickness=0.18 //x=50.34 //y=6.2 //x2=50.34 //y2=5.045
r761 (  179 213 ) resistor r=592.245 //w=0.094 //l=1.155 //layer=ply \
 //thickness=0.18 //x=26.36 //y=6.2 //x2=26.36 //y2=5.045
r762 (  178 203 ) resistor r=592.245 //w=0.094 //l=1.155 //layer=ply \
 //thickness=0.18 //x=25.92 //y=6.2 //x2=25.92 //y2=5.045
r763 (  177 196 ) resistor r=592.245 //w=0.094 //l=1.155 //layer=ply \
 //thickness=0.18 //x=1.94 //y=6.2 //x2=1.94 //y2=5.045
r764 (  176 186 ) resistor r=592.245 //w=0.094 //l=1.155 //layer=ply \
 //thickness=0.18 //x=1.5 //y=6.2 //x2=1.5 //y2=5.045
r765 (  175 225 ) resistor r=56.4043 //w=0.094 //l=0.11 //layer=ply \
 //thickness=0.18 //x=50.51 //y=1.545 //x2=50.62 //y2=1.545
r766 (  175 226 ) resistor r=56.4043 //w=0.094 //l=0.11 //layer=ply \
 //thickness=0.18 //x=50.51 //y=1.545 //x2=50.4 //y2=1.545
r767 (  174 208 ) resistor r=56.4043 //w=0.094 //l=0.11 //layer=ply \
 //thickness=0.18 //x=26.09 //y=1.545 //x2=26.2 //y2=1.545
r768 (  174 209 ) resistor r=56.4043 //w=0.094 //l=0.11 //layer=ply \
 //thickness=0.18 //x=26.09 //y=1.545 //x2=25.98 //y2=1.545
r769 (  173 191 ) resistor r=56.4043 //w=0.094 //l=0.11 //layer=ply \
 //thickness=0.18 //x=1.67 //y=1.545 //x2=1.78 //y2=1.545
r770 (  173 192 ) resistor r=56.4043 //w=0.094 //l=0.11 //layer=ply \
 //thickness=0.18 //x=1.67 //y=1.545 //x2=1.56 //y2=1.545
r771 (  169 257 ) resistor r=152 //w=0.17 //l=0.17 //layer=licon //count=1 \
 //x=50.44 //y=4.88 //x2=50.44 //y2=4.88
r772 (  160 252 ) resistor r=152 //w=0.17 //l=0.17 //layer=licon //count=1 \
 //x=50.44 //y=2.26 //x2=50.44 //y2=2.26
r773 (  155 248 ) resistor r=152 //w=0.17 //l=0.17 //layer=licon //count=1 \
 //x=26.02 //y=4.88 //x2=26.02 //y2=4.88
r774 (  146 243 ) resistor r=152 //w=0.17 //l=0.17 //layer=licon //count=1 \
 //x=26.02 //y=2.26 //x2=26.02 //y2=2.26
r775 (  141 239 ) resistor r=152 //w=0.17 //l=0.17 //layer=licon //count=1 \
 //x=1.6 //y=4.88 //x2=1.6 //y2=4.88
r776 (  132 234 ) resistor r=152 //w=0.17 //l=0.17 //layer=licon //count=1 \
 //x=1.6 //y=2.26 //x2=1.6 //y2=2.26
r777 (  124 126 ) resistor r=0.10734 //w=0.281 //l=0.16 //layer=m2 \
 //thickness=0.36 //x=1.605 //y=3.145 //x2=1.765 //y2=3.145
r778 (  121 130 ) resistor r=1.03696 //w=0.197 //l=1.63748 //layer=m2 \
 //thickness=0.36 //x=48.8 //y=3.17 //x2=50.43 //y2=3.155
r779 (  121 122 ) resistor r=0.329198 //w=0.131 //l=0.345 //layer=m2 \
 //thickness=0.36 //x=48.8 //y=3.17 //x2=48.455 //y2=3.17
r780 (  119 122 ) resistor r=0.1875 //w=0.17 //l=0.269583 //layer=m2 \
 //thickness=0.36 //x=48.2 //y=3.14 //x2=48.455 //y2=3.17
r781 (  119 120 ) resistor r=2.08492 //w=0.131 //l=2.185 //layer=m2 \
 //thickness=0.36 //x=48.2 //y=3.14 //x2=46.015 //y2=3.14
r782 (  117 120 ) resistor r=0.125 //w=0.17 //l=0.184391 //layer=m2 \
 //thickness=0.36 //x=45.845 //y=3.17 //x2=46.015 //y2=3.14
r783 (  117 118 ) resistor r=0.329198 //w=0.131 //l=0.345 //layer=m2 \
 //thickness=0.36 //x=45.845 //y=3.17 //x2=45.5 //y2=3.17
r784 (  115 118 ) resistor r=0.1875 //w=0.17 //l=0.269583 //layer=m2 \
 //thickness=0.36 //x=45.245 //y=3.14 //x2=45.5 //y2=3.17
r785 (  115 116 ) resistor r=1.03531 //w=0.131 //l=1.085 //layer=m2 \
 //thickness=0.36 //x=45.245 //y=3.14 //x2=44.16 //y2=3.14
r786 (  113 116 ) resistor r=0.125 //w=0.17 //l=0.184391 //layer=m2 \
 //thickness=0.36 //x=43.99 //y=3.17 //x2=44.16 //y2=3.14
r787 (  113 114 ) resistor r=0.329198 //w=0.131 //l=0.345 //layer=m2 \
 //thickness=0.36 //x=43.99 //y=3.17 //x2=43.645 //y2=3.17
r788 (  111 114 ) resistor r=0.1875 //w=0.17 //l=0.269583 //layer=m2 \
 //thickness=0.36 //x=43.39 //y=3.14 //x2=43.645 //y2=3.17
r789 (  111 112 ) resistor r=3.85496 //w=0.131 //l=4.04 //layer=m2 \
 //thickness=0.36 //x=43.39 //y=3.14 //x2=39.35 //y2=3.14
r790 (  109 112 ) resistor r=0.125 //w=0.17 //l=0.184391 //layer=m2 \
 //thickness=0.36 //x=39.18 //y=3.17 //x2=39.35 //y2=3.14
r791 (  109 110 ) resistor r=0.329198 //w=0.131 //l=0.345 //layer=m2 \
 //thickness=0.36 //x=39.18 //y=3.17 //x2=38.835 //y2=3.17
r792 (  107 110 ) resistor r=0.1875 //w=0.17 //l=0.269583 //layer=m2 \
 //thickness=0.36 //x=38.58 //y=3.14 //x2=38.835 //y2=3.17
r793 (  107 108 ) resistor r=1.02576 //w=0.131 //l=1.075 //layer=m2 \
 //thickness=0.36 //x=38.58 //y=3.14 //x2=37.505 //y2=3.14
r794 (  105 108 ) resistor r=0.125 //w=0.17 //l=0.184391 //layer=m2 \
 //thickness=0.36 //x=37.335 //y=3.17 //x2=37.505 //y2=3.14
r795 (  105 106 ) resistor r=0.329198 //w=0.131 //l=0.345 //layer=m2 \
 //thickness=0.36 //x=37.335 //y=3.17 //x2=36.99 //y2=3.17
r796 (  103 106 ) resistor r=0.1875 //w=0.17 //l=0.269583 //layer=m2 \
 //thickness=0.36 //x=36.735 //y=3.14 //x2=36.99 //y2=3.17
r797 (  103 104 ) resistor r=2.08969 //w=0.131 //l=2.19 //layer=m2 \
 //thickness=0.36 //x=36.735 //y=3.14 //x2=34.545 //y2=3.14
r798 (  101 104 ) resistor r=0.125 //w=0.17 //l=0.179722 //layer=m2 \
 //thickness=0.36 //x=34.375 //y=3.16 //x2=34.545 //y2=3.14
r799 (  101 102 ) resistor r=0.329198 //w=0.131 //l=0.345 //layer=m2 \
 //thickness=0.36 //x=34.375 //y=3.16 //x2=34.03 //y2=3.16
r800 (  99 102 ) resistor r=0.1875 //w=0.17 //l=0.264811 //layer=m2 \
 //thickness=0.36 //x=33.775 //y=3.14 //x2=34.03 //y2=3.16
r801 (  99 100 ) resistor r=3.85496 //w=0.131 //l=4.04 //layer=m2 \
 //thickness=0.36 //x=33.775 //y=3.14 //x2=29.735 //y2=3.14
r802 (  97 100 ) resistor r=0.125 //w=0.17 //l=0.177341 //layer=m2 \
 //thickness=0.36 //x=29.565 //y=3.155 //x2=29.735 //y2=3.14
r803 (  97 98 ) resistor r=0.329198 //w=0.131 //l=0.345 //layer=m2 \
 //thickness=0.36 //x=29.565 //y=3.155 //x2=29.22 //y2=3.155
r804 (  95 98 ) resistor r=0.1875 //w=0.17 //l=0.262393 //layer=m2 \
 //thickness=0.36 //x=28.965 //y=3.14 //x2=29.22 //y2=3.155
r805 (  95 96 ) resistor r=1.03053 //w=0.131 //l=1.08 //layer=m2 \
 //thickness=0.36 //x=28.965 //y=3.14 //x2=27.885 //y2=3.14
r806 (  94 128 ) resistor r=0.955256 //w=0.176 //l=1.36239 //layer=m2 \
 //thickness=0.36 //x=27.37 //y=3.155 //x2=26.025 //y2=3.12
r807 (  93 96 ) resistor r=0.125 //w=0.17 //l=0.177341 //layer=m2 \
 //thickness=0.36 //x=27.715 //y=3.155 //x2=27.885 //y2=3.14
r808 (  93 94 ) resistor r=0.329198 //w=0.131 //l=0.345 //layer=m2 \
 //thickness=0.36 //x=27.715 //y=3.155 //x2=27.37 //y2=3.155
r809 (  91 128 ) resistor r=5.10653 //w=0.176 //l=7.195 //layer=m2 \
 //thickness=0.36 //x=18.835 //y=3.11 //x2=26.025 //y2=3.12
r810 (  91 92 ) resistor r=0.410305 //w=0.131 //l=0.43 //layer=m2 \
 //thickness=0.36 //x=18.835 //y=3.11 //x2=18.405 //y2=3.11
r811 (  89 92 ) resistor r=0.125 //w=0.17 //l=0.184391 //layer=m2 \
 //thickness=0.36 //x=18.235 //y=3.14 //x2=18.405 //y2=3.11
r812 (  89 90 ) resistor r=3.15363 //w=0.131 //l=3.305 //layer=m2 \
 //thickness=0.36 //x=18.235 //y=3.14 //x2=14.93 //y2=3.14
r813 (  87 90 ) resistor r=0.125 //w=0.17 //l=0.184391 //layer=m2 \
 //thickness=0.36 //x=14.76 //y=3.17 //x2=14.93 //y2=3.14
r814 (  87 88 ) resistor r=0.329198 //w=0.131 //l=0.345 //layer=m2 \
 //thickness=0.36 //x=14.76 //y=3.17 //x2=14.415 //y2=3.17
r815 (  85 88 ) resistor r=0.1875 //w=0.17 //l=0.269583 //layer=m2 \
 //thickness=0.36 //x=14.16 //y=3.14 //x2=14.415 //y2=3.17
r816 (  85 86 ) resistor r=1.02576 //w=0.131 //l=1.075 //layer=m2 \
 //thickness=0.36 //x=14.16 //y=3.14 //x2=13.085 //y2=3.14
r817 (  83 86 ) resistor r=0.125 //w=0.17 //l=0.184391 //layer=m2 \
 //thickness=0.36 //x=12.915 //y=3.17 //x2=13.085 //y2=3.14
r818 (  83 84 ) resistor r=0.329198 //w=0.131 //l=0.345 //layer=m2 \
 //thickness=0.36 //x=12.915 //y=3.17 //x2=12.57 //y2=3.17
r819 (  81 84 ) resistor r=0.1875 //w=0.17 //l=0.269583 //layer=m2 \
 //thickness=0.36 //x=12.315 //y=3.14 //x2=12.57 //y2=3.17
r820 (  81 82 ) resistor r=2.08969 //w=0.131 //l=2.19 //layer=m2 \
 //thickness=0.36 //x=12.315 //y=3.14 //x2=10.125 //y2=3.14
r821 (  79 82 ) resistor r=0.125 //w=0.17 //l=0.179722 //layer=m2 \
 //thickness=0.36 //x=9.955 //y=3.16 //x2=10.125 //y2=3.14
r822 (  79 80 ) resistor r=0.329198 //w=0.131 //l=0.345 //layer=m2 \
 //thickness=0.36 //x=9.955 //y=3.16 //x2=9.61 //y2=3.16
r823 (  77 80 ) resistor r=0.1875 //w=0.17 //l=0.264811 //layer=m2 \
 //thickness=0.36 //x=9.355 //y=3.14 //x2=9.61 //y2=3.16
r824 (  77 78 ) resistor r=3.85496 //w=0.131 //l=4.04 //layer=m2 \
 //thickness=0.36 //x=9.355 //y=3.14 //x2=5.315 //y2=3.14
r825 (  75 78 ) resistor r=0.125 //w=0.17 //l=0.177341 //layer=m2 \
 //thickness=0.36 //x=5.145 //y=3.155 //x2=5.315 //y2=3.14
r826 (  75 76 ) resistor r=0.329198 //w=0.131 //l=0.345 //layer=m2 \
 //thickness=0.36 //x=5.145 //y=3.155 //x2=4.8 //y2=3.155
r827 (  73 76 ) resistor r=0.1875 //w=0.17 //l=0.262393 //layer=m2 \
 //thickness=0.36 //x=4.545 //y=3.14 //x2=4.8 //y2=3.155
r828 (  73 74 ) resistor r=1.03053 //w=0.131 //l=1.08 //layer=m2 \
 //thickness=0.36 //x=4.545 //y=3.14 //x2=3.465 //y2=3.14
r829 (  71 74 ) resistor r=0.125 //w=0.17 //l=0.177341 //layer=m2 \
 //thickness=0.36 //x=3.295 //y=3.155 //x2=3.465 //y2=3.14
r830 (  71 72 ) resistor r=0.329198 //w=0.131 //l=0.345 //layer=m2 \
 //thickness=0.36 //x=3.295 //y=3.155 //x2=2.95 //y2=3.155
r831 (  69 72 ) resistor r=0.1875 //w=0.17 //l=0.262393 //layer=m2 \
 //thickness=0.36 //x=2.695 //y=3.14 //x2=2.95 //y2=3.155
r832 (  69 126 ) resistor r=0.887405 //w=0.131 //l=0.93 //layer=m2 \
 //thickness=0.36 //x=2.695 //y=3.14 //x2=1.765 //y2=3.14
r833 (  66 169 ) resistor r=9.3 //w=0.17 //l=0.17 //layer=mcon //count=1 \
 //x=50.44 //y=4.88 //x2=50.44 //y2=4.88
r834 (  66 67 ) resistor r=0.103207 //w=0.196 //l=0.14 //layer=m1 \
 //thickness=0.36 //x=50.442 //y=4.88 //x2=50.442 //y2=4.74
r835 (  63 160 ) resistor r=9.3 //w=0.17 //l=0.17 //layer=mcon //count=1 \
 //x=50.44 //y=2.26 //x2=50.44 //y2=2.26
r836 (  61 130 ) resistor r=4.5 //w=0.15 //l=0.15 //layer=via1 //count=1 \
 //x=50.43 //y=3.155 //x2=50.43 //y2=3.155
r837 (  55 128 ) resistor r=4.5 //w=0.15 //l=0.15 //layer=via1 //count=1 \
 //x=26.025 //y=3.12 //x2=26.025 //y2=3.12
r838 (  51 155 ) resistor r=9.3 //w=0.17 //l=0.17 //layer=mcon //count=1 \
 //x=26.02 //y=4.88 //x2=26.02 //y2=4.88
r839 (  51 52 ) resistor r=0.103207 //w=0.196 //l=0.14 //layer=m1 \
 //thickness=0.36 //x=26.022 //y=4.88 //x2=26.022 //y2=4.74
r840 (  48 146 ) resistor r=9.3 //w=0.17 //l=0.17 //layer=mcon //count=1 \
 //x=26.02 //y=2.26 //x2=26.02 //y2=2.26
r841 (  46 124 ) resistor r=4.5 //w=0.15 //l=0.15 //layer=via1 //count=1 \
 //x=1.605 //y=3.145 //x2=1.605 //y2=3.145
r842 (  40 141 ) resistor r=9.3 //w=0.17 //l=0.17 //layer=mcon //count=1 \
 //x=1.6 //y=4.88 //x2=1.6 //y2=4.88
r843 (  40 41 ) resistor r=0.103207 //w=0.196 //l=0.14 //layer=m1 \
 //thickness=0.36 //x=1.602 //y=4.88 //x2=1.602 //y2=4.74
r844 (  37 132 ) resistor r=9.3 //w=0.17 //l=0.17 //layer=mcon //count=1 \
 //x=1.6 //y=2.26 //x2=1.6 //y2=2.26
r845 (  32 61 ) resistor r=0.0909648 //w=0.371 //l=0.186762 //layer=m1 \
 //thickness=0.36 //x=50.44 //y=3.315 //x2=50.382 //y2=3.155
r846 (  30 63 ) resistor r=0.0933015 //w=0.201 //l=0.125 //layer=m1 \
 //thickness=0.36 //x=50.44 //y=2.385 //x2=50.44 //y2=2.26
r847 (  30 31 ) resistor r=0.582061 //w=0.131 //l=0.61 //layer=m1 \
 //thickness=0.36 //x=50.44 //y=2.385 //x2=50.44 //y2=2.995
r848 (  24 55 ) resistor r=0.0910802 //w=0.374 //l=0.185472 //layer=m1 \
 //thickness=0.36 //x=26.02 //y=2.96 //x2=26.075 //y2=3.12
r849 (  23 48 ) resistor r=0.0933015 //w=0.201 //l=0.125 //layer=m1 \
 //thickness=0.36 //x=26.02 //y=2.385 //x2=26.02 //y2=2.26
r850 (  17 46 ) resistor r=0.0910802 //w=0.374 //l=0.185472 //layer=m1 \
 //thickness=0.36 //x=1.6 //y=3.305 //x2=1.655 //y2=3.145
r851 (  14 37 ) resistor r=0.0933015 //w=0.201 //l=0.125 //layer=m1 \
 //thickness=0.36 //x=1.6 //y=2.385 //x2=1.6 //y2=2.26
r852 (  13 61 ) resistor r=0.00505391 //w=0.371 //l=0.015 //layer=m1 \
 //thickness=0.36 //x=50.382 //y=3.14 //x2=50.382 //y2=3.155
r853 (  13 31 ) resistor r=0.0859108 //w=0.371 //l=0.171566 //layer=m1 \
 //thickness=0.36 //x=50.382 //y=3.14 //x2=50.44 //y2=2.995
r854 (  12 26 ) resistor r=0.0843957 //w=0.374 //l=0.165227 //layer=m1 \
 //thickness=0.36 //x=26.075 //y=3.14 //x2=26.02 //y2=3.28
r855 (  12 55 ) resistor r=0.00668449 //w=0.374 //l=0.02 //layer=m1 \
 //thickness=0.36 //x=26.075 //y=3.14 //x2=26.075 //y2=3.12
r856 (  11 46 ) resistor r=0.00167112 //w=0.374 //l=0.005 //layer=m1 \
 //thickness=0.36 //x=1.655 //y=3.14 //x2=1.655 //y2=3.145
r857 (  11 15 ) resistor r=0.089409 //w=0.374 //l=0.180416 //layer=m1 \
 //thickness=0.36 //x=1.655 //y=3.14 //x2=1.6 //y2=2.985
r858 (  10 67 ) resistor r=0.467557 //w=0.131 //l=0.49 //layer=m1 \
 //thickness=0.36 //x=50.44 //y=4.25 //x2=50.44 //y2=4.74
r859 (  9 10 ) resistor r=0.353053 //w=0.131 //l=0.37 //layer=m1 \
 //thickness=0.36 //x=50.44 //y=3.88 //x2=50.44 //y2=4.25
r860 (  9 32 ) resistor r=0.539122 //w=0.131 //l=0.565 //layer=m1 \
 //thickness=0.36 //x=50.44 //y=3.88 //x2=50.44 //y2=3.315
r861 (  8 52 ) resistor r=0.467557 //w=0.131 //l=0.49 //layer=m1 \
 //thickness=0.36 //x=26.02 //y=4.25 //x2=26.02 //y2=4.74
r862 (  7 8 ) resistor r=0.353053 //w=0.131 //l=0.37 //layer=m1 \
 //thickness=0.36 //x=26.02 //y=3.88 //x2=26.02 //y2=4.25
r863 (  7 26 ) resistor r=0.572519 //w=0.131 //l=0.6 //layer=m1 \
 //thickness=0.36 //x=26.02 //y=3.88 //x2=26.02 //y2=3.28
r864 (  6 24 ) resistor r=0.181298 //w=0.131 //l=0.19 //layer=m1 \
 //thickness=0.36 //x=26.02 //y=2.77 //x2=26.02 //y2=2.96
r865 (  6 23 ) resistor r=0.367366 //w=0.131 //l=0.385 //layer=m1 \
 //thickness=0.36 //x=26.02 //y=2.77 //x2=26.02 //y2=2.385
r866 (  5 41 ) resistor r=0.114504 //w=0.131 //l=0.12 //layer=m1 \
 //thickness=0.36 //x=1.6 //y=4.62 //x2=1.6 //y2=4.74
r867 (  4 5 ) resistor r=0.353053 //w=0.131 //l=0.37 //layer=m1 \
 //thickness=0.36 //x=1.6 //y=4.25 //x2=1.6 //y2=4.62
r868 (  3 4 ) resistor r=0.353053 //w=0.131 //l=0.37 //layer=m1 \
 //thickness=0.36 //x=1.6 //y=3.88 //x2=1.6 //y2=4.25
r869 (  2 3 ) resistor r=0.353053 //w=0.131 //l=0.37 //layer=m1 \
 //thickness=0.36 //x=1.6 //y=3.51 //x2=1.6 //y2=3.88
r870 (  2 17 ) resistor r=0.195611 //w=0.131 //l=0.205 //layer=m1 \
 //thickness=0.36 //x=1.6 //y=3.51 //x2=1.6 //y2=3.305
r871 (  1 15 ) resistor r=0.205153 //w=0.131 //l=0.215 //layer=m1 \
 //thickness=0.36 //x=1.6 //y=2.77 //x2=1.6 //y2=2.985
r872 (  1 14 ) resistor r=0.367366 //w=0.131 //l=0.385 //layer=m1 \
 //thickness=0.36 //x=1.6 //y=2.77 //x2=1.6 //y2=2.385
ends PM_TMRDFFSNQX1\%D

subckt PM_TMRDFFSNQX1\%noxref_13 ( 3 8 9 11 12 14 15 16 17 18 19 20 21 22 23 \
 24 27 28 31 33 36 43 47 54 55 57 64 65 68 76 93 102 107 116 120 121 122 123 \
 124 125 126 127 128 129 130 132 138 139 140 141 145 146 147 148 149 151 157 \
 158 159 160 180 182 183 )
c429 ( 180 0 ) capacitor c=0.00878249f //x=51.29 //y=1.085
c430 ( 160 0 ) capacitor c=0.0612936f //x=58.855 //y=4.97
c431 ( 159 0 ) capacitor c=0.0376642f //x=59.145 //y=4.97
c432 ( 158 0 ) capacitor c=0.0346489f //x=58.81 //y=1.4
c433 ( 157 0 ) capacitor c=0.018692f //x=58.81 //y=1.055
c434 ( 151 0 ) capacitor c=0.0137077f //x=58.655 //y=1.555
c435 ( 149 0 ) capacitor c=0.0158585f //x=58.655 //y=0.9
c436 ( 148 0 ) capacitor c=0.0979511f //x=58.28 //y=2.095
c437 ( 147 0 ) capacitor c=0.0229444f //x=58.28 //y=1.71
c438 ( 146 0 ) capacitor c=0.0234359f //x=58.28 //y=1.4
c439 ( 145 0 ) capacitor c=0.019815f //x=58.28 //y=1.055
c440 ( 141 0 ) capacitor c=0.0612936f //x=54.045 //y=4.97
c441 ( 140 0 ) capacitor c=0.0376642f //x=54.335 //y=4.97
c442 ( 139 0 ) capacitor c=0.0346489f //x=54 //y=1.4
c443 ( 138 0 ) capacitor c=0.018692f //x=54 //y=1.055
c444 ( 132 0 ) capacitor c=0.0137077f //x=53.845 //y=1.555
c445 ( 130 0 ) capacitor c=0.0158585f //x=53.845 //y=0.9
c446 ( 129 0 ) capacitor c=0.099553f //x=53.47 //y=2.095
c447 ( 128 0 ) capacitor c=0.0229444f //x=53.47 //y=1.71
c448 ( 127 0 ) capacitor c=0.0234359f //x=53.47 //y=1.4
c449 ( 126 0 ) capacitor c=0.019815f //x=53.47 //y=1.055
c450 ( 125 0 ) capacitor c=0.110208f //x=59.22 //y=6.2
c451 ( 124 0 ) capacitor c=0.158957f //x=58.78 //y=6.2
c452 ( 123 0 ) capacitor c=0.110208f //x=54.41 //y=6.2
c453 ( 122 0 ) capacitor c=0.158957f //x=53.97 //y=6.2
c454 ( 116 0 ) capacitor c=0.0014751f //x=58.58 //y=4.88
c455 ( 107 0 ) capacitor c=9.93222e-19 //x=58.58 //y=2.26
c456 ( 102 0 ) capacitor c=0.0014751f //x=53.77 //y=4.88
c457 ( 93 0 ) capacitor c=9.93222e-19 //x=53.77 //y=2.26
c458 ( 76 0 ) capacitor c=0.0322017f //x=51.44 //y=5.56
c459 ( 68 0 ) capacitor c=0.0290186f //x=50.56 //y=5.56
c460 ( 65 0 ) capacitor c=0.0398037f //x=58.42 //y=2.775
c461 ( 64 0 ) capacitor c=6.56496e-19 //x=58.58 //y=2.775
c462 ( 57 0 ) capacitor c=6.57651e-19 //x=53.93 //y=2.77
c463 ( 55 0 ) capacitor c=8.02114e-19 //x=52.08 //y=2.77
c464 ( 54 0 ) capacitor c=0.0166477f //x=53.61 //y=2.77
c465 ( 47 0 ) capacitor c=0.0154699f //x=58.58 //y=2.77
c466 ( 43 0 ) capacitor c=0.0146914f //x=53.77 //y=2.765
c467 ( 36 0 ) capacitor c=0.0148063f //x=51.92 //y=2.77
c468 ( 33 0 ) capacitor c=0.011349f //x=51.48 //y=1.18
c469 ( 31 0 ) capacitor c=5.78613e-19 //x=51.44 //y=5.56
c470 ( 28 0 ) capacitor c=0.0108509f //x=51.44 //y=5.38
c471 ( 27 0 ) capacitor c=0.00944936f //x=50.56 //y=5.56
c472 ( 24 0 ) capacitor c=0.0609582f //x=58.58 //y=4.755
c473 ( 23 0 ) capacitor c=0.0130119f //x=58.58 //y=2.935
c474 ( 22 0 ) capacitor c=0.00415551f //x=58.58 //y=2.615
c475 ( 21 0 ) capacitor c=0.00474211f //x=58.58 //y=2.375
c476 ( 20 0 ) capacitor c=0.0637246f //x=53.77 //y=4.755
c477 ( 19 0 ) capacitor c=0.0130033f //x=53.77 //y=2.93
c478 ( 18 0 ) capacitor c=0.00452361f //x=53.77 //y=2.61
c479 ( 17 0 ) capacitor c=0.00485545f //x=53.77 //y=2.375
c480 ( 16 0 ) capacitor c=0.0656382f //x=51.92 //y=5.295
c481 ( 15 0 ) capacitor c=0.0120687f //x=51.92 //y=2.93
c482 ( 14 0 ) capacitor c=0.0175872f //x=51.92 //y=2.61
c483 ( 12 0 ) capacitor c=0.0046997f //x=51.565 //y=1.835
c484 ( 11 0 ) capacitor c=0.0117163f //x=51.835 //y=1.835
c485 ( 9 0 ) capacitor c=0.011753f //x=51.835 //y=5.38
c486 ( 8 0 ) capacitor c=0.0134844f //x=51.48 //y=1.75
c487 ( 3 0 ) capacitor c=0.0144605f //x=51.325 //y=5.38
r488 (  159 161 ) resistor r=26.9307 //w=0.15 //l=0.106066 //layer=ply \
 //thickness=0.18 //x=59.145 //y=4.97 //x2=59.22 //y2=5.045
r489 (  159 160 ) resistor r=148.702 //w=0.094 //l=0.29 //layer=ply \
 //thickness=0.18 //x=59.145 //y=4.97 //x2=58.855 //y2=4.97
r490 (  158 179 ) resistor r=45.1352 //w=0.168 //l=0.173853 //layer=ply \
 //thickness=0.18 //x=58.81 //y=1.4 //x2=58.77 //y2=1.555
r491 (  157 178 ) resistor r=45.1352 //w=0.168 //l=0.173853 //layer=ply \
 //thickness=0.18 //x=58.81 //y=1.055 //x2=58.77 //y2=0.9
r492 (  157 158 ) resistor r=176.904 //w=0.094 //l=0.345 //layer=ply \
 //thickness=0.18 //x=58.81 //y=1.055 //x2=58.81 //y2=1.4
r493 (  154 160 ) resistor r=22.7971 //w=0.269 //l=0.106066 //layer=ply \
 //thickness=0.18 //x=58.78 //y=5.045 //x2=58.855 //y2=4.97
r494 (  154 177 ) resistor r=35.8364 //w=0.269 //l=0.270185 //layer=ply \
 //thickness=0.18 //x=58.78 //y=5.045 //x2=58.58 //y2=4.88
r495 (  152 173 ) resistor r=10.701 //w=0.21 //l=0.115 //layer=ply \
 //thickness=0.18 //x=58.435 //y=1.555 //x2=58.32 //y2=1.555
r496 (  151 179 ) resistor r=5.52526 //w=0.168 //l=0.115 //layer=ply \
 //thickness=0.18 //x=58.655 //y=1.555 //x2=58.77 //y2=1.555
r497 (  150 172 ) resistor r=5.52526 //w=0.168 //l=0.115 //layer=ply \
 //thickness=0.18 //x=58.435 //y=0.9 //x2=58.32 //y2=0.9
r498 (  149 178 ) resistor r=5.52526 //w=0.168 //l=0.115 //layer=ply \
 //thickness=0.18 //x=58.655 //y=0.9 //x2=58.77 //y2=0.9
r499 (  149 150 ) resistor r=112.809 //w=0.094 //l=0.22 //layer=ply \
 //thickness=0.18 //x=58.655 //y=0.9 //x2=58.435 //y2=0.9
r500 (  148 175 ) resistor r=58.7805 //w=0.246 //l=0.373497 //layer=ply \
 //thickness=0.18 //x=58.28 //y=2.095 //x2=58.58 //y2=2.26
r501 (  147 173 ) resistor r=39.5823 //w=0.21 //l=0.173853 //layer=ply \
 //thickness=0.18 //x=58.28 //y=1.71 //x2=58.32 //y2=1.555
r502 (  147 148 ) resistor r=197.415 //w=0.094 //l=0.385 //layer=ply \
 //thickness=0.18 //x=58.28 //y=1.71 //x2=58.28 //y2=2.095
r503 (  146 173 ) resistor r=39.5823 //w=0.21 //l=0.173853 //layer=ply \
 //thickness=0.18 //x=58.28 //y=1.4 //x2=58.32 //y2=1.555
r504 (  145 172 ) resistor r=45.1352 //w=0.168 //l=0.173853 //layer=ply \
 //thickness=0.18 //x=58.28 //y=1.055 //x2=58.32 //y2=0.9
r505 (  145 146 ) resistor r=176.904 //w=0.094 //l=0.345 //layer=ply \
 //thickness=0.18 //x=58.28 //y=1.055 //x2=58.28 //y2=1.4
r506 (  140 142 ) resistor r=26.9307 //w=0.15 //l=0.106066 //layer=ply \
 //thickness=0.18 //x=54.335 //y=4.97 //x2=54.41 //y2=5.045
r507 (  140 141 ) resistor r=148.702 //w=0.094 //l=0.29 //layer=ply \
 //thickness=0.18 //x=54.335 //y=4.97 //x2=54.045 //y2=4.97
r508 (  139 171 ) resistor r=45.1352 //w=0.168 //l=0.173853 //layer=ply \
 //thickness=0.18 //x=54 //y=1.4 //x2=53.96 //y2=1.555
r509 (  138 170 ) resistor r=45.1352 //w=0.168 //l=0.173853 //layer=ply \
 //thickness=0.18 //x=54 //y=1.055 //x2=53.96 //y2=0.9
r510 (  138 139 ) resistor r=176.904 //w=0.094 //l=0.345 //layer=ply \
 //thickness=0.18 //x=54 //y=1.055 //x2=54 //y2=1.4
r511 (  135 141 ) resistor r=22.7971 //w=0.269 //l=0.106066 //layer=ply \
 //thickness=0.18 //x=53.97 //y=5.045 //x2=54.045 //y2=4.97
r512 (  135 169 ) resistor r=35.8364 //w=0.269 //l=0.270185 //layer=ply \
 //thickness=0.18 //x=53.97 //y=5.045 //x2=53.77 //y2=4.88
r513 (  133 165 ) resistor r=10.701 //w=0.21 //l=0.115 //layer=ply \
 //thickness=0.18 //x=53.625 //y=1.555 //x2=53.51 //y2=1.555
r514 (  132 171 ) resistor r=5.52526 //w=0.168 //l=0.115 //layer=ply \
 //thickness=0.18 //x=53.845 //y=1.555 //x2=53.96 //y2=1.555
r515 (  131 164 ) resistor r=5.52526 //w=0.168 //l=0.115 //layer=ply \
 //thickness=0.18 //x=53.625 //y=0.9 //x2=53.51 //y2=0.9
r516 (  130 170 ) resistor r=5.52526 //w=0.168 //l=0.115 //layer=ply \
 //thickness=0.18 //x=53.845 //y=0.9 //x2=53.96 //y2=0.9
r517 (  130 131 ) resistor r=112.809 //w=0.094 //l=0.22 //layer=ply \
 //thickness=0.18 //x=53.845 //y=0.9 //x2=53.625 //y2=0.9
r518 (  129 167 ) resistor r=58.7805 //w=0.246 //l=0.373497 //layer=ply \
 //thickness=0.18 //x=53.47 //y=2.095 //x2=53.77 //y2=2.26
r519 (  128 165 ) resistor r=39.5823 //w=0.21 //l=0.173853 //layer=ply \
 //thickness=0.18 //x=53.47 //y=1.71 //x2=53.51 //y2=1.555
r520 (  128 129 ) resistor r=197.415 //w=0.094 //l=0.385 //layer=ply \
 //thickness=0.18 //x=53.47 //y=1.71 //x2=53.47 //y2=2.095
r521 (  127 165 ) resistor r=39.5823 //w=0.21 //l=0.173853 //layer=ply \
 //thickness=0.18 //x=53.47 //y=1.4 //x2=53.51 //y2=1.555
r522 (  126 164 ) resistor r=45.1352 //w=0.168 //l=0.173853 //layer=ply \
 //thickness=0.18 //x=53.47 //y=1.055 //x2=53.51 //y2=0.9
r523 (  126 127 ) resistor r=176.904 //w=0.094 //l=0.345 //layer=ply \
 //thickness=0.18 //x=53.47 //y=1.055 //x2=53.47 //y2=1.4
r524 (  125 161 ) resistor r=592.245 //w=0.094 //l=1.155 //layer=ply \
 //thickness=0.18 //x=59.22 //y=6.2 //x2=59.22 //y2=5.045
r525 (  124 154 ) resistor r=592.245 //w=0.094 //l=1.155 //layer=ply \
 //thickness=0.18 //x=58.78 //y=6.2 //x2=58.78 //y2=5.045
r526 (  123 142 ) resistor r=592.245 //w=0.094 //l=1.155 //layer=ply \
 //thickness=0.18 //x=54.41 //y=6.2 //x2=54.41 //y2=5.045
r527 (  122 135 ) resistor r=592.245 //w=0.094 //l=1.155 //layer=ply \
 //thickness=0.18 //x=53.97 //y=6.2 //x2=53.97 //y2=5.045
r528 (  121 151 ) resistor r=56.4043 //w=0.094 //l=0.11 //layer=ply \
 //thickness=0.18 //x=58.545 //y=1.555 //x2=58.655 //y2=1.555
r529 (  121 152 ) resistor r=56.4043 //w=0.094 //l=0.11 //layer=ply \
 //thickness=0.18 //x=58.545 //y=1.555 //x2=58.435 //y2=1.555
r530 (  120 132 ) resistor r=56.4043 //w=0.094 //l=0.11 //layer=ply \
 //thickness=0.18 //x=53.735 //y=1.555 //x2=53.845 //y2=1.555
r531 (  120 133 ) resistor r=56.4043 //w=0.094 //l=0.11 //layer=ply \
 //thickness=0.18 //x=53.735 //y=1.555 //x2=53.625 //y2=1.555
r532 (  116 177 ) resistor r=152 //w=0.17 //l=0.17 //layer=licon //count=1 \
 //x=58.58 //y=4.88 //x2=58.58 //y2=4.88
r533 (  107 175 ) resistor r=152 //w=0.17 //l=0.17 //layer=licon //count=1 \
 //x=58.58 //y=2.26 //x2=58.58 //y2=2.26
r534 (  102 169 ) resistor r=152 //w=0.17 //l=0.17 //layer=licon //count=1 \
 //x=53.77 //y=4.88 //x2=53.77 //y2=4.88
r535 (  93 167 ) resistor r=152 //w=0.17 //l=0.17 //layer=licon //count=1 \
 //x=53.77 //y=2.26 //x2=53.77 //y2=2.26
r536 (  76 183 ) resistor r=23.615 //w=0.187 //l=0.345 //layer=li \
 //thickness=0.1 //x=51.44 //y=5.56 //x2=51.44 //y2=5.905
r537 (  68 182 ) resistor r=23.615 //w=0.187 //l=0.345 //layer=li \
 //thickness=0.1 //x=50.56 //y=5.56 //x2=50.56 //y2=5.905
r538 (  64 65 ) resistor r=0.10734 //w=0.281 //l=0.16 //layer=m2 \
 //thickness=0.36 //x=58.58 //y=2.775 //x2=58.42 //y2=2.775
r539 (  57 62 ) resistor r=0.10734 //w=0.281 //l=0.16 //layer=m2 \
 //thickness=0.36 //x=53.93 //y=2.77 //x2=53.77 //y2=2.77
r540 (  57 65 ) resistor r=4.28435 //w=0.131 //l=4.49 //layer=m2 \
 //thickness=0.36 //x=53.93 //y=2.77 //x2=58.42 //y2=2.77
r541 (  55 59 ) resistor r=0.10734 //w=0.281 //l=0.16 //layer=m2 \
 //thickness=0.36 //x=52.08 //y=2.77 //x2=51.92 //y2=2.77
r542 (  54 62 ) resistor r=0.10734 //w=0.281 //l=0.16 //layer=m2 \
 //thickness=0.36 //x=53.61 //y=2.77 //x2=53.77 //y2=2.77
r543 (  54 55 ) resistor r=1.45992 //w=0.131 //l=1.53 //layer=m2 \
 //thickness=0.36 //x=53.61 //y=2.77 //x2=52.08 //y2=2.77
r544 (  53 116 ) resistor r=9.3 //w=0.17 //l=0.17 //layer=mcon //count=1 \
 //x=58.58 //y=4.88 //x2=58.58 //y2=4.88
r545 (  51 107 ) resistor r=9.3 //w=0.17 //l=0.17 //layer=mcon //count=1 \
 //x=58.58 //y=2.26 //x2=58.58 //y2=2.26
r546 (  49 64 ) resistor r=4.5 //w=0.15 //l=0.15 //layer=via1 //count=1 \
 //x=58.58 //y=2.775 //x2=58.58 //y2=2.775
r547 (  47 49 ) resistor r=0.00166223 //w=0.376 //l=0.005 //layer=m1 \
 //thickness=0.36 //x=58.527 //y=2.77 //x2=58.527 //y2=2.775
r548 (  45 62 ) resistor r=4.5 //w=0.15 //l=0.15 //layer=via1 //count=1 \
 //x=53.77 //y=2.77 //x2=53.77 //y2=2.77
r549 (  43 45 ) resistor r=0.00166223 //w=0.376 //l=0.005 //layer=m1 \
 //thickness=0.36 //x=53.822 //y=2.765 //x2=53.822 //y2=2.77
r550 (  41 102 ) resistor r=9.3 //w=0.17 //l=0.17 //layer=mcon //count=1 \
 //x=53.77 //y=4.88 //x2=53.77 //y2=4.88
r551 (  39 93 ) resistor r=9.3 //w=0.17 //l=0.17 //layer=mcon //count=1 \
 //x=53.77 //y=2.26 //x2=53.77 //y2=2.26
r552 (  36 59 ) resistor r=4.5 //w=0.15 //l=0.15 //layer=via1 //count=1 \
 //x=51.92 //y=2.77 //x2=51.92 //y2=2.77
r553 (  33 180 ) resistor r=9.3 //w=0.17 //l=0.17 //layer=mcon //count=1 \
 //x=51.48 //y=1.18 //x2=51.48 //y2=1.18
r554 (  31 76 ) resistor r=9.3 //w=0.17 //l=0.17 //layer=mcon //count=1 \
 //x=51.44 //y=5.56 //x2=51.44 //y2=5.56
r555 (  28 31 ) resistor r=0.117801 //w=0.191 //l=0.18 //layer=m1 \
 //thickness=0.36 //x=51.44 //y=5.38 //x2=51.44 //y2=5.56
r556 (  27 68 ) resistor r=9.3 //w=0.17 //l=0.17 //layer=mcon //count=1 \
 //x=50.56 //y=5.56 //x2=50.56 //y2=5.56
r557 (  25 27 ) resistor r=0.10274 //w=0.219 //l=0.18 //layer=m1 \
 //thickness=0.36 //x=50.56 //y=5.38 //x2=50.56 //y2=5.56
r558 (  24 53 ) resistor r=0.0760407 //w=0.238 //l=0.125 //layer=m1 \
 //thickness=0.36 //x=58.58 //y=4.755 //x2=58.58 //y2=4.88
r559 (  23 49 ) resistor r=0.0911593 //w=0.376 //l=0.184608 //layer=m1 \
 //thickness=0.36 //x=58.58 //y=2.935 //x2=58.527 //y2=2.775
r560 (  23 24 ) resistor r=1.73664 //w=0.131 //l=1.82 //layer=m1 \
 //thickness=0.36 //x=58.58 //y=2.935 //x2=58.58 //y2=4.755
r561 (  22 47 ) resistor r=0.0894971 //w=0.376 //l=0.179555 //layer=m1 \
 //thickness=0.36 //x=58.58 //y=2.615 //x2=58.527 //y2=2.77
r562 (  21 51 ) resistor r=0.0719237 //w=0.222 //l=0.115 //layer=m1 \
 //thickness=0.36 //x=58.58 //y=2.375 //x2=58.58 //y2=2.26
r563 (  21 22 ) resistor r=0.229008 //w=0.131 //l=0.24 //layer=m1 \
 //thickness=0.36 //x=58.58 //y=2.375 //x2=58.58 //y2=2.615
r564 (  20 41 ) resistor r=0.0760407 //w=0.238 //l=0.125 //layer=m1 \
 //thickness=0.36 //x=53.77 //y=4.755 //x2=53.77 //y2=4.88
r565 (  19 45 ) resistor r=0.0911593 //w=0.376 //l=0.184174 //layer=m1 \
 //thickness=0.36 //x=53.77 //y=2.93 //x2=53.822 //y2=2.77
r566 (  19 20 ) resistor r=1.74141 //w=0.131 //l=1.825 //layer=m1 \
 //thickness=0.36 //x=53.77 //y=2.93 //x2=53.77 //y2=4.755
r567 (  18 43 ) resistor r=0.0894971 //w=0.376 //l=0.179123 //layer=m1 \
 //thickness=0.36 //x=53.77 //y=2.61 //x2=53.822 //y2=2.765
r568 (  17 39 ) resistor r=0.0719237 //w=0.222 //l=0.115 //layer=m1 \
 //thickness=0.36 //x=53.77 //y=2.375 //x2=53.77 //y2=2.26
r569 (  17 18 ) resistor r=0.224237 //w=0.131 //l=0.235 //layer=m1 \
 //thickness=0.36 //x=53.77 //y=2.375 //x2=53.77 //y2=2.61
r570 (  15 36 ) resistor r=0.0911593 //w=0.376 //l=0.184174 //layer=m1 \
 //thickness=0.36 //x=51.92 //y=2.93 //x2=51.972 //y2=2.77
r571 (  15 16 ) resistor r=2.25668 //w=0.131 //l=2.365 //layer=m1 \
 //thickness=0.36 //x=51.92 //y=2.93 //x2=51.92 //y2=5.295
r572 (  14 36 ) resistor r=0.0911593 //w=0.376 //l=0.184174 //layer=m1 \
 //thickness=0.36 //x=51.92 //y=2.61 //x2=51.972 //y2=2.77
r573 (  13 14 ) resistor r=0.658397 //w=0.131 //l=0.69 //layer=m1 \
 //thickness=0.36 //x=51.92 //y=1.92 //x2=51.92 //y2=2.61
r574 (  11 13 ) resistor r=0.0698411 //w=0.17 //l=0.120208 //layer=m1 \
 //thickness=0.36 //x=51.835 //y=1.835 //x2=51.92 //y2=1.92
r575 (  11 12 ) resistor r=0.257634 //w=0.131 //l=0.27 //layer=m1 \
 //thickness=0.36 //x=51.835 //y=1.835 //x2=51.565 //y2=1.835
r576 (  10 28 ) resistor r=0.0257089 //w=0.23 //l=0.115 //layer=m1 \
 //thickness=0.36 //x=51.555 //y=5.38 //x2=51.44 //y2=5.38
r577 (  9 16 ) resistor r=0.0698411 //w=0.17 //l=0.120208 //layer=m1 \
 //thickness=0.36 //x=51.835 //y=5.38 //x2=51.92 //y2=5.295
r578 (  9 10 ) resistor r=0.267176 //w=0.131 //l=0.28 //layer=m1 \
 //thickness=0.36 //x=51.835 //y=5.38 //x2=51.555 //y2=5.38
r579 (  8 12 ) resistor r=0.0698411 //w=0.17 //l=0.120208 //layer=m1 \
 //thickness=0.36 //x=51.48 //y=1.75 //x2=51.565 //y2=1.835
r580 (  7 33 ) resistor r=0.0913624 //w=0.191 //l=0.12 //layer=m1 \
 //thickness=0.36 //x=51.48 //y=1.3 //x2=51.48 //y2=1.18
r581 (  7 8 ) resistor r=0.429389 //w=0.131 //l=0.45 //layer=m1 \
 //thickness=0.36 //x=51.48 //y=1.3 //x2=51.48 //y2=1.75
r582 (  4 25 ) resistor r=0.0227762 //w=0.219 //l=0.115 //layer=m1 \
 //thickness=0.36 //x=50.675 //y=5.38 //x2=50.56 //y2=5.38
r583 (  3 28 ) resistor r=0.0257089 //w=0.23 //l=0.115 //layer=m1 \
 //thickness=0.36 //x=51.325 //y=5.38 //x2=51.44 //y2=5.38
r584 (  3 4 ) resistor r=0.620229 //w=0.131 //l=0.65 //layer=m1 \
 //thickness=0.36 //x=51.325 //y=5.38 //x2=50.675 //y2=5.38
ends PM_TMRDFFSNQX1\%noxref_13

subckt PM_TMRDFFSNQX1\%noxref_14 ( 1 3 6 7 9 10 11 12 14 15 16 18 19 21 24 27 \
 33 37 41 44 45 52 54 55 58 66 74 91 100 104 105 106 107 108 109 110 114 116 \
 119 120 130 133 135 136 137 )
c300 ( 133 0 ) capacitor c=0.00885916f //x=60.865 //y=1.095
c301 ( 130 0 ) capacitor c=0.0682508f //x=63.39 //y=4.88
c302 ( 120 0 ) capacitor c=0.0318956f //x=63.725 //y=1.39
c303 ( 119 0 ) capacitor c=0.0186809f //x=63.725 //y=1.045
c304 ( 116 0 ) capacitor c=0.0141821f //x=63.57 //y=1.545
c305 ( 114 0 ) capacitor c=0.0158553f //x=63.57 //y=0.89
c306 ( 110 0 ) capacitor c=0.0815114f //x=63.195 //y=2.095
c307 ( 109 0 ) capacitor c=0.0229235f //x=63.195 //y=1.7
c308 ( 108 0 ) capacitor c=0.0234359f //x=63.195 //y=1.39
c309 ( 107 0 ) capacitor c=0.0198759f //x=63.195 //y=1.045
c310 ( 106 0 ) capacitor c=0.110369f //x=63.73 //y=6.2
c311 ( 105 0 ) capacitor c=0.154619f //x=63.29 //y=6.2
c312 ( 100 0 ) capacitor c=8.13425e-19 //x=63.39 //y=4.88
c313 ( 91 0 ) capacitor c=5.17312e-19 //x=63.39 //y=2.26
c314 ( 74 0 ) capacitor c=0.0293219f //x=60.76 //y=5.56
c315 ( 66 0 ) capacitor c=0.029137f //x=59.88 //y=5.56
c316 ( 58 0 ) capacitor c=0.0278099f //x=59 //y=5.56
c317 ( 55 0 ) capacitor c=0.0156383f //x=63.225 //y=2.785
c318 ( 54 0 ) capacitor c=6.75833e-19 //x=63.385 //y=2.785
c319 ( 52 0 ) capacitor c=9.41304e-19 //x=61.7 //y=2.785
c320 ( 45 0 ) capacitor c=0.048855f //x=63.392 //y=4.74
c321 ( 44 0 ) capacitor c=0.00631721f //x=63.39 //y=4.88
c322 ( 41 0 ) capacitor c=0.00463527f //x=63.39 //y=2.26
c323 ( 37 0 ) capacitor c=0.0145985f //x=63.39 //y=2.77
c324 ( 33 0 ) capacitor c=0.0149529f //x=61.54 //y=2.77
c325 ( 27 0 ) capacitor c=8.88597e-19 //x=60.76 //y=5.335
c326 ( 24 0 ) capacitor c=0.00796615f //x=59.88 //y=5.335
c327 ( 21 0 ) capacitor c=0.0111234f //x=59.002 //y=5.335
c328 ( 19 0 ) capacitor c=0.0120345f //x=63.39 //y=2.945
c329 ( 18 0 ) capacitor c=0.00384658f //x=63.39 //y=2.625
c330 ( 16 0 ) capacitor c=0.0631071f //x=61.54 //y=5.25
c331 ( 15 0 ) capacitor c=0.0123676f //x=61.54 //y=2.945
c332 ( 14 0 ) capacitor c=0.0168574f //x=61.54 //y=2.625
c333 ( 12 0 ) capacitor c=0.00493487f //x=61.14 //y=1.845
c334 ( 11 0 ) capacitor c=0.0126211f //x=61.455 //y=1.845
c335 ( 10 0 ) capacitor c=0.0136149f //x=61.055 //y=1.76
c336 ( 9 0 ) capacitor c=0.0113786f //x=61.055 //y=1.305
c337 ( 7 0 ) capacitor c=0.0235567f //x=61.455 //y=5.335
c338 ( 6 0 ) capacitor c=0.00906713f //x=60.76 //y=5.56
c339 ( 3 0 ) capacitor c=0.0180822f //x=60.645 //y=5.335
c340 ( 1 0 ) capacitor c=0.0152149f //x=59.76 //y=5.335
r341 (  128 130 ) resistor r=20.6867 //w=0.233 //l=0.1 //layer=ply \
 //thickness=0.18 //x=63.29 //y=4.88 //x2=63.39 //y2=4.88
r342 (  121 130 ) resistor r=70.3348 //w=0.233 //l=0.414367 //layer=ply \
 //thickness=0.18 //x=63.73 //y=5.045 //x2=63.39 //y2=4.88
r343 (  120 132 ) resistor r=45.1352 //w=0.168 //l=0.173853 //layer=ply \
 //thickness=0.18 //x=63.725 //y=1.39 //x2=63.685 //y2=1.545
r344 (  119 131 ) resistor r=45.1352 //w=0.168 //l=0.173853 //layer=ply \
 //thickness=0.18 //x=63.725 //y=1.045 //x2=63.685 //y2=0.89
r345 (  119 120 ) resistor r=176.904 //w=0.094 //l=0.345 //layer=ply \
 //thickness=0.18 //x=63.725 //y=1.045 //x2=63.725 //y2=1.39
r346 (  117 127 ) resistor r=10.701 //w=0.21 //l=0.115 //layer=ply \
 //thickness=0.18 //x=63.35 //y=1.545 //x2=63.235 //y2=1.545
r347 (  116 132 ) resistor r=5.52526 //w=0.168 //l=0.115 //layer=ply \
 //thickness=0.18 //x=63.57 //y=1.545 //x2=63.685 //y2=1.545
r348 (  115 126 ) resistor r=5.52526 //w=0.168 //l=0.115 //layer=ply \
 //thickness=0.18 //x=63.35 //y=0.89 //x2=63.235 //y2=0.89
r349 (  114 131 ) resistor r=5.52526 //w=0.168 //l=0.115 //layer=ply \
 //thickness=0.18 //x=63.57 //y=0.89 //x2=63.685 //y2=0.89
r350 (  114 115 ) resistor r=112.809 //w=0.094 //l=0.22 //layer=ply \
 //thickness=0.18 //x=63.57 //y=0.89 //x2=63.35 //y2=0.89
r351 (  111 128 ) resistor r=13.0941 //w=0.233 //l=0.165 //layer=ply \
 //thickness=0.18 //x=63.29 //y=5.045 //x2=63.29 //y2=4.88
r352 (  110 125 ) resistor r=34.8111 //w=0.27 //l=0.264953 //layer=ply \
 //thickness=0.18 //x=63.195 //y=2.095 //x2=63.39 //y2=2.26
r353 (  109 127 ) resistor r=39.5823 //w=0.21 //l=0.173853 //layer=ply \
 //thickness=0.18 //x=63.195 //y=1.7 //x2=63.235 //y2=1.545
r354 (  109 110 ) resistor r=202.543 //w=0.094 //l=0.395 //layer=ply \
 //thickness=0.18 //x=63.195 //y=1.7 //x2=63.195 //y2=2.095
r355 (  108 127 ) resistor r=39.5823 //w=0.21 //l=0.173853 //layer=ply \
 //thickness=0.18 //x=63.195 //y=1.39 //x2=63.235 //y2=1.545
r356 (  107 126 ) resistor r=45.1352 //w=0.168 //l=0.173853 //layer=ply \
 //thickness=0.18 //x=63.195 //y=1.045 //x2=63.235 //y2=0.89
r357 (  107 108 ) resistor r=176.904 //w=0.094 //l=0.345 //layer=ply \
 //thickness=0.18 //x=63.195 //y=1.045 //x2=63.195 //y2=1.39
r358 (  106 121 ) resistor r=592.245 //w=0.094 //l=1.155 //layer=ply \
 //thickness=0.18 //x=63.73 //y=6.2 //x2=63.73 //y2=5.045
r359 (  105 111 ) resistor r=592.245 //w=0.094 //l=1.155 //layer=ply \
 //thickness=0.18 //x=63.29 //y=6.2 //x2=63.29 //y2=5.045
r360 (  104 116 ) resistor r=56.4043 //w=0.094 //l=0.11 //layer=ply \
 //thickness=0.18 //x=63.46 //y=1.545 //x2=63.57 //y2=1.545
r361 (  104 117 ) resistor r=56.4043 //w=0.094 //l=0.11 //layer=ply \
 //thickness=0.18 //x=63.46 //y=1.545 //x2=63.35 //y2=1.545
r362 (  100 130 ) resistor r=152 //w=0.17 //l=0.17 //layer=licon //count=1 \
 //x=63.39 //y=4.88 //x2=63.39 //y2=4.88
r363 (  91 125 ) resistor r=152 //w=0.17 //l=0.17 //layer=licon //count=1 \
 //x=63.39 //y=2.26 //x2=63.39 //y2=2.26
r364 (  74 137 ) resistor r=23.615 //w=0.187 //l=0.345 //layer=li \
 //thickness=0.1 //x=60.76 //y=5.56 //x2=60.76 //y2=5.905
r365 (  66 136 ) resistor r=23.615 //w=0.187 //l=0.345 //layer=li \
 //thickness=0.1 //x=59.88 //y=5.56 //x2=59.88 //y2=5.905
r366 (  58 135 ) resistor r=23.615 //w=0.187 //l=0.345 //layer=li \
 //thickness=0.1 //x=59 //y=5.56 //x2=59 //y2=5.905
r367 (  54 55 ) resistor r=0.10734 //w=0.281 //l=0.16 //layer=m2 \
 //thickness=0.36 //x=63.385 //y=2.785 //x2=63.225 //y2=2.785
r368 (  52 55 ) resistor r=1.45515 //w=0.131 //l=1.525 //layer=m2 \
 //thickness=0.36 //x=61.7 //y=2.77 //x2=63.225 //y2=2.77
r369 (  50 52 ) resistor r=0.10734 //w=0.281 //l=0.16 //layer=m2 \
 //thickness=0.36 //x=61.54 //y=2.785 //x2=61.7 //y2=2.785
r370 (  44 100 ) resistor r=9.3 //w=0.17 //l=0.17 //layer=mcon //count=1 \
 //x=63.39 //y=4.88 //x2=63.39 //y2=4.88
r371 (  44 45 ) resistor r=0.103207 //w=0.196 //l=0.14 //layer=m1 \
 //thickness=0.36 //x=63.392 //y=4.88 //x2=63.392 //y2=4.74
r372 (  41 91 ) resistor r=9.3 //w=0.17 //l=0.17 //layer=mcon //count=1 \
 //x=63.39 //y=2.26 //x2=63.39 //y2=2.26
r373 (  39 54 ) resistor r=4.5 //w=0.15 //l=0.15 //layer=via1 //count=1 \
 //x=63.385 //y=2.785 //x2=63.385 //y2=2.785
r374 (  37 39 ) resistor r=0.00501337 //w=0.374 //l=0.015 //layer=m1 \
 //thickness=0.36 //x=63.335 //y=2.77 //x2=63.335 //y2=2.785
r375 (  35 50 ) resistor r=4.5 //w=0.15 //l=0.15 //layer=via1 //count=1 \
 //x=61.54 //y=2.785 //x2=61.54 //y2=2.785
r376 (  33 35 ) resistor r=0.0049867 //w=0.376 //l=0.015 //layer=m1 \
 //thickness=0.36 //x=61.592 //y=2.77 //x2=61.592 //y2=2.785
r377 (  31 133 ) resistor r=9.3 //w=0.17 //l=0.17 //layer=mcon //count=1 \
 //x=61.055 //y=1.19 //x2=61.055 //y2=1.19
r378 (  29 74 ) resistor r=9.3 //w=0.17 //l=0.17 //layer=mcon //count=1 \
 //x=60.76 //y=5.56 //x2=60.76 //y2=5.56
r379 (  26 66 ) resistor r=9.3 //w=0.17 //l=0.17 //layer=mcon //count=1 \
 //x=59.88 //y=5.56 //x2=59.88 //y2=5.56
r380 (  24 26 ) resistor r=0.121228 //w=0.232 //l=0.225 //layer=m1 \
 //thickness=0.36 //x=59.88 //y=5.335 //x2=59.88 //y2=5.56
r381 (  23 58 ) resistor r=9.3 //w=0.17 //l=0.17 //layer=mcon //count=1 //x=59 \
 //y=5.56 //x2=59 //y2=5.56
r382 (  21 23 ) resistor r=0.129608 //w=0.217 //l=0.225 //layer=m1 \
 //thickness=0.36 //x=59.002 //y=5.335 //x2=59.002 //y2=5.56
r383 (  19 39 ) resistor r=0.0910802 //w=0.374 //l=0.185472 //layer=m1 \
 //thickness=0.36 //x=63.39 //y=2.945 //x2=63.335 //y2=2.785
r384 (  19 45 ) resistor r=1.71279 //w=0.131 //l=1.795 //layer=m1 \
 //thickness=0.36 //x=63.39 //y=2.945 //x2=63.39 //y2=4.74
r385 (  18 37 ) resistor r=0.0860668 //w=0.374 //l=0.170294 //layer=m1 \
 //thickness=0.36 //x=63.39 //y=2.625 //x2=63.335 //y2=2.77
r386 (  17 41 ) resistor r=0.0933015 //w=0.201 //l=0.125 //layer=m1 \
 //thickness=0.36 //x=63.39 //y=2.385 //x2=63.39 //y2=2.26
r387 (  17 18 ) resistor r=0.229008 //w=0.131 //l=0.24 //layer=m1 \
 //thickness=0.36 //x=63.39 //y=2.385 //x2=63.39 //y2=2.625
r388 (  15 35 ) resistor r=0.0911593 //w=0.376 //l=0.184174 //layer=m1 \
 //thickness=0.36 //x=61.54 //y=2.945 //x2=61.592 //y2=2.785
r389 (  15 16 ) resistor r=2.19943 //w=0.131 //l=2.305 //layer=m1 \
 //thickness=0.36 //x=61.54 //y=2.945 //x2=61.54 //y2=5.25
r390 (  14 33 ) resistor r=0.0861726 //w=0.376 //l=0.169012 //layer=m1 \
 //thickness=0.36 //x=61.54 //y=2.625 //x2=61.592 //y2=2.77
r391 (  13 14 ) resistor r=0.663168 //w=0.131 //l=0.695 //layer=m1 \
 //thickness=0.36 //x=61.54 //y=1.93 //x2=61.54 //y2=2.625
r392 (  11 13 ) resistor r=0.0698411 //w=0.17 //l=0.120208 //layer=m1 \
 //thickness=0.36 //x=61.455 //y=1.845 //x2=61.54 //y2=1.93
r393 (  11 12 ) resistor r=0.300573 //w=0.131 //l=0.315 //layer=m1 \
 //thickness=0.36 //x=61.455 //y=1.845 //x2=61.14 //y2=1.845
r394 (  10 12 ) resistor r=0.0698411 //w=0.17 //l=0.120208 //layer=m1 \
 //thickness=0.36 //x=61.055 //y=1.76 //x2=61.14 //y2=1.845
r395 (  9 31 ) resistor r=0.0717383 //w=0.224 //l=0.115 //layer=m1 \
 //thickness=0.36 //x=61.055 //y=1.305 //x2=61.055 //y2=1.19
r396 (  9 10 ) resistor r=0.43416 //w=0.131 //l=0.455 //layer=m1 \
 //thickness=0.36 //x=61.055 //y=1.305 //x2=61.055 //y2=1.76
r397 (  8 27 ) resistor r=0.0675342 //w=0.23 //l=0.115 //layer=m1 \
 //thickness=0.36 //x=60.875 //y=5.335 //x2=60.76 //y2=5.335
r398 (  7 16 ) resistor r=0.0698411 //w=0.17 //l=0.120208 //layer=m1 \
 //thickness=0.36 //x=61.455 //y=5.335 //x2=61.54 //y2=5.25
r399 (  7 8 ) resistor r=0.553435 //w=0.131 //l=0.58 //layer=m1 \
 //thickness=0.36 //x=61.455 //y=5.335 //x2=60.875 //y2=5.335
r400 (  6 29 ) resistor r=0.00118313 //w=0.23 //layer=m1 //thickness=0.36 \
 //x=60.76 //y=5.56 //x2=60.76 //y2=5.56
r401 (  5 27 ) resistor r=0.002872 //w=0.34 //l=0.085 //layer=m1 \
 //thickness=0.36 //x=60.76 //y=5.42 //x2=60.76 //y2=5.335
r402 (  5 6 ) resistor r=0.091623 //w=0.191 //l=0.14 //layer=m1 \
 //thickness=0.36 //x=60.76 //y=5.42 //x2=60.76 //y2=5.56
r403 (  4 24 ) resistor r=0.0262263 //w=0.232 //l=0.12 //layer=m1 \
 //thickness=0.36 //x=60 //y=5.335 //x2=59.88 //y2=5.335
r404 (  3 27 ) resistor r=0.0675342 //w=0.23 //l=0.115 //layer=m1 \
 //thickness=0.36 //x=60.645 //y=5.335 //x2=60.76 //y2=5.335
r405 (  3 4 ) resistor r=0.615458 //w=0.131 //l=0.645 //layer=m1 \
 //thickness=0.36 //x=60.645 //y=5.335 //x2=60 //y2=5.335
r406 (  2 21 ) resistor r=0.0222262 //w=0.217 //l=0.118 //layer=m1 \
 //thickness=0.36 //x=59.12 //y=5.335 //x2=59.002 //y2=5.335
r407 (  1 24 ) resistor r=0.0262263 //w=0.232 //l=0.12 //layer=m1 \
 //thickness=0.36 //x=59.76 //y=5.335 //x2=59.88 //y2=5.335
r408 (  1 2 ) resistor r=0.610687 //w=0.131 //l=0.64 //layer=m1 \
 //thickness=0.36 //x=59.76 //y=5.335 //x2=59.12 //y2=5.335
ends PM_TMRDFFSNQX1\%noxref_14

subckt PM_TMRDFFSNQX1\%CLK ( 1 2 3 4 5 6 7 8 9 10 11 12 13 14 15 16 25 31 41 \
 45 50 57 61 66 73 77 82 85 87 89 90 91 93 95 97 99 101 103 104 105 106 107 \
 109 111 112 113 127 132 137 142 147 152 157 162 167 172 177 182 186 187 188 \
 189 190 191 192 193 194 195 196 197 198 199 200 201 202 203 204 205 206 208 \
 214 215 216 217 218 223 224 225 230 232 234 240 241 242 243 244 246 252 253 \
 254 255 256 261 262 263 268 270 272 278 279 280 281 282 284 290 291 292 293 \
 294 299 300 301 306 308 310 316 317 321 330 331 334 345 354 355 358 369 378 \
 379 382 )
c991 ( 382 0 ) capacitor c=0.0368618f //x=64.16 //y=4.88
c992 ( 379 0 ) capacitor c=0.0284095f //x=64.13 //y=2.095
c993 ( 378 0 ) capacitor c=0.0476356f //x=64.13 //y=2.26
c994 ( 369 0 ) capacitor c=0.035802f //x=54.88 //y=4.88
c995 ( 358 0 ) capacitor c=0.0368618f //x=39.74 //y=4.88
c996 ( 355 0 ) capacitor c=0.0284095f //x=39.71 //y=2.095
c997 ( 354 0 ) capacitor c=0.0476356f //x=39.71 //y=2.26
c998 ( 345 0 ) capacitor c=0.035802f //x=30.46 //y=4.88
c999 ( 334 0 ) capacitor c=0.0368618f //x=15.32 //y=4.88
c1000 ( 331 0 ) capacitor c=0.0284095f //x=15.29 //y=2.095
c1001 ( 330 0 ) capacitor c=0.0476356f //x=15.29 //y=2.26
c1002 ( 321 0 ) capacitor c=0.035802f //x=6.04 //y=4.88
c1003 ( 317 0 ) capacitor c=0.0439708f //x=64.695 //y=1.43
c1004 ( 316 0 ) capacitor c=0.0192582f //x=64.695 //y=1.085
c1005 ( 310 0 ) capacitor c=0.0162526f //x=64.54 //y=1.585
c1006 ( 308 0 ) capacitor c=0.0157807f //x=64.54 //y=0.93
c1007 ( 306 0 ) capacitor c=0.0352777f //x=64.535 //y=4.97
c1008 ( 301 0 ) capacitor c=0.0210762f //x=64.165 //y=1.74
c1009 ( 300 0 ) capacitor c=0.0168511f //x=64.165 //y=1.43
c1010 ( 299 0 ) capacitor c=0.0175485f //x=64.165 //y=1.085
c1011 ( 294 0 ) capacitor c=0.0305913f //x=55.215 //y=4.97
c1012 ( 293 0 ) capacitor c=0.0863671f //x=54.97 //y=2.095
c1013 ( 292 0 ) capacitor c=0.0170266f //x=54.97 //y=1.63
c1014 ( 291 0 ) capacitor c=0.018609f //x=54.97 //y=1.4
c1015 ( 290 0 ) capacitor c=0.0186599f //x=54.97 //y=1.09
c1016 ( 284 0 ) capacitor c=0.0146988f //x=54.815 //y=1.555
c1017 ( 282 0 ) capacitor c=0.0148531f //x=54.815 //y=0.935
c1018 ( 281 0 ) capacitor c=0.0334406f //x=54.445 //y=1.4
c1019 ( 280 0 ) capacitor c=0.0173191f //x=54.445 //y=1.09
c1020 ( 279 0 ) capacitor c=0.0439708f //x=40.275 //y=1.43
c1021 ( 278 0 ) capacitor c=0.0192582f //x=40.275 //y=1.085
c1022 ( 272 0 ) capacitor c=0.0162526f //x=40.12 //y=1.585
c1023 ( 270 0 ) capacitor c=0.0157807f //x=40.12 //y=0.93
c1024 ( 268 0 ) capacitor c=0.0352777f //x=40.115 //y=4.97
c1025 ( 263 0 ) capacitor c=0.0210762f //x=39.745 //y=1.74
c1026 ( 262 0 ) capacitor c=0.0168511f //x=39.745 //y=1.43
c1027 ( 261 0 ) capacitor c=0.0175485f //x=39.745 //y=1.085
c1028 ( 256 0 ) capacitor c=0.0305913f //x=30.795 //y=4.97
c1029 ( 255 0 ) capacitor c=0.0863671f //x=30.55 //y=2.095
c1030 ( 254 0 ) capacitor c=0.0170266f //x=30.55 //y=1.63
c1031 ( 253 0 ) capacitor c=0.018609f //x=30.55 //y=1.4
c1032 ( 252 0 ) capacitor c=0.0186599f //x=30.55 //y=1.09
c1033 ( 246 0 ) capacitor c=0.0146988f //x=30.395 //y=1.555
c1034 ( 244 0 ) capacitor c=0.0148531f //x=30.395 //y=0.935
c1035 ( 243 0 ) capacitor c=0.0334406f //x=30.025 //y=1.4
c1036 ( 242 0 ) capacitor c=0.0173191f //x=30.025 //y=1.09
c1037 ( 241 0 ) capacitor c=0.0439708f //x=15.855 //y=1.43
c1038 ( 240 0 ) capacitor c=0.0192582f //x=15.855 //y=1.085
c1039 ( 234 0 ) capacitor c=0.0162526f //x=15.7 //y=1.585
c1040 ( 232 0 ) capacitor c=0.0157807f //x=15.7 //y=0.93
c1041 ( 230 0 ) capacitor c=0.0352777f //x=15.695 //y=4.97
c1042 ( 225 0 ) capacitor c=0.0210762f //x=15.325 //y=1.74
c1043 ( 224 0 ) capacitor c=0.0168511f //x=15.325 //y=1.43
c1044 ( 223 0 ) capacitor c=0.0175485f //x=15.325 //y=1.085
c1045 ( 218 0 ) capacitor c=0.0305913f //x=6.375 //y=4.97
c1046 ( 217 0 ) capacitor c=0.0863671f //x=6.13 //y=2.095
c1047 ( 216 0 ) capacitor c=0.0170266f //x=6.13 //y=1.63
c1048 ( 215 0 ) capacitor c=0.018609f //x=6.13 //y=1.4
c1049 ( 214 0 ) capacitor c=0.0186599f //x=6.13 //y=1.09
c1050 ( 208 0 ) capacitor c=0.0146988f //x=5.975 //y=1.555
c1051 ( 206 0 ) capacitor c=0.0148531f //x=5.975 //y=0.935
c1052 ( 205 0 ) capacitor c=0.0334406f //x=5.605 //y=1.4
c1053 ( 204 0 ) capacitor c=0.0173191f //x=5.605 //y=1.09
c1054 ( 203 0 ) capacitor c=0.155269f //x=64.61 //y=6.2
c1055 ( 202 0 ) capacitor c=0.110375f //x=64.17 //y=6.2
c1056 ( 201 0 ) capacitor c=0.110208f //x=55.29 //y=6.2
c1057 ( 200 0 ) capacitor c=0.110214f //x=54.85 //y=6.2
c1058 ( 199 0 ) capacitor c=0.155269f //x=40.19 //y=6.2
c1059 ( 198 0 ) capacitor c=0.110375f //x=39.75 //y=6.2
c1060 ( 197 0 ) capacitor c=0.110208f //x=30.87 //y=6.2
c1061 ( 196 0 ) capacitor c=0.110214f //x=30.43 //y=6.2
c1062 ( 195 0 ) capacitor c=0.155269f //x=15.77 //y=6.2
c1063 ( 194 0 ) capacitor c=0.110375f //x=15.33 //y=6.2
c1064 ( 193 0 ) capacitor c=0.110208f //x=6.45 //y=6.2
c1065 ( 192 0 ) capacitor c=0.110214f //x=6.01 //y=6.2
c1066 ( 182 0 ) capacitor c=8.63406e-19 //x=64.16 //y=4.88
c1067 ( 177 0 ) capacitor c=7.72439e-19 //x=64.13 //y=2.26
c1068 ( 172 0 ) capacitor c=0.00129935f //x=54.88 //y=4.88
c1069 ( 167 0 ) capacitor c=0.00121786f //x=54.88 //y=2.26
c1070 ( 162 0 ) capacitor c=8.63406e-19 //x=39.74 //y=4.88
c1071 ( 157 0 ) capacitor c=7.72439e-19 //x=39.71 //y=2.26
c1072 ( 152 0 ) capacitor c=0.00129935f //x=30.46 //y=4.88
c1073 ( 147 0 ) capacitor c=0.00121786f //x=30.46 //y=2.26
c1074 ( 142 0 ) capacitor c=8.63406e-19 //x=15.32 //y=4.88
c1075 ( 137 0 ) capacitor c=7.72439e-19 //x=15.29 //y=2.26
c1076 ( 132 0 ) capacitor c=0.00129935f //x=6.04 //y=4.88
c1077 ( 127 0 ) capacitor c=0.00121786f //x=6.04 //y=2.26
c1078 ( 113 0 ) capacitor c=0.00532303f //x=6.04 //y=4.62
c1079 ( 112 0 ) capacitor c=0.128217f //x=56.595 //y=4.635
c1080 ( 111 0 ) capacitor c=0.194011f //x=56.94 //y=4.635
c1081 ( 109 0 ) capacitor c=0.0043561f //x=51.395 //y=4.63
c1082 ( 107 0 ) capacitor c=0.202747f //x=50.795 //y=4.62
c1083 ( 106 0 ) capacitor c=0.244933f //x=42.17 //y=4.65
c1084 ( 105 0 ) capacitor c=0.0246137f //x=43.245 //y=4.65
c1085 ( 104 0 ) capacitor c=0.128217f //x=32.175 //y=4.635
c1086 ( 103 0 ) capacitor c=0.00691742f //x=32.52 //y=4.635
c1087 ( 101 0 ) capacitor c=0.0043561f //x=26.975 //y=4.63
c1088 ( 99 0 ) capacitor c=0.137793f //x=26.375 //y=4.62
c1089 ( 97 0 ) capacitor c=0.0147807f //x=21.425 //y=4.65
c1090 ( 95 0 ) capacitor c=0.0405234f //x=20.825 //y=4.62
c1091 ( 93 0 ) capacitor c=0.0138309f //x=19.575 //y=4.65
c1092 ( 91 0 ) capacitor c=0.0214517f //x=18.975 //y=4.62
c1093 ( 90 0 ) capacitor c=0.244897f //x=17.75 //y=4.65
c1094 ( 89 0 ) capacitor c=0.010396f //x=18.095 //y=4.65
c1095 ( 87 0 ) capacitor c=0.00691742f //x=8.1 //y=4.635
c1096 ( 85 0 ) capacitor c=0.0322851f //x=7.5 //y=4.62
c1097 ( 82 0 ) capacitor c=0.00896434f //x=64.165 //y=4.75
c1098 ( 77 0 ) capacitor c=0.00504845f //x=64.13 //y=2.26
c1099 ( 73 0 ) capacitor c=0.00985633f //x=54.88 //y=4.755
c1100 ( 66 0 ) capacitor c=0.00896434f //x=39.745 //y=4.75
c1101 ( 61 0 ) capacitor c=0.00504845f //x=39.71 //y=2.26
c1102 ( 57 0 ) capacitor c=0.00985633f //x=30.46 //y=4.755
c1103 ( 50 0 ) capacitor c=0.00896434f //x=15.325 //y=4.75
c1104 ( 45 0 ) capacitor c=0.00504845f //x=15.29 //y=2.26
c1105 ( 41 0 ) capacitor c=0.00986189f //x=6.04 //y=4.755
c1106 ( 31 0 ) capacitor c=0.00380207f //x=54.88 //y=2.375
c1107 ( 25 0 ) capacitor c=0.00380207f //x=30.46 //y=2.375
c1108 ( 16 0 ) capacitor c=0.00562626f //x=6.04 //y=2.375
c1109 ( 9 0 ) capacitor c=0.0449052f //x=64.13 //y=2.77
c1110 ( 8 0 ) capacitor c=0.0594704f //x=54.88 //y=3.88
c1111 ( 7 0 ) capacitor c=0.0449052f //x=39.71 //y=2.77
c1112 ( 6 0 ) capacitor c=0.0594704f //x=30.46 //y=3.88
c1113 ( 4 0 ) capacitor c=0.0465236f //x=15.29 //y=2.77
c1114 ( 1 0 ) capacitor c=0.0633852f //x=6.04 //y=2.4
r1115 (  384 385 ) resistor r=32.4568 //w=0.214 //l=0.075 //layer=ply \
 //thickness=0.18 //x=64.16 //y=4.97 //x2=64.16 //y2=5.045
r1116 (  382 384 ) resistor r=20.271 //w=0.214 //l=0.09 //layer=ply \
 //thickness=0.18 //x=64.16 //y=4.88 //x2=64.16 //y2=4.97
r1117 (  378 379 ) resistor r=52.7279 //w=0.214 //l=0.165 //layer=ply \
 //thickness=0.18 //x=64.13 //y=2.26 //x2=64.13 //y2=2.095
r1118 (  371 372 ) resistor r=32.4568 //w=0.214 //l=0.075 //layer=ply \
 //thickness=0.18 //x=54.88 //y=4.97 //x2=54.88 //y2=5.045
r1119 (  369 371 ) resistor r=20.271 //w=0.214 //l=0.09 //layer=ply \
 //thickness=0.18 //x=54.88 //y=4.88 //x2=54.88 //y2=4.97
r1120 (  360 361 ) resistor r=32.4568 //w=0.214 //l=0.075 //layer=ply \
 //thickness=0.18 //x=39.74 //y=4.97 //x2=39.74 //y2=5.045
r1121 (  358 360 ) resistor r=20.271 //w=0.214 //l=0.09 //layer=ply \
 //thickness=0.18 //x=39.74 //y=4.88 //x2=39.74 //y2=4.97
r1122 (  354 355 ) resistor r=52.7279 //w=0.214 //l=0.165 //layer=ply \
 //thickness=0.18 //x=39.71 //y=2.26 //x2=39.71 //y2=2.095
r1123 (  347 348 ) resistor r=32.4568 //w=0.214 //l=0.075 //layer=ply \
 //thickness=0.18 //x=30.46 //y=4.97 //x2=30.46 //y2=5.045
r1124 (  345 347 ) resistor r=20.271 //w=0.214 //l=0.09 //layer=ply \
 //thickness=0.18 //x=30.46 //y=4.88 //x2=30.46 //y2=4.97
r1125 (  336 337 ) resistor r=32.4568 //w=0.214 //l=0.075 //layer=ply \
 //thickness=0.18 //x=15.32 //y=4.97 //x2=15.32 //y2=5.045
r1126 (  334 336 ) resistor r=20.271 //w=0.214 //l=0.09 //layer=ply \
 //thickness=0.18 //x=15.32 //y=4.88 //x2=15.32 //y2=4.97
r1127 (  330 331 ) resistor r=52.7279 //w=0.214 //l=0.165 //layer=ply \
 //thickness=0.18 //x=15.29 //y=2.26 //x2=15.29 //y2=2.095
r1128 (  323 324 ) resistor r=32.4568 //w=0.214 //l=0.075 //layer=ply \
 //thickness=0.18 //x=6.04 //y=4.97 //x2=6.04 //y2=5.045
r1129 (  321 323 ) resistor r=20.271 //w=0.214 //l=0.09 //layer=ply \
 //thickness=0.18 //x=6.04 //y=4.88 //x2=6.04 //y2=4.97
r1130 (  317 389 ) resistor r=45.1352 //w=0.168 //l=0.173853 //layer=ply \
 //thickness=0.18 //x=64.695 //y=1.43 //x2=64.655 //y2=1.585
r1131 (  316 388 ) resistor r=45.1352 //w=0.168 //l=0.173853 //layer=ply \
 //thickness=0.18 //x=64.695 //y=1.085 //x2=64.655 //y2=0.93
r1132 (  316 317 ) resistor r=176.904 //w=0.094 //l=0.345 //layer=ply \
 //thickness=0.18 //x=64.695 //y=1.085 //x2=64.695 //y2=1.43
r1133 (  311 387 ) resistor r=10.701 //w=0.21 //l=0.115 //layer=ply \
 //thickness=0.18 //x=64.32 //y=1.585 //x2=64.205 //y2=1.585
r1134 (  310 389 ) resistor r=5.52526 //w=0.168 //l=0.115 //layer=ply \
 //thickness=0.18 //x=64.54 //y=1.585 //x2=64.655 //y2=1.585
r1135 (  309 386 ) resistor r=5.52526 //w=0.168 //l=0.115 //layer=ply \
 //thickness=0.18 //x=64.32 //y=0.93 //x2=64.205 //y2=0.93
r1136 (  308 388 ) resistor r=5.52526 //w=0.168 //l=0.115 //layer=ply \
 //thickness=0.18 //x=64.54 //y=0.93 //x2=64.655 //y2=0.93
r1137 (  308 309 ) resistor r=112.809 //w=0.094 //l=0.22 //layer=ply \
 //thickness=0.18 //x=64.54 //y=0.93 //x2=64.32 //y2=0.93
r1138 (  307 384 ) resistor r=16.5046 //w=0.27 //l=0.135 //layer=ply \
 //thickness=0.18 //x=64.295 //y=4.97 //x2=64.16 //y2=4.97
r1139 (  306 313 ) resistor r=26.9307 //w=0.15 //l=0.106066 //layer=ply \
 //thickness=0.18 //x=64.535 //y=4.97 //x2=64.61 //y2=5.045
r1140 (  306 307 ) resistor r=123.064 //w=0.094 //l=0.24 //layer=ply \
 //thickness=0.18 //x=64.535 //y=4.97 //x2=64.295 //y2=4.97
r1141 (  301 387 ) resistor r=39.5823 //w=0.21 //l=0.173853 //layer=ply \
 //thickness=0.18 //x=64.165 //y=1.74 //x2=64.205 //y2=1.585
r1142 (  301 379 ) resistor r=182.032 //w=0.094 //l=0.355 //layer=ply \
 //thickness=0.18 //x=64.165 //y=1.74 //x2=64.165 //y2=2.095
r1143 (  300 387 ) resistor r=39.5823 //w=0.21 //l=0.173853 //layer=ply \
 //thickness=0.18 //x=64.165 //y=1.43 //x2=64.205 //y2=1.585
r1144 (  299 386 ) resistor r=45.1352 //w=0.168 //l=0.173853 //layer=ply \
 //thickness=0.18 //x=64.165 //y=1.085 //x2=64.205 //y2=0.93
r1145 (  299 300 ) resistor r=176.904 //w=0.094 //l=0.345 //layer=ply \
 //thickness=0.18 //x=64.165 //y=1.085 //x2=64.165 //y2=1.43
r1146 (  295 371 ) resistor r=16.5046 //w=0.27 //l=0.135 //layer=ply \
 //thickness=0.18 //x=55.015 //y=4.97 //x2=54.88 //y2=4.97
r1147 (  294 296 ) resistor r=26.9307 //w=0.15 //l=0.106066 //layer=ply \
 //thickness=0.18 //x=55.215 //y=4.97 //x2=55.29 //y2=5.045
r1148 (  294 295 ) resistor r=102.553 //w=0.094 //l=0.2 //layer=ply \
 //thickness=0.18 //x=55.215 //y=4.97 //x2=55.015 //y2=4.97
r1149 (  293 376 ) resistor r=38.6777 //w=0.284 //l=0.198997 //layer=ply \
 //thickness=0.18 //x=54.97 //y=2.095 //x2=54.895 //y2=2.26
r1150 (  292 374 ) resistor r=21.2976 //w=0.217 //l=0.0928709 //layer=ply \
 //thickness=0.18 //x=54.97 //y=1.63 //x2=54.93 //y2=1.555
r1151 (  292 293 ) resistor r=238.436 //w=0.094 //l=0.465 //layer=ply \
 //thickness=0.18 //x=54.97 //y=1.63 //x2=54.97 //y2=2.095
r1152 (  291 374 ) resistor r=39.0671 //w=0.217 //l=0.173853 //layer=ply \
 //thickness=0.18 //x=54.97 //y=1.4 //x2=54.93 //y2=1.555
r1153 (  290 373 ) resistor r=45.1352 //w=0.168 //l=0.173853 //layer=ply \
 //thickness=0.18 //x=54.97 //y=1.09 //x2=54.93 //y2=0.935
r1154 (  290 291 ) resistor r=158.957 //w=0.094 //l=0.31 //layer=ply \
 //thickness=0.18 //x=54.97 //y=1.09 //x2=54.97 //y2=1.4
r1155 (  285 367 ) resistor r=5.52526 //w=0.168 //l=0.115 //layer=ply \
 //thickness=0.18 //x=54.6 //y=1.555 //x2=54.485 //y2=1.555
r1156 (  284 374 ) resistor r=11.4558 //w=0.217 //l=0.115 //layer=ply \
 //thickness=0.18 //x=54.815 //y=1.555 //x2=54.93 //y2=1.555
r1157 (  283 366 ) resistor r=5.52526 //w=0.168 //l=0.115 //layer=ply \
 //thickness=0.18 //x=54.6 //y=0.935 //x2=54.485 //y2=0.935
r1158 (  282 373 ) resistor r=5.52526 //w=0.168 //l=0.115 //layer=ply \
 //thickness=0.18 //x=54.815 //y=0.935 //x2=54.93 //y2=0.935
r1159 (  282 283 ) resistor r=110.245 //w=0.094 //l=0.215 //layer=ply \
 //thickness=0.18 //x=54.815 //y=0.935 //x2=54.6 //y2=0.935
r1160 (  281 367 ) resistor r=45.1352 //w=0.168 //l=0.173853 //layer=ply \
 //thickness=0.18 //x=54.445 //y=1.4 //x2=54.485 //y2=1.555
r1161 (  280 366 ) resistor r=45.1352 //w=0.168 //l=0.173853 //layer=ply \
 //thickness=0.18 //x=54.445 //y=1.09 //x2=54.485 //y2=0.935
r1162 (  280 281 ) resistor r=158.957 //w=0.094 //l=0.31 //layer=ply \
 //thickness=0.18 //x=54.445 //y=1.09 //x2=54.445 //y2=1.4
r1163 (  279 365 ) resistor r=45.1352 //w=0.168 //l=0.173853 //layer=ply \
 //thickness=0.18 //x=40.275 //y=1.43 //x2=40.235 //y2=1.585
r1164 (  278 364 ) resistor r=45.1352 //w=0.168 //l=0.173853 //layer=ply \
 //thickness=0.18 //x=40.275 //y=1.085 //x2=40.235 //y2=0.93
r1165 (  278 279 ) resistor r=176.904 //w=0.094 //l=0.345 //layer=ply \
 //thickness=0.18 //x=40.275 //y=1.085 //x2=40.275 //y2=1.43
r1166 (  273 363 ) resistor r=10.701 //w=0.21 //l=0.115 //layer=ply \
 //thickness=0.18 //x=39.9 //y=1.585 //x2=39.785 //y2=1.585
r1167 (  272 365 ) resistor r=5.52526 //w=0.168 //l=0.115 //layer=ply \
 //thickness=0.18 //x=40.12 //y=1.585 //x2=40.235 //y2=1.585
r1168 (  271 362 ) resistor r=5.52526 //w=0.168 //l=0.115 //layer=ply \
 //thickness=0.18 //x=39.9 //y=0.93 //x2=39.785 //y2=0.93
r1169 (  270 364 ) resistor r=5.52526 //w=0.168 //l=0.115 //layer=ply \
 //thickness=0.18 //x=40.12 //y=0.93 //x2=40.235 //y2=0.93
r1170 (  270 271 ) resistor r=112.809 //w=0.094 //l=0.22 //layer=ply \
 //thickness=0.18 //x=40.12 //y=0.93 //x2=39.9 //y2=0.93
r1171 (  269 360 ) resistor r=16.5046 //w=0.27 //l=0.135 //layer=ply \
 //thickness=0.18 //x=39.875 //y=4.97 //x2=39.74 //y2=4.97
r1172 (  268 275 ) resistor r=26.9307 //w=0.15 //l=0.106066 //layer=ply \
 //thickness=0.18 //x=40.115 //y=4.97 //x2=40.19 //y2=5.045
r1173 (  268 269 ) resistor r=123.064 //w=0.094 //l=0.24 //layer=ply \
 //thickness=0.18 //x=40.115 //y=4.97 //x2=39.875 //y2=4.97
r1174 (  263 363 ) resistor r=39.5823 //w=0.21 //l=0.173853 //layer=ply \
 //thickness=0.18 //x=39.745 //y=1.74 //x2=39.785 //y2=1.585
r1175 (  263 355 ) resistor r=182.032 //w=0.094 //l=0.355 //layer=ply \
 //thickness=0.18 //x=39.745 //y=1.74 //x2=39.745 //y2=2.095
r1176 (  262 363 ) resistor r=39.5823 //w=0.21 //l=0.173853 //layer=ply \
 //thickness=0.18 //x=39.745 //y=1.43 //x2=39.785 //y2=1.585
r1177 (  261 362 ) resistor r=45.1352 //w=0.168 //l=0.173853 //layer=ply \
 //thickness=0.18 //x=39.745 //y=1.085 //x2=39.785 //y2=0.93
r1178 (  261 262 ) resistor r=176.904 //w=0.094 //l=0.345 //layer=ply \
 //thickness=0.18 //x=39.745 //y=1.085 //x2=39.745 //y2=1.43
r1179 (  257 347 ) resistor r=16.5046 //w=0.27 //l=0.135 //layer=ply \
 //thickness=0.18 //x=30.595 //y=4.97 //x2=30.46 //y2=4.97
r1180 (  256 258 ) resistor r=26.9307 //w=0.15 //l=0.106066 //layer=ply \
 //thickness=0.18 //x=30.795 //y=4.97 //x2=30.87 //y2=5.045
r1181 (  256 257 ) resistor r=102.553 //w=0.094 //l=0.2 //layer=ply \
 //thickness=0.18 //x=30.795 //y=4.97 //x2=30.595 //y2=4.97
r1182 (  255 352 ) resistor r=38.6777 //w=0.284 //l=0.198997 //layer=ply \
 //thickness=0.18 //x=30.55 //y=2.095 //x2=30.475 //y2=2.26
r1183 (  254 350 ) resistor r=21.2976 //w=0.217 //l=0.0928709 //layer=ply \
 //thickness=0.18 //x=30.55 //y=1.63 //x2=30.51 //y2=1.555
r1184 (  254 255 ) resistor r=238.436 //w=0.094 //l=0.465 //layer=ply \
 //thickness=0.18 //x=30.55 //y=1.63 //x2=30.55 //y2=2.095
r1185 (  253 350 ) resistor r=39.0671 //w=0.217 //l=0.173853 //layer=ply \
 //thickness=0.18 //x=30.55 //y=1.4 //x2=30.51 //y2=1.555
r1186 (  252 349 ) resistor r=45.1352 //w=0.168 //l=0.173853 //layer=ply \
 //thickness=0.18 //x=30.55 //y=1.09 //x2=30.51 //y2=0.935
r1187 (  252 253 ) resistor r=158.957 //w=0.094 //l=0.31 //layer=ply \
 //thickness=0.18 //x=30.55 //y=1.09 //x2=30.55 //y2=1.4
r1188 (  247 343 ) resistor r=5.52526 //w=0.168 //l=0.115 //layer=ply \
 //thickness=0.18 //x=30.18 //y=1.555 //x2=30.065 //y2=1.555
r1189 (  246 350 ) resistor r=11.4558 //w=0.217 //l=0.115 //layer=ply \
 //thickness=0.18 //x=30.395 //y=1.555 //x2=30.51 //y2=1.555
r1190 (  245 342 ) resistor r=5.52526 //w=0.168 //l=0.115 //layer=ply \
 //thickness=0.18 //x=30.18 //y=0.935 //x2=30.065 //y2=0.935
r1191 (  244 349 ) resistor r=5.52526 //w=0.168 //l=0.115 //layer=ply \
 //thickness=0.18 //x=30.395 //y=0.935 //x2=30.51 //y2=0.935
r1192 (  244 245 ) resistor r=110.245 //w=0.094 //l=0.215 //layer=ply \
 //thickness=0.18 //x=30.395 //y=0.935 //x2=30.18 //y2=0.935
r1193 (  243 343 ) resistor r=45.1352 //w=0.168 //l=0.173853 //layer=ply \
 //thickness=0.18 //x=30.025 //y=1.4 //x2=30.065 //y2=1.555
r1194 (  242 342 ) resistor r=45.1352 //w=0.168 //l=0.173853 //layer=ply \
 //thickness=0.18 //x=30.025 //y=1.09 //x2=30.065 //y2=0.935
r1195 (  242 243 ) resistor r=158.957 //w=0.094 //l=0.31 //layer=ply \
 //thickness=0.18 //x=30.025 //y=1.09 //x2=30.025 //y2=1.4
r1196 (  241 341 ) resistor r=45.1352 //w=0.168 //l=0.173853 //layer=ply \
 //thickness=0.18 //x=15.855 //y=1.43 //x2=15.815 //y2=1.585
r1197 (  240 340 ) resistor r=45.1352 //w=0.168 //l=0.173853 //layer=ply \
 //thickness=0.18 //x=15.855 //y=1.085 //x2=15.815 //y2=0.93
r1198 (  240 241 ) resistor r=176.904 //w=0.094 //l=0.345 //layer=ply \
 //thickness=0.18 //x=15.855 //y=1.085 //x2=15.855 //y2=1.43
r1199 (  235 339 ) resistor r=10.701 //w=0.21 //l=0.115 //layer=ply \
 //thickness=0.18 //x=15.48 //y=1.585 //x2=15.365 //y2=1.585
r1200 (  234 341 ) resistor r=5.52526 //w=0.168 //l=0.115 //layer=ply \
 //thickness=0.18 //x=15.7 //y=1.585 //x2=15.815 //y2=1.585
r1201 (  233 338 ) resistor r=5.52526 //w=0.168 //l=0.115 //layer=ply \
 //thickness=0.18 //x=15.48 //y=0.93 //x2=15.365 //y2=0.93
r1202 (  232 340 ) resistor r=5.52526 //w=0.168 //l=0.115 //layer=ply \
 //thickness=0.18 //x=15.7 //y=0.93 //x2=15.815 //y2=0.93
r1203 (  232 233 ) resistor r=112.809 //w=0.094 //l=0.22 //layer=ply \
 //thickness=0.18 //x=15.7 //y=0.93 //x2=15.48 //y2=0.93
r1204 (  231 336 ) resistor r=16.5046 //w=0.27 //l=0.135 //layer=ply \
 //thickness=0.18 //x=15.455 //y=4.97 //x2=15.32 //y2=4.97
r1205 (  230 237 ) resistor r=26.9307 //w=0.15 //l=0.106066 //layer=ply \
 //thickness=0.18 //x=15.695 //y=4.97 //x2=15.77 //y2=5.045
r1206 (  230 231 ) resistor r=123.064 //w=0.094 //l=0.24 //layer=ply \
 //thickness=0.18 //x=15.695 //y=4.97 //x2=15.455 //y2=4.97
r1207 (  225 339 ) resistor r=39.5823 //w=0.21 //l=0.173853 //layer=ply \
 //thickness=0.18 //x=15.325 //y=1.74 //x2=15.365 //y2=1.585
r1208 (  225 331 ) resistor r=182.032 //w=0.094 //l=0.355 //layer=ply \
 //thickness=0.18 //x=15.325 //y=1.74 //x2=15.325 //y2=2.095
r1209 (  224 339 ) resistor r=39.5823 //w=0.21 //l=0.173853 //layer=ply \
 //thickness=0.18 //x=15.325 //y=1.43 //x2=15.365 //y2=1.585
r1210 (  223 338 ) resistor r=45.1352 //w=0.168 //l=0.173853 //layer=ply \
 //thickness=0.18 //x=15.325 //y=1.085 //x2=15.365 //y2=0.93
r1211 (  223 224 ) resistor r=176.904 //w=0.094 //l=0.345 //layer=ply \
 //thickness=0.18 //x=15.325 //y=1.085 //x2=15.325 //y2=1.43
r1212 (  219 323 ) resistor r=16.5046 //w=0.27 //l=0.135 //layer=ply \
 //thickness=0.18 //x=6.175 //y=4.97 //x2=6.04 //y2=4.97
r1213 (  218 220 ) resistor r=26.9307 //w=0.15 //l=0.106066 //layer=ply \
 //thickness=0.18 //x=6.375 //y=4.97 //x2=6.45 //y2=5.045
r1214 (  218 219 ) resistor r=102.553 //w=0.094 //l=0.2 //layer=ply \
 //thickness=0.18 //x=6.375 //y=4.97 //x2=6.175 //y2=4.97
r1215 (  217 328 ) resistor r=38.6777 //w=0.284 //l=0.198997 //layer=ply \
 //thickness=0.18 //x=6.13 //y=2.095 //x2=6.055 //y2=2.26
r1216 (  216 326 ) resistor r=21.2976 //w=0.217 //l=0.0928709 //layer=ply \
 //thickness=0.18 //x=6.13 //y=1.63 //x2=6.09 //y2=1.555
r1217 (  216 217 ) resistor r=238.436 //w=0.094 //l=0.465 //layer=ply \
 //thickness=0.18 //x=6.13 //y=1.63 //x2=6.13 //y2=2.095
r1218 (  215 326 ) resistor r=39.0671 //w=0.217 //l=0.173853 //layer=ply \
 //thickness=0.18 //x=6.13 //y=1.4 //x2=6.09 //y2=1.555
r1219 (  214 325 ) resistor r=45.1352 //w=0.168 //l=0.173853 //layer=ply \
 //thickness=0.18 //x=6.13 //y=1.09 //x2=6.09 //y2=0.935
r1220 (  214 215 ) resistor r=158.957 //w=0.094 //l=0.31 //layer=ply \
 //thickness=0.18 //x=6.13 //y=1.09 //x2=6.13 //y2=1.4
r1221 (  209 319 ) resistor r=5.52526 //w=0.168 //l=0.115 //layer=ply \
 //thickness=0.18 //x=5.76 //y=1.555 //x2=5.645 //y2=1.555
r1222 (  208 326 ) resistor r=11.4558 //w=0.217 //l=0.115 //layer=ply \
 //thickness=0.18 //x=5.975 //y=1.555 //x2=6.09 //y2=1.555
r1223 (  207 318 ) resistor r=5.52526 //w=0.168 //l=0.115 //layer=ply \
 //thickness=0.18 //x=5.76 //y=0.935 //x2=5.645 //y2=0.935
r1224 (  206 325 ) resistor r=5.52526 //w=0.168 //l=0.115 //layer=ply \
 //thickness=0.18 //x=5.975 //y=0.935 //x2=6.09 //y2=0.935
r1225 (  206 207 ) resistor r=110.245 //w=0.094 //l=0.215 //layer=ply \
 //thickness=0.18 //x=5.975 //y=0.935 //x2=5.76 //y2=0.935
r1226 (  205 319 ) resistor r=45.1352 //w=0.168 //l=0.173853 //layer=ply \
 //thickness=0.18 //x=5.605 //y=1.4 //x2=5.645 //y2=1.555
r1227 (  204 318 ) resistor r=45.1352 //w=0.168 //l=0.173853 //layer=ply \
 //thickness=0.18 //x=5.605 //y=1.09 //x2=5.645 //y2=0.935
r1228 (  204 205 ) resistor r=158.957 //w=0.094 //l=0.31 //layer=ply \
 //thickness=0.18 //x=5.605 //y=1.09 //x2=5.605 //y2=1.4
r1229 (  203 313 ) resistor r=592.245 //w=0.094 //l=1.155 //layer=ply \
 //thickness=0.18 //x=64.61 //y=6.2 //x2=64.61 //y2=5.045
r1230 (  202 385 ) resistor r=592.245 //w=0.094 //l=1.155 //layer=ply \
 //thickness=0.18 //x=64.17 //y=6.2 //x2=64.17 //y2=5.045
r1231 (  201 296 ) resistor r=592.245 //w=0.094 //l=1.155 //layer=ply \
 //thickness=0.18 //x=55.29 //y=6.2 //x2=55.29 //y2=5.045
r1232 (  200 372 ) resistor r=592.245 //w=0.094 //l=1.155 //layer=ply \
 //thickness=0.18 //x=54.85 //y=6.2 //x2=54.85 //y2=5.045
r1233 (  199 275 ) resistor r=592.245 //w=0.094 //l=1.155 //layer=ply \
 //thickness=0.18 //x=40.19 //y=6.2 //x2=40.19 //y2=5.045
r1234 (  198 361 ) resistor r=592.245 //w=0.094 //l=1.155 //layer=ply \
 //thickness=0.18 //x=39.75 //y=6.2 //x2=39.75 //y2=5.045
r1235 (  197 258 ) resistor r=592.245 //w=0.094 //l=1.155 //layer=ply \
 //thickness=0.18 //x=30.87 //y=6.2 //x2=30.87 //y2=5.045
r1236 (  196 348 ) resistor r=592.245 //w=0.094 //l=1.155 //layer=ply \
 //thickness=0.18 //x=30.43 //y=6.2 //x2=30.43 //y2=5.045
r1237 (  195 237 ) resistor r=592.245 //w=0.094 //l=1.155 //layer=ply \
 //thickness=0.18 //x=15.77 //y=6.2 //x2=15.77 //y2=5.045
r1238 (  194 337 ) resistor r=592.245 //w=0.094 //l=1.155 //layer=ply \
 //thickness=0.18 //x=15.33 //y=6.2 //x2=15.33 //y2=5.045
r1239 (  193 220 ) resistor r=592.245 //w=0.094 //l=1.155 //layer=ply \
 //thickness=0.18 //x=6.45 //y=6.2 //x2=6.45 //y2=5.045
r1240 (  192 324 ) resistor r=592.245 //w=0.094 //l=1.155 //layer=ply \
 //thickness=0.18 //x=6.01 //y=6.2 //x2=6.01 //y2=5.045
r1241 (  191 310 ) resistor r=56.4043 //w=0.094 //l=0.11 //layer=ply \
 //thickness=0.18 //x=64.43 //y=1.585 //x2=64.54 //y2=1.585
r1242 (  191 311 ) resistor r=56.4043 //w=0.094 //l=0.11 //layer=ply \
 //thickness=0.18 //x=64.43 //y=1.585 //x2=64.32 //y2=1.585
r1243 (  190 284 ) resistor r=55.3787 //w=0.094 //l=0.108 //layer=ply \
 //thickness=0.18 //x=54.707 //y=1.555 //x2=54.815 //y2=1.555
r1244 (  190 285 ) resistor r=54.866 //w=0.094 //l=0.107 //layer=ply \
 //thickness=0.18 //x=54.707 //y=1.555 //x2=54.6 //y2=1.555
r1245 (  189 272 ) resistor r=56.4043 //w=0.094 //l=0.11 //layer=ply \
 //thickness=0.18 //x=40.01 //y=1.585 //x2=40.12 //y2=1.585
r1246 (  189 273 ) resistor r=56.4043 //w=0.094 //l=0.11 //layer=ply \
 //thickness=0.18 //x=40.01 //y=1.585 //x2=39.9 //y2=1.585
r1247 (  188 246 ) resistor r=55.3787 //w=0.094 //l=0.108 //layer=ply \
 //thickness=0.18 //x=30.287 //y=1.555 //x2=30.395 //y2=1.555
r1248 (  188 247 ) resistor r=54.866 //w=0.094 //l=0.107 //layer=ply \
 //thickness=0.18 //x=30.287 //y=1.555 //x2=30.18 //y2=1.555
r1249 (  187 234 ) resistor r=56.4043 //w=0.094 //l=0.11 //layer=ply \
 //thickness=0.18 //x=15.59 //y=1.585 //x2=15.7 //y2=1.585
r1250 (  187 235 ) resistor r=56.4043 //w=0.094 //l=0.11 //layer=ply \
 //thickness=0.18 //x=15.59 //y=1.585 //x2=15.48 //y2=1.585
r1251 (  186 208 ) resistor r=55.3787 //w=0.094 //l=0.108 //layer=ply \
 //thickness=0.18 //x=5.867 //y=1.555 //x2=5.975 //y2=1.555
r1252 (  186 209 ) resistor r=54.866 //w=0.094 //l=0.107 //layer=ply \
 //thickness=0.18 //x=5.867 //y=1.555 //x2=5.76 //y2=1.555
r1253 (  182 382 ) resistor r=152 //w=0.17 //l=0.17 //layer=licon //count=1 \
 //x=64.16 //y=4.88 //x2=64.16 //y2=4.88
r1254 (  177 378 ) resistor r=152 //w=0.17 //l=0.17 //layer=licon //count=1 \
 //x=64.13 //y=2.26 //x2=64.13 //y2=2.26
r1255 (  172 369 ) resistor r=152 //w=0.17 //l=0.17 //layer=licon //count=1 \
 //x=54.88 //y=4.88 //x2=54.88 //y2=4.88
r1256 (  167 376 ) resistor r=152 //w=0.17 //l=0.17 //layer=licon //count=1 \
 //x=54.88 //y=2.26 //x2=54.88 //y2=2.26
r1257 (  162 358 ) resistor r=152 //w=0.17 //l=0.17 //layer=licon //count=1 \
 //x=39.74 //y=4.88 //x2=39.74 //y2=4.88
r1258 (  157 354 ) resistor r=152 //w=0.17 //l=0.17 //layer=licon //count=1 \
 //x=39.71 //y=2.26 //x2=39.71 //y2=2.26
r1259 (  152 345 ) resistor r=152 //w=0.17 //l=0.17 //layer=licon //count=1 \
 //x=30.46 //y=4.88 //x2=30.46 //y2=4.88
r1260 (  147 352 ) resistor r=152 //w=0.17 //l=0.17 //layer=licon //count=1 \
 //x=30.46 //y=2.26 //x2=30.46 //y2=2.26
r1261 (  142 334 ) resistor r=152 //w=0.17 //l=0.17 //layer=licon //count=1 \
 //x=15.32 //y=4.88 //x2=15.32 //y2=4.88
r1262 (  137 330 ) resistor r=152 //w=0.17 //l=0.17 //layer=licon //count=1 \
 //x=15.29 //y=2.26 //x2=15.29 //y2=2.26
r1263 (  132 321 ) resistor r=152 //w=0.17 //l=0.17 //layer=licon //count=1 \
 //x=6.04 //y=4.88 //x2=6.04 //y2=4.88
r1264 (  127 328 ) resistor r=152 //w=0.17 //l=0.17 //layer=licon //count=1 \
 //x=6.04 //y=2.26 //x2=6.04 //y2=2.26
r1265 (  113 115 ) resistor r=0.0546116 //w=0.309 //l=0.135 //layer=m2 \
 //thickness=0.36 //x=6.04 //y=4.62 //x2=6.04 //y2=4.755
r1266 (  112 123 ) resistor r=1.17227 //w=0.183 //l=1.74965 //layer=m2 \
 //thickness=0.36 //x=56.595 //y=4.635 //x2=54.88 //y2=4.705
r1267 (  111 125 ) resistor r=5.04583 //w=0.179 //l=7.25992 //layer=m2 \
 //thickness=0.36 //x=56.94 //y=4.635 //x2=64.165 //y2=4.705
r1268 (  111 112 ) resistor r=0.329198 //w=0.131 //l=0.345 //layer=m2 \
 //thickness=0.36 //x=56.94 //y=4.635 //x2=56.595 //y2=4.635
r1269 (  109 123 ) resistor r=2.38129 //w=0.183 //l=3.5223 //layer=m2 \
 //thickness=0.36 //x=51.395 //y=4.63 //x2=54.88 //y2=4.705
r1270 (  109 110 ) resistor r=0.329198 //w=0.131 //l=0.345 //layer=m2 \
 //thickness=0.36 //x=51.395 //y=4.63 //x2=51.05 //y2=4.63
r1271 (  107 110 ) resistor r=0.1875 //w=0.17 //l=0.259952 //layer=m2 \
 //thickness=0.36 //x=50.795 //y=4.62 //x2=51.05 //y2=4.63
r1272 (  107 108 ) resistor r=7.04198 //w=0.131 //l=7.38 //layer=m2 \
 //thickness=0.36 //x=50.795 //y=4.62 //x2=43.415 //y2=4.62
r1273 (  106 121 ) resistor r=1.71257 //w=0.177 //l=2.45235 //layer=m2 \
 //thickness=0.36 //x=42.17 //y=4.65 //x2=39.745 //y2=4.705
r1274 (  105 108 ) resistor r=0.125 //w=0.17 //l=0.184391 //layer=m2 \
 //thickness=0.36 //x=43.245 //y=4.65 //x2=43.415 //y2=4.62
r1275 (  105 106 ) resistor r=1.02576 //w=0.131 //l=1.075 //layer=m2 \
 //thickness=0.36 //x=43.245 //y=4.65 //x2=42.17 //y2=4.65
r1276 (  104 119 ) resistor r=1.17227 //w=0.183 //l=1.74965 //layer=m2 \
 //thickness=0.36 //x=32.175 //y=4.635 //x2=30.46 //y2=4.705
r1277 (  103 121 ) resistor r=5.1024 //w=0.177 //l=7.25992 //layer=m2 \
 //thickness=0.36 //x=32.52 //y=4.635 //x2=39.745 //y2=4.705
r1278 (  103 104 ) resistor r=0.329198 //w=0.131 //l=0.345 //layer=m2 \
 //thickness=0.36 //x=32.52 //y=4.635 //x2=32.175 //y2=4.635
r1279 (  101 119 ) resistor r=2.38129 //w=0.183 //l=3.5223 //layer=m2 \
 //thickness=0.36 //x=26.975 //y=4.63 //x2=30.46 //y2=4.705
r1280 (  101 102 ) resistor r=0.329198 //w=0.131 //l=0.345 //layer=m2 \
 //thickness=0.36 //x=26.975 //y=4.63 //x2=26.63 //y2=4.63
r1281 (  99 102 ) resistor r=0.1875 //w=0.17 //l=0.259952 //layer=m2 \
 //thickness=0.36 //x=26.375 //y=4.62 //x2=26.63 //y2=4.63
r1282 (  99 100 ) resistor r=4.56107 //w=0.131 //l=4.78 //layer=m2 \
 //thickness=0.36 //x=26.375 //y=4.62 //x2=21.595 //y2=4.62
r1283 (  97 100 ) resistor r=0.125 //w=0.17 //l=0.184391 //layer=m2 \
 //thickness=0.36 //x=21.425 //y=4.65 //x2=21.595 //y2=4.62
r1284 (  97 98 ) resistor r=0.329198 //w=0.131 //l=0.345 //layer=m2 \
 //thickness=0.36 //x=21.425 //y=4.65 //x2=21.08 //y2=4.65
r1285 (  95 98 ) resistor r=0.1875 //w=0.17 //l=0.269583 //layer=m2 \
 //thickness=0.36 //x=20.825 //y=4.62 //x2=21.08 //y2=4.65
r1286 (  95 96 ) resistor r=1.03053 //w=0.131 //l=1.08 //layer=m2 \
 //thickness=0.36 //x=20.825 //y=4.62 //x2=19.745 //y2=4.62
r1287 (  93 96 ) resistor r=0.125 //w=0.17 //l=0.184391 //layer=m2 \
 //thickness=0.36 //x=19.575 //y=4.65 //x2=19.745 //y2=4.62
r1288 (  93 94 ) resistor r=0.329198 //w=0.131 //l=0.345 //layer=m2 \
 //thickness=0.36 //x=19.575 //y=4.65 //x2=19.23 //y2=4.65
r1289 (  91 94 ) resistor r=0.1875 //w=0.17 //l=0.269583 //layer=m2 \
 //thickness=0.36 //x=18.975 //y=4.62 //x2=19.23 //y2=4.65
r1290 (  91 92 ) resistor r=0.677481 //w=0.131 //l=0.71 //layer=m2 \
 //thickness=0.36 //x=18.975 //y=4.62 //x2=18.265 //y2=4.62
r1291 (  90 117 ) resistor r=1.71257 //w=0.177 //l=2.45235 //layer=m2 \
 //thickness=0.36 //x=17.75 //y=4.65 //x2=15.325 //y2=4.705
r1292 (  89 92 ) resistor r=0.125 //w=0.17 //l=0.184391 //layer=m2 \
 //thickness=0.36 //x=18.095 //y=4.65 //x2=18.265 //y2=4.62
r1293 (  89 90 ) resistor r=0.329198 //w=0.131 //l=0.345 //layer=m2 \
 //thickness=0.36 //x=18.095 //y=4.65 //x2=17.75 //y2=4.65
r1294 (  87 117 ) resistor r=5.1024 //w=0.177 //l=7.25992 //layer=m2 \
 //thickness=0.36 //x=8.1 //y=4.635 //x2=15.325 //y2=4.705
r1295 (  87 88 ) resistor r=0.329198 //w=0.131 //l=0.345 //layer=m2 \
 //thickness=0.36 //x=8.1 //y=4.635 //x2=7.755 //y2=4.635
r1296 (  86 113 ) resistor r=0.0433913 //w=0.309 //l=0.16 //layer=m2 \
 //thickness=0.36 //x=6.2 //y=4.62 //x2=6.04 //y2=4.62
r1297 (  85 88 ) resistor r=0.1875 //w=0.17 //l=0.262393 //layer=m2 \
 //thickness=0.36 //x=7.5 //y=4.62 //x2=7.755 //y2=4.635
r1298 (  85 86 ) resistor r=1.24046 //w=0.131 //l=1.3 //layer=m2 \
 //thickness=0.36 //x=7.5 //y=4.62 //x2=6.2 //y2=4.62
r1299 (  84 182 ) resistor r=9.3 //w=0.17 //l=0.17 //layer=mcon //count=1 \
 //x=64.16 //y=4.88 //x2=64.16 //y2=4.88
r1300 (  82 125 ) resistor r=4.5 //w=0.15 //l=0.15 //layer=via1 //count=1 \
 //x=64.165 //y=4.75 //x2=64.165 //y2=4.75
r1301 (  82 84 ) resistor r=0.0547138 //w=0.297 //l=0.13 //layer=m1 \
 //thickness=0.36 //x=64.165 //y=4.75 //x2=64.165 //y2=4.88
r1302 (  77 177 ) resistor r=9.3 //w=0.17 //l=0.17 //layer=mcon //count=1 \
 //x=64.13 //y=2.26 //x2=64.13 //y2=2.26
r1303 (  77 79 ) resistor r=0.0936408 //w=0.196 //l=0.125 //layer=m1 \
 //thickness=0.36 //x=64.132 //y=2.26 //x2=64.132 //y2=2.385
r1304 (  75 172 ) resistor r=9.3 //w=0.17 //l=0.17 //layer=mcon //count=1 \
 //x=54.88 //y=4.88 //x2=54.88 //y2=4.88
r1305 (  73 123 ) resistor r=4.5 //w=0.15 //l=0.15 //layer=via1 //count=1 \
 //x=54.88 //y=4.755 //x2=54.88 //y2=4.755
r1306 (  73 75 ) resistor r=0.0533276 //w=0.293 //l=0.125 //layer=m1 \
 //thickness=0.36 //x=54.88 //y=4.755 //x2=54.88 //y2=4.88
r1307 (  70 167 ) resistor r=9.3 //w=0.17 //l=0.17 //layer=mcon //count=1 \
 //x=54.88 //y=2.26 //x2=54.88 //y2=2.26
r1308 (  68 162 ) resistor r=9.3 //w=0.17 //l=0.17 //layer=mcon //count=1 \
 //x=39.74 //y=4.88 //x2=39.74 //y2=4.88
r1309 (  66 121 ) resistor r=4.5 //w=0.15 //l=0.15 //layer=via1 //count=1 \
 //x=39.745 //y=4.75 //x2=39.745 //y2=4.75
r1310 (  66 68 ) resistor r=0.0547138 //w=0.297 //l=0.13 //layer=m1 \
 //thickness=0.36 //x=39.745 //y=4.75 //x2=39.745 //y2=4.88
r1311 (  61 157 ) resistor r=9.3 //w=0.17 //l=0.17 //layer=mcon //count=1 \
 //x=39.71 //y=2.26 //x2=39.71 //y2=2.26
r1312 (  61 63 ) resistor r=0.0936408 //w=0.196 //l=0.125 //layer=m1 \
 //thickness=0.36 //x=39.712 //y=2.26 //x2=39.712 //y2=2.385
r1313 (  59 152 ) resistor r=9.3 //w=0.17 //l=0.17 //layer=mcon //count=1 \
 //x=30.46 //y=4.88 //x2=30.46 //y2=4.88
r1314 (  57 119 ) resistor r=4.5 //w=0.15 //l=0.15 //layer=via1 //count=1 \
 //x=30.46 //y=4.755 //x2=30.46 //y2=4.755
r1315 (  57 59 ) resistor r=0.0533276 //w=0.293 //l=0.125 //layer=m1 \
 //thickness=0.36 //x=30.46 //y=4.755 //x2=30.46 //y2=4.88
r1316 (  54 147 ) resistor r=9.3 //w=0.17 //l=0.17 //layer=mcon //count=1 \
 //x=30.46 //y=2.26 //x2=30.46 //y2=2.26
r1317 (  52 142 ) resistor r=9.3 //w=0.17 //l=0.17 //layer=mcon //count=1 \
 //x=15.32 //y=4.88 //x2=15.32 //y2=4.88
r1318 (  50 117 ) resistor r=4.5 //w=0.15 //l=0.15 //layer=via1 //count=1 \
 //x=15.325 //y=4.75 //x2=15.325 //y2=4.75
r1319 (  50 52 ) resistor r=0.0547138 //w=0.297 //l=0.13 //layer=m1 \
 //thickness=0.36 //x=15.325 //y=4.75 //x2=15.325 //y2=4.88
r1320 (  45 137 ) resistor r=9.3 //w=0.17 //l=0.17 //layer=mcon //count=1 \
 //x=15.29 //y=2.26 //x2=15.29 //y2=2.26
r1321 (  45 47 ) resistor r=0.0936408 //w=0.196 //l=0.125 //layer=m1 \
 //thickness=0.36 //x=15.292 //y=2.26 //x2=15.292 //y2=2.385
r1322 (  43 132 ) resistor r=9.3 //w=0.17 //l=0.17 //layer=mcon //count=1 \
 //x=6.04 //y=4.88 //x2=6.04 //y2=4.88
r1323 (  41 115 ) resistor r=4.5 //w=0.15 //l=0.15 //layer=via1 //count=1 \
 //x=6.04 //y=4.755 //x2=6.04 //y2=4.755
r1324 (  41 43 ) resistor r=0.0533276 //w=0.293 //l=0.125 //layer=m1 \
 //thickness=0.36 //x=6.04 //y=4.755 //x2=6.04 //y2=4.88
r1325 (  38 127 ) resistor r=9.3 //w=0.17 //l=0.17 //layer=mcon //count=1 \
 //x=6.04 //y=2.26 //x2=6.04 //y2=2.26
r1326 (  31 70 ) resistor r=0.0715665 //w=0.226 //l=0.115996 //layer=m1 \
 //thickness=0.36 //x=54.88 //y=2.375 //x2=54.882 //y2=2.26
r1327 (  25 54 ) resistor r=0.0715665 //w=0.226 //l=0.115996 //layer=m1 \
 //thickness=0.36 //x=30.46 //y=2.375 //x2=30.462 //y2=2.26
r1328 (  16 38 ) resistor r=0.0715665 //w=0.226 //l=0.115996 //layer=m1 \
 //thickness=0.36 //x=6.04 //y=2.375 //x2=6.042 //y2=2.26
r1329 (  15 82 ) resistor r=0.0547138 //w=0.297 //l=0.13 //layer=m1 \
 //thickness=0.36 //x=64.165 //y=4.62 //x2=64.165 //y2=4.75
r1330 (  15 35 ) resistor r=0.0352913 //w=0.297 //l=0.047697 //layer=m1 \
 //thickness=0.36 //x=64.165 //y=4.62 //x2=64.13 //y2=4.59
r1331 (  14 73 ) resistor r=0.0575939 //w=0.293 //l=0.135 //layer=m1 \
 //thickness=0.36 //x=54.88 //y=4.62 //x2=54.88 //y2=4.755
r1332 (  14 32 ) resistor r=0.0325091 //w=0.293 //l=0.025 //layer=m1 \
 //thickness=0.36 //x=54.88 //y=4.62 //x2=54.88 //y2=4.595
r1333 (  13 66 ) resistor r=0.0547138 //w=0.297 //l=0.13 //layer=m1 \
 //thickness=0.36 //x=39.745 //y=4.62 //x2=39.745 //y2=4.75
r1334 (  13 29 ) resistor r=0.0352913 //w=0.297 //l=0.047697 //layer=m1 \
 //thickness=0.36 //x=39.745 //y=4.62 //x2=39.71 //y2=4.59
r1335 (  12 57 ) resistor r=0.0575939 //w=0.293 //l=0.135 //layer=m1 \
 //thickness=0.36 //x=30.46 //y=4.62 //x2=30.46 //y2=4.755
r1336 (  12 26 ) resistor r=0.0325091 //w=0.293 //l=0.025 //layer=m1 \
 //thickness=0.36 //x=30.46 //y=4.62 //x2=30.46 //y2=4.595
r1337 (  11 50 ) resistor r=0.0547138 //w=0.297 //l=0.13 //layer=m1 \
 //thickness=0.36 //x=15.325 //y=4.62 //x2=15.325 //y2=4.75
r1338 (  11 22 ) resistor r=0.0352913 //w=0.297 //l=0.047697 //layer=m1 \
 //thickness=0.36 //x=15.325 //y=4.62 //x2=15.29 //y2=4.59
r1339 (  10 41 ) resistor r=0.0575939 //w=0.293 //l=0.135 //layer=m1 \
 //thickness=0.36 //x=6.04 //y=4.62 //x2=6.04 //y2=4.755
r1340 (  10 17 ) resistor r=0.0325091 //w=0.293 //l=0.025 //layer=m1 \
 //thickness=0.36 //x=6.04 //y=4.62 //x2=6.04 //y2=4.595
r1341 (  9 35 ) resistor r=1.73664 //w=0.131 //l=1.82 //layer=m1 \
 //thickness=0.36 //x=64.13 //y=2.77 //x2=64.13 //y2=4.59
r1342 (  9 79 ) resistor r=0.367366 //w=0.131 //l=0.385 //layer=m1 \
 //thickness=0.36 //x=64.13 //y=2.77 //x2=64.13 //y2=2.385
r1343 (  8 32 ) resistor r=0.682252 //w=0.131 //l=0.715 //layer=m1 \
 //thickness=0.36 //x=54.88 //y=3.88 //x2=54.88 //y2=4.595
r1344 (  8 31 ) resistor r=1.43607 //w=0.131 //l=1.505 //layer=m1 \
 //thickness=0.36 //x=54.88 //y=3.88 //x2=54.88 //y2=2.375
r1345 (  7 29 ) resistor r=1.73664 //w=0.131 //l=1.82 //layer=m1 \
 //thickness=0.36 //x=39.71 //y=2.77 //x2=39.71 //y2=4.59
r1346 (  7 63 ) resistor r=0.367366 //w=0.131 //l=0.385 //layer=m1 \
 //thickness=0.36 //x=39.71 //y=2.77 //x2=39.71 //y2=2.385
r1347 (  6 26 ) resistor r=0.682252 //w=0.131 //l=0.715 //layer=m1 \
 //thickness=0.36 //x=30.46 //y=3.88 //x2=30.46 //y2=4.595
r1348 (  6 25 ) resistor r=1.43607 //w=0.131 //l=1.505 //layer=m1 \
 //thickness=0.36 //x=30.46 //y=3.88 //x2=30.46 //y2=2.375
r1349 (  5 22 ) resistor r=1.03053 //w=0.131 //l=1.08 //layer=m1 \
 //thickness=0.36 //x=15.29 //y=3.51 //x2=15.29 //y2=4.59
r1350 (  4 5 ) resistor r=0.706107 //w=0.131 //l=0.74 //layer=m1 \
 //thickness=0.36 //x=15.29 //y=2.77 //x2=15.29 //y2=3.51
r1351 (  4 47 ) resistor r=0.367366 //w=0.131 //l=0.385 //layer=m1 \
 //thickness=0.36 //x=15.29 //y=2.77 //x2=15.29 //y2=2.385
r1352 (  3 17 ) resistor r=0.682252 //w=0.131 //l=0.715 //layer=m1 \
 //thickness=0.36 //x=6.04 //y=3.88 //x2=6.04 //y2=4.595
r1353 (  2 3 ) resistor r=0.353053 //w=0.131 //l=0.37 //layer=m1 \
 //thickness=0.36 //x=6.04 //y=3.51 //x2=6.04 //y2=3.88
r1354 (  1 2 ) resistor r=1.05916 //w=0.131 //l=1.11 //layer=m1 \
 //thickness=0.36 //x=6.04 //y=2.4 //x2=6.04 //y2=3.51
r1355 (  1 16 ) resistor r=0.023855 //w=0.131 //l=0.025 //layer=m1 \
 //thickness=0.36 //x=6.04 //y=2.4 //x2=6.04 //y2=2.375
ends PM_TMRDFFSNQX1\%CLK

subckt PM_TMRDFFSNQX1\%noxref_16 ( 2 3 4 5 7 10 11 13 14 15 16 18 19 20 22 23 \
 26 34 35 38 41 47 50 54 57 58 60 63 67 71 72 75 84 89 97 105 122 131 135 136 \
 137 138 139 140 141 142 143 148 150 152 158 159 160 161 162 163 167 169 172 \
 173 178 179 182 196 199 201 202 203 )
c497 ( 199 0 ) capacitor c=0.00885916f //x=56.055 //y=1.095
c498 ( 196 0 ) capacitor c=0.0633698f //x=66.72 //y=4.88
c499 ( 182 0 ) capacitor c=0.0354953f //x=51.21 //y=4.88
c500 ( 179 0 ) capacitor c=0.0284095f //x=51.18 //y=2.095
c501 ( 178 0 ) capacitor c=0.0476356f //x=51.18 //y=2.26
c502 ( 173 0 ) capacitor c=0.0318956f //x=67.055 //y=1.39
c503 ( 172 0 ) capacitor c=0.0186809f //x=67.055 //y=1.045
c504 ( 169 0 ) capacitor c=0.0141821f //x=66.9 //y=1.545
c505 ( 167 0 ) capacitor c=0.0158553f //x=66.9 //y=0.89
c506 ( 163 0 ) capacitor c=0.088055f //x=66.525 //y=2.095
c507 ( 162 0 ) capacitor c=0.0229235f //x=66.525 //y=1.7
c508 ( 161 0 ) capacitor c=0.0234359f //x=66.525 //y=1.39
c509 ( 160 0 ) capacitor c=0.0198759f //x=66.525 //y=1.045
c510 ( 159 0 ) capacitor c=0.0439708f //x=51.745 //y=1.43
c511 ( 158 0 ) capacitor c=0.0192582f //x=51.745 //y=1.085
c512 ( 152 0 ) capacitor c=0.0162526f //x=51.59 //y=1.585
c513 ( 150 0 ) capacitor c=0.0157807f //x=51.59 //y=0.93
c514 ( 148 0 ) capacitor c=0.0357885f //x=51.585 //y=4.97
c515 ( 143 0 ) capacitor c=0.0210762f //x=51.215 //y=1.74
c516 ( 142 0 ) capacitor c=0.0168511f //x=51.215 //y=1.43
c517 ( 141 0 ) capacitor c=0.0175485f //x=51.215 //y=1.085
c518 ( 140 0 ) capacitor c=0.110235f //x=67.06 //y=6.2
c519 ( 139 0 ) capacitor c=0.154619f //x=66.62 //y=6.2
c520 ( 138 0 ) capacitor c=0.155269f //x=51.66 //y=6.2
c521 ( 137 0 ) capacitor c=0.110375f //x=51.22 //y=6.2
c522 ( 131 0 ) capacitor c=5.6005e-19 //x=66.72 //y=4.88
c523 ( 122 0 ) capacitor c=7.85889e-19 //x=66.72 //y=2.26
c524 ( 105 0 ) capacitor c=0.0293709f //x=55.95 //y=5.56
c525 ( 97 0 ) capacitor c=0.029137f //x=55.07 //y=5.56
c526 ( 89 0 ) capacitor c=0.0277605f //x=54.19 //y=5.56
c527 ( 84 0 ) capacitor c=5.80994e-19 //x=51.21 //y=4.88
c528 ( 75 0 ) capacitor c=5.78095e-19 //x=51.18 //y=2.26
c529 ( 72 0 ) capacitor c=0.129792f //x=66.56 //y=4.265
c530 ( 71 0 ) capacitor c=0.00334332f //x=66.72 //y=4.265
c531 ( 67 0 ) capacitor c=7.93125e-19 //x=51.34 //y=4.245
c532 ( 63 0 ) capacitor c=9.81648e-19 //x=56.885 //y=4.25
c533 ( 60 0 ) capacitor c=0.0589187f //x=56.565 //y=4.25
c534 ( 58 0 ) capacitor c=0.00548117f //x=66.722 //y=4.74
c535 ( 57 0 ) capacitor c=0.00585551f //x=66.72 //y=4.88
c536 ( 54 0 ) capacitor c=0.00463527f //x=66.72 //y=2.26
c537 ( 50 0 ) capacitor c=0.0145916f //x=66.72 //y=4.25
c538 ( 47 0 ) capacitor c=0.0149922f //x=56.725 //y=4.25
c539 ( 41 0 ) capacitor c=8.88597e-19 //x=55.95 //y=5.335
c540 ( 38 0 ) capacitor c=0.0073827f //x=55.07 //y=5.335
c541 ( 35 0 ) capacitor c=0.0112819f //x=54.192 //y=5.335
c542 ( 34 0 ) capacitor c=0.0152963f //x=51.18 //y=4.25
c543 ( 26 0 ) capacitor c=0.00504845f //x=51.18 //y=2.26
c544 ( 23 0 ) capacitor c=0.0118473f //x=66.72 //y=4.425
c545 ( 22 0 ) capacitor c=0.0475343f //x=66.72 //y=4.105
c546 ( 20 0 ) capacitor c=0.0222419f //x=56.73 //y=5.25
c547 ( 19 0 ) capacitor c=0.0128722f //x=56.73 //y=4.41
c548 ( 18 0 ) capacitor c=0.0595446f //x=56.73 //y=4.09
c549 ( 16 0 ) capacitor c=0.0048771f //x=56.33 //y=1.845
c550 ( 15 0 ) capacitor c=0.0132264f //x=56.645 //y=1.845
c551 ( 14 0 ) capacitor c=0.0167333f //x=56.245 //y=1.76
c552 ( 13 0 ) capacitor c=0.0111164f //x=56.245 //y=1.305
c553 ( 11 0 ) capacitor c=0.0223199f //x=56.645 //y=5.335
c554 ( 10 0 ) capacitor c=0.00933983f //x=55.95 //y=5.56
c555 ( 7 0 ) capacitor c=0.019596f //x=55.835 //y=5.335
c556 ( 5 0 ) capacitor c=0.0147581f //x=54.95 //y=5.335
c557 ( 4 0 ) capacitor c=0.00931067f //x=51.18 //y=4.735
c558 ( 3 0 ) capacitor c=0.0102157f //x=51.18 //y=4.405
c559 ( 2 0 ) capacitor c=0.0357445f //x=51.18 //y=4.085
r560 (  194 196 ) resistor r=20.6867 //w=0.233 //l=0.1 //layer=ply \
 //thickness=0.18 //x=66.62 //y=4.88 //x2=66.72 //y2=4.88
r561 (  184 185 ) resistor r=32.4568 //w=0.214 //l=0.075 //layer=ply \
 //thickness=0.18 //x=51.21 //y=4.97 //x2=51.21 //y2=5.045
r562 (  182 184 ) resistor r=20.271 //w=0.214 //l=0.09 //layer=ply \
 //thickness=0.18 //x=51.21 //y=4.88 //x2=51.21 //y2=4.97
r563 (  178 179 ) resistor r=52.7279 //w=0.214 //l=0.165 //layer=ply \
 //thickness=0.18 //x=51.18 //y=2.26 //x2=51.18 //y2=2.095
r564 (  174 196 ) resistor r=70.3348 //w=0.233 //l=0.414367 //layer=ply \
 //thickness=0.18 //x=67.06 //y=5.045 //x2=66.72 //y2=4.88
r565 (  173 198 ) resistor r=45.1352 //w=0.168 //l=0.173853 //layer=ply \
 //thickness=0.18 //x=67.055 //y=1.39 //x2=67.015 //y2=1.545
r566 (  172 197 ) resistor r=45.1352 //w=0.168 //l=0.173853 //layer=ply \
 //thickness=0.18 //x=67.055 //y=1.045 //x2=67.015 //y2=0.89
r567 (  172 173 ) resistor r=176.904 //w=0.094 //l=0.345 //layer=ply \
 //thickness=0.18 //x=67.055 //y=1.045 //x2=67.055 //y2=1.39
r568 (  170 193 ) resistor r=10.701 //w=0.21 //l=0.115 //layer=ply \
 //thickness=0.18 //x=66.68 //y=1.545 //x2=66.565 //y2=1.545
r569 (  169 198 ) resistor r=5.52526 //w=0.168 //l=0.115 //layer=ply \
 //thickness=0.18 //x=66.9 //y=1.545 //x2=67.015 //y2=1.545
r570 (  168 192 ) resistor r=5.52526 //w=0.168 //l=0.115 //layer=ply \
 //thickness=0.18 //x=66.68 //y=0.89 //x2=66.565 //y2=0.89
r571 (  167 197 ) resistor r=5.52526 //w=0.168 //l=0.115 //layer=ply \
 //thickness=0.18 //x=66.9 //y=0.89 //x2=67.015 //y2=0.89
r572 (  167 168 ) resistor r=112.809 //w=0.094 //l=0.22 //layer=ply \
 //thickness=0.18 //x=66.9 //y=0.89 //x2=66.68 //y2=0.89
r573 (  164 194 ) resistor r=13.0941 //w=0.233 //l=0.165 //layer=ply \
 //thickness=0.18 //x=66.62 //y=5.045 //x2=66.62 //y2=4.88
r574 (  163 191 ) resistor r=34.8111 //w=0.27 //l=0.264953 //layer=ply \
 //thickness=0.18 //x=66.525 //y=2.095 //x2=66.72 //y2=2.26
r575 (  162 193 ) resistor r=39.5823 //w=0.21 //l=0.173853 //layer=ply \
 //thickness=0.18 //x=66.525 //y=1.7 //x2=66.565 //y2=1.545
r576 (  162 163 ) resistor r=202.543 //w=0.094 //l=0.395 //layer=ply \
 //thickness=0.18 //x=66.525 //y=1.7 //x2=66.525 //y2=2.095
r577 (  161 193 ) resistor r=39.5823 //w=0.21 //l=0.173853 //layer=ply \
 //thickness=0.18 //x=66.525 //y=1.39 //x2=66.565 //y2=1.545
r578 (  160 192 ) resistor r=45.1352 //w=0.168 //l=0.173853 //layer=ply \
 //thickness=0.18 //x=66.525 //y=1.045 //x2=66.565 //y2=0.89
r579 (  160 161 ) resistor r=176.904 //w=0.094 //l=0.345 //layer=ply \
 //thickness=0.18 //x=66.525 //y=1.045 //x2=66.525 //y2=1.39
r580 (  159 189 ) resistor r=45.1352 //w=0.168 //l=0.173853 //layer=ply \
 //thickness=0.18 //x=51.745 //y=1.43 //x2=51.705 //y2=1.585
r581 (  158 188 ) resistor r=45.1352 //w=0.168 //l=0.173853 //layer=ply \
 //thickness=0.18 //x=51.745 //y=1.085 //x2=51.705 //y2=0.93
r582 (  158 159 ) resistor r=176.904 //w=0.094 //l=0.345 //layer=ply \
 //thickness=0.18 //x=51.745 //y=1.085 //x2=51.745 //y2=1.43
r583 (  153 187 ) resistor r=10.701 //w=0.21 //l=0.115 //layer=ply \
 //thickness=0.18 //x=51.37 //y=1.585 //x2=51.255 //y2=1.585
r584 (  152 189 ) resistor r=5.52526 //w=0.168 //l=0.115 //layer=ply \
 //thickness=0.18 //x=51.59 //y=1.585 //x2=51.705 //y2=1.585
r585 (  151 186 ) resistor r=5.52526 //w=0.168 //l=0.115 //layer=ply \
 //thickness=0.18 //x=51.37 //y=0.93 //x2=51.255 //y2=0.93
r586 (  150 188 ) resistor r=5.52526 //w=0.168 //l=0.115 //layer=ply \
 //thickness=0.18 //x=51.59 //y=0.93 //x2=51.705 //y2=0.93
r587 (  150 151 ) resistor r=112.809 //w=0.094 //l=0.22 //layer=ply \
 //thickness=0.18 //x=51.59 //y=0.93 //x2=51.37 //y2=0.93
r588 (  149 184 ) resistor r=16.5046 //w=0.27 //l=0.135 //layer=ply \
 //thickness=0.18 //x=51.345 //y=4.97 //x2=51.21 //y2=4.97
r589 (  148 155 ) resistor r=26.9307 //w=0.15 //l=0.106066 //layer=ply \
 //thickness=0.18 //x=51.585 //y=4.97 //x2=51.66 //y2=5.045
r590 (  148 149 ) resistor r=123.064 //w=0.094 //l=0.24 //layer=ply \
 //thickness=0.18 //x=51.585 //y=4.97 //x2=51.345 //y2=4.97
r591 (  143 187 ) resistor r=39.5823 //w=0.21 //l=0.173853 //layer=ply \
 //thickness=0.18 //x=51.215 //y=1.74 //x2=51.255 //y2=1.585
r592 (  143 179 ) resistor r=182.032 //w=0.094 //l=0.355 //layer=ply \
 //thickness=0.18 //x=51.215 //y=1.74 //x2=51.215 //y2=2.095
r593 (  142 187 ) resistor r=39.5823 //w=0.21 //l=0.173853 //layer=ply \
 //thickness=0.18 //x=51.215 //y=1.43 //x2=51.255 //y2=1.585
r594 (  141 186 ) resistor r=45.1352 //w=0.168 //l=0.173853 //layer=ply \
 //thickness=0.18 //x=51.215 //y=1.085 //x2=51.255 //y2=0.93
r595 (  141 142 ) resistor r=176.904 //w=0.094 //l=0.345 //layer=ply \
 //thickness=0.18 //x=51.215 //y=1.085 //x2=51.215 //y2=1.43
r596 (  140 174 ) resistor r=592.245 //w=0.094 //l=1.155 //layer=ply \
 //thickness=0.18 //x=67.06 //y=6.2 //x2=67.06 //y2=5.045
r597 (  139 164 ) resistor r=592.245 //w=0.094 //l=1.155 //layer=ply \
 //thickness=0.18 //x=66.62 //y=6.2 //x2=66.62 //y2=5.045
r598 (  138 155 ) resistor r=592.245 //w=0.094 //l=1.155 //layer=ply \
 //thickness=0.18 //x=51.66 //y=6.2 //x2=51.66 //y2=5.045
r599 (  137 185 ) resistor r=592.245 //w=0.094 //l=1.155 //layer=ply \
 //thickness=0.18 //x=51.22 //y=6.2 //x2=51.22 //y2=5.045
r600 (  136 169 ) resistor r=56.4043 //w=0.094 //l=0.11 //layer=ply \
 //thickness=0.18 //x=66.79 //y=1.545 //x2=66.9 //y2=1.545
r601 (  136 170 ) resistor r=56.4043 //w=0.094 //l=0.11 //layer=ply \
 //thickness=0.18 //x=66.79 //y=1.545 //x2=66.68 //y2=1.545
r602 (  135 152 ) resistor r=56.4043 //w=0.094 //l=0.11 //layer=ply \
 //thickness=0.18 //x=51.48 //y=1.585 //x2=51.59 //y2=1.585
r603 (  135 153 ) resistor r=56.4043 //w=0.094 //l=0.11 //layer=ply \
 //thickness=0.18 //x=51.48 //y=1.585 //x2=51.37 //y2=1.585
r604 (  131 196 ) resistor r=152 //w=0.17 //l=0.17 //layer=licon //count=1 \
 //x=66.72 //y=4.88 //x2=66.72 //y2=4.88
r605 (  122 191 ) resistor r=152 //w=0.17 //l=0.17 //layer=licon //count=1 \
 //x=66.72 //y=2.26 //x2=66.72 //y2=2.26
r606 (  105 203 ) resistor r=23.615 //w=0.187 //l=0.345 //layer=li \
 //thickness=0.1 //x=55.95 //y=5.56 //x2=55.95 //y2=5.905
r607 (  97 202 ) resistor r=23.615 //w=0.187 //l=0.345 //layer=li \
 //thickness=0.1 //x=55.07 //y=5.56 //x2=55.07 //y2=5.905
r608 (  89 201 ) resistor r=23.615 //w=0.187 //l=0.345 //layer=li \
 //thickness=0.1 //x=54.19 //y=5.56 //x2=54.19 //y2=5.905
r609 (  84 182 ) resistor r=152 //w=0.17 //l=0.17 //layer=licon //count=1 \
 //x=51.21 //y=4.88 //x2=51.21 //y2=4.88
r610 (  75 178 ) resistor r=152 //w=0.17 //l=0.17 //layer=licon //count=1 \
 //x=51.18 //y=2.26 //x2=51.18 //y2=2.26
r611 (  71 72 ) resistor r=0.10734 //w=0.281 //l=0.16 //layer=m2 \
 //thickness=0.36 //x=66.72 //y=4.265 //x2=66.56 //y2=4.265
r612 (  65 67 ) resistor r=0.10734 //w=0.281 //l=0.16 //layer=m2 \
 //thickness=0.36 //x=51.18 //y=4.245 //x2=51.34 //y2=4.245
r613 (  63 69 ) resistor r=0.10734 //w=0.281 //l=0.16 //layer=m2 \
 //thickness=0.36 //x=56.885 //y=4.25 //x2=56.725 //y2=4.25
r614 (  63 72 ) resistor r=9.23187 //w=0.131 //l=9.675 //layer=m2 \
 //thickness=0.36 //x=56.885 //y=4.25 //x2=66.56 //y2=4.25
r615 (  60 69 ) resistor r=0.10734 //w=0.281 //l=0.16 //layer=m2 \
 //thickness=0.36 //x=56.565 //y=4.25 //x2=56.725 //y2=4.25
r616 (  60 67 ) resistor r=4.98569 //w=0.131 //l=5.225 //layer=m2 \
 //thickness=0.36 //x=56.565 //y=4.25 //x2=51.34 //y2=4.25
r617 (  57 131 ) resistor r=9.3 //w=0.17 //l=0.17 //layer=mcon //count=1 \
 //x=66.72 //y=4.88 //x2=66.72 //y2=4.88
r618 (  57 58 ) resistor r=0.103207 //w=0.196 //l=0.14 //layer=m1 \
 //thickness=0.36 //x=66.722 //y=4.88 //x2=66.722 //y2=4.74
r619 (  54 122 ) resistor r=9.3 //w=0.17 //l=0.17 //layer=mcon //count=1 \
 //x=66.72 //y=2.26 //x2=66.72 //y2=2.26
r620 (  52 71 ) resistor r=4.5 //w=0.15 //l=0.15 //layer=via1 //count=1 \
 //x=66.72 //y=4.265 //x2=66.72 //y2=4.265
r621 (  50 52 ) resistor r=0.0049867 //w=0.376 //l=0.015 //layer=m1 \
 //thickness=0.36 //x=66.667 //y=4.25 //x2=66.667 //y2=4.265
r622 (  47 69 ) resistor r=4.5 //w=0.15 //l=0.15 //layer=via1 //count=1 \
 //x=56.725 //y=4.25 //x2=56.725 //y2=4.25
r623 (  45 199 ) resistor r=9.3 //w=0.17 //l=0.17 //layer=mcon //count=1 \
 //x=56.245 //y=1.19 //x2=56.245 //y2=1.19
r624 (  43 105 ) resistor r=9.3 //w=0.17 //l=0.17 //layer=mcon //count=1 \
 //x=55.95 //y=5.56 //x2=55.95 //y2=5.56
r625 (  40 97 ) resistor r=9.3 //w=0.17 //l=0.17 //layer=mcon //count=1 \
 //x=55.07 //y=5.56 //x2=55.07 //y2=5.56
r626 (  38 40 ) resistor r=0.121228 //w=0.232 //l=0.225 //layer=m1 \
 //thickness=0.36 //x=55.07 //y=5.335 //x2=55.07 //y2=5.56
r627 (  37 89 ) resistor r=9.3 //w=0.17 //l=0.17 //layer=mcon //count=1 \
 //x=54.19 //y=5.56 //x2=54.19 //y2=5.56
r628 (  35 37 ) resistor r=0.129608 //w=0.217 //l=0.225 //layer=m1 \
 //thickness=0.36 //x=54.192 //y=5.335 //x2=54.192 //y2=5.56
r629 (  32 65 ) resistor r=4.5 //w=0.15 //l=0.15 //layer=via1 //count=1 \
 //x=51.18 //y=4.245 //x2=51.18 //y2=4.245
r630 (  32 34 ) resistor r=0.00166223 //w=0.376 //l=0.005 //layer=m1 \
 //thickness=0.36 //x=51.232 //y=4.245 //x2=51.232 //y2=4.25
r631 (  30 84 ) resistor r=9.3 //w=0.17 //l=0.17 //layer=mcon //count=1 \
 //x=51.21 //y=4.88 //x2=51.21 //y2=4.88
r632 (  26 75 ) resistor r=9.3 //w=0.17 //l=0.17 //layer=mcon //count=1 \
 //x=51.18 //y=2.26 //x2=51.18 //y2=2.26
r633 (  26 28 ) resistor r=0.0936408 //w=0.196 //l=0.125 //layer=m1 \
 //thickness=0.36 //x=51.182 //y=2.26 //x2=51.182 //y2=2.385
r634 (  23 52 ) resistor r=0.0911593 //w=0.376 //l=0.184608 //layer=m1 \
 //thickness=0.36 //x=66.72 //y=4.425 //x2=66.667 //y2=4.265
r635 (  23 58 ) resistor r=0.300573 //w=0.131 //l=0.315 //layer=m1 \
 //thickness=0.36 //x=66.72 //y=4.425 //x2=66.72 //y2=4.74
r636 (  22 50 ) resistor r=0.0861726 //w=0.376 //l=0.16944 //layer=m1 \
 //thickness=0.36 //x=66.72 //y=4.105 //x2=66.667 //y2=4.25
r637 (  21 54 ) resistor r=0.0933015 //w=0.201 //l=0.125 //layer=m1 \
 //thickness=0.36 //x=66.72 //y=2.385 //x2=66.72 //y2=2.26
r638 (  21 22 ) resistor r=1.64122 //w=0.131 //l=1.72 //layer=m1 \
 //thickness=0.36 //x=66.72 //y=2.385 //x2=66.72 //y2=4.105
r639 (  19 47 ) resistor r=0.0911593 //w=0.376 //l=0.181989 //layer=m1 \
 //thickness=0.36 //x=56.73 //y=4.41 //x2=56.777 //y2=4.25
r640 (  19 20 ) resistor r=0.801527 //w=0.131 //l=0.84 //layer=m1 \
 //thickness=0.36 //x=56.73 //y=4.41 //x2=56.73 //y2=5.25
r641 (  18 47 ) resistor r=0.0911593 //w=0.376 //l=0.181989 //layer=m1 \
 //thickness=0.36 //x=56.73 //y=4.09 //x2=56.777 //y2=4.25
r642 (  17 18 ) resistor r=2.06107 //w=0.131 //l=2.16 //layer=m1 \
 //thickness=0.36 //x=56.73 //y=1.93 //x2=56.73 //y2=4.09
r643 (  15 17 ) resistor r=0.0698411 //w=0.17 //l=0.120208 //layer=m1 \
 //thickness=0.36 //x=56.645 //y=1.845 //x2=56.73 //y2=1.93
r644 (  15 16 ) resistor r=0.300573 //w=0.131 //l=0.315 //layer=m1 \
 //thickness=0.36 //x=56.645 //y=1.845 //x2=56.33 //y2=1.845
r645 (  14 16 ) resistor r=0.0698411 //w=0.17 //l=0.120208 //layer=m1 \
 //thickness=0.36 //x=56.245 //y=1.76 //x2=56.33 //y2=1.845
r646 (  13 45 ) resistor r=0.0717383 //w=0.224 //l=0.115 //layer=m1 \
 //thickness=0.36 //x=56.245 //y=1.305 //x2=56.245 //y2=1.19
r647 (  13 14 ) resistor r=0.43416 //w=0.131 //l=0.455 //layer=m1 \
 //thickness=0.36 //x=56.245 //y=1.305 //x2=56.245 //y2=1.76
r648 (  12 41 ) resistor r=0.0675342 //w=0.23 //l=0.115 //layer=m1 \
 //thickness=0.36 //x=56.065 //y=5.335 //x2=55.95 //y2=5.335
r649 (  11 20 ) resistor r=0.0698411 //w=0.17 //l=0.120208 //layer=m1 \
 //thickness=0.36 //x=56.645 //y=5.335 //x2=56.73 //y2=5.25
r650 (  11 12 ) resistor r=0.553435 //w=0.131 //l=0.58 //layer=m1 \
 //thickness=0.36 //x=56.645 //y=5.335 //x2=56.065 //y2=5.335
r651 (  10 43 ) resistor r=0.00118313 //w=0.23 //layer=m1 //thickness=0.36 \
 //x=55.95 //y=5.56 //x2=55.95 //y2=5.56
r652 (  9 41 ) resistor r=0.002872 //w=0.34 //l=0.085 //layer=m1 \
 //thickness=0.36 //x=55.95 //y=5.42 //x2=55.95 //y2=5.335
r653 (  9 10 ) resistor r=0.091623 //w=0.191 //l=0.14 //layer=m1 \
 //thickness=0.36 //x=55.95 //y=5.42 //x2=55.95 //y2=5.56
r654 (  8 38 ) resistor r=0.0262263 //w=0.232 //l=0.12 //layer=m1 \
 //thickness=0.36 //x=55.19 //y=5.335 //x2=55.07 //y2=5.335
r655 (  7 41 ) resistor r=0.0675342 //w=0.23 //l=0.115 //layer=m1 \
 //thickness=0.36 //x=55.835 //y=5.335 //x2=55.95 //y2=5.335
r656 (  7 8 ) resistor r=0.615458 //w=0.131 //l=0.645 //layer=m1 \
 //thickness=0.36 //x=55.835 //y=5.335 //x2=55.19 //y2=5.335
r657 (  6 35 ) resistor r=0.0222262 //w=0.217 //l=0.118 //layer=m1 \
 //thickness=0.36 //x=54.31 //y=5.335 //x2=54.192 //y2=5.335
r658 (  5 38 ) resistor r=0.0262263 //w=0.232 //l=0.12 //layer=m1 \
 //thickness=0.36 //x=54.95 //y=5.335 //x2=55.07 //y2=5.335
r659 (  5 6 ) resistor r=0.610687 //w=0.131 //l=0.64 //layer=m1 \
 //thickness=0.36 //x=54.95 //y=5.335 //x2=54.31 //y2=5.335
r660 (  4 30 ) resistor r=0.0878548 //w=0.228 //l=0.159295 //layer=m1 \
 //thickness=0.36 //x=51.18 //y=4.735 //x2=51.21 //y2=4.88
r661 (  3 34 ) resistor r=0.0894971 //w=0.376 //l=0.179123 //layer=m1 \
 //thickness=0.36 //x=51.18 //y=4.405 //x2=51.232 //y2=4.25
r662 (  3 4 ) resistor r=0.314885 //w=0.131 //l=0.33 //layer=m1 \
 //thickness=0.36 //x=51.18 //y=4.405 //x2=51.18 //y2=4.735
r663 (  2 32 ) resistor r=0.0911593 //w=0.376 //l=0.184174 //layer=m1 \
 //thickness=0.36 //x=51.18 //y=4.085 //x2=51.232 //y2=4.245
r664 (  2 28 ) resistor r=1.62214 //w=0.131 //l=1.7 //layer=m1 \
 //thickness=0.36 //x=51.18 //y=4.085 //x2=51.18 //y2=2.385
ends PM_TMRDFFSNQX1\%noxref_16

subckt PM_TMRDFFSNQX1\%noxref_17 ( 3 8 9 11 12 14 15 16 19 20 23 25 28 30 35 \
 43 45 46 49 57 74 79 83 84 85 86 87 88 89 90 92 98 99 100 101 113 115 116 )
c272 ( 113 0 ) capacitor c=0.00878249f //x=67.57 //y=1.085
c273 ( 101 0 ) capacitor c=0.059695f //x=70.325 //y=4.97
c274 ( 100 0 ) capacitor c=0.0376642f //x=70.615 //y=4.97
c275 ( 99 0 ) capacitor c=0.0346489f //x=70.28 //y=1.4
c276 ( 98 0 ) capacitor c=0.018692f //x=70.28 //y=1.055
c277 ( 92 0 ) capacitor c=0.0137077f //x=70.125 //y=1.555
c278 ( 90 0 ) capacitor c=0.0158585f //x=70.125 //y=0.9
c279 ( 89 0 ) capacitor c=0.1037f //x=69.75 //y=2.095
c280 ( 88 0 ) capacitor c=0.0229444f //x=69.75 //y=1.71
c281 ( 87 0 ) capacitor c=0.0234359f //x=69.75 //y=1.4
c282 ( 86 0 ) capacitor c=0.019815f //x=69.75 //y=1.055
c283 ( 85 0 ) capacitor c=0.110208f //x=70.69 //y=6.2
c284 ( 84 0 ) capacitor c=0.157753f //x=70.25 //y=6.2
c285 ( 79 0 ) capacitor c=0.00157752f //x=70.05 //y=4.88
c286 ( 74 0 ) capacitor c=0.0012618f //x=70.05 //y=2.26
c287 ( 57 0 ) capacitor c=0.0319332f //x=67.72 //y=5.56
c288 ( 49 0 ) capacitor c=0.0290435f //x=66.84 //y=5.56
c289 ( 46 0 ) capacitor c=0.0345172f //x=69.88 //y=5.005
c290 ( 45 0 ) capacitor c=0.00639614f //x=70.04 //y=5.005
c291 ( 43 0 ) capacitor c=0.0138146f //x=68.435 //y=5.03
c292 ( 35 0 ) capacitor c=0.00964353f //x=70.05 //y=4.88
c293 ( 30 0 ) capacitor c=0.0215315f //x=68.275 //y=5.03
c294 ( 28 0 ) capacitor c=0.0144429f //x=68.2 //y=4.99
c295 ( 25 0 ) capacitor c=0.0112381f //x=67.76 //y=1.18
c296 ( 23 0 ) capacitor c=5.78613e-19 //x=67.72 //y=5.56
c297 ( 20 0 ) capacitor c=0.0104614f //x=67.72 //y=5.38
c298 ( 19 0 ) capacitor c=0.00911838f //x=66.84 //y=5.56
c299 ( 16 0 ) capacitor c=0.0747686f //x=70.05 //y=4.755
c300 ( 15 0 ) capacitor c=0.00492791f //x=70.05 //y=2.375
c301 ( 14 0 ) capacitor c=0.0785106f //x=68.2 //y=4.87
c302 ( 12 0 ) capacitor c=0.00465779f //x=67.845 //y=1.835
c303 ( 11 0 ) capacitor c=0.0120938f //x=68.115 //y=1.835
c304 ( 9 0 ) capacitor c=0.0065185f //x=68.115 //y=5.38
c305 ( 8 0 ) capacitor c=0.0133876f //x=67.76 //y=1.75
c306 ( 3 0 ) capacitor c=0.0148074f //x=67.605 //y=5.38
r307 (  100 102 ) resistor r=26.9307 //w=0.15 //l=0.106066 //layer=ply \
 //thickness=0.18 //x=70.615 //y=4.97 //x2=70.69 //y2=5.045
r308 (  100 101 ) resistor r=148.702 //w=0.094 //l=0.29 //layer=ply \
 //thickness=0.18 //x=70.615 //y=4.97 //x2=70.325 //y2=4.97
r309 (  99 112 ) resistor r=45.1352 //w=0.168 //l=0.173853 //layer=ply \
 //thickness=0.18 //x=70.28 //y=1.4 //x2=70.24 //y2=1.555
r310 (  98 111 ) resistor r=45.1352 //w=0.168 //l=0.173853 //layer=ply \
 //thickness=0.18 //x=70.28 //y=1.055 //x2=70.24 //y2=0.9
r311 (  98 99 ) resistor r=176.904 //w=0.094 //l=0.345 //layer=ply \
 //thickness=0.18 //x=70.28 //y=1.055 //x2=70.28 //y2=1.4
r312 (  95 101 ) resistor r=22.7971 //w=0.269 //l=0.106066 //layer=ply \
 //thickness=0.18 //x=70.25 //y=5.045 //x2=70.325 //y2=4.97
r313 (  95 110 ) resistor r=35.8364 //w=0.269 //l=0.270185 //layer=ply \
 //thickness=0.18 //x=70.25 //y=5.045 //x2=70.05 //y2=4.88
r314 (  93 106 ) resistor r=10.701 //w=0.21 //l=0.115 //layer=ply \
 //thickness=0.18 //x=69.905 //y=1.555 //x2=69.79 //y2=1.555
r315 (  92 112 ) resistor r=5.52526 //w=0.168 //l=0.115 //layer=ply \
 //thickness=0.18 //x=70.125 //y=1.555 //x2=70.24 //y2=1.555
r316 (  91 105 ) resistor r=5.52526 //w=0.168 //l=0.115 //layer=ply \
 //thickness=0.18 //x=69.905 //y=0.9 //x2=69.79 //y2=0.9
r317 (  90 111 ) resistor r=5.52526 //w=0.168 //l=0.115 //layer=ply \
 //thickness=0.18 //x=70.125 //y=0.9 //x2=70.24 //y2=0.9
r318 (  90 91 ) resistor r=112.809 //w=0.094 //l=0.22 //layer=ply \
 //thickness=0.18 //x=70.125 //y=0.9 //x2=69.905 //y2=0.9
r319 (  89 108 ) resistor r=58.7805 //w=0.246 //l=0.373497 //layer=ply \
 //thickness=0.18 //x=69.75 //y=2.095 //x2=70.05 //y2=2.26
r320 (  88 106 ) resistor r=39.5823 //w=0.21 //l=0.173853 //layer=ply \
 //thickness=0.18 //x=69.75 //y=1.71 //x2=69.79 //y2=1.555
r321 (  88 89 ) resistor r=197.415 //w=0.094 //l=0.385 //layer=ply \
 //thickness=0.18 //x=69.75 //y=1.71 //x2=69.75 //y2=2.095
r322 (  87 106 ) resistor r=39.5823 //w=0.21 //l=0.173853 //layer=ply \
 //thickness=0.18 //x=69.75 //y=1.4 //x2=69.79 //y2=1.555
r323 (  86 105 ) resistor r=45.1352 //w=0.168 //l=0.173853 //layer=ply \
 //thickness=0.18 //x=69.75 //y=1.055 //x2=69.79 //y2=0.9
r324 (  86 87 ) resistor r=176.904 //w=0.094 //l=0.345 //layer=ply \
 //thickness=0.18 //x=69.75 //y=1.055 //x2=69.75 //y2=1.4
r325 (  85 102 ) resistor r=592.245 //w=0.094 //l=1.155 //layer=ply \
 //thickness=0.18 //x=70.69 //y=6.2 //x2=70.69 //y2=5.045
r326 (  84 95 ) resistor r=592.245 //w=0.094 //l=1.155 //layer=ply \
 //thickness=0.18 //x=70.25 //y=6.2 //x2=70.25 //y2=5.045
r327 (  83 92 ) resistor r=56.4043 //w=0.094 //l=0.11 //layer=ply \
 //thickness=0.18 //x=70.015 //y=1.555 //x2=70.125 //y2=1.555
r328 (  83 93 ) resistor r=56.4043 //w=0.094 //l=0.11 //layer=ply \
 //thickness=0.18 //x=70.015 //y=1.555 //x2=69.905 //y2=1.555
r329 (  79 110 ) resistor r=152 //w=0.17 //l=0.17 //layer=licon //count=1 \
 //x=70.05 //y=4.88 //x2=70.05 //y2=4.88
r330 (  74 108 ) resistor r=152 //w=0.17 //l=0.17 //layer=licon //count=1 \
 //x=70.05 //y=2.26 //x2=70.05 //y2=2.26
r331 (  57 116 ) resistor r=23.615 //w=0.187 //l=0.345 //layer=li \
 //thickness=0.1 //x=67.72 //y=5.56 //x2=67.72 //y2=5.905
r332 (  49 115 ) resistor r=23.615 //w=0.187 //l=0.345 //layer=li \
 //thickness=0.1 //x=66.84 //y=5.56 //x2=66.84 //y2=5.905
r333 (  45 46 ) resistor r=0.10734 //w=0.281 //l=0.16 //layer=m2 \
 //thickness=0.36 //x=70.04 //y=5.005 //x2=69.88 //y2=5.005
r334 (  43 46 ) resistor r=1.37882 //w=0.131 //l=1.445 //layer=m2 \
 //thickness=0.36 //x=68.435 //y=4.99 //x2=69.88 //y2=4.99
r335 (  41 43 ) resistor r=0.10734 //w=0.281 //l=0.16 //layer=m2 \
 //thickness=0.36 //x=68.275 //y=5.03 //x2=68.435 //y2=5.03
r336 (  37 45 ) resistor r=4.5 //w=0.15 //l=0.15 //layer=via1 //count=1 \
 //x=70.04 //y=5.005 //x2=70.04 //y2=5.005
r337 (  35 79 ) resistor r=9.3 //w=0.17 //l=0.17 //layer=mcon //count=1 \
 //x=70.05 //y=4.88 //x2=70.05 //y2=4.88
r338 (  35 37 ) resistor r=0.0515677 //w=0.303 //l=0.125 //layer=m1 \
 //thickness=0.36 //x=70.04 //y=4.88 //x2=70.04 //y2=5.005
r339 (  33 74 ) resistor r=9.3 //w=0.17 //l=0.17 //layer=mcon //count=1 \
 //x=70.05 //y=2.26 //x2=70.05 //y2=2.26
r340 (  30 41 ) resistor r=4.5 //w=0.15 //l=0.15 //layer=via1 //count=1 \
 //x=68.275 //y=5.03 //x2=68.275 //y2=5.03
r341 (  30 31 ) resistor r=0.15625 //w=0.28 //l=0.35 //layer=m1 \
 //thickness=0.36 //x=68.26 //y=5.03 //x2=68.26 //y2=5.38
r342 (  28 30 ) resistor r=0.0178571 //w=0.28 //l=0.04 //layer=m1 \
 //thickness=0.36 //x=68.26 //y=4.99 //x2=68.26 //y2=5.03
r343 (  25 113 ) resistor r=9.3 //w=0.17 //l=0.17 //layer=mcon //count=1 \
 //x=67.76 //y=1.18 //x2=67.76 //y2=1.18
r344 (  23 57 ) resistor r=9.3 //w=0.17 //l=0.17 //layer=mcon //count=1 \
 //x=67.72 //y=5.56 //x2=67.72 //y2=5.56
r345 (  20 23 ) resistor r=0.117801 //w=0.191 //l=0.18 //layer=m1 \
 //thickness=0.36 //x=67.72 //y=5.38 //x2=67.72 //y2=5.56
r346 (  19 49 ) resistor r=9.3 //w=0.17 //l=0.17 //layer=mcon //count=1 \
 //x=66.84 //y=5.56 //x2=66.84 //y2=5.56
r347 (  17 19 ) resistor r=0.10274 //w=0.219 //l=0.18 //layer=m1 \
 //thickness=0.36 //x=66.84 //y=5.38 //x2=66.84 //y2=5.56
r348 (  16 35 ) resistor r=0.075458 //w=0.303 //l=0.129904 //layer=m1 \
 //thickness=0.36 //x=70.05 //y=4.755 //x2=70.04 //y2=4.88
r349 (  15 33 ) resistor r=0.0719237 //w=0.222 //l=0.115 //layer=m1 \
 //thickness=0.36 //x=70.05 //y=2.375 //x2=70.05 //y2=2.26
r350 (  15 16 ) resistor r=2.27099 //w=0.131 //l=2.38 //layer=m1 \
 //thickness=0.36 //x=70.05 //y=2.375 //x2=70.05 //y2=4.755
r351 (  14 28 ) resistor r=0.0727232 //w=0.28 //l=0.146969 //layer=m1 \
 //thickness=0.36 //x=68.2 //y=4.87 //x2=68.26 //y2=4.99
r352 (  13 14 ) resistor r=2.81489 //w=0.131 //l=2.95 //layer=m1 \
 //thickness=0.36 //x=68.2 //y=1.92 //x2=68.2 //y2=4.87
r353 (  11 13 ) resistor r=0.0698411 //w=0.17 //l=0.120208 //layer=m1 \
 //thickness=0.36 //x=68.115 //y=1.835 //x2=68.2 //y2=1.92
r354 (  11 12 ) resistor r=0.257634 //w=0.131 //l=0.27 //layer=m1 \
 //thickness=0.36 //x=68.115 //y=1.835 //x2=67.845 //y2=1.835
r355 (  10 20 ) resistor r=0.0257089 //w=0.23 //l=0.115 //layer=m1 \
 //thickness=0.36 //x=67.835 //y=5.38 //x2=67.72 //y2=5.38
r356 (  9 31 ) resistor r=0.0374639 //w=0.28 //l=0.145 //layer=m1 \
 //thickness=0.36 //x=68.115 //y=5.38 //x2=68.26 //y2=5.38
r357 (  9 10 ) resistor r=0.267176 //w=0.131 //l=0.28 //layer=m1 \
 //thickness=0.36 //x=68.115 //y=5.38 //x2=67.835 //y2=5.38
r358 (  8 12 ) resistor r=0.0698411 //w=0.17 //l=0.120208 //layer=m1 \
 //thickness=0.36 //x=67.76 //y=1.75 //x2=67.845 //y2=1.835
r359 (  7 25 ) resistor r=0.0913624 //w=0.191 //l=0.12 //layer=m1 \
 //thickness=0.36 //x=67.76 //y=1.3 //x2=67.76 //y2=1.18
r360 (  7 8 ) resistor r=0.429389 //w=0.131 //l=0.45 //layer=m1 \
 //thickness=0.36 //x=67.76 //y=1.3 //x2=67.76 //y2=1.75
r361 (  4 17 ) resistor r=0.0227762 //w=0.219 //l=0.115 //layer=m1 \
 //thickness=0.36 //x=66.955 //y=5.38 //x2=66.84 //y2=5.38
r362 (  3 20 ) resistor r=0.0257089 //w=0.23 //l=0.115 //layer=m1 \
 //thickness=0.36 //x=67.605 //y=5.38 //x2=67.72 //y2=5.38
r363 (  3 4 ) resistor r=0.620229 //w=0.131 //l=0.65 //layer=m1 \
 //thickness=0.36 //x=67.605 //y=5.38 //x2=66.955 //y2=5.38
ends PM_TMRDFFSNQX1\%noxref_17

subckt PM_TMRDFFSNQX1\%SN ( 1 2 3 4 5 6 7 8 9 10 11 12 15 16 19 20 21 22 23 24 \
 26 27 69 71 72 73 75 77 79 81 82 83 84 85 87 89 91 94 98 108 109 112 117 122 \
 127 132 137 142 147 152 157 162 167 171 172 173 174 175 176 177 178 179 180 \
 181 182 183 184 185 186 187 188 189 190 191 193 199 200 201 202 203 208 209 \
 210 212 218 219 220 221 222 227 228 229 231 237 238 239 240 241 246 247 248 \
 250 256 257 258 259 260 265 266 267 269 275 276 277 278 279 284 285 286 288 \
 294 295 296 297 298 306 317 328 339 350 361 )
c1216 ( 361 0 ) capacitor c=0.0368478f //x=71.16 //y=4.88
c1217 ( 350 0 ) capacitor c=0.0369044f //x=59.69 //y=4.88
c1218 ( 339 0 ) capacitor c=0.0369044f //x=46.74 //y=4.88
c1219 ( 328 0 ) capacitor c=0.0369044f //x=35.27 //y=4.88
c1220 ( 317 0 ) capacitor c=0.0369044f //x=22.32 //y=4.88
c1221 ( 306 0 ) capacitor c=0.0369044f //x=10.85 //y=4.88
c1222 ( 298 0 ) capacitor c=0.0309248f //x=71.495 //y=4.97
c1223 ( 297 0 ) capacitor c=0.0847377f //x=71.25 //y=2.095
c1224 ( 296 0 ) capacitor c=0.0170266f //x=71.25 //y=1.63
c1225 ( 295 0 ) capacitor c=0.018609f //x=71.25 //y=1.4
c1226 ( 294 0 ) capacitor c=0.0186599f //x=71.25 //y=1.09
c1227 ( 288 0 ) capacitor c=0.0146988f //x=71.095 //y=1.555
c1228 ( 286 0 ) capacitor c=0.0148531f //x=71.095 //y=0.935
c1229 ( 285 0 ) capacitor c=0.0334406f //x=70.725 //y=1.4
c1230 ( 284 0 ) capacitor c=0.0173191f //x=70.725 //y=1.09
c1231 ( 279 0 ) capacitor c=0.0309248f //x=60.025 //y=4.97
c1232 ( 278 0 ) capacitor c=0.0845067f //x=59.78 //y=2.095
c1233 ( 277 0 ) capacitor c=0.0170266f //x=59.78 //y=1.63
c1234 ( 276 0 ) capacitor c=0.018609f //x=59.78 //y=1.4
c1235 ( 275 0 ) capacitor c=0.0186599f //x=59.78 //y=1.09
c1236 ( 269 0 ) capacitor c=0.0146988f //x=59.625 //y=1.555
c1237 ( 267 0 ) capacitor c=0.0148531f //x=59.625 //y=0.935
c1238 ( 266 0 ) capacitor c=0.0334406f //x=59.255 //y=1.4
c1239 ( 265 0 ) capacitor c=0.0173191f //x=59.255 //y=1.09
c1240 ( 260 0 ) capacitor c=0.0309248f //x=47.075 //y=4.97
c1241 ( 259 0 ) capacitor c=0.0847377f //x=46.83 //y=2.095
c1242 ( 258 0 ) capacitor c=0.0170266f //x=46.83 //y=1.63
c1243 ( 257 0 ) capacitor c=0.018609f //x=46.83 //y=1.4
c1244 ( 256 0 ) capacitor c=0.0186599f //x=46.83 //y=1.09
c1245 ( 250 0 ) capacitor c=0.0146988f //x=46.675 //y=1.555
c1246 ( 248 0 ) capacitor c=0.0148531f //x=46.675 //y=0.935
c1247 ( 247 0 ) capacitor c=0.0334406f //x=46.305 //y=1.4
c1248 ( 246 0 ) capacitor c=0.0173191f //x=46.305 //y=1.09
c1249 ( 241 0 ) capacitor c=0.0309248f //x=35.605 //y=4.97
c1250 ( 240 0 ) capacitor c=0.0845067f //x=35.36 //y=2.095
c1251 ( 239 0 ) capacitor c=0.0170266f //x=35.36 //y=1.63
c1252 ( 238 0 ) capacitor c=0.018609f //x=35.36 //y=1.4
c1253 ( 237 0 ) capacitor c=0.0186599f //x=35.36 //y=1.09
c1254 ( 231 0 ) capacitor c=0.0146988f //x=35.205 //y=1.555
c1255 ( 229 0 ) capacitor c=0.0148531f //x=35.205 //y=0.935
c1256 ( 228 0 ) capacitor c=0.0334406f //x=34.835 //y=1.4
c1257 ( 227 0 ) capacitor c=0.0173191f //x=34.835 //y=1.09
c1258 ( 222 0 ) capacitor c=0.0309248f //x=22.655 //y=4.97
c1259 ( 221 0 ) capacitor c=0.0847377f //x=22.41 //y=2.095
c1260 ( 220 0 ) capacitor c=0.0170266f //x=22.41 //y=1.63
c1261 ( 219 0 ) capacitor c=0.018609f //x=22.41 //y=1.4
c1262 ( 218 0 ) capacitor c=0.0186599f //x=22.41 //y=1.09
c1263 ( 212 0 ) capacitor c=0.0146988f //x=22.255 //y=1.555
c1264 ( 210 0 ) capacitor c=0.0148531f //x=22.255 //y=0.935
c1265 ( 209 0 ) capacitor c=0.0334406f //x=21.885 //y=1.4
c1266 ( 208 0 ) capacitor c=0.0173191f //x=21.885 //y=1.09
c1267 ( 203 0 ) capacitor c=0.0309248f //x=11.185 //y=4.97
c1268 ( 202 0 ) capacitor c=0.0845067f //x=10.94 //y=2.095
c1269 ( 201 0 ) capacitor c=0.0170266f //x=10.94 //y=1.63
c1270 ( 200 0 ) capacitor c=0.018609f //x=10.94 //y=1.4
c1271 ( 199 0 ) capacitor c=0.0186599f //x=10.94 //y=1.09
c1272 ( 193 0 ) capacitor c=0.0146988f //x=10.785 //y=1.555
c1273 ( 191 0 ) capacitor c=0.0148531f //x=10.785 //y=0.935
c1274 ( 190 0 ) capacitor c=0.0334406f //x=10.415 //y=1.4
c1275 ( 189 0 ) capacitor c=0.0173191f //x=10.415 //y=1.09
c1276 ( 188 0 ) capacitor c=0.110208f //x=71.57 //y=6.2
c1277 ( 187 0 ) capacitor c=0.109933f //x=71.13 //y=6.2
c1278 ( 186 0 ) capacitor c=0.110208f //x=60.1 //y=6.2
c1279 ( 185 0 ) capacitor c=0.110214f //x=59.66 //y=6.2
c1280 ( 184 0 ) capacitor c=0.110208f //x=47.15 //y=6.2
c1281 ( 183 0 ) capacitor c=0.110214f //x=46.71 //y=6.2
c1282 ( 182 0 ) capacitor c=0.110208f //x=35.68 //y=6.2
c1283 ( 181 0 ) capacitor c=0.110214f //x=35.24 //y=6.2
c1284 ( 180 0 ) capacitor c=0.110208f //x=22.73 //y=6.2
c1285 ( 179 0 ) capacitor c=0.110214f //x=22.29 //y=6.2
c1286 ( 178 0 ) capacitor c=0.110208f //x=11.26 //y=6.2
c1287 ( 177 0 ) capacitor c=0.110214f //x=10.82 //y=6.2
c1288 ( 167 0 ) capacitor c=0.00129935f //x=71.16 //y=4.88
c1289 ( 162 0 ) capacitor c=0.00121786f //x=71.16 //y=2.26
c1290 ( 157 0 ) capacitor c=0.00129935f //x=59.69 //y=4.88
c1291 ( 152 0 ) capacitor c=0.00121786f //x=59.69 //y=2.26
c1292 ( 147 0 ) capacitor c=0.00129935f //x=46.74 //y=4.88
c1293 ( 142 0 ) capacitor c=0.00121786f //x=46.74 //y=2.26
c1294 ( 137 0 ) capacitor c=0.00129935f //x=35.27 //y=4.88
c1295 ( 132 0 ) capacitor c=0.00121786f //x=35.27 //y=2.26
c1296 ( 127 0 ) capacitor c=0.00129935f //x=22.32 //y=4.88
c1297 ( 122 0 ) capacitor c=0.00121786f //x=22.32 //y=2.26
c1298 ( 117 0 ) capacitor c=0.00129935f //x=10.85 //y=4.88
c1299 ( 112 0 ) capacitor c=0.00121786f //x=10.85 //y=2.26
c1300 ( 109 0 ) capacitor c=0.276108f //x=70.99 //y=2.39
c1301 ( 108 0 ) capacitor c=0.00509167f //x=71.15 //y=2.39
c1302 ( 98 0 ) capacitor c=0.00509167f //x=11.01 //y=2.39
c1303 ( 94 0 ) capacitor c=0.0261338f //x=59.85 //y=2.4
c1304 ( 91 0 ) capacitor c=0.008735f //x=58.795 //y=2.39
c1305 ( 89 0 ) capacitor c=0.0938815f //x=58.195 //y=2.4
c1306 ( 87 0 ) capacitor c=0.0147801f //x=53.985 //y=2.385
c1307 ( 85 0 ) capacitor c=0.0269815f //x=53.385 //y=2.4
c1308 ( 84 0 ) capacitor c=0.118696f //x=51.705 //y=2.385
c1309 ( 83 0 ) capacitor c=0.0145823f //x=52.135 //y=2.385
c1310 ( 82 0 ) capacitor c=0.0261338f //x=35.43 //y=2.4
c1311 ( 81 0 ) capacitor c=0.267416f //x=46.57 //y=2.4
c1312 ( 79 0 ) capacitor c=0.008735f //x=34.375 //y=2.39
c1313 ( 77 0 ) capacitor c=0.0938815f //x=33.775 //y=2.4
c1314 ( 75 0 ) capacitor c=0.0147801f //x=29.565 //y=2.385
c1315 ( 73 0 ) capacitor c=0.0269815f //x=28.965 //y=2.4
c1316 ( 72 0 ) capacitor c=0.126128f //x=27.285 //y=2.385
c1317 ( 71 0 ) capacitor c=0.0145823f //x=27.715 //y=2.385
c1318 ( 69 0 ) capacitor c=0.274049f //x=22.15 //y=2.4
c1319 ( 27 0 ) capacitor c=0.0695604f //x=71.16 //y=4.765
c1320 ( 26 0 ) capacitor c=0.0113796f //x=71.16 //y=2.55
c1321 ( 24 0 ) capacitor c=0.00505177f //x=59.69 //y=4.765
c1322 ( 23 0 ) capacitor c=0.0112516f //x=59.69 //y=2.55
c1323 ( 22 0 ) capacitor c=0.06261f //x=46.74 //y=4.765
c1324 ( 21 0 ) capacitor c=0.0113796f //x=46.74 //y=2.55
c1325 ( 20 0 ) capacitor c=0.0632983f //x=35.27 //y=4.765
c1326 ( 19 0 ) capacitor c=0.0112516f //x=35.27 //y=2.55
c1327 ( 16 0 ) capacitor c=0.00505177f //x=22.32 //y=4.765
c1328 ( 15 0 ) capacitor c=0.0113796f //x=22.32 //y=2.55
c1329 ( 12 0 ) capacitor c=0.00505177f //x=10.85 //y=4.765
c1330 ( 11 0 ) capacitor c=0.0112516f //x=10.85 //y=2.55
c1331 ( 5 0 ) capacitor c=0.0582466f //x=59.69 //y=2.77
c1332 ( 3 0 ) capacitor c=0.0606019f //x=22.32 //y=2.77
c1333 ( 1 0 ) capacitor c=0.0609174f //x=10.85 //y=2.77
r1334 (  363 364 ) resistor r=32.4568 //w=0.214 //l=0.075 //layer=ply \
 //thickness=0.18 //x=71.16 //y=4.97 //x2=71.16 //y2=5.045
r1335 (  361 363 ) resistor r=20.271 //w=0.214 //l=0.09 //layer=ply \
 //thickness=0.18 //x=71.16 //y=4.88 //x2=71.16 //y2=4.97
r1336 (  352 353 ) resistor r=32.4568 //w=0.214 //l=0.075 //layer=ply \
 //thickness=0.18 //x=59.69 //y=4.97 //x2=59.69 //y2=5.045
r1337 (  350 352 ) resistor r=20.271 //w=0.214 //l=0.09 //layer=ply \
 //thickness=0.18 //x=59.69 //y=4.88 //x2=59.69 //y2=4.97
r1338 (  341 342 ) resistor r=32.4568 //w=0.214 //l=0.075 //layer=ply \
 //thickness=0.18 //x=46.74 //y=4.97 //x2=46.74 //y2=5.045
r1339 (  339 341 ) resistor r=20.271 //w=0.214 //l=0.09 //layer=ply \
 //thickness=0.18 //x=46.74 //y=4.88 //x2=46.74 //y2=4.97
r1340 (  330 331 ) resistor r=32.4568 //w=0.214 //l=0.075 //layer=ply \
 //thickness=0.18 //x=35.27 //y=4.97 //x2=35.27 //y2=5.045
r1341 (  328 330 ) resistor r=20.271 //w=0.214 //l=0.09 //layer=ply \
 //thickness=0.18 //x=35.27 //y=4.88 //x2=35.27 //y2=4.97
r1342 (  319 320 ) resistor r=32.4568 //w=0.214 //l=0.075 //layer=ply \
 //thickness=0.18 //x=22.32 //y=4.97 //x2=22.32 //y2=5.045
r1343 (  317 319 ) resistor r=20.271 //w=0.214 //l=0.09 //layer=ply \
 //thickness=0.18 //x=22.32 //y=4.88 //x2=22.32 //y2=4.97
r1344 (  308 309 ) resistor r=32.4568 //w=0.214 //l=0.075 //layer=ply \
 //thickness=0.18 //x=10.85 //y=4.97 //x2=10.85 //y2=5.045
r1345 (  306 308 ) resistor r=20.271 //w=0.214 //l=0.09 //layer=ply \
 //thickness=0.18 //x=10.85 //y=4.88 //x2=10.85 //y2=4.97
r1346 (  299 363 ) resistor r=16.5046 //w=0.27 //l=0.135 //layer=ply \
 //thickness=0.18 //x=71.295 //y=4.97 //x2=71.16 //y2=4.97
r1347 (  298 300 ) resistor r=26.9307 //w=0.15 //l=0.106066 //layer=ply \
 //thickness=0.18 //x=71.495 //y=4.97 //x2=71.57 //y2=5.045
r1348 (  298 299 ) resistor r=102.553 //w=0.094 //l=0.2 //layer=ply \
 //thickness=0.18 //x=71.495 //y=4.97 //x2=71.295 //y2=4.97
r1349 (  297 368 ) resistor r=38.6777 //w=0.284 //l=0.198997 //layer=ply \
 //thickness=0.18 //x=71.25 //y=2.095 //x2=71.175 //y2=2.26
r1350 (  296 366 ) resistor r=21.2976 //w=0.217 //l=0.0928709 //layer=ply \
 //thickness=0.18 //x=71.25 //y=1.63 //x2=71.21 //y2=1.555
r1351 (  296 297 ) resistor r=238.436 //w=0.094 //l=0.465 //layer=ply \
 //thickness=0.18 //x=71.25 //y=1.63 //x2=71.25 //y2=2.095
r1352 (  295 366 ) resistor r=39.0671 //w=0.217 //l=0.173853 //layer=ply \
 //thickness=0.18 //x=71.25 //y=1.4 //x2=71.21 //y2=1.555
r1353 (  294 365 ) resistor r=45.1352 //w=0.168 //l=0.173853 //layer=ply \
 //thickness=0.18 //x=71.25 //y=1.09 //x2=71.21 //y2=0.935
r1354 (  294 295 ) resistor r=158.957 //w=0.094 //l=0.31 //layer=ply \
 //thickness=0.18 //x=71.25 //y=1.09 //x2=71.25 //y2=1.4
r1355 (  289 359 ) resistor r=5.52526 //w=0.168 //l=0.115 //layer=ply \
 //thickness=0.18 //x=70.88 //y=1.555 //x2=70.765 //y2=1.555
r1356 (  288 366 ) resistor r=11.4558 //w=0.217 //l=0.115 //layer=ply \
 //thickness=0.18 //x=71.095 //y=1.555 //x2=71.21 //y2=1.555
r1357 (  287 358 ) resistor r=5.52526 //w=0.168 //l=0.115 //layer=ply \
 //thickness=0.18 //x=70.88 //y=0.935 //x2=70.765 //y2=0.935
r1358 (  286 365 ) resistor r=5.52526 //w=0.168 //l=0.115 //layer=ply \
 //thickness=0.18 //x=71.095 //y=0.935 //x2=71.21 //y2=0.935
r1359 (  286 287 ) resistor r=110.245 //w=0.094 //l=0.215 //layer=ply \
 //thickness=0.18 //x=71.095 //y=0.935 //x2=70.88 //y2=0.935
r1360 (  285 359 ) resistor r=45.1352 //w=0.168 //l=0.173853 //layer=ply \
 //thickness=0.18 //x=70.725 //y=1.4 //x2=70.765 //y2=1.555
r1361 (  284 358 ) resistor r=45.1352 //w=0.168 //l=0.173853 //layer=ply \
 //thickness=0.18 //x=70.725 //y=1.09 //x2=70.765 //y2=0.935
r1362 (  284 285 ) resistor r=158.957 //w=0.094 //l=0.31 //layer=ply \
 //thickness=0.18 //x=70.725 //y=1.09 //x2=70.725 //y2=1.4
r1363 (  280 352 ) resistor r=16.5046 //w=0.27 //l=0.135 //layer=ply \
 //thickness=0.18 //x=59.825 //y=4.97 //x2=59.69 //y2=4.97
r1364 (  279 281 ) resistor r=26.9307 //w=0.15 //l=0.106066 //layer=ply \
 //thickness=0.18 //x=60.025 //y=4.97 //x2=60.1 //y2=5.045
r1365 (  279 280 ) resistor r=102.553 //w=0.094 //l=0.2 //layer=ply \
 //thickness=0.18 //x=60.025 //y=4.97 //x2=59.825 //y2=4.97
r1366 (  278 357 ) resistor r=38.6777 //w=0.284 //l=0.198997 //layer=ply \
 //thickness=0.18 //x=59.78 //y=2.095 //x2=59.705 //y2=2.26
r1367 (  277 355 ) resistor r=21.2976 //w=0.217 //l=0.0928709 //layer=ply \
 //thickness=0.18 //x=59.78 //y=1.63 //x2=59.74 //y2=1.555
r1368 (  277 278 ) resistor r=238.436 //w=0.094 //l=0.465 //layer=ply \
 //thickness=0.18 //x=59.78 //y=1.63 //x2=59.78 //y2=2.095
r1369 (  276 355 ) resistor r=39.0671 //w=0.217 //l=0.173853 //layer=ply \
 //thickness=0.18 //x=59.78 //y=1.4 //x2=59.74 //y2=1.555
r1370 (  275 354 ) resistor r=45.1352 //w=0.168 //l=0.173853 //layer=ply \
 //thickness=0.18 //x=59.78 //y=1.09 //x2=59.74 //y2=0.935
r1371 (  275 276 ) resistor r=158.957 //w=0.094 //l=0.31 //layer=ply \
 //thickness=0.18 //x=59.78 //y=1.09 //x2=59.78 //y2=1.4
r1372 (  270 348 ) resistor r=5.52526 //w=0.168 //l=0.115 //layer=ply \
 //thickness=0.18 //x=59.41 //y=1.555 //x2=59.295 //y2=1.555
r1373 (  269 355 ) resistor r=11.4558 //w=0.217 //l=0.115 //layer=ply \
 //thickness=0.18 //x=59.625 //y=1.555 //x2=59.74 //y2=1.555
r1374 (  268 347 ) resistor r=5.52526 //w=0.168 //l=0.115 //layer=ply \
 //thickness=0.18 //x=59.41 //y=0.935 //x2=59.295 //y2=0.935
r1375 (  267 354 ) resistor r=5.52526 //w=0.168 //l=0.115 //layer=ply \
 //thickness=0.18 //x=59.625 //y=0.935 //x2=59.74 //y2=0.935
r1376 (  267 268 ) resistor r=110.245 //w=0.094 //l=0.215 //layer=ply \
 //thickness=0.18 //x=59.625 //y=0.935 //x2=59.41 //y2=0.935
r1377 (  266 348 ) resistor r=45.1352 //w=0.168 //l=0.173853 //layer=ply \
 //thickness=0.18 //x=59.255 //y=1.4 //x2=59.295 //y2=1.555
r1378 (  265 347 ) resistor r=45.1352 //w=0.168 //l=0.173853 //layer=ply \
 //thickness=0.18 //x=59.255 //y=1.09 //x2=59.295 //y2=0.935
r1379 (  265 266 ) resistor r=158.957 //w=0.094 //l=0.31 //layer=ply \
 //thickness=0.18 //x=59.255 //y=1.09 //x2=59.255 //y2=1.4
r1380 (  261 341 ) resistor r=16.5046 //w=0.27 //l=0.135 //layer=ply \
 //thickness=0.18 //x=46.875 //y=4.97 //x2=46.74 //y2=4.97
r1381 (  260 262 ) resistor r=26.9307 //w=0.15 //l=0.106066 //layer=ply \
 //thickness=0.18 //x=47.075 //y=4.97 //x2=47.15 //y2=5.045
r1382 (  260 261 ) resistor r=102.553 //w=0.094 //l=0.2 //layer=ply \
 //thickness=0.18 //x=47.075 //y=4.97 //x2=46.875 //y2=4.97
r1383 (  259 346 ) resistor r=38.6777 //w=0.284 //l=0.198997 //layer=ply \
 //thickness=0.18 //x=46.83 //y=2.095 //x2=46.755 //y2=2.26
r1384 (  258 344 ) resistor r=21.2976 //w=0.217 //l=0.0928709 //layer=ply \
 //thickness=0.18 //x=46.83 //y=1.63 //x2=46.79 //y2=1.555
r1385 (  258 259 ) resistor r=238.436 //w=0.094 //l=0.465 //layer=ply \
 //thickness=0.18 //x=46.83 //y=1.63 //x2=46.83 //y2=2.095
r1386 (  257 344 ) resistor r=39.0671 //w=0.217 //l=0.173853 //layer=ply \
 //thickness=0.18 //x=46.83 //y=1.4 //x2=46.79 //y2=1.555
r1387 (  256 343 ) resistor r=45.1352 //w=0.168 //l=0.173853 //layer=ply \
 //thickness=0.18 //x=46.83 //y=1.09 //x2=46.79 //y2=0.935
r1388 (  256 257 ) resistor r=158.957 //w=0.094 //l=0.31 //layer=ply \
 //thickness=0.18 //x=46.83 //y=1.09 //x2=46.83 //y2=1.4
r1389 (  251 337 ) resistor r=5.52526 //w=0.168 //l=0.115 //layer=ply \
 //thickness=0.18 //x=46.46 //y=1.555 //x2=46.345 //y2=1.555
r1390 (  250 344 ) resistor r=11.4558 //w=0.217 //l=0.115 //layer=ply \
 //thickness=0.18 //x=46.675 //y=1.555 //x2=46.79 //y2=1.555
r1391 (  249 336 ) resistor r=5.52526 //w=0.168 //l=0.115 //layer=ply \
 //thickness=0.18 //x=46.46 //y=0.935 //x2=46.345 //y2=0.935
r1392 (  248 343 ) resistor r=5.52526 //w=0.168 //l=0.115 //layer=ply \
 //thickness=0.18 //x=46.675 //y=0.935 //x2=46.79 //y2=0.935
r1393 (  248 249 ) resistor r=110.245 //w=0.094 //l=0.215 //layer=ply \
 //thickness=0.18 //x=46.675 //y=0.935 //x2=46.46 //y2=0.935
r1394 (  247 337 ) resistor r=45.1352 //w=0.168 //l=0.173853 //layer=ply \
 //thickness=0.18 //x=46.305 //y=1.4 //x2=46.345 //y2=1.555
r1395 (  246 336 ) resistor r=45.1352 //w=0.168 //l=0.173853 //layer=ply \
 //thickness=0.18 //x=46.305 //y=1.09 //x2=46.345 //y2=0.935
r1396 (  246 247 ) resistor r=158.957 //w=0.094 //l=0.31 //layer=ply \
 //thickness=0.18 //x=46.305 //y=1.09 //x2=46.305 //y2=1.4
r1397 (  242 330 ) resistor r=16.5046 //w=0.27 //l=0.135 //layer=ply \
 //thickness=0.18 //x=35.405 //y=4.97 //x2=35.27 //y2=4.97
r1398 (  241 243 ) resistor r=26.9307 //w=0.15 //l=0.106066 //layer=ply \
 //thickness=0.18 //x=35.605 //y=4.97 //x2=35.68 //y2=5.045
r1399 (  241 242 ) resistor r=102.553 //w=0.094 //l=0.2 //layer=ply \
 //thickness=0.18 //x=35.605 //y=4.97 //x2=35.405 //y2=4.97
r1400 (  240 335 ) resistor r=38.6777 //w=0.284 //l=0.198997 //layer=ply \
 //thickness=0.18 //x=35.36 //y=2.095 //x2=35.285 //y2=2.26
r1401 (  239 333 ) resistor r=21.2976 //w=0.217 //l=0.0928709 //layer=ply \
 //thickness=0.18 //x=35.36 //y=1.63 //x2=35.32 //y2=1.555
r1402 (  239 240 ) resistor r=238.436 //w=0.094 //l=0.465 //layer=ply \
 //thickness=0.18 //x=35.36 //y=1.63 //x2=35.36 //y2=2.095
r1403 (  238 333 ) resistor r=39.0671 //w=0.217 //l=0.173853 //layer=ply \
 //thickness=0.18 //x=35.36 //y=1.4 //x2=35.32 //y2=1.555
r1404 (  237 332 ) resistor r=45.1352 //w=0.168 //l=0.173853 //layer=ply \
 //thickness=0.18 //x=35.36 //y=1.09 //x2=35.32 //y2=0.935
r1405 (  237 238 ) resistor r=158.957 //w=0.094 //l=0.31 //layer=ply \
 //thickness=0.18 //x=35.36 //y=1.09 //x2=35.36 //y2=1.4
r1406 (  232 326 ) resistor r=5.52526 //w=0.168 //l=0.115 //layer=ply \
 //thickness=0.18 //x=34.99 //y=1.555 //x2=34.875 //y2=1.555
r1407 (  231 333 ) resistor r=11.4558 //w=0.217 //l=0.115 //layer=ply \
 //thickness=0.18 //x=35.205 //y=1.555 //x2=35.32 //y2=1.555
r1408 (  230 325 ) resistor r=5.52526 //w=0.168 //l=0.115 //layer=ply \
 //thickness=0.18 //x=34.99 //y=0.935 //x2=34.875 //y2=0.935
r1409 (  229 332 ) resistor r=5.52526 //w=0.168 //l=0.115 //layer=ply \
 //thickness=0.18 //x=35.205 //y=0.935 //x2=35.32 //y2=0.935
r1410 (  229 230 ) resistor r=110.245 //w=0.094 //l=0.215 //layer=ply \
 //thickness=0.18 //x=35.205 //y=0.935 //x2=34.99 //y2=0.935
r1411 (  228 326 ) resistor r=45.1352 //w=0.168 //l=0.173853 //layer=ply \
 //thickness=0.18 //x=34.835 //y=1.4 //x2=34.875 //y2=1.555
r1412 (  227 325 ) resistor r=45.1352 //w=0.168 //l=0.173853 //layer=ply \
 //thickness=0.18 //x=34.835 //y=1.09 //x2=34.875 //y2=0.935
r1413 (  227 228 ) resistor r=158.957 //w=0.094 //l=0.31 //layer=ply \
 //thickness=0.18 //x=34.835 //y=1.09 //x2=34.835 //y2=1.4
r1414 (  223 319 ) resistor r=16.5046 //w=0.27 //l=0.135 //layer=ply \
 //thickness=0.18 //x=22.455 //y=4.97 //x2=22.32 //y2=4.97
r1415 (  222 224 ) resistor r=26.9307 //w=0.15 //l=0.106066 //layer=ply \
 //thickness=0.18 //x=22.655 //y=4.97 //x2=22.73 //y2=5.045
r1416 (  222 223 ) resistor r=102.553 //w=0.094 //l=0.2 //layer=ply \
 //thickness=0.18 //x=22.655 //y=4.97 //x2=22.455 //y2=4.97
r1417 (  221 324 ) resistor r=38.6777 //w=0.284 //l=0.198997 //layer=ply \
 //thickness=0.18 //x=22.41 //y=2.095 //x2=22.335 //y2=2.26
r1418 (  220 322 ) resistor r=21.2976 //w=0.217 //l=0.0928709 //layer=ply \
 //thickness=0.18 //x=22.41 //y=1.63 //x2=22.37 //y2=1.555
r1419 (  220 221 ) resistor r=238.436 //w=0.094 //l=0.465 //layer=ply \
 //thickness=0.18 //x=22.41 //y=1.63 //x2=22.41 //y2=2.095
r1420 (  219 322 ) resistor r=39.0671 //w=0.217 //l=0.173853 //layer=ply \
 //thickness=0.18 //x=22.41 //y=1.4 //x2=22.37 //y2=1.555
r1421 (  218 321 ) resistor r=45.1352 //w=0.168 //l=0.173853 //layer=ply \
 //thickness=0.18 //x=22.41 //y=1.09 //x2=22.37 //y2=0.935
r1422 (  218 219 ) resistor r=158.957 //w=0.094 //l=0.31 //layer=ply \
 //thickness=0.18 //x=22.41 //y=1.09 //x2=22.41 //y2=1.4
r1423 (  213 315 ) resistor r=5.52526 //w=0.168 //l=0.115 //layer=ply \
 //thickness=0.18 //x=22.04 //y=1.555 //x2=21.925 //y2=1.555
r1424 (  212 322 ) resistor r=11.4558 //w=0.217 //l=0.115 //layer=ply \
 //thickness=0.18 //x=22.255 //y=1.555 //x2=22.37 //y2=1.555
r1425 (  211 314 ) resistor r=5.52526 //w=0.168 //l=0.115 //layer=ply \
 //thickness=0.18 //x=22.04 //y=0.935 //x2=21.925 //y2=0.935
r1426 (  210 321 ) resistor r=5.52526 //w=0.168 //l=0.115 //layer=ply \
 //thickness=0.18 //x=22.255 //y=0.935 //x2=22.37 //y2=0.935
r1427 (  210 211 ) resistor r=110.245 //w=0.094 //l=0.215 //layer=ply \
 //thickness=0.18 //x=22.255 //y=0.935 //x2=22.04 //y2=0.935
r1428 (  209 315 ) resistor r=45.1352 //w=0.168 //l=0.173853 //layer=ply \
 //thickness=0.18 //x=21.885 //y=1.4 //x2=21.925 //y2=1.555
r1429 (  208 314 ) resistor r=45.1352 //w=0.168 //l=0.173853 //layer=ply \
 //thickness=0.18 //x=21.885 //y=1.09 //x2=21.925 //y2=0.935
r1430 (  208 209 ) resistor r=158.957 //w=0.094 //l=0.31 //layer=ply \
 //thickness=0.18 //x=21.885 //y=1.09 //x2=21.885 //y2=1.4
r1431 (  204 308 ) resistor r=16.5046 //w=0.27 //l=0.135 //layer=ply \
 //thickness=0.18 //x=10.985 //y=4.97 //x2=10.85 //y2=4.97
r1432 (  203 205 ) resistor r=26.9307 //w=0.15 //l=0.106066 //layer=ply \
 //thickness=0.18 //x=11.185 //y=4.97 //x2=11.26 //y2=5.045
r1433 (  203 204 ) resistor r=102.553 //w=0.094 //l=0.2 //layer=ply \
 //thickness=0.18 //x=11.185 //y=4.97 //x2=10.985 //y2=4.97
r1434 (  202 313 ) resistor r=38.6777 //w=0.284 //l=0.198997 //layer=ply \
 //thickness=0.18 //x=10.94 //y=2.095 //x2=10.865 //y2=2.26
r1435 (  201 311 ) resistor r=21.2976 //w=0.217 //l=0.0928709 //layer=ply \
 //thickness=0.18 //x=10.94 //y=1.63 //x2=10.9 //y2=1.555
r1436 (  201 202 ) resistor r=238.436 //w=0.094 //l=0.465 //layer=ply \
 //thickness=0.18 //x=10.94 //y=1.63 //x2=10.94 //y2=2.095
r1437 (  200 311 ) resistor r=39.0671 //w=0.217 //l=0.173853 //layer=ply \
 //thickness=0.18 //x=10.94 //y=1.4 //x2=10.9 //y2=1.555
r1438 (  199 310 ) resistor r=45.1352 //w=0.168 //l=0.173853 //layer=ply \
 //thickness=0.18 //x=10.94 //y=1.09 //x2=10.9 //y2=0.935
r1439 (  199 200 ) resistor r=158.957 //w=0.094 //l=0.31 //layer=ply \
 //thickness=0.18 //x=10.94 //y=1.09 //x2=10.94 //y2=1.4
r1440 (  194 304 ) resistor r=5.52526 //w=0.168 //l=0.115 //layer=ply \
 //thickness=0.18 //x=10.57 //y=1.555 //x2=10.455 //y2=1.555
r1441 (  193 311 ) resistor r=11.4558 //w=0.217 //l=0.115 //layer=ply \
 //thickness=0.18 //x=10.785 //y=1.555 //x2=10.9 //y2=1.555
r1442 (  192 303 ) resistor r=5.52526 //w=0.168 //l=0.115 //layer=ply \
 //thickness=0.18 //x=10.57 //y=0.935 //x2=10.455 //y2=0.935
r1443 (  191 310 ) resistor r=5.52526 //w=0.168 //l=0.115 //layer=ply \
 //thickness=0.18 //x=10.785 //y=0.935 //x2=10.9 //y2=0.935
r1444 (  191 192 ) resistor r=110.245 //w=0.094 //l=0.215 //layer=ply \
 //thickness=0.18 //x=10.785 //y=0.935 //x2=10.57 //y2=0.935
r1445 (  190 304 ) resistor r=45.1352 //w=0.168 //l=0.173853 //layer=ply \
 //thickness=0.18 //x=10.415 //y=1.4 //x2=10.455 //y2=1.555
r1446 (  189 303 ) resistor r=45.1352 //w=0.168 //l=0.173853 //layer=ply \
 //thickness=0.18 //x=10.415 //y=1.09 //x2=10.455 //y2=0.935
r1447 (  189 190 ) resistor r=158.957 //w=0.094 //l=0.31 //layer=ply \
 //thickness=0.18 //x=10.415 //y=1.09 //x2=10.415 //y2=1.4
r1448 (  188 300 ) resistor r=592.245 //w=0.094 //l=1.155 //layer=ply \
 //thickness=0.18 //x=71.57 //y=6.2 //x2=71.57 //y2=5.045
r1449 (  187 364 ) resistor r=592.245 //w=0.094 //l=1.155 //layer=ply \
 //thickness=0.18 //x=71.13 //y=6.2 //x2=71.13 //y2=5.045
r1450 (  186 281 ) resistor r=592.245 //w=0.094 //l=1.155 //layer=ply \
 //thickness=0.18 //x=60.1 //y=6.2 //x2=60.1 //y2=5.045
r1451 (  185 353 ) resistor r=592.245 //w=0.094 //l=1.155 //layer=ply \
 //thickness=0.18 //x=59.66 //y=6.2 //x2=59.66 //y2=5.045
r1452 (  184 262 ) resistor r=592.245 //w=0.094 //l=1.155 //layer=ply \
 //thickness=0.18 //x=47.15 //y=6.2 //x2=47.15 //y2=5.045
r1453 (  183 342 ) resistor r=592.245 //w=0.094 //l=1.155 //layer=ply \
 //thickness=0.18 //x=46.71 //y=6.2 //x2=46.71 //y2=5.045
r1454 (  182 243 ) resistor r=592.245 //w=0.094 //l=1.155 //layer=ply \
 //thickness=0.18 //x=35.68 //y=6.2 //x2=35.68 //y2=5.045
r1455 (  181 331 ) resistor r=592.245 //w=0.094 //l=1.155 //layer=ply \
 //thickness=0.18 //x=35.24 //y=6.2 //x2=35.24 //y2=5.045
r1456 (  180 224 ) resistor r=592.245 //w=0.094 //l=1.155 //layer=ply \
 //thickness=0.18 //x=22.73 //y=6.2 //x2=22.73 //y2=5.045
r1457 (  179 320 ) resistor r=592.245 //w=0.094 //l=1.155 //layer=ply \
 //thickness=0.18 //x=22.29 //y=6.2 //x2=22.29 //y2=5.045
r1458 (  178 205 ) resistor r=592.245 //w=0.094 //l=1.155 //layer=ply \
 //thickness=0.18 //x=11.26 //y=6.2 //x2=11.26 //y2=5.045
r1459 (  177 309 ) resistor r=592.245 //w=0.094 //l=1.155 //layer=ply \
 //thickness=0.18 //x=10.82 //y=6.2 //x2=10.82 //y2=5.045
r1460 (  176 288 ) resistor r=55.3787 //w=0.094 //l=0.108 //layer=ply \
 //thickness=0.18 //x=70.987 //y=1.555 //x2=71.095 //y2=1.555
r1461 (  176 289 ) resistor r=54.866 //w=0.094 //l=0.107 //layer=ply \
 //thickness=0.18 //x=70.987 //y=1.555 //x2=70.88 //y2=1.555
r1462 (  175 269 ) resistor r=55.3787 //w=0.094 //l=0.108 //layer=ply \
 //thickness=0.18 //x=59.517 //y=1.555 //x2=59.625 //y2=1.555
r1463 (  175 270 ) resistor r=54.866 //w=0.094 //l=0.107 //layer=ply \
 //thickness=0.18 //x=59.517 //y=1.555 //x2=59.41 //y2=1.555
r1464 (  174 250 ) resistor r=55.3787 //w=0.094 //l=0.108 //layer=ply \
 //thickness=0.18 //x=46.567 //y=1.555 //x2=46.675 //y2=1.555
r1465 (  174 251 ) resistor r=54.866 //w=0.094 //l=0.107 //layer=ply \
 //thickness=0.18 //x=46.567 //y=1.555 //x2=46.46 //y2=1.555
r1466 (  173 231 ) resistor r=55.3787 //w=0.094 //l=0.108 //layer=ply \
 //thickness=0.18 //x=35.097 //y=1.555 //x2=35.205 //y2=1.555
r1467 (  173 232 ) resistor r=54.866 //w=0.094 //l=0.107 //layer=ply \
 //thickness=0.18 //x=35.097 //y=1.555 //x2=34.99 //y2=1.555
r1468 (  172 212 ) resistor r=55.3787 //w=0.094 //l=0.108 //layer=ply \
 //thickness=0.18 //x=22.147 //y=1.555 //x2=22.255 //y2=1.555
r1469 (  172 213 ) resistor r=54.866 //w=0.094 //l=0.107 //layer=ply \
 //thickness=0.18 //x=22.147 //y=1.555 //x2=22.04 //y2=1.555
r1470 (  171 193 ) resistor r=55.3787 //w=0.094 //l=0.108 //layer=ply \
 //thickness=0.18 //x=10.677 //y=1.555 //x2=10.785 //y2=1.555
r1471 (  171 194 ) resistor r=54.866 //w=0.094 //l=0.107 //layer=ply \
 //thickness=0.18 //x=10.677 //y=1.555 //x2=10.57 //y2=1.555
r1472 (  167 361 ) resistor r=152 //w=0.17 //l=0.17 //layer=licon //count=1 \
 //x=71.16 //y=4.88 //x2=71.16 //y2=4.88
r1473 (  162 368 ) resistor r=152 //w=0.17 //l=0.17 //layer=licon //count=1 \
 //x=71.16 //y=2.26 //x2=71.16 //y2=2.26
r1474 (  157 350 ) resistor r=152 //w=0.17 //l=0.17 //layer=licon //count=1 \
 //x=59.69 //y=4.88 //x2=59.69 //y2=4.88
r1475 (  152 357 ) resistor r=152 //w=0.17 //l=0.17 //layer=licon //count=1 \
 //x=59.69 //y=2.26 //x2=59.69 //y2=2.26
r1476 (  147 339 ) resistor r=152 //w=0.17 //l=0.17 //layer=licon //count=1 \
 //x=46.74 //y=4.88 //x2=46.74 //y2=4.88
r1477 (  142 346 ) resistor r=152 //w=0.17 //l=0.17 //layer=licon //count=1 \
 //x=46.74 //y=2.26 //x2=46.74 //y2=2.26
r1478 (  137 328 ) resistor r=152 //w=0.17 //l=0.17 //layer=licon //count=1 \
 //x=35.27 //y=4.88 //x2=35.27 //y2=4.88
r1479 (  132 335 ) resistor r=152 //w=0.17 //l=0.17 //layer=licon //count=1 \
 //x=35.27 //y=2.26 //x2=35.27 //y2=2.26
r1480 (  127 317 ) resistor r=152 //w=0.17 //l=0.17 //layer=licon //count=1 \
 //x=22.32 //y=4.88 //x2=22.32 //y2=4.88
r1481 (  122 324 ) resistor r=152 //w=0.17 //l=0.17 //layer=licon //count=1 \
 //x=22.32 //y=2.26 //x2=22.32 //y2=2.26
r1482 (  117 306 ) resistor r=152 //w=0.17 //l=0.17 //layer=licon //count=1 \
 //x=10.85 //y=4.88 //x2=10.85 //y2=4.88
r1483 (  112 313 ) resistor r=152 //w=0.17 //l=0.17 //layer=licon //count=1 \
 //x=10.85 //y=2.26 //x2=10.85 //y2=2.26
r1484 (  108 109 ) resistor r=0.10734 //w=0.281 //l=0.16 //layer=m2 \
 //thickness=0.36 //x=71.15 //y=2.39 //x2=70.99 //y2=2.39
r1485 (  96 98 ) resistor r=0.10734 //w=0.281 //l=0.16 //layer=m2 \
 //thickness=0.36 //x=10.85 //y=2.39 //x2=11.01 //y2=2.39
r1486 (  94 106 ) resistor r=0.0986081 //w=0.216 //l=0.164924 //layer=m2 \
 //thickness=0.36 //x=59.85 //y=2.4 //x2=59.69 //y2=2.39
r1487 (  94 109 ) resistor r=10.6298 //w=0.131 //l=11.14 //layer=m2 \
 //thickness=0.36 //x=59.85 //y=2.4 //x2=70.99 //y2=2.4
r1488 (  91 106 ) resistor r=0.523955 //w=0.216 //l=0.895 //layer=m2 \
 //thickness=0.36 //x=58.795 //y=2.39 //x2=59.69 //y2=2.39
r1489 (  91 92 ) resistor r=0.410305 //w=0.131 //l=0.43 //layer=m2 \
 //thickness=0.36 //x=58.795 //y=2.39 //x2=58.365 //y2=2.39
r1490 (  89 92 ) resistor r=0.125 //w=0.17 //l=0.174929 //layer=m2 \
 //thickness=0.36 //x=58.195 //y=2.4 //x2=58.365 //y2=2.39
r1491 (  89 90 ) resistor r=3.77385 //w=0.131 //l=3.955 //layer=m2 \
 //thickness=0.36 //x=58.195 //y=2.4 //x2=54.24 //y2=2.4
r1492 (  87 90 ) resistor r=0.1875 //w=0.17 //l=0.262393 //layer=m2 \
 //thickness=0.36 //x=53.985 //y=2.385 //x2=54.24 //y2=2.4
r1493 (  87 88 ) resistor r=0.410305 //w=0.131 //l=0.43 //layer=m2 \
 //thickness=0.36 //x=53.985 //y=2.385 //x2=53.555 //y2=2.385
r1494 (  85 88 ) resistor r=0.125 //w=0.17 //l=0.177341 //layer=m2 \
 //thickness=0.36 //x=53.385 //y=2.4 //x2=53.555 //y2=2.385
r1495 (  85 86 ) resistor r=0.949427 //w=0.131 //l=0.995 //layer=m2 \
 //thickness=0.36 //x=53.385 //y=2.4 //x2=52.39 //y2=2.4
r1496 (  84 104 ) resistor r=3.45539 //w=0.18 //l=4.9775 //layer=m2 \
 //thickness=0.36 //x=51.705 //y=2.385 //x2=46.73 //y2=2.39
r1497 (  83 86 ) resistor r=0.1875 //w=0.17 //l=0.262393 //layer=m2 \
 //thickness=0.36 //x=52.135 //y=2.385 //x2=52.39 //y2=2.4
r1498 (  83 84 ) resistor r=0.410305 //w=0.131 //l=0.43 //layer=m2 \
 //thickness=0.36 //x=52.135 //y=2.385 //x2=51.705 //y2=2.385
r1499 (  82 102 ) resistor r=0.0986081 //w=0.216 //l=0.164924 //layer=m2 \
 //thickness=0.36 //x=35.43 //y=2.4 //x2=35.27 //y2=2.39
r1500 (  81 104 ) resistor r=0.111638 //w=0.18 //l=0.164924 //layer=m2 \
 //thickness=0.36 //x=46.57 //y=2.4 //x2=46.73 //y2=2.39
r1501 (  81 82 ) resistor r=10.6298 //w=0.131 //l=11.14 //layer=m2 \
 //thickness=0.36 //x=46.57 //y=2.4 //x2=35.43 //y2=2.4
r1502 (  79 102 ) resistor r=0.523955 //w=0.216 //l=0.895 //layer=m2 \
 //thickness=0.36 //x=34.375 //y=2.39 //x2=35.27 //y2=2.39
r1503 (  79 80 ) resistor r=0.410305 //w=0.131 //l=0.43 //layer=m2 \
 //thickness=0.36 //x=34.375 //y=2.39 //x2=33.945 //y2=2.39
r1504 (  77 80 ) resistor r=0.125 //w=0.17 //l=0.174929 //layer=m2 \
 //thickness=0.36 //x=33.775 //y=2.4 //x2=33.945 //y2=2.39
r1505 (  77 78 ) resistor r=3.77385 //w=0.131 //l=3.955 //layer=m2 \
 //thickness=0.36 //x=33.775 //y=2.4 //x2=29.82 //y2=2.4
r1506 (  75 78 ) resistor r=0.1875 //w=0.17 //l=0.262393 //layer=m2 \
 //thickness=0.36 //x=29.565 //y=2.385 //x2=29.82 //y2=2.4
r1507 (  75 76 ) resistor r=0.410305 //w=0.131 //l=0.43 //layer=m2 \
 //thickness=0.36 //x=29.565 //y=2.385 //x2=29.135 //y2=2.385
r1508 (  73 76 ) resistor r=0.125 //w=0.17 //l=0.177341 //layer=m2 \
 //thickness=0.36 //x=28.965 //y=2.4 //x2=29.135 //y2=2.385
r1509 (  73 74 ) resistor r=0.949427 //w=0.131 //l=0.995 //layer=m2 \
 //thickness=0.36 //x=28.965 //y=2.4 //x2=27.97 //y2=2.4
r1510 (  72 100 ) resistor r=3.45539 //w=0.18 //l=4.9775 //layer=m2 \
 //thickness=0.36 //x=27.285 //y=2.385 //x2=22.31 //y2=2.39
r1511 (  71 74 ) resistor r=0.1875 //w=0.17 //l=0.262393 //layer=m2 \
 //thickness=0.36 //x=27.715 //y=2.385 //x2=27.97 //y2=2.4
r1512 (  71 72 ) resistor r=0.410305 //w=0.131 //l=0.43 //layer=m2 \
 //thickness=0.36 //x=27.715 //y=2.385 //x2=27.285 //y2=2.385
r1513 (  69 100 ) resistor r=0.111638 //w=0.18 //l=0.164924 //layer=m2 \
 //thickness=0.36 //x=22.15 //y=2.4 //x2=22.31 //y2=2.39
r1514 (  69 98 ) resistor r=10.6298 //w=0.131 //l=11.14 //layer=m2 \
 //thickness=0.36 //x=22.15 //y=2.4 //x2=11.01 //y2=2.4
r1515 (  67 108 ) resistor r=4.5 //w=0.15 //l=0.15 //layer=via1 //count=1 \
 //x=71.15 //y=2.39 //x2=71.15 //y2=2.39
r1516 (  65 162 ) resistor r=9.3 //w=0.17 //l=0.17 //layer=mcon //count=1 \
 //x=71.16 //y=2.26 //x2=71.16 //y2=2.26
r1517 (  65 67 ) resistor r=0.0560345 //w=0.29 //l=0.13 //layer=m1 \
 //thickness=0.36 //x=71.15 //y=2.26 //x2=71.15 //y2=2.39
r1518 (  63 167 ) resistor r=9.3 //w=0.17 //l=0.17 //layer=mcon //count=1 \
 //x=71.16 //y=4.88 //x2=71.16 //y2=4.88
r1519 (  60 106 ) resistor r=4.5 //w=0.15 //l=0.15 //layer=via1 //count=1 \
 //x=59.69 //y=2.39 //x2=59.69 //y2=2.39
r1520 (  58 152 ) resistor r=9.3 //w=0.17 //l=0.17 //layer=mcon //count=1 \
 //x=59.69 //y=2.26 //x2=59.69 //y2=2.26
r1521 (  58 60 ) resistor r=0.0560345 //w=0.29 //l=0.13 //layer=m1 \
 //thickness=0.36 //x=59.69 //y=2.26 //x2=59.69 //y2=2.39
r1522 (  56 157 ) resistor r=9.3 //w=0.17 //l=0.17 //layer=mcon //count=1 \
 //x=59.69 //y=4.88 //x2=59.69 //y2=4.88
r1523 (  54 104 ) resistor r=4.5 //w=0.15 //l=0.15 //layer=via1 //count=1 \
 //x=46.73 //y=2.39 //x2=46.73 //y2=2.39
r1524 (  52 142 ) resistor r=9.3 //w=0.17 //l=0.17 //layer=mcon //count=1 \
 //x=46.74 //y=2.26 //x2=46.74 //y2=2.26
r1525 (  52 54 ) resistor r=0.0560345 //w=0.29 //l=0.13 //layer=m1 \
 //thickness=0.36 //x=46.73 //y=2.26 //x2=46.73 //y2=2.39
r1526 (  50 147 ) resistor r=9.3 //w=0.17 //l=0.17 //layer=mcon //count=1 \
 //x=46.74 //y=4.88 //x2=46.74 //y2=4.88
r1527 (  47 102 ) resistor r=4.5 //w=0.15 //l=0.15 //layer=via1 //count=1 \
 //x=35.27 //y=2.39 //x2=35.27 //y2=2.39
r1528 (  45 132 ) resistor r=9.3 //w=0.17 //l=0.17 //layer=mcon //count=1 \
 //x=35.27 //y=2.26 //x2=35.27 //y2=2.26
r1529 (  45 47 ) resistor r=0.0560345 //w=0.29 //l=0.13 //layer=m1 \
 //thickness=0.36 //x=35.27 //y=2.26 //x2=35.27 //y2=2.39
r1530 (  43 137 ) resistor r=9.3 //w=0.17 //l=0.17 //layer=mcon //count=1 \
 //x=35.27 //y=4.88 //x2=35.27 //y2=4.88
r1531 (  40 100 ) resistor r=4.5 //w=0.15 //l=0.15 //layer=via1 //count=1 \
 //x=22.31 //y=2.39 //x2=22.31 //y2=2.39
r1532 (  38 122 ) resistor r=9.3 //w=0.17 //l=0.17 //layer=mcon //count=1 \
 //x=22.32 //y=2.26 //x2=22.32 //y2=2.26
r1533 (  38 40 ) resistor r=0.0560345 //w=0.29 //l=0.13 //layer=m1 \
 //thickness=0.36 //x=22.31 //y=2.26 //x2=22.31 //y2=2.39
r1534 (  36 127 ) resistor r=9.3 //w=0.17 //l=0.17 //layer=mcon //count=1 \
 //x=22.32 //y=4.88 //x2=22.32 //y2=4.88
r1535 (  33 96 ) resistor r=4.5 //w=0.15 //l=0.15 //layer=via1 //count=1 \
 //x=10.85 //y=2.39 //x2=10.85 //y2=2.39
r1536 (  31 112 ) resistor r=9.3 //w=0.17 //l=0.17 //layer=mcon //count=1 \
 //x=10.85 //y=2.26 //x2=10.85 //y2=2.26
r1537 (  31 33 ) resistor r=0.0560345 //w=0.29 //l=0.13 //layer=m1 \
 //thickness=0.36 //x=10.85 //y=2.26 //x2=10.85 //y2=2.39
r1538 (  29 117 ) resistor r=9.3 //w=0.17 //l=0.17 //layer=mcon //count=1 \
 //x=10.85 //y=4.88 //x2=10.85 //y2=4.88
r1539 (  27 63 ) resistor r=0.0717383 //w=0.224 //l=0.115 //layer=m1 \
 //thickness=0.36 //x=71.16 //y=4.765 //x2=71.16 //y2=4.88
r1540 (  26 27 ) resistor r=2.11355 //w=0.131 //l=2.215 //layer=m1 \
 //thickness=0.36 //x=71.16 //y=2.55 //x2=71.16 //y2=4.765
r1541 (  24 56 ) resistor r=0.0717383 //w=0.224 //l=0.115 //layer=m1 \
 //thickness=0.36 //x=59.69 //y=4.765 //x2=59.69 //y2=4.88
r1542 (  22 50 ) resistor r=0.0717383 //w=0.224 //l=0.115 //layer=m1 \
 //thickness=0.36 //x=46.74 //y=4.765 //x2=46.74 //y2=4.88
r1543 (  21 54 ) resistor r=0.0901908 //w=0.29 //l=0.164924 //layer=m1 \
 //thickness=0.36 //x=46.74 //y=2.55 //x2=46.73 //y2=2.39
r1544 (  21 22 ) resistor r=2.11355 //w=0.131 //l=2.215 //layer=m1 \
 //thickness=0.36 //x=46.74 //y=2.55 //x2=46.74 //y2=4.765
r1545 (  20 43 ) resistor r=0.0717383 //w=0.224 //l=0.115 //layer=m1 \
 //thickness=0.36 //x=35.27 //y=4.765 //x2=35.27 //y2=4.88
r1546 (  19 20 ) resistor r=2.11355 //w=0.131 //l=2.215 //layer=m1 \
 //thickness=0.36 //x=35.27 //y=2.55 //x2=35.27 //y2=4.765
r1547 (  16 36 ) resistor r=0.0717383 //w=0.224 //l=0.115 //layer=m1 \
 //thickness=0.36 //x=22.32 //y=4.765 //x2=22.32 //y2=4.88
r1548 (  12 29 ) resistor r=0.0717383 //w=0.224 //l=0.115 //layer=m1 \
 //thickness=0.36 //x=10.85 //y=4.765 //x2=10.85 //y2=4.88
r1549 (  10 26 ) resistor r=0.0858804 //w=0.29 //l=0.154919 //layer=m1 \
 //thickness=0.36 //x=71.15 //y=2.4 //x2=71.16 //y2=2.55
r1550 (  10 67 ) resistor r=0.00431034 //w=0.29 //l=0.01 //layer=m1 \
 //thickness=0.36 //x=71.15 //y=2.4 //x2=71.15 //y2=2.39
r1551 (  9 23 ) resistor r=0.0858804 //w=0.29 //l=0.15 //layer=m1 \
 //thickness=0.36 //x=59.69 //y=2.4 //x2=59.69 //y2=2.55
r1552 (  9 60 ) resistor r=0.00431034 //w=0.29 //l=0.01 //layer=m1 \
 //thickness=0.36 //x=59.69 //y=2.4 //x2=59.69 //y2=2.39
r1553 (  8 19 ) resistor r=0.0858804 //w=0.29 //l=0.15 //layer=m1 \
 //thickness=0.36 //x=35.27 //y=2.4 //x2=35.27 //y2=2.55
r1554 (  8 47 ) resistor r=0.00431034 //w=0.29 //l=0.01 //layer=m1 \
 //thickness=0.36 //x=35.27 //y=2.4 //x2=35.27 //y2=2.39
r1555 (  7 15 ) resistor r=0.0858804 //w=0.29 //l=0.154919 //layer=m1 \
 //thickness=0.36 //x=22.31 //y=2.4 //x2=22.32 //y2=2.55
r1556 (  7 40 ) resistor r=0.00431034 //w=0.29 //l=0.01 //layer=m1 \
 //thickness=0.36 //x=22.31 //y=2.4 //x2=22.31 //y2=2.39
r1557 (  6 11 ) resistor r=0.0858804 //w=0.29 //l=0.15 //layer=m1 \
 //thickness=0.36 //x=10.85 //y=2.4 //x2=10.85 //y2=2.55
r1558 (  6 33 ) resistor r=0.00431034 //w=0.29 //l=0.01 //layer=m1 \
 //thickness=0.36 //x=10.85 //y=2.4 //x2=10.85 //y2=2.39
r1559 (  5 24 ) resistor r=1.90363 //w=0.131 //l=1.995 //layer=m1 \
 //thickness=0.36 //x=59.69 //y=2.77 //x2=59.69 //y2=4.765
r1560 (  5 23 ) resistor r=0.209924 //w=0.131 //l=0.22 //layer=m1 \
 //thickness=0.36 //x=59.69 //y=2.77 //x2=59.69 //y2=2.55
r1561 (  4 16 ) resistor r=0.491412 //w=0.131 //l=0.515 //layer=m1 \
 //thickness=0.36 //x=22.32 //y=4.25 //x2=22.32 //y2=4.765
r1562 (  3 4 ) resistor r=1.41221 //w=0.131 //l=1.48 //layer=m1 \
 //thickness=0.36 //x=22.32 //y=2.77 //x2=22.32 //y2=4.25
r1563 (  3 15 ) resistor r=0.209924 //w=0.131 //l=0.22 //layer=m1 \
 //thickness=0.36 //x=22.32 //y=2.77 //x2=22.32 //y2=2.55
r1564 (  2 12 ) resistor r=1.19752 //w=0.131 //l=1.255 //layer=m1 \
 //thickness=0.36 //x=10.85 //y=3.51 //x2=10.85 //y2=4.765
r1565 (  1 2 ) resistor r=0.706107 //w=0.131 //l=0.74 //layer=m1 \
 //thickness=0.36 //x=10.85 //y=2.77 //x2=10.85 //y2=3.51
r1566 (  1 11 ) resistor r=0.209924 //w=0.131 //l=0.22 //layer=m1 \
 //thickness=0.36 //x=10.85 //y=2.77 //x2=10.85 //y2=2.55
ends PM_TMRDFFSNQX1\%SN

subckt PM_TMRDFFSNQX1\%noxref_19 ( 1 2 3 4 5 6 7 8 11 16 17 19 20 22 23 24 25 \
 26 27 28 36 40 47 48 51 53 58 60 67 69 72 78 83 84 86 87 90 99 104 113 118 \
 126 143 152 156 157 158 159 160 161 162 163 164 168 169 170 175 177 180 181 \
 185 186 187 192 194 197 198 202 203 204 209 211 214 215 217 218 223 227 228 \
 233 237 238 243 246 248 249 )
c582 ( 246 0 ) capacitor c=0.00878249f //x=64.24 //y=1.085
c583 ( 243 0 ) capacitor c=0.0649531f //x=72.27 //y=4.88
c584 ( 238 0 ) capacitor c=0.0278202f //x=72.27 //y=2.095
c585 ( 237 0 ) capacitor c=0.0503043f //x=72.27 //y=2.26
c586 ( 233 0 ) capacitor c=0.0651619f //x=60.8 //y=4.88
c587 ( 228 0 ) capacitor c=0.0278202f //x=60.8 //y=2.095
c588 ( 227 0 ) capacitor c=0.0503043f //x=60.8 //y=2.26
c589 ( 223 0 ) capacitor c=0.0654765f //x=55.99 //y=4.88
c590 ( 218 0 ) capacitor c=0.0278202f //x=55.99 //y=2.095
c591 ( 217 0 ) capacitor c=0.0503043f //x=55.99 //y=2.26
c592 ( 215 0 ) capacitor c=0.0443175f //x=72.79 //y=1.44
c593 ( 214 0 ) capacitor c=0.0199703f //x=72.79 //y=1.095
c594 ( 211 0 ) capacitor c=0.0162526f //x=72.635 //y=1.595
c595 ( 209 0 ) capacitor c=0.0157807f //x=72.635 //y=0.94
c596 ( 204 0 ) capacitor c=0.0220935f //x=72.26 //y=1.75
c597 ( 203 0 ) capacitor c=0.0207489f //x=72.26 //y=1.44
c598 ( 202 0 ) capacitor c=0.0194091f //x=72.26 //y=1.095
c599 ( 198 0 ) capacitor c=0.0443175f //x=61.32 //y=1.44
c600 ( 197 0 ) capacitor c=0.0199703f //x=61.32 //y=1.095
c601 ( 194 0 ) capacitor c=0.0162526f //x=61.165 //y=1.595
c602 ( 192 0 ) capacitor c=0.0157807f //x=61.165 //y=0.94
c603 ( 187 0 ) capacitor c=0.0220935f //x=60.79 //y=1.75
c604 ( 186 0 ) capacitor c=0.0207489f //x=60.79 //y=1.44
c605 ( 185 0 ) capacitor c=0.0194091f //x=60.79 //y=1.095
c606 ( 181 0 ) capacitor c=0.0443175f //x=56.51 //y=1.44
c607 ( 180 0 ) capacitor c=0.0199703f //x=56.51 //y=1.095
c608 ( 177 0 ) capacitor c=0.0162526f //x=56.355 //y=1.595
c609 ( 175 0 ) capacitor c=0.0157807f //x=56.355 //y=0.94
c610 ( 170 0 ) capacitor c=0.0220935f //x=55.98 //y=1.75
c611 ( 169 0 ) capacitor c=0.0207489f //x=55.98 //y=1.44
c612 ( 168 0 ) capacitor c=0.0194091f //x=55.98 //y=1.095
c613 ( 164 0 ) capacitor c=0.159671f //x=72.45 //y=6.2
c614 ( 163 0 ) capacitor c=0.110208f //x=72.01 //y=6.2
c615 ( 162 0 ) capacitor c=0.159671f //x=60.98 //y=6.2
c616 ( 161 0 ) capacitor c=0.110208f //x=60.54 //y=6.2
c617 ( 160 0 ) capacitor c=0.159671f //x=56.17 //y=6.2
c618 ( 159 0 ) capacitor c=0.110208f //x=55.73 //y=6.2
c619 ( 152 0 ) capacitor c=7.7417e-19 //x=72.27 //y=4.88
c620 ( 143 0 ) capacitor c=0.00101179f //x=72.27 //y=2.26
c621 ( 126 0 ) capacitor c=0.0319332f //x=64.39 //y=5.56
c622 ( 118 0 ) capacitor c=0.0290186f //x=63.51 //y=5.56
c623 ( 113 0 ) capacitor c=7.7417e-19 //x=60.8 //y=4.88
c624 ( 104 0 ) capacitor c=0.00101179f //x=60.8 //y=2.26
c625 ( 99 0 ) capacitor c=7.7417e-19 //x=55.99 //y=4.88
c626 ( 90 0 ) capacitor c=0.00101179f //x=55.99 //y=2.26
c627 ( 87 0 ) capacitor c=0.09033f //x=72.11 //y=3.885
c628 ( 86 0 ) capacitor c=7.01701e-19 //x=72.27 //y=3.885
c629 ( 84 0 ) capacitor c=6.66367e-19 //x=65.025 //y=3.865
c630 ( 83 0 ) capacitor c=0.0371579f //x=64.705 //y=3.865
c631 ( 78 0 ) capacitor c=6.13673e-19 //x=56.155 //y=3.865
c632 ( 72 0 ) capacitor c=0.0413042f //x=60.96 //y=3.88
c633 ( 69 0 ) capacitor c=0.00240665f //x=56.94 //y=3.865
c634 ( 67 0 ) capacitor c=0.00238969f //x=56.34 //y=3.88
c635 ( 60 0 ) capacitor c=0.0149589f //x=72.27 //y=3.88
c636 ( 58 0 ) capacitor c=0.0158493f //x=64.87 //y=3.88
c637 ( 53 0 ) capacitor c=0.0113632f //x=64.43 //y=1.18
c638 ( 51 0 ) capacitor c=5.78613e-19 //x=64.39 //y=5.56
c639 ( 48 0 ) capacitor c=0.0105477f //x=64.39 //y=5.38
c640 ( 47 0 ) capacitor c=0.00947836f //x=63.51 //y=5.56
c641 ( 40 0 ) capacitor c=0.0149589f //x=60.8 //y=3.88
c642 ( 36 0 ) capacitor c=0.0149589f //x=55.99 //y=3.88
c643 ( 28 0 ) capacitor c=0.020875f //x=72.27 //y=4.75
c644 ( 27 0 ) capacitor c=0.011264f //x=72.27 //y=4.045
c645 ( 26 0 ) capacitor c=0.0344849f //x=72.27 //y=3.725
c646 ( 25 0 ) capacitor c=0.00694371f //x=72.27 //y=2.375
c647 ( 24 0 ) capacitor c=0.0282137f //x=64.87 //y=5.295
c648 ( 23 0 ) capacitor c=0.0126593f //x=64.87 //y=4.025
c649 ( 22 0 ) capacitor c=0.0466317f //x=64.87 //y=3.705
c650 ( 20 0 ) capacitor c=0.00466468f //x=64.515 //y=1.835
c651 ( 19 0 ) capacitor c=0.0118534f //x=64.785 //y=1.835
c652 ( 17 0 ) capacitor c=0.0107481f //x=64.785 //y=5.38
c653 ( 16 0 ) capacitor c=0.0102514f //x=64.43 //y=1.75
c654 ( 11 0 ) capacitor c=0.0144196f //x=64.275 //y=5.38
c655 ( 8 0 ) capacitor c=0.0205242f //x=60.8 //y=4.75
c656 ( 7 0 ) capacitor c=0.0115359f //x=60.8 //y=4.025
c657 ( 6 0 ) capacitor c=0.0296421f //x=60.8 //y=3.705
c658 ( 5 0 ) capacitor c=0.00554287f //x=60.8 //y=2.375
c659 ( 4 0 ) capacitor c=0.0190807f //x=55.99 //y=4.75
c660 ( 3 0 ) capacitor c=0.0113483f //x=55.99 //y=4.025
c661 ( 2 0 ) capacitor c=0.0312976f //x=55.99 //y=3.705
c662 ( 1 0 ) capacitor c=0.00556102f //x=55.99 //y=2.375
r663 (  237 238 ) resistor r=52.7279 //w=0.214 //l=0.165 //layer=ply \
 //thickness=0.18 //x=72.27 //y=2.26 //x2=72.27 //y2=2.095
r664 (  227 228 ) resistor r=52.7279 //w=0.214 //l=0.165 //layer=ply \
 //thickness=0.18 //x=60.8 //y=2.26 //x2=60.8 //y2=2.095
r665 (  217 218 ) resistor r=52.7279 //w=0.214 //l=0.165 //layer=ply \
 //thickness=0.18 //x=55.99 //y=2.26 //x2=55.99 //y2=2.095
r666 (  215 245 ) resistor r=45.1352 //w=0.168 //l=0.173853 //layer=ply \
 //thickness=0.18 //x=72.79 //y=1.44 //x2=72.75 //y2=1.595
r667 (  214 244 ) resistor r=45.1352 //w=0.168 //l=0.173853 //layer=ply \
 //thickness=0.18 //x=72.79 //y=1.095 //x2=72.75 //y2=0.94
r668 (  214 215 ) resistor r=176.904 //w=0.094 //l=0.345 //layer=ply \
 //thickness=0.18 //x=72.79 //y=1.095 //x2=72.79 //y2=1.44
r669 (  212 241 ) resistor r=10.701 //w=0.21 //l=0.115 //layer=ply \
 //thickness=0.18 //x=72.415 //y=1.595 //x2=72.3 //y2=1.595
r670 (  211 245 ) resistor r=5.52526 //w=0.168 //l=0.115 //layer=ply \
 //thickness=0.18 //x=72.635 //y=1.595 //x2=72.75 //y2=1.595
r671 (  210 240 ) resistor r=5.52526 //w=0.168 //l=0.115 //layer=ply \
 //thickness=0.18 //x=72.415 //y=0.94 //x2=72.3 //y2=0.94
r672 (  209 244 ) resistor r=5.52526 //w=0.168 //l=0.115 //layer=ply \
 //thickness=0.18 //x=72.635 //y=0.94 //x2=72.75 //y2=0.94
r673 (  209 210 ) resistor r=112.809 //w=0.094 //l=0.22 //layer=ply \
 //thickness=0.18 //x=72.635 //y=0.94 //x2=72.415 //y2=0.94
r674 (  206 243 ) resistor r=37.236 //w=0.233 //l=0.249199 //layer=ply \
 //thickness=0.18 //x=72.45 //y=5.045 //x2=72.27 //y2=4.88
r675 (  204 241 ) resistor r=39.5823 //w=0.21 //l=0.173853 //layer=ply \
 //thickness=0.18 //x=72.26 //y=1.75 //x2=72.3 //y2=1.595
r676 (  204 238 ) resistor r=176.904 //w=0.094 //l=0.345 //layer=ply \
 //thickness=0.18 //x=72.26 //y=1.75 //x2=72.26 //y2=2.095
r677 (  203 241 ) resistor r=39.5823 //w=0.21 //l=0.173853 //layer=ply \
 //thickness=0.18 //x=72.26 //y=1.44 //x2=72.3 //y2=1.595
r678 (  202 240 ) resistor r=45.1352 //w=0.168 //l=0.173853 //layer=ply \
 //thickness=0.18 //x=72.26 //y=1.095 //x2=72.3 //y2=0.94
r679 (  202 203 ) resistor r=176.904 //w=0.094 //l=0.345 //layer=ply \
 //thickness=0.18 //x=72.26 //y=1.095 //x2=72.26 //y2=1.44
r680 (  199 243 ) resistor r=53.7854 //w=0.233 //l=0.332415 //layer=ply \
 //thickness=0.18 //x=72.01 //y=5.045 //x2=72.27 //y2=4.88
r681 (  198 235 ) resistor r=45.1352 //w=0.168 //l=0.173853 //layer=ply \
 //thickness=0.18 //x=61.32 //y=1.44 //x2=61.28 //y2=1.595
r682 (  197 234 ) resistor r=45.1352 //w=0.168 //l=0.173853 //layer=ply \
 //thickness=0.18 //x=61.32 //y=1.095 //x2=61.28 //y2=0.94
r683 (  197 198 ) resistor r=176.904 //w=0.094 //l=0.345 //layer=ply \
 //thickness=0.18 //x=61.32 //y=1.095 //x2=61.32 //y2=1.44
r684 (  195 231 ) resistor r=10.701 //w=0.21 //l=0.115 //layer=ply \
 //thickness=0.18 //x=60.945 //y=1.595 //x2=60.83 //y2=1.595
r685 (  194 235 ) resistor r=5.52526 //w=0.168 //l=0.115 //layer=ply \
 //thickness=0.18 //x=61.165 //y=1.595 //x2=61.28 //y2=1.595
r686 (  193 230 ) resistor r=5.52526 //w=0.168 //l=0.115 //layer=ply \
 //thickness=0.18 //x=60.945 //y=0.94 //x2=60.83 //y2=0.94
r687 (  192 234 ) resistor r=5.52526 //w=0.168 //l=0.115 //layer=ply \
 //thickness=0.18 //x=61.165 //y=0.94 //x2=61.28 //y2=0.94
r688 (  192 193 ) resistor r=112.809 //w=0.094 //l=0.22 //layer=ply \
 //thickness=0.18 //x=61.165 //y=0.94 //x2=60.945 //y2=0.94
r689 (  189 233 ) resistor r=37.236 //w=0.233 //l=0.249199 //layer=ply \
 //thickness=0.18 //x=60.98 //y=5.045 //x2=60.8 //y2=4.88
r690 (  187 231 ) resistor r=39.5823 //w=0.21 //l=0.173853 //layer=ply \
 //thickness=0.18 //x=60.79 //y=1.75 //x2=60.83 //y2=1.595
r691 (  187 228 ) resistor r=176.904 //w=0.094 //l=0.345 //layer=ply \
 //thickness=0.18 //x=60.79 //y=1.75 //x2=60.79 //y2=2.095
r692 (  186 231 ) resistor r=39.5823 //w=0.21 //l=0.173853 //layer=ply \
 //thickness=0.18 //x=60.79 //y=1.44 //x2=60.83 //y2=1.595
r693 (  185 230 ) resistor r=45.1352 //w=0.168 //l=0.173853 //layer=ply \
 //thickness=0.18 //x=60.79 //y=1.095 //x2=60.83 //y2=0.94
r694 (  185 186 ) resistor r=176.904 //w=0.094 //l=0.345 //layer=ply \
 //thickness=0.18 //x=60.79 //y=1.095 //x2=60.79 //y2=1.44
r695 (  182 233 ) resistor r=53.7854 //w=0.233 //l=0.332415 //layer=ply \
 //thickness=0.18 //x=60.54 //y=5.045 //x2=60.8 //y2=4.88
r696 (  181 225 ) resistor r=45.1352 //w=0.168 //l=0.173853 //layer=ply \
 //thickness=0.18 //x=56.51 //y=1.44 //x2=56.47 //y2=1.595
r697 (  180 224 ) resistor r=45.1352 //w=0.168 //l=0.173853 //layer=ply \
 //thickness=0.18 //x=56.51 //y=1.095 //x2=56.47 //y2=0.94
r698 (  180 181 ) resistor r=176.904 //w=0.094 //l=0.345 //layer=ply \
 //thickness=0.18 //x=56.51 //y=1.095 //x2=56.51 //y2=1.44
r699 (  178 221 ) resistor r=10.701 //w=0.21 //l=0.115 //layer=ply \
 //thickness=0.18 //x=56.135 //y=1.595 //x2=56.02 //y2=1.595
r700 (  177 225 ) resistor r=5.52526 //w=0.168 //l=0.115 //layer=ply \
 //thickness=0.18 //x=56.355 //y=1.595 //x2=56.47 //y2=1.595
r701 (  176 220 ) resistor r=5.52526 //w=0.168 //l=0.115 //layer=ply \
 //thickness=0.18 //x=56.135 //y=0.94 //x2=56.02 //y2=0.94
r702 (  175 224 ) resistor r=5.52526 //w=0.168 //l=0.115 //layer=ply \
 //thickness=0.18 //x=56.355 //y=0.94 //x2=56.47 //y2=0.94
r703 (  175 176 ) resistor r=112.809 //w=0.094 //l=0.22 //layer=ply \
 //thickness=0.18 //x=56.355 //y=0.94 //x2=56.135 //y2=0.94
r704 (  172 223 ) resistor r=37.236 //w=0.233 //l=0.249199 //layer=ply \
 //thickness=0.18 //x=56.17 //y=5.045 //x2=55.99 //y2=4.88
r705 (  170 221 ) resistor r=39.5823 //w=0.21 //l=0.173853 //layer=ply \
 //thickness=0.18 //x=55.98 //y=1.75 //x2=56.02 //y2=1.595
r706 (  170 218 ) resistor r=176.904 //w=0.094 //l=0.345 //layer=ply \
 //thickness=0.18 //x=55.98 //y=1.75 //x2=55.98 //y2=2.095
r707 (  169 221 ) resistor r=39.5823 //w=0.21 //l=0.173853 //layer=ply \
 //thickness=0.18 //x=55.98 //y=1.44 //x2=56.02 //y2=1.595
r708 (  168 220 ) resistor r=45.1352 //w=0.168 //l=0.173853 //layer=ply \
 //thickness=0.18 //x=55.98 //y=1.095 //x2=56.02 //y2=0.94
r709 (  168 169 ) resistor r=176.904 //w=0.094 //l=0.345 //layer=ply \
 //thickness=0.18 //x=55.98 //y=1.095 //x2=55.98 //y2=1.44
r710 (  165 223 ) resistor r=53.7854 //w=0.233 //l=0.332415 //layer=ply \
 //thickness=0.18 //x=55.73 //y=5.045 //x2=55.99 //y2=4.88
r711 (  164 206 ) resistor r=592.245 //w=0.094 //l=1.155 //layer=ply \
 //thickness=0.18 //x=72.45 //y=6.2 //x2=72.45 //y2=5.045
r712 (  163 199 ) resistor r=592.245 //w=0.094 //l=1.155 //layer=ply \
 //thickness=0.18 //x=72.01 //y=6.2 //x2=72.01 //y2=5.045
r713 (  162 189 ) resistor r=592.245 //w=0.094 //l=1.155 //layer=ply \
 //thickness=0.18 //x=60.98 //y=6.2 //x2=60.98 //y2=5.045
r714 (  161 182 ) resistor r=592.245 //w=0.094 //l=1.155 //layer=ply \
 //thickness=0.18 //x=60.54 //y=6.2 //x2=60.54 //y2=5.045
r715 (  160 172 ) resistor r=592.245 //w=0.094 //l=1.155 //layer=ply \
 //thickness=0.18 //x=56.17 //y=6.2 //x2=56.17 //y2=5.045
r716 (  159 165 ) resistor r=592.245 //w=0.094 //l=1.155 //layer=ply \
 //thickness=0.18 //x=55.73 //y=6.2 //x2=55.73 //y2=5.045
r717 (  158 211 ) resistor r=56.4043 //w=0.094 //l=0.11 //layer=ply \
 //thickness=0.18 //x=72.525 //y=1.595 //x2=72.635 //y2=1.595
r718 (  158 212 ) resistor r=56.4043 //w=0.094 //l=0.11 //layer=ply \
 //thickness=0.18 //x=72.525 //y=1.595 //x2=72.415 //y2=1.595
r719 (  157 194 ) resistor r=56.4043 //w=0.094 //l=0.11 //layer=ply \
 //thickness=0.18 //x=61.055 //y=1.595 //x2=61.165 //y2=1.595
r720 (  157 195 ) resistor r=56.4043 //w=0.094 //l=0.11 //layer=ply \
 //thickness=0.18 //x=61.055 //y=1.595 //x2=60.945 //y2=1.595
r721 (  156 177 ) resistor r=56.4043 //w=0.094 //l=0.11 //layer=ply \
 //thickness=0.18 //x=56.245 //y=1.595 //x2=56.355 //y2=1.595
r722 (  156 178 ) resistor r=56.4043 //w=0.094 //l=0.11 //layer=ply \
 //thickness=0.18 //x=56.245 //y=1.595 //x2=56.135 //y2=1.595
r723 (  152 243 ) resistor r=152 //w=0.17 //l=0.17 //layer=licon //count=1 \
 //x=72.27 //y=4.88 //x2=72.27 //y2=4.88
r724 (  143 237 ) resistor r=152 //w=0.17 //l=0.17 //layer=licon //count=1 \
 //x=72.27 //y=2.26 //x2=72.27 //y2=2.26
r725 (  126 249 ) resistor r=23.615 //w=0.187 //l=0.345 //layer=li \
 //thickness=0.1 //x=64.39 //y=5.56 //x2=64.39 //y2=5.905
r726 (  118 248 ) resistor r=23.615 //w=0.187 //l=0.345 //layer=li \
 //thickness=0.1 //x=63.51 //y=5.56 //x2=63.51 //y2=5.905
r727 (  113 233 ) resistor r=152 //w=0.17 //l=0.17 //layer=licon //count=1 \
 //x=60.8 //y=4.88 //x2=60.8 //y2=4.88
r728 (  104 227 ) resistor r=152 //w=0.17 //l=0.17 //layer=licon //count=1 \
 //x=60.8 //y=2.26 //x2=60.8 //y2=2.26
r729 (  99 223 ) resistor r=152 //w=0.17 //l=0.17 //layer=licon //count=1 \
 //x=55.99 //y=4.88 //x2=55.99 //y2=4.88
r730 (  90 217 ) resistor r=152 //w=0.17 //l=0.17 //layer=licon //count=1 \
 //x=55.99 //y=2.26 //x2=55.99 //y2=2.26
r731 (  86 87 ) resistor r=0.10734 //w=0.281 //l=0.16 //layer=m2 \
 //thickness=0.36 //x=72.27 //y=3.885 //x2=72.11 //y2=3.885
r732 (  84 87 ) resistor r=6.7605 //w=0.131 //l=7.085 //layer=m2 \
 //thickness=0.36 //x=65.025 //y=3.88 //x2=72.11 //y2=3.88
r733 (  82 84 ) resistor r=0.10734 //w=0.281 //l=0.16 //layer=m2 \
 //thickness=0.36 //x=64.865 //y=3.865 //x2=65.025 //y2=3.865
r734 (  82 83 ) resistor r=0.10734 //w=0.281 //l=0.16 //layer=m2 \
 //thickness=0.36 //x=64.865 //y=3.865 //x2=64.705 //y2=3.865
r735 (  76 78 ) resistor r=0.10734 //w=0.281 //l=0.16 //layer=m2 \
 //thickness=0.36 //x=55.995 //y=3.865 //x2=56.155 //y2=3.865
r736 (  72 80 ) resistor r=0.110608 //w=0.182 //l=0.167332 //layer=m2 \
 //thickness=0.36 //x=60.96 //y=3.88 //x2=60.8 //y2=3.865
r737 (  72 83 ) resistor r=3.57347 //w=0.131 //l=3.745 //layer=m2 \
 //thickness=0.36 //x=60.96 //y=3.88 //x2=64.705 //y2=3.88
r738 (  69 80 ) resistor r=2.65182 //w=0.182 //l=3.86 //layer=m2 \
 //thickness=0.36 //x=56.94 //y=3.865 //x2=60.8 //y2=3.865
r739 (  69 70 ) resistor r=0.410305 //w=0.131 //l=0.43 //layer=m2 \
 //thickness=0.36 //x=56.94 //y=3.865 //x2=56.51 //y2=3.865
r740 (  67 70 ) resistor r=0.125 //w=0.17 //l=0.177341 //layer=m2 \
 //thickness=0.36 //x=56.34 //y=3.88 //x2=56.51 //y2=3.865
r741 (  67 78 ) resistor r=0.176527 //w=0.131 //l=0.185 //layer=m2 \
 //thickness=0.36 //x=56.34 //y=3.88 //x2=56.155 //y2=3.88
r742 (  66 152 ) resistor r=9.3 //w=0.17 //l=0.17 //layer=mcon //count=1 \
 //x=72.27 //y=4.88 //x2=72.27 //y2=4.88
r743 (  64 143 ) resistor r=9.3 //w=0.17 //l=0.17 //layer=mcon //count=1 \
 //x=72.27 //y=2.26 //x2=72.27 //y2=2.26
r744 (  62 86 ) resistor r=4.5 //w=0.15 //l=0.15 //layer=via1 //count=1 \
 //x=72.27 //y=3.885 //x2=72.27 //y2=3.885
r745 (  60 62 ) resistor r=0.00166223 //w=0.376 //l=0.005 //layer=m1 \
 //thickness=0.36 //x=72.217 //y=3.88 //x2=72.217 //y2=3.885
r746 (  56 82 ) resistor r=4.5 //w=0.15 //l=0.15 //layer=via1 //count=1 \
 //x=64.865 //y=3.865 //x2=64.865 //y2=3.865
r747 (  56 58 ) resistor r=0.00501337 //w=0.374 //l=0.015 //layer=m1 \
 //thickness=0.36 //x=64.815 //y=3.865 //x2=64.815 //y2=3.88
r748 (  53 246 ) resistor r=9.3 //w=0.17 //l=0.17 //layer=mcon //count=1 \
 //x=64.43 //y=1.18 //x2=64.43 //y2=1.18
r749 (  51 126 ) resistor r=9.3 //w=0.17 //l=0.17 //layer=mcon //count=1 \
 //x=64.39 //y=5.56 //x2=64.39 //y2=5.56
r750 (  48 51 ) resistor r=0.117801 //w=0.191 //l=0.18 //layer=m1 \
 //thickness=0.36 //x=64.39 //y=5.38 //x2=64.39 //y2=5.56
r751 (  47 118 ) resistor r=9.3 //w=0.17 //l=0.17 //layer=mcon //count=1 \
 //x=63.51 //y=5.56 //x2=63.51 //y2=5.56
r752 (  45 47 ) resistor r=0.10274 //w=0.219 //l=0.18 //layer=m1 \
 //thickness=0.36 //x=63.51 //y=5.38 //x2=63.51 //y2=5.56
r753 (  44 113 ) resistor r=9.3 //w=0.17 //l=0.17 //layer=mcon //count=1 \
 //x=60.8 //y=4.88 //x2=60.8 //y2=4.88
r754 (  42 104 ) resistor r=9.3 //w=0.17 //l=0.17 //layer=mcon //count=1 \
 //x=60.8 //y=2.26 //x2=60.8 //y2=2.26
r755 (  38 80 ) resistor r=4.5 //w=0.15 //l=0.15 //layer=via1 //count=1 \
 //x=60.8 //y=3.865 //x2=60.8 //y2=3.865
r756 (  38 40 ) resistor r=0.0049867 //w=0.376 //l=0.015 //layer=m1 \
 //thickness=0.36 //x=60.747 //y=3.865 //x2=60.747 //y2=3.88
r757 (  34 76 ) resistor r=4.5 //w=0.15 //l=0.15 //layer=via1 //count=1 \
 //x=55.995 //y=3.865 //x2=55.995 //y2=3.865
r758 (  34 36 ) resistor r=0.00501337 //w=0.374 //l=0.015 //layer=m1 \
 //thickness=0.36 //x=56.045 //y=3.865 //x2=56.045 //y2=3.88
r759 (  32 99 ) resistor r=9.3 //w=0.17 //l=0.17 //layer=mcon //count=1 \
 //x=55.99 //y=4.88 //x2=55.99 //y2=4.88
r760 (  30 90 ) resistor r=9.3 //w=0.17 //l=0.17 //layer=mcon //count=1 \
 //x=55.99 //y=2.26 //x2=55.99 //y2=2.26
r761 (  28 66 ) resistor r=0.0801089 //w=0.224 //l=0.13 //layer=m1 \
 //thickness=0.36 //x=72.27 //y=4.75 //x2=72.27 //y2=4.88
r762 (  27 62 ) resistor r=0.0911593 //w=0.376 //l=0.184608 //layer=m1 \
 //thickness=0.36 //x=72.27 //y=4.045 //x2=72.217 //y2=3.885
r763 (  27 28 ) resistor r=0.67271 //w=0.131 //l=0.705 //layer=m1 \
 //thickness=0.36 //x=72.27 //y=4.045 //x2=72.27 //y2=4.75
r764 (  26 60 ) resistor r=0.0894971 //w=0.376 //l=0.179555 //layer=m1 \
 //thickness=0.36 //x=72.27 //y=3.725 //x2=72.217 //y2=3.88
r765 (  25 64 ) resistor r=0.0719237 //w=0.222 //l=0.115 //layer=m1 \
 //thickness=0.36 //x=72.27 //y=2.375 //x2=72.27 //y2=2.26
r766 (  25 26 ) resistor r=1.28817 //w=0.131 //l=1.35 //layer=m1 \
 //thickness=0.36 //x=72.27 //y=2.375 //x2=72.27 //y2=3.725
r767 (  23 58 ) resistor r=0.0860668 //w=0.374 //l=0.170294 //layer=m1 \
 //thickness=0.36 //x=64.87 //y=4.025 //x2=64.815 //y2=3.88
r768 (  23 24 ) resistor r=1.21183 //w=0.131 //l=1.27 //layer=m1 \
 //thickness=0.36 //x=64.87 //y=4.025 //x2=64.87 //y2=5.295
r769 (  22 56 ) resistor r=0.0910802 //w=0.374 //l=0.185472 //layer=m1 \
 //thickness=0.36 //x=64.87 //y=3.705 //x2=64.815 //y2=3.865
r770 (  21 22 ) resistor r=1.70324 //w=0.131 //l=1.785 //layer=m1 \
 //thickness=0.36 //x=64.87 //y=1.92 //x2=64.87 //y2=3.705
r771 (  19 21 ) resistor r=0.0698411 //w=0.17 //l=0.120208 //layer=m1 \
 //thickness=0.36 //x=64.785 //y=1.835 //x2=64.87 //y2=1.92
r772 (  19 20 ) resistor r=0.257634 //w=0.131 //l=0.27 //layer=m1 \
 //thickness=0.36 //x=64.785 //y=1.835 //x2=64.515 //y2=1.835
r773 (  18 48 ) resistor r=0.0257089 //w=0.23 //l=0.115 //layer=m1 \
 //thickness=0.36 //x=64.505 //y=5.38 //x2=64.39 //y2=5.38
r774 (  17 24 ) resistor r=0.0698411 //w=0.17 //l=0.120208 //layer=m1 \
 //thickness=0.36 //x=64.785 //y=5.38 //x2=64.87 //y2=5.295
r775 (  17 18 ) resistor r=0.267176 //w=0.131 //l=0.28 //layer=m1 \
 //thickness=0.36 //x=64.785 //y=5.38 //x2=64.505 //y2=5.38
r776 (  16 20 ) resistor r=0.0698411 //w=0.17 //l=0.120208 //layer=m1 \
 //thickness=0.36 //x=64.43 //y=1.75 //x2=64.515 //y2=1.835
r777 (  15 53 ) resistor r=0.0913624 //w=0.191 //l=0.12 //layer=m1 \
 //thickness=0.36 //x=64.43 //y=1.3 //x2=64.43 //y2=1.18
r778 (  15 16 ) resistor r=0.429389 //w=0.131 //l=0.45 //layer=m1 \
 //thickness=0.36 //x=64.43 //y=1.3 //x2=64.43 //y2=1.75
r779 (  12 45 ) resistor r=0.0227762 //w=0.219 //l=0.115 //layer=m1 \
 //thickness=0.36 //x=63.625 //y=5.38 //x2=63.51 //y2=5.38
r780 (  11 48 ) resistor r=0.0257089 //w=0.23 //l=0.115 //layer=m1 \
 //thickness=0.36 //x=64.275 //y=5.38 //x2=64.39 //y2=5.38
r781 (  11 12 ) resistor r=0.620229 //w=0.131 //l=0.65 //layer=m1 \
 //thickness=0.36 //x=64.275 //y=5.38 //x2=63.625 //y2=5.38
r782 (  8 44 ) resistor r=0.0801089 //w=0.224 //l=0.13 //layer=m1 \
 //thickness=0.36 //x=60.8 //y=4.75 //x2=60.8 //y2=4.88
r783 (  7 40 ) resistor r=0.0861726 //w=0.376 //l=0.16944 //layer=m1 \
 //thickness=0.36 //x=60.8 //y=4.025 //x2=60.747 //y2=3.88
r784 (  7 8 ) resistor r=0.691794 //w=0.131 //l=0.725 //layer=m1 \
 //thickness=0.36 //x=60.8 //y=4.025 //x2=60.8 //y2=4.75
r785 (  6 38 ) resistor r=0.0911593 //w=0.376 //l=0.184608 //layer=m1 \
 //thickness=0.36 //x=60.8 //y=3.705 //x2=60.747 //y2=3.865
r786 (  5 42 ) resistor r=0.0719237 //w=0.222 //l=0.115 //layer=m1 \
 //thickness=0.36 //x=60.8 //y=2.375 //x2=60.8 //y2=2.26
r787 (  5 6 ) resistor r=1.26908 //w=0.131 //l=1.33 //layer=m1 \
 //thickness=0.36 //x=60.8 //y=2.375 //x2=60.8 //y2=3.705
r788 (  4 32 ) resistor r=0.0801089 //w=0.224 //l=0.13 //layer=m1 \
 //thickness=0.36 //x=55.99 //y=4.75 //x2=55.99 //y2=4.88
r789 (  3 36 ) resistor r=0.0860668 //w=0.374 //l=0.170294 //layer=m1 \
 //thickness=0.36 //x=55.99 //y=4.025 //x2=56.045 //y2=3.88
r790 (  3 4 ) resistor r=0.691794 //w=0.131 //l=0.725 //layer=m1 \
 //thickness=0.36 //x=55.99 //y=4.025 //x2=55.99 //y2=4.75
r791 (  2 34 ) resistor r=0.0910802 //w=0.374 //l=0.185472 //layer=m1 \
 //thickness=0.36 //x=55.99 //y=3.705 //x2=56.045 //y2=3.865
r792 (  1 30 ) resistor r=0.0719237 //w=0.222 //l=0.115 //layer=m1 \
 //thickness=0.36 //x=55.99 //y=2.375 //x2=55.99 //y2=2.26
r793 (  1 2 ) resistor r=1.26908 //w=0.131 //l=1.33 //layer=m1 \
 //thickness=0.36 //x=55.99 //y=2.375 //x2=55.99 //y2=3.705
ends PM_TMRDFFSNQX1\%noxref_19

subckt PM_TMRDFFSNQX1\%noxref_20 ( 2 3 5 8 9 11 12 13 14 16 17 18 19 20 21 22 \
 24 28 31 34 37 45 49 52 59 62 66 69 70 74 75 78 83 88 96 104 121 126 132 137 \
 142 143 144 145 146 147 148 149 150 151 152 153 158 160 162 168 169 170 171 \
 172 173 177 179 182 183 184 185 189 190 191 192 196 198 204 205 207 208 211 \
 220 233 236 238 239 240 )
c560 ( 236 0 ) capacitor c=0.00885916f //x=72.335 //y=1.095
c561 ( 233 0 ) capacitor c=0.0692896f //x=78.19 //y=4.885
c562 ( 220 0 ) capacitor c=0.0603371f //x=74.49 //y=2.26
c563 ( 211 0 ) capacitor c=0.0364378f //x=67.49 //y=4.88
c564 ( 208 0 ) capacitor c=0.0284095f //x=67.46 //y=2.095
c565 ( 207 0 ) capacitor c=0.0476356f //x=67.46 //y=2.26
c566 ( 205 0 ) capacitor c=0.0344584f //x=78.525 //y=1.39
c567 ( 204 0 ) capacitor c=0.0186809f //x=78.525 //y=1.045
c568 ( 198 0 ) capacitor c=0.0141797f //x=78.37 //y=1.545
c569 ( 196 0 ) capacitor c=0.0158553f //x=78.37 //y=0.89
c570 ( 192 0 ) capacitor c=0.103881f //x=77.995 //y=2.095
c571 ( 191 0 ) capacitor c=0.0227978f //x=77.995 //y=1.7
c572 ( 190 0 ) capacitor c=0.0234352f //x=77.995 //y=1.39
c573 ( 189 0 ) capacitor c=0.0198759f //x=77.995 //y=1.045
c574 ( 185 0 ) capacitor c=0.0318956f //x=75.195 //y=1.39
c575 ( 184 0 ) capacitor c=0.0186809f //x=75.195 //y=1.045
c576 ( 183 0 ) capacitor c=0.0624333f //x=74.835 //y=4.975
c577 ( 182 0 ) capacitor c=0.0375163f //x=75.125 //y=4.975
c578 ( 179 0 ) capacitor c=0.0157936f //x=75.04 //y=1.545
c579 ( 177 0 ) capacitor c=0.0158553f //x=75.04 //y=0.89
c580 ( 173 0 ) capacitor c=0.0302441f //x=74.665 //y=2.095
c581 ( 172 0 ) capacitor c=0.0238107f //x=74.665 //y=1.7
c582 ( 171 0 ) capacitor c=0.0234359f //x=74.665 //y=1.39
c583 ( 170 0 ) capacitor c=0.0199332f //x=74.665 //y=1.045
c584 ( 169 0 ) capacitor c=0.0439708f //x=68.025 //y=1.43
c585 ( 168 0 ) capacitor c=0.0192582f //x=68.025 //y=1.085
c586 ( 162 0 ) capacitor c=0.0162526f //x=67.87 //y=1.585
c587 ( 160 0 ) capacitor c=0.0157807f //x=67.87 //y=0.93
c588 ( 158 0 ) capacitor c=0.0363718f //x=67.865 //y=4.97
c589 ( 153 0 ) capacitor c=0.0210762f //x=67.495 //y=1.74
c590 ( 152 0 ) capacitor c=0.0168511f //x=67.495 //y=1.43
c591 ( 151 0 ) capacitor c=0.0175485f //x=67.495 //y=1.085
c592 ( 150 0 ) capacitor c=0.111167f //x=78.52 //y=6.205
c593 ( 149 0 ) capacitor c=0.154978f //x=78.08 //y=6.205
c594 ( 148 0 ) capacitor c=0.110282f //x=75.2 //y=6.205
c595 ( 147 0 ) capacitor c=0.155219f //x=74.76 //y=6.205
c596 ( 146 0 ) capacitor c=0.154853f //x=67.94 //y=6.2
c597 ( 145 0 ) capacitor c=0.110375f //x=67.5 //y=6.2
c598 ( 137 0 ) capacitor c=0.0156727f //x=78.19 //y=4.62
c599 ( 132 0 ) capacitor c=0.00126053f //x=78.19 //y=2.26
c600 ( 126 0 ) capacitor c=0.0129759f //x=74.49 //y=4.62
c601 ( 121 0 ) capacitor c=7.43216e-19 //x=74.49 //y=2.26
c602 ( 104 0 ) capacitor c=0.0292914f //x=72.23 //y=5.56
c603 ( 96 0 ) capacitor c=0.029098f //x=71.35 //y=5.56
c604 ( 88 0 ) capacitor c=0.0277605f //x=70.47 //y=5.56
c605 ( 83 0 ) capacitor c=6.57489e-19 //x=67.49 //y=4.88
c606 ( 78 0 ) capacitor c=7.72439e-19 //x=67.46 //y=2.26
c607 ( 75 0 ) capacitor c=0.0723112f //x=78.035 //y=4.64
c608 ( 74 0 ) capacitor c=0.00642399f //x=78.195 //y=4.64
c609 ( 70 0 ) capacitor c=0.00430583f //x=73.165 //y=4.615
c610 ( 69 0 ) capacitor c=0.104335f //x=72.845 //y=4.615
c611 ( 66 0 ) capacitor c=0.00464454f //x=67.64 //y=4.64
c612 ( 62 0 ) capacitor c=0.00609426f //x=74.655 //y=4.62
c613 ( 59 0 ) capacitor c=0.0411281f //x=74.335 //y=4.62
c614 ( 52 0 ) capacitor c=0.0127992f //x=78.19 //y=4.62
c615 ( 49 0 ) capacitor c=0.0137491f //x=74.49 //y=4.62
c616 ( 45 0 ) capacitor c=0.0145768f //x=73.01 //y=4.62
c617 ( 37 0 ) capacitor c=8.84507e-19 //x=72.23 //y=5.335
c618 ( 34 0 ) capacitor c=0.00799521f //x=71.35 //y=5.335
c619 ( 31 0 ) capacitor c=0.0111234f //x=70.472 //y=5.335
c620 ( 28 0 ) capacitor c=0.011527f //x=67.48 //y=4.64
c621 ( 24 0 ) capacitor c=0.00504845f //x=67.46 //y=2.26
c622 ( 22 0 ) capacitor c=0.0770357f //x=78.19 //y=4.475
c623 ( 21 0 ) capacitor c=0.00888199f //x=78.19 //y=2.385
c624 ( 20 0 ) capacitor c=0.0584781f //x=74.49 //y=4.46
c625 ( 19 0 ) capacitor c=0.00562527f //x=74.49 //y=2.375
c626 ( 18 0 ) capacitor c=0.0132749f //x=73.01 //y=5.25
c627 ( 17 0 ) capacitor c=0.0126216f //x=73.01 //y=4.775
c628 ( 16 0 ) capacitor c=0.0686702f //x=73.01 //y=4.455
c629 ( 14 0 ) capacitor c=0.00647115f //x=72.61 //y=1.845
c630 ( 13 0 ) capacitor c=0.0168551f //x=72.925 //y=1.845
c631 ( 12 0 ) capacitor c=0.0149757f //x=72.525 //y=1.76
c632 ( 11 0 ) capacitor c=0.0113674f //x=72.525 //y=1.305
c633 ( 9 0 ) capacitor c=0.0220615f //x=72.925 //y=5.335
c634 ( 8 0 ) capacitor c=0.00906283f //x=72.23 //y=5.56
c635 ( 5 0 ) capacitor c=0.0180822f //x=72.115 //y=5.335
c636 ( 3 0 ) capacitor c=0.0151888f //x=71.23 //y=5.335
c637 ( 2 0 ) capacitor c=0.0458209f //x=67.46 //y=4.48
r638 (  231 233 ) resistor r=22.7554 //w=0.233 //l=0.11 //layer=ply \
 //thickness=0.18 //x=78.08 //y=4.885 //x2=78.19 //y2=4.885
r639 (  213 214 ) resistor r=32.4568 //w=0.214 //l=0.075 //layer=ply \
 //thickness=0.18 //x=67.49 //y=4.97 //x2=67.49 //y2=5.045
r640 (  211 213 ) resistor r=20.271 //w=0.214 //l=0.09 //layer=ply \
 //thickness=0.18 //x=67.49 //y=4.88 //x2=67.49 //y2=4.97
r641 (  207 208 ) resistor r=52.7279 //w=0.214 //l=0.165 //layer=ply \
 //thickness=0.18 //x=67.46 //y=2.26 //x2=67.46 //y2=2.095
r642 (  205 235 ) resistor r=45.1352 //w=0.168 //l=0.173853 //layer=ply \
 //thickness=0.18 //x=78.525 //y=1.39 //x2=78.485 //y2=1.545
r643 (  204 234 ) resistor r=45.1352 //w=0.168 //l=0.173853 //layer=ply \
 //thickness=0.18 //x=78.525 //y=1.045 //x2=78.485 //y2=0.89
r644 (  204 205 ) resistor r=176.904 //w=0.094 //l=0.345 //layer=ply \
 //thickness=0.18 //x=78.525 //y=1.045 //x2=78.525 //y2=1.39
r645 (  201 233 ) resistor r=68.2661 //w=0.233 //l=0.404166 //layer=ply \
 //thickness=0.18 //x=78.52 //y=5.05 //x2=78.19 //y2=4.885
r646 (  199 230 ) resistor r=10.701 //w=0.21 //l=0.115 //layer=ply \
 //thickness=0.18 //x=78.15 //y=1.545 //x2=78.035 //y2=1.545
r647 (  198 235 ) resistor r=5.52526 //w=0.168 //l=0.115 //layer=ply \
 //thickness=0.18 //x=78.37 //y=1.545 //x2=78.485 //y2=1.545
r648 (  197 229 ) resistor r=5.52526 //w=0.168 //l=0.115 //layer=ply \
 //thickness=0.18 //x=78.15 //y=0.89 //x2=78.035 //y2=0.89
r649 (  196 234 ) resistor r=5.52526 //w=0.168 //l=0.115 //layer=ply \
 //thickness=0.18 //x=78.37 //y=0.89 //x2=78.485 //y2=0.89
r650 (  196 197 ) resistor r=112.809 //w=0.094 //l=0.22 //layer=ply \
 //thickness=0.18 //x=78.37 //y=0.89 //x2=78.15 //y2=0.89
r651 (  193 231 ) resistor r=13.0941 //w=0.233 //l=0.165 //layer=ply \
 //thickness=0.18 //x=78.08 //y=5.05 //x2=78.08 //y2=4.885
r652 (  192 228 ) resistor r=34.8111 //w=0.27 //l=0.264953 //layer=ply \
 //thickness=0.18 //x=77.995 //y=2.095 //x2=78.19 //y2=2.26
r653 (  191 230 ) resistor r=39.5823 //w=0.21 //l=0.173853 //layer=ply \
 //thickness=0.18 //x=77.995 //y=1.7 //x2=78.035 //y2=1.545
r654 (  191 192 ) resistor r=202.543 //w=0.094 //l=0.395 //layer=ply \
 //thickness=0.18 //x=77.995 //y=1.7 //x2=77.995 //y2=2.095
r655 (  190 230 ) resistor r=39.5823 //w=0.21 //l=0.173853 //layer=ply \
 //thickness=0.18 //x=77.995 //y=1.39 //x2=78.035 //y2=1.545
r656 (  189 229 ) resistor r=45.1352 //w=0.168 //l=0.173853 //layer=ply \
 //thickness=0.18 //x=77.995 //y=1.045 //x2=78.035 //y2=0.89
r657 (  189 190 ) resistor r=176.904 //w=0.094 //l=0.345 //layer=ply \
 //thickness=0.18 //x=77.995 //y=1.045 //x2=77.995 //y2=1.39
r658 (  185 226 ) resistor r=45.1352 //w=0.168 //l=0.173853 //layer=ply \
 //thickness=0.18 //x=75.195 //y=1.39 //x2=75.155 //y2=1.545
r659 (  184 225 ) resistor r=45.1352 //w=0.168 //l=0.173853 //layer=ply \
 //thickness=0.18 //x=75.195 //y=1.045 //x2=75.155 //y2=0.89
r660 (  184 185 ) resistor r=176.904 //w=0.094 //l=0.345 //layer=ply \
 //thickness=0.18 //x=75.195 //y=1.045 //x2=75.195 //y2=1.39
r661 (  182 186 ) resistor r=26.9307 //w=0.15 //l=0.106066 //layer=ply \
 //thickness=0.18 //x=75.125 //y=4.975 //x2=75.2 //y2=5.05
r662 (  182 183 ) resistor r=148.702 //w=0.094 //l=0.29 //layer=ply \
 //thickness=0.18 //x=75.125 //y=4.975 //x2=74.835 //y2=4.975
r663 (  180 224 ) resistor r=10.701 //w=0.21 //l=0.115 //layer=ply \
 //thickness=0.18 //x=74.82 //y=1.545 //x2=74.705 //y2=1.545
r664 (  179 226 ) resistor r=5.52526 //w=0.168 //l=0.115 //layer=ply \
 //thickness=0.18 //x=75.04 //y=1.545 //x2=75.155 //y2=1.545
r665 (  178 223 ) resistor r=5.52526 //w=0.168 //l=0.115 //layer=ply \
 //thickness=0.18 //x=74.82 //y=0.89 //x2=74.705 //y2=0.89
r666 (  177 225 ) resistor r=5.52526 //w=0.168 //l=0.115 //layer=ply \
 //thickness=0.18 //x=75.04 //y=0.89 //x2=75.155 //y2=0.89
r667 (  177 178 ) resistor r=112.809 //w=0.094 //l=0.22 //layer=ply \
 //thickness=0.18 //x=75.04 //y=0.89 //x2=74.82 //y2=0.89
r668 (  174 183 ) resistor r=22.1787 //w=0.252 //l=0.106066 //layer=ply \
 //thickness=0.18 //x=74.76 //y=5.05 //x2=74.835 //y2=4.975
r669 (  174 222 ) resistor r=51.6429 //w=0.252 //l=0.34271 //layer=ply \
 //thickness=0.18 //x=74.76 //y=5.05 //x2=74.49 //y2=4.885
r670 (  173 220 ) resistor r=30.4513 //w=0.277 //l=0.243926 //layer=ply \
 //thickness=0.18 //x=74.665 //y=2.095 //x2=74.49 //y2=2.26
r671 (  172 224 ) resistor r=39.5823 //w=0.21 //l=0.173853 //layer=ply \
 //thickness=0.18 //x=74.665 //y=1.7 //x2=74.705 //y2=1.545
r672 (  172 173 ) resistor r=202.543 //w=0.094 //l=0.395 //layer=ply \
 //thickness=0.18 //x=74.665 //y=1.7 //x2=74.665 //y2=2.095
r673 (  171 224 ) resistor r=39.5823 //w=0.21 //l=0.173853 //layer=ply \
 //thickness=0.18 //x=74.665 //y=1.39 //x2=74.705 //y2=1.545
r674 (  170 223 ) resistor r=45.1352 //w=0.168 //l=0.173853 //layer=ply \
 //thickness=0.18 //x=74.665 //y=1.045 //x2=74.705 //y2=0.89
r675 (  170 171 ) resistor r=176.904 //w=0.094 //l=0.345 //layer=ply \
 //thickness=0.18 //x=74.665 //y=1.045 //x2=74.665 //y2=1.39
r676 (  169 218 ) resistor r=45.1352 //w=0.168 //l=0.173853 //layer=ply \
 //thickness=0.18 //x=68.025 //y=1.43 //x2=67.985 //y2=1.585
r677 (  168 217 ) resistor r=45.1352 //w=0.168 //l=0.173853 //layer=ply \
 //thickness=0.18 //x=68.025 //y=1.085 //x2=67.985 //y2=0.93
r678 (  168 169 ) resistor r=176.904 //w=0.094 //l=0.345 //layer=ply \
 //thickness=0.18 //x=68.025 //y=1.085 //x2=68.025 //y2=1.43
r679 (  163 216 ) resistor r=10.701 //w=0.21 //l=0.115 //layer=ply \
 //thickness=0.18 //x=67.65 //y=1.585 //x2=67.535 //y2=1.585
r680 (  162 218 ) resistor r=5.52526 //w=0.168 //l=0.115 //layer=ply \
 //thickness=0.18 //x=67.87 //y=1.585 //x2=67.985 //y2=1.585
r681 (  161 215 ) resistor r=5.52526 //w=0.168 //l=0.115 //layer=ply \
 //thickness=0.18 //x=67.65 //y=0.93 //x2=67.535 //y2=0.93
r682 (  160 217 ) resistor r=5.52526 //w=0.168 //l=0.115 //layer=ply \
 //thickness=0.18 //x=67.87 //y=0.93 //x2=67.985 //y2=0.93
r683 (  160 161 ) resistor r=112.809 //w=0.094 //l=0.22 //layer=ply \
 //thickness=0.18 //x=67.87 //y=0.93 //x2=67.65 //y2=0.93
r684 (  159 213 ) resistor r=16.5046 //w=0.27 //l=0.135 //layer=ply \
 //thickness=0.18 //x=67.625 //y=4.97 //x2=67.49 //y2=4.97
r685 (  158 165 ) resistor r=26.9307 //w=0.15 //l=0.106066 //layer=ply \
 //thickness=0.18 //x=67.865 //y=4.97 //x2=67.94 //y2=5.045
r686 (  158 159 ) resistor r=123.064 //w=0.094 //l=0.24 //layer=ply \
 //thickness=0.18 //x=67.865 //y=4.97 //x2=67.625 //y2=4.97
r687 (  153 216 ) resistor r=39.5823 //w=0.21 //l=0.173853 //layer=ply \
 //thickness=0.18 //x=67.495 //y=1.74 //x2=67.535 //y2=1.585
r688 (  153 208 ) resistor r=182.032 //w=0.094 //l=0.355 //layer=ply \
 //thickness=0.18 //x=67.495 //y=1.74 //x2=67.495 //y2=2.095
r689 (  152 216 ) resistor r=39.5823 //w=0.21 //l=0.173853 //layer=ply \
 //thickness=0.18 //x=67.495 //y=1.43 //x2=67.535 //y2=1.585
r690 (  151 215 ) resistor r=45.1352 //w=0.168 //l=0.173853 //layer=ply \
 //thickness=0.18 //x=67.495 //y=1.085 //x2=67.535 //y2=0.93
r691 (  151 152 ) resistor r=176.904 //w=0.094 //l=0.345 //layer=ply \
 //thickness=0.18 //x=67.495 //y=1.085 //x2=67.495 //y2=1.43
r692 (  150 201 ) resistor r=592.245 //w=0.094 //l=1.155 //layer=ply \
 //thickness=0.18 //x=78.52 //y=6.205 //x2=78.52 //y2=5.05
r693 (  149 193 ) resistor r=592.245 //w=0.094 //l=1.155 //layer=ply \
 //thickness=0.18 //x=78.08 //y=6.205 //x2=78.08 //y2=5.05
r694 (  148 186 ) resistor r=592.245 //w=0.094 //l=1.155 //layer=ply \
 //thickness=0.18 //x=75.2 //y=6.205 //x2=75.2 //y2=5.05
r695 (  147 174 ) resistor r=592.245 //w=0.094 //l=1.155 //layer=ply \
 //thickness=0.18 //x=74.76 //y=6.205 //x2=74.76 //y2=5.05
r696 (  146 165 ) resistor r=592.245 //w=0.094 //l=1.155 //layer=ply \
 //thickness=0.18 //x=67.94 //y=6.2 //x2=67.94 //y2=5.045
r697 (  145 214 ) resistor r=592.245 //w=0.094 //l=1.155 //layer=ply \
 //thickness=0.18 //x=67.5 //y=6.2 //x2=67.5 //y2=5.045
r698 (  144 198 ) resistor r=56.4043 //w=0.094 //l=0.11 //layer=ply \
 //thickness=0.18 //x=78.26 //y=1.545 //x2=78.37 //y2=1.545
r699 (  144 199 ) resistor r=56.4043 //w=0.094 //l=0.11 //layer=ply \
 //thickness=0.18 //x=78.26 //y=1.545 //x2=78.15 //y2=1.545
r700 (  143 179 ) resistor r=56.4043 //w=0.094 //l=0.11 //layer=ply \
 //thickness=0.18 //x=74.93 //y=1.545 //x2=75.04 //y2=1.545
r701 (  143 180 ) resistor r=56.4043 //w=0.094 //l=0.11 //layer=ply \
 //thickness=0.18 //x=74.93 //y=1.545 //x2=74.82 //y2=1.545
r702 (  142 162 ) resistor r=56.4043 //w=0.094 //l=0.11 //layer=ply \
 //thickness=0.18 //x=67.76 //y=1.585 //x2=67.87 //y2=1.585
r703 (  142 163 ) resistor r=56.4043 //w=0.094 //l=0.11 //layer=ply \
 //thickness=0.18 //x=67.76 //y=1.585 //x2=67.65 //y2=1.585
r704 (  140 233 ) resistor r=152 //w=0.17 //l=0.17 //layer=licon //count=1 \
 //x=78.19 //y=4.885 //x2=78.19 //y2=4.885
r705 (  137 140 ) resistor r=18.139 //w=0.187 //l=0.265 //layer=li \
 //thickness=0.1 //x=78.19 //y=4.62 //x2=78.19 //y2=4.885
r706 (  132 228 ) resistor r=152 //w=0.17 //l=0.17 //layer=licon //count=1 \
 //x=78.19 //y=2.26 //x2=78.19 //y2=2.26
r707 (  129 222 ) resistor r=152 //w=0.17 //l=0.17 //layer=licon //count=1 \
 //x=74.49 //y=4.885 //x2=74.49 //y2=4.885
r708 (  126 129 ) resistor r=18.139 //w=0.187 //l=0.265 //layer=li \
 //thickness=0.1 //x=74.49 //y=4.62 //x2=74.49 //y2=4.885
r709 (  121 220 ) resistor r=152 //w=0.17 //l=0.17 //layer=licon //count=1 \
 //x=74.49 //y=2.26 //x2=74.49 //y2=2.26
r710 (  104 240 ) resistor r=23.615 //w=0.187 //l=0.345 //layer=li \
 //thickness=0.1 //x=72.23 //y=5.56 //x2=72.23 //y2=5.905
r711 (  96 239 ) resistor r=23.615 //w=0.187 //l=0.345 //layer=li \
 //thickness=0.1 //x=71.35 //y=5.56 //x2=71.35 //y2=5.905
r712 (  88 238 ) resistor r=23.615 //w=0.187 //l=0.345 //layer=li \
 //thickness=0.1 //x=70.47 //y=5.56 //x2=70.47 //y2=5.905
r713 (  83 211 ) resistor r=152 //w=0.17 //l=0.17 //layer=licon //count=1 \
 //x=67.49 //y=4.88 //x2=67.49 //y2=4.88
r714 (  78 207 ) resistor r=152 //w=0.17 //l=0.17 //layer=licon //count=1 \
 //x=67.46 //y=2.26 //x2=67.46 //y2=2.26
r715 (  74 75 ) resistor r=0.10734 //w=0.281 //l=0.16 //layer=m2 \
 //thickness=0.36 //x=78.195 //y=4.64 //x2=78.035 //y2=4.64
r716 (  68 70 ) resistor r=0.10734 //w=0.281 //l=0.16 //layer=m2 \
 //thickness=0.36 //x=73.005 //y=4.615 //x2=73.165 //y2=4.615
r717 (  68 69 ) resistor r=0.10734 //w=0.281 //l=0.16 //layer=m2 \
 //thickness=0.36 //x=73.005 //y=4.615 //x2=72.845 //y2=4.615
r718 (  66 69 ) resistor r=4.9666 //w=0.131 //l=5.205 //layer=m2 \
 //thickness=0.36 //x=67.64 //y=4.62 //x2=72.845 //y2=4.62
r719 (  64 66 ) resistor r=0.10734 //w=0.281 //l=0.16 //layer=m2 \
 //thickness=0.36 //x=67.48 //y=4.64 //x2=67.64 //y2=4.64
r720 (  62 72 ) resistor r=0.10734 //w=0.281 //l=0.16 //layer=m2 \
 //thickness=0.36 //x=74.655 //y=4.62 //x2=74.495 //y2=4.62
r721 (  62 75 ) resistor r=3.22519 //w=0.131 //l=3.38 //layer=m2 \
 //thickness=0.36 //x=74.655 //y=4.62 //x2=78.035 //y2=4.62
r722 (  59 72 ) resistor r=0.10734 //w=0.281 //l=0.16 //layer=m2 \
 //thickness=0.36 //x=74.335 //y=4.62 //x2=74.495 //y2=4.62
r723 (  59 70 ) resistor r=1.11641 //w=0.131 //l=1.17 //layer=m2 \
 //thickness=0.36 //x=74.335 //y=4.62 //x2=73.165 //y2=4.62
r724 (  56 132 ) resistor r=9.3 //w=0.17 //l=0.17 //layer=mcon //count=1 \
 //x=78.19 //y=2.26 //x2=78.19 //y2=2.26
r725 (  54 74 ) resistor r=4.5 //w=0.15 //l=0.15 //layer=via1 //count=1 \
 //x=78.195 //y=4.64 //x2=78.195 //y2=4.64
r726 (  52 137 ) resistor r=9.3 //w=0.17 //l=0.17 //layer=mcon //count=1 \
 //x=78.19 //y=4.62 //x2=78.19 //y2=4.62
r727 (  52 54 ) resistor r=0.00659631 //w=0.379 //l=0.02 //layer=m1 \
 //thickness=0.36 //x=78.14 //y=4.62 //x2=78.14 //y2=4.64
r728 (  49 126 ) resistor r=9.3 //w=0.17 //l=0.17 //layer=mcon //count=1 \
 //x=74.49 //y=4.62 //x2=74.49 //y2=4.62
r729 (  49 72 ) resistor r=4.5 //w=0.15 //l=0.15 //layer=via1 //count=1 \
 //x=74.495 //y=4.62 //x2=74.495 //y2=4.62
r730 (  47 121 ) resistor r=9.3 //w=0.17 //l=0.17 //layer=mcon //count=1 \
 //x=74.49 //y=2.26 //x2=74.49 //y2=2.26
r731 (  43 68 ) resistor r=4.5 //w=0.15 //l=0.15 //layer=via1 //count=1 \
 //x=73.005 //y=4.615 //x2=73.005 //y2=4.615
r732 (  43 45 ) resistor r=0.00167112 //w=0.374 //l=0.005 //layer=m1 \
 //thickness=0.36 //x=72.955 //y=4.615 //x2=72.955 //y2=4.62
r733 (  41 236 ) resistor r=9.3 //w=0.17 //l=0.17 //layer=mcon //count=1 \
 //x=72.525 //y=1.19 //x2=72.525 //y2=1.19
r734 (  39 104 ) resistor r=9.3 //w=0.17 //l=0.17 //layer=mcon //count=1 \
 //x=72.23 //y=5.56 //x2=72.23 //y2=5.56
r735 (  36 96 ) resistor r=9.3 //w=0.17 //l=0.17 //layer=mcon //count=1 \
 //x=71.35 //y=5.56 //x2=71.35 //y2=5.56
r736 (  34 36 ) resistor r=0.121228 //w=0.232 //l=0.225 //layer=m1 \
 //thickness=0.36 //x=71.35 //y=5.335 //x2=71.35 //y2=5.56
r737 (  33 88 ) resistor r=9.3 //w=0.17 //l=0.17 //layer=mcon //count=1 \
 //x=70.47 //y=5.56 //x2=70.47 //y2=5.56
r738 (  31 33 ) resistor r=0.129608 //w=0.217 //l=0.225 //layer=m1 \
 //thickness=0.36 //x=70.472 //y=5.335 //x2=70.472 //y2=5.56
r739 (  30 83 ) resistor r=9.3 //w=0.17 //l=0.17 //layer=mcon //count=1 \
 //x=67.49 //y=4.88 //x2=67.49 //y2=4.88
r740 (  28 64 ) resistor r=4.5 //w=0.15 //l=0.15 //layer=via1 //count=1 \
 //x=67.48 //y=4.64 //x2=67.48 //y2=4.64
r741 (  28 30 ) resistor r=0.106007 //w=0.283 //l=0.24 //layer=m1 \
 //thickness=0.36 //x=67.48 //y=4.64 //x2=67.48 //y2=4.88
r742 (  24 78 ) resistor r=9.3 //w=0.17 //l=0.17 //layer=mcon //count=1 \
 //x=67.46 //y=2.26 //x2=67.46 //y2=2.26
r743 (  24 26 ) resistor r=0.0936408 //w=0.196 //l=0.125 //layer=m1 \
 //thickness=0.36 //x=67.462 //y=2.26 //x2=67.462 //y2=2.385
r744 (  22 52 ) resistor r=0.0863342 //w=0.379 //l=0.168152 //layer=m1 \
 //thickness=0.36 //x=78.19 //y=4.475 //x2=78.14 //y2=4.62
r745 (  21 56 ) resistor r=0.0761125 //w=0.237 //l=0.126491 //layer=m1 \
 //thickness=0.36 //x=78.19 //y=2.385 //x2=78.187 //y2=2.26
r746 (  21 22 ) resistor r=1.99427 //w=0.131 //l=2.09 //layer=m1 \
 //thickness=0.36 //x=78.19 //y=2.385 //x2=78.19 //y2=4.475
r747 (  20 49 ) resistor r=0.0898201 //w=0.322 //l=0.185472 //layer=m1 \
 //thickness=0.36 //x=74.49 //y=4.46 //x2=74.545 //y2=4.62
r748 (  19 47 ) resistor r=0.0717383 //w=0.224 //l=0.115 //layer=m1 \
 //thickness=0.36 //x=74.49 //y=2.375 //x2=74.49 //y2=2.26
r749 (  19 20 ) resistor r=1.9895 //w=0.131 //l=2.085 //layer=m1 \
 //thickness=0.36 //x=74.49 //y=2.375 //x2=74.49 //y2=4.46
r750 (  17 45 ) resistor r=0.089409 //w=0.374 //l=0.180416 //layer=m1 \
 //thickness=0.36 //x=73.01 //y=4.775 //x2=72.955 //y2=4.62
r751 (  17 18 ) resistor r=0.453244 //w=0.131 //l=0.475 //layer=m1 \
 //thickness=0.36 //x=73.01 //y=4.775 //x2=73.01 //y2=5.25
r752 (  16 43 ) resistor r=0.0910802 //w=0.374 //l=0.185472 //layer=m1 \
 //thickness=0.36 //x=73.01 //y=4.455 //x2=72.955 //y2=4.615
r753 (  15 16 ) resistor r=2.40935 //w=0.131 //l=2.525 //layer=m1 \
 //thickness=0.36 //x=73.01 //y=1.93 //x2=73.01 //y2=4.455
r754 (  13 15 ) resistor r=0.0698411 //w=0.17 //l=0.120208 //layer=m1 \
 //thickness=0.36 //x=72.925 //y=1.845 //x2=73.01 //y2=1.93
r755 (  13 14 ) resistor r=0.300573 //w=0.131 //l=0.315 //layer=m1 \
 //thickness=0.36 //x=72.925 //y=1.845 //x2=72.61 //y2=1.845
r756 (  12 14 ) resistor r=0.0698411 //w=0.17 //l=0.120208 //layer=m1 \
 //thickness=0.36 //x=72.525 //y=1.76 //x2=72.61 //y2=1.845
r757 (  11 41 ) resistor r=0.0717383 //w=0.224 //l=0.115 //layer=m1 \
 //thickness=0.36 //x=72.525 //y=1.305 //x2=72.525 //y2=1.19
r758 (  11 12 ) resistor r=0.43416 //w=0.131 //l=0.455 //layer=m1 \
 //thickness=0.36 //x=72.525 //y=1.305 //x2=72.525 //y2=1.76
r759 (  10 37 ) resistor r=0.0675342 //w=0.23 //l=0.115 //layer=m1 \
 //thickness=0.36 //x=72.345 //y=5.335 //x2=72.23 //y2=5.335
r760 (  9 18 ) resistor r=0.0698411 //w=0.17 //l=0.120208 //layer=m1 \
 //thickness=0.36 //x=72.925 //y=5.335 //x2=73.01 //y2=5.25
r761 (  9 10 ) resistor r=0.553435 //w=0.131 //l=0.58 //layer=m1 \
 //thickness=0.36 //x=72.925 //y=5.335 //x2=72.345 //y2=5.335
r762 (  8 39 ) resistor r=0.00118313 //w=0.23 //layer=m1 //thickness=0.36 \
 //x=72.23 //y=5.56 //x2=72.23 //y2=5.56
r763 (  7 37 ) resistor r=0.002872 //w=0.34 //l=0.085 //layer=m1 \
 //thickness=0.36 //x=72.23 //y=5.42 //x2=72.23 //y2=5.335
r764 (  7 8 ) resistor r=0.091623 //w=0.191 //l=0.14 //layer=m1 \
 //thickness=0.36 //x=72.23 //y=5.42 //x2=72.23 //y2=5.56
r765 (  6 34 ) resistor r=0.0262263 //w=0.232 //l=0.12 //layer=m1 \
 //thickness=0.36 //x=71.47 //y=5.335 //x2=71.35 //y2=5.335
r766 (  5 37 ) resistor r=0.0675342 //w=0.23 //l=0.115 //layer=m1 \
 //thickness=0.36 //x=72.115 //y=5.335 //x2=72.23 //y2=5.335
r767 (  5 6 ) resistor r=0.615458 //w=0.131 //l=0.645 //layer=m1 \
 //thickness=0.36 //x=72.115 //y=5.335 //x2=71.47 //y2=5.335
r768 (  4 31 ) resistor r=0.0222262 //w=0.217 //l=0.118 //layer=m1 \
 //thickness=0.36 //x=70.59 //y=5.335 //x2=70.472 //y2=5.335
r769 (  3 34 ) resistor r=0.0262263 //w=0.232 //l=0.12 //layer=m1 \
 //thickness=0.36 //x=71.23 //y=5.335 //x2=71.35 //y2=5.335
r770 (  3 4 ) resistor r=0.610687 //w=0.131 //l=0.64 //layer=m1 \
 //thickness=0.36 //x=71.23 //y=5.335 //x2=70.59 //y2=5.335
r771 (  2 28 ) resistor r=0.090447 //w=0.283 //l=0.169706 //layer=m1 \
 //thickness=0.36 //x=67.46 //y=4.48 //x2=67.48 //y2=4.64
r772 (  2 26 ) resistor r=1.99905 //w=0.131 //l=2.095 //layer=m1 \
 //thickness=0.36 //x=67.46 //y=4.48 //x2=67.46 //y2=2.385
ends PM_TMRDFFSNQX1\%noxref_20

subckt PM_TMRDFFSNQX1\%noxref_21 ( 2 3 4 5 7 10 11 13 14 15 16 18 19 20 21 22 \
 23 24 25 26 28 36 37 40 43 49 53 68 70 72 73 74 76 78 80 82 84 86 88 90 92 94 \
 96 98 100 102 104 111 119 121 122 125 134 139 147 155 172 181 186 191 195 196 \
 197 198 199 200 201 202 203 204 205 206 211 213 215 221 222 226 227 228 229 \
 230 232 235 238 239 240 241 242 243 244 245 249 251 254 255 256 257 262 263 \
 266 283 290 292 293 294 )
c780 ( 290 0 ) capacitor c=0.00885916f //x=23.495 //y=1.095
c781 ( 283 0 ) capacitor c=0.0586737f //x=81.15 //y=2.26
c782 ( 266 0 ) capacitor c=0.0393541f //x=18.65 //y=4.88
c783 ( 263 0 ) capacitor c=0.0284095f //x=18.62 //y=2.095
c784 ( 262 0 ) capacitor c=0.0450457f //x=18.62 //y=2.26
c785 ( 257 0 ) capacitor c=0.0318956f //x=81.855 //y=1.39
c786 ( 256 0 ) capacitor c=0.0186809f //x=81.855 //y=1.045
c787 ( 255 0 ) capacitor c=0.0659968f //x=81.495 //y=4.975
c788 ( 254 0 ) capacitor c=0.0373387f //x=81.785 //y=4.975
c789 ( 251 0 ) capacitor c=0.0157936f //x=81.7 //y=1.545
c790 ( 249 0 ) capacitor c=0.0158553f //x=81.7 //y=0.89
c791 ( 245 0 ) capacitor c=0.0302441f //x=81.325 //y=2.095
c792 ( 244 0 ) capacitor c=0.0238107f //x=81.325 //y=1.7
c793 ( 243 0 ) capacitor c=0.0234359f //x=81.325 //y=1.39
c794 ( 242 0 ) capacitor c=0.0199332f //x=81.325 //y=1.045
c795 ( 241 0 ) capacitor c=0.0955672f //x=79.495 //y=2.095
c796 ( 240 0 ) capacitor c=0.0251353f //x=79.495 //y=1.74
c797 ( 239 0 ) capacitor c=0.0234318f //x=79.495 //y=1.43
c798 ( 238 0 ) capacitor c=0.0192547f //x=79.495 //y=1.085
c799 ( 235 0 ) capacitor c=0.0714656f //x=79.4 //y=5.05
c800 ( 232 0 ) capacitor c=0.0186579f //x=79.34 //y=1.585
c801 ( 230 0 ) capacitor c=0.0157803f //x=79.34 //y=0.93
c802 ( 229 0 ) capacitor c=0.0134011f //x=79.035 //y=4.975
c803 ( 228 0 ) capacitor c=0.0243282f //x=79.325 //y=4.975
c804 ( 227 0 ) capacitor c=0.0364928f //x=78.965 //y=1.43
c805 ( 226 0 ) capacitor c=0.0174823f //x=78.965 //y=1.085
c806 ( 222 0 ) capacitor c=0.0439708f //x=19.185 //y=1.43
c807 ( 221 0 ) capacitor c=0.0192582f //x=19.185 //y=1.085
c808 ( 215 0 ) capacitor c=0.0162526f //x=19.03 //y=1.585
c809 ( 213 0 ) capacitor c=0.0157807f //x=19.03 //y=0.93
c810 ( 211 0 ) capacitor c=0.0372668f //x=19.025 //y=4.97
c811 ( 206 0 ) capacitor c=0.0210762f //x=18.655 //y=1.74
c812 ( 205 0 ) capacitor c=0.0168511f //x=18.655 //y=1.43
c813 ( 204 0 ) capacitor c=0.0175485f //x=18.655 //y=1.085
c814 ( 203 0 ) capacitor c=0.11081f //x=81.86 //y=6.205
c815 ( 202 0 ) capacitor c=0.154997f //x=81.42 //y=6.205
c816 ( 201 0 ) capacitor c=0.155934f //x=79.4 //y=6.205
c817 ( 200 0 ) capacitor c=0.110594f //x=78.96 //y=6.205
c818 ( 199 0 ) capacitor c=0.155269f //x=19.1 //y=6.2
c819 ( 198 0 ) capacitor c=0.110375f //x=18.66 //y=6.2
c820 ( 191 0 ) capacitor c=7.7962e-19 //x=81.15 //y=4.885
c821 ( 186 0 ) capacitor c=7.89145e-19 //x=81.15 //y=2.26
c822 ( 181 0 ) capacitor c=7.79163e-19 //x=79.67 //y=4.885
c823 ( 172 0 ) capacitor c=7.43216e-19 //x=79.67 //y=2.26
c824 ( 155 0 ) capacitor c=0.0293228f //x=23.39 //y=5.56
c825 ( 147 0 ) capacitor c=0.029137f //x=22.51 //y=5.56
c826 ( 139 0 ) capacitor c=0.0277605f //x=21.63 //y=5.56
c827 ( 134 0 ) capacitor c=8.90417e-19 //x=18.65 //y=4.88
c828 ( 125 0 ) capacitor c=5.78095e-19 //x=18.62 //y=2.26
c829 ( 122 0 ) capacitor c=0.0208859f //x=80.985 //y=2.27
c830 ( 121 0 ) capacitor c=0.00247225f //x=81.145 //y=2.27
c831 ( 119 0 ) capacitor c=0.00157156f //x=79.835 //y=2.27
c832 ( 111 0 ) capacitor c=4.48903e-19 //x=18.78 //y=3.495
c833 ( 104 0 ) capacitor c=0.127333f //x=72.485 //y=3.5
c834 ( 102 0 ) capacitor c=0.0707411f //x=71.885 //y=3.51
c835 ( 100 0 ) capacitor c=0.00680738f //x=65.08 //y=3.48
c836 ( 98 0 ) capacitor c=0.034648f //x=64.48 //y=3.51
c837 ( 96 0 ) capacitor c=0.00505683f //x=61.015 //y=3.48
c838 ( 94 0 ) capacitor c=0.0436319f //x=60.415 //y=3.51
c839 ( 92 0 ) capacitor c=0.00503199f //x=56.21 //y=3.48
c840 ( 90 0 ) capacitor c=0.0620292f //x=55.61 //y=3.51
c841 ( 88 0 ) capacitor c=0.00550592f //x=50.645 //y=3.54
c842 ( 86 0 ) capacitor c=0.0316505f //x=50.045 //y=3.51
c843 ( 84 0 ) capacitor c=0.00544612f //x=48.065 //y=3.495
c844 ( 82 0 ) capacitor c=0.0699164f //x=47.465 //y=3.51
c845 ( 80 0 ) capacitor c=0.00680738f //x=40.66 //y=3.48
c846 ( 78 0 ) capacitor c=0.034648f //x=40.06 //y=3.51
c847 ( 76 0 ) capacitor c=0.00505683f //x=36.595 //y=3.48
c848 ( 74 0 ) capacitor c=0.0436319f //x=35.995 //y=3.51
c849 ( 73 0 ) capacitor c=0.0998265f //x=31.36 //y=3.48
c850 ( 72 0 ) capacitor c=0.00503199f //x=31.79 //y=3.48
c851 ( 70 0 ) capacitor c=0.00245315f //x=23.645 //y=3.5
c852 ( 68 0 ) capacitor c=0.0450138f //x=23.045 //y=3.51
c853 ( 53 0 ) capacitor c=0.0155604f //x=79.67 //y=3.51
c854 ( 49 0 ) capacitor c=0.0158593f //x=24.17 //y=3.51
c855 ( 43 0 ) capacitor c=8.84507e-19 //x=23.39 //y=5.335
c856 ( 40 0 ) capacitor c=0.00799482f //x=22.51 //y=5.335
c857 ( 37 0 ) capacitor c=0.0112819f //x=21.632 //y=5.335
c858 ( 36 0 ) capacitor c=0.0146597f //x=18.62 //y=3.51
c859 ( 28 0 ) capacitor c=0.00504845f //x=18.62 //y=2.26
c860 ( 26 0 ) capacitor c=0.0767052f //x=81.15 //y=4.755
c861 ( 25 0 ) capacitor c=0.00995077f //x=81.15 //y=2.43
c862 ( 24 0 ) capacitor c=0.040948f //x=79.67 //y=4.76
c863 ( 23 0 ) capacitor c=0.0138273f //x=79.67 //y=3.675
c864 ( 22 0 ) capacitor c=0.0308605f //x=79.67 //y=3.355
c865 ( 21 0 ) capacitor c=0.0101441f //x=79.67 //y=2.43
c866 ( 20 0 ) capacitor c=0.042046f //x=24.17 //y=5.25
c867 ( 19 0 ) capacitor c=0.01369f //x=24.17 //y=3.685
c868 ( 18 0 ) capacitor c=0.0372592f //x=24.17 //y=3.365
c869 ( 16 0 ) capacitor c=0.00493487f //x=23.77 //y=1.845
c870 ( 15 0 ) capacitor c=0.0129389f //x=24.085 //y=1.845
c871 ( 14 0 ) capacitor c=0.013549f //x=23.685 //y=1.76
c872 ( 13 0 ) capacitor c=0.0113783f //x=23.685 //y=1.305
c873 ( 11 0 ) capacitor c=0.0234536f //x=24.085 //y=5.335
c874 ( 10 0 ) capacitor c=0.00906713f //x=23.39 //y=5.56
c875 ( 7 0 ) capacitor c=0.0180822f //x=23.275 //y=5.335
c876 ( 5 0 ) capacitor c=0.0151888f //x=22.39 //y=5.335
c877 ( 4 0 ) capacitor c=0.0228761f //x=18.62 //y=4.735
c878 ( 3 0 ) capacitor c=0.0104665f //x=18.62 //y=3.655
c879 ( 2 0 ) capacitor c=0.0198462f //x=18.62 //y=3.335
r880 (  268 269 ) resistor r=32.4568 //w=0.214 //l=0.075 //layer=ply \
 //thickness=0.18 //x=18.65 //y=4.97 //x2=18.65 //y2=5.045
r881 (  266 268 ) resistor r=20.271 //w=0.214 //l=0.09 //layer=ply \
 //thickness=0.18 //x=18.65 //y=4.88 //x2=18.65 //y2=4.97
r882 (  262 263 ) resistor r=52.7279 //w=0.214 //l=0.165 //layer=ply \
 //thickness=0.18 //x=18.62 //y=2.26 //x2=18.62 //y2=2.095
r883 (  257 289 ) resistor r=45.1352 //w=0.168 //l=0.173853 //layer=ply \
 //thickness=0.18 //x=81.855 //y=1.39 //x2=81.815 //y2=1.545
r884 (  256 288 ) resistor r=45.1352 //w=0.168 //l=0.173853 //layer=ply \
 //thickness=0.18 //x=81.855 //y=1.045 //x2=81.815 //y2=0.89
r885 (  256 257 ) resistor r=176.904 //w=0.094 //l=0.345 //layer=ply \
 //thickness=0.18 //x=81.855 //y=1.045 //x2=81.855 //y2=1.39
r886 (  254 258 ) resistor r=26.9307 //w=0.15 //l=0.106066 //layer=ply \
 //thickness=0.18 //x=81.785 //y=4.975 //x2=81.86 //y2=5.05
r887 (  254 255 ) resistor r=148.702 //w=0.094 //l=0.29 //layer=ply \
 //thickness=0.18 //x=81.785 //y=4.975 //x2=81.495 //y2=4.975
r888 (  252 287 ) resistor r=10.701 //w=0.21 //l=0.115 //layer=ply \
 //thickness=0.18 //x=81.48 //y=1.545 //x2=81.365 //y2=1.545
r889 (  251 289 ) resistor r=5.52526 //w=0.168 //l=0.115 //layer=ply \
 //thickness=0.18 //x=81.7 //y=1.545 //x2=81.815 //y2=1.545
r890 (  250 286 ) resistor r=5.52526 //w=0.168 //l=0.115 //layer=ply \
 //thickness=0.18 //x=81.48 //y=0.89 //x2=81.365 //y2=0.89
r891 (  249 288 ) resistor r=5.52526 //w=0.168 //l=0.115 //layer=ply \
 //thickness=0.18 //x=81.7 //y=0.89 //x2=81.815 //y2=0.89
r892 (  249 250 ) resistor r=112.809 //w=0.094 //l=0.22 //layer=ply \
 //thickness=0.18 //x=81.7 //y=0.89 //x2=81.48 //y2=0.89
r893 (  246 255 ) resistor r=22.1787 //w=0.252 //l=0.106066 //layer=ply \
 //thickness=0.18 //x=81.42 //y=5.05 //x2=81.495 //y2=4.975
r894 (  246 285 ) resistor r=51.6429 //w=0.252 //l=0.34271 //layer=ply \
 //thickness=0.18 //x=81.42 //y=5.05 //x2=81.15 //y2=4.885
r895 (  245 283 ) resistor r=30.4513 //w=0.277 //l=0.243926 //layer=ply \
 //thickness=0.18 //x=81.325 //y=2.095 //x2=81.15 //y2=2.26
r896 (  244 287 ) resistor r=39.5823 //w=0.21 //l=0.173853 //layer=ply \
 //thickness=0.18 //x=81.325 //y=1.7 //x2=81.365 //y2=1.545
r897 (  244 245 ) resistor r=202.543 //w=0.094 //l=0.395 //layer=ply \
 //thickness=0.18 //x=81.325 //y=1.7 //x2=81.325 //y2=2.095
r898 (  243 287 ) resistor r=39.5823 //w=0.21 //l=0.173853 //layer=ply \
 //thickness=0.18 //x=81.325 //y=1.39 //x2=81.365 //y2=1.545
r899 (  242 286 ) resistor r=45.1352 //w=0.168 //l=0.173853 //layer=ply \
 //thickness=0.18 //x=81.325 //y=1.045 //x2=81.365 //y2=0.89
r900 (  242 243 ) resistor r=176.904 //w=0.094 //l=0.345 //layer=ply \
 //thickness=0.18 //x=81.325 //y=1.045 //x2=81.325 //y2=1.39
r901 (  241 279 ) resistor r=30.4513 //w=0.277 //l=0.243926 //layer=ply \
 //thickness=0.18 //x=79.495 //y=2.095 //x2=79.67 //y2=2.26
r902 (  240 277 ) resistor r=39.5823 //w=0.21 //l=0.173853 //layer=ply \
 //thickness=0.18 //x=79.495 //y=1.74 //x2=79.455 //y2=1.585
r903 (  240 241 ) resistor r=182.032 //w=0.094 //l=0.355 //layer=ply \
 //thickness=0.18 //x=79.495 //y=1.74 //x2=79.495 //y2=2.095
r904 (  239 277 ) resistor r=39.5823 //w=0.21 //l=0.173853 //layer=ply \
 //thickness=0.18 //x=79.495 //y=1.43 //x2=79.455 //y2=1.585
r905 (  238 276 ) resistor r=45.1352 //w=0.168 //l=0.173853 //layer=ply \
 //thickness=0.18 //x=79.495 //y=1.085 //x2=79.455 //y2=0.93
r906 (  238 239 ) resistor r=176.904 //w=0.094 //l=0.345 //layer=ply \
 //thickness=0.18 //x=79.495 //y=1.085 //x2=79.495 //y2=1.43
r907 (  235 281 ) resistor r=51.6429 //w=0.252 //l=0.34271 //layer=ply \
 //thickness=0.18 //x=79.4 //y=5.05 //x2=79.67 //y2=4.885
r908 (  233 275 ) resistor r=5.52526 //w=0.168 //l=0.115 //layer=ply \
 //thickness=0.18 //x=79.12 //y=1.585 //x2=79.005 //y2=1.585
r909 (  232 277 ) resistor r=10.701 //w=0.21 //l=0.115 //layer=ply \
 //thickness=0.18 //x=79.34 //y=1.585 //x2=79.455 //y2=1.585
r910 (  231 274 ) resistor r=5.52526 //w=0.168 //l=0.115 //layer=ply \
 //thickness=0.18 //x=79.12 //y=0.93 //x2=79.005 //y2=0.93
r911 (  230 276 ) resistor r=5.52526 //w=0.168 //l=0.115 //layer=ply \
 //thickness=0.18 //x=79.34 //y=0.93 //x2=79.455 //y2=0.93
r912 (  230 231 ) resistor r=112.809 //w=0.094 //l=0.22 //layer=ply \
 //thickness=0.18 //x=79.34 //y=0.93 //x2=79.12 //y2=0.93
r913 (  228 235 ) resistor r=22.1787 //w=0.252 //l=0.106066 //layer=ply \
 //thickness=0.18 //x=79.325 //y=4.975 //x2=79.4 //y2=5.05
r914 (  228 229 ) resistor r=148.702 //w=0.094 //l=0.29 //layer=ply \
 //thickness=0.18 //x=79.325 //y=4.975 //x2=79.035 //y2=4.975
r915 (  227 275 ) resistor r=45.1352 //w=0.168 //l=0.173853 //layer=ply \
 //thickness=0.18 //x=78.965 //y=1.43 //x2=79.005 //y2=1.585
r916 (  226 274 ) resistor r=45.1352 //w=0.168 //l=0.173853 //layer=ply \
 //thickness=0.18 //x=78.965 //y=1.085 //x2=79.005 //y2=0.93
r917 (  226 227 ) resistor r=176.904 //w=0.094 //l=0.345 //layer=ply \
 //thickness=0.18 //x=78.965 //y=1.085 //x2=78.965 //y2=1.43
r918 (  223 229 ) resistor r=26.9307 //w=0.15 //l=0.106066 //layer=ply \
 //thickness=0.18 //x=78.96 //y=5.05 //x2=79.035 //y2=4.975
r919 (  222 273 ) resistor r=45.1352 //w=0.168 //l=0.173853 //layer=ply \
 //thickness=0.18 //x=19.185 //y=1.43 //x2=19.145 //y2=1.585
r920 (  221 272 ) resistor r=45.1352 //w=0.168 //l=0.173853 //layer=ply \
 //thickness=0.18 //x=19.185 //y=1.085 //x2=19.145 //y2=0.93
r921 (  221 222 ) resistor r=176.904 //w=0.094 //l=0.345 //layer=ply \
 //thickness=0.18 //x=19.185 //y=1.085 //x2=19.185 //y2=1.43
r922 (  216 271 ) resistor r=10.701 //w=0.21 //l=0.115 //layer=ply \
 //thickness=0.18 //x=18.81 //y=1.585 //x2=18.695 //y2=1.585
r923 (  215 273 ) resistor r=5.52526 //w=0.168 //l=0.115 //layer=ply \
 //thickness=0.18 //x=19.03 //y=1.585 //x2=19.145 //y2=1.585
r924 (  214 270 ) resistor r=5.52526 //w=0.168 //l=0.115 //layer=ply \
 //thickness=0.18 //x=18.81 //y=0.93 //x2=18.695 //y2=0.93
r925 (  213 272 ) resistor r=5.52526 //w=0.168 //l=0.115 //layer=ply \
 //thickness=0.18 //x=19.03 //y=0.93 //x2=19.145 //y2=0.93
r926 (  213 214 ) resistor r=112.809 //w=0.094 //l=0.22 //layer=ply \
 //thickness=0.18 //x=19.03 //y=0.93 //x2=18.81 //y2=0.93
r927 (  212 268 ) resistor r=16.5046 //w=0.27 //l=0.135 //layer=ply \
 //thickness=0.18 //x=18.785 //y=4.97 //x2=18.65 //y2=4.97
r928 (  211 218 ) resistor r=26.9307 //w=0.15 //l=0.106066 //layer=ply \
 //thickness=0.18 //x=19.025 //y=4.97 //x2=19.1 //y2=5.045
r929 (  211 212 ) resistor r=123.064 //w=0.094 //l=0.24 //layer=ply \
 //thickness=0.18 //x=19.025 //y=4.97 //x2=18.785 //y2=4.97
r930 (  206 271 ) resistor r=39.5823 //w=0.21 //l=0.173853 //layer=ply \
 //thickness=0.18 //x=18.655 //y=1.74 //x2=18.695 //y2=1.585
r931 (  206 263 ) resistor r=182.032 //w=0.094 //l=0.355 //layer=ply \
 //thickness=0.18 //x=18.655 //y=1.74 //x2=18.655 //y2=2.095
r932 (  205 271 ) resistor r=39.5823 //w=0.21 //l=0.173853 //layer=ply \
 //thickness=0.18 //x=18.655 //y=1.43 //x2=18.695 //y2=1.585
r933 (  204 270 ) resistor r=45.1352 //w=0.168 //l=0.173853 //layer=ply \
 //thickness=0.18 //x=18.655 //y=1.085 //x2=18.695 //y2=0.93
r934 (  204 205 ) resistor r=176.904 //w=0.094 //l=0.345 //layer=ply \
 //thickness=0.18 //x=18.655 //y=1.085 //x2=18.655 //y2=1.43
r935 (  203 258 ) resistor r=592.245 //w=0.094 //l=1.155 //layer=ply \
 //thickness=0.18 //x=81.86 //y=6.205 //x2=81.86 //y2=5.05
r936 (  202 246 ) resistor r=592.245 //w=0.094 //l=1.155 //layer=ply \
 //thickness=0.18 //x=81.42 //y=6.205 //x2=81.42 //y2=5.05
r937 (  201 235 ) resistor r=592.245 //w=0.094 //l=1.155 //layer=ply \
 //thickness=0.18 //x=79.4 //y=6.205 //x2=79.4 //y2=5.05
r938 (  200 223 ) resistor r=592.245 //w=0.094 //l=1.155 //layer=ply \
 //thickness=0.18 //x=78.96 //y=6.205 //x2=78.96 //y2=5.05
r939 (  199 218 ) resistor r=592.245 //w=0.094 //l=1.155 //layer=ply \
 //thickness=0.18 //x=19.1 //y=6.2 //x2=19.1 //y2=5.045
r940 (  198 269 ) resistor r=592.245 //w=0.094 //l=1.155 //layer=ply \
 //thickness=0.18 //x=18.66 //y=6.2 //x2=18.66 //y2=5.045
r941 (  197 251 ) resistor r=56.4043 //w=0.094 //l=0.11 //layer=ply \
 //thickness=0.18 //x=81.59 //y=1.545 //x2=81.7 //y2=1.545
r942 (  197 252 ) resistor r=56.4043 //w=0.094 //l=0.11 //layer=ply \
 //thickness=0.18 //x=81.59 //y=1.545 //x2=81.48 //y2=1.545
r943 (  196 232 ) resistor r=56.4043 //w=0.094 //l=0.11 //layer=ply \
 //thickness=0.18 //x=79.23 //y=1.585 //x2=79.34 //y2=1.585
r944 (  196 233 ) resistor r=56.4043 //w=0.094 //l=0.11 //layer=ply \
 //thickness=0.18 //x=79.23 //y=1.585 //x2=79.12 //y2=1.585
r945 (  195 215 ) resistor r=56.4043 //w=0.094 //l=0.11 //layer=ply \
 //thickness=0.18 //x=18.92 //y=1.585 //x2=19.03 //y2=1.585
r946 (  195 216 ) resistor r=56.4043 //w=0.094 //l=0.11 //layer=ply \
 //thickness=0.18 //x=18.92 //y=1.585 //x2=18.81 //y2=1.585
r947 (  191 285 ) resistor r=152 //w=0.17 //l=0.17 //layer=licon //count=1 \
 //x=81.15 //y=4.885 //x2=81.15 //y2=4.885
r948 (  186 283 ) resistor r=152 //w=0.17 //l=0.17 //layer=licon //count=1 \
 //x=81.15 //y=2.26 //x2=81.15 //y2=2.26
r949 (  181 281 ) resistor r=152 //w=0.17 //l=0.17 //layer=licon //count=1 \
 //x=79.67 //y=4.885 //x2=79.67 //y2=4.885
r950 (  172 279 ) resistor r=152 //w=0.17 //l=0.17 //layer=licon //count=1 \
 //x=79.67 //y=2.26 //x2=79.67 //y2=2.26
r951 (  155 294 ) resistor r=23.615 //w=0.187 //l=0.345 //layer=li \
 //thickness=0.1 //x=23.39 //y=5.56 //x2=23.39 //y2=5.905
r952 (  147 293 ) resistor r=23.615 //w=0.187 //l=0.345 //layer=li \
 //thickness=0.1 //x=22.51 //y=5.56 //x2=22.51 //y2=5.905
r953 (  139 292 ) resistor r=23.615 //w=0.187 //l=0.345 //layer=li \
 //thickness=0.1 //x=21.63 //y=5.56 //x2=21.63 //y2=5.905
r954 (  134 266 ) resistor r=152 //w=0.17 //l=0.17 //layer=licon //count=1 \
 //x=18.65 //y=4.88 //x2=18.65 //y2=4.88
r955 (  125 262 ) resistor r=152 //w=0.17 //l=0.17 //layer=licon //count=1 \
 //x=18.62 //y=2.26 //x2=18.62 //y2=2.26
r956 (  121 122 ) resistor r=0.10734 //w=0.281 //l=0.16 //layer=m2 \
 //thickness=0.36 //x=81.145 //y=2.27 //x2=80.985 //y2=2.27
r957 (  119 122 ) resistor r=1.09733 //w=0.131 //l=1.15 //layer=m2 \
 //thickness=0.36 //x=79.835 //y=2.26 //x2=80.985 //y2=2.26
r958 (  117 119 ) resistor r=0.10734 //w=0.281 //l=0.16 //layer=m2 \
 //thickness=0.36 //x=79.675 //y=2.27 //x2=79.835 //y2=2.27
r959 (  109 111 ) resistor r=0.10734 //w=0.281 //l=0.16 //layer=m2 \
 //thickness=0.36 //x=18.62 //y=3.495 //x2=18.78 //y2=3.495
r960 (  104 115 ) resistor r=5.07062 //w=0.177 //l=7.1875 //layer=m2 \
 //thickness=0.36 //x=72.485 //y=3.5 //x2=79.665 //y2=3.515
r961 (  104 105 ) resistor r=0.410305 //w=0.131 //l=0.43 //layer=m2 \
 //thickness=0.36 //x=72.485 //y=3.5 //x2=72.055 //y2=3.5
r962 (  102 105 ) resistor r=0.125 //w=0.17 //l=0.174929 //layer=m2 \
 //thickness=0.36 //x=71.885 //y=3.51 //x2=72.055 //y2=3.5
r963 (  102 103 ) resistor r=6.25 //w=0.131 //l=6.55 //layer=m2 \
 //thickness=0.36 //x=71.885 //y=3.51 //x2=65.335 //y2=3.51
r964 (  100 103 ) resistor r=0.1875 //w=0.17 //l=0.269583 //layer=m2 \
 //thickness=0.36 //x=65.08 //y=3.48 //x2=65.335 //y2=3.51
r965 (  100 101 ) resistor r=0.410305 //w=0.131 //l=0.43 //layer=m2 \
 //thickness=0.36 //x=65.08 //y=3.48 //x2=64.65 //y2=3.48
r966 (  98 101 ) resistor r=0.125 //w=0.17 //l=0.184391 //layer=m2 \
 //thickness=0.36 //x=64.48 //y=3.51 //x2=64.65 //y2=3.48
r967 (  98 99 ) resistor r=3.06298 //w=0.131 //l=3.21 //layer=m2 \
 //thickness=0.36 //x=64.48 //y=3.51 //x2=61.27 //y2=3.51
r968 (  96 99 ) resistor r=0.1875 //w=0.17 //l=0.269583 //layer=m2 \
 //thickness=0.36 //x=61.015 //y=3.48 //x2=61.27 //y2=3.51
r969 (  96 97 ) resistor r=0.410305 //w=0.131 //l=0.43 //layer=m2 \
 //thickness=0.36 //x=61.015 //y=3.48 //x2=60.585 //y2=3.48
r970 (  94 97 ) resistor r=0.125 //w=0.17 //l=0.184391 //layer=m2 \
 //thickness=0.36 //x=60.415 //y=3.51 //x2=60.585 //y2=3.48
r971 (  94 95 ) resistor r=3.76908 //w=0.131 //l=3.95 //layer=m2 \
 //thickness=0.36 //x=60.415 //y=3.51 //x2=56.465 //y2=3.51
r972 (  92 95 ) resistor r=0.1875 //w=0.17 //l=0.269583 //layer=m2 \
 //thickness=0.36 //x=56.21 //y=3.48 //x2=56.465 //y2=3.51
r973 (  92 93 ) resistor r=0.410305 //w=0.131 //l=0.43 //layer=m2 \
 //thickness=0.36 //x=56.21 //y=3.48 //x2=55.78 //y2=3.48
r974 (  90 93 ) resistor r=0.125 //w=0.17 //l=0.184391 //layer=m2 \
 //thickness=0.36 //x=55.61 //y=3.51 //x2=55.78 //y2=3.48
r975 (  90 91 ) resistor r=4.57538 //w=0.131 //l=4.795 //layer=m2 \
 //thickness=0.36 //x=55.61 //y=3.51 //x2=50.815 //y2=3.51
r976 (  88 91 ) resistor r=0.125 //w=0.17 //l=0.184391 //layer=m2 \
 //thickness=0.36 //x=50.645 //y=3.54 //x2=50.815 //y2=3.51
r977 (  88 89 ) resistor r=0.329198 //w=0.131 //l=0.345 //layer=m2 \
 //thickness=0.36 //x=50.645 //y=3.54 //x2=50.3 //y2=3.54
r978 (  86 89 ) resistor r=0.1875 //w=0.17 //l=0.269583 //layer=m2 \
 //thickness=0.36 //x=50.045 //y=3.51 //x2=50.3 //y2=3.54
r979 (  86 87 ) resistor r=1.64599 //w=0.131 //l=1.725 //layer=m2 \
 //thickness=0.36 //x=50.045 //y=3.51 //x2=48.32 //y2=3.51
r980 (  84 87 ) resistor r=0.1875 //w=0.17 //l=0.262393 //layer=m2 \
 //thickness=0.36 //x=48.065 //y=3.495 //x2=48.32 //y2=3.51
r981 (  84 85 ) resistor r=0.410305 //w=0.131 //l=0.43 //layer=m2 \
 //thickness=0.36 //x=48.065 //y=3.495 //x2=47.635 //y2=3.495
r982 (  82 85 ) resistor r=0.125 //w=0.17 //l=0.177341 //layer=m2 \
 //thickness=0.36 //x=47.465 //y=3.51 //x2=47.635 //y2=3.495
r983 (  82 83 ) resistor r=6.25 //w=0.131 //l=6.55 //layer=m2 //thickness=0.36 \
 //x=47.465 //y=3.51 //x2=40.915 //y2=3.51
r984 (  80 83 ) resistor r=0.1875 //w=0.17 //l=0.269583 //layer=m2 \
 //thickness=0.36 //x=40.66 //y=3.48 //x2=40.915 //y2=3.51
r985 (  80 81 ) resistor r=0.410305 //w=0.131 //l=0.43 //layer=m2 \
 //thickness=0.36 //x=40.66 //y=3.48 //x2=40.23 //y2=3.48
r986 (  78 81 ) resistor r=0.125 //w=0.17 //l=0.184391 //layer=m2 \
 //thickness=0.36 //x=40.06 //y=3.51 //x2=40.23 //y2=3.48
r987 (  78 79 ) resistor r=3.06298 //w=0.131 //l=3.21 //layer=m2 \
 //thickness=0.36 //x=40.06 //y=3.51 //x2=36.85 //y2=3.51
r988 (  76 79 ) resistor r=0.1875 //w=0.17 //l=0.269583 //layer=m2 \
 //thickness=0.36 //x=36.595 //y=3.48 //x2=36.85 //y2=3.51
r989 (  76 77 ) resistor r=0.410305 //w=0.131 //l=0.43 //layer=m2 \
 //thickness=0.36 //x=36.595 //y=3.48 //x2=36.165 //y2=3.48
r990 (  74 77 ) resistor r=0.125 //w=0.17 //l=0.184391 //layer=m2 \
 //thickness=0.36 //x=35.995 //y=3.51 //x2=36.165 //y2=3.48
r991 (  74 75 ) resistor r=3.76908 //w=0.131 //l=3.95 //layer=m2 \
 //thickness=0.36 //x=35.995 //y=3.51 //x2=32.045 //y2=3.51
r992 (  73 113 ) resistor r=5.07768 //w=0.177 //l=7.21246 //layer=m2 \
 //thickness=0.36 //x=31.36 //y=3.48 //x2=24.17 //y2=3.525
r993 (  72 75 ) resistor r=0.1875 //w=0.17 //l=0.269583 //layer=m2 \
 //thickness=0.36 //x=31.79 //y=3.48 //x2=32.045 //y2=3.51
r994 (  72 73 ) resistor r=0.410305 //w=0.131 //l=0.43 //layer=m2 \
 //thickness=0.36 //x=31.79 //y=3.48 //x2=31.36 //y2=3.48
r995 (  70 113 ) resistor r=0.370763 //w=0.177 //l=0.537355 //layer=m2 \
 //thickness=0.36 //x=23.645 //y=3.5 //x2=24.17 //y2=3.525
r996 (  70 71 ) resistor r=0.410305 //w=0.131 //l=0.43 //layer=m2 \
 //thickness=0.36 //x=23.645 //y=3.5 //x2=23.215 //y2=3.5
r997 (  68 71 ) resistor r=0.125 //w=0.17 //l=0.174929 //layer=m2 \
 //thickness=0.36 //x=23.045 //y=3.51 //x2=23.215 //y2=3.5
r998 (  68 111 ) resistor r=4.06966 //w=0.131 //l=4.265 //layer=m2 \
 //thickness=0.36 //x=23.045 //y=3.51 //x2=18.78 //y2=3.51
r999 (  67 191 ) resistor r=9.3 //w=0.17 //l=0.17 //layer=mcon //count=1 \
 //x=81.15 //y=4.885 //x2=81.15 //y2=4.885
r1000 (  65 121 ) resistor r=4.5 //w=0.15 //l=0.15 //layer=via1 //count=1 \
 //x=81.145 //y=2.27 //x2=81.145 //y2=2.27
r1001 (  63 186 ) resistor r=9.3 //w=0.17 //l=0.17 //layer=mcon //count=1 \
 //x=81.15 //y=2.26 //x2=81.15 //y2=2.26
r1002 (  63 65 ) resistor r=0.00334225 //w=0.374 //l=0.01 //layer=m1 \
 //thickness=0.36 //x=81.095 //y=2.26 //x2=81.095 //y2=2.27
r1003 (  61 117 ) resistor r=4.5 //w=0.15 //l=0.15 //layer=via1 //count=1 \
 //x=79.675 //y=2.27 //x2=79.675 //y2=2.27
r1004 (  59 172 ) resistor r=9.3 //w=0.17 //l=0.17 //layer=mcon //count=1 \
 //x=79.67 //y=2.26 //x2=79.67 //y2=2.26
r1005 (  59 61 ) resistor r=0.00334225 //w=0.374 //l=0.01 //layer=m1 \
 //thickness=0.36 //x=79.725 //y=2.26 //x2=79.725 //y2=2.27
r1006 (  57 181 ) resistor r=9.3 //w=0.17 //l=0.17 //layer=mcon //count=1 \
 //x=79.67 //y=4.885 //x2=79.67 //y2=4.885
r1007 (  55 115 ) resistor r=4.5 //w=0.15 //l=0.15 //layer=via1 //count=1 \
 //x=79.665 //y=3.515 //x2=79.665 //y2=3.515
r1008 (  53 55 ) resistor r=0.00167112 //w=0.374 //l=0.005 //layer=m1 \
 //thickness=0.36 //x=79.615 //y=3.51 //x2=79.615 //y2=3.515
r1009 (  51 113 ) resistor r=4.5 //w=0.15 //l=0.15 //layer=via1 //count=1 \
 //x=24.17 //y=3.525 //x2=24.17 //y2=3.525
r1010 (  49 51 ) resistor r=0.0049867 //w=0.376 //l=0.015 //layer=m1 \
 //thickness=0.36 //x=24.222 //y=3.51 //x2=24.222 //y2=3.525
r1011 (  47 290 ) resistor r=9.3 //w=0.17 //l=0.17 //layer=mcon //count=1 \
 //x=23.685 //y=1.19 //x2=23.685 //y2=1.19
r1012 (  45 155 ) resistor r=9.3 //w=0.17 //l=0.17 //layer=mcon //count=1 \
 //x=23.39 //y=5.56 //x2=23.39 //y2=5.56
r1013 (  42 147 ) resistor r=9.3 //w=0.17 //l=0.17 //layer=mcon //count=1 \
 //x=22.51 //y=5.56 //x2=22.51 //y2=5.56
r1014 (  40 42 ) resistor r=0.121228 //w=0.232 //l=0.225 //layer=m1 \
 //thickness=0.36 //x=22.51 //y=5.335 //x2=22.51 //y2=5.56
r1015 (  39 139 ) resistor r=9.3 //w=0.17 //l=0.17 //layer=mcon //count=1 \
 //x=21.63 //y=5.56 //x2=21.63 //y2=5.56
r1016 (  37 39 ) resistor r=0.129608 //w=0.217 //l=0.225 //layer=m1 \
 //thickness=0.36 //x=21.632 //y=5.335 //x2=21.632 //y2=5.56
r1017 (  34 109 ) resistor r=4.5 //w=0.15 //l=0.15 //layer=via1 //count=1 \
 //x=18.62 //y=3.495 //x2=18.62 //y2=3.495
r1018 (  34 36 ) resistor r=0.0049867 //w=0.376 //l=0.015 //layer=m1 \
 //thickness=0.36 //x=18.672 //y=3.495 //x2=18.672 //y2=3.51
r1019 (  32 134 ) resistor r=9.3 //w=0.17 //l=0.17 //layer=mcon //count=1 \
 //x=18.65 //y=4.88 //x2=18.65 //y2=4.88
r1020 (  28 125 ) resistor r=9.3 //w=0.17 //l=0.17 //layer=mcon //count=1 \
 //x=18.62 //y=2.26 //x2=18.62 //y2=2.26
r1021 (  28 30 ) resistor r=0.0936408 //w=0.196 //l=0.125 //layer=m1 \
 //thickness=0.36 //x=18.622 //y=2.26 //x2=18.622 //y2=2.385
r1022 (  26 67 ) resistor r=0.0777782 //w=0.252 //l=0.131491 //layer=m1 \
 //thickness=0.36 //x=81.15 //y=4.755 //x2=81.147 //y2=4.885
r1023 (  25 65 ) resistor r=0.0910802 //w=0.374 //l=0.185472 //layer=m1 \
 //thickness=0.36 //x=81.15 //y=2.43 //x2=81.095 //y2=2.27
r1024 (  25 26 ) resistor r=2.21851 //w=0.131 //l=2.325 //layer=m1 \
 //thickness=0.36 //x=81.15 //y=2.43 //x2=81.15 //y2=4.755
r1025 (  24 57 ) resistor r=0.075298 //w=0.252 //l=0.125 //layer=m1 \
 //thickness=0.36 //x=79.67 //y=4.76 //x2=79.67 //y2=4.885
r1026 (  23 55 ) resistor r=0.0910802 //w=0.374 //l=0.185472 //layer=m1 \
 //thickness=0.36 //x=79.67 //y=3.675 //x2=79.615 //y2=3.515
r1027 (  23 24 ) resistor r=1.03531 //w=0.131 //l=1.085 //layer=m1 \
 //thickness=0.36 //x=79.67 //y=3.675 //x2=79.67 //y2=4.76
r1028 (  22 53 ) resistor r=0.089409 //w=0.374 //l=0.180416 //layer=m1 \
 //thickness=0.36 //x=79.67 //y=3.355 //x2=79.615 //y2=3.51
r1029 (  21 61 ) resistor r=0.0910802 //w=0.374 //l=0.185472 //layer=m1 \
 //thickness=0.36 //x=79.67 //y=2.43 //x2=79.725 //y2=2.27
r1030 (  21 22 ) resistor r=0.882634 //w=0.131 //l=0.925 //layer=m1 \
 //thickness=0.36 //x=79.67 //y=2.43 //x2=79.67 //y2=3.355
r1031 (  19 51 ) resistor r=0.0911593 //w=0.376 //l=0.184174 //layer=m1 \
 //thickness=0.36 //x=24.17 //y=3.685 //x2=24.222 //y2=3.525
r1032 (  19 20 ) resistor r=1.49332 //w=0.131 //l=1.565 //layer=m1 \
 //thickness=0.36 //x=24.17 //y=3.685 //x2=24.17 //y2=5.25
r1033 (  18 49 ) resistor r=0.0861726 //w=0.376 //l=0.169012 //layer=m1 \
 //thickness=0.36 //x=24.17 //y=3.365 //x2=24.222 //y2=3.51
r1034 (  17 18 ) resistor r=1.36927 //w=0.131 //l=1.435 //layer=m1 \
 //thickness=0.36 //x=24.17 //y=1.93 //x2=24.17 //y2=3.365
r1035 (  15 17 ) resistor r=0.0698411 //w=0.17 //l=0.120208 //layer=m1 \
 //thickness=0.36 //x=24.085 //y=1.845 //x2=24.17 //y2=1.93
r1036 (  15 16 ) resistor r=0.300573 //w=0.131 //l=0.315 //layer=m1 \
 //thickness=0.36 //x=24.085 //y=1.845 //x2=23.77 //y2=1.845
r1037 (  14 16 ) resistor r=0.0698411 //w=0.17 //l=0.120208 //layer=m1 \
 //thickness=0.36 //x=23.685 //y=1.76 //x2=23.77 //y2=1.845
r1038 (  13 47 ) resistor r=0.0717383 //w=0.224 //l=0.115 //layer=m1 \
 //thickness=0.36 //x=23.685 //y=1.305 //x2=23.685 //y2=1.19
r1039 (  13 14 ) resistor r=0.43416 //w=0.131 //l=0.455 //layer=m1 \
 //thickness=0.36 //x=23.685 //y=1.305 //x2=23.685 //y2=1.76
r1040 (  12 43 ) resistor r=0.0675342 //w=0.23 //l=0.115 //layer=m1 \
 //thickness=0.36 //x=23.505 //y=5.335 //x2=23.39 //y2=5.335
r1041 (  11 20 ) resistor r=0.0698411 //w=0.17 //l=0.120208 //layer=m1 \
 //thickness=0.36 //x=24.085 //y=5.335 //x2=24.17 //y2=5.25
r1042 (  11 12 ) resistor r=0.553435 //w=0.131 //l=0.58 //layer=m1 \
 //thickness=0.36 //x=24.085 //y=5.335 //x2=23.505 //y2=5.335
r1043 (  10 45 ) resistor r=0.00118313 //w=0.23 //layer=m1 //thickness=0.36 \
 //x=23.39 //y=5.56 //x2=23.39 //y2=5.56
r1044 (  9 43 ) resistor r=0.002872 //w=0.34 //l=0.085 //layer=m1 \
 //thickness=0.36 //x=23.39 //y=5.42 //x2=23.39 //y2=5.335
r1045 (  9 10 ) resistor r=0.091623 //w=0.191 //l=0.14 //layer=m1 \
 //thickness=0.36 //x=23.39 //y=5.42 //x2=23.39 //y2=5.56
r1046 (  8 40 ) resistor r=0.0262263 //w=0.232 //l=0.12 //layer=m1 \
 //thickness=0.36 //x=22.63 //y=5.335 //x2=22.51 //y2=5.335
r1047 (  7 43 ) resistor r=0.0675342 //w=0.23 //l=0.115 //layer=m1 \
 //thickness=0.36 //x=23.275 //y=5.335 //x2=23.39 //y2=5.335
r1048 (  7 8 ) resistor r=0.615458 //w=0.131 //l=0.645 //layer=m1 \
 //thickness=0.36 //x=23.275 //y=5.335 //x2=22.63 //y2=5.335
r1049 (  6 37 ) resistor r=0.0222262 //w=0.217 //l=0.118 //layer=m1 \
 //thickness=0.36 //x=21.75 //y=5.335 //x2=21.632 //y2=5.335
r1050 (  5 40 ) resistor r=0.0262263 //w=0.232 //l=0.12 //layer=m1 \
 //thickness=0.36 //x=22.39 //y=5.335 //x2=22.51 //y2=5.335
r1051 (  5 6 ) resistor r=0.610687 //w=0.131 //l=0.64 //layer=m1 \
 //thickness=0.36 //x=22.39 //y=5.335 //x2=21.75 //y2=5.335
r1052 (  4 32 ) resistor r=0.0878548 //w=0.228 //l=0.159295 //layer=m1 \
 //thickness=0.36 //x=18.62 //y=4.735 //x2=18.65 //y2=4.88
r1053 (  3 36 ) resistor r=0.0861726 //w=0.376 //l=0.169012 //layer=m1 \
 //thickness=0.36 //x=18.62 //y=3.655 //x2=18.672 //y2=3.51
r1054 (  3 4 ) resistor r=1.03053 //w=0.131 //l=1.08 //layer=m1 \
 //thickness=0.36 //x=18.62 //y=3.655 //x2=18.62 //y2=4.735
r1055 (  2 34 ) resistor r=0.0911593 //w=0.376 //l=0.184174 //layer=m1 \
 //thickness=0.36 //x=18.62 //y=3.335 //x2=18.672 //y2=3.495
r1056 (  2 30 ) resistor r=0.906489 //w=0.131 //l=0.95 //layer=m1 \
 //thickness=0.36 //x=18.62 //y=3.335 //x2=18.62 //y2=2.385
ends PM_TMRDFFSNQX1\%noxref_21

subckt PM_TMRDFFSNQX1\%noxref_22 ( 1 3 4 5 7 8 10 11 12 14 15 16 18 22 25 28 \
 36 40 44 57 60 61 63 64 69 71 72 81 89 107 116 124 125 126 127 128 129 130 \
 134 135 136 138 144 145 147 155 156 157 161 162 )
c339 ( 157 0 ) capacitor c=0.00985497f //x=82.37 //y=1.085
c340 ( 156 0 ) capacitor c=0.0108944f //x=79.04 //y=1.085
c341 ( 155 0 ) capacitor c=0.0110396f //x=75.71 //y=1.085
c342 ( 147 0 ) capacitor c=0.0588117f //x=84.48 //y=2.265
c343 ( 145 0 ) capacitor c=0.0439576f //x=85.12 //y=1.435
c344 ( 144 0 ) capacitor c=0.0201087f //x=85.12 //y=1.09
c345 ( 138 0 ) capacitor c=0.0161986f //x=84.965 //y=1.59
c346 ( 136 0 ) capacitor c=0.0157807f //x=84.965 //y=0.935
c347 ( 135 0 ) capacitor c=0.051364f //x=84.71 //y=4.97
c348 ( 134 0 ) capacitor c=0.0406047f //x=85 //y=4.97
c349 ( 130 0 ) capacitor c=0.0301471f //x=84.59 //y=2.1
c350 ( 129 0 ) capacitor c=0.0255349f //x=84.59 //y=1.745
c351 ( 128 0 ) capacitor c=0.0234346f //x=84.59 //y=1.435
c352 ( 127 0 ) capacitor c=0.02013f //x=84.59 //y=1.09
c353 ( 126 0 ) capacitor c=0.153839f //x=85.075 //y=6.2
c354 ( 125 0 ) capacitor c=0.15434f //x=84.635 //y=6.2
c355 ( 116 0 ) capacitor c=6.76693e-19 //x=84.48 //y=4.88
c356 ( 107 0 ) capacitor c=9.11699e-19 //x=84.48 //y=2.265
c357 ( 89 0 ) capacitor c=0.0265472f //x=82.52 //y=5.56
c358 ( 81 0 ) capacitor c=0.0232072f //x=81.64 //y=5.56
c359 ( 72 0 ) capacitor c=0.0554023f //x=84.32 //y=4.255
c360 ( 71 0 ) capacitor c=0.00507699f //x=84.48 //y=4.255
c361 ( 69 0 ) capacitor c=0.00713729f //x=83.16 //y=4.255
c362 ( 64 0 ) capacitor c=0.0848419f //x=82.395 //y=1.405
c363 ( 63 0 ) capacitor c=0.0257508f //x=82.555 //y=1.405
c364 ( 61 0 ) capacitor c=0.00767971f //x=79.36 //y=1.405
c365 ( 60 0 ) capacitor c=0.0878164f //x=79.1 //y=1.405
c366 ( 57 0 ) capacitor c=0.00368337f //x=76.065 //y=1.405
c367 ( 44 0 ) capacitor c=0.0116317f //x=84.48 //y=2.265
c368 ( 40 0 ) capacitor c=0.0139687f //x=84.48 //y=4.25
c369 ( 36 0 ) capacitor c=0.0138558f //x=83 //y=4.25
c370 ( 28 0 ) capacitor c=0.0125078f //x=82.517 //y=5.39
c371 ( 25 0 ) capacitor c=0.0156957f //x=81.64 //y=5.39
c372 ( 22 0 ) capacitor c=0.00905508f //x=79.23 //y=1.36
c373 ( 18 0 ) capacitor c=0.00597397f //x=75.9 //y=1.36
c374 ( 16 0 ) capacitor c=0.010406f //x=84.48 //y=4.76
c375 ( 15 0 ) capacitor c=0.0112315f //x=84.48 //y=4.415
c376 ( 14 0 ) capacitor c=0.0499188f //x=84.48 //y=4.095
c377 ( 12 0 ) capacitor c=0.0203608f //x=83 //y=5.305
c378 ( 11 0 ) capacitor c=0.0114995f //x=83 //y=4.415
c379 ( 10 0 ) capacitor c=0.0630549f //x=83 //y=4.095
c380 ( 8 0 ) capacitor c=0.00834076f //x=82.645 //y=1.825
c381 ( 7 0 ) capacitor c=0.014154f //x=82.915 //y=1.825
c382 ( 5 0 ) capacitor c=0.00996583f //x=82.915 //y=5.39
c383 ( 4 0 ) capacitor c=0.00638645f //x=82.56 //y=1.74
c384 ( 3 0 ) capacitor c=0.00623208f //x=82.56 //y=1.535
c385 ( 1 0 ) capacitor c=0.0116295f //x=82.395 //y=5.39
r386 (  147 148 ) resistor r=17.5563 //w=0.302 //l=0.11 //layer=ply \
 //thickness=0.18 //x=84.48 //y=2.265 //x2=84.59 //y2=2.265
r387 (  145 154 ) resistor r=45.1352 //w=0.168 //l=0.173853 //layer=ply \
 //thickness=0.18 //x=85.12 //y=1.435 //x2=85.08 //y2=1.59
r388 (  144 153 ) resistor r=45.1352 //w=0.168 //l=0.173853 //layer=ply \
 //thickness=0.18 //x=85.12 //y=1.09 //x2=85.08 //y2=0.935
r389 (  144 145 ) resistor r=176.904 //w=0.094 //l=0.345 //layer=ply \
 //thickness=0.18 //x=85.12 //y=1.09 //x2=85.12 //y2=1.435
r390 (  139 152 ) resistor r=10.701 //w=0.21 //l=0.115 //layer=ply \
 //thickness=0.18 //x=84.745 //y=1.59 //x2=84.63 //y2=1.59
r391 (  138 154 ) resistor r=5.52526 //w=0.168 //l=0.115 //layer=ply \
 //thickness=0.18 //x=84.965 //y=1.59 //x2=85.08 //y2=1.59
r392 (  137 151 ) resistor r=5.52526 //w=0.168 //l=0.115 //layer=ply \
 //thickness=0.18 //x=84.745 //y=0.935 //x2=84.63 //y2=0.935
r393 (  136 153 ) resistor r=5.52526 //w=0.168 //l=0.115 //layer=ply \
 //thickness=0.18 //x=84.965 //y=0.935 //x2=85.08 //y2=0.935
r394 (  136 137 ) resistor r=112.809 //w=0.094 //l=0.22 //layer=ply \
 //thickness=0.18 //x=84.965 //y=0.935 //x2=84.745 //y2=0.935
r395 (  134 141 ) resistor r=26.9307 //w=0.15 //l=0.106066 //layer=ply \
 //thickness=0.18 //x=85 //y=4.97 //x2=85.075 //y2=5.045
r396 (  134 135 ) resistor r=148.702 //w=0.094 //l=0.29 //layer=ply \
 //thickness=0.18 //x=85 //y=4.97 //x2=84.71 //y2=4.97
r397 (  131 135 ) resistor r=23.403 //w=0.284 //l=0.106066 //layer=ply \
 //thickness=0.18 //x=84.635 //y=5.045 //x2=84.71 //y2=4.97
r398 (  131 150 ) resistor r=26.3063 //w=0.284 //l=0.229783 //layer=ply \
 //thickness=0.18 //x=84.635 //y=5.045 //x2=84.48 //y2=4.88
r399 (  130 148 ) resistor r=19.1248 //w=0.302 //l=0.165 //layer=ply \
 //thickness=0.18 //x=84.59 //y=2.1 //x2=84.59 //y2=2.265
r400 (  129 152 ) resistor r=39.5823 //w=0.21 //l=0.173853 //layer=ply \
 //thickness=0.18 //x=84.59 //y=1.745 //x2=84.63 //y2=1.59
r401 (  129 130 ) resistor r=182.032 //w=0.094 //l=0.355 //layer=ply \
 //thickness=0.18 //x=84.59 //y=1.745 //x2=84.59 //y2=2.1
r402 (  128 152 ) resistor r=39.5823 //w=0.21 //l=0.173853 //layer=ply \
 //thickness=0.18 //x=84.59 //y=1.435 //x2=84.63 //y2=1.59
r403 (  127 151 ) resistor r=45.1352 //w=0.168 //l=0.173853 //layer=ply \
 //thickness=0.18 //x=84.59 //y=1.09 //x2=84.63 //y2=0.935
r404 (  127 128 ) resistor r=176.904 //w=0.094 //l=0.345 //layer=ply \
 //thickness=0.18 //x=84.59 //y=1.09 //x2=84.59 //y2=1.435
r405 (  126 141 ) resistor r=592.245 //w=0.094 //l=1.155 //layer=ply \
 //thickness=0.18 //x=85.075 //y=6.2 //x2=85.075 //y2=5.045
r406 (  125 131 ) resistor r=592.245 //w=0.094 //l=1.155 //layer=ply \
 //thickness=0.18 //x=84.635 //y=6.2 //x2=84.635 //y2=5.045
r407 (  124 138 ) resistor r=56.4043 //w=0.094 //l=0.11 //layer=ply \
 //thickness=0.18 //x=84.855 //y=1.59 //x2=84.965 //y2=1.59
r408 (  124 139 ) resistor r=56.4043 //w=0.094 //l=0.11 //layer=ply \
 //thickness=0.18 //x=84.855 //y=1.59 //x2=84.745 //y2=1.59
r409 (  123 155 ) resistor r=13.3953 //w=0.172 //l=0.18 //layer=li \
 //thickness=0.1 //x=75.897 //y=1.36 //x2=75.897 //y2=1.18
r410 (  116 150 ) resistor r=152 //w=0.17 //l=0.17 //layer=licon //count=1 \
 //x=84.48 //y=4.88 //x2=84.48 //y2=4.88
r411 (  107 147 ) resistor r=152 //w=0.17 //l=0.17 //layer=licon //count=1 \
 //x=84.48 //y=2.265 //x2=84.48 //y2=2.265
r412 (  100 157 ) resistor r=12.3209 //w=0.187 //l=0.18 //layer=li \
 //thickness=0.1 //x=82.56 //y=1.36 //x2=82.56 //y2=1.18
r413 (  89 162 ) resistor r=23.2727 //w=0.187 //l=0.34 //layer=li \
 //thickness=0.1 //x=82.52 //y=5.56 //x2=82.52 //y2=5.9
r414 (  81 161 ) resistor r=23.2727 //w=0.187 //l=0.34 //layer=li \
 //thickness=0.1 //x=81.64 //y=5.56 //x2=81.64 //y2=5.9
r415 (  78 156 ) resistor r=12.3209 //w=0.187 //l=0.18 //layer=li \
 //thickness=0.1 //x=79.23 //y=1.36 //x2=79.23 //y2=1.18
r416 (  71 72 ) resistor r=0.10734 //w=0.281 //l=0.16 //layer=m2 \
 //thickness=0.36 //x=84.48 //y=4.255 //x2=84.32 //y2=4.255
r417 (  69 72 ) resistor r=1.10687 //w=0.131 //l=1.16 //layer=m2 \
 //thickness=0.36 //x=83.16 //y=4.25 //x2=84.32 //y2=4.25
r418 (  67 69 ) resistor r=0.10734 //w=0.281 //l=0.16 //layer=m2 \
 //thickness=0.36 //x=83 //y=4.255 //x2=83.16 //y2=4.255
r419 (  63 64 ) resistor r=0.10734 //w=0.281 //l=0.16 //layer=m2 \
 //thickness=0.36 //x=82.555 //y=1.405 //x2=82.395 //y2=1.405
r420 (  61 64 ) resistor r=2.89599 //w=0.131 //l=3.035 //layer=m2 \
 //thickness=0.36 //x=79.36 //y=1.36 //x2=82.395 //y2=1.36
r421 (  59 61 ) resistor r=0.0942778 //w=0.221 //l=0.13 //layer=m2 \
 //thickness=0.36 //x=79.23 //y=1.405 //x2=79.36 //y2=1.405
r422 (  59 60 ) resistor r=0.0942778 //w=0.221 //l=0.13 //layer=m2 \
 //thickness=0.36 //x=79.23 //y=1.405 //x2=79.1 //y2=1.405
r423 (  57 60 ) resistor r=2.89599 //w=0.131 //l=3.035 //layer=m2 \
 //thickness=0.36 //x=76.065 //y=1.36 //x2=79.1 //y2=1.36
r424 (  55 57 ) resistor r=0.10734 //w=0.281 //l=0.16 //layer=m2 \
 //thickness=0.36 //x=75.905 //y=1.405 //x2=76.065 //y2=1.405
r425 (  47 116 ) resistor r=9.3 //w=0.17 //l=0.17 //layer=mcon //count=1 \
 //x=84.48 //y=4.88 //x2=84.48 //y2=4.88
r426 (  44 107 ) resistor r=9.3 //w=0.17 //l=0.17 //layer=mcon //count=1 \
 //x=84.48 //y=2.265 //x2=84.48 //y2=2.265
r427 (  42 71 ) resistor r=4.5 //w=0.15 //l=0.15 //layer=via1 //count=1 \
 //x=84.48 //y=4.255 //x2=84.48 //y2=4.255
r428 (  40 42 ) resistor r=0.00166223 //w=0.376 //l=0.005 //layer=m1 \
 //thickness=0.36 //x=84.427 //y=4.25 //x2=84.427 //y2=4.255
r429 (  38 67 ) resistor r=4.5 //w=0.15 //l=0.15 //layer=via1 //count=1 //x=83 \
 //y=4.255 //x2=83 //y2=4.255
r430 (  36 38 ) resistor r=0.00166223 //w=0.376 //l=0.005 //layer=m1 \
 //thickness=0.36 //x=83.052 //y=4.25 //x2=83.052 //y2=4.255
r431 (  34 63 ) resistor r=4.5 //w=0.15 //l=0.15 //layer=via1 //count=1 \
 //x=82.555 //y=1.405 //x2=82.555 //y2=1.405
r432 (  32 100 ) resistor r=9.3 //w=0.17 //l=0.17 //layer=mcon //count=1 \
 //x=82.56 //y=1.36 //x2=82.56 //y2=1.36
r433 (  32 34 ) resistor r=0.0163043 //w=0.345 //l=0.045 //layer=m1 \
 //thickness=0.36 //x=82.5 //y=1.36 //x2=82.5 //y2=1.405
r434 (  30 89 ) resistor r=9.3 //w=0.17 //l=0.17 //layer=mcon //count=1 \
 //x=82.52 //y=5.56 //x2=82.52 //y2=5.56
r435 (  28 30 ) resistor r=0.0944444 //w=0.225 //l=0.17 //layer=m1 \
 //thickness=0.36 //x=82.517 //y=5.39 //x2=82.517 //y2=5.56
r436 (  27 81 ) resistor r=9.3 //w=0.17 //l=0.17 //layer=mcon //count=1 \
 //x=81.64 //y=5.56 //x2=81.64 //y2=5.56
r437 (  25 27 ) resistor r=0.0936123 //w=0.227 //l=0.17 //layer=m1 \
 //thickness=0.36 //x=81.64 //y=5.39 //x2=81.64 //y2=5.56
r438 (  24 59 ) resistor r=4.5 //w=0.15 //l=0.15 //layer=via1 //count=1 \
 //x=79.23 //y=1.405 //x2=79.23 //y2=1.405
r439 (  22 78 ) resistor r=9.3 //w=0.17 //l=0.17 //layer=mcon //count=1 \
 //x=79.23 //y=1.36 //x2=79.23 //y2=1.36
r440 (  22 24 ) resistor r=0.0163043 //w=0.345 //l=0.045 //layer=m1 \
 //thickness=0.36 //x=79.17 //y=1.36 //x2=79.17 //y2=1.405
r441 (  20 55 ) resistor r=4.5 //w=0.15 //l=0.15 //layer=via1 //count=1 \
 //x=75.905 //y=1.405 //x2=75.905 //y2=1.405
r442 (  18 123 ) resistor r=9.3 //w=0.17 //l=0.17 //layer=mcon //count=1 \
 //x=75.9 //y=1.36 //x2=75.9 //y2=1.36
r443 (  18 20 ) resistor r=0.0150401 //w=0.374 //l=0.045 //layer=m1 \
 //thickness=0.36 //x=75.955 //y=1.36 //x2=75.955 //y2=1.405
r444 (  16 47 ) resistor r=0.0732479 //w=0.241 //l=0.122474 //layer=m1 \
 //thickness=0.36 //x=84.48 //y=4.76 //x2=84.485 //y2=4.88
r445 (  15 42 ) resistor r=0.0911593 //w=0.376 //l=0.184608 //layer=m1 \
 //thickness=0.36 //x=84.48 //y=4.415 //x2=84.427 //y2=4.255
r446 (  15 16 ) resistor r=0.329198 //w=0.131 //l=0.345 //layer=m1 \
 //thickness=0.36 //x=84.48 //y=4.415 //x2=84.48 //y2=4.76
r447 (  14 40 ) resistor r=0.0894971 //w=0.376 //l=0.179555 //layer=m1 \
 //thickness=0.36 //x=84.48 //y=4.095 //x2=84.427 //y2=4.25
r448 (  13 44 ) resistor r=0.116051 //w=0.211 //l=0.165 //layer=m1 \
 //thickness=0.36 //x=84.48 //y=2.43 //x2=84.48 //y2=2.265
r449 (  13 14 ) resistor r=1.58874 //w=0.131 //l=1.665 //layer=m1 \
 //thickness=0.36 //x=84.48 //y=2.43 //x2=84.48 //y2=4.095
r450 (  11 38 ) resistor r=0.0911593 //w=0.376 //l=0.184174 //layer=m1 \
 //thickness=0.36 //x=83 //y=4.415 //x2=83.052 //y2=4.255
r451 (  11 12 ) resistor r=0.849237 //w=0.131 //l=0.89 //layer=m1 \
 //thickness=0.36 //x=83 //y=4.415 //x2=83 //y2=5.305
r452 (  10 36 ) resistor r=0.0894971 //w=0.376 //l=0.179123 //layer=m1 \
 //thickness=0.36 //x=83 //y=4.095 //x2=83.052 //y2=4.25
r453 (  9 10 ) resistor r=2.08492 //w=0.131 //l=2.185 //layer=m1 \
 //thickness=0.36 //x=83 //y=1.91 //x2=83 //y2=4.095
r454 (  7 9 ) resistor r=0.0698411 //w=0.17 //l=0.120208 //layer=m1 \
 //thickness=0.36 //x=82.915 //y=1.825 //x2=83 //y2=1.91
r455 (  7 8 ) resistor r=0.257634 //w=0.131 //l=0.27 //layer=m1 \
 //thickness=0.36 //x=82.915 //y=1.825 //x2=82.645 //y2=1.825
r456 (  6 28 ) resistor r=0.0243946 //w=0.225 //l=0.123 //layer=m1 \
 //thickness=0.36 //x=82.64 //y=5.39 //x2=82.517 //y2=5.39
r457 (  5 12 ) resistor r=0.0698411 //w=0.17 //l=0.120208 //layer=m1 \
 //thickness=0.36 //x=82.915 //y=5.39 //x2=83 //y2=5.305
r458 (  5 6 ) resistor r=0.262405 //w=0.131 //l=0.275 //layer=m1 \
 //thickness=0.36 //x=82.915 //y=5.39 //x2=82.64 //y2=5.39
r459 (  4 8 ) resistor r=0.0698411 //w=0.17 //l=0.120208 //layer=m1 \
 //thickness=0.36 //x=82.56 //y=1.74 //x2=82.645 //y2=1.825
r460 (  3 34 ) resistor r=0.0792909 //w=0.345 //l=0.157162 //layer=m1 \
 //thickness=0.36 //x=82.56 //y=1.535 //x2=82.5 //y2=1.405
r461 (  3 4 ) resistor r=0.195611 //w=0.131 //l=0.205 //layer=m1 \
 //thickness=0.36 //x=82.56 //y=1.535 //x2=82.56 //y2=1.74
r462 (  2 25 ) resistor r=0.0249239 //w=0.227 //l=0.125 //layer=m1 \
 //thickness=0.36 //x=81.765 //y=5.39 //x2=81.64 //y2=5.39
r463 (  1 28 ) resistor r=0.0243946 //w=0.225 //l=0.122 //layer=m1 \
 //thickness=0.36 //x=82.395 //y=5.39 //x2=82.517 //y2=5.39
r464 (  1 2 ) resistor r=0.601145 //w=0.131 //l=0.63 //layer=m1 \
 //thickness=0.36 //x=82.395 //y=5.39 //x2=81.765 //y2=5.39
ends PM_TMRDFFSNQX1\%noxref_22

subckt PM_TMRDFFSNQX1\%VDD ( 1 2 125 126 127 129 130 131 135 136 153 219 227 \
 253 261 271 281 297 305 315 325 341 351 377 387 395 399 411 421 429 439 455 \
 463 489 497 507 517 533 541 551 561 577 587 613 623 647 657 665 675 691 699 \
 725 733 743 753 769 777 787 797 813 823 849 859 867 883 893 901 911 917 952 \
 960 980 995 998 1004 1010 1014 1019 1024 1029 1035 1041 1045 1050 1055 1060 \
 1066 1072 1076 1081 1086 1087 1088 1089 1093 1094 1095 1096 1097 1098 1099 \
 1100 1101 1102 1103 1104 1105 1106 1107 1108 1109 1110 1111 1112 1113 1114 \
 1115 1116 1117 1118 1119 1120 1121 1122 1123 1124 1125 1126 1127 1128 1129 \
 1130 1131 1132 1133 1134 1135 1136 1137 1138 1139 1140 1141 1142 1143 1144 \
 1145 1146 1147 1148 1149 1150 1151 1152 1153 1154 1155 1156 1157 1158 1159 \
 1160 1161 )
c1428 ( 1161 0 ) capacitor c=0.0632648f //x=85.15 //y=5.2
c1429 ( 1160 0 ) capacitor c=0.0575062f //x=84.28 //y=5.2
c1430 ( 1159 0 ) capacitor c=0.0424825f //x=76.155 //y=5.205
c1431 ( 1158 0 ) capacitor c=0.0224071f //x=75.275 //y=5.205
c1432 ( 1157 0 ) capacitor c=0.051473f //x=74.405 //y=5.205
c1433 ( 1156 0 ) capacitor c=0.046689f //x=72.525 //y=5.2
c1434 ( 1155 0 ) capacitor c=0.0255621f //x=71.645 //y=5.2
c1435 ( 1154 0 ) capacitor c=0.0255777f //x=70.765 //y=5.2
c1436 ( 1153 0 ) capacitor c=0.0671938f //x=69.895 //y=5.2
c1437 ( 1152 0 ) capacitor c=0.0382916f //x=68.015 //y=5.2
c1438 ( 1151 0 ) capacitor c=0.0248174f //x=67.135 //y=5.2
c1439 ( 1150 0 ) capacitor c=0.0621883f //x=66.265 //y=5.2
c1440 ( 1149 0 ) capacitor c=0.0393089f //x=64.685 //y=5.2
c1441 ( 1148 0 ) capacitor c=0.0248174f //x=63.805 //y=5.2
c1442 ( 1147 0 ) capacitor c=0.0629527f //x=62.935 //y=5.2
c1443 ( 1146 0 ) capacitor c=0.0466891f //x=61.055 //y=5.2
c1444 ( 1145 0 ) capacitor c=0.0255836f //x=60.175 //y=5.2
c1445 ( 1144 0 ) capacitor c=0.0256114f //x=59.295 //y=5.2
c1446 ( 1143 0 ) capacitor c=0.0677135f //x=58.425 //y=5.2
c1447 ( 1142 0 ) capacitor c=0.0466891f //x=56.245 //y=5.2
c1448 ( 1141 0 ) capacitor c=0.025617f //x=55.365 //y=5.2
c1449 ( 1140 0 ) capacitor c=0.0255777f //x=54.485 //y=5.2
c1450 ( 1139 0 ) capacitor c=0.0675218f //x=53.615 //y=5.2
c1451 ( 1138 0 ) capacitor c=0.0399069f //x=51.735 //y=5.2
c1452 ( 1137 0 ) capacitor c=0.0248174f //x=50.855 //y=5.2
c1453 ( 1136 0 ) capacitor c=0.062891f //x=49.985 //y=5.2
c1454 ( 1135 0 ) capacitor c=0.0466891f //x=48.105 //y=5.2
c1455 ( 1134 0 ) capacitor c=0.0255836f //x=47.225 //y=5.2
c1456 ( 1133 0 ) capacitor c=0.0255777f //x=46.345 //y=5.2
c1457 ( 1132 0 ) capacitor c=0.0675806f //x=45.475 //y=5.2
c1458 ( 1131 0 ) capacitor c=0.0399069f //x=43.595 //y=5.2
c1459 ( 1130 0 ) capacitor c=0.0248174f //x=42.715 //y=5.2
c1460 ( 1129 0 ) capacitor c=0.0619457f //x=41.845 //y=5.2
c1461 ( 1128 0 ) capacitor c=0.0393089f //x=40.265 //y=5.2
c1462 ( 1127 0 ) capacitor c=0.0248174f //x=39.385 //y=5.2
c1463 ( 1126 0 ) capacitor c=0.0629527f //x=38.515 //y=5.2
c1464 ( 1125 0 ) capacitor c=0.0466891f //x=36.635 //y=5.2
c1465 ( 1124 0 ) capacitor c=0.0255836f //x=35.755 //y=5.2
c1466 ( 1123 0 ) capacitor c=0.0256114f //x=34.875 //y=5.2
c1467 ( 1122 0 ) capacitor c=0.0677135f //x=34.005 //y=5.2
c1468 ( 1121 0 ) capacitor c=0.0466891f //x=31.825 //y=5.2
c1469 ( 1120 0 ) capacitor c=0.025617f //x=30.945 //y=5.2
c1470 ( 1119 0 ) capacitor c=0.0255777f //x=30.065 //y=5.2
c1471 ( 1118 0 ) capacitor c=0.0675218f //x=29.195 //y=5.2
c1472 ( 1117 0 ) capacitor c=0.0399069f //x=27.315 //y=5.2
c1473 ( 1116 0 ) capacitor c=0.0248174f //x=26.435 //y=5.2
c1474 ( 1115 0 ) capacitor c=0.0627878f //x=25.565 //y=5.2
c1475 ( 1114 0 ) capacitor c=0.0466891f //x=23.685 //y=5.2
c1476 ( 1113 0 ) capacitor c=0.0255836f //x=22.805 //y=5.2
c1477 ( 1112 0 ) capacitor c=0.0255777f //x=21.925 //y=5.2
c1478 ( 1111 0 ) capacitor c=0.0674353f //x=21.055 //y=5.2
c1479 ( 1110 0 ) capacitor c=0.0390282f //x=19.175 //y=5.2
c1480 ( 1109 0 ) capacitor c=0.0248174f //x=18.295 //y=5.2
c1481 ( 1108 0 ) capacitor c=0.0619457f //x=17.425 //y=5.2
c1482 ( 1107 0 ) capacitor c=0.0393089f //x=15.845 //y=5.2
c1483 ( 1106 0 ) capacitor c=0.0248174f //x=14.965 //y=5.2
c1484 ( 1105 0 ) capacitor c=0.0629527f //x=14.095 //y=5.2
c1485 ( 1104 0 ) capacitor c=0.0466891f //x=12.215 //y=5.2
c1486 ( 1103 0 ) capacitor c=0.0255836f //x=11.335 //y=5.2
c1487 ( 1102 0 ) capacitor c=0.0256114f //x=10.455 //y=5.2
c1488 ( 1101 0 ) capacitor c=0.0676542f //x=9.585 //y=5.2
c1489 ( 1100 0 ) capacitor c=0.0466891f //x=7.405 //y=5.2
c1490 ( 1099 0 ) capacitor c=0.025617f //x=6.525 //y=5.2
c1491 ( 1098 0 ) capacitor c=0.0255777f //x=5.645 //y=5.2
c1492 ( 1097 0 ) capacitor c=0.0676078f //x=4.775 //y=5.2
c1493 ( 1096 0 ) capacitor c=0.0399069f //x=2.895 //y=5.2
c1494 ( 1095 0 ) capacitor c=0.0248174f //x=2.015 //y=5.2
c1495 ( 1094 0 ) capacitor c=0.0678368f //x=1.145 //y=5.2
c1496 ( 1093 0 ) capacitor c=0.258867f //x=85.22 //y=7.58
c1497 ( 1091 0 ) capacitor c=0.00597439f //x=84.48 //y=7.58
c1498 ( 1089 0 ) capacitor c=0.117824f //x=83.74 //y=7.585
c1499 ( 1088 0 ) capacitor c=0.121201f //x=80.41 //y=7.585
c1500 ( 1087 0 ) capacitor c=0.125805f //x=77.08 //y=7.585
c1501 ( 1086 0 ) capacitor c=0.139512f //x=73.75 //y=7.585
c1502 ( 1085 0 ) capacitor c=0.00597439f //x=72.67 //y=7.585
c1503 ( 1084 0 ) capacitor c=0.00597439f //x=71.79 //y=7.585
c1504 ( 1083 0 ) capacitor c=0.00597439f //x=70.91 //y=7.585
c1505 ( 1082 0 ) capacitor c=0.00597439f //x=70.03 //y=7.585
c1506 ( 1081 0 ) capacitor c=0.143681f //x=68.94 //y=7.585
c1507 ( 1080 0 ) capacitor c=0.00597439f //x=68.2 //y=7.58
c1508 ( 1078 0 ) capacitor c=0.00597439f //x=67.28 //y=7.585
c1509 ( 1077 0 ) capacitor c=0.00597439f //x=66.4 //y=7.585
c1510 ( 1076 0 ) capacitor c=0.12632f //x=65.61 //y=7.585
c1511 ( 1075 0 ) capacitor c=0.00597439f //x=64.83 //y=7.585
c1512 ( 1074 0 ) capacitor c=0.00597439f //x=63.95 //y=7.585
c1513 ( 1073 0 ) capacitor c=0.00597439f //x=63.07 //y=7.585
c1514 ( 1072 0 ) capacitor c=0.145673f //x=62.28 //y=7.585
c1515 ( 1071 0 ) capacitor c=0.00597439f //x=61.2 //y=7.585
c1516 ( 1070 0 ) capacitor c=0.00597439f //x=60.32 //y=7.585
c1517 ( 1069 0 ) capacitor c=0.00597439f //x=59.44 //y=7.585
c1518 ( 1068 0 ) capacitor c=0.00597439f //x=58.58 //y=7.58
c1519 ( 1066 0 ) capacitor c=0.162199f //x=57.47 //y=7.585
c1520 ( 1065 0 ) capacitor c=0.00597439f //x=56.39 //y=7.585
c1521 ( 1064 0 ) capacitor c=0.00597439f //x=55.51 //y=7.585
c1522 ( 1063 0 ) capacitor c=0.00597439f //x=54.63 //y=7.585
c1523 ( 1062 0 ) capacitor c=0.00597439f //x=53.77 //y=7.58
c1524 ( 1060 0 ) capacitor c=0.14448f //x=52.66 //y=7.585
c1525 ( 1059 0 ) capacitor c=0.00597439f //x=51.88 //y=7.585
c1526 ( 1058 0 ) capacitor c=0.00597439f //x=51 //y=7.585
c1527 ( 1057 0 ) capacitor c=0.00597439f //x=50.07 //y=7.58
c1528 ( 1055 0 ) capacitor c=0.145933f //x=49.33 //y=7.585
c1529 ( 1054 0 ) capacitor c=0.00597439f //x=48.25 //y=7.585
c1530 ( 1053 0 ) capacitor c=0.00597439f //x=47.37 //y=7.585
c1531 ( 1052 0 ) capacitor c=0.00597439f //x=46.49 //y=7.585
c1532 ( 1051 0 ) capacitor c=0.00597439f //x=45.61 //y=7.585
c1533 ( 1050 0 ) capacitor c=0.144432f //x=44.52 //y=7.585
c1534 ( 1049 0 ) capacitor c=0.00597439f //x=43.78 //y=7.58
c1535 ( 1047 0 ) capacitor c=0.00597439f //x=42.86 //y=7.585
c1536 ( 1046 0 ) capacitor c=0.00597439f //x=41.98 //y=7.585
c1537 ( 1045 0 ) capacitor c=0.126123f //x=41.19 //y=7.585
c1538 ( 1044 0 ) capacitor c=0.00597439f //x=40.41 //y=7.585
c1539 ( 1043 0 ) capacitor c=0.00597439f //x=39.53 //y=7.585
c1540 ( 1042 0 ) capacitor c=0.00597439f //x=38.65 //y=7.585
c1541 ( 1041 0 ) capacitor c=0.145673f //x=37.86 //y=7.585
c1542 ( 1040 0 ) capacitor c=0.00597439f //x=36.78 //y=7.585
c1543 ( 1039 0 ) capacitor c=0.00597439f //x=35.9 //y=7.585
c1544 ( 1038 0 ) capacitor c=0.00597439f //x=35.02 //y=7.585
c1545 ( 1037 0 ) capacitor c=0.00597439f //x=34.16 //y=7.58
c1546 ( 1035 0 ) capacitor c=0.162199f //x=33.05 //y=7.585
c1547 ( 1034 0 ) capacitor c=0.00597439f //x=31.97 //y=7.585
c1548 ( 1033 0 ) capacitor c=0.00597439f //x=31.09 //y=7.585
c1549 ( 1032 0 ) capacitor c=0.00597439f //x=30.21 //y=7.585
c1550 ( 1031 0 ) capacitor c=0.00597439f //x=29.35 //y=7.58
c1551 ( 1029 0 ) capacitor c=0.14448f //x=28.24 //y=7.585
c1552 ( 1028 0 ) capacitor c=0.00597439f //x=27.46 //y=7.585
c1553 ( 1027 0 ) capacitor c=0.00597439f //x=26.58 //y=7.585
c1554 ( 1026 0 ) capacitor c=0.00597439f //x=25.65 //y=7.58
c1555 ( 1024 0 ) capacitor c=0.146977f //x=24.91 //y=7.585
c1556 ( 1023 0 ) capacitor c=0.00597439f //x=23.83 //y=7.585
c1557 ( 1022 0 ) capacitor c=0.00597439f //x=22.95 //y=7.585
c1558 ( 1021 0 ) capacitor c=0.00597439f //x=22.07 //y=7.585
c1559 ( 1020 0 ) capacitor c=0.00597439f //x=21.19 //y=7.585
c1560 ( 1019 0 ) capacitor c=0.142863f //x=20.1 //y=7.585
c1561 ( 1018 0 ) capacitor c=0.00597439f //x=19.36 //y=7.58
c1562 ( 1016 0 ) capacitor c=0.00597439f //x=18.44 //y=7.585
c1563 ( 1015 0 ) capacitor c=0.00597439f //x=17.56 //y=7.585
c1564 ( 1014 0 ) capacitor c=0.126123f //x=16.77 //y=7.585
c1565 ( 1013 0 ) capacitor c=0.00597439f //x=15.99 //y=7.585
c1566 ( 1012 0 ) capacitor c=0.00597439f //x=15.11 //y=7.585
c1567 ( 1011 0 ) capacitor c=0.00597439f //x=14.23 //y=7.585
c1568 ( 1010 0 ) capacitor c=0.145673f //x=13.44 //y=7.585
c1569 ( 1009 0 ) capacitor c=0.00597439f //x=12.36 //y=7.585
c1570 ( 1008 0 ) capacitor c=0.00597439f //x=11.48 //y=7.585
c1571 ( 1007 0 ) capacitor c=0.00597439f //x=10.6 //y=7.585
c1572 ( 1006 0 ) capacitor c=0.00597439f //x=9.74 //y=7.58
c1573 ( 1004 0 ) capacitor c=0.162199f //x=8.63 //y=7.585
c1574 ( 1003 0 ) capacitor c=0.00597439f //x=7.55 //y=7.585
c1575 ( 1002 0 ) capacitor c=0.00597439f //x=6.67 //y=7.585
c1576 ( 1001 0 ) capacitor c=0.00597439f //x=5.79 //y=7.585
c1577 ( 1000 0 ) capacitor c=0.00597439f //x=4.93 //y=7.58
c1578 ( 998 0 ) capacitor c=0.14484f //x=3.82 //y=7.585
c1579 ( 997 0 ) capacitor c=0.00597439f //x=3.04 //y=7.585
c1580 ( 996 0 ) capacitor c=0.00597439f //x=2.16 //y=7.585
c1581 ( 995 0 ) capacitor c=0.27142f //x=1.23 //y=7.58
c1582 ( 980 0 ) capacitor c=0.0290604f //x=85.21 //y=7.585
c1583 ( 970 0 ) capacitor c=0.021306f //x=84.33 //y=7.585
c1584 ( 960 0 ) capacitor c=0.134506f //x=83.57 //y=7.585
c1585 ( 952 0 ) capacitor c=0.131873f //x=80.24 //y=7.585
c1586 ( 917 0 ) capacitor c=0.133054f //x=76.91 //y=7.585
c1587 ( 911 0 ) capacitor c=0.0429023f //x=73.58 //y=7.585
c1588 ( 901 0 ) capacitor c=0.0288858f //x=72.585 //y=7.585
c1589 ( 893 0 ) capacitor c=0.0289326f //x=71.705 //y=7.585
c1590 ( 883 0 ) capacitor c=0.029042f //x=70.825 //y=7.585
c1591 ( 871 0 ) capacitor c=0.0387402f //x=69.945 //y=7.585
c1592 ( 867 0 ) capacitor c=0.0238235f //x=68.77 //y=7.585
c1593 ( 859 0 ) capacitor c=0.0287377f //x=68.075 //y=7.585
c1594 ( 849 0 ) capacitor c=0.0291726f //x=67.195 //y=7.585
c1595 ( 837 0 ) capacitor c=0.0283511f //x=66.315 //y=7.585
c1596 ( 833 0 ) capacitor c=0.0277785f //x=65.44 //y=7.585
c1597 ( 823 0 ) capacitor c=0.0287377f //x=64.745 //y=7.585
c1598 ( 813 0 ) capacitor c=0.0291078f //x=63.865 //y=7.585
c1599 ( 803 0 ) capacitor c=0.0283511f //x=62.985 //y=7.585
c1600 ( 797 0 ) capacitor c=0.042257f //x=62.11 //y=7.585
c1601 ( 787 0 ) capacitor c=0.0288858f //x=61.115 //y=7.585
c1602 ( 777 0 ) capacitor c=0.0289326f //x=60.235 //y=7.585
c1603 ( 769 0 ) capacitor c=0.0290299f //x=59.355 //y=7.585
c1604 ( 759 0 ) capacitor c=0.0455283f //x=58.475 //y=7.585
c1605 ( 753 0 ) capacitor c=0.041708f //x=57.3 //y=7.585
c1606 ( 743 0 ) capacitor c=0.0288858f //x=56.305 //y=7.585
c1607 ( 733 0 ) capacitor c=0.0288437f //x=55.425 //y=7.585
c1608 ( 725 0 ) capacitor c=0.0290299f //x=54.545 //y=7.585
c1609 ( 715 0 ) capacitor c=0.0455283f //x=53.665 //y=7.585
c1610 ( 709 0 ) capacitor c=0.0277785f //x=52.49 //y=7.585
c1611 ( 699 0 ) capacitor c=0.0287376f //x=51.795 //y=7.585
c1612 ( 691 0 ) capacitor c=0.0291078f //x=50.915 //y=7.585
c1613 ( 681 0 ) capacitor c=0.0283511f //x=50.035 //y=7.585
c1614 ( 675 0 ) capacitor c=0.0428776f //x=49.16 //y=7.585
c1615 ( 665 0 ) capacitor c=0.0288858f //x=48.165 //y=7.585
c1616 ( 657 0 ) capacitor c=0.0289326f //x=47.285 //y=7.585
c1617 ( 647 0 ) capacitor c=0.0290299f //x=46.405 //y=7.585
c1618 ( 635 0 ) capacitor c=0.0455283f //x=45.525 //y=7.585
c1619 ( 631 0 ) capacitor c=0.0277785f //x=44.35 //y=7.585
c1620 ( 623 0 ) capacitor c=0.0287376f //x=43.655 //y=7.585
c1621 ( 613 0 ) capacitor c=0.0291726f //x=42.775 //y=7.585
c1622 ( 601 0 ) capacitor c=0.0283511f //x=41.895 //y=7.585
c1623 ( 597 0 ) capacitor c=0.0277785f //x=41.02 //y=7.585
c1624 ( 587 0 ) capacitor c=0.0287377f //x=40.325 //y=7.585
c1625 ( 577 0 ) capacitor c=0.0291078f //x=39.445 //y=7.585
c1626 ( 567 0 ) capacitor c=0.0283511f //x=38.565 //y=7.585
c1627 ( 561 0 ) capacitor c=0.042257f //x=37.69 //y=7.585
c1628 ( 551 0 ) capacitor c=0.0288858f //x=36.695 //y=7.585
c1629 ( 541 0 ) capacitor c=0.0289326f //x=35.815 //y=7.585
c1630 ( 533 0 ) capacitor c=0.0290299f //x=34.935 //y=7.585
c1631 ( 523 0 ) capacitor c=0.0455283f //x=34.055 //y=7.585
c1632 ( 517 0 ) capacitor c=0.041708f //x=32.88 //y=7.585
c1633 ( 507 0 ) capacitor c=0.0288858f //x=31.885 //y=7.585
c1634 ( 497 0 ) capacitor c=0.0288437f //x=31.005 //y=7.585
c1635 ( 489 0 ) capacitor c=0.0290299f //x=30.125 //y=7.585
c1636 ( 479 0 ) capacitor c=0.0455283f //x=29.245 //y=7.585
c1637 ( 473 0 ) capacitor c=0.0277785f //x=28.07 //y=7.585
c1638 ( 463 0 ) capacitor c=0.0287376f //x=27.375 //y=7.585
c1639 ( 455 0 ) capacitor c=0.0291078f //x=26.495 //y=7.585
c1640 ( 445 0 ) capacitor c=0.0283511f //x=25.615 //y=7.585
c1641 ( 439 0 ) capacitor c=0.042257f //x=24.74 //y=7.585
c1642 ( 429 0 ) capacitor c=0.0288858f //x=23.745 //y=7.585
c1643 ( 421 0 ) capacitor c=0.0289326f //x=22.865 //y=7.585
c1644 ( 411 0 ) capacitor c=0.0290745f //x=21.985 //y=7.585
c1645 ( 399 0 ) capacitor c=0.0445047f //x=21.105 //y=7.585
c1646 ( 395 0 ) capacitor c=0.0261965f //x=19.93 //y=7.585
c1647 ( 387 0 ) capacitor c=0.0287375f //x=19.235 //y=7.585
c1648 ( 377 0 ) capacitor c=0.0291726f //x=18.355 //y=7.585
c1649 ( 365 0 ) capacitor c=0.0283511f //x=17.475 //y=7.585
c1650 ( 361 0 ) capacitor c=0.0277785f //x=16.6 //y=7.585
c1651 ( 351 0 ) capacitor c=0.0287377f //x=15.905 //y=7.585
c1652 ( 341 0 ) capacitor c=0.0291078f //x=15.025 //y=7.585
c1653 ( 331 0 ) capacitor c=0.0283511f //x=14.145 //y=7.585
c1654 ( 325 0 ) capacitor c=0.042257f //x=13.27 //y=7.585
c1655 ( 315 0 ) capacitor c=0.0288858f //x=12.275 //y=7.585
c1656 ( 305 0 ) capacitor c=0.0289326f //x=11.395 //y=7.585
c1657 ( 297 0 ) capacitor c=0.0290299f //x=10.515 //y=7.585
c1658 ( 287 0 ) capacitor c=0.0455283f //x=9.635 //y=7.585
c1659 ( 281 0 ) capacitor c=0.041708f //x=8.46 //y=7.585
c1660 ( 271 0 ) capacitor c=0.0288858f //x=7.465 //y=7.585
c1661 ( 261 0 ) capacitor c=0.0288437f //x=6.585 //y=7.585
c1662 ( 253 0 ) capacitor c=0.0290299f //x=5.705 //y=7.585
c1663 ( 243 0 ) capacitor c=0.0455283f //x=4.825 //y=7.585
c1664 ( 237 0 ) capacitor c=0.0277785f //x=3.65 //y=7.585
c1665 ( 227 0 ) capacitor c=0.0287376f //x=2.955 //y=7.585
c1666 ( 219 0 ) capacitor c=0.0291078f //x=2.075 //y=7.585
c1667 ( 200 0 ) capacitor c=0.00499323f //x=76.3 //y=7.585
c1668 ( 197 0 ) capacitor c=0.00499323f //x=75.42 //y=7.585
c1669 ( 192 0 ) capacitor c=0.00499323f //x=74.49 //y=7.58
c1670 ( 153 0 ) capacitor c=0.348083f //x=85.22 //y=7.58
c1671 ( 136 0 ) capacitor c=0.00657976f //x=76.3 //y=7.41
c1672 ( 135 0 ) capacitor c=0.00827249f //x=76.3 //y=7.035
c1673 ( 131 0 ) capacitor c=0.0220779f //x=76.215 //y=7.585
c1674 ( 130 0 ) capacitor c=0.00369726f //x=75.42 //y=7.41
c1675 ( 129 0 ) capacitor c=0.00650208f //x=75.42 //y=7.035
c1676 ( 127 0 ) capacitor c=0.02242f //x=75.335 //y=7.585
c1677 ( 126 0 ) capacitor c=0.0090067f //x=74.54 //y=7.41
c1678 ( 125 0 ) capacitor c=0.0125184f //x=74.54 //y=7.035
c1679 ( 2 0 ) capacitor c=2.661f //x=74.455 //y=7.585
r1680 (  982 1093 ) resistor r=4.23183 //w=0.7 //l=0.175 //layer=li \
 //thickness=0.1 //x=85.295 //y=7.41 //x2=85.295 //y2=7.585
r1681 (  982 1161 ) resistor r=56.4706 //w=0.187 //l=0.825 //layer=li \
 //thickness=0.1 //x=85.295 //y=7.41 //x2=85.295 //y2=6.585
r1682 (  981 1091 ) resistor r=2.87058 //w=0.35 //l=0.085 //layer=li \
 //thickness=0.1 //x=84.5 //y=7.585 //x2=84.415 //y2=7.585
r1683 (  980 1093 ) resistor r=2.87058 //w=0.35 //l=0.085 //layer=li \
 //thickness=0.1 //x=85.21 //y=7.585 //x2=85.295 //y2=7.585
r1684 (  980 981 ) resistor r=24.7629 //w=0.367 //l=0.71 //layer=li \
 //thickness=0.1 //x=85.21 //y=7.585 //x2=84.5 //y2=7.585
r1685 (  972 1091 ) resistor r=4.23183 //w=0.7 //l=0.175 //layer=li \
 //thickness=0.1 //x=84.415 //y=7.41 //x2=84.415 //y2=7.585
r1686 (  972 1160 ) resistor r=56.4706 //w=0.187 //l=0.825 //layer=li \
 //thickness=0.1 //x=84.415 //y=7.41 //x2=84.415 //y2=6.585
r1687 (  971 1089 ) resistor r=5.29055 //w=0.35 //l=0.17 //layer=li \
 //thickness=0.1 //x=83.91 //y=7.585 //x2=83.74 //y2=7.585
r1688 (  970 1091 ) resistor r=2.87058 //w=0.35 //l=0.085 //layer=li \
 //thickness=0.1 //x=84.33 //y=7.585 //x2=84.415 //y2=7.585
r1689 (  970 971 ) resistor r=14.6485 //w=0.367 //l=0.42 //layer=li \
 //thickness=0.1 //x=84.33 //y=7.585 //x2=83.91 //y2=7.585
r1690 (  965 967 ) resistor r=38.7139 //w=0.367 //l=1.11 //layer=li \
 //thickness=0.1 //x=81.89 //y=7.585 //x2=83 //y2=7.585
r1691 (  963 965 ) resistor r=38.7139 //w=0.367 //l=1.11 //layer=li \
 //thickness=0.1 //x=80.78 //y=7.585 //x2=81.89 //y2=7.585
r1692 (  961 1088 ) resistor r=5.29055 //w=0.35 //l=0.17 //layer=li \
 //thickness=0.1 //x=80.58 //y=7.585 //x2=80.41 //y2=7.585
r1693 (  961 963 ) resistor r=6.97548 //w=0.367 //l=0.2 //layer=li \
 //thickness=0.1 //x=80.58 //y=7.585 //x2=80.78 //y2=7.585
r1694 (  960 1089 ) resistor r=5.29055 //w=0.35 //l=0.17 //layer=li \
 //thickness=0.1 //x=83.57 //y=7.585 //x2=83.74 //y2=7.585
r1695 (  960 967 ) resistor r=19.8801 //w=0.367 //l=0.57 //layer=li \
 //thickness=0.1 //x=83.57 //y=7.585 //x2=83 //y2=7.585
r1696 (  955 957 ) resistor r=38.7139 //w=0.367 //l=1.11 //layer=li \
 //thickness=0.1 //x=78.19 //y=7.585 //x2=79.3 //y2=7.585
r1697 (  953 1087 ) resistor r=5.29055 //w=0.35 //l=0.17 //layer=li \
 //thickness=0.1 //x=77.25 //y=7.585 //x2=77.08 //y2=7.585
r1698 (  953 955 ) resistor r=32.7847 //w=0.367 //l=0.94 //layer=li \
 //thickness=0.1 //x=77.25 //y=7.585 //x2=78.19 //y2=7.585
r1699 (  952 1088 ) resistor r=5.29055 //w=0.35 //l=0.17 //layer=li \
 //thickness=0.1 //x=80.24 //y=7.585 //x2=80.41 //y2=7.585
r1700 (  952 957 ) resistor r=32.7847 //w=0.367 //l=0.94 //layer=li \
 //thickness=0.1 //x=80.24 //y=7.585 //x2=79.3 //y2=7.585
r1701 (  948 1159 ) resistor r=23.2727 //w=0.187 //l=0.34 //layer=li \
 //thickness=0.1 //x=76.3 //y=6.92 //x2=76.3 //y2=6.58
r1702 (  933 1157 ) resistor r=23.2727 //w=0.187 //l=0.34 //layer=li \
 //thickness=0.1 //x=74.54 //y=6.92 //x2=74.54 //y2=6.58
r1703 (  922 924 ) resistor r=38.7139 //w=0.367 //l=1.11 //layer=li \
 //thickness=0.1 //x=75.6 //y=7.585 //x2=76.71 //y2=7.585
r1704 (  920 922 ) resistor r=38.7139 //w=0.367 //l=1.11 //layer=li \
 //thickness=0.1 //x=74.49 //y=7.585 //x2=75.6 //y2=7.585
r1705 (  918 1086 ) resistor r=5.29055 //w=0.35 //l=0.17 //layer=li \
 //thickness=0.1 //x=73.92 //y=7.585 //x2=73.75 //y2=7.585
r1706 (  918 920 ) resistor r=19.8801 //w=0.367 //l=0.57 //layer=li \
 //thickness=0.1 //x=73.92 //y=7.585 //x2=74.49 //y2=7.585
r1707 (  917 1087 ) resistor r=5.29055 //w=0.35 //l=0.17 //layer=li \
 //thickness=0.1 //x=76.91 //y=7.585 //x2=77.08 //y2=7.585
r1708 (  917 924 ) resistor r=6.97548 //w=0.367 //l=0.2 //layer=li \
 //thickness=0.1 //x=76.91 //y=7.585 //x2=76.71 //y2=7.585
r1709 (  912 1085 ) resistor r=2.87058 //w=0.35 //l=0.085 //layer=li \
 //thickness=0.1 //x=72.755 //y=7.585 //x2=72.67 //y2=7.585
r1710 (  912 914 ) resistor r=8.89373 //w=0.367 //l=0.255 //layer=li \
 //thickness=0.1 //x=72.755 //y=7.585 //x2=73.01 //y2=7.585
r1711 (  911 1086 ) resistor r=5.29055 //w=0.35 //l=0.17 //layer=li \
 //thickness=0.1 //x=73.58 //y=7.585 //x2=73.75 //y2=7.585
r1712 (  911 914 ) resistor r=19.8801 //w=0.367 //l=0.57 //layer=li \
 //thickness=0.1 //x=73.58 //y=7.585 //x2=73.01 //y2=7.585
r1713 (  905 1085 ) resistor r=4.23183 //w=0.7 //l=0.175 //layer=li \
 //thickness=0.1 //x=72.67 //y=7.41 //x2=72.67 //y2=7.585
r1714 (  905 1156 ) resistor r=33.1979 //w=0.187 //l=0.485 //layer=li \
 //thickness=0.1 //x=72.67 //y=7.41 //x2=72.67 //y2=6.925
r1715 (  902 1084 ) resistor r=2.87058 //w=0.35 //l=0.085 //layer=li \
 //thickness=0.1 //x=71.875 //y=7.585 //x2=71.79 //y2=7.585
r1716 (  902 904 ) resistor r=0.871935 //w=0.367 //l=0.025 //layer=li \
 //thickness=0.1 //x=71.875 //y=7.585 //x2=71.9 //y2=7.585
r1717 (  901 1085 ) resistor r=2.87058 //w=0.35 //l=0.085 //layer=li \
 //thickness=0.1 //x=72.585 //y=7.585 //x2=72.67 //y2=7.585
r1718 (  901 904 ) resistor r=23.891 //w=0.367 //l=0.685 //layer=li \
 //thickness=0.1 //x=72.585 //y=7.585 //x2=71.9 //y2=7.585
r1719 (  895 1084 ) resistor r=4.23183 //w=0.7 //l=0.175 //layer=li \
 //thickness=0.1 //x=71.79 //y=7.41 //x2=71.79 //y2=7.585
r1720 (  895 1155 ) resistor r=33.1979 //w=0.187 //l=0.485 //layer=li \
 //thickness=0.1 //x=71.79 //y=7.41 //x2=71.79 //y2=6.925
r1721 (  894 1083 ) resistor r=2.87058 //w=0.35 //l=0.085 //layer=li \
 //thickness=0.1 //x=70.995 //y=7.585 //x2=70.91 //y2=7.585
r1722 (  893 1084 ) resistor r=2.87058 //w=0.35 //l=0.085 //layer=li \
 //thickness=0.1 //x=71.705 //y=7.585 //x2=71.79 //y2=7.585
r1723 (  893 894 ) resistor r=24.7629 //w=0.367 //l=0.71 //layer=li \
 //thickness=0.1 //x=71.705 //y=7.585 //x2=70.995 //y2=7.585
r1724 (  887 1083 ) resistor r=4.23183 //w=0.7 //l=0.175 //layer=li \
 //thickness=0.1 //x=70.91 //y=7.41 //x2=70.91 //y2=7.585
r1725 (  887 1154 ) resistor r=33.1979 //w=0.187 //l=0.485 //layer=li \
 //thickness=0.1 //x=70.91 //y=7.41 //x2=70.91 //y2=6.925
r1726 (  884 1082 ) resistor r=2.87058 //w=0.35 //l=0.085 //layer=li \
 //thickness=0.1 //x=70.115 //y=7.585 //x2=70.03 //y2=7.585
r1727 (  884 886 ) resistor r=23.5422 //w=0.367 //l=0.675 //layer=li \
 //thickness=0.1 //x=70.115 //y=7.585 //x2=70.79 //y2=7.585
r1728 (  883 1083 ) resistor r=2.87058 //w=0.35 //l=0.085 //layer=li \
 //thickness=0.1 //x=70.825 //y=7.585 //x2=70.91 //y2=7.585
r1729 (  883 886 ) resistor r=1.22071 //w=0.367 //l=0.035 //layer=li \
 //thickness=0.1 //x=70.825 //y=7.585 //x2=70.79 //y2=7.585
r1730 (  875 1082 ) resistor r=4.23183 //w=0.7 //l=0.175 //layer=li \
 //thickness=0.1 //x=70.03 //y=7.41 //x2=70.03 //y2=7.585
r1731 (  875 1153 ) resistor r=56.4706 //w=0.187 //l=0.825 //layer=li \
 //thickness=0.1 //x=70.03 //y=7.41 //x2=70.03 //y2=6.585
r1732 (  872 1081 ) resistor r=5.29055 //w=0.35 //l=0.17 //layer=li \
 //thickness=0.1 //x=69.11 //y=7.585 //x2=68.94 //y2=7.585
r1733 (  872 874 ) resistor r=19.8801 //w=0.367 //l=0.57 //layer=li \
 //thickness=0.1 //x=69.11 //y=7.585 //x2=69.68 //y2=7.585
r1734 (  871 1082 ) resistor r=2.87058 //w=0.35 //l=0.085 //layer=li \
 //thickness=0.1 //x=69.945 //y=7.585 //x2=70.03 //y2=7.585
r1735 (  871 874 ) resistor r=9.24251 //w=0.367 //l=0.265 //layer=li \
 //thickness=0.1 //x=69.945 //y=7.585 //x2=69.68 //y2=7.585
r1736 (  868 1080 ) resistor r=2.87058 //w=0.35 //l=0.085 //layer=li \
 //thickness=0.1 //x=68.245 //y=7.585 //x2=68.16 //y2=7.585
r1737 (  867 1081 ) resistor r=5.29055 //w=0.35 //l=0.17 //layer=li \
 //thickness=0.1 //x=68.77 //y=7.585 //x2=68.94 //y2=7.585
r1738 (  867 868 ) resistor r=18.3106 //w=0.367 //l=0.525 //layer=li \
 //thickness=0.1 //x=68.77 //y=7.585 //x2=68.245 //y2=7.585
r1739 (  861 1080 ) resistor r=4.23183 //w=0.7 //l=0.175 //layer=li \
 //thickness=0.1 //x=68.16 //y=7.41 //x2=68.16 //y2=7.585
r1740 (  861 1152 ) resistor r=33.1979 //w=0.187 //l=0.485 //layer=li \
 //thickness=0.1 //x=68.16 //y=7.41 //x2=68.16 //y2=6.925
r1741 (  860 1078 ) resistor r=2.87058 //w=0.35 //l=0.085 //layer=li \
 //thickness=0.1 //x=67.365 //y=7.585 //x2=67.28 //y2=7.585
r1742 (  859 1080 ) resistor r=2.87058 //w=0.35 //l=0.085 //layer=li \
 //thickness=0.1 //x=68.075 //y=7.585 //x2=68.16 //y2=7.585
r1743 (  859 860 ) resistor r=24.7629 //w=0.367 //l=0.71 //layer=li \
 //thickness=0.1 //x=68.075 //y=7.585 //x2=67.365 //y2=7.585
r1744 (  853 1078 ) resistor r=4.23183 //w=0.7 //l=0.175 //layer=li \
 //thickness=0.1 //x=67.28 //y=7.41 //x2=67.28 //y2=7.585
r1745 (  853 1151 ) resistor r=33.1979 //w=0.187 //l=0.485 //layer=li \
 //thickness=0.1 //x=67.28 //y=7.41 //x2=67.28 //y2=6.925
r1746 (  850 1077 ) resistor r=2.87058 //w=0.35 //l=0.085 //layer=li \
 //thickness=0.1 //x=66.485 //y=7.585 //x2=66.4 //y2=7.585
r1747 (  850 852 ) resistor r=21.1008 //w=0.367 //l=0.605 //layer=li \
 //thickness=0.1 //x=66.485 //y=7.585 //x2=67.09 //y2=7.585
r1748 (  849 1078 ) resistor r=2.87058 //w=0.35 //l=0.085 //layer=li \
 //thickness=0.1 //x=67.195 //y=7.585 //x2=67.28 //y2=7.585
r1749 (  849 852 ) resistor r=3.66213 //w=0.367 //l=0.105 //layer=li \
 //thickness=0.1 //x=67.195 //y=7.585 //x2=67.09 //y2=7.585
r1750 (  841 1077 ) resistor r=4.23183 //w=0.7 //l=0.175 //layer=li \
 //thickness=0.1 //x=66.4 //y=7.41 //x2=66.4 //y2=7.585
r1751 (  841 1150 ) resistor r=56.4706 //w=0.187 //l=0.825 //layer=li \
 //thickness=0.1 //x=66.4 //y=7.41 //x2=66.4 //y2=6.585
r1752 (  838 1076 ) resistor r=5.29055 //w=0.35 //l=0.17 //layer=li \
 //thickness=0.1 //x=65.78 //y=7.585 //x2=65.61 //y2=7.585
r1753 (  838 840 ) resistor r=6.97548 //w=0.367 //l=0.2 //layer=li \
 //thickness=0.1 //x=65.78 //y=7.585 //x2=65.98 //y2=7.585
r1754 (  837 1077 ) resistor r=2.87058 //w=0.35 //l=0.085 //layer=li \
 //thickness=0.1 //x=66.315 //y=7.585 //x2=66.4 //y2=7.585
r1755 (  837 840 ) resistor r=11.6839 //w=0.367 //l=0.335 //layer=li \
 //thickness=0.1 //x=66.315 //y=7.585 //x2=65.98 //y2=7.585
r1756 (  834 1075 ) resistor r=2.87058 //w=0.35 //l=0.085 //layer=li \
 //thickness=0.1 //x=64.915 //y=7.585 //x2=64.83 //y2=7.585
r1757 (  833 1076 ) resistor r=5.29055 //w=0.35 //l=0.17 //layer=li \
 //thickness=0.1 //x=65.44 //y=7.585 //x2=65.61 //y2=7.585
r1758 (  833 834 ) resistor r=18.3106 //w=0.367 //l=0.525 //layer=li \
 //thickness=0.1 //x=65.44 //y=7.585 //x2=64.915 //y2=7.585
r1759 (  827 1075 ) resistor r=4.23183 //w=0.7 //l=0.175 //layer=li \
 //thickness=0.1 //x=64.83 //y=7.41 //x2=64.83 //y2=7.585
r1760 (  827 1149 ) resistor r=33.1979 //w=0.187 //l=0.485 //layer=li \
 //thickness=0.1 //x=64.83 //y=7.41 //x2=64.83 //y2=6.925
r1761 (  824 1074 ) resistor r=2.87058 //w=0.35 //l=0.085 //layer=li \
 //thickness=0.1 //x=64.035 //y=7.585 //x2=63.95 //y2=7.585
r1762 (  824 826 ) resistor r=16.218 //w=0.367 //l=0.465 //layer=li \
 //thickness=0.1 //x=64.035 //y=7.585 //x2=64.5 //y2=7.585
r1763 (  823 1075 ) resistor r=2.87058 //w=0.35 //l=0.085 //layer=li \
 //thickness=0.1 //x=64.745 //y=7.585 //x2=64.83 //y2=7.585
r1764 (  823 826 ) resistor r=8.54496 //w=0.367 //l=0.245 //layer=li \
 //thickness=0.1 //x=64.745 //y=7.585 //x2=64.5 //y2=7.585
r1765 (  817 1074 ) resistor r=4.23183 //w=0.7 //l=0.175 //layer=li \
 //thickness=0.1 //x=63.95 //y=7.41 //x2=63.95 //y2=7.585
r1766 (  817 1148 ) resistor r=33.1979 //w=0.187 //l=0.485 //layer=li \
 //thickness=0.1 //x=63.95 //y=7.41 //x2=63.95 //y2=6.925
r1767 (  814 1073 ) resistor r=2.87058 //w=0.35 //l=0.085 //layer=li \
 //thickness=0.1 //x=63.155 //y=7.585 //x2=63.07 //y2=7.585
r1768 (  814 816 ) resistor r=8.19619 //w=0.367 //l=0.235 //layer=li \
 //thickness=0.1 //x=63.155 //y=7.585 //x2=63.39 //y2=7.585
r1769 (  813 1074 ) resistor r=2.87058 //w=0.35 //l=0.085 //layer=li \
 //thickness=0.1 //x=63.865 //y=7.585 //x2=63.95 //y2=7.585
r1770 (  813 816 ) resistor r=16.5668 //w=0.367 //l=0.475 //layer=li \
 //thickness=0.1 //x=63.865 //y=7.585 //x2=63.39 //y2=7.585
r1771 (  805 1073 ) resistor r=4.23183 //w=0.7 //l=0.175 //layer=li \
 //thickness=0.1 //x=63.07 //y=7.41 //x2=63.07 //y2=7.585
r1772 (  805 1147 ) resistor r=56.4706 //w=0.187 //l=0.825 //layer=li \
 //thickness=0.1 //x=63.07 //y=7.41 //x2=63.07 //y2=6.585
r1773 (  804 1072 ) resistor r=5.29055 //w=0.35 //l=0.17 //layer=li \
 //thickness=0.1 //x=62.45 //y=7.585 //x2=62.28 //y2=7.585
r1774 (  803 1073 ) resistor r=2.87058 //w=0.35 //l=0.085 //layer=li \
 //thickness=0.1 //x=62.985 //y=7.585 //x2=63.07 //y2=7.585
r1775 (  803 804 ) resistor r=18.6594 //w=0.367 //l=0.535 //layer=li \
 //thickness=0.1 //x=62.985 //y=7.585 //x2=62.45 //y2=7.585
r1776 (  798 1071 ) resistor r=2.87058 //w=0.35 //l=0.085 //layer=li \
 //thickness=0.1 //x=61.285 //y=7.585 //x2=61.2 //y2=7.585
r1777 (  798 800 ) resistor r=21.7984 //w=0.367 //l=0.625 //layer=li \
 //thickness=0.1 //x=61.285 //y=7.585 //x2=61.91 //y2=7.585
r1778 (  797 1072 ) resistor r=5.29055 //w=0.35 //l=0.17 //layer=li \
 //thickness=0.1 //x=62.11 //y=7.585 //x2=62.28 //y2=7.585
r1779 (  797 800 ) resistor r=6.97548 //w=0.367 //l=0.2 //layer=li \
 //thickness=0.1 //x=62.11 //y=7.585 //x2=61.91 //y2=7.585
r1780 (  791 1071 ) resistor r=4.23183 //w=0.7 //l=0.175 //layer=li \
 //thickness=0.1 //x=61.2 //y=7.41 //x2=61.2 //y2=7.585
r1781 (  791 1146 ) resistor r=33.1979 //w=0.187 //l=0.485 //layer=li \
 //thickness=0.1 //x=61.2 //y=7.41 //x2=61.2 //y2=6.925
r1782 (  788 1070 ) resistor r=2.87058 //w=0.35 //l=0.085 //layer=li \
 //thickness=0.1 //x=60.405 //y=7.585 //x2=60.32 //y2=7.585
r1783 (  788 790 ) resistor r=13.7766 //w=0.367 //l=0.395 //layer=li \
 //thickness=0.1 //x=60.405 //y=7.585 //x2=60.8 //y2=7.585
r1784 (  787 1071 ) resistor r=2.87058 //w=0.35 //l=0.085 //layer=li \
 //thickness=0.1 //x=61.115 //y=7.585 //x2=61.2 //y2=7.585
r1785 (  787 790 ) resistor r=10.9864 //w=0.367 //l=0.315 //layer=li \
 //thickness=0.1 //x=61.115 //y=7.585 //x2=60.8 //y2=7.585
r1786 (  781 1070 ) resistor r=4.23183 //w=0.7 //l=0.175 //layer=li \
 //thickness=0.1 //x=60.32 //y=7.41 //x2=60.32 //y2=7.585
r1787 (  781 1145 ) resistor r=33.1979 //w=0.187 //l=0.485 //layer=li \
 //thickness=0.1 //x=60.32 //y=7.41 //x2=60.32 //y2=6.925
r1788 (  778 1069 ) resistor r=2.87058 //w=0.35 //l=0.085 //layer=li \
 //thickness=0.1 //x=59.525 //y=7.585 //x2=59.44 //y2=7.585
r1789 (  778 780 ) resistor r=5.75477 //w=0.367 //l=0.165 //layer=li \
 //thickness=0.1 //x=59.525 //y=7.585 //x2=59.69 //y2=7.585
r1790 (  777 1070 ) resistor r=2.87058 //w=0.35 //l=0.085 //layer=li \
 //thickness=0.1 //x=60.235 //y=7.585 //x2=60.32 //y2=7.585
r1791 (  777 780 ) resistor r=19.0082 //w=0.367 //l=0.545 //layer=li \
 //thickness=0.1 //x=60.235 //y=7.585 //x2=59.69 //y2=7.585
r1792 (  771 1069 ) resistor r=4.23183 //w=0.7 //l=0.175 //layer=li \
 //thickness=0.1 //x=59.44 //y=7.41 //x2=59.44 //y2=7.585
r1793 (  771 1144 ) resistor r=33.1979 //w=0.187 //l=0.485 //layer=li \
 //thickness=0.1 //x=59.44 //y=7.41 //x2=59.44 //y2=6.925
r1794 (  770 1068 ) resistor r=2.87058 //w=0.35 //l=0.085 //layer=li \
 //thickness=0.1 //x=58.645 //y=7.585 //x2=58.56 //y2=7.585
r1795 (  769 1069 ) resistor r=2.87058 //w=0.35 //l=0.085 //layer=li \
 //thickness=0.1 //x=59.355 //y=7.585 //x2=59.44 //y2=7.585
r1796 (  769 770 ) resistor r=24.7629 //w=0.367 //l=0.71 //layer=li \
 //thickness=0.1 //x=59.355 //y=7.585 //x2=58.645 //y2=7.585
r1797 (  761 1068 ) resistor r=4.23183 //w=0.7 //l=0.175 //layer=li \
 //thickness=0.1 //x=58.56 //y=7.41 //x2=58.56 //y2=7.585
r1798 (  761 1143 ) resistor r=56.4706 //w=0.187 //l=0.825 //layer=li \
 //thickness=0.1 //x=58.56 //y=7.41 //x2=58.56 //y2=6.585
r1799 (  760 1066 ) resistor r=5.29055 //w=0.35 //l=0.17 //layer=li \
 //thickness=0.1 //x=57.64 //y=7.585 //x2=57.47 //y2=7.585
r1800 (  759 1068 ) resistor r=2.87058 //w=0.35 //l=0.085 //layer=li \
 //thickness=0.1 //x=58.475 //y=7.585 //x2=58.56 //y2=7.585
r1801 (  759 760 ) resistor r=29.1226 //w=0.367 //l=0.835 //layer=li \
 //thickness=0.1 //x=58.475 //y=7.585 //x2=57.64 //y2=7.585
r1802 (  754 1065 ) resistor r=2.87058 //w=0.35 //l=0.085 //layer=li \
 //thickness=0.1 //x=56.475 //y=7.585 //x2=56.39 //y2=7.585
r1803 (  754 756 ) resistor r=21.7984 //w=0.367 //l=0.625 //layer=li \
 //thickness=0.1 //x=56.475 //y=7.585 //x2=57.1 //y2=7.585
r1804 (  753 1066 ) resistor r=5.29055 //w=0.35 //l=0.17 //layer=li \
 //thickness=0.1 //x=57.3 //y=7.585 //x2=57.47 //y2=7.585
r1805 (  753 756 ) resistor r=6.97548 //w=0.367 //l=0.2 //layer=li \
 //thickness=0.1 //x=57.3 //y=7.585 //x2=57.1 //y2=7.585
r1806 (  747 1065 ) resistor r=4.23183 //w=0.7 //l=0.175 //layer=li \
 //thickness=0.1 //x=56.39 //y=7.41 //x2=56.39 //y2=7.585
r1807 (  747 1142 ) resistor r=33.1979 //w=0.187 //l=0.485 //layer=li \
 //thickness=0.1 //x=56.39 //y=7.41 //x2=56.39 //y2=6.925
r1808 (  744 1064 ) resistor r=2.87058 //w=0.35 //l=0.085 //layer=li \
 //thickness=0.1 //x=55.595 //y=7.585 //x2=55.51 //y2=7.585
r1809 (  744 746 ) resistor r=13.7766 //w=0.367 //l=0.395 //layer=li \
 //thickness=0.1 //x=55.595 //y=7.585 //x2=55.99 //y2=7.585
r1810 (  743 1065 ) resistor r=2.87058 //w=0.35 //l=0.085 //layer=li \
 //thickness=0.1 //x=56.305 //y=7.585 //x2=56.39 //y2=7.585
r1811 (  743 746 ) resistor r=10.9864 //w=0.367 //l=0.315 //layer=li \
 //thickness=0.1 //x=56.305 //y=7.585 //x2=55.99 //y2=7.585
r1812 (  737 1064 ) resistor r=4.23183 //w=0.7 //l=0.175 //layer=li \
 //thickness=0.1 //x=55.51 //y=7.41 //x2=55.51 //y2=7.585
r1813 (  737 1141 ) resistor r=33.1979 //w=0.187 //l=0.485 //layer=li \
 //thickness=0.1 //x=55.51 //y=7.41 //x2=55.51 //y2=6.925
r1814 (  734 1063 ) resistor r=2.87058 //w=0.35 //l=0.085 //layer=li \
 //thickness=0.1 //x=54.715 //y=7.585 //x2=54.63 //y2=7.585
r1815 (  734 736 ) resistor r=5.75477 //w=0.367 //l=0.165 //layer=li \
 //thickness=0.1 //x=54.715 //y=7.585 //x2=54.88 //y2=7.585
r1816 (  733 1064 ) resistor r=2.87058 //w=0.35 //l=0.085 //layer=li \
 //thickness=0.1 //x=55.425 //y=7.585 //x2=55.51 //y2=7.585
r1817 (  733 736 ) resistor r=19.0082 //w=0.367 //l=0.545 //layer=li \
 //thickness=0.1 //x=55.425 //y=7.585 //x2=54.88 //y2=7.585
r1818 (  727 1063 ) resistor r=4.23183 //w=0.7 //l=0.175 //layer=li \
 //thickness=0.1 //x=54.63 //y=7.41 //x2=54.63 //y2=7.585
r1819 (  727 1140 ) resistor r=33.1979 //w=0.187 //l=0.485 //layer=li \
 //thickness=0.1 //x=54.63 //y=7.41 //x2=54.63 //y2=6.925
r1820 (  726 1062 ) resistor r=2.87058 //w=0.35 //l=0.085 //layer=li \
 //thickness=0.1 //x=53.835 //y=7.585 //x2=53.75 //y2=7.585
r1821 (  725 1063 ) resistor r=2.87058 //w=0.35 //l=0.085 //layer=li \
 //thickness=0.1 //x=54.545 //y=7.585 //x2=54.63 //y2=7.585
r1822 (  725 726 ) resistor r=24.7629 //w=0.367 //l=0.71 //layer=li \
 //thickness=0.1 //x=54.545 //y=7.585 //x2=53.835 //y2=7.585
r1823 (  717 1062 ) resistor r=4.23183 //w=0.7 //l=0.175 //layer=li \
 //thickness=0.1 //x=53.75 //y=7.41 //x2=53.75 //y2=7.585
r1824 (  717 1139 ) resistor r=56.4706 //w=0.187 //l=0.825 //layer=li \
 //thickness=0.1 //x=53.75 //y=7.41 //x2=53.75 //y2=6.585
r1825 (  716 1060 ) resistor r=5.29055 //w=0.35 //l=0.17 //layer=li \
 //thickness=0.1 //x=52.83 //y=7.585 //x2=52.66 //y2=7.585
r1826 (  715 1062 ) resistor r=2.87058 //w=0.35 //l=0.085 //layer=li \
 //thickness=0.1 //x=53.665 //y=7.585 //x2=53.75 //y2=7.585
r1827 (  715 716 ) resistor r=29.1226 //w=0.367 //l=0.835 //layer=li \
 //thickness=0.1 //x=53.665 //y=7.585 //x2=52.83 //y2=7.585
r1828 (  710 1059 ) resistor r=2.87058 //w=0.35 //l=0.085 //layer=li \
 //thickness=0.1 //x=51.965 //y=7.585 //x2=51.88 //y2=7.585
r1829 (  710 712 ) resistor r=11.3351 //w=0.367 //l=0.325 //layer=li \
 //thickness=0.1 //x=51.965 //y=7.585 //x2=52.29 //y2=7.585
r1830 (  709 1060 ) resistor r=5.29055 //w=0.35 //l=0.17 //layer=li \
 //thickness=0.1 //x=52.49 //y=7.585 //x2=52.66 //y2=7.585
r1831 (  709 712 ) resistor r=6.97548 //w=0.367 //l=0.2 //layer=li \
 //thickness=0.1 //x=52.49 //y=7.585 //x2=52.29 //y2=7.585
r1832 (  703 1059 ) resistor r=4.23183 //w=0.7 //l=0.175 //layer=li \
 //thickness=0.1 //x=51.88 //y=7.41 //x2=51.88 //y2=7.585
r1833 (  703 1138 ) resistor r=33.1979 //w=0.187 //l=0.485 //layer=li \
 //thickness=0.1 //x=51.88 //y=7.41 //x2=51.88 //y2=6.925
r1834 (  700 1058 ) resistor r=2.87058 //w=0.35 //l=0.085 //layer=li \
 //thickness=0.1 //x=51.085 //y=7.585 //x2=51 //y2=7.585
r1835 (  700 702 ) resistor r=3.31335 //w=0.367 //l=0.095 //layer=li \
 //thickness=0.1 //x=51.085 //y=7.585 //x2=51.18 //y2=7.585
r1836 (  699 1059 ) resistor r=2.87058 //w=0.35 //l=0.085 //layer=li \
 //thickness=0.1 //x=51.795 //y=7.585 //x2=51.88 //y2=7.585
r1837 (  699 702 ) resistor r=21.4496 //w=0.367 //l=0.615 //layer=li \
 //thickness=0.1 //x=51.795 //y=7.585 //x2=51.18 //y2=7.585
r1838 (  693 1058 ) resistor r=4.23183 //w=0.7 //l=0.175 //layer=li \
 //thickness=0.1 //x=51 //y=7.41 //x2=51 //y2=7.585
r1839 (  693 1137 ) resistor r=33.1979 //w=0.187 //l=0.485 //layer=li \
 //thickness=0.1 //x=51 //y=7.41 //x2=51 //y2=6.925
r1840 (  692 1057 ) resistor r=2.87058 //w=0.35 //l=0.085 //layer=li \
 //thickness=0.1 //x=50.205 //y=7.585 //x2=50.12 //y2=7.585
r1841 (  691 1058 ) resistor r=2.87058 //w=0.35 //l=0.085 //layer=li \
 //thickness=0.1 //x=50.915 //y=7.585 //x2=51 //y2=7.585
r1842 (  691 692 ) resistor r=24.7629 //w=0.367 //l=0.71 //layer=li \
 //thickness=0.1 //x=50.915 //y=7.585 //x2=50.205 //y2=7.585
r1843 (  683 1057 ) resistor r=4.23183 //w=0.7 //l=0.175 //layer=li \
 //thickness=0.1 //x=50.12 //y=7.41 //x2=50.12 //y2=7.585
r1844 (  683 1136 ) resistor r=56.4706 //w=0.187 //l=0.825 //layer=li \
 //thickness=0.1 //x=50.12 //y=7.41 //x2=50.12 //y2=6.585
r1845 (  682 1055 ) resistor r=5.29055 //w=0.35 //l=0.17 //layer=li \
 //thickness=0.1 //x=49.5 //y=7.585 //x2=49.33 //y2=7.585
r1846 (  681 1057 ) resistor r=2.87058 //w=0.35 //l=0.085 //layer=li \
 //thickness=0.1 //x=50.035 //y=7.585 //x2=50.12 //y2=7.585
r1847 (  681 682 ) resistor r=18.6594 //w=0.367 //l=0.535 //layer=li \
 //thickness=0.1 //x=50.035 //y=7.585 //x2=49.5 //y2=7.585
r1848 (  676 1054 ) resistor r=2.87058 //w=0.35 //l=0.085 //layer=li \
 //thickness=0.1 //x=48.335 //y=7.585 //x2=48.25 //y2=7.585
r1849 (  676 678 ) resistor r=8.89373 //w=0.367 //l=0.255 //layer=li \
 //thickness=0.1 //x=48.335 //y=7.585 //x2=48.59 //y2=7.585
r1850 (  675 1055 ) resistor r=5.29055 //w=0.35 //l=0.17 //layer=li \
 //thickness=0.1 //x=49.16 //y=7.585 //x2=49.33 //y2=7.585
r1851 (  675 678 ) resistor r=19.8801 //w=0.367 //l=0.57 //layer=li \
 //thickness=0.1 //x=49.16 //y=7.585 //x2=48.59 //y2=7.585
r1852 (  669 1054 ) resistor r=4.23183 //w=0.7 //l=0.175 //layer=li \
 //thickness=0.1 //x=48.25 //y=7.41 //x2=48.25 //y2=7.585
r1853 (  669 1135 ) resistor r=33.1979 //w=0.187 //l=0.485 //layer=li \
 //thickness=0.1 //x=48.25 //y=7.41 //x2=48.25 //y2=6.925
r1854 (  666 1053 ) resistor r=2.87058 //w=0.35 //l=0.085 //layer=li \
 //thickness=0.1 //x=47.455 //y=7.585 //x2=47.37 //y2=7.585
r1855 (  666 668 ) resistor r=0.871935 //w=0.367 //l=0.025 //layer=li \
 //thickness=0.1 //x=47.455 //y=7.585 //x2=47.48 //y2=7.585
r1856 (  665 1054 ) resistor r=2.87058 //w=0.35 //l=0.085 //layer=li \
 //thickness=0.1 //x=48.165 //y=7.585 //x2=48.25 //y2=7.585
r1857 (  665 668 ) resistor r=23.891 //w=0.367 //l=0.685 //layer=li \
 //thickness=0.1 //x=48.165 //y=7.585 //x2=47.48 //y2=7.585
r1858 (  659 1053 ) resistor r=4.23183 //w=0.7 //l=0.175 //layer=li \
 //thickness=0.1 //x=47.37 //y=7.41 //x2=47.37 //y2=7.585
r1859 (  659 1134 ) resistor r=33.1979 //w=0.187 //l=0.485 //layer=li \
 //thickness=0.1 //x=47.37 //y=7.41 //x2=47.37 //y2=6.925
r1860 (  658 1052 ) resistor r=2.87058 //w=0.35 //l=0.085 //layer=li \
 //thickness=0.1 //x=46.575 //y=7.585 //x2=46.49 //y2=7.585
r1861 (  657 1053 ) resistor r=2.87058 //w=0.35 //l=0.085 //layer=li \
 //thickness=0.1 //x=47.285 //y=7.585 //x2=47.37 //y2=7.585
r1862 (  657 658 ) resistor r=24.7629 //w=0.367 //l=0.71 //layer=li \
 //thickness=0.1 //x=47.285 //y=7.585 //x2=46.575 //y2=7.585
r1863 (  651 1052 ) resistor r=4.23183 //w=0.7 //l=0.175 //layer=li \
 //thickness=0.1 //x=46.49 //y=7.41 //x2=46.49 //y2=7.585
r1864 (  651 1133 ) resistor r=33.1979 //w=0.187 //l=0.485 //layer=li \
 //thickness=0.1 //x=46.49 //y=7.41 //x2=46.49 //y2=6.925
r1865 (  648 1051 ) resistor r=2.87058 //w=0.35 //l=0.085 //layer=li \
 //thickness=0.1 //x=45.695 //y=7.585 //x2=45.61 //y2=7.585
r1866 (  648 650 ) resistor r=23.5422 //w=0.367 //l=0.675 //layer=li \
 //thickness=0.1 //x=45.695 //y=7.585 //x2=46.37 //y2=7.585
r1867 (  647 1052 ) resistor r=2.87058 //w=0.35 //l=0.085 //layer=li \
 //thickness=0.1 //x=46.405 //y=7.585 //x2=46.49 //y2=7.585
r1868 (  647 650 ) resistor r=1.22071 //w=0.367 //l=0.035 //layer=li \
 //thickness=0.1 //x=46.405 //y=7.585 //x2=46.37 //y2=7.585
r1869 (  639 1051 ) resistor r=4.23183 //w=0.7 //l=0.175 //layer=li \
 //thickness=0.1 //x=45.61 //y=7.41 //x2=45.61 //y2=7.585
r1870 (  639 1132 ) resistor r=56.4706 //w=0.187 //l=0.825 //layer=li \
 //thickness=0.1 //x=45.61 //y=7.41 //x2=45.61 //y2=6.585
r1871 (  636 1050 ) resistor r=5.29055 //w=0.35 //l=0.17 //layer=li \
 //thickness=0.1 //x=44.69 //y=7.585 //x2=44.52 //y2=7.585
r1872 (  636 638 ) resistor r=19.8801 //w=0.367 //l=0.57 //layer=li \
 //thickness=0.1 //x=44.69 //y=7.585 //x2=45.26 //y2=7.585
r1873 (  635 1051 ) resistor r=2.87058 //w=0.35 //l=0.085 //layer=li \
 //thickness=0.1 //x=45.525 //y=7.585 //x2=45.61 //y2=7.585
r1874 (  635 638 ) resistor r=9.24251 //w=0.367 //l=0.265 //layer=li \
 //thickness=0.1 //x=45.525 //y=7.585 //x2=45.26 //y2=7.585
r1875 (  632 1049 ) resistor r=2.87058 //w=0.35 //l=0.085 //layer=li \
 //thickness=0.1 //x=43.825 //y=7.585 //x2=43.74 //y2=7.585
r1876 (  631 1050 ) resistor r=5.29055 //w=0.35 //l=0.17 //layer=li \
 //thickness=0.1 //x=44.35 //y=7.585 //x2=44.52 //y2=7.585
r1877 (  631 632 ) resistor r=18.3106 //w=0.367 //l=0.525 //layer=li \
 //thickness=0.1 //x=44.35 //y=7.585 //x2=43.825 //y2=7.585
r1878 (  625 1049 ) resistor r=4.23183 //w=0.7 //l=0.175 //layer=li \
 //thickness=0.1 //x=43.74 //y=7.41 //x2=43.74 //y2=7.585
r1879 (  625 1131 ) resistor r=33.1979 //w=0.187 //l=0.485 //layer=li \
 //thickness=0.1 //x=43.74 //y=7.41 //x2=43.74 //y2=6.925
r1880 (  624 1047 ) resistor r=2.87058 //w=0.35 //l=0.085 //layer=li \
 //thickness=0.1 //x=42.945 //y=7.585 //x2=42.86 //y2=7.585
r1881 (  623 1049 ) resistor r=2.87058 //w=0.35 //l=0.085 //layer=li \
 //thickness=0.1 //x=43.655 //y=7.585 //x2=43.74 //y2=7.585
r1882 (  623 624 ) resistor r=24.7629 //w=0.367 //l=0.71 //layer=li \
 //thickness=0.1 //x=43.655 //y=7.585 //x2=42.945 //y2=7.585
r1883 (  617 1047 ) resistor r=4.23183 //w=0.7 //l=0.175 //layer=li \
 //thickness=0.1 //x=42.86 //y=7.41 //x2=42.86 //y2=7.585
r1884 (  617 1130 ) resistor r=33.1979 //w=0.187 //l=0.485 //layer=li \
 //thickness=0.1 //x=42.86 //y=7.41 //x2=42.86 //y2=6.925
r1885 (  614 1046 ) resistor r=2.87058 //w=0.35 //l=0.085 //layer=li \
 //thickness=0.1 //x=42.065 //y=7.585 //x2=41.98 //y2=7.585
r1886 (  614 616 ) resistor r=21.1008 //w=0.367 //l=0.605 //layer=li \
 //thickness=0.1 //x=42.065 //y=7.585 //x2=42.67 //y2=7.585
r1887 (  613 1047 ) resistor r=2.87058 //w=0.35 //l=0.085 //layer=li \
 //thickness=0.1 //x=42.775 //y=7.585 //x2=42.86 //y2=7.585
r1888 (  613 616 ) resistor r=3.66213 //w=0.367 //l=0.105 //layer=li \
 //thickness=0.1 //x=42.775 //y=7.585 //x2=42.67 //y2=7.585
r1889 (  605 1046 ) resistor r=4.23183 //w=0.7 //l=0.175 //layer=li \
 //thickness=0.1 //x=41.98 //y=7.41 //x2=41.98 //y2=7.585
r1890 (  605 1129 ) resistor r=56.4706 //w=0.187 //l=0.825 //layer=li \
 //thickness=0.1 //x=41.98 //y=7.41 //x2=41.98 //y2=6.585
r1891 (  602 1045 ) resistor r=5.29055 //w=0.35 //l=0.17 //layer=li \
 //thickness=0.1 //x=41.36 //y=7.585 //x2=41.19 //y2=7.585
r1892 (  602 604 ) resistor r=6.97548 //w=0.367 //l=0.2 //layer=li \
 //thickness=0.1 //x=41.36 //y=7.585 //x2=41.56 //y2=7.585
r1893 (  601 1046 ) resistor r=2.87058 //w=0.35 //l=0.085 //layer=li \
 //thickness=0.1 //x=41.895 //y=7.585 //x2=41.98 //y2=7.585
r1894 (  601 604 ) resistor r=11.6839 //w=0.367 //l=0.335 //layer=li \
 //thickness=0.1 //x=41.895 //y=7.585 //x2=41.56 //y2=7.585
r1895 (  598 1044 ) resistor r=2.87058 //w=0.35 //l=0.085 //layer=li \
 //thickness=0.1 //x=40.495 //y=7.585 //x2=40.41 //y2=7.585
r1896 (  597 1045 ) resistor r=5.29055 //w=0.35 //l=0.17 //layer=li \
 //thickness=0.1 //x=41.02 //y=7.585 //x2=41.19 //y2=7.585
r1897 (  597 598 ) resistor r=18.3106 //w=0.367 //l=0.525 //layer=li \
 //thickness=0.1 //x=41.02 //y=7.585 //x2=40.495 //y2=7.585
r1898 (  591 1044 ) resistor r=4.23183 //w=0.7 //l=0.175 //layer=li \
 //thickness=0.1 //x=40.41 //y=7.41 //x2=40.41 //y2=7.585
r1899 (  591 1128 ) resistor r=33.1979 //w=0.187 //l=0.485 //layer=li \
 //thickness=0.1 //x=40.41 //y=7.41 //x2=40.41 //y2=6.925
r1900 (  588 1043 ) resistor r=2.87058 //w=0.35 //l=0.085 //layer=li \
 //thickness=0.1 //x=39.615 //y=7.585 //x2=39.53 //y2=7.585
r1901 (  588 590 ) resistor r=16.218 //w=0.367 //l=0.465 //layer=li \
 //thickness=0.1 //x=39.615 //y=7.585 //x2=40.08 //y2=7.585
r1902 (  587 1044 ) resistor r=2.87058 //w=0.35 //l=0.085 //layer=li \
 //thickness=0.1 //x=40.325 //y=7.585 //x2=40.41 //y2=7.585
r1903 (  587 590 ) resistor r=8.54496 //w=0.367 //l=0.245 //layer=li \
 //thickness=0.1 //x=40.325 //y=7.585 //x2=40.08 //y2=7.585
r1904 (  581 1043 ) resistor r=4.23183 //w=0.7 //l=0.175 //layer=li \
 //thickness=0.1 //x=39.53 //y=7.41 //x2=39.53 //y2=7.585
r1905 (  581 1127 ) resistor r=33.1979 //w=0.187 //l=0.485 //layer=li \
 //thickness=0.1 //x=39.53 //y=7.41 //x2=39.53 //y2=6.925
r1906 (  578 1042 ) resistor r=2.87058 //w=0.35 //l=0.085 //layer=li \
 //thickness=0.1 //x=38.735 //y=7.585 //x2=38.65 //y2=7.585
r1907 (  578 580 ) resistor r=8.19619 //w=0.367 //l=0.235 //layer=li \
 //thickness=0.1 //x=38.735 //y=7.585 //x2=38.97 //y2=7.585
r1908 (  577 1043 ) resistor r=2.87058 //w=0.35 //l=0.085 //layer=li \
 //thickness=0.1 //x=39.445 //y=7.585 //x2=39.53 //y2=7.585
r1909 (  577 580 ) resistor r=16.5668 //w=0.367 //l=0.475 //layer=li \
 //thickness=0.1 //x=39.445 //y=7.585 //x2=38.97 //y2=7.585
r1910 (  569 1042 ) resistor r=4.23183 //w=0.7 //l=0.175 //layer=li \
 //thickness=0.1 //x=38.65 //y=7.41 //x2=38.65 //y2=7.585
r1911 (  569 1126 ) resistor r=56.4706 //w=0.187 //l=0.825 //layer=li \
 //thickness=0.1 //x=38.65 //y=7.41 //x2=38.65 //y2=6.585
r1912 (  568 1041 ) resistor r=5.29055 //w=0.35 //l=0.17 //layer=li \
 //thickness=0.1 //x=38.03 //y=7.585 //x2=37.86 //y2=7.585
r1913 (  567 1042 ) resistor r=2.87058 //w=0.35 //l=0.085 //layer=li \
 //thickness=0.1 //x=38.565 //y=7.585 //x2=38.65 //y2=7.585
r1914 (  567 568 ) resistor r=18.6594 //w=0.367 //l=0.535 //layer=li \
 //thickness=0.1 //x=38.565 //y=7.585 //x2=38.03 //y2=7.585
r1915 (  562 1040 ) resistor r=2.87058 //w=0.35 //l=0.085 //layer=li \
 //thickness=0.1 //x=36.865 //y=7.585 //x2=36.78 //y2=7.585
r1916 (  562 564 ) resistor r=21.7984 //w=0.367 //l=0.625 //layer=li \
 //thickness=0.1 //x=36.865 //y=7.585 //x2=37.49 //y2=7.585
r1917 (  561 1041 ) resistor r=5.29055 //w=0.35 //l=0.17 //layer=li \
 //thickness=0.1 //x=37.69 //y=7.585 //x2=37.86 //y2=7.585
r1918 (  561 564 ) resistor r=6.97548 //w=0.367 //l=0.2 //layer=li \
 //thickness=0.1 //x=37.69 //y=7.585 //x2=37.49 //y2=7.585
r1919 (  555 1040 ) resistor r=4.23183 //w=0.7 //l=0.175 //layer=li \
 //thickness=0.1 //x=36.78 //y=7.41 //x2=36.78 //y2=7.585
r1920 (  555 1125 ) resistor r=33.1979 //w=0.187 //l=0.485 //layer=li \
 //thickness=0.1 //x=36.78 //y=7.41 //x2=36.78 //y2=6.925
r1921 (  552 1039 ) resistor r=2.87058 //w=0.35 //l=0.085 //layer=li \
 //thickness=0.1 //x=35.985 //y=7.585 //x2=35.9 //y2=7.585
r1922 (  552 554 ) resistor r=13.7766 //w=0.367 //l=0.395 //layer=li \
 //thickness=0.1 //x=35.985 //y=7.585 //x2=36.38 //y2=7.585
r1923 (  551 1040 ) resistor r=2.87058 //w=0.35 //l=0.085 //layer=li \
 //thickness=0.1 //x=36.695 //y=7.585 //x2=36.78 //y2=7.585
r1924 (  551 554 ) resistor r=10.9864 //w=0.367 //l=0.315 //layer=li \
 //thickness=0.1 //x=36.695 //y=7.585 //x2=36.38 //y2=7.585
r1925 (  545 1039 ) resistor r=4.23183 //w=0.7 //l=0.175 //layer=li \
 //thickness=0.1 //x=35.9 //y=7.41 //x2=35.9 //y2=7.585
r1926 (  545 1124 ) resistor r=33.1979 //w=0.187 //l=0.485 //layer=li \
 //thickness=0.1 //x=35.9 //y=7.41 //x2=35.9 //y2=6.925
r1927 (  542 1038 ) resistor r=2.87058 //w=0.35 //l=0.085 //layer=li \
 //thickness=0.1 //x=35.105 //y=7.585 //x2=35.02 //y2=7.585
r1928 (  542 544 ) resistor r=5.75477 //w=0.367 //l=0.165 //layer=li \
 //thickness=0.1 //x=35.105 //y=7.585 //x2=35.27 //y2=7.585
r1929 (  541 1039 ) resistor r=2.87058 //w=0.35 //l=0.085 //layer=li \
 //thickness=0.1 //x=35.815 //y=7.585 //x2=35.9 //y2=7.585
r1930 (  541 544 ) resistor r=19.0082 //w=0.367 //l=0.545 //layer=li \
 //thickness=0.1 //x=35.815 //y=7.585 //x2=35.27 //y2=7.585
r1931 (  535 1038 ) resistor r=4.23183 //w=0.7 //l=0.175 //layer=li \
 //thickness=0.1 //x=35.02 //y=7.41 //x2=35.02 //y2=7.585
r1932 (  535 1123 ) resistor r=33.1979 //w=0.187 //l=0.485 //layer=li \
 //thickness=0.1 //x=35.02 //y=7.41 //x2=35.02 //y2=6.925
r1933 (  534 1037 ) resistor r=2.87058 //w=0.35 //l=0.085 //layer=li \
 //thickness=0.1 //x=34.225 //y=7.585 //x2=34.14 //y2=7.585
r1934 (  533 1038 ) resistor r=2.87058 //w=0.35 //l=0.085 //layer=li \
 //thickness=0.1 //x=34.935 //y=7.585 //x2=35.02 //y2=7.585
r1935 (  533 534 ) resistor r=24.7629 //w=0.367 //l=0.71 //layer=li \
 //thickness=0.1 //x=34.935 //y=7.585 //x2=34.225 //y2=7.585
r1936 (  525 1037 ) resistor r=4.23183 //w=0.7 //l=0.175 //layer=li \
 //thickness=0.1 //x=34.14 //y=7.41 //x2=34.14 //y2=7.585
r1937 (  525 1122 ) resistor r=56.4706 //w=0.187 //l=0.825 //layer=li \
 //thickness=0.1 //x=34.14 //y=7.41 //x2=34.14 //y2=6.585
r1938 (  524 1035 ) resistor r=5.29055 //w=0.35 //l=0.17 //layer=li \
 //thickness=0.1 //x=33.22 //y=7.585 //x2=33.05 //y2=7.585
r1939 (  523 1037 ) resistor r=2.87058 //w=0.35 //l=0.085 //layer=li \
 //thickness=0.1 //x=34.055 //y=7.585 //x2=34.14 //y2=7.585
r1940 (  523 524 ) resistor r=29.1226 //w=0.367 //l=0.835 //layer=li \
 //thickness=0.1 //x=34.055 //y=7.585 //x2=33.22 //y2=7.585
r1941 (  518 1034 ) resistor r=2.87058 //w=0.35 //l=0.085 //layer=li \
 //thickness=0.1 //x=32.055 //y=7.585 //x2=31.97 //y2=7.585
r1942 (  518 520 ) resistor r=21.7984 //w=0.367 //l=0.625 //layer=li \
 //thickness=0.1 //x=32.055 //y=7.585 //x2=32.68 //y2=7.585
r1943 (  517 1035 ) resistor r=5.29055 //w=0.35 //l=0.17 //layer=li \
 //thickness=0.1 //x=32.88 //y=7.585 //x2=33.05 //y2=7.585
r1944 (  517 520 ) resistor r=6.97548 //w=0.367 //l=0.2 //layer=li \
 //thickness=0.1 //x=32.88 //y=7.585 //x2=32.68 //y2=7.585
r1945 (  511 1034 ) resistor r=4.23183 //w=0.7 //l=0.175 //layer=li \
 //thickness=0.1 //x=31.97 //y=7.41 //x2=31.97 //y2=7.585
r1946 (  511 1121 ) resistor r=33.1979 //w=0.187 //l=0.485 //layer=li \
 //thickness=0.1 //x=31.97 //y=7.41 //x2=31.97 //y2=6.925
r1947 (  508 1033 ) resistor r=2.87058 //w=0.35 //l=0.085 //layer=li \
 //thickness=0.1 //x=31.175 //y=7.585 //x2=31.09 //y2=7.585
r1948 (  508 510 ) resistor r=13.7766 //w=0.367 //l=0.395 //layer=li \
 //thickness=0.1 //x=31.175 //y=7.585 //x2=31.57 //y2=7.585
r1949 (  507 1034 ) resistor r=2.87058 //w=0.35 //l=0.085 //layer=li \
 //thickness=0.1 //x=31.885 //y=7.585 //x2=31.97 //y2=7.585
r1950 (  507 510 ) resistor r=10.9864 //w=0.367 //l=0.315 //layer=li \
 //thickness=0.1 //x=31.885 //y=7.585 //x2=31.57 //y2=7.585
r1951 (  501 1033 ) resistor r=4.23183 //w=0.7 //l=0.175 //layer=li \
 //thickness=0.1 //x=31.09 //y=7.41 //x2=31.09 //y2=7.585
r1952 (  501 1120 ) resistor r=33.1979 //w=0.187 //l=0.485 //layer=li \
 //thickness=0.1 //x=31.09 //y=7.41 //x2=31.09 //y2=6.925
r1953 (  498 1032 ) resistor r=2.87058 //w=0.35 //l=0.085 //layer=li \
 //thickness=0.1 //x=30.295 //y=7.585 //x2=30.21 //y2=7.585
r1954 (  498 500 ) resistor r=5.75477 //w=0.367 //l=0.165 //layer=li \
 //thickness=0.1 //x=30.295 //y=7.585 //x2=30.46 //y2=7.585
r1955 (  497 1033 ) resistor r=2.87058 //w=0.35 //l=0.085 //layer=li \
 //thickness=0.1 //x=31.005 //y=7.585 //x2=31.09 //y2=7.585
r1956 (  497 500 ) resistor r=19.0082 //w=0.367 //l=0.545 //layer=li \
 //thickness=0.1 //x=31.005 //y=7.585 //x2=30.46 //y2=7.585
r1957 (  491 1032 ) resistor r=4.23183 //w=0.7 //l=0.175 //layer=li \
 //thickness=0.1 //x=30.21 //y=7.41 //x2=30.21 //y2=7.585
r1958 (  491 1119 ) resistor r=33.1979 //w=0.187 //l=0.485 //layer=li \
 //thickness=0.1 //x=30.21 //y=7.41 //x2=30.21 //y2=6.925
r1959 (  490 1031 ) resistor r=2.87058 //w=0.35 //l=0.085 //layer=li \
 //thickness=0.1 //x=29.415 //y=7.585 //x2=29.33 //y2=7.585
r1960 (  489 1032 ) resistor r=2.87058 //w=0.35 //l=0.085 //layer=li \
 //thickness=0.1 //x=30.125 //y=7.585 //x2=30.21 //y2=7.585
r1961 (  489 490 ) resistor r=24.7629 //w=0.367 //l=0.71 //layer=li \
 //thickness=0.1 //x=30.125 //y=7.585 //x2=29.415 //y2=7.585
r1962 (  481 1031 ) resistor r=4.23183 //w=0.7 //l=0.175 //layer=li \
 //thickness=0.1 //x=29.33 //y=7.41 //x2=29.33 //y2=7.585
r1963 (  481 1118 ) resistor r=56.4706 //w=0.187 //l=0.825 //layer=li \
 //thickness=0.1 //x=29.33 //y=7.41 //x2=29.33 //y2=6.585
r1964 (  480 1029 ) resistor r=5.29055 //w=0.35 //l=0.17 //layer=li \
 //thickness=0.1 //x=28.41 //y=7.585 //x2=28.24 //y2=7.585
r1965 (  479 1031 ) resistor r=2.87058 //w=0.35 //l=0.085 //layer=li \
 //thickness=0.1 //x=29.245 //y=7.585 //x2=29.33 //y2=7.585
r1966 (  479 480 ) resistor r=29.1226 //w=0.367 //l=0.835 //layer=li \
 //thickness=0.1 //x=29.245 //y=7.585 //x2=28.41 //y2=7.585
r1967 (  474 1028 ) resistor r=2.87058 //w=0.35 //l=0.085 //layer=li \
 //thickness=0.1 //x=27.545 //y=7.585 //x2=27.46 //y2=7.585
r1968 (  474 476 ) resistor r=11.3351 //w=0.367 //l=0.325 //layer=li \
 //thickness=0.1 //x=27.545 //y=7.585 //x2=27.87 //y2=7.585
r1969 (  473 1029 ) resistor r=5.29055 //w=0.35 //l=0.17 //layer=li \
 //thickness=0.1 //x=28.07 //y=7.585 //x2=28.24 //y2=7.585
r1970 (  473 476 ) resistor r=6.97548 //w=0.367 //l=0.2 //layer=li \
 //thickness=0.1 //x=28.07 //y=7.585 //x2=27.87 //y2=7.585
r1971 (  467 1028 ) resistor r=4.23183 //w=0.7 //l=0.175 //layer=li \
 //thickness=0.1 //x=27.46 //y=7.41 //x2=27.46 //y2=7.585
r1972 (  467 1117 ) resistor r=33.1979 //w=0.187 //l=0.485 //layer=li \
 //thickness=0.1 //x=27.46 //y=7.41 //x2=27.46 //y2=6.925
r1973 (  464 1027 ) resistor r=2.87058 //w=0.35 //l=0.085 //layer=li \
 //thickness=0.1 //x=26.665 //y=7.585 //x2=26.58 //y2=7.585
r1974 (  464 466 ) resistor r=3.31335 //w=0.367 //l=0.095 //layer=li \
 //thickness=0.1 //x=26.665 //y=7.585 //x2=26.76 //y2=7.585
r1975 (  463 1028 ) resistor r=2.87058 //w=0.35 //l=0.085 //layer=li \
 //thickness=0.1 //x=27.375 //y=7.585 //x2=27.46 //y2=7.585
r1976 (  463 466 ) resistor r=21.4496 //w=0.367 //l=0.615 //layer=li \
 //thickness=0.1 //x=27.375 //y=7.585 //x2=26.76 //y2=7.585
r1977 (  457 1027 ) resistor r=4.23183 //w=0.7 //l=0.175 //layer=li \
 //thickness=0.1 //x=26.58 //y=7.41 //x2=26.58 //y2=7.585
r1978 (  457 1116 ) resistor r=33.1979 //w=0.187 //l=0.485 //layer=li \
 //thickness=0.1 //x=26.58 //y=7.41 //x2=26.58 //y2=6.925
r1979 (  456 1026 ) resistor r=2.87058 //w=0.35 //l=0.085 //layer=li \
 //thickness=0.1 //x=25.785 //y=7.585 //x2=25.7 //y2=7.585
r1980 (  455 1027 ) resistor r=2.87058 //w=0.35 //l=0.085 //layer=li \
 //thickness=0.1 //x=26.495 //y=7.585 //x2=26.58 //y2=7.585
r1981 (  455 456 ) resistor r=24.7629 //w=0.367 //l=0.71 //layer=li \
 //thickness=0.1 //x=26.495 //y=7.585 //x2=25.785 //y2=7.585
r1982 (  447 1026 ) resistor r=4.23183 //w=0.7 //l=0.175 //layer=li \
 //thickness=0.1 //x=25.7 //y=7.41 //x2=25.7 //y2=7.585
r1983 (  447 1115 ) resistor r=56.4706 //w=0.187 //l=0.825 //layer=li \
 //thickness=0.1 //x=25.7 //y=7.41 //x2=25.7 //y2=6.585
r1984 (  446 1024 ) resistor r=5.29055 //w=0.35 //l=0.17 //layer=li \
 //thickness=0.1 //x=25.08 //y=7.585 //x2=24.91 //y2=7.585
r1985 (  445 1026 ) resistor r=2.87058 //w=0.35 //l=0.085 //layer=li \
 //thickness=0.1 //x=25.615 //y=7.585 //x2=25.7 //y2=7.585
r1986 (  445 446 ) resistor r=18.6594 //w=0.367 //l=0.535 //layer=li \
 //thickness=0.1 //x=25.615 //y=7.585 //x2=25.08 //y2=7.585
r1987 (  440 1023 ) resistor r=2.87058 //w=0.35 //l=0.085 //layer=li \
 //thickness=0.1 //x=23.915 //y=7.585 //x2=23.83 //y2=7.585
r1988 (  440 442 ) resistor r=8.89373 //w=0.367 //l=0.255 //layer=li \
 //thickness=0.1 //x=23.915 //y=7.585 //x2=24.17 //y2=7.585
r1989 (  439 1024 ) resistor r=5.29055 //w=0.35 //l=0.17 //layer=li \
 //thickness=0.1 //x=24.74 //y=7.585 //x2=24.91 //y2=7.585
r1990 (  439 442 ) resistor r=19.8801 //w=0.367 //l=0.57 //layer=li \
 //thickness=0.1 //x=24.74 //y=7.585 //x2=24.17 //y2=7.585
r1991 (  433 1023 ) resistor r=4.23183 //w=0.7 //l=0.175 //layer=li \
 //thickness=0.1 //x=23.83 //y=7.41 //x2=23.83 //y2=7.585
r1992 (  433 1114 ) resistor r=33.1979 //w=0.187 //l=0.485 //layer=li \
 //thickness=0.1 //x=23.83 //y=7.41 //x2=23.83 //y2=6.925
r1993 (  430 1022 ) resistor r=2.87058 //w=0.35 //l=0.085 //layer=li \
 //thickness=0.1 //x=23.035 //y=7.585 //x2=22.95 //y2=7.585
r1994 (  430 432 ) resistor r=0.871935 //w=0.367 //l=0.025 //layer=li \
 //thickness=0.1 //x=23.035 //y=7.585 //x2=23.06 //y2=7.585
r1995 (  429 1023 ) resistor r=2.87058 //w=0.35 //l=0.085 //layer=li \
 //thickness=0.1 //x=23.745 //y=7.585 //x2=23.83 //y2=7.585
r1996 (  429 432 ) resistor r=23.891 //w=0.367 //l=0.685 //layer=li \
 //thickness=0.1 //x=23.745 //y=7.585 //x2=23.06 //y2=7.585
r1997 (  423 1022 ) resistor r=4.23183 //w=0.7 //l=0.175 //layer=li \
 //thickness=0.1 //x=22.95 //y=7.41 //x2=22.95 //y2=7.585
r1998 (  423 1113 ) resistor r=33.1979 //w=0.187 //l=0.485 //layer=li \
 //thickness=0.1 //x=22.95 //y=7.41 //x2=22.95 //y2=6.925
r1999 (  422 1021 ) resistor r=2.87058 //w=0.35 //l=0.085 //layer=li \
 //thickness=0.1 //x=22.155 //y=7.585 //x2=22.07 //y2=7.585
r2000 (  421 1022 ) resistor r=2.87058 //w=0.35 //l=0.085 //layer=li \
 //thickness=0.1 //x=22.865 //y=7.585 //x2=22.95 //y2=7.585
r2001 (  421 422 ) resistor r=24.7629 //w=0.367 //l=0.71 //layer=li \
 //thickness=0.1 //x=22.865 //y=7.585 //x2=22.155 //y2=7.585
r2002 (  415 1021 ) resistor r=4.23183 //w=0.7 //l=0.175 //layer=li \
 //thickness=0.1 //x=22.07 //y=7.41 //x2=22.07 //y2=7.585
r2003 (  415 1112 ) resistor r=33.1979 //w=0.187 //l=0.485 //layer=li \
 //thickness=0.1 //x=22.07 //y=7.41 //x2=22.07 //y2=6.925
r2004 (  412 1020 ) resistor r=2.87058 //w=0.35 //l=0.085 //layer=li \
 //thickness=0.1 //x=21.275 //y=7.585 //x2=21.19 //y2=7.585
r2005 (  412 414 ) resistor r=23.5422 //w=0.367 //l=0.675 //layer=li \
 //thickness=0.1 //x=21.275 //y=7.585 //x2=21.95 //y2=7.585
r2006 (  411 1021 ) resistor r=2.87058 //w=0.35 //l=0.085 //layer=li \
 //thickness=0.1 //x=21.985 //y=7.585 //x2=22.07 //y2=7.585
r2007 (  411 414 ) resistor r=1.22071 //w=0.367 //l=0.035 //layer=li \
 //thickness=0.1 //x=21.985 //y=7.585 //x2=21.95 //y2=7.585
r2008 (  403 1020 ) resistor r=4.23183 //w=0.7 //l=0.175 //layer=li \
 //thickness=0.1 //x=21.19 //y=7.41 //x2=21.19 //y2=7.585
r2009 (  403 1111 ) resistor r=56.4706 //w=0.187 //l=0.825 //layer=li \
 //thickness=0.1 //x=21.19 //y=7.41 //x2=21.19 //y2=6.585
r2010 (  400 1019 ) resistor r=5.29055 //w=0.35 //l=0.17 //layer=li \
 //thickness=0.1 //x=20.27 //y=7.585 //x2=20.1 //y2=7.585
r2011 (  400 402 ) resistor r=19.8801 //w=0.367 //l=0.57 //layer=li \
 //thickness=0.1 //x=20.27 //y=7.585 //x2=20.84 //y2=7.585
r2012 (  399 1020 ) resistor r=2.87058 //w=0.35 //l=0.085 //layer=li \
 //thickness=0.1 //x=21.105 //y=7.585 //x2=21.19 //y2=7.585
r2013 (  399 402 ) resistor r=9.24251 //w=0.367 //l=0.265 //layer=li \
 //thickness=0.1 //x=21.105 //y=7.585 //x2=20.84 //y2=7.585
r2014 (  396 1018 ) resistor r=2.87058 //w=0.35 //l=0.085 //layer=li \
 //thickness=0.1 //x=19.405 //y=7.585 //x2=19.32 //y2=7.585
r2015 (  395 1019 ) resistor r=5.29055 //w=0.35 //l=0.17 //layer=li \
 //thickness=0.1 //x=19.93 //y=7.585 //x2=20.1 //y2=7.585
r2016 (  395 396 ) resistor r=18.3106 //w=0.367 //l=0.525 //layer=li \
 //thickness=0.1 //x=19.93 //y=7.585 //x2=19.405 //y2=7.585
r2017 (  389 1018 ) resistor r=4.23183 //w=0.7 //l=0.175 //layer=li \
 //thickness=0.1 //x=19.32 //y=7.41 //x2=19.32 //y2=7.585
r2018 (  389 1110 ) resistor r=33.1979 //w=0.187 //l=0.485 //layer=li \
 //thickness=0.1 //x=19.32 //y=7.41 //x2=19.32 //y2=6.925
r2019 (  388 1016 ) resistor r=2.87058 //w=0.35 //l=0.085 //layer=li \
 //thickness=0.1 //x=18.525 //y=7.585 //x2=18.44 //y2=7.585
r2020 (  387 1018 ) resistor r=2.87058 //w=0.35 //l=0.085 //layer=li \
 //thickness=0.1 //x=19.235 //y=7.585 //x2=19.32 //y2=7.585
r2021 (  387 388 ) resistor r=24.7629 //w=0.367 //l=0.71 //layer=li \
 //thickness=0.1 //x=19.235 //y=7.585 //x2=18.525 //y2=7.585
r2022 (  381 1016 ) resistor r=4.23183 //w=0.7 //l=0.175 //layer=li \
 //thickness=0.1 //x=18.44 //y=7.41 //x2=18.44 //y2=7.585
r2023 (  381 1109 ) resistor r=33.1979 //w=0.187 //l=0.485 //layer=li \
 //thickness=0.1 //x=18.44 //y=7.41 //x2=18.44 //y2=6.925
r2024 (  378 1015 ) resistor r=2.87058 //w=0.35 //l=0.085 //layer=li \
 //thickness=0.1 //x=17.645 //y=7.585 //x2=17.56 //y2=7.585
r2025 (  378 380 ) resistor r=21.1008 //w=0.367 //l=0.605 //layer=li \
 //thickness=0.1 //x=17.645 //y=7.585 //x2=18.25 //y2=7.585
r2026 (  377 1016 ) resistor r=2.87058 //w=0.35 //l=0.085 //layer=li \
 //thickness=0.1 //x=18.355 //y=7.585 //x2=18.44 //y2=7.585
r2027 (  377 380 ) resistor r=3.66213 //w=0.367 //l=0.105 //layer=li \
 //thickness=0.1 //x=18.355 //y=7.585 //x2=18.25 //y2=7.585
r2028 (  369 1015 ) resistor r=4.23183 //w=0.7 //l=0.175 //layer=li \
 //thickness=0.1 //x=17.56 //y=7.41 //x2=17.56 //y2=7.585
r2029 (  369 1108 ) resistor r=56.4706 //w=0.187 //l=0.825 //layer=li \
 //thickness=0.1 //x=17.56 //y=7.41 //x2=17.56 //y2=6.585
r2030 (  366 1014 ) resistor r=5.29055 //w=0.35 //l=0.17 //layer=li \
 //thickness=0.1 //x=16.94 //y=7.585 //x2=16.77 //y2=7.585
r2031 (  366 368 ) resistor r=6.97548 //w=0.367 //l=0.2 //layer=li \
 //thickness=0.1 //x=16.94 //y=7.585 //x2=17.14 //y2=7.585
r2032 (  365 1015 ) resistor r=2.87058 //w=0.35 //l=0.085 //layer=li \
 //thickness=0.1 //x=17.475 //y=7.585 //x2=17.56 //y2=7.585
r2033 (  365 368 ) resistor r=11.6839 //w=0.367 //l=0.335 //layer=li \
 //thickness=0.1 //x=17.475 //y=7.585 //x2=17.14 //y2=7.585
r2034 (  362 1013 ) resistor r=2.87058 //w=0.35 //l=0.085 //layer=li \
 //thickness=0.1 //x=16.075 //y=7.585 //x2=15.99 //y2=7.585
r2035 (  361 1014 ) resistor r=5.29055 //w=0.35 //l=0.17 //layer=li \
 //thickness=0.1 //x=16.6 //y=7.585 //x2=16.77 //y2=7.585
r2036 (  361 362 ) resistor r=18.3106 //w=0.367 //l=0.525 //layer=li \
 //thickness=0.1 //x=16.6 //y=7.585 //x2=16.075 //y2=7.585
r2037 (  355 1013 ) resistor r=4.23183 //w=0.7 //l=0.175 //layer=li \
 //thickness=0.1 //x=15.99 //y=7.41 //x2=15.99 //y2=7.585
r2038 (  355 1107 ) resistor r=33.1979 //w=0.187 //l=0.485 //layer=li \
 //thickness=0.1 //x=15.99 //y=7.41 //x2=15.99 //y2=6.925
r2039 (  352 1012 ) resistor r=2.87058 //w=0.35 //l=0.085 //layer=li \
 //thickness=0.1 //x=15.195 //y=7.585 //x2=15.11 //y2=7.585
r2040 (  352 354 ) resistor r=16.218 //w=0.367 //l=0.465 //layer=li \
 //thickness=0.1 //x=15.195 //y=7.585 //x2=15.66 //y2=7.585
r2041 (  351 1013 ) resistor r=2.87058 //w=0.35 //l=0.085 //layer=li \
 //thickness=0.1 //x=15.905 //y=7.585 //x2=15.99 //y2=7.585
r2042 (  351 354 ) resistor r=8.54496 //w=0.367 //l=0.245 //layer=li \
 //thickness=0.1 //x=15.905 //y=7.585 //x2=15.66 //y2=7.585
r2043 (  345 1012 ) resistor r=4.23183 //w=0.7 //l=0.175 //layer=li \
 //thickness=0.1 //x=15.11 //y=7.41 //x2=15.11 //y2=7.585
r2044 (  345 1106 ) resistor r=33.1979 //w=0.187 //l=0.485 //layer=li \
 //thickness=0.1 //x=15.11 //y=7.41 //x2=15.11 //y2=6.925
r2045 (  342 1011 ) resistor r=2.87058 //w=0.35 //l=0.085 //layer=li \
 //thickness=0.1 //x=14.315 //y=7.585 //x2=14.23 //y2=7.585
r2046 (  342 344 ) resistor r=8.19619 //w=0.367 //l=0.235 //layer=li \
 //thickness=0.1 //x=14.315 //y=7.585 //x2=14.55 //y2=7.585
r2047 (  341 1012 ) resistor r=2.87058 //w=0.35 //l=0.085 //layer=li \
 //thickness=0.1 //x=15.025 //y=7.585 //x2=15.11 //y2=7.585
r2048 (  341 344 ) resistor r=16.5668 //w=0.367 //l=0.475 //layer=li \
 //thickness=0.1 //x=15.025 //y=7.585 //x2=14.55 //y2=7.585
r2049 (  333 1011 ) resistor r=4.23183 //w=0.7 //l=0.175 //layer=li \
 //thickness=0.1 //x=14.23 //y=7.41 //x2=14.23 //y2=7.585
r2050 (  333 1105 ) resistor r=56.4706 //w=0.187 //l=0.825 //layer=li \
 //thickness=0.1 //x=14.23 //y=7.41 //x2=14.23 //y2=6.585
r2051 (  332 1010 ) resistor r=5.29055 //w=0.35 //l=0.17 //layer=li \
 //thickness=0.1 //x=13.61 //y=7.585 //x2=13.44 //y2=7.585
r2052 (  331 1011 ) resistor r=2.87058 //w=0.35 //l=0.085 //layer=li \
 //thickness=0.1 //x=14.145 //y=7.585 //x2=14.23 //y2=7.585
r2053 (  331 332 ) resistor r=18.6594 //w=0.367 //l=0.535 //layer=li \
 //thickness=0.1 //x=14.145 //y=7.585 //x2=13.61 //y2=7.585
r2054 (  326 1009 ) resistor r=2.87058 //w=0.35 //l=0.085 //layer=li \
 //thickness=0.1 //x=12.445 //y=7.585 //x2=12.36 //y2=7.585
r2055 (  326 328 ) resistor r=21.7984 //w=0.367 //l=0.625 //layer=li \
 //thickness=0.1 //x=12.445 //y=7.585 //x2=13.07 //y2=7.585
r2056 (  325 1010 ) resistor r=5.29055 //w=0.35 //l=0.17 //layer=li \
 //thickness=0.1 //x=13.27 //y=7.585 //x2=13.44 //y2=7.585
r2057 (  325 328 ) resistor r=6.97548 //w=0.367 //l=0.2 //layer=li \
 //thickness=0.1 //x=13.27 //y=7.585 //x2=13.07 //y2=7.585
r2058 (  319 1009 ) resistor r=4.23183 //w=0.7 //l=0.175 //layer=li \
 //thickness=0.1 //x=12.36 //y=7.41 //x2=12.36 //y2=7.585
r2059 (  319 1104 ) resistor r=33.1979 //w=0.187 //l=0.485 //layer=li \
 //thickness=0.1 //x=12.36 //y=7.41 //x2=12.36 //y2=6.925
r2060 (  316 1008 ) resistor r=2.87058 //w=0.35 //l=0.085 //layer=li \
 //thickness=0.1 //x=11.565 //y=7.585 //x2=11.48 //y2=7.585
r2061 (  316 318 ) resistor r=13.7766 //w=0.367 //l=0.395 //layer=li \
 //thickness=0.1 //x=11.565 //y=7.585 //x2=11.96 //y2=7.585
r2062 (  315 1009 ) resistor r=2.87058 //w=0.35 //l=0.085 //layer=li \
 //thickness=0.1 //x=12.275 //y=7.585 //x2=12.36 //y2=7.585
r2063 (  315 318 ) resistor r=10.9864 //w=0.367 //l=0.315 //layer=li \
 //thickness=0.1 //x=12.275 //y=7.585 //x2=11.96 //y2=7.585
r2064 (  309 1008 ) resistor r=4.23183 //w=0.7 //l=0.175 //layer=li \
 //thickness=0.1 //x=11.48 //y=7.41 //x2=11.48 //y2=7.585
r2065 (  309 1103 ) resistor r=33.1979 //w=0.187 //l=0.485 //layer=li \
 //thickness=0.1 //x=11.48 //y=7.41 //x2=11.48 //y2=6.925
r2066 (  306 1007 ) resistor r=2.87058 //w=0.35 //l=0.085 //layer=li \
 //thickness=0.1 //x=10.685 //y=7.585 //x2=10.6 //y2=7.585
r2067 (  306 308 ) resistor r=5.75477 //w=0.367 //l=0.165 //layer=li \
 //thickness=0.1 //x=10.685 //y=7.585 //x2=10.85 //y2=7.585
r2068 (  305 1008 ) resistor r=2.87058 //w=0.35 //l=0.085 //layer=li \
 //thickness=0.1 //x=11.395 //y=7.585 //x2=11.48 //y2=7.585
r2069 (  305 308 ) resistor r=19.0082 //w=0.367 //l=0.545 //layer=li \
 //thickness=0.1 //x=11.395 //y=7.585 //x2=10.85 //y2=7.585
r2070 (  299 1007 ) resistor r=4.23183 //w=0.7 //l=0.175 //layer=li \
 //thickness=0.1 //x=10.6 //y=7.41 //x2=10.6 //y2=7.585
r2071 (  299 1102 ) resistor r=33.1979 //w=0.187 //l=0.485 //layer=li \
 //thickness=0.1 //x=10.6 //y=7.41 //x2=10.6 //y2=6.925
r2072 (  298 1006 ) resistor r=2.87058 //w=0.35 //l=0.085 //layer=li \
 //thickness=0.1 //x=9.805 //y=7.585 //x2=9.72 //y2=7.585
r2073 (  297 1007 ) resistor r=2.87058 //w=0.35 //l=0.085 //layer=li \
 //thickness=0.1 //x=10.515 //y=7.585 //x2=10.6 //y2=7.585
r2074 (  297 298 ) resistor r=24.7629 //w=0.367 //l=0.71 //layer=li \
 //thickness=0.1 //x=10.515 //y=7.585 //x2=9.805 //y2=7.585
r2075 (  289 1006 ) resistor r=4.23183 //w=0.7 //l=0.175 //layer=li \
 //thickness=0.1 //x=9.72 //y=7.41 //x2=9.72 //y2=7.585
r2076 (  289 1101 ) resistor r=56.4706 //w=0.187 //l=0.825 //layer=li \
 //thickness=0.1 //x=9.72 //y=7.41 //x2=9.72 //y2=6.585
r2077 (  288 1004 ) resistor r=5.29055 //w=0.35 //l=0.17 //layer=li \
 //thickness=0.1 //x=8.8 //y=7.585 //x2=8.63 //y2=7.585
r2078 (  287 1006 ) resistor r=2.87058 //w=0.35 //l=0.085 //layer=li \
 //thickness=0.1 //x=9.635 //y=7.585 //x2=9.72 //y2=7.585
r2079 (  287 288 ) resistor r=29.1226 //w=0.367 //l=0.835 //layer=li \
 //thickness=0.1 //x=9.635 //y=7.585 //x2=8.8 //y2=7.585
r2080 (  282 1003 ) resistor r=2.87058 //w=0.35 //l=0.085 //layer=li \
 //thickness=0.1 //x=7.635 //y=7.585 //x2=7.55 //y2=7.585
r2081 (  282 284 ) resistor r=21.7984 //w=0.367 //l=0.625 //layer=li \
 //thickness=0.1 //x=7.635 //y=7.585 //x2=8.26 //y2=7.585
r2082 (  281 1004 ) resistor r=5.29055 //w=0.35 //l=0.17 //layer=li \
 //thickness=0.1 //x=8.46 //y=7.585 //x2=8.63 //y2=7.585
r2083 (  281 284 ) resistor r=6.97548 //w=0.367 //l=0.2 //layer=li \
 //thickness=0.1 //x=8.46 //y=7.585 //x2=8.26 //y2=7.585
r2084 (  275 1003 ) resistor r=4.23183 //w=0.7 //l=0.175 //layer=li \
 //thickness=0.1 //x=7.55 //y=7.41 //x2=7.55 //y2=7.585
r2085 (  275 1100 ) resistor r=33.1979 //w=0.187 //l=0.485 //layer=li \
 //thickness=0.1 //x=7.55 //y=7.41 //x2=7.55 //y2=6.925
r2086 (  272 1002 ) resistor r=2.87058 //w=0.35 //l=0.085 //layer=li \
 //thickness=0.1 //x=6.755 //y=7.585 //x2=6.67 //y2=7.585
r2087 (  272 274 ) resistor r=13.7766 //w=0.367 //l=0.395 //layer=li \
 //thickness=0.1 //x=6.755 //y=7.585 //x2=7.15 //y2=7.585
r2088 (  271 1003 ) resistor r=2.87058 //w=0.35 //l=0.085 //layer=li \
 //thickness=0.1 //x=7.465 //y=7.585 //x2=7.55 //y2=7.585
r2089 (  271 274 ) resistor r=10.9864 //w=0.367 //l=0.315 //layer=li \
 //thickness=0.1 //x=7.465 //y=7.585 //x2=7.15 //y2=7.585
r2090 (  265 1002 ) resistor r=4.23183 //w=0.7 //l=0.175 //layer=li \
 //thickness=0.1 //x=6.67 //y=7.41 //x2=6.67 //y2=7.585
r2091 (  265 1099 ) resistor r=33.1979 //w=0.187 //l=0.485 //layer=li \
 //thickness=0.1 //x=6.67 //y=7.41 //x2=6.67 //y2=6.925
r2092 (  262 1001 ) resistor r=2.87058 //w=0.35 //l=0.085 //layer=li \
 //thickness=0.1 //x=5.875 //y=7.585 //x2=5.79 //y2=7.585
r2093 (  262 264 ) resistor r=5.75477 //w=0.367 //l=0.165 //layer=li \
 //thickness=0.1 //x=5.875 //y=7.585 //x2=6.04 //y2=7.585
r2094 (  261 1002 ) resistor r=2.87058 //w=0.35 //l=0.085 //layer=li \
 //thickness=0.1 //x=6.585 //y=7.585 //x2=6.67 //y2=7.585
r2095 (  261 264 ) resistor r=19.0082 //w=0.367 //l=0.545 //layer=li \
 //thickness=0.1 //x=6.585 //y=7.585 //x2=6.04 //y2=7.585
r2096 (  255 1001 ) resistor r=4.23183 //w=0.7 //l=0.175 //layer=li \
 //thickness=0.1 //x=5.79 //y=7.41 //x2=5.79 //y2=7.585
r2097 (  255 1098 ) resistor r=33.1979 //w=0.187 //l=0.485 //layer=li \
 //thickness=0.1 //x=5.79 //y=7.41 //x2=5.79 //y2=6.925
r2098 (  254 1000 ) resistor r=2.87058 //w=0.35 //l=0.085 //layer=li \
 //thickness=0.1 //x=4.995 //y=7.585 //x2=4.91 //y2=7.585
r2099 (  253 1001 ) resistor r=2.87058 //w=0.35 //l=0.085 //layer=li \
 //thickness=0.1 //x=5.705 //y=7.585 //x2=5.79 //y2=7.585
r2100 (  253 254 ) resistor r=24.7629 //w=0.367 //l=0.71 //layer=li \
 //thickness=0.1 //x=5.705 //y=7.585 //x2=4.995 //y2=7.585
r2101 (  245 1000 ) resistor r=4.23183 //w=0.7 //l=0.175 //layer=li \
 //thickness=0.1 //x=4.91 //y=7.41 //x2=4.91 //y2=7.585
r2102 (  245 1097 ) resistor r=56.4706 //w=0.187 //l=0.825 //layer=li \
 //thickness=0.1 //x=4.91 //y=7.41 //x2=4.91 //y2=6.585
r2103 (  244 998 ) resistor r=5.29055 //w=0.35 //l=0.17 //layer=li \
 //thickness=0.1 //x=3.99 //y=7.585 //x2=3.82 //y2=7.585
r2104 (  243 1000 ) resistor r=2.87058 //w=0.35 //l=0.085 //layer=li \
 //thickness=0.1 //x=4.825 //y=7.585 //x2=4.91 //y2=7.585
r2105 (  243 244 ) resistor r=29.1226 //w=0.367 //l=0.835 //layer=li \
 //thickness=0.1 //x=4.825 //y=7.585 //x2=3.99 //y2=7.585
r2106 (  238 997 ) resistor r=2.87058 //w=0.35 //l=0.085 //layer=li \
 //thickness=0.1 //x=3.125 //y=7.585 //x2=3.04 //y2=7.585
r2107 (  238 240 ) resistor r=11.3351 //w=0.367 //l=0.325 //layer=li \
 //thickness=0.1 //x=3.125 //y=7.585 //x2=3.45 //y2=7.585
r2108 (  237 998 ) resistor r=5.29055 //w=0.35 //l=0.17 //layer=li \
 //thickness=0.1 //x=3.65 //y=7.585 //x2=3.82 //y2=7.585
r2109 (  237 240 ) resistor r=6.97548 //w=0.367 //l=0.2 //layer=li \
 //thickness=0.1 //x=3.65 //y=7.585 //x2=3.45 //y2=7.585
r2110 (  231 997 ) resistor r=4.23183 //w=0.7 //l=0.175 //layer=li \
 //thickness=0.1 //x=3.04 //y=7.41 //x2=3.04 //y2=7.585
r2111 (  231 1096 ) resistor r=33.1979 //w=0.187 //l=0.485 //layer=li \
 //thickness=0.1 //x=3.04 //y=7.41 //x2=3.04 //y2=6.925
r2112 (  228 996 ) resistor r=2.87058 //w=0.35 //l=0.085 //layer=li \
 //thickness=0.1 //x=2.245 //y=7.585 //x2=2.16 //y2=7.585
r2113 (  228 230 ) resistor r=3.31335 //w=0.367 //l=0.095 //layer=li \
 //thickness=0.1 //x=2.245 //y=7.585 //x2=2.34 //y2=7.585
r2114 (  227 997 ) resistor r=2.87058 //w=0.35 //l=0.085 //layer=li \
 //thickness=0.1 //x=2.955 //y=7.585 //x2=3.04 //y2=7.585
r2115 (  227 230 ) resistor r=21.4496 //w=0.367 //l=0.615 //layer=li \
 //thickness=0.1 //x=2.955 //y=7.585 //x2=2.34 //y2=7.585
r2116 (  221 996 ) resistor r=4.23183 //w=0.7 //l=0.175 //layer=li \
 //thickness=0.1 //x=2.16 //y=7.41 //x2=2.16 //y2=7.585
r2117 (  221 1095 ) resistor r=33.1979 //w=0.187 //l=0.485 //layer=li \
 //thickness=0.1 //x=2.16 //y=7.41 //x2=2.16 //y2=6.925
r2118 (  220 995 ) resistor r=2.87058 //w=0.35 //l=0.085 //layer=li \
 //thickness=0.1 //x=1.365 //y=7.585 //x2=1.28 //y2=7.585
r2119 (  219 996 ) resistor r=2.87058 //w=0.35 //l=0.085 //layer=li \
 //thickness=0.1 //x=2.075 //y=7.585 //x2=2.16 //y2=7.585
r2120 (  219 220 ) resistor r=24.7629 //w=0.367 //l=0.71 //layer=li \
 //thickness=0.1 //x=2.075 //y=7.585 //x2=1.365 //y2=7.585
r2121 (  211 995 ) resistor r=4.23183 //w=0.7 //l=0.175 //layer=li \
 //thickness=0.1 //x=1.28 //y=7.41 //x2=1.28 //y2=7.585
r2122 (  211 1094 ) resistor r=56.4706 //w=0.187 //l=0.825 //layer=li \
 //thickness=0.1 //x=1.28 //y=7.41 //x2=1.28 //y2=6.585
r2123 (  202 948 ) resistor r=9.3 //w=0.17 //l=0.17 //layer=mcon //count=1 \
 //x=76.3 //y=6.92 //x2=76.3 //y2=6.92
r2124 (  199 1158 ) resistor r=9.3 //w=0.17 //l=0.17 //layer=mcon //count=1 \
 //x=75.42 //y=6.92 //x2=75.42 //y2=6.92
r2125 (  196 933 ) resistor r=9.3 //w=0.17 //l=0.17 //layer=mcon //count=1 \
 //x=74.54 //y=6.92 //x2=74.54 //y2=6.92
r2126 (  192 920 ) resistor r=3.1 //w=0.17 //l=0.51 //layer=mcon //count=3 \
 //x=74.49 //y=7.58 //x2=74.49 //y2=7.58
r2127 (  153 1093 ) resistor r=4.65 //w=0.17 //l=0.34 //layer=mcon //count=2 \
 //x=85.22 //y=7.58 //x2=85.22 //y2=7.58
r2128 (  151 1091 ) resistor r=3.1 //w=0.17 //l=0.51 //layer=mcon //count=3 \
 //x=84.48 //y=7.58 //x2=84.48 //y2=7.58
r2129 (  151 153 ) resistor r=0.297428 //w=0.311 //l=0.74 //layer=m1 \
 //thickness=0.36 //x=84.48 //y=7.585 //x2=85.22 //y2=7.585
r2130 (  149 967 ) resistor r=3.1 //w=0.17 //l=0.51 //layer=mcon //count=3 \
 //x=83 //y=7.58 //x2=83 //y2=7.58
r2131 (  149 151 ) resistor r=0.594855 //w=0.311 //l=1.48 //layer=m1 \
 //thickness=0.36 //x=83 //y=7.585 //x2=84.48 //y2=7.585
r2132 (  147 965 ) resistor r=3.1 //w=0.17 //l=0.51 //layer=mcon //count=3 \
 //x=81.89 //y=7.58 //x2=81.89 //y2=7.58
r2133 (  147 149 ) resistor r=0.446141 //w=0.311 //l=1.11 //layer=m1 \
 //thickness=0.36 //x=81.89 //y=7.585 //x2=83 //y2=7.585
r2134 (  145 963 ) resistor r=3.1 //w=0.17 //l=0.51 //layer=mcon //count=3 \
 //x=80.78 //y=7.58 //x2=80.78 //y2=7.58
r2135 (  145 147 ) resistor r=0.446141 //w=0.311 //l=1.11 //layer=m1 \
 //thickness=0.36 //x=80.78 //y=7.585 //x2=81.89 //y2=7.585
r2136 (  143 957 ) resistor r=3.1 //w=0.17 //l=0.51 //layer=mcon //count=3 \
 //x=79.3 //y=7.58 //x2=79.3 //y2=7.58
r2137 (  143 145 ) resistor r=0.594855 //w=0.311 //l=1.48 //layer=m1 \
 //thickness=0.36 //x=79.3 //y=7.585 //x2=80.78 //y2=7.585
r2138 (  141 955 ) resistor r=3.1 //w=0.17 //l=0.51 //layer=mcon //count=3 \
 //x=78.19 //y=7.58 //x2=78.19 //y2=7.58
r2139 (  141 143 ) resistor r=0.446141 //w=0.311 //l=1.11 //layer=m1 \
 //thickness=0.36 //x=78.19 //y=7.585 //x2=79.3 //y2=7.585
r2140 (  139 924 ) resistor r=3.1 //w=0.17 //l=0.51 //layer=mcon //count=3 \
 //x=76.71 //y=7.58 //x2=76.71 //y2=7.58
r2141 (  139 141 ) resistor r=0.594855 //w=0.311 //l=1.48 //layer=m1 \
 //thickness=0.36 //x=76.71 //y=7.585 //x2=78.19 //y2=7.585
r2142 (  137 200 ) resistor r=0.028033 //w=0.35 //l=0.085 //layer=m1 \
 //thickness=0.36 //x=76.385 //y=7.585 //x2=76.3 //y2=7.585
r2143 (  137 139 ) resistor r=0.130627 //w=0.311 //l=0.325 //layer=m1 \
 //thickness=0.36 //x=76.385 //y=7.585 //x2=76.71 //y2=7.585
r2144 (  136 200 ) resistor r=0.0413265 //w=0.7 //l=0.175 //layer=m1 \
 //thickness=0.36 //x=76.3 //y=7.41 //x2=76.3 //y2=7.585
r2145 (  135 202 ) resistor r=0.0715665 //w=0.226 //l=0.115 //layer=m1 \
 //thickness=0.36 //x=76.3 //y=7.035 //x2=76.3 //y2=6.92
r2146 (  135 136 ) resistor r=0.357824 //w=0.131 //l=0.375 //layer=m1 \
 //thickness=0.36 //x=76.3 //y=7.035 //x2=76.3 //y2=7.41
r2147 (  134 922 ) resistor r=3.1 //w=0.17 //l=0.51 //layer=mcon //count=3 \
 //x=75.6 //y=7.58 //x2=75.6 //y2=7.58
r2148 (  132 197 ) resistor r=0.028033 //w=0.35 //l=0.085 //layer=m1 \
 //thickness=0.36 //x=75.505 //y=7.585 //x2=75.42 //y2=7.585
r2149 (  132 134 ) resistor r=0.0381833 //w=0.311 //l=0.095 //layer=m1 \
 //thickness=0.36 //x=75.505 //y=7.585 //x2=75.6 //y2=7.585
r2150 (  131 200 ) resistor r=0.028033 //w=0.35 //l=0.085 //layer=m1 \
 //thickness=0.36 //x=76.215 //y=7.585 //x2=76.3 //y2=7.585
r2151 (  131 134 ) resistor r=0.247186 //w=0.311 //l=0.615 //layer=m1 \
 //thickness=0.36 //x=76.215 //y=7.585 //x2=75.6 //y2=7.585
r2152 (  130 197 ) resistor r=0.0413265 //w=0.7 //l=0.175 //layer=m1 \
 //thickness=0.36 //x=75.42 //y=7.41 //x2=75.42 //y2=7.585
r2153 (  129 199 ) resistor r=0.0715665 //w=0.226 //l=0.117473 //layer=m1 \
 //thickness=0.36 //x=75.42 //y=7.035 //x2=75.425 //y2=6.92
r2154 (  129 130 ) resistor r=0.357824 //w=0.131 //l=0.375 //layer=m1 \
 //thickness=0.36 //x=75.42 //y=7.035 //x2=75.42 //y2=7.41
r2155 (  128 192 ) resistor r=0.028033 //w=0.35 //l=0.085 //layer=m1 \
 //thickness=0.36 //x=74.625 //y=7.585 //x2=74.54 //y2=7.585
r2156 (  127 197 ) resistor r=0.028033 //w=0.35 //l=0.085 //layer=m1 \
 //thickness=0.36 //x=75.335 //y=7.585 //x2=75.42 //y2=7.585
r2157 (  127 128 ) resistor r=0.28537 //w=0.311 //l=0.71 //layer=m1 \
 //thickness=0.36 //x=75.335 //y=7.585 //x2=74.625 //y2=7.585
r2158 (  126 192 ) resistor r=0.0413265 //w=0.7 //l=0.175 //layer=m1 \
 //thickness=0.36 //x=74.54 //y=7.41 //x2=74.54 //y2=7.585
r2159 (  125 196 ) resistor r=0.0712609 //w=0.23 //l=0.11649 //layer=m1 \
 //thickness=0.36 //x=74.54 //y=7.035 //x2=74.537 //y2=6.92
r2160 (  125 126 ) resistor r=0.357824 //w=0.131 //l=0.375 //layer=m1 \
 //thickness=0.36 //x=74.54 //y=7.035 //x2=74.54 //y2=7.41
r2161 (  124 914 ) resistor r=3.1 //w=0.17 //l=0.51 //layer=mcon //count=3 \
 //x=73.01 //y=7.58 //x2=73.01 //y2=7.58
r2162 (  122 904 ) resistor r=3.1 //w=0.17 //l=0.51 //layer=mcon //count=3 \
 //x=71.9 //y=7.58 //x2=71.9 //y2=7.58
r2163 (  122 124 ) resistor r=0.446141 //w=0.311 //l=1.11 //layer=m1 \
 //thickness=0.36 //x=71.9 //y=7.585 //x2=73.01 //y2=7.585
r2164 (  120 886 ) resistor r=3.1 //w=0.17 //l=0.51 //layer=mcon //count=3 \
 //x=70.79 //y=7.58 //x2=70.79 //y2=7.58
r2165 (  120 122 ) resistor r=0.446141 //w=0.311 //l=1.11 //layer=m1 \
 //thickness=0.36 //x=70.79 //y=7.585 //x2=71.9 //y2=7.585
r2166 (  118 874 ) resistor r=3.1 //w=0.17 //l=0.51 //layer=mcon //count=3 \
 //x=69.68 //y=7.58 //x2=69.68 //y2=7.58
r2167 (  118 120 ) resistor r=0.446141 //w=0.311 //l=1.11 //layer=m1 \
 //thickness=0.36 //x=69.68 //y=7.585 //x2=70.79 //y2=7.585
r2168 (  116 1080 ) resistor r=3.1 //w=0.17 //l=0.51 //layer=mcon //count=3 \
 //x=68.2 //y=7.58 //x2=68.2 //y2=7.58
r2169 (  116 118 ) resistor r=0.594855 //w=0.311 //l=1.48 //layer=m1 \
 //thickness=0.36 //x=68.2 //y=7.585 //x2=69.68 //y2=7.585
r2170 (  114 852 ) resistor r=3.1 //w=0.17 //l=0.51 //layer=mcon //count=3 \
 //x=67.09 //y=7.58 //x2=67.09 //y2=7.58
r2171 (  114 116 ) resistor r=0.446141 //w=0.311 //l=1.11 //layer=m1 \
 //thickness=0.36 //x=67.09 //y=7.585 //x2=68.2 //y2=7.585
r2172 (  112 840 ) resistor r=3.1 //w=0.17 //l=0.51 //layer=mcon //count=3 \
 //x=65.98 //y=7.58 //x2=65.98 //y2=7.58
r2173 (  112 114 ) resistor r=0.446141 //w=0.311 //l=1.11 //layer=m1 \
 //thickness=0.36 //x=65.98 //y=7.585 //x2=67.09 //y2=7.585
r2174 (  110 826 ) resistor r=3.1 //w=0.17 //l=0.51 //layer=mcon //count=3 \
 //x=64.5 //y=7.58 //x2=64.5 //y2=7.58
r2175 (  110 112 ) resistor r=0.594855 //w=0.311 //l=1.48 //layer=m1 \
 //thickness=0.36 //x=64.5 //y=7.585 //x2=65.98 //y2=7.585
r2176 (  108 816 ) resistor r=3.1 //w=0.17 //l=0.51 //layer=mcon //count=3 \
 //x=63.39 //y=7.58 //x2=63.39 //y2=7.58
r2177 (  108 110 ) resistor r=0.446141 //w=0.311 //l=1.11 //layer=m1 \
 //thickness=0.36 //x=63.39 //y=7.585 //x2=64.5 //y2=7.585
r2178 (  106 800 ) resistor r=3.1 //w=0.17 //l=0.51 //layer=mcon //count=3 \
 //x=61.91 //y=7.58 //x2=61.91 //y2=7.58
r2179 (  106 108 ) resistor r=0.594855 //w=0.311 //l=1.48 //layer=m1 \
 //thickness=0.36 //x=61.91 //y=7.585 //x2=63.39 //y2=7.585
r2180 (  104 790 ) resistor r=3.1 //w=0.17 //l=0.51 //layer=mcon //count=3 \
 //x=60.8 //y=7.58 //x2=60.8 //y2=7.58
r2181 (  104 106 ) resistor r=0.446141 //w=0.311 //l=1.11 //layer=m1 \
 //thickness=0.36 //x=60.8 //y=7.585 //x2=61.91 //y2=7.585
r2182 (  102 780 ) resistor r=3.1 //w=0.17 //l=0.51 //layer=mcon //count=3 \
 //x=59.69 //y=7.58 //x2=59.69 //y2=7.58
r2183 (  102 104 ) resistor r=0.446141 //w=0.311 //l=1.11 //layer=m1 \
 //thickness=0.36 //x=59.69 //y=7.585 //x2=60.8 //y2=7.585
r2184 (  100 1068 ) resistor r=3.1 //w=0.17 //l=0.51 //layer=mcon //count=3 \
 //x=58.58 //y=7.58 //x2=58.58 //y2=7.58
r2185 (  100 102 ) resistor r=0.446141 //w=0.311 //l=1.11 //layer=m1 \
 //thickness=0.36 //x=58.58 //y=7.585 //x2=59.69 //y2=7.585
r2186 (  98 756 ) resistor r=3.1 //w=0.17 //l=0.51 //layer=mcon //count=3 \
 //x=57.1 //y=7.58 //x2=57.1 //y2=7.58
r2187 (  98 100 ) resistor r=0.594855 //w=0.311 //l=1.48 //layer=m1 \
 //thickness=0.36 //x=57.1 //y=7.585 //x2=58.58 //y2=7.585
r2188 (  96 746 ) resistor r=3.1 //w=0.17 //l=0.51 //layer=mcon //count=3 \
 //x=55.99 //y=7.58 //x2=55.99 //y2=7.58
r2189 (  96 98 ) resistor r=0.446141 //w=0.311 //l=1.11 //layer=m1 \
 //thickness=0.36 //x=55.99 //y=7.585 //x2=57.1 //y2=7.585
r2190 (  94 736 ) resistor r=3.1 //w=0.17 //l=0.51 //layer=mcon //count=3 \
 //x=54.88 //y=7.58 //x2=54.88 //y2=7.58
r2191 (  94 96 ) resistor r=0.446141 //w=0.311 //l=1.11 //layer=m1 \
 //thickness=0.36 //x=54.88 //y=7.585 //x2=55.99 //y2=7.585
r2192 (  92 1062 ) resistor r=3.1 //w=0.17 //l=0.51 //layer=mcon //count=3 \
 //x=53.77 //y=7.58 //x2=53.77 //y2=7.58
r2193 (  92 94 ) resistor r=0.446141 //w=0.311 //l=1.11 //layer=m1 \
 //thickness=0.36 //x=53.77 //y=7.585 //x2=54.88 //y2=7.585
r2194 (  90 712 ) resistor r=3.1 //w=0.17 //l=0.51 //layer=mcon //count=3 \
 //x=52.29 //y=7.58 //x2=52.29 //y2=7.58
r2195 (  90 92 ) resistor r=0.594855 //w=0.311 //l=1.48 //layer=m1 \
 //thickness=0.36 //x=52.29 //y=7.585 //x2=53.77 //y2=7.585
r2196 (  88 702 ) resistor r=3.1 //w=0.17 //l=0.51 //layer=mcon //count=3 \
 //x=51.18 //y=7.58 //x2=51.18 //y2=7.58
r2197 (  88 90 ) resistor r=0.446141 //w=0.311 //l=1.11 //layer=m1 \
 //thickness=0.36 //x=51.18 //y=7.585 //x2=52.29 //y2=7.585
r2198 (  86 1057 ) resistor r=3.1 //w=0.17 //l=0.51 //layer=mcon //count=3 \
 //x=50.07 //y=7.58 //x2=50.07 //y2=7.58
r2199 (  86 88 ) resistor r=0.446141 //w=0.311 //l=1.11 //layer=m1 \
 //thickness=0.36 //x=50.07 //y=7.585 //x2=51.18 //y2=7.585
r2200 (  84 678 ) resistor r=3.1 //w=0.17 //l=0.51 //layer=mcon //count=3 \
 //x=48.59 //y=7.58 //x2=48.59 //y2=7.58
r2201 (  84 86 ) resistor r=0.594855 //w=0.311 //l=1.48 //layer=m1 \
 //thickness=0.36 //x=48.59 //y=7.585 //x2=50.07 //y2=7.585
r2202 (  82 668 ) resistor r=3.1 //w=0.17 //l=0.51 //layer=mcon //count=3 \
 //x=47.48 //y=7.58 //x2=47.48 //y2=7.58
r2203 (  82 84 ) resistor r=0.446141 //w=0.311 //l=1.11 //layer=m1 \
 //thickness=0.36 //x=47.48 //y=7.585 //x2=48.59 //y2=7.585
r2204 (  80 650 ) resistor r=3.1 //w=0.17 //l=0.51 //layer=mcon //count=3 \
 //x=46.37 //y=7.58 //x2=46.37 //y2=7.58
r2205 (  80 82 ) resistor r=0.446141 //w=0.311 //l=1.11 //layer=m1 \
 //thickness=0.36 //x=46.37 //y=7.585 //x2=47.48 //y2=7.585
r2206 (  78 638 ) resistor r=3.1 //w=0.17 //l=0.51 //layer=mcon //count=3 \
 //x=45.26 //y=7.58 //x2=45.26 //y2=7.58
r2207 (  78 80 ) resistor r=0.446141 //w=0.311 //l=1.11 //layer=m1 \
 //thickness=0.36 //x=45.26 //y=7.585 //x2=46.37 //y2=7.585
r2208 (  76 1049 ) resistor r=3.1 //w=0.17 //l=0.51 //layer=mcon //count=3 \
 //x=43.78 //y=7.58 //x2=43.78 //y2=7.58
r2209 (  76 78 ) resistor r=0.594855 //w=0.311 //l=1.48 //layer=m1 \
 //thickness=0.36 //x=43.78 //y=7.585 //x2=45.26 //y2=7.585
r2210 (  73 616 ) resistor r=3.1 //w=0.17 //l=0.51 //layer=mcon //count=3 \
 //x=42.67 //y=7.58 //x2=42.67 //y2=7.58
r2211 (  71 604 ) resistor r=3.1 //w=0.17 //l=0.51 //layer=mcon //count=3 \
 //x=41.56 //y=7.58 //x2=41.56 //y2=7.58
r2212 (  71 73 ) resistor r=0.446141 //w=0.311 //l=1.11 //layer=m1 \
 //thickness=0.36 //x=41.56 //y=7.585 //x2=42.67 //y2=7.585
r2213 (  69 590 ) resistor r=3.1 //w=0.17 //l=0.51 //layer=mcon //count=3 \
 //x=40.08 //y=7.58 //x2=40.08 //y2=7.58
r2214 (  69 71 ) resistor r=0.594855 //w=0.311 //l=1.48 //layer=m1 \
 //thickness=0.36 //x=40.08 //y=7.585 //x2=41.56 //y2=7.585
r2215 (  67 580 ) resistor r=3.1 //w=0.17 //l=0.51 //layer=mcon //count=3 \
 //x=38.97 //y=7.58 //x2=38.97 //y2=7.58
r2216 (  67 69 ) resistor r=0.446141 //w=0.311 //l=1.11 //layer=m1 \
 //thickness=0.36 //x=38.97 //y=7.585 //x2=40.08 //y2=7.585
r2217 (  65 564 ) resistor r=3.1 //w=0.17 //l=0.51 //layer=mcon //count=3 \
 //x=37.49 //y=7.58 //x2=37.49 //y2=7.58
r2218 (  65 67 ) resistor r=0.594855 //w=0.311 //l=1.48 //layer=m1 \
 //thickness=0.36 //x=37.49 //y=7.585 //x2=38.97 //y2=7.585
r2219 (  63 554 ) resistor r=3.1 //w=0.17 //l=0.51 //layer=mcon //count=3 \
 //x=36.38 //y=7.58 //x2=36.38 //y2=7.58
r2220 (  63 65 ) resistor r=0.446141 //w=0.311 //l=1.11 //layer=m1 \
 //thickness=0.36 //x=36.38 //y=7.585 //x2=37.49 //y2=7.585
r2221 (  61 544 ) resistor r=3.1 //w=0.17 //l=0.51 //layer=mcon //count=3 \
 //x=35.27 //y=7.58 //x2=35.27 //y2=7.58
r2222 (  61 63 ) resistor r=0.446141 //w=0.311 //l=1.11 //layer=m1 \
 //thickness=0.36 //x=35.27 //y=7.585 //x2=36.38 //y2=7.585
r2223 (  59 1037 ) resistor r=3.1 //w=0.17 //l=0.51 //layer=mcon //count=3 \
 //x=34.16 //y=7.58 //x2=34.16 //y2=7.58
r2224 (  59 61 ) resistor r=0.446141 //w=0.311 //l=1.11 //layer=m1 \
 //thickness=0.36 //x=34.16 //y=7.585 //x2=35.27 //y2=7.585
r2225 (  57 520 ) resistor r=3.1 //w=0.17 //l=0.51 //layer=mcon //count=3 \
 //x=32.68 //y=7.58 //x2=32.68 //y2=7.58
r2226 (  57 59 ) resistor r=0.594855 //w=0.311 //l=1.48 //layer=m1 \
 //thickness=0.36 //x=32.68 //y=7.585 //x2=34.16 //y2=7.585
r2227 (  55 510 ) resistor r=3.1 //w=0.17 //l=0.51 //layer=mcon //count=3 \
 //x=31.57 //y=7.58 //x2=31.57 //y2=7.58
r2228 (  55 57 ) resistor r=0.446141 //w=0.311 //l=1.11 //layer=m1 \
 //thickness=0.36 //x=31.57 //y=7.585 //x2=32.68 //y2=7.585
r2229 (  53 500 ) resistor r=3.1 //w=0.17 //l=0.51 //layer=mcon //count=3 \
 //x=30.46 //y=7.58 //x2=30.46 //y2=7.58
r2230 (  53 55 ) resistor r=0.446141 //w=0.311 //l=1.11 //layer=m1 \
 //thickness=0.36 //x=30.46 //y=7.585 //x2=31.57 //y2=7.585
r2231 (  51 1031 ) resistor r=3.1 //w=0.17 //l=0.51 //layer=mcon //count=3 \
 //x=29.35 //y=7.58 //x2=29.35 //y2=7.58
r2232 (  51 53 ) resistor r=0.446141 //w=0.311 //l=1.11 //layer=m1 \
 //thickness=0.36 //x=29.35 //y=7.585 //x2=30.46 //y2=7.585
r2233 (  49 476 ) resistor r=3.1 //w=0.17 //l=0.51 //layer=mcon //count=3 \
 //x=27.87 //y=7.58 //x2=27.87 //y2=7.58
r2234 (  49 51 ) resistor r=0.594855 //w=0.311 //l=1.48 //layer=m1 \
 //thickness=0.36 //x=27.87 //y=7.585 //x2=29.35 //y2=7.585
r2235 (  47 466 ) resistor r=3.1 //w=0.17 //l=0.51 //layer=mcon //count=3 \
 //x=26.76 //y=7.58 //x2=26.76 //y2=7.58
r2236 (  47 49 ) resistor r=0.446141 //w=0.311 //l=1.11 //layer=m1 \
 //thickness=0.36 //x=26.76 //y=7.585 //x2=27.87 //y2=7.585
r2237 (  45 1026 ) resistor r=3.1 //w=0.17 //l=0.51 //layer=mcon //count=3 \
 //x=25.65 //y=7.58 //x2=25.65 //y2=7.58
r2238 (  45 47 ) resistor r=0.446141 //w=0.311 //l=1.11 //layer=m1 \
 //thickness=0.36 //x=25.65 //y=7.585 //x2=26.76 //y2=7.585
r2239 (  43 442 ) resistor r=3.1 //w=0.17 //l=0.51 //layer=mcon //count=3 \
 //x=24.17 //y=7.58 //x2=24.17 //y2=7.58
r2240 (  43 45 ) resistor r=0.594855 //w=0.311 //l=1.48 //layer=m1 \
 //thickness=0.36 //x=24.17 //y=7.585 //x2=25.65 //y2=7.585
r2241 (  41 432 ) resistor r=3.1 //w=0.17 //l=0.51 //layer=mcon //count=3 \
 //x=23.06 //y=7.58 //x2=23.06 //y2=7.58
r2242 (  41 43 ) resistor r=0.446141 //w=0.311 //l=1.11 //layer=m1 \
 //thickness=0.36 //x=23.06 //y=7.585 //x2=24.17 //y2=7.585
r2243 (  39 414 ) resistor r=3.1 //w=0.17 //l=0.51 //layer=mcon //count=3 \
 //x=21.95 //y=7.58 //x2=21.95 //y2=7.58
r2244 (  39 41 ) resistor r=0.446141 //w=0.311 //l=1.11 //layer=m1 \
 //thickness=0.36 //x=21.95 //y=7.585 //x2=23.06 //y2=7.585
r2245 (  37 402 ) resistor r=3.1 //w=0.17 //l=0.51 //layer=mcon //count=3 \
 //x=20.84 //y=7.58 //x2=20.84 //y2=7.58
r2246 (  37 39 ) resistor r=0.446141 //w=0.311 //l=1.11 //layer=m1 \
 //thickness=0.36 //x=20.84 //y=7.585 //x2=21.95 //y2=7.585
r2247 (  35 1018 ) resistor r=3.1 //w=0.17 //l=0.51 //layer=mcon //count=3 \
 //x=19.36 //y=7.58 //x2=19.36 //y2=7.58
r2248 (  35 37 ) resistor r=0.594855 //w=0.311 //l=1.48 //layer=m1 \
 //thickness=0.36 //x=19.36 //y=7.585 //x2=20.84 //y2=7.585
r2249 (  33 380 ) resistor r=3.1 //w=0.17 //l=0.51 //layer=mcon //count=3 \
 //x=18.25 //y=7.58 //x2=18.25 //y2=7.58
r2250 (  33 35 ) resistor r=0.446141 //w=0.311 //l=1.11 //layer=m1 \
 //thickness=0.36 //x=18.25 //y=7.585 //x2=19.36 //y2=7.585
r2251 (  31 368 ) resistor r=3.1 //w=0.17 //l=0.51 //layer=mcon //count=3 \
 //x=17.14 //y=7.58 //x2=17.14 //y2=7.58
r2252 (  31 33 ) resistor r=0.446141 //w=0.311 //l=1.11 //layer=m1 \
 //thickness=0.36 //x=17.14 //y=7.585 //x2=18.25 //y2=7.585
r2253 (  29 354 ) resistor r=3.1 //w=0.17 //l=0.51 //layer=mcon //count=3 \
 //x=15.66 //y=7.58 //x2=15.66 //y2=7.58
r2254 (  29 31 ) resistor r=0.594855 //w=0.311 //l=1.48 //layer=m1 \
 //thickness=0.36 //x=15.66 //y=7.585 //x2=17.14 //y2=7.585
r2255 (  27 344 ) resistor r=3.1 //w=0.17 //l=0.51 //layer=mcon //count=3 \
 //x=14.55 //y=7.58 //x2=14.55 //y2=7.58
r2256 (  27 29 ) resistor r=0.446141 //w=0.311 //l=1.11 //layer=m1 \
 //thickness=0.36 //x=14.55 //y=7.585 //x2=15.66 //y2=7.585
r2257 (  25 328 ) resistor r=3.1 //w=0.17 //l=0.51 //layer=mcon //count=3 \
 //x=13.07 //y=7.58 //x2=13.07 //y2=7.58
r2258 (  25 27 ) resistor r=0.594855 //w=0.311 //l=1.48 //layer=m1 \
 //thickness=0.36 //x=13.07 //y=7.585 //x2=14.55 //y2=7.585
r2259 (  23 318 ) resistor r=3.1 //w=0.17 //l=0.51 //layer=mcon //count=3 \
 //x=11.96 //y=7.58 //x2=11.96 //y2=7.58
r2260 (  23 25 ) resistor r=0.446141 //w=0.311 //l=1.11 //layer=m1 \
 //thickness=0.36 //x=11.96 //y=7.585 //x2=13.07 //y2=7.585
r2261 (  21 308 ) resistor r=3.1 //w=0.17 //l=0.51 //layer=mcon //count=3 \
 //x=10.85 //y=7.58 //x2=10.85 //y2=7.58
r2262 (  21 23 ) resistor r=0.446141 //w=0.311 //l=1.11 //layer=m1 \
 //thickness=0.36 //x=10.85 //y=7.585 //x2=11.96 //y2=7.585
r2263 (  19 1006 ) resistor r=3.1 //w=0.17 //l=0.51 //layer=mcon //count=3 \
 //x=9.74 //y=7.58 //x2=9.74 //y2=7.58
r2264 (  19 21 ) resistor r=0.446141 //w=0.311 //l=1.11 //layer=m1 \
 //thickness=0.36 //x=9.74 //y=7.585 //x2=10.85 //y2=7.585
r2265 (  17 284 ) resistor r=3.1 //w=0.17 //l=0.51 //layer=mcon //count=3 \
 //x=8.26 //y=7.58 //x2=8.26 //y2=7.58
r2266 (  17 19 ) resistor r=0.594855 //w=0.311 //l=1.48 //layer=m1 \
 //thickness=0.36 //x=8.26 //y=7.585 //x2=9.74 //y2=7.585
r2267 (  15 274 ) resistor r=3.1 //w=0.17 //l=0.51 //layer=mcon //count=3 \
 //x=7.15 //y=7.58 //x2=7.15 //y2=7.58
r2268 (  15 17 ) resistor r=0.446141 //w=0.311 //l=1.11 //layer=m1 \
 //thickness=0.36 //x=7.15 //y=7.585 //x2=8.26 //y2=7.585
r2269 (  13 264 ) resistor r=3.1 //w=0.17 //l=0.51 //layer=mcon //count=3 \
 //x=6.04 //y=7.58 //x2=6.04 //y2=7.58
r2270 (  13 15 ) resistor r=0.446141 //w=0.311 //l=1.11 //layer=m1 \
 //thickness=0.36 //x=6.04 //y=7.585 //x2=7.15 //y2=7.585
r2271 (  11 1000 ) resistor r=3.1 //w=0.17 //l=0.51 //layer=mcon //count=3 \
 //x=4.93 //y=7.58 //x2=4.93 //y2=7.58
r2272 (  11 13 ) resistor r=0.446141 //w=0.311 //l=1.11 //layer=m1 \
 //thickness=0.36 //x=4.93 //y=7.585 //x2=6.04 //y2=7.585
r2273 (  9 240 ) resistor r=3.1 //w=0.17 //l=0.51 //layer=mcon //count=3 \
 //x=3.45 //y=7.58 //x2=3.45 //y2=7.58
r2274 (  9 11 ) resistor r=0.594855 //w=0.311 //l=1.48 //layer=m1 \
 //thickness=0.36 //x=3.45 //y=7.585 //x2=4.93 //y2=7.585
r2275 (  7 230 ) resistor r=3.1 //w=0.17 //l=0.51 //layer=mcon //count=3 \
 //x=2.34 //y=7.58 //x2=2.34 //y2=7.58
r2276 (  7 9 ) resistor r=0.446141 //w=0.311 //l=1.11 //layer=m1 \
 //thickness=0.36 //x=2.34 //y=7.585 //x2=3.45 //y2=7.585
r2277 (  4 995 ) resistor r=3.1 //w=0.17 //l=0.51 //layer=mcon //count=3 \
 //x=1.23 //y=7.58 //x2=1.23 //y2=7.58
r2278 (  4 7 ) resistor r=0.446141 //w=0.311 //l=1.11 //layer=m1 \
 //thickness=0.36 //x=1.23 //y=7.585 //x2=2.34 //y2=7.585
r2279 (  2 192 ) resistor r=0.028033 //w=0.35 //l=0.085 //layer=m1 \
 //thickness=0.36 //x=74.455 //y=7.585 //x2=74.54 //y2=7.585
r2280 (  2 124 ) resistor r=0.580788 //w=0.311 //l=1.445 //layer=m1 \
 //thickness=0.36 //x=74.455 //y=7.585 //x2=73.01 //y2=7.585
r2281 (  1 76 ) resistor r=0.223071 //w=0.311 //l=0.555 //layer=m1 \
 //thickness=0.36 //x=43.225 //y=7.585 //x2=43.78 //y2=7.585
r2282 (  1 73 ) resistor r=0.223071 //w=0.311 //l=0.555 //layer=m1 \
 //thickness=0.36 //x=43.225 //y=7.585 //x2=42.67 //y2=7.585
ends PM_TMRDFFSNQX1\%VDD

subckt PM_TMRDFFSNQX1\%noxref_24 ( 5 7 15 19 30 33 34 )
c67 ( 34 0 ) capacitor c=0.0457851f //x=6.785 //y=0.555
c68 ( 33 0 ) capacitor c=0.0195185f //x=5.68 //y=1.09
c69 ( 30 0 ) capacitor c=0.00141302f //x=6.92 //y=1.175
c70 ( 19 0 ) capacitor c=0.00692795f //x=7.89 //y=0.805
c71 ( 15 0 ) capacitor c=0.0154984f //x=7.805 //y=0.72
c72 ( 7 0 ) capacitor c=0.00689459f //x=6.92 //y=0.805
c73 ( 5 0 ) capacitor c=0.0241875f //x=6.835 //y=1.175
r74 (  19 34 ) resistor r=3.57586 //w=0.17 //l=0.125 //layer=li \
 //thickness=0.1 //x=7.89 //y=0.805 //x2=7.89 //y2=0.68
r75 (  19 34 ) resistor r=18.139 //w=0.187 //l=0.265 //layer=li \
 //thickness=0.1 //x=7.89 //y=0.805 //x2=7.89 //y2=1.07
r76 (  16 34 ) resistor r=3.57586 //w=0.17 //l=0.103078 //layer=li \
 //thickness=0.1 //x=7.005 //y=0.72 //x2=6.92 //y2=0.68
r77 (  16 34 ) resistor r=27.3797 //w=0.187 //l=0.4 //layer=li //thickness=0.1 \
 //x=7.005 //y=0.72 //x2=7.405 //y2=0.72
r78 (  15 34 ) resistor r=3.57586 //w=0.17 //l=0.103078 //layer=li \
 //thickness=0.1 //x=7.805 //y=0.72 //x2=7.89 //y2=0.68
r79 (  15 34 ) resistor r=27.3797 //w=0.187 //l=0.4 //layer=li //thickness=0.1 \
 //x=7.805 //y=0.72 //x2=7.405 //y2=0.72
r80 (  11 30 ) resistor r=5.4201 //w=0.17 //l=0.085 //layer=li //thickness=0.1 \
 //x=6.92 //y=1.26 //x2=6.92 //y2=1.175
r81 (  11 34 ) resistor r=10.2674 //w=0.187 //l=0.15 //layer=li \
 //thickness=0.1 //x=6.92 //y=1.26 //x2=6.92 //y2=1.41
r82 (  8 30 ) resistor r=5.4201 //w=0.17 //l=0.085 //layer=li //thickness=0.1 \
 //x=6.92 //y=1.09 //x2=6.92 //y2=1.175
r83 (  8 34 ) resistor r=1.36898 //w=0.187 //l=0.02 //layer=li //thickness=0.1 \
 //x=6.92 //y=1.09 //x2=6.92 //y2=1.07
r84 (  7 34 ) resistor r=3.57586 //w=0.17 //l=0.125 //layer=li //thickness=0.1 \
 //x=6.92 //y=0.805 //x2=6.92 //y2=0.68
r85 (  7 34 ) resistor r=18.139 //w=0.187 //l=0.265 //layer=li //thickness=0.1 \
 //x=6.92 //y=0.805 //x2=6.92 //y2=1.07
r86 (  6 33 ) resistor r=0.751729 //w=0.17 //l=0.085 //layer=li \
 //thickness=0.1 //x=5.955 //y=1.175 //x2=5.87 //y2=1.175
r87 (  5 30 ) resistor r=1.40859 //w=0.34 //l=0.085 //layer=li //thickness=0.1 \
 //x=6.835 //y=1.175 //x2=6.92 //y2=1.175
r88 (  5 6 ) resistor r=60.2353 //w=0.187 //l=0.88 //layer=li //thickness=0.1 \
 //x=6.835 //y=1.175 //x2=5.955 //y2=1.175
ends PM_TMRDFFSNQX1\%noxref_24

subckt PM_TMRDFFSNQX1\%noxref_25 ( 5 7 15 19 30 33 34 )
c69 ( 34 0 ) capacitor c=0.044206f //x=11.595 //y=0.555
c70 ( 33 0 ) capacitor c=0.0191162f //x=10.49 //y=1.09
c71 ( 30 0 ) capacitor c=0.00141302f //x=11.73 //y=1.175
c72 ( 19 0 ) capacitor c=0.00695768f //x=12.7 //y=0.805
c73 ( 15 0 ) capacitor c=0.0154882f //x=12.615 //y=0.72
c74 ( 7 0 ) capacitor c=0.00689476f //x=11.73 //y=0.805
c75 ( 5 0 ) capacitor c=0.0235962f //x=11.645 //y=1.175
r76 (  19 34 ) resistor r=3.57586 //w=0.17 //l=0.125 //layer=li \
 //thickness=0.1 //x=12.7 //y=0.805 //x2=12.7 //y2=0.68
r77 (  19 34 ) resistor r=18.139 //w=0.187 //l=0.265 //layer=li \
 //thickness=0.1 //x=12.7 //y=0.805 //x2=12.7 //y2=1.07
r78 (  16 34 ) resistor r=3.57586 //w=0.17 //l=0.103078 //layer=li \
 //thickness=0.1 //x=11.815 //y=0.72 //x2=11.73 //y2=0.68
r79 (  16 34 ) resistor r=27.3797 //w=0.187 //l=0.4 //layer=li //thickness=0.1 \
 //x=11.815 //y=0.72 //x2=12.215 //y2=0.72
r80 (  15 34 ) resistor r=3.57586 //w=0.17 //l=0.103078 //layer=li \
 //thickness=0.1 //x=12.615 //y=0.72 //x2=12.7 //y2=0.68
r81 (  15 34 ) resistor r=27.3797 //w=0.187 //l=0.4 //layer=li //thickness=0.1 \
 //x=12.615 //y=0.72 //x2=12.215 //y2=0.72
r82 (  11 30 ) resistor r=5.4201 //w=0.17 //l=0.085 //layer=li //thickness=0.1 \
 //x=11.73 //y=1.26 //x2=11.73 //y2=1.175
r83 (  11 34 ) resistor r=10.2674 //w=0.187 //l=0.15 //layer=li \
 //thickness=0.1 //x=11.73 //y=1.26 //x2=11.73 //y2=1.41
r84 (  8 30 ) resistor r=5.4201 //w=0.17 //l=0.085 //layer=li //thickness=0.1 \
 //x=11.73 //y=1.09 //x2=11.73 //y2=1.175
r85 (  8 34 ) resistor r=1.36898 //w=0.187 //l=0.02 //layer=li //thickness=0.1 \
 //x=11.73 //y=1.09 //x2=11.73 //y2=1.07
r86 (  7 34 ) resistor r=3.57586 //w=0.17 //l=0.125 //layer=li //thickness=0.1 \
 //x=11.73 //y=0.805 //x2=11.73 //y2=0.68
r87 (  7 34 ) resistor r=18.139 //w=0.187 //l=0.265 //layer=li //thickness=0.1 \
 //x=11.73 //y=0.805 //x2=11.73 //y2=1.07
r88 (  6 33 ) resistor r=0.751729 //w=0.17 //l=0.085 //layer=li \
 //thickness=0.1 //x=10.765 //y=1.175 //x2=10.68 //y2=1.175
r89 (  5 30 ) resistor r=1.40859 //w=0.34 //l=0.085 //layer=li //thickness=0.1 \
 //x=11.645 //y=1.175 //x2=11.73 //y2=1.175
r90 (  5 6 ) resistor r=60.2353 //w=0.187 //l=0.88 //layer=li //thickness=0.1 \
 //x=11.645 //y=1.175 //x2=10.765 //y2=1.175
ends PM_TMRDFFSNQX1\%noxref_25

subckt PM_TMRDFFSNQX1\%noxref_26 ( 5 7 15 19 30 33 34 )
c69 ( 34 0 ) capacitor c=0.0449454f //x=23.065 //y=0.555
c70 ( 33 0 ) capacitor c=0.0189646f //x=21.96 //y=1.09
c71 ( 30 0 ) capacitor c=0.00141302f //x=23.2 //y=1.175
c72 ( 19 0 ) capacitor c=0.00695768f //x=24.17 //y=0.805
c73 ( 15 0 ) capacitor c=0.0154873f //x=24.085 //y=0.72
c74 ( 7 0 ) capacitor c=0.00689476f //x=23.2 //y=0.805
c75 ( 5 0 ) capacitor c=0.0235962f //x=23.115 //y=1.175
r76 (  19 34 ) resistor r=3.57586 //w=0.17 //l=0.125 //layer=li \
 //thickness=0.1 //x=24.17 //y=0.805 //x2=24.17 //y2=0.68
r77 (  19 34 ) resistor r=18.139 //w=0.187 //l=0.265 //layer=li \
 //thickness=0.1 //x=24.17 //y=0.805 //x2=24.17 //y2=1.07
r78 (  16 34 ) resistor r=3.57586 //w=0.17 //l=0.103078 //layer=li \
 //thickness=0.1 //x=23.285 //y=0.72 //x2=23.2 //y2=0.68
r79 (  16 34 ) resistor r=27.3797 //w=0.187 //l=0.4 //layer=li //thickness=0.1 \
 //x=23.285 //y=0.72 //x2=23.685 //y2=0.72
r80 (  15 34 ) resistor r=3.57586 //w=0.17 //l=0.103078 //layer=li \
 //thickness=0.1 //x=24.085 //y=0.72 //x2=24.17 //y2=0.68
r81 (  15 34 ) resistor r=27.3797 //w=0.187 //l=0.4 //layer=li //thickness=0.1 \
 //x=24.085 //y=0.72 //x2=23.685 //y2=0.72
r82 (  11 30 ) resistor r=5.4201 //w=0.17 //l=0.085 //layer=li //thickness=0.1 \
 //x=23.2 //y=1.26 //x2=23.2 //y2=1.175
r83 (  11 34 ) resistor r=10.2674 //w=0.187 //l=0.15 //layer=li \
 //thickness=0.1 //x=23.2 //y=1.26 //x2=23.2 //y2=1.41
r84 (  8 30 ) resistor r=5.4201 //w=0.17 //l=0.085 //layer=li //thickness=0.1 \
 //x=23.2 //y=1.09 //x2=23.2 //y2=1.175
r85 (  8 34 ) resistor r=1.36898 //w=0.187 //l=0.02 //layer=li //thickness=0.1 \
 //x=23.2 //y=1.09 //x2=23.2 //y2=1.07
r86 (  7 34 ) resistor r=3.57586 //w=0.17 //l=0.125 //layer=li //thickness=0.1 \
 //x=23.2 //y=0.805 //x2=23.2 //y2=0.68
r87 (  7 34 ) resistor r=18.139 //w=0.187 //l=0.265 //layer=li //thickness=0.1 \
 //x=23.2 //y=0.805 //x2=23.2 //y2=1.07
r88 (  6 33 ) resistor r=0.751729 //w=0.17 //l=0.085 //layer=li \
 //thickness=0.1 //x=22.235 //y=1.175 //x2=22.15 //y2=1.175
r89 (  5 30 ) resistor r=1.40859 //w=0.34 //l=0.085 //layer=li //thickness=0.1 \
 //x=23.115 //y=1.175 //x2=23.2 //y2=1.175
r90 (  5 6 ) resistor r=60.2353 //w=0.187 //l=0.88 //layer=li //thickness=0.1 \
 //x=23.115 //y=1.175 //x2=22.235 //y2=1.175
ends PM_TMRDFFSNQX1\%noxref_26

subckt PM_TMRDFFSNQX1\%noxref_27 ( 5 7 15 19 30 33 34 )
c67 ( 34 0 ) capacitor c=0.0456187f //x=31.205 //y=0.555
c68 ( 33 0 ) capacitor c=0.0194877f //x=30.1 //y=1.09
c69 ( 30 0 ) capacitor c=0.00141302f //x=31.34 //y=1.175
c70 ( 19 0 ) capacitor c=0.00692795f //x=32.31 //y=0.805
c71 ( 15 0 ) capacitor c=0.0154882f //x=32.225 //y=0.72
c72 ( 7 0 ) capacitor c=0.00689459f //x=31.34 //y=0.805
c73 ( 5 0 ) capacitor c=0.0235962f //x=31.255 //y=1.175
r74 (  19 34 ) resistor r=3.57586 //w=0.17 //l=0.125 //layer=li \
 //thickness=0.1 //x=32.31 //y=0.805 //x2=32.31 //y2=0.68
r75 (  19 34 ) resistor r=18.139 //w=0.187 //l=0.265 //layer=li \
 //thickness=0.1 //x=32.31 //y=0.805 //x2=32.31 //y2=1.07
r76 (  16 34 ) resistor r=3.57586 //w=0.17 //l=0.103078 //layer=li \
 //thickness=0.1 //x=31.425 //y=0.72 //x2=31.34 //y2=0.68
r77 (  16 34 ) resistor r=27.3797 //w=0.187 //l=0.4 //layer=li //thickness=0.1 \
 //x=31.425 //y=0.72 //x2=31.825 //y2=0.72
r78 (  15 34 ) resistor r=3.57586 //w=0.17 //l=0.103078 //layer=li \
 //thickness=0.1 //x=32.225 //y=0.72 //x2=32.31 //y2=0.68
r79 (  15 34 ) resistor r=27.3797 //w=0.187 //l=0.4 //layer=li //thickness=0.1 \
 //x=32.225 //y=0.72 //x2=31.825 //y2=0.72
r80 (  11 30 ) resistor r=5.4201 //w=0.17 //l=0.085 //layer=li //thickness=0.1 \
 //x=31.34 //y=1.26 //x2=31.34 //y2=1.175
r81 (  11 34 ) resistor r=10.2674 //w=0.187 //l=0.15 //layer=li \
 //thickness=0.1 //x=31.34 //y=1.26 //x2=31.34 //y2=1.41
r82 (  8 30 ) resistor r=5.4201 //w=0.17 //l=0.085 //layer=li //thickness=0.1 \
 //x=31.34 //y=1.09 //x2=31.34 //y2=1.175
r83 (  8 34 ) resistor r=1.36898 //w=0.187 //l=0.02 //layer=li //thickness=0.1 \
 //x=31.34 //y=1.09 //x2=31.34 //y2=1.07
r84 (  7 34 ) resistor r=3.57586 //w=0.17 //l=0.125 //layer=li //thickness=0.1 \
 //x=31.34 //y=0.805 //x2=31.34 //y2=0.68
r85 (  7 34 ) resistor r=18.139 //w=0.187 //l=0.265 //layer=li //thickness=0.1 \
 //x=31.34 //y=0.805 //x2=31.34 //y2=1.07
r86 (  6 33 ) resistor r=0.751729 //w=0.17 //l=0.085 //layer=li \
 //thickness=0.1 //x=30.375 //y=1.175 //x2=30.29 //y2=1.175
r87 (  5 30 ) resistor r=1.40859 //w=0.34 //l=0.085 //layer=li //thickness=0.1 \
 //x=31.255 //y=1.175 //x2=31.34 //y2=1.175
r88 (  5 6 ) resistor r=60.2353 //w=0.187 //l=0.88 //layer=li //thickness=0.1 \
 //x=31.255 //y=1.175 //x2=30.375 //y2=1.175
ends PM_TMRDFFSNQX1\%noxref_27

subckt PM_TMRDFFSNQX1\%noxref_28 ( 5 7 15 19 30 33 34 )
c68 ( 34 0 ) capacitor c=0.044206f //x=36.015 //y=0.555
c69 ( 33 0 ) capacitor c=0.0190646f //x=34.91 //y=1.09
c70 ( 30 0 ) capacitor c=0.00141302f //x=36.15 //y=1.175
c71 ( 19 0 ) capacitor c=0.00695768f //x=37.12 //y=0.805
c72 ( 15 0 ) capacitor c=0.0154882f //x=37.035 //y=0.72
c73 ( 7 0 ) capacitor c=0.00689476f //x=36.15 //y=0.805
c74 ( 5 0 ) capacitor c=0.0235962f //x=36.065 //y=1.175
r75 (  19 34 ) resistor r=3.57586 //w=0.17 //l=0.125 //layer=li \
 //thickness=0.1 //x=37.12 //y=0.805 //x2=37.12 //y2=0.68
r76 (  19 34 ) resistor r=18.139 //w=0.187 //l=0.265 //layer=li \
 //thickness=0.1 //x=37.12 //y=0.805 //x2=37.12 //y2=1.07
r77 (  16 34 ) resistor r=3.57586 //w=0.17 //l=0.103078 //layer=li \
 //thickness=0.1 //x=36.235 //y=0.72 //x2=36.15 //y2=0.68
r78 (  16 34 ) resistor r=27.3797 //w=0.187 //l=0.4 //layer=li //thickness=0.1 \
 //x=36.235 //y=0.72 //x2=36.635 //y2=0.72
r79 (  15 34 ) resistor r=3.57586 //w=0.17 //l=0.103078 //layer=li \
 //thickness=0.1 //x=37.035 //y=0.72 //x2=37.12 //y2=0.68
r80 (  15 34 ) resistor r=27.3797 //w=0.187 //l=0.4 //layer=li //thickness=0.1 \
 //x=37.035 //y=0.72 //x2=36.635 //y2=0.72
r81 (  11 30 ) resistor r=5.4201 //w=0.17 //l=0.085 //layer=li //thickness=0.1 \
 //x=36.15 //y=1.26 //x2=36.15 //y2=1.175
r82 (  11 34 ) resistor r=10.2674 //w=0.187 //l=0.15 //layer=li \
 //thickness=0.1 //x=36.15 //y=1.26 //x2=36.15 //y2=1.41
r83 (  8 30 ) resistor r=5.4201 //w=0.17 //l=0.085 //layer=li //thickness=0.1 \
 //x=36.15 //y=1.09 //x2=36.15 //y2=1.175
r84 (  8 34 ) resistor r=1.36898 //w=0.187 //l=0.02 //layer=li //thickness=0.1 \
 //x=36.15 //y=1.09 //x2=36.15 //y2=1.07
r85 (  7 34 ) resistor r=3.57586 //w=0.17 //l=0.125 //layer=li //thickness=0.1 \
 //x=36.15 //y=0.805 //x2=36.15 //y2=0.68
r86 (  7 34 ) resistor r=18.139 //w=0.187 //l=0.265 //layer=li //thickness=0.1 \
 //x=36.15 //y=0.805 //x2=36.15 //y2=1.07
r87 (  6 33 ) resistor r=0.751729 //w=0.17 //l=0.085 //layer=li \
 //thickness=0.1 //x=35.185 //y=1.175 //x2=35.1 //y2=1.175
r88 (  5 30 ) resistor r=1.40859 //w=0.34 //l=0.085 //layer=li //thickness=0.1 \
 //x=36.065 //y=1.175 //x2=36.15 //y2=1.175
r89 (  5 6 ) resistor r=60.2353 //w=0.187 //l=0.88 //layer=li //thickness=0.1 \
 //x=36.065 //y=1.175 //x2=35.185 //y2=1.175
ends PM_TMRDFFSNQX1\%noxref_28

subckt PM_TMRDFFSNQX1\%noxref_29 ( 5 7 15 19 30 33 34 )
c69 ( 34 0 ) capacitor c=0.044206f //x=47.485 //y=0.555
c70 ( 33 0 ) capacitor c=0.0189646f //x=46.38 //y=1.09
c71 ( 30 0 ) capacitor c=0.00141302f //x=47.62 //y=1.175
c72 ( 19 0 ) capacitor c=0.00695768f //x=48.59 //y=0.805
c73 ( 15 0 ) capacitor c=0.0154873f //x=48.505 //y=0.72
c74 ( 7 0 ) capacitor c=0.00689476f //x=47.62 //y=0.805
c75 ( 5 0 ) capacitor c=0.0235962f //x=47.535 //y=1.175
r76 (  19 34 ) resistor r=3.57586 //w=0.17 //l=0.125 //layer=li \
 //thickness=0.1 //x=48.59 //y=0.805 //x2=48.59 //y2=0.68
r77 (  19 34 ) resistor r=18.139 //w=0.187 //l=0.265 //layer=li \
 //thickness=0.1 //x=48.59 //y=0.805 //x2=48.59 //y2=1.07
r78 (  16 34 ) resistor r=3.57586 //w=0.17 //l=0.103078 //layer=li \
 //thickness=0.1 //x=47.705 //y=0.72 //x2=47.62 //y2=0.68
r79 (  16 34 ) resistor r=27.3797 //w=0.187 //l=0.4 //layer=li //thickness=0.1 \
 //x=47.705 //y=0.72 //x2=48.105 //y2=0.72
r80 (  15 34 ) resistor r=3.57586 //w=0.17 //l=0.103078 //layer=li \
 //thickness=0.1 //x=48.505 //y=0.72 //x2=48.59 //y2=0.68
r81 (  15 34 ) resistor r=27.3797 //w=0.187 //l=0.4 //layer=li //thickness=0.1 \
 //x=48.505 //y=0.72 //x2=48.105 //y2=0.72
r82 (  11 30 ) resistor r=5.4201 //w=0.17 //l=0.085 //layer=li //thickness=0.1 \
 //x=47.62 //y=1.26 //x2=47.62 //y2=1.175
r83 (  11 34 ) resistor r=10.2674 //w=0.187 //l=0.15 //layer=li \
 //thickness=0.1 //x=47.62 //y=1.26 //x2=47.62 //y2=1.41
r84 (  8 30 ) resistor r=5.4201 //w=0.17 //l=0.085 //layer=li //thickness=0.1 \
 //x=47.62 //y=1.09 //x2=47.62 //y2=1.175
r85 (  8 34 ) resistor r=1.36898 //w=0.187 //l=0.02 //layer=li //thickness=0.1 \
 //x=47.62 //y=1.09 //x2=47.62 //y2=1.07
r86 (  7 34 ) resistor r=3.57586 //w=0.17 //l=0.125 //layer=li //thickness=0.1 \
 //x=47.62 //y=0.805 //x2=47.62 //y2=0.68
r87 (  7 34 ) resistor r=18.139 //w=0.187 //l=0.265 //layer=li //thickness=0.1 \
 //x=47.62 //y=0.805 //x2=47.62 //y2=1.07
r88 (  6 33 ) resistor r=0.751729 //w=0.17 //l=0.085 //layer=li \
 //thickness=0.1 //x=46.655 //y=1.175 //x2=46.57 //y2=1.175
r89 (  5 30 ) resistor r=1.40859 //w=0.34 //l=0.085 //layer=li //thickness=0.1 \
 //x=47.535 //y=1.175 //x2=47.62 //y2=1.175
r90 (  5 6 ) resistor r=60.2353 //w=0.187 //l=0.88 //layer=li //thickness=0.1 \
 //x=47.535 //y=1.175 //x2=46.655 //y2=1.175
ends PM_TMRDFFSNQX1\%noxref_29

subckt PM_TMRDFFSNQX1\%noxref_30 ( 5 7 15 19 30 33 34 )
c67 ( 34 0 ) capacitor c=0.0456187f //x=55.625 //y=0.555
c68 ( 33 0 ) capacitor c=0.0194877f //x=54.52 //y=1.09
c69 ( 30 0 ) capacitor c=0.00141302f //x=55.76 //y=1.175
c70 ( 19 0 ) capacitor c=0.00692795f //x=56.73 //y=0.805
c71 ( 15 0 ) capacitor c=0.0154882f //x=56.645 //y=0.72
c72 ( 7 0 ) capacitor c=0.00689459f //x=55.76 //y=0.805
c73 ( 5 0 ) capacitor c=0.0235962f //x=55.675 //y=1.175
r74 (  19 34 ) resistor r=3.57586 //w=0.17 //l=0.125 //layer=li \
 //thickness=0.1 //x=56.73 //y=0.805 //x2=56.73 //y2=0.68
r75 (  19 34 ) resistor r=18.139 //w=0.187 //l=0.265 //layer=li \
 //thickness=0.1 //x=56.73 //y=0.805 //x2=56.73 //y2=1.07
r76 (  16 34 ) resistor r=3.57586 //w=0.17 //l=0.103078 //layer=li \
 //thickness=0.1 //x=55.845 //y=0.72 //x2=55.76 //y2=0.68
r77 (  16 34 ) resistor r=27.3797 //w=0.187 //l=0.4 //layer=li //thickness=0.1 \
 //x=55.845 //y=0.72 //x2=56.245 //y2=0.72
r78 (  15 34 ) resistor r=3.57586 //w=0.17 //l=0.103078 //layer=li \
 //thickness=0.1 //x=56.645 //y=0.72 //x2=56.73 //y2=0.68
r79 (  15 34 ) resistor r=27.3797 //w=0.187 //l=0.4 //layer=li //thickness=0.1 \
 //x=56.645 //y=0.72 //x2=56.245 //y2=0.72
r80 (  11 30 ) resistor r=5.4201 //w=0.17 //l=0.085 //layer=li //thickness=0.1 \
 //x=55.76 //y=1.26 //x2=55.76 //y2=1.175
r81 (  11 34 ) resistor r=10.2674 //w=0.187 //l=0.15 //layer=li \
 //thickness=0.1 //x=55.76 //y=1.26 //x2=55.76 //y2=1.41
r82 (  8 30 ) resistor r=5.4201 //w=0.17 //l=0.085 //layer=li //thickness=0.1 \
 //x=55.76 //y=1.09 //x2=55.76 //y2=1.175
r83 (  8 34 ) resistor r=1.36898 //w=0.187 //l=0.02 //layer=li //thickness=0.1 \
 //x=55.76 //y=1.09 //x2=55.76 //y2=1.07
r84 (  7 34 ) resistor r=3.57586 //w=0.17 //l=0.125 //layer=li //thickness=0.1 \
 //x=55.76 //y=0.805 //x2=55.76 //y2=0.68
r85 (  7 34 ) resistor r=18.139 //w=0.187 //l=0.265 //layer=li //thickness=0.1 \
 //x=55.76 //y=0.805 //x2=55.76 //y2=1.07
r86 (  6 33 ) resistor r=0.751729 //w=0.17 //l=0.085 //layer=li \
 //thickness=0.1 //x=54.795 //y=1.175 //x2=54.71 //y2=1.175
r87 (  5 30 ) resistor r=1.40859 //w=0.34 //l=0.085 //layer=li //thickness=0.1 \
 //x=55.675 //y=1.175 //x2=55.76 //y2=1.175
r88 (  5 6 ) resistor r=60.2353 //w=0.187 //l=0.88 //layer=li //thickness=0.1 \
 //x=55.675 //y=1.175 //x2=54.795 //y2=1.175
ends PM_TMRDFFSNQX1\%noxref_30

subckt PM_TMRDFFSNQX1\%noxref_31 ( 5 7 15 19 30 33 34 )
c68 ( 34 0 ) capacitor c=0.044206f //x=60.435 //y=0.555
c69 ( 33 0 ) capacitor c=0.0190646f //x=59.33 //y=1.09
c70 ( 30 0 ) capacitor c=0.00141302f //x=60.57 //y=1.175
c71 ( 19 0 ) capacitor c=0.00695768f //x=61.54 //y=0.805
c72 ( 15 0 ) capacitor c=0.0154882f //x=61.455 //y=0.72
c73 ( 7 0 ) capacitor c=0.00689476f //x=60.57 //y=0.805
c74 ( 5 0 ) capacitor c=0.0235962f //x=60.485 //y=1.175
r75 (  19 34 ) resistor r=3.57586 //w=0.17 //l=0.125 //layer=li \
 //thickness=0.1 //x=61.54 //y=0.805 //x2=61.54 //y2=0.68
r76 (  19 34 ) resistor r=18.139 //w=0.187 //l=0.265 //layer=li \
 //thickness=0.1 //x=61.54 //y=0.805 //x2=61.54 //y2=1.07
r77 (  16 34 ) resistor r=3.57586 //w=0.17 //l=0.103078 //layer=li \
 //thickness=0.1 //x=60.655 //y=0.72 //x2=60.57 //y2=0.68
r78 (  16 34 ) resistor r=27.3797 //w=0.187 //l=0.4 //layer=li //thickness=0.1 \
 //x=60.655 //y=0.72 //x2=61.055 //y2=0.72
r79 (  15 34 ) resistor r=3.57586 //w=0.17 //l=0.103078 //layer=li \
 //thickness=0.1 //x=61.455 //y=0.72 //x2=61.54 //y2=0.68
r80 (  15 34 ) resistor r=27.3797 //w=0.187 //l=0.4 //layer=li //thickness=0.1 \
 //x=61.455 //y=0.72 //x2=61.055 //y2=0.72
r81 (  11 30 ) resistor r=5.4201 //w=0.17 //l=0.085 //layer=li //thickness=0.1 \
 //x=60.57 //y=1.26 //x2=60.57 //y2=1.175
r82 (  11 34 ) resistor r=10.2674 //w=0.187 //l=0.15 //layer=li \
 //thickness=0.1 //x=60.57 //y=1.26 //x2=60.57 //y2=1.41
r83 (  8 30 ) resistor r=5.4201 //w=0.17 //l=0.085 //layer=li //thickness=0.1 \
 //x=60.57 //y=1.09 //x2=60.57 //y2=1.175
r84 (  8 34 ) resistor r=1.36898 //w=0.187 //l=0.02 //layer=li //thickness=0.1 \
 //x=60.57 //y=1.09 //x2=60.57 //y2=1.07
r85 (  7 34 ) resistor r=3.57586 //w=0.17 //l=0.125 //layer=li //thickness=0.1 \
 //x=60.57 //y=0.805 //x2=60.57 //y2=0.68
r86 (  7 34 ) resistor r=18.139 //w=0.187 //l=0.265 //layer=li //thickness=0.1 \
 //x=60.57 //y=0.805 //x2=60.57 //y2=1.07
r87 (  6 33 ) resistor r=0.751729 //w=0.17 //l=0.085 //layer=li \
 //thickness=0.1 //x=59.605 //y=1.175 //x2=59.52 //y2=1.175
r88 (  5 30 ) resistor r=1.40859 //w=0.34 //l=0.085 //layer=li //thickness=0.1 \
 //x=60.485 //y=1.175 //x2=60.57 //y2=1.175
r89 (  5 6 ) resistor r=60.2353 //w=0.187 //l=0.88 //layer=li //thickness=0.1 \
 //x=60.485 //y=1.175 //x2=59.605 //y2=1.175
ends PM_TMRDFFSNQX1\%noxref_31

subckt PM_TMRDFFSNQX1\%noxref_32 ( 5 7 15 19 30 33 34 )
c69 ( 34 0 ) capacitor c=0.0460315f //x=71.905 //y=0.555
c70 ( 33 0 ) capacitor c=0.0189604f //x=70.8 //y=1.09
c71 ( 30 0 ) capacitor c=0.00141302f //x=72.04 //y=1.175
c72 ( 19 0 ) capacitor c=0.00695768f //x=73.01 //y=0.805
c73 ( 15 0 ) capacitor c=0.0155071f //x=72.925 //y=0.72
c74 ( 7 0 ) capacitor c=0.00689476f //x=72.04 //y=0.805
c75 ( 5 0 ) capacitor c=0.0247635f //x=71.955 //y=1.175
r76 (  19 34 ) resistor r=3.57586 //w=0.17 //l=0.125 //layer=li \
 //thickness=0.1 //x=73.01 //y=0.805 //x2=73.01 //y2=0.68
r77 (  19 34 ) resistor r=18.139 //w=0.187 //l=0.265 //layer=li \
 //thickness=0.1 //x=73.01 //y=0.805 //x2=73.01 //y2=1.07
r78 (  16 34 ) resistor r=3.57586 //w=0.17 //l=0.103078 //layer=li \
 //thickness=0.1 //x=72.125 //y=0.72 //x2=72.04 //y2=0.68
r79 (  16 34 ) resistor r=27.3797 //w=0.187 //l=0.4 //layer=li //thickness=0.1 \
 //x=72.125 //y=0.72 //x2=72.525 //y2=0.72
r80 (  15 34 ) resistor r=3.57586 //w=0.17 //l=0.103078 //layer=li \
 //thickness=0.1 //x=72.925 //y=0.72 //x2=73.01 //y2=0.68
r81 (  15 34 ) resistor r=27.3797 //w=0.187 //l=0.4 //layer=li //thickness=0.1 \
 //x=72.925 //y=0.72 //x2=72.525 //y2=0.72
r82 (  11 30 ) resistor r=5.4201 //w=0.17 //l=0.085 //layer=li //thickness=0.1 \
 //x=72.04 //y=1.26 //x2=72.04 //y2=1.175
r83 (  11 34 ) resistor r=10.2674 //w=0.187 //l=0.15 //layer=li \
 //thickness=0.1 //x=72.04 //y=1.26 //x2=72.04 //y2=1.41
r84 (  8 30 ) resistor r=5.4201 //w=0.17 //l=0.085 //layer=li //thickness=0.1 \
 //x=72.04 //y=1.09 //x2=72.04 //y2=1.175
r85 (  8 34 ) resistor r=1.36898 //w=0.187 //l=0.02 //layer=li //thickness=0.1 \
 //x=72.04 //y=1.09 //x2=72.04 //y2=1.07
r86 (  7 34 ) resistor r=3.57586 //w=0.17 //l=0.125 //layer=li //thickness=0.1 \
 //x=72.04 //y=0.805 //x2=72.04 //y2=0.68
r87 (  7 34 ) resistor r=18.139 //w=0.187 //l=0.265 //layer=li //thickness=0.1 \
 //x=72.04 //y=0.805 //x2=72.04 //y2=1.07
r88 (  6 33 ) resistor r=0.751729 //w=0.17 //l=0.085 //layer=li \
 //thickness=0.1 //x=71.075 //y=1.175 //x2=70.99 //y2=1.175
r89 (  5 30 ) resistor r=1.40859 //w=0.34 //l=0.085 //layer=li //thickness=0.1 \
 //x=71.955 //y=1.175 //x2=72.04 //y2=1.175
r90 (  5 6 ) resistor r=60.2353 //w=0.187 //l=0.88 //layer=li //thickness=0.1 \
 //x=71.955 //y=1.175 //x2=71.075 //y2=1.175
ends PM_TMRDFFSNQX1\%noxref_32

subckt PM_TMRDFFSNQX1\%noxref_33 ( 1 3 4 5 7 9 19 25 27 30 40 49 71 72 73 74 \
 75 )
c162 ( 75 0 ) capacitor c=0.0354016f //x=79.475 //y=5.205
c163 ( 74 0 ) capacitor c=0.0241107f //x=78.595 //y=5.205
c164 ( 72 0 ) capacitor c=0.00544792f //x=75.715 //y=5.205
c165 ( 71 0 ) capacitor c=0.00516996f //x=74.835 //y=5.205
c166 ( 49 0 ) capacitor c=0.0508454f //x=77.86 //y=5.39
c167 ( 40 0 ) capacitor c=0.0363228f //x=75.86 //y=5.39
c168 ( 30 0 ) capacitor c=0.0294643f //x=74.98 //y=5.56
c169 ( 27 0 ) capacitor c=0.00984489f //x=79.62 //y=6.92
c170 ( 25 0 ) capacitor c=0.0059844f //x=78.737 //y=7.09
c171 ( 19 0 ) capacitor c=0.00975753f //x=77.86 //y=6.92
c172 ( 9 0 ) capacitor c=0.014892f //x=74.982 //y=5.39
c173 ( 7 0 ) capacitor c=0.00787288f //x=79.505 //y=7.09
c174 ( 5 0 ) capacitor c=0.00659042f //x=78.62 //y=7.09
c175 ( 4 0 ) capacitor c=0.00558326f //x=75.975 //y=5.39
c176 ( 3 0 ) capacitor c=0.0636102f //x=77.745 //y=5.39
c177 ( 1 0 ) capacitor c=0.0141007f //x=75.745 //y=5.39
r178 (  49 73 ) resistor r=58.1818 //w=0.187 //l=0.85 //layer=li \
 //thickness=0.1 //x=77.86 //y=5.39 //x2=77.86 //y2=6.24
r179 (  40 72 ) resistor r=58.1818 //w=0.187 //l=0.85 //layer=li \
 //thickness=0.1 //x=75.86 //y=5.39 //x2=75.86 //y2=6.24
r180 (  30 71 ) resistor r=23.2727 //w=0.187 //l=0.34 //layer=li \
 //thickness=0.1 //x=74.98 //y=5.56 //x2=74.98 //y2=5.9
r181 (  27 75 ) resistor r=9.3 //w=0.17 //l=0.17 //layer=mcon //count=1 \
 //x=79.62 //y=6.92 //x2=79.62 //y2=6.92
r182 (  27 28 ) resistor r=0.0988372 //w=0.215 //l=0.17 //layer=m1 \
 //thickness=0.36 //x=79.622 //y=6.92 //x2=79.622 //y2=7.09
r183 (  24 74 ) resistor r=9.3 //w=0.17 //l=0.17 //layer=mcon //count=1 \
 //x=78.74 //y=6.92 //x2=78.74 //y2=6.92
r184 (  24 25 ) resistor r=0.0940266 //w=0.226 //l=0.17 //layer=m1 \
 //thickness=0.36 //x=78.737 //y=6.92 //x2=78.737 //y2=7.09
r185 (  22 49 ) resistor r=9.3 //w=0.17 //l=0.17 //layer=mcon //count=1 \
 //x=77.86 //y=5.39 //x2=77.86 //y2=5.39
r186 (  19 73 ) resistor r=9.3 //w=0.17 //l=0.17 //layer=mcon //count=1 \
 //x=77.86 //y=6.92 //x2=77.86 //y2=6.92
r187 (  19 20 ) resistor r=0.0979263 //w=0.217 //l=0.17 //layer=m1 \
 //thickness=0.36 //x=77.862 //y=6.92 //x2=77.862 //y2=7.09
r188 (  15 40 ) resistor r=9.3 //w=0.17 //l=0.17 //layer=mcon //count=1 \
 //x=75.86 //y=5.39 //x2=75.86 //y2=5.39
r189 (  11 30 ) resistor r=9.3 //w=0.17 //l=0.17 //layer=mcon //count=1 \
 //x=74.98 //y=5.56 //x2=74.98 //y2=5.56
r190 (  9 11 ) resistor r=0.0944444 //w=0.225 //l=0.17 //layer=m1 \
 //thickness=0.36 //x=74.982 //y=5.39 //x2=74.982 //y2=5.56
r191 (  8 25 ) resistor r=0.0246599 //w=0.226 //l=0.118 //layer=m1 \
 //thickness=0.36 //x=78.855 //y=7.09 //x2=78.737 //y2=7.09
r192 (  7 28 ) resistor r=0.0216707 //w=0.215 //l=0.117 //layer=m1 \
 //thickness=0.36 //x=79.505 //y=7.09 //x2=79.622 //y2=7.09
r193 (  7 8 ) resistor r=0.620229 //w=0.131 //l=0.65 //layer=m1 \
 //thickness=0.36 //x=79.505 //y=7.09 //x2=78.855 //y2=7.09
r194 (  6 20 ) resistor r=0.0222262 //w=0.217 //l=0.118 //layer=m1 \
 //thickness=0.36 //x=77.98 //y=7.09 //x2=77.862 //y2=7.09
r195 (  5 25 ) resistor r=0.0246599 //w=0.226 //l=0.117 //layer=m1 \
 //thickness=0.36 //x=78.62 //y=7.09 //x2=78.737 //y2=7.09
r196 (  5 6 ) resistor r=0.610687 //w=0.131 //l=0.64 //layer=m1 \
 //thickness=0.36 //x=78.62 //y=7.09 //x2=77.98 //y2=7.09
r197 (  4 15 ) resistor r=0.0880901 //w=0.191 //l=0.115 //layer=m1 \
 //thickness=0.36 //x=75.975 //y=5.39 //x2=75.86 //y2=5.39
r198 (  3 22 ) resistor r=0.0717383 //w=0.224 //l=0.115 //layer=m1 \
 //thickness=0.36 //x=77.745 //y=5.39 //x2=77.86 //y2=5.39
r199 (  3 4 ) resistor r=1.68893 //w=0.131 //l=1.77 //layer=m1 \
 //thickness=0.36 //x=77.745 //y=5.39 //x2=75.975 //y2=5.39
r200 (  2 9 ) resistor r=0.0243946 //w=0.225 //l=0.123 //layer=m1 \
 //thickness=0.36 //x=75.105 //y=5.39 //x2=74.982 //y2=5.39
r201 (  1 15 ) resistor r=0.0880901 //w=0.191 //l=0.115 //layer=m1 \
 //thickness=0.36 //x=75.745 //y=5.39 //x2=75.86 //y2=5.39
r202 (  1 2 ) resistor r=0.610687 //w=0.131 //l=0.64 //layer=m1 \
 //thickness=0.36 //x=75.745 //y=5.39 //x2=75.105 //y2=5.39
ends PM_TMRDFFSNQX1\%noxref_33

subckt PM_TMRDFFSNQX1\%noxref_34 ( 1 3 4 5 7 9 13 15 21 23 26 38 60 61 62 63 )
c133 ( 63 0 ) capacitor c=0.0343252f //x=82.815 //y=5.205
c134 ( 62 0 ) capacitor c=0.0239063f //x=81.935 //y=5.205
c135 ( 38 0 ) capacitor c=0.0496553f //x=81.2 //y=5.39
c136 ( 26 0 ) capacitor c=0.0229521f //x=78.3 //y=5.56
c137 ( 23 0 ) capacitor c=0.0155899f //x=82.96 //y=6.92
c138 ( 21 0 ) capacitor c=0.00566376f //x=82.08 //y=7.09
c139 ( 15 0 ) capacitor c=0.00945187f //x=81.2 //y=6.92
c140 ( 13 0 ) capacitor c=0.0163615f //x=79.18 //y=5.39
c141 ( 9 0 ) capacitor c=0.0152859f //x=78.3 //y=5.39
c142 ( 7 0 ) capacitor c=0.0068287f //x=82.83 //y=7.09
c143 ( 5 0 ) capacitor c=0.00878908f //x=81.965 //y=7.09
c144 ( 4 0 ) capacitor c=0.00826388f //x=79.295 //y=5.39
c145 ( 3 0 ) capacitor c=0.0558338f //x=81.085 //y=5.39
c146 ( 1 0 ) capacitor c=0.0183137f //x=79.065 //y=5.39
r147 (  38 61 ) resistor r=58.1818 //w=0.187 //l=0.85 //layer=li \
 //thickness=0.1 //x=81.2 //y=5.39 //x2=81.2 //y2=6.24
r148 (  26 60 ) resistor r=23.2727 //w=0.187 //l=0.34 //layer=li \
 //thickness=0.1 //x=78.3 //y=5.56 //x2=78.3 //y2=5.9
r149 (  23 63 ) resistor r=9.3 //w=0.17 //l=0.17 //layer=mcon //count=1 \
 //x=82.96 //y=6.92 //x2=82.96 //y2=6.92
r150 (  23 24 ) resistor r=0.0923913 //w=0.23 //l=0.17 //layer=m1 \
 //thickness=0.36 //x=82.955 //y=6.92 //x2=82.955 //y2=7.09
r151 (  20 62 ) resistor r=9.3 //w=0.17 //l=0.17 //layer=mcon //count=1 \
 //x=82.08 //y=6.92 //x2=82.08 //y2=6.92
r152 (  20 21 ) resistor r=0.0957207 //w=0.222 //l=0.17 //layer=m1 \
 //thickness=0.36 //x=82.08 //y=6.92 //x2=82.08 //y2=7.09
r153 (  18 38 ) resistor r=9.3 //w=0.17 //l=0.17 //layer=mcon //count=1 \
 //x=81.2 //y=5.39 //x2=81.2 //y2=5.39
r154 (  15 61 ) resistor r=9.3 //w=0.17 //l=0.17 //layer=mcon //count=1 \
 //x=81.2 //y=6.92 //x2=81.2 //y2=6.92
r155 (  15 16 ) resistor r=0.100236 //w=0.212 //l=0.17 //layer=m1 \
 //thickness=0.36 //x=81.2 //y=6.92 //x2=81.2 //y2=7.09
r156 (  11 26 ) resistor r=9.3 //w=0.17 //l=0.17 //layer=mcon //count=1 \
 //x=78.3 //y=5.56 //x2=78.3 //y2=5.56
r157 (  9 11 ) resistor r=0.100236 //w=0.212 //l=0.17 //layer=m1 \
 //thickness=0.36 //x=78.3 //y=5.39 //x2=78.3 //y2=5.56
r158 (  8 21 ) resistor r=0.0235912 //w=0.222 //l=0.115 //layer=m1 \
 //thickness=0.36 //x=82.195 //y=7.09 //x2=82.08 //y2=7.09
r159 (  7 24 ) resistor r=0.0257089 //w=0.23 //l=0.125 //layer=m1 \
 //thickness=0.36 //x=82.83 //y=7.09 //x2=82.955 //y2=7.09
r160 (  7 8 ) resistor r=0.605916 //w=0.131 //l=0.635 //layer=m1 \
 //thickness=0.36 //x=82.83 //y=7.09 //x2=82.195 //y2=7.09
r161 (  6 16 ) resistor r=0.0208269 //w=0.212 //l=0.115 //layer=m1 \
 //thickness=0.36 //x=81.315 //y=7.09 //x2=81.2 //y2=7.09
r162 (  5 21 ) resistor r=0.0235912 //w=0.222 //l=0.115 //layer=m1 \
 //thickness=0.36 //x=81.965 //y=7.09 //x2=82.08 //y2=7.09
r163 (  5 6 ) resistor r=0.620229 //w=0.131 //l=0.65 //layer=m1 \
 //thickness=0.36 //x=81.965 //y=7.09 //x2=81.315 //y2=7.09
r164 (  4 13 ) resistor r=0.0880901 //w=0.191 //l=0.115 //layer=m1 \
 //thickness=0.36 //x=79.295 //y=5.39 //x2=79.18 //y2=5.39
r165 (  3 18 ) resistor r=0.0717383 //w=0.224 //l=0.115 //layer=m1 \
 //thickness=0.36 //x=81.085 //y=5.39 //x2=81.2 //y2=5.39
r166 (  3 4 ) resistor r=1.70802 //w=0.131 //l=1.79 //layer=m1 \
 //thickness=0.36 //x=81.085 //y=5.39 //x2=79.295 //y2=5.39
r167 (  2 9 ) resistor r=0.0208269 //w=0.212 //l=0.115 //layer=m1 \
 //thickness=0.36 //x=78.415 //y=5.39 //x2=78.3 //y2=5.39
r168 (  1 13 ) resistor r=0.0880901 //w=0.191 //l=0.115 //layer=m1 \
 //thickness=0.36 //x=79.065 //y=5.39 //x2=79.18 //y2=5.39
r169 (  1 2 ) resistor r=0.620229 //w=0.131 //l=0.65 //layer=m1 \
 //thickness=0.36 //x=79.065 //y=5.39 //x2=78.415 //y2=5.39
ends PM_TMRDFFSNQX1\%noxref_34

subckt PM_TMRDFFSNQX1\%GND ( 1 2 8 15 16 25 26 36 44 53 54 66 73 74 83 84 94 \
 102 112 113 125 132 133 142 143 153 161 170 171 182 183 190 191 198 207 210 \
 211 215 220 225 226 231 232 236 240 241 245 250 255 256 261 262 266 270 271 \
 275 280 285 286 291 292 296 311 314 326 343 360 373 388 405 420 437 454 467 \
 482 499 514 531 548 561 576 593 608 621 639 644 648 660 661 662 663 664 665 \
 666 667 668 669 670 671 672 673 674 675 676 677 678 679 680 687 694 695 696 \
 697 698 699 700 701 702 703 704 705 706 707 708 709 710 711 712 713 714 715 )
c1658 ( 715 0 ) capacitor c=0.0654471f //x=84.235 //y=0.55
c1659 ( 714 0 ) capacitor c=0.00828027f //x=81.4 //y=1.045
c1660 ( 713 0 ) capacitor c=0.00867576f //x=78.07 //y=1.045
c1661 ( 712 0 ) capacitor c=0.0083251f //x=74.74 //y=1.045
c1662 ( 711 0 ) capacitor c=0.00840423f //x=69.825 //y=1.055
c1663 ( 710 0 ) capacitor c=0.00843555f //x=66.6 //y=1.045
c1664 ( 709 0 ) capacitor c=0.00843555f //x=63.27 //y=1.045
c1665 ( 708 0 ) capacitor c=0.00840423f //x=58.355 //y=1.055
c1666 ( 707 0 ) capacitor c=0.00840423f //x=53.545 //y=1.055
c1667 ( 706 0 ) capacitor c=0.00843555f //x=50.32 //y=1.045
c1668 ( 705 0 ) capacitor c=0.00840423f //x=45.405 //y=1.055
c1669 ( 704 0 ) capacitor c=0.00843555f //x=42.18 //y=1.045
c1670 ( 703 0 ) capacitor c=0.00843555f //x=38.85 //y=1.045
c1671 ( 702 0 ) capacitor c=0.00840423f //x=33.935 //y=1.055
c1672 ( 701 0 ) capacitor c=0.00840423f //x=29.125 //y=1.055
c1673 ( 700 0 ) capacitor c=0.00843555f //x=25.9 //y=1.045
c1674 ( 699 0 ) capacitor c=0.00840423f //x=20.985 //y=1.055
c1675 ( 698 0 ) capacitor c=0.00843555f //x=17.76 //y=1.045
c1676 ( 697 0 ) capacitor c=0.00843555f //x=14.43 //y=1.045
c1677 ( 696 0 ) capacitor c=0.00840423f //x=9.515 //y=1.055
c1678 ( 695 0 ) capacitor c=0.00840423f //x=4.705 //y=1.055
c1679 ( 694 0 ) capacitor c=0.00843555f //x=1.48 //y=1.045
c1680 ( 687 0 ) capacitor c=0.260313f //x=85.34 //y=0.175
c1681 ( 680 0 ) capacitor c=0.11347f //x=83.74 //y=0.175
c1682 ( 679 0 ) capacitor c=0.110242f //x=80.41 //y=0.175
c1683 ( 678 0 ) capacitor c=0.123802f //x=77.08 //y=0.175
c1684 ( 677 0 ) capacitor c=0.115672f //x=73.75 //y=0.175
c1685 ( 676 0 ) capacitor c=0.112855f //x=68.94 //y=0.175
c1686 ( 675 0 ) capacitor c=0.117575f //x=65.61 //y=0.175
c1687 ( 674 0 ) capacitor c=0.112938f //x=62.28 //y=0.175
c1688 ( 673 0 ) capacitor c=0.112435f //x=57.47 //y=0.175
c1689 ( 672 0 ) capacitor c=0.10764f //x=52.66 //y=0.175
c1690 ( 671 0 ) capacitor c=0.115075f //x=49.33 //y=0.175
c1691 ( 670 0 ) capacitor c=0.10763f //x=44.52 //y=0.175
c1692 ( 669 0 ) capacitor c=0.117089f //x=41.19 //y=0.175
c1693 ( 668 0 ) capacitor c=0.112938f //x=37.86 //y=0.175
c1694 ( 667 0 ) capacitor c=0.112435f //x=33.05 //y=0.175
c1695 ( 666 0 ) capacitor c=0.10764f //x=28.24 //y=0.175
c1696 ( 665 0 ) capacitor c=0.118515f //x=24.91 //y=0.175
c1697 ( 664 0 ) capacitor c=0.112855f //x=20.1 //y=0.175
c1698 ( 663 0 ) capacitor c=0.117575f //x=16.77 //y=0.175
c1699 ( 662 0 ) capacitor c=0.112938f //x=13.44 //y=0.175
c1700 ( 661 0 ) capacitor c=0.11182f //x=8.63 //y=0.175
c1701 ( 660 0 ) capacitor c=0.107177f //x=3.82 //y=0.175
c1702 ( 651 0 ) capacitor c=0.00585268f //x=85.34 //y=0.63
c1703 ( 648 0 ) capacitor c=0.00625302f //x=85.255 //y=0.715
c1704 ( 647 0 ) capacitor c=0.00479851f //x=84.85 //y=0.63
c1705 ( 644 0 ) capacitor c=0.00645299f //x=84.765 //y=0.715
c1706 ( 639 0 ) capacitor c=0.00586769f //x=84.37 //y=0.63
c1707 ( 636 0 ) capacitor c=0.0191899f //x=84.285 //y=0.175
c1708 ( 621 0 ) capacitor c=0.122563f //x=83.57 //y=0.175
c1709 ( 608 0 ) capacitor c=0.118812f //x=80.24 //y=0.175
c1710 ( 593 0 ) capacitor c=0.123122f //x=76.91 //y=0.175
c1711 ( 576 0 ) capacitor c=0.178514f //x=73.58 //y=0.175
c1712 ( 561 0 ) capacitor c=0.118923f //x=68.77 //y=0.175
c1713 ( 548 0 ) capacitor c=0.118923f //x=65.44 //y=0.175
c1714 ( 531 0 ) capacitor c=0.176363f //x=62.11 //y=0.175
c1715 ( 514 0 ) capacitor c=0.176363f //x=57.3 //y=0.175
c1716 ( 499 0 ) capacitor c=0.118923f //x=52.49 //y=0.175
c1717 ( 482 0 ) capacitor c=0.176388f //x=49.16 //y=0.175
c1718 ( 467 0 ) capacitor c=0.118923f //x=44.35 //y=0.175
c1719 ( 454 0 ) capacitor c=0.118923f //x=41.02 //y=0.175
c1720 ( 437 0 ) capacitor c=0.176363f //x=37.69 //y=0.175
c1721 ( 420 0 ) capacitor c=0.176363f //x=32.88 //y=0.175
c1722 ( 405 0 ) capacitor c=0.118923f //x=28.07 //y=0.175
c1723 ( 388 0 ) capacitor c=0.176388f //x=24.74 //y=0.175
c1724 ( 373 0 ) capacitor c=0.118923f //x=19.93 //y=0.175
c1725 ( 360 0 ) capacitor c=0.118923f //x=16.6 //y=0.175
c1726 ( 343 0 ) capacitor c=0.176433f //x=13.27 //y=0.175
c1727 ( 326 0 ) capacitor c=0.176513f //x=8.46 //y=0.175
c1728 ( 314 0 ) capacitor c=0.201723f //x=1.23 //y=0.18
c1729 ( 311 0 ) capacitor c=0.122877f //x=3.65 //y=0.175
c1730 ( 306 0 ) capacitor c=0.00509083f //x=81.59 //y=0.175
c1731 ( 303 0 ) capacitor c=0.00510068f //x=78.19 //y=0.18
c1732 ( 299 0 ) capacitor c=0.00509083f //x=74.93 //y=0.175
c1733 ( 298 0 ) capacitor c=0.00509414f //x=70.015 //y=0.175
c1734 ( 296 0 ) capacitor c=0.0131346f //x=70.015 //y=1.145
c1735 ( 294 0 ) capacitor c=0.00509083f //x=66.79 //y=0.175
c1736 ( 292 0 ) capacitor c=0.0187613f //x=66.787 //y=1.005
c1737 ( 291 0 ) capacitor c=0.0124186f //x=66.79 //y=1.135
c1738 ( 289 0 ) capacitor c=0.00509083f //x=63.39 //y=0.18
c1739 ( 286 0 ) capacitor c=0.0235363f //x=63.457 //y=1.005
c1740 ( 285 0 ) capacitor c=0.0134704f //x=63.46 //y=1.135
c1741 ( 283 0 ) capacitor c=0.00509414f //x=58.58 //y=0.18
c1742 ( 280 0 ) capacitor c=0.0140159f //x=58.545 //y=1.145
c1743 ( 278 0 ) capacitor c=0.00509414f //x=53.77 //y=0.18
c1744 ( 275 0 ) capacitor c=0.0130816f //x=53.735 //y=1.145
c1745 ( 273 0 ) capacitor c=0.00509083f //x=50.51 //y=0.175
c1746 ( 271 0 ) capacitor c=0.0234055f //x=50.507 //y=1.005
c1747 ( 270 0 ) capacitor c=0.0135618f //x=50.51 //y=1.135
c1748 ( 268 0 ) capacitor c=0.00509414f //x=45.595 //y=0.175
c1749 ( 266 0 ) capacitor c=0.013111f //x=45.595 //y=1.145
c1750 ( 264 0 ) capacitor c=0.00509083f //x=42.37 //y=0.175
c1751 ( 262 0 ) capacitor c=0.0187613f //x=42.367 //y=1.005
c1752 ( 261 0 ) capacitor c=0.0124186f //x=42.37 //y=1.135
c1753 ( 259 0 ) capacitor c=0.00509083f //x=38.97 //y=0.18
c1754 ( 256 0 ) capacitor c=0.0235363f //x=39.037 //y=1.005
c1755 ( 255 0 ) capacitor c=0.0134704f //x=39.04 //y=1.135
c1756 ( 253 0 ) capacitor c=0.00509414f //x=34.16 //y=0.18
c1757 ( 250 0 ) capacitor c=0.0140159f //x=34.125 //y=1.145
c1758 ( 248 0 ) capacitor c=0.00509414f //x=29.35 //y=0.18
c1759 ( 245 0 ) capacitor c=0.0130816f //x=29.315 //y=1.145
c1760 ( 243 0 ) capacitor c=0.00509083f //x=26.09 //y=0.175
c1761 ( 241 0 ) capacitor c=0.0234055f //x=26.087 //y=1.005
c1762 ( 240 0 ) capacitor c=0.0135101f //x=26.09 //y=1.135
c1763 ( 238 0 ) capacitor c=0.00509414f //x=21.175 //y=0.175
c1764 ( 236 0 ) capacitor c=0.0131543f //x=21.175 //y=1.145
c1765 ( 234 0 ) capacitor c=0.00509083f //x=17.95 //y=0.175
c1766 ( 232 0 ) capacitor c=0.0187613f //x=17.947 //y=1.005
c1767 ( 231 0 ) capacitor c=0.0124186f //x=17.95 //y=1.135
c1768 ( 229 0 ) capacitor c=0.00509083f //x=14.55 //y=0.18
c1769 ( 226 0 ) capacitor c=0.0235363f //x=14.617 //y=1.005
c1770 ( 225 0 ) capacitor c=0.0134704f //x=14.62 //y=1.135
c1771 ( 223 0 ) capacitor c=0.00509414f //x=9.74 //y=0.18
c1772 ( 220 0 ) capacitor c=0.0140227f //x=9.705 //y=1.145
c1773 ( 218 0 ) capacitor c=0.00509414f //x=4.93 //y=0.18
c1774 ( 215 0 ) capacitor c=0.0132507f //x=4.895 //y=1.145
c1775 ( 213 0 ) capacitor c=0.00509083f //x=1.67 //y=0.175
c1776 ( 211 0 ) capacitor c=0.0234055f //x=1.667 //y=1.005
c1777 ( 210 0 ) capacitor c=0.0159643f //x=1.67 //y=1.135
c1778 ( 207 0 ) capacitor c=0.179237f //x=85.22 //y=0.18
c1779 ( 198 0 ) capacitor c=0.0350931f //x=81.59 //y=1.02
c1780 ( 191 0 ) capacitor c=0.107469f //x=81.505 //y=0.175
c1781 ( 190 0 ) capacitor c=0.0274205f //x=78.26 //y=1.015
c1782 ( 183 0 ) capacitor c=0.112314f //x=78.175 //y=0.175
c1783 ( 182 0 ) capacitor c=0.0348508f //x=74.93 //y=1.015
c1784 ( 171 0 ) capacitor c=0.155117f //x=74.845 //y=0.175
c1785 ( 170 0 ) capacitor c=0.0253397f //x=70.015 //y=1.015
c1786 ( 161 0 ) capacitor c=0.106828f //x=69.93 //y=0.175
c1787 ( 153 0 ) capacitor c=0.112203f //x=66.705 //y=0.175
c1788 ( 143 0 ) capacitor c=0.154167f //x=63.375 //y=0.175
c1789 ( 142 0 ) capacitor c=0.0302305f //x=58.545 //y=1.015
c1790 ( 133 0 ) capacitor c=0.149464f //x=58.46 //y=0.175
c1791 ( 132 0 ) capacitor c=0.0253397f //x=53.735 //y=1.015
c1792 ( 125 0 ) capacitor c=0.105162f //x=53.65 //y=0.175
c1793 ( 113 0 ) capacitor c=0.154188f //x=50.425 //y=0.175
c1794 ( 112 0 ) capacitor c=0.0253397f //x=45.595 //y=1.015
c1795 ( 102 0 ) capacitor c=0.105059f //x=45.51 //y=0.175
c1796 ( 94 0 ) capacitor c=0.112203f //x=42.285 //y=0.175
c1797 ( 84 0 ) capacitor c=0.154167f //x=38.955 //y=0.175
c1798 ( 83 0 ) capacitor c=0.0302305f //x=34.125 //y=1.015
c1799 ( 74 0 ) capacitor c=0.149464f //x=34.04 //y=0.175
c1800 ( 73 0 ) capacitor c=0.0253397f //x=29.315 //y=1.015
c1801 ( 66 0 ) capacitor c=0.105162f //x=29.23 //y=0.175
c1802 ( 54 0 ) capacitor c=0.154484f //x=26.005 //y=0.175
c1803 ( 53 0 ) capacitor c=0.0253397f //x=21.175 //y=1.015
c1804 ( 44 0 ) capacitor c=0.105643f //x=21.09 //y=0.175
c1805 ( 36 0 ) capacitor c=0.112204f //x=17.865 //y=0.175
c1806 ( 26 0 ) capacitor c=0.154222f //x=14.535 //y=0.175
c1807 ( 25 0 ) capacitor c=0.0302305f //x=9.705 //y=1.015
c1808 ( 16 0 ) capacitor c=0.14953f //x=9.62 //y=0.175
c1809 ( 15 0 ) capacitor c=0.0253397f //x=4.895 //y=1.015
c1810 ( 8 0 ) capacitor c=0.105221f //x=4.81 //y=0.175
c1811 ( 2 0 ) capacitor c=0.0765201f //x=1.585 //y=0.175
r1812 (  686 687 ) resistor r=4.18529 //w=0.367 //l=0.12 //layer=li \
 //thickness=0.1 //x=85.22 //y=0.175 //x2=85.34 //y2=0.175
r1813 (  684 686 ) resistor r=12.9046 //w=0.367 //l=0.37 //layer=li \
 //thickness=0.1 //x=84.85 //y=0.175 //x2=85.22 //y2=0.175
r1814 (  683 684 ) resistor r=12.9046 //w=0.367 //l=0.37 //layer=li \
 //thickness=0.1 //x=84.48 //y=0.175 //x2=84.85 //y2=0.175
r1815 (  681 683 ) resistor r=3.83651 //w=0.367 //l=0.11 //layer=li \
 //thickness=0.1 //x=84.37 //y=0.175 //x2=84.48 //y2=0.175
r1816 (  652 715 ) resistor r=5.4201 //w=0.17 //l=0.085 //layer=li \
 //thickness=0.1 //x=85.34 //y=0.8 //x2=85.34 //y2=0.715
r1817 (  652 715 ) resistor r=41.4118 //w=0.187 //l=0.605 //layer=li \
 //thickness=0.1 //x=85.34 //y=0.8 //x2=85.34 //y2=1.405
r1818 (  651 715 ) resistor r=5.4201 //w=0.17 //l=0.085 //layer=li \
 //thickness=0.1 //x=85.34 //y=0.63 //x2=85.34 //y2=0.715
r1819 (  650 687 ) resistor r=5.21862 //w=0.35 //l=0.175 //layer=li \
 //thickness=0.1 //x=85.34 //y=0.35 //x2=85.34 //y2=0.175
r1820 (  650 651 ) resistor r=19.1658 //w=0.187 //l=0.28 //layer=li \
 //thickness=0.1 //x=85.34 //y=0.35 //x2=85.34 //y2=0.63
r1821 (  649 715 ) resistor r=5.4201 //w=0.17 //l=0.085 //layer=li \
 //thickness=0.1 //x=84.935 //y=0.715 //x2=84.85 //y2=0.715
r1822 (  648 715 ) resistor r=1.40859 //w=0.34 //l=0.085 //layer=li \
 //thickness=0.1 //x=85.255 //y=0.715 //x2=85.34 //y2=0.715
r1823 (  648 649 ) resistor r=21.9037 //w=0.187 //l=0.32 //layer=li \
 //thickness=0.1 //x=85.255 //y=0.715 //x2=84.935 //y2=0.715
r1824 (  647 715 ) resistor r=1.40859 //w=0.34 //l=0.085 //layer=li \
 //thickness=0.1 //x=84.85 //y=0.63 //x2=84.85 //y2=0.715
r1825 (  646 684 ) resistor r=5.21862 //w=0.35 //l=0.175 //layer=li \
 //thickness=0.1 //x=84.85 //y=0.35 //x2=84.85 //y2=0.175
r1826 (  646 647 ) resistor r=19.1658 //w=0.187 //l=0.28 //layer=li \
 //thickness=0.1 //x=84.85 //y=0.35 //x2=84.85 //y2=0.63
r1827 (  645 715 ) resistor r=1.40859 //w=0.34 //l=0.085 //layer=li \
 //thickness=0.1 //x=84.455 //y=0.715 //x2=84.37 //y2=0.715
r1828 (  644 715 ) resistor r=5.4201 //w=0.17 //l=0.085 //layer=li \
 //thickness=0.1 //x=84.765 //y=0.715 //x2=84.85 //y2=0.715
r1829 (  644 645 ) resistor r=21.2193 //w=0.187 //l=0.31 //layer=li \
 //thickness=0.1 //x=84.765 //y=0.715 //x2=84.455 //y2=0.715
r1830 (  640 715 ) resistor r=5.4201 //w=0.17 //l=0.085 //layer=li \
 //thickness=0.1 //x=84.37 //y=0.8 //x2=84.37 //y2=0.715
r1831 (  640 715 ) resistor r=41.4118 //w=0.187 //l=0.605 //layer=li \
 //thickness=0.1 //x=84.37 //y=0.8 //x2=84.37 //y2=1.405
r1832 (  639 715 ) resistor r=5.4201 //w=0.17 //l=0.085 //layer=li \
 //thickness=0.1 //x=84.37 //y=0.63 //x2=84.37 //y2=0.715
r1833 (  638 681 ) resistor r=5.21862 //w=0.35 //l=0.175 //layer=li \
 //thickness=0.1 //x=84.37 //y=0.35 //x2=84.37 //y2=0.175
r1834 (  638 639 ) resistor r=19.1658 //w=0.187 //l=0.28 //layer=li \
 //thickness=0.1 //x=84.37 //y=0.35 //x2=84.37 //y2=0.63
r1835 (  637 680 ) resistor r=5.29055 //w=0.35 //l=0.17 //layer=li \
 //thickness=0.1 //x=83.91 //y=0.175 //x2=83.74 //y2=0.175
r1836 (  636 681 ) resistor r=2.96458 //w=0.367 //l=0.085 //layer=li \
 //thickness=0.1 //x=84.285 //y=0.175 //x2=84.37 //y2=0.175
r1837 (  636 637 ) resistor r=13.079 //w=0.367 //l=0.375 //layer=li \
 //thickness=0.1 //x=84.285 //y=0.175 //x2=83.91 //y2=0.175
r1838 (  626 628 ) resistor r=38.7139 //w=0.367 //l=1.11 //layer=li \
 //thickness=0.1 //x=81.89 //y=0.175 //x2=83 //y2=0.175
r1839 (  624 626 ) resistor r=38.7139 //w=0.367 //l=1.11 //layer=li \
 //thickness=0.1 //x=80.78 //y=0.175 //x2=81.89 //y2=0.175
r1840 (  622 679 ) resistor r=5.29055 //w=0.35 //l=0.17 //layer=li \
 //thickness=0.1 //x=80.58 //y=0.175 //x2=80.41 //y2=0.175
r1841 (  622 624 ) resistor r=6.97548 //w=0.367 //l=0.2 //layer=li \
 //thickness=0.1 //x=80.58 //y=0.175 //x2=80.78 //y2=0.175
r1842 (  621 680 ) resistor r=5.29055 //w=0.35 //l=0.17 //layer=li \
 //thickness=0.1 //x=83.57 //y=0.175 //x2=83.74 //y2=0.175
r1843 (  621 628 ) resistor r=19.8801 //w=0.367 //l=0.57 //layer=li \
 //thickness=0.1 //x=83.57 //y=0.175 //x2=83 //y2=0.175
r1844 (  611 613 ) resistor r=38.7139 //w=0.367 //l=1.11 //layer=li \
 //thickness=0.1 //x=78.19 //y=0.175 //x2=79.3 //y2=0.175
r1845 (  609 678 ) resistor r=5.29055 //w=0.35 //l=0.17 //layer=li \
 //thickness=0.1 //x=77.25 //y=0.175 //x2=77.08 //y2=0.175
r1846 (  609 611 ) resistor r=32.7847 //w=0.367 //l=0.94 //layer=li \
 //thickness=0.1 //x=77.25 //y=0.175 //x2=78.19 //y2=0.175
r1847 (  608 679 ) resistor r=5.29055 //w=0.35 //l=0.17 //layer=li \
 //thickness=0.1 //x=80.24 //y=0.175 //x2=80.41 //y2=0.175
r1848 (  608 613 ) resistor r=32.7847 //w=0.367 //l=0.94 //layer=li \
 //thickness=0.1 //x=80.24 //y=0.175 //x2=79.3 //y2=0.175
r1849 (  598 600 ) resistor r=38.7139 //w=0.367 //l=1.11 //layer=li \
 //thickness=0.1 //x=75.6 //y=0.175 //x2=76.71 //y2=0.175
r1850 (  596 598 ) resistor r=38.7139 //w=0.367 //l=1.11 //layer=li \
 //thickness=0.1 //x=74.49 //y=0.175 //x2=75.6 //y2=0.175
r1851 (  594 677 ) resistor r=5.29055 //w=0.35 //l=0.17 //layer=li \
 //thickness=0.1 //x=73.92 //y=0.175 //x2=73.75 //y2=0.175
r1852 (  594 596 ) resistor r=19.8801 //w=0.367 //l=0.57 //layer=li \
 //thickness=0.1 //x=73.92 //y=0.175 //x2=74.49 //y2=0.175
r1853 (  593 678 ) resistor r=5.29055 //w=0.35 //l=0.17 //layer=li \
 //thickness=0.1 //x=76.91 //y=0.175 //x2=77.08 //y2=0.175
r1854 (  593 600 ) resistor r=6.97548 //w=0.367 //l=0.2 //layer=li \
 //thickness=0.1 //x=76.91 //y=0.175 //x2=76.71 //y2=0.175
r1855 (  583 585 ) resistor r=38.7139 //w=0.367 //l=1.11 //layer=li \
 //thickness=0.1 //x=71.9 //y=0.175 //x2=73.01 //y2=0.175
r1856 (  581 583 ) resistor r=38.7139 //w=0.367 //l=1.11 //layer=li \
 //thickness=0.1 //x=70.79 //y=0.175 //x2=71.9 //y2=0.175
r1857 (  579 581 ) resistor r=38.7139 //w=0.367 //l=1.11 //layer=li \
 //thickness=0.1 //x=69.68 //y=0.175 //x2=70.79 //y2=0.175
r1858 (  577 676 ) resistor r=5.29055 //w=0.35 //l=0.17 //layer=li \
 //thickness=0.1 //x=69.11 //y=0.175 //x2=68.94 //y2=0.175
r1859 (  577 579 ) resistor r=19.8801 //w=0.367 //l=0.57 //layer=li \
 //thickness=0.1 //x=69.11 //y=0.175 //x2=69.68 //y2=0.175
r1860 (  576 677 ) resistor r=5.29055 //w=0.35 //l=0.17 //layer=li \
 //thickness=0.1 //x=73.58 //y=0.175 //x2=73.75 //y2=0.175
r1861 (  576 585 ) resistor r=19.8801 //w=0.367 //l=0.57 //layer=li \
 //thickness=0.1 //x=73.58 //y=0.175 //x2=73.01 //y2=0.175
r1862 (  566 568 ) resistor r=38.7139 //w=0.367 //l=1.11 //layer=li \
 //thickness=0.1 //x=67.09 //y=0.175 //x2=68.2 //y2=0.175
r1863 (  564 566 ) resistor r=38.7139 //w=0.367 //l=1.11 //layer=li \
 //thickness=0.1 //x=65.98 //y=0.175 //x2=67.09 //y2=0.175
r1864 (  562 675 ) resistor r=5.29055 //w=0.35 //l=0.17 //layer=li \
 //thickness=0.1 //x=65.78 //y=0.175 //x2=65.61 //y2=0.175
r1865 (  562 564 ) resistor r=6.97548 //w=0.367 //l=0.2 //layer=li \
 //thickness=0.1 //x=65.78 //y=0.175 //x2=65.98 //y2=0.175
r1866 (  561 676 ) resistor r=5.29055 //w=0.35 //l=0.17 //layer=li \
 //thickness=0.1 //x=68.77 //y=0.175 //x2=68.94 //y2=0.175
r1867 (  561 568 ) resistor r=19.8801 //w=0.367 //l=0.57 //layer=li \
 //thickness=0.1 //x=68.77 //y=0.175 //x2=68.2 //y2=0.175
r1868 (  551 553 ) resistor r=38.7139 //w=0.367 //l=1.11 //layer=li \
 //thickness=0.1 //x=63.39 //y=0.175 //x2=64.5 //y2=0.175
r1869 (  549 674 ) resistor r=5.29055 //w=0.35 //l=0.17 //layer=li \
 //thickness=0.1 //x=62.45 //y=0.175 //x2=62.28 //y2=0.175
r1870 (  549 551 ) resistor r=32.7847 //w=0.367 //l=0.94 //layer=li \
 //thickness=0.1 //x=62.45 //y=0.175 //x2=63.39 //y2=0.175
r1871 (  548 675 ) resistor r=5.29055 //w=0.35 //l=0.17 //layer=li \
 //thickness=0.1 //x=65.44 //y=0.175 //x2=65.61 //y2=0.175
r1872 (  548 553 ) resistor r=32.7847 //w=0.367 //l=0.94 //layer=li \
 //thickness=0.1 //x=65.44 //y=0.175 //x2=64.5 //y2=0.175
r1873 (  538 540 ) resistor r=38.7139 //w=0.367 //l=1.11 //layer=li \
 //thickness=0.1 //x=60.8 //y=0.175 //x2=61.91 //y2=0.175
r1874 (  536 538 ) resistor r=38.7139 //w=0.367 //l=1.11 //layer=li \
 //thickness=0.1 //x=59.69 //y=0.175 //x2=60.8 //y2=0.175
r1875 (  534 536 ) resistor r=38.7139 //w=0.367 //l=1.11 //layer=li \
 //thickness=0.1 //x=58.58 //y=0.175 //x2=59.69 //y2=0.175
r1876 (  532 673 ) resistor r=5.29055 //w=0.35 //l=0.17 //layer=li \
 //thickness=0.1 //x=57.64 //y=0.175 //x2=57.47 //y2=0.175
r1877 (  532 534 ) resistor r=32.7847 //w=0.367 //l=0.94 //layer=li \
 //thickness=0.1 //x=57.64 //y=0.175 //x2=58.58 //y2=0.175
r1878 (  531 674 ) resistor r=5.29055 //w=0.35 //l=0.17 //layer=li \
 //thickness=0.1 //x=62.11 //y=0.175 //x2=62.28 //y2=0.175
r1879 (  531 540 ) resistor r=6.97548 //w=0.367 //l=0.2 //layer=li \
 //thickness=0.1 //x=62.11 //y=0.175 //x2=61.91 //y2=0.175
r1880 (  521 523 ) resistor r=38.7139 //w=0.367 //l=1.11 //layer=li \
 //thickness=0.1 //x=55.99 //y=0.175 //x2=57.1 //y2=0.175
r1881 (  519 521 ) resistor r=38.7139 //w=0.367 //l=1.11 //layer=li \
 //thickness=0.1 //x=54.88 //y=0.175 //x2=55.99 //y2=0.175
r1882 (  517 519 ) resistor r=38.7139 //w=0.367 //l=1.11 //layer=li \
 //thickness=0.1 //x=53.77 //y=0.175 //x2=54.88 //y2=0.175
r1883 (  515 672 ) resistor r=5.29055 //w=0.35 //l=0.17 //layer=li \
 //thickness=0.1 //x=52.83 //y=0.175 //x2=52.66 //y2=0.175
r1884 (  515 517 ) resistor r=32.7847 //w=0.367 //l=0.94 //layer=li \
 //thickness=0.1 //x=52.83 //y=0.175 //x2=53.77 //y2=0.175
r1885 (  514 673 ) resistor r=5.29055 //w=0.35 //l=0.17 //layer=li \
 //thickness=0.1 //x=57.3 //y=0.175 //x2=57.47 //y2=0.175
r1886 (  514 523 ) resistor r=6.97548 //w=0.367 //l=0.2 //layer=li \
 //thickness=0.1 //x=57.3 //y=0.175 //x2=57.1 //y2=0.175
r1887 (  504 506 ) resistor r=38.7139 //w=0.367 //l=1.11 //layer=li \
 //thickness=0.1 //x=51.18 //y=0.175 //x2=52.29 //y2=0.175
r1888 (  502 504 ) resistor r=38.7139 //w=0.367 //l=1.11 //layer=li \
 //thickness=0.1 //x=50.07 //y=0.175 //x2=51.18 //y2=0.175
r1889 (  500 671 ) resistor r=5.29055 //w=0.35 //l=0.17 //layer=li \
 //thickness=0.1 //x=49.5 //y=0.175 //x2=49.33 //y2=0.175
r1890 (  500 502 ) resistor r=19.8801 //w=0.367 //l=0.57 //layer=li \
 //thickness=0.1 //x=49.5 //y=0.175 //x2=50.07 //y2=0.175
r1891 (  499 672 ) resistor r=5.29055 //w=0.35 //l=0.17 //layer=li \
 //thickness=0.1 //x=52.49 //y=0.175 //x2=52.66 //y2=0.175
r1892 (  499 506 ) resistor r=6.97548 //w=0.367 //l=0.2 //layer=li \
 //thickness=0.1 //x=52.49 //y=0.175 //x2=52.29 //y2=0.175
r1893 (  489 491 ) resistor r=38.7139 //w=0.367 //l=1.11 //layer=li \
 //thickness=0.1 //x=47.48 //y=0.175 //x2=48.59 //y2=0.175
r1894 (  487 489 ) resistor r=38.7139 //w=0.367 //l=1.11 //layer=li \
 //thickness=0.1 //x=46.37 //y=0.175 //x2=47.48 //y2=0.175
r1895 (  485 487 ) resistor r=38.7139 //w=0.367 //l=1.11 //layer=li \
 //thickness=0.1 //x=45.26 //y=0.175 //x2=46.37 //y2=0.175
r1896 (  483 670 ) resistor r=5.29055 //w=0.35 //l=0.17 //layer=li \
 //thickness=0.1 //x=44.69 //y=0.175 //x2=44.52 //y2=0.175
r1897 (  483 485 ) resistor r=19.8801 //w=0.367 //l=0.57 //layer=li \
 //thickness=0.1 //x=44.69 //y=0.175 //x2=45.26 //y2=0.175
r1898 (  482 671 ) resistor r=5.29055 //w=0.35 //l=0.17 //layer=li \
 //thickness=0.1 //x=49.16 //y=0.175 //x2=49.33 //y2=0.175
r1899 (  482 491 ) resistor r=19.8801 //w=0.367 //l=0.57 //layer=li \
 //thickness=0.1 //x=49.16 //y=0.175 //x2=48.59 //y2=0.175
r1900 (  472 474 ) resistor r=38.7139 //w=0.367 //l=1.11 //layer=li \
 //thickness=0.1 //x=42.67 //y=0.175 //x2=43.78 //y2=0.175
r1901 (  470 472 ) resistor r=38.7139 //w=0.367 //l=1.11 //layer=li \
 //thickness=0.1 //x=41.56 //y=0.175 //x2=42.67 //y2=0.175
r1902 (  468 669 ) resistor r=5.29055 //w=0.35 //l=0.17 //layer=li \
 //thickness=0.1 //x=41.36 //y=0.175 //x2=41.19 //y2=0.175
r1903 (  468 470 ) resistor r=6.97548 //w=0.367 //l=0.2 //layer=li \
 //thickness=0.1 //x=41.36 //y=0.175 //x2=41.56 //y2=0.175
r1904 (  467 670 ) resistor r=5.29055 //w=0.35 //l=0.17 //layer=li \
 //thickness=0.1 //x=44.35 //y=0.175 //x2=44.52 //y2=0.175
r1905 (  467 474 ) resistor r=19.8801 //w=0.367 //l=0.57 //layer=li \
 //thickness=0.1 //x=44.35 //y=0.175 //x2=43.78 //y2=0.175
r1906 (  457 459 ) resistor r=38.7139 //w=0.367 //l=1.11 //layer=li \
 //thickness=0.1 //x=38.97 //y=0.175 //x2=40.08 //y2=0.175
r1907 (  455 668 ) resistor r=5.29055 //w=0.35 //l=0.17 //layer=li \
 //thickness=0.1 //x=38.03 //y=0.175 //x2=37.86 //y2=0.175
r1908 (  455 457 ) resistor r=32.7847 //w=0.367 //l=0.94 //layer=li \
 //thickness=0.1 //x=38.03 //y=0.175 //x2=38.97 //y2=0.175
r1909 (  454 669 ) resistor r=5.29055 //w=0.35 //l=0.17 //layer=li \
 //thickness=0.1 //x=41.02 //y=0.175 //x2=41.19 //y2=0.175
r1910 (  454 459 ) resistor r=32.7847 //w=0.367 //l=0.94 //layer=li \
 //thickness=0.1 //x=41.02 //y=0.175 //x2=40.08 //y2=0.175
r1911 (  444 446 ) resistor r=38.7139 //w=0.367 //l=1.11 //layer=li \
 //thickness=0.1 //x=36.38 //y=0.175 //x2=37.49 //y2=0.175
r1912 (  442 444 ) resistor r=38.7139 //w=0.367 //l=1.11 //layer=li \
 //thickness=0.1 //x=35.27 //y=0.175 //x2=36.38 //y2=0.175
r1913 (  440 442 ) resistor r=38.7139 //w=0.367 //l=1.11 //layer=li \
 //thickness=0.1 //x=34.16 //y=0.175 //x2=35.27 //y2=0.175
r1914 (  438 667 ) resistor r=5.29055 //w=0.35 //l=0.17 //layer=li \
 //thickness=0.1 //x=33.22 //y=0.175 //x2=33.05 //y2=0.175
r1915 (  438 440 ) resistor r=32.7847 //w=0.367 //l=0.94 //layer=li \
 //thickness=0.1 //x=33.22 //y=0.175 //x2=34.16 //y2=0.175
r1916 (  437 668 ) resistor r=5.29055 //w=0.35 //l=0.17 //layer=li \
 //thickness=0.1 //x=37.69 //y=0.175 //x2=37.86 //y2=0.175
r1917 (  437 446 ) resistor r=6.97548 //w=0.367 //l=0.2 //layer=li \
 //thickness=0.1 //x=37.69 //y=0.175 //x2=37.49 //y2=0.175
r1918 (  427 429 ) resistor r=38.7139 //w=0.367 //l=1.11 //layer=li \
 //thickness=0.1 //x=31.57 //y=0.175 //x2=32.68 //y2=0.175
r1919 (  425 427 ) resistor r=38.7139 //w=0.367 //l=1.11 //layer=li \
 //thickness=0.1 //x=30.46 //y=0.175 //x2=31.57 //y2=0.175
r1920 (  423 425 ) resistor r=38.7139 //w=0.367 //l=1.11 //layer=li \
 //thickness=0.1 //x=29.35 //y=0.175 //x2=30.46 //y2=0.175
r1921 (  421 666 ) resistor r=5.29055 //w=0.35 //l=0.17 //layer=li \
 //thickness=0.1 //x=28.41 //y=0.175 //x2=28.24 //y2=0.175
r1922 (  421 423 ) resistor r=32.7847 //w=0.367 //l=0.94 //layer=li \
 //thickness=0.1 //x=28.41 //y=0.175 //x2=29.35 //y2=0.175
r1923 (  420 667 ) resistor r=5.29055 //w=0.35 //l=0.17 //layer=li \
 //thickness=0.1 //x=32.88 //y=0.175 //x2=33.05 //y2=0.175
r1924 (  420 429 ) resistor r=6.97548 //w=0.367 //l=0.2 //layer=li \
 //thickness=0.1 //x=32.88 //y=0.175 //x2=32.68 //y2=0.175
r1925 (  410 412 ) resistor r=38.7139 //w=0.367 //l=1.11 //layer=li \
 //thickness=0.1 //x=26.76 //y=0.175 //x2=27.87 //y2=0.175
r1926 (  408 410 ) resistor r=38.7139 //w=0.367 //l=1.11 //layer=li \
 //thickness=0.1 //x=25.65 //y=0.175 //x2=26.76 //y2=0.175
r1927 (  406 665 ) resistor r=5.29055 //w=0.35 //l=0.17 //layer=li \
 //thickness=0.1 //x=25.08 //y=0.175 //x2=24.91 //y2=0.175
r1928 (  406 408 ) resistor r=19.8801 //w=0.367 //l=0.57 //layer=li \
 //thickness=0.1 //x=25.08 //y=0.175 //x2=25.65 //y2=0.175
r1929 (  405 666 ) resistor r=5.29055 //w=0.35 //l=0.17 //layer=li \
 //thickness=0.1 //x=28.07 //y=0.175 //x2=28.24 //y2=0.175
r1930 (  405 412 ) resistor r=6.97548 //w=0.367 //l=0.2 //layer=li \
 //thickness=0.1 //x=28.07 //y=0.175 //x2=27.87 //y2=0.175
r1931 (  395 397 ) resistor r=38.7139 //w=0.367 //l=1.11 //layer=li \
 //thickness=0.1 //x=23.06 //y=0.175 //x2=24.17 //y2=0.175
r1932 (  393 395 ) resistor r=38.7139 //w=0.367 //l=1.11 //layer=li \
 //thickness=0.1 //x=21.95 //y=0.175 //x2=23.06 //y2=0.175
r1933 (  391 393 ) resistor r=38.7139 //w=0.367 //l=1.11 //layer=li \
 //thickness=0.1 //x=20.84 //y=0.175 //x2=21.95 //y2=0.175
r1934 (  389 664 ) resistor r=5.29055 //w=0.35 //l=0.17 //layer=li \
 //thickness=0.1 //x=20.27 //y=0.175 //x2=20.1 //y2=0.175
r1935 (  389 391 ) resistor r=19.8801 //w=0.367 //l=0.57 //layer=li \
 //thickness=0.1 //x=20.27 //y=0.175 //x2=20.84 //y2=0.175
r1936 (  388 665 ) resistor r=5.29055 //w=0.35 //l=0.17 //layer=li \
 //thickness=0.1 //x=24.74 //y=0.175 //x2=24.91 //y2=0.175
r1937 (  388 397 ) resistor r=19.8801 //w=0.367 //l=0.57 //layer=li \
 //thickness=0.1 //x=24.74 //y=0.175 //x2=24.17 //y2=0.175
r1938 (  378 380 ) resistor r=38.7139 //w=0.367 //l=1.11 //layer=li \
 //thickness=0.1 //x=18.25 //y=0.175 //x2=19.36 //y2=0.175
r1939 (  376 378 ) resistor r=38.7139 //w=0.367 //l=1.11 //layer=li \
 //thickness=0.1 //x=17.14 //y=0.175 //x2=18.25 //y2=0.175
r1940 (  374 663 ) resistor r=5.29055 //w=0.35 //l=0.17 //layer=li \
 //thickness=0.1 //x=16.94 //y=0.175 //x2=16.77 //y2=0.175
r1941 (  374 376 ) resistor r=6.97548 //w=0.367 //l=0.2 //layer=li \
 //thickness=0.1 //x=16.94 //y=0.175 //x2=17.14 //y2=0.175
r1942 (  373 664 ) resistor r=5.29055 //w=0.35 //l=0.17 //layer=li \
 //thickness=0.1 //x=19.93 //y=0.175 //x2=20.1 //y2=0.175
r1943 (  373 380 ) resistor r=19.8801 //w=0.367 //l=0.57 //layer=li \
 //thickness=0.1 //x=19.93 //y=0.175 //x2=19.36 //y2=0.175
r1944 (  363 365 ) resistor r=38.7139 //w=0.367 //l=1.11 //layer=li \
 //thickness=0.1 //x=14.55 //y=0.175 //x2=15.66 //y2=0.175
r1945 (  361 662 ) resistor r=5.29055 //w=0.35 //l=0.17 //layer=li \
 //thickness=0.1 //x=13.61 //y=0.175 //x2=13.44 //y2=0.175
r1946 (  361 363 ) resistor r=32.7847 //w=0.367 //l=0.94 //layer=li \
 //thickness=0.1 //x=13.61 //y=0.175 //x2=14.55 //y2=0.175
r1947 (  360 663 ) resistor r=5.29055 //w=0.35 //l=0.17 //layer=li \
 //thickness=0.1 //x=16.6 //y=0.175 //x2=16.77 //y2=0.175
r1948 (  360 365 ) resistor r=32.7847 //w=0.367 //l=0.94 //layer=li \
 //thickness=0.1 //x=16.6 //y=0.175 //x2=15.66 //y2=0.175
r1949 (  350 352 ) resistor r=38.7139 //w=0.367 //l=1.11 //layer=li \
 //thickness=0.1 //x=11.96 //y=0.175 //x2=13.07 //y2=0.175
r1950 (  348 350 ) resistor r=38.7139 //w=0.367 //l=1.11 //layer=li \
 //thickness=0.1 //x=10.85 //y=0.175 //x2=11.96 //y2=0.175
r1951 (  346 348 ) resistor r=38.7139 //w=0.367 //l=1.11 //layer=li \
 //thickness=0.1 //x=9.74 //y=0.175 //x2=10.85 //y2=0.175
r1952 (  344 661 ) resistor r=5.29055 //w=0.35 //l=0.17 //layer=li \
 //thickness=0.1 //x=8.8 //y=0.175 //x2=8.63 //y2=0.175
r1953 (  344 346 ) resistor r=32.7847 //w=0.367 //l=0.94 //layer=li \
 //thickness=0.1 //x=8.8 //y=0.175 //x2=9.74 //y2=0.175
r1954 (  343 662 ) resistor r=5.29055 //w=0.35 //l=0.17 //layer=li \
 //thickness=0.1 //x=13.27 //y=0.175 //x2=13.44 //y2=0.175
r1955 (  343 352 ) resistor r=6.97548 //w=0.367 //l=0.2 //layer=li \
 //thickness=0.1 //x=13.27 //y=0.175 //x2=13.07 //y2=0.175
r1956 (  333 335 ) resistor r=38.7139 //w=0.367 //l=1.11 //layer=li \
 //thickness=0.1 //x=7.15 //y=0.175 //x2=8.26 //y2=0.175
r1957 (  331 333 ) resistor r=38.7139 //w=0.367 //l=1.11 //layer=li \
 //thickness=0.1 //x=6.04 //y=0.175 //x2=7.15 //y2=0.175
r1958 (  329 331 ) resistor r=38.7139 //w=0.367 //l=1.11 //layer=li \
 //thickness=0.1 //x=4.93 //y=0.175 //x2=6.04 //y2=0.175
r1959 (  327 660 ) resistor r=5.29055 //w=0.35 //l=0.17 //layer=li \
 //thickness=0.1 //x=3.99 //y=0.175 //x2=3.82 //y2=0.175
r1960 (  327 329 ) resistor r=32.7847 //w=0.367 //l=0.94 //layer=li \
 //thickness=0.1 //x=3.99 //y=0.175 //x2=4.93 //y2=0.175
r1961 (  326 661 ) resistor r=5.29055 //w=0.35 //l=0.17 //layer=li \
 //thickness=0.1 //x=8.46 //y=0.175 //x2=8.63 //y2=0.175
r1962 (  326 335 ) resistor r=6.97548 //w=0.367 //l=0.2 //layer=li \
 //thickness=0.1 //x=8.46 //y=0.175 //x2=8.26 //y2=0.175
r1963 (  316 318 ) resistor r=38.7139 //w=0.367 //l=1.11 //layer=li \
 //thickness=0.1 //x=2.34 //y=0.175 //x2=3.45 //y2=0.175
r1964 (  314 316 ) resistor r=38.7139 //w=0.367 //l=1.11 //layer=li \
 //thickness=0.1 //x=1.23 //y=0.175 //x2=2.34 //y2=0.175
r1965 (  311 660 ) resistor r=5.29055 //w=0.35 //l=0.17 //layer=li \
 //thickness=0.1 //x=3.65 //y=0.175 //x2=3.82 //y2=0.175
r1966 (  311 318 ) resistor r=6.97548 //w=0.367 //l=0.2 //layer=li \
 //thickness=0.1 //x=3.65 //y=0.175 //x2=3.45 //y2=0.175
r1967 (  308 714 ) resistor r=9.3 //w=0.17 //l=0.17 //layer=mcon //count=1 \
 //x=81.59 //y=1.135 //x2=81.59 //y2=1.135
r1968 (  305 713 ) resistor r=9.3 //w=0.17 //l=0.17 //layer=mcon //count=1 \
 //x=78.26 //y=1.135 //x2=78.26 //y2=1.135
r1969 (  303 611 ) resistor r=3.1 //w=0.17 //l=0.51 //layer=mcon //count=3 \
 //x=78.19 //y=0.18 //x2=78.19 //y2=0.18
r1970 (  301 712 ) resistor r=9.3 //w=0.17 //l=0.17 //layer=mcon //count=1 \
 //x=74.93 //y=1.135 //x2=74.93 //y2=1.135
r1971 (  296 711 ) resistor r=9.3 //w=0.17 //l=0.17 //layer=mcon //count=1 \
 //x=70.015 //y=1.145 //x2=70.015 //y2=1.145
r1972 (  291 710 ) resistor r=9.3 //w=0.17 //l=0.17 //layer=mcon //count=1 \
 //x=66.79 //y=1.135 //x2=66.79 //y2=1.135
r1973 (  291 292 ) resistor r=0.0939994 //w=0.226 //l=0.13 //layer=m1 \
 //thickness=0.36 //x=66.787 //y=1.135 //x2=66.787 //y2=1.005
r1974 (  289 551 ) resistor r=3.1 //w=0.17 //l=0.51 //layer=mcon //count=3 \
 //x=63.39 //y=0.18 //x2=63.39 //y2=0.18
r1975 (  285 709 ) resistor r=9.3 //w=0.17 //l=0.17 //layer=mcon //count=1 \
 //x=63.46 //y=1.135 //x2=63.46 //y2=1.135
r1976 (  285 286 ) resistor r=0.0939994 //w=0.226 //l=0.13 //layer=m1 \
 //thickness=0.36 //x=63.457 //y=1.135 //x2=63.457 //y2=1.005
r1977 (  283 534 ) resistor r=3.1 //w=0.17 //l=0.51 //layer=mcon //count=3 \
 //x=58.58 //y=0.18 //x2=58.58 //y2=0.18
r1978 (  280 708 ) resistor r=9.3 //w=0.17 //l=0.17 //layer=mcon //count=1 \
 //x=58.545 //y=1.145 //x2=58.545 //y2=1.145
r1979 (  278 517 ) resistor r=3.1 //w=0.17 //l=0.51 //layer=mcon //count=3 \
 //x=53.77 //y=0.18 //x2=53.77 //y2=0.18
r1980 (  275 707 ) resistor r=9.3 //w=0.17 //l=0.17 //layer=mcon //count=1 \
 //x=53.735 //y=1.145 //x2=53.735 //y2=1.145
r1981 (  270 706 ) resistor r=9.3 //w=0.17 //l=0.17 //layer=mcon //count=1 \
 //x=50.51 //y=1.135 //x2=50.51 //y2=1.135
r1982 (  270 271 ) resistor r=0.0939994 //w=0.226 //l=0.13 //layer=m1 \
 //thickness=0.36 //x=50.507 //y=1.135 //x2=50.507 //y2=1.005
r1983 (  266 705 ) resistor r=9.3 //w=0.17 //l=0.17 //layer=mcon //count=1 \
 //x=45.595 //y=1.145 //x2=45.595 //y2=1.145
r1984 (  261 704 ) resistor r=9.3 //w=0.17 //l=0.17 //layer=mcon //count=1 \
 //x=42.37 //y=1.135 //x2=42.37 //y2=1.135
r1985 (  261 262 ) resistor r=0.0939994 //w=0.226 //l=0.13 //layer=m1 \
 //thickness=0.36 //x=42.367 //y=1.135 //x2=42.367 //y2=1.005
r1986 (  259 457 ) resistor r=3.1 //w=0.17 //l=0.51 //layer=mcon //count=3 \
 //x=38.97 //y=0.18 //x2=38.97 //y2=0.18
r1987 (  255 703 ) resistor r=9.3 //w=0.17 //l=0.17 //layer=mcon //count=1 \
 //x=39.04 //y=1.135 //x2=39.04 //y2=1.135
r1988 (  255 256 ) resistor r=0.0939994 //w=0.226 //l=0.13 //layer=m1 \
 //thickness=0.36 //x=39.037 //y=1.135 //x2=39.037 //y2=1.005
r1989 (  253 440 ) resistor r=3.1 //w=0.17 //l=0.51 //layer=mcon //count=3 \
 //x=34.16 //y=0.18 //x2=34.16 //y2=0.18
r1990 (  250 702 ) resistor r=9.3 //w=0.17 //l=0.17 //layer=mcon //count=1 \
 //x=34.125 //y=1.145 //x2=34.125 //y2=1.145
r1991 (  248 423 ) resistor r=3.1 //w=0.17 //l=0.51 //layer=mcon //count=3 \
 //x=29.35 //y=0.18 //x2=29.35 //y2=0.18
r1992 (  245 701 ) resistor r=9.3 //w=0.17 //l=0.17 //layer=mcon //count=1 \
 //x=29.315 //y=1.145 //x2=29.315 //y2=1.145
r1993 (  240 700 ) resistor r=9.3 //w=0.17 //l=0.17 //layer=mcon //count=1 \
 //x=26.09 //y=1.135 //x2=26.09 //y2=1.135
r1994 (  240 241 ) resistor r=0.0939994 //w=0.226 //l=0.13 //layer=m1 \
 //thickness=0.36 //x=26.087 //y=1.135 //x2=26.087 //y2=1.005
r1995 (  236 699 ) resistor r=9.3 //w=0.17 //l=0.17 //layer=mcon //count=1 \
 //x=21.175 //y=1.145 //x2=21.175 //y2=1.145
r1996 (  231 698 ) resistor r=9.3 //w=0.17 //l=0.17 //layer=mcon //count=1 \
 //x=17.95 //y=1.135 //x2=17.95 //y2=1.135
r1997 (  231 232 ) resistor r=0.0939994 //w=0.226 //l=0.13 //layer=m1 \
 //thickness=0.36 //x=17.947 //y=1.135 //x2=17.947 //y2=1.005
r1998 (  229 363 ) resistor r=3.1 //w=0.17 //l=0.51 //layer=mcon //count=3 \
 //x=14.55 //y=0.18 //x2=14.55 //y2=0.18
r1999 (  225 697 ) resistor r=9.3 //w=0.17 //l=0.17 //layer=mcon //count=1 \
 //x=14.62 //y=1.135 //x2=14.62 //y2=1.135
r2000 (  225 226 ) resistor r=0.0939994 //w=0.226 //l=0.13 //layer=m1 \
 //thickness=0.36 //x=14.617 //y=1.135 //x2=14.617 //y2=1.005
r2001 (  223 346 ) resistor r=3.1 //w=0.17 //l=0.51 //layer=mcon //count=3 \
 //x=9.74 //y=0.18 //x2=9.74 //y2=0.18
r2002 (  220 696 ) resistor r=9.3 //w=0.17 //l=0.17 //layer=mcon //count=1 \
 //x=9.705 //y=1.145 //x2=9.705 //y2=1.145
r2003 (  218 329 ) resistor r=3.1 //w=0.17 //l=0.51 //layer=mcon //count=3 \
 //x=4.93 //y=0.18 //x2=4.93 //y2=0.18
r2004 (  215 695 ) resistor r=9.3 //w=0.17 //l=0.17 //layer=mcon //count=1 \
 //x=4.895 //y=1.145 //x2=4.895 //y2=1.145
r2005 (  210 694 ) resistor r=9.3 //w=0.17 //l=0.17 //layer=mcon //count=1 \
 //x=1.67 //y=1.135 //x2=1.67 //y2=1.135
r2006 (  210 211 ) resistor r=0.0939994 //w=0.226 //l=0.13 //layer=m1 \
 //thickness=0.36 //x=1.667 //y=1.135 //x2=1.667 //y2=1.005
r2007 (  207 686 ) resistor r=4.65 //w=0.17 //l=0.34 //layer=mcon //count=2 \
 //x=85.22 //y=0.18 //x2=85.22 //y2=0.18
r2008 (  205 683 ) resistor r=3.1 //w=0.17 //l=0.51 //layer=mcon //count=3 \
 //x=84.48 //y=0.18 //x2=84.48 //y2=0.18
r2009 (  205 207 ) resistor r=0.297428 //w=0.311 //l=0.74 //layer=m1 \
 //thickness=0.36 //x=84.48 //y=0.175 //x2=85.22 //y2=0.175
r2010 (  203 628 ) resistor r=3.1 //w=0.17 //l=0.51 //layer=mcon //count=3 \
 //x=83 //y=0.18 //x2=83 //y2=0.18
r2011 (  203 205 ) resistor r=0.594855 //w=0.311 //l=1.48 //layer=m1 \
 //thickness=0.36 //x=83 //y=0.175 //x2=84.48 //y2=0.175
r2012 (  201 626 ) resistor r=3.1 //w=0.17 //l=0.51 //layer=mcon //count=3 \
 //x=81.89 //y=0.18 //x2=81.89 //y2=0.18
r2013 (  201 203 ) resistor r=0.446141 //w=0.311 //l=1.11 //layer=m1 \
 //thickness=0.36 //x=81.89 //y=0.175 //x2=83 //y2=0.175
r2014 (  199 306 ) resistor r=0.028033 //w=0.35 //l=0.085 //layer=m1 \
 //thickness=0.36 //x=81.675 //y=0.175 //x2=81.59 //y2=0.175
r2015 (  199 201 ) resistor r=0.0864148 //w=0.311 //l=0.215 //layer=m1 \
 //thickness=0.36 //x=81.675 //y=0.175 //x2=81.89 //y2=0.175
r2016 (  198 308 ) resistor r=0.0703067 //w=0.254 //l=0.11649 //layer=m1 \
 //thickness=0.36 //x=81.59 //y=1.02 //x2=81.587 //y2=1.135
r2017 (  197 306 ) resistor r=0.0413265 //w=0.7 //l=0.175 //layer=m1 \
 //thickness=0.36 //x=81.59 //y=0.35 //x2=81.59 //y2=0.175
r2018 (  197 198 ) resistor r=0.639313 //w=0.131 //l=0.67 //layer=m1 \
 //thickness=0.36 //x=81.59 //y=0.35 //x2=81.59 //y2=1.02
r2019 (  196 624 ) resistor r=3.1 //w=0.17 //l=0.51 //layer=mcon //count=3 \
 //x=80.78 //y=0.18 //x2=80.78 //y2=0.18
r2020 (  194 613 ) resistor r=3.1 //w=0.17 //l=0.51 //layer=mcon //count=3 \
 //x=79.3 //y=0.18 //x2=79.3 //y2=0.18
r2021 (  194 196 ) resistor r=0.594855 //w=0.311 //l=1.48 //layer=m1 \
 //thickness=0.36 //x=79.3 //y=0.175 //x2=80.78 //y2=0.175
r2022 (  192 303 ) resistor r=0.028033 //w=0.35 //l=0.085 //layer=m1 \
 //thickness=0.36 //x=78.345 //y=0.175 //x2=78.26 //y2=0.175
r2023 (  192 194 ) resistor r=0.383842 //w=0.311 //l=0.955 //layer=m1 \
 //thickness=0.36 //x=78.345 //y=0.175 //x2=79.3 //y2=0.175
r2024 (  191 306 ) resistor r=0.028033 //w=0.35 //l=0.085 //layer=m1 \
 //thickness=0.36 //x=81.505 //y=0.175 //x2=81.59 //y2=0.175
r2025 (  191 196 ) resistor r=0.291399 //w=0.311 //l=0.725 //layer=m1 \
 //thickness=0.36 //x=81.505 //y=0.175 //x2=80.78 //y2=0.175
r2026 (  190 305 ) resistor r=0.0738201 //w=0.232 //l=0.121491 //layer=m1 \
 //thickness=0.36 //x=78.26 //y=1.015 //x2=78.257 //y2=1.135
r2027 (  189 303 ) resistor r=0.0413265 //w=0.7 //l=0.175 //layer=m1 \
 //thickness=0.36 //x=78.26 //y=0.35 //x2=78.26 //y2=0.175
r2028 (  189 190 ) resistor r=0.634542 //w=0.131 //l=0.665 //layer=m1 \
 //thickness=0.36 //x=78.26 //y=0.35 //x2=78.26 //y2=1.015
r2029 (  188 600 ) resistor r=3.1 //w=0.17 //l=0.51 //layer=mcon //count=3 \
 //x=76.71 //y=0.18 //x2=76.71 //y2=0.18
r2030 (  186 598 ) resistor r=3.1 //w=0.17 //l=0.51 //layer=mcon //count=3 \
 //x=75.6 //y=0.18 //x2=75.6 //y2=0.18
r2031 (  186 188 ) resistor r=0.446141 //w=0.311 //l=1.11 //layer=m1 \
 //thickness=0.36 //x=75.6 //y=0.175 //x2=76.71 //y2=0.175
r2032 (  184 299 ) resistor r=0.028033 //w=0.35 //l=0.085 //layer=m1 \
 //thickness=0.36 //x=75.015 //y=0.175 //x2=74.93 //y2=0.175
r2033 (  184 186 ) resistor r=0.235129 //w=0.311 //l=0.585 //layer=m1 \
 //thickness=0.36 //x=75.015 //y=0.175 //x2=75.6 //y2=0.175
r2034 (  183 303 ) resistor r=0.028033 //w=0.35 //l=0.085 //layer=m1 \
 //thickness=0.36 //x=78.175 //y=0.175 //x2=78.26 //y2=0.175
r2035 (  183 188 ) resistor r=0.588826 //w=0.311 //l=1.465 //layer=m1 \
 //thickness=0.36 //x=78.175 //y=0.175 //x2=76.71 //y2=0.175
r2036 (  182 301 ) resistor r=0.0729089 //w=0.249 //l=0.120996 //layer=m1 \
 //thickness=0.36 //x=74.93 //y=1.015 //x2=74.932 //y2=1.135
r2037 (  181 299 ) resistor r=0.0413265 //w=0.7 //l=0.175 //layer=m1 \
 //thickness=0.36 //x=74.93 //y=0.35 //x2=74.93 //y2=0.175
r2038 (  181 182 ) resistor r=0.634542 //w=0.131 //l=0.665 //layer=m1 \
 //thickness=0.36 //x=74.93 //y=0.35 //x2=74.93 //y2=1.015
r2039 (  180 596 ) resistor r=3.1 //w=0.17 //l=0.51 //layer=mcon //count=3 \
 //x=74.49 //y=0.18 //x2=74.49 //y2=0.18
r2040 (  178 585 ) resistor r=3.1 //w=0.17 //l=0.51 //layer=mcon //count=3 \
 //x=73.01 //y=0.18 //x2=73.01 //y2=0.18
r2041 (  178 180 ) resistor r=0.594855 //w=0.311 //l=1.48 //layer=m1 \
 //thickness=0.36 //x=73.01 //y=0.175 //x2=74.49 //y2=0.175
r2042 (  176 583 ) resistor r=3.1 //w=0.17 //l=0.51 //layer=mcon //count=3 \
 //x=71.9 //y=0.18 //x2=71.9 //y2=0.18
r2043 (  176 178 ) resistor r=0.446141 //w=0.311 //l=1.11 //layer=m1 \
 //thickness=0.36 //x=71.9 //y=0.175 //x2=73.01 //y2=0.175
r2044 (  174 581 ) resistor r=3.1 //w=0.17 //l=0.51 //layer=mcon //count=3 \
 //x=70.79 //y=0.18 //x2=70.79 //y2=0.18
r2045 (  174 176 ) resistor r=0.446141 //w=0.311 //l=1.11 //layer=m1 \
 //thickness=0.36 //x=70.79 //y=0.175 //x2=71.9 //y2=0.175
r2046 (  172 298 ) resistor r=0.028033 //w=0.35 //l=0.085 //layer=m1 \
 //thickness=0.36 //x=70.1 //y=0.175 //x2=70.015 //y2=0.175
r2047 (  172 174 ) resistor r=0.277331 //w=0.311 //l=0.69 //layer=m1 \
 //thickness=0.36 //x=70.1 //y=0.175 //x2=70.79 //y2=0.175
r2048 (  171 299 ) resistor r=0.028033 //w=0.35 //l=0.085 //layer=m1 \
 //thickness=0.36 //x=74.845 //y=0.175 //x2=74.93 //y2=0.175
r2049 (  171 180 ) resistor r=0.142685 //w=0.311 //l=0.355 //layer=m1 \
 //thickness=0.36 //x=74.845 //y=0.175 //x2=74.49 //y2=0.175
r2050 (  170 296 ) resistor r=0.0942778 //w=0.221 //l=0.13 //layer=m1 \
 //thickness=0.36 //x=70.015 //y=1.015 //x2=70.015 //y2=1.145
r2051 (  169 298 ) resistor r=0.0413265 //w=0.7 //l=0.175 //layer=m1 \
 //thickness=0.36 //x=70.015 //y=0.35 //x2=70.015 //y2=0.175
r2052 (  169 170 ) resistor r=0.634542 //w=0.131 //l=0.665 //layer=m1 \
 //thickness=0.36 //x=70.015 //y=0.35 //x2=70.015 //y2=1.015
r2053 (  168 579 ) resistor r=3.1 //w=0.17 //l=0.51 //layer=mcon //count=3 \
 //x=69.68 //y=0.18 //x2=69.68 //y2=0.18
r2054 (  166 568 ) resistor r=3.1 //w=0.17 //l=0.51 //layer=mcon //count=3 \
 //x=68.2 //y=0.18 //x2=68.2 //y2=0.18
r2055 (  166 168 ) resistor r=0.594855 //w=0.311 //l=1.48 //layer=m1 \
 //thickness=0.36 //x=68.2 //y=0.175 //x2=69.68 //y2=0.175
r2056 (  164 566 ) resistor r=3.1 //w=0.17 //l=0.51 //layer=mcon //count=3 \
 //x=67.09 //y=0.18 //x2=67.09 //y2=0.18
r2057 (  164 166 ) resistor r=0.446141 //w=0.311 //l=1.11 //layer=m1 \
 //thickness=0.36 //x=67.09 //y=0.175 //x2=68.2 //y2=0.175
r2058 (  162 294 ) resistor r=0.028033 //w=0.35 //l=0.085 //layer=m1 \
 //thickness=0.36 //x=66.875 //y=0.175 //x2=66.79 //y2=0.175
r2059 (  162 164 ) resistor r=0.0864148 //w=0.311 //l=0.215 //layer=m1 \
 //thickness=0.36 //x=66.875 //y=0.175 //x2=67.09 //y2=0.175
r2060 (  161 298 ) resistor r=0.028033 //w=0.35 //l=0.085 //layer=m1 \
 //thickness=0.36 //x=69.93 //y=0.175 //x2=70.015 //y2=0.175
r2061 (  161 168 ) resistor r=0.100482 //w=0.311 //l=0.25 //layer=m1 \
 //thickness=0.36 //x=69.93 //y=0.175 //x2=69.68 //y2=0.175
r2062 (  159 294 ) resistor r=0.0413265 //w=0.7 //l=0.175 //layer=m1 \
 //thickness=0.36 //x=66.79 //y=0.35 //x2=66.79 //y2=0.175
r2063 (  159 292 ) resistor r=0.625 //w=0.131 //l=0.655 //layer=m1 \
 //thickness=0.36 //x=66.79 //y=0.35 //x2=66.79 //y2=1.005
r2064 (  158 564 ) resistor r=3.1 //w=0.17 //l=0.51 //layer=mcon //count=3 \
 //x=65.98 //y=0.18 //x2=65.98 //y2=0.18
r2065 (  156 553 ) resistor r=3.1 //w=0.17 //l=0.51 //layer=mcon //count=3 \
 //x=64.5 //y=0.18 //x2=64.5 //y2=0.18
r2066 (  156 158 ) resistor r=0.594855 //w=0.311 //l=1.48 //layer=m1 \
 //thickness=0.36 //x=64.5 //y=0.175 //x2=65.98 //y2=0.175
r2067 (  154 289 ) resistor r=0.028033 //w=0.35 //l=0.085 //layer=m1 \
 //thickness=0.36 //x=63.545 //y=0.175 //x2=63.46 //y2=0.175
r2068 (  154 156 ) resistor r=0.383842 //w=0.311 //l=0.955 //layer=m1 \
 //thickness=0.36 //x=63.545 //y=0.175 //x2=64.5 //y2=0.175
r2069 (  153 294 ) resistor r=0.028033 //w=0.35 //l=0.085 //layer=m1 \
 //thickness=0.36 //x=66.705 //y=0.175 //x2=66.79 //y2=0.175
r2070 (  153 158 ) resistor r=0.291399 //w=0.311 //l=0.725 //layer=m1 \
 //thickness=0.36 //x=66.705 //y=0.175 //x2=65.98 //y2=0.175
r2071 (  151 289 ) resistor r=0.0413265 //w=0.7 //l=0.175 //layer=m1 \
 //thickness=0.36 //x=63.46 //y=0.35 //x2=63.46 //y2=0.175
r2072 (  151 286 ) resistor r=0.625 //w=0.131 //l=0.655 //layer=m1 \
 //thickness=0.36 //x=63.46 //y=0.35 //x2=63.46 //y2=1.005
r2073 (  150 540 ) resistor r=3.1 //w=0.17 //l=0.51 //layer=mcon //count=3 \
 //x=61.91 //y=0.18 //x2=61.91 //y2=0.18
r2074 (  148 538 ) resistor r=3.1 //w=0.17 //l=0.51 //layer=mcon //count=3 \
 //x=60.8 //y=0.18 //x2=60.8 //y2=0.18
r2075 (  148 150 ) resistor r=0.446141 //w=0.311 //l=1.11 //layer=m1 \
 //thickness=0.36 //x=60.8 //y=0.175 //x2=61.91 //y2=0.175
r2076 (  146 536 ) resistor r=3.1 //w=0.17 //l=0.51 //layer=mcon //count=3 \
 //x=59.69 //y=0.18 //x2=59.69 //y2=0.18
r2077 (  146 148 ) resistor r=0.446141 //w=0.311 //l=1.11 //layer=m1 \
 //thickness=0.36 //x=59.69 //y=0.175 //x2=60.8 //y2=0.175
r2078 (  144 283 ) resistor r=0.028033 //w=0.35 //l=0.085 //layer=m1 \
 //thickness=0.36 //x=58.63 //y=0.175 //x2=58.545 //y2=0.175
r2079 (  144 146 ) resistor r=0.426045 //w=0.311 //l=1.06 //layer=m1 \
 //thickness=0.36 //x=58.63 //y=0.175 //x2=59.69 //y2=0.175
r2080 (  143 289 ) resistor r=0.028033 //w=0.35 //l=0.085 //layer=m1 \
 //thickness=0.36 //x=63.375 //y=0.175 //x2=63.46 //y2=0.175
r2081 (  143 150 ) resistor r=0.588826 //w=0.311 //l=1.465 //layer=m1 \
 //thickness=0.36 //x=63.375 //y=0.175 //x2=61.91 //y2=0.175
r2082 (  142 280 ) resistor r=0.0942778 //w=0.221 //l=0.13 //layer=m1 \
 //thickness=0.36 //x=58.545 //y=1.015 //x2=58.545 //y2=1.145
r2083 (  141 283 ) resistor r=0.0413265 //w=0.7 //l=0.175 //layer=m1 \
 //thickness=0.36 //x=58.545 //y=0.35 //x2=58.545 //y2=0.175
r2084 (  141 142 ) resistor r=0.634542 //w=0.131 //l=0.665 //layer=m1 \
 //thickness=0.36 //x=58.545 //y=0.35 //x2=58.545 //y2=1.015
r2085 (  140 523 ) resistor r=3.1 //w=0.17 //l=0.51 //layer=mcon //count=3 \
 //x=57.1 //y=0.18 //x2=57.1 //y2=0.18
r2086 (  138 521 ) resistor r=3.1 //w=0.17 //l=0.51 //layer=mcon //count=3 \
 //x=55.99 //y=0.18 //x2=55.99 //y2=0.18
r2087 (  138 140 ) resistor r=0.446141 //w=0.311 //l=1.11 //layer=m1 \
 //thickness=0.36 //x=55.99 //y=0.175 //x2=57.1 //y2=0.175
r2088 (  136 519 ) resistor r=3.1 //w=0.17 //l=0.51 //layer=mcon //count=3 \
 //x=54.88 //y=0.18 //x2=54.88 //y2=0.18
r2089 (  136 138 ) resistor r=0.446141 //w=0.311 //l=1.11 //layer=m1 \
 //thickness=0.36 //x=54.88 //y=0.175 //x2=55.99 //y2=0.175
r2090 (  134 278 ) resistor r=0.028033 //w=0.35 //l=0.085 //layer=m1 \
 //thickness=0.36 //x=53.82 //y=0.175 //x2=53.735 //y2=0.175
r2091 (  134 136 ) resistor r=0.426045 //w=0.311 //l=1.06 //layer=m1 \
 //thickness=0.36 //x=53.82 //y=0.175 //x2=54.88 //y2=0.175
r2092 (  133 283 ) resistor r=0.028033 //w=0.35 //l=0.085 //layer=m1 \
 //thickness=0.36 //x=58.46 //y=0.175 //x2=58.545 //y2=0.175
r2093 (  133 140 ) resistor r=0.546624 //w=0.311 //l=1.36 //layer=m1 \
 //thickness=0.36 //x=58.46 //y=0.175 //x2=57.1 //y2=0.175
r2094 (  132 275 ) resistor r=0.0942778 //w=0.221 //l=0.13 //layer=m1 \
 //thickness=0.36 //x=53.735 //y=1.015 //x2=53.735 //y2=1.145
r2095 (  131 278 ) resistor r=0.0413265 //w=0.7 //l=0.175 //layer=m1 \
 //thickness=0.36 //x=53.735 //y=0.35 //x2=53.735 //y2=0.175
r2096 (  131 132 ) resistor r=0.634542 //w=0.131 //l=0.665 //layer=m1 \
 //thickness=0.36 //x=53.735 //y=0.35 //x2=53.735 //y2=1.015
r2097 (  130 506 ) resistor r=3.1 //w=0.17 //l=0.51 //layer=mcon //count=3 \
 //x=52.29 //y=0.18 //x2=52.29 //y2=0.18
r2098 (  128 504 ) resistor r=3.1 //w=0.17 //l=0.51 //layer=mcon //count=3 \
 //x=51.18 //y=0.18 //x2=51.18 //y2=0.18
r2099 (  128 130 ) resistor r=0.446141 //w=0.311 //l=1.11 //layer=m1 \
 //thickness=0.36 //x=51.18 //y=0.175 //x2=52.29 //y2=0.175
r2100 (  126 273 ) resistor r=0.028033 //w=0.35 //l=0.085 //layer=m1 \
 //thickness=0.36 //x=50.595 //y=0.175 //x2=50.51 //y2=0.175
r2101 (  126 128 ) resistor r=0.235129 //w=0.311 //l=0.585 //layer=m1 \
 //thickness=0.36 //x=50.595 //y=0.175 //x2=51.18 //y2=0.175
r2102 (  125 278 ) resistor r=0.028033 //w=0.35 //l=0.085 //layer=m1 \
 //thickness=0.36 //x=53.65 //y=0.175 //x2=53.735 //y2=0.175
r2103 (  125 130 ) resistor r=0.546624 //w=0.311 //l=1.36 //layer=m1 \
 //thickness=0.36 //x=53.65 //y=0.175 //x2=52.29 //y2=0.175
r2104 (  123 273 ) resistor r=0.0413265 //w=0.7 //l=0.175 //layer=m1 \
 //thickness=0.36 //x=50.51 //y=0.35 //x2=50.51 //y2=0.175
r2105 (  123 271 ) resistor r=0.625 //w=0.131 //l=0.655 //layer=m1 \
 //thickness=0.36 //x=50.51 //y=0.35 //x2=50.51 //y2=1.005
r2106 (  122 502 ) resistor r=3.1 //w=0.17 //l=0.51 //layer=mcon //count=3 \
 //x=50.07 //y=0.18 //x2=50.07 //y2=0.18
r2107 (  120 491 ) resistor r=3.1 //w=0.17 //l=0.51 //layer=mcon //count=3 \
 //x=48.59 //y=0.18 //x2=48.59 //y2=0.18
r2108 (  120 122 ) resistor r=0.594855 //w=0.311 //l=1.48 //layer=m1 \
 //thickness=0.36 //x=48.59 //y=0.175 //x2=50.07 //y2=0.175
r2109 (  118 489 ) resistor r=3.1 //w=0.17 //l=0.51 //layer=mcon //count=3 \
 //x=47.48 //y=0.18 //x2=47.48 //y2=0.18
r2110 (  118 120 ) resistor r=0.446141 //w=0.311 //l=1.11 //layer=m1 \
 //thickness=0.36 //x=47.48 //y=0.175 //x2=48.59 //y2=0.175
r2111 (  116 487 ) resistor r=3.1 //w=0.17 //l=0.51 //layer=mcon //count=3 \
 //x=46.37 //y=0.18 //x2=46.37 //y2=0.18
r2112 (  116 118 ) resistor r=0.446141 //w=0.311 //l=1.11 //layer=m1 \
 //thickness=0.36 //x=46.37 //y=0.175 //x2=47.48 //y2=0.175
r2113 (  114 268 ) resistor r=0.028033 //w=0.35 //l=0.085 //layer=m1 \
 //thickness=0.36 //x=45.68 //y=0.175 //x2=45.595 //y2=0.175
r2114 (  114 116 ) resistor r=0.277331 //w=0.311 //l=0.69 //layer=m1 \
 //thickness=0.36 //x=45.68 //y=0.175 //x2=46.37 //y2=0.175
r2115 (  113 273 ) resistor r=0.028033 //w=0.35 //l=0.085 //layer=m1 \
 //thickness=0.36 //x=50.425 //y=0.175 //x2=50.51 //y2=0.175
r2116 (  113 122 ) resistor r=0.142685 //w=0.311 //l=0.355 //layer=m1 \
 //thickness=0.36 //x=50.425 //y=0.175 //x2=50.07 //y2=0.175
r2117 (  112 266 ) resistor r=0.0942778 //w=0.221 //l=0.13 //layer=m1 \
 //thickness=0.36 //x=45.595 //y=1.015 //x2=45.595 //y2=1.145
r2118 (  111 268 ) resistor r=0.0413265 //w=0.7 //l=0.175 //layer=m1 \
 //thickness=0.36 //x=45.595 //y=0.35 //x2=45.595 //y2=0.175
r2119 (  111 112 ) resistor r=0.634542 //w=0.131 //l=0.665 //layer=m1 \
 //thickness=0.36 //x=45.595 //y=0.35 //x2=45.595 //y2=1.015
r2120 (  110 485 ) resistor r=3.1 //w=0.17 //l=0.51 //layer=mcon //count=3 \
 //x=45.26 //y=0.18 //x2=45.26 //y2=0.18
r2121 (  108 474 ) resistor r=3.1 //w=0.17 //l=0.51 //layer=mcon //count=3 \
 //x=43.78 //y=0.18 //x2=43.78 //y2=0.18
r2122 (  108 110 ) resistor r=0.594855 //w=0.311 //l=1.48 //layer=m1 \
 //thickness=0.36 //x=43.78 //y=0.175 //x2=45.26 //y2=0.175
r2123 (  105 472 ) resistor r=3.1 //w=0.17 //l=0.51 //layer=mcon //count=3 \
 //x=42.67 //y=0.18 //x2=42.67 //y2=0.18
r2124 (  103 264 ) resistor r=0.028033 //w=0.35 //l=0.085 //layer=m1 \
 //thickness=0.36 //x=42.455 //y=0.175 //x2=42.37 //y2=0.175
r2125 (  103 105 ) resistor r=0.0864148 //w=0.311 //l=0.215 //layer=m1 \
 //thickness=0.36 //x=42.455 //y=0.175 //x2=42.67 //y2=0.175
r2126 (  102 268 ) resistor r=0.028033 //w=0.35 //l=0.085 //layer=m1 \
 //thickness=0.36 //x=45.51 //y=0.175 //x2=45.595 //y2=0.175
r2127 (  102 110 ) resistor r=0.100482 //w=0.311 //l=0.25 //layer=m1 \
 //thickness=0.36 //x=45.51 //y=0.175 //x2=45.26 //y2=0.175
r2128 (  100 264 ) resistor r=0.0413265 //w=0.7 //l=0.175 //layer=m1 \
 //thickness=0.36 //x=42.37 //y=0.35 //x2=42.37 //y2=0.175
r2129 (  100 262 ) resistor r=0.625 //w=0.131 //l=0.655 //layer=m1 \
 //thickness=0.36 //x=42.37 //y=0.35 //x2=42.37 //y2=1.005
r2130 (  99 470 ) resistor r=3.1 //w=0.17 //l=0.51 //layer=mcon //count=3 \
 //x=41.56 //y=0.18 //x2=41.56 //y2=0.18
r2131 (  97 459 ) resistor r=3.1 //w=0.17 //l=0.51 //layer=mcon //count=3 \
 //x=40.08 //y=0.18 //x2=40.08 //y2=0.18
r2132 (  97 99 ) resistor r=0.594855 //w=0.311 //l=1.48 //layer=m1 \
 //thickness=0.36 //x=40.08 //y=0.175 //x2=41.56 //y2=0.175
r2133 (  95 259 ) resistor r=0.028033 //w=0.35 //l=0.085 //layer=m1 \
 //thickness=0.36 //x=39.125 //y=0.175 //x2=39.04 //y2=0.175
r2134 (  95 97 ) resistor r=0.383842 //w=0.311 //l=0.955 //layer=m1 \
 //thickness=0.36 //x=39.125 //y=0.175 //x2=40.08 //y2=0.175
r2135 (  94 264 ) resistor r=0.028033 //w=0.35 //l=0.085 //layer=m1 \
 //thickness=0.36 //x=42.285 //y=0.175 //x2=42.37 //y2=0.175
r2136 (  94 99 ) resistor r=0.291399 //w=0.311 //l=0.725 //layer=m1 \
 //thickness=0.36 //x=42.285 //y=0.175 //x2=41.56 //y2=0.175
r2137 (  92 259 ) resistor r=0.0413265 //w=0.7 //l=0.175 //layer=m1 \
 //thickness=0.36 //x=39.04 //y=0.35 //x2=39.04 //y2=0.175
r2138 (  92 256 ) resistor r=0.625 //w=0.131 //l=0.655 //layer=m1 \
 //thickness=0.36 //x=39.04 //y=0.35 //x2=39.04 //y2=1.005
r2139 (  91 446 ) resistor r=3.1 //w=0.17 //l=0.51 //layer=mcon //count=3 \
 //x=37.49 //y=0.18 //x2=37.49 //y2=0.18
r2140 (  89 444 ) resistor r=3.1 //w=0.17 //l=0.51 //layer=mcon //count=3 \
 //x=36.38 //y=0.18 //x2=36.38 //y2=0.18
r2141 (  89 91 ) resistor r=0.446141 //w=0.311 //l=1.11 //layer=m1 \
 //thickness=0.36 //x=36.38 //y=0.175 //x2=37.49 //y2=0.175
r2142 (  87 442 ) resistor r=3.1 //w=0.17 //l=0.51 //layer=mcon //count=3 \
 //x=35.27 //y=0.18 //x2=35.27 //y2=0.18
r2143 (  87 89 ) resistor r=0.446141 //w=0.311 //l=1.11 //layer=m1 \
 //thickness=0.36 //x=35.27 //y=0.175 //x2=36.38 //y2=0.175
r2144 (  85 253 ) resistor r=0.028033 //w=0.35 //l=0.085 //layer=m1 \
 //thickness=0.36 //x=34.21 //y=0.175 //x2=34.125 //y2=0.175
r2145 (  85 87 ) resistor r=0.426045 //w=0.311 //l=1.06 //layer=m1 \
 //thickness=0.36 //x=34.21 //y=0.175 //x2=35.27 //y2=0.175
r2146 (  84 259 ) resistor r=0.028033 //w=0.35 //l=0.085 //layer=m1 \
 //thickness=0.36 //x=38.955 //y=0.175 //x2=39.04 //y2=0.175
r2147 (  84 91 ) resistor r=0.588826 //w=0.311 //l=1.465 //layer=m1 \
 //thickness=0.36 //x=38.955 //y=0.175 //x2=37.49 //y2=0.175
r2148 (  83 250 ) resistor r=0.0942778 //w=0.221 //l=0.13 //layer=m1 \
 //thickness=0.36 //x=34.125 //y=1.015 //x2=34.125 //y2=1.145
r2149 (  82 253 ) resistor r=0.0413265 //w=0.7 //l=0.175 //layer=m1 \
 //thickness=0.36 //x=34.125 //y=0.35 //x2=34.125 //y2=0.175
r2150 (  82 83 ) resistor r=0.634542 //w=0.131 //l=0.665 //layer=m1 \
 //thickness=0.36 //x=34.125 //y=0.35 //x2=34.125 //y2=1.015
r2151 (  81 429 ) resistor r=3.1 //w=0.17 //l=0.51 //layer=mcon //count=3 \
 //x=32.68 //y=0.18 //x2=32.68 //y2=0.18
r2152 (  79 427 ) resistor r=3.1 //w=0.17 //l=0.51 //layer=mcon //count=3 \
 //x=31.57 //y=0.18 //x2=31.57 //y2=0.18
r2153 (  79 81 ) resistor r=0.446141 //w=0.311 //l=1.11 //layer=m1 \
 //thickness=0.36 //x=31.57 //y=0.175 //x2=32.68 //y2=0.175
r2154 (  77 425 ) resistor r=3.1 //w=0.17 //l=0.51 //layer=mcon //count=3 \
 //x=30.46 //y=0.18 //x2=30.46 //y2=0.18
r2155 (  77 79 ) resistor r=0.446141 //w=0.311 //l=1.11 //layer=m1 \
 //thickness=0.36 //x=30.46 //y=0.175 //x2=31.57 //y2=0.175
r2156 (  75 248 ) resistor r=0.028033 //w=0.35 //l=0.085 //layer=m1 \
 //thickness=0.36 //x=29.4 //y=0.175 //x2=29.315 //y2=0.175
r2157 (  75 77 ) resistor r=0.426045 //w=0.311 //l=1.06 //layer=m1 \
 //thickness=0.36 //x=29.4 //y=0.175 //x2=30.46 //y2=0.175
r2158 (  74 253 ) resistor r=0.028033 //w=0.35 //l=0.085 //layer=m1 \
 //thickness=0.36 //x=34.04 //y=0.175 //x2=34.125 //y2=0.175
r2159 (  74 81 ) resistor r=0.546624 //w=0.311 //l=1.36 //layer=m1 \
 //thickness=0.36 //x=34.04 //y=0.175 //x2=32.68 //y2=0.175
r2160 (  73 245 ) resistor r=0.0942778 //w=0.221 //l=0.13 //layer=m1 \
 //thickness=0.36 //x=29.315 //y=1.015 //x2=29.315 //y2=1.145
r2161 (  72 248 ) resistor r=0.0413265 //w=0.7 //l=0.175 //layer=m1 \
 //thickness=0.36 //x=29.315 //y=0.35 //x2=29.315 //y2=0.175
r2162 (  72 73 ) resistor r=0.634542 //w=0.131 //l=0.665 //layer=m1 \
 //thickness=0.36 //x=29.315 //y=0.35 //x2=29.315 //y2=1.015
r2163 (  71 412 ) resistor r=3.1 //w=0.17 //l=0.51 //layer=mcon //count=3 \
 //x=27.87 //y=0.18 //x2=27.87 //y2=0.18
r2164 (  69 410 ) resistor r=3.1 //w=0.17 //l=0.51 //layer=mcon //count=3 \
 //x=26.76 //y=0.18 //x2=26.76 //y2=0.18
r2165 (  69 71 ) resistor r=0.446141 //w=0.311 //l=1.11 //layer=m1 \
 //thickness=0.36 //x=26.76 //y=0.175 //x2=27.87 //y2=0.175
r2166 (  67 243 ) resistor r=0.028033 //w=0.35 //l=0.085 //layer=m1 \
 //thickness=0.36 //x=26.175 //y=0.175 //x2=26.09 //y2=0.175
r2167 (  67 69 ) resistor r=0.235129 //w=0.311 //l=0.585 //layer=m1 \
 //thickness=0.36 //x=26.175 //y=0.175 //x2=26.76 //y2=0.175
r2168 (  66 248 ) resistor r=0.028033 //w=0.35 //l=0.085 //layer=m1 \
 //thickness=0.36 //x=29.23 //y=0.175 //x2=29.315 //y2=0.175
r2169 (  66 71 ) resistor r=0.546624 //w=0.311 //l=1.36 //layer=m1 \
 //thickness=0.36 //x=29.23 //y=0.175 //x2=27.87 //y2=0.175
r2170 (  64 243 ) resistor r=0.0413265 //w=0.7 //l=0.175 //layer=m1 \
 //thickness=0.36 //x=26.09 //y=0.35 //x2=26.09 //y2=0.175
r2171 (  64 241 ) resistor r=0.625 //w=0.131 //l=0.655 //layer=m1 \
 //thickness=0.36 //x=26.09 //y=0.35 //x2=26.09 //y2=1.005
r2172 (  63 408 ) resistor r=3.1 //w=0.17 //l=0.51 //layer=mcon //count=3 \
 //x=25.65 //y=0.18 //x2=25.65 //y2=0.18
r2173 (  61 397 ) resistor r=3.1 //w=0.17 //l=0.51 //layer=mcon //count=3 \
 //x=24.17 //y=0.18 //x2=24.17 //y2=0.18
r2174 (  61 63 ) resistor r=0.594855 //w=0.311 //l=1.48 //layer=m1 \
 //thickness=0.36 //x=24.17 //y=0.175 //x2=25.65 //y2=0.175
r2175 (  59 395 ) resistor r=3.1 //w=0.17 //l=0.51 //layer=mcon //count=3 \
 //x=23.06 //y=0.18 //x2=23.06 //y2=0.18
r2176 (  59 61 ) resistor r=0.446141 //w=0.311 //l=1.11 //layer=m1 \
 //thickness=0.36 //x=23.06 //y=0.175 //x2=24.17 //y2=0.175
r2177 (  57 393 ) resistor r=3.1 //w=0.17 //l=0.51 //layer=mcon //count=3 \
 //x=21.95 //y=0.18 //x2=21.95 //y2=0.18
r2178 (  57 59 ) resistor r=0.446141 //w=0.311 //l=1.11 //layer=m1 \
 //thickness=0.36 //x=21.95 //y=0.175 //x2=23.06 //y2=0.175
r2179 (  55 238 ) resistor r=0.028033 //w=0.35 //l=0.085 //layer=m1 \
 //thickness=0.36 //x=21.26 //y=0.175 //x2=21.175 //y2=0.175
r2180 (  55 57 ) resistor r=0.277331 //w=0.311 //l=0.69 //layer=m1 \
 //thickness=0.36 //x=21.26 //y=0.175 //x2=21.95 //y2=0.175
r2181 (  54 243 ) resistor r=0.028033 //w=0.35 //l=0.085 //layer=m1 \
 //thickness=0.36 //x=26.005 //y=0.175 //x2=26.09 //y2=0.175
r2182 (  54 63 ) resistor r=0.142685 //w=0.311 //l=0.355 //layer=m1 \
 //thickness=0.36 //x=26.005 //y=0.175 //x2=25.65 //y2=0.175
r2183 (  53 236 ) resistor r=0.0942778 //w=0.221 //l=0.13 //layer=m1 \
 //thickness=0.36 //x=21.175 //y=1.015 //x2=21.175 //y2=1.145
r2184 (  52 238 ) resistor r=0.0413265 //w=0.7 //l=0.175 //layer=m1 \
 //thickness=0.36 //x=21.175 //y=0.35 //x2=21.175 //y2=0.175
r2185 (  52 53 ) resistor r=0.634542 //w=0.131 //l=0.665 //layer=m1 \
 //thickness=0.36 //x=21.175 //y=0.35 //x2=21.175 //y2=1.015
r2186 (  51 391 ) resistor r=3.1 //w=0.17 //l=0.51 //layer=mcon //count=3 \
 //x=20.84 //y=0.18 //x2=20.84 //y2=0.18
r2187 (  49 380 ) resistor r=3.1 //w=0.17 //l=0.51 //layer=mcon //count=3 \
 //x=19.36 //y=0.18 //x2=19.36 //y2=0.18
r2188 (  49 51 ) resistor r=0.594855 //w=0.311 //l=1.48 //layer=m1 \
 //thickness=0.36 //x=19.36 //y=0.175 //x2=20.84 //y2=0.175
r2189 (  47 378 ) resistor r=3.1 //w=0.17 //l=0.51 //layer=mcon //count=3 \
 //x=18.25 //y=0.18 //x2=18.25 //y2=0.18
r2190 (  47 49 ) resistor r=0.446141 //w=0.311 //l=1.11 //layer=m1 \
 //thickness=0.36 //x=18.25 //y=0.175 //x2=19.36 //y2=0.175
r2191 (  45 234 ) resistor r=0.028033 //w=0.35 //l=0.085 //layer=m1 \
 //thickness=0.36 //x=18.035 //y=0.175 //x2=17.95 //y2=0.175
r2192 (  45 47 ) resistor r=0.0864148 //w=0.311 //l=0.215 //layer=m1 \
 //thickness=0.36 //x=18.035 //y=0.175 //x2=18.25 //y2=0.175
r2193 (  44 238 ) resistor r=0.028033 //w=0.35 //l=0.085 //layer=m1 \
 //thickness=0.36 //x=21.09 //y=0.175 //x2=21.175 //y2=0.175
r2194 (  44 51 ) resistor r=0.100482 //w=0.311 //l=0.25 //layer=m1 \
 //thickness=0.36 //x=21.09 //y=0.175 //x2=20.84 //y2=0.175
r2195 (  42 234 ) resistor r=0.0413265 //w=0.7 //l=0.175 //layer=m1 \
 //thickness=0.36 //x=17.95 //y=0.35 //x2=17.95 //y2=0.175
r2196 (  42 232 ) resistor r=0.625 //w=0.131 //l=0.655 //layer=m1 \
 //thickness=0.36 //x=17.95 //y=0.35 //x2=17.95 //y2=1.005
r2197 (  41 376 ) resistor r=3.1 //w=0.17 //l=0.51 //layer=mcon //count=3 \
 //x=17.14 //y=0.18 //x2=17.14 //y2=0.18
r2198 (  39 365 ) resistor r=3.1 //w=0.17 //l=0.51 //layer=mcon //count=3 \
 //x=15.66 //y=0.18 //x2=15.66 //y2=0.18
r2199 (  39 41 ) resistor r=0.594855 //w=0.311 //l=1.48 //layer=m1 \
 //thickness=0.36 //x=15.66 //y=0.175 //x2=17.14 //y2=0.175
r2200 (  37 229 ) resistor r=0.028033 //w=0.35 //l=0.085 //layer=m1 \
 //thickness=0.36 //x=14.705 //y=0.175 //x2=14.62 //y2=0.175
r2201 (  37 39 ) resistor r=0.383842 //w=0.311 //l=0.955 //layer=m1 \
 //thickness=0.36 //x=14.705 //y=0.175 //x2=15.66 //y2=0.175
r2202 (  36 234 ) resistor r=0.028033 //w=0.35 //l=0.085 //layer=m1 \
 //thickness=0.36 //x=17.865 //y=0.175 //x2=17.95 //y2=0.175
r2203 (  36 41 ) resistor r=0.291399 //w=0.311 //l=0.725 //layer=m1 \
 //thickness=0.36 //x=17.865 //y=0.175 //x2=17.14 //y2=0.175
r2204 (  34 229 ) resistor r=0.0413265 //w=0.7 //l=0.175 //layer=m1 \
 //thickness=0.36 //x=14.62 //y=0.35 //x2=14.62 //y2=0.175
r2205 (  34 226 ) resistor r=0.625 //w=0.131 //l=0.655 //layer=m1 \
 //thickness=0.36 //x=14.62 //y=0.35 //x2=14.62 //y2=1.005
r2206 (  33 352 ) resistor r=3.1 //w=0.17 //l=0.51 //layer=mcon //count=3 \
 //x=13.07 //y=0.18 //x2=13.07 //y2=0.18
r2207 (  31 350 ) resistor r=3.1 //w=0.17 //l=0.51 //layer=mcon //count=3 \
 //x=11.96 //y=0.18 //x2=11.96 //y2=0.18
r2208 (  31 33 ) resistor r=0.446141 //w=0.311 //l=1.11 //layer=m1 \
 //thickness=0.36 //x=11.96 //y=0.175 //x2=13.07 //y2=0.175
r2209 (  29 348 ) resistor r=3.1 //w=0.17 //l=0.51 //layer=mcon //count=3 \
 //x=10.85 //y=0.18 //x2=10.85 //y2=0.18
r2210 (  29 31 ) resistor r=0.446141 //w=0.311 //l=1.11 //layer=m1 \
 //thickness=0.36 //x=10.85 //y=0.175 //x2=11.96 //y2=0.175
r2211 (  27 223 ) resistor r=0.028033 //w=0.35 //l=0.085 //layer=m1 \
 //thickness=0.36 //x=9.79 //y=0.175 //x2=9.705 //y2=0.175
r2212 (  27 29 ) resistor r=0.426045 //w=0.311 //l=1.06 //layer=m1 \
 //thickness=0.36 //x=9.79 //y=0.175 //x2=10.85 //y2=0.175
r2213 (  26 229 ) resistor r=0.028033 //w=0.35 //l=0.085 //layer=m1 \
 //thickness=0.36 //x=14.535 //y=0.175 //x2=14.62 //y2=0.175
r2214 (  26 33 ) resistor r=0.588826 //w=0.311 //l=1.465 //layer=m1 \
 //thickness=0.36 //x=14.535 //y=0.175 //x2=13.07 //y2=0.175
r2215 (  25 220 ) resistor r=0.0942778 //w=0.221 //l=0.13 //layer=m1 \
 //thickness=0.36 //x=9.705 //y=1.015 //x2=9.705 //y2=1.145
r2216 (  24 223 ) resistor r=0.0413265 //w=0.7 //l=0.175 //layer=m1 \
 //thickness=0.36 //x=9.705 //y=0.35 //x2=9.705 //y2=0.175
r2217 (  24 25 ) resistor r=0.634542 //w=0.131 //l=0.665 //layer=m1 \
 //thickness=0.36 //x=9.705 //y=0.35 //x2=9.705 //y2=1.015
r2218 (  23 335 ) resistor r=3.1 //w=0.17 //l=0.51 //layer=mcon //count=3 \
 //x=8.26 //y=0.18 //x2=8.26 //y2=0.18
r2219 (  21 333 ) resistor r=3.1 //w=0.17 //l=0.51 //layer=mcon //count=3 \
 //x=7.15 //y=0.18 //x2=7.15 //y2=0.18
r2220 (  21 23 ) resistor r=0.446141 //w=0.311 //l=1.11 //layer=m1 \
 //thickness=0.36 //x=7.15 //y=0.175 //x2=8.26 //y2=0.175
r2221 (  19 331 ) resistor r=3.1 //w=0.17 //l=0.51 //layer=mcon //count=3 \
 //x=6.04 //y=0.18 //x2=6.04 //y2=0.18
r2222 (  19 21 ) resistor r=0.446141 //w=0.311 //l=1.11 //layer=m1 \
 //thickness=0.36 //x=6.04 //y=0.175 //x2=7.15 //y2=0.175
r2223 (  17 218 ) resistor r=0.028033 //w=0.35 //l=0.085 //layer=m1 \
 //thickness=0.36 //x=4.98 //y=0.175 //x2=4.895 //y2=0.175
r2224 (  17 19 ) resistor r=0.426045 //w=0.311 //l=1.06 //layer=m1 \
 //thickness=0.36 //x=4.98 //y=0.175 //x2=6.04 //y2=0.175
r2225 (  16 223 ) resistor r=0.028033 //w=0.35 //l=0.085 //layer=m1 \
 //thickness=0.36 //x=9.62 //y=0.175 //x2=9.705 //y2=0.175
r2226 (  16 23 ) resistor r=0.546624 //w=0.311 //l=1.36 //layer=m1 \
 //thickness=0.36 //x=9.62 //y=0.175 //x2=8.26 //y2=0.175
r2227 (  15 215 ) resistor r=0.0942778 //w=0.221 //l=0.13 //layer=m1 \
 //thickness=0.36 //x=4.895 //y=1.015 //x2=4.895 //y2=1.145
r2228 (  14 218 ) resistor r=0.0413265 //w=0.7 //l=0.175 //layer=m1 \
 //thickness=0.36 //x=4.895 //y=0.35 //x2=4.895 //y2=0.175
r2229 (  14 15 ) resistor r=0.634542 //w=0.131 //l=0.665 //layer=m1 \
 //thickness=0.36 //x=4.895 //y=0.35 //x2=4.895 //y2=1.015
r2230 (  13 318 ) resistor r=3.1 //w=0.17 //l=0.51 //layer=mcon //count=3 \
 //x=3.45 //y=0.18 //x2=3.45 //y2=0.18
r2231 (  11 316 ) resistor r=3.1 //w=0.17 //l=0.51 //layer=mcon //count=3 \
 //x=2.34 //y=0.18 //x2=2.34 //y2=0.18
r2232 (  11 13 ) resistor r=0.446141 //w=0.311 //l=1.11 //layer=m1 \
 //thickness=0.36 //x=2.34 //y=0.175 //x2=3.45 //y2=0.175
r2233 (  9 213 ) resistor r=0.028033 //w=0.35 //l=0.085 //layer=m1 \
 //thickness=0.36 //x=1.755 //y=0.175 //x2=1.67 //y2=0.175
r2234 (  9 11 ) resistor r=0.235129 //w=0.311 //l=0.585 //layer=m1 \
 //thickness=0.36 //x=1.755 //y=0.175 //x2=2.34 //y2=0.175
r2235 (  8 218 ) resistor r=0.028033 //w=0.35 //l=0.085 //layer=m1 \
 //thickness=0.36 //x=4.81 //y=0.175 //x2=4.895 //y2=0.175
r2236 (  8 13 ) resistor r=0.546624 //w=0.311 //l=1.36 //layer=m1 \
 //thickness=0.36 //x=4.81 //y=0.175 //x2=3.45 //y2=0.175
r2237 (  6 213 ) resistor r=0.0413265 //w=0.7 //l=0.175 //layer=m1 \
 //thickness=0.36 //x=1.67 //y=0.35 //x2=1.67 //y2=0.175
r2238 (  6 211 ) resistor r=0.625 //w=0.131 //l=0.655 //layer=m1 \
 //thickness=0.36 //x=1.67 //y=0.35 //x2=1.67 //y2=1.005
r2239 (  4 314 ) resistor r=3.1 //w=0.17 //l=0.51 //layer=mcon //count=3 \
 //x=1.23 //y=0.18 //x2=1.23 //y2=0.18
r2240 (  2 213 ) resistor r=0.028033 //w=0.35 //l=0.085 //layer=m1 \
 //thickness=0.36 //x=1.585 //y=0.175 //x2=1.67 //y2=0.175
r2241 (  2 4 ) resistor r=0.142685 //w=0.311 //l=0.355 //layer=m1 \
 //thickness=0.36 //x=1.585 //y=0.175 //x2=1.23 //y2=0.175
r2242 (  1 108 ) resistor r=0.223071 //w=0.311 //l=0.555 //layer=m1 \
 //thickness=0.36 //x=43.225 //y=0.175 //x2=43.78 //y2=0.175
r2243 (  1 105 ) resistor r=0.223071 //w=0.311 //l=0.555 //layer=m1 \
 //thickness=0.36 //x=43.225 //y=0.175 //x2=42.67 //y2=0.175
ends PM_TMRDFFSNQX1\%GND

subckt PM_TMRDFFSNQX1\%Q ( 1 2 3 4 5 6 7 9 11 12 13 14 15 26 36 43 45 )
c80 ( 43 0 ) capacitor c=0.00875839f //x=84.665 //y=1.09
c81 ( 36 0 ) capacitor c=0.0261871f //x=84.855 //y=5.56
c82 ( 26 0 ) capacitor c=0.0196817f //x=84.85 //y=1.185
c83 ( 15 0 ) capacitor c=0.00557311f //x=84.94 //y=5.14
c84 ( 14 0 ) capacitor c=0.00944012f //x=85.135 //y=5.14
c85 ( 13 0 ) capacitor c=0.00724565f //x=84.935 //y=2.02
c86 ( 12 0 ) capacitor c=0.0145753f //x=85.135 //y=2.02
c87 ( 11 0 ) capacitor c=0.0117946f //x=84.855 //y=5.42
c88 ( 9 0 ) capacitor c=0.0166561f //x=84.85 //y=1.935
c89 ( 1 0 ) capacitor c=0.116158f //x=85.22 //y=2.4
r90 (  36 45 ) resistor r=23.615 //w=0.187 //l=0.345 //layer=li \
 //thickness=0.1 //x=84.855 //y=5.56 //x2=84.855 //y2=5.905
r91 (  29 36 ) resistor r=9.3 //w=0.17 //l=0.17 //layer=mcon //count=1 \
 //x=84.855 //y=5.56 //x2=84.855 //y2=5.56
r92 (  26 43 ) resistor r=9.3 //w=0.17 //l=0.17 //layer=mcon //count=1 \
 //x=84.85 //y=1.185 //x2=84.85 //y2=1.185
r93 (  14 17 ) resistor r=0.0698411 //w=0.17 //l=0.120208 //layer=m1 \
 //thickness=0.36 //x=85.135 //y=5.14 //x2=85.22 //y2=5.055
r94 (  14 15 ) resistor r=0.186069 //w=0.131 //l=0.195 //layer=m1 \
 //thickness=0.36 //x=85.135 //y=5.14 //x2=84.94 //y2=5.14
r95 (  12 16 ) resistor r=0.0698411 //w=0.17 //l=0.120208 //layer=m1 \
 //thickness=0.36 //x=85.135 //y=2.02 //x2=85.22 //y2=2.105
r96 (  12 13 ) resistor r=0.19084 //w=0.131 //l=0.2 //layer=m1 \
 //thickness=0.36 //x=85.135 //y=2.02 //x2=84.935 //y2=2.02
r97 (  11 29 ) resistor r=0.086672 //w=0.218 //l=0.14 //layer=m1 \
 //thickness=0.36 //x=84.855 //y=5.42 //x2=84.855 //y2=5.56
r98 (  10 15 ) resistor r=0.0698411 //w=0.17 //l=0.120208 //layer=m1 \
 //thickness=0.36 //x=84.855 //y=5.225 //x2=84.94 //y2=5.14
r99 (  10 11 ) resistor r=0.186069 //w=0.131 //l=0.195 //layer=m1 \
 //thickness=0.36 //x=84.855 //y=5.225 //x2=84.855 //y2=5.42
r100 (  9 13 ) resistor r=0.0698411 //w=0.17 //l=0.120208 //layer=m1 \
 //thickness=0.36 //x=84.85 //y=1.935 //x2=84.935 //y2=2.02
r101 (  8 26 ) resistor r=0.105739 //w=0.201 //l=0.145 //layer=m1 \
 //thickness=0.36 //x=84.85 //y=1.33 //x2=84.85 //y2=1.185
r102 (  8 9 ) resistor r=0.57729 //w=0.131 //l=0.605 //layer=m1 \
 //thickness=0.36 //x=84.85 //y=1.33 //x2=84.85 //y2=1.935
r103 (  7 17 ) resistor r=0.415076 //w=0.131 //l=0.435 //layer=m1 \
 //thickness=0.36 //x=85.22 //y=4.62 //x2=85.22 //y2=5.055
r104 (  6 7 ) resistor r=0.353053 //w=0.131 //l=0.37 //layer=m1 \
 //thickness=0.36 //x=85.22 //y=4.25 //x2=85.22 //y2=4.62
r105 (  5 6 ) resistor r=0.353053 //w=0.131 //l=0.37 //layer=m1 \
 //thickness=0.36 //x=85.22 //y=3.88 //x2=85.22 //y2=4.25
r106 (  4 5 ) resistor r=0.353053 //w=0.131 //l=0.37 //layer=m1 \
 //thickness=0.36 //x=85.22 //y=3.51 //x2=85.22 //y2=3.88
r107 (  3 4 ) resistor r=0.353053 //w=0.131 //l=0.37 //layer=m1 \
 //thickness=0.36 //x=85.22 //y=3.14 //x2=85.22 //y2=3.51
r108 (  2 3 ) resistor r=0.353053 //w=0.131 //l=0.37 //layer=m1 \
 //thickness=0.36 //x=85.22 //y=2.77 //x2=85.22 //y2=3.14
r109 (  1 2 ) resistor r=0.353053 //w=0.131 //l=0.37 //layer=m1 \
 //thickness=0.36 //x=85.22 //y=2.4 //x2=85.22 //y2=2.77
r110 (  1 16 ) resistor r=0.281489 //w=0.131 //l=0.295 //layer=m1 \
 //thickness=0.36 //x=85.22 //y=2.4 //x2=85.22 //y2=2.105
ends PM_TMRDFFSNQX1\%Q

subckt PM_TMRDFFSNQX1\%noxref_37 ( 1 5 9 10 13 17 29 )
c63 ( 29 0 ) capacitor c=0.0672418f //x=1.05 //y=0.545
c64 ( 17 0 ) capacitor c=0.00675704f //x=3.125 //y=0.795
c65 ( 13 0 ) capacitor c=0.0156697f //x=3.04 //y=0.71
c66 ( 10 0 ) capacitor c=0.007067f //x=2.155 //y=1.675
c67 ( 9 0 ) capacitor c=0.00770028f //x=2.155 //y=0.795
c68 ( 5 0 ) capacitor c=0.019857f //x=2.07 //y=1.76
c69 ( 1 0 ) capacitor c=0.0115037f //x=1.185 //y=1.675
r70 (  17 29 ) resistor r=3.57586 //w=0.17 //l=0.125 //layer=li \
 //thickness=0.1 //x=3.125 //y=0.795 //x2=3.125 //y2=0.67
r71 (  17 29 ) resistor r=18.139 //w=0.187 //l=0.265 //layer=li \
 //thickness=0.1 //x=3.125 //y=0.795 //x2=3.125 //y2=1.06
r72 (  14 29 ) resistor r=3.57586 //w=0.17 //l=0.103078 //layer=li \
 //thickness=0.1 //x=2.24 //y=0.71 //x2=2.155 //y2=0.67
r73 (  14 29 ) resistor r=27.3797 //w=0.187 //l=0.4 //layer=li //thickness=0.1 \
 //x=2.24 //y=0.71 //x2=2.64 //y2=0.71
r74 (  13 29 ) resistor r=3.57586 //w=0.17 //l=0.103078 //layer=li \
 //thickness=0.1 //x=3.04 //y=0.71 //x2=3.125 //y2=0.67
r75 (  13 29 ) resistor r=27.3797 //w=0.187 //l=0.4 //layer=li //thickness=0.1 \
 //x=3.04 //y=0.71 //x2=2.64 //y2=0.71
r76 (  10 29 ) resistor r=3.57586 //w=0.17 //l=0.125 //layer=li \
 //thickness=0.1 //x=2.155 //y=1.675 //x2=2.155 //y2=1.8
r77 (  10 29 ) resistor r=42.0963 //w=0.187 //l=0.615 //layer=li \
 //thickness=0.1 //x=2.155 //y=1.675 //x2=2.155 //y2=1.06
r78 (  9 29 ) resistor r=3.57586 //w=0.17 //l=0.125 //layer=li //thickness=0.1 \
 //x=2.155 //y=0.795 //x2=2.155 //y2=0.67
r79 (  9 29 ) resistor r=18.139 //w=0.187 //l=0.265 //layer=li //thickness=0.1 \
 //x=2.155 //y=0.795 //x2=2.155 //y2=1.06
r80 (  6 29 ) resistor r=3.57586 //w=0.17 //l=0.103078 //layer=li \
 //thickness=0.1 //x=1.27 //y=1.76 //x2=1.185 //y2=1.8
r81 (  6 29 ) resistor r=27.3797 //w=0.187 //l=0.4 //layer=li //thickness=0.1 \
 //x=1.27 //y=1.76 //x2=1.67 //y2=1.76
r82 (  5 29 ) resistor r=3.57586 //w=0.17 //l=0.103078 //layer=li \
 //thickness=0.1 //x=2.07 //y=1.76 //x2=2.155 //y2=1.8
r83 (  5 29 ) resistor r=27.3797 //w=0.187 //l=0.4 //layer=li //thickness=0.1 \
 //x=2.07 //y=1.76 //x2=1.67 //y2=1.76
r84 (  1 29 ) resistor r=3.57586 //w=0.17 //l=0.125 //layer=li //thickness=0.1 \
 //x=1.185 //y=1.675 //x2=1.185 //y2=1.8
r85 (  1 29 ) resistor r=42.0963 //w=0.187 //l=0.615 //layer=li \
 //thickness=0.1 //x=1.185 //y=1.675 //x2=1.185 //y2=1.06
ends PM_TMRDFFSNQX1\%noxref_37

subckt PM_TMRDFFSNQX1\%noxref_38 ( 1 5 9 13 17 35 )
c59 ( 35 0 ) capacitor c=0.0691972f //x=4.275 //y=0.555
c60 ( 17 0 ) capacitor c=0.0195855f //x=6.265 //y=1.77
c61 ( 13 0 ) capacitor c=0.015342f //x=6.265 //y=0.72
c62 ( 9 0 ) capacitor c=0.00772076f //x=5.38 //y=0.805
c63 ( 5 0 ) capacitor c=0.0168722f //x=5.295 //y=1.77
c64 ( 1 0 ) capacitor c=0.00726193f //x=4.41 //y=1.685
r65 (  18 35 ) resistor r=5.4201 //w=0.17 //l=0.103078 //layer=li \
 //thickness=0.1 //x=5.465 //y=1.77 //x2=5.38 //y2=1.81
r66 (  18 35 ) resistor r=27.3797 //w=0.187 //l=0.4 //layer=li //thickness=0.1 \
 //x=5.465 //y=1.77 //x2=5.865 //y2=1.77
r67 (  17 35 ) resistor r=0.751729 //w=0.17 //l=0.085 //layer=li \
 //thickness=0.1 //x=6.265 //y=1.77 //x2=6.35 //y2=1.77
r68 (  17 35 ) resistor r=27.3797 //w=0.187 //l=0.4 //layer=li //thickness=0.1 \
 //x=6.265 //y=1.77 //x2=5.865 //y2=1.77
r69 (  14 35 ) resistor r=3.57586 //w=0.17 //l=0.103078 //layer=li \
 //thickness=0.1 //x=5.465 //y=0.72 //x2=5.38 //y2=0.68
r70 (  14 35 ) resistor r=27.3797 //w=0.187 //l=0.4 //layer=li //thickness=0.1 \
 //x=5.465 //y=0.72 //x2=5.865 //y2=0.72
r71 (  13 35 ) resistor r=0.751729 //w=0.17 //l=0.085 //layer=li \
 //thickness=0.1 //x=6.265 //y=0.72 //x2=6.35 //y2=0.72
r72 (  13 35 ) resistor r=27.3797 //w=0.187 //l=0.4 //layer=li //thickness=0.1 \
 //x=6.265 //y=0.72 //x2=5.865 //y2=0.72
r73 (  10 35 ) resistor r=1.40859 //w=0.34 //l=0.125 //layer=li \
 //thickness=0.1 //x=5.38 //y=1.685 //x2=5.38 //y2=1.81
r74 (  10 35 ) resistor r=42.0963 //w=0.187 //l=0.615 //layer=li \
 //thickness=0.1 //x=5.38 //y=1.685 //x2=5.38 //y2=1.07
r75 (  9 35 ) resistor r=3.57586 //w=0.17 //l=0.125 //layer=li //thickness=0.1 \
 //x=5.38 //y=0.805 //x2=5.38 //y2=0.68
r76 (  9 35 ) resistor r=18.139 //w=0.187 //l=0.265 //layer=li //thickness=0.1 \
 //x=5.38 //y=0.805 //x2=5.38 //y2=1.07
r77 (  6 35 ) resistor r=3.57586 //w=0.17 //l=0.103078 //layer=li \
 //thickness=0.1 //x=4.495 //y=1.77 //x2=4.41 //y2=1.81
r78 (  6 35 ) resistor r=27.3797 //w=0.187 //l=0.4 //layer=li //thickness=0.1 \
 //x=4.495 //y=1.77 //x2=4.895 //y2=1.77
r79 (  5 35 ) resistor r=5.4201 //w=0.17 //l=0.103078 //layer=li \
 //thickness=0.1 //x=5.295 //y=1.77 //x2=5.38 //y2=1.81
r80 (  5 35 ) resistor r=27.3797 //w=0.187 //l=0.4 //layer=li //thickness=0.1 \
 //x=5.295 //y=1.77 //x2=4.895 //y2=1.77
r81 (  1 35 ) resistor r=3.57586 //w=0.17 //l=0.125 //layer=li //thickness=0.1 \
 //x=4.41 //y=1.685 //x2=4.41 //y2=1.81
r82 (  1 35 ) resistor r=42.0963 //w=0.187 //l=0.615 //layer=li \
 //thickness=0.1 //x=4.41 //y=1.685 //x2=4.41 //y2=1.07
ends PM_TMRDFFSNQX1\%noxref_38

subckt PM_TMRDFFSNQX1\%noxref_39 ( 1 5 9 13 17 35 )
c59 ( 35 0 ) capacitor c=0.0695128f //x=9.085 //y=0.555
c60 ( 17 0 ) capacitor c=0.0199063f //x=11.075 //y=1.77
c61 ( 13 0 ) capacitor c=0.0153215f //x=11.075 //y=0.72
c62 ( 9 0 ) capacitor c=0.00772076f //x=10.19 //y=0.805
c63 ( 5 0 ) capacitor c=0.0173197f //x=10.105 //y=1.77
c64 ( 1 0 ) capacitor c=0.00727095f //x=9.22 //y=1.685
r65 (  18 35 ) resistor r=5.4201 //w=0.17 //l=0.103078 //layer=li \
 //thickness=0.1 //x=10.275 //y=1.77 //x2=10.19 //y2=1.81
r66 (  18 35 ) resistor r=27.3797 //w=0.187 //l=0.4 //layer=li //thickness=0.1 \
 //x=10.275 //y=1.77 //x2=10.675 //y2=1.77
r67 (  17 35 ) resistor r=0.751729 //w=0.17 //l=0.085 //layer=li \
 //thickness=0.1 //x=11.075 //y=1.77 //x2=11.16 //y2=1.77
r68 (  17 35 ) resistor r=27.3797 //w=0.187 //l=0.4 //layer=li //thickness=0.1 \
 //x=11.075 //y=1.77 //x2=10.675 //y2=1.77
r69 (  14 35 ) resistor r=3.57586 //w=0.17 //l=0.103078 //layer=li \
 //thickness=0.1 //x=10.275 //y=0.72 //x2=10.19 //y2=0.68
r70 (  14 35 ) resistor r=27.3797 //w=0.187 //l=0.4 //layer=li //thickness=0.1 \
 //x=10.275 //y=0.72 //x2=10.675 //y2=0.72
r71 (  13 35 ) resistor r=0.751729 //w=0.17 //l=0.085 //layer=li \
 //thickness=0.1 //x=11.075 //y=0.72 //x2=11.16 //y2=0.72
r72 (  13 35 ) resistor r=27.3797 //w=0.187 //l=0.4 //layer=li //thickness=0.1 \
 //x=11.075 //y=0.72 //x2=10.675 //y2=0.72
r73 (  10 35 ) resistor r=1.40859 //w=0.34 //l=0.125 //layer=li \
 //thickness=0.1 //x=10.19 //y=1.685 //x2=10.19 //y2=1.81
r74 (  10 35 ) resistor r=42.0963 //w=0.187 //l=0.615 //layer=li \
 //thickness=0.1 //x=10.19 //y=1.685 //x2=10.19 //y2=1.07
r75 (  9 35 ) resistor r=3.57586 //w=0.17 //l=0.125 //layer=li //thickness=0.1 \
 //x=10.19 //y=0.805 //x2=10.19 //y2=0.68
r76 (  9 35 ) resistor r=18.139 //w=0.187 //l=0.265 //layer=li //thickness=0.1 \
 //x=10.19 //y=0.805 //x2=10.19 //y2=1.07
r77 (  6 35 ) resistor r=3.57586 //w=0.17 //l=0.103078 //layer=li \
 //thickness=0.1 //x=9.305 //y=1.77 //x2=9.22 //y2=1.81
r78 (  6 35 ) resistor r=27.3797 //w=0.187 //l=0.4 //layer=li //thickness=0.1 \
 //x=9.305 //y=1.77 //x2=9.705 //y2=1.77
r79 (  5 35 ) resistor r=5.4201 //w=0.17 //l=0.103078 //layer=li \
 //thickness=0.1 //x=10.105 //y=1.77 //x2=10.19 //y2=1.81
r80 (  5 35 ) resistor r=27.3797 //w=0.187 //l=0.4 //layer=li //thickness=0.1 \
 //x=10.105 //y=1.77 //x2=9.705 //y2=1.77
r81 (  1 35 ) resistor r=3.57586 //w=0.17 //l=0.125 //layer=li //thickness=0.1 \
 //x=9.22 //y=1.685 //x2=9.22 //y2=1.81
r82 (  1 35 ) resistor r=42.0963 //w=0.187 //l=0.615 //layer=li \
 //thickness=0.1 //x=9.22 //y=1.685 //x2=9.22 //y2=1.07
ends PM_TMRDFFSNQX1\%noxref_39

subckt PM_TMRDFFSNQX1\%noxref_40 ( 1 5 9 10 13 17 29 )
c66 ( 29 0 ) capacitor c=0.0671873f //x=14 //y=0.545
c67 ( 17 0 ) capacitor c=0.0067865f //x=16.075 //y=0.795
c68 ( 13 0 ) capacitor c=0.0154977f //x=15.99 //y=0.71
c69 ( 10 0 ) capacitor c=0.00678687f //x=15.105 //y=1.675
c70 ( 9 0 ) capacitor c=0.00770028f //x=15.105 //y=0.795
c71 ( 5 0 ) capacitor c=0.0179209f //x=15.02 //y=1.76
c72 ( 1 0 ) capacitor c=0.00761099f //x=14.135 //y=1.675
r73 (  17 29 ) resistor r=3.57586 //w=0.17 //l=0.125 //layer=li \
 //thickness=0.1 //x=16.075 //y=0.795 //x2=16.075 //y2=0.67
r74 (  17 29 ) resistor r=18.139 //w=0.187 //l=0.265 //layer=li \
 //thickness=0.1 //x=16.075 //y=0.795 //x2=16.075 //y2=1.06
r75 (  14 29 ) resistor r=3.57586 //w=0.17 //l=0.103078 //layer=li \
 //thickness=0.1 //x=15.19 //y=0.71 //x2=15.105 //y2=0.67
r76 (  14 29 ) resistor r=27.3797 //w=0.187 //l=0.4 //layer=li //thickness=0.1 \
 //x=15.19 //y=0.71 //x2=15.59 //y2=0.71
r77 (  13 29 ) resistor r=3.57586 //w=0.17 //l=0.103078 //layer=li \
 //thickness=0.1 //x=15.99 //y=0.71 //x2=16.075 //y2=0.67
r78 (  13 29 ) resistor r=27.3797 //w=0.187 //l=0.4 //layer=li //thickness=0.1 \
 //x=15.99 //y=0.71 //x2=15.59 //y2=0.71
r79 (  10 29 ) resistor r=3.57586 //w=0.17 //l=0.125 //layer=li \
 //thickness=0.1 //x=15.105 //y=1.675 //x2=15.105 //y2=1.8
r80 (  10 29 ) resistor r=42.0963 //w=0.187 //l=0.615 //layer=li \
 //thickness=0.1 //x=15.105 //y=1.675 //x2=15.105 //y2=1.06
r81 (  9 29 ) resistor r=3.57586 //w=0.17 //l=0.125 //layer=li //thickness=0.1 \
 //x=15.105 //y=0.795 //x2=15.105 //y2=0.67
r82 (  9 29 ) resistor r=18.139 //w=0.187 //l=0.265 //layer=li //thickness=0.1 \
 //x=15.105 //y=0.795 //x2=15.105 //y2=1.06
r83 (  6 29 ) resistor r=3.57586 //w=0.17 //l=0.103078 //layer=li \
 //thickness=0.1 //x=14.22 //y=1.76 //x2=14.135 //y2=1.8
r84 (  6 29 ) resistor r=27.3797 //w=0.187 //l=0.4 //layer=li //thickness=0.1 \
 //x=14.22 //y=1.76 //x2=14.62 //y2=1.76
r85 (  5 29 ) resistor r=3.57586 //w=0.17 //l=0.103078 //layer=li \
 //thickness=0.1 //x=15.02 //y=1.76 //x2=15.105 //y2=1.8
r86 (  5 29 ) resistor r=27.3797 //w=0.187 //l=0.4 //layer=li //thickness=0.1 \
 //x=15.02 //y=1.76 //x2=14.62 //y2=1.76
r87 (  1 29 ) resistor r=3.57586 //w=0.17 //l=0.125 //layer=li //thickness=0.1 \
 //x=14.135 //y=1.675 //x2=14.135 //y2=1.8
r88 (  1 29 ) resistor r=42.0963 //w=0.187 //l=0.615 //layer=li \
 //thickness=0.1 //x=14.135 //y=1.675 //x2=14.135 //y2=1.06
ends PM_TMRDFFSNQX1\%noxref_40

subckt PM_TMRDFFSNQX1\%noxref_41 ( 1 5 9 10 13 17 29 )
c69 ( 29 0 ) capacitor c=0.0671324f //x=17.33 //y=0.545
c70 ( 17 0 ) capacitor c=0.00675704f //x=19.405 //y=0.795
c71 ( 13 0 ) capacitor c=0.0154977f //x=19.32 //y=0.71
c72 ( 10 0 ) capacitor c=0.00673372f //x=18.435 //y=1.675
c73 ( 9 0 ) capacitor c=0.00770028f //x=18.435 //y=0.795
c74 ( 5 0 ) capacitor c=0.0179513f //x=18.35 //y=1.76
c75 ( 1 0 ) capacitor c=0.0076012f //x=17.465 //y=1.675
r76 (  17 29 ) resistor r=3.57586 //w=0.17 //l=0.125 //layer=li \
 //thickness=0.1 //x=19.405 //y=0.795 //x2=19.405 //y2=0.67
r77 (  17 29 ) resistor r=18.139 //w=0.187 //l=0.265 //layer=li \
 //thickness=0.1 //x=19.405 //y=0.795 //x2=19.405 //y2=1.06
r78 (  14 29 ) resistor r=3.57586 //w=0.17 //l=0.103078 //layer=li \
 //thickness=0.1 //x=18.52 //y=0.71 //x2=18.435 //y2=0.67
r79 (  14 29 ) resistor r=27.3797 //w=0.187 //l=0.4 //layer=li //thickness=0.1 \
 //x=18.52 //y=0.71 //x2=18.92 //y2=0.71
r80 (  13 29 ) resistor r=3.57586 //w=0.17 //l=0.103078 //layer=li \
 //thickness=0.1 //x=19.32 //y=0.71 //x2=19.405 //y2=0.67
r81 (  13 29 ) resistor r=27.3797 //w=0.187 //l=0.4 //layer=li //thickness=0.1 \
 //x=19.32 //y=0.71 //x2=18.92 //y2=0.71
r82 (  10 29 ) resistor r=3.57586 //w=0.17 //l=0.125 //layer=li \
 //thickness=0.1 //x=18.435 //y=1.675 //x2=18.435 //y2=1.8
r83 (  10 29 ) resistor r=42.0963 //w=0.187 //l=0.615 //layer=li \
 //thickness=0.1 //x=18.435 //y=1.675 //x2=18.435 //y2=1.06
r84 (  9 29 ) resistor r=3.57586 //w=0.17 //l=0.125 //layer=li //thickness=0.1 \
 //x=18.435 //y=0.795 //x2=18.435 //y2=0.67
r85 (  9 29 ) resistor r=18.139 //w=0.187 //l=0.265 //layer=li //thickness=0.1 \
 //x=18.435 //y=0.795 //x2=18.435 //y2=1.06
r86 (  6 29 ) resistor r=3.57586 //w=0.17 //l=0.103078 //layer=li \
 //thickness=0.1 //x=17.55 //y=1.76 //x2=17.465 //y2=1.8
r87 (  6 29 ) resistor r=27.3797 //w=0.187 //l=0.4 //layer=li //thickness=0.1 \
 //x=17.55 //y=1.76 //x2=17.95 //y2=1.76
r88 (  5 29 ) resistor r=3.57586 //w=0.17 //l=0.103078 //layer=li \
 //thickness=0.1 //x=18.35 //y=1.76 //x2=18.435 //y2=1.8
r89 (  5 29 ) resistor r=27.3797 //w=0.187 //l=0.4 //layer=li //thickness=0.1 \
 //x=18.35 //y=1.76 //x2=17.95 //y2=1.76
r90 (  1 29 ) resistor r=3.57586 //w=0.17 //l=0.125 //layer=li //thickness=0.1 \
 //x=17.465 //y=1.675 //x2=17.465 //y2=1.8
r91 (  1 29 ) resistor r=42.0963 //w=0.187 //l=0.615 //layer=li \
 //thickness=0.1 //x=17.465 //y=1.675 //x2=17.465 //y2=1.06
ends PM_TMRDFFSNQX1\%noxref_41

subckt PM_TMRDFFSNQX1\%noxref_42 ( 1 5 9 13 17 35 )
c59 ( 35 0 ) capacitor c=0.0688411f //x=20.555 //y=0.555
c60 ( 17 0 ) capacitor c=0.0189392f //x=22.545 //y=1.77
c61 ( 13 0 ) capacitor c=0.0153224f //x=22.545 //y=0.72
c62 ( 9 0 ) capacitor c=0.00772076f //x=21.66 //y=0.805
c63 ( 5 0 ) capacitor c=0.0168501f //x=21.575 //y=1.77
c64 ( 1 0 ) capacitor c=0.00709556f //x=20.69 //y=1.685
r65 (  18 35 ) resistor r=5.4201 //w=0.17 //l=0.103078 //layer=li \
 //thickness=0.1 //x=21.745 //y=1.77 //x2=21.66 //y2=1.81
r66 (  18 35 ) resistor r=27.3797 //w=0.187 //l=0.4 //layer=li //thickness=0.1 \
 //x=21.745 //y=1.77 //x2=22.145 //y2=1.77
r67 (  17 35 ) resistor r=0.751729 //w=0.17 //l=0.085 //layer=li \
 //thickness=0.1 //x=22.545 //y=1.77 //x2=22.63 //y2=1.77
r68 (  17 35 ) resistor r=27.3797 //w=0.187 //l=0.4 //layer=li //thickness=0.1 \
 //x=22.545 //y=1.77 //x2=22.145 //y2=1.77
r69 (  14 35 ) resistor r=3.57586 //w=0.17 //l=0.103078 //layer=li \
 //thickness=0.1 //x=21.745 //y=0.72 //x2=21.66 //y2=0.68
r70 (  14 35 ) resistor r=27.3797 //w=0.187 //l=0.4 //layer=li //thickness=0.1 \
 //x=21.745 //y=0.72 //x2=22.145 //y2=0.72
r71 (  13 35 ) resistor r=0.751729 //w=0.17 //l=0.085 //layer=li \
 //thickness=0.1 //x=22.545 //y=0.72 //x2=22.63 //y2=0.72
r72 (  13 35 ) resistor r=27.3797 //w=0.187 //l=0.4 //layer=li //thickness=0.1 \
 //x=22.545 //y=0.72 //x2=22.145 //y2=0.72
r73 (  10 35 ) resistor r=1.40859 //w=0.34 //l=0.125 //layer=li \
 //thickness=0.1 //x=21.66 //y=1.685 //x2=21.66 //y2=1.81
r74 (  10 35 ) resistor r=42.0963 //w=0.187 //l=0.615 //layer=li \
 //thickness=0.1 //x=21.66 //y=1.685 //x2=21.66 //y2=1.07
r75 (  9 35 ) resistor r=3.57586 //w=0.17 //l=0.125 //layer=li //thickness=0.1 \
 //x=21.66 //y=0.805 //x2=21.66 //y2=0.68
r76 (  9 35 ) resistor r=18.139 //w=0.187 //l=0.265 //layer=li //thickness=0.1 \
 //x=21.66 //y=0.805 //x2=21.66 //y2=1.07
r77 (  6 35 ) resistor r=3.57586 //w=0.17 //l=0.103078 //layer=li \
 //thickness=0.1 //x=20.775 //y=1.77 //x2=20.69 //y2=1.81
r78 (  6 35 ) resistor r=27.3797 //w=0.187 //l=0.4 //layer=li //thickness=0.1 \
 //x=20.775 //y=1.77 //x2=21.175 //y2=1.77
r79 (  5 35 ) resistor r=5.4201 //w=0.17 //l=0.103078 //layer=li \
 //thickness=0.1 //x=21.575 //y=1.77 //x2=21.66 //y2=1.81
r80 (  5 35 ) resistor r=27.3797 //w=0.187 //l=0.4 //layer=li //thickness=0.1 \
 //x=21.575 //y=1.77 //x2=21.175 //y2=1.77
r81 (  1 35 ) resistor r=3.57586 //w=0.17 //l=0.125 //layer=li //thickness=0.1 \
 //x=20.69 //y=1.685 //x2=20.69 //y2=1.81
r82 (  1 35 ) resistor r=42.0963 //w=0.187 //l=0.615 //layer=li \
 //thickness=0.1 //x=20.69 //y=1.685 //x2=20.69 //y2=1.07
ends PM_TMRDFFSNQX1\%noxref_42

subckt PM_TMRDFFSNQX1\%noxref_43 ( 1 5 9 10 13 17 29 )
c67 ( 29 0 ) capacitor c=0.0664911f //x=25.47 //y=0.545
c68 ( 17 0 ) capacitor c=0.00675704f //x=27.545 //y=0.795
c69 ( 13 0 ) capacitor c=0.0156182f //x=27.46 //y=0.71
c70 ( 10 0 ) capacitor c=0.00673372f //x=26.575 //y=1.675
c71 ( 9 0 ) capacitor c=0.00770028f //x=26.575 //y=0.795
c72 ( 5 0 ) capacitor c=0.0179513f //x=26.49 //y=1.76
c73 ( 1 0 ) capacitor c=0.00761099f //x=25.605 //y=1.675
r74 (  17 29 ) resistor r=3.57586 //w=0.17 //l=0.125 //layer=li \
 //thickness=0.1 //x=27.545 //y=0.795 //x2=27.545 //y2=0.67
r75 (  17 29 ) resistor r=18.139 //w=0.187 //l=0.265 //layer=li \
 //thickness=0.1 //x=27.545 //y=0.795 //x2=27.545 //y2=1.06
r76 (  14 29 ) resistor r=3.57586 //w=0.17 //l=0.103078 //layer=li \
 //thickness=0.1 //x=26.66 //y=0.71 //x2=26.575 //y2=0.67
r77 (  14 29 ) resistor r=27.3797 //w=0.187 //l=0.4 //layer=li //thickness=0.1 \
 //x=26.66 //y=0.71 //x2=27.06 //y2=0.71
r78 (  13 29 ) resistor r=3.57586 //w=0.17 //l=0.103078 //layer=li \
 //thickness=0.1 //x=27.46 //y=0.71 //x2=27.545 //y2=0.67
r79 (  13 29 ) resistor r=27.3797 //w=0.187 //l=0.4 //layer=li //thickness=0.1 \
 //x=27.46 //y=0.71 //x2=27.06 //y2=0.71
r80 (  10 29 ) resistor r=3.57586 //w=0.17 //l=0.125 //layer=li \
 //thickness=0.1 //x=26.575 //y=1.675 //x2=26.575 //y2=1.8
r81 (  10 29 ) resistor r=42.0963 //w=0.187 //l=0.615 //layer=li \
 //thickness=0.1 //x=26.575 //y=1.675 //x2=26.575 //y2=1.06
r82 (  9 29 ) resistor r=3.57586 //w=0.17 //l=0.125 //layer=li //thickness=0.1 \
 //x=26.575 //y=0.795 //x2=26.575 //y2=0.67
r83 (  9 29 ) resistor r=18.139 //w=0.187 //l=0.265 //layer=li //thickness=0.1 \
 //x=26.575 //y=0.795 //x2=26.575 //y2=1.06
r84 (  6 29 ) resistor r=3.57586 //w=0.17 //l=0.103078 //layer=li \
 //thickness=0.1 //x=25.69 //y=1.76 //x2=25.605 //y2=1.8
r85 (  6 29 ) resistor r=27.3797 //w=0.187 //l=0.4 //layer=li //thickness=0.1 \
 //x=25.69 //y=1.76 //x2=26.09 //y2=1.76
r86 (  5 29 ) resistor r=3.57586 //w=0.17 //l=0.103078 //layer=li \
 //thickness=0.1 //x=26.49 //y=1.76 //x2=26.575 //y2=1.8
r87 (  5 29 ) resistor r=27.3797 //w=0.187 //l=0.4 //layer=li //thickness=0.1 \
 //x=26.49 //y=1.76 //x2=26.09 //y2=1.76
r88 (  1 29 ) resistor r=3.57586 //w=0.17 //l=0.125 //layer=li //thickness=0.1 \
 //x=25.605 //y=1.675 //x2=25.605 //y2=1.8
r89 (  1 29 ) resistor r=42.0963 //w=0.187 //l=0.615 //layer=li \
 //thickness=0.1 //x=25.605 //y=1.675 //x2=25.605 //y2=1.06
ends PM_TMRDFFSNQX1\%noxref_43

subckt PM_TMRDFFSNQX1\%noxref_44 ( 1 5 9 13 17 35 )
c60 ( 35 0 ) capacitor c=0.068832f //x=28.695 //y=0.555
c61 ( 17 0 ) capacitor c=0.0190725f //x=30.685 //y=1.77
c62 ( 13 0 ) capacitor c=0.015325f //x=30.685 //y=0.72
c63 ( 9 0 ) capacitor c=0.00772076f //x=29.8 //y=0.805
c64 ( 5 0 ) capacitor c=0.0166883f //x=29.715 //y=1.77
c65 ( 1 0 ) capacitor c=0.00709556f //x=28.83 //y=1.685
r66 (  18 35 ) resistor r=5.4201 //w=0.17 //l=0.103078 //layer=li \
 //thickness=0.1 //x=29.885 //y=1.77 //x2=29.8 //y2=1.81
r67 (  18 35 ) resistor r=27.3797 //w=0.187 //l=0.4 //layer=li //thickness=0.1 \
 //x=29.885 //y=1.77 //x2=30.285 //y2=1.77
r68 (  17 35 ) resistor r=0.751729 //w=0.17 //l=0.085 //layer=li \
 //thickness=0.1 //x=30.685 //y=1.77 //x2=30.77 //y2=1.77
r69 (  17 35 ) resistor r=27.3797 //w=0.187 //l=0.4 //layer=li //thickness=0.1 \
 //x=30.685 //y=1.77 //x2=30.285 //y2=1.77
r70 (  14 35 ) resistor r=3.57586 //w=0.17 //l=0.103078 //layer=li \
 //thickness=0.1 //x=29.885 //y=0.72 //x2=29.8 //y2=0.68
r71 (  14 35 ) resistor r=27.3797 //w=0.187 //l=0.4 //layer=li //thickness=0.1 \
 //x=29.885 //y=0.72 //x2=30.285 //y2=0.72
r72 (  13 35 ) resistor r=0.751729 //w=0.17 //l=0.085 //layer=li \
 //thickness=0.1 //x=30.685 //y=0.72 //x2=30.77 //y2=0.72
r73 (  13 35 ) resistor r=27.3797 //w=0.187 //l=0.4 //layer=li //thickness=0.1 \
 //x=30.685 //y=0.72 //x2=30.285 //y2=0.72
r74 (  10 35 ) resistor r=1.40859 //w=0.34 //l=0.125 //layer=li \
 //thickness=0.1 //x=29.8 //y=1.685 //x2=29.8 //y2=1.81
r75 (  10 35 ) resistor r=42.0963 //w=0.187 //l=0.615 //layer=li \
 //thickness=0.1 //x=29.8 //y=1.685 //x2=29.8 //y2=1.07
r76 (  9 35 ) resistor r=3.57586 //w=0.17 //l=0.125 //layer=li //thickness=0.1 \
 //x=29.8 //y=0.805 //x2=29.8 //y2=0.68
r77 (  9 35 ) resistor r=18.139 //w=0.187 //l=0.265 //layer=li //thickness=0.1 \
 //x=29.8 //y=0.805 //x2=29.8 //y2=1.07
r78 (  6 35 ) resistor r=3.57586 //w=0.17 //l=0.103078 //layer=li \
 //thickness=0.1 //x=28.915 //y=1.77 //x2=28.83 //y2=1.81
r79 (  6 35 ) resistor r=27.3797 //w=0.187 //l=0.4 //layer=li //thickness=0.1 \
 //x=28.915 //y=1.77 //x2=29.315 //y2=1.77
r80 (  5 35 ) resistor r=5.4201 //w=0.17 //l=0.103078 //layer=li \
 //thickness=0.1 //x=29.715 //y=1.77 //x2=29.8 //y2=1.81
r81 (  5 35 ) resistor r=27.3797 //w=0.187 //l=0.4 //layer=li //thickness=0.1 \
 //x=29.715 //y=1.77 //x2=29.315 //y2=1.77
r82 (  1 35 ) resistor r=3.57586 //w=0.17 //l=0.125 //layer=li //thickness=0.1 \
 //x=28.83 //y=1.685 //x2=28.83 //y2=1.81
r83 (  1 35 ) resistor r=42.0963 //w=0.187 //l=0.615 //layer=li \
 //thickness=0.1 //x=28.83 //y=1.685 //x2=28.83 //y2=1.07
ends PM_TMRDFFSNQX1\%noxref_44

subckt PM_TMRDFFSNQX1\%noxref_45 ( 1 5 9 13 17 35 )
c60 ( 35 0 ) capacitor c=0.0691304f //x=33.505 //y=0.555
c61 ( 17 0 ) capacitor c=0.0189711f //x=35.495 //y=1.77
c62 ( 13 0 ) capacitor c=0.0153215f //x=35.495 //y=0.72
c63 ( 9 0 ) capacitor c=0.00772076f //x=34.61 //y=0.805
c64 ( 5 0 ) capacitor c=0.0167734f //x=34.525 //y=1.77
c65 ( 1 0 ) capacitor c=0.00710458f //x=33.64 //y=1.685
r66 (  18 35 ) resistor r=5.4201 //w=0.17 //l=0.103078 //layer=li \
 //thickness=0.1 //x=34.695 //y=1.77 //x2=34.61 //y2=1.81
r67 (  18 35 ) resistor r=27.3797 //w=0.187 //l=0.4 //layer=li //thickness=0.1 \
 //x=34.695 //y=1.77 //x2=35.095 //y2=1.77
r68 (  17 35 ) resistor r=0.751729 //w=0.17 //l=0.085 //layer=li \
 //thickness=0.1 //x=35.495 //y=1.77 //x2=35.58 //y2=1.77
r69 (  17 35 ) resistor r=27.3797 //w=0.187 //l=0.4 //layer=li //thickness=0.1 \
 //x=35.495 //y=1.77 //x2=35.095 //y2=1.77
r70 (  14 35 ) resistor r=3.57586 //w=0.17 //l=0.103078 //layer=li \
 //thickness=0.1 //x=34.695 //y=0.72 //x2=34.61 //y2=0.68
r71 (  14 35 ) resistor r=27.3797 //w=0.187 //l=0.4 //layer=li //thickness=0.1 \
 //x=34.695 //y=0.72 //x2=35.095 //y2=0.72
r72 (  13 35 ) resistor r=0.751729 //w=0.17 //l=0.085 //layer=li \
 //thickness=0.1 //x=35.495 //y=0.72 //x2=35.58 //y2=0.72
r73 (  13 35 ) resistor r=27.3797 //w=0.187 //l=0.4 //layer=li //thickness=0.1 \
 //x=35.495 //y=0.72 //x2=35.095 //y2=0.72
r74 (  10 35 ) resistor r=1.40859 //w=0.34 //l=0.125 //layer=li \
 //thickness=0.1 //x=34.61 //y=1.685 //x2=34.61 //y2=1.81
r75 (  10 35 ) resistor r=42.0963 //w=0.187 //l=0.615 //layer=li \
 //thickness=0.1 //x=34.61 //y=1.685 //x2=34.61 //y2=1.07
r76 (  9 35 ) resistor r=3.57586 //w=0.17 //l=0.125 //layer=li //thickness=0.1 \
 //x=34.61 //y=0.805 //x2=34.61 //y2=0.68
r77 (  9 35 ) resistor r=18.139 //w=0.187 //l=0.265 //layer=li //thickness=0.1 \
 //x=34.61 //y=0.805 //x2=34.61 //y2=1.07
r78 (  6 35 ) resistor r=3.57586 //w=0.17 //l=0.103078 //layer=li \
 //thickness=0.1 //x=33.725 //y=1.77 //x2=33.64 //y2=1.81
r79 (  6 35 ) resistor r=27.3797 //w=0.187 //l=0.4 //layer=li //thickness=0.1 \
 //x=33.725 //y=1.77 //x2=34.125 //y2=1.77
r80 (  5 35 ) resistor r=5.4201 //w=0.17 //l=0.103078 //layer=li \
 //thickness=0.1 //x=34.525 //y=1.77 //x2=34.61 //y2=1.81
r81 (  5 35 ) resistor r=27.3797 //w=0.187 //l=0.4 //layer=li //thickness=0.1 \
 //x=34.525 //y=1.77 //x2=34.125 //y2=1.77
r82 (  1 35 ) resistor r=3.57586 //w=0.17 //l=0.125 //layer=li //thickness=0.1 \
 //x=33.64 //y=1.685 //x2=33.64 //y2=1.81
r83 (  1 35 ) resistor r=42.0963 //w=0.187 //l=0.615 //layer=li \
 //thickness=0.1 //x=33.64 //y=1.685 //x2=33.64 //y2=1.07
ends PM_TMRDFFSNQX1\%noxref_45

subckt PM_TMRDFFSNQX1\%noxref_46 ( 1 5 9 10 13 17 29 )
c66 ( 29 0 ) capacitor c=0.0671873f //x=38.42 //y=0.545
c67 ( 17 0 ) capacitor c=0.0067865f //x=40.495 //y=0.795
c68 ( 13 0 ) capacitor c=0.0154977f //x=40.41 //y=0.71
c69 ( 10 0 ) capacitor c=0.00678687f //x=39.525 //y=1.675
c70 ( 9 0 ) capacitor c=0.00770028f //x=39.525 //y=0.795
c71 ( 5 0 ) capacitor c=0.0179209f //x=39.44 //y=1.76
c72 ( 1 0 ) capacitor c=0.00761099f //x=38.555 //y=1.675
r73 (  17 29 ) resistor r=3.57586 //w=0.17 //l=0.125 //layer=li \
 //thickness=0.1 //x=40.495 //y=0.795 //x2=40.495 //y2=0.67
r74 (  17 29 ) resistor r=18.139 //w=0.187 //l=0.265 //layer=li \
 //thickness=0.1 //x=40.495 //y=0.795 //x2=40.495 //y2=1.06
r75 (  14 29 ) resistor r=3.57586 //w=0.17 //l=0.103078 //layer=li \
 //thickness=0.1 //x=39.61 //y=0.71 //x2=39.525 //y2=0.67
r76 (  14 29 ) resistor r=27.3797 //w=0.187 //l=0.4 //layer=li //thickness=0.1 \
 //x=39.61 //y=0.71 //x2=40.01 //y2=0.71
r77 (  13 29 ) resistor r=3.57586 //w=0.17 //l=0.103078 //layer=li \
 //thickness=0.1 //x=40.41 //y=0.71 //x2=40.495 //y2=0.67
r78 (  13 29 ) resistor r=27.3797 //w=0.187 //l=0.4 //layer=li //thickness=0.1 \
 //x=40.41 //y=0.71 //x2=40.01 //y2=0.71
r79 (  10 29 ) resistor r=3.57586 //w=0.17 //l=0.125 //layer=li \
 //thickness=0.1 //x=39.525 //y=1.675 //x2=39.525 //y2=1.8
r80 (  10 29 ) resistor r=42.0963 //w=0.187 //l=0.615 //layer=li \
 //thickness=0.1 //x=39.525 //y=1.675 //x2=39.525 //y2=1.06
r81 (  9 29 ) resistor r=3.57586 //w=0.17 //l=0.125 //layer=li //thickness=0.1 \
 //x=39.525 //y=0.795 //x2=39.525 //y2=0.67
r82 (  9 29 ) resistor r=18.139 //w=0.187 //l=0.265 //layer=li //thickness=0.1 \
 //x=39.525 //y=0.795 //x2=39.525 //y2=1.06
r83 (  6 29 ) resistor r=3.57586 //w=0.17 //l=0.103078 //layer=li \
 //thickness=0.1 //x=38.64 //y=1.76 //x2=38.555 //y2=1.8
r84 (  6 29 ) resistor r=27.3797 //w=0.187 //l=0.4 //layer=li //thickness=0.1 \
 //x=38.64 //y=1.76 //x2=39.04 //y2=1.76
r85 (  5 29 ) resistor r=3.57586 //w=0.17 //l=0.103078 //layer=li \
 //thickness=0.1 //x=39.44 //y=1.76 //x2=39.525 //y2=1.8
r86 (  5 29 ) resistor r=27.3797 //w=0.187 //l=0.4 //layer=li //thickness=0.1 \
 //x=39.44 //y=1.76 //x2=39.04 //y2=1.76
r87 (  1 29 ) resistor r=3.57586 //w=0.17 //l=0.125 //layer=li //thickness=0.1 \
 //x=38.555 //y=1.675 //x2=38.555 //y2=1.8
r88 (  1 29 ) resistor r=42.0963 //w=0.187 //l=0.615 //layer=li \
 //thickness=0.1 //x=38.555 //y=1.675 //x2=38.555 //y2=1.06
ends PM_TMRDFFSNQX1\%noxref_46

subckt PM_TMRDFFSNQX1\%noxref_47 ( 1 5 9 10 13 17 29 )
c68 ( 29 0 ) capacitor c=0.0661913f //x=41.75 //y=0.545
c69 ( 17 0 ) capacitor c=0.00675704f //x=43.825 //y=0.795
c70 ( 13 0 ) capacitor c=0.0154977f //x=43.74 //y=0.71
c71 ( 10 0 ) capacitor c=0.00673372f //x=42.855 //y=1.675
c72 ( 9 0 ) capacitor c=0.00770028f //x=42.855 //y=0.795
c73 ( 5 0 ) capacitor c=0.0179513f //x=42.77 //y=1.76
c74 ( 1 0 ) capacitor c=0.0076012f //x=41.885 //y=1.675
r75 (  17 29 ) resistor r=3.57586 //w=0.17 //l=0.125 //layer=li \
 //thickness=0.1 //x=43.825 //y=0.795 //x2=43.825 //y2=0.67
r76 (  17 29 ) resistor r=18.139 //w=0.187 //l=0.265 //layer=li \
 //thickness=0.1 //x=43.825 //y=0.795 //x2=43.825 //y2=1.06
r77 (  14 29 ) resistor r=3.57586 //w=0.17 //l=0.103078 //layer=li \
 //thickness=0.1 //x=42.94 //y=0.71 //x2=42.855 //y2=0.67
r78 (  14 29 ) resistor r=27.3797 //w=0.187 //l=0.4 //layer=li //thickness=0.1 \
 //x=42.94 //y=0.71 //x2=43.34 //y2=0.71
r79 (  13 29 ) resistor r=3.57586 //w=0.17 //l=0.103078 //layer=li \
 //thickness=0.1 //x=43.74 //y=0.71 //x2=43.825 //y2=0.67
r80 (  13 29 ) resistor r=27.3797 //w=0.187 //l=0.4 //layer=li //thickness=0.1 \
 //x=43.74 //y=0.71 //x2=43.34 //y2=0.71
r81 (  10 29 ) resistor r=3.57586 //w=0.17 //l=0.125 //layer=li \
 //thickness=0.1 //x=42.855 //y=1.675 //x2=42.855 //y2=1.8
r82 (  10 29 ) resistor r=42.0963 //w=0.187 //l=0.615 //layer=li \
 //thickness=0.1 //x=42.855 //y=1.675 //x2=42.855 //y2=1.06
r83 (  9 29 ) resistor r=3.57586 //w=0.17 //l=0.125 //layer=li //thickness=0.1 \
 //x=42.855 //y=0.795 //x2=42.855 //y2=0.67
r84 (  9 29 ) resistor r=18.139 //w=0.187 //l=0.265 //layer=li //thickness=0.1 \
 //x=42.855 //y=0.795 //x2=42.855 //y2=1.06
r85 (  6 29 ) resistor r=3.57586 //w=0.17 //l=0.103078 //layer=li \
 //thickness=0.1 //x=41.97 //y=1.76 //x2=41.885 //y2=1.8
r86 (  6 29 ) resistor r=27.3797 //w=0.187 //l=0.4 //layer=li //thickness=0.1 \
 //x=41.97 //y=1.76 //x2=42.37 //y2=1.76
r87 (  5 29 ) resistor r=3.57586 //w=0.17 //l=0.103078 //layer=li \
 //thickness=0.1 //x=42.77 //y=1.76 //x2=42.855 //y2=1.8
r88 (  5 29 ) resistor r=27.3797 //w=0.187 //l=0.4 //layer=li //thickness=0.1 \
 //x=42.77 //y=1.76 //x2=42.37 //y2=1.76
r89 (  1 29 ) resistor r=3.57586 //w=0.17 //l=0.125 //layer=li //thickness=0.1 \
 //x=41.885 //y=1.675 //x2=41.885 //y2=1.8
r90 (  1 29 ) resistor r=42.0963 //w=0.187 //l=0.615 //layer=li \
 //thickness=0.1 //x=41.885 //y=1.675 //x2=41.885 //y2=1.06
ends PM_TMRDFFSNQX1\%noxref_47

subckt PM_TMRDFFSNQX1\%noxref_48 ( 1 5 9 13 17 35 )
c59 ( 35 0 ) capacitor c=0.0688411f //x=44.975 //y=0.555
c60 ( 17 0 ) capacitor c=0.0189392f //x=46.965 //y=1.77
c61 ( 13 0 ) capacitor c=0.0153224f //x=46.965 //y=0.72
c62 ( 9 0 ) capacitor c=0.00772076f //x=46.08 //y=0.805
c63 ( 5 0 ) capacitor c=0.0167789f //x=45.995 //y=1.77
c64 ( 1 0 ) capacitor c=0.00709556f //x=45.11 //y=1.685
r65 (  18 35 ) resistor r=5.4201 //w=0.17 //l=0.103078 //layer=li \
 //thickness=0.1 //x=46.165 //y=1.77 //x2=46.08 //y2=1.81
r66 (  18 35 ) resistor r=27.3797 //w=0.187 //l=0.4 //layer=li //thickness=0.1 \
 //x=46.165 //y=1.77 //x2=46.565 //y2=1.77
r67 (  17 35 ) resistor r=0.751729 //w=0.17 //l=0.085 //layer=li \
 //thickness=0.1 //x=46.965 //y=1.77 //x2=47.05 //y2=1.77
r68 (  17 35 ) resistor r=27.3797 //w=0.187 //l=0.4 //layer=li //thickness=0.1 \
 //x=46.965 //y=1.77 //x2=46.565 //y2=1.77
r69 (  14 35 ) resistor r=3.57586 //w=0.17 //l=0.103078 //layer=li \
 //thickness=0.1 //x=46.165 //y=0.72 //x2=46.08 //y2=0.68
r70 (  14 35 ) resistor r=27.3797 //w=0.187 //l=0.4 //layer=li //thickness=0.1 \
 //x=46.165 //y=0.72 //x2=46.565 //y2=0.72
r71 (  13 35 ) resistor r=0.751729 //w=0.17 //l=0.085 //layer=li \
 //thickness=0.1 //x=46.965 //y=0.72 //x2=47.05 //y2=0.72
r72 (  13 35 ) resistor r=27.3797 //w=0.187 //l=0.4 //layer=li //thickness=0.1 \
 //x=46.965 //y=0.72 //x2=46.565 //y2=0.72
r73 (  10 35 ) resistor r=1.40859 //w=0.34 //l=0.125 //layer=li \
 //thickness=0.1 //x=46.08 //y=1.685 //x2=46.08 //y2=1.81
r74 (  10 35 ) resistor r=42.0963 //w=0.187 //l=0.615 //layer=li \
 //thickness=0.1 //x=46.08 //y=1.685 //x2=46.08 //y2=1.07
r75 (  9 35 ) resistor r=3.57586 //w=0.17 //l=0.125 //layer=li //thickness=0.1 \
 //x=46.08 //y=0.805 //x2=46.08 //y2=0.68
r76 (  9 35 ) resistor r=18.139 //w=0.187 //l=0.265 //layer=li //thickness=0.1 \
 //x=46.08 //y=0.805 //x2=46.08 //y2=1.07
r77 (  6 35 ) resistor r=3.57586 //w=0.17 //l=0.103078 //layer=li \
 //thickness=0.1 //x=45.195 //y=1.77 //x2=45.11 //y2=1.81
r78 (  6 35 ) resistor r=27.3797 //w=0.187 //l=0.4 //layer=li //thickness=0.1 \
 //x=45.195 //y=1.77 //x2=45.595 //y2=1.77
r79 (  5 35 ) resistor r=5.4201 //w=0.17 //l=0.103078 //layer=li \
 //thickness=0.1 //x=45.995 //y=1.77 //x2=46.08 //y2=1.81
r80 (  5 35 ) resistor r=27.3797 //w=0.187 //l=0.4 //layer=li //thickness=0.1 \
 //x=45.995 //y=1.77 //x2=45.595 //y2=1.77
r81 (  1 35 ) resistor r=3.57586 //w=0.17 //l=0.125 //layer=li //thickness=0.1 \
 //x=45.11 //y=1.685 //x2=45.11 //y2=1.81
r82 (  1 35 ) resistor r=42.0963 //w=0.187 //l=0.615 //layer=li \
 //thickness=0.1 //x=45.11 //y=1.685 //x2=45.11 //y2=1.07
ends PM_TMRDFFSNQX1\%noxref_48

subckt PM_TMRDFFSNQX1\%noxref_49 ( 1 5 9 10 13 17 29 )
c67 ( 29 0 ) capacitor c=0.0664911f //x=49.89 //y=0.545
c68 ( 17 0 ) capacitor c=0.00675704f //x=51.965 //y=0.795
c69 ( 13 0 ) capacitor c=0.0156182f //x=51.88 //y=0.71
c70 ( 10 0 ) capacitor c=0.00673372f //x=50.995 //y=1.675
c71 ( 9 0 ) capacitor c=0.00770028f //x=50.995 //y=0.795
c72 ( 5 0 ) capacitor c=0.0179513f //x=50.91 //y=1.76
c73 ( 1 0 ) capacitor c=0.00761099f //x=50.025 //y=1.675
r74 (  17 29 ) resistor r=3.57586 //w=0.17 //l=0.125 //layer=li \
 //thickness=0.1 //x=51.965 //y=0.795 //x2=51.965 //y2=0.67
r75 (  17 29 ) resistor r=18.139 //w=0.187 //l=0.265 //layer=li \
 //thickness=0.1 //x=51.965 //y=0.795 //x2=51.965 //y2=1.06
r76 (  14 29 ) resistor r=3.57586 //w=0.17 //l=0.103078 //layer=li \
 //thickness=0.1 //x=51.08 //y=0.71 //x2=50.995 //y2=0.67
r77 (  14 29 ) resistor r=27.3797 //w=0.187 //l=0.4 //layer=li //thickness=0.1 \
 //x=51.08 //y=0.71 //x2=51.48 //y2=0.71
r78 (  13 29 ) resistor r=3.57586 //w=0.17 //l=0.103078 //layer=li \
 //thickness=0.1 //x=51.88 //y=0.71 //x2=51.965 //y2=0.67
r79 (  13 29 ) resistor r=27.3797 //w=0.187 //l=0.4 //layer=li //thickness=0.1 \
 //x=51.88 //y=0.71 //x2=51.48 //y2=0.71
r80 (  10 29 ) resistor r=3.57586 //w=0.17 //l=0.125 //layer=li \
 //thickness=0.1 //x=50.995 //y=1.675 //x2=50.995 //y2=1.8
r81 (  10 29 ) resistor r=42.0963 //w=0.187 //l=0.615 //layer=li \
 //thickness=0.1 //x=50.995 //y=1.675 //x2=50.995 //y2=1.06
r82 (  9 29 ) resistor r=3.57586 //w=0.17 //l=0.125 //layer=li //thickness=0.1 \
 //x=50.995 //y=0.795 //x2=50.995 //y2=0.67
r83 (  9 29 ) resistor r=18.139 //w=0.187 //l=0.265 //layer=li //thickness=0.1 \
 //x=50.995 //y=0.795 //x2=50.995 //y2=1.06
r84 (  6 29 ) resistor r=3.57586 //w=0.17 //l=0.103078 //layer=li \
 //thickness=0.1 //x=50.11 //y=1.76 //x2=50.025 //y2=1.8
r85 (  6 29 ) resistor r=27.3797 //w=0.187 //l=0.4 //layer=li //thickness=0.1 \
 //x=50.11 //y=1.76 //x2=50.51 //y2=1.76
r86 (  5 29 ) resistor r=3.57586 //w=0.17 //l=0.103078 //layer=li \
 //thickness=0.1 //x=50.91 //y=1.76 //x2=50.995 //y2=1.8
r87 (  5 29 ) resistor r=27.3797 //w=0.187 //l=0.4 //layer=li //thickness=0.1 \
 //x=50.91 //y=1.76 //x2=50.51 //y2=1.76
r88 (  1 29 ) resistor r=3.57586 //w=0.17 //l=0.125 //layer=li //thickness=0.1 \
 //x=50.025 //y=1.675 //x2=50.025 //y2=1.8
r89 (  1 29 ) resistor r=42.0963 //w=0.187 //l=0.615 //layer=li \
 //thickness=0.1 //x=50.025 //y=1.675 //x2=50.025 //y2=1.06
ends PM_TMRDFFSNQX1\%noxref_49

subckt PM_TMRDFFSNQX1\%noxref_50 ( 1 5 9 13 17 35 )
c60 ( 35 0 ) capacitor c=0.068832f //x=53.115 //y=0.555
c61 ( 17 0 ) capacitor c=0.0190725f //x=55.105 //y=1.77
c62 ( 13 0 ) capacitor c=0.015325f //x=55.105 //y=0.72
c63 ( 9 0 ) capacitor c=0.00772076f //x=54.22 //y=0.805
c64 ( 5 0 ) capacitor c=0.0166883f //x=54.135 //y=1.77
c65 ( 1 0 ) capacitor c=0.00709556f //x=53.25 //y=1.685
r66 (  18 35 ) resistor r=5.4201 //w=0.17 //l=0.103078 //layer=li \
 //thickness=0.1 //x=54.305 //y=1.77 //x2=54.22 //y2=1.81
r67 (  18 35 ) resistor r=27.3797 //w=0.187 //l=0.4 //layer=li //thickness=0.1 \
 //x=54.305 //y=1.77 //x2=54.705 //y2=1.77
r68 (  17 35 ) resistor r=0.751729 //w=0.17 //l=0.085 //layer=li \
 //thickness=0.1 //x=55.105 //y=1.77 //x2=55.19 //y2=1.77
r69 (  17 35 ) resistor r=27.3797 //w=0.187 //l=0.4 //layer=li //thickness=0.1 \
 //x=55.105 //y=1.77 //x2=54.705 //y2=1.77
r70 (  14 35 ) resistor r=3.57586 //w=0.17 //l=0.103078 //layer=li \
 //thickness=0.1 //x=54.305 //y=0.72 //x2=54.22 //y2=0.68
r71 (  14 35 ) resistor r=27.3797 //w=0.187 //l=0.4 //layer=li //thickness=0.1 \
 //x=54.305 //y=0.72 //x2=54.705 //y2=0.72
r72 (  13 35 ) resistor r=0.751729 //w=0.17 //l=0.085 //layer=li \
 //thickness=0.1 //x=55.105 //y=0.72 //x2=55.19 //y2=0.72
r73 (  13 35 ) resistor r=27.3797 //w=0.187 //l=0.4 //layer=li //thickness=0.1 \
 //x=55.105 //y=0.72 //x2=54.705 //y2=0.72
r74 (  10 35 ) resistor r=1.40859 //w=0.34 //l=0.125 //layer=li \
 //thickness=0.1 //x=54.22 //y=1.685 //x2=54.22 //y2=1.81
r75 (  10 35 ) resistor r=42.0963 //w=0.187 //l=0.615 //layer=li \
 //thickness=0.1 //x=54.22 //y=1.685 //x2=54.22 //y2=1.07
r76 (  9 35 ) resistor r=3.57586 //w=0.17 //l=0.125 //layer=li //thickness=0.1 \
 //x=54.22 //y=0.805 //x2=54.22 //y2=0.68
r77 (  9 35 ) resistor r=18.139 //w=0.187 //l=0.265 //layer=li //thickness=0.1 \
 //x=54.22 //y=0.805 //x2=54.22 //y2=1.07
r78 (  6 35 ) resistor r=3.57586 //w=0.17 //l=0.103078 //layer=li \
 //thickness=0.1 //x=53.335 //y=1.77 //x2=53.25 //y2=1.81
r79 (  6 35 ) resistor r=27.3797 //w=0.187 //l=0.4 //layer=li //thickness=0.1 \
 //x=53.335 //y=1.77 //x2=53.735 //y2=1.77
r80 (  5 35 ) resistor r=5.4201 //w=0.17 //l=0.103078 //layer=li \
 //thickness=0.1 //x=54.135 //y=1.77 //x2=54.22 //y2=1.81
r81 (  5 35 ) resistor r=27.3797 //w=0.187 //l=0.4 //layer=li //thickness=0.1 \
 //x=54.135 //y=1.77 //x2=53.735 //y2=1.77
r82 (  1 35 ) resistor r=3.57586 //w=0.17 //l=0.125 //layer=li //thickness=0.1 \
 //x=53.25 //y=1.685 //x2=53.25 //y2=1.81
r83 (  1 35 ) resistor r=42.0963 //w=0.187 //l=0.615 //layer=li \
 //thickness=0.1 //x=53.25 //y=1.685 //x2=53.25 //y2=1.07
ends PM_TMRDFFSNQX1\%noxref_50

subckt PM_TMRDFFSNQX1\%noxref_51 ( 1 5 9 13 17 35 )
c60 ( 35 0 ) capacitor c=0.0691304f //x=57.925 //y=0.555
c61 ( 17 0 ) capacitor c=0.0189711f //x=59.915 //y=1.77
c62 ( 13 0 ) capacitor c=0.0153215f //x=59.915 //y=0.72
c63 ( 9 0 ) capacitor c=0.00772076f //x=59.03 //y=0.805
c64 ( 5 0 ) capacitor c=0.0167734f //x=58.945 //y=1.77
c65 ( 1 0 ) capacitor c=0.00710458f //x=58.06 //y=1.685
r66 (  18 35 ) resistor r=5.4201 //w=0.17 //l=0.103078 //layer=li \
 //thickness=0.1 //x=59.115 //y=1.77 //x2=59.03 //y2=1.81
r67 (  18 35 ) resistor r=27.3797 //w=0.187 //l=0.4 //layer=li //thickness=0.1 \
 //x=59.115 //y=1.77 //x2=59.515 //y2=1.77
r68 (  17 35 ) resistor r=0.751729 //w=0.17 //l=0.085 //layer=li \
 //thickness=0.1 //x=59.915 //y=1.77 //x2=60 //y2=1.77
r69 (  17 35 ) resistor r=27.3797 //w=0.187 //l=0.4 //layer=li //thickness=0.1 \
 //x=59.915 //y=1.77 //x2=59.515 //y2=1.77
r70 (  14 35 ) resistor r=3.57586 //w=0.17 //l=0.103078 //layer=li \
 //thickness=0.1 //x=59.115 //y=0.72 //x2=59.03 //y2=0.68
r71 (  14 35 ) resistor r=27.3797 //w=0.187 //l=0.4 //layer=li //thickness=0.1 \
 //x=59.115 //y=0.72 //x2=59.515 //y2=0.72
r72 (  13 35 ) resistor r=0.751729 //w=0.17 //l=0.085 //layer=li \
 //thickness=0.1 //x=59.915 //y=0.72 //x2=60 //y2=0.72
r73 (  13 35 ) resistor r=27.3797 //w=0.187 //l=0.4 //layer=li //thickness=0.1 \
 //x=59.915 //y=0.72 //x2=59.515 //y2=0.72
r74 (  10 35 ) resistor r=1.40859 //w=0.34 //l=0.125 //layer=li \
 //thickness=0.1 //x=59.03 //y=1.685 //x2=59.03 //y2=1.81
r75 (  10 35 ) resistor r=42.0963 //w=0.187 //l=0.615 //layer=li \
 //thickness=0.1 //x=59.03 //y=1.685 //x2=59.03 //y2=1.07
r76 (  9 35 ) resistor r=3.57586 //w=0.17 //l=0.125 //layer=li //thickness=0.1 \
 //x=59.03 //y=0.805 //x2=59.03 //y2=0.68
r77 (  9 35 ) resistor r=18.139 //w=0.187 //l=0.265 //layer=li //thickness=0.1 \
 //x=59.03 //y=0.805 //x2=59.03 //y2=1.07
r78 (  6 35 ) resistor r=3.57586 //w=0.17 //l=0.103078 //layer=li \
 //thickness=0.1 //x=58.145 //y=1.77 //x2=58.06 //y2=1.81
r79 (  6 35 ) resistor r=27.3797 //w=0.187 //l=0.4 //layer=li //thickness=0.1 \
 //x=58.145 //y=1.77 //x2=58.545 //y2=1.77
r80 (  5 35 ) resistor r=5.4201 //w=0.17 //l=0.103078 //layer=li \
 //thickness=0.1 //x=58.945 //y=1.77 //x2=59.03 //y2=1.81
r81 (  5 35 ) resistor r=27.3797 //w=0.187 //l=0.4 //layer=li //thickness=0.1 \
 //x=58.945 //y=1.77 //x2=58.545 //y2=1.77
r82 (  1 35 ) resistor r=3.57586 //w=0.17 //l=0.125 //layer=li //thickness=0.1 \
 //x=58.06 //y=1.685 //x2=58.06 //y2=1.81
r83 (  1 35 ) resistor r=42.0963 //w=0.187 //l=0.615 //layer=li \
 //thickness=0.1 //x=58.06 //y=1.685 //x2=58.06 //y2=1.07
ends PM_TMRDFFSNQX1\%noxref_51

subckt PM_TMRDFFSNQX1\%noxref_52 ( 1 5 9 10 13 17 29 )
c66 ( 29 0 ) capacitor c=0.0671873f //x=62.84 //y=0.545
c67 ( 17 0 ) capacitor c=0.0067865f //x=64.915 //y=0.795
c68 ( 13 0 ) capacitor c=0.0154977f //x=64.83 //y=0.71
c69 ( 10 0 ) capacitor c=0.00678687f //x=63.945 //y=1.675
c70 ( 9 0 ) capacitor c=0.00770028f //x=63.945 //y=0.795
c71 ( 5 0 ) capacitor c=0.0179209f //x=63.86 //y=1.76
c72 ( 1 0 ) capacitor c=0.00761099f //x=62.975 //y=1.675
r73 (  17 29 ) resistor r=3.57586 //w=0.17 //l=0.125 //layer=li \
 //thickness=0.1 //x=64.915 //y=0.795 //x2=64.915 //y2=0.67
r74 (  17 29 ) resistor r=18.139 //w=0.187 //l=0.265 //layer=li \
 //thickness=0.1 //x=64.915 //y=0.795 //x2=64.915 //y2=1.06
r75 (  14 29 ) resistor r=3.57586 //w=0.17 //l=0.103078 //layer=li \
 //thickness=0.1 //x=64.03 //y=0.71 //x2=63.945 //y2=0.67
r76 (  14 29 ) resistor r=27.3797 //w=0.187 //l=0.4 //layer=li //thickness=0.1 \
 //x=64.03 //y=0.71 //x2=64.43 //y2=0.71
r77 (  13 29 ) resistor r=3.57586 //w=0.17 //l=0.103078 //layer=li \
 //thickness=0.1 //x=64.83 //y=0.71 //x2=64.915 //y2=0.67
r78 (  13 29 ) resistor r=27.3797 //w=0.187 //l=0.4 //layer=li //thickness=0.1 \
 //x=64.83 //y=0.71 //x2=64.43 //y2=0.71
r79 (  10 29 ) resistor r=3.57586 //w=0.17 //l=0.125 //layer=li \
 //thickness=0.1 //x=63.945 //y=1.675 //x2=63.945 //y2=1.8
r80 (  10 29 ) resistor r=42.0963 //w=0.187 //l=0.615 //layer=li \
 //thickness=0.1 //x=63.945 //y=1.675 //x2=63.945 //y2=1.06
r81 (  9 29 ) resistor r=3.57586 //w=0.17 //l=0.125 //layer=li //thickness=0.1 \
 //x=63.945 //y=0.795 //x2=63.945 //y2=0.67
r82 (  9 29 ) resistor r=18.139 //w=0.187 //l=0.265 //layer=li //thickness=0.1 \
 //x=63.945 //y=0.795 //x2=63.945 //y2=1.06
r83 (  6 29 ) resistor r=3.57586 //w=0.17 //l=0.103078 //layer=li \
 //thickness=0.1 //x=63.06 //y=1.76 //x2=62.975 //y2=1.8
r84 (  6 29 ) resistor r=27.3797 //w=0.187 //l=0.4 //layer=li //thickness=0.1 \
 //x=63.06 //y=1.76 //x2=63.46 //y2=1.76
r85 (  5 29 ) resistor r=3.57586 //w=0.17 //l=0.103078 //layer=li \
 //thickness=0.1 //x=63.86 //y=1.76 //x2=63.945 //y2=1.8
r86 (  5 29 ) resistor r=27.3797 //w=0.187 //l=0.4 //layer=li //thickness=0.1 \
 //x=63.86 //y=1.76 //x2=63.46 //y2=1.76
r87 (  1 29 ) resistor r=3.57586 //w=0.17 //l=0.125 //layer=li //thickness=0.1 \
 //x=62.975 //y=1.675 //x2=62.975 //y2=1.8
r88 (  1 29 ) resistor r=42.0963 //w=0.187 //l=0.615 //layer=li \
 //thickness=0.1 //x=62.975 //y=1.675 //x2=62.975 //y2=1.06
ends PM_TMRDFFSNQX1\%noxref_52

subckt PM_TMRDFFSNQX1\%noxref_53 ( 1 5 9 10 13 17 29 )
c66 ( 29 0 ) capacitor c=0.0673904f //x=66.17 //y=0.545
c67 ( 17 0 ) capacitor c=0.00675704f //x=68.245 //y=0.795
c68 ( 13 0 ) capacitor c=0.0154977f //x=68.16 //y=0.71
c69 ( 10 0 ) capacitor c=0.00687502f //x=67.275 //y=1.675
c70 ( 9 0 ) capacitor c=0.00770028f //x=67.275 //y=0.795
c71 ( 5 0 ) capacitor c=0.0179513f //x=67.19 //y=1.76
c72 ( 1 0 ) capacitor c=0.0076012f //x=66.305 //y=1.675
r73 (  17 29 ) resistor r=3.57586 //w=0.17 //l=0.125 //layer=li \
 //thickness=0.1 //x=68.245 //y=0.795 //x2=68.245 //y2=0.67
r74 (  17 29 ) resistor r=18.139 //w=0.187 //l=0.265 //layer=li \
 //thickness=0.1 //x=68.245 //y=0.795 //x2=68.245 //y2=1.06
r75 (  14 29 ) resistor r=3.57586 //w=0.17 //l=0.103078 //layer=li \
 //thickness=0.1 //x=67.36 //y=0.71 //x2=67.275 //y2=0.67
r76 (  14 29 ) resistor r=27.3797 //w=0.187 //l=0.4 //layer=li //thickness=0.1 \
 //x=67.36 //y=0.71 //x2=67.76 //y2=0.71
r77 (  13 29 ) resistor r=3.57586 //w=0.17 //l=0.103078 //layer=li \
 //thickness=0.1 //x=68.16 //y=0.71 //x2=68.245 //y2=0.67
r78 (  13 29 ) resistor r=27.3797 //w=0.187 //l=0.4 //layer=li //thickness=0.1 \
 //x=68.16 //y=0.71 //x2=67.76 //y2=0.71
r79 (  10 29 ) resistor r=3.57586 //w=0.17 //l=0.125 //layer=li \
 //thickness=0.1 //x=67.275 //y=1.675 //x2=67.275 //y2=1.8
r80 (  10 29 ) resistor r=42.0963 //w=0.187 //l=0.615 //layer=li \
 //thickness=0.1 //x=67.275 //y=1.675 //x2=67.275 //y2=1.06
r81 (  9 29 ) resistor r=3.57586 //w=0.17 //l=0.125 //layer=li //thickness=0.1 \
 //x=67.275 //y=0.795 //x2=67.275 //y2=0.67
r82 (  9 29 ) resistor r=18.139 //w=0.187 //l=0.265 //layer=li //thickness=0.1 \
 //x=67.275 //y=0.795 //x2=67.275 //y2=1.06
r83 (  6 29 ) resistor r=3.57586 //w=0.17 //l=0.103078 //layer=li \
 //thickness=0.1 //x=66.39 //y=1.76 //x2=66.305 //y2=1.8
r84 (  6 29 ) resistor r=27.3797 //w=0.187 //l=0.4 //layer=li //thickness=0.1 \
 //x=66.39 //y=1.76 //x2=66.79 //y2=1.76
r85 (  5 29 ) resistor r=3.57586 //w=0.17 //l=0.103078 //layer=li \
 //thickness=0.1 //x=67.19 //y=1.76 //x2=67.275 //y2=1.8
r86 (  5 29 ) resistor r=27.3797 //w=0.187 //l=0.4 //layer=li //thickness=0.1 \
 //x=67.19 //y=1.76 //x2=66.79 //y2=1.76
r87 (  1 29 ) resistor r=3.57586 //w=0.17 //l=0.125 //layer=li //thickness=0.1 \
 //x=66.305 //y=1.675 //x2=66.305 //y2=1.8
r88 (  1 29 ) resistor r=42.0963 //w=0.187 //l=0.615 //layer=li \
 //thickness=0.1 //x=66.305 //y=1.675 //x2=66.305 //y2=1.06
ends PM_TMRDFFSNQX1\%noxref_53

subckt PM_TMRDFFSNQX1\%noxref_54 ( 1 5 9 13 17 35 )
c59 ( 35 0 ) capacitor c=0.069279f //x=69.395 //y=0.555
c60 ( 17 0 ) capacitor c=0.0190725f //x=71.385 //y=1.77
c61 ( 13 0 ) capacitor c=0.0153491f //x=71.385 //y=0.72
c62 ( 9 0 ) capacitor c=0.00772076f //x=70.5 //y=0.805
c63 ( 5 0 ) capacitor c=0.0168501f //x=70.415 //y=1.77
c64 ( 1 0 ) capacitor c=0.00709556f //x=69.53 //y=1.685
r65 (  18 35 ) resistor r=5.4201 //w=0.17 //l=0.103078 //layer=li \
 //thickness=0.1 //x=70.585 //y=1.77 //x2=70.5 //y2=1.81
r66 (  18 35 ) resistor r=27.3797 //w=0.187 //l=0.4 //layer=li //thickness=0.1 \
 //x=70.585 //y=1.77 //x2=70.985 //y2=1.77
r67 (  17 35 ) resistor r=0.751729 //w=0.17 //l=0.085 //layer=li \
 //thickness=0.1 //x=71.385 //y=1.77 //x2=71.47 //y2=1.77
r68 (  17 35 ) resistor r=27.3797 //w=0.187 //l=0.4 //layer=li //thickness=0.1 \
 //x=71.385 //y=1.77 //x2=70.985 //y2=1.77
r69 (  14 35 ) resistor r=3.57586 //w=0.17 //l=0.103078 //layer=li \
 //thickness=0.1 //x=70.585 //y=0.72 //x2=70.5 //y2=0.68
r70 (  14 35 ) resistor r=27.3797 //w=0.187 //l=0.4 //layer=li //thickness=0.1 \
 //x=70.585 //y=0.72 //x2=70.985 //y2=0.72
r71 (  13 35 ) resistor r=0.751729 //w=0.17 //l=0.085 //layer=li \
 //thickness=0.1 //x=71.385 //y=0.72 //x2=71.47 //y2=0.72
r72 (  13 35 ) resistor r=27.3797 //w=0.187 //l=0.4 //layer=li //thickness=0.1 \
 //x=71.385 //y=0.72 //x2=70.985 //y2=0.72
r73 (  10 35 ) resistor r=1.40859 //w=0.34 //l=0.125 //layer=li \
 //thickness=0.1 //x=70.5 //y=1.685 //x2=70.5 //y2=1.81
r74 (  10 35 ) resistor r=42.0963 //w=0.187 //l=0.615 //layer=li \
 //thickness=0.1 //x=70.5 //y=1.685 //x2=70.5 //y2=1.07
r75 (  9 35 ) resistor r=3.57586 //w=0.17 //l=0.125 //layer=li //thickness=0.1 \
 //x=70.5 //y=0.805 //x2=70.5 //y2=0.68
r76 (  9 35 ) resistor r=18.139 //w=0.187 //l=0.265 //layer=li //thickness=0.1 \
 //x=70.5 //y=0.805 //x2=70.5 //y2=1.07
r77 (  6 35 ) resistor r=3.57586 //w=0.17 //l=0.103078 //layer=li \
 //thickness=0.1 //x=69.615 //y=1.77 //x2=69.53 //y2=1.81
r78 (  6 35 ) resistor r=27.3797 //w=0.187 //l=0.4 //layer=li //thickness=0.1 \
 //x=69.615 //y=1.77 //x2=70.015 //y2=1.77
r79 (  5 35 ) resistor r=5.4201 //w=0.17 //l=0.103078 //layer=li \
 //thickness=0.1 //x=70.415 //y=1.77 //x2=70.5 //y2=1.81
r80 (  5 35 ) resistor r=27.3797 //w=0.187 //l=0.4 //layer=li //thickness=0.1 \
 //x=70.415 //y=1.77 //x2=70.015 //y2=1.77
r81 (  1 35 ) resistor r=3.57586 //w=0.17 //l=0.125 //layer=li //thickness=0.1 \
 //x=69.53 //y=1.685 //x2=69.53 //y2=1.81
r82 (  1 35 ) resistor r=42.0963 //w=0.187 //l=0.615 //layer=li \
 //thickness=0.1 //x=69.53 //y=1.685 //x2=69.53 //y2=1.07
ends PM_TMRDFFSNQX1\%noxref_54

subckt PM_TMRDFFSNQX1\%noxref_55 ( 1 5 9 10 13 17 29 )
c65 ( 29 0 ) capacitor c=0.0770393f //x=74.31 //y=0.545
c66 ( 17 0 ) capacitor c=0.00678917f //x=76.385 //y=0.795
c67 ( 13 0 ) capacitor c=0.0155017f //x=76.3 //y=0.71
c68 ( 10 0 ) capacitor c=0.00766091f //x=75.415 //y=1.675
c69 ( 9 0 ) capacitor c=0.00770028f //x=75.415 //y=0.795
c70 ( 5 0 ) capacitor c=0.0216744f //x=75.33 //y=1.76
c71 ( 1 0 ) capacitor c=0.00455693f //x=74.445 //y=1.675
r72 (  17 29 ) resistor r=3.57586 //w=0.17 //l=0.125 //layer=li \
 //thickness=0.1 //x=76.385 //y=0.795 //x2=76.385 //y2=0.67
r73 (  17 29 ) resistor r=41.4118 //w=0.187 //l=0.605 //layer=li \
 //thickness=0.1 //x=76.385 //y=0.795 //x2=76.385 //y2=1.4
r74 (  14 29 ) resistor r=3.57586 //w=0.17 //l=0.103078 //layer=li \
 //thickness=0.1 //x=75.5 //y=0.71 //x2=75.415 //y2=0.67
r75 (  14 29 ) resistor r=27.0374 //w=0.187 //l=0.395 //layer=li \
 //thickness=0.1 //x=75.5 //y=0.71 //x2=75.895 //y2=0.71
r76 (  13 29 ) resistor r=3.57586 //w=0.17 //l=0.103078 //layer=li \
 //thickness=0.1 //x=76.3 //y=0.71 //x2=76.385 //y2=0.67
r77 (  13 29 ) resistor r=27.7219 //w=0.187 //l=0.405 //layer=li \
 //thickness=0.1 //x=76.3 //y=0.71 //x2=75.895 //y2=0.71
r78 (  10 29 ) resistor r=3.57586 //w=0.17 //l=0.125 //layer=li \
 //thickness=0.1 //x=75.415 //y=1.675 //x2=75.415 //y2=1.8
r79 (  10 29 ) resistor r=42.0963 //w=0.187 //l=0.615 //layer=li \
 //thickness=0.1 //x=75.415 //y=1.675 //x2=75.415 //y2=1.06
r80 (  9 29 ) resistor r=3.57586 //w=0.17 //l=0.125 //layer=li //thickness=0.1 \
 //x=75.415 //y=0.795 //x2=75.415 //y2=0.67
r81 (  9 29 ) resistor r=18.139 //w=0.187 //l=0.265 //layer=li //thickness=0.1 \
 //x=75.415 //y=0.795 //x2=75.415 //y2=1.06
r82 (  6 29 ) resistor r=3.57586 //w=0.17 //l=0.103078 //layer=li \
 //thickness=0.1 //x=74.53 //y=1.76 //x2=74.445 //y2=1.8
r83 (  6 29 ) resistor r=27.3797 //w=0.187 //l=0.4 //layer=li //thickness=0.1 \
 //x=74.53 //y=1.76 //x2=74.93 //y2=1.76
r84 (  5 29 ) resistor r=3.57586 //w=0.17 //l=0.103078 //layer=li \
 //thickness=0.1 //x=75.33 //y=1.76 //x2=75.415 //y2=1.8
r85 (  5 29 ) resistor r=27.3797 //w=0.187 //l=0.4 //layer=li //thickness=0.1 \
 //x=75.33 //y=1.76 //x2=74.93 //y2=1.76
r86 (  1 29 ) resistor r=3.57586 //w=0.17 //l=0.125 //layer=li //thickness=0.1 \
 //x=74.445 //y=1.675 //x2=74.445 //y2=1.8
r87 (  1 29 ) resistor r=42.0963 //w=0.187 //l=0.615 //layer=li \
 //thickness=0.1 //x=74.445 //y=1.675 //x2=74.445 //y2=1.06
ends PM_TMRDFFSNQX1\%noxref_55

subckt PM_TMRDFFSNQX1\%noxref_57 ( 1 5 9 10 13 17 29 )
c63 ( 29 0 ) capacitor c=0.073823f //x=77.64 //y=0.545
c64 ( 17 0 ) capacitor c=0.00678917f //x=79.715 //y=0.795
c65 ( 13 0 ) capacitor c=0.0158009f //x=79.63 //y=0.71
c66 ( 10 0 ) capacitor c=0.00926288f //x=78.745 //y=1.675
c67 ( 9 0 ) capacitor c=0.00770028f //x=78.745 //y=0.795
c68 ( 5 0 ) capacitor c=0.0191566f //x=78.66 //y=1.76
c69 ( 1 0 ) capacitor c=0.00901612f //x=77.775 //y=1.675
r70 (  17 29 ) resistor r=3.57586 //w=0.17 //l=0.125 //layer=li \
 //thickness=0.1 //x=79.715 //y=0.795 //x2=79.715 //y2=0.67
r71 (  17 29 ) resistor r=41.4118 //w=0.187 //l=0.605 //layer=li \
 //thickness=0.1 //x=79.715 //y=0.795 //x2=79.715 //y2=1.4
r72 (  14 29 ) resistor r=3.57586 //w=0.17 //l=0.103078 //layer=li \
 //thickness=0.1 //x=78.83 //y=0.71 //x2=78.745 //y2=0.67
r73 (  14 29 ) resistor r=27.3797 //w=0.187 //l=0.4 //layer=li //thickness=0.1 \
 //x=78.83 //y=0.71 //x2=79.23 //y2=0.71
r74 (  13 29 ) resistor r=3.57586 //w=0.17 //l=0.103078 //layer=li \
 //thickness=0.1 //x=79.63 //y=0.71 //x2=79.715 //y2=0.67
r75 (  13 29 ) resistor r=27.3797 //w=0.187 //l=0.4 //layer=li //thickness=0.1 \
 //x=79.63 //y=0.71 //x2=79.23 //y2=0.71
r76 (  10 29 ) resistor r=3.57586 //w=0.17 //l=0.125 //layer=li \
 //thickness=0.1 //x=78.745 //y=1.675 //x2=78.745 //y2=1.8
r77 (  10 29 ) resistor r=42.0963 //w=0.187 //l=0.615 //layer=li \
 //thickness=0.1 //x=78.745 //y=1.675 //x2=78.745 //y2=1.06
r78 (  9 29 ) resistor r=3.57586 //w=0.17 //l=0.125 //layer=li //thickness=0.1 \
 //x=78.745 //y=0.795 //x2=78.745 //y2=0.67
r79 (  9 29 ) resistor r=18.139 //w=0.187 //l=0.265 //layer=li //thickness=0.1 \
 //x=78.745 //y=0.795 //x2=78.745 //y2=1.06
r80 (  6 29 ) resistor r=3.57586 //w=0.17 //l=0.103078 //layer=li \
 //thickness=0.1 //x=77.86 //y=1.76 //x2=77.775 //y2=1.8
r81 (  6 29 ) resistor r=27.3797 //w=0.187 //l=0.4 //layer=li //thickness=0.1 \
 //x=77.86 //y=1.76 //x2=78.26 //y2=1.76
r82 (  5 29 ) resistor r=3.57586 //w=0.17 //l=0.103078 //layer=li \
 //thickness=0.1 //x=78.66 //y=1.76 //x2=78.745 //y2=1.8
r83 (  5 29 ) resistor r=27.3797 //w=0.187 //l=0.4 //layer=li //thickness=0.1 \
 //x=78.66 //y=1.76 //x2=78.26 //y2=1.76
r84 (  1 29 ) resistor r=3.57586 //w=0.17 //l=0.125 //layer=li //thickness=0.1 \
 //x=77.775 //y=1.675 //x2=77.775 //y2=1.8
r85 (  1 29 ) resistor r=42.0963 //w=0.187 //l=0.615 //layer=li \
 //thickness=0.1 //x=77.775 //y=1.675 //x2=77.775 //y2=1.06
ends PM_TMRDFFSNQX1\%noxref_57

subckt PM_TMRDFFSNQX1\%noxref_58 ( 1 5 9 10 13 17 29 )
c69 ( 29 0 ) capacitor c=0.0677185f //x=80.97 //y=0.545
c70 ( 17 0 ) capacitor c=0.00709795f //x=83.045 //y=0.795
c71 ( 13 0 ) capacitor c=0.0152565f //x=82.96 //y=0.71
c72 ( 10 0 ) capacitor c=0.00749806f //x=82.075 //y=1.675
c73 ( 9 0 ) capacitor c=0.00770028f //x=82.075 //y=0.795
c74 ( 5 0 ) capacitor c=0.0236235f //x=81.99 //y=1.76
c75 ( 1 0 ) capacitor c=0.00498238f //x=81.105 //y=1.675
r76 (  17 29 ) resistor r=3.57586 //w=0.17 //l=0.125 //layer=li \
 //thickness=0.1 //x=83.045 //y=0.795 //x2=83.045 //y2=0.67
r77 (  17 29 ) resistor r=18.139 //w=0.187 //l=0.265 //layer=li \
 //thickness=0.1 //x=83.045 //y=0.795 //x2=83.045 //y2=1.06
r78 (  14 29 ) resistor r=3.57586 //w=0.17 //l=0.103078 //layer=li \
 //thickness=0.1 //x=82.16 //y=0.71 //x2=82.075 //y2=0.67
r79 (  14 29 ) resistor r=27.3797 //w=0.187 //l=0.4 //layer=li //thickness=0.1 \
 //x=82.16 //y=0.71 //x2=82.56 //y2=0.71
r80 (  13 29 ) resistor r=3.57586 //w=0.17 //l=0.103078 //layer=li \
 //thickness=0.1 //x=82.96 //y=0.71 //x2=83.045 //y2=0.67
r81 (  13 29 ) resistor r=27.3797 //w=0.187 //l=0.4 //layer=li //thickness=0.1 \
 //x=82.96 //y=0.71 //x2=82.56 //y2=0.71
r82 (  10 29 ) resistor r=3.57586 //w=0.17 //l=0.125 //layer=li \
 //thickness=0.1 //x=82.075 //y=1.675 //x2=82.075 //y2=1.8
r83 (  10 29 ) resistor r=42.0963 //w=0.187 //l=0.615 //layer=li \
 //thickness=0.1 //x=82.075 //y=1.675 //x2=82.075 //y2=1.06
r84 (  9 29 ) resistor r=3.57586 //w=0.17 //l=0.125 //layer=li //thickness=0.1 \
 //x=82.075 //y=0.795 //x2=82.075 //y2=0.67
r85 (  9 29 ) resistor r=18.139 //w=0.187 //l=0.265 //layer=li //thickness=0.1 \
 //x=82.075 //y=0.795 //x2=82.075 //y2=1.06
r86 (  6 29 ) resistor r=3.57586 //w=0.17 //l=0.103078 //layer=li \
 //thickness=0.1 //x=81.19 //y=1.76 //x2=81.105 //y2=1.8
r87 (  6 29 ) resistor r=27.3797 //w=0.187 //l=0.4 //layer=li //thickness=0.1 \
 //x=81.19 //y=1.76 //x2=81.59 //y2=1.76
r88 (  5 29 ) resistor r=3.57586 //w=0.17 //l=0.103078 //layer=li \
 //thickness=0.1 //x=81.99 //y=1.76 //x2=82.075 //y2=1.8
r89 (  5 29 ) resistor r=27.3797 //w=0.187 //l=0.4 //layer=li //thickness=0.1 \
 //x=81.99 //y=1.76 //x2=81.59 //y2=1.76
r90 (  1 29 ) resistor r=3.57586 //w=0.17 //l=0.125 //layer=li //thickness=0.1 \
 //x=81.105 //y=1.675 //x2=81.105 //y2=1.8
r91 (  1 29 ) resistor r=42.0963 //w=0.187 //l=0.615 //layer=li \
 //thickness=0.1 //x=81.105 //y=1.675 //x2=81.105 //y2=1.06
ends PM_TMRDFFSNQX1\%noxref_58
