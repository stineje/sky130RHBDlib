// File: TMRDFFSNQX1.spi.pex
// Created: Tue Apr 29 10:45:59 2025
// Program "Calibre xRC"
// Version "v2023.2_27.15"
// Nominal Temperature: 30C
// Circuit Temperature: 30C
//
simulator lang=spectre
subckt PM_TMRDFFSNQX1\%GND ( 1 143 147 150 155 163 169 179 185 195 201 207 215 \
 223 231 241 249 257 263 273 279 289 295 301 309 317 325 335 343 351 357 367 \
 373 383 389 395 403 411 419 429 437 445 451 457 465 476 481 485 498 501 504 \
 507 509 511 513 516 519 522 524 526 528 531 534 537 539 541 543 546 548 555 \
 562 563 564 565 566 567 568 569 570 571 572 573 574 575 576 577 578 579 580 \
 581 582 583 )
c1011 ( 583 0 ) capacitor c=0.0604394f //x=84.235 //y=0.55
c1012 ( 582 0 ) capacitor c=0.0215013f //x=81.4 //y=1.045
c1013 ( 581 0 ) capacitor c=0.0215013f //x=78.07 //y=1.045
c1014 ( 580 0 ) capacitor c=0.0207525f //x=74.74 //y=1.045
c1015 ( 579 0 ) capacitor c=0.0226075f //x=69.825 //y=1.055
c1016 ( 578 0 ) capacitor c=0.0207408f //x=66.6 //y=1.045
c1017 ( 577 0 ) capacitor c=0.0207408f //x=63.27 //y=1.045
c1018 ( 576 0 ) capacitor c=0.0225954f //x=58.355 //y=1.055
c1019 ( 575 0 ) capacitor c=0.0226075f //x=53.545 //y=1.055
c1020 ( 574 0 ) capacitor c=0.0207408f //x=50.32 //y=1.045
c1021 ( 573 0 ) capacitor c=0.0226075f //x=45.405 //y=1.055
c1022 ( 572 0 ) capacitor c=0.0207408f //x=42.18 //y=1.045
c1023 ( 571 0 ) capacitor c=0.0207408f //x=38.85 //y=1.045
c1024 ( 570 0 ) capacitor c=0.0225954f //x=33.935 //y=1.055
c1025 ( 569 0 ) capacitor c=0.0226075f //x=29.125 //y=1.055
c1026 ( 568 0 ) capacitor c=0.0207408f //x=25.9 //y=1.045
c1027 ( 567 0 ) capacitor c=0.0226075f //x=20.985 //y=1.055
c1028 ( 566 0 ) capacitor c=0.0207408f //x=17.76 //y=1.045
c1029 ( 565 0 ) capacitor c=0.0207408f //x=14.43 //y=1.045
c1030 ( 564 0 ) capacitor c=0.0226206f //x=9.515 //y=1.055
c1031 ( 563 0 ) capacitor c=0.0226323f //x=4.705 //y=1.055
c1032 ( 562 0 ) capacitor c=0.0207863f //x=1.48 //y=1.045
c1033 ( 555 0 ) capacitor c=0.253772f //x=85.34 //y=0.175
c1034 ( 548 0 ) capacitor c=0.102069f //x=83.74 //y=0.175
c1035 ( 547 0 ) capacitor c=0.00446416f //x=81.59 //y=0.175
c1036 ( 546 0 ) capacitor c=0.101602f //x=80.41 //y=0.175
c1037 ( 545 0 ) capacitor c=0.00446416f //x=78.19 //y=0.18
c1038 ( 543 0 ) capacitor c=0.11712f //x=77.08 //y=0.175
c1039 ( 542 0 ) capacitor c=0.00446416f //x=74.93 //y=0.175
c1040 ( 541 0 ) capacitor c=0.106952f //x=73.75 //y=0.175
c1041 ( 540 0 ) capacitor c=0.00446464f //x=70.015 //y=0.175
c1042 ( 539 0 ) capacitor c=0.104217f //x=68.94 //y=0.175
c1043 ( 538 0 ) capacitor c=0.00446416f //x=66.79 //y=0.175
c1044 ( 537 0 ) capacitor c=0.105249f //x=65.61 //y=0.175
c1045 ( 536 0 ) capacitor c=0.00446416f //x=63.39 //y=0.18
c1046 ( 534 0 ) capacitor c=0.108374f //x=62.28 //y=0.175
c1047 ( 533 0 ) capacitor c=0.00446464f //x=58.58 //y=0.18
c1048 ( 531 0 ) capacitor c=0.107355f //x=57.47 //y=0.175
c1049 ( 530 0 ) capacitor c=0.00446464f //x=53.77 //y=0.18
c1050 ( 528 0 ) capacitor c=0.104239f //x=52.66 //y=0.175
c1051 ( 527 0 ) capacitor c=0.00446416f //x=50.51 //y=0.175
c1052 ( 526 0 ) capacitor c=0.108477f //x=49.33 //y=0.175
c1053 ( 525 0 ) capacitor c=0.00446464f //x=45.595 //y=0.175
c1054 ( 524 0 ) capacitor c=0.104206f //x=44.52 //y=0.175
c1055 ( 523 0 ) capacitor c=0.00446416f //x=42.37 //y=0.175
c1056 ( 522 0 ) capacitor c=0.105007f //x=41.19 //y=0.175
c1057 ( 521 0 ) capacitor c=0.00446416f //x=38.97 //y=0.18
c1058 ( 519 0 ) capacitor c=0.108374f //x=37.86 //y=0.175
c1059 ( 518 0 ) capacitor c=0.00446464f //x=34.16 //y=0.18
c1060 ( 516 0 ) capacitor c=0.107355f //x=33.05 //y=0.175
c1061 ( 515 0 ) capacitor c=0.00446464f //x=29.35 //y=0.18
c1062 ( 513 0 ) capacitor c=0.104268f //x=28.24 //y=0.175
c1063 ( 512 0 ) capacitor c=0.00446416f //x=26.09 //y=0.175
c1064 ( 511 0 ) capacitor c=0.108143f //x=24.91 //y=0.175
c1065 ( 510 0 ) capacitor c=0.00446464f //x=21.175 //y=0.175
c1066 ( 509 0 ) capacitor c=0.104217f //x=20.1 //y=0.175
c1067 ( 508 0 ) capacitor c=0.00446416f //x=17.95 //y=0.175
c1068 ( 507 0 ) capacitor c=0.105249f //x=16.77 //y=0.175
c1069 ( 506 0 ) capacitor c=0.00446416f //x=14.55 //y=0.18
c1070 ( 504 0 ) capacitor c=0.108374f //x=13.44 //y=0.175
c1071 ( 503 0 ) capacitor c=0.00446464f //x=9.74 //y=0.18
c1072 ( 501 0 ) capacitor c=0.108361f //x=8.63 //y=0.175
c1073 ( 500 0 ) capacitor c=0.00446464f //x=4.93 //y=0.18
c1074 ( 498 0 ) capacitor c=0.105439f //x=3.82 //y=0.175
c1075 ( 497 0 ) capacitor c=0.00446416f //x=1.67 //y=0.175
c1076 ( 488 0 ) capacitor c=0.00583665f //x=85.34 //y=0.63
c1077 ( 485 0 ) capacitor c=0.00542565f //x=85.255 //y=0.715
c1078 ( 484 0 ) capacitor c=0.00479856f //x=84.855 //y=0.63
c1079 ( 481 0 ) capacitor c=0.00707849f //x=84.77 //y=0.715
c1080 ( 476 0 ) capacitor c=0.00588377f //x=84.37 //y=0.63
c1081 ( 473 0 ) capacitor c=0.0191899f //x=84.285 //y=0.175
c1082 ( 465 0 ) capacitor c=0.0758845f //x=83.57 //y=0.175
c1083 ( 457 0 ) capacitor c=0.0393378f //x=81.505 //y=0.175
c1084 ( 451 0 ) capacitor c=0.0725462f //x=80.24 //y=0.175
c1085 ( 445 0 ) capacitor c=0.0391794f //x=78.175 //y=0.175
c1086 ( 437 0 ) capacitor c=0.0728652f //x=76.91 //y=0.175
c1087 ( 429 0 ) capacitor c=0.0394931f //x=74.845 //y=0.175
c1088 ( 419 0 ) capacitor c=0.13531f //x=73.58 //y=0.175
c1089 ( 411 0 ) capacitor c=0.0342713f //x=69.93 //y=0.175
c1090 ( 403 0 ) capacitor c=0.0727058f //x=68.77 //y=0.175
c1091 ( 395 0 ) capacitor c=0.0392405f //x=66.705 //y=0.175
c1092 ( 389 0 ) capacitor c=0.0727058f //x=65.44 //y=0.175
c1093 ( 383 0 ) capacitor c=0.0392405f //x=63.375 //y=0.175
c1094 ( 373 0 ) capacitor c=0.135066f //x=62.11 //y=0.175
c1095 ( 367 0 ) capacitor c=0.0342713f //x=58.46 //y=0.175
c1096 ( 357 0 ) capacitor c=0.135066f //x=57.3 //y=0.175
c1097 ( 351 0 ) capacitor c=0.0342713f //x=53.65 //y=0.175
c1098 ( 343 0 ) capacitor c=0.0727058f //x=52.49 //y=0.175
c1099 ( 335 0 ) capacitor c=0.0392405f //x=50.425 //y=0.175
c1100 ( 325 0 ) capacitor c=0.135066f //x=49.16 //y=0.175
c1101 ( 317 0 ) capacitor c=0.0342713f //x=45.51 //y=0.175
c1102 ( 309 0 ) capacitor c=0.0727058f //x=44.35 //y=0.175
c1103 ( 301 0 ) capacitor c=0.0392405f //x=42.285 //y=0.175
c1104 ( 295 0 ) capacitor c=0.0727058f //x=41.02 //y=0.175
c1105 ( 289 0 ) capacitor c=0.0392405f //x=38.955 //y=0.175
c1106 ( 279 0 ) capacitor c=0.135066f //x=37.69 //y=0.175
c1107 ( 273 0 ) capacitor c=0.0342713f //x=34.04 //y=0.175
c1108 ( 263 0 ) capacitor c=0.135066f //x=32.88 //y=0.175
c1109 ( 257 0 ) capacitor c=0.0342713f //x=29.23 //y=0.175
c1110 ( 249 0 ) capacitor c=0.0727058f //x=28.07 //y=0.175
c1111 ( 241 0 ) capacitor c=0.0392405f //x=26.005 //y=0.175
c1112 ( 231 0 ) capacitor c=0.135066f //x=24.74 //y=0.175
c1113 ( 223 0 ) capacitor c=0.0342713f //x=21.09 //y=0.175
c1114 ( 215 0 ) capacitor c=0.0727058f //x=19.93 //y=0.175
c1115 ( 207 0 ) capacitor c=0.0392405f //x=17.865 //y=0.175
c1116 ( 201 0 ) capacitor c=0.0727058f //x=16.6 //y=0.175
c1117 ( 195 0 ) capacitor c=0.0392405f //x=14.535 //y=0.175
c1118 ( 185 0 ) capacitor c=0.135108f //x=13.27 //y=0.175
c1119 ( 179 0 ) capacitor c=0.0342869f //x=9.62 //y=0.175
c1120 ( 169 0 ) capacitor c=0.135219f //x=8.46 //y=0.175
c1121 ( 163 0 ) capacitor c=0.0342869f //x=4.81 //y=0.175
c1122 ( 155 0 ) capacitor c=0.0729471f //x=3.65 //y=0.175
c1123 ( 150 0 ) capacitor c=0.197933f //x=1.23 //y=0.18
c1124 ( 147 0 ) capacitor c=0.0430284f //x=1.585 //y=0.175
c1125 ( 143 0 ) capacitor c=2.63163f //x=85.22 //y=0.18
r1126 (  554 555 ) resistor r=4.18529 //w=0.367 //l=0.12 //layer=li \
 //thickness=0.1 //x=85.22 //y=0.175 //x2=85.34 //y2=0.175
r1127 (  552 554 ) resistor r=12.7302 //w=0.367 //l=0.365 //layer=li \
 //thickness=0.1 //x=84.855 //y=0.175 //x2=85.22 //y2=0.175
r1128 (  551 552 ) resistor r=13.079 //w=0.367 //l=0.375 //layer=li \
 //thickness=0.1 //x=84.48 //y=0.175 //x2=84.855 //y2=0.175
r1129 (  549 551 ) resistor r=3.83651 //w=0.367 //l=0.11 //layer=li \
 //thickness=0.1 //x=84.37 //y=0.175 //x2=84.48 //y2=0.175
r1130 (  489 583 ) resistor r=5.4201 //w=0.17 //l=0.085 //layer=li \
 //thickness=0.1 //x=85.34 //y=0.8 //x2=85.34 //y2=0.715
r1131 (  489 583 ) resistor r=41.4118 //w=0.187 //l=0.605 //layer=li \
 //thickness=0.1 //x=85.34 //y=0.8 //x2=85.34 //y2=1.405
r1132 (  488 583 ) resistor r=5.4201 //w=0.17 //l=0.085 //layer=li \
 //thickness=0.1 //x=85.34 //y=0.63 //x2=85.34 //y2=0.715
r1133 (  487 555 ) resistor r=5.21862 //w=0.35 //l=0.175 //layer=li \
 //thickness=0.1 //x=85.34 //y=0.35 //x2=85.34 //y2=0.175
r1134 (  487 488 ) resistor r=19.1658 //w=0.187 //l=0.28 //layer=li \
 //thickness=0.1 //x=85.34 //y=0.35 //x2=85.34 //y2=0.63
r1135 (  486 583 ) resistor r=5.4201 //w=0.17 //l=0.085 //layer=li \
 //thickness=0.1 //x=84.94 //y=0.715 //x2=84.855 //y2=0.715
r1136 (  485 583 ) resistor r=1.40859 //w=0.34 //l=0.085 //layer=li \
 //thickness=0.1 //x=85.255 //y=0.715 //x2=85.34 //y2=0.715
r1137 (  485 486 ) resistor r=21.5615 //w=0.187 //l=0.315 //layer=li \
 //thickness=0.1 //x=85.255 //y=0.715 //x2=84.94 //y2=0.715
r1138 (  484 583 ) resistor r=1.40859 //w=0.34 //l=0.085 //layer=li \
 //thickness=0.1 //x=84.855 //y=0.63 //x2=84.855 //y2=0.715
r1139 (  483 552 ) resistor r=5.21862 //w=0.35 //l=0.175 //layer=li \
 //thickness=0.1 //x=84.855 //y=0.35 //x2=84.855 //y2=0.175
r1140 (  483 484 ) resistor r=19.1658 //w=0.187 //l=0.28 //layer=li \
 //thickness=0.1 //x=84.855 //y=0.35 //x2=84.855 //y2=0.63
r1141 (  482 583 ) resistor r=1.40859 //w=0.34 //l=0.085 //layer=li \
 //thickness=0.1 //x=84.455 //y=0.715 //x2=84.37 //y2=0.715
r1142 (  481 583 ) resistor r=5.4201 //w=0.17 //l=0.085 //layer=li \
 //thickness=0.1 //x=84.77 //y=0.715 //x2=84.855 //y2=0.715
r1143 (  481 482 ) resistor r=21.5615 //w=0.187 //l=0.315 //layer=li \
 //thickness=0.1 //x=84.77 //y=0.715 //x2=84.455 //y2=0.715
r1144 (  477 583 ) resistor r=5.4201 //w=0.17 //l=0.085 //layer=li \
 //thickness=0.1 //x=84.37 //y=0.8 //x2=84.37 //y2=0.715
r1145 (  477 583 ) resistor r=41.4118 //w=0.187 //l=0.605 //layer=li \
 //thickness=0.1 //x=84.37 //y=0.8 //x2=84.37 //y2=1.405
r1146 (  476 583 ) resistor r=5.4201 //w=0.17 //l=0.085 //layer=li \
 //thickness=0.1 //x=84.37 //y=0.63 //x2=84.37 //y2=0.715
r1147 (  475 549 ) resistor r=5.21862 //w=0.35 //l=0.175 //layer=li \
 //thickness=0.1 //x=84.37 //y=0.35 //x2=84.37 //y2=0.175
r1148 (  475 476 ) resistor r=19.1658 //w=0.187 //l=0.28 //layer=li \
 //thickness=0.1 //x=84.37 //y=0.35 //x2=84.37 //y2=0.63
r1149 (  474 548 ) resistor r=5.29055 //w=0.35 //l=0.17 //layer=li \
 //thickness=0.1 //x=83.91 //y=0.175 //x2=83.74 //y2=0.175
r1150 (  473 549 ) resistor r=2.96458 //w=0.367 //l=0.085 //layer=li \
 //thickness=0.1 //x=84.285 //y=0.175 //x2=84.37 //y2=0.175
r1151 (  473 474 ) resistor r=13.079 //w=0.367 //l=0.375 //layer=li \
 //thickness=0.1 //x=84.285 //y=0.175 //x2=83.91 //y2=0.175
r1152 (  468 470 ) resistor r=38.7139 //w=0.367 //l=1.11 //layer=li \
 //thickness=0.1 //x=81.89 //y=0.175 //x2=83 //y2=0.175
r1153 (  466 547 ) resistor r=2.87058 //w=0.35 //l=0.085 //layer=li \
 //thickness=0.1 //x=81.675 //y=0.175 //x2=81.59 //y2=0.175
r1154 (  466 468 ) resistor r=7.49864 //w=0.367 //l=0.215 //layer=li \
 //thickness=0.1 //x=81.675 //y=0.175 //x2=81.89 //y2=0.175
r1155 (  465 548 ) resistor r=5.29055 //w=0.35 //l=0.17 //layer=li \
 //thickness=0.1 //x=83.57 //y=0.175 //x2=83.74 //y2=0.175
r1156 (  465 470 ) resistor r=19.8801 //w=0.367 //l=0.57 //layer=li \
 //thickness=0.1 //x=83.57 //y=0.175 //x2=83 //y2=0.175
r1157 (  461 547 ) resistor r=4.23183 //w=0.7 //l=0.175 //layer=li \
 //thickness=0.1 //x=81.59 //y=0.35 //x2=81.59 //y2=0.175
r1158 (  461 582 ) resistor r=53.7326 //w=0.187 //l=0.785 //layer=li \
 //thickness=0.1 //x=81.59 //y=0.35 //x2=81.59 //y2=1.135
r1159 (  458 546 ) resistor r=5.29055 //w=0.35 //l=0.17 //layer=li \
 //thickness=0.1 //x=80.58 //y=0.175 //x2=80.41 //y2=0.175
r1160 (  458 460 ) resistor r=6.97548 //w=0.367 //l=0.2 //layer=li \
 //thickness=0.1 //x=80.58 //y=0.175 //x2=80.78 //y2=0.175
r1161 (  457 547 ) resistor r=2.87058 //w=0.35 //l=0.085 //layer=li \
 //thickness=0.1 //x=81.505 //y=0.175 //x2=81.59 //y2=0.175
r1162 (  457 460 ) resistor r=25.2861 //w=0.367 //l=0.725 //layer=li \
 //thickness=0.1 //x=81.505 //y=0.175 //x2=80.78 //y2=0.175
r1163 (  452 545 ) resistor r=2.87058 //w=0.35 //l=0.085 //layer=li \
 //thickness=0.1 //x=78.345 //y=0.175 //x2=78.26 //y2=0.175
r1164 (  452 454 ) resistor r=33.3079 //w=0.367 //l=0.955 //layer=li \
 //thickness=0.1 //x=78.345 //y=0.175 //x2=79.3 //y2=0.175
r1165 (  451 546 ) resistor r=5.29055 //w=0.35 //l=0.17 //layer=li \
 //thickness=0.1 //x=80.24 //y=0.175 //x2=80.41 //y2=0.175
r1166 (  451 454 ) resistor r=32.7847 //w=0.367 //l=0.94 //layer=li \
 //thickness=0.1 //x=80.24 //y=0.175 //x2=79.3 //y2=0.175
r1167 (  447 545 ) resistor r=4.23183 //w=0.7 //l=0.175 //layer=li \
 //thickness=0.1 //x=78.26 //y=0.35 //x2=78.26 //y2=0.175
r1168 (  447 581 ) resistor r=53.7326 //w=0.187 //l=0.785 //layer=li \
 //thickness=0.1 //x=78.26 //y=0.35 //x2=78.26 //y2=1.135
r1169 (  446 543 ) resistor r=5.29055 //w=0.35 //l=0.17 //layer=li \
 //thickness=0.1 //x=77.25 //y=0.175 //x2=77.08 //y2=0.175
r1170 (  445 545 ) resistor r=2.87058 //w=0.35 //l=0.085 //layer=li \
 //thickness=0.1 //x=78.175 //y=0.175 //x2=78.26 //y2=0.175
r1171 (  445 446 ) resistor r=32.2616 //w=0.367 //l=0.925 //layer=li \
 //thickness=0.1 //x=78.175 //y=0.175 //x2=77.25 //y2=0.175
r1172 (  440 442 ) resistor r=38.7139 //w=0.367 //l=1.11 //layer=li \
 //thickness=0.1 //x=75.6 //y=0.175 //x2=76.71 //y2=0.175
r1173 (  438 542 ) resistor r=2.87058 //w=0.35 //l=0.085 //layer=li \
 //thickness=0.1 //x=75.015 //y=0.175 //x2=74.93 //y2=0.175
r1174 (  438 440 ) resistor r=20.4033 //w=0.367 //l=0.585 //layer=li \
 //thickness=0.1 //x=75.015 //y=0.175 //x2=75.6 //y2=0.175
r1175 (  437 543 ) resistor r=5.29055 //w=0.35 //l=0.17 //layer=li \
 //thickness=0.1 //x=76.91 //y=0.175 //x2=77.08 //y2=0.175
r1176 (  437 442 ) resistor r=6.97548 //w=0.367 //l=0.2 //layer=li \
 //thickness=0.1 //x=76.91 //y=0.175 //x2=76.71 //y2=0.175
r1177 (  433 542 ) resistor r=4.23183 //w=0.7 //l=0.175 //layer=li \
 //thickness=0.1 //x=74.93 //y=0.35 //x2=74.93 //y2=0.175
r1178 (  433 580 ) resistor r=53.7326 //w=0.187 //l=0.785 //layer=li \
 //thickness=0.1 //x=74.93 //y=0.35 //x2=74.93 //y2=1.135
r1179 (  430 541 ) resistor r=5.29055 //w=0.35 //l=0.17 //layer=li \
 //thickness=0.1 //x=73.92 //y=0.175 //x2=73.75 //y2=0.175
r1180 (  430 432 ) resistor r=19.8801 //w=0.367 //l=0.57 //layer=li \
 //thickness=0.1 //x=73.92 //y=0.175 //x2=74.49 //y2=0.175
r1181 (  429 542 ) resistor r=2.87058 //w=0.35 //l=0.085 //layer=li \
 //thickness=0.1 //x=74.845 //y=0.175 //x2=74.93 //y2=0.175
r1182 (  429 432 ) resistor r=12.3815 //w=0.367 //l=0.355 //layer=li \
 //thickness=0.1 //x=74.845 //y=0.175 //x2=74.49 //y2=0.175
r1183 (  424 426 ) resistor r=38.7139 //w=0.367 //l=1.11 //layer=li \
 //thickness=0.1 //x=71.9 //y=0.175 //x2=73.01 //y2=0.175
r1184 (  422 424 ) resistor r=38.7139 //w=0.367 //l=1.11 //layer=li \
 //thickness=0.1 //x=70.79 //y=0.175 //x2=71.9 //y2=0.175
r1185 (  420 540 ) resistor r=2.87058 //w=0.35 //l=0.085 //layer=li \
 //thickness=0.1 //x=70.1 //y=0.175 //x2=70.015 //y2=0.175
r1186 (  420 422 ) resistor r=24.0654 //w=0.367 //l=0.69 //layer=li \
 //thickness=0.1 //x=70.1 //y=0.175 //x2=70.79 //y2=0.175
r1187 (  419 541 ) resistor r=5.29055 //w=0.35 //l=0.17 //layer=li \
 //thickness=0.1 //x=73.58 //y=0.175 //x2=73.75 //y2=0.175
r1188 (  419 426 ) resistor r=19.8801 //w=0.367 //l=0.57 //layer=li \
 //thickness=0.1 //x=73.58 //y=0.175 //x2=73.01 //y2=0.175
r1189 (  415 540 ) resistor r=4.23183 //w=0.7 //l=0.175 //layer=li \
 //thickness=0.1 //x=70.015 //y=0.35 //x2=70.015 //y2=0.175
r1190 (  415 579 ) resistor r=54.4171 //w=0.187 //l=0.795 //layer=li \
 //thickness=0.1 //x=70.015 //y=0.35 //x2=70.015 //y2=1.145
r1191 (  412 539 ) resistor r=5.29055 //w=0.35 //l=0.17 //layer=li \
 //thickness=0.1 //x=69.11 //y=0.175 //x2=68.94 //y2=0.175
r1192 (  412 414 ) resistor r=19.8801 //w=0.367 //l=0.57 //layer=li \
 //thickness=0.1 //x=69.11 //y=0.175 //x2=69.68 //y2=0.175
r1193 (  411 540 ) resistor r=2.87058 //w=0.35 //l=0.085 //layer=li \
 //thickness=0.1 //x=69.93 //y=0.175 //x2=70.015 //y2=0.175
r1194 (  411 414 ) resistor r=8.71935 //w=0.367 //l=0.25 //layer=li \
 //thickness=0.1 //x=69.93 //y=0.175 //x2=69.68 //y2=0.175
r1195 (  406 408 ) resistor r=38.7139 //w=0.367 //l=1.11 //layer=li \
 //thickness=0.1 //x=67.09 //y=0.175 //x2=68.2 //y2=0.175
r1196 (  404 538 ) resistor r=2.87058 //w=0.35 //l=0.085 //layer=li \
 //thickness=0.1 //x=66.875 //y=0.175 //x2=66.79 //y2=0.175
r1197 (  404 406 ) resistor r=7.49864 //w=0.367 //l=0.215 //layer=li \
 //thickness=0.1 //x=66.875 //y=0.175 //x2=67.09 //y2=0.175
r1198 (  403 539 ) resistor r=5.29055 //w=0.35 //l=0.17 //layer=li \
 //thickness=0.1 //x=68.77 //y=0.175 //x2=68.94 //y2=0.175
r1199 (  403 408 ) resistor r=19.8801 //w=0.367 //l=0.57 //layer=li \
 //thickness=0.1 //x=68.77 //y=0.175 //x2=68.2 //y2=0.175
r1200 (  399 538 ) resistor r=4.23183 //w=0.7 //l=0.175 //layer=li \
 //thickness=0.1 //x=66.79 //y=0.35 //x2=66.79 //y2=0.175
r1201 (  399 578 ) resistor r=53.7326 //w=0.187 //l=0.785 //layer=li \
 //thickness=0.1 //x=66.79 //y=0.35 //x2=66.79 //y2=1.135
r1202 (  396 537 ) resistor r=5.29055 //w=0.35 //l=0.17 //layer=li \
 //thickness=0.1 //x=65.78 //y=0.175 //x2=65.61 //y2=0.175
r1203 (  396 398 ) resistor r=6.97548 //w=0.367 //l=0.2 //layer=li \
 //thickness=0.1 //x=65.78 //y=0.175 //x2=65.98 //y2=0.175
r1204 (  395 538 ) resistor r=2.87058 //w=0.35 //l=0.085 //layer=li \
 //thickness=0.1 //x=66.705 //y=0.175 //x2=66.79 //y2=0.175
r1205 (  395 398 ) resistor r=25.2861 //w=0.367 //l=0.725 //layer=li \
 //thickness=0.1 //x=66.705 //y=0.175 //x2=65.98 //y2=0.175
r1206 (  390 536 ) resistor r=2.87058 //w=0.35 //l=0.085 //layer=li \
 //thickness=0.1 //x=63.545 //y=0.175 //x2=63.46 //y2=0.175
r1207 (  390 392 ) resistor r=33.3079 //w=0.367 //l=0.955 //layer=li \
 //thickness=0.1 //x=63.545 //y=0.175 //x2=64.5 //y2=0.175
r1208 (  389 537 ) resistor r=5.29055 //w=0.35 //l=0.17 //layer=li \
 //thickness=0.1 //x=65.44 //y=0.175 //x2=65.61 //y2=0.175
r1209 (  389 392 ) resistor r=32.7847 //w=0.367 //l=0.94 //layer=li \
 //thickness=0.1 //x=65.44 //y=0.175 //x2=64.5 //y2=0.175
r1210 (  385 536 ) resistor r=4.23183 //w=0.7 //l=0.175 //layer=li \
 //thickness=0.1 //x=63.46 //y=0.35 //x2=63.46 //y2=0.175
r1211 (  385 577 ) resistor r=53.7326 //w=0.187 //l=0.785 //layer=li \
 //thickness=0.1 //x=63.46 //y=0.35 //x2=63.46 //y2=1.135
r1212 (  384 534 ) resistor r=5.29055 //w=0.35 //l=0.17 //layer=li \
 //thickness=0.1 //x=62.45 //y=0.175 //x2=62.28 //y2=0.175
r1213 (  383 536 ) resistor r=2.87058 //w=0.35 //l=0.085 //layer=li \
 //thickness=0.1 //x=63.375 //y=0.175 //x2=63.46 //y2=0.175
r1214 (  383 384 ) resistor r=32.2616 //w=0.367 //l=0.925 //layer=li \
 //thickness=0.1 //x=63.375 //y=0.175 //x2=62.45 //y2=0.175
r1215 (  378 380 ) resistor r=38.7139 //w=0.367 //l=1.11 //layer=li \
 //thickness=0.1 //x=60.8 //y=0.175 //x2=61.91 //y2=0.175
r1216 (  376 378 ) resistor r=38.7139 //w=0.367 //l=1.11 //layer=li \
 //thickness=0.1 //x=59.69 //y=0.175 //x2=60.8 //y2=0.175
r1217 (  374 533 ) resistor r=2.87058 //w=0.35 //l=0.085 //layer=li \
 //thickness=0.1 //x=58.63 //y=0.175 //x2=58.545 //y2=0.175
r1218 (  374 376 ) resistor r=36.97 //w=0.367 //l=1.06 //layer=li \
 //thickness=0.1 //x=58.63 //y=0.175 //x2=59.69 //y2=0.175
r1219 (  373 534 ) resistor r=5.29055 //w=0.35 //l=0.17 //layer=li \
 //thickness=0.1 //x=62.11 //y=0.175 //x2=62.28 //y2=0.175
r1220 (  373 380 ) resistor r=6.97548 //w=0.367 //l=0.2 //layer=li \
 //thickness=0.1 //x=62.11 //y=0.175 //x2=61.91 //y2=0.175
r1221 (  369 533 ) resistor r=4.23183 //w=0.7 //l=0.175 //layer=li \
 //thickness=0.1 //x=58.545 //y=0.35 //x2=58.545 //y2=0.175
r1222 (  369 576 ) resistor r=54.4171 //w=0.187 //l=0.795 //layer=li \
 //thickness=0.1 //x=58.545 //y=0.35 //x2=58.545 //y2=1.145
r1223 (  368 531 ) resistor r=5.29055 //w=0.35 //l=0.17 //layer=li \
 //thickness=0.1 //x=57.64 //y=0.175 //x2=57.47 //y2=0.175
r1224 (  367 533 ) resistor r=2.87058 //w=0.35 //l=0.085 //layer=li \
 //thickness=0.1 //x=58.46 //y=0.175 //x2=58.545 //y2=0.175
r1225 (  367 368 ) resistor r=28.5995 //w=0.367 //l=0.82 //layer=li \
 //thickness=0.1 //x=58.46 //y=0.175 //x2=57.64 //y2=0.175
r1226 (  362 364 ) resistor r=38.7139 //w=0.367 //l=1.11 //layer=li \
 //thickness=0.1 //x=55.99 //y=0.175 //x2=57.1 //y2=0.175
r1227 (  360 362 ) resistor r=38.7139 //w=0.367 //l=1.11 //layer=li \
 //thickness=0.1 //x=54.88 //y=0.175 //x2=55.99 //y2=0.175
r1228 (  358 530 ) resistor r=2.87058 //w=0.35 //l=0.085 //layer=li \
 //thickness=0.1 //x=53.82 //y=0.175 //x2=53.735 //y2=0.175
r1229 (  358 360 ) resistor r=36.97 //w=0.367 //l=1.06 //layer=li \
 //thickness=0.1 //x=53.82 //y=0.175 //x2=54.88 //y2=0.175
r1230 (  357 531 ) resistor r=5.29055 //w=0.35 //l=0.17 //layer=li \
 //thickness=0.1 //x=57.3 //y=0.175 //x2=57.47 //y2=0.175
r1231 (  357 364 ) resistor r=6.97548 //w=0.367 //l=0.2 //layer=li \
 //thickness=0.1 //x=57.3 //y=0.175 //x2=57.1 //y2=0.175
r1232 (  353 530 ) resistor r=4.23183 //w=0.7 //l=0.175 //layer=li \
 //thickness=0.1 //x=53.735 //y=0.35 //x2=53.735 //y2=0.175
r1233 (  353 575 ) resistor r=54.4171 //w=0.187 //l=0.795 //layer=li \
 //thickness=0.1 //x=53.735 //y=0.35 //x2=53.735 //y2=1.145
r1234 (  352 528 ) resistor r=5.29055 //w=0.35 //l=0.17 //layer=li \
 //thickness=0.1 //x=52.83 //y=0.175 //x2=52.66 //y2=0.175
r1235 (  351 530 ) resistor r=2.87058 //w=0.35 //l=0.085 //layer=li \
 //thickness=0.1 //x=53.65 //y=0.175 //x2=53.735 //y2=0.175
r1236 (  351 352 ) resistor r=28.5995 //w=0.367 //l=0.82 //layer=li \
 //thickness=0.1 //x=53.65 //y=0.175 //x2=52.83 //y2=0.175
r1237 (  346 348 ) resistor r=38.7139 //w=0.367 //l=1.11 //layer=li \
 //thickness=0.1 //x=51.18 //y=0.175 //x2=52.29 //y2=0.175
r1238 (  344 527 ) resistor r=2.87058 //w=0.35 //l=0.085 //layer=li \
 //thickness=0.1 //x=50.595 //y=0.175 //x2=50.51 //y2=0.175
r1239 (  344 346 ) resistor r=20.4033 //w=0.367 //l=0.585 //layer=li \
 //thickness=0.1 //x=50.595 //y=0.175 //x2=51.18 //y2=0.175
r1240 (  343 528 ) resistor r=5.29055 //w=0.35 //l=0.17 //layer=li \
 //thickness=0.1 //x=52.49 //y=0.175 //x2=52.66 //y2=0.175
r1241 (  343 348 ) resistor r=6.97548 //w=0.367 //l=0.2 //layer=li \
 //thickness=0.1 //x=52.49 //y=0.175 //x2=52.29 //y2=0.175
r1242 (  339 527 ) resistor r=4.23183 //w=0.7 //l=0.175 //layer=li \
 //thickness=0.1 //x=50.51 //y=0.35 //x2=50.51 //y2=0.175
r1243 (  339 574 ) resistor r=53.7326 //w=0.187 //l=0.785 //layer=li \
 //thickness=0.1 //x=50.51 //y=0.35 //x2=50.51 //y2=1.135
r1244 (  336 526 ) resistor r=5.29055 //w=0.35 //l=0.17 //layer=li \
 //thickness=0.1 //x=49.5 //y=0.175 //x2=49.33 //y2=0.175
r1245 (  336 338 ) resistor r=19.8801 //w=0.367 //l=0.57 //layer=li \
 //thickness=0.1 //x=49.5 //y=0.175 //x2=50.07 //y2=0.175
r1246 (  335 527 ) resistor r=2.87058 //w=0.35 //l=0.085 //layer=li \
 //thickness=0.1 //x=50.425 //y=0.175 //x2=50.51 //y2=0.175
r1247 (  335 338 ) resistor r=12.3815 //w=0.367 //l=0.355 //layer=li \
 //thickness=0.1 //x=50.425 //y=0.175 //x2=50.07 //y2=0.175
r1248 (  330 332 ) resistor r=38.7139 //w=0.367 //l=1.11 //layer=li \
 //thickness=0.1 //x=47.48 //y=0.175 //x2=48.59 //y2=0.175
r1249 (  328 330 ) resistor r=38.7139 //w=0.367 //l=1.11 //layer=li \
 //thickness=0.1 //x=46.37 //y=0.175 //x2=47.48 //y2=0.175
r1250 (  326 525 ) resistor r=2.87058 //w=0.35 //l=0.085 //layer=li \
 //thickness=0.1 //x=45.68 //y=0.175 //x2=45.595 //y2=0.175
r1251 (  326 328 ) resistor r=24.0654 //w=0.367 //l=0.69 //layer=li \
 //thickness=0.1 //x=45.68 //y=0.175 //x2=46.37 //y2=0.175
r1252 (  325 526 ) resistor r=5.29055 //w=0.35 //l=0.17 //layer=li \
 //thickness=0.1 //x=49.16 //y=0.175 //x2=49.33 //y2=0.175
r1253 (  325 332 ) resistor r=19.8801 //w=0.367 //l=0.57 //layer=li \
 //thickness=0.1 //x=49.16 //y=0.175 //x2=48.59 //y2=0.175
r1254 (  321 525 ) resistor r=4.23183 //w=0.7 //l=0.175 //layer=li \
 //thickness=0.1 //x=45.595 //y=0.35 //x2=45.595 //y2=0.175
r1255 (  321 573 ) resistor r=54.4171 //w=0.187 //l=0.795 //layer=li \
 //thickness=0.1 //x=45.595 //y=0.35 //x2=45.595 //y2=1.145
r1256 (  318 524 ) resistor r=5.29055 //w=0.35 //l=0.17 //layer=li \
 //thickness=0.1 //x=44.69 //y=0.175 //x2=44.52 //y2=0.175
r1257 (  318 320 ) resistor r=19.8801 //w=0.367 //l=0.57 //layer=li \
 //thickness=0.1 //x=44.69 //y=0.175 //x2=45.26 //y2=0.175
r1258 (  317 525 ) resistor r=2.87058 //w=0.35 //l=0.085 //layer=li \
 //thickness=0.1 //x=45.51 //y=0.175 //x2=45.595 //y2=0.175
r1259 (  317 320 ) resistor r=8.71935 //w=0.367 //l=0.25 //layer=li \
 //thickness=0.1 //x=45.51 //y=0.175 //x2=45.26 //y2=0.175
r1260 (  312 314 ) resistor r=38.7139 //w=0.367 //l=1.11 //layer=li \
 //thickness=0.1 //x=42.67 //y=0.175 //x2=43.78 //y2=0.175
r1261 (  310 523 ) resistor r=2.87058 //w=0.35 //l=0.085 //layer=li \
 //thickness=0.1 //x=42.455 //y=0.175 //x2=42.37 //y2=0.175
r1262 (  310 312 ) resistor r=7.49864 //w=0.367 //l=0.215 //layer=li \
 //thickness=0.1 //x=42.455 //y=0.175 //x2=42.67 //y2=0.175
r1263 (  309 524 ) resistor r=5.29055 //w=0.35 //l=0.17 //layer=li \
 //thickness=0.1 //x=44.35 //y=0.175 //x2=44.52 //y2=0.175
r1264 (  309 314 ) resistor r=19.8801 //w=0.367 //l=0.57 //layer=li \
 //thickness=0.1 //x=44.35 //y=0.175 //x2=43.78 //y2=0.175
r1265 (  305 523 ) resistor r=4.23183 //w=0.7 //l=0.175 //layer=li \
 //thickness=0.1 //x=42.37 //y=0.35 //x2=42.37 //y2=0.175
r1266 (  305 572 ) resistor r=53.7326 //w=0.187 //l=0.785 //layer=li \
 //thickness=0.1 //x=42.37 //y=0.35 //x2=42.37 //y2=1.135
r1267 (  302 522 ) resistor r=5.29055 //w=0.35 //l=0.17 //layer=li \
 //thickness=0.1 //x=41.36 //y=0.175 //x2=41.19 //y2=0.175
r1268 (  302 304 ) resistor r=6.97548 //w=0.367 //l=0.2 //layer=li \
 //thickness=0.1 //x=41.36 //y=0.175 //x2=41.56 //y2=0.175
r1269 (  301 523 ) resistor r=2.87058 //w=0.35 //l=0.085 //layer=li \
 //thickness=0.1 //x=42.285 //y=0.175 //x2=42.37 //y2=0.175
r1270 (  301 304 ) resistor r=25.2861 //w=0.367 //l=0.725 //layer=li \
 //thickness=0.1 //x=42.285 //y=0.175 //x2=41.56 //y2=0.175
r1271 (  296 521 ) resistor r=2.87058 //w=0.35 //l=0.085 //layer=li \
 //thickness=0.1 //x=39.125 //y=0.175 //x2=39.04 //y2=0.175
r1272 (  296 298 ) resistor r=33.3079 //w=0.367 //l=0.955 //layer=li \
 //thickness=0.1 //x=39.125 //y=0.175 //x2=40.08 //y2=0.175
r1273 (  295 522 ) resistor r=5.29055 //w=0.35 //l=0.17 //layer=li \
 //thickness=0.1 //x=41.02 //y=0.175 //x2=41.19 //y2=0.175
r1274 (  295 298 ) resistor r=32.7847 //w=0.367 //l=0.94 //layer=li \
 //thickness=0.1 //x=41.02 //y=0.175 //x2=40.08 //y2=0.175
r1275 (  291 521 ) resistor r=4.23183 //w=0.7 //l=0.175 //layer=li \
 //thickness=0.1 //x=39.04 //y=0.35 //x2=39.04 //y2=0.175
r1276 (  291 571 ) resistor r=53.7326 //w=0.187 //l=0.785 //layer=li \
 //thickness=0.1 //x=39.04 //y=0.35 //x2=39.04 //y2=1.135
r1277 (  290 519 ) resistor r=5.29055 //w=0.35 //l=0.17 //layer=li \
 //thickness=0.1 //x=38.03 //y=0.175 //x2=37.86 //y2=0.175
r1278 (  289 521 ) resistor r=2.87058 //w=0.35 //l=0.085 //layer=li \
 //thickness=0.1 //x=38.955 //y=0.175 //x2=39.04 //y2=0.175
r1279 (  289 290 ) resistor r=32.2616 //w=0.367 //l=0.925 //layer=li \
 //thickness=0.1 //x=38.955 //y=0.175 //x2=38.03 //y2=0.175
r1280 (  284 286 ) resistor r=38.7139 //w=0.367 //l=1.11 //layer=li \
 //thickness=0.1 //x=36.38 //y=0.175 //x2=37.49 //y2=0.175
r1281 (  282 284 ) resistor r=38.7139 //w=0.367 //l=1.11 //layer=li \
 //thickness=0.1 //x=35.27 //y=0.175 //x2=36.38 //y2=0.175
r1282 (  280 518 ) resistor r=2.87058 //w=0.35 //l=0.085 //layer=li \
 //thickness=0.1 //x=34.21 //y=0.175 //x2=34.125 //y2=0.175
r1283 (  280 282 ) resistor r=36.97 //w=0.367 //l=1.06 //layer=li \
 //thickness=0.1 //x=34.21 //y=0.175 //x2=35.27 //y2=0.175
r1284 (  279 519 ) resistor r=5.29055 //w=0.35 //l=0.17 //layer=li \
 //thickness=0.1 //x=37.69 //y=0.175 //x2=37.86 //y2=0.175
r1285 (  279 286 ) resistor r=6.97548 //w=0.367 //l=0.2 //layer=li \
 //thickness=0.1 //x=37.69 //y=0.175 //x2=37.49 //y2=0.175
r1286 (  275 518 ) resistor r=4.23183 //w=0.7 //l=0.175 //layer=li \
 //thickness=0.1 //x=34.125 //y=0.35 //x2=34.125 //y2=0.175
r1287 (  275 570 ) resistor r=54.4171 //w=0.187 //l=0.795 //layer=li \
 //thickness=0.1 //x=34.125 //y=0.35 //x2=34.125 //y2=1.145
r1288 (  274 516 ) resistor r=5.29055 //w=0.35 //l=0.17 //layer=li \
 //thickness=0.1 //x=33.22 //y=0.175 //x2=33.05 //y2=0.175
r1289 (  273 518 ) resistor r=2.87058 //w=0.35 //l=0.085 //layer=li \
 //thickness=0.1 //x=34.04 //y=0.175 //x2=34.125 //y2=0.175
r1290 (  273 274 ) resistor r=28.5995 //w=0.367 //l=0.82 //layer=li \
 //thickness=0.1 //x=34.04 //y=0.175 //x2=33.22 //y2=0.175
r1291 (  268 270 ) resistor r=38.7139 //w=0.367 //l=1.11 //layer=li \
 //thickness=0.1 //x=31.57 //y=0.175 //x2=32.68 //y2=0.175
r1292 (  266 268 ) resistor r=38.7139 //w=0.367 //l=1.11 //layer=li \
 //thickness=0.1 //x=30.46 //y=0.175 //x2=31.57 //y2=0.175
r1293 (  264 515 ) resistor r=2.87058 //w=0.35 //l=0.085 //layer=li \
 //thickness=0.1 //x=29.4 //y=0.175 //x2=29.315 //y2=0.175
r1294 (  264 266 ) resistor r=36.97 //w=0.367 //l=1.06 //layer=li \
 //thickness=0.1 //x=29.4 //y=0.175 //x2=30.46 //y2=0.175
r1295 (  263 516 ) resistor r=5.29055 //w=0.35 //l=0.17 //layer=li \
 //thickness=0.1 //x=32.88 //y=0.175 //x2=33.05 //y2=0.175
r1296 (  263 270 ) resistor r=6.97548 //w=0.367 //l=0.2 //layer=li \
 //thickness=0.1 //x=32.88 //y=0.175 //x2=32.68 //y2=0.175
r1297 (  259 515 ) resistor r=4.23183 //w=0.7 //l=0.175 //layer=li \
 //thickness=0.1 //x=29.315 //y=0.35 //x2=29.315 //y2=0.175
r1298 (  259 569 ) resistor r=54.4171 //w=0.187 //l=0.795 //layer=li \
 //thickness=0.1 //x=29.315 //y=0.35 //x2=29.315 //y2=1.145
r1299 (  258 513 ) resistor r=5.29055 //w=0.35 //l=0.17 //layer=li \
 //thickness=0.1 //x=28.41 //y=0.175 //x2=28.24 //y2=0.175
r1300 (  257 515 ) resistor r=2.87058 //w=0.35 //l=0.085 //layer=li \
 //thickness=0.1 //x=29.23 //y=0.175 //x2=29.315 //y2=0.175
r1301 (  257 258 ) resistor r=28.5995 //w=0.367 //l=0.82 //layer=li \
 //thickness=0.1 //x=29.23 //y=0.175 //x2=28.41 //y2=0.175
r1302 (  252 254 ) resistor r=38.7139 //w=0.367 //l=1.11 //layer=li \
 //thickness=0.1 //x=26.76 //y=0.175 //x2=27.87 //y2=0.175
r1303 (  250 512 ) resistor r=2.87058 //w=0.35 //l=0.085 //layer=li \
 //thickness=0.1 //x=26.175 //y=0.175 //x2=26.09 //y2=0.175
r1304 (  250 252 ) resistor r=20.4033 //w=0.367 //l=0.585 //layer=li \
 //thickness=0.1 //x=26.175 //y=0.175 //x2=26.76 //y2=0.175
r1305 (  249 513 ) resistor r=5.29055 //w=0.35 //l=0.17 //layer=li \
 //thickness=0.1 //x=28.07 //y=0.175 //x2=28.24 //y2=0.175
r1306 (  249 254 ) resistor r=6.97548 //w=0.367 //l=0.2 //layer=li \
 //thickness=0.1 //x=28.07 //y=0.175 //x2=27.87 //y2=0.175
r1307 (  245 512 ) resistor r=4.23183 //w=0.7 //l=0.175 //layer=li \
 //thickness=0.1 //x=26.09 //y=0.35 //x2=26.09 //y2=0.175
r1308 (  245 568 ) resistor r=53.7326 //w=0.187 //l=0.785 //layer=li \
 //thickness=0.1 //x=26.09 //y=0.35 //x2=26.09 //y2=1.135
r1309 (  242 511 ) resistor r=5.29055 //w=0.35 //l=0.17 //layer=li \
 //thickness=0.1 //x=25.08 //y=0.175 //x2=24.91 //y2=0.175
r1310 (  242 244 ) resistor r=19.8801 //w=0.367 //l=0.57 //layer=li \
 //thickness=0.1 //x=25.08 //y=0.175 //x2=25.65 //y2=0.175
r1311 (  241 512 ) resistor r=2.87058 //w=0.35 //l=0.085 //layer=li \
 //thickness=0.1 //x=26.005 //y=0.175 //x2=26.09 //y2=0.175
r1312 (  241 244 ) resistor r=12.3815 //w=0.367 //l=0.355 //layer=li \
 //thickness=0.1 //x=26.005 //y=0.175 //x2=25.65 //y2=0.175
r1313 (  236 238 ) resistor r=38.7139 //w=0.367 //l=1.11 //layer=li \
 //thickness=0.1 //x=23.06 //y=0.175 //x2=24.17 //y2=0.175
r1314 (  234 236 ) resistor r=38.7139 //w=0.367 //l=1.11 //layer=li \
 //thickness=0.1 //x=21.95 //y=0.175 //x2=23.06 //y2=0.175
r1315 (  232 510 ) resistor r=2.87058 //w=0.35 //l=0.085 //layer=li \
 //thickness=0.1 //x=21.26 //y=0.175 //x2=21.175 //y2=0.175
r1316 (  232 234 ) resistor r=24.0654 //w=0.367 //l=0.69 //layer=li \
 //thickness=0.1 //x=21.26 //y=0.175 //x2=21.95 //y2=0.175
r1317 (  231 511 ) resistor r=5.29055 //w=0.35 //l=0.17 //layer=li \
 //thickness=0.1 //x=24.74 //y=0.175 //x2=24.91 //y2=0.175
r1318 (  231 238 ) resistor r=19.8801 //w=0.367 //l=0.57 //layer=li \
 //thickness=0.1 //x=24.74 //y=0.175 //x2=24.17 //y2=0.175
r1319 (  227 510 ) resistor r=4.23183 //w=0.7 //l=0.175 //layer=li \
 //thickness=0.1 //x=21.175 //y=0.35 //x2=21.175 //y2=0.175
r1320 (  227 567 ) resistor r=54.4171 //w=0.187 //l=0.795 //layer=li \
 //thickness=0.1 //x=21.175 //y=0.35 //x2=21.175 //y2=1.145
r1321 (  224 509 ) resistor r=5.29055 //w=0.35 //l=0.17 //layer=li \
 //thickness=0.1 //x=20.27 //y=0.175 //x2=20.1 //y2=0.175
r1322 (  224 226 ) resistor r=19.8801 //w=0.367 //l=0.57 //layer=li \
 //thickness=0.1 //x=20.27 //y=0.175 //x2=20.84 //y2=0.175
r1323 (  223 510 ) resistor r=2.87058 //w=0.35 //l=0.085 //layer=li \
 //thickness=0.1 //x=21.09 //y=0.175 //x2=21.175 //y2=0.175
r1324 (  223 226 ) resistor r=8.71935 //w=0.367 //l=0.25 //layer=li \
 //thickness=0.1 //x=21.09 //y=0.175 //x2=20.84 //y2=0.175
r1325 (  218 220 ) resistor r=38.7139 //w=0.367 //l=1.11 //layer=li \
 //thickness=0.1 //x=18.25 //y=0.175 //x2=19.36 //y2=0.175
r1326 (  216 508 ) resistor r=2.87058 //w=0.35 //l=0.085 //layer=li \
 //thickness=0.1 //x=18.035 //y=0.175 //x2=17.95 //y2=0.175
r1327 (  216 218 ) resistor r=7.49864 //w=0.367 //l=0.215 //layer=li \
 //thickness=0.1 //x=18.035 //y=0.175 //x2=18.25 //y2=0.175
r1328 (  215 509 ) resistor r=5.29055 //w=0.35 //l=0.17 //layer=li \
 //thickness=0.1 //x=19.93 //y=0.175 //x2=20.1 //y2=0.175
r1329 (  215 220 ) resistor r=19.8801 //w=0.367 //l=0.57 //layer=li \
 //thickness=0.1 //x=19.93 //y=0.175 //x2=19.36 //y2=0.175
r1330 (  211 508 ) resistor r=4.23183 //w=0.7 //l=0.175 //layer=li \
 //thickness=0.1 //x=17.95 //y=0.35 //x2=17.95 //y2=0.175
r1331 (  211 566 ) resistor r=53.7326 //w=0.187 //l=0.785 //layer=li \
 //thickness=0.1 //x=17.95 //y=0.35 //x2=17.95 //y2=1.135
r1332 (  208 507 ) resistor r=5.29055 //w=0.35 //l=0.17 //layer=li \
 //thickness=0.1 //x=16.94 //y=0.175 //x2=16.77 //y2=0.175
r1333 (  208 210 ) resistor r=6.97548 //w=0.367 //l=0.2 //layer=li \
 //thickness=0.1 //x=16.94 //y=0.175 //x2=17.14 //y2=0.175
r1334 (  207 508 ) resistor r=2.87058 //w=0.35 //l=0.085 //layer=li \
 //thickness=0.1 //x=17.865 //y=0.175 //x2=17.95 //y2=0.175
r1335 (  207 210 ) resistor r=25.2861 //w=0.367 //l=0.725 //layer=li \
 //thickness=0.1 //x=17.865 //y=0.175 //x2=17.14 //y2=0.175
r1336 (  202 506 ) resistor r=2.87058 //w=0.35 //l=0.085 //layer=li \
 //thickness=0.1 //x=14.705 //y=0.175 //x2=14.62 //y2=0.175
r1337 (  202 204 ) resistor r=33.3079 //w=0.367 //l=0.955 //layer=li \
 //thickness=0.1 //x=14.705 //y=0.175 //x2=15.66 //y2=0.175
r1338 (  201 507 ) resistor r=5.29055 //w=0.35 //l=0.17 //layer=li \
 //thickness=0.1 //x=16.6 //y=0.175 //x2=16.77 //y2=0.175
r1339 (  201 204 ) resistor r=32.7847 //w=0.367 //l=0.94 //layer=li \
 //thickness=0.1 //x=16.6 //y=0.175 //x2=15.66 //y2=0.175
r1340 (  197 506 ) resistor r=4.23183 //w=0.7 //l=0.175 //layer=li \
 //thickness=0.1 //x=14.62 //y=0.35 //x2=14.62 //y2=0.175
r1341 (  197 565 ) resistor r=53.7326 //w=0.187 //l=0.785 //layer=li \
 //thickness=0.1 //x=14.62 //y=0.35 //x2=14.62 //y2=1.135
r1342 (  196 504 ) resistor r=5.29055 //w=0.35 //l=0.17 //layer=li \
 //thickness=0.1 //x=13.61 //y=0.175 //x2=13.44 //y2=0.175
r1343 (  195 506 ) resistor r=2.87058 //w=0.35 //l=0.085 //layer=li \
 //thickness=0.1 //x=14.535 //y=0.175 //x2=14.62 //y2=0.175
r1344 (  195 196 ) resistor r=32.2616 //w=0.367 //l=0.925 //layer=li \
 //thickness=0.1 //x=14.535 //y=0.175 //x2=13.61 //y2=0.175
r1345 (  190 192 ) resistor r=38.7139 //w=0.367 //l=1.11 //layer=li \
 //thickness=0.1 //x=11.96 //y=0.175 //x2=13.07 //y2=0.175
r1346 (  188 190 ) resistor r=38.7139 //w=0.367 //l=1.11 //layer=li \
 //thickness=0.1 //x=10.85 //y=0.175 //x2=11.96 //y2=0.175
r1347 (  186 503 ) resistor r=2.87058 //w=0.35 //l=0.085 //layer=li \
 //thickness=0.1 //x=9.79 //y=0.175 //x2=9.705 //y2=0.175
r1348 (  186 188 ) resistor r=36.97 //w=0.367 //l=1.06 //layer=li \
 //thickness=0.1 //x=9.79 //y=0.175 //x2=10.85 //y2=0.175
r1349 (  185 504 ) resistor r=5.29055 //w=0.35 //l=0.17 //layer=li \
 //thickness=0.1 //x=13.27 //y=0.175 //x2=13.44 //y2=0.175
r1350 (  185 192 ) resistor r=6.97548 //w=0.367 //l=0.2 //layer=li \
 //thickness=0.1 //x=13.27 //y=0.175 //x2=13.07 //y2=0.175
r1351 (  181 503 ) resistor r=4.23183 //w=0.7 //l=0.175 //layer=li \
 //thickness=0.1 //x=9.705 //y=0.35 //x2=9.705 //y2=0.175
r1352 (  181 564 ) resistor r=54.4171 //w=0.187 //l=0.795 //layer=li \
 //thickness=0.1 //x=9.705 //y=0.35 //x2=9.705 //y2=1.145
r1353 (  180 501 ) resistor r=5.29055 //w=0.35 //l=0.17 //layer=li \
 //thickness=0.1 //x=8.8 //y=0.175 //x2=8.63 //y2=0.175
r1354 (  179 503 ) resistor r=2.87058 //w=0.35 //l=0.085 //layer=li \
 //thickness=0.1 //x=9.62 //y=0.175 //x2=9.705 //y2=0.175
r1355 (  179 180 ) resistor r=28.5995 //w=0.367 //l=0.82 //layer=li \
 //thickness=0.1 //x=9.62 //y=0.175 //x2=8.8 //y2=0.175
r1356 (  174 176 ) resistor r=38.7139 //w=0.367 //l=1.11 //layer=li \
 //thickness=0.1 //x=7.15 //y=0.175 //x2=8.26 //y2=0.175
r1357 (  172 174 ) resistor r=38.7139 //w=0.367 //l=1.11 //layer=li \
 //thickness=0.1 //x=6.04 //y=0.175 //x2=7.15 //y2=0.175
r1358 (  170 500 ) resistor r=2.87058 //w=0.35 //l=0.085 //layer=li \
 //thickness=0.1 //x=4.98 //y=0.175 //x2=4.895 //y2=0.175
r1359 (  170 172 ) resistor r=36.97 //w=0.367 //l=1.06 //layer=li \
 //thickness=0.1 //x=4.98 //y=0.175 //x2=6.04 //y2=0.175
r1360 (  169 501 ) resistor r=5.29055 //w=0.35 //l=0.17 //layer=li \
 //thickness=0.1 //x=8.46 //y=0.175 //x2=8.63 //y2=0.175
r1361 (  169 176 ) resistor r=6.97548 //w=0.367 //l=0.2 //layer=li \
 //thickness=0.1 //x=8.46 //y=0.175 //x2=8.26 //y2=0.175
r1362 (  165 500 ) resistor r=4.23183 //w=0.7 //l=0.175 //layer=li \
 //thickness=0.1 //x=4.895 //y=0.35 //x2=4.895 //y2=0.175
r1363 (  165 563 ) resistor r=54.4171 //w=0.187 //l=0.795 //layer=li \
 //thickness=0.1 //x=4.895 //y=0.35 //x2=4.895 //y2=1.145
r1364 (  164 498 ) resistor r=5.29055 //w=0.35 //l=0.17 //layer=li \
 //thickness=0.1 //x=3.99 //y=0.175 //x2=3.82 //y2=0.175
r1365 (  163 500 ) resistor r=2.87058 //w=0.35 //l=0.085 //layer=li \
 //thickness=0.1 //x=4.81 //y=0.175 //x2=4.895 //y2=0.175
r1366 (  163 164 ) resistor r=28.5995 //w=0.367 //l=0.82 //layer=li \
 //thickness=0.1 //x=4.81 //y=0.175 //x2=3.99 //y2=0.175
r1367 (  158 160 ) resistor r=38.7139 //w=0.367 //l=1.11 //layer=li \
 //thickness=0.1 //x=2.34 //y=0.175 //x2=3.45 //y2=0.175
r1368 (  156 497 ) resistor r=2.87058 //w=0.35 //l=0.085 //layer=li \
 //thickness=0.1 //x=1.755 //y=0.175 //x2=1.67 //y2=0.175
r1369 (  156 158 ) resistor r=20.4033 //w=0.367 //l=0.585 //layer=li \
 //thickness=0.1 //x=1.755 //y=0.175 //x2=2.34 //y2=0.175
r1370 (  155 498 ) resistor r=5.29055 //w=0.35 //l=0.17 //layer=li \
 //thickness=0.1 //x=3.65 //y=0.175 //x2=3.82 //y2=0.175
r1371 (  155 160 ) resistor r=6.97548 //w=0.367 //l=0.2 //layer=li \
 //thickness=0.1 //x=3.65 //y=0.175 //x2=3.45 //y2=0.175
r1372 (  151 497 ) resistor r=4.23183 //w=0.7 //l=0.175 //layer=li \
 //thickness=0.1 //x=1.67 //y=0.35 //x2=1.67 //y2=0.175
r1373 (  151 562 ) resistor r=53.7326 //w=0.187 //l=0.785 //layer=li \
 //thickness=0.1 //x=1.67 //y=0.35 //x2=1.67 //y2=1.135
r1374 (  147 497 ) resistor r=2.87058 //w=0.35 //l=0.085 //layer=li \
 //thickness=0.1 //x=1.585 //y=0.175 //x2=1.67 //y2=0.175
r1375 (  147 150 ) resistor r=12.3815 //w=0.367 //l=0.355 //layer=li \
 //thickness=0.1 //x=1.585 //y=0.175 //x2=1.23 //y2=0.175
r1376 (  143 554 ) resistor r=4.65 //w=0.17 //l=0.34 //layer=mcon //count=2 \
 //x=85.22 //y=0.18 //x2=85.22 //y2=0.18
r1377 (  141 551 ) resistor r=3.1 //w=0.17 //l=0.51 //layer=mcon //count=3 \
 //x=84.48 //y=0.18 //x2=84.48 //y2=0.18
r1378 (  141 143 ) resistor r=0.297428 //w=0.311 //l=0.74 //layer=m1 \
 //thickness=0.36 //x=84.48 //y=0.175 //x2=85.22 //y2=0.175
r1379 (  139 470 ) resistor r=3.1 //w=0.17 //l=0.51 //layer=mcon //count=3 \
 //x=83 //y=0.18 //x2=83 //y2=0.18
r1380 (  139 141 ) resistor r=0.594855 //w=0.311 //l=1.48 //layer=m1 \
 //thickness=0.36 //x=83 //y=0.175 //x2=84.48 //y2=0.175
r1381 (  137 468 ) resistor r=3.1 //w=0.17 //l=0.51 //layer=mcon //count=3 \
 //x=81.89 //y=0.18 //x2=81.89 //y2=0.18
r1382 (  137 139 ) resistor r=0.446141 //w=0.311 //l=1.11 //layer=m1 \
 //thickness=0.36 //x=81.89 //y=0.175 //x2=83 //y2=0.175
r1383 (  135 460 ) resistor r=3.1 //w=0.17 //l=0.51 //layer=mcon //count=3 \
 //x=80.78 //y=0.18 //x2=80.78 //y2=0.18
r1384 (  135 137 ) resistor r=0.446141 //w=0.311 //l=1.11 //layer=m1 \
 //thickness=0.36 //x=80.78 //y=0.175 //x2=81.89 //y2=0.175
r1385 (  133 454 ) resistor r=3.1 //w=0.17 //l=0.51 //layer=mcon //count=3 \
 //x=79.3 //y=0.18 //x2=79.3 //y2=0.18
r1386 (  133 135 ) resistor r=0.594855 //w=0.311 //l=1.48 //layer=m1 \
 //thickness=0.36 //x=79.3 //y=0.175 //x2=80.78 //y2=0.175
r1387 (  131 545 ) resistor r=3.1 //w=0.17 //l=0.51 //layer=mcon //count=3 \
 //x=78.19 //y=0.18 //x2=78.19 //y2=0.18
r1388 (  131 133 ) resistor r=0.446141 //w=0.311 //l=1.11 //layer=m1 \
 //thickness=0.36 //x=78.19 //y=0.175 //x2=79.3 //y2=0.175
r1389 (  129 442 ) resistor r=3.1 //w=0.17 //l=0.51 //layer=mcon //count=3 \
 //x=76.71 //y=0.18 //x2=76.71 //y2=0.18
r1390 (  129 131 ) resistor r=0.594855 //w=0.311 //l=1.48 //layer=m1 \
 //thickness=0.36 //x=76.71 //y=0.175 //x2=78.19 //y2=0.175
r1391 (  127 440 ) resistor r=3.1 //w=0.17 //l=0.51 //layer=mcon //count=3 \
 //x=75.6 //y=0.18 //x2=75.6 //y2=0.18
r1392 (  127 129 ) resistor r=0.446141 //w=0.311 //l=1.11 //layer=m1 \
 //thickness=0.36 //x=75.6 //y=0.175 //x2=76.71 //y2=0.175
r1393 (  125 432 ) resistor r=3.1 //w=0.17 //l=0.51 //layer=mcon //count=3 \
 //x=74.49 //y=0.18 //x2=74.49 //y2=0.18
r1394 (  125 127 ) resistor r=0.446141 //w=0.311 //l=1.11 //layer=m1 \
 //thickness=0.36 //x=74.49 //y=0.175 //x2=75.6 //y2=0.175
r1395 (  123 426 ) resistor r=3.1 //w=0.17 //l=0.51 //layer=mcon //count=3 \
 //x=73.01 //y=0.18 //x2=73.01 //y2=0.18
r1396 (  123 125 ) resistor r=0.594855 //w=0.311 //l=1.48 //layer=m1 \
 //thickness=0.36 //x=73.01 //y=0.175 //x2=74.49 //y2=0.175
r1397 (  121 424 ) resistor r=3.1 //w=0.17 //l=0.51 //layer=mcon //count=3 \
 //x=71.9 //y=0.18 //x2=71.9 //y2=0.18
r1398 (  121 123 ) resistor r=0.446141 //w=0.311 //l=1.11 //layer=m1 \
 //thickness=0.36 //x=71.9 //y=0.175 //x2=73.01 //y2=0.175
r1399 (  119 422 ) resistor r=3.1 //w=0.17 //l=0.51 //layer=mcon //count=3 \
 //x=70.79 //y=0.18 //x2=70.79 //y2=0.18
r1400 (  119 121 ) resistor r=0.446141 //w=0.311 //l=1.11 //layer=m1 \
 //thickness=0.36 //x=70.79 //y=0.175 //x2=71.9 //y2=0.175
r1401 (  117 414 ) resistor r=3.1 //w=0.17 //l=0.51 //layer=mcon //count=3 \
 //x=69.68 //y=0.18 //x2=69.68 //y2=0.18
r1402 (  117 119 ) resistor r=0.446141 //w=0.311 //l=1.11 //layer=m1 \
 //thickness=0.36 //x=69.68 //y=0.175 //x2=70.79 //y2=0.175
r1403 (  115 408 ) resistor r=3.1 //w=0.17 //l=0.51 //layer=mcon //count=3 \
 //x=68.2 //y=0.18 //x2=68.2 //y2=0.18
r1404 (  115 117 ) resistor r=0.594855 //w=0.311 //l=1.48 //layer=m1 \
 //thickness=0.36 //x=68.2 //y=0.175 //x2=69.68 //y2=0.175
r1405 (  113 406 ) resistor r=3.1 //w=0.17 //l=0.51 //layer=mcon //count=3 \
 //x=67.09 //y=0.18 //x2=67.09 //y2=0.18
r1406 (  113 115 ) resistor r=0.446141 //w=0.311 //l=1.11 //layer=m1 \
 //thickness=0.36 //x=67.09 //y=0.175 //x2=68.2 //y2=0.175
r1407 (  111 398 ) resistor r=3.1 //w=0.17 //l=0.51 //layer=mcon //count=3 \
 //x=65.98 //y=0.18 //x2=65.98 //y2=0.18
r1408 (  111 113 ) resistor r=0.446141 //w=0.311 //l=1.11 //layer=m1 \
 //thickness=0.36 //x=65.98 //y=0.175 //x2=67.09 //y2=0.175
r1409 (  109 392 ) resistor r=3.1 //w=0.17 //l=0.51 //layer=mcon //count=3 \
 //x=64.5 //y=0.18 //x2=64.5 //y2=0.18
r1410 (  109 111 ) resistor r=0.594855 //w=0.311 //l=1.48 //layer=m1 \
 //thickness=0.36 //x=64.5 //y=0.175 //x2=65.98 //y2=0.175
r1411 (  107 536 ) resistor r=3.1 //w=0.17 //l=0.51 //layer=mcon //count=3 \
 //x=63.39 //y=0.18 //x2=63.39 //y2=0.18
r1412 (  107 109 ) resistor r=0.446141 //w=0.311 //l=1.11 //layer=m1 \
 //thickness=0.36 //x=63.39 //y=0.175 //x2=64.5 //y2=0.175
r1413 (  105 380 ) resistor r=3.1 //w=0.17 //l=0.51 //layer=mcon //count=3 \
 //x=61.91 //y=0.18 //x2=61.91 //y2=0.18
r1414 (  105 107 ) resistor r=0.594855 //w=0.311 //l=1.48 //layer=m1 \
 //thickness=0.36 //x=61.91 //y=0.175 //x2=63.39 //y2=0.175
r1415 (  103 378 ) resistor r=3.1 //w=0.17 //l=0.51 //layer=mcon //count=3 \
 //x=60.8 //y=0.18 //x2=60.8 //y2=0.18
r1416 (  103 105 ) resistor r=0.446141 //w=0.311 //l=1.11 //layer=m1 \
 //thickness=0.36 //x=60.8 //y=0.175 //x2=61.91 //y2=0.175
r1417 (  101 376 ) resistor r=3.1 //w=0.17 //l=0.51 //layer=mcon //count=3 \
 //x=59.69 //y=0.18 //x2=59.69 //y2=0.18
r1418 (  101 103 ) resistor r=0.446141 //w=0.311 //l=1.11 //layer=m1 \
 //thickness=0.36 //x=59.69 //y=0.175 //x2=60.8 //y2=0.175
r1419 (  99 533 ) resistor r=3.1 //w=0.17 //l=0.51 //layer=mcon //count=3 \
 //x=58.58 //y=0.18 //x2=58.58 //y2=0.18
r1420 (  99 101 ) resistor r=0.446141 //w=0.311 //l=1.11 //layer=m1 \
 //thickness=0.36 //x=58.58 //y=0.175 //x2=59.69 //y2=0.175
r1421 (  97 364 ) resistor r=3.1 //w=0.17 //l=0.51 //layer=mcon //count=3 \
 //x=57.1 //y=0.18 //x2=57.1 //y2=0.18
r1422 (  97 99 ) resistor r=0.594855 //w=0.311 //l=1.48 //layer=m1 \
 //thickness=0.36 //x=57.1 //y=0.175 //x2=58.58 //y2=0.175
r1423 (  95 362 ) resistor r=3.1 //w=0.17 //l=0.51 //layer=mcon //count=3 \
 //x=55.99 //y=0.18 //x2=55.99 //y2=0.18
r1424 (  95 97 ) resistor r=0.446141 //w=0.311 //l=1.11 //layer=m1 \
 //thickness=0.36 //x=55.99 //y=0.175 //x2=57.1 //y2=0.175
r1425 (  93 360 ) resistor r=3.1 //w=0.17 //l=0.51 //layer=mcon //count=3 \
 //x=54.88 //y=0.18 //x2=54.88 //y2=0.18
r1426 (  93 95 ) resistor r=0.446141 //w=0.311 //l=1.11 //layer=m1 \
 //thickness=0.36 //x=54.88 //y=0.175 //x2=55.99 //y2=0.175
r1427 (  91 530 ) resistor r=3.1 //w=0.17 //l=0.51 //layer=mcon //count=3 \
 //x=53.77 //y=0.18 //x2=53.77 //y2=0.18
r1428 (  91 93 ) resistor r=0.446141 //w=0.311 //l=1.11 //layer=m1 \
 //thickness=0.36 //x=53.77 //y=0.175 //x2=54.88 //y2=0.175
r1429 (  89 348 ) resistor r=3.1 //w=0.17 //l=0.51 //layer=mcon //count=3 \
 //x=52.29 //y=0.18 //x2=52.29 //y2=0.18
r1430 (  89 91 ) resistor r=0.594855 //w=0.311 //l=1.48 //layer=m1 \
 //thickness=0.36 //x=52.29 //y=0.175 //x2=53.77 //y2=0.175
r1431 (  87 346 ) resistor r=3.1 //w=0.17 //l=0.51 //layer=mcon //count=3 \
 //x=51.18 //y=0.18 //x2=51.18 //y2=0.18
r1432 (  87 89 ) resistor r=0.446141 //w=0.311 //l=1.11 //layer=m1 \
 //thickness=0.36 //x=51.18 //y=0.175 //x2=52.29 //y2=0.175
r1433 (  85 338 ) resistor r=3.1 //w=0.17 //l=0.51 //layer=mcon //count=3 \
 //x=50.07 //y=0.18 //x2=50.07 //y2=0.18
r1434 (  85 87 ) resistor r=0.446141 //w=0.311 //l=1.11 //layer=m1 \
 //thickness=0.36 //x=50.07 //y=0.175 //x2=51.18 //y2=0.175
r1435 (  83 332 ) resistor r=3.1 //w=0.17 //l=0.51 //layer=mcon //count=3 \
 //x=48.59 //y=0.18 //x2=48.59 //y2=0.18
r1436 (  83 85 ) resistor r=0.594855 //w=0.311 //l=1.48 //layer=m1 \
 //thickness=0.36 //x=48.59 //y=0.175 //x2=50.07 //y2=0.175
r1437 (  81 330 ) resistor r=3.1 //w=0.17 //l=0.51 //layer=mcon //count=3 \
 //x=47.48 //y=0.18 //x2=47.48 //y2=0.18
r1438 (  81 83 ) resistor r=0.446141 //w=0.311 //l=1.11 //layer=m1 \
 //thickness=0.36 //x=47.48 //y=0.175 //x2=48.59 //y2=0.175
r1439 (  79 328 ) resistor r=3.1 //w=0.17 //l=0.51 //layer=mcon //count=3 \
 //x=46.37 //y=0.18 //x2=46.37 //y2=0.18
r1440 (  79 81 ) resistor r=0.446141 //w=0.311 //l=1.11 //layer=m1 \
 //thickness=0.36 //x=46.37 //y=0.175 //x2=47.48 //y2=0.175
r1441 (  77 320 ) resistor r=3.1 //w=0.17 //l=0.51 //layer=mcon //count=3 \
 //x=45.26 //y=0.18 //x2=45.26 //y2=0.18
r1442 (  77 79 ) resistor r=0.446141 //w=0.311 //l=1.11 //layer=m1 \
 //thickness=0.36 //x=45.26 //y=0.175 //x2=46.37 //y2=0.175
r1443 (  75 314 ) resistor r=3.1 //w=0.17 //l=0.51 //layer=mcon //count=3 \
 //x=43.78 //y=0.18 //x2=43.78 //y2=0.18
r1444 (  75 77 ) resistor r=0.594855 //w=0.311 //l=1.48 //layer=m1 \
 //thickness=0.36 //x=43.78 //y=0.175 //x2=45.26 //y2=0.175
r1445 (  72 312 ) resistor r=3.1 //w=0.17 //l=0.51 //layer=mcon //count=3 \
 //x=42.67 //y=0.18 //x2=42.67 //y2=0.18
r1446 (  70 304 ) resistor r=3.1 //w=0.17 //l=0.51 //layer=mcon //count=3 \
 //x=41.56 //y=0.18 //x2=41.56 //y2=0.18
r1447 (  70 72 ) resistor r=0.446141 //w=0.311 //l=1.11 //layer=m1 \
 //thickness=0.36 //x=41.56 //y=0.175 //x2=42.67 //y2=0.175
r1448 (  68 298 ) resistor r=3.1 //w=0.17 //l=0.51 //layer=mcon //count=3 \
 //x=40.08 //y=0.18 //x2=40.08 //y2=0.18
r1449 (  68 70 ) resistor r=0.594855 //w=0.311 //l=1.48 //layer=m1 \
 //thickness=0.36 //x=40.08 //y=0.175 //x2=41.56 //y2=0.175
r1450 (  66 521 ) resistor r=3.1 //w=0.17 //l=0.51 //layer=mcon //count=3 \
 //x=38.97 //y=0.18 //x2=38.97 //y2=0.18
r1451 (  66 68 ) resistor r=0.446141 //w=0.311 //l=1.11 //layer=m1 \
 //thickness=0.36 //x=38.97 //y=0.175 //x2=40.08 //y2=0.175
r1452 (  64 286 ) resistor r=3.1 //w=0.17 //l=0.51 //layer=mcon //count=3 \
 //x=37.49 //y=0.18 //x2=37.49 //y2=0.18
r1453 (  64 66 ) resistor r=0.594855 //w=0.311 //l=1.48 //layer=m1 \
 //thickness=0.36 //x=37.49 //y=0.175 //x2=38.97 //y2=0.175
r1454 (  62 284 ) resistor r=3.1 //w=0.17 //l=0.51 //layer=mcon //count=3 \
 //x=36.38 //y=0.18 //x2=36.38 //y2=0.18
r1455 (  62 64 ) resistor r=0.446141 //w=0.311 //l=1.11 //layer=m1 \
 //thickness=0.36 //x=36.38 //y=0.175 //x2=37.49 //y2=0.175
r1456 (  60 282 ) resistor r=3.1 //w=0.17 //l=0.51 //layer=mcon //count=3 \
 //x=35.27 //y=0.18 //x2=35.27 //y2=0.18
r1457 (  60 62 ) resistor r=0.446141 //w=0.311 //l=1.11 //layer=m1 \
 //thickness=0.36 //x=35.27 //y=0.175 //x2=36.38 //y2=0.175
r1458 (  58 518 ) resistor r=3.1 //w=0.17 //l=0.51 //layer=mcon //count=3 \
 //x=34.16 //y=0.18 //x2=34.16 //y2=0.18
r1459 (  58 60 ) resistor r=0.446141 //w=0.311 //l=1.11 //layer=m1 \
 //thickness=0.36 //x=34.16 //y=0.175 //x2=35.27 //y2=0.175
r1460 (  56 270 ) resistor r=3.1 //w=0.17 //l=0.51 //layer=mcon //count=3 \
 //x=32.68 //y=0.18 //x2=32.68 //y2=0.18
r1461 (  56 58 ) resistor r=0.594855 //w=0.311 //l=1.48 //layer=m1 \
 //thickness=0.36 //x=32.68 //y=0.175 //x2=34.16 //y2=0.175
r1462 (  54 268 ) resistor r=3.1 //w=0.17 //l=0.51 //layer=mcon //count=3 \
 //x=31.57 //y=0.18 //x2=31.57 //y2=0.18
r1463 (  54 56 ) resistor r=0.446141 //w=0.311 //l=1.11 //layer=m1 \
 //thickness=0.36 //x=31.57 //y=0.175 //x2=32.68 //y2=0.175
r1464 (  52 266 ) resistor r=3.1 //w=0.17 //l=0.51 //layer=mcon //count=3 \
 //x=30.46 //y=0.18 //x2=30.46 //y2=0.18
r1465 (  52 54 ) resistor r=0.446141 //w=0.311 //l=1.11 //layer=m1 \
 //thickness=0.36 //x=30.46 //y=0.175 //x2=31.57 //y2=0.175
r1466 (  50 515 ) resistor r=3.1 //w=0.17 //l=0.51 //layer=mcon //count=3 \
 //x=29.35 //y=0.18 //x2=29.35 //y2=0.18
r1467 (  50 52 ) resistor r=0.446141 //w=0.311 //l=1.11 //layer=m1 \
 //thickness=0.36 //x=29.35 //y=0.175 //x2=30.46 //y2=0.175
r1468 (  48 254 ) resistor r=3.1 //w=0.17 //l=0.51 //layer=mcon //count=3 \
 //x=27.87 //y=0.18 //x2=27.87 //y2=0.18
r1469 (  48 50 ) resistor r=0.594855 //w=0.311 //l=1.48 //layer=m1 \
 //thickness=0.36 //x=27.87 //y=0.175 //x2=29.35 //y2=0.175
r1470 (  46 252 ) resistor r=3.1 //w=0.17 //l=0.51 //layer=mcon //count=3 \
 //x=26.76 //y=0.18 //x2=26.76 //y2=0.18
r1471 (  46 48 ) resistor r=0.446141 //w=0.311 //l=1.11 //layer=m1 \
 //thickness=0.36 //x=26.76 //y=0.175 //x2=27.87 //y2=0.175
r1472 (  44 244 ) resistor r=3.1 //w=0.17 //l=0.51 //layer=mcon //count=3 \
 //x=25.65 //y=0.18 //x2=25.65 //y2=0.18
r1473 (  44 46 ) resistor r=0.446141 //w=0.311 //l=1.11 //layer=m1 \
 //thickness=0.36 //x=25.65 //y=0.175 //x2=26.76 //y2=0.175
r1474 (  42 238 ) resistor r=3.1 //w=0.17 //l=0.51 //layer=mcon //count=3 \
 //x=24.17 //y=0.18 //x2=24.17 //y2=0.18
r1475 (  42 44 ) resistor r=0.594855 //w=0.311 //l=1.48 //layer=m1 \
 //thickness=0.36 //x=24.17 //y=0.175 //x2=25.65 //y2=0.175
r1476 (  40 236 ) resistor r=3.1 //w=0.17 //l=0.51 //layer=mcon //count=3 \
 //x=23.06 //y=0.18 //x2=23.06 //y2=0.18
r1477 (  40 42 ) resistor r=0.446141 //w=0.311 //l=1.11 //layer=m1 \
 //thickness=0.36 //x=23.06 //y=0.175 //x2=24.17 //y2=0.175
r1478 (  38 234 ) resistor r=3.1 //w=0.17 //l=0.51 //layer=mcon //count=3 \
 //x=21.95 //y=0.18 //x2=21.95 //y2=0.18
r1479 (  38 40 ) resistor r=0.446141 //w=0.311 //l=1.11 //layer=m1 \
 //thickness=0.36 //x=21.95 //y=0.175 //x2=23.06 //y2=0.175
r1480 (  36 226 ) resistor r=3.1 //w=0.17 //l=0.51 //layer=mcon //count=3 \
 //x=20.84 //y=0.18 //x2=20.84 //y2=0.18
r1481 (  36 38 ) resistor r=0.446141 //w=0.311 //l=1.11 //layer=m1 \
 //thickness=0.36 //x=20.84 //y=0.175 //x2=21.95 //y2=0.175
r1482 (  34 220 ) resistor r=3.1 //w=0.17 //l=0.51 //layer=mcon //count=3 \
 //x=19.36 //y=0.18 //x2=19.36 //y2=0.18
r1483 (  34 36 ) resistor r=0.594855 //w=0.311 //l=1.48 //layer=m1 \
 //thickness=0.36 //x=19.36 //y=0.175 //x2=20.84 //y2=0.175
r1484 (  32 218 ) resistor r=3.1 //w=0.17 //l=0.51 //layer=mcon //count=3 \
 //x=18.25 //y=0.18 //x2=18.25 //y2=0.18
r1485 (  32 34 ) resistor r=0.446141 //w=0.311 //l=1.11 //layer=m1 \
 //thickness=0.36 //x=18.25 //y=0.175 //x2=19.36 //y2=0.175
r1486 (  30 210 ) resistor r=3.1 //w=0.17 //l=0.51 //layer=mcon //count=3 \
 //x=17.14 //y=0.18 //x2=17.14 //y2=0.18
r1487 (  30 32 ) resistor r=0.446141 //w=0.311 //l=1.11 //layer=m1 \
 //thickness=0.36 //x=17.14 //y=0.175 //x2=18.25 //y2=0.175
r1488 (  28 204 ) resistor r=3.1 //w=0.17 //l=0.51 //layer=mcon //count=3 \
 //x=15.66 //y=0.18 //x2=15.66 //y2=0.18
r1489 (  28 30 ) resistor r=0.594855 //w=0.311 //l=1.48 //layer=m1 \
 //thickness=0.36 //x=15.66 //y=0.175 //x2=17.14 //y2=0.175
r1490 (  26 506 ) resistor r=3.1 //w=0.17 //l=0.51 //layer=mcon //count=3 \
 //x=14.55 //y=0.18 //x2=14.55 //y2=0.18
r1491 (  26 28 ) resistor r=0.446141 //w=0.311 //l=1.11 //layer=m1 \
 //thickness=0.36 //x=14.55 //y=0.175 //x2=15.66 //y2=0.175
r1492 (  24 192 ) resistor r=3.1 //w=0.17 //l=0.51 //layer=mcon //count=3 \
 //x=13.07 //y=0.18 //x2=13.07 //y2=0.18
r1493 (  24 26 ) resistor r=0.594855 //w=0.311 //l=1.48 //layer=m1 \
 //thickness=0.36 //x=13.07 //y=0.175 //x2=14.55 //y2=0.175
r1494 (  22 190 ) resistor r=3.1 //w=0.17 //l=0.51 //layer=mcon //count=3 \
 //x=11.96 //y=0.18 //x2=11.96 //y2=0.18
r1495 (  22 24 ) resistor r=0.446141 //w=0.311 //l=1.11 //layer=m1 \
 //thickness=0.36 //x=11.96 //y=0.175 //x2=13.07 //y2=0.175
r1496 (  20 188 ) resistor r=3.1 //w=0.17 //l=0.51 //layer=mcon //count=3 \
 //x=10.85 //y=0.18 //x2=10.85 //y2=0.18
r1497 (  20 22 ) resistor r=0.446141 //w=0.311 //l=1.11 //layer=m1 \
 //thickness=0.36 //x=10.85 //y=0.175 //x2=11.96 //y2=0.175
r1498 (  18 503 ) resistor r=3.1 //w=0.17 //l=0.51 //layer=mcon //count=3 \
 //x=9.74 //y=0.18 //x2=9.74 //y2=0.18
r1499 (  18 20 ) resistor r=0.446141 //w=0.311 //l=1.11 //layer=m1 \
 //thickness=0.36 //x=9.74 //y=0.175 //x2=10.85 //y2=0.175
r1500 (  16 176 ) resistor r=3.1 //w=0.17 //l=0.51 //layer=mcon //count=3 \
 //x=8.26 //y=0.18 //x2=8.26 //y2=0.18
r1501 (  16 18 ) resistor r=0.594855 //w=0.311 //l=1.48 //layer=m1 \
 //thickness=0.36 //x=8.26 //y=0.175 //x2=9.74 //y2=0.175
r1502 (  14 174 ) resistor r=3.1 //w=0.17 //l=0.51 //layer=mcon //count=3 \
 //x=7.15 //y=0.18 //x2=7.15 //y2=0.18
r1503 (  14 16 ) resistor r=0.446141 //w=0.311 //l=1.11 //layer=m1 \
 //thickness=0.36 //x=7.15 //y=0.175 //x2=8.26 //y2=0.175
r1504 (  12 172 ) resistor r=3.1 //w=0.17 //l=0.51 //layer=mcon //count=3 \
 //x=6.04 //y=0.18 //x2=6.04 //y2=0.18
r1505 (  12 14 ) resistor r=0.446141 //w=0.311 //l=1.11 //layer=m1 \
 //thickness=0.36 //x=6.04 //y=0.175 //x2=7.15 //y2=0.175
r1506 (  10 500 ) resistor r=3.1 //w=0.17 //l=0.51 //layer=mcon //count=3 \
 //x=4.93 //y=0.18 //x2=4.93 //y2=0.18
r1507 (  10 12 ) resistor r=0.446141 //w=0.311 //l=1.11 //layer=m1 \
 //thickness=0.36 //x=4.93 //y=0.175 //x2=6.04 //y2=0.175
r1508 (  8 160 ) resistor r=3.1 //w=0.17 //l=0.51 //layer=mcon //count=3 \
 //x=3.45 //y=0.18 //x2=3.45 //y2=0.18
r1509 (  8 10 ) resistor r=0.594855 //w=0.311 //l=1.48 //layer=m1 \
 //thickness=0.36 //x=3.45 //y=0.175 //x2=4.93 //y2=0.175
r1510 (  6 158 ) resistor r=3.1 //w=0.17 //l=0.51 //layer=mcon //count=3 \
 //x=2.34 //y=0.18 //x2=2.34 //y2=0.18
r1511 (  6 8 ) resistor r=0.446141 //w=0.311 //l=1.11 //layer=m1 \
 //thickness=0.36 //x=2.34 //y=0.175 //x2=3.45 //y2=0.175
r1512 (  3 150 ) resistor r=3.1 //w=0.17 //l=0.51 //layer=mcon //count=3 \
 //x=1.23 //y=0.18 //x2=1.23 //y2=0.18
r1513 (  3 6 ) resistor r=0.446141 //w=0.311 //l=1.11 //layer=m1 \
 //thickness=0.36 //x=1.23 //y=0.175 //x2=2.34 //y2=0.175
r1514 (  1 75 ) resistor r=0.223071 //w=0.311 //l=0.555 //layer=m1 \
 //thickness=0.36 //x=43.225 //y=0.175 //x2=43.78 //y2=0.175
r1515 (  1 72 ) resistor r=0.223071 //w=0.311 //l=0.555 //layer=m1 \
 //thickness=0.36 //x=43.225 //y=0.175 //x2=42.67 //y2=0.175
ends PM_TMRDFFSNQX1\%GND

subckt PM_TMRDFFSNQX1\%VDD ( 1 143 155 163 173 179 187 195 205 215 221 229 237 \
 247 257 263 271 281 291 295 305 315 323 327 337 347 355 365 371 379 387 397 \
 403 411 419 429 439 445 453 461 471 481 487 495 505 515 519 529 539 547 551 \
 561 571 579 589 595 603 611 621 627 635 643 653 663 669 677 685 695 705 711 \
 719 729 739 743 753 763 771 775 785 795 803 813 819 827 835 845 851 859 869 \
 877 890 893 899 905 909 914 919 924 930 936 940 945 950 955 961 967 971 976 \
 981 986 987 988 992 993 994 995 996 997 998 999 1000 1001 1002 1003 1004 1005 \
 1006 1007 1008 1009 1010 1011 1012 1013 1014 1015 1016 1017 1018 1019 1020 \
 1021 1022 1023 1024 1025 1026 1027 1028 1029 1030 1031 1032 1033 1034 1035 \
 1036 1037 1038 1039 1040 1041 1042 1043 1044 1045 1046 1047 1048 1049 1050 \
 1051 1052 1053 1054 1055 1056 1057 1058 1059 1060 )
c1105 ( 1060 0 ) capacitor c=0.0451938f //x=85.15 //y=5.2
c1106 ( 1059 0 ) capacitor c=0.0420334f //x=84.28 //y=5.2
c1107 ( 1058 0 ) capacitor c=0.0476809f //x=76.155 //y=5.205
c1108 ( 1057 0 ) capacitor c=0.0241715f //x=75.275 //y=5.205
c1109 ( 1056 0 ) capacitor c=0.0467094f //x=74.405 //y=5.205
c1110 ( 1055 0 ) capacitor c=0.045218f //x=72.525 //y=5.2
c1111 ( 1054 0 ) capacitor c=0.0241521f //x=71.645 //y=5.2
c1112 ( 1053 0 ) capacitor c=0.0241521f //x=70.765 //y=5.2
c1113 ( 1052 0 ) capacitor c=0.0530764f //x=69.895 //y=5.2
c1114 ( 1051 0 ) capacitor c=0.0379509f //x=68.015 //y=5.2
c1115 ( 1050 0 ) capacitor c=0.0241089f //x=67.135 //y=5.2
c1116 ( 1049 0 ) capacitor c=0.0493661f //x=66.265 //y=5.2
c1117 ( 1048 0 ) capacitor c=0.0381506f //x=64.685 //y=5.2
c1118 ( 1047 0 ) capacitor c=0.0240074f //x=63.805 //y=5.2
c1119 ( 1046 0 ) capacitor c=0.0492093f //x=62.935 //y=5.2
c1120 ( 1045 0 ) capacitor c=0.045218f //x=61.055 //y=5.2
c1121 ( 1044 0 ) capacitor c=0.0241521f //x=60.175 //y=5.2
c1122 ( 1043 0 ) capacitor c=0.0241521f //x=59.295 //y=5.2
c1123 ( 1042 0 ) capacitor c=0.053132f //x=58.425 //y=5.2
c1124 ( 1041 0 ) capacitor c=0.045218f //x=56.245 //y=5.2
c1125 ( 1040 0 ) capacitor c=0.0241521f //x=55.365 //y=5.2
c1126 ( 1039 0 ) capacitor c=0.0241521f //x=54.485 //y=5.2
c1127 ( 1038 0 ) capacitor c=0.0531894f //x=53.615 //y=5.2
c1128 ( 1037 0 ) capacitor c=0.038068f //x=51.735 //y=5.2
c1129 ( 1036 0 ) capacitor c=0.0240081f //x=50.855 //y=5.2
c1130 ( 1035 0 ) capacitor c=0.0492093f //x=49.985 //y=5.2
c1131 ( 1034 0 ) capacitor c=0.045218f //x=48.105 //y=5.2
c1132 ( 1033 0 ) capacitor c=0.0241521f //x=47.225 //y=5.2
c1133 ( 1032 0 ) capacitor c=0.0241521f //x=46.345 //y=5.2
c1134 ( 1031 0 ) capacitor c=0.0531894f //x=45.475 //y=5.2
c1135 ( 1030 0 ) capacitor c=0.038068f //x=43.595 //y=5.2
c1136 ( 1029 0 ) capacitor c=0.0240081f //x=42.715 //y=5.2
c1137 ( 1028 0 ) capacitor c=0.0490306f //x=41.845 //y=5.2
c1138 ( 1027 0 ) capacitor c=0.038068f //x=40.265 //y=5.2
c1139 ( 1026 0 ) capacitor c=0.0240074f //x=39.385 //y=5.2
c1140 ( 1025 0 ) capacitor c=0.0492093f //x=38.515 //y=5.2
c1141 ( 1024 0 ) capacitor c=0.045218f //x=36.635 //y=5.2
c1142 ( 1023 0 ) capacitor c=0.0241521f //x=35.755 //y=5.2
c1143 ( 1022 0 ) capacitor c=0.0241521f //x=34.875 //y=5.2
c1144 ( 1021 0 ) capacitor c=0.053132f //x=34.005 //y=5.2
c1145 ( 1020 0 ) capacitor c=0.045218f //x=31.825 //y=5.2
c1146 ( 1019 0 ) capacitor c=0.0241521f //x=30.945 //y=5.2
c1147 ( 1018 0 ) capacitor c=0.0241521f //x=30.065 //y=5.2
c1148 ( 1017 0 ) capacitor c=0.0531894f //x=29.195 //y=5.2
c1149 ( 1016 0 ) capacitor c=0.038068f //x=27.315 //y=5.2
c1150 ( 1015 0 ) capacitor c=0.0240081f //x=26.435 //y=5.2
c1151 ( 1014 0 ) capacitor c=0.0492093f //x=25.565 //y=5.2
c1152 ( 1013 0 ) capacitor c=0.045218f //x=23.685 //y=5.2
c1153 ( 1012 0 ) capacitor c=0.0241521f //x=22.805 //y=5.2
c1154 ( 1011 0 ) capacitor c=0.0241521f //x=21.925 //y=5.2
c1155 ( 1010 0 ) capacitor c=0.0531894f //x=21.055 //y=5.2
c1156 ( 1009 0 ) capacitor c=0.038068f //x=19.175 //y=5.2
c1157 ( 1008 0 ) capacitor c=0.0240081f //x=18.295 //y=5.2
c1158 ( 1007 0 ) capacitor c=0.0490306f //x=17.425 //y=5.2
c1159 ( 1006 0 ) capacitor c=0.038068f //x=15.845 //y=5.2
c1160 ( 1005 0 ) capacitor c=0.0240074f //x=14.965 //y=5.2
c1161 ( 1004 0 ) capacitor c=0.0492093f //x=14.095 //y=5.2
c1162 ( 1003 0 ) capacitor c=0.045218f //x=12.215 //y=5.2
c1163 ( 1002 0 ) capacitor c=0.0241521f //x=11.335 //y=5.2
c1164 ( 1001 0 ) capacitor c=0.0241521f //x=10.455 //y=5.2
c1165 ( 1000 0 ) capacitor c=0.053132f //x=9.585 //y=5.2
c1166 ( 999 0 ) capacitor c=0.045218f //x=7.405 //y=5.2
c1167 ( 998 0 ) capacitor c=0.0241521f //x=6.525 //y=5.2
c1168 ( 997 0 ) capacitor c=0.0242401f //x=5.645 //y=5.2
c1169 ( 996 0 ) capacitor c=0.0532367f //x=4.775 //y=5.2
c1170 ( 995 0 ) capacitor c=0.0381506f //x=2.895 //y=5.2
c1171 ( 994 0 ) capacitor c=0.0241853f //x=2.015 //y=5.2
c1172 ( 993 0 ) capacitor c=0.0531988f //x=1.145 //y=5.2
c1173 ( 992 0 ) capacitor c=0.253514f //x=85.22 //y=7.58
c1174 ( 990 0 ) capacitor c=0.00597439f //x=84.48 //y=7.58
c1175 ( 988 0 ) capacitor c=0.107782f //x=83.74 //y=7.585
c1176 ( 987 0 ) capacitor c=0.113453f //x=80.41 //y=7.585
c1177 ( 986 0 ) capacitor c=0.121185f //x=77.08 //y=7.585
c1178 ( 985 0 ) capacitor c=0.00597439f //x=76.3 //y=7.585
c1179 ( 984 0 ) capacitor c=0.00597439f //x=75.42 //y=7.585
c1180 ( 983 0 ) capacitor c=0.00597439f //x=74.49 //y=7.58
c1181 ( 981 0 ) capacitor c=0.136786f //x=73.75 //y=7.585
c1182 ( 980 0 ) capacitor c=0.00597439f //x=72.67 //y=7.585
c1183 ( 979 0 ) capacitor c=0.00597439f //x=71.79 //y=7.585
c1184 ( 978 0 ) capacitor c=0.00597439f //x=70.91 //y=7.585
c1185 ( 977 0 ) capacitor c=0.00597439f //x=70.03 //y=7.585
c1186 ( 976 0 ) capacitor c=0.137593f //x=68.94 //y=7.585
c1187 ( 975 0 ) capacitor c=0.00597439f //x=68.2 //y=7.58
c1188 ( 973 0 ) capacitor c=0.00597439f //x=67.28 //y=7.585
c1189 ( 972 0 ) capacitor c=0.00597439f //x=66.4 //y=7.585
c1190 ( 971 0 ) capacitor c=0.115718f //x=65.61 //y=7.585
c1191 ( 970 0 ) capacitor c=0.00597439f //x=64.83 //y=7.585
c1192 ( 969 0 ) capacitor c=0.00597439f //x=63.95 //y=7.585
c1193 ( 968 0 ) capacitor c=0.00597439f //x=63.07 //y=7.585
c1194 ( 967 0 ) capacitor c=0.134644f //x=62.28 //y=7.585
c1195 ( 966 0 ) capacitor c=0.00597439f //x=61.2 //y=7.585
c1196 ( 965 0 ) capacitor c=0.00597439f //x=60.32 //y=7.585
c1197 ( 964 0 ) capacitor c=0.00597439f //x=59.44 //y=7.585
c1198 ( 963 0 ) capacitor c=0.00597439f //x=58.58 //y=7.58
c1199 ( 961 0 ) capacitor c=0.155205f //x=57.47 //y=7.585
c1200 ( 960 0 ) capacitor c=0.00597439f //x=56.39 //y=7.585
c1201 ( 959 0 ) capacitor c=0.00597439f //x=55.51 //y=7.585
c1202 ( 958 0 ) capacitor c=0.00597439f //x=54.63 //y=7.585
c1203 ( 957 0 ) capacitor c=0.00597439f //x=53.77 //y=7.58
c1204 ( 955 0 ) capacitor c=0.13534f //x=52.66 //y=7.585
c1205 ( 954 0 ) capacitor c=0.00597439f //x=51.88 //y=7.585
c1206 ( 953 0 ) capacitor c=0.00597439f //x=51 //y=7.585
c1207 ( 952 0 ) capacitor c=0.00597439f //x=50.07 //y=7.58
c1208 ( 950 0 ) capacitor c=0.138873f //x=49.33 //y=7.585
c1209 ( 949 0 ) capacitor c=0.00597439f //x=48.25 //y=7.585
c1210 ( 948 0 ) capacitor c=0.00597439f //x=47.37 //y=7.585
c1211 ( 947 0 ) capacitor c=0.00597439f //x=46.49 //y=7.585
c1212 ( 946 0 ) capacitor c=0.00597439f //x=45.61 //y=7.585
c1213 ( 945 0 ) capacitor c=0.135232f //x=44.52 //y=7.585
c1214 ( 944 0 ) capacitor c=0.00597439f //x=43.78 //y=7.58
c1215 ( 942 0 ) capacitor c=0.00597439f //x=42.86 //y=7.585
c1216 ( 941 0 ) capacitor c=0.00597439f //x=41.98 //y=7.585
c1217 ( 940 0 ) capacitor c=0.114443f //x=41.19 //y=7.585
c1218 ( 939 0 ) capacitor c=0.00597439f //x=40.41 //y=7.585
c1219 ( 938 0 ) capacitor c=0.00597439f //x=39.53 //y=7.585
c1220 ( 937 0 ) capacitor c=0.00597439f //x=38.65 //y=7.585
c1221 ( 936 0 ) capacitor c=0.134644f //x=37.86 //y=7.585
c1222 ( 935 0 ) capacitor c=0.00597439f //x=36.78 //y=7.585
c1223 ( 934 0 ) capacitor c=0.00597439f //x=35.9 //y=7.585
c1224 ( 933 0 ) capacitor c=0.00597439f //x=35.02 //y=7.585
c1225 ( 932 0 ) capacitor c=0.00597439f //x=34.16 //y=7.58
c1226 ( 930 0 ) capacitor c=0.155205f //x=33.05 //y=7.585
c1227 ( 929 0 ) capacitor c=0.00597439f //x=31.97 //y=7.585
c1228 ( 928 0 ) capacitor c=0.00597439f //x=31.09 //y=7.585
c1229 ( 927 0 ) capacitor c=0.00597439f //x=30.21 //y=7.585
c1230 ( 926 0 ) capacitor c=0.00597439f //x=29.35 //y=7.58
c1231 ( 924 0 ) capacitor c=0.13534f //x=28.24 //y=7.585
c1232 ( 923 0 ) capacitor c=0.00597439f //x=27.46 //y=7.585
c1233 ( 922 0 ) capacitor c=0.00597439f //x=26.58 //y=7.585
c1234 ( 921 0 ) capacitor c=0.00597439f //x=25.65 //y=7.58
c1235 ( 919 0 ) capacitor c=0.139148f //x=24.91 //y=7.585
c1236 ( 918 0 ) capacitor c=0.00597439f //x=23.83 //y=7.585
c1237 ( 917 0 ) capacitor c=0.00597439f //x=22.95 //y=7.585
c1238 ( 916 0 ) capacitor c=0.00597439f //x=22.07 //y=7.585
c1239 ( 915 0 ) capacitor c=0.00597439f //x=21.19 //y=7.585
c1240 ( 914 0 ) capacitor c=0.135074f //x=20.1 //y=7.585
c1241 ( 913 0 ) capacitor c=0.00597439f //x=19.36 //y=7.58
c1242 ( 911 0 ) capacitor c=0.00597439f //x=18.44 //y=7.585
c1243 ( 910 0 ) capacitor c=0.00597439f //x=17.56 //y=7.585
c1244 ( 909 0 ) capacitor c=0.114443f //x=16.77 //y=7.585
c1245 ( 908 0 ) capacitor c=0.00597439f //x=15.99 //y=7.585
c1246 ( 907 0 ) capacitor c=0.00597439f //x=15.11 //y=7.585
c1247 ( 906 0 ) capacitor c=0.00597439f //x=14.23 //y=7.585
c1248 ( 905 0 ) capacitor c=0.134644f //x=13.44 //y=7.585
c1249 ( 904 0 ) capacitor c=0.00597439f //x=12.36 //y=7.585
c1250 ( 903 0 ) capacitor c=0.00597439f //x=11.48 //y=7.585
c1251 ( 902 0 ) capacitor c=0.00597439f //x=10.6 //y=7.585
c1252 ( 901 0 ) capacitor c=0.00597439f //x=9.74 //y=7.58
c1253 ( 899 0 ) capacitor c=0.155205f //x=8.63 //y=7.585
c1254 ( 898 0 ) capacitor c=0.00597439f //x=7.55 //y=7.585
c1255 ( 897 0 ) capacitor c=0.00597439f //x=6.67 //y=7.585
c1256 ( 896 0 ) capacitor c=0.00597439f //x=5.79 //y=7.585
c1257 ( 895 0 ) capacitor c=0.00597439f //x=4.93 //y=7.58
c1258 ( 893 0 ) capacitor c=0.137421f //x=3.82 //y=7.585
c1259 ( 892 0 ) capacitor c=0.00597439f //x=3.04 //y=7.585
c1260 ( 891 0 ) capacitor c=0.00597439f //x=2.16 //y=7.585
c1261 ( 890 0 ) capacitor c=0.267249f //x=1.23 //y=7.58
c1262 ( 877 0 ) capacitor c=0.0290557f //x=85.21 //y=7.585
c1263 ( 869 0 ) capacitor c=0.0187886f //x=84.33 //y=7.585
c1264 ( 859 0 ) capacitor c=0.122205f //x=83.57 //y=7.585
c1265 ( 851 0 ) capacitor c=0.122102f //x=80.24 //y=7.585
c1266 ( 845 0 ) capacitor c=0.0238235f //x=76.91 //y=7.585
c1267 ( 835 0 ) capacitor c=0.0288071f //x=76.215 //y=7.585
c1268 ( 827 0 ) capacitor c=0.0287754f //x=75.335 //y=7.585
c1269 ( 819 0 ) capacitor c=0.024303f //x=74.455 //y=7.585
c1270 ( 813 0 ) capacitor c=0.0397701f //x=73.58 //y=7.585
c1271 ( 803 0 ) capacitor c=0.0291138f //x=72.585 //y=7.585
c1272 ( 795 0 ) capacitor c=0.0290172f //x=71.705 //y=7.585
c1273 ( 785 0 ) capacitor c=0.0287649f //x=70.825 //y=7.585
c1274 ( 775 0 ) capacitor c=0.0386886f //x=69.945 //y=7.585
c1275 ( 771 0 ) capacitor c=0.0239456f //x=68.77 //y=7.585
c1276 ( 763 0 ) capacitor c=0.0291007f //x=68.075 //y=7.585
c1277 ( 753 0 ) capacitor c=0.029371f //x=67.195 //y=7.585
c1278 ( 743 0 ) capacitor c=0.024303f //x=66.315 //y=7.585
c1279 ( 739 0 ) capacitor c=0.0238235f //x=65.44 //y=7.585
c1280 ( 729 0 ) capacitor c=0.0291247f //x=64.745 //y=7.585
c1281 ( 719 0 ) capacitor c=0.0291028f //x=63.865 //y=7.585
c1282 ( 711 0 ) capacitor c=0.024303f //x=62.985 //y=7.585
c1283 ( 705 0 ) capacitor c=0.0397734f //x=62.11 //y=7.585
c1284 ( 695 0 ) capacitor c=0.0291138f //x=61.115 //y=7.585
c1285 ( 685 0 ) capacitor c=0.0290172f //x=60.235 //y=7.585
c1286 ( 677 0 ) capacitor c=0.0287649f //x=59.355 //y=7.585
c1287 ( 669 0 ) capacitor c=0.0386886f //x=58.475 //y=7.585
c1288 ( 663 0 ) capacitor c=0.0397734f //x=57.3 //y=7.585
c1289 ( 653 0 ) capacitor c=0.0291138f //x=56.305 //y=7.585
c1290 ( 643 0 ) capacitor c=0.0290163f //x=55.425 //y=7.585
c1291 ( 635 0 ) capacitor c=0.0287649f //x=54.545 //y=7.585
c1292 ( 627 0 ) capacitor c=0.0386886f //x=53.665 //y=7.585
c1293 ( 621 0 ) capacitor c=0.0238235f //x=52.49 //y=7.585
c1294 ( 611 0 ) capacitor c=0.0291008f //x=51.795 //y=7.585
c1295 ( 603 0 ) capacitor c=0.0291028f //x=50.915 //y=7.585
c1296 ( 595 0 ) capacitor c=0.024303f //x=50.035 //y=7.585
c1297 ( 589 0 ) capacitor c=0.0397734f //x=49.16 //y=7.585
c1298 ( 579 0 ) capacitor c=0.0291138f //x=48.165 //y=7.585
c1299 ( 571 0 ) capacitor c=0.0290172f //x=47.285 //y=7.585
c1300 ( 561 0 ) capacitor c=0.0287649f //x=46.405 //y=7.585
c1301 ( 551 0 ) capacitor c=0.0386886f //x=45.525 //y=7.585
c1302 ( 547 0 ) capacitor c=0.0238235f //x=44.35 //y=7.585
c1303 ( 539 0 ) capacitor c=0.0291008f //x=43.655 //y=7.585
c1304 ( 529 0 ) capacitor c=0.0291028f //x=42.775 //y=7.585
c1305 ( 519 0 ) capacitor c=0.024303f //x=41.895 //y=7.585
c1306 ( 515 0 ) capacitor c=0.0238235f //x=41.02 //y=7.585
c1307 ( 505 0 ) capacitor c=0.0291007f //x=40.325 //y=7.585
c1308 ( 495 0 ) capacitor c=0.0291028f //x=39.445 //y=7.585
c1309 ( 487 0 ) capacitor c=0.024303f //x=38.565 //y=7.585
c1310 ( 481 0 ) capacitor c=0.0397734f //x=37.69 //y=7.585
c1311 ( 471 0 ) capacitor c=0.0291138f //x=36.695 //y=7.585
c1312 ( 461 0 ) capacitor c=0.0290172f //x=35.815 //y=7.585
c1313 ( 453 0 ) capacitor c=0.0287649f //x=34.935 //y=7.585
c1314 ( 445 0 ) capacitor c=0.0386886f //x=34.055 //y=7.585
c1315 ( 439 0 ) capacitor c=0.0397734f //x=32.88 //y=7.585
c1316 ( 429 0 ) capacitor c=0.0291138f //x=31.885 //y=7.585
c1317 ( 419 0 ) capacitor c=0.0290163f //x=31.005 //y=7.585
c1318 ( 411 0 ) capacitor c=0.0287649f //x=30.125 //y=7.585
c1319 ( 403 0 ) capacitor c=0.0386886f //x=29.245 //y=7.585
c1320 ( 397 0 ) capacitor c=0.0238235f //x=28.07 //y=7.585
c1321 ( 387 0 ) capacitor c=0.0291008f //x=27.375 //y=7.585
c1322 ( 379 0 ) capacitor c=0.0291028f //x=26.495 //y=7.585
c1323 ( 371 0 ) capacitor c=0.024303f //x=25.615 //y=7.585
c1324 ( 365 0 ) capacitor c=0.0397734f //x=24.74 //y=7.585
c1325 ( 355 0 ) capacitor c=0.0291138f //x=23.745 //y=7.585
c1326 ( 347 0 ) capacitor c=0.0290172f //x=22.865 //y=7.585
c1327 ( 337 0 ) capacitor c=0.0287649f //x=21.985 //y=7.585
c1328 ( 327 0 ) capacitor c=0.0386886f //x=21.105 //y=7.585
c1329 ( 323 0 ) capacitor c=0.0238235f //x=19.93 //y=7.585
c1330 ( 315 0 ) capacitor c=0.0291008f //x=19.235 //y=7.585
c1331 ( 305 0 ) capacitor c=0.0291028f //x=18.355 //y=7.585
c1332 ( 295 0 ) capacitor c=0.024303f //x=17.475 //y=7.585
c1333 ( 291 0 ) capacitor c=0.0238235f //x=16.6 //y=7.585
c1334 ( 281 0 ) capacitor c=0.0291007f //x=15.905 //y=7.585
c1335 ( 271 0 ) capacitor c=0.0291028f //x=15.025 //y=7.585
c1336 ( 263 0 ) capacitor c=0.024303f //x=14.145 //y=7.585
c1337 ( 257 0 ) capacitor c=0.0397734f //x=13.27 //y=7.585
c1338 ( 247 0 ) capacitor c=0.0291138f //x=12.275 //y=7.585
c1339 ( 237 0 ) capacitor c=0.0290172f //x=11.395 //y=7.585
c1340 ( 229 0 ) capacitor c=0.0287649f //x=10.515 //y=7.585
c1341 ( 221 0 ) capacitor c=0.0386886f //x=9.635 //y=7.585
c1342 ( 215 0 ) capacitor c=0.0397734f //x=8.46 //y=7.585
c1343 ( 205 0 ) capacitor c=0.0291138f //x=7.465 //y=7.585
c1344 ( 195 0 ) capacitor c=0.0290163f //x=6.585 //y=7.585
c1345 ( 187 0 ) capacitor c=0.0287792f //x=5.705 //y=7.585
c1346 ( 179 0 ) capacitor c=0.0386886f //x=4.825 //y=7.585
c1347 ( 173 0 ) capacitor c=0.0238235f //x=3.65 //y=7.585
c1348 ( 163 0 ) capacitor c=0.0291286f //x=2.955 //y=7.585
c1349 ( 155 0 ) capacitor c=0.0289072f //x=2.075 //y=7.585
c1350 ( 143 0 ) capacitor c=2.85929f //x=85.22 //y=7.58
r1351 (  879 992 ) resistor r=4.23183 //w=0.7 //l=0.175 //layer=li \
 //thickness=0.1 //x=85.295 //y=7.41 //x2=85.295 //y2=7.585
r1352 (  879 1060 ) resistor r=56.4706 //w=0.187 //l=0.825 //layer=li \
 //thickness=0.1 //x=85.295 //y=7.41 //x2=85.295 //y2=6.585
r1353 (  878 990 ) resistor r=2.87058 //w=0.35 //l=0.085 //layer=li \
 //thickness=0.1 //x=84.5 //y=7.585 //x2=84.415 //y2=7.585
r1354 (  877 992 ) resistor r=2.87058 //w=0.35 //l=0.085 //layer=li \
 //thickness=0.1 //x=85.21 //y=7.585 //x2=85.295 //y2=7.585
r1355 (  877 878 ) resistor r=24.7629 //w=0.367 //l=0.71 //layer=li \
 //thickness=0.1 //x=85.21 //y=7.585 //x2=84.5 //y2=7.585
r1356 (  871 990 ) resistor r=4.23183 //w=0.7 //l=0.175 //layer=li \
 //thickness=0.1 //x=84.415 //y=7.41 //x2=84.415 //y2=7.585
r1357 (  871 1059 ) resistor r=56.4706 //w=0.187 //l=0.825 //layer=li \
 //thickness=0.1 //x=84.415 //y=7.41 //x2=84.415 //y2=6.585
r1358 (  870 988 ) resistor r=5.29055 //w=0.35 //l=0.17 //layer=li \
 //thickness=0.1 //x=83.91 //y=7.585 //x2=83.74 //y2=7.585
r1359 (  869 990 ) resistor r=2.87058 //w=0.35 //l=0.085 //layer=li \
 //thickness=0.1 //x=84.33 //y=7.585 //x2=84.415 //y2=7.585
r1360 (  869 870 ) resistor r=14.6485 //w=0.367 //l=0.42 //layer=li \
 //thickness=0.1 //x=84.33 //y=7.585 //x2=83.91 //y2=7.585
r1361 (  864 866 ) resistor r=38.7139 //w=0.367 //l=1.11 //layer=li \
 //thickness=0.1 //x=81.89 //y=7.585 //x2=83 //y2=7.585
r1362 (  862 864 ) resistor r=38.7139 //w=0.367 //l=1.11 //layer=li \
 //thickness=0.1 //x=80.78 //y=7.585 //x2=81.89 //y2=7.585
r1363 (  860 987 ) resistor r=5.29055 //w=0.35 //l=0.17 //layer=li \
 //thickness=0.1 //x=80.58 //y=7.585 //x2=80.41 //y2=7.585
r1364 (  860 862 ) resistor r=6.97548 //w=0.367 //l=0.2 //layer=li \
 //thickness=0.1 //x=80.58 //y=7.585 //x2=80.78 //y2=7.585
r1365 (  859 988 ) resistor r=5.29055 //w=0.35 //l=0.17 //layer=li \
 //thickness=0.1 //x=83.57 //y=7.585 //x2=83.74 //y2=7.585
r1366 (  859 866 ) resistor r=19.8801 //w=0.367 //l=0.57 //layer=li \
 //thickness=0.1 //x=83.57 //y=7.585 //x2=83 //y2=7.585
r1367 (  854 856 ) resistor r=38.7139 //w=0.367 //l=1.11 //layer=li \
 //thickness=0.1 //x=78.19 //y=7.585 //x2=79.3 //y2=7.585
r1368 (  852 986 ) resistor r=5.29055 //w=0.35 //l=0.17 //layer=li \
 //thickness=0.1 //x=77.25 //y=7.585 //x2=77.08 //y2=7.585
r1369 (  852 854 ) resistor r=32.7847 //w=0.367 //l=0.94 //layer=li \
 //thickness=0.1 //x=77.25 //y=7.585 //x2=78.19 //y2=7.585
r1370 (  851 987 ) resistor r=5.29055 //w=0.35 //l=0.17 //layer=li \
 //thickness=0.1 //x=80.24 //y=7.585 //x2=80.41 //y2=7.585
r1371 (  851 856 ) resistor r=32.7847 //w=0.367 //l=0.94 //layer=li \
 //thickness=0.1 //x=80.24 //y=7.585 //x2=79.3 //y2=7.585
r1372 (  846 985 ) resistor r=2.87058 //w=0.35 //l=0.085 //layer=li \
 //thickness=0.1 //x=76.385 //y=7.585 //x2=76.3 //y2=7.585
r1373 (  846 848 ) resistor r=11.3351 //w=0.367 //l=0.325 //layer=li \
 //thickness=0.1 //x=76.385 //y=7.585 //x2=76.71 //y2=7.585
r1374 (  845 986 ) resistor r=5.29055 //w=0.35 //l=0.17 //layer=li \
 //thickness=0.1 //x=76.91 //y=7.585 //x2=77.08 //y2=7.585
r1375 (  845 848 ) resistor r=6.97548 //w=0.367 //l=0.2 //layer=li \
 //thickness=0.1 //x=76.91 //y=7.585 //x2=76.71 //y2=7.585
r1376 (  839 985 ) resistor r=4.23183 //w=0.7 //l=0.175 //layer=li \
 //thickness=0.1 //x=76.3 //y=7.41 //x2=76.3 //y2=7.585
r1377 (  839 1058 ) resistor r=56.8128 //w=0.187 //l=0.83 //layer=li \
 //thickness=0.1 //x=76.3 //y=7.41 //x2=76.3 //y2=6.58
r1378 (  836 984 ) resistor r=2.87058 //w=0.35 //l=0.085 //layer=li \
 //thickness=0.1 //x=75.505 //y=7.585 //x2=75.42 //y2=7.585
r1379 (  836 838 ) resistor r=3.31335 //w=0.367 //l=0.095 //layer=li \
 //thickness=0.1 //x=75.505 //y=7.585 //x2=75.6 //y2=7.585
r1380 (  835 985 ) resistor r=2.87058 //w=0.35 //l=0.085 //layer=li \
 //thickness=0.1 //x=76.215 //y=7.585 //x2=76.3 //y2=7.585
r1381 (  835 838 ) resistor r=21.4496 //w=0.367 //l=0.615 //layer=li \
 //thickness=0.1 //x=76.215 //y=7.585 //x2=75.6 //y2=7.585
r1382 (  829 984 ) resistor r=4.23183 //w=0.7 //l=0.175 //layer=li \
 //thickness=0.1 //x=75.42 //y=7.41 //x2=75.42 //y2=7.585
r1383 (  829 1057 ) resistor r=33.5401 //w=0.187 //l=0.49 //layer=li \
 //thickness=0.1 //x=75.42 //y=7.41 //x2=75.42 //y2=6.92
r1384 (  828 983 ) resistor r=2.87058 //w=0.35 //l=0.085 //layer=li \
 //thickness=0.1 //x=74.625 //y=7.585 //x2=74.54 //y2=7.585
r1385 (  827 984 ) resistor r=2.87058 //w=0.35 //l=0.085 //layer=li \
 //thickness=0.1 //x=75.335 //y=7.585 //x2=75.42 //y2=7.585
r1386 (  827 828 ) resistor r=24.7629 //w=0.367 //l=0.71 //layer=li \
 //thickness=0.1 //x=75.335 //y=7.585 //x2=74.625 //y2=7.585
r1387 (  821 983 ) resistor r=4.23183 //w=0.7 //l=0.175 //layer=li \
 //thickness=0.1 //x=74.54 //y=7.41 //x2=74.54 //y2=7.585
r1388 (  821 1056 ) resistor r=56.8128 //w=0.187 //l=0.83 //layer=li \
 //thickness=0.1 //x=74.54 //y=7.41 //x2=74.54 //y2=6.58
r1389 (  820 981 ) resistor r=5.29055 //w=0.35 //l=0.17 //layer=li \
 //thickness=0.1 //x=73.92 //y=7.585 //x2=73.75 //y2=7.585
r1390 (  819 983 ) resistor r=2.87058 //w=0.35 //l=0.085 //layer=li \
 //thickness=0.1 //x=74.455 //y=7.585 //x2=74.54 //y2=7.585
r1391 (  819 820 ) resistor r=18.6594 //w=0.367 //l=0.535 //layer=li \
 //thickness=0.1 //x=74.455 //y=7.585 //x2=73.92 //y2=7.585
r1392 (  814 980 ) resistor r=2.87058 //w=0.35 //l=0.085 //layer=li \
 //thickness=0.1 //x=72.755 //y=7.585 //x2=72.67 //y2=7.585
r1393 (  814 816 ) resistor r=8.89373 //w=0.367 //l=0.255 //layer=li \
 //thickness=0.1 //x=72.755 //y=7.585 //x2=73.01 //y2=7.585
r1394 (  813 981 ) resistor r=5.29055 //w=0.35 //l=0.17 //layer=li \
 //thickness=0.1 //x=73.58 //y=7.585 //x2=73.75 //y2=7.585
r1395 (  813 816 ) resistor r=19.8801 //w=0.367 //l=0.57 //layer=li \
 //thickness=0.1 //x=73.58 //y=7.585 //x2=73.01 //y2=7.585
r1396 (  807 980 ) resistor r=4.23183 //w=0.7 //l=0.175 //layer=li \
 //thickness=0.1 //x=72.67 //y=7.41 //x2=72.67 //y2=7.585
r1397 (  807 1055 ) resistor r=33.1979 //w=0.187 //l=0.485 //layer=li \
 //thickness=0.1 //x=72.67 //y=7.41 //x2=72.67 //y2=6.925
r1398 (  804 979 ) resistor r=2.87058 //w=0.35 //l=0.085 //layer=li \
 //thickness=0.1 //x=71.875 //y=7.585 //x2=71.79 //y2=7.585
r1399 (  804 806 ) resistor r=0.871935 //w=0.367 //l=0.025 //layer=li \
 //thickness=0.1 //x=71.875 //y=7.585 //x2=71.9 //y2=7.585
r1400 (  803 980 ) resistor r=2.87058 //w=0.35 //l=0.085 //layer=li \
 //thickness=0.1 //x=72.585 //y=7.585 //x2=72.67 //y2=7.585
r1401 (  803 806 ) resistor r=23.891 //w=0.367 //l=0.685 //layer=li \
 //thickness=0.1 //x=72.585 //y=7.585 //x2=71.9 //y2=7.585
r1402 (  797 979 ) resistor r=4.23183 //w=0.7 //l=0.175 //layer=li \
 //thickness=0.1 //x=71.79 //y=7.41 //x2=71.79 //y2=7.585
r1403 (  797 1054 ) resistor r=33.1979 //w=0.187 //l=0.485 //layer=li \
 //thickness=0.1 //x=71.79 //y=7.41 //x2=71.79 //y2=6.925
r1404 (  796 978 ) resistor r=2.87058 //w=0.35 //l=0.085 //layer=li \
 //thickness=0.1 //x=70.995 //y=7.585 //x2=70.91 //y2=7.585
r1405 (  795 979 ) resistor r=2.87058 //w=0.35 //l=0.085 //layer=li \
 //thickness=0.1 //x=71.705 //y=7.585 //x2=71.79 //y2=7.585
r1406 (  795 796 ) resistor r=24.7629 //w=0.367 //l=0.71 //layer=li \
 //thickness=0.1 //x=71.705 //y=7.585 //x2=70.995 //y2=7.585
r1407 (  789 978 ) resistor r=4.23183 //w=0.7 //l=0.175 //layer=li \
 //thickness=0.1 //x=70.91 //y=7.41 //x2=70.91 //y2=7.585
r1408 (  789 1053 ) resistor r=33.1979 //w=0.187 //l=0.485 //layer=li \
 //thickness=0.1 //x=70.91 //y=7.41 //x2=70.91 //y2=6.925
r1409 (  786 977 ) resistor r=2.87058 //w=0.35 //l=0.085 //layer=li \
 //thickness=0.1 //x=70.115 //y=7.585 //x2=70.03 //y2=7.585
r1410 (  786 788 ) resistor r=23.5422 //w=0.367 //l=0.675 //layer=li \
 //thickness=0.1 //x=70.115 //y=7.585 //x2=70.79 //y2=7.585
r1411 (  785 978 ) resistor r=2.87058 //w=0.35 //l=0.085 //layer=li \
 //thickness=0.1 //x=70.825 //y=7.585 //x2=70.91 //y2=7.585
r1412 (  785 788 ) resistor r=1.22071 //w=0.367 //l=0.035 //layer=li \
 //thickness=0.1 //x=70.825 //y=7.585 //x2=70.79 //y2=7.585
r1413 (  779 977 ) resistor r=4.23183 //w=0.7 //l=0.175 //layer=li \
 //thickness=0.1 //x=70.03 //y=7.41 //x2=70.03 //y2=7.585
r1414 (  779 1052 ) resistor r=56.4706 //w=0.187 //l=0.825 //layer=li \
 //thickness=0.1 //x=70.03 //y=7.41 //x2=70.03 //y2=6.585
r1415 (  776 976 ) resistor r=5.29055 //w=0.35 //l=0.17 //layer=li \
 //thickness=0.1 //x=69.11 //y=7.585 //x2=68.94 //y2=7.585
r1416 (  776 778 ) resistor r=19.8801 //w=0.367 //l=0.57 //layer=li \
 //thickness=0.1 //x=69.11 //y=7.585 //x2=69.68 //y2=7.585
r1417 (  775 977 ) resistor r=2.87058 //w=0.35 //l=0.085 //layer=li \
 //thickness=0.1 //x=69.945 //y=7.585 //x2=70.03 //y2=7.585
r1418 (  775 778 ) resistor r=9.24251 //w=0.367 //l=0.265 //layer=li \
 //thickness=0.1 //x=69.945 //y=7.585 //x2=69.68 //y2=7.585
r1419 (  772 975 ) resistor r=2.87058 //w=0.35 //l=0.085 //layer=li \
 //thickness=0.1 //x=68.245 //y=7.585 //x2=68.16 //y2=7.585
r1420 (  771 976 ) resistor r=5.29055 //w=0.35 //l=0.17 //layer=li \
 //thickness=0.1 //x=68.77 //y=7.585 //x2=68.94 //y2=7.585
r1421 (  771 772 ) resistor r=18.3106 //w=0.367 //l=0.525 //layer=li \
 //thickness=0.1 //x=68.77 //y=7.585 //x2=68.245 //y2=7.585
r1422 (  765 975 ) resistor r=4.23183 //w=0.7 //l=0.175 //layer=li \
 //thickness=0.1 //x=68.16 //y=7.41 //x2=68.16 //y2=7.585
r1423 (  765 1051 ) resistor r=33.1979 //w=0.187 //l=0.485 //layer=li \
 //thickness=0.1 //x=68.16 //y=7.41 //x2=68.16 //y2=6.925
r1424 (  764 973 ) resistor r=2.87058 //w=0.35 //l=0.085 //layer=li \
 //thickness=0.1 //x=67.365 //y=7.585 //x2=67.28 //y2=7.585
r1425 (  763 975 ) resistor r=2.87058 //w=0.35 //l=0.085 //layer=li \
 //thickness=0.1 //x=68.075 //y=7.585 //x2=68.16 //y2=7.585
r1426 (  763 764 ) resistor r=24.7629 //w=0.367 //l=0.71 //layer=li \
 //thickness=0.1 //x=68.075 //y=7.585 //x2=67.365 //y2=7.585
r1427 (  757 973 ) resistor r=4.23183 //w=0.7 //l=0.175 //layer=li \
 //thickness=0.1 //x=67.28 //y=7.41 //x2=67.28 //y2=7.585
r1428 (  757 1050 ) resistor r=33.1979 //w=0.187 //l=0.485 //layer=li \
 //thickness=0.1 //x=67.28 //y=7.41 //x2=67.28 //y2=6.925
r1429 (  754 972 ) resistor r=2.87058 //w=0.35 //l=0.085 //layer=li \
 //thickness=0.1 //x=66.485 //y=7.585 //x2=66.4 //y2=7.585
r1430 (  754 756 ) resistor r=21.1008 //w=0.367 //l=0.605 //layer=li \
 //thickness=0.1 //x=66.485 //y=7.585 //x2=67.09 //y2=7.585
r1431 (  753 973 ) resistor r=2.87058 //w=0.35 //l=0.085 //layer=li \
 //thickness=0.1 //x=67.195 //y=7.585 //x2=67.28 //y2=7.585
r1432 (  753 756 ) resistor r=3.66213 //w=0.367 //l=0.105 //layer=li \
 //thickness=0.1 //x=67.195 //y=7.585 //x2=67.09 //y2=7.585
r1433 (  747 972 ) resistor r=4.23183 //w=0.7 //l=0.175 //layer=li \
 //thickness=0.1 //x=66.4 //y=7.41 //x2=66.4 //y2=7.585
r1434 (  747 1049 ) resistor r=56.4706 //w=0.187 //l=0.825 //layer=li \
 //thickness=0.1 //x=66.4 //y=7.41 //x2=66.4 //y2=6.585
r1435 (  744 971 ) resistor r=5.29055 //w=0.35 //l=0.17 //layer=li \
 //thickness=0.1 //x=65.78 //y=7.585 //x2=65.61 //y2=7.585
r1436 (  744 746 ) resistor r=6.97548 //w=0.367 //l=0.2 //layer=li \
 //thickness=0.1 //x=65.78 //y=7.585 //x2=65.98 //y2=7.585
r1437 (  743 972 ) resistor r=2.87058 //w=0.35 //l=0.085 //layer=li \
 //thickness=0.1 //x=66.315 //y=7.585 //x2=66.4 //y2=7.585
r1438 (  743 746 ) resistor r=11.6839 //w=0.367 //l=0.335 //layer=li \
 //thickness=0.1 //x=66.315 //y=7.585 //x2=65.98 //y2=7.585
r1439 (  740 970 ) resistor r=2.87058 //w=0.35 //l=0.085 //layer=li \
 //thickness=0.1 //x=64.915 //y=7.585 //x2=64.83 //y2=7.585
r1440 (  739 971 ) resistor r=5.29055 //w=0.35 //l=0.17 //layer=li \
 //thickness=0.1 //x=65.44 //y=7.585 //x2=65.61 //y2=7.585
r1441 (  739 740 ) resistor r=18.3106 //w=0.367 //l=0.525 //layer=li \
 //thickness=0.1 //x=65.44 //y=7.585 //x2=64.915 //y2=7.585
r1442 (  733 970 ) resistor r=4.23183 //w=0.7 //l=0.175 //layer=li \
 //thickness=0.1 //x=64.83 //y=7.41 //x2=64.83 //y2=7.585
r1443 (  733 1048 ) resistor r=33.1979 //w=0.187 //l=0.485 //layer=li \
 //thickness=0.1 //x=64.83 //y=7.41 //x2=64.83 //y2=6.925
r1444 (  730 969 ) resistor r=2.87058 //w=0.35 //l=0.085 //layer=li \
 //thickness=0.1 //x=64.035 //y=7.585 //x2=63.95 //y2=7.585
r1445 (  730 732 ) resistor r=16.218 //w=0.367 //l=0.465 //layer=li \
 //thickness=0.1 //x=64.035 //y=7.585 //x2=64.5 //y2=7.585
r1446 (  729 970 ) resistor r=2.87058 //w=0.35 //l=0.085 //layer=li \
 //thickness=0.1 //x=64.745 //y=7.585 //x2=64.83 //y2=7.585
r1447 (  729 732 ) resistor r=8.54496 //w=0.367 //l=0.245 //layer=li \
 //thickness=0.1 //x=64.745 //y=7.585 //x2=64.5 //y2=7.585
r1448 (  723 969 ) resistor r=4.23183 //w=0.7 //l=0.175 //layer=li \
 //thickness=0.1 //x=63.95 //y=7.41 //x2=63.95 //y2=7.585
r1449 (  723 1047 ) resistor r=33.1979 //w=0.187 //l=0.485 //layer=li \
 //thickness=0.1 //x=63.95 //y=7.41 //x2=63.95 //y2=6.925
r1450 (  720 968 ) resistor r=2.87058 //w=0.35 //l=0.085 //layer=li \
 //thickness=0.1 //x=63.155 //y=7.585 //x2=63.07 //y2=7.585
r1451 (  720 722 ) resistor r=8.19619 //w=0.367 //l=0.235 //layer=li \
 //thickness=0.1 //x=63.155 //y=7.585 //x2=63.39 //y2=7.585
r1452 (  719 969 ) resistor r=2.87058 //w=0.35 //l=0.085 //layer=li \
 //thickness=0.1 //x=63.865 //y=7.585 //x2=63.95 //y2=7.585
r1453 (  719 722 ) resistor r=16.5668 //w=0.367 //l=0.475 //layer=li \
 //thickness=0.1 //x=63.865 //y=7.585 //x2=63.39 //y2=7.585
r1454 (  713 968 ) resistor r=4.23183 //w=0.7 //l=0.175 //layer=li \
 //thickness=0.1 //x=63.07 //y=7.41 //x2=63.07 //y2=7.585
r1455 (  713 1046 ) resistor r=56.4706 //w=0.187 //l=0.825 //layer=li \
 //thickness=0.1 //x=63.07 //y=7.41 //x2=63.07 //y2=6.585
r1456 (  712 967 ) resistor r=5.29055 //w=0.35 //l=0.17 //layer=li \
 //thickness=0.1 //x=62.45 //y=7.585 //x2=62.28 //y2=7.585
r1457 (  711 968 ) resistor r=2.87058 //w=0.35 //l=0.085 //layer=li \
 //thickness=0.1 //x=62.985 //y=7.585 //x2=63.07 //y2=7.585
r1458 (  711 712 ) resistor r=18.6594 //w=0.367 //l=0.535 //layer=li \
 //thickness=0.1 //x=62.985 //y=7.585 //x2=62.45 //y2=7.585
r1459 (  706 966 ) resistor r=2.87058 //w=0.35 //l=0.085 //layer=li \
 //thickness=0.1 //x=61.285 //y=7.585 //x2=61.2 //y2=7.585
r1460 (  706 708 ) resistor r=21.7984 //w=0.367 //l=0.625 //layer=li \
 //thickness=0.1 //x=61.285 //y=7.585 //x2=61.91 //y2=7.585
r1461 (  705 967 ) resistor r=5.29055 //w=0.35 //l=0.17 //layer=li \
 //thickness=0.1 //x=62.11 //y=7.585 //x2=62.28 //y2=7.585
r1462 (  705 708 ) resistor r=6.97548 //w=0.367 //l=0.2 //layer=li \
 //thickness=0.1 //x=62.11 //y=7.585 //x2=61.91 //y2=7.585
r1463 (  699 966 ) resistor r=4.23183 //w=0.7 //l=0.175 //layer=li \
 //thickness=0.1 //x=61.2 //y=7.41 //x2=61.2 //y2=7.585
r1464 (  699 1045 ) resistor r=33.1979 //w=0.187 //l=0.485 //layer=li \
 //thickness=0.1 //x=61.2 //y=7.41 //x2=61.2 //y2=6.925
r1465 (  696 965 ) resistor r=2.87058 //w=0.35 //l=0.085 //layer=li \
 //thickness=0.1 //x=60.405 //y=7.585 //x2=60.32 //y2=7.585
r1466 (  696 698 ) resistor r=13.7766 //w=0.367 //l=0.395 //layer=li \
 //thickness=0.1 //x=60.405 //y=7.585 //x2=60.8 //y2=7.585
r1467 (  695 966 ) resistor r=2.87058 //w=0.35 //l=0.085 //layer=li \
 //thickness=0.1 //x=61.115 //y=7.585 //x2=61.2 //y2=7.585
r1468 (  695 698 ) resistor r=10.9864 //w=0.367 //l=0.315 //layer=li \
 //thickness=0.1 //x=61.115 //y=7.585 //x2=60.8 //y2=7.585
r1469 (  689 965 ) resistor r=4.23183 //w=0.7 //l=0.175 //layer=li \
 //thickness=0.1 //x=60.32 //y=7.41 //x2=60.32 //y2=7.585
r1470 (  689 1044 ) resistor r=33.1979 //w=0.187 //l=0.485 //layer=li \
 //thickness=0.1 //x=60.32 //y=7.41 //x2=60.32 //y2=6.925
r1471 (  686 964 ) resistor r=2.87058 //w=0.35 //l=0.085 //layer=li \
 //thickness=0.1 //x=59.525 //y=7.585 //x2=59.44 //y2=7.585
r1472 (  686 688 ) resistor r=5.75477 //w=0.367 //l=0.165 //layer=li \
 //thickness=0.1 //x=59.525 //y=7.585 //x2=59.69 //y2=7.585
r1473 (  685 965 ) resistor r=2.87058 //w=0.35 //l=0.085 //layer=li \
 //thickness=0.1 //x=60.235 //y=7.585 //x2=60.32 //y2=7.585
r1474 (  685 688 ) resistor r=19.0082 //w=0.367 //l=0.545 //layer=li \
 //thickness=0.1 //x=60.235 //y=7.585 //x2=59.69 //y2=7.585
r1475 (  679 964 ) resistor r=4.23183 //w=0.7 //l=0.175 //layer=li \
 //thickness=0.1 //x=59.44 //y=7.41 //x2=59.44 //y2=7.585
r1476 (  679 1043 ) resistor r=33.1979 //w=0.187 //l=0.485 //layer=li \
 //thickness=0.1 //x=59.44 //y=7.41 //x2=59.44 //y2=6.925
r1477 (  678 963 ) resistor r=2.87058 //w=0.35 //l=0.085 //layer=li \
 //thickness=0.1 //x=58.645 //y=7.585 //x2=58.56 //y2=7.585
r1478 (  677 964 ) resistor r=2.87058 //w=0.35 //l=0.085 //layer=li \
 //thickness=0.1 //x=59.355 //y=7.585 //x2=59.44 //y2=7.585
r1479 (  677 678 ) resistor r=24.7629 //w=0.367 //l=0.71 //layer=li \
 //thickness=0.1 //x=59.355 //y=7.585 //x2=58.645 //y2=7.585
r1480 (  671 963 ) resistor r=4.23183 //w=0.7 //l=0.175 //layer=li \
 //thickness=0.1 //x=58.56 //y=7.41 //x2=58.56 //y2=7.585
r1481 (  671 1042 ) resistor r=56.4706 //w=0.187 //l=0.825 //layer=li \
 //thickness=0.1 //x=58.56 //y=7.41 //x2=58.56 //y2=6.585
r1482 (  670 961 ) resistor r=5.29055 //w=0.35 //l=0.17 //layer=li \
 //thickness=0.1 //x=57.64 //y=7.585 //x2=57.47 //y2=7.585
r1483 (  669 963 ) resistor r=2.87058 //w=0.35 //l=0.085 //layer=li \
 //thickness=0.1 //x=58.475 //y=7.585 //x2=58.56 //y2=7.585
r1484 (  669 670 ) resistor r=29.1226 //w=0.367 //l=0.835 //layer=li \
 //thickness=0.1 //x=58.475 //y=7.585 //x2=57.64 //y2=7.585
r1485 (  664 960 ) resistor r=2.87058 //w=0.35 //l=0.085 //layer=li \
 //thickness=0.1 //x=56.475 //y=7.585 //x2=56.39 //y2=7.585
r1486 (  664 666 ) resistor r=21.7984 //w=0.367 //l=0.625 //layer=li \
 //thickness=0.1 //x=56.475 //y=7.585 //x2=57.1 //y2=7.585
r1487 (  663 961 ) resistor r=5.29055 //w=0.35 //l=0.17 //layer=li \
 //thickness=0.1 //x=57.3 //y=7.585 //x2=57.47 //y2=7.585
r1488 (  663 666 ) resistor r=6.97548 //w=0.367 //l=0.2 //layer=li \
 //thickness=0.1 //x=57.3 //y=7.585 //x2=57.1 //y2=7.585
r1489 (  657 960 ) resistor r=4.23183 //w=0.7 //l=0.175 //layer=li \
 //thickness=0.1 //x=56.39 //y=7.41 //x2=56.39 //y2=7.585
r1490 (  657 1041 ) resistor r=33.1979 //w=0.187 //l=0.485 //layer=li \
 //thickness=0.1 //x=56.39 //y=7.41 //x2=56.39 //y2=6.925
r1491 (  654 959 ) resistor r=2.87058 //w=0.35 //l=0.085 //layer=li \
 //thickness=0.1 //x=55.595 //y=7.585 //x2=55.51 //y2=7.585
r1492 (  654 656 ) resistor r=13.7766 //w=0.367 //l=0.395 //layer=li \
 //thickness=0.1 //x=55.595 //y=7.585 //x2=55.99 //y2=7.585
r1493 (  653 960 ) resistor r=2.87058 //w=0.35 //l=0.085 //layer=li \
 //thickness=0.1 //x=56.305 //y=7.585 //x2=56.39 //y2=7.585
r1494 (  653 656 ) resistor r=10.9864 //w=0.367 //l=0.315 //layer=li \
 //thickness=0.1 //x=56.305 //y=7.585 //x2=55.99 //y2=7.585
r1495 (  647 959 ) resistor r=4.23183 //w=0.7 //l=0.175 //layer=li \
 //thickness=0.1 //x=55.51 //y=7.41 //x2=55.51 //y2=7.585
r1496 (  647 1040 ) resistor r=33.1979 //w=0.187 //l=0.485 //layer=li \
 //thickness=0.1 //x=55.51 //y=7.41 //x2=55.51 //y2=6.925
r1497 (  644 958 ) resistor r=2.87058 //w=0.35 //l=0.085 //layer=li \
 //thickness=0.1 //x=54.715 //y=7.585 //x2=54.63 //y2=7.585
r1498 (  644 646 ) resistor r=5.75477 //w=0.367 //l=0.165 //layer=li \
 //thickness=0.1 //x=54.715 //y=7.585 //x2=54.88 //y2=7.585
r1499 (  643 959 ) resistor r=2.87058 //w=0.35 //l=0.085 //layer=li \
 //thickness=0.1 //x=55.425 //y=7.585 //x2=55.51 //y2=7.585
r1500 (  643 646 ) resistor r=19.0082 //w=0.367 //l=0.545 //layer=li \
 //thickness=0.1 //x=55.425 //y=7.585 //x2=54.88 //y2=7.585
r1501 (  637 958 ) resistor r=4.23183 //w=0.7 //l=0.175 //layer=li \
 //thickness=0.1 //x=54.63 //y=7.41 //x2=54.63 //y2=7.585
r1502 (  637 1039 ) resistor r=33.1979 //w=0.187 //l=0.485 //layer=li \
 //thickness=0.1 //x=54.63 //y=7.41 //x2=54.63 //y2=6.925
r1503 (  636 957 ) resistor r=2.87058 //w=0.35 //l=0.085 //layer=li \
 //thickness=0.1 //x=53.835 //y=7.585 //x2=53.75 //y2=7.585
r1504 (  635 958 ) resistor r=2.87058 //w=0.35 //l=0.085 //layer=li \
 //thickness=0.1 //x=54.545 //y=7.585 //x2=54.63 //y2=7.585
r1505 (  635 636 ) resistor r=24.7629 //w=0.367 //l=0.71 //layer=li \
 //thickness=0.1 //x=54.545 //y=7.585 //x2=53.835 //y2=7.585
r1506 (  629 957 ) resistor r=4.23183 //w=0.7 //l=0.175 //layer=li \
 //thickness=0.1 //x=53.75 //y=7.41 //x2=53.75 //y2=7.585
r1507 (  629 1038 ) resistor r=56.4706 //w=0.187 //l=0.825 //layer=li \
 //thickness=0.1 //x=53.75 //y=7.41 //x2=53.75 //y2=6.585
r1508 (  628 955 ) resistor r=5.29055 //w=0.35 //l=0.17 //layer=li \
 //thickness=0.1 //x=52.83 //y=7.585 //x2=52.66 //y2=7.585
r1509 (  627 957 ) resistor r=2.87058 //w=0.35 //l=0.085 //layer=li \
 //thickness=0.1 //x=53.665 //y=7.585 //x2=53.75 //y2=7.585
r1510 (  627 628 ) resistor r=29.1226 //w=0.367 //l=0.835 //layer=li \
 //thickness=0.1 //x=53.665 //y=7.585 //x2=52.83 //y2=7.585
r1511 (  622 954 ) resistor r=2.87058 //w=0.35 //l=0.085 //layer=li \
 //thickness=0.1 //x=51.965 //y=7.585 //x2=51.88 //y2=7.585
r1512 (  622 624 ) resistor r=11.3351 //w=0.367 //l=0.325 //layer=li \
 //thickness=0.1 //x=51.965 //y=7.585 //x2=52.29 //y2=7.585
r1513 (  621 955 ) resistor r=5.29055 //w=0.35 //l=0.17 //layer=li \
 //thickness=0.1 //x=52.49 //y=7.585 //x2=52.66 //y2=7.585
r1514 (  621 624 ) resistor r=6.97548 //w=0.367 //l=0.2 //layer=li \
 //thickness=0.1 //x=52.49 //y=7.585 //x2=52.29 //y2=7.585
r1515 (  615 954 ) resistor r=4.23183 //w=0.7 //l=0.175 //layer=li \
 //thickness=0.1 //x=51.88 //y=7.41 //x2=51.88 //y2=7.585
r1516 (  615 1037 ) resistor r=33.1979 //w=0.187 //l=0.485 //layer=li \
 //thickness=0.1 //x=51.88 //y=7.41 //x2=51.88 //y2=6.925
r1517 (  612 953 ) resistor r=2.87058 //w=0.35 //l=0.085 //layer=li \
 //thickness=0.1 //x=51.085 //y=7.585 //x2=51 //y2=7.585
r1518 (  612 614 ) resistor r=3.31335 //w=0.367 //l=0.095 //layer=li \
 //thickness=0.1 //x=51.085 //y=7.585 //x2=51.18 //y2=7.585
r1519 (  611 954 ) resistor r=2.87058 //w=0.35 //l=0.085 //layer=li \
 //thickness=0.1 //x=51.795 //y=7.585 //x2=51.88 //y2=7.585
r1520 (  611 614 ) resistor r=21.4496 //w=0.367 //l=0.615 //layer=li \
 //thickness=0.1 //x=51.795 //y=7.585 //x2=51.18 //y2=7.585
r1521 (  605 953 ) resistor r=4.23183 //w=0.7 //l=0.175 //layer=li \
 //thickness=0.1 //x=51 //y=7.41 //x2=51 //y2=7.585
r1522 (  605 1036 ) resistor r=33.1979 //w=0.187 //l=0.485 //layer=li \
 //thickness=0.1 //x=51 //y=7.41 //x2=51 //y2=6.925
r1523 (  604 952 ) resistor r=2.87058 //w=0.35 //l=0.085 //layer=li \
 //thickness=0.1 //x=50.205 //y=7.585 //x2=50.12 //y2=7.585
r1524 (  603 953 ) resistor r=2.87058 //w=0.35 //l=0.085 //layer=li \
 //thickness=0.1 //x=50.915 //y=7.585 //x2=51 //y2=7.585
r1525 (  603 604 ) resistor r=24.7629 //w=0.367 //l=0.71 //layer=li \
 //thickness=0.1 //x=50.915 //y=7.585 //x2=50.205 //y2=7.585
r1526 (  597 952 ) resistor r=4.23183 //w=0.7 //l=0.175 //layer=li \
 //thickness=0.1 //x=50.12 //y=7.41 //x2=50.12 //y2=7.585
r1527 (  597 1035 ) resistor r=56.4706 //w=0.187 //l=0.825 //layer=li \
 //thickness=0.1 //x=50.12 //y=7.41 //x2=50.12 //y2=6.585
r1528 (  596 950 ) resistor r=5.29055 //w=0.35 //l=0.17 //layer=li \
 //thickness=0.1 //x=49.5 //y=7.585 //x2=49.33 //y2=7.585
r1529 (  595 952 ) resistor r=2.87058 //w=0.35 //l=0.085 //layer=li \
 //thickness=0.1 //x=50.035 //y=7.585 //x2=50.12 //y2=7.585
r1530 (  595 596 ) resistor r=18.6594 //w=0.367 //l=0.535 //layer=li \
 //thickness=0.1 //x=50.035 //y=7.585 //x2=49.5 //y2=7.585
r1531 (  590 949 ) resistor r=2.87058 //w=0.35 //l=0.085 //layer=li \
 //thickness=0.1 //x=48.335 //y=7.585 //x2=48.25 //y2=7.585
r1532 (  590 592 ) resistor r=8.89373 //w=0.367 //l=0.255 //layer=li \
 //thickness=0.1 //x=48.335 //y=7.585 //x2=48.59 //y2=7.585
r1533 (  589 950 ) resistor r=5.29055 //w=0.35 //l=0.17 //layer=li \
 //thickness=0.1 //x=49.16 //y=7.585 //x2=49.33 //y2=7.585
r1534 (  589 592 ) resistor r=19.8801 //w=0.367 //l=0.57 //layer=li \
 //thickness=0.1 //x=49.16 //y=7.585 //x2=48.59 //y2=7.585
r1535 (  583 949 ) resistor r=4.23183 //w=0.7 //l=0.175 //layer=li \
 //thickness=0.1 //x=48.25 //y=7.41 //x2=48.25 //y2=7.585
r1536 (  583 1034 ) resistor r=33.1979 //w=0.187 //l=0.485 //layer=li \
 //thickness=0.1 //x=48.25 //y=7.41 //x2=48.25 //y2=6.925
r1537 (  580 948 ) resistor r=2.87058 //w=0.35 //l=0.085 //layer=li \
 //thickness=0.1 //x=47.455 //y=7.585 //x2=47.37 //y2=7.585
r1538 (  580 582 ) resistor r=0.871935 //w=0.367 //l=0.025 //layer=li \
 //thickness=0.1 //x=47.455 //y=7.585 //x2=47.48 //y2=7.585
r1539 (  579 949 ) resistor r=2.87058 //w=0.35 //l=0.085 //layer=li \
 //thickness=0.1 //x=48.165 //y=7.585 //x2=48.25 //y2=7.585
r1540 (  579 582 ) resistor r=23.891 //w=0.367 //l=0.685 //layer=li \
 //thickness=0.1 //x=48.165 //y=7.585 //x2=47.48 //y2=7.585
r1541 (  573 948 ) resistor r=4.23183 //w=0.7 //l=0.175 //layer=li \
 //thickness=0.1 //x=47.37 //y=7.41 //x2=47.37 //y2=7.585
r1542 (  573 1033 ) resistor r=33.1979 //w=0.187 //l=0.485 //layer=li \
 //thickness=0.1 //x=47.37 //y=7.41 //x2=47.37 //y2=6.925
r1543 (  572 947 ) resistor r=2.87058 //w=0.35 //l=0.085 //layer=li \
 //thickness=0.1 //x=46.575 //y=7.585 //x2=46.49 //y2=7.585
r1544 (  571 948 ) resistor r=2.87058 //w=0.35 //l=0.085 //layer=li \
 //thickness=0.1 //x=47.285 //y=7.585 //x2=47.37 //y2=7.585
r1545 (  571 572 ) resistor r=24.7629 //w=0.367 //l=0.71 //layer=li \
 //thickness=0.1 //x=47.285 //y=7.585 //x2=46.575 //y2=7.585
r1546 (  565 947 ) resistor r=4.23183 //w=0.7 //l=0.175 //layer=li \
 //thickness=0.1 //x=46.49 //y=7.41 //x2=46.49 //y2=7.585
r1547 (  565 1032 ) resistor r=33.1979 //w=0.187 //l=0.485 //layer=li \
 //thickness=0.1 //x=46.49 //y=7.41 //x2=46.49 //y2=6.925
r1548 (  562 946 ) resistor r=2.87058 //w=0.35 //l=0.085 //layer=li \
 //thickness=0.1 //x=45.695 //y=7.585 //x2=45.61 //y2=7.585
r1549 (  562 564 ) resistor r=23.5422 //w=0.367 //l=0.675 //layer=li \
 //thickness=0.1 //x=45.695 //y=7.585 //x2=46.37 //y2=7.585
r1550 (  561 947 ) resistor r=2.87058 //w=0.35 //l=0.085 //layer=li \
 //thickness=0.1 //x=46.405 //y=7.585 //x2=46.49 //y2=7.585
r1551 (  561 564 ) resistor r=1.22071 //w=0.367 //l=0.035 //layer=li \
 //thickness=0.1 //x=46.405 //y=7.585 //x2=46.37 //y2=7.585
r1552 (  555 946 ) resistor r=4.23183 //w=0.7 //l=0.175 //layer=li \
 //thickness=0.1 //x=45.61 //y=7.41 //x2=45.61 //y2=7.585
r1553 (  555 1031 ) resistor r=56.4706 //w=0.187 //l=0.825 //layer=li \
 //thickness=0.1 //x=45.61 //y=7.41 //x2=45.61 //y2=6.585
r1554 (  552 945 ) resistor r=5.29055 //w=0.35 //l=0.17 //layer=li \
 //thickness=0.1 //x=44.69 //y=7.585 //x2=44.52 //y2=7.585
r1555 (  552 554 ) resistor r=19.8801 //w=0.367 //l=0.57 //layer=li \
 //thickness=0.1 //x=44.69 //y=7.585 //x2=45.26 //y2=7.585
r1556 (  551 946 ) resistor r=2.87058 //w=0.35 //l=0.085 //layer=li \
 //thickness=0.1 //x=45.525 //y=7.585 //x2=45.61 //y2=7.585
r1557 (  551 554 ) resistor r=9.24251 //w=0.367 //l=0.265 //layer=li \
 //thickness=0.1 //x=45.525 //y=7.585 //x2=45.26 //y2=7.585
r1558 (  548 944 ) resistor r=2.87058 //w=0.35 //l=0.085 //layer=li \
 //thickness=0.1 //x=43.825 //y=7.585 //x2=43.74 //y2=7.585
r1559 (  547 945 ) resistor r=5.29055 //w=0.35 //l=0.17 //layer=li \
 //thickness=0.1 //x=44.35 //y=7.585 //x2=44.52 //y2=7.585
r1560 (  547 548 ) resistor r=18.3106 //w=0.367 //l=0.525 //layer=li \
 //thickness=0.1 //x=44.35 //y=7.585 //x2=43.825 //y2=7.585
r1561 (  541 944 ) resistor r=4.23183 //w=0.7 //l=0.175 //layer=li \
 //thickness=0.1 //x=43.74 //y=7.41 //x2=43.74 //y2=7.585
r1562 (  541 1030 ) resistor r=33.1979 //w=0.187 //l=0.485 //layer=li \
 //thickness=0.1 //x=43.74 //y=7.41 //x2=43.74 //y2=6.925
r1563 (  540 942 ) resistor r=2.87058 //w=0.35 //l=0.085 //layer=li \
 //thickness=0.1 //x=42.945 //y=7.585 //x2=42.86 //y2=7.585
r1564 (  539 944 ) resistor r=2.87058 //w=0.35 //l=0.085 //layer=li \
 //thickness=0.1 //x=43.655 //y=7.585 //x2=43.74 //y2=7.585
r1565 (  539 540 ) resistor r=24.7629 //w=0.367 //l=0.71 //layer=li \
 //thickness=0.1 //x=43.655 //y=7.585 //x2=42.945 //y2=7.585
r1566 (  533 942 ) resistor r=4.23183 //w=0.7 //l=0.175 //layer=li \
 //thickness=0.1 //x=42.86 //y=7.41 //x2=42.86 //y2=7.585
r1567 (  533 1029 ) resistor r=33.1979 //w=0.187 //l=0.485 //layer=li \
 //thickness=0.1 //x=42.86 //y=7.41 //x2=42.86 //y2=6.925
r1568 (  530 941 ) resistor r=2.87058 //w=0.35 //l=0.085 //layer=li \
 //thickness=0.1 //x=42.065 //y=7.585 //x2=41.98 //y2=7.585
r1569 (  530 532 ) resistor r=21.1008 //w=0.367 //l=0.605 //layer=li \
 //thickness=0.1 //x=42.065 //y=7.585 //x2=42.67 //y2=7.585
r1570 (  529 942 ) resistor r=2.87058 //w=0.35 //l=0.085 //layer=li \
 //thickness=0.1 //x=42.775 //y=7.585 //x2=42.86 //y2=7.585
r1571 (  529 532 ) resistor r=3.66213 //w=0.367 //l=0.105 //layer=li \
 //thickness=0.1 //x=42.775 //y=7.585 //x2=42.67 //y2=7.585
r1572 (  523 941 ) resistor r=4.23183 //w=0.7 //l=0.175 //layer=li \
 //thickness=0.1 //x=41.98 //y=7.41 //x2=41.98 //y2=7.585
r1573 (  523 1028 ) resistor r=56.4706 //w=0.187 //l=0.825 //layer=li \
 //thickness=0.1 //x=41.98 //y=7.41 //x2=41.98 //y2=6.585
r1574 (  520 940 ) resistor r=5.29055 //w=0.35 //l=0.17 //layer=li \
 //thickness=0.1 //x=41.36 //y=7.585 //x2=41.19 //y2=7.585
r1575 (  520 522 ) resistor r=6.97548 //w=0.367 //l=0.2 //layer=li \
 //thickness=0.1 //x=41.36 //y=7.585 //x2=41.56 //y2=7.585
r1576 (  519 941 ) resistor r=2.87058 //w=0.35 //l=0.085 //layer=li \
 //thickness=0.1 //x=41.895 //y=7.585 //x2=41.98 //y2=7.585
r1577 (  519 522 ) resistor r=11.6839 //w=0.367 //l=0.335 //layer=li \
 //thickness=0.1 //x=41.895 //y=7.585 //x2=41.56 //y2=7.585
r1578 (  516 939 ) resistor r=2.87058 //w=0.35 //l=0.085 //layer=li \
 //thickness=0.1 //x=40.495 //y=7.585 //x2=40.41 //y2=7.585
r1579 (  515 940 ) resistor r=5.29055 //w=0.35 //l=0.17 //layer=li \
 //thickness=0.1 //x=41.02 //y=7.585 //x2=41.19 //y2=7.585
r1580 (  515 516 ) resistor r=18.3106 //w=0.367 //l=0.525 //layer=li \
 //thickness=0.1 //x=41.02 //y=7.585 //x2=40.495 //y2=7.585
r1581 (  509 939 ) resistor r=4.23183 //w=0.7 //l=0.175 //layer=li \
 //thickness=0.1 //x=40.41 //y=7.41 //x2=40.41 //y2=7.585
r1582 (  509 1027 ) resistor r=33.1979 //w=0.187 //l=0.485 //layer=li \
 //thickness=0.1 //x=40.41 //y=7.41 //x2=40.41 //y2=6.925
r1583 (  506 938 ) resistor r=2.87058 //w=0.35 //l=0.085 //layer=li \
 //thickness=0.1 //x=39.615 //y=7.585 //x2=39.53 //y2=7.585
r1584 (  506 508 ) resistor r=16.218 //w=0.367 //l=0.465 //layer=li \
 //thickness=0.1 //x=39.615 //y=7.585 //x2=40.08 //y2=7.585
r1585 (  505 939 ) resistor r=2.87058 //w=0.35 //l=0.085 //layer=li \
 //thickness=0.1 //x=40.325 //y=7.585 //x2=40.41 //y2=7.585
r1586 (  505 508 ) resistor r=8.54496 //w=0.367 //l=0.245 //layer=li \
 //thickness=0.1 //x=40.325 //y=7.585 //x2=40.08 //y2=7.585
r1587 (  499 938 ) resistor r=4.23183 //w=0.7 //l=0.175 //layer=li \
 //thickness=0.1 //x=39.53 //y=7.41 //x2=39.53 //y2=7.585
r1588 (  499 1026 ) resistor r=33.1979 //w=0.187 //l=0.485 //layer=li \
 //thickness=0.1 //x=39.53 //y=7.41 //x2=39.53 //y2=6.925
r1589 (  496 937 ) resistor r=2.87058 //w=0.35 //l=0.085 //layer=li \
 //thickness=0.1 //x=38.735 //y=7.585 //x2=38.65 //y2=7.585
r1590 (  496 498 ) resistor r=8.19619 //w=0.367 //l=0.235 //layer=li \
 //thickness=0.1 //x=38.735 //y=7.585 //x2=38.97 //y2=7.585
r1591 (  495 938 ) resistor r=2.87058 //w=0.35 //l=0.085 //layer=li \
 //thickness=0.1 //x=39.445 //y=7.585 //x2=39.53 //y2=7.585
r1592 (  495 498 ) resistor r=16.5668 //w=0.367 //l=0.475 //layer=li \
 //thickness=0.1 //x=39.445 //y=7.585 //x2=38.97 //y2=7.585
r1593 (  489 937 ) resistor r=4.23183 //w=0.7 //l=0.175 //layer=li \
 //thickness=0.1 //x=38.65 //y=7.41 //x2=38.65 //y2=7.585
r1594 (  489 1025 ) resistor r=56.4706 //w=0.187 //l=0.825 //layer=li \
 //thickness=0.1 //x=38.65 //y=7.41 //x2=38.65 //y2=6.585
r1595 (  488 936 ) resistor r=5.29055 //w=0.35 //l=0.17 //layer=li \
 //thickness=0.1 //x=38.03 //y=7.585 //x2=37.86 //y2=7.585
r1596 (  487 937 ) resistor r=2.87058 //w=0.35 //l=0.085 //layer=li \
 //thickness=0.1 //x=38.565 //y=7.585 //x2=38.65 //y2=7.585
r1597 (  487 488 ) resistor r=18.6594 //w=0.367 //l=0.535 //layer=li \
 //thickness=0.1 //x=38.565 //y=7.585 //x2=38.03 //y2=7.585
r1598 (  482 935 ) resistor r=2.87058 //w=0.35 //l=0.085 //layer=li \
 //thickness=0.1 //x=36.865 //y=7.585 //x2=36.78 //y2=7.585
r1599 (  482 484 ) resistor r=21.7984 //w=0.367 //l=0.625 //layer=li \
 //thickness=0.1 //x=36.865 //y=7.585 //x2=37.49 //y2=7.585
r1600 (  481 936 ) resistor r=5.29055 //w=0.35 //l=0.17 //layer=li \
 //thickness=0.1 //x=37.69 //y=7.585 //x2=37.86 //y2=7.585
r1601 (  481 484 ) resistor r=6.97548 //w=0.367 //l=0.2 //layer=li \
 //thickness=0.1 //x=37.69 //y=7.585 //x2=37.49 //y2=7.585
r1602 (  475 935 ) resistor r=4.23183 //w=0.7 //l=0.175 //layer=li \
 //thickness=0.1 //x=36.78 //y=7.41 //x2=36.78 //y2=7.585
r1603 (  475 1024 ) resistor r=33.1979 //w=0.187 //l=0.485 //layer=li \
 //thickness=0.1 //x=36.78 //y=7.41 //x2=36.78 //y2=6.925
r1604 (  472 934 ) resistor r=2.87058 //w=0.35 //l=0.085 //layer=li \
 //thickness=0.1 //x=35.985 //y=7.585 //x2=35.9 //y2=7.585
r1605 (  472 474 ) resistor r=13.7766 //w=0.367 //l=0.395 //layer=li \
 //thickness=0.1 //x=35.985 //y=7.585 //x2=36.38 //y2=7.585
r1606 (  471 935 ) resistor r=2.87058 //w=0.35 //l=0.085 //layer=li \
 //thickness=0.1 //x=36.695 //y=7.585 //x2=36.78 //y2=7.585
r1607 (  471 474 ) resistor r=10.9864 //w=0.367 //l=0.315 //layer=li \
 //thickness=0.1 //x=36.695 //y=7.585 //x2=36.38 //y2=7.585
r1608 (  465 934 ) resistor r=4.23183 //w=0.7 //l=0.175 //layer=li \
 //thickness=0.1 //x=35.9 //y=7.41 //x2=35.9 //y2=7.585
r1609 (  465 1023 ) resistor r=33.1979 //w=0.187 //l=0.485 //layer=li \
 //thickness=0.1 //x=35.9 //y=7.41 //x2=35.9 //y2=6.925
r1610 (  462 933 ) resistor r=2.87058 //w=0.35 //l=0.085 //layer=li \
 //thickness=0.1 //x=35.105 //y=7.585 //x2=35.02 //y2=7.585
r1611 (  462 464 ) resistor r=5.75477 //w=0.367 //l=0.165 //layer=li \
 //thickness=0.1 //x=35.105 //y=7.585 //x2=35.27 //y2=7.585
r1612 (  461 934 ) resistor r=2.87058 //w=0.35 //l=0.085 //layer=li \
 //thickness=0.1 //x=35.815 //y=7.585 //x2=35.9 //y2=7.585
r1613 (  461 464 ) resistor r=19.0082 //w=0.367 //l=0.545 //layer=li \
 //thickness=0.1 //x=35.815 //y=7.585 //x2=35.27 //y2=7.585
r1614 (  455 933 ) resistor r=4.23183 //w=0.7 //l=0.175 //layer=li \
 //thickness=0.1 //x=35.02 //y=7.41 //x2=35.02 //y2=7.585
r1615 (  455 1022 ) resistor r=33.1979 //w=0.187 //l=0.485 //layer=li \
 //thickness=0.1 //x=35.02 //y=7.41 //x2=35.02 //y2=6.925
r1616 (  454 932 ) resistor r=2.87058 //w=0.35 //l=0.085 //layer=li \
 //thickness=0.1 //x=34.225 //y=7.585 //x2=34.14 //y2=7.585
r1617 (  453 933 ) resistor r=2.87058 //w=0.35 //l=0.085 //layer=li \
 //thickness=0.1 //x=34.935 //y=7.585 //x2=35.02 //y2=7.585
r1618 (  453 454 ) resistor r=24.7629 //w=0.367 //l=0.71 //layer=li \
 //thickness=0.1 //x=34.935 //y=7.585 //x2=34.225 //y2=7.585
r1619 (  447 932 ) resistor r=4.23183 //w=0.7 //l=0.175 //layer=li \
 //thickness=0.1 //x=34.14 //y=7.41 //x2=34.14 //y2=7.585
r1620 (  447 1021 ) resistor r=56.4706 //w=0.187 //l=0.825 //layer=li \
 //thickness=0.1 //x=34.14 //y=7.41 //x2=34.14 //y2=6.585
r1621 (  446 930 ) resistor r=5.29055 //w=0.35 //l=0.17 //layer=li \
 //thickness=0.1 //x=33.22 //y=7.585 //x2=33.05 //y2=7.585
r1622 (  445 932 ) resistor r=2.87058 //w=0.35 //l=0.085 //layer=li \
 //thickness=0.1 //x=34.055 //y=7.585 //x2=34.14 //y2=7.585
r1623 (  445 446 ) resistor r=29.1226 //w=0.367 //l=0.835 //layer=li \
 //thickness=0.1 //x=34.055 //y=7.585 //x2=33.22 //y2=7.585
r1624 (  440 929 ) resistor r=2.87058 //w=0.35 //l=0.085 //layer=li \
 //thickness=0.1 //x=32.055 //y=7.585 //x2=31.97 //y2=7.585
r1625 (  440 442 ) resistor r=21.7984 //w=0.367 //l=0.625 //layer=li \
 //thickness=0.1 //x=32.055 //y=7.585 //x2=32.68 //y2=7.585
r1626 (  439 930 ) resistor r=5.29055 //w=0.35 //l=0.17 //layer=li \
 //thickness=0.1 //x=32.88 //y=7.585 //x2=33.05 //y2=7.585
r1627 (  439 442 ) resistor r=6.97548 //w=0.367 //l=0.2 //layer=li \
 //thickness=0.1 //x=32.88 //y=7.585 //x2=32.68 //y2=7.585
r1628 (  433 929 ) resistor r=4.23183 //w=0.7 //l=0.175 //layer=li \
 //thickness=0.1 //x=31.97 //y=7.41 //x2=31.97 //y2=7.585
r1629 (  433 1020 ) resistor r=33.1979 //w=0.187 //l=0.485 //layer=li \
 //thickness=0.1 //x=31.97 //y=7.41 //x2=31.97 //y2=6.925
r1630 (  430 928 ) resistor r=2.87058 //w=0.35 //l=0.085 //layer=li \
 //thickness=0.1 //x=31.175 //y=7.585 //x2=31.09 //y2=7.585
r1631 (  430 432 ) resistor r=13.7766 //w=0.367 //l=0.395 //layer=li \
 //thickness=0.1 //x=31.175 //y=7.585 //x2=31.57 //y2=7.585
r1632 (  429 929 ) resistor r=2.87058 //w=0.35 //l=0.085 //layer=li \
 //thickness=0.1 //x=31.885 //y=7.585 //x2=31.97 //y2=7.585
r1633 (  429 432 ) resistor r=10.9864 //w=0.367 //l=0.315 //layer=li \
 //thickness=0.1 //x=31.885 //y=7.585 //x2=31.57 //y2=7.585
r1634 (  423 928 ) resistor r=4.23183 //w=0.7 //l=0.175 //layer=li \
 //thickness=0.1 //x=31.09 //y=7.41 //x2=31.09 //y2=7.585
r1635 (  423 1019 ) resistor r=33.1979 //w=0.187 //l=0.485 //layer=li \
 //thickness=0.1 //x=31.09 //y=7.41 //x2=31.09 //y2=6.925
r1636 (  420 927 ) resistor r=2.87058 //w=0.35 //l=0.085 //layer=li \
 //thickness=0.1 //x=30.295 //y=7.585 //x2=30.21 //y2=7.585
r1637 (  420 422 ) resistor r=5.75477 //w=0.367 //l=0.165 //layer=li \
 //thickness=0.1 //x=30.295 //y=7.585 //x2=30.46 //y2=7.585
r1638 (  419 928 ) resistor r=2.87058 //w=0.35 //l=0.085 //layer=li \
 //thickness=0.1 //x=31.005 //y=7.585 //x2=31.09 //y2=7.585
r1639 (  419 422 ) resistor r=19.0082 //w=0.367 //l=0.545 //layer=li \
 //thickness=0.1 //x=31.005 //y=7.585 //x2=30.46 //y2=7.585
r1640 (  413 927 ) resistor r=4.23183 //w=0.7 //l=0.175 //layer=li \
 //thickness=0.1 //x=30.21 //y=7.41 //x2=30.21 //y2=7.585
r1641 (  413 1018 ) resistor r=33.1979 //w=0.187 //l=0.485 //layer=li \
 //thickness=0.1 //x=30.21 //y=7.41 //x2=30.21 //y2=6.925
r1642 (  412 926 ) resistor r=2.87058 //w=0.35 //l=0.085 //layer=li \
 //thickness=0.1 //x=29.415 //y=7.585 //x2=29.33 //y2=7.585
r1643 (  411 927 ) resistor r=2.87058 //w=0.35 //l=0.085 //layer=li \
 //thickness=0.1 //x=30.125 //y=7.585 //x2=30.21 //y2=7.585
r1644 (  411 412 ) resistor r=24.7629 //w=0.367 //l=0.71 //layer=li \
 //thickness=0.1 //x=30.125 //y=7.585 //x2=29.415 //y2=7.585
r1645 (  405 926 ) resistor r=4.23183 //w=0.7 //l=0.175 //layer=li \
 //thickness=0.1 //x=29.33 //y=7.41 //x2=29.33 //y2=7.585
r1646 (  405 1017 ) resistor r=56.4706 //w=0.187 //l=0.825 //layer=li \
 //thickness=0.1 //x=29.33 //y=7.41 //x2=29.33 //y2=6.585
r1647 (  404 924 ) resistor r=5.29055 //w=0.35 //l=0.17 //layer=li \
 //thickness=0.1 //x=28.41 //y=7.585 //x2=28.24 //y2=7.585
r1648 (  403 926 ) resistor r=2.87058 //w=0.35 //l=0.085 //layer=li \
 //thickness=0.1 //x=29.245 //y=7.585 //x2=29.33 //y2=7.585
r1649 (  403 404 ) resistor r=29.1226 //w=0.367 //l=0.835 //layer=li \
 //thickness=0.1 //x=29.245 //y=7.585 //x2=28.41 //y2=7.585
r1650 (  398 923 ) resistor r=2.87058 //w=0.35 //l=0.085 //layer=li \
 //thickness=0.1 //x=27.545 //y=7.585 //x2=27.46 //y2=7.585
r1651 (  398 400 ) resistor r=11.3351 //w=0.367 //l=0.325 //layer=li \
 //thickness=0.1 //x=27.545 //y=7.585 //x2=27.87 //y2=7.585
r1652 (  397 924 ) resistor r=5.29055 //w=0.35 //l=0.17 //layer=li \
 //thickness=0.1 //x=28.07 //y=7.585 //x2=28.24 //y2=7.585
r1653 (  397 400 ) resistor r=6.97548 //w=0.367 //l=0.2 //layer=li \
 //thickness=0.1 //x=28.07 //y=7.585 //x2=27.87 //y2=7.585
r1654 (  391 923 ) resistor r=4.23183 //w=0.7 //l=0.175 //layer=li \
 //thickness=0.1 //x=27.46 //y=7.41 //x2=27.46 //y2=7.585
r1655 (  391 1016 ) resistor r=33.1979 //w=0.187 //l=0.485 //layer=li \
 //thickness=0.1 //x=27.46 //y=7.41 //x2=27.46 //y2=6.925
r1656 (  388 922 ) resistor r=2.87058 //w=0.35 //l=0.085 //layer=li \
 //thickness=0.1 //x=26.665 //y=7.585 //x2=26.58 //y2=7.585
r1657 (  388 390 ) resistor r=3.31335 //w=0.367 //l=0.095 //layer=li \
 //thickness=0.1 //x=26.665 //y=7.585 //x2=26.76 //y2=7.585
r1658 (  387 923 ) resistor r=2.87058 //w=0.35 //l=0.085 //layer=li \
 //thickness=0.1 //x=27.375 //y=7.585 //x2=27.46 //y2=7.585
r1659 (  387 390 ) resistor r=21.4496 //w=0.367 //l=0.615 //layer=li \
 //thickness=0.1 //x=27.375 //y=7.585 //x2=26.76 //y2=7.585
r1660 (  381 922 ) resistor r=4.23183 //w=0.7 //l=0.175 //layer=li \
 //thickness=0.1 //x=26.58 //y=7.41 //x2=26.58 //y2=7.585
r1661 (  381 1015 ) resistor r=33.1979 //w=0.187 //l=0.485 //layer=li \
 //thickness=0.1 //x=26.58 //y=7.41 //x2=26.58 //y2=6.925
r1662 (  380 921 ) resistor r=2.87058 //w=0.35 //l=0.085 //layer=li \
 //thickness=0.1 //x=25.785 //y=7.585 //x2=25.7 //y2=7.585
r1663 (  379 922 ) resistor r=2.87058 //w=0.35 //l=0.085 //layer=li \
 //thickness=0.1 //x=26.495 //y=7.585 //x2=26.58 //y2=7.585
r1664 (  379 380 ) resistor r=24.7629 //w=0.367 //l=0.71 //layer=li \
 //thickness=0.1 //x=26.495 //y=7.585 //x2=25.785 //y2=7.585
r1665 (  373 921 ) resistor r=4.23183 //w=0.7 //l=0.175 //layer=li \
 //thickness=0.1 //x=25.7 //y=7.41 //x2=25.7 //y2=7.585
r1666 (  373 1014 ) resistor r=56.4706 //w=0.187 //l=0.825 //layer=li \
 //thickness=0.1 //x=25.7 //y=7.41 //x2=25.7 //y2=6.585
r1667 (  372 919 ) resistor r=5.29055 //w=0.35 //l=0.17 //layer=li \
 //thickness=0.1 //x=25.08 //y=7.585 //x2=24.91 //y2=7.585
r1668 (  371 921 ) resistor r=2.87058 //w=0.35 //l=0.085 //layer=li \
 //thickness=0.1 //x=25.615 //y=7.585 //x2=25.7 //y2=7.585
r1669 (  371 372 ) resistor r=18.6594 //w=0.367 //l=0.535 //layer=li \
 //thickness=0.1 //x=25.615 //y=7.585 //x2=25.08 //y2=7.585
r1670 (  366 918 ) resistor r=2.87058 //w=0.35 //l=0.085 //layer=li \
 //thickness=0.1 //x=23.915 //y=7.585 //x2=23.83 //y2=7.585
r1671 (  366 368 ) resistor r=8.89373 //w=0.367 //l=0.255 //layer=li \
 //thickness=0.1 //x=23.915 //y=7.585 //x2=24.17 //y2=7.585
r1672 (  365 919 ) resistor r=5.29055 //w=0.35 //l=0.17 //layer=li \
 //thickness=0.1 //x=24.74 //y=7.585 //x2=24.91 //y2=7.585
r1673 (  365 368 ) resistor r=19.8801 //w=0.367 //l=0.57 //layer=li \
 //thickness=0.1 //x=24.74 //y=7.585 //x2=24.17 //y2=7.585
r1674 (  359 918 ) resistor r=4.23183 //w=0.7 //l=0.175 //layer=li \
 //thickness=0.1 //x=23.83 //y=7.41 //x2=23.83 //y2=7.585
r1675 (  359 1013 ) resistor r=33.1979 //w=0.187 //l=0.485 //layer=li \
 //thickness=0.1 //x=23.83 //y=7.41 //x2=23.83 //y2=6.925
r1676 (  356 917 ) resistor r=2.87058 //w=0.35 //l=0.085 //layer=li \
 //thickness=0.1 //x=23.035 //y=7.585 //x2=22.95 //y2=7.585
r1677 (  356 358 ) resistor r=0.871935 //w=0.367 //l=0.025 //layer=li \
 //thickness=0.1 //x=23.035 //y=7.585 //x2=23.06 //y2=7.585
r1678 (  355 918 ) resistor r=2.87058 //w=0.35 //l=0.085 //layer=li \
 //thickness=0.1 //x=23.745 //y=7.585 //x2=23.83 //y2=7.585
r1679 (  355 358 ) resistor r=23.891 //w=0.367 //l=0.685 //layer=li \
 //thickness=0.1 //x=23.745 //y=7.585 //x2=23.06 //y2=7.585
r1680 (  349 917 ) resistor r=4.23183 //w=0.7 //l=0.175 //layer=li \
 //thickness=0.1 //x=22.95 //y=7.41 //x2=22.95 //y2=7.585
r1681 (  349 1012 ) resistor r=33.1979 //w=0.187 //l=0.485 //layer=li \
 //thickness=0.1 //x=22.95 //y=7.41 //x2=22.95 //y2=6.925
r1682 (  348 916 ) resistor r=2.87058 //w=0.35 //l=0.085 //layer=li \
 //thickness=0.1 //x=22.155 //y=7.585 //x2=22.07 //y2=7.585
r1683 (  347 917 ) resistor r=2.87058 //w=0.35 //l=0.085 //layer=li \
 //thickness=0.1 //x=22.865 //y=7.585 //x2=22.95 //y2=7.585
r1684 (  347 348 ) resistor r=24.7629 //w=0.367 //l=0.71 //layer=li \
 //thickness=0.1 //x=22.865 //y=7.585 //x2=22.155 //y2=7.585
r1685 (  341 916 ) resistor r=4.23183 //w=0.7 //l=0.175 //layer=li \
 //thickness=0.1 //x=22.07 //y=7.41 //x2=22.07 //y2=7.585
r1686 (  341 1011 ) resistor r=33.1979 //w=0.187 //l=0.485 //layer=li \
 //thickness=0.1 //x=22.07 //y=7.41 //x2=22.07 //y2=6.925
r1687 (  338 915 ) resistor r=2.87058 //w=0.35 //l=0.085 //layer=li \
 //thickness=0.1 //x=21.275 //y=7.585 //x2=21.19 //y2=7.585
r1688 (  338 340 ) resistor r=23.5422 //w=0.367 //l=0.675 //layer=li \
 //thickness=0.1 //x=21.275 //y=7.585 //x2=21.95 //y2=7.585
r1689 (  337 916 ) resistor r=2.87058 //w=0.35 //l=0.085 //layer=li \
 //thickness=0.1 //x=21.985 //y=7.585 //x2=22.07 //y2=7.585
r1690 (  337 340 ) resistor r=1.22071 //w=0.367 //l=0.035 //layer=li \
 //thickness=0.1 //x=21.985 //y=7.585 //x2=21.95 //y2=7.585
r1691 (  331 915 ) resistor r=4.23183 //w=0.7 //l=0.175 //layer=li \
 //thickness=0.1 //x=21.19 //y=7.41 //x2=21.19 //y2=7.585
r1692 (  331 1010 ) resistor r=56.4706 //w=0.187 //l=0.825 //layer=li \
 //thickness=0.1 //x=21.19 //y=7.41 //x2=21.19 //y2=6.585
r1693 (  328 914 ) resistor r=5.29055 //w=0.35 //l=0.17 //layer=li \
 //thickness=0.1 //x=20.27 //y=7.585 //x2=20.1 //y2=7.585
r1694 (  328 330 ) resistor r=19.8801 //w=0.367 //l=0.57 //layer=li \
 //thickness=0.1 //x=20.27 //y=7.585 //x2=20.84 //y2=7.585
r1695 (  327 915 ) resistor r=2.87058 //w=0.35 //l=0.085 //layer=li \
 //thickness=0.1 //x=21.105 //y=7.585 //x2=21.19 //y2=7.585
r1696 (  327 330 ) resistor r=9.24251 //w=0.367 //l=0.265 //layer=li \
 //thickness=0.1 //x=21.105 //y=7.585 //x2=20.84 //y2=7.585
r1697 (  324 913 ) resistor r=2.87058 //w=0.35 //l=0.085 //layer=li \
 //thickness=0.1 //x=19.405 //y=7.585 //x2=19.32 //y2=7.585
r1698 (  323 914 ) resistor r=5.29055 //w=0.35 //l=0.17 //layer=li \
 //thickness=0.1 //x=19.93 //y=7.585 //x2=20.1 //y2=7.585
r1699 (  323 324 ) resistor r=18.3106 //w=0.367 //l=0.525 //layer=li \
 //thickness=0.1 //x=19.93 //y=7.585 //x2=19.405 //y2=7.585
r1700 (  317 913 ) resistor r=4.23183 //w=0.7 //l=0.175 //layer=li \
 //thickness=0.1 //x=19.32 //y=7.41 //x2=19.32 //y2=7.585
r1701 (  317 1009 ) resistor r=33.1979 //w=0.187 //l=0.485 //layer=li \
 //thickness=0.1 //x=19.32 //y=7.41 //x2=19.32 //y2=6.925
r1702 (  316 911 ) resistor r=2.87058 //w=0.35 //l=0.085 //layer=li \
 //thickness=0.1 //x=18.525 //y=7.585 //x2=18.44 //y2=7.585
r1703 (  315 913 ) resistor r=2.87058 //w=0.35 //l=0.085 //layer=li \
 //thickness=0.1 //x=19.235 //y=7.585 //x2=19.32 //y2=7.585
r1704 (  315 316 ) resistor r=24.7629 //w=0.367 //l=0.71 //layer=li \
 //thickness=0.1 //x=19.235 //y=7.585 //x2=18.525 //y2=7.585
r1705 (  309 911 ) resistor r=4.23183 //w=0.7 //l=0.175 //layer=li \
 //thickness=0.1 //x=18.44 //y=7.41 //x2=18.44 //y2=7.585
r1706 (  309 1008 ) resistor r=33.1979 //w=0.187 //l=0.485 //layer=li \
 //thickness=0.1 //x=18.44 //y=7.41 //x2=18.44 //y2=6.925
r1707 (  306 910 ) resistor r=2.87058 //w=0.35 //l=0.085 //layer=li \
 //thickness=0.1 //x=17.645 //y=7.585 //x2=17.56 //y2=7.585
r1708 (  306 308 ) resistor r=21.1008 //w=0.367 //l=0.605 //layer=li \
 //thickness=0.1 //x=17.645 //y=7.585 //x2=18.25 //y2=7.585
r1709 (  305 911 ) resistor r=2.87058 //w=0.35 //l=0.085 //layer=li \
 //thickness=0.1 //x=18.355 //y=7.585 //x2=18.44 //y2=7.585
r1710 (  305 308 ) resistor r=3.66213 //w=0.367 //l=0.105 //layer=li \
 //thickness=0.1 //x=18.355 //y=7.585 //x2=18.25 //y2=7.585
r1711 (  299 910 ) resistor r=4.23183 //w=0.7 //l=0.175 //layer=li \
 //thickness=0.1 //x=17.56 //y=7.41 //x2=17.56 //y2=7.585
r1712 (  299 1007 ) resistor r=56.4706 //w=0.187 //l=0.825 //layer=li \
 //thickness=0.1 //x=17.56 //y=7.41 //x2=17.56 //y2=6.585
r1713 (  296 909 ) resistor r=5.29055 //w=0.35 //l=0.17 //layer=li \
 //thickness=0.1 //x=16.94 //y=7.585 //x2=16.77 //y2=7.585
r1714 (  296 298 ) resistor r=6.97548 //w=0.367 //l=0.2 //layer=li \
 //thickness=0.1 //x=16.94 //y=7.585 //x2=17.14 //y2=7.585
r1715 (  295 910 ) resistor r=2.87058 //w=0.35 //l=0.085 //layer=li \
 //thickness=0.1 //x=17.475 //y=7.585 //x2=17.56 //y2=7.585
r1716 (  295 298 ) resistor r=11.6839 //w=0.367 //l=0.335 //layer=li \
 //thickness=0.1 //x=17.475 //y=7.585 //x2=17.14 //y2=7.585
r1717 (  292 908 ) resistor r=2.87058 //w=0.35 //l=0.085 //layer=li \
 //thickness=0.1 //x=16.075 //y=7.585 //x2=15.99 //y2=7.585
r1718 (  291 909 ) resistor r=5.29055 //w=0.35 //l=0.17 //layer=li \
 //thickness=0.1 //x=16.6 //y=7.585 //x2=16.77 //y2=7.585
r1719 (  291 292 ) resistor r=18.3106 //w=0.367 //l=0.525 //layer=li \
 //thickness=0.1 //x=16.6 //y=7.585 //x2=16.075 //y2=7.585
r1720 (  285 908 ) resistor r=4.23183 //w=0.7 //l=0.175 //layer=li \
 //thickness=0.1 //x=15.99 //y=7.41 //x2=15.99 //y2=7.585
r1721 (  285 1006 ) resistor r=33.1979 //w=0.187 //l=0.485 //layer=li \
 //thickness=0.1 //x=15.99 //y=7.41 //x2=15.99 //y2=6.925
r1722 (  282 907 ) resistor r=2.87058 //w=0.35 //l=0.085 //layer=li \
 //thickness=0.1 //x=15.195 //y=7.585 //x2=15.11 //y2=7.585
r1723 (  282 284 ) resistor r=16.218 //w=0.367 //l=0.465 //layer=li \
 //thickness=0.1 //x=15.195 //y=7.585 //x2=15.66 //y2=7.585
r1724 (  281 908 ) resistor r=2.87058 //w=0.35 //l=0.085 //layer=li \
 //thickness=0.1 //x=15.905 //y=7.585 //x2=15.99 //y2=7.585
r1725 (  281 284 ) resistor r=8.54496 //w=0.367 //l=0.245 //layer=li \
 //thickness=0.1 //x=15.905 //y=7.585 //x2=15.66 //y2=7.585
r1726 (  275 907 ) resistor r=4.23183 //w=0.7 //l=0.175 //layer=li \
 //thickness=0.1 //x=15.11 //y=7.41 //x2=15.11 //y2=7.585
r1727 (  275 1005 ) resistor r=33.1979 //w=0.187 //l=0.485 //layer=li \
 //thickness=0.1 //x=15.11 //y=7.41 //x2=15.11 //y2=6.925
r1728 (  272 906 ) resistor r=2.87058 //w=0.35 //l=0.085 //layer=li \
 //thickness=0.1 //x=14.315 //y=7.585 //x2=14.23 //y2=7.585
r1729 (  272 274 ) resistor r=8.19619 //w=0.367 //l=0.235 //layer=li \
 //thickness=0.1 //x=14.315 //y=7.585 //x2=14.55 //y2=7.585
r1730 (  271 907 ) resistor r=2.87058 //w=0.35 //l=0.085 //layer=li \
 //thickness=0.1 //x=15.025 //y=7.585 //x2=15.11 //y2=7.585
r1731 (  271 274 ) resistor r=16.5668 //w=0.367 //l=0.475 //layer=li \
 //thickness=0.1 //x=15.025 //y=7.585 //x2=14.55 //y2=7.585
r1732 (  265 906 ) resistor r=4.23183 //w=0.7 //l=0.175 //layer=li \
 //thickness=0.1 //x=14.23 //y=7.41 //x2=14.23 //y2=7.585
r1733 (  265 1004 ) resistor r=56.4706 //w=0.187 //l=0.825 //layer=li \
 //thickness=0.1 //x=14.23 //y=7.41 //x2=14.23 //y2=6.585
r1734 (  264 905 ) resistor r=5.29055 //w=0.35 //l=0.17 //layer=li \
 //thickness=0.1 //x=13.61 //y=7.585 //x2=13.44 //y2=7.585
r1735 (  263 906 ) resistor r=2.87058 //w=0.35 //l=0.085 //layer=li \
 //thickness=0.1 //x=14.145 //y=7.585 //x2=14.23 //y2=7.585
r1736 (  263 264 ) resistor r=18.6594 //w=0.367 //l=0.535 //layer=li \
 //thickness=0.1 //x=14.145 //y=7.585 //x2=13.61 //y2=7.585
r1737 (  258 904 ) resistor r=2.87058 //w=0.35 //l=0.085 //layer=li \
 //thickness=0.1 //x=12.445 //y=7.585 //x2=12.36 //y2=7.585
r1738 (  258 260 ) resistor r=21.7984 //w=0.367 //l=0.625 //layer=li \
 //thickness=0.1 //x=12.445 //y=7.585 //x2=13.07 //y2=7.585
r1739 (  257 905 ) resistor r=5.29055 //w=0.35 //l=0.17 //layer=li \
 //thickness=0.1 //x=13.27 //y=7.585 //x2=13.44 //y2=7.585
r1740 (  257 260 ) resistor r=6.97548 //w=0.367 //l=0.2 //layer=li \
 //thickness=0.1 //x=13.27 //y=7.585 //x2=13.07 //y2=7.585
r1741 (  251 904 ) resistor r=4.23183 //w=0.7 //l=0.175 //layer=li \
 //thickness=0.1 //x=12.36 //y=7.41 //x2=12.36 //y2=7.585
r1742 (  251 1003 ) resistor r=33.1979 //w=0.187 //l=0.485 //layer=li \
 //thickness=0.1 //x=12.36 //y=7.41 //x2=12.36 //y2=6.925
r1743 (  248 903 ) resistor r=2.87058 //w=0.35 //l=0.085 //layer=li \
 //thickness=0.1 //x=11.565 //y=7.585 //x2=11.48 //y2=7.585
r1744 (  248 250 ) resistor r=13.7766 //w=0.367 //l=0.395 //layer=li \
 //thickness=0.1 //x=11.565 //y=7.585 //x2=11.96 //y2=7.585
r1745 (  247 904 ) resistor r=2.87058 //w=0.35 //l=0.085 //layer=li \
 //thickness=0.1 //x=12.275 //y=7.585 //x2=12.36 //y2=7.585
r1746 (  247 250 ) resistor r=10.9864 //w=0.367 //l=0.315 //layer=li \
 //thickness=0.1 //x=12.275 //y=7.585 //x2=11.96 //y2=7.585
r1747 (  241 903 ) resistor r=4.23183 //w=0.7 //l=0.175 //layer=li \
 //thickness=0.1 //x=11.48 //y=7.41 //x2=11.48 //y2=7.585
r1748 (  241 1002 ) resistor r=33.1979 //w=0.187 //l=0.485 //layer=li \
 //thickness=0.1 //x=11.48 //y=7.41 //x2=11.48 //y2=6.925
r1749 (  238 902 ) resistor r=2.87058 //w=0.35 //l=0.085 //layer=li \
 //thickness=0.1 //x=10.685 //y=7.585 //x2=10.6 //y2=7.585
r1750 (  238 240 ) resistor r=5.75477 //w=0.367 //l=0.165 //layer=li \
 //thickness=0.1 //x=10.685 //y=7.585 //x2=10.85 //y2=7.585
r1751 (  237 903 ) resistor r=2.87058 //w=0.35 //l=0.085 //layer=li \
 //thickness=0.1 //x=11.395 //y=7.585 //x2=11.48 //y2=7.585
r1752 (  237 240 ) resistor r=19.0082 //w=0.367 //l=0.545 //layer=li \
 //thickness=0.1 //x=11.395 //y=7.585 //x2=10.85 //y2=7.585
r1753 (  231 902 ) resistor r=4.23183 //w=0.7 //l=0.175 //layer=li \
 //thickness=0.1 //x=10.6 //y=7.41 //x2=10.6 //y2=7.585
r1754 (  231 1001 ) resistor r=33.1979 //w=0.187 //l=0.485 //layer=li \
 //thickness=0.1 //x=10.6 //y=7.41 //x2=10.6 //y2=6.925
r1755 (  230 901 ) resistor r=2.87058 //w=0.35 //l=0.085 //layer=li \
 //thickness=0.1 //x=9.805 //y=7.585 //x2=9.72 //y2=7.585
r1756 (  229 902 ) resistor r=2.87058 //w=0.35 //l=0.085 //layer=li \
 //thickness=0.1 //x=10.515 //y=7.585 //x2=10.6 //y2=7.585
r1757 (  229 230 ) resistor r=24.7629 //w=0.367 //l=0.71 //layer=li \
 //thickness=0.1 //x=10.515 //y=7.585 //x2=9.805 //y2=7.585
r1758 (  223 901 ) resistor r=4.23183 //w=0.7 //l=0.175 //layer=li \
 //thickness=0.1 //x=9.72 //y=7.41 //x2=9.72 //y2=7.585
r1759 (  223 1000 ) resistor r=56.4706 //w=0.187 //l=0.825 //layer=li \
 //thickness=0.1 //x=9.72 //y=7.41 //x2=9.72 //y2=6.585
r1760 (  222 899 ) resistor r=5.29055 //w=0.35 //l=0.17 //layer=li \
 //thickness=0.1 //x=8.8 //y=7.585 //x2=8.63 //y2=7.585
r1761 (  221 901 ) resistor r=2.87058 //w=0.35 //l=0.085 //layer=li \
 //thickness=0.1 //x=9.635 //y=7.585 //x2=9.72 //y2=7.585
r1762 (  221 222 ) resistor r=29.1226 //w=0.367 //l=0.835 //layer=li \
 //thickness=0.1 //x=9.635 //y=7.585 //x2=8.8 //y2=7.585
r1763 (  216 898 ) resistor r=2.87058 //w=0.35 //l=0.085 //layer=li \
 //thickness=0.1 //x=7.635 //y=7.585 //x2=7.55 //y2=7.585
r1764 (  216 218 ) resistor r=21.7984 //w=0.367 //l=0.625 //layer=li \
 //thickness=0.1 //x=7.635 //y=7.585 //x2=8.26 //y2=7.585
r1765 (  215 899 ) resistor r=5.29055 //w=0.35 //l=0.17 //layer=li \
 //thickness=0.1 //x=8.46 //y=7.585 //x2=8.63 //y2=7.585
r1766 (  215 218 ) resistor r=6.97548 //w=0.367 //l=0.2 //layer=li \
 //thickness=0.1 //x=8.46 //y=7.585 //x2=8.26 //y2=7.585
r1767 (  209 898 ) resistor r=4.23183 //w=0.7 //l=0.175 //layer=li \
 //thickness=0.1 //x=7.55 //y=7.41 //x2=7.55 //y2=7.585
r1768 (  209 999 ) resistor r=33.1979 //w=0.187 //l=0.485 //layer=li \
 //thickness=0.1 //x=7.55 //y=7.41 //x2=7.55 //y2=6.925
r1769 (  206 897 ) resistor r=2.87058 //w=0.35 //l=0.085 //layer=li \
 //thickness=0.1 //x=6.755 //y=7.585 //x2=6.67 //y2=7.585
r1770 (  206 208 ) resistor r=13.7766 //w=0.367 //l=0.395 //layer=li \
 //thickness=0.1 //x=6.755 //y=7.585 //x2=7.15 //y2=7.585
r1771 (  205 898 ) resistor r=2.87058 //w=0.35 //l=0.085 //layer=li \
 //thickness=0.1 //x=7.465 //y=7.585 //x2=7.55 //y2=7.585
r1772 (  205 208 ) resistor r=10.9864 //w=0.367 //l=0.315 //layer=li \
 //thickness=0.1 //x=7.465 //y=7.585 //x2=7.15 //y2=7.585
r1773 (  199 897 ) resistor r=4.23183 //w=0.7 //l=0.175 //layer=li \
 //thickness=0.1 //x=6.67 //y=7.41 //x2=6.67 //y2=7.585
r1774 (  199 998 ) resistor r=33.1979 //w=0.187 //l=0.485 //layer=li \
 //thickness=0.1 //x=6.67 //y=7.41 //x2=6.67 //y2=6.925
r1775 (  196 896 ) resistor r=2.87058 //w=0.35 //l=0.085 //layer=li \
 //thickness=0.1 //x=5.875 //y=7.585 //x2=5.79 //y2=7.585
r1776 (  196 198 ) resistor r=5.75477 //w=0.367 //l=0.165 //layer=li \
 //thickness=0.1 //x=5.875 //y=7.585 //x2=6.04 //y2=7.585
r1777 (  195 897 ) resistor r=2.87058 //w=0.35 //l=0.085 //layer=li \
 //thickness=0.1 //x=6.585 //y=7.585 //x2=6.67 //y2=7.585
r1778 (  195 198 ) resistor r=19.0082 //w=0.367 //l=0.545 //layer=li \
 //thickness=0.1 //x=6.585 //y=7.585 //x2=6.04 //y2=7.585
r1779 (  189 896 ) resistor r=4.23183 //w=0.7 //l=0.175 //layer=li \
 //thickness=0.1 //x=5.79 //y=7.41 //x2=5.79 //y2=7.585
r1780 (  189 997 ) resistor r=33.1979 //w=0.187 //l=0.485 //layer=li \
 //thickness=0.1 //x=5.79 //y=7.41 //x2=5.79 //y2=6.925
r1781 (  188 895 ) resistor r=2.87058 //w=0.35 //l=0.085 //layer=li \
 //thickness=0.1 //x=4.995 //y=7.585 //x2=4.91 //y2=7.585
r1782 (  187 896 ) resistor r=2.87058 //w=0.35 //l=0.085 //layer=li \
 //thickness=0.1 //x=5.705 //y=7.585 //x2=5.79 //y2=7.585
r1783 (  187 188 ) resistor r=24.7629 //w=0.367 //l=0.71 //layer=li \
 //thickness=0.1 //x=5.705 //y=7.585 //x2=4.995 //y2=7.585
r1784 (  181 895 ) resistor r=4.23183 //w=0.7 //l=0.175 //layer=li \
 //thickness=0.1 //x=4.91 //y=7.41 //x2=4.91 //y2=7.585
r1785 (  181 996 ) resistor r=56.4706 //w=0.187 //l=0.825 //layer=li \
 //thickness=0.1 //x=4.91 //y=7.41 //x2=4.91 //y2=6.585
r1786 (  180 893 ) resistor r=5.29055 //w=0.35 //l=0.17 //layer=li \
 //thickness=0.1 //x=3.99 //y=7.585 //x2=3.82 //y2=7.585
r1787 (  179 895 ) resistor r=2.87058 //w=0.35 //l=0.085 //layer=li \
 //thickness=0.1 //x=4.825 //y=7.585 //x2=4.91 //y2=7.585
r1788 (  179 180 ) resistor r=29.1226 //w=0.367 //l=0.835 //layer=li \
 //thickness=0.1 //x=4.825 //y=7.585 //x2=3.99 //y2=7.585
r1789 (  174 892 ) resistor r=2.87058 //w=0.35 //l=0.085 //layer=li \
 //thickness=0.1 //x=3.125 //y=7.585 //x2=3.04 //y2=7.585
r1790 (  174 176 ) resistor r=11.3351 //w=0.367 //l=0.325 //layer=li \
 //thickness=0.1 //x=3.125 //y=7.585 //x2=3.45 //y2=7.585
r1791 (  173 893 ) resistor r=5.29055 //w=0.35 //l=0.17 //layer=li \
 //thickness=0.1 //x=3.65 //y=7.585 //x2=3.82 //y2=7.585
r1792 (  173 176 ) resistor r=6.97548 //w=0.367 //l=0.2 //layer=li \
 //thickness=0.1 //x=3.65 //y=7.585 //x2=3.45 //y2=7.585
r1793 (  167 892 ) resistor r=4.23183 //w=0.7 //l=0.175 //layer=li \
 //thickness=0.1 //x=3.04 //y=7.41 //x2=3.04 //y2=7.585
r1794 (  167 995 ) resistor r=33.1979 //w=0.187 //l=0.485 //layer=li \
 //thickness=0.1 //x=3.04 //y=7.41 //x2=3.04 //y2=6.925
r1795 (  164 891 ) resistor r=2.87058 //w=0.35 //l=0.085 //layer=li \
 //thickness=0.1 //x=2.245 //y=7.585 //x2=2.16 //y2=7.585
r1796 (  164 166 ) resistor r=3.31335 //w=0.367 //l=0.095 //layer=li \
 //thickness=0.1 //x=2.245 //y=7.585 //x2=2.34 //y2=7.585
r1797 (  163 892 ) resistor r=2.87058 //w=0.35 //l=0.085 //layer=li \
 //thickness=0.1 //x=2.955 //y=7.585 //x2=3.04 //y2=7.585
r1798 (  163 166 ) resistor r=21.4496 //w=0.367 //l=0.615 //layer=li \
 //thickness=0.1 //x=2.955 //y=7.585 //x2=2.34 //y2=7.585
r1799 (  157 891 ) resistor r=4.23183 //w=0.7 //l=0.175 //layer=li \
 //thickness=0.1 //x=2.16 //y=7.41 //x2=2.16 //y2=7.585
r1800 (  157 994 ) resistor r=33.1979 //w=0.187 //l=0.485 //layer=li \
 //thickness=0.1 //x=2.16 //y=7.41 //x2=2.16 //y2=6.925
r1801 (  156 890 ) resistor r=2.87058 //w=0.35 //l=0.085 //layer=li \
 //thickness=0.1 //x=1.365 //y=7.585 //x2=1.28 //y2=7.585
r1802 (  155 891 ) resistor r=2.87058 //w=0.35 //l=0.085 //layer=li \
 //thickness=0.1 //x=2.075 //y=7.585 //x2=2.16 //y2=7.585
r1803 (  155 156 ) resistor r=24.7629 //w=0.367 //l=0.71 //layer=li \
 //thickness=0.1 //x=2.075 //y=7.585 //x2=1.365 //y2=7.585
r1804 (  149 890 ) resistor r=4.23183 //w=0.7 //l=0.175 //layer=li \
 //thickness=0.1 //x=1.28 //y=7.41 //x2=1.28 //y2=7.585
r1805 (  149 993 ) resistor r=56.4706 //w=0.187 //l=0.825 //layer=li \
 //thickness=0.1 //x=1.28 //y=7.41 //x2=1.28 //y2=6.585
r1806 (  143 992 ) resistor r=4.65 //w=0.17 //l=0.34 //layer=mcon //count=2 \
 //x=85.22 //y=7.58 //x2=85.22 //y2=7.58
r1807 (  141 990 ) resistor r=3.1 //w=0.17 //l=0.51 //layer=mcon //count=3 \
 //x=84.48 //y=7.58 //x2=84.48 //y2=7.58
r1808 (  141 143 ) resistor r=0.297428 //w=0.311 //l=0.74 //layer=m1 \
 //thickness=0.36 //x=84.48 //y=7.585 //x2=85.22 //y2=7.585
r1809 (  139 866 ) resistor r=3.1 //w=0.17 //l=0.51 //layer=mcon //count=3 \
 //x=83 //y=7.58 //x2=83 //y2=7.58
r1810 (  139 141 ) resistor r=0.594855 //w=0.311 //l=1.48 //layer=m1 \
 //thickness=0.36 //x=83 //y=7.585 //x2=84.48 //y2=7.585
r1811 (  137 864 ) resistor r=3.1 //w=0.17 //l=0.51 //layer=mcon //count=3 \
 //x=81.89 //y=7.58 //x2=81.89 //y2=7.58
r1812 (  137 139 ) resistor r=0.446141 //w=0.311 //l=1.11 //layer=m1 \
 //thickness=0.36 //x=81.89 //y=7.585 //x2=83 //y2=7.585
r1813 (  135 862 ) resistor r=3.1 //w=0.17 //l=0.51 //layer=mcon //count=3 \
 //x=80.78 //y=7.58 //x2=80.78 //y2=7.58
r1814 (  135 137 ) resistor r=0.446141 //w=0.311 //l=1.11 //layer=m1 \
 //thickness=0.36 //x=80.78 //y=7.585 //x2=81.89 //y2=7.585
r1815 (  133 856 ) resistor r=3.1 //w=0.17 //l=0.51 //layer=mcon //count=3 \
 //x=79.3 //y=7.58 //x2=79.3 //y2=7.58
r1816 (  133 135 ) resistor r=0.594855 //w=0.311 //l=1.48 //layer=m1 \
 //thickness=0.36 //x=79.3 //y=7.585 //x2=80.78 //y2=7.585
r1817 (  131 854 ) resistor r=3.1 //w=0.17 //l=0.51 //layer=mcon //count=3 \
 //x=78.19 //y=7.58 //x2=78.19 //y2=7.58
r1818 (  131 133 ) resistor r=0.446141 //w=0.311 //l=1.11 //layer=m1 \
 //thickness=0.36 //x=78.19 //y=7.585 //x2=79.3 //y2=7.585
r1819 (  129 848 ) resistor r=3.1 //w=0.17 //l=0.51 //layer=mcon //count=3 \
 //x=76.71 //y=7.58 //x2=76.71 //y2=7.58
r1820 (  129 131 ) resistor r=0.594855 //w=0.311 //l=1.48 //layer=m1 \
 //thickness=0.36 //x=76.71 //y=7.585 //x2=78.19 //y2=7.585
r1821 (  127 838 ) resistor r=3.1 //w=0.17 //l=0.51 //layer=mcon //count=3 \
 //x=75.6 //y=7.58 //x2=75.6 //y2=7.58
r1822 (  127 129 ) resistor r=0.446141 //w=0.311 //l=1.11 //layer=m1 \
 //thickness=0.36 //x=75.6 //y=7.585 //x2=76.71 //y2=7.585
r1823 (  125 983 ) resistor r=3.1 //w=0.17 //l=0.51 //layer=mcon //count=3 \
 //x=74.49 //y=7.58 //x2=74.49 //y2=7.58
r1824 (  125 127 ) resistor r=0.446141 //w=0.311 //l=1.11 //layer=m1 \
 //thickness=0.36 //x=74.49 //y=7.585 //x2=75.6 //y2=7.585
r1825 (  123 816 ) resistor r=3.1 //w=0.17 //l=0.51 //layer=mcon //count=3 \
 //x=73.01 //y=7.58 //x2=73.01 //y2=7.58
r1826 (  123 125 ) resistor r=0.594855 //w=0.311 //l=1.48 //layer=m1 \
 //thickness=0.36 //x=73.01 //y=7.585 //x2=74.49 //y2=7.585
r1827 (  121 806 ) resistor r=3.1 //w=0.17 //l=0.51 //layer=mcon //count=3 \
 //x=71.9 //y=7.58 //x2=71.9 //y2=7.58
r1828 (  121 123 ) resistor r=0.446141 //w=0.311 //l=1.11 //layer=m1 \
 //thickness=0.36 //x=71.9 //y=7.585 //x2=73.01 //y2=7.585
r1829 (  119 788 ) resistor r=3.1 //w=0.17 //l=0.51 //layer=mcon //count=3 \
 //x=70.79 //y=7.58 //x2=70.79 //y2=7.58
r1830 (  119 121 ) resistor r=0.446141 //w=0.311 //l=1.11 //layer=m1 \
 //thickness=0.36 //x=70.79 //y=7.585 //x2=71.9 //y2=7.585
r1831 (  117 778 ) resistor r=3.1 //w=0.17 //l=0.51 //layer=mcon //count=3 \
 //x=69.68 //y=7.58 //x2=69.68 //y2=7.58
r1832 (  117 119 ) resistor r=0.446141 //w=0.311 //l=1.11 //layer=m1 \
 //thickness=0.36 //x=69.68 //y=7.585 //x2=70.79 //y2=7.585
r1833 (  115 975 ) resistor r=3.1 //w=0.17 //l=0.51 //layer=mcon //count=3 \
 //x=68.2 //y=7.58 //x2=68.2 //y2=7.58
r1834 (  115 117 ) resistor r=0.594855 //w=0.311 //l=1.48 //layer=m1 \
 //thickness=0.36 //x=68.2 //y=7.585 //x2=69.68 //y2=7.585
r1835 (  113 756 ) resistor r=3.1 //w=0.17 //l=0.51 //layer=mcon //count=3 \
 //x=67.09 //y=7.58 //x2=67.09 //y2=7.58
r1836 (  113 115 ) resistor r=0.446141 //w=0.311 //l=1.11 //layer=m1 \
 //thickness=0.36 //x=67.09 //y=7.585 //x2=68.2 //y2=7.585
r1837 (  111 746 ) resistor r=3.1 //w=0.17 //l=0.51 //layer=mcon //count=3 \
 //x=65.98 //y=7.58 //x2=65.98 //y2=7.58
r1838 (  111 113 ) resistor r=0.446141 //w=0.311 //l=1.11 //layer=m1 \
 //thickness=0.36 //x=65.98 //y=7.585 //x2=67.09 //y2=7.585
r1839 (  109 732 ) resistor r=3.1 //w=0.17 //l=0.51 //layer=mcon //count=3 \
 //x=64.5 //y=7.58 //x2=64.5 //y2=7.58
r1840 (  109 111 ) resistor r=0.594855 //w=0.311 //l=1.48 //layer=m1 \
 //thickness=0.36 //x=64.5 //y=7.585 //x2=65.98 //y2=7.585
r1841 (  107 722 ) resistor r=3.1 //w=0.17 //l=0.51 //layer=mcon //count=3 \
 //x=63.39 //y=7.58 //x2=63.39 //y2=7.58
r1842 (  107 109 ) resistor r=0.446141 //w=0.311 //l=1.11 //layer=m1 \
 //thickness=0.36 //x=63.39 //y=7.585 //x2=64.5 //y2=7.585
r1843 (  105 708 ) resistor r=3.1 //w=0.17 //l=0.51 //layer=mcon //count=3 \
 //x=61.91 //y=7.58 //x2=61.91 //y2=7.58
r1844 (  105 107 ) resistor r=0.594855 //w=0.311 //l=1.48 //layer=m1 \
 //thickness=0.36 //x=61.91 //y=7.585 //x2=63.39 //y2=7.585
r1845 (  103 698 ) resistor r=3.1 //w=0.17 //l=0.51 //layer=mcon //count=3 \
 //x=60.8 //y=7.58 //x2=60.8 //y2=7.58
r1846 (  103 105 ) resistor r=0.446141 //w=0.311 //l=1.11 //layer=m1 \
 //thickness=0.36 //x=60.8 //y=7.585 //x2=61.91 //y2=7.585
r1847 (  101 688 ) resistor r=3.1 //w=0.17 //l=0.51 //layer=mcon //count=3 \
 //x=59.69 //y=7.58 //x2=59.69 //y2=7.58
r1848 (  101 103 ) resistor r=0.446141 //w=0.311 //l=1.11 //layer=m1 \
 //thickness=0.36 //x=59.69 //y=7.585 //x2=60.8 //y2=7.585
r1849 (  99 963 ) resistor r=3.1 //w=0.17 //l=0.51 //layer=mcon //count=3 \
 //x=58.58 //y=7.58 //x2=58.58 //y2=7.58
r1850 (  99 101 ) resistor r=0.446141 //w=0.311 //l=1.11 //layer=m1 \
 //thickness=0.36 //x=58.58 //y=7.585 //x2=59.69 //y2=7.585
r1851 (  97 666 ) resistor r=3.1 //w=0.17 //l=0.51 //layer=mcon //count=3 \
 //x=57.1 //y=7.58 //x2=57.1 //y2=7.58
r1852 (  97 99 ) resistor r=0.594855 //w=0.311 //l=1.48 //layer=m1 \
 //thickness=0.36 //x=57.1 //y=7.585 //x2=58.58 //y2=7.585
r1853 (  95 656 ) resistor r=3.1 //w=0.17 //l=0.51 //layer=mcon //count=3 \
 //x=55.99 //y=7.58 //x2=55.99 //y2=7.58
r1854 (  95 97 ) resistor r=0.446141 //w=0.311 //l=1.11 //layer=m1 \
 //thickness=0.36 //x=55.99 //y=7.585 //x2=57.1 //y2=7.585
r1855 (  93 646 ) resistor r=3.1 //w=0.17 //l=0.51 //layer=mcon //count=3 \
 //x=54.88 //y=7.58 //x2=54.88 //y2=7.58
r1856 (  93 95 ) resistor r=0.446141 //w=0.311 //l=1.11 //layer=m1 \
 //thickness=0.36 //x=54.88 //y=7.585 //x2=55.99 //y2=7.585
r1857 (  91 957 ) resistor r=3.1 //w=0.17 //l=0.51 //layer=mcon //count=3 \
 //x=53.77 //y=7.58 //x2=53.77 //y2=7.58
r1858 (  91 93 ) resistor r=0.446141 //w=0.311 //l=1.11 //layer=m1 \
 //thickness=0.36 //x=53.77 //y=7.585 //x2=54.88 //y2=7.585
r1859 (  89 624 ) resistor r=3.1 //w=0.17 //l=0.51 //layer=mcon //count=3 \
 //x=52.29 //y=7.58 //x2=52.29 //y2=7.58
r1860 (  89 91 ) resistor r=0.594855 //w=0.311 //l=1.48 //layer=m1 \
 //thickness=0.36 //x=52.29 //y=7.585 //x2=53.77 //y2=7.585
r1861 (  87 614 ) resistor r=3.1 //w=0.17 //l=0.51 //layer=mcon //count=3 \
 //x=51.18 //y=7.58 //x2=51.18 //y2=7.58
r1862 (  87 89 ) resistor r=0.446141 //w=0.311 //l=1.11 //layer=m1 \
 //thickness=0.36 //x=51.18 //y=7.585 //x2=52.29 //y2=7.585
r1863 (  85 952 ) resistor r=3.1 //w=0.17 //l=0.51 //layer=mcon //count=3 \
 //x=50.07 //y=7.58 //x2=50.07 //y2=7.58
r1864 (  85 87 ) resistor r=0.446141 //w=0.311 //l=1.11 //layer=m1 \
 //thickness=0.36 //x=50.07 //y=7.585 //x2=51.18 //y2=7.585
r1865 (  83 592 ) resistor r=3.1 //w=0.17 //l=0.51 //layer=mcon //count=3 \
 //x=48.59 //y=7.58 //x2=48.59 //y2=7.58
r1866 (  83 85 ) resistor r=0.594855 //w=0.311 //l=1.48 //layer=m1 \
 //thickness=0.36 //x=48.59 //y=7.585 //x2=50.07 //y2=7.585
r1867 (  81 582 ) resistor r=3.1 //w=0.17 //l=0.51 //layer=mcon //count=3 \
 //x=47.48 //y=7.58 //x2=47.48 //y2=7.58
r1868 (  81 83 ) resistor r=0.446141 //w=0.311 //l=1.11 //layer=m1 \
 //thickness=0.36 //x=47.48 //y=7.585 //x2=48.59 //y2=7.585
r1869 (  79 564 ) resistor r=3.1 //w=0.17 //l=0.51 //layer=mcon //count=3 \
 //x=46.37 //y=7.58 //x2=46.37 //y2=7.58
r1870 (  79 81 ) resistor r=0.446141 //w=0.311 //l=1.11 //layer=m1 \
 //thickness=0.36 //x=46.37 //y=7.585 //x2=47.48 //y2=7.585
r1871 (  77 554 ) resistor r=3.1 //w=0.17 //l=0.51 //layer=mcon //count=3 \
 //x=45.26 //y=7.58 //x2=45.26 //y2=7.58
r1872 (  77 79 ) resistor r=0.446141 //w=0.311 //l=1.11 //layer=m1 \
 //thickness=0.36 //x=45.26 //y=7.585 //x2=46.37 //y2=7.585
r1873 (  75 944 ) resistor r=3.1 //w=0.17 //l=0.51 //layer=mcon //count=3 \
 //x=43.78 //y=7.58 //x2=43.78 //y2=7.58
r1874 (  75 77 ) resistor r=0.594855 //w=0.311 //l=1.48 //layer=m1 \
 //thickness=0.36 //x=43.78 //y=7.585 //x2=45.26 //y2=7.585
r1875 (  72 532 ) resistor r=3.1 //w=0.17 //l=0.51 //layer=mcon //count=3 \
 //x=42.67 //y=7.58 //x2=42.67 //y2=7.58
r1876 (  70 522 ) resistor r=3.1 //w=0.17 //l=0.51 //layer=mcon //count=3 \
 //x=41.56 //y=7.58 //x2=41.56 //y2=7.58
r1877 (  70 72 ) resistor r=0.446141 //w=0.311 //l=1.11 //layer=m1 \
 //thickness=0.36 //x=41.56 //y=7.585 //x2=42.67 //y2=7.585
r1878 (  68 508 ) resistor r=3.1 //w=0.17 //l=0.51 //layer=mcon //count=3 \
 //x=40.08 //y=7.58 //x2=40.08 //y2=7.58
r1879 (  68 70 ) resistor r=0.594855 //w=0.311 //l=1.48 //layer=m1 \
 //thickness=0.36 //x=40.08 //y=7.585 //x2=41.56 //y2=7.585
r1880 (  66 498 ) resistor r=3.1 //w=0.17 //l=0.51 //layer=mcon //count=3 \
 //x=38.97 //y=7.58 //x2=38.97 //y2=7.58
r1881 (  66 68 ) resistor r=0.446141 //w=0.311 //l=1.11 //layer=m1 \
 //thickness=0.36 //x=38.97 //y=7.585 //x2=40.08 //y2=7.585
r1882 (  64 484 ) resistor r=3.1 //w=0.17 //l=0.51 //layer=mcon //count=3 \
 //x=37.49 //y=7.58 //x2=37.49 //y2=7.58
r1883 (  64 66 ) resistor r=0.594855 //w=0.311 //l=1.48 //layer=m1 \
 //thickness=0.36 //x=37.49 //y=7.585 //x2=38.97 //y2=7.585
r1884 (  62 474 ) resistor r=3.1 //w=0.17 //l=0.51 //layer=mcon //count=3 \
 //x=36.38 //y=7.58 //x2=36.38 //y2=7.58
r1885 (  62 64 ) resistor r=0.446141 //w=0.311 //l=1.11 //layer=m1 \
 //thickness=0.36 //x=36.38 //y=7.585 //x2=37.49 //y2=7.585
r1886 (  60 464 ) resistor r=3.1 //w=0.17 //l=0.51 //layer=mcon //count=3 \
 //x=35.27 //y=7.58 //x2=35.27 //y2=7.58
r1887 (  60 62 ) resistor r=0.446141 //w=0.311 //l=1.11 //layer=m1 \
 //thickness=0.36 //x=35.27 //y=7.585 //x2=36.38 //y2=7.585
r1888 (  58 932 ) resistor r=3.1 //w=0.17 //l=0.51 //layer=mcon //count=3 \
 //x=34.16 //y=7.58 //x2=34.16 //y2=7.58
r1889 (  58 60 ) resistor r=0.446141 //w=0.311 //l=1.11 //layer=m1 \
 //thickness=0.36 //x=34.16 //y=7.585 //x2=35.27 //y2=7.585
r1890 (  56 442 ) resistor r=3.1 //w=0.17 //l=0.51 //layer=mcon //count=3 \
 //x=32.68 //y=7.58 //x2=32.68 //y2=7.58
r1891 (  56 58 ) resistor r=0.594855 //w=0.311 //l=1.48 //layer=m1 \
 //thickness=0.36 //x=32.68 //y=7.585 //x2=34.16 //y2=7.585
r1892 (  54 432 ) resistor r=3.1 //w=0.17 //l=0.51 //layer=mcon //count=3 \
 //x=31.57 //y=7.58 //x2=31.57 //y2=7.58
r1893 (  54 56 ) resistor r=0.446141 //w=0.311 //l=1.11 //layer=m1 \
 //thickness=0.36 //x=31.57 //y=7.585 //x2=32.68 //y2=7.585
r1894 (  52 422 ) resistor r=3.1 //w=0.17 //l=0.51 //layer=mcon //count=3 \
 //x=30.46 //y=7.58 //x2=30.46 //y2=7.58
r1895 (  52 54 ) resistor r=0.446141 //w=0.311 //l=1.11 //layer=m1 \
 //thickness=0.36 //x=30.46 //y=7.585 //x2=31.57 //y2=7.585
r1896 (  50 926 ) resistor r=3.1 //w=0.17 //l=0.51 //layer=mcon //count=3 \
 //x=29.35 //y=7.58 //x2=29.35 //y2=7.58
r1897 (  50 52 ) resistor r=0.446141 //w=0.311 //l=1.11 //layer=m1 \
 //thickness=0.36 //x=29.35 //y=7.585 //x2=30.46 //y2=7.585
r1898 (  48 400 ) resistor r=3.1 //w=0.17 //l=0.51 //layer=mcon //count=3 \
 //x=27.87 //y=7.58 //x2=27.87 //y2=7.58
r1899 (  48 50 ) resistor r=0.594855 //w=0.311 //l=1.48 //layer=m1 \
 //thickness=0.36 //x=27.87 //y=7.585 //x2=29.35 //y2=7.585
r1900 (  46 390 ) resistor r=3.1 //w=0.17 //l=0.51 //layer=mcon //count=3 \
 //x=26.76 //y=7.58 //x2=26.76 //y2=7.58
r1901 (  46 48 ) resistor r=0.446141 //w=0.311 //l=1.11 //layer=m1 \
 //thickness=0.36 //x=26.76 //y=7.585 //x2=27.87 //y2=7.585
r1902 (  44 921 ) resistor r=3.1 //w=0.17 //l=0.51 //layer=mcon //count=3 \
 //x=25.65 //y=7.58 //x2=25.65 //y2=7.58
r1903 (  44 46 ) resistor r=0.446141 //w=0.311 //l=1.11 //layer=m1 \
 //thickness=0.36 //x=25.65 //y=7.585 //x2=26.76 //y2=7.585
r1904 (  42 368 ) resistor r=3.1 //w=0.17 //l=0.51 //layer=mcon //count=3 \
 //x=24.17 //y=7.58 //x2=24.17 //y2=7.58
r1905 (  42 44 ) resistor r=0.594855 //w=0.311 //l=1.48 //layer=m1 \
 //thickness=0.36 //x=24.17 //y=7.585 //x2=25.65 //y2=7.585
r1906 (  40 358 ) resistor r=3.1 //w=0.17 //l=0.51 //layer=mcon //count=3 \
 //x=23.06 //y=7.58 //x2=23.06 //y2=7.58
r1907 (  40 42 ) resistor r=0.446141 //w=0.311 //l=1.11 //layer=m1 \
 //thickness=0.36 //x=23.06 //y=7.585 //x2=24.17 //y2=7.585
r1908 (  38 340 ) resistor r=3.1 //w=0.17 //l=0.51 //layer=mcon //count=3 \
 //x=21.95 //y=7.58 //x2=21.95 //y2=7.58
r1909 (  38 40 ) resistor r=0.446141 //w=0.311 //l=1.11 //layer=m1 \
 //thickness=0.36 //x=21.95 //y=7.585 //x2=23.06 //y2=7.585
r1910 (  36 330 ) resistor r=3.1 //w=0.17 //l=0.51 //layer=mcon //count=3 \
 //x=20.84 //y=7.58 //x2=20.84 //y2=7.58
r1911 (  36 38 ) resistor r=0.446141 //w=0.311 //l=1.11 //layer=m1 \
 //thickness=0.36 //x=20.84 //y=7.585 //x2=21.95 //y2=7.585
r1912 (  34 913 ) resistor r=3.1 //w=0.17 //l=0.51 //layer=mcon //count=3 \
 //x=19.36 //y=7.58 //x2=19.36 //y2=7.58
r1913 (  34 36 ) resistor r=0.594855 //w=0.311 //l=1.48 //layer=m1 \
 //thickness=0.36 //x=19.36 //y=7.585 //x2=20.84 //y2=7.585
r1914 (  32 308 ) resistor r=3.1 //w=0.17 //l=0.51 //layer=mcon //count=3 \
 //x=18.25 //y=7.58 //x2=18.25 //y2=7.58
r1915 (  32 34 ) resistor r=0.446141 //w=0.311 //l=1.11 //layer=m1 \
 //thickness=0.36 //x=18.25 //y=7.585 //x2=19.36 //y2=7.585
r1916 (  30 298 ) resistor r=3.1 //w=0.17 //l=0.51 //layer=mcon //count=3 \
 //x=17.14 //y=7.58 //x2=17.14 //y2=7.58
r1917 (  30 32 ) resistor r=0.446141 //w=0.311 //l=1.11 //layer=m1 \
 //thickness=0.36 //x=17.14 //y=7.585 //x2=18.25 //y2=7.585
r1918 (  28 284 ) resistor r=3.1 //w=0.17 //l=0.51 //layer=mcon //count=3 \
 //x=15.66 //y=7.58 //x2=15.66 //y2=7.58
r1919 (  28 30 ) resistor r=0.594855 //w=0.311 //l=1.48 //layer=m1 \
 //thickness=0.36 //x=15.66 //y=7.585 //x2=17.14 //y2=7.585
r1920 (  26 274 ) resistor r=3.1 //w=0.17 //l=0.51 //layer=mcon //count=3 \
 //x=14.55 //y=7.58 //x2=14.55 //y2=7.58
r1921 (  26 28 ) resistor r=0.446141 //w=0.311 //l=1.11 //layer=m1 \
 //thickness=0.36 //x=14.55 //y=7.585 //x2=15.66 //y2=7.585
r1922 (  24 260 ) resistor r=3.1 //w=0.17 //l=0.51 //layer=mcon //count=3 \
 //x=13.07 //y=7.58 //x2=13.07 //y2=7.58
r1923 (  24 26 ) resistor r=0.594855 //w=0.311 //l=1.48 //layer=m1 \
 //thickness=0.36 //x=13.07 //y=7.585 //x2=14.55 //y2=7.585
r1924 (  22 250 ) resistor r=3.1 //w=0.17 //l=0.51 //layer=mcon //count=3 \
 //x=11.96 //y=7.58 //x2=11.96 //y2=7.58
r1925 (  22 24 ) resistor r=0.446141 //w=0.311 //l=1.11 //layer=m1 \
 //thickness=0.36 //x=11.96 //y=7.585 //x2=13.07 //y2=7.585
r1926 (  20 240 ) resistor r=3.1 //w=0.17 //l=0.51 //layer=mcon //count=3 \
 //x=10.85 //y=7.58 //x2=10.85 //y2=7.58
r1927 (  20 22 ) resistor r=0.446141 //w=0.311 //l=1.11 //layer=m1 \
 //thickness=0.36 //x=10.85 //y=7.585 //x2=11.96 //y2=7.585
r1928 (  18 901 ) resistor r=3.1 //w=0.17 //l=0.51 //layer=mcon //count=3 \
 //x=9.74 //y=7.58 //x2=9.74 //y2=7.58
r1929 (  18 20 ) resistor r=0.446141 //w=0.311 //l=1.11 //layer=m1 \
 //thickness=0.36 //x=9.74 //y=7.585 //x2=10.85 //y2=7.585
r1930 (  16 218 ) resistor r=3.1 //w=0.17 //l=0.51 //layer=mcon //count=3 \
 //x=8.26 //y=7.58 //x2=8.26 //y2=7.58
r1931 (  16 18 ) resistor r=0.594855 //w=0.311 //l=1.48 //layer=m1 \
 //thickness=0.36 //x=8.26 //y=7.585 //x2=9.74 //y2=7.585
r1932 (  14 208 ) resistor r=3.1 //w=0.17 //l=0.51 //layer=mcon //count=3 \
 //x=7.15 //y=7.58 //x2=7.15 //y2=7.58
r1933 (  14 16 ) resistor r=0.446141 //w=0.311 //l=1.11 //layer=m1 \
 //thickness=0.36 //x=7.15 //y=7.585 //x2=8.26 //y2=7.585
r1934 (  12 198 ) resistor r=3.1 //w=0.17 //l=0.51 //layer=mcon //count=3 \
 //x=6.04 //y=7.58 //x2=6.04 //y2=7.58
r1935 (  12 14 ) resistor r=0.446141 //w=0.311 //l=1.11 //layer=m1 \
 //thickness=0.36 //x=6.04 //y=7.585 //x2=7.15 //y2=7.585
r1936 (  10 895 ) resistor r=3.1 //w=0.17 //l=0.51 //layer=mcon //count=3 \
 //x=4.93 //y=7.58 //x2=4.93 //y2=7.58
r1937 (  10 12 ) resistor r=0.446141 //w=0.311 //l=1.11 //layer=m1 \
 //thickness=0.36 //x=4.93 //y=7.585 //x2=6.04 //y2=7.585
r1938 (  8 176 ) resistor r=3.1 //w=0.17 //l=0.51 //layer=mcon //count=3 \
 //x=3.45 //y=7.58 //x2=3.45 //y2=7.58
r1939 (  8 10 ) resistor r=0.594855 //w=0.311 //l=1.48 //layer=m1 \
 //thickness=0.36 //x=3.45 //y=7.585 //x2=4.93 //y2=7.585
r1940 (  6 166 ) resistor r=3.1 //w=0.17 //l=0.51 //layer=mcon //count=3 \
 //x=2.34 //y=7.58 //x2=2.34 //y2=7.58
r1941 (  6 8 ) resistor r=0.446141 //w=0.311 //l=1.11 //layer=m1 \
 //thickness=0.36 //x=2.34 //y=7.585 //x2=3.45 //y2=7.585
r1942 (  3 890 ) resistor r=3.1 //w=0.17 //l=0.51 //layer=mcon //count=3 \
 //x=1.23 //y=7.58 //x2=1.23 //y2=7.58
r1943 (  3 6 ) resistor r=0.446141 //w=0.311 //l=1.11 //layer=m1 \
 //thickness=0.36 //x=1.23 //y=7.585 //x2=2.34 //y2=7.585
r1944 (  1 75 ) resistor r=0.223071 //w=0.311 //l=0.555 //layer=m1 \
 //thickness=0.36 //x=43.225 //y=7.585 //x2=43.78 //y2=7.585
r1945 (  1 72 ) resistor r=0.223071 //w=0.311 //l=0.555 //layer=m1 \
 //thickness=0.36 //x=43.225 //y=7.585 //x2=42.67 //y2=7.585
ends PM_TMRDFFSNQX1\%VDD

subckt PM_TMRDFFSNQX1\%noxref_3 ( 1 2 3 4 17 18 29 31 32 36 38 46 53 54 55 56 \
 57 58 59 60 61 62 63 64 66 72 73 74 75 79 80 81 82 83 85 91 92 93 94 114 116 \
 117 )
c244 ( 117 0 ) capacitor c=0.0220291f //x=2.455 //y=5.2
c245 ( 116 0 ) capacitor c=0.0217503f //x=1.575 //y=5.2
c246 ( 114 0 ) capacitor c=0.0084702f //x=2.45 //y=1.085
c247 ( 94 0 ) capacitor c=0.0556143f //x=10.015 //y=4.97
c248 ( 93 0 ) capacitor c=0.0293157f //x=10.305 //y=4.97
c249 ( 92 0 ) capacitor c=0.0347816f //x=9.97 //y=1.4
c250 ( 91 0 ) capacitor c=0.0187487f //x=9.97 //y=1.055
c251 ( 85 0 ) capacitor c=0.0137055f //x=9.815 //y=1.555
c252 ( 83 0 ) capacitor c=0.0149861f //x=9.815 //y=0.9
c253 ( 82 0 ) capacitor c=0.0965257f //x=9.44 //y=2.095
c254 ( 81 0 ) capacitor c=0.0229444f //x=9.44 //y=1.71
c255 ( 80 0 ) capacitor c=0.0234352f //x=9.44 //y=1.4
c256 ( 79 0 ) capacitor c=0.0198724f //x=9.44 //y=1.055
c257 ( 75 0 ) capacitor c=0.055995f //x=5.205 //y=4.97
c258 ( 74 0 ) capacitor c=0.0298189f //x=5.495 //y=4.97
c259 ( 73 0 ) capacitor c=0.0347816f //x=5.16 //y=1.4
c260 ( 72 0 ) capacitor c=0.0187487f //x=5.16 //y=1.055
c261 ( 66 0 ) capacitor c=0.0137055f //x=5.005 //y=1.555
c262 ( 64 0 ) capacitor c=0.0149861f //x=5.005 //y=0.9
c263 ( 63 0 ) capacitor c=0.0965245f //x=4.63 //y=2.095
c264 ( 62 0 ) capacitor c=0.0229444f //x=4.63 //y=1.71
c265 ( 61 0 ) capacitor c=0.0234352f //x=4.63 //y=1.4
c266 ( 60 0 ) capacitor c=0.0198724f //x=4.63 //y=1.055
c267 ( 59 0 ) capacitor c=0.110114f //x=10.38 //y=6.2
c268 ( 58 0 ) capacitor c=0.158956f //x=9.94 //y=6.2
c269 ( 57 0 ) capacitor c=0.110114f //x=5.57 //y=6.2
c270 ( 56 0 ) capacitor c=0.158956f //x=5.13 //y=6.2
c271 ( 53 0 ) capacitor c=0.0023043f //x=2.6 //y=5.38
c272 ( 46 0 ) capacitor c=0.100197f //x=9.74 //y=2.26
c273 ( 38 0 ) capacitor c=0.104868f //x=4.93 //y=2.26
c274 ( 36 0 ) capacitor c=0.110973f //x=3.08 //y=2.77
c275 ( 32 0 ) capacitor c=0.00468667f //x=2.725 //y=1.835
c276 ( 31 0 ) capacitor c=0.013082f //x=2.995 //y=1.835
c277 ( 29 0 ) capacitor c=0.0140934f //x=2.995 //y=5.38
c278 ( 18 0 ) capacitor c=0.00295092f //x=1.805 //y=5.38
c279 ( 17 0 ) capacitor c=0.0162034f //x=2.515 //y=5.38
c280 ( 4 0 ) capacitor c=0.00988709f //x=5.195 //y=2.77
c281 ( 3 0 ) capacitor c=0.110983f //x=9.625 //y=2.77
c282 ( 2 0 ) capacitor c=0.0138865f //x=3.195 //y=2.77
c283 ( 1 0 ) capacitor c=0.0386784f //x=4.785 //y=2.77
r284 (  93 95 ) resistor r=26.9307 //w=0.15 //l=0.106066 //layer=ply \
 //thickness=0.18 //x=10.305 //y=4.97 //x2=10.38 //y2=5.045
r285 (  93 94 ) resistor r=148.702 //w=0.094 //l=0.29 //layer=ply \
 //thickness=0.18 //x=10.305 //y=4.97 //x2=10.015 //y2=4.97
r286 (  92 113 ) resistor r=45.1352 //w=0.168 //l=0.173853 //layer=ply \
 //thickness=0.18 //x=9.97 //y=1.4 //x2=9.93 //y2=1.555
r287 (  91 112 ) resistor r=45.1352 //w=0.168 //l=0.173853 //layer=ply \
 //thickness=0.18 //x=9.97 //y=1.055 //x2=9.93 //y2=0.9
r288 (  91 92 ) resistor r=176.904 //w=0.094 //l=0.345 //layer=ply \
 //thickness=0.18 //x=9.97 //y=1.055 //x2=9.97 //y2=1.4
r289 (  88 94 ) resistor r=22.7971 //w=0.269 //l=0.106066 //layer=ply \
 //thickness=0.18 //x=9.94 //y=5.045 //x2=10.015 //y2=4.97
r290 (  88 111 ) resistor r=35.8364 //w=0.269 //l=0.270185 //layer=ply \
 //thickness=0.18 //x=9.94 //y=5.045 //x2=9.74 //y2=4.88
r291 (  86 107 ) resistor r=10.701 //w=0.21 //l=0.115 //layer=ply \
 //thickness=0.18 //x=9.595 //y=1.555 //x2=9.48 //y2=1.555
r292 (  85 113 ) resistor r=5.52526 //w=0.168 //l=0.115 //layer=ply \
 //thickness=0.18 //x=9.815 //y=1.555 //x2=9.93 //y2=1.555
r293 (  84 106 ) resistor r=5.52526 //w=0.168 //l=0.115 //layer=ply \
 //thickness=0.18 //x=9.595 //y=0.9 //x2=9.48 //y2=0.9
r294 (  83 112 ) resistor r=5.52526 //w=0.168 //l=0.115 //layer=ply \
 //thickness=0.18 //x=9.815 //y=0.9 //x2=9.93 //y2=0.9
r295 (  83 84 ) resistor r=112.809 //w=0.094 //l=0.22 //layer=ply \
 //thickness=0.18 //x=9.815 //y=0.9 //x2=9.595 //y2=0.9
r296 (  82 109 ) resistor r=58.7805 //w=0.246 //l=0.373497 //layer=ply \
 //thickness=0.18 //x=9.44 //y=2.095 //x2=9.74 //y2=2.26
r297 (  81 107 ) resistor r=39.5823 //w=0.21 //l=0.173853 //layer=ply \
 //thickness=0.18 //x=9.44 //y=1.71 //x2=9.48 //y2=1.555
r298 (  81 82 ) resistor r=197.415 //w=0.094 //l=0.385 //layer=ply \
 //thickness=0.18 //x=9.44 //y=1.71 //x2=9.44 //y2=2.095
r299 (  80 107 ) resistor r=39.5823 //w=0.21 //l=0.173853 //layer=ply \
 //thickness=0.18 //x=9.44 //y=1.4 //x2=9.48 //y2=1.555
r300 (  79 106 ) resistor r=45.1352 //w=0.168 //l=0.173853 //layer=ply \
 //thickness=0.18 //x=9.44 //y=1.055 //x2=9.48 //y2=0.9
r301 (  79 80 ) resistor r=176.904 //w=0.094 //l=0.345 //layer=ply \
 //thickness=0.18 //x=9.44 //y=1.055 //x2=9.44 //y2=1.4
r302 (  74 76 ) resistor r=26.9307 //w=0.15 //l=0.106066 //layer=ply \
 //thickness=0.18 //x=5.495 //y=4.97 //x2=5.57 //y2=5.045
r303 (  74 75 ) resistor r=148.702 //w=0.094 //l=0.29 //layer=ply \
 //thickness=0.18 //x=5.495 //y=4.97 //x2=5.205 //y2=4.97
r304 (  73 105 ) resistor r=45.1352 //w=0.168 //l=0.173853 //layer=ply \
 //thickness=0.18 //x=5.16 //y=1.4 //x2=5.12 //y2=1.555
r305 (  72 104 ) resistor r=45.1352 //w=0.168 //l=0.173853 //layer=ply \
 //thickness=0.18 //x=5.16 //y=1.055 //x2=5.12 //y2=0.9
r306 (  72 73 ) resistor r=176.904 //w=0.094 //l=0.345 //layer=ply \
 //thickness=0.18 //x=5.16 //y=1.055 //x2=5.16 //y2=1.4
r307 (  69 75 ) resistor r=22.7971 //w=0.269 //l=0.106066 //layer=ply \
 //thickness=0.18 //x=5.13 //y=5.045 //x2=5.205 //y2=4.97
r308 (  69 103 ) resistor r=35.8364 //w=0.269 //l=0.270185 //layer=ply \
 //thickness=0.18 //x=5.13 //y=5.045 //x2=4.93 //y2=4.88
r309 (  67 99 ) resistor r=10.701 //w=0.21 //l=0.115 //layer=ply \
 //thickness=0.18 //x=4.785 //y=1.555 //x2=4.67 //y2=1.555
r310 (  66 105 ) resistor r=5.52526 //w=0.168 //l=0.115 //layer=ply \
 //thickness=0.18 //x=5.005 //y=1.555 //x2=5.12 //y2=1.555
r311 (  65 98 ) resistor r=5.52526 //w=0.168 //l=0.115 //layer=ply \
 //thickness=0.18 //x=4.785 //y=0.9 //x2=4.67 //y2=0.9
r312 (  64 104 ) resistor r=5.52526 //w=0.168 //l=0.115 //layer=ply \
 //thickness=0.18 //x=5.005 //y=0.9 //x2=5.12 //y2=0.9
r313 (  64 65 ) resistor r=112.809 //w=0.094 //l=0.22 //layer=ply \
 //thickness=0.18 //x=5.005 //y=0.9 //x2=4.785 //y2=0.9
r314 (  63 101 ) resistor r=58.7805 //w=0.246 //l=0.373497 //layer=ply \
 //thickness=0.18 //x=4.63 //y=2.095 //x2=4.93 //y2=2.26
r315 (  62 99 ) resistor r=39.5823 //w=0.21 //l=0.173853 //layer=ply \
 //thickness=0.18 //x=4.63 //y=1.71 //x2=4.67 //y2=1.555
r316 (  62 63 ) resistor r=197.415 //w=0.094 //l=0.385 //layer=ply \
 //thickness=0.18 //x=4.63 //y=1.71 //x2=4.63 //y2=2.095
r317 (  61 99 ) resistor r=39.5823 //w=0.21 //l=0.173853 //layer=ply \
 //thickness=0.18 //x=4.63 //y=1.4 //x2=4.67 //y2=1.555
r318 (  60 98 ) resistor r=45.1352 //w=0.168 //l=0.173853 //layer=ply \
 //thickness=0.18 //x=4.63 //y=1.055 //x2=4.67 //y2=0.9
r319 (  60 61 ) resistor r=176.904 //w=0.094 //l=0.345 //layer=ply \
 //thickness=0.18 //x=4.63 //y=1.055 //x2=4.63 //y2=1.4
r320 (  59 95 ) resistor r=592.245 //w=0.094 //l=1.155 //layer=ply \
 //thickness=0.18 //x=10.38 //y=6.2 //x2=10.38 //y2=5.045
r321 (  58 88 ) resistor r=592.245 //w=0.094 //l=1.155 //layer=ply \
 //thickness=0.18 //x=9.94 //y=6.2 //x2=9.94 //y2=5.045
r322 (  57 76 ) resistor r=592.245 //w=0.094 //l=1.155 //layer=ply \
 //thickness=0.18 //x=5.57 //y=6.2 //x2=5.57 //y2=5.045
r323 (  56 69 ) resistor r=592.245 //w=0.094 //l=1.155 //layer=ply \
 //thickness=0.18 //x=5.13 //y=6.2 //x2=5.13 //y2=5.045
r324 (  55 85 ) resistor r=56.4043 //w=0.094 //l=0.11 //layer=ply \
 //thickness=0.18 //x=9.705 //y=1.555 //x2=9.815 //y2=1.555
r325 (  55 86 ) resistor r=56.4043 //w=0.094 //l=0.11 //layer=ply \
 //thickness=0.18 //x=9.705 //y=1.555 //x2=9.595 //y2=1.555
r326 (  54 66 ) resistor r=56.4043 //w=0.094 //l=0.11 //layer=ply \
 //thickness=0.18 //x=4.895 //y=1.555 //x2=5.005 //y2=1.555
r327 (  54 67 ) resistor r=56.4043 //w=0.094 //l=0.11 //layer=ply \
 //thickness=0.18 //x=4.895 //y=1.555 //x2=4.785 //y2=1.555
r328 (  51 111 ) resistor r=152 //w=0.17 //l=0.17 //layer=licon //count=1 \
 //x=9.74 //y=4.88 //x2=9.74 //y2=4.88
r329 (  49 51 ) resistor r=144.428 //w=0.187 //l=2.11 //layer=li \
 //thickness=0.1 //x=9.74 //y=2.77 //x2=9.74 //y2=4.88
r330 (  46 109 ) resistor r=152 //w=0.17 //l=0.17 //layer=licon //count=1 \
 //x=9.74 //y=2.26 //x2=9.74 //y2=2.26
r331 (  46 49 ) resistor r=34.9091 //w=0.187 //l=0.51 //layer=li \
 //thickness=0.1 //x=9.74 //y=2.26 //x2=9.74 //y2=2.77
r332 (  43 103 ) resistor r=152 //w=0.17 //l=0.17 //layer=licon //count=1 \
 //x=4.93 //y=4.88 //x2=4.93 //y2=4.88
r333 (  41 43 ) resistor r=144.77 //w=0.187 //l=2.115 //layer=li \
 //thickness=0.1 //x=4.93 //y=2.765 //x2=4.93 //y2=4.88
r334 (  38 101 ) resistor r=152 //w=0.17 //l=0.17 //layer=licon //count=1 \
 //x=4.93 //y=2.26 //x2=4.93 //y2=2.26
r335 (  38 41 ) resistor r=34.5668 //w=0.187 //l=0.505 //layer=li \
 //thickness=0.1 //x=4.93 //y=2.26 //x2=4.93 //y2=2.765
r336 (  34 36 ) resistor r=172.834 //w=0.187 //l=2.525 //layer=li \
 //thickness=0.1 //x=3.08 //y=5.295 //x2=3.08 //y2=2.77
r337 (  33 36 ) resistor r=58.1818 //w=0.187 //l=0.85 //layer=li \
 //thickness=0.1 //x=3.08 //y=1.92 //x2=3.08 //y2=2.77
r338 (  31 33 ) resistor r=7.15173 //w=0.17 //l=0.120208 //layer=li \
 //thickness=0.1 //x=2.995 //y=1.835 //x2=3.08 //y2=1.92
r339 (  31 32 ) resistor r=18.4813 //w=0.187 //l=0.27 //layer=li \
 //thickness=0.1 //x=2.995 //y=1.835 //x2=2.725 //y2=1.835
r340 (  30 53 ) resistor r=5.4201 //w=0.17 //l=0.085 //layer=li \
 //thickness=0.1 //x=2.685 //y=5.38 //x2=2.6 //y2=5.38
r341 (  29 34 ) resistor r=7.15173 //w=0.17 //l=0.120208 //layer=li \
 //thickness=0.1 //x=2.995 //y=5.38 //x2=3.08 //y2=5.295
r342 (  29 30 ) resistor r=21.2193 //w=0.187 //l=0.31 //layer=li \
 //thickness=0.1 //x=2.995 //y=5.38 //x2=2.685 //y2=5.38
r343 (  25 32 ) resistor r=7.15173 //w=0.17 //l=0.120208 //layer=li \
 //thickness=0.1 //x=2.64 //y=1.75 //x2=2.725 //y2=1.835
r344 (  25 114 ) resistor r=39.016 //w=0.187 //l=0.57 //layer=li \
 //thickness=0.1 //x=2.64 //y=1.75 //x2=2.64 //y2=1.18
r345 (  19 53 ) resistor r=1.40859 //w=0.34 //l=0.085 //layer=li \
 //thickness=0.1 //x=2.6 //y=5.465 //x2=2.6 //y2=5.38
r346 (  19 117 ) resistor r=30.1176 //w=0.187 //l=0.44 //layer=li \
 //thickness=0.1 //x=2.6 //y=5.465 //x2=2.6 //y2=5.905
r347 (  17 53 ) resistor r=5.4201 //w=0.17 //l=0.085 //layer=li \
 //thickness=0.1 //x=2.515 //y=5.38 //x2=2.6 //y2=5.38
r348 (  17 18 ) resistor r=48.5989 //w=0.187 //l=0.71 //layer=li \
 //thickness=0.1 //x=2.515 //y=5.38 //x2=1.805 //y2=5.38
r349 (  11 18 ) resistor r=7.15173 //w=0.17 //l=0.120208 //layer=li \
 //thickness=0.1 //x=1.72 //y=5.465 //x2=1.805 //y2=5.38
r350 (  11 116 ) resistor r=30.1176 //w=0.187 //l=0.44 //layer=li \
 //thickness=0.1 //x=1.72 //y=5.465 //x2=1.72 //y2=5.905
r351 (  10 49 ) resistor r=9.3 //w=0.17 //l=0.17 //layer=mcon //count=1 \
 //x=9.74 //y=2.77 //x2=9.74 //y2=2.77
r352 (  8 41 ) resistor r=9.3 //w=0.17 //l=0.17 //layer=mcon //count=1 \
 //x=4.93 //y=2.765 //x2=4.93 //y2=2.765
r353 (  6 36 ) resistor r=9.3 //w=0.17 //l=0.17 //layer=mcon //count=1 \
 //x=3.08 //y=2.77 //x2=3.08 //y2=2.77
r354 (  4 8 ) resistor r=0.164988 //w=0.206 //l=0.267488 //layer=m1 \
 //thickness=0.36 //x=5.195 //y=2.77 //x2=4.93 //y2=2.765
r355 (  3 10 ) resistor r=0.0717383 //w=0.224 //l=0.115 //layer=m1 \
 //thickness=0.36 //x=9.625 //y=2.77 //x2=9.74 //y2=2.77
r356 (  3 4 ) resistor r=4.2271 //w=0.131 //l=4.43 //layer=m1 //thickness=0.36 \
 //x=9.625 //y=2.77 //x2=5.195 //y2=2.77
r357 (  2 6 ) resistor r=0.0717383 //w=0.224 //l=0.115 //layer=m1 \
 //thickness=0.36 //x=3.195 //y=2.77 //x2=3.08 //y2=2.77
r358 (  1 8 ) resistor r=0.0921728 //w=0.206 //l=0.147479 //layer=m1 \
 //thickness=0.36 //x=4.785 //y=2.77 //x2=4.93 //y2=2.765
r359 (  1 2 ) resistor r=1.51718 //w=0.131 //l=1.59 //layer=m1 \
 //thickness=0.36 //x=4.785 //y=2.77 //x2=3.195 //y2=2.77
ends PM_TMRDFFSNQX1\%noxref_3

subckt PM_TMRDFFSNQX1\%noxref_4 ( 1 2 13 14 21 29 35 36 40 42 49 50 51 52 53 \
 54 55 56 57 61 63 66 67 77 80 82 83 84 )
c164 ( 84 0 ) capacitor c=0.023087f //x=11.775 //y=5.2
c165 ( 83 0 ) capacitor c=0.023519f //x=10.895 //y=5.2
c166 ( 82 0 ) capacitor c=0.0224735f //x=10.015 //y=5.2
c167 ( 80 0 ) capacitor c=0.00872971f //x=12.025 //y=1.095
c168 ( 77 0 ) capacitor c=0.0588816f //x=14.55 //y=4.88
c169 ( 67 0 ) capacitor c=0.0318948f //x=14.885 //y=1.39
c170 ( 66 0 ) capacitor c=0.0187384f //x=14.885 //y=1.045
c171 ( 63 0 ) capacitor c=0.0141798f //x=14.73 //y=1.545
c172 ( 61 0 ) capacitor c=0.0149844f //x=14.73 //y=0.89
c173 ( 57 0 ) capacitor c=0.0813322f //x=14.355 //y=2.095
c174 ( 56 0 ) capacitor c=0.0229267f //x=14.355 //y=1.7
c175 ( 55 0 ) capacitor c=0.0234352f //x=14.355 //y=1.39
c176 ( 54 0 ) capacitor c=0.0199343f //x=14.355 //y=1.045
c177 ( 53 0 ) capacitor c=0.110275f //x=14.89 //y=6.2
c178 ( 52 0 ) capacitor c=0.154305f //x=14.45 //y=6.2
c179 ( 50 0 ) capacitor c=0.00106608f //x=11.92 //y=5.335
c180 ( 49 0 ) capacitor c=0.00207319f //x=11.04 //y=5.335
c181 ( 42 0 ) capacitor c=0.0869732f //x=14.55 //y=2.26
c182 ( 40 0 ) capacitor c=0.107064f //x=12.7 //y=2.77
c183 ( 36 0 ) capacitor c=0.00398962f //x=12.3 //y=1.845
c184 ( 35 0 ) capacitor c=0.0137288f //x=12.615 //y=1.845
c185 ( 29 0 ) capacitor c=0.0284988f //x=12.615 //y=5.335
c186 ( 21 0 ) capacitor c=0.0176454f //x=11.835 //y=5.335
c187 ( 14 0 ) capacitor c=0.00332903f //x=10.245 //y=5.335
c188 ( 13 0 ) capacitor c=0.0148427f //x=10.955 //y=5.335
c189 ( 2 0 ) capacitor c=0.00808366f //x=12.815 //y=2.77
c190 ( 1 0 ) capacitor c=0.0353429f //x=14.435 //y=2.77
r191 (  75 77 ) resistor r=20.6867 //w=0.233 //l=0.1 //layer=ply \
 //thickness=0.18 //x=14.45 //y=4.88 //x2=14.55 //y2=4.88
r192 (  68 77 ) resistor r=70.3348 //w=0.233 //l=0.414367 //layer=ply \
 //thickness=0.18 //x=14.89 //y=5.045 //x2=14.55 //y2=4.88
r193 (  67 79 ) resistor r=45.1352 //w=0.168 //l=0.173853 //layer=ply \
 //thickness=0.18 //x=14.885 //y=1.39 //x2=14.845 //y2=1.545
r194 (  66 78 ) resistor r=45.1352 //w=0.168 //l=0.173853 //layer=ply \
 //thickness=0.18 //x=14.885 //y=1.045 //x2=14.845 //y2=0.89
r195 (  66 67 ) resistor r=176.904 //w=0.094 //l=0.345 //layer=ply \
 //thickness=0.18 //x=14.885 //y=1.045 //x2=14.885 //y2=1.39
r196 (  64 74 ) resistor r=10.701 //w=0.21 //l=0.115 //layer=ply \
 //thickness=0.18 //x=14.51 //y=1.545 //x2=14.395 //y2=1.545
r197 (  63 79 ) resistor r=5.52526 //w=0.168 //l=0.115 //layer=ply \
 //thickness=0.18 //x=14.73 //y=1.545 //x2=14.845 //y2=1.545
r198 (  62 73 ) resistor r=5.52526 //w=0.168 //l=0.115 //layer=ply \
 //thickness=0.18 //x=14.51 //y=0.89 //x2=14.395 //y2=0.89
r199 (  61 78 ) resistor r=5.52526 //w=0.168 //l=0.115 //layer=ply \
 //thickness=0.18 //x=14.73 //y=0.89 //x2=14.845 //y2=0.89
r200 (  61 62 ) resistor r=112.809 //w=0.094 //l=0.22 //layer=ply \
 //thickness=0.18 //x=14.73 //y=0.89 //x2=14.51 //y2=0.89
r201 (  58 75 ) resistor r=13.0941 //w=0.233 //l=0.165 //layer=ply \
 //thickness=0.18 //x=14.45 //y=5.045 //x2=14.45 //y2=4.88
r202 (  57 72 ) resistor r=34.8111 //w=0.27 //l=0.264953 //layer=ply \
 //thickness=0.18 //x=14.355 //y=2.095 //x2=14.55 //y2=2.26
r203 (  56 74 ) resistor r=39.5823 //w=0.21 //l=0.173853 //layer=ply \
 //thickness=0.18 //x=14.355 //y=1.7 //x2=14.395 //y2=1.545
r204 (  56 57 ) resistor r=202.543 //w=0.094 //l=0.395 //layer=ply \
 //thickness=0.18 //x=14.355 //y=1.7 //x2=14.355 //y2=2.095
r205 (  55 74 ) resistor r=39.5823 //w=0.21 //l=0.173853 //layer=ply \
 //thickness=0.18 //x=14.355 //y=1.39 //x2=14.395 //y2=1.545
r206 (  54 73 ) resistor r=45.1352 //w=0.168 //l=0.173853 //layer=ply \
 //thickness=0.18 //x=14.355 //y=1.045 //x2=14.395 //y2=0.89
r207 (  54 55 ) resistor r=176.904 //w=0.094 //l=0.345 //layer=ply \
 //thickness=0.18 //x=14.355 //y=1.045 //x2=14.355 //y2=1.39
r208 (  53 68 ) resistor r=592.245 //w=0.094 //l=1.155 //layer=ply \
 //thickness=0.18 //x=14.89 //y=6.2 //x2=14.89 //y2=5.045
r209 (  52 58 ) resistor r=592.245 //w=0.094 //l=1.155 //layer=ply \
 //thickness=0.18 //x=14.45 //y=6.2 //x2=14.45 //y2=5.045
r210 (  51 63 ) resistor r=56.4043 //w=0.094 //l=0.11 //layer=ply \
 //thickness=0.18 //x=14.62 //y=1.545 //x2=14.73 //y2=1.545
r211 (  51 64 ) resistor r=56.4043 //w=0.094 //l=0.11 //layer=ply \
 //thickness=0.18 //x=14.62 //y=1.545 //x2=14.51 //y2=1.545
r212 (  47 77 ) resistor r=152 //w=0.17 //l=0.17 //layer=licon //count=1 \
 //x=14.55 //y=4.88 //x2=14.55 //y2=4.88
r213 (  45 47 ) resistor r=144.428 //w=0.187 //l=2.11 //layer=li \
 //thickness=0.1 //x=14.55 //y=2.77 //x2=14.55 //y2=4.88
r214 (  42 72 ) resistor r=152 //w=0.17 //l=0.17 //layer=licon //count=1 \
 //x=14.55 //y=2.26 //x2=14.55 //y2=2.26
r215 (  42 45 ) resistor r=34.9091 //w=0.187 //l=0.51 //layer=li \
 //thickness=0.1 //x=14.55 //y=2.26 //x2=14.55 //y2=2.77
r216 (  38 40 ) resistor r=169.754 //w=0.187 //l=2.48 //layer=li \
 //thickness=0.1 //x=12.7 //y=5.25 //x2=12.7 //y2=2.77
r217 (  37 40 ) resistor r=57.4973 //w=0.187 //l=0.84 //layer=li \
 //thickness=0.1 //x=12.7 //y=1.93 //x2=12.7 //y2=2.77
r218 (  35 37 ) resistor r=7.15173 //w=0.17 //l=0.120208 //layer=li \
 //thickness=0.1 //x=12.615 //y=1.845 //x2=12.7 //y2=1.93
r219 (  35 36 ) resistor r=21.5615 //w=0.187 //l=0.315 //layer=li \
 //thickness=0.1 //x=12.615 //y=1.845 //x2=12.3 //y2=1.845
r220 (  31 36 ) resistor r=7.15173 //w=0.17 //l=0.120208 //layer=li \
 //thickness=0.1 //x=12.215 //y=1.76 //x2=12.3 //y2=1.845
r221 (  31 80 ) resistor r=39.016 //w=0.187 //l=0.57 //layer=li \
 //thickness=0.1 //x=12.215 //y=1.76 //x2=12.215 //y2=1.19
r222 (  30 50 ) resistor r=5.4201 //w=0.17 //l=0.085 //layer=li \
 //thickness=0.1 //x=12.005 //y=5.335 //x2=11.92 //y2=5.335
r223 (  29 38 ) resistor r=7.15173 //w=0.17 //l=0.120208 //layer=li \
 //thickness=0.1 //x=12.615 //y=5.335 //x2=12.7 //y2=5.25
r224 (  29 30 ) resistor r=41.754 //w=0.187 //l=0.61 //layer=li \
 //thickness=0.1 //x=12.615 //y=5.335 //x2=12.005 //y2=5.335
r225 (  23 50 ) resistor r=1.40859 //w=0.34 //l=0.085 //layer=li \
 //thickness=0.1 //x=11.92 //y=5.42 //x2=11.92 //y2=5.335
r226 (  23 84 ) resistor r=33.1979 //w=0.187 //l=0.485 //layer=li \
 //thickness=0.1 //x=11.92 //y=5.42 //x2=11.92 //y2=5.905
r227 (  22 49 ) resistor r=5.4201 //w=0.17 //l=0.085 //layer=li \
 //thickness=0.1 //x=11.125 //y=5.335 //x2=11.04 //y2=5.335
r228 (  21 50 ) resistor r=5.4201 //w=0.17 //l=0.085 //layer=li \
 //thickness=0.1 //x=11.835 //y=5.335 //x2=11.92 //y2=5.335
r229 (  21 22 ) resistor r=48.5989 //w=0.187 //l=0.71 //layer=li \
 //thickness=0.1 //x=11.835 //y=5.335 //x2=11.125 //y2=5.335
r230 (  15 49 ) resistor r=1.40859 //w=0.34 //l=0.085 //layer=li \
 //thickness=0.1 //x=11.04 //y=5.42 //x2=11.04 //y2=5.335
r231 (  15 83 ) resistor r=33.1979 //w=0.187 //l=0.485 //layer=li \
 //thickness=0.1 //x=11.04 //y=5.42 //x2=11.04 //y2=5.905
r232 (  13 49 ) resistor r=5.4201 //w=0.17 //l=0.085 //layer=li \
 //thickness=0.1 //x=10.955 //y=5.335 //x2=11.04 //y2=5.335
r233 (  13 14 ) resistor r=48.5989 //w=0.187 //l=0.71 //layer=li \
 //thickness=0.1 //x=10.955 //y=5.335 //x2=10.245 //y2=5.335
r234 (  7 14 ) resistor r=7.15173 //w=0.17 //l=0.120208 //layer=li \
 //thickness=0.1 //x=10.16 //y=5.42 //x2=10.245 //y2=5.335
r235 (  7 82 ) resistor r=33.1979 //w=0.187 //l=0.485 //layer=li \
 //thickness=0.1 //x=10.16 //y=5.42 //x2=10.16 //y2=5.905
r236 (  6 45 ) resistor r=9.3 //w=0.17 //l=0.17 //layer=mcon //count=1 \
 //x=14.55 //y=2.77 //x2=14.55 //y2=2.77
r237 (  4 40 ) resistor r=9.3 //w=0.17 //l=0.17 //layer=mcon //count=1 \
 //x=12.7 //y=2.77 //x2=12.7 //y2=2.77
r238 (  2 4 ) resistor r=0.0717383 //w=0.224 //l=0.115 //layer=m1 \
 //thickness=0.36 //x=12.815 //y=2.77 //x2=12.7 //y2=2.77
r239 (  1 6 ) resistor r=0.0717383 //w=0.224 //l=0.115 //layer=m1 \
 //thickness=0.36 //x=14.435 //y=2.77 //x2=14.55 //y2=2.77
r240 (  1 2 ) resistor r=1.5458 //w=0.131 //l=1.62 //layer=m1 //thickness=0.36 \
 //x=14.435 //y=2.77 //x2=12.815 //y2=2.77
ends PM_TMRDFFSNQX1\%noxref_4

subckt PM_TMRDFFSNQX1\%noxref_5 ( 1 2 3 4 11 13 23 24 31 39 45 46 50 52 61 62 \
 64 65 67 68 69 70 71 72 73 74 75 80 82 84 90 91 92 93 94 95 99 101 104 105 \
 110 111 114 128 131 133 134 135 )
c278 ( 135 0 ) capacitor c=0.023087f //x=6.965 //y=5.2
c279 ( 134 0 ) capacitor c=0.023519f //x=6.085 //y=5.2
c280 ( 133 0 ) capacitor c=0.0224735f //x=5.205 //y=5.2
c281 ( 131 0 ) capacitor c=0.00853354f //x=7.215 //y=1.095
c282 ( 128 0 ) capacitor c=0.0588816f //x=17.88 //y=4.88
c283 ( 114 0 ) capacitor c=0.0331534f //x=2.37 //y=4.88
c284 ( 111 0 ) capacitor c=0.0279499f //x=2.34 //y=2.095
c285 ( 110 0 ) capacitor c=0.0422587f //x=2.34 //y=2.26
c286 ( 105 0 ) capacitor c=0.0318948f //x=18.215 //y=1.39
c287 ( 104 0 ) capacitor c=0.0187384f //x=18.215 //y=1.045
c288 ( 101 0 ) capacitor c=0.0141798f //x=18.06 //y=1.545
c289 ( 99 0 ) capacitor c=0.0149844f //x=18.06 //y=0.89
c290 ( 95 0 ) capacitor c=0.0813322f //x=17.685 //y=2.095
c291 ( 94 0 ) capacitor c=0.0229267f //x=17.685 //y=1.7
c292 ( 93 0 ) capacitor c=0.0234352f //x=17.685 //y=1.39
c293 ( 92 0 ) capacitor c=0.0199343f //x=17.685 //y=1.045
c294 ( 91 0 ) capacitor c=0.0429696f //x=2.905 //y=1.43
c295 ( 90 0 ) capacitor c=0.0192208f //x=2.905 //y=1.085
c296 ( 84 0 ) capacitor c=0.0158629f //x=2.75 //y=1.585
c297 ( 82 0 ) capacitor c=0.0157803f //x=2.75 //y=0.93
c298 ( 80 0 ) capacitor c=0.0299681f //x=2.745 //y=4.97
c299 ( 75 0 ) capacitor c=0.0205163f //x=2.375 //y=1.74
c300 ( 74 0 ) capacitor c=0.0168481f //x=2.375 //y=1.43
c301 ( 73 0 ) capacitor c=0.0174783f //x=2.375 //y=1.085
c302 ( 72 0 ) capacitor c=0.110275f //x=18.22 //y=6.2
c303 ( 71 0 ) capacitor c=0.154305f //x=17.78 //y=6.2
c304 ( 70 0 ) capacitor c=0.15358f //x=2.82 //y=6.2
c305 ( 69 0 ) capacitor c=0.110281f //x=2.38 //y=6.2
c306 ( 65 0 ) capacitor c=0.0755336f //x=7.887 //y=4.085
c307 ( 64 0 ) capacitor c=0.0101843f //x=7.885 //y=4.25
c308 ( 62 0 ) capacitor c=0.00106608f //x=7.11 //y=5.335
c309 ( 61 0 ) capacitor c=0.00207162f //x=6.23 //y=5.335
c310 ( 52 0 ) capacitor c=0.0887144f //x=17.88 //y=2.26
c311 ( 50 0 ) capacitor c=0.0236247f //x=7.89 //y=5.25
c312 ( 46 0 ) capacitor c=0.00431225f //x=7.49 //y=1.845
c313 ( 45 0 ) capacitor c=0.0141453f //x=7.805 //y=1.845
c314 ( 39 0 ) capacitor c=0.0281378f //x=7.805 //y=5.335
c315 ( 31 0 ) capacitor c=0.0176454f //x=7.025 //y=5.335
c316 ( 24 0 ) capacitor c=0.00351598f //x=5.435 //y=5.335
c317 ( 23 0 ) capacitor c=0.0154196f //x=6.145 //y=5.335
c318 ( 13 0 ) capacitor c=0.0765924f //x=2.34 //y=2.26
c319 ( 11 0 ) capacitor c=0.00453889f //x=2.34 //y=4.715
c320 ( 4 0 ) capacitor c=0.00551102f //x=8 //y=4.25
c321 ( 3 0 ) capacitor c=0.143514f //x=17.765 //y=4.25
c322 ( 2 0 ) capacitor c=0.0165998f //x=2.455 //y=4.25
c323 ( 1 0 ) capacitor c=0.143583f //x=7.77 //y=4.25
r324 (  126 128 ) resistor r=20.6867 //w=0.233 //l=0.1 //layer=ply \
 //thickness=0.18 //x=17.78 //y=4.88 //x2=17.88 //y2=4.88
r325 (  116 117 ) resistor r=32.4568 //w=0.214 //l=0.075 //layer=ply \
 //thickness=0.18 //x=2.37 //y=4.97 //x2=2.37 //y2=5.045
r326 (  114 116 ) resistor r=20.271 //w=0.214 //l=0.09 //layer=ply \
 //thickness=0.18 //x=2.37 //y=4.88 //x2=2.37 //y2=4.97
r327 (  110 111 ) resistor r=52.7279 //w=0.214 //l=0.165 //layer=ply \
 //thickness=0.18 //x=2.34 //y=2.26 //x2=2.34 //y2=2.095
r328 (  106 128 ) resistor r=70.3348 //w=0.233 //l=0.414367 //layer=ply \
 //thickness=0.18 //x=18.22 //y=5.045 //x2=17.88 //y2=4.88
r329 (  105 130 ) resistor r=45.1352 //w=0.168 //l=0.173853 //layer=ply \
 //thickness=0.18 //x=18.215 //y=1.39 //x2=18.175 //y2=1.545
r330 (  104 129 ) resistor r=45.1352 //w=0.168 //l=0.173853 //layer=ply \
 //thickness=0.18 //x=18.215 //y=1.045 //x2=18.175 //y2=0.89
r331 (  104 105 ) resistor r=176.904 //w=0.094 //l=0.345 //layer=ply \
 //thickness=0.18 //x=18.215 //y=1.045 //x2=18.215 //y2=1.39
r332 (  102 125 ) resistor r=10.701 //w=0.21 //l=0.115 //layer=ply \
 //thickness=0.18 //x=17.84 //y=1.545 //x2=17.725 //y2=1.545
r333 (  101 130 ) resistor r=5.52526 //w=0.168 //l=0.115 //layer=ply \
 //thickness=0.18 //x=18.06 //y=1.545 //x2=18.175 //y2=1.545
r334 (  100 124 ) resistor r=5.52526 //w=0.168 //l=0.115 //layer=ply \
 //thickness=0.18 //x=17.84 //y=0.89 //x2=17.725 //y2=0.89
r335 (  99 129 ) resistor r=5.52526 //w=0.168 //l=0.115 //layer=ply \
 //thickness=0.18 //x=18.06 //y=0.89 //x2=18.175 //y2=0.89
r336 (  99 100 ) resistor r=112.809 //w=0.094 //l=0.22 //layer=ply \
 //thickness=0.18 //x=18.06 //y=0.89 //x2=17.84 //y2=0.89
r337 (  96 126 ) resistor r=13.0941 //w=0.233 //l=0.165 //layer=ply \
 //thickness=0.18 //x=17.78 //y=5.045 //x2=17.78 //y2=4.88
r338 (  95 123 ) resistor r=34.8111 //w=0.27 //l=0.264953 //layer=ply \
 //thickness=0.18 //x=17.685 //y=2.095 //x2=17.88 //y2=2.26
r339 (  94 125 ) resistor r=39.5823 //w=0.21 //l=0.173853 //layer=ply \
 //thickness=0.18 //x=17.685 //y=1.7 //x2=17.725 //y2=1.545
r340 (  94 95 ) resistor r=202.543 //w=0.094 //l=0.395 //layer=ply \
 //thickness=0.18 //x=17.685 //y=1.7 //x2=17.685 //y2=2.095
r341 (  93 125 ) resistor r=39.5823 //w=0.21 //l=0.173853 //layer=ply \
 //thickness=0.18 //x=17.685 //y=1.39 //x2=17.725 //y2=1.545
r342 (  92 124 ) resistor r=45.1352 //w=0.168 //l=0.173853 //layer=ply \
 //thickness=0.18 //x=17.685 //y=1.045 //x2=17.725 //y2=0.89
r343 (  92 93 ) resistor r=176.904 //w=0.094 //l=0.345 //layer=ply \
 //thickness=0.18 //x=17.685 //y=1.045 //x2=17.685 //y2=1.39
r344 (  91 121 ) resistor r=45.1352 //w=0.168 //l=0.173853 //layer=ply \
 //thickness=0.18 //x=2.905 //y=1.43 //x2=2.865 //y2=1.585
r345 (  90 120 ) resistor r=45.1352 //w=0.168 //l=0.173853 //layer=ply \
 //thickness=0.18 //x=2.905 //y=1.085 //x2=2.865 //y2=0.93
r346 (  90 91 ) resistor r=176.904 //w=0.094 //l=0.345 //layer=ply \
 //thickness=0.18 //x=2.905 //y=1.085 //x2=2.905 //y2=1.43
r347 (  85 119 ) resistor r=10.701 //w=0.21 //l=0.115 //layer=ply \
 //thickness=0.18 //x=2.53 //y=1.585 //x2=2.415 //y2=1.585
r348 (  84 121 ) resistor r=5.52526 //w=0.168 //l=0.115 //layer=ply \
 //thickness=0.18 //x=2.75 //y=1.585 //x2=2.865 //y2=1.585
r349 (  83 118 ) resistor r=5.52526 //w=0.168 //l=0.115 //layer=ply \
 //thickness=0.18 //x=2.53 //y=0.93 //x2=2.415 //y2=0.93
r350 (  82 120 ) resistor r=5.52526 //w=0.168 //l=0.115 //layer=ply \
 //thickness=0.18 //x=2.75 //y=0.93 //x2=2.865 //y2=0.93
r351 (  82 83 ) resistor r=112.809 //w=0.094 //l=0.22 //layer=ply \
 //thickness=0.18 //x=2.75 //y=0.93 //x2=2.53 //y2=0.93
r352 (  81 116 ) resistor r=16.5046 //w=0.27 //l=0.135 //layer=ply \
 //thickness=0.18 //x=2.505 //y=4.97 //x2=2.37 //y2=4.97
r353 (  80 87 ) resistor r=26.9307 //w=0.15 //l=0.106066 //layer=ply \
 //thickness=0.18 //x=2.745 //y=4.97 //x2=2.82 //y2=5.045
r354 (  80 81 ) resistor r=123.064 //w=0.094 //l=0.24 //layer=ply \
 //thickness=0.18 //x=2.745 //y=4.97 //x2=2.505 //y2=4.97
r355 (  75 119 ) resistor r=39.5823 //w=0.21 //l=0.173853 //layer=ply \
 //thickness=0.18 //x=2.375 //y=1.74 //x2=2.415 //y2=1.585
r356 (  75 111 ) resistor r=182.032 //w=0.094 //l=0.355 //layer=ply \
 //thickness=0.18 //x=2.375 //y=1.74 //x2=2.375 //y2=2.095
r357 (  74 119 ) resistor r=39.5823 //w=0.21 //l=0.173853 //layer=ply \
 //thickness=0.18 //x=2.375 //y=1.43 //x2=2.415 //y2=1.585
r358 (  73 118 ) resistor r=45.1352 //w=0.168 //l=0.173853 //layer=ply \
 //thickness=0.18 //x=2.375 //y=1.085 //x2=2.415 //y2=0.93
r359 (  73 74 ) resistor r=176.904 //w=0.094 //l=0.345 //layer=ply \
 //thickness=0.18 //x=2.375 //y=1.085 //x2=2.375 //y2=1.43
r360 (  72 106 ) resistor r=592.245 //w=0.094 //l=1.155 //layer=ply \
 //thickness=0.18 //x=18.22 //y=6.2 //x2=18.22 //y2=5.045
r361 (  71 96 ) resistor r=592.245 //w=0.094 //l=1.155 //layer=ply \
 //thickness=0.18 //x=17.78 //y=6.2 //x2=17.78 //y2=5.045
r362 (  70 87 ) resistor r=592.245 //w=0.094 //l=1.155 //layer=ply \
 //thickness=0.18 //x=2.82 //y=6.2 //x2=2.82 //y2=5.045
r363 (  69 117 ) resistor r=592.245 //w=0.094 //l=1.155 //layer=ply \
 //thickness=0.18 //x=2.38 //y=6.2 //x2=2.38 //y2=5.045
r364 (  68 101 ) resistor r=56.4043 //w=0.094 //l=0.11 //layer=ply \
 //thickness=0.18 //x=17.95 //y=1.545 //x2=18.06 //y2=1.545
r365 (  68 102 ) resistor r=56.4043 //w=0.094 //l=0.11 //layer=ply \
 //thickness=0.18 //x=17.95 //y=1.545 //x2=17.84 //y2=1.545
r366 (  67 84 ) resistor r=56.4043 //w=0.094 //l=0.11 //layer=ply \
 //thickness=0.18 //x=2.64 //y=1.585 //x2=2.75 //y2=1.585
r367 (  67 85 ) resistor r=56.4043 //w=0.094 //l=0.11 //layer=ply \
 //thickness=0.18 //x=2.64 //y=1.585 //x2=2.53 //y2=1.585
r368 (  64 66 ) resistor r=11 //w=0.192 //l=0.165 //layer=li //thickness=0.1 \
 //x=7.887 //y=4.25 //x2=7.887 //y2=4.415
r369 (  64 65 ) resistor r=11 //w=0.192 //l=0.165 //layer=li //thickness=0.1 \
 //x=7.887 //y=4.25 //x2=7.887 //y2=4.085
r370 (  60 114 ) resistor r=152 //w=0.17 //l=0.17 //layer=licon //count=1 \
 //x=2.37 //y=4.88 //x2=2.37 //y2=4.88
r371 (  57 128 ) resistor r=152 //w=0.17 //l=0.17 //layer=licon //count=1 \
 //x=17.88 //y=4.88 //x2=17.88 //y2=4.88
r372 (  55 57 ) resistor r=43.123 //w=0.187 //l=0.63 //layer=li \
 //thickness=0.1 //x=17.88 //y=4.25 //x2=17.88 //y2=4.88
r373 (  52 123 ) resistor r=152 //w=0.17 //l=0.17 //layer=licon //count=1 \
 //x=17.88 //y=2.26 //x2=17.88 //y2=2.26
r374 (  52 55 ) resistor r=136.214 //w=0.187 //l=1.99 //layer=li \
 //thickness=0.1 //x=17.88 //y=2.26 //x2=17.88 //y2=4.25
r375 (  50 66 ) resistor r=57.1551 //w=0.187 //l=0.835 //layer=li \
 //thickness=0.1 //x=7.89 //y=5.25 //x2=7.89 //y2=4.415
r376 (  47 65 ) resistor r=147.508 //w=0.187 //l=2.155 //layer=li \
 //thickness=0.1 //x=7.89 //y=1.93 //x2=7.89 //y2=4.085
r377 (  45 47 ) resistor r=7.15173 //w=0.17 //l=0.120208 //layer=li \
 //thickness=0.1 //x=7.805 //y=1.845 //x2=7.89 //y2=1.93
r378 (  45 46 ) resistor r=21.5615 //w=0.187 //l=0.315 //layer=li \
 //thickness=0.1 //x=7.805 //y=1.845 //x2=7.49 //y2=1.845
r379 (  41 46 ) resistor r=7.15173 //w=0.17 //l=0.120208 //layer=li \
 //thickness=0.1 //x=7.405 //y=1.76 //x2=7.49 //y2=1.845
r380 (  41 131 ) resistor r=39.016 //w=0.187 //l=0.57 //layer=li \
 //thickness=0.1 //x=7.405 //y=1.76 //x2=7.405 //y2=1.19
r381 (  40 62 ) resistor r=5.4201 //w=0.17 //l=0.085 //layer=li \
 //thickness=0.1 //x=7.195 //y=5.335 //x2=7.11 //y2=5.335
r382 (  39 50 ) resistor r=7.15173 //w=0.17 //l=0.120208 //layer=li \
 //thickness=0.1 //x=7.805 //y=5.335 //x2=7.89 //y2=5.25
r383 (  39 40 ) resistor r=41.754 //w=0.187 //l=0.61 //layer=li \
 //thickness=0.1 //x=7.805 //y=5.335 //x2=7.195 //y2=5.335
r384 (  33 62 ) resistor r=1.40859 //w=0.34 //l=0.085 //layer=li \
 //thickness=0.1 //x=7.11 //y=5.42 //x2=7.11 //y2=5.335
r385 (  33 135 ) resistor r=33.1979 //w=0.187 //l=0.485 //layer=li \
 //thickness=0.1 //x=7.11 //y=5.42 //x2=7.11 //y2=5.905
r386 (  32 61 ) resistor r=5.4201 //w=0.17 //l=0.085 //layer=li \
 //thickness=0.1 //x=6.315 //y=5.335 //x2=6.23 //y2=5.335
r387 (  31 62 ) resistor r=5.4201 //w=0.17 //l=0.085 //layer=li \
 //thickness=0.1 //x=7.025 //y=5.335 //x2=7.11 //y2=5.335
r388 (  31 32 ) resistor r=48.5989 //w=0.187 //l=0.71 //layer=li \
 //thickness=0.1 //x=7.025 //y=5.335 //x2=6.315 //y2=5.335
r389 (  25 61 ) resistor r=1.40859 //w=0.34 //l=0.085 //layer=li \
 //thickness=0.1 //x=6.23 //y=5.42 //x2=6.23 //y2=5.335
r390 (  25 134 ) resistor r=33.1979 //w=0.187 //l=0.485 //layer=li \
 //thickness=0.1 //x=6.23 //y=5.42 //x2=6.23 //y2=5.905
r391 (  23 61 ) resistor r=5.4201 //w=0.17 //l=0.085 //layer=li \
 //thickness=0.1 //x=6.145 //y=5.335 //x2=6.23 //y2=5.335
r392 (  23 24 ) resistor r=48.5989 //w=0.187 //l=0.71 //layer=li \
 //thickness=0.1 //x=6.145 //y=5.335 //x2=5.435 //y2=5.335
r393 (  17 24 ) resistor r=7.15173 //w=0.17 //l=0.120208 //layer=li \
 //thickness=0.1 //x=5.35 //y=5.42 //x2=5.435 //y2=5.335
r394 (  17 133 ) resistor r=33.1979 //w=0.187 //l=0.485 //layer=li \
 //thickness=0.1 //x=5.35 //y=5.42 //x2=5.35 //y2=5.905
r395 (  13 110 ) resistor r=152 //w=0.17 //l=0.17 //layer=licon //count=1 \
 //x=2.34 //y=2.26 //x2=2.34 //y2=2.26
r396 (  13 16 ) resistor r=136.214 //w=0.187 //l=1.99 //layer=li \
 //thickness=0.1 //x=2.34 //y=2.26 //x2=2.34 //y2=4.25
r397 (  11 60 ) resistor r=11.4737 //w=0.186 //l=0.172337 //layer=li \
 //thickness=0.1 //x=2.34 //y=4.715 //x2=2.355 //y2=4.88
r398 (  11 16 ) resistor r=31.8289 //w=0.187 //l=0.465 //layer=li \
 //thickness=0.1 //x=2.34 //y=4.715 //x2=2.34 //y2=4.25
r399 (  10 55 ) resistor r=9.3 //w=0.17 //l=0.17 //layer=mcon //count=1 \
 //x=17.88 //y=4.25 //x2=17.88 //y2=4.25
r400 (  8 64 ) resistor r=9.3 //w=0.17 //l=0.17 //layer=mcon //count=1 \
 //x=7.885 //y=4.25 //x2=7.885 //y2=4.25
r401 (  6 16 ) resistor r=9.3 //w=0.17 //l=0.17 //layer=mcon //count=1 \
 //x=2.34 //y=4.25 //x2=2.34 //y2=4.25
r402 (  4 8 ) resistor r=0.0880901 //w=0.191 //l=0.115 //layer=m1 \
 //thickness=0.36 //x=8 //y=4.25 //x2=7.885 //y2=4.25
r403 (  3 10 ) resistor r=0.0717383 //w=0.224 //l=0.115 //layer=m1 \
 //thickness=0.36 //x=17.765 //y=4.25 //x2=17.88 //y2=4.25
r404 (  3 4 ) resistor r=9.31775 //w=0.131 //l=9.765 //layer=m1 \
 //thickness=0.36 //x=17.765 //y=4.25 //x2=8 //y2=4.25
r405 (  2 6 ) resistor r=0.0717383 //w=0.224 //l=0.115 //layer=m1 \
 //thickness=0.36 //x=2.455 //y=4.25 //x2=2.34 //y2=4.25
r406 (  1 8 ) resistor r=0.0880901 //w=0.191 //l=0.115 //layer=m1 \
 //thickness=0.36 //x=7.77 //y=4.25 //x2=7.885 //y2=4.25
r407 (  1 2 ) resistor r=5.07156 //w=0.131 //l=5.315 //layer=m1 \
 //thickness=0.36 //x=7.77 //y=4.25 //x2=2.455 //y2=4.25
ends PM_TMRDFFSNQX1\%noxref_5

subckt PM_TMRDFFSNQX1\%noxref_6 ( 1 2 13 14 25 27 28 32 34 41 42 43 44 45 46 \
 47 48 49 51 57 58 59 60 72 74 75 )
c152 ( 75 0 ) capacitor c=0.0220291f //x=18.735 //y=5.2
c153 ( 74 0 ) capacitor c=0.0217503f //x=17.855 //y=5.2
c154 ( 72 0 ) capacitor c=0.0084702f //x=18.73 //y=1.085
c155 ( 60 0 ) capacitor c=0.0556143f //x=21.485 //y=4.97
c156 ( 59 0 ) capacitor c=0.0293157f //x=21.775 //y=4.97
c157 ( 58 0 ) capacitor c=0.0347816f //x=21.44 //y=1.4
c158 ( 57 0 ) capacitor c=0.0187487f //x=21.44 //y=1.055
c159 ( 51 0 ) capacitor c=0.0137055f //x=21.285 //y=1.555
c160 ( 49 0 ) capacitor c=0.0149861f //x=21.285 //y=0.9
c161 ( 48 0 ) capacitor c=0.096037f //x=20.91 //y=2.095
c162 ( 47 0 ) capacitor c=0.0228993f //x=20.91 //y=1.71
c163 ( 46 0 ) capacitor c=0.0234352f //x=20.91 //y=1.4
c164 ( 45 0 ) capacitor c=0.0198724f //x=20.91 //y=1.055
c165 ( 44 0 ) capacitor c=0.110114f //x=21.85 //y=6.2
c166 ( 43 0 ) capacitor c=0.158956f //x=21.41 //y=6.2
c167 ( 41 0 ) capacitor c=0.00211606f //x=18.88 //y=5.38
c168 ( 34 0 ) capacitor c=0.0963459f //x=21.21 //y=2.26
c169 ( 32 0 ) capacitor c=0.104321f //x=19.36 //y=4.25
c170 ( 28 0 ) capacitor c=0.00404073f //x=19.005 //y=1.835
c171 ( 27 0 ) capacitor c=0.0122201f //x=19.275 //y=1.835
c172 ( 25 0 ) capacitor c=0.0137995f //x=19.275 //y=5.38
c173 ( 14 0 ) capacitor c=0.00251459f //x=18.085 //y=5.38
c174 ( 13 0 ) capacitor c=0.0142423f //x=18.795 //y=5.38
c175 ( 2 0 ) capacitor c=0.00645515f //x=19.475 //y=4.25
c176 ( 1 0 ) capacitor c=0.0383007f //x=21.095 //y=4.25
r177 (  59 61 ) resistor r=26.9307 //w=0.15 //l=0.106066 //layer=ply \
 //thickness=0.18 //x=21.775 //y=4.97 //x2=21.85 //y2=5.045
r178 (  59 60 ) resistor r=148.702 //w=0.094 //l=0.29 //layer=ply \
 //thickness=0.18 //x=21.775 //y=4.97 //x2=21.485 //y2=4.97
r179 (  58 71 ) resistor r=45.1352 //w=0.168 //l=0.173853 //layer=ply \
 //thickness=0.18 //x=21.44 //y=1.4 //x2=21.4 //y2=1.555
r180 (  57 70 ) resistor r=45.1352 //w=0.168 //l=0.173853 //layer=ply \
 //thickness=0.18 //x=21.44 //y=1.055 //x2=21.4 //y2=0.9
r181 (  57 58 ) resistor r=176.904 //w=0.094 //l=0.345 //layer=ply \
 //thickness=0.18 //x=21.44 //y=1.055 //x2=21.44 //y2=1.4
r182 (  54 60 ) resistor r=22.7971 //w=0.269 //l=0.106066 //layer=ply \
 //thickness=0.18 //x=21.41 //y=5.045 //x2=21.485 //y2=4.97
r183 (  54 69 ) resistor r=35.8364 //w=0.269 //l=0.270185 //layer=ply \
 //thickness=0.18 //x=21.41 //y=5.045 //x2=21.21 //y2=4.88
r184 (  52 65 ) resistor r=10.701 //w=0.21 //l=0.115 //layer=ply \
 //thickness=0.18 //x=21.065 //y=1.555 //x2=20.95 //y2=1.555
r185 (  51 71 ) resistor r=5.52526 //w=0.168 //l=0.115 //layer=ply \
 //thickness=0.18 //x=21.285 //y=1.555 //x2=21.4 //y2=1.555
r186 (  50 64 ) resistor r=5.52526 //w=0.168 //l=0.115 //layer=ply \
 //thickness=0.18 //x=21.065 //y=0.9 //x2=20.95 //y2=0.9
r187 (  49 70 ) resistor r=5.52526 //w=0.168 //l=0.115 //layer=ply \
 //thickness=0.18 //x=21.285 //y=0.9 //x2=21.4 //y2=0.9
r188 (  49 50 ) resistor r=112.809 //w=0.094 //l=0.22 //layer=ply \
 //thickness=0.18 //x=21.285 //y=0.9 //x2=21.065 //y2=0.9
r189 (  48 67 ) resistor r=58.7805 //w=0.246 //l=0.373497 //layer=ply \
 //thickness=0.18 //x=20.91 //y=2.095 //x2=21.21 //y2=2.26
r190 (  47 65 ) resistor r=39.5823 //w=0.21 //l=0.173853 //layer=ply \
 //thickness=0.18 //x=20.91 //y=1.71 //x2=20.95 //y2=1.555
r191 (  47 48 ) resistor r=197.415 //w=0.094 //l=0.385 //layer=ply \
 //thickness=0.18 //x=20.91 //y=1.71 //x2=20.91 //y2=2.095
r192 (  46 65 ) resistor r=39.5823 //w=0.21 //l=0.173853 //layer=ply \
 //thickness=0.18 //x=20.91 //y=1.4 //x2=20.95 //y2=1.555
r193 (  45 64 ) resistor r=45.1352 //w=0.168 //l=0.173853 //layer=ply \
 //thickness=0.18 //x=20.91 //y=1.055 //x2=20.95 //y2=0.9
r194 (  45 46 ) resistor r=176.904 //w=0.094 //l=0.345 //layer=ply \
 //thickness=0.18 //x=20.91 //y=1.055 //x2=20.91 //y2=1.4
r195 (  44 61 ) resistor r=592.245 //w=0.094 //l=1.155 //layer=ply \
 //thickness=0.18 //x=21.85 //y=6.2 //x2=21.85 //y2=5.045
r196 (  43 54 ) resistor r=592.245 //w=0.094 //l=1.155 //layer=ply \
 //thickness=0.18 //x=21.41 //y=6.2 //x2=21.41 //y2=5.045
r197 (  42 51 ) resistor r=56.4043 //w=0.094 //l=0.11 //layer=ply \
 //thickness=0.18 //x=21.175 //y=1.555 //x2=21.285 //y2=1.555
r198 (  42 52 ) resistor r=56.4043 //w=0.094 //l=0.11 //layer=ply \
 //thickness=0.18 //x=21.175 //y=1.555 //x2=21.065 //y2=1.555
r199 (  39 69 ) resistor r=152 //w=0.17 //l=0.17 //layer=licon //count=1 \
 //x=21.21 //y=4.88 //x2=21.21 //y2=4.88
r200 (  37 39 ) resistor r=43.123 //w=0.187 //l=0.63 //layer=li \
 //thickness=0.1 //x=21.21 //y=4.25 //x2=21.21 //y2=4.88
r201 (  34 67 ) resistor r=152 //w=0.17 //l=0.17 //layer=licon //count=1 \
 //x=21.21 //y=2.26 //x2=21.21 //y2=2.26
r202 (  34 37 ) resistor r=136.214 //w=0.187 //l=1.99 //layer=li \
 //thickness=0.1 //x=21.21 //y=2.26 //x2=21.21 //y2=4.25
r203 (  30 32 ) resistor r=71.5294 //w=0.187 //l=1.045 //layer=li \
 //thickness=0.1 //x=19.36 //y=5.295 //x2=19.36 //y2=4.25
r204 (  29 32 ) resistor r=159.487 //w=0.187 //l=2.33 //layer=li \
 //thickness=0.1 //x=19.36 //y=1.92 //x2=19.36 //y2=4.25
r205 (  27 29 ) resistor r=7.15173 //w=0.17 //l=0.120208 //layer=li \
 //thickness=0.1 //x=19.275 //y=1.835 //x2=19.36 //y2=1.92
r206 (  27 28 ) resistor r=18.4813 //w=0.187 //l=0.27 //layer=li \
 //thickness=0.1 //x=19.275 //y=1.835 //x2=19.005 //y2=1.835
r207 (  26 41 ) resistor r=5.4201 //w=0.17 //l=0.085 //layer=li \
 //thickness=0.1 //x=18.965 //y=5.38 //x2=18.88 //y2=5.38
r208 (  25 30 ) resistor r=7.15173 //w=0.17 //l=0.120208 //layer=li \
 //thickness=0.1 //x=19.275 //y=5.38 //x2=19.36 //y2=5.295
r209 (  25 26 ) resistor r=21.2193 //w=0.187 //l=0.31 //layer=li \
 //thickness=0.1 //x=19.275 //y=5.38 //x2=18.965 //y2=5.38
r210 (  21 28 ) resistor r=7.15173 //w=0.17 //l=0.120208 //layer=li \
 //thickness=0.1 //x=18.92 //y=1.75 //x2=19.005 //y2=1.835
r211 (  21 72 ) resistor r=39.016 //w=0.187 //l=0.57 //layer=li \
 //thickness=0.1 //x=18.92 //y=1.75 //x2=18.92 //y2=1.18
r212 (  15 41 ) resistor r=1.40859 //w=0.34 //l=0.085 //layer=li \
 //thickness=0.1 //x=18.88 //y=5.465 //x2=18.88 //y2=5.38
r213 (  15 75 ) resistor r=30.1176 //w=0.187 //l=0.44 //layer=li \
 //thickness=0.1 //x=18.88 //y=5.465 //x2=18.88 //y2=5.905
r214 (  13 41 ) resistor r=5.4201 //w=0.17 //l=0.085 //layer=li \
 //thickness=0.1 //x=18.795 //y=5.38 //x2=18.88 //y2=5.38
r215 (  13 14 ) resistor r=48.5989 //w=0.187 //l=0.71 //layer=li \
 //thickness=0.1 //x=18.795 //y=5.38 //x2=18.085 //y2=5.38
r216 (  7 14 ) resistor r=7.15173 //w=0.17 //l=0.120208 //layer=li \
 //thickness=0.1 //x=18 //y=5.465 //x2=18.085 //y2=5.38
r217 (  7 74 ) resistor r=30.1176 //w=0.187 //l=0.44 //layer=li \
 //thickness=0.1 //x=18 //y=5.465 //x2=18 //y2=5.905
r218 (  6 37 ) resistor r=9.3 //w=0.17 //l=0.17 //layer=mcon //count=1 \
 //x=21.21 //y=4.25 //x2=21.21 //y2=4.25
r219 (  4 32 ) resistor r=9.3 //w=0.17 //l=0.17 //layer=mcon //count=1 \
 //x=19.36 //y=4.25 //x2=19.36 //y2=4.25
r220 (  2 4 ) resistor r=0.0717383 //w=0.224 //l=0.115 //layer=m1 \
 //thickness=0.36 //x=19.475 //y=4.25 //x2=19.36 //y2=4.25
r221 (  1 6 ) resistor r=0.0717383 //w=0.224 //l=0.115 //layer=m1 \
 //thickness=0.36 //x=21.095 //y=4.25 //x2=21.21 //y2=4.25
r222 (  1 2 ) resistor r=1.5458 //w=0.131 //l=1.62 //layer=m1 //thickness=0.36 \
 //x=21.095 //y=4.25 //x2=19.475 //y2=4.25
ends PM_TMRDFFSNQX1\%noxref_6

subckt PM_TMRDFFSNQX1\%noxref_7 ( 1 2 3 4 5 6 16 24 37 38 49 51 52 56 58 65 66 \
 67 68 69 70 71 72 73 74 78 79 80 85 87 90 91 95 96 97 102 104 107 108 112 113 \
 114 119 121 124 125 127 128 133 137 138 143 147 148 153 156 158 159 )
c322 ( 159 0 ) capacitor c=0.0220291f //x=15.405 //y=5.2
c323 ( 158 0 ) capacitor c=0.0217503f //x=14.525 //y=5.2
c324 ( 156 0 ) capacitor c=0.00866655f //x=15.4 //y=1.085
c325 ( 153 0 ) capacitor c=0.0587755f //x=23.43 //y=4.88
c326 ( 148 0 ) capacitor c=0.0273931f //x=23.43 //y=2.095
c327 ( 147 0 ) capacitor c=0.0456313f //x=23.43 //y=2.26
c328 ( 143 0 ) capacitor c=0.0587755f //x=11.96 //y=4.88
c329 ( 138 0 ) capacitor c=0.0273931f //x=11.96 //y=2.095
c330 ( 137 0 ) capacitor c=0.0456313f //x=11.96 //y=2.26
c331 ( 133 0 ) capacitor c=0.058931f //x=7.15 //y=4.88
c332 ( 128 0 ) capacitor c=0.0267105f //x=7.15 //y=2.095
c333 ( 127 0 ) capacitor c=0.0457054f //x=7.15 //y=2.26
c334 ( 125 0 ) capacitor c=0.0432517f //x=23.95 //y=1.44
c335 ( 124 0 ) capacitor c=0.0200379f //x=23.95 //y=1.095
c336 ( 121 0 ) capacitor c=0.0148873f //x=23.795 //y=1.595
c337 ( 119 0 ) capacitor c=0.0157803f //x=23.795 //y=0.94
c338 ( 114 0 ) capacitor c=0.0218028f //x=23.42 //y=1.75
c339 ( 113 0 ) capacitor c=0.0207459f //x=23.42 //y=1.44
c340 ( 112 0 ) capacitor c=0.0194308f //x=23.42 //y=1.095
c341 ( 108 0 ) capacitor c=0.0432517f //x=12.48 //y=1.44
c342 ( 107 0 ) capacitor c=0.0200379f //x=12.48 //y=1.095
c343 ( 104 0 ) capacitor c=0.0148873f //x=12.325 //y=1.595
c344 ( 102 0 ) capacitor c=0.0157803f //x=12.325 //y=0.94
c345 ( 97 0 ) capacitor c=0.0218028f //x=11.95 //y=1.75
c346 ( 96 0 ) capacitor c=0.0207459f //x=11.95 //y=1.44
c347 ( 95 0 ) capacitor c=0.0194308f //x=11.95 //y=1.095
c348 ( 91 0 ) capacitor c=0.0432517f //x=7.67 //y=1.44
c349 ( 90 0 ) capacitor c=0.0200379f //x=7.67 //y=1.095
c350 ( 87 0 ) capacitor c=0.0158629f //x=7.515 //y=1.595
c351 ( 85 0 ) capacitor c=0.0157803f //x=7.515 //y=0.94
c352 ( 80 0 ) capacitor c=0.0218028f //x=7.14 //y=1.75
c353 ( 79 0 ) capacitor c=0.0207459f //x=7.14 //y=1.44
c354 ( 78 0 ) capacitor c=0.0194308f //x=7.14 //y=1.095
c355 ( 74 0 ) capacitor c=0.158794f //x=23.61 //y=6.2
c356 ( 73 0 ) capacitor c=0.110114f //x=23.17 //y=6.2
c357 ( 72 0 ) capacitor c=0.158794f //x=12.14 //y=6.2
c358 ( 71 0 ) capacitor c=0.110114f //x=11.7 //y=6.2
c359 ( 70 0 ) capacitor c=0.158048f //x=7.33 //y=6.2
c360 ( 69 0 ) capacitor c=0.110114f //x=6.89 //y=6.2
c361 ( 65 0 ) capacitor c=0.00211606f //x=15.55 //y=5.38
c362 ( 58 0 ) capacitor c=0.0839891f //x=23.43 //y=2.26
c363 ( 56 0 ) capacitor c=0.10649f //x=16.03 //y=3.88
c364 ( 52 0 ) capacitor c=0.00404073f //x=15.675 //y=1.835
c365 ( 51 0 ) capacitor c=0.0122201f //x=15.945 //y=1.835
c366 ( 49 0 ) capacitor c=0.0137522f //x=15.945 //y=5.38
c367 ( 38 0 ) capacitor c=0.00251635f //x=14.755 //y=5.38
c368 ( 37 0 ) capacitor c=0.0142529f //x=15.465 //y=5.38
c369 ( 24 0 ) capacitor c=0.0834768f //x=11.96 //y=2.26
c370 ( 16 0 ) capacitor c=0.0842778f //x=7.15 //y=2.26
c371 ( 6 0 ) capacitor c=0.0043044f //x=16.145 //y=3.88
c372 ( 5 0 ) capacitor c=0.13532f //x=23.315 //y=3.88
c373 ( 4 0 ) capacitor c=0.00443912f //x=12.075 //y=3.88
c374 ( 3 0 ) capacitor c=0.0668348f //x=15.915 //y=3.88
c375 ( 2 0 ) capacitor c=0.0143354f //x=7.265 //y=3.88
c376 ( 1 0 ) capacitor c=0.0815699f //x=11.845 //y=3.88
r377 (  147 148 ) resistor r=52.7279 //w=0.214 //l=0.165 //layer=ply \
 //thickness=0.18 //x=23.43 //y=2.26 //x2=23.43 //y2=2.095
r378 (  137 138 ) resistor r=52.7279 //w=0.214 //l=0.165 //layer=ply \
 //thickness=0.18 //x=11.96 //y=2.26 //x2=11.96 //y2=2.095
r379 (  127 128 ) resistor r=52.7279 //w=0.214 //l=0.165 //layer=ply \
 //thickness=0.18 //x=7.15 //y=2.26 //x2=7.15 //y2=2.095
r380 (  125 155 ) resistor r=45.1352 //w=0.168 //l=0.173853 //layer=ply \
 //thickness=0.18 //x=23.95 //y=1.44 //x2=23.91 //y2=1.595
r381 (  124 154 ) resistor r=45.1352 //w=0.168 //l=0.173853 //layer=ply \
 //thickness=0.18 //x=23.95 //y=1.095 //x2=23.91 //y2=0.94
r382 (  124 125 ) resistor r=176.904 //w=0.094 //l=0.345 //layer=ply \
 //thickness=0.18 //x=23.95 //y=1.095 //x2=23.95 //y2=1.44
r383 (  122 151 ) resistor r=10.701 //w=0.21 //l=0.115 //layer=ply \
 //thickness=0.18 //x=23.575 //y=1.595 //x2=23.46 //y2=1.595
r384 (  121 155 ) resistor r=5.52526 //w=0.168 //l=0.115 //layer=ply \
 //thickness=0.18 //x=23.795 //y=1.595 //x2=23.91 //y2=1.595
r385 (  120 150 ) resistor r=5.52526 //w=0.168 //l=0.115 //layer=ply \
 //thickness=0.18 //x=23.575 //y=0.94 //x2=23.46 //y2=0.94
r386 (  119 154 ) resistor r=5.52526 //w=0.168 //l=0.115 //layer=ply \
 //thickness=0.18 //x=23.795 //y=0.94 //x2=23.91 //y2=0.94
r387 (  119 120 ) resistor r=112.809 //w=0.094 //l=0.22 //layer=ply \
 //thickness=0.18 //x=23.795 //y=0.94 //x2=23.575 //y2=0.94
r388 (  116 153 ) resistor r=37.236 //w=0.233 //l=0.249199 //layer=ply \
 //thickness=0.18 //x=23.61 //y=5.045 //x2=23.43 //y2=4.88
r389 (  114 151 ) resistor r=39.5823 //w=0.21 //l=0.173853 //layer=ply \
 //thickness=0.18 //x=23.42 //y=1.75 //x2=23.46 //y2=1.595
r390 (  114 148 ) resistor r=176.904 //w=0.094 //l=0.345 //layer=ply \
 //thickness=0.18 //x=23.42 //y=1.75 //x2=23.42 //y2=2.095
r391 (  113 151 ) resistor r=39.5823 //w=0.21 //l=0.173853 //layer=ply \
 //thickness=0.18 //x=23.42 //y=1.44 //x2=23.46 //y2=1.595
r392 (  112 150 ) resistor r=45.1352 //w=0.168 //l=0.173853 //layer=ply \
 //thickness=0.18 //x=23.42 //y=1.095 //x2=23.46 //y2=0.94
r393 (  112 113 ) resistor r=176.904 //w=0.094 //l=0.345 //layer=ply \
 //thickness=0.18 //x=23.42 //y=1.095 //x2=23.42 //y2=1.44
r394 (  109 153 ) resistor r=53.7854 //w=0.233 //l=0.332415 //layer=ply \
 //thickness=0.18 //x=23.17 //y=5.045 //x2=23.43 //y2=4.88
r395 (  108 145 ) resistor r=45.1352 //w=0.168 //l=0.173853 //layer=ply \
 //thickness=0.18 //x=12.48 //y=1.44 //x2=12.44 //y2=1.595
r396 (  107 144 ) resistor r=45.1352 //w=0.168 //l=0.173853 //layer=ply \
 //thickness=0.18 //x=12.48 //y=1.095 //x2=12.44 //y2=0.94
r397 (  107 108 ) resistor r=176.904 //w=0.094 //l=0.345 //layer=ply \
 //thickness=0.18 //x=12.48 //y=1.095 //x2=12.48 //y2=1.44
r398 (  105 141 ) resistor r=10.701 //w=0.21 //l=0.115 //layer=ply \
 //thickness=0.18 //x=12.105 //y=1.595 //x2=11.99 //y2=1.595
r399 (  104 145 ) resistor r=5.52526 //w=0.168 //l=0.115 //layer=ply \
 //thickness=0.18 //x=12.325 //y=1.595 //x2=12.44 //y2=1.595
r400 (  103 140 ) resistor r=5.52526 //w=0.168 //l=0.115 //layer=ply \
 //thickness=0.18 //x=12.105 //y=0.94 //x2=11.99 //y2=0.94
r401 (  102 144 ) resistor r=5.52526 //w=0.168 //l=0.115 //layer=ply \
 //thickness=0.18 //x=12.325 //y=0.94 //x2=12.44 //y2=0.94
r402 (  102 103 ) resistor r=112.809 //w=0.094 //l=0.22 //layer=ply \
 //thickness=0.18 //x=12.325 //y=0.94 //x2=12.105 //y2=0.94
r403 (  99 143 ) resistor r=37.236 //w=0.233 //l=0.249199 //layer=ply \
 //thickness=0.18 //x=12.14 //y=5.045 //x2=11.96 //y2=4.88
r404 (  97 141 ) resistor r=39.5823 //w=0.21 //l=0.173853 //layer=ply \
 //thickness=0.18 //x=11.95 //y=1.75 //x2=11.99 //y2=1.595
r405 (  97 138 ) resistor r=176.904 //w=0.094 //l=0.345 //layer=ply \
 //thickness=0.18 //x=11.95 //y=1.75 //x2=11.95 //y2=2.095
r406 (  96 141 ) resistor r=39.5823 //w=0.21 //l=0.173853 //layer=ply \
 //thickness=0.18 //x=11.95 //y=1.44 //x2=11.99 //y2=1.595
r407 (  95 140 ) resistor r=45.1352 //w=0.168 //l=0.173853 //layer=ply \
 //thickness=0.18 //x=11.95 //y=1.095 //x2=11.99 //y2=0.94
r408 (  95 96 ) resistor r=176.904 //w=0.094 //l=0.345 //layer=ply \
 //thickness=0.18 //x=11.95 //y=1.095 //x2=11.95 //y2=1.44
r409 (  92 143 ) resistor r=53.7854 //w=0.233 //l=0.332415 //layer=ply \
 //thickness=0.18 //x=11.7 //y=5.045 //x2=11.96 //y2=4.88
r410 (  91 135 ) resistor r=45.1352 //w=0.168 //l=0.173853 //layer=ply \
 //thickness=0.18 //x=7.67 //y=1.44 //x2=7.63 //y2=1.595
r411 (  90 134 ) resistor r=45.1352 //w=0.168 //l=0.173853 //layer=ply \
 //thickness=0.18 //x=7.67 //y=1.095 //x2=7.63 //y2=0.94
r412 (  90 91 ) resistor r=176.904 //w=0.094 //l=0.345 //layer=ply \
 //thickness=0.18 //x=7.67 //y=1.095 //x2=7.67 //y2=1.44
r413 (  88 131 ) resistor r=10.701 //w=0.21 //l=0.115 //layer=ply \
 //thickness=0.18 //x=7.295 //y=1.595 //x2=7.18 //y2=1.595
r414 (  87 135 ) resistor r=5.52526 //w=0.168 //l=0.115 //layer=ply \
 //thickness=0.18 //x=7.515 //y=1.595 //x2=7.63 //y2=1.595
r415 (  86 130 ) resistor r=5.52526 //w=0.168 //l=0.115 //layer=ply \
 //thickness=0.18 //x=7.295 //y=0.94 //x2=7.18 //y2=0.94
r416 (  85 134 ) resistor r=5.52526 //w=0.168 //l=0.115 //layer=ply \
 //thickness=0.18 //x=7.515 //y=0.94 //x2=7.63 //y2=0.94
r417 (  85 86 ) resistor r=112.809 //w=0.094 //l=0.22 //layer=ply \
 //thickness=0.18 //x=7.515 //y=0.94 //x2=7.295 //y2=0.94
r418 (  82 133 ) resistor r=37.236 //w=0.233 //l=0.249199 //layer=ply \
 //thickness=0.18 //x=7.33 //y=5.045 //x2=7.15 //y2=4.88
r419 (  80 131 ) resistor r=39.5823 //w=0.21 //l=0.173853 //layer=ply \
 //thickness=0.18 //x=7.14 //y=1.75 //x2=7.18 //y2=1.595
r420 (  80 128 ) resistor r=176.904 //w=0.094 //l=0.345 //layer=ply \
 //thickness=0.18 //x=7.14 //y=1.75 //x2=7.14 //y2=2.095
r421 (  79 131 ) resistor r=39.5823 //w=0.21 //l=0.173853 //layer=ply \
 //thickness=0.18 //x=7.14 //y=1.44 //x2=7.18 //y2=1.595
r422 (  78 130 ) resistor r=45.1352 //w=0.168 //l=0.173853 //layer=ply \
 //thickness=0.18 //x=7.14 //y=1.095 //x2=7.18 //y2=0.94
r423 (  78 79 ) resistor r=176.904 //w=0.094 //l=0.345 //layer=ply \
 //thickness=0.18 //x=7.14 //y=1.095 //x2=7.14 //y2=1.44
r424 (  75 133 ) resistor r=53.7854 //w=0.233 //l=0.332415 //layer=ply \
 //thickness=0.18 //x=6.89 //y=5.045 //x2=7.15 //y2=4.88
r425 (  74 116 ) resistor r=592.245 //w=0.094 //l=1.155 //layer=ply \
 //thickness=0.18 //x=23.61 //y=6.2 //x2=23.61 //y2=5.045
r426 (  73 109 ) resistor r=592.245 //w=0.094 //l=1.155 //layer=ply \
 //thickness=0.18 //x=23.17 //y=6.2 //x2=23.17 //y2=5.045
r427 (  72 99 ) resistor r=592.245 //w=0.094 //l=1.155 //layer=ply \
 //thickness=0.18 //x=12.14 //y=6.2 //x2=12.14 //y2=5.045
r428 (  71 92 ) resistor r=592.245 //w=0.094 //l=1.155 //layer=ply \
 //thickness=0.18 //x=11.7 //y=6.2 //x2=11.7 //y2=5.045
r429 (  70 82 ) resistor r=592.245 //w=0.094 //l=1.155 //layer=ply \
 //thickness=0.18 //x=7.33 //y=6.2 //x2=7.33 //y2=5.045
r430 (  69 75 ) resistor r=592.245 //w=0.094 //l=1.155 //layer=ply \
 //thickness=0.18 //x=6.89 //y=6.2 //x2=6.89 //y2=5.045
r431 (  68 121 ) resistor r=56.4043 //w=0.094 //l=0.11 //layer=ply \
 //thickness=0.18 //x=23.685 //y=1.595 //x2=23.795 //y2=1.595
r432 (  68 122 ) resistor r=56.4043 //w=0.094 //l=0.11 //layer=ply \
 //thickness=0.18 //x=23.685 //y=1.595 //x2=23.575 //y2=1.595
r433 (  67 104 ) resistor r=56.4043 //w=0.094 //l=0.11 //layer=ply \
 //thickness=0.18 //x=12.215 //y=1.595 //x2=12.325 //y2=1.595
r434 (  67 105 ) resistor r=56.4043 //w=0.094 //l=0.11 //layer=ply \
 //thickness=0.18 //x=12.215 //y=1.595 //x2=12.105 //y2=1.595
r435 (  66 87 ) resistor r=56.4043 //w=0.094 //l=0.11 //layer=ply \
 //thickness=0.18 //x=7.405 //y=1.595 //x2=7.515 //y2=1.595
r436 (  66 88 ) resistor r=56.4043 //w=0.094 //l=0.11 //layer=ply \
 //thickness=0.18 //x=7.405 //y=1.595 //x2=7.295 //y2=1.595
r437 (  63 153 ) resistor r=152 //w=0.17 //l=0.17 //layer=licon //count=1 \
 //x=23.43 //y=4.88 //x2=23.43 //y2=4.88
r438 (  61 63 ) resistor r=68.4492 //w=0.187 //l=1 //layer=li //thickness=0.1 \
 //x=23.43 //y=3.88 //x2=23.43 //y2=4.88
r439 (  58 147 ) resistor r=152 //w=0.17 //l=0.17 //layer=licon //count=1 \
 //x=23.43 //y=2.26 //x2=23.43 //y2=2.26
r440 (  58 61 ) resistor r=110.888 //w=0.187 //l=1.62 //layer=li \
 //thickness=0.1 //x=23.43 //y=2.26 //x2=23.43 //y2=3.88
r441 (  54 56 ) resistor r=96.8556 //w=0.187 //l=1.415 //layer=li \
 //thickness=0.1 //x=16.03 //y=5.295 //x2=16.03 //y2=3.88
r442 (  53 56 ) resistor r=134.16 //w=0.187 //l=1.96 //layer=li \
 //thickness=0.1 //x=16.03 //y=1.92 //x2=16.03 //y2=3.88
r443 (  51 53 ) resistor r=7.15173 //w=0.17 //l=0.120208 //layer=li \
 //thickness=0.1 //x=15.945 //y=1.835 //x2=16.03 //y2=1.92
r444 (  51 52 ) resistor r=18.4813 //w=0.187 //l=0.27 //layer=li \
 //thickness=0.1 //x=15.945 //y=1.835 //x2=15.675 //y2=1.835
r445 (  50 65 ) resistor r=5.4201 //w=0.17 //l=0.085 //layer=li \
 //thickness=0.1 //x=15.635 //y=5.38 //x2=15.55 //y2=5.38
r446 (  49 54 ) resistor r=7.15173 //w=0.17 //l=0.120208 //layer=li \
 //thickness=0.1 //x=15.945 //y=5.38 //x2=16.03 //y2=5.295
r447 (  49 50 ) resistor r=21.2193 //w=0.187 //l=0.31 //layer=li \
 //thickness=0.1 //x=15.945 //y=5.38 //x2=15.635 //y2=5.38
r448 (  45 52 ) resistor r=7.15173 //w=0.17 //l=0.120208 //layer=li \
 //thickness=0.1 //x=15.59 //y=1.75 //x2=15.675 //y2=1.835
r449 (  45 156 ) resistor r=39.016 //w=0.187 //l=0.57 //layer=li \
 //thickness=0.1 //x=15.59 //y=1.75 //x2=15.59 //y2=1.18
r450 (  39 65 ) resistor r=1.40859 //w=0.34 //l=0.085 //layer=li \
 //thickness=0.1 //x=15.55 //y=5.465 //x2=15.55 //y2=5.38
r451 (  39 159 ) resistor r=30.1176 //w=0.187 //l=0.44 //layer=li \
 //thickness=0.1 //x=15.55 //y=5.465 //x2=15.55 //y2=5.905
r452 (  37 65 ) resistor r=5.4201 //w=0.17 //l=0.085 //layer=li \
 //thickness=0.1 //x=15.465 //y=5.38 //x2=15.55 //y2=5.38
r453 (  37 38 ) resistor r=48.5989 //w=0.187 //l=0.71 //layer=li \
 //thickness=0.1 //x=15.465 //y=5.38 //x2=14.755 //y2=5.38
r454 (  31 38 ) resistor r=7.15173 //w=0.17 //l=0.120208 //layer=li \
 //thickness=0.1 //x=14.67 //y=5.465 //x2=14.755 //y2=5.38
r455 (  31 158 ) resistor r=30.1176 //w=0.187 //l=0.44 //layer=li \
 //thickness=0.1 //x=14.67 //y=5.465 //x2=14.67 //y2=5.905
r456 (  29 143 ) resistor r=152 //w=0.17 //l=0.17 //layer=licon //count=1 \
 //x=11.96 //y=4.88 //x2=11.96 //y2=4.88
r457 (  27 29 ) resistor r=68.4492 //w=0.187 //l=1 //layer=li //thickness=0.1 \
 //x=11.96 //y=3.88 //x2=11.96 //y2=4.88
r458 (  24 137 ) resistor r=152 //w=0.17 //l=0.17 //layer=licon //count=1 \
 //x=11.96 //y=2.26 //x2=11.96 //y2=2.26
r459 (  24 27 ) resistor r=110.888 //w=0.187 //l=1.62 //layer=li \
 //thickness=0.1 //x=11.96 //y=2.26 //x2=11.96 //y2=3.88
r460 (  21 133 ) resistor r=152 //w=0.17 //l=0.17 //layer=licon //count=1 \
 //x=7.15 //y=4.88 //x2=7.15 //y2=4.88
r461 (  19 21 ) resistor r=68.4492 //w=0.187 //l=1 //layer=li //thickness=0.1 \
 //x=7.15 //y=3.88 //x2=7.15 //y2=4.88
r462 (  16 127 ) resistor r=152 //w=0.17 //l=0.17 //layer=licon //count=1 \
 //x=7.15 //y=2.26 //x2=7.15 //y2=2.26
r463 (  16 19 ) resistor r=110.888 //w=0.187 //l=1.62 //layer=li \
 //thickness=0.1 //x=7.15 //y=2.26 //x2=7.15 //y2=3.88
r464 (  14 61 ) resistor r=9.3 //w=0.17 //l=0.17 //layer=mcon //count=1 \
 //x=23.43 //y=3.88 //x2=23.43 //y2=3.88
r465 (  12 56 ) resistor r=9.3 //w=0.17 //l=0.17 //layer=mcon //count=1 \
 //x=16.03 //y=3.88 //x2=16.03 //y2=3.88
r466 (  10 27 ) resistor r=9.3 //w=0.17 //l=0.17 //layer=mcon //count=1 \
 //x=11.96 //y=3.88 //x2=11.96 //y2=3.88
r467 (  8 19 ) resistor r=9.3 //w=0.17 //l=0.17 //layer=mcon //count=1 \
 //x=7.15 //y=3.88 //x2=7.15 //y2=3.88
r468 (  6 12 ) resistor r=0.0880901 //w=0.191 //l=0.115 //layer=m1 \
 //thickness=0.36 //x=16.145 //y=3.88 //x2=16.03 //y2=3.88
r469 (  5 14 ) resistor r=0.0717383 //w=0.224 //l=0.115 //layer=m1 \
 //thickness=0.36 //x=23.315 //y=3.88 //x2=23.43 //y2=3.88
r470 (  5 6 ) resistor r=6.8416 //w=0.131 //l=7.17 //layer=m1 //thickness=0.36 \
 //x=23.315 //y=3.88 //x2=16.145 //y2=3.88
r471 (  4 10 ) resistor r=0.0880901 //w=0.191 //l=0.115 //layer=m1 \
 //thickness=0.36 //x=12.075 //y=3.88 //x2=11.96 //y2=3.88
r472 (  3 12 ) resistor r=0.0880901 //w=0.191 //l=0.115 //layer=m1 \
 //thickness=0.36 //x=15.915 //y=3.88 //x2=16.03 //y2=3.88
r473 (  3 4 ) resistor r=3.66412 //w=0.131 //l=3.84 //layer=m1 \
 //thickness=0.36 //x=15.915 //y=3.88 //x2=12.075 //y2=3.88
r474 (  2 8 ) resistor r=0.0717383 //w=0.224 //l=0.115 //layer=m1 \
 //thickness=0.36 //x=7.265 //y=3.88 //x2=7.15 //y2=3.88
r475 (  1 10 ) resistor r=0.0880901 //w=0.191 //l=0.115 //layer=m1 \
 //thickness=0.36 //x=11.845 //y=3.88 //x2=11.96 //y2=3.88
r476 (  1 2 ) resistor r=4.37023 //w=0.131 //l=4.58 //layer=m1 \
 //thickness=0.36 //x=11.845 //y=3.88 //x2=7.265 //y2=3.88
ends PM_TMRDFFSNQX1\%noxref_7

subckt PM_TMRDFFSNQX1\%noxref_8 ( 1 2 3 4 17 18 29 31 32 36 38 46 53 54 55 56 \
 57 58 59 60 61 62 63 64 66 72 73 74 75 79 80 81 82 83 85 91 92 93 94 114 116 \
 117 )
c232 ( 117 0 ) capacitor c=0.0220291f //x=26.875 //y=5.2
c233 ( 116 0 ) capacitor c=0.0217503f //x=25.995 //y=5.2
c234 ( 114 0 ) capacitor c=0.0084702f //x=26.87 //y=1.085
c235 ( 94 0 ) capacitor c=0.0556143f //x=34.435 //y=4.97
c236 ( 93 0 ) capacitor c=0.0293157f //x=34.725 //y=4.97
c237 ( 92 0 ) capacitor c=0.0347816f //x=34.39 //y=1.4
c238 ( 91 0 ) capacitor c=0.0187487f //x=34.39 //y=1.055
c239 ( 85 0 ) capacitor c=0.0137055f //x=34.235 //y=1.555
c240 ( 83 0 ) capacitor c=0.0149861f //x=34.235 //y=0.9
c241 ( 82 0 ) capacitor c=0.096037f //x=33.86 //y=2.095
c242 ( 81 0 ) capacitor c=0.0228993f //x=33.86 //y=1.71
c243 ( 80 0 ) capacitor c=0.0234352f //x=33.86 //y=1.4
c244 ( 79 0 ) capacitor c=0.0198724f //x=33.86 //y=1.055
c245 ( 75 0 ) capacitor c=0.0557698f //x=29.625 //y=4.97
c246 ( 74 0 ) capacitor c=0.0293157f //x=29.915 //y=4.97
c247 ( 73 0 ) capacitor c=0.0347816f //x=29.58 //y=1.4
c248 ( 72 0 ) capacitor c=0.0187487f //x=29.58 //y=1.055
c249 ( 66 0 ) capacitor c=0.0137055f //x=29.425 //y=1.555
c250 ( 64 0 ) capacitor c=0.0149861f //x=29.425 //y=0.9
c251 ( 63 0 ) capacitor c=0.096037f //x=29.05 //y=2.095
c252 ( 62 0 ) capacitor c=0.0228993f //x=29.05 //y=1.71
c253 ( 61 0 ) capacitor c=0.0234352f //x=29.05 //y=1.4
c254 ( 60 0 ) capacitor c=0.0198724f //x=29.05 //y=1.055
c255 ( 59 0 ) capacitor c=0.110114f //x=34.8 //y=6.2
c256 ( 58 0 ) capacitor c=0.158956f //x=34.36 //y=6.2
c257 ( 57 0 ) capacitor c=0.110114f //x=29.99 //y=6.2
c258 ( 56 0 ) capacitor c=0.158956f //x=29.55 //y=6.2
c259 ( 53 0 ) capacitor c=0.00211606f //x=27.02 //y=5.38
c260 ( 46 0 ) capacitor c=0.0943831f //x=34.16 //y=2.26
c261 ( 38 0 ) capacitor c=0.0969522f //x=29.35 //y=2.26
c262 ( 36 0 ) capacitor c=0.105101f //x=27.5 //y=2.77
c263 ( 32 0 ) capacitor c=0.00404073f //x=27.145 //y=1.835
c264 ( 31 0 ) capacitor c=0.0122201f //x=27.415 //y=1.835
c265 ( 29 0 ) capacitor c=0.0137995f //x=27.415 //y=5.38
c266 ( 18 0 ) capacitor c=0.00251635f //x=26.225 //y=5.38
c267 ( 17 0 ) capacitor c=0.0143649f //x=26.935 //y=5.38
c268 ( 4 0 ) capacitor c=0.00673266f //x=29.615 //y=2.77
c269 ( 3 0 ) capacitor c=0.0686809f //x=34.045 //y=2.77
c270 ( 2 0 ) capacitor c=0.0121637f //x=27.615 //y=2.77
c271 ( 1 0 ) capacitor c=0.0230071f //x=29.205 //y=2.77
r272 (  93 95 ) resistor r=26.9307 //w=0.15 //l=0.106066 //layer=ply \
 //thickness=0.18 //x=34.725 //y=4.97 //x2=34.8 //y2=5.045
r273 (  93 94 ) resistor r=148.702 //w=0.094 //l=0.29 //layer=ply \
 //thickness=0.18 //x=34.725 //y=4.97 //x2=34.435 //y2=4.97
r274 (  92 113 ) resistor r=45.1352 //w=0.168 //l=0.173853 //layer=ply \
 //thickness=0.18 //x=34.39 //y=1.4 //x2=34.35 //y2=1.555
r275 (  91 112 ) resistor r=45.1352 //w=0.168 //l=0.173853 //layer=ply \
 //thickness=0.18 //x=34.39 //y=1.055 //x2=34.35 //y2=0.9
r276 (  91 92 ) resistor r=176.904 //w=0.094 //l=0.345 //layer=ply \
 //thickness=0.18 //x=34.39 //y=1.055 //x2=34.39 //y2=1.4
r277 (  88 94 ) resistor r=22.7971 //w=0.269 //l=0.106066 //layer=ply \
 //thickness=0.18 //x=34.36 //y=5.045 //x2=34.435 //y2=4.97
r278 (  88 111 ) resistor r=35.8364 //w=0.269 //l=0.270185 //layer=ply \
 //thickness=0.18 //x=34.36 //y=5.045 //x2=34.16 //y2=4.88
r279 (  86 107 ) resistor r=10.701 //w=0.21 //l=0.115 //layer=ply \
 //thickness=0.18 //x=34.015 //y=1.555 //x2=33.9 //y2=1.555
r280 (  85 113 ) resistor r=5.52526 //w=0.168 //l=0.115 //layer=ply \
 //thickness=0.18 //x=34.235 //y=1.555 //x2=34.35 //y2=1.555
r281 (  84 106 ) resistor r=5.52526 //w=0.168 //l=0.115 //layer=ply \
 //thickness=0.18 //x=34.015 //y=0.9 //x2=33.9 //y2=0.9
r282 (  83 112 ) resistor r=5.52526 //w=0.168 //l=0.115 //layer=ply \
 //thickness=0.18 //x=34.235 //y=0.9 //x2=34.35 //y2=0.9
r283 (  83 84 ) resistor r=112.809 //w=0.094 //l=0.22 //layer=ply \
 //thickness=0.18 //x=34.235 //y=0.9 //x2=34.015 //y2=0.9
r284 (  82 109 ) resistor r=58.7805 //w=0.246 //l=0.373497 //layer=ply \
 //thickness=0.18 //x=33.86 //y=2.095 //x2=34.16 //y2=2.26
r285 (  81 107 ) resistor r=39.5823 //w=0.21 //l=0.173853 //layer=ply \
 //thickness=0.18 //x=33.86 //y=1.71 //x2=33.9 //y2=1.555
r286 (  81 82 ) resistor r=197.415 //w=0.094 //l=0.385 //layer=ply \
 //thickness=0.18 //x=33.86 //y=1.71 //x2=33.86 //y2=2.095
r287 (  80 107 ) resistor r=39.5823 //w=0.21 //l=0.173853 //layer=ply \
 //thickness=0.18 //x=33.86 //y=1.4 //x2=33.9 //y2=1.555
r288 (  79 106 ) resistor r=45.1352 //w=0.168 //l=0.173853 //layer=ply \
 //thickness=0.18 //x=33.86 //y=1.055 //x2=33.9 //y2=0.9
r289 (  79 80 ) resistor r=176.904 //w=0.094 //l=0.345 //layer=ply \
 //thickness=0.18 //x=33.86 //y=1.055 //x2=33.86 //y2=1.4
r290 (  74 76 ) resistor r=26.9307 //w=0.15 //l=0.106066 //layer=ply \
 //thickness=0.18 //x=29.915 //y=4.97 //x2=29.99 //y2=5.045
r291 (  74 75 ) resistor r=148.702 //w=0.094 //l=0.29 //layer=ply \
 //thickness=0.18 //x=29.915 //y=4.97 //x2=29.625 //y2=4.97
r292 (  73 105 ) resistor r=45.1352 //w=0.168 //l=0.173853 //layer=ply \
 //thickness=0.18 //x=29.58 //y=1.4 //x2=29.54 //y2=1.555
r293 (  72 104 ) resistor r=45.1352 //w=0.168 //l=0.173853 //layer=ply \
 //thickness=0.18 //x=29.58 //y=1.055 //x2=29.54 //y2=0.9
r294 (  72 73 ) resistor r=176.904 //w=0.094 //l=0.345 //layer=ply \
 //thickness=0.18 //x=29.58 //y=1.055 //x2=29.58 //y2=1.4
r295 (  69 75 ) resistor r=22.7971 //w=0.269 //l=0.106066 //layer=ply \
 //thickness=0.18 //x=29.55 //y=5.045 //x2=29.625 //y2=4.97
r296 (  69 103 ) resistor r=35.8364 //w=0.269 //l=0.270185 //layer=ply \
 //thickness=0.18 //x=29.55 //y=5.045 //x2=29.35 //y2=4.88
r297 (  67 99 ) resistor r=10.701 //w=0.21 //l=0.115 //layer=ply \
 //thickness=0.18 //x=29.205 //y=1.555 //x2=29.09 //y2=1.555
r298 (  66 105 ) resistor r=5.52526 //w=0.168 //l=0.115 //layer=ply \
 //thickness=0.18 //x=29.425 //y=1.555 //x2=29.54 //y2=1.555
r299 (  65 98 ) resistor r=5.52526 //w=0.168 //l=0.115 //layer=ply \
 //thickness=0.18 //x=29.205 //y=0.9 //x2=29.09 //y2=0.9
r300 (  64 104 ) resistor r=5.52526 //w=0.168 //l=0.115 //layer=ply \
 //thickness=0.18 //x=29.425 //y=0.9 //x2=29.54 //y2=0.9
r301 (  64 65 ) resistor r=112.809 //w=0.094 //l=0.22 //layer=ply \
 //thickness=0.18 //x=29.425 //y=0.9 //x2=29.205 //y2=0.9
r302 (  63 101 ) resistor r=58.7805 //w=0.246 //l=0.373497 //layer=ply \
 //thickness=0.18 //x=29.05 //y=2.095 //x2=29.35 //y2=2.26
r303 (  62 99 ) resistor r=39.5823 //w=0.21 //l=0.173853 //layer=ply \
 //thickness=0.18 //x=29.05 //y=1.71 //x2=29.09 //y2=1.555
r304 (  62 63 ) resistor r=197.415 //w=0.094 //l=0.385 //layer=ply \
 //thickness=0.18 //x=29.05 //y=1.71 //x2=29.05 //y2=2.095
r305 (  61 99 ) resistor r=39.5823 //w=0.21 //l=0.173853 //layer=ply \
 //thickness=0.18 //x=29.05 //y=1.4 //x2=29.09 //y2=1.555
r306 (  60 98 ) resistor r=45.1352 //w=0.168 //l=0.173853 //layer=ply \
 //thickness=0.18 //x=29.05 //y=1.055 //x2=29.09 //y2=0.9
r307 (  60 61 ) resistor r=176.904 //w=0.094 //l=0.345 //layer=ply \
 //thickness=0.18 //x=29.05 //y=1.055 //x2=29.05 //y2=1.4
r308 (  59 95 ) resistor r=592.245 //w=0.094 //l=1.155 //layer=ply \
 //thickness=0.18 //x=34.8 //y=6.2 //x2=34.8 //y2=5.045
r309 (  58 88 ) resistor r=592.245 //w=0.094 //l=1.155 //layer=ply \
 //thickness=0.18 //x=34.36 //y=6.2 //x2=34.36 //y2=5.045
r310 (  57 76 ) resistor r=592.245 //w=0.094 //l=1.155 //layer=ply \
 //thickness=0.18 //x=29.99 //y=6.2 //x2=29.99 //y2=5.045
r311 (  56 69 ) resistor r=592.245 //w=0.094 //l=1.155 //layer=ply \
 //thickness=0.18 //x=29.55 //y=6.2 //x2=29.55 //y2=5.045
r312 (  55 85 ) resistor r=56.4043 //w=0.094 //l=0.11 //layer=ply \
 //thickness=0.18 //x=34.125 //y=1.555 //x2=34.235 //y2=1.555
r313 (  55 86 ) resistor r=56.4043 //w=0.094 //l=0.11 //layer=ply \
 //thickness=0.18 //x=34.125 //y=1.555 //x2=34.015 //y2=1.555
r314 (  54 66 ) resistor r=56.4043 //w=0.094 //l=0.11 //layer=ply \
 //thickness=0.18 //x=29.315 //y=1.555 //x2=29.425 //y2=1.555
r315 (  54 67 ) resistor r=56.4043 //w=0.094 //l=0.11 //layer=ply \
 //thickness=0.18 //x=29.315 //y=1.555 //x2=29.205 //y2=1.555
r316 (  51 111 ) resistor r=152 //w=0.17 //l=0.17 //layer=licon //count=1 \
 //x=34.16 //y=4.88 //x2=34.16 //y2=4.88
r317 (  49 51 ) resistor r=144.428 //w=0.187 //l=2.11 //layer=li \
 //thickness=0.1 //x=34.16 //y=2.77 //x2=34.16 //y2=4.88
r318 (  46 109 ) resistor r=152 //w=0.17 //l=0.17 //layer=licon //count=1 \
 //x=34.16 //y=2.26 //x2=34.16 //y2=2.26
r319 (  46 49 ) resistor r=34.9091 //w=0.187 //l=0.51 //layer=li \
 //thickness=0.1 //x=34.16 //y=2.26 //x2=34.16 //y2=2.77
r320 (  43 103 ) resistor r=152 //w=0.17 //l=0.17 //layer=licon //count=1 \
 //x=29.35 //y=4.88 //x2=29.35 //y2=4.88
r321 (  41 43 ) resistor r=144.77 //w=0.187 //l=2.115 //layer=li \
 //thickness=0.1 //x=29.35 //y=2.765 //x2=29.35 //y2=4.88
r322 (  38 101 ) resistor r=152 //w=0.17 //l=0.17 //layer=licon //count=1 \
 //x=29.35 //y=2.26 //x2=29.35 //y2=2.26
r323 (  38 41 ) resistor r=34.5668 //w=0.187 //l=0.505 //layer=li \
 //thickness=0.1 //x=29.35 //y=2.26 //x2=29.35 //y2=2.765
r324 (  34 36 ) resistor r=172.834 //w=0.187 //l=2.525 //layer=li \
 //thickness=0.1 //x=27.5 //y=5.295 //x2=27.5 //y2=2.77
r325 (  33 36 ) resistor r=58.1818 //w=0.187 //l=0.85 //layer=li \
 //thickness=0.1 //x=27.5 //y=1.92 //x2=27.5 //y2=2.77
r326 (  31 33 ) resistor r=7.15173 //w=0.17 //l=0.120208 //layer=li \
 //thickness=0.1 //x=27.415 //y=1.835 //x2=27.5 //y2=1.92
r327 (  31 32 ) resistor r=18.4813 //w=0.187 //l=0.27 //layer=li \
 //thickness=0.1 //x=27.415 //y=1.835 //x2=27.145 //y2=1.835
r328 (  30 53 ) resistor r=5.4201 //w=0.17 //l=0.085 //layer=li \
 //thickness=0.1 //x=27.105 //y=5.38 //x2=27.02 //y2=5.38
r329 (  29 34 ) resistor r=7.15173 //w=0.17 //l=0.120208 //layer=li \
 //thickness=0.1 //x=27.415 //y=5.38 //x2=27.5 //y2=5.295
r330 (  29 30 ) resistor r=21.2193 //w=0.187 //l=0.31 //layer=li \
 //thickness=0.1 //x=27.415 //y=5.38 //x2=27.105 //y2=5.38
r331 (  25 32 ) resistor r=7.15173 //w=0.17 //l=0.120208 //layer=li \
 //thickness=0.1 //x=27.06 //y=1.75 //x2=27.145 //y2=1.835
r332 (  25 114 ) resistor r=39.016 //w=0.187 //l=0.57 //layer=li \
 //thickness=0.1 //x=27.06 //y=1.75 //x2=27.06 //y2=1.18
r333 (  19 53 ) resistor r=1.40859 //w=0.34 //l=0.085 //layer=li \
 //thickness=0.1 //x=27.02 //y=5.465 //x2=27.02 //y2=5.38
r334 (  19 117 ) resistor r=30.1176 //w=0.187 //l=0.44 //layer=li \
 //thickness=0.1 //x=27.02 //y=5.465 //x2=27.02 //y2=5.905
r335 (  17 53 ) resistor r=5.4201 //w=0.17 //l=0.085 //layer=li \
 //thickness=0.1 //x=26.935 //y=5.38 //x2=27.02 //y2=5.38
r336 (  17 18 ) resistor r=48.5989 //w=0.187 //l=0.71 //layer=li \
 //thickness=0.1 //x=26.935 //y=5.38 //x2=26.225 //y2=5.38
r337 (  11 18 ) resistor r=7.15173 //w=0.17 //l=0.120208 //layer=li \
 //thickness=0.1 //x=26.14 //y=5.465 //x2=26.225 //y2=5.38
r338 (  11 116 ) resistor r=30.1176 //w=0.187 //l=0.44 //layer=li \
 //thickness=0.1 //x=26.14 //y=5.465 //x2=26.14 //y2=5.905
r339 (  10 49 ) resistor r=9.3 //w=0.17 //l=0.17 //layer=mcon //count=1 \
 //x=34.16 //y=2.77 //x2=34.16 //y2=2.77
r340 (  8 41 ) resistor r=9.3 //w=0.17 //l=0.17 //layer=mcon //count=1 \
 //x=29.35 //y=2.765 //x2=29.35 //y2=2.765
r341 (  6 36 ) resistor r=9.3 //w=0.17 //l=0.17 //layer=mcon //count=1 \
 //x=27.5 //y=2.77 //x2=27.5 //y2=2.77
r342 (  4 8 ) resistor r=0.164988 //w=0.206 //l=0.267488 //layer=m1 \
 //thickness=0.36 //x=29.615 //y=2.77 //x2=29.35 //y2=2.765
r343 (  3 10 ) resistor r=0.0717383 //w=0.224 //l=0.115 //layer=m1 \
 //thickness=0.36 //x=34.045 //y=2.77 //x2=34.16 //y2=2.77
r344 (  3 4 ) resistor r=4.2271 //w=0.131 //l=4.43 //layer=m1 //thickness=0.36 \
 //x=34.045 //y=2.77 //x2=29.615 //y2=2.77
r345 (  2 6 ) resistor r=0.0717383 //w=0.224 //l=0.115 //layer=m1 \
 //thickness=0.36 //x=27.615 //y=2.77 //x2=27.5 //y2=2.77
r346 (  1 8 ) resistor r=0.0921728 //w=0.206 //l=0.147479 //layer=m1 \
 //thickness=0.36 //x=29.205 //y=2.77 //x2=29.35 //y2=2.765
r347 (  1 2 ) resistor r=1.51718 //w=0.131 //l=1.59 //layer=m1 \
 //thickness=0.36 //x=29.205 //y=2.77 //x2=27.615 //y2=2.77
ends PM_TMRDFFSNQX1\%noxref_8

subckt PM_TMRDFFSNQX1\%noxref_9 ( 1 2 13 14 21 29 35 36 40 42 49 50 51 52 53 \
 54 55 56 57 61 63 66 67 77 80 82 83 84 )
c166 ( 84 0 ) capacitor c=0.023087f //x=36.195 //y=5.2
c167 ( 83 0 ) capacitor c=0.023519f //x=35.315 //y=5.2
c168 ( 82 0 ) capacitor c=0.0224735f //x=34.435 //y=5.2
c169 ( 80 0 ) capacitor c=0.00872971f //x=36.445 //y=1.095
c170 ( 77 0 ) capacitor c=0.0588816f //x=38.97 //y=4.88
c171 ( 67 0 ) capacitor c=0.0318948f //x=39.305 //y=1.39
c172 ( 66 0 ) capacitor c=0.0187384f //x=39.305 //y=1.045
c173 ( 63 0 ) capacitor c=0.0141798f //x=39.15 //y=1.545
c174 ( 61 0 ) capacitor c=0.0149844f //x=39.15 //y=0.89
c175 ( 57 0 ) capacitor c=0.0813322f //x=38.775 //y=2.095
c176 ( 56 0 ) capacitor c=0.0229267f //x=38.775 //y=1.7
c177 ( 55 0 ) capacitor c=0.0234352f //x=38.775 //y=1.39
c178 ( 54 0 ) capacitor c=0.0199343f //x=38.775 //y=1.045
c179 ( 53 0 ) capacitor c=0.110275f //x=39.31 //y=6.2
c180 ( 52 0 ) capacitor c=0.154305f //x=38.87 //y=6.2
c181 ( 50 0 ) capacitor c=0.00106608f //x=36.34 //y=5.335
c182 ( 49 0 ) capacitor c=0.00207319f //x=35.46 //y=5.335
c183 ( 42 0 ) capacitor c=0.0839295f //x=38.97 //y=2.26
c184 ( 40 0 ) capacitor c=0.10402f //x=37.12 //y=2.77
c185 ( 36 0 ) capacitor c=0.00398962f //x=36.72 //y=1.845
c186 ( 35 0 ) capacitor c=0.0137288f //x=37.035 //y=1.845
c187 ( 29 0 ) capacitor c=0.0284988f //x=37.035 //y=5.335
c188 ( 21 0 ) capacitor c=0.0176454f //x=36.255 //y=5.335
c189 ( 14 0 ) capacitor c=0.00332903f //x=34.665 //y=5.335
c190 ( 13 0 ) capacitor c=0.0148427f //x=35.375 //y=5.335
c191 ( 2 0 ) capacitor c=0.00808366f //x=37.235 //y=2.77
c192 ( 1 0 ) capacitor c=0.0353429f //x=38.855 //y=2.77
r193 (  75 77 ) resistor r=20.6867 //w=0.233 //l=0.1 //layer=ply \
 //thickness=0.18 //x=38.87 //y=4.88 //x2=38.97 //y2=4.88
r194 (  68 77 ) resistor r=70.3348 //w=0.233 //l=0.414367 //layer=ply \
 //thickness=0.18 //x=39.31 //y=5.045 //x2=38.97 //y2=4.88
r195 (  67 79 ) resistor r=45.1352 //w=0.168 //l=0.173853 //layer=ply \
 //thickness=0.18 //x=39.305 //y=1.39 //x2=39.265 //y2=1.545
r196 (  66 78 ) resistor r=45.1352 //w=0.168 //l=0.173853 //layer=ply \
 //thickness=0.18 //x=39.305 //y=1.045 //x2=39.265 //y2=0.89
r197 (  66 67 ) resistor r=176.904 //w=0.094 //l=0.345 //layer=ply \
 //thickness=0.18 //x=39.305 //y=1.045 //x2=39.305 //y2=1.39
r198 (  64 74 ) resistor r=10.701 //w=0.21 //l=0.115 //layer=ply \
 //thickness=0.18 //x=38.93 //y=1.545 //x2=38.815 //y2=1.545
r199 (  63 79 ) resistor r=5.52526 //w=0.168 //l=0.115 //layer=ply \
 //thickness=0.18 //x=39.15 //y=1.545 //x2=39.265 //y2=1.545
r200 (  62 73 ) resistor r=5.52526 //w=0.168 //l=0.115 //layer=ply \
 //thickness=0.18 //x=38.93 //y=0.89 //x2=38.815 //y2=0.89
r201 (  61 78 ) resistor r=5.52526 //w=0.168 //l=0.115 //layer=ply \
 //thickness=0.18 //x=39.15 //y=0.89 //x2=39.265 //y2=0.89
r202 (  61 62 ) resistor r=112.809 //w=0.094 //l=0.22 //layer=ply \
 //thickness=0.18 //x=39.15 //y=0.89 //x2=38.93 //y2=0.89
r203 (  58 75 ) resistor r=13.0941 //w=0.233 //l=0.165 //layer=ply \
 //thickness=0.18 //x=38.87 //y=5.045 //x2=38.87 //y2=4.88
r204 (  57 72 ) resistor r=34.8111 //w=0.27 //l=0.264953 //layer=ply \
 //thickness=0.18 //x=38.775 //y=2.095 //x2=38.97 //y2=2.26
r205 (  56 74 ) resistor r=39.5823 //w=0.21 //l=0.173853 //layer=ply \
 //thickness=0.18 //x=38.775 //y=1.7 //x2=38.815 //y2=1.545
r206 (  56 57 ) resistor r=202.543 //w=0.094 //l=0.395 //layer=ply \
 //thickness=0.18 //x=38.775 //y=1.7 //x2=38.775 //y2=2.095
r207 (  55 74 ) resistor r=39.5823 //w=0.21 //l=0.173853 //layer=ply \
 //thickness=0.18 //x=38.775 //y=1.39 //x2=38.815 //y2=1.545
r208 (  54 73 ) resistor r=45.1352 //w=0.168 //l=0.173853 //layer=ply \
 //thickness=0.18 //x=38.775 //y=1.045 //x2=38.815 //y2=0.89
r209 (  54 55 ) resistor r=176.904 //w=0.094 //l=0.345 //layer=ply \
 //thickness=0.18 //x=38.775 //y=1.045 //x2=38.775 //y2=1.39
r210 (  53 68 ) resistor r=592.245 //w=0.094 //l=1.155 //layer=ply \
 //thickness=0.18 //x=39.31 //y=6.2 //x2=39.31 //y2=5.045
r211 (  52 58 ) resistor r=592.245 //w=0.094 //l=1.155 //layer=ply \
 //thickness=0.18 //x=38.87 //y=6.2 //x2=38.87 //y2=5.045
r212 (  51 63 ) resistor r=56.4043 //w=0.094 //l=0.11 //layer=ply \
 //thickness=0.18 //x=39.04 //y=1.545 //x2=39.15 //y2=1.545
r213 (  51 64 ) resistor r=56.4043 //w=0.094 //l=0.11 //layer=ply \
 //thickness=0.18 //x=39.04 //y=1.545 //x2=38.93 //y2=1.545
r214 (  47 77 ) resistor r=152 //w=0.17 //l=0.17 //layer=licon //count=1 \
 //x=38.97 //y=4.88 //x2=38.97 //y2=4.88
r215 (  45 47 ) resistor r=144.428 //w=0.187 //l=2.11 //layer=li \
 //thickness=0.1 //x=38.97 //y=2.77 //x2=38.97 //y2=4.88
r216 (  42 72 ) resistor r=152 //w=0.17 //l=0.17 //layer=licon //count=1 \
 //x=38.97 //y=2.26 //x2=38.97 //y2=2.26
r217 (  42 45 ) resistor r=34.9091 //w=0.187 //l=0.51 //layer=li \
 //thickness=0.1 //x=38.97 //y=2.26 //x2=38.97 //y2=2.77
r218 (  38 40 ) resistor r=169.754 //w=0.187 //l=2.48 //layer=li \
 //thickness=0.1 //x=37.12 //y=5.25 //x2=37.12 //y2=2.77
r219 (  37 40 ) resistor r=57.4973 //w=0.187 //l=0.84 //layer=li \
 //thickness=0.1 //x=37.12 //y=1.93 //x2=37.12 //y2=2.77
r220 (  35 37 ) resistor r=7.15173 //w=0.17 //l=0.120208 //layer=li \
 //thickness=0.1 //x=37.035 //y=1.845 //x2=37.12 //y2=1.93
r221 (  35 36 ) resistor r=21.5615 //w=0.187 //l=0.315 //layer=li \
 //thickness=0.1 //x=37.035 //y=1.845 //x2=36.72 //y2=1.845
r222 (  31 36 ) resistor r=7.15173 //w=0.17 //l=0.120208 //layer=li \
 //thickness=0.1 //x=36.635 //y=1.76 //x2=36.72 //y2=1.845
r223 (  31 80 ) resistor r=39.016 //w=0.187 //l=0.57 //layer=li \
 //thickness=0.1 //x=36.635 //y=1.76 //x2=36.635 //y2=1.19
r224 (  30 50 ) resistor r=5.4201 //w=0.17 //l=0.085 //layer=li \
 //thickness=0.1 //x=36.425 //y=5.335 //x2=36.34 //y2=5.335
r225 (  29 38 ) resistor r=7.15173 //w=0.17 //l=0.120208 //layer=li \
 //thickness=0.1 //x=37.035 //y=5.335 //x2=37.12 //y2=5.25
r226 (  29 30 ) resistor r=41.754 //w=0.187 //l=0.61 //layer=li \
 //thickness=0.1 //x=37.035 //y=5.335 //x2=36.425 //y2=5.335
r227 (  23 50 ) resistor r=1.40859 //w=0.34 //l=0.085 //layer=li \
 //thickness=0.1 //x=36.34 //y=5.42 //x2=36.34 //y2=5.335
r228 (  23 84 ) resistor r=33.1979 //w=0.187 //l=0.485 //layer=li \
 //thickness=0.1 //x=36.34 //y=5.42 //x2=36.34 //y2=5.905
r229 (  22 49 ) resistor r=5.4201 //w=0.17 //l=0.085 //layer=li \
 //thickness=0.1 //x=35.545 //y=5.335 //x2=35.46 //y2=5.335
r230 (  21 50 ) resistor r=5.4201 //w=0.17 //l=0.085 //layer=li \
 //thickness=0.1 //x=36.255 //y=5.335 //x2=36.34 //y2=5.335
r231 (  21 22 ) resistor r=48.5989 //w=0.187 //l=0.71 //layer=li \
 //thickness=0.1 //x=36.255 //y=5.335 //x2=35.545 //y2=5.335
r232 (  15 49 ) resistor r=1.40859 //w=0.34 //l=0.085 //layer=li \
 //thickness=0.1 //x=35.46 //y=5.42 //x2=35.46 //y2=5.335
r233 (  15 83 ) resistor r=33.1979 //w=0.187 //l=0.485 //layer=li \
 //thickness=0.1 //x=35.46 //y=5.42 //x2=35.46 //y2=5.905
r234 (  13 49 ) resistor r=5.4201 //w=0.17 //l=0.085 //layer=li \
 //thickness=0.1 //x=35.375 //y=5.335 //x2=35.46 //y2=5.335
r235 (  13 14 ) resistor r=48.5989 //w=0.187 //l=0.71 //layer=li \
 //thickness=0.1 //x=35.375 //y=5.335 //x2=34.665 //y2=5.335
r236 (  7 14 ) resistor r=7.15173 //w=0.17 //l=0.120208 //layer=li \
 //thickness=0.1 //x=34.58 //y=5.42 //x2=34.665 //y2=5.335
r237 (  7 82 ) resistor r=33.1979 //w=0.187 //l=0.485 //layer=li \
 //thickness=0.1 //x=34.58 //y=5.42 //x2=34.58 //y2=5.905
r238 (  6 45 ) resistor r=9.3 //w=0.17 //l=0.17 //layer=mcon //count=1 \
 //x=38.97 //y=2.77 //x2=38.97 //y2=2.77
r239 (  4 40 ) resistor r=9.3 //w=0.17 //l=0.17 //layer=mcon //count=1 \
 //x=37.12 //y=2.77 //x2=37.12 //y2=2.77
r240 (  2 4 ) resistor r=0.0717383 //w=0.224 //l=0.115 //layer=m1 \
 //thickness=0.36 //x=37.235 //y=2.77 //x2=37.12 //y2=2.77
r241 (  1 6 ) resistor r=0.0717383 //w=0.224 //l=0.115 //layer=m1 \
 //thickness=0.36 //x=38.855 //y=2.77 //x2=38.97 //y2=2.77
r242 (  1 2 ) resistor r=1.5458 //w=0.131 //l=1.62 //layer=m1 //thickness=0.36 \
 //x=38.855 //y=2.77 //x2=37.235 //y2=2.77
ends PM_TMRDFFSNQX1\%noxref_9

subckt PM_TMRDFFSNQX1\%noxref_10 ( 1 2 3 4 11 13 23 24 31 39 45 46 50 52 61 62 \
 64 65 67 68 69 70 71 72 73 74 75 80 82 84 90 91 92 93 94 95 99 101 104 105 \
 110 111 114 128 131 133 134 135 )
c281 ( 135 0 ) capacitor c=0.023087f //x=31.385 //y=5.2
c282 ( 134 0 ) capacitor c=0.023519f //x=30.505 //y=5.2
c283 ( 133 0 ) capacitor c=0.0224735f //x=29.625 //y=5.2
c284 ( 131 0 ) capacitor c=0.00853354f //x=31.635 //y=1.095
c285 ( 128 0 ) capacitor c=0.0588816f //x=42.3 //y=4.88
c286 ( 114 0 ) capacitor c=0.0331095f //x=26.79 //y=4.88
c287 ( 111 0 ) capacitor c=0.0279499f //x=26.76 //y=2.095
c288 ( 110 0 ) capacitor c=0.0421676f //x=26.76 //y=2.26
c289 ( 105 0 ) capacitor c=0.0318948f //x=42.635 //y=1.39
c290 ( 104 0 ) capacitor c=0.0187384f //x=42.635 //y=1.045
c291 ( 101 0 ) capacitor c=0.0141798f //x=42.48 //y=1.545
c292 ( 99 0 ) capacitor c=0.0149844f //x=42.48 //y=0.89
c293 ( 95 0 ) capacitor c=0.0813322f //x=42.105 //y=2.095
c294 ( 94 0 ) capacitor c=0.0229267f //x=42.105 //y=1.7
c295 ( 93 0 ) capacitor c=0.0234352f //x=42.105 //y=1.39
c296 ( 92 0 ) capacitor c=0.0199343f //x=42.105 //y=1.045
c297 ( 91 0 ) capacitor c=0.0429696f //x=27.325 //y=1.43
c298 ( 90 0 ) capacitor c=0.0192208f //x=27.325 //y=1.085
c299 ( 84 0 ) capacitor c=0.0148884f //x=27.17 //y=1.585
c300 ( 82 0 ) capacitor c=0.0157803f //x=27.17 //y=0.93
c301 ( 80 0 ) capacitor c=0.0295235f //x=27.165 //y=4.97
c302 ( 75 0 ) capacitor c=0.0205163f //x=26.795 //y=1.74
c303 ( 74 0 ) capacitor c=0.0168481f //x=26.795 //y=1.43
c304 ( 73 0 ) capacitor c=0.0174783f //x=26.795 //y=1.085
c305 ( 72 0 ) capacitor c=0.110275f //x=42.64 //y=6.2
c306 ( 71 0 ) capacitor c=0.154305f //x=42.2 //y=6.2
c307 ( 70 0 ) capacitor c=0.15358f //x=27.24 //y=6.2
c308 ( 69 0 ) capacitor c=0.110281f //x=26.8 //y=6.2
c309 ( 65 0 ) capacitor c=0.0715637f //x=32.307 //y=4.085
c310 ( 64 0 ) capacitor c=0.0101843f //x=32.305 //y=4.25
c311 ( 62 0 ) capacitor c=0.00106608f //x=31.53 //y=5.335
c312 ( 61 0 ) capacitor c=0.00207162f //x=30.65 //y=5.335
c313 ( 52 0 ) capacitor c=0.0857541f //x=42.3 //y=2.26
c314 ( 50 0 ) capacitor c=0.0236247f //x=32.31 //y=5.25
c315 ( 46 0 ) capacitor c=0.00398962f //x=31.91 //y=1.845
c316 ( 45 0 ) capacitor c=0.0135805f //x=32.225 //y=1.845
c317 ( 39 0 ) capacitor c=0.0281378f //x=32.225 //y=5.335
c318 ( 31 0 ) capacitor c=0.0176454f //x=31.445 //y=5.335
c319 ( 24 0 ) capacitor c=0.00332903f //x=29.855 //y=5.335
c320 ( 23 0 ) capacitor c=0.014837f //x=30.565 //y=5.335
c321 ( 13 0 ) capacitor c=0.0705158f //x=26.76 //y=2.26
c322 ( 11 0 ) capacitor c=0.00453889f //x=26.76 //y=4.715
c323 ( 4 0 ) capacitor c=0.00551102f //x=32.42 //y=4.25
c324 ( 3 0 ) capacitor c=0.141703f //x=42.185 //y=4.25
c325 ( 2 0 ) capacitor c=0.0142462f //x=26.875 //y=4.25
c326 ( 1 0 ) capacitor c=0.0882171f //x=32.19 //y=4.25
r327 (  126 128 ) resistor r=20.6867 //w=0.233 //l=0.1 //layer=ply \
 //thickness=0.18 //x=42.2 //y=4.88 //x2=42.3 //y2=4.88
r328 (  116 117 ) resistor r=32.4568 //w=0.214 //l=0.075 //layer=ply \
 //thickness=0.18 //x=26.79 //y=4.97 //x2=26.79 //y2=5.045
r329 (  114 116 ) resistor r=20.271 //w=0.214 //l=0.09 //layer=ply \
 //thickness=0.18 //x=26.79 //y=4.88 //x2=26.79 //y2=4.97
r330 (  110 111 ) resistor r=52.7279 //w=0.214 //l=0.165 //layer=ply \
 //thickness=0.18 //x=26.76 //y=2.26 //x2=26.76 //y2=2.095
r331 (  106 128 ) resistor r=70.3348 //w=0.233 //l=0.414367 //layer=ply \
 //thickness=0.18 //x=42.64 //y=5.045 //x2=42.3 //y2=4.88
r332 (  105 130 ) resistor r=45.1352 //w=0.168 //l=0.173853 //layer=ply \
 //thickness=0.18 //x=42.635 //y=1.39 //x2=42.595 //y2=1.545
r333 (  104 129 ) resistor r=45.1352 //w=0.168 //l=0.173853 //layer=ply \
 //thickness=0.18 //x=42.635 //y=1.045 //x2=42.595 //y2=0.89
r334 (  104 105 ) resistor r=176.904 //w=0.094 //l=0.345 //layer=ply \
 //thickness=0.18 //x=42.635 //y=1.045 //x2=42.635 //y2=1.39
r335 (  102 125 ) resistor r=10.701 //w=0.21 //l=0.115 //layer=ply \
 //thickness=0.18 //x=42.26 //y=1.545 //x2=42.145 //y2=1.545
r336 (  101 130 ) resistor r=5.52526 //w=0.168 //l=0.115 //layer=ply \
 //thickness=0.18 //x=42.48 //y=1.545 //x2=42.595 //y2=1.545
r337 (  100 124 ) resistor r=5.52526 //w=0.168 //l=0.115 //layer=ply \
 //thickness=0.18 //x=42.26 //y=0.89 //x2=42.145 //y2=0.89
r338 (  99 129 ) resistor r=5.52526 //w=0.168 //l=0.115 //layer=ply \
 //thickness=0.18 //x=42.48 //y=0.89 //x2=42.595 //y2=0.89
r339 (  99 100 ) resistor r=112.809 //w=0.094 //l=0.22 //layer=ply \
 //thickness=0.18 //x=42.48 //y=0.89 //x2=42.26 //y2=0.89
r340 (  96 126 ) resistor r=13.0941 //w=0.233 //l=0.165 //layer=ply \
 //thickness=0.18 //x=42.2 //y=5.045 //x2=42.2 //y2=4.88
r341 (  95 123 ) resistor r=34.8111 //w=0.27 //l=0.264953 //layer=ply \
 //thickness=0.18 //x=42.105 //y=2.095 //x2=42.3 //y2=2.26
r342 (  94 125 ) resistor r=39.5823 //w=0.21 //l=0.173853 //layer=ply \
 //thickness=0.18 //x=42.105 //y=1.7 //x2=42.145 //y2=1.545
r343 (  94 95 ) resistor r=202.543 //w=0.094 //l=0.395 //layer=ply \
 //thickness=0.18 //x=42.105 //y=1.7 //x2=42.105 //y2=2.095
r344 (  93 125 ) resistor r=39.5823 //w=0.21 //l=0.173853 //layer=ply \
 //thickness=0.18 //x=42.105 //y=1.39 //x2=42.145 //y2=1.545
r345 (  92 124 ) resistor r=45.1352 //w=0.168 //l=0.173853 //layer=ply \
 //thickness=0.18 //x=42.105 //y=1.045 //x2=42.145 //y2=0.89
r346 (  92 93 ) resistor r=176.904 //w=0.094 //l=0.345 //layer=ply \
 //thickness=0.18 //x=42.105 //y=1.045 //x2=42.105 //y2=1.39
r347 (  91 121 ) resistor r=45.1352 //w=0.168 //l=0.173853 //layer=ply \
 //thickness=0.18 //x=27.325 //y=1.43 //x2=27.285 //y2=1.585
r348 (  90 120 ) resistor r=45.1352 //w=0.168 //l=0.173853 //layer=ply \
 //thickness=0.18 //x=27.325 //y=1.085 //x2=27.285 //y2=0.93
r349 (  90 91 ) resistor r=176.904 //w=0.094 //l=0.345 //layer=ply \
 //thickness=0.18 //x=27.325 //y=1.085 //x2=27.325 //y2=1.43
r350 (  85 119 ) resistor r=10.701 //w=0.21 //l=0.115 //layer=ply \
 //thickness=0.18 //x=26.95 //y=1.585 //x2=26.835 //y2=1.585
r351 (  84 121 ) resistor r=5.52526 //w=0.168 //l=0.115 //layer=ply \
 //thickness=0.18 //x=27.17 //y=1.585 //x2=27.285 //y2=1.585
r352 (  83 118 ) resistor r=5.52526 //w=0.168 //l=0.115 //layer=ply \
 //thickness=0.18 //x=26.95 //y=0.93 //x2=26.835 //y2=0.93
r353 (  82 120 ) resistor r=5.52526 //w=0.168 //l=0.115 //layer=ply \
 //thickness=0.18 //x=27.17 //y=0.93 //x2=27.285 //y2=0.93
r354 (  82 83 ) resistor r=112.809 //w=0.094 //l=0.22 //layer=ply \
 //thickness=0.18 //x=27.17 //y=0.93 //x2=26.95 //y2=0.93
r355 (  81 116 ) resistor r=16.5046 //w=0.27 //l=0.135 //layer=ply \
 //thickness=0.18 //x=26.925 //y=4.97 //x2=26.79 //y2=4.97
r356 (  80 87 ) resistor r=26.9307 //w=0.15 //l=0.106066 //layer=ply \
 //thickness=0.18 //x=27.165 //y=4.97 //x2=27.24 //y2=5.045
r357 (  80 81 ) resistor r=123.064 //w=0.094 //l=0.24 //layer=ply \
 //thickness=0.18 //x=27.165 //y=4.97 //x2=26.925 //y2=4.97
r358 (  75 119 ) resistor r=39.5823 //w=0.21 //l=0.173853 //layer=ply \
 //thickness=0.18 //x=26.795 //y=1.74 //x2=26.835 //y2=1.585
r359 (  75 111 ) resistor r=182.032 //w=0.094 //l=0.355 //layer=ply \
 //thickness=0.18 //x=26.795 //y=1.74 //x2=26.795 //y2=2.095
r360 (  74 119 ) resistor r=39.5823 //w=0.21 //l=0.173853 //layer=ply \
 //thickness=0.18 //x=26.795 //y=1.43 //x2=26.835 //y2=1.585
r361 (  73 118 ) resistor r=45.1352 //w=0.168 //l=0.173853 //layer=ply \
 //thickness=0.18 //x=26.795 //y=1.085 //x2=26.835 //y2=0.93
r362 (  73 74 ) resistor r=176.904 //w=0.094 //l=0.345 //layer=ply \
 //thickness=0.18 //x=26.795 //y=1.085 //x2=26.795 //y2=1.43
r363 (  72 106 ) resistor r=592.245 //w=0.094 //l=1.155 //layer=ply \
 //thickness=0.18 //x=42.64 //y=6.2 //x2=42.64 //y2=5.045
r364 (  71 96 ) resistor r=592.245 //w=0.094 //l=1.155 //layer=ply \
 //thickness=0.18 //x=42.2 //y=6.2 //x2=42.2 //y2=5.045
r365 (  70 87 ) resistor r=592.245 //w=0.094 //l=1.155 //layer=ply \
 //thickness=0.18 //x=27.24 //y=6.2 //x2=27.24 //y2=5.045
r366 (  69 117 ) resistor r=592.245 //w=0.094 //l=1.155 //layer=ply \
 //thickness=0.18 //x=26.8 //y=6.2 //x2=26.8 //y2=5.045
r367 (  68 101 ) resistor r=56.4043 //w=0.094 //l=0.11 //layer=ply \
 //thickness=0.18 //x=42.37 //y=1.545 //x2=42.48 //y2=1.545
r368 (  68 102 ) resistor r=56.4043 //w=0.094 //l=0.11 //layer=ply \
 //thickness=0.18 //x=42.37 //y=1.545 //x2=42.26 //y2=1.545
r369 (  67 84 ) resistor r=56.4043 //w=0.094 //l=0.11 //layer=ply \
 //thickness=0.18 //x=27.06 //y=1.585 //x2=27.17 //y2=1.585
r370 (  67 85 ) resistor r=56.4043 //w=0.094 //l=0.11 //layer=ply \
 //thickness=0.18 //x=27.06 //y=1.585 //x2=26.95 //y2=1.585
r371 (  64 66 ) resistor r=11 //w=0.192 //l=0.165 //layer=li //thickness=0.1 \
 //x=32.307 //y=4.25 //x2=32.307 //y2=4.415
r372 (  64 65 ) resistor r=11 //w=0.192 //l=0.165 //layer=li //thickness=0.1 \
 //x=32.307 //y=4.25 //x2=32.307 //y2=4.085
r373 (  60 114 ) resistor r=152 //w=0.17 //l=0.17 //layer=licon //count=1 \
 //x=26.79 //y=4.88 //x2=26.79 //y2=4.88
r374 (  57 128 ) resistor r=152 //w=0.17 //l=0.17 //layer=licon //count=1 \
 //x=42.3 //y=4.88 //x2=42.3 //y2=4.88
r375 (  55 57 ) resistor r=43.123 //w=0.187 //l=0.63 //layer=li \
 //thickness=0.1 //x=42.3 //y=4.25 //x2=42.3 //y2=4.88
r376 (  52 123 ) resistor r=152 //w=0.17 //l=0.17 //layer=licon //count=1 \
 //x=42.3 //y=2.26 //x2=42.3 //y2=2.26
r377 (  52 55 ) resistor r=136.214 //w=0.187 //l=1.99 //layer=li \
 //thickness=0.1 //x=42.3 //y=2.26 //x2=42.3 //y2=4.25
r378 (  50 66 ) resistor r=57.1551 //w=0.187 //l=0.835 //layer=li \
 //thickness=0.1 //x=32.31 //y=5.25 //x2=32.31 //y2=4.415
r379 (  47 65 ) resistor r=147.508 //w=0.187 //l=2.155 //layer=li \
 //thickness=0.1 //x=32.31 //y=1.93 //x2=32.31 //y2=4.085
r380 (  45 47 ) resistor r=7.15173 //w=0.17 //l=0.120208 //layer=li \
 //thickness=0.1 //x=32.225 //y=1.845 //x2=32.31 //y2=1.93
r381 (  45 46 ) resistor r=21.5615 //w=0.187 //l=0.315 //layer=li \
 //thickness=0.1 //x=32.225 //y=1.845 //x2=31.91 //y2=1.845
r382 (  41 46 ) resistor r=7.15173 //w=0.17 //l=0.120208 //layer=li \
 //thickness=0.1 //x=31.825 //y=1.76 //x2=31.91 //y2=1.845
r383 (  41 131 ) resistor r=39.016 //w=0.187 //l=0.57 //layer=li \
 //thickness=0.1 //x=31.825 //y=1.76 //x2=31.825 //y2=1.19
r384 (  40 62 ) resistor r=5.4201 //w=0.17 //l=0.085 //layer=li \
 //thickness=0.1 //x=31.615 //y=5.335 //x2=31.53 //y2=5.335
r385 (  39 50 ) resistor r=7.15173 //w=0.17 //l=0.120208 //layer=li \
 //thickness=0.1 //x=32.225 //y=5.335 //x2=32.31 //y2=5.25
r386 (  39 40 ) resistor r=41.754 //w=0.187 //l=0.61 //layer=li \
 //thickness=0.1 //x=32.225 //y=5.335 //x2=31.615 //y2=5.335
r387 (  33 62 ) resistor r=1.40859 //w=0.34 //l=0.085 //layer=li \
 //thickness=0.1 //x=31.53 //y=5.42 //x2=31.53 //y2=5.335
r388 (  33 135 ) resistor r=33.1979 //w=0.187 //l=0.485 //layer=li \
 //thickness=0.1 //x=31.53 //y=5.42 //x2=31.53 //y2=5.905
r389 (  32 61 ) resistor r=5.4201 //w=0.17 //l=0.085 //layer=li \
 //thickness=0.1 //x=30.735 //y=5.335 //x2=30.65 //y2=5.335
r390 (  31 62 ) resistor r=5.4201 //w=0.17 //l=0.085 //layer=li \
 //thickness=0.1 //x=31.445 //y=5.335 //x2=31.53 //y2=5.335
r391 (  31 32 ) resistor r=48.5989 //w=0.187 //l=0.71 //layer=li \
 //thickness=0.1 //x=31.445 //y=5.335 //x2=30.735 //y2=5.335
r392 (  25 61 ) resistor r=1.40859 //w=0.34 //l=0.085 //layer=li \
 //thickness=0.1 //x=30.65 //y=5.42 //x2=30.65 //y2=5.335
r393 (  25 134 ) resistor r=33.1979 //w=0.187 //l=0.485 //layer=li \
 //thickness=0.1 //x=30.65 //y=5.42 //x2=30.65 //y2=5.905
r394 (  23 61 ) resistor r=5.4201 //w=0.17 //l=0.085 //layer=li \
 //thickness=0.1 //x=30.565 //y=5.335 //x2=30.65 //y2=5.335
r395 (  23 24 ) resistor r=48.5989 //w=0.187 //l=0.71 //layer=li \
 //thickness=0.1 //x=30.565 //y=5.335 //x2=29.855 //y2=5.335
r396 (  17 24 ) resistor r=7.15173 //w=0.17 //l=0.120208 //layer=li \
 //thickness=0.1 //x=29.77 //y=5.42 //x2=29.855 //y2=5.335
r397 (  17 133 ) resistor r=33.1979 //w=0.187 //l=0.485 //layer=li \
 //thickness=0.1 //x=29.77 //y=5.42 //x2=29.77 //y2=5.905
r398 (  13 110 ) resistor r=152 //w=0.17 //l=0.17 //layer=licon //count=1 \
 //x=26.76 //y=2.26 //x2=26.76 //y2=2.26
r399 (  13 16 ) resistor r=136.214 //w=0.187 //l=1.99 //layer=li \
 //thickness=0.1 //x=26.76 //y=2.26 //x2=26.76 //y2=4.25
r400 (  11 60 ) resistor r=11.4737 //w=0.186 //l=0.172337 //layer=li \
 //thickness=0.1 //x=26.76 //y=4.715 //x2=26.775 //y2=4.88
r401 (  11 16 ) resistor r=31.8289 //w=0.187 //l=0.465 //layer=li \
 //thickness=0.1 //x=26.76 //y=4.715 //x2=26.76 //y2=4.25
r402 (  10 55 ) resistor r=9.3 //w=0.17 //l=0.17 //layer=mcon //count=1 \
 //x=42.3 //y=4.25 //x2=42.3 //y2=4.25
r403 (  8 64 ) resistor r=9.3 //w=0.17 //l=0.17 //layer=mcon //count=1 \
 //x=32.305 //y=4.25 //x2=32.305 //y2=4.25
r404 (  6 16 ) resistor r=9.3 //w=0.17 //l=0.17 //layer=mcon //count=1 \
 //x=26.76 //y=4.25 //x2=26.76 //y2=4.25
r405 (  4 8 ) resistor r=0.0880901 //w=0.191 //l=0.115 //layer=m1 \
 //thickness=0.36 //x=32.42 //y=4.25 //x2=32.305 //y2=4.25
r406 (  3 10 ) resistor r=0.0717383 //w=0.224 //l=0.115 //layer=m1 \
 //thickness=0.36 //x=42.185 //y=4.25 //x2=42.3 //y2=4.25
r407 (  3 4 ) resistor r=9.31775 //w=0.131 //l=9.765 //layer=m1 \
 //thickness=0.36 //x=42.185 //y=4.25 //x2=32.42 //y2=4.25
r408 (  2 6 ) resistor r=0.0717383 //w=0.224 //l=0.115 //layer=m1 \
 //thickness=0.36 //x=26.875 //y=4.25 //x2=26.76 //y2=4.25
r409 (  1 8 ) resistor r=0.0880901 //w=0.191 //l=0.115 //layer=m1 \
 //thickness=0.36 //x=32.19 //y=4.25 //x2=32.305 //y2=4.25
r410 (  1 2 ) resistor r=5.07156 //w=0.131 //l=5.315 //layer=m1 \
 //thickness=0.36 //x=32.19 //y=4.25 //x2=26.875 //y2=4.25
ends PM_TMRDFFSNQX1\%noxref_10

subckt PM_TMRDFFSNQX1\%noxref_11 ( 1 2 13 14 25 27 28 32 34 41 42 43 44 45 46 \
 47 48 49 51 57 58 59 60 72 74 75 )
c155 ( 75 0 ) capacitor c=0.0220291f //x=43.155 //y=5.2
c156 ( 74 0 ) capacitor c=0.0217503f //x=42.275 //y=5.2
c157 ( 72 0 ) capacitor c=0.0084702f //x=43.15 //y=1.085
c158 ( 60 0 ) capacitor c=0.0556143f //x=45.905 //y=4.97
c159 ( 59 0 ) capacitor c=0.0293157f //x=46.195 //y=4.97
c160 ( 58 0 ) capacitor c=0.0347816f //x=45.86 //y=1.4
c161 ( 57 0 ) capacitor c=0.0187487f //x=45.86 //y=1.055
c162 ( 51 0 ) capacitor c=0.0137055f //x=45.705 //y=1.555
c163 ( 49 0 ) capacitor c=0.0149861f //x=45.705 //y=0.9
c164 ( 48 0 ) capacitor c=0.096037f //x=45.33 //y=2.095
c165 ( 47 0 ) capacitor c=0.0228993f //x=45.33 //y=1.71
c166 ( 46 0 ) capacitor c=0.0234352f //x=45.33 //y=1.4
c167 ( 45 0 ) capacitor c=0.0198724f //x=45.33 //y=1.055
c168 ( 44 0 ) capacitor c=0.110114f //x=46.27 //y=6.2
c169 ( 43 0 ) capacitor c=0.158956f //x=45.83 //y=6.2
c170 ( 41 0 ) capacitor c=0.00211606f //x=43.3 //y=5.38
c171 ( 34 0 ) capacitor c=0.0944841f //x=45.63 //y=2.26
c172 ( 32 0 ) capacitor c=0.10219f //x=43.78 //y=2.77
c173 ( 28 0 ) capacitor c=0.00404073f //x=43.425 //y=1.835
c174 ( 27 0 ) capacitor c=0.0122201f //x=43.695 //y=1.835
c175 ( 25 0 ) capacitor c=0.0137995f //x=43.695 //y=5.38
c176 ( 14 0 ) capacitor c=0.00251459f //x=42.505 //y=5.38
c177 ( 13 0 ) capacitor c=0.0143649f //x=43.215 //y=5.38
c178 ( 2 0 ) capacitor c=0.0115544f //x=43.895 //y=2.77
c179 ( 1 0 ) capacitor c=0.0317176f //x=45.515 //y=2.77
r180 (  59 61 ) resistor r=26.9307 //w=0.15 //l=0.106066 //layer=ply \
 //thickness=0.18 //x=46.195 //y=4.97 //x2=46.27 //y2=5.045
r181 (  59 60 ) resistor r=148.702 //w=0.094 //l=0.29 //layer=ply \
 //thickness=0.18 //x=46.195 //y=4.97 //x2=45.905 //y2=4.97
r182 (  58 71 ) resistor r=45.1352 //w=0.168 //l=0.173853 //layer=ply \
 //thickness=0.18 //x=45.86 //y=1.4 //x2=45.82 //y2=1.555
r183 (  57 70 ) resistor r=45.1352 //w=0.168 //l=0.173853 //layer=ply \
 //thickness=0.18 //x=45.86 //y=1.055 //x2=45.82 //y2=0.9
r184 (  57 58 ) resistor r=176.904 //w=0.094 //l=0.345 //layer=ply \
 //thickness=0.18 //x=45.86 //y=1.055 //x2=45.86 //y2=1.4
r185 (  54 60 ) resistor r=22.7971 //w=0.269 //l=0.106066 //layer=ply \
 //thickness=0.18 //x=45.83 //y=5.045 //x2=45.905 //y2=4.97
r186 (  54 69 ) resistor r=35.8364 //w=0.269 //l=0.270185 //layer=ply \
 //thickness=0.18 //x=45.83 //y=5.045 //x2=45.63 //y2=4.88
r187 (  52 65 ) resistor r=10.701 //w=0.21 //l=0.115 //layer=ply \
 //thickness=0.18 //x=45.485 //y=1.555 //x2=45.37 //y2=1.555
r188 (  51 71 ) resistor r=5.52526 //w=0.168 //l=0.115 //layer=ply \
 //thickness=0.18 //x=45.705 //y=1.555 //x2=45.82 //y2=1.555
r189 (  50 64 ) resistor r=5.52526 //w=0.168 //l=0.115 //layer=ply \
 //thickness=0.18 //x=45.485 //y=0.9 //x2=45.37 //y2=0.9
r190 (  49 70 ) resistor r=5.52526 //w=0.168 //l=0.115 //layer=ply \
 //thickness=0.18 //x=45.705 //y=0.9 //x2=45.82 //y2=0.9
r191 (  49 50 ) resistor r=112.809 //w=0.094 //l=0.22 //layer=ply \
 //thickness=0.18 //x=45.705 //y=0.9 //x2=45.485 //y2=0.9
r192 (  48 67 ) resistor r=58.7805 //w=0.246 //l=0.373497 //layer=ply \
 //thickness=0.18 //x=45.33 //y=2.095 //x2=45.63 //y2=2.26
r193 (  47 65 ) resistor r=39.5823 //w=0.21 //l=0.173853 //layer=ply \
 //thickness=0.18 //x=45.33 //y=1.71 //x2=45.37 //y2=1.555
r194 (  47 48 ) resistor r=197.415 //w=0.094 //l=0.385 //layer=ply \
 //thickness=0.18 //x=45.33 //y=1.71 //x2=45.33 //y2=2.095
r195 (  46 65 ) resistor r=39.5823 //w=0.21 //l=0.173853 //layer=ply \
 //thickness=0.18 //x=45.33 //y=1.4 //x2=45.37 //y2=1.555
r196 (  45 64 ) resistor r=45.1352 //w=0.168 //l=0.173853 //layer=ply \
 //thickness=0.18 //x=45.33 //y=1.055 //x2=45.37 //y2=0.9
r197 (  45 46 ) resistor r=176.904 //w=0.094 //l=0.345 //layer=ply \
 //thickness=0.18 //x=45.33 //y=1.055 //x2=45.33 //y2=1.4
r198 (  44 61 ) resistor r=592.245 //w=0.094 //l=1.155 //layer=ply \
 //thickness=0.18 //x=46.27 //y=6.2 //x2=46.27 //y2=5.045
r199 (  43 54 ) resistor r=592.245 //w=0.094 //l=1.155 //layer=ply \
 //thickness=0.18 //x=45.83 //y=6.2 //x2=45.83 //y2=5.045
r200 (  42 51 ) resistor r=56.4043 //w=0.094 //l=0.11 //layer=ply \
 //thickness=0.18 //x=45.595 //y=1.555 //x2=45.705 //y2=1.555
r201 (  42 52 ) resistor r=56.4043 //w=0.094 //l=0.11 //layer=ply \
 //thickness=0.18 //x=45.595 //y=1.555 //x2=45.485 //y2=1.555
r202 (  39 69 ) resistor r=152 //w=0.17 //l=0.17 //layer=licon //count=1 \
 //x=45.63 //y=4.88 //x2=45.63 //y2=4.88
r203 (  37 39 ) resistor r=144.428 //w=0.187 //l=2.11 //layer=li \
 //thickness=0.1 //x=45.63 //y=2.77 //x2=45.63 //y2=4.88
r204 (  34 67 ) resistor r=152 //w=0.17 //l=0.17 //layer=licon //count=1 \
 //x=45.63 //y=2.26 //x2=45.63 //y2=2.26
r205 (  34 37 ) resistor r=34.9091 //w=0.187 //l=0.51 //layer=li \
 //thickness=0.1 //x=45.63 //y=2.26 //x2=45.63 //y2=2.77
r206 (  30 32 ) resistor r=172.834 //w=0.187 //l=2.525 //layer=li \
 //thickness=0.1 //x=43.78 //y=5.295 //x2=43.78 //y2=2.77
r207 (  29 32 ) resistor r=58.1818 //w=0.187 //l=0.85 //layer=li \
 //thickness=0.1 //x=43.78 //y=1.92 //x2=43.78 //y2=2.77
r208 (  27 29 ) resistor r=7.15173 //w=0.17 //l=0.120208 //layer=li \
 //thickness=0.1 //x=43.695 //y=1.835 //x2=43.78 //y2=1.92
r209 (  27 28 ) resistor r=18.4813 //w=0.187 //l=0.27 //layer=li \
 //thickness=0.1 //x=43.695 //y=1.835 //x2=43.425 //y2=1.835
r210 (  26 41 ) resistor r=5.4201 //w=0.17 //l=0.085 //layer=li \
 //thickness=0.1 //x=43.385 //y=5.38 //x2=43.3 //y2=5.38
r211 (  25 30 ) resistor r=7.15173 //w=0.17 //l=0.120208 //layer=li \
 //thickness=0.1 //x=43.695 //y=5.38 //x2=43.78 //y2=5.295
r212 (  25 26 ) resistor r=21.2193 //w=0.187 //l=0.31 //layer=li \
 //thickness=0.1 //x=43.695 //y=5.38 //x2=43.385 //y2=5.38
r213 (  21 28 ) resistor r=7.15173 //w=0.17 //l=0.120208 //layer=li \
 //thickness=0.1 //x=43.34 //y=1.75 //x2=43.425 //y2=1.835
r214 (  21 72 ) resistor r=39.016 //w=0.187 //l=0.57 //layer=li \
 //thickness=0.1 //x=43.34 //y=1.75 //x2=43.34 //y2=1.18
r215 (  15 41 ) resistor r=1.40859 //w=0.34 //l=0.085 //layer=li \
 //thickness=0.1 //x=43.3 //y=5.465 //x2=43.3 //y2=5.38
r216 (  15 75 ) resistor r=30.1176 //w=0.187 //l=0.44 //layer=li \
 //thickness=0.1 //x=43.3 //y=5.465 //x2=43.3 //y2=5.905
r217 (  13 41 ) resistor r=5.4201 //w=0.17 //l=0.085 //layer=li \
 //thickness=0.1 //x=43.215 //y=5.38 //x2=43.3 //y2=5.38
r218 (  13 14 ) resistor r=48.5989 //w=0.187 //l=0.71 //layer=li \
 //thickness=0.1 //x=43.215 //y=5.38 //x2=42.505 //y2=5.38
r219 (  7 14 ) resistor r=7.15173 //w=0.17 //l=0.120208 //layer=li \
 //thickness=0.1 //x=42.42 //y=5.465 //x2=42.505 //y2=5.38
r220 (  7 74 ) resistor r=30.1176 //w=0.187 //l=0.44 //layer=li \
 //thickness=0.1 //x=42.42 //y=5.465 //x2=42.42 //y2=5.905
r221 (  6 37 ) resistor r=9.3 //w=0.17 //l=0.17 //layer=mcon //count=1 \
 //x=45.63 //y=2.77 //x2=45.63 //y2=2.77
r222 (  4 32 ) resistor r=9.3 //w=0.17 //l=0.17 //layer=mcon //count=1 \
 //x=43.78 //y=2.77 //x2=43.78 //y2=2.77
r223 (  2 4 ) resistor r=0.0717383 //w=0.224 //l=0.115 //layer=m1 \
 //thickness=0.36 //x=43.895 //y=2.77 //x2=43.78 //y2=2.77
r224 (  1 6 ) resistor r=0.0717383 //w=0.224 //l=0.115 //layer=m1 \
 //thickness=0.36 //x=45.515 //y=2.77 //x2=45.63 //y2=2.77
r225 (  1 2 ) resistor r=1.5458 //w=0.131 //l=1.62 //layer=m1 //thickness=0.36 \
 //x=45.515 //y=2.77 //x2=43.895 //y2=2.77
ends PM_TMRDFFSNQX1\%noxref_11

subckt PM_TMRDFFSNQX1\%noxref_12 ( 1 2 3 4 5 6 16 24 37 38 49 51 52 56 58 65 \
 66 67 68 69 70 71 72 73 74 78 79 80 85 87 90 91 95 96 97 102 104 107 108 112 \
 113 114 119 121 124 125 127 128 133 137 138 143 147 148 153 156 158 159 )
c322 ( 159 0 ) capacitor c=0.0220291f //x=39.825 //y=5.2
c323 ( 158 0 ) capacitor c=0.0217503f //x=38.945 //y=5.2
c324 ( 156 0 ) capacitor c=0.00866655f //x=39.82 //y=1.085
c325 ( 153 0 ) capacitor c=0.0587755f //x=47.85 //y=4.88
c326 ( 148 0 ) capacitor c=0.0273931f //x=47.85 //y=2.095
c327 ( 147 0 ) capacitor c=0.0456313f //x=47.85 //y=2.26
c328 ( 143 0 ) capacitor c=0.0587755f //x=36.38 //y=4.88
c329 ( 138 0 ) capacitor c=0.0273931f //x=36.38 //y=2.095
c330 ( 137 0 ) capacitor c=0.0456313f //x=36.38 //y=2.26
c331 ( 133 0 ) capacitor c=0.058931f //x=31.57 //y=4.88
c332 ( 128 0 ) capacitor c=0.0267105f //x=31.57 //y=2.095
c333 ( 127 0 ) capacitor c=0.0456313f //x=31.57 //y=2.26
c334 ( 125 0 ) capacitor c=0.0432517f //x=48.37 //y=1.44
c335 ( 124 0 ) capacitor c=0.0200379f //x=48.37 //y=1.095
c336 ( 121 0 ) capacitor c=0.0148873f //x=48.215 //y=1.595
c337 ( 119 0 ) capacitor c=0.0157803f //x=48.215 //y=0.94
c338 ( 114 0 ) capacitor c=0.0218028f //x=47.84 //y=1.75
c339 ( 113 0 ) capacitor c=0.0207459f //x=47.84 //y=1.44
c340 ( 112 0 ) capacitor c=0.0194308f //x=47.84 //y=1.095
c341 ( 108 0 ) capacitor c=0.0432517f //x=36.9 //y=1.44
c342 ( 107 0 ) capacitor c=0.0200379f //x=36.9 //y=1.095
c343 ( 104 0 ) capacitor c=0.0148873f //x=36.745 //y=1.595
c344 ( 102 0 ) capacitor c=0.0157803f //x=36.745 //y=0.94
c345 ( 97 0 ) capacitor c=0.0218028f //x=36.37 //y=1.75
c346 ( 96 0 ) capacitor c=0.0207459f //x=36.37 //y=1.44
c347 ( 95 0 ) capacitor c=0.0194308f //x=36.37 //y=1.095
c348 ( 91 0 ) capacitor c=0.0432517f //x=32.09 //y=1.44
c349 ( 90 0 ) capacitor c=0.0200379f //x=32.09 //y=1.095
c350 ( 87 0 ) capacitor c=0.0148873f //x=31.935 //y=1.595
c351 ( 85 0 ) capacitor c=0.0157803f //x=31.935 //y=0.94
c352 ( 80 0 ) capacitor c=0.0218028f //x=31.56 //y=1.75
c353 ( 79 0 ) capacitor c=0.0207459f //x=31.56 //y=1.44
c354 ( 78 0 ) capacitor c=0.0194308f //x=31.56 //y=1.095
c355 ( 74 0 ) capacitor c=0.158794f //x=48.03 //y=6.2
c356 ( 73 0 ) capacitor c=0.110114f //x=47.59 //y=6.2
c357 ( 72 0 ) capacitor c=0.158794f //x=36.56 //y=6.2
c358 ( 71 0 ) capacitor c=0.110114f //x=36.12 //y=6.2
c359 ( 70 0 ) capacitor c=0.158048f //x=31.75 //y=6.2
c360 ( 69 0 ) capacitor c=0.110114f //x=31.31 //y=6.2
c361 ( 65 0 ) capacitor c=0.00211606f //x=39.97 //y=5.38
c362 ( 58 0 ) capacitor c=0.0808586f //x=47.85 //y=2.26
c363 ( 56 0 ) capacitor c=0.103614f //x=40.45 //y=3.88
c364 ( 52 0 ) capacitor c=0.00404073f //x=40.095 //y=1.835
c365 ( 51 0 ) capacitor c=0.0122201f //x=40.365 //y=1.835
c366 ( 49 0 ) capacitor c=0.0137522f //x=40.365 //y=5.38
c367 ( 38 0 ) capacitor c=0.00251635f //x=39.175 //y=5.38
c368 ( 37 0 ) capacitor c=0.0142529f //x=39.885 //y=5.38
c369 ( 24 0 ) capacitor c=0.0811636f //x=36.38 //y=2.26
c370 ( 16 0 ) capacitor c=0.0796434f //x=31.57 //y=2.26
c371 ( 6 0 ) capacitor c=0.00405261f //x=40.565 //y=3.88
c372 ( 5 0 ) capacitor c=0.120326f //x=47.735 //y=3.88
c373 ( 4 0 ) capacitor c=0.00412452f //x=36.495 //y=3.88
c374 ( 3 0 ) capacitor c=0.0546427f //x=40.335 //y=3.88
c375 ( 2 0 ) capacitor c=0.0138772f //x=31.685 //y=3.88
c376 ( 1 0 ) capacitor c=0.0670382f //x=36.265 //y=3.88
r377 (  147 148 ) resistor r=52.7279 //w=0.214 //l=0.165 //layer=ply \
 //thickness=0.18 //x=47.85 //y=2.26 //x2=47.85 //y2=2.095
r378 (  137 138 ) resistor r=52.7279 //w=0.214 //l=0.165 //layer=ply \
 //thickness=0.18 //x=36.38 //y=2.26 //x2=36.38 //y2=2.095
r379 (  127 128 ) resistor r=52.7279 //w=0.214 //l=0.165 //layer=ply \
 //thickness=0.18 //x=31.57 //y=2.26 //x2=31.57 //y2=2.095
r380 (  125 155 ) resistor r=45.1352 //w=0.168 //l=0.173853 //layer=ply \
 //thickness=0.18 //x=48.37 //y=1.44 //x2=48.33 //y2=1.595
r381 (  124 154 ) resistor r=45.1352 //w=0.168 //l=0.173853 //layer=ply \
 //thickness=0.18 //x=48.37 //y=1.095 //x2=48.33 //y2=0.94
r382 (  124 125 ) resistor r=176.904 //w=0.094 //l=0.345 //layer=ply \
 //thickness=0.18 //x=48.37 //y=1.095 //x2=48.37 //y2=1.44
r383 (  122 151 ) resistor r=10.701 //w=0.21 //l=0.115 //layer=ply \
 //thickness=0.18 //x=47.995 //y=1.595 //x2=47.88 //y2=1.595
r384 (  121 155 ) resistor r=5.52526 //w=0.168 //l=0.115 //layer=ply \
 //thickness=0.18 //x=48.215 //y=1.595 //x2=48.33 //y2=1.595
r385 (  120 150 ) resistor r=5.52526 //w=0.168 //l=0.115 //layer=ply \
 //thickness=0.18 //x=47.995 //y=0.94 //x2=47.88 //y2=0.94
r386 (  119 154 ) resistor r=5.52526 //w=0.168 //l=0.115 //layer=ply \
 //thickness=0.18 //x=48.215 //y=0.94 //x2=48.33 //y2=0.94
r387 (  119 120 ) resistor r=112.809 //w=0.094 //l=0.22 //layer=ply \
 //thickness=0.18 //x=48.215 //y=0.94 //x2=47.995 //y2=0.94
r388 (  116 153 ) resistor r=37.236 //w=0.233 //l=0.249199 //layer=ply \
 //thickness=0.18 //x=48.03 //y=5.045 //x2=47.85 //y2=4.88
r389 (  114 151 ) resistor r=39.5823 //w=0.21 //l=0.173853 //layer=ply \
 //thickness=0.18 //x=47.84 //y=1.75 //x2=47.88 //y2=1.595
r390 (  114 148 ) resistor r=176.904 //w=0.094 //l=0.345 //layer=ply \
 //thickness=0.18 //x=47.84 //y=1.75 //x2=47.84 //y2=2.095
r391 (  113 151 ) resistor r=39.5823 //w=0.21 //l=0.173853 //layer=ply \
 //thickness=0.18 //x=47.84 //y=1.44 //x2=47.88 //y2=1.595
r392 (  112 150 ) resistor r=45.1352 //w=0.168 //l=0.173853 //layer=ply \
 //thickness=0.18 //x=47.84 //y=1.095 //x2=47.88 //y2=0.94
r393 (  112 113 ) resistor r=176.904 //w=0.094 //l=0.345 //layer=ply \
 //thickness=0.18 //x=47.84 //y=1.095 //x2=47.84 //y2=1.44
r394 (  109 153 ) resistor r=53.7854 //w=0.233 //l=0.332415 //layer=ply \
 //thickness=0.18 //x=47.59 //y=5.045 //x2=47.85 //y2=4.88
r395 (  108 145 ) resistor r=45.1352 //w=0.168 //l=0.173853 //layer=ply \
 //thickness=0.18 //x=36.9 //y=1.44 //x2=36.86 //y2=1.595
r396 (  107 144 ) resistor r=45.1352 //w=0.168 //l=0.173853 //layer=ply \
 //thickness=0.18 //x=36.9 //y=1.095 //x2=36.86 //y2=0.94
r397 (  107 108 ) resistor r=176.904 //w=0.094 //l=0.345 //layer=ply \
 //thickness=0.18 //x=36.9 //y=1.095 //x2=36.9 //y2=1.44
r398 (  105 141 ) resistor r=10.701 //w=0.21 //l=0.115 //layer=ply \
 //thickness=0.18 //x=36.525 //y=1.595 //x2=36.41 //y2=1.595
r399 (  104 145 ) resistor r=5.52526 //w=0.168 //l=0.115 //layer=ply \
 //thickness=0.18 //x=36.745 //y=1.595 //x2=36.86 //y2=1.595
r400 (  103 140 ) resistor r=5.52526 //w=0.168 //l=0.115 //layer=ply \
 //thickness=0.18 //x=36.525 //y=0.94 //x2=36.41 //y2=0.94
r401 (  102 144 ) resistor r=5.52526 //w=0.168 //l=0.115 //layer=ply \
 //thickness=0.18 //x=36.745 //y=0.94 //x2=36.86 //y2=0.94
r402 (  102 103 ) resistor r=112.809 //w=0.094 //l=0.22 //layer=ply \
 //thickness=0.18 //x=36.745 //y=0.94 //x2=36.525 //y2=0.94
r403 (  99 143 ) resistor r=37.236 //w=0.233 //l=0.249199 //layer=ply \
 //thickness=0.18 //x=36.56 //y=5.045 //x2=36.38 //y2=4.88
r404 (  97 141 ) resistor r=39.5823 //w=0.21 //l=0.173853 //layer=ply \
 //thickness=0.18 //x=36.37 //y=1.75 //x2=36.41 //y2=1.595
r405 (  97 138 ) resistor r=176.904 //w=0.094 //l=0.345 //layer=ply \
 //thickness=0.18 //x=36.37 //y=1.75 //x2=36.37 //y2=2.095
r406 (  96 141 ) resistor r=39.5823 //w=0.21 //l=0.173853 //layer=ply \
 //thickness=0.18 //x=36.37 //y=1.44 //x2=36.41 //y2=1.595
r407 (  95 140 ) resistor r=45.1352 //w=0.168 //l=0.173853 //layer=ply \
 //thickness=0.18 //x=36.37 //y=1.095 //x2=36.41 //y2=0.94
r408 (  95 96 ) resistor r=176.904 //w=0.094 //l=0.345 //layer=ply \
 //thickness=0.18 //x=36.37 //y=1.095 //x2=36.37 //y2=1.44
r409 (  92 143 ) resistor r=53.7854 //w=0.233 //l=0.332415 //layer=ply \
 //thickness=0.18 //x=36.12 //y=5.045 //x2=36.38 //y2=4.88
r410 (  91 135 ) resistor r=45.1352 //w=0.168 //l=0.173853 //layer=ply \
 //thickness=0.18 //x=32.09 //y=1.44 //x2=32.05 //y2=1.595
r411 (  90 134 ) resistor r=45.1352 //w=0.168 //l=0.173853 //layer=ply \
 //thickness=0.18 //x=32.09 //y=1.095 //x2=32.05 //y2=0.94
r412 (  90 91 ) resistor r=176.904 //w=0.094 //l=0.345 //layer=ply \
 //thickness=0.18 //x=32.09 //y=1.095 //x2=32.09 //y2=1.44
r413 (  88 131 ) resistor r=10.701 //w=0.21 //l=0.115 //layer=ply \
 //thickness=0.18 //x=31.715 //y=1.595 //x2=31.6 //y2=1.595
r414 (  87 135 ) resistor r=5.52526 //w=0.168 //l=0.115 //layer=ply \
 //thickness=0.18 //x=31.935 //y=1.595 //x2=32.05 //y2=1.595
r415 (  86 130 ) resistor r=5.52526 //w=0.168 //l=0.115 //layer=ply \
 //thickness=0.18 //x=31.715 //y=0.94 //x2=31.6 //y2=0.94
r416 (  85 134 ) resistor r=5.52526 //w=0.168 //l=0.115 //layer=ply \
 //thickness=0.18 //x=31.935 //y=0.94 //x2=32.05 //y2=0.94
r417 (  85 86 ) resistor r=112.809 //w=0.094 //l=0.22 //layer=ply \
 //thickness=0.18 //x=31.935 //y=0.94 //x2=31.715 //y2=0.94
r418 (  82 133 ) resistor r=37.236 //w=0.233 //l=0.249199 //layer=ply \
 //thickness=0.18 //x=31.75 //y=5.045 //x2=31.57 //y2=4.88
r419 (  80 131 ) resistor r=39.5823 //w=0.21 //l=0.173853 //layer=ply \
 //thickness=0.18 //x=31.56 //y=1.75 //x2=31.6 //y2=1.595
r420 (  80 128 ) resistor r=176.904 //w=0.094 //l=0.345 //layer=ply \
 //thickness=0.18 //x=31.56 //y=1.75 //x2=31.56 //y2=2.095
r421 (  79 131 ) resistor r=39.5823 //w=0.21 //l=0.173853 //layer=ply \
 //thickness=0.18 //x=31.56 //y=1.44 //x2=31.6 //y2=1.595
r422 (  78 130 ) resistor r=45.1352 //w=0.168 //l=0.173853 //layer=ply \
 //thickness=0.18 //x=31.56 //y=1.095 //x2=31.6 //y2=0.94
r423 (  78 79 ) resistor r=176.904 //w=0.094 //l=0.345 //layer=ply \
 //thickness=0.18 //x=31.56 //y=1.095 //x2=31.56 //y2=1.44
r424 (  75 133 ) resistor r=53.7854 //w=0.233 //l=0.332415 //layer=ply \
 //thickness=0.18 //x=31.31 //y=5.045 //x2=31.57 //y2=4.88
r425 (  74 116 ) resistor r=592.245 //w=0.094 //l=1.155 //layer=ply \
 //thickness=0.18 //x=48.03 //y=6.2 //x2=48.03 //y2=5.045
r426 (  73 109 ) resistor r=592.245 //w=0.094 //l=1.155 //layer=ply \
 //thickness=0.18 //x=47.59 //y=6.2 //x2=47.59 //y2=5.045
r427 (  72 99 ) resistor r=592.245 //w=0.094 //l=1.155 //layer=ply \
 //thickness=0.18 //x=36.56 //y=6.2 //x2=36.56 //y2=5.045
r428 (  71 92 ) resistor r=592.245 //w=0.094 //l=1.155 //layer=ply \
 //thickness=0.18 //x=36.12 //y=6.2 //x2=36.12 //y2=5.045
r429 (  70 82 ) resistor r=592.245 //w=0.094 //l=1.155 //layer=ply \
 //thickness=0.18 //x=31.75 //y=6.2 //x2=31.75 //y2=5.045
r430 (  69 75 ) resistor r=592.245 //w=0.094 //l=1.155 //layer=ply \
 //thickness=0.18 //x=31.31 //y=6.2 //x2=31.31 //y2=5.045
r431 (  68 121 ) resistor r=56.4043 //w=0.094 //l=0.11 //layer=ply \
 //thickness=0.18 //x=48.105 //y=1.595 //x2=48.215 //y2=1.595
r432 (  68 122 ) resistor r=56.4043 //w=0.094 //l=0.11 //layer=ply \
 //thickness=0.18 //x=48.105 //y=1.595 //x2=47.995 //y2=1.595
r433 (  67 104 ) resistor r=56.4043 //w=0.094 //l=0.11 //layer=ply \
 //thickness=0.18 //x=36.635 //y=1.595 //x2=36.745 //y2=1.595
r434 (  67 105 ) resistor r=56.4043 //w=0.094 //l=0.11 //layer=ply \
 //thickness=0.18 //x=36.635 //y=1.595 //x2=36.525 //y2=1.595
r435 (  66 87 ) resistor r=56.4043 //w=0.094 //l=0.11 //layer=ply \
 //thickness=0.18 //x=31.825 //y=1.595 //x2=31.935 //y2=1.595
r436 (  66 88 ) resistor r=56.4043 //w=0.094 //l=0.11 //layer=ply \
 //thickness=0.18 //x=31.825 //y=1.595 //x2=31.715 //y2=1.595
r437 (  63 153 ) resistor r=152 //w=0.17 //l=0.17 //layer=licon //count=1 \
 //x=47.85 //y=4.88 //x2=47.85 //y2=4.88
r438 (  61 63 ) resistor r=68.4492 //w=0.187 //l=1 //layer=li //thickness=0.1 \
 //x=47.85 //y=3.88 //x2=47.85 //y2=4.88
r439 (  58 147 ) resistor r=152 //w=0.17 //l=0.17 //layer=licon //count=1 \
 //x=47.85 //y=2.26 //x2=47.85 //y2=2.26
r440 (  58 61 ) resistor r=110.888 //w=0.187 //l=1.62 //layer=li \
 //thickness=0.1 //x=47.85 //y=2.26 //x2=47.85 //y2=3.88
r441 (  54 56 ) resistor r=96.8556 //w=0.187 //l=1.415 //layer=li \
 //thickness=0.1 //x=40.45 //y=5.295 //x2=40.45 //y2=3.88
r442 (  53 56 ) resistor r=134.16 //w=0.187 //l=1.96 //layer=li \
 //thickness=0.1 //x=40.45 //y=1.92 //x2=40.45 //y2=3.88
r443 (  51 53 ) resistor r=7.15173 //w=0.17 //l=0.120208 //layer=li \
 //thickness=0.1 //x=40.365 //y=1.835 //x2=40.45 //y2=1.92
r444 (  51 52 ) resistor r=18.4813 //w=0.187 //l=0.27 //layer=li \
 //thickness=0.1 //x=40.365 //y=1.835 //x2=40.095 //y2=1.835
r445 (  50 65 ) resistor r=5.4201 //w=0.17 //l=0.085 //layer=li \
 //thickness=0.1 //x=40.055 //y=5.38 //x2=39.97 //y2=5.38
r446 (  49 54 ) resistor r=7.15173 //w=0.17 //l=0.120208 //layer=li \
 //thickness=0.1 //x=40.365 //y=5.38 //x2=40.45 //y2=5.295
r447 (  49 50 ) resistor r=21.2193 //w=0.187 //l=0.31 //layer=li \
 //thickness=0.1 //x=40.365 //y=5.38 //x2=40.055 //y2=5.38
r448 (  45 52 ) resistor r=7.15173 //w=0.17 //l=0.120208 //layer=li \
 //thickness=0.1 //x=40.01 //y=1.75 //x2=40.095 //y2=1.835
r449 (  45 156 ) resistor r=39.016 //w=0.187 //l=0.57 //layer=li \
 //thickness=0.1 //x=40.01 //y=1.75 //x2=40.01 //y2=1.18
r450 (  39 65 ) resistor r=1.40859 //w=0.34 //l=0.085 //layer=li \
 //thickness=0.1 //x=39.97 //y=5.465 //x2=39.97 //y2=5.38
r451 (  39 159 ) resistor r=30.1176 //w=0.187 //l=0.44 //layer=li \
 //thickness=0.1 //x=39.97 //y=5.465 //x2=39.97 //y2=5.905
r452 (  37 65 ) resistor r=5.4201 //w=0.17 //l=0.085 //layer=li \
 //thickness=0.1 //x=39.885 //y=5.38 //x2=39.97 //y2=5.38
r453 (  37 38 ) resistor r=48.5989 //w=0.187 //l=0.71 //layer=li \
 //thickness=0.1 //x=39.885 //y=5.38 //x2=39.175 //y2=5.38
r454 (  31 38 ) resistor r=7.15173 //w=0.17 //l=0.120208 //layer=li \
 //thickness=0.1 //x=39.09 //y=5.465 //x2=39.175 //y2=5.38
r455 (  31 158 ) resistor r=30.1176 //w=0.187 //l=0.44 //layer=li \
 //thickness=0.1 //x=39.09 //y=5.465 //x2=39.09 //y2=5.905
r456 (  29 143 ) resistor r=152 //w=0.17 //l=0.17 //layer=licon //count=1 \
 //x=36.38 //y=4.88 //x2=36.38 //y2=4.88
r457 (  27 29 ) resistor r=68.4492 //w=0.187 //l=1 //layer=li //thickness=0.1 \
 //x=36.38 //y=3.88 //x2=36.38 //y2=4.88
r458 (  24 137 ) resistor r=152 //w=0.17 //l=0.17 //layer=licon //count=1 \
 //x=36.38 //y=2.26 //x2=36.38 //y2=2.26
r459 (  24 27 ) resistor r=110.888 //w=0.187 //l=1.62 //layer=li \
 //thickness=0.1 //x=36.38 //y=2.26 //x2=36.38 //y2=3.88
r460 (  21 133 ) resistor r=152 //w=0.17 //l=0.17 //layer=licon //count=1 \
 //x=31.57 //y=4.88 //x2=31.57 //y2=4.88
r461 (  19 21 ) resistor r=68.4492 //w=0.187 //l=1 //layer=li //thickness=0.1 \
 //x=31.57 //y=3.88 //x2=31.57 //y2=4.88
r462 (  16 127 ) resistor r=152 //w=0.17 //l=0.17 //layer=licon //count=1 \
 //x=31.57 //y=2.26 //x2=31.57 //y2=2.26
r463 (  16 19 ) resistor r=110.888 //w=0.187 //l=1.62 //layer=li \
 //thickness=0.1 //x=31.57 //y=2.26 //x2=31.57 //y2=3.88
r464 (  14 61 ) resistor r=9.3 //w=0.17 //l=0.17 //layer=mcon //count=1 \
 //x=47.85 //y=3.88 //x2=47.85 //y2=3.88
r465 (  12 56 ) resistor r=9.3 //w=0.17 //l=0.17 //layer=mcon //count=1 \
 //x=40.45 //y=3.88 //x2=40.45 //y2=3.88
r466 (  10 27 ) resistor r=9.3 //w=0.17 //l=0.17 //layer=mcon //count=1 \
 //x=36.38 //y=3.88 //x2=36.38 //y2=3.88
r467 (  8 19 ) resistor r=9.3 //w=0.17 //l=0.17 //layer=mcon //count=1 \
 //x=31.57 //y=3.88 //x2=31.57 //y2=3.88
r468 (  6 12 ) resistor r=0.0880901 //w=0.191 //l=0.115 //layer=m1 \
 //thickness=0.36 //x=40.565 //y=3.88 //x2=40.45 //y2=3.88
r469 (  5 14 ) resistor r=0.0717383 //w=0.224 //l=0.115 //layer=m1 \
 //thickness=0.36 //x=47.735 //y=3.88 //x2=47.85 //y2=3.88
r470 (  5 6 ) resistor r=6.8416 //w=0.131 //l=7.17 //layer=m1 //thickness=0.36 \
 //x=47.735 //y=3.88 //x2=40.565 //y2=3.88
r471 (  4 10 ) resistor r=0.0880901 //w=0.191 //l=0.115 //layer=m1 \
 //thickness=0.36 //x=36.495 //y=3.88 //x2=36.38 //y2=3.88
r472 (  3 12 ) resistor r=0.0880901 //w=0.191 //l=0.115 //layer=m1 \
 //thickness=0.36 //x=40.335 //y=3.88 //x2=40.45 //y2=3.88
r473 (  3 4 ) resistor r=3.66412 //w=0.131 //l=3.84 //layer=m1 \
 //thickness=0.36 //x=40.335 //y=3.88 //x2=36.495 //y2=3.88
r474 (  2 8 ) resistor r=0.0717383 //w=0.224 //l=0.115 //layer=m1 \
 //thickness=0.36 //x=31.685 //y=3.88 //x2=31.57 //y2=3.88
r475 (  1 10 ) resistor r=0.0880901 //w=0.191 //l=0.115 //layer=m1 \
 //thickness=0.36 //x=36.265 //y=3.88 //x2=36.38 //y2=3.88
r476 (  1 2 ) resistor r=4.37023 //w=0.131 //l=4.58 //layer=m1 \
 //thickness=0.36 //x=36.265 //y=3.88 //x2=31.685 //y2=3.88
ends PM_TMRDFFSNQX1\%noxref_12

subckt PM_TMRDFFSNQX1\%noxref_13 ( 1 2 3 4 6 7 8 9 10 23 25 35 36 43 51 57 58 \
 62 65 67 75 81 82 86 89 90 91 92 93 94 95 96 97 98 99 100 105 107 109 115 116 \
 117 118 119 124 126 128 134 135 136 137 138 143 145 147 153 154 156 157 160 \
 169 170 173 181 182 185 193 195 196 197 )
c467 ( 197 0 ) capacitor c=0.023087f //x=47.665 //y=5.2
c468 ( 196 0 ) capacitor c=0.023519f //x=46.785 //y=5.2
c469 ( 195 0 ) capacitor c=0.0224735f //x=45.905 //y=5.2
c470 ( 193 0 ) capacitor c=0.00872971f //x=47.915 //y=1.095
c471 ( 185 0 ) capacitor c=0.0352016f //x=82.28 //y=4.885
c472 ( 182 0 ) capacitor c=0.0279733f //x=82.26 //y=2.095
c473 ( 181 0 ) capacitor c=0.0467621f //x=82.26 //y=2.26
c474 ( 173 0 ) capacitor c=0.03845f //x=75.64 //y=4.885
c475 ( 170 0 ) capacitor c=0.0300885f //x=75.6 //y=2.095
c476 ( 169 0 ) capacitor c=0.0520257f //x=75.6 //y=2.26
c477 ( 160 0 ) capacitor c=0.0331095f //x=43.07 //y=4.88
c478 ( 157 0 ) capacitor c=0.0279499f //x=43.04 //y=2.095
c479 ( 156 0 ) capacitor c=0.0421676f //x=43.04 //y=2.26
c480 ( 154 0 ) capacitor c=0.0237734f //x=82.825 //y=1.435
c481 ( 153 0 ) capacitor c=0.0191782f //x=82.825 //y=1.085
c482 ( 147 0 ) capacitor c=0.0351663f //x=82.67 //y=1.585
c483 ( 145 0 ) capacitor c=0.0157803f //x=82.67 //y=0.93
c484 ( 143 0 ) capacitor c=0.0374703f //x=82.665 //y=4.975
c485 ( 138 0 ) capacitor c=0.0200628f //x=82.295 //y=1.74
c486 ( 137 0 ) capacitor c=0.0168575f //x=82.295 //y=1.435
c487 ( 136 0 ) capacitor c=0.0174993f //x=82.295 //y=1.085
c488 ( 135 0 ) capacitor c=0.0447087f //x=76.165 //y=1.43
c489 ( 134 0 ) capacitor c=0.019286f //x=76.165 //y=1.085
c490 ( 128 0 ) capacitor c=0.0187932f //x=76.01 //y=1.585
c491 ( 126 0 ) capacitor c=0.0157795f //x=76.01 //y=0.93
c492 ( 124 0 ) capacitor c=0.029531f //x=76.005 //y=4.975
c493 ( 119 0 ) capacitor c=0.0206178f //x=75.635 //y=1.74
c494 ( 118 0 ) capacitor c=0.016848f //x=75.635 //y=1.43
c495 ( 117 0 ) capacitor c=0.0174777f //x=75.635 //y=1.085
c496 ( 116 0 ) capacitor c=0.0429696f //x=43.605 //y=1.43
c497 ( 115 0 ) capacitor c=0.0192208f //x=43.605 //y=1.085
c498 ( 109 0 ) capacitor c=0.0148884f //x=43.45 //y=1.585
c499 ( 107 0 ) capacitor c=0.0157803f //x=43.45 //y=0.93
c500 ( 105 0 ) capacitor c=0.0295235f //x=43.445 //y=4.97
c501 ( 100 0 ) capacitor c=0.0205163f //x=43.075 //y=1.74
c502 ( 99 0 ) capacitor c=0.0168481f //x=43.075 //y=1.43
c503 ( 98 0 ) capacitor c=0.0174783f //x=43.075 //y=1.085
c504 ( 97 0 ) capacitor c=0.15325f //x=82.74 //y=6.205
c505 ( 96 0 ) capacitor c=0.110411f //x=82.3 //y=6.205
c506 ( 95 0 ) capacitor c=0.154236f //x=76.08 //y=6.205
c507 ( 94 0 ) capacitor c=0.110294f //x=75.64 //y=6.205
c508 ( 93 0 ) capacitor c=0.15358f //x=43.52 //y=6.2
c509 ( 92 0 ) capacitor c=0.110281f //x=43.08 //y=6.2
c510 ( 86 0 ) capacitor c=0.00501304f //x=82.28 //y=4.885
c511 ( 82 0 ) capacitor c=0.00106608f //x=47.81 //y=5.335
c512 ( 81 0 ) capacitor c=0.00207319f //x=46.93 //y=5.335
c513 ( 75 0 ) capacitor c=0.0901308f //x=82.26 //y=2.26
c514 ( 67 0 ) capacitor c=0.104623f //x=75.6 //y=2.26
c515 ( 65 0 ) capacitor c=0.00669947f //x=75.6 //y=4.72
c516 ( 62 0 ) capacitor c=0.106131f //x=48.59 //y=2.77
c517 ( 58 0 ) capacitor c=0.00398962f //x=48.19 //y=1.845
c518 ( 57 0 ) capacitor c=0.0137288f //x=48.505 //y=1.845
c519 ( 51 0 ) capacitor c=0.0284988f //x=48.505 //y=5.335
c520 ( 43 0 ) capacitor c=0.0176454f //x=47.725 //y=5.335
c521 ( 36 0 ) capacitor c=0.00332903f //x=46.135 //y=5.335
c522 ( 35 0 ) capacitor c=0.0148427f //x=46.845 //y=5.335
c523 ( 25 0 ) capacitor c=0.0689632f //x=43.04 //y=2.26
c524 ( 23 0 ) capacitor c=0.00453889f //x=43.04 //y=4.715
c525 ( 10 0 ) capacitor c=0.0144297f //x=75.715 //y=4.25
c526 ( 9 0 ) capacitor c=0.181505f //x=82.145 //y=4.25
c527 ( 8 0 ) capacitor c=1.21334e-19 //x=51.265 //y=3.14
c528 ( 7 0 ) capacitor c=0.431437f //x=75.485 //y=3.14
c529 ( 4 0 ) capacitor c=0.00871105f //x=48.705 //y=2.77
c530 ( 3 0 ) capacitor c=0.0344714f //x=51.095 //y=2.77
c531 ( 2 0 ) capacitor c=0.00621861f //x=43.155 //y=4.25
c532 ( 1 0 ) capacitor c=0.0841928f //x=48.475 //y=4.25
r533 (  187 188 ) resistor r=32.4568 //w=0.214 //l=0.075 //layer=ply \
 //thickness=0.18 //x=82.28 //y=4.975 //x2=82.28 //y2=5.05
r534 (  185 187 ) resistor r=20.271 //w=0.214 //l=0.09 //layer=ply \
 //thickness=0.18 //x=82.28 //y=4.885 //x2=82.28 //y2=4.975
r535 (  181 182 ) resistor r=52.7279 //w=0.214 //l=0.165 //layer=ply \
 //thickness=0.18 //x=82.26 //y=2.26 //x2=82.26 //y2=2.095
r536 (  173 175 ) resistor r=20.271 //w=0.214 //l=0.09 //layer=ply \
 //thickness=0.18 //x=75.64 //y=4.885 //x2=75.64 //y2=4.975
r537 (  169 170 ) resistor r=52.7279 //w=0.214 //l=0.165 //layer=ply \
 //thickness=0.18 //x=75.6 //y=2.26 //x2=75.6 //y2=2.095
r538 (  162 163 ) resistor r=32.4568 //w=0.214 //l=0.075 //layer=ply \
 //thickness=0.18 //x=43.07 //y=4.97 //x2=43.07 //y2=5.045
r539 (  160 162 ) resistor r=20.271 //w=0.214 //l=0.09 //layer=ply \
 //thickness=0.18 //x=43.07 //y=4.88 //x2=43.07 //y2=4.97
r540 (  156 157 ) resistor r=52.7279 //w=0.214 //l=0.165 //layer=ply \
 //thickness=0.18 //x=43.04 //y=2.26 //x2=43.04 //y2=2.095
r541 (  154 192 ) resistor r=4.95774 //w=0.164 //l=0.112 //layer=ply \
 //thickness=0.18 //x=82.825 //y=1.435 //x2=82.825 //y2=1.547
r542 (  153 191 ) resistor r=45.1352 //w=0.168 //l=0.173853 //layer=ply \
 //thickness=0.18 //x=82.825 //y=1.085 //x2=82.785 //y2=0.93
r543 (  153 154 ) resistor r=179.468 //w=0.094 //l=0.35 //layer=ply \
 //thickness=0.18 //x=82.825 //y=1.085 //x2=82.825 //y2=1.435
r544 (  148 190 ) resistor r=10.8103 //w=0.211 //l=0.115 //layer=ply \
 //thickness=0.18 //x=82.45 //y=1.585 //x2=82.335 //y2=1.585
r545 (  147 192 ) resistor r=45.9962 //w=0.164 //l=0.17296 //layer=ply \
 //thickness=0.18 //x=82.67 //y=1.585 //x2=82.825 //y2=1.547
r546 (  146 189 ) resistor r=5.52526 //w=0.168 //l=0.115 //layer=ply \
 //thickness=0.18 //x=82.45 //y=0.93 //x2=82.335 //y2=0.93
r547 (  145 191 ) resistor r=5.52526 //w=0.168 //l=0.115 //layer=ply \
 //thickness=0.18 //x=82.67 //y=0.93 //x2=82.785 //y2=0.93
r548 (  145 146 ) resistor r=112.809 //w=0.094 //l=0.22 //layer=ply \
 //thickness=0.18 //x=82.67 //y=0.93 //x2=82.45 //y2=0.93
r549 (  144 187 ) resistor r=16.5046 //w=0.27 //l=0.135 //layer=ply \
 //thickness=0.18 //x=82.415 //y=4.975 //x2=82.28 //y2=4.975
r550 (  143 150 ) resistor r=26.9307 //w=0.15 //l=0.106066 //layer=ply \
 //thickness=0.18 //x=82.665 //y=4.975 //x2=82.74 //y2=5.05
r551 (  143 144 ) resistor r=128.191 //w=0.094 //l=0.25 //layer=ply \
 //thickness=0.18 //x=82.665 //y=4.975 //x2=82.415 //y2=4.975
r552 (  138 190 ) resistor r=39.5036 //w=0.211 //l=0.173853 //layer=ply \
 //thickness=0.18 //x=82.295 //y=1.74 //x2=82.335 //y2=1.585
r553 (  138 182 ) resistor r=182.032 //w=0.094 //l=0.355 //layer=ply \
 //thickness=0.18 //x=82.295 //y=1.74 //x2=82.295 //y2=2.095
r554 (  137 190 ) resistor r=38.3614 //w=0.211 //l=0.168819 //layer=ply \
 //thickness=0.18 //x=82.295 //y=1.435 //x2=82.335 //y2=1.585
r555 (  136 189 ) resistor r=45.1352 //w=0.168 //l=0.173853 //layer=ply \
 //thickness=0.18 //x=82.295 //y=1.085 //x2=82.335 //y2=0.93
r556 (  136 137 ) resistor r=179.468 //w=0.094 //l=0.35 //layer=ply \
 //thickness=0.18 //x=82.295 //y=1.085 //x2=82.295 //y2=1.435
r557 (  135 179 ) resistor r=45.1352 //w=0.168 //l=0.173853 //layer=ply \
 //thickness=0.18 //x=76.165 //y=1.43 //x2=76.125 //y2=1.585
r558 (  134 178 ) resistor r=45.1352 //w=0.168 //l=0.173853 //layer=ply \
 //thickness=0.18 //x=76.165 //y=1.085 //x2=76.125 //y2=0.93
r559 (  134 135 ) resistor r=176.904 //w=0.094 //l=0.345 //layer=ply \
 //thickness=0.18 //x=76.165 //y=1.085 //x2=76.165 //y2=1.43
r560 (  129 177 ) resistor r=10.701 //w=0.21 //l=0.115 //layer=ply \
 //thickness=0.18 //x=75.79 //y=1.585 //x2=75.675 //y2=1.585
r561 (  128 179 ) resistor r=5.52526 //w=0.168 //l=0.115 //layer=ply \
 //thickness=0.18 //x=76.01 //y=1.585 //x2=76.125 //y2=1.585
r562 (  127 176 ) resistor r=5.52526 //w=0.168 //l=0.115 //layer=ply \
 //thickness=0.18 //x=75.79 //y=0.93 //x2=75.675 //y2=0.93
r563 (  126 178 ) resistor r=5.52526 //w=0.168 //l=0.115 //layer=ply \
 //thickness=0.18 //x=76.01 //y=0.93 //x2=76.125 //y2=0.93
r564 (  126 127 ) resistor r=112.809 //w=0.094 //l=0.22 //layer=ply \
 //thickness=0.18 //x=76.01 //y=0.93 //x2=75.79 //y2=0.93
r565 (  125 175 ) resistor r=16.5046 //w=0.27 //l=0.135 //layer=ply \
 //thickness=0.18 //x=75.775 //y=4.975 //x2=75.64 //y2=4.975
r566 (  124 131 ) resistor r=26.9307 //w=0.15 //l=0.106066 //layer=ply \
 //thickness=0.18 //x=76.005 //y=4.975 //x2=76.08 //y2=5.05
r567 (  124 125 ) resistor r=117.936 //w=0.094 //l=0.23 //layer=ply \
 //thickness=0.18 //x=76.005 //y=4.975 //x2=75.775 //y2=4.975
r568 (  121 175 ) resistor r=32.4568 //w=0.214 //l=0.075 //layer=ply \
 //thickness=0.18 //x=75.64 //y=5.05 //x2=75.64 //y2=4.975
r569 (  119 177 ) resistor r=39.5823 //w=0.21 //l=0.173853 //layer=ply \
 //thickness=0.18 //x=75.635 //y=1.74 //x2=75.675 //y2=1.585
r570 (  119 170 ) resistor r=182.032 //w=0.094 //l=0.355 //layer=ply \
 //thickness=0.18 //x=75.635 //y=1.74 //x2=75.635 //y2=2.095
r571 (  118 177 ) resistor r=39.5823 //w=0.21 //l=0.173853 //layer=ply \
 //thickness=0.18 //x=75.635 //y=1.43 //x2=75.675 //y2=1.585
r572 (  117 176 ) resistor r=45.1352 //w=0.168 //l=0.173853 //layer=ply \
 //thickness=0.18 //x=75.635 //y=1.085 //x2=75.675 //y2=0.93
r573 (  117 118 ) resistor r=176.904 //w=0.094 //l=0.345 //layer=ply \
 //thickness=0.18 //x=75.635 //y=1.085 //x2=75.635 //y2=1.43
r574 (  116 167 ) resistor r=45.1352 //w=0.168 //l=0.173853 //layer=ply \
 //thickness=0.18 //x=43.605 //y=1.43 //x2=43.565 //y2=1.585
r575 (  115 166 ) resistor r=45.1352 //w=0.168 //l=0.173853 //layer=ply \
 //thickness=0.18 //x=43.605 //y=1.085 //x2=43.565 //y2=0.93
r576 (  115 116 ) resistor r=176.904 //w=0.094 //l=0.345 //layer=ply \
 //thickness=0.18 //x=43.605 //y=1.085 //x2=43.605 //y2=1.43
r577 (  110 165 ) resistor r=10.701 //w=0.21 //l=0.115 //layer=ply \
 //thickness=0.18 //x=43.23 //y=1.585 //x2=43.115 //y2=1.585
r578 (  109 167 ) resistor r=5.52526 //w=0.168 //l=0.115 //layer=ply \
 //thickness=0.18 //x=43.45 //y=1.585 //x2=43.565 //y2=1.585
r579 (  108 164 ) resistor r=5.52526 //w=0.168 //l=0.115 //layer=ply \
 //thickness=0.18 //x=43.23 //y=0.93 //x2=43.115 //y2=0.93
r580 (  107 166 ) resistor r=5.52526 //w=0.168 //l=0.115 //layer=ply \
 //thickness=0.18 //x=43.45 //y=0.93 //x2=43.565 //y2=0.93
r581 (  107 108 ) resistor r=112.809 //w=0.094 //l=0.22 //layer=ply \
 //thickness=0.18 //x=43.45 //y=0.93 //x2=43.23 //y2=0.93
r582 (  106 162 ) resistor r=16.5046 //w=0.27 //l=0.135 //layer=ply \
 //thickness=0.18 //x=43.205 //y=4.97 //x2=43.07 //y2=4.97
r583 (  105 112 ) resistor r=26.9307 //w=0.15 //l=0.106066 //layer=ply \
 //thickness=0.18 //x=43.445 //y=4.97 //x2=43.52 //y2=5.045
r584 (  105 106 ) resistor r=123.064 //w=0.094 //l=0.24 //layer=ply \
 //thickness=0.18 //x=43.445 //y=4.97 //x2=43.205 //y2=4.97
r585 (  100 165 ) resistor r=39.5823 //w=0.21 //l=0.173853 //layer=ply \
 //thickness=0.18 //x=43.075 //y=1.74 //x2=43.115 //y2=1.585
r586 (  100 157 ) resistor r=182.032 //w=0.094 //l=0.355 //layer=ply \
 //thickness=0.18 //x=43.075 //y=1.74 //x2=43.075 //y2=2.095
r587 (  99 165 ) resistor r=39.5823 //w=0.21 //l=0.173853 //layer=ply \
 //thickness=0.18 //x=43.075 //y=1.43 //x2=43.115 //y2=1.585
r588 (  98 164 ) resistor r=45.1352 //w=0.168 //l=0.173853 //layer=ply \
 //thickness=0.18 //x=43.075 //y=1.085 //x2=43.115 //y2=0.93
r589 (  98 99 ) resistor r=176.904 //w=0.094 //l=0.345 //layer=ply \
 //thickness=0.18 //x=43.075 //y=1.085 //x2=43.075 //y2=1.43
r590 (  97 150 ) resistor r=592.245 //w=0.094 //l=1.155 //layer=ply \
 //thickness=0.18 //x=82.74 //y=6.205 //x2=82.74 //y2=5.05
r591 (  96 188 ) resistor r=592.245 //w=0.094 //l=1.155 //layer=ply \
 //thickness=0.18 //x=82.3 //y=6.205 //x2=82.3 //y2=5.05
r592 (  95 131 ) resistor r=592.245 //w=0.094 //l=1.155 //layer=ply \
 //thickness=0.18 //x=76.08 //y=6.205 //x2=76.08 //y2=5.05
r593 (  94 121 ) resistor r=592.245 //w=0.094 //l=1.155 //layer=ply \
 //thickness=0.18 //x=75.64 //y=6.205 //x2=75.64 //y2=5.05
r594 (  93 112 ) resistor r=592.245 //w=0.094 //l=1.155 //layer=ply \
 //thickness=0.18 //x=43.52 //y=6.2 //x2=43.52 //y2=5.045
r595 (  92 163 ) resistor r=592.245 //w=0.094 //l=1.155 //layer=ply \
 //thickness=0.18 //x=43.08 //y=6.2 //x2=43.08 //y2=5.045
r596 (  91 147 ) resistor r=56.4043 //w=0.094 //l=0.11 //layer=ply \
 //thickness=0.18 //x=82.56 //y=1.585 //x2=82.67 //y2=1.585
r597 (  91 148 ) resistor r=56.4043 //w=0.094 //l=0.11 //layer=ply \
 //thickness=0.18 //x=82.56 //y=1.585 //x2=82.45 //y2=1.585
r598 (  90 128 ) resistor r=56.4043 //w=0.094 //l=0.11 //layer=ply \
 //thickness=0.18 //x=75.9 //y=1.585 //x2=76.01 //y2=1.585
r599 (  90 129 ) resistor r=56.4043 //w=0.094 //l=0.11 //layer=ply \
 //thickness=0.18 //x=75.9 //y=1.585 //x2=75.79 //y2=1.585
r600 (  89 109 ) resistor r=56.4043 //w=0.094 //l=0.11 //layer=ply \
 //thickness=0.18 //x=43.34 //y=1.585 //x2=43.45 //y2=1.585
r601 (  89 110 ) resistor r=56.4043 //w=0.094 //l=0.11 //layer=ply \
 //thickness=0.18 //x=43.34 //y=1.585 //x2=43.23 //y2=1.585
r602 (  86 185 ) resistor r=152 //w=0.17 //l=0.17 //layer=licon //count=1 \
 //x=82.28 //y=4.885 //x2=82.28 //y2=4.885
r603 (  86 87 ) resistor r=10.3507 //w=0.207 //l=0.165 //layer=li \
 //thickness=0.1 //x=82.27 //y=4.885 //x2=82.27 //y2=4.72
r604 (  84 173 ) resistor r=152 //w=0.17 //l=0.17 //layer=licon //count=1 \
 //x=75.64 //y=4.885 //x2=75.64 //y2=4.885
r605 (  80 160 ) resistor r=152 //w=0.17 //l=0.17 //layer=licon //count=1 \
 //x=43.07 //y=4.88 //x2=43.07 //y2=4.88
r606 (  78 87 ) resistor r=32.1711 //w=0.187 //l=0.47 //layer=li \
 //thickness=0.1 //x=82.26 //y=4.25 //x2=82.26 //y2=4.72
r607 (  75 181 ) resistor r=152 //w=0.17 //l=0.17 //layer=licon //count=1 \
 //x=82.26 //y=2.26 //x2=82.26 //y2=2.26
r608 (  75 78 ) resistor r=136.214 //w=0.187 //l=1.99 //layer=li \
 //thickness=0.1 //x=82.26 //y=2.26 //x2=82.26 //y2=4.25
r609 (  70 72 ) resistor r=75.9786 //w=0.187 //l=1.11 //layer=li \
 //thickness=0.1 //x=75.6 //y=3.14 //x2=75.6 //y2=4.25
r610 (  67 169 ) resistor r=152 //w=0.17 //l=0.17 //layer=licon //count=1 \
 //x=75.6 //y=2.26 //x2=75.6 //y2=2.26
r611 (  67 70 ) resistor r=60.2353 //w=0.187 //l=0.88 //layer=li \
 //thickness=0.1 //x=75.6 //y=2.26 //x2=75.6 //y2=3.14
r612 (  65 84 ) resistor r=11.2426 //w=0.191 //l=0.174714 //layer=li \
 //thickness=0.1 //x=75.6 //y=4.72 //x2=75.62 //y2=4.885
r613 (  65 72 ) resistor r=32.1711 //w=0.187 //l=0.47 //layer=li \
 //thickness=0.1 //x=75.6 //y=4.72 //x2=75.6 //y2=4.25
r614 (  62 64 ) resistor r=101.305 //w=0.187 //l=1.48 //layer=li \
 //thickness=0.1 //x=48.59 //y=2.77 //x2=48.59 //y2=4.25
r615 (  60 64 ) resistor r=68.4492 //w=0.187 //l=1 //layer=li //thickness=0.1 \
 //x=48.59 //y=5.25 //x2=48.59 //y2=4.25
r616 (  59 62 ) resistor r=57.4973 //w=0.187 //l=0.84 //layer=li \
 //thickness=0.1 //x=48.59 //y=1.93 //x2=48.59 //y2=2.77
r617 (  57 59 ) resistor r=7.15173 //w=0.17 //l=0.120208 //layer=li \
 //thickness=0.1 //x=48.505 //y=1.845 //x2=48.59 //y2=1.93
r618 (  57 58 ) resistor r=21.5615 //w=0.187 //l=0.315 //layer=li \
 //thickness=0.1 //x=48.505 //y=1.845 //x2=48.19 //y2=1.845
r619 (  53 58 ) resistor r=7.15173 //w=0.17 //l=0.120208 //layer=li \
 //thickness=0.1 //x=48.105 //y=1.76 //x2=48.19 //y2=1.845
r620 (  53 193 ) resistor r=39.016 //w=0.187 //l=0.57 //layer=li \
 //thickness=0.1 //x=48.105 //y=1.76 //x2=48.105 //y2=1.19
r621 (  52 82 ) resistor r=5.4201 //w=0.17 //l=0.085 //layer=li \
 //thickness=0.1 //x=47.895 //y=5.335 //x2=47.81 //y2=5.335
r622 (  51 60 ) resistor r=7.15173 //w=0.17 //l=0.120208 //layer=li \
 //thickness=0.1 //x=48.505 //y=5.335 //x2=48.59 //y2=5.25
r623 (  51 52 ) resistor r=41.754 //w=0.187 //l=0.61 //layer=li \
 //thickness=0.1 //x=48.505 //y=5.335 //x2=47.895 //y2=5.335
r624 (  45 82 ) resistor r=1.40859 //w=0.34 //l=0.085 //layer=li \
 //thickness=0.1 //x=47.81 //y=5.42 //x2=47.81 //y2=5.335
r625 (  45 197 ) resistor r=33.1979 //w=0.187 //l=0.485 //layer=li \
 //thickness=0.1 //x=47.81 //y=5.42 //x2=47.81 //y2=5.905
r626 (  44 81 ) resistor r=5.4201 //w=0.17 //l=0.085 //layer=li \
 //thickness=0.1 //x=47.015 //y=5.335 //x2=46.93 //y2=5.335
r627 (  43 82 ) resistor r=5.4201 //w=0.17 //l=0.085 //layer=li \
 //thickness=0.1 //x=47.725 //y=5.335 //x2=47.81 //y2=5.335
r628 (  43 44 ) resistor r=48.5989 //w=0.187 //l=0.71 //layer=li \
 //thickness=0.1 //x=47.725 //y=5.335 //x2=47.015 //y2=5.335
r629 (  37 81 ) resistor r=1.40859 //w=0.34 //l=0.085 //layer=li \
 //thickness=0.1 //x=46.93 //y=5.42 //x2=46.93 //y2=5.335
r630 (  37 196 ) resistor r=33.1979 //w=0.187 //l=0.485 //layer=li \
 //thickness=0.1 //x=46.93 //y=5.42 //x2=46.93 //y2=5.905
r631 (  35 81 ) resistor r=5.4201 //w=0.17 //l=0.085 //layer=li \
 //thickness=0.1 //x=46.845 //y=5.335 //x2=46.93 //y2=5.335
r632 (  35 36 ) resistor r=48.5989 //w=0.187 //l=0.71 //layer=li \
 //thickness=0.1 //x=46.845 //y=5.335 //x2=46.135 //y2=5.335
r633 (  29 36 ) resistor r=7.15173 //w=0.17 //l=0.120208 //layer=li \
 //thickness=0.1 //x=46.05 //y=5.42 //x2=46.135 //y2=5.335
r634 (  29 195 ) resistor r=33.1979 //w=0.187 //l=0.485 //layer=li \
 //thickness=0.1 //x=46.05 //y=5.42 //x2=46.05 //y2=5.905
r635 (  25 156 ) resistor r=152 //w=0.17 //l=0.17 //layer=licon //count=1 \
 //x=43.04 //y=2.26 //x2=43.04 //y2=2.26
r636 (  25 28 ) resistor r=136.214 //w=0.187 //l=1.99 //layer=li \
 //thickness=0.1 //x=43.04 //y=2.26 //x2=43.04 //y2=4.25
r637 (  23 80 ) resistor r=11.4737 //w=0.186 //l=0.172337 //layer=li \
 //thickness=0.1 //x=43.04 //y=4.715 //x2=43.055 //y2=4.88
r638 (  23 28 ) resistor r=31.8289 //w=0.187 //l=0.465 //layer=li \
 //thickness=0.1 //x=43.04 //y=4.715 //x2=43.04 //y2=4.25
r639 (  22 78 ) resistor r=9.3 //w=0.17 //l=0.17 //layer=mcon //count=1 \
 //x=82.26 //y=4.25 //x2=82.26 //y2=4.25
r640 (  20 70 ) resistor r=9.3 //w=0.17 //l=0.17 //layer=mcon //count=1 \
 //x=75.6 //y=3.14 //x2=75.6 //y2=3.14
r641 (  18 72 ) resistor r=9.3 //w=0.17 //l=0.17 //layer=mcon //count=1 \
 //x=75.6 //y=4.25 //x2=75.6 //y2=4.25
r642 (  16 64 ) resistor r=9.3 //w=0.17 //l=0.17 //layer=mcon //count=1 \
 //x=48.59 //y=4.25 //x2=48.59 //y2=4.25
r643 (  14 62 ) resistor r=9.3 //w=0.17 //l=0.17 //layer=mcon //count=1 \
 //x=48.59 //y=2.77 //x2=48.59 //y2=2.77
r644 (  12 28 ) resistor r=9.3 //w=0.17 //l=0.17 //layer=mcon //count=1 \
 //x=43.04 //y=4.25 //x2=43.04 //y2=4.25
r645 (  10 18 ) resistor r=0.0717383 //w=0.224 //l=0.115 //layer=m1 \
 //thickness=0.36 //x=75.715 //y=4.25 //x2=75.6 //y2=4.25
r646 (  9 22 ) resistor r=0.0717383 //w=0.224 //l=0.115 //layer=m1 \
 //thickness=0.36 //x=82.145 //y=4.25 //x2=82.26 //y2=4.25
r647 (  9 10 ) resistor r=6.1355 //w=0.131 //l=6.43 //layer=m1 \
 //thickness=0.36 //x=82.145 //y=4.25 //x2=75.715 //y2=4.25
r648 (  7 20 ) resistor r=0.0717383 //w=0.224 //l=0.115 //layer=m1 \
 //thickness=0.36 //x=75.485 //y=3.14 //x2=75.6 //y2=3.14
r649 (  7 8 ) resistor r=23.1107 //w=0.131 //l=24.22 //layer=m1 \
 //thickness=0.36 //x=75.485 //y=3.14 //x2=51.265 //y2=3.14
r650 (  6 8 ) resistor r=0.0698411 //w=0.17 //l=0.120208 //layer=m1 \
 //thickness=0.36 //x=51.18 //y=3.055 //x2=51.265 //y2=3.14
r651 (  5 6 ) resistor r=0.19084 //w=0.131 //l=0.2 //layer=m1 //thickness=0.36 \
 //x=51.18 //y=2.855 //x2=51.18 //y2=3.055
r652 (  4 14 ) resistor r=0.0717383 //w=0.224 //l=0.115 //layer=m1 \
 //thickness=0.36 //x=48.705 //y=2.77 //x2=48.59 //y2=2.77
r653 (  3 5 ) resistor r=0.0698411 //w=0.17 //l=0.120208 //layer=m1 \
 //thickness=0.36 //x=51.095 //y=2.77 //x2=51.18 //y2=2.855
r654 (  3 4 ) resistor r=2.28053 //w=0.131 //l=2.39 //layer=m1 \
 //thickness=0.36 //x=51.095 //y=2.77 //x2=48.705 //y2=2.77
r655 (  2 12 ) resistor r=0.0717383 //w=0.224 //l=0.115 //layer=m1 \
 //thickness=0.36 //x=43.155 //y=4.25 //x2=43.04 //y2=4.25
r656 (  1 16 ) resistor r=0.0717383 //w=0.224 //l=0.115 //layer=m1 \
 //thickness=0.36 //x=48.475 //y=4.25 //x2=48.59 //y2=4.25
r657 (  1 2 ) resistor r=5.07634 //w=0.131 //l=5.32 //layer=m1 \
 //thickness=0.36 //x=48.475 //y=4.25 //x2=43.155 //y2=4.25
ends PM_TMRDFFSNQX1\%noxref_13

subckt PM_TMRDFFSNQX1\%D ( 1 2 3 4 11 12 13 14 15 16 17 18 19 20 21 22 23 25 \
 38 49 58 59 60 61 62 63 64 65 66 67 68 69 70 74 76 79 80 84 85 86 87 91 93 96 \
 97 101 102 103 104 108 110 113 114 124 133 142 )
c321 ( 142 0 ) capacitor c=0.0588816f //x=50.44 //y=4.88
c322 ( 133 0 ) capacitor c=0.0588816f //x=26.02 //y=4.88
c323 ( 124 0 ) capacitor c=0.0667949f //x=1.6 //y=4.88
c324 ( 114 0 ) capacitor c=0.0318948f //x=50.775 //y=1.39
c325 ( 113 0 ) capacitor c=0.0187384f //x=50.775 //y=1.045
c326 ( 110 0 ) capacitor c=0.0141798f //x=50.62 //y=1.545
c327 ( 108 0 ) capacitor c=0.0149844f //x=50.62 //y=0.89
c328 ( 104 0 ) capacitor c=0.0813322f //x=50.245 //y=2.095
c329 ( 103 0 ) capacitor c=0.0229267f //x=50.245 //y=1.7
c330 ( 102 0 ) capacitor c=0.0234352f //x=50.245 //y=1.39
c331 ( 101 0 ) capacitor c=0.0199343f //x=50.245 //y=1.045
c332 ( 97 0 ) capacitor c=0.0318948f //x=26.355 //y=1.39
c333 ( 96 0 ) capacitor c=0.0187384f //x=26.355 //y=1.045
c334 ( 93 0 ) capacitor c=0.0141798f //x=26.2 //y=1.545
c335 ( 91 0 ) capacitor c=0.0149844f //x=26.2 //y=0.89
c336 ( 87 0 ) capacitor c=0.0813322f //x=25.825 //y=2.095
c337 ( 86 0 ) capacitor c=0.0229267f //x=25.825 //y=1.7
c338 ( 85 0 ) capacitor c=0.0234352f //x=25.825 //y=1.39
c339 ( 84 0 ) capacitor c=0.0199343f //x=25.825 //y=1.045
c340 ( 80 0 ) capacitor c=0.0318948f //x=1.935 //y=1.39
c341 ( 79 0 ) capacitor c=0.0187384f //x=1.935 //y=1.045
c342 ( 76 0 ) capacitor c=0.0141798f //x=1.78 //y=1.545
c343 ( 74 0 ) capacitor c=0.0149844f //x=1.78 //y=0.89
c344 ( 70 0 ) capacitor c=0.0844059f //x=1.405 //y=2.095
c345 ( 69 0 ) capacitor c=0.0229722f //x=1.405 //y=1.7
c346 ( 68 0 ) capacitor c=0.0234352f //x=1.405 //y=1.39
c347 ( 67 0 ) capacitor c=0.0199343f //x=1.405 //y=1.045
c348 ( 66 0 ) capacitor c=0.110275f //x=50.78 //y=6.2
c349 ( 65 0 ) capacitor c=0.154305f //x=50.34 //y=6.2
c350 ( 64 0 ) capacitor c=0.110275f //x=26.36 //y=6.2
c351 ( 63 0 ) capacitor c=0.154305f //x=25.92 //y=6.2
c352 ( 62 0 ) capacitor c=0.110275f //x=1.94 //y=6.2
c353 ( 61 0 ) capacitor c=0.154305f //x=1.5 //y=6.2
c354 ( 49 0 ) capacitor c=0.0876359f //x=50.44 //y=2.26
c355 ( 38 0 ) capacitor c=0.0903622f //x=26.02 //y=2.26
c356 ( 25 0 ) capacitor c=0.111725f //x=1.6 //y=2.26
c357 ( 4 0 ) capacitor c=0.00583987f //x=26.135 //y=3.14
c358 ( 3 0 ) capacitor c=0.373149f //x=50.325 //y=3.14
c359 ( 2 0 ) capacitor c=0.0150814f //x=1.715 //y=3.14
c360 ( 1 0 ) capacitor c=0.470661f //x=25.905 //y=3.14
r361 (  140 142 ) resistor r=20.6867 //w=0.233 //l=0.1 //layer=ply \
 //thickness=0.18 //x=50.34 //y=4.88 //x2=50.44 //y2=4.88
r362 (  131 133 ) resistor r=20.6867 //w=0.233 //l=0.1 //layer=ply \
 //thickness=0.18 //x=25.92 //y=4.88 //x2=26.02 //y2=4.88
r363 (  122 124 ) resistor r=20.6867 //w=0.233 //l=0.1 //layer=ply \
 //thickness=0.18 //x=1.5 //y=4.88 //x2=1.6 //y2=4.88
r364 (  115 142 ) resistor r=70.3348 //w=0.233 //l=0.414367 //layer=ply \
 //thickness=0.18 //x=50.78 //y=5.045 //x2=50.44 //y2=4.88
r365 (  114 144 ) resistor r=45.1352 //w=0.168 //l=0.173853 //layer=ply \
 //thickness=0.18 //x=50.775 //y=1.39 //x2=50.735 //y2=1.545
r366 (  113 143 ) resistor r=45.1352 //w=0.168 //l=0.173853 //layer=ply \
 //thickness=0.18 //x=50.775 //y=1.045 //x2=50.735 //y2=0.89
r367 (  113 114 ) resistor r=176.904 //w=0.094 //l=0.345 //layer=ply \
 //thickness=0.18 //x=50.775 //y=1.045 //x2=50.775 //y2=1.39
r368 (  111 139 ) resistor r=10.701 //w=0.21 //l=0.115 //layer=ply \
 //thickness=0.18 //x=50.4 //y=1.545 //x2=50.285 //y2=1.545
r369 (  110 144 ) resistor r=5.52526 //w=0.168 //l=0.115 //layer=ply \
 //thickness=0.18 //x=50.62 //y=1.545 //x2=50.735 //y2=1.545
r370 (  109 138 ) resistor r=5.52526 //w=0.168 //l=0.115 //layer=ply \
 //thickness=0.18 //x=50.4 //y=0.89 //x2=50.285 //y2=0.89
r371 (  108 143 ) resistor r=5.52526 //w=0.168 //l=0.115 //layer=ply \
 //thickness=0.18 //x=50.62 //y=0.89 //x2=50.735 //y2=0.89
r372 (  108 109 ) resistor r=112.809 //w=0.094 //l=0.22 //layer=ply \
 //thickness=0.18 //x=50.62 //y=0.89 //x2=50.4 //y2=0.89
r373 (  105 140 ) resistor r=13.0941 //w=0.233 //l=0.165 //layer=ply \
 //thickness=0.18 //x=50.34 //y=5.045 //x2=50.34 //y2=4.88
r374 (  104 137 ) resistor r=34.8111 //w=0.27 //l=0.264953 //layer=ply \
 //thickness=0.18 //x=50.245 //y=2.095 //x2=50.44 //y2=2.26
r375 (  103 139 ) resistor r=39.5823 //w=0.21 //l=0.173853 //layer=ply \
 //thickness=0.18 //x=50.245 //y=1.7 //x2=50.285 //y2=1.545
r376 (  103 104 ) resistor r=202.543 //w=0.094 //l=0.395 //layer=ply \
 //thickness=0.18 //x=50.245 //y=1.7 //x2=50.245 //y2=2.095
r377 (  102 139 ) resistor r=39.5823 //w=0.21 //l=0.173853 //layer=ply \
 //thickness=0.18 //x=50.245 //y=1.39 //x2=50.285 //y2=1.545
r378 (  101 138 ) resistor r=45.1352 //w=0.168 //l=0.173853 //layer=ply \
 //thickness=0.18 //x=50.245 //y=1.045 //x2=50.285 //y2=0.89
r379 (  101 102 ) resistor r=176.904 //w=0.094 //l=0.345 //layer=ply \
 //thickness=0.18 //x=50.245 //y=1.045 //x2=50.245 //y2=1.39
r380 (  98 133 ) resistor r=70.3348 //w=0.233 //l=0.414367 //layer=ply \
 //thickness=0.18 //x=26.36 //y=5.045 //x2=26.02 //y2=4.88
r381 (  97 135 ) resistor r=45.1352 //w=0.168 //l=0.173853 //layer=ply \
 //thickness=0.18 //x=26.355 //y=1.39 //x2=26.315 //y2=1.545
r382 (  96 134 ) resistor r=45.1352 //w=0.168 //l=0.173853 //layer=ply \
 //thickness=0.18 //x=26.355 //y=1.045 //x2=26.315 //y2=0.89
r383 (  96 97 ) resistor r=176.904 //w=0.094 //l=0.345 //layer=ply \
 //thickness=0.18 //x=26.355 //y=1.045 //x2=26.355 //y2=1.39
r384 (  94 130 ) resistor r=10.701 //w=0.21 //l=0.115 //layer=ply \
 //thickness=0.18 //x=25.98 //y=1.545 //x2=25.865 //y2=1.545
r385 (  93 135 ) resistor r=5.52526 //w=0.168 //l=0.115 //layer=ply \
 //thickness=0.18 //x=26.2 //y=1.545 //x2=26.315 //y2=1.545
r386 (  92 129 ) resistor r=5.52526 //w=0.168 //l=0.115 //layer=ply \
 //thickness=0.18 //x=25.98 //y=0.89 //x2=25.865 //y2=0.89
r387 (  91 134 ) resistor r=5.52526 //w=0.168 //l=0.115 //layer=ply \
 //thickness=0.18 //x=26.2 //y=0.89 //x2=26.315 //y2=0.89
r388 (  91 92 ) resistor r=112.809 //w=0.094 //l=0.22 //layer=ply \
 //thickness=0.18 //x=26.2 //y=0.89 //x2=25.98 //y2=0.89
r389 (  88 131 ) resistor r=13.0941 //w=0.233 //l=0.165 //layer=ply \
 //thickness=0.18 //x=25.92 //y=5.045 //x2=25.92 //y2=4.88
r390 (  87 128 ) resistor r=34.8111 //w=0.27 //l=0.264953 //layer=ply \
 //thickness=0.18 //x=25.825 //y=2.095 //x2=26.02 //y2=2.26
r391 (  86 130 ) resistor r=39.5823 //w=0.21 //l=0.173853 //layer=ply \
 //thickness=0.18 //x=25.825 //y=1.7 //x2=25.865 //y2=1.545
r392 (  86 87 ) resistor r=202.543 //w=0.094 //l=0.395 //layer=ply \
 //thickness=0.18 //x=25.825 //y=1.7 //x2=25.825 //y2=2.095
r393 (  85 130 ) resistor r=39.5823 //w=0.21 //l=0.173853 //layer=ply \
 //thickness=0.18 //x=25.825 //y=1.39 //x2=25.865 //y2=1.545
r394 (  84 129 ) resistor r=45.1352 //w=0.168 //l=0.173853 //layer=ply \
 //thickness=0.18 //x=25.825 //y=1.045 //x2=25.865 //y2=0.89
r395 (  84 85 ) resistor r=176.904 //w=0.094 //l=0.345 //layer=ply \
 //thickness=0.18 //x=25.825 //y=1.045 //x2=25.825 //y2=1.39
r396 (  81 124 ) resistor r=70.3348 //w=0.233 //l=0.414367 //layer=ply \
 //thickness=0.18 //x=1.94 //y=5.045 //x2=1.6 //y2=4.88
r397 (  80 126 ) resistor r=45.1352 //w=0.168 //l=0.173853 //layer=ply \
 //thickness=0.18 //x=1.935 //y=1.39 //x2=1.895 //y2=1.545
r398 (  79 125 ) resistor r=45.1352 //w=0.168 //l=0.173853 //layer=ply \
 //thickness=0.18 //x=1.935 //y=1.045 //x2=1.895 //y2=0.89
r399 (  79 80 ) resistor r=176.904 //w=0.094 //l=0.345 //layer=ply \
 //thickness=0.18 //x=1.935 //y=1.045 //x2=1.935 //y2=1.39
r400 (  77 121 ) resistor r=10.701 //w=0.21 //l=0.115 //layer=ply \
 //thickness=0.18 //x=1.56 //y=1.545 //x2=1.445 //y2=1.545
r401 (  76 126 ) resistor r=5.52526 //w=0.168 //l=0.115 //layer=ply \
 //thickness=0.18 //x=1.78 //y=1.545 //x2=1.895 //y2=1.545
r402 (  75 120 ) resistor r=5.52526 //w=0.168 //l=0.115 //layer=ply \
 //thickness=0.18 //x=1.56 //y=0.89 //x2=1.445 //y2=0.89
r403 (  74 125 ) resistor r=5.52526 //w=0.168 //l=0.115 //layer=ply \
 //thickness=0.18 //x=1.78 //y=0.89 //x2=1.895 //y2=0.89
r404 (  74 75 ) resistor r=112.809 //w=0.094 //l=0.22 //layer=ply \
 //thickness=0.18 //x=1.78 //y=0.89 //x2=1.56 //y2=0.89
r405 (  71 122 ) resistor r=13.0941 //w=0.233 //l=0.165 //layer=ply \
 //thickness=0.18 //x=1.5 //y=5.045 //x2=1.5 //y2=4.88
r406 (  70 119 ) resistor r=34.8111 //w=0.27 //l=0.264953 //layer=ply \
 //thickness=0.18 //x=1.405 //y=2.095 //x2=1.6 //y2=2.26
r407 (  69 121 ) resistor r=39.5823 //w=0.21 //l=0.173853 //layer=ply \
 //thickness=0.18 //x=1.405 //y=1.7 //x2=1.445 //y2=1.545
r408 (  69 70 ) resistor r=202.543 //w=0.094 //l=0.395 //layer=ply \
 //thickness=0.18 //x=1.405 //y=1.7 //x2=1.405 //y2=2.095
r409 (  68 121 ) resistor r=39.5823 //w=0.21 //l=0.173853 //layer=ply \
 //thickness=0.18 //x=1.405 //y=1.39 //x2=1.445 //y2=1.545
r410 (  67 120 ) resistor r=45.1352 //w=0.168 //l=0.173853 //layer=ply \
 //thickness=0.18 //x=1.405 //y=1.045 //x2=1.445 //y2=0.89
r411 (  67 68 ) resistor r=176.904 //w=0.094 //l=0.345 //layer=ply \
 //thickness=0.18 //x=1.405 //y=1.045 //x2=1.405 //y2=1.39
r412 (  66 115 ) resistor r=592.245 //w=0.094 //l=1.155 //layer=ply \
 //thickness=0.18 //x=50.78 //y=6.2 //x2=50.78 //y2=5.045
r413 (  65 105 ) resistor r=592.245 //w=0.094 //l=1.155 //layer=ply \
 //thickness=0.18 //x=50.34 //y=6.2 //x2=50.34 //y2=5.045
r414 (  64 98 ) resistor r=592.245 //w=0.094 //l=1.155 //layer=ply \
 //thickness=0.18 //x=26.36 //y=6.2 //x2=26.36 //y2=5.045
r415 (  63 88 ) resistor r=592.245 //w=0.094 //l=1.155 //layer=ply \
 //thickness=0.18 //x=25.92 //y=6.2 //x2=25.92 //y2=5.045
r416 (  62 81 ) resistor r=592.245 //w=0.094 //l=1.155 //layer=ply \
 //thickness=0.18 //x=1.94 //y=6.2 //x2=1.94 //y2=5.045
r417 (  61 71 ) resistor r=592.245 //w=0.094 //l=1.155 //layer=ply \
 //thickness=0.18 //x=1.5 //y=6.2 //x2=1.5 //y2=5.045
r418 (  60 110 ) resistor r=56.4043 //w=0.094 //l=0.11 //layer=ply \
 //thickness=0.18 //x=50.51 //y=1.545 //x2=50.62 //y2=1.545
r419 (  60 111 ) resistor r=56.4043 //w=0.094 //l=0.11 //layer=ply \
 //thickness=0.18 //x=50.51 //y=1.545 //x2=50.4 //y2=1.545
r420 (  59 93 ) resistor r=56.4043 //w=0.094 //l=0.11 //layer=ply \
 //thickness=0.18 //x=26.09 //y=1.545 //x2=26.2 //y2=1.545
r421 (  59 94 ) resistor r=56.4043 //w=0.094 //l=0.11 //layer=ply \
 //thickness=0.18 //x=26.09 //y=1.545 //x2=25.98 //y2=1.545
r422 (  58 76 ) resistor r=56.4043 //w=0.094 //l=0.11 //layer=ply \
 //thickness=0.18 //x=1.67 //y=1.545 //x2=1.78 //y2=1.545
r423 (  58 77 ) resistor r=56.4043 //w=0.094 //l=0.11 //layer=ply \
 //thickness=0.18 //x=1.67 //y=1.545 //x2=1.56 //y2=1.545
r424 (  56 142 ) resistor r=152 //w=0.17 //l=0.17 //layer=licon //count=1 \
 //x=50.44 //y=4.88 //x2=50.44 //y2=4.88
r425 (  49 137 ) resistor r=152 //w=0.17 //l=0.17 //layer=licon //count=1 \
 //x=50.44 //y=2.26 //x2=50.44 //y2=2.26
r426 (  46 133 ) resistor r=152 //w=0.17 //l=0.17 //layer=licon //count=1 \
 //x=26.02 //y=4.88 //x2=26.02 //y2=4.88
r427 (  38 128 ) resistor r=152 //w=0.17 //l=0.17 //layer=licon //count=1 \
 //x=26.02 //y=2.26 //x2=26.02 //y2=2.26
r428 (  35 124 ) resistor r=152 //w=0.17 //l=0.17 //layer=licon //count=1 \
 //x=1.6 //y=4.88 //x2=1.6 //y2=4.88
r429 (  25 119 ) resistor r=152 //w=0.17 //l=0.17 //layer=licon //count=1 \
 //x=1.6 //y=2.26 //x2=1.6 //y2=2.26
r430 (  23 56 ) resistor r=43.123 //w=0.187 //l=0.63 //layer=li \
 //thickness=0.1 //x=50.44 //y=4.25 //x2=50.44 //y2=4.88
r431 (  22 23 ) resistor r=25.3262 //w=0.187 //l=0.37 //layer=li \
 //thickness=0.1 //x=50.44 //y=3.88 //x2=50.44 //y2=4.25
r432 (  21 22 ) resistor r=50.6524 //w=0.187 //l=0.74 //layer=li \
 //thickness=0.1 //x=50.44 //y=3.14 //x2=50.44 //y2=3.88
r433 (  21 49 ) resistor r=60.2353 //w=0.187 //l=0.88 //layer=li \
 //thickness=0.1 //x=50.44 //y=3.14 //x2=50.44 //y2=2.26
r434 (  20 46 ) resistor r=43.123 //w=0.187 //l=0.63 //layer=li \
 //thickness=0.1 //x=26.02 //y=4.25 //x2=26.02 //y2=4.88
r435 (  19 20 ) resistor r=25.3262 //w=0.187 //l=0.37 //layer=li \
 //thickness=0.1 //x=26.02 //y=3.88 //x2=26.02 //y2=4.25
r436 (  18 19 ) resistor r=50.6524 //w=0.187 //l=0.74 //layer=li \
 //thickness=0.1 //x=26.02 //y=3.14 //x2=26.02 //y2=3.88
r437 (  17 18 ) resistor r=25.3262 //w=0.187 //l=0.37 //layer=li \
 //thickness=0.1 //x=26.02 //y=2.77 //x2=26.02 //y2=3.14
r438 (  17 38 ) resistor r=34.9091 //w=0.187 //l=0.51 //layer=li \
 //thickness=0.1 //x=26.02 //y=2.77 //x2=26.02 //y2=2.26
r439 (  16 35 ) resistor r=17.7968 //w=0.187 //l=0.26 //layer=li \
 //thickness=0.1 //x=1.6 //y=4.62 //x2=1.6 //y2=4.88
r440 (  15 16 ) resistor r=25.3262 //w=0.187 //l=0.37 //layer=li \
 //thickness=0.1 //x=1.6 //y=4.25 //x2=1.6 //y2=4.62
r441 (  14 15 ) resistor r=25.3262 //w=0.187 //l=0.37 //layer=li \
 //thickness=0.1 //x=1.6 //y=3.88 //x2=1.6 //y2=4.25
r442 (  13 14 ) resistor r=25.3262 //w=0.187 //l=0.37 //layer=li \
 //thickness=0.1 //x=1.6 //y=3.51 //x2=1.6 //y2=3.88
r443 (  12 13 ) resistor r=25.3262 //w=0.187 //l=0.37 //layer=li \
 //thickness=0.1 //x=1.6 //y=3.14 //x2=1.6 //y2=3.51
r444 (  11 12 ) resistor r=25.3262 //w=0.187 //l=0.37 //layer=li \
 //thickness=0.1 //x=1.6 //y=2.77 //x2=1.6 //y2=3.14
r445 (  11 25 ) resistor r=34.9091 //w=0.187 //l=0.51 //layer=li \
 //thickness=0.1 //x=1.6 //y=2.77 //x2=1.6 //y2=2.26
r446 (  10 21 ) resistor r=9.3 //w=0.17 //l=0.17 //layer=mcon //count=1 \
 //x=50.44 //y=3.14 //x2=50.44 //y2=3.14
r447 (  8 18 ) resistor r=9.3 //w=0.17 //l=0.17 //layer=mcon //count=1 \
 //x=26.02 //y=3.14 //x2=26.02 //y2=3.14
r448 (  6 12 ) resistor r=9.3 //w=0.17 //l=0.17 //layer=mcon //count=1 //x=1.6 \
 //y=3.14 //x2=1.6 //y2=3.14
r449 (  4 8 ) resistor r=0.0880901 //w=0.191 //l=0.115 //layer=m1 \
 //thickness=0.36 //x=26.135 //y=3.14 //x2=26.02 //y2=3.14
r450 (  3 10 ) resistor r=0.0717383 //w=0.224 //l=0.115 //layer=m1 \
 //thickness=0.36 //x=50.325 //y=3.14 //x2=50.44 //y2=3.14
r451 (  3 4 ) resistor r=23.0821 //w=0.131 //l=24.19 //layer=m1 \
 //thickness=0.36 //x=50.325 //y=3.14 //x2=26.135 //y2=3.14
r452 (  2 6 ) resistor r=0.0717383 //w=0.224 //l=0.115 //layer=m1 \
 //thickness=0.36 //x=1.715 //y=3.14 //x2=1.6 //y2=3.14
r453 (  1 8 ) resistor r=0.0880901 //w=0.191 //l=0.115 //layer=m1 \
 //thickness=0.36 //x=25.905 //y=3.14 //x2=26.02 //y2=3.14
r454 (  1 2 ) resistor r=23.0821 //w=0.131 //l=24.19 //layer=m1 \
 //thickness=0.36 //x=25.905 //y=3.14 //x2=1.715 //y2=3.14
ends PM_TMRDFFSNQX1\%D

subckt PM_TMRDFFSNQX1\%noxref_15 ( 1 2 3 4 17 18 29 31 32 36 38 46 53 54 55 56 \
 57 58 59 60 61 62 63 64 66 72 73 74 75 79 80 81 82 83 85 91 92 93 94 114 116 \
 117 )
c237 ( 117 0 ) capacitor c=0.0220291f //x=51.295 //y=5.2
c238 ( 116 0 ) capacitor c=0.0217503f //x=50.415 //y=5.2
c239 ( 114 0 ) capacitor c=0.0084702f //x=51.29 //y=1.085
c240 ( 94 0 ) capacitor c=0.0556143f //x=58.855 //y=4.97
c241 ( 93 0 ) capacitor c=0.0293157f //x=59.145 //y=4.97
c242 ( 92 0 ) capacitor c=0.0347816f //x=58.81 //y=1.4
c243 ( 91 0 ) capacitor c=0.0187487f //x=58.81 //y=1.055
c244 ( 85 0 ) capacitor c=0.0137055f //x=58.655 //y=1.555
c245 ( 83 0 ) capacitor c=0.0149861f //x=58.655 //y=0.9
c246 ( 82 0 ) capacitor c=0.096037f //x=58.28 //y=2.095
c247 ( 81 0 ) capacitor c=0.0228993f //x=58.28 //y=1.71
c248 ( 80 0 ) capacitor c=0.0234352f //x=58.28 //y=1.4
c249 ( 79 0 ) capacitor c=0.0198724f //x=58.28 //y=1.055
c250 ( 75 0 ) capacitor c=0.0557698f //x=54.045 //y=4.97
c251 ( 74 0 ) capacitor c=0.0293157f //x=54.335 //y=4.97
c252 ( 73 0 ) capacitor c=0.0347816f //x=54 //y=1.4
c253 ( 72 0 ) capacitor c=0.0187487f //x=54 //y=1.055
c254 ( 66 0 ) capacitor c=0.0137055f //x=53.845 //y=1.555
c255 ( 64 0 ) capacitor c=0.0149861f //x=53.845 //y=0.9
c256 ( 63 0 ) capacitor c=0.096037f //x=53.47 //y=2.095
c257 ( 62 0 ) capacitor c=0.0228993f //x=53.47 //y=1.71
c258 ( 61 0 ) capacitor c=0.0234352f //x=53.47 //y=1.4
c259 ( 60 0 ) capacitor c=0.0198724f //x=53.47 //y=1.055
c260 ( 59 0 ) capacitor c=0.110114f //x=59.22 //y=6.2
c261 ( 58 0 ) capacitor c=0.158956f //x=58.78 //y=6.2
c262 ( 57 0 ) capacitor c=0.110114f //x=54.41 //y=6.2
c263 ( 56 0 ) capacitor c=0.158956f //x=53.97 //y=6.2
c264 ( 53 0 ) capacitor c=0.00211606f //x=51.44 //y=5.38
c265 ( 46 0 ) capacitor c=0.0943831f //x=58.58 //y=2.26
c266 ( 38 0 ) capacitor c=0.0969368f //x=53.77 //y=2.26
c267 ( 36 0 ) capacitor c=0.104747f //x=51.92 //y=2.77
c268 ( 32 0 ) capacitor c=0.00404073f //x=51.565 //y=1.835
c269 ( 31 0 ) capacitor c=0.0122201f //x=51.835 //y=1.835
c270 ( 29 0 ) capacitor c=0.0137995f //x=51.835 //y=5.38
c271 ( 18 0 ) capacitor c=0.00251635f //x=50.645 //y=5.38
c272 ( 17 0 ) capacitor c=0.0143649f //x=51.355 //y=5.38
c273 ( 4 0 ) capacitor c=0.00673266f //x=54.035 //y=2.77
c274 ( 3 0 ) capacitor c=0.0686809f //x=58.465 //y=2.77
c275 ( 2 0 ) capacitor c=0.00515785f //x=52.035 //y=2.77
c276 ( 1 0 ) capacitor c=0.0230071f //x=53.625 //y=2.77
r277 (  93 95 ) resistor r=26.9307 //w=0.15 //l=0.106066 //layer=ply \
 //thickness=0.18 //x=59.145 //y=4.97 //x2=59.22 //y2=5.045
r278 (  93 94 ) resistor r=148.702 //w=0.094 //l=0.29 //layer=ply \
 //thickness=0.18 //x=59.145 //y=4.97 //x2=58.855 //y2=4.97
r279 (  92 113 ) resistor r=45.1352 //w=0.168 //l=0.173853 //layer=ply \
 //thickness=0.18 //x=58.81 //y=1.4 //x2=58.77 //y2=1.555
r280 (  91 112 ) resistor r=45.1352 //w=0.168 //l=0.173853 //layer=ply \
 //thickness=0.18 //x=58.81 //y=1.055 //x2=58.77 //y2=0.9
r281 (  91 92 ) resistor r=176.904 //w=0.094 //l=0.345 //layer=ply \
 //thickness=0.18 //x=58.81 //y=1.055 //x2=58.81 //y2=1.4
r282 (  88 94 ) resistor r=22.7971 //w=0.269 //l=0.106066 //layer=ply \
 //thickness=0.18 //x=58.78 //y=5.045 //x2=58.855 //y2=4.97
r283 (  88 111 ) resistor r=35.8364 //w=0.269 //l=0.270185 //layer=ply \
 //thickness=0.18 //x=58.78 //y=5.045 //x2=58.58 //y2=4.88
r284 (  86 107 ) resistor r=10.701 //w=0.21 //l=0.115 //layer=ply \
 //thickness=0.18 //x=58.435 //y=1.555 //x2=58.32 //y2=1.555
r285 (  85 113 ) resistor r=5.52526 //w=0.168 //l=0.115 //layer=ply \
 //thickness=0.18 //x=58.655 //y=1.555 //x2=58.77 //y2=1.555
r286 (  84 106 ) resistor r=5.52526 //w=0.168 //l=0.115 //layer=ply \
 //thickness=0.18 //x=58.435 //y=0.9 //x2=58.32 //y2=0.9
r287 (  83 112 ) resistor r=5.52526 //w=0.168 //l=0.115 //layer=ply \
 //thickness=0.18 //x=58.655 //y=0.9 //x2=58.77 //y2=0.9
r288 (  83 84 ) resistor r=112.809 //w=0.094 //l=0.22 //layer=ply \
 //thickness=0.18 //x=58.655 //y=0.9 //x2=58.435 //y2=0.9
r289 (  82 109 ) resistor r=58.7805 //w=0.246 //l=0.373497 //layer=ply \
 //thickness=0.18 //x=58.28 //y=2.095 //x2=58.58 //y2=2.26
r290 (  81 107 ) resistor r=39.5823 //w=0.21 //l=0.173853 //layer=ply \
 //thickness=0.18 //x=58.28 //y=1.71 //x2=58.32 //y2=1.555
r291 (  81 82 ) resistor r=197.415 //w=0.094 //l=0.385 //layer=ply \
 //thickness=0.18 //x=58.28 //y=1.71 //x2=58.28 //y2=2.095
r292 (  80 107 ) resistor r=39.5823 //w=0.21 //l=0.173853 //layer=ply \
 //thickness=0.18 //x=58.28 //y=1.4 //x2=58.32 //y2=1.555
r293 (  79 106 ) resistor r=45.1352 //w=0.168 //l=0.173853 //layer=ply \
 //thickness=0.18 //x=58.28 //y=1.055 //x2=58.32 //y2=0.9
r294 (  79 80 ) resistor r=176.904 //w=0.094 //l=0.345 //layer=ply \
 //thickness=0.18 //x=58.28 //y=1.055 //x2=58.28 //y2=1.4
r295 (  74 76 ) resistor r=26.9307 //w=0.15 //l=0.106066 //layer=ply \
 //thickness=0.18 //x=54.335 //y=4.97 //x2=54.41 //y2=5.045
r296 (  74 75 ) resistor r=148.702 //w=0.094 //l=0.29 //layer=ply \
 //thickness=0.18 //x=54.335 //y=4.97 //x2=54.045 //y2=4.97
r297 (  73 105 ) resistor r=45.1352 //w=0.168 //l=0.173853 //layer=ply \
 //thickness=0.18 //x=54 //y=1.4 //x2=53.96 //y2=1.555
r298 (  72 104 ) resistor r=45.1352 //w=0.168 //l=0.173853 //layer=ply \
 //thickness=0.18 //x=54 //y=1.055 //x2=53.96 //y2=0.9
r299 (  72 73 ) resistor r=176.904 //w=0.094 //l=0.345 //layer=ply \
 //thickness=0.18 //x=54 //y=1.055 //x2=54 //y2=1.4
r300 (  69 75 ) resistor r=22.7971 //w=0.269 //l=0.106066 //layer=ply \
 //thickness=0.18 //x=53.97 //y=5.045 //x2=54.045 //y2=4.97
r301 (  69 103 ) resistor r=35.8364 //w=0.269 //l=0.270185 //layer=ply \
 //thickness=0.18 //x=53.97 //y=5.045 //x2=53.77 //y2=4.88
r302 (  67 99 ) resistor r=10.701 //w=0.21 //l=0.115 //layer=ply \
 //thickness=0.18 //x=53.625 //y=1.555 //x2=53.51 //y2=1.555
r303 (  66 105 ) resistor r=5.52526 //w=0.168 //l=0.115 //layer=ply \
 //thickness=0.18 //x=53.845 //y=1.555 //x2=53.96 //y2=1.555
r304 (  65 98 ) resistor r=5.52526 //w=0.168 //l=0.115 //layer=ply \
 //thickness=0.18 //x=53.625 //y=0.9 //x2=53.51 //y2=0.9
r305 (  64 104 ) resistor r=5.52526 //w=0.168 //l=0.115 //layer=ply \
 //thickness=0.18 //x=53.845 //y=0.9 //x2=53.96 //y2=0.9
r306 (  64 65 ) resistor r=112.809 //w=0.094 //l=0.22 //layer=ply \
 //thickness=0.18 //x=53.845 //y=0.9 //x2=53.625 //y2=0.9
r307 (  63 101 ) resistor r=58.7805 //w=0.246 //l=0.373497 //layer=ply \
 //thickness=0.18 //x=53.47 //y=2.095 //x2=53.77 //y2=2.26
r308 (  62 99 ) resistor r=39.5823 //w=0.21 //l=0.173853 //layer=ply \
 //thickness=0.18 //x=53.47 //y=1.71 //x2=53.51 //y2=1.555
r309 (  62 63 ) resistor r=197.415 //w=0.094 //l=0.385 //layer=ply \
 //thickness=0.18 //x=53.47 //y=1.71 //x2=53.47 //y2=2.095
r310 (  61 99 ) resistor r=39.5823 //w=0.21 //l=0.173853 //layer=ply \
 //thickness=0.18 //x=53.47 //y=1.4 //x2=53.51 //y2=1.555
r311 (  60 98 ) resistor r=45.1352 //w=0.168 //l=0.173853 //layer=ply \
 //thickness=0.18 //x=53.47 //y=1.055 //x2=53.51 //y2=0.9
r312 (  60 61 ) resistor r=176.904 //w=0.094 //l=0.345 //layer=ply \
 //thickness=0.18 //x=53.47 //y=1.055 //x2=53.47 //y2=1.4
r313 (  59 95 ) resistor r=592.245 //w=0.094 //l=1.155 //layer=ply \
 //thickness=0.18 //x=59.22 //y=6.2 //x2=59.22 //y2=5.045
r314 (  58 88 ) resistor r=592.245 //w=0.094 //l=1.155 //layer=ply \
 //thickness=0.18 //x=58.78 //y=6.2 //x2=58.78 //y2=5.045
r315 (  57 76 ) resistor r=592.245 //w=0.094 //l=1.155 //layer=ply \
 //thickness=0.18 //x=54.41 //y=6.2 //x2=54.41 //y2=5.045
r316 (  56 69 ) resistor r=592.245 //w=0.094 //l=1.155 //layer=ply \
 //thickness=0.18 //x=53.97 //y=6.2 //x2=53.97 //y2=5.045
r317 (  55 85 ) resistor r=56.4043 //w=0.094 //l=0.11 //layer=ply \
 //thickness=0.18 //x=58.545 //y=1.555 //x2=58.655 //y2=1.555
r318 (  55 86 ) resistor r=56.4043 //w=0.094 //l=0.11 //layer=ply \
 //thickness=0.18 //x=58.545 //y=1.555 //x2=58.435 //y2=1.555
r319 (  54 66 ) resistor r=56.4043 //w=0.094 //l=0.11 //layer=ply \
 //thickness=0.18 //x=53.735 //y=1.555 //x2=53.845 //y2=1.555
r320 (  54 67 ) resistor r=56.4043 //w=0.094 //l=0.11 //layer=ply \
 //thickness=0.18 //x=53.735 //y=1.555 //x2=53.625 //y2=1.555
r321 (  51 111 ) resistor r=152 //w=0.17 //l=0.17 //layer=licon //count=1 \
 //x=58.58 //y=4.88 //x2=58.58 //y2=4.88
r322 (  49 51 ) resistor r=144.428 //w=0.187 //l=2.11 //layer=li \
 //thickness=0.1 //x=58.58 //y=2.77 //x2=58.58 //y2=4.88
r323 (  46 109 ) resistor r=152 //w=0.17 //l=0.17 //layer=licon //count=1 \
 //x=58.58 //y=2.26 //x2=58.58 //y2=2.26
r324 (  46 49 ) resistor r=34.9091 //w=0.187 //l=0.51 //layer=li \
 //thickness=0.1 //x=58.58 //y=2.26 //x2=58.58 //y2=2.77
r325 (  43 103 ) resistor r=152 //w=0.17 //l=0.17 //layer=licon //count=1 \
 //x=53.77 //y=4.88 //x2=53.77 //y2=4.88
r326 (  41 43 ) resistor r=144.77 //w=0.187 //l=2.115 //layer=li \
 //thickness=0.1 //x=53.77 //y=2.765 //x2=53.77 //y2=4.88
r327 (  38 101 ) resistor r=152 //w=0.17 //l=0.17 //layer=licon //count=1 \
 //x=53.77 //y=2.26 //x2=53.77 //y2=2.26
r328 (  38 41 ) resistor r=34.5668 //w=0.187 //l=0.505 //layer=li \
 //thickness=0.1 //x=53.77 //y=2.26 //x2=53.77 //y2=2.765
r329 (  34 36 ) resistor r=172.834 //w=0.187 //l=2.525 //layer=li \
 //thickness=0.1 //x=51.92 //y=5.295 //x2=51.92 //y2=2.77
r330 (  33 36 ) resistor r=58.1818 //w=0.187 //l=0.85 //layer=li \
 //thickness=0.1 //x=51.92 //y=1.92 //x2=51.92 //y2=2.77
r331 (  31 33 ) resistor r=7.15173 //w=0.17 //l=0.120208 //layer=li \
 //thickness=0.1 //x=51.835 //y=1.835 //x2=51.92 //y2=1.92
r332 (  31 32 ) resistor r=18.4813 //w=0.187 //l=0.27 //layer=li \
 //thickness=0.1 //x=51.835 //y=1.835 //x2=51.565 //y2=1.835
r333 (  30 53 ) resistor r=5.4201 //w=0.17 //l=0.085 //layer=li \
 //thickness=0.1 //x=51.525 //y=5.38 //x2=51.44 //y2=5.38
r334 (  29 34 ) resistor r=7.15173 //w=0.17 //l=0.120208 //layer=li \
 //thickness=0.1 //x=51.835 //y=5.38 //x2=51.92 //y2=5.295
r335 (  29 30 ) resistor r=21.2193 //w=0.187 //l=0.31 //layer=li \
 //thickness=0.1 //x=51.835 //y=5.38 //x2=51.525 //y2=5.38
r336 (  25 32 ) resistor r=7.15173 //w=0.17 //l=0.120208 //layer=li \
 //thickness=0.1 //x=51.48 //y=1.75 //x2=51.565 //y2=1.835
r337 (  25 114 ) resistor r=39.016 //w=0.187 //l=0.57 //layer=li \
 //thickness=0.1 //x=51.48 //y=1.75 //x2=51.48 //y2=1.18
r338 (  19 53 ) resistor r=1.40859 //w=0.34 //l=0.085 //layer=li \
 //thickness=0.1 //x=51.44 //y=5.465 //x2=51.44 //y2=5.38
r339 (  19 117 ) resistor r=30.1176 //w=0.187 //l=0.44 //layer=li \
 //thickness=0.1 //x=51.44 //y=5.465 //x2=51.44 //y2=5.905
r340 (  17 53 ) resistor r=5.4201 //w=0.17 //l=0.085 //layer=li \
 //thickness=0.1 //x=51.355 //y=5.38 //x2=51.44 //y2=5.38
r341 (  17 18 ) resistor r=48.5989 //w=0.187 //l=0.71 //layer=li \
 //thickness=0.1 //x=51.355 //y=5.38 //x2=50.645 //y2=5.38
r342 (  11 18 ) resistor r=7.15173 //w=0.17 //l=0.120208 //layer=li \
 //thickness=0.1 //x=50.56 //y=5.465 //x2=50.645 //y2=5.38
r343 (  11 116 ) resistor r=30.1176 //w=0.187 //l=0.44 //layer=li \
 //thickness=0.1 //x=50.56 //y=5.465 //x2=50.56 //y2=5.905
r344 (  10 49 ) resistor r=9.3 //w=0.17 //l=0.17 //layer=mcon //count=1 \
 //x=58.58 //y=2.77 //x2=58.58 //y2=2.77
r345 (  8 41 ) resistor r=9.3 //w=0.17 //l=0.17 //layer=mcon //count=1 \
 //x=53.77 //y=2.765 //x2=53.77 //y2=2.765
r346 (  6 36 ) resistor r=9.3 //w=0.17 //l=0.17 //layer=mcon //count=1 \
 //x=51.92 //y=2.77 //x2=51.92 //y2=2.77
r347 (  4 8 ) resistor r=0.164988 //w=0.206 //l=0.267488 //layer=m1 \
 //thickness=0.36 //x=54.035 //y=2.77 //x2=53.77 //y2=2.765
r348 (  3 10 ) resistor r=0.0717383 //w=0.224 //l=0.115 //layer=m1 \
 //thickness=0.36 //x=58.465 //y=2.77 //x2=58.58 //y2=2.77
r349 (  3 4 ) resistor r=4.2271 //w=0.131 //l=4.43 //layer=m1 //thickness=0.36 \
 //x=58.465 //y=2.77 //x2=54.035 //y2=2.77
r350 (  2 6 ) resistor r=0.0717383 //w=0.224 //l=0.115 //layer=m1 \
 //thickness=0.36 //x=52.035 //y=2.77 //x2=51.92 //y2=2.77
r351 (  1 8 ) resistor r=0.0921728 //w=0.206 //l=0.147479 //layer=m1 \
 //thickness=0.36 //x=53.625 //y=2.77 //x2=53.77 //y2=2.765
r352 (  1 2 ) resistor r=1.51718 //w=0.131 //l=1.59 //layer=m1 \
 //thickness=0.36 //x=53.625 //y=2.77 //x2=52.035 //y2=2.77
ends PM_TMRDFFSNQX1\%noxref_15

subckt PM_TMRDFFSNQX1\%noxref_16 ( 1 2 13 14 21 29 35 36 40 42 49 50 51 52 53 \
 54 55 56 57 61 63 66 67 77 80 82 83 84 )
c164 ( 84 0 ) capacitor c=0.023087f //x=60.615 //y=5.2
c165 ( 83 0 ) capacitor c=0.023519f //x=59.735 //y=5.2
c166 ( 82 0 ) capacitor c=0.0224735f //x=58.855 //y=5.2
c167 ( 80 0 ) capacitor c=0.00872971f //x=60.865 //y=1.095
c168 ( 77 0 ) capacitor c=0.0588816f //x=63.39 //y=4.88
c169 ( 67 0 ) capacitor c=0.0318948f //x=63.725 //y=1.39
c170 ( 66 0 ) capacitor c=0.0187384f //x=63.725 //y=1.045
c171 ( 63 0 ) capacitor c=0.0141798f //x=63.57 //y=1.545
c172 ( 61 0 ) capacitor c=0.0149844f //x=63.57 //y=0.89
c173 ( 57 0 ) capacitor c=0.0813322f //x=63.195 //y=2.095
c174 ( 56 0 ) capacitor c=0.0229267f //x=63.195 //y=1.7
c175 ( 55 0 ) capacitor c=0.0234352f //x=63.195 //y=1.39
c176 ( 54 0 ) capacitor c=0.0199343f //x=63.195 //y=1.045
c177 ( 53 0 ) capacitor c=0.110275f //x=63.73 //y=6.2
c178 ( 52 0 ) capacitor c=0.154305f //x=63.29 //y=6.2
c179 ( 50 0 ) capacitor c=0.00106608f //x=60.76 //y=5.335
c180 ( 49 0 ) capacitor c=0.00207319f //x=59.88 //y=5.335
c181 ( 42 0 ) capacitor c=0.0839295f //x=63.39 //y=2.26
c182 ( 40 0 ) capacitor c=0.10402f //x=61.54 //y=2.77
c183 ( 36 0 ) capacitor c=0.00398962f //x=61.14 //y=1.845
c184 ( 35 0 ) capacitor c=0.0137288f //x=61.455 //y=1.845
c185 ( 29 0 ) capacitor c=0.0284988f //x=61.455 //y=5.335
c186 ( 21 0 ) capacitor c=0.0176454f //x=60.675 //y=5.335
c187 ( 14 0 ) capacitor c=0.00332903f //x=59.085 //y=5.335
c188 ( 13 0 ) capacitor c=0.0148427f //x=59.795 //y=5.335
c189 ( 2 0 ) capacitor c=0.00808366f //x=61.655 //y=2.77
c190 ( 1 0 ) capacitor c=0.0353429f //x=63.275 //y=2.77
r191 (  75 77 ) resistor r=20.6867 //w=0.233 //l=0.1 //layer=ply \
 //thickness=0.18 //x=63.29 //y=4.88 //x2=63.39 //y2=4.88
r192 (  68 77 ) resistor r=70.3348 //w=0.233 //l=0.414367 //layer=ply \
 //thickness=0.18 //x=63.73 //y=5.045 //x2=63.39 //y2=4.88
r193 (  67 79 ) resistor r=45.1352 //w=0.168 //l=0.173853 //layer=ply \
 //thickness=0.18 //x=63.725 //y=1.39 //x2=63.685 //y2=1.545
r194 (  66 78 ) resistor r=45.1352 //w=0.168 //l=0.173853 //layer=ply \
 //thickness=0.18 //x=63.725 //y=1.045 //x2=63.685 //y2=0.89
r195 (  66 67 ) resistor r=176.904 //w=0.094 //l=0.345 //layer=ply \
 //thickness=0.18 //x=63.725 //y=1.045 //x2=63.725 //y2=1.39
r196 (  64 74 ) resistor r=10.701 //w=0.21 //l=0.115 //layer=ply \
 //thickness=0.18 //x=63.35 //y=1.545 //x2=63.235 //y2=1.545
r197 (  63 79 ) resistor r=5.52526 //w=0.168 //l=0.115 //layer=ply \
 //thickness=0.18 //x=63.57 //y=1.545 //x2=63.685 //y2=1.545
r198 (  62 73 ) resistor r=5.52526 //w=0.168 //l=0.115 //layer=ply \
 //thickness=0.18 //x=63.35 //y=0.89 //x2=63.235 //y2=0.89
r199 (  61 78 ) resistor r=5.52526 //w=0.168 //l=0.115 //layer=ply \
 //thickness=0.18 //x=63.57 //y=0.89 //x2=63.685 //y2=0.89
r200 (  61 62 ) resistor r=112.809 //w=0.094 //l=0.22 //layer=ply \
 //thickness=0.18 //x=63.57 //y=0.89 //x2=63.35 //y2=0.89
r201 (  58 75 ) resistor r=13.0941 //w=0.233 //l=0.165 //layer=ply \
 //thickness=0.18 //x=63.29 //y=5.045 //x2=63.29 //y2=4.88
r202 (  57 72 ) resistor r=34.8111 //w=0.27 //l=0.264953 //layer=ply \
 //thickness=0.18 //x=63.195 //y=2.095 //x2=63.39 //y2=2.26
r203 (  56 74 ) resistor r=39.5823 //w=0.21 //l=0.173853 //layer=ply \
 //thickness=0.18 //x=63.195 //y=1.7 //x2=63.235 //y2=1.545
r204 (  56 57 ) resistor r=202.543 //w=0.094 //l=0.395 //layer=ply \
 //thickness=0.18 //x=63.195 //y=1.7 //x2=63.195 //y2=2.095
r205 (  55 74 ) resistor r=39.5823 //w=0.21 //l=0.173853 //layer=ply \
 //thickness=0.18 //x=63.195 //y=1.39 //x2=63.235 //y2=1.545
r206 (  54 73 ) resistor r=45.1352 //w=0.168 //l=0.173853 //layer=ply \
 //thickness=0.18 //x=63.195 //y=1.045 //x2=63.235 //y2=0.89
r207 (  54 55 ) resistor r=176.904 //w=0.094 //l=0.345 //layer=ply \
 //thickness=0.18 //x=63.195 //y=1.045 //x2=63.195 //y2=1.39
r208 (  53 68 ) resistor r=592.245 //w=0.094 //l=1.155 //layer=ply \
 //thickness=0.18 //x=63.73 //y=6.2 //x2=63.73 //y2=5.045
r209 (  52 58 ) resistor r=592.245 //w=0.094 //l=1.155 //layer=ply \
 //thickness=0.18 //x=63.29 //y=6.2 //x2=63.29 //y2=5.045
r210 (  51 63 ) resistor r=56.4043 //w=0.094 //l=0.11 //layer=ply \
 //thickness=0.18 //x=63.46 //y=1.545 //x2=63.57 //y2=1.545
r211 (  51 64 ) resistor r=56.4043 //w=0.094 //l=0.11 //layer=ply \
 //thickness=0.18 //x=63.46 //y=1.545 //x2=63.35 //y2=1.545
r212 (  47 77 ) resistor r=152 //w=0.17 //l=0.17 //layer=licon //count=1 \
 //x=63.39 //y=4.88 //x2=63.39 //y2=4.88
r213 (  45 47 ) resistor r=144.428 //w=0.187 //l=2.11 //layer=li \
 //thickness=0.1 //x=63.39 //y=2.77 //x2=63.39 //y2=4.88
r214 (  42 72 ) resistor r=152 //w=0.17 //l=0.17 //layer=licon //count=1 \
 //x=63.39 //y=2.26 //x2=63.39 //y2=2.26
r215 (  42 45 ) resistor r=34.9091 //w=0.187 //l=0.51 //layer=li \
 //thickness=0.1 //x=63.39 //y=2.26 //x2=63.39 //y2=2.77
r216 (  38 40 ) resistor r=169.754 //w=0.187 //l=2.48 //layer=li \
 //thickness=0.1 //x=61.54 //y=5.25 //x2=61.54 //y2=2.77
r217 (  37 40 ) resistor r=57.4973 //w=0.187 //l=0.84 //layer=li \
 //thickness=0.1 //x=61.54 //y=1.93 //x2=61.54 //y2=2.77
r218 (  35 37 ) resistor r=7.15173 //w=0.17 //l=0.120208 //layer=li \
 //thickness=0.1 //x=61.455 //y=1.845 //x2=61.54 //y2=1.93
r219 (  35 36 ) resistor r=21.5615 //w=0.187 //l=0.315 //layer=li \
 //thickness=0.1 //x=61.455 //y=1.845 //x2=61.14 //y2=1.845
r220 (  31 36 ) resistor r=7.15173 //w=0.17 //l=0.120208 //layer=li \
 //thickness=0.1 //x=61.055 //y=1.76 //x2=61.14 //y2=1.845
r221 (  31 80 ) resistor r=39.016 //w=0.187 //l=0.57 //layer=li \
 //thickness=0.1 //x=61.055 //y=1.76 //x2=61.055 //y2=1.19
r222 (  30 50 ) resistor r=5.4201 //w=0.17 //l=0.085 //layer=li \
 //thickness=0.1 //x=60.845 //y=5.335 //x2=60.76 //y2=5.335
r223 (  29 38 ) resistor r=7.15173 //w=0.17 //l=0.120208 //layer=li \
 //thickness=0.1 //x=61.455 //y=5.335 //x2=61.54 //y2=5.25
r224 (  29 30 ) resistor r=41.754 //w=0.187 //l=0.61 //layer=li \
 //thickness=0.1 //x=61.455 //y=5.335 //x2=60.845 //y2=5.335
r225 (  23 50 ) resistor r=1.40859 //w=0.34 //l=0.085 //layer=li \
 //thickness=0.1 //x=60.76 //y=5.42 //x2=60.76 //y2=5.335
r226 (  23 84 ) resistor r=33.1979 //w=0.187 //l=0.485 //layer=li \
 //thickness=0.1 //x=60.76 //y=5.42 //x2=60.76 //y2=5.905
r227 (  22 49 ) resistor r=5.4201 //w=0.17 //l=0.085 //layer=li \
 //thickness=0.1 //x=59.965 //y=5.335 //x2=59.88 //y2=5.335
r228 (  21 50 ) resistor r=5.4201 //w=0.17 //l=0.085 //layer=li \
 //thickness=0.1 //x=60.675 //y=5.335 //x2=60.76 //y2=5.335
r229 (  21 22 ) resistor r=48.5989 //w=0.187 //l=0.71 //layer=li \
 //thickness=0.1 //x=60.675 //y=5.335 //x2=59.965 //y2=5.335
r230 (  15 49 ) resistor r=1.40859 //w=0.34 //l=0.085 //layer=li \
 //thickness=0.1 //x=59.88 //y=5.42 //x2=59.88 //y2=5.335
r231 (  15 83 ) resistor r=33.1979 //w=0.187 //l=0.485 //layer=li \
 //thickness=0.1 //x=59.88 //y=5.42 //x2=59.88 //y2=5.905
r232 (  13 49 ) resistor r=5.4201 //w=0.17 //l=0.085 //layer=li \
 //thickness=0.1 //x=59.795 //y=5.335 //x2=59.88 //y2=5.335
r233 (  13 14 ) resistor r=48.5989 //w=0.187 //l=0.71 //layer=li \
 //thickness=0.1 //x=59.795 //y=5.335 //x2=59.085 //y2=5.335
r234 (  7 14 ) resistor r=7.15173 //w=0.17 //l=0.120208 //layer=li \
 //thickness=0.1 //x=59 //y=5.42 //x2=59.085 //y2=5.335
r235 (  7 82 ) resistor r=33.1979 //w=0.187 //l=0.485 //layer=li \
 //thickness=0.1 //x=59 //y=5.42 //x2=59 //y2=5.905
r236 (  6 45 ) resistor r=9.3 //w=0.17 //l=0.17 //layer=mcon //count=1 \
 //x=63.39 //y=2.77 //x2=63.39 //y2=2.77
r237 (  4 40 ) resistor r=9.3 //w=0.17 //l=0.17 //layer=mcon //count=1 \
 //x=61.54 //y=2.77 //x2=61.54 //y2=2.77
r238 (  2 4 ) resistor r=0.0717383 //w=0.224 //l=0.115 //layer=m1 \
 //thickness=0.36 //x=61.655 //y=2.77 //x2=61.54 //y2=2.77
r239 (  1 6 ) resistor r=0.0717383 //w=0.224 //l=0.115 //layer=m1 \
 //thickness=0.36 //x=63.275 //y=2.77 //x2=63.39 //y2=2.77
r240 (  1 2 ) resistor r=1.5458 //w=0.131 //l=1.62 //layer=m1 //thickness=0.36 \
 //x=63.275 //y=2.77 //x2=61.655 //y2=2.77
ends PM_TMRDFFSNQX1\%noxref_16

subckt PM_TMRDFFSNQX1\%CLK ( 1 2 3 4 5 6 7 8 9 10 23 24 25 26 27 28 29 30 31 \
 32 33 34 35 36 37 39 49 51 58 66 68 74 82 84 95 96 97 98 99 100 101 102 103 \
 104 105 106 107 108 109 110 111 112 113 114 115 117 123 124 125 126 127 132 \
 133 134 139 141 143 149 150 151 152 153 155 161 162 163 164 165 170 171 172 \
 177 179 181 187 188 189 190 191 193 199 200 201 202 203 208 209 210 215 217 \
 219 225 226 230 239 240 243 254 263 264 267 278 287 288 291 )
c755 ( 291 0 ) capacitor c=0.0331838f //x=64.16 //y=4.88
c756 ( 288 0 ) capacitor c=0.0279499f //x=64.13 //y=2.095
c757 ( 287 0 ) capacitor c=0.0421676f //x=64.13 //y=2.26
c758 ( 278 0 ) capacitor c=0.0334842f //x=54.88 //y=4.88
c759 ( 267 0 ) capacitor c=0.0331706f //x=39.74 //y=4.88
c760 ( 264 0 ) capacitor c=0.0279499f //x=39.71 //y=2.095
c761 ( 263 0 ) capacitor c=0.0421676f //x=39.71 //y=2.26
c762 ( 254 0 ) capacitor c=0.0334842f //x=30.46 //y=4.88
c763 ( 243 0 ) capacitor c=0.0331706f //x=15.32 //y=4.88
c764 ( 240 0 ) capacitor c=0.0279499f //x=15.29 //y=2.095
c765 ( 239 0 ) capacitor c=0.0421676f //x=15.29 //y=2.26
c766 ( 230 0 ) capacitor c=0.0334842f //x=6.04 //y=4.88
c767 ( 226 0 ) capacitor c=0.0429696f //x=64.695 //y=1.43
c768 ( 225 0 ) capacitor c=0.0192208f //x=64.695 //y=1.085
c769 ( 219 0 ) capacitor c=0.0148884f //x=64.54 //y=1.585
c770 ( 217 0 ) capacitor c=0.0157803f //x=64.54 //y=0.93
c771 ( 215 0 ) capacitor c=0.0299681f //x=64.535 //y=4.97
c772 ( 210 0 ) capacitor c=0.0205163f //x=64.165 //y=1.74
c773 ( 209 0 ) capacitor c=0.0168481f //x=64.165 //y=1.43
c774 ( 208 0 ) capacitor c=0.0174783f //x=64.165 //y=1.085
c775 ( 203 0 ) capacitor c=0.0245352f //x=55.215 //y=4.97
c776 ( 202 0 ) capacitor c=0.0825763f //x=54.97 //y=2.095
c777 ( 201 0 ) capacitor c=0.0170266f //x=54.97 //y=1.63
c778 ( 200 0 ) capacitor c=0.018609f //x=54.97 //y=1.4
c779 ( 199 0 ) capacitor c=0.0187309f //x=54.97 //y=1.09
c780 ( 193 0 ) capacitor c=0.014725f //x=54.815 //y=1.555
c781 ( 191 0 ) capacitor c=0.0146567f //x=54.815 //y=0.935
c782 ( 190 0 ) capacitor c=0.0335408f //x=54.445 //y=1.4
c783 ( 189 0 ) capacitor c=0.0173761f //x=54.445 //y=1.09
c784 ( 188 0 ) capacitor c=0.0429696f //x=40.275 //y=1.43
c785 ( 187 0 ) capacitor c=0.0192208f //x=40.275 //y=1.085
c786 ( 181 0 ) capacitor c=0.0148884f //x=40.12 //y=1.585
c787 ( 179 0 ) capacitor c=0.0157803f //x=40.12 //y=0.93
c788 ( 177 0 ) capacitor c=0.0295235f //x=40.115 //y=4.97
c789 ( 172 0 ) capacitor c=0.0205163f //x=39.745 //y=1.74
c790 ( 171 0 ) capacitor c=0.0168481f //x=39.745 //y=1.43
c791 ( 170 0 ) capacitor c=0.0174783f //x=39.745 //y=1.085
c792 ( 165 0 ) capacitor c=0.0245352f //x=30.795 //y=4.97
c793 ( 164 0 ) capacitor c=0.0825763f //x=30.55 //y=2.095
c794 ( 163 0 ) capacitor c=0.0170266f //x=30.55 //y=1.63
c795 ( 162 0 ) capacitor c=0.018609f //x=30.55 //y=1.4
c796 ( 161 0 ) capacitor c=0.0187309f //x=30.55 //y=1.09
c797 ( 155 0 ) capacitor c=0.014725f //x=30.395 //y=1.555
c798 ( 153 0 ) capacitor c=0.0146567f //x=30.395 //y=0.935
c799 ( 152 0 ) capacitor c=0.0335408f //x=30.025 //y=1.4
c800 ( 151 0 ) capacitor c=0.0173761f //x=30.025 //y=1.09
c801 ( 150 0 ) capacitor c=0.0429696f //x=15.855 //y=1.43
c802 ( 149 0 ) capacitor c=0.0192208f //x=15.855 //y=1.085
c803 ( 143 0 ) capacitor c=0.0148884f //x=15.7 //y=1.585
c804 ( 141 0 ) capacitor c=0.0157803f //x=15.7 //y=0.93
c805 ( 139 0 ) capacitor c=0.0295235f //x=15.695 //y=4.97
c806 ( 134 0 ) capacitor c=0.0205163f //x=15.325 //y=1.74
c807 ( 133 0 ) capacitor c=0.0168481f //x=15.325 //y=1.43
c808 ( 132 0 ) capacitor c=0.0174783f //x=15.325 //y=1.085
c809 ( 127 0 ) capacitor c=0.0245352f //x=6.375 //y=4.97
c810 ( 126 0 ) capacitor c=0.0826403f //x=6.13 //y=2.095
c811 ( 125 0 ) capacitor c=0.0170266f //x=6.13 //y=1.63
c812 ( 124 0 ) capacitor c=0.018609f //x=6.13 //y=1.4
c813 ( 123 0 ) capacitor c=0.0187309f //x=6.13 //y=1.09
c814 ( 117 0 ) capacitor c=0.014725f //x=5.975 //y=1.555
c815 ( 115 0 ) capacitor c=0.0146567f //x=5.975 //y=0.935
c816 ( 114 0 ) capacitor c=0.0335408f //x=5.605 //y=1.4
c817 ( 113 0 ) capacitor c=0.0173761f //x=5.605 //y=1.09
c818 ( 112 0 ) capacitor c=0.15358f //x=64.61 //y=6.2
c819 ( 111 0 ) capacitor c=0.110281f //x=64.17 //y=6.2
c820 ( 110 0 ) capacitor c=0.110114f //x=55.29 //y=6.2
c821 ( 109 0 ) capacitor c=0.11012f //x=54.85 //y=6.2
c822 ( 108 0 ) capacitor c=0.15358f //x=40.19 //y=6.2
c823 ( 107 0 ) capacitor c=0.110281f //x=39.75 //y=6.2
c824 ( 106 0 ) capacitor c=0.110114f //x=30.87 //y=6.2
c825 ( 105 0 ) capacitor c=0.11012f //x=30.43 //y=6.2
c826 ( 104 0 ) capacitor c=0.15358f //x=15.77 //y=6.2
c827 ( 103 0 ) capacitor c=0.110281f //x=15.33 //y=6.2
c828 ( 102 0 ) capacitor c=0.110114f //x=6.45 //y=6.2
c829 ( 101 0 ) capacitor c=0.11012f //x=6.01 //y=6.2
c830 ( 84 0 ) capacitor c=0.0691208f //x=64.13 //y=2.26
c831 ( 82 0 ) capacitor c=0.00369614f //x=64.13 //y=4.715
c832 ( 74 0 ) capacitor c=0.0900341f //x=54.88 //y=2.26
c833 ( 68 0 ) capacitor c=0.0687295f //x=39.71 //y=2.26
c834 ( 66 0 ) capacitor c=0.00369614f //x=39.71 //y=4.715
c835 ( 58 0 ) capacitor c=0.0900341f //x=30.46 //y=2.26
c836 ( 51 0 ) capacitor c=0.0706177f //x=15.29 //y=2.26
c837 ( 49 0 ) capacitor c=0.00369614f //x=15.29 //y=4.715
c838 ( 39 0 ) capacitor c=0.0953538f //x=6.04 //y=2.26
c839 ( 10 0 ) capacitor c=0.00697397f //x=54.995 //y=4.62
c840 ( 9 0 ) capacitor c=0.213217f //x=64.015 //y=4.62
c841 ( 8 0 ) capacitor c=0.00680508f //x=39.825 //y=4.62
c842 ( 7 0 ) capacitor c=0.354845f //x=54.765 //y=4.62
c843 ( 6 0 ) capacitor c=0.00697397f //x=30.575 //y=4.62
c844 ( 5 0 ) capacitor c=0.201328f //x=39.595 //y=4.62
c845 ( 4 0 ) capacitor c=0.00680508f //x=15.405 //y=4.62
c846 ( 3 0 ) capacitor c=0.368123f //x=30.345 //y=4.62
c847 ( 2 0 ) capacitor c=0.0154455f //x=6.155 //y=4.62
c848 ( 1 0 ) capacitor c=0.201328f //x=15.175 //y=4.62
r849 (  293 294 ) resistor r=32.4568 //w=0.214 //l=0.075 //layer=ply \
 //thickness=0.18 //x=64.16 //y=4.97 //x2=64.16 //y2=5.045
r850 (  291 293 ) resistor r=20.271 //w=0.214 //l=0.09 //layer=ply \
 //thickness=0.18 //x=64.16 //y=4.88 //x2=64.16 //y2=4.97
r851 (  287 288 ) resistor r=52.7279 //w=0.214 //l=0.165 //layer=ply \
 //thickness=0.18 //x=64.13 //y=2.26 //x2=64.13 //y2=2.095
r852 (  280 281 ) resistor r=32.4568 //w=0.214 //l=0.075 //layer=ply \
 //thickness=0.18 //x=54.88 //y=4.97 //x2=54.88 //y2=5.045
r853 (  278 280 ) resistor r=20.271 //w=0.214 //l=0.09 //layer=ply \
 //thickness=0.18 //x=54.88 //y=4.88 //x2=54.88 //y2=4.97
r854 (  269 270 ) resistor r=32.4568 //w=0.214 //l=0.075 //layer=ply \
 //thickness=0.18 //x=39.74 //y=4.97 //x2=39.74 //y2=5.045
r855 (  267 269 ) resistor r=20.271 //w=0.214 //l=0.09 //layer=ply \
 //thickness=0.18 //x=39.74 //y=4.88 //x2=39.74 //y2=4.97
r856 (  263 264 ) resistor r=52.7279 //w=0.214 //l=0.165 //layer=ply \
 //thickness=0.18 //x=39.71 //y=2.26 //x2=39.71 //y2=2.095
r857 (  256 257 ) resistor r=32.4568 //w=0.214 //l=0.075 //layer=ply \
 //thickness=0.18 //x=30.46 //y=4.97 //x2=30.46 //y2=5.045
r858 (  254 256 ) resistor r=20.271 //w=0.214 //l=0.09 //layer=ply \
 //thickness=0.18 //x=30.46 //y=4.88 //x2=30.46 //y2=4.97
r859 (  245 246 ) resistor r=32.4568 //w=0.214 //l=0.075 //layer=ply \
 //thickness=0.18 //x=15.32 //y=4.97 //x2=15.32 //y2=5.045
r860 (  243 245 ) resistor r=20.271 //w=0.214 //l=0.09 //layer=ply \
 //thickness=0.18 //x=15.32 //y=4.88 //x2=15.32 //y2=4.97
r861 (  239 240 ) resistor r=52.7279 //w=0.214 //l=0.165 //layer=ply \
 //thickness=0.18 //x=15.29 //y=2.26 //x2=15.29 //y2=2.095
r862 (  232 233 ) resistor r=32.4568 //w=0.214 //l=0.075 //layer=ply \
 //thickness=0.18 //x=6.04 //y=4.97 //x2=6.04 //y2=5.045
r863 (  230 232 ) resistor r=20.271 //w=0.214 //l=0.09 //layer=ply \
 //thickness=0.18 //x=6.04 //y=4.88 //x2=6.04 //y2=4.97
r864 (  226 298 ) resistor r=45.1352 //w=0.168 //l=0.173853 //layer=ply \
 //thickness=0.18 //x=64.695 //y=1.43 //x2=64.655 //y2=1.585
r865 (  225 297 ) resistor r=45.1352 //w=0.168 //l=0.173853 //layer=ply \
 //thickness=0.18 //x=64.695 //y=1.085 //x2=64.655 //y2=0.93
r866 (  225 226 ) resistor r=176.904 //w=0.094 //l=0.345 //layer=ply \
 //thickness=0.18 //x=64.695 //y=1.085 //x2=64.695 //y2=1.43
r867 (  220 296 ) resistor r=10.701 //w=0.21 //l=0.115 //layer=ply \
 //thickness=0.18 //x=64.32 //y=1.585 //x2=64.205 //y2=1.585
r868 (  219 298 ) resistor r=5.52526 //w=0.168 //l=0.115 //layer=ply \
 //thickness=0.18 //x=64.54 //y=1.585 //x2=64.655 //y2=1.585
r869 (  218 295 ) resistor r=5.52526 //w=0.168 //l=0.115 //layer=ply \
 //thickness=0.18 //x=64.32 //y=0.93 //x2=64.205 //y2=0.93
r870 (  217 297 ) resistor r=5.52526 //w=0.168 //l=0.115 //layer=ply \
 //thickness=0.18 //x=64.54 //y=0.93 //x2=64.655 //y2=0.93
r871 (  217 218 ) resistor r=112.809 //w=0.094 //l=0.22 //layer=ply \
 //thickness=0.18 //x=64.54 //y=0.93 //x2=64.32 //y2=0.93
r872 (  216 293 ) resistor r=16.5046 //w=0.27 //l=0.135 //layer=ply \
 //thickness=0.18 //x=64.295 //y=4.97 //x2=64.16 //y2=4.97
r873 (  215 222 ) resistor r=26.9307 //w=0.15 //l=0.106066 //layer=ply \
 //thickness=0.18 //x=64.535 //y=4.97 //x2=64.61 //y2=5.045
r874 (  215 216 ) resistor r=123.064 //w=0.094 //l=0.24 //layer=ply \
 //thickness=0.18 //x=64.535 //y=4.97 //x2=64.295 //y2=4.97
r875 (  210 296 ) resistor r=39.5823 //w=0.21 //l=0.173853 //layer=ply \
 //thickness=0.18 //x=64.165 //y=1.74 //x2=64.205 //y2=1.585
r876 (  210 288 ) resistor r=182.032 //w=0.094 //l=0.355 //layer=ply \
 //thickness=0.18 //x=64.165 //y=1.74 //x2=64.165 //y2=2.095
r877 (  209 296 ) resistor r=39.5823 //w=0.21 //l=0.173853 //layer=ply \
 //thickness=0.18 //x=64.165 //y=1.43 //x2=64.205 //y2=1.585
r878 (  208 295 ) resistor r=45.1352 //w=0.168 //l=0.173853 //layer=ply \
 //thickness=0.18 //x=64.165 //y=1.085 //x2=64.205 //y2=0.93
r879 (  208 209 ) resistor r=176.904 //w=0.094 //l=0.345 //layer=ply \
 //thickness=0.18 //x=64.165 //y=1.085 //x2=64.165 //y2=1.43
r880 (  204 280 ) resistor r=16.5046 //w=0.27 //l=0.135 //layer=ply \
 //thickness=0.18 //x=55.015 //y=4.97 //x2=54.88 //y2=4.97
r881 (  203 205 ) resistor r=26.9307 //w=0.15 //l=0.106066 //layer=ply \
 //thickness=0.18 //x=55.215 //y=4.97 //x2=55.29 //y2=5.045
r882 (  203 204 ) resistor r=102.553 //w=0.094 //l=0.2 //layer=ply \
 //thickness=0.18 //x=55.215 //y=4.97 //x2=55.015 //y2=4.97
r883 (  202 285 ) resistor r=38.6777 //w=0.284 //l=0.198997 //layer=ply \
 //thickness=0.18 //x=54.97 //y=2.095 //x2=54.895 //y2=2.26
r884 (  201 283 ) resistor r=21.2976 //w=0.217 //l=0.0928709 //layer=ply \
 //thickness=0.18 //x=54.97 //y=1.63 //x2=54.93 //y2=1.555
r885 (  201 202 ) resistor r=238.436 //w=0.094 //l=0.465 //layer=ply \
 //thickness=0.18 //x=54.97 //y=1.63 //x2=54.97 //y2=2.095
r886 (  200 283 ) resistor r=39.0671 //w=0.217 //l=0.173853 //layer=ply \
 //thickness=0.18 //x=54.97 //y=1.4 //x2=54.93 //y2=1.555
r887 (  199 282 ) resistor r=45.1352 //w=0.168 //l=0.173853 //layer=ply \
 //thickness=0.18 //x=54.97 //y=1.09 //x2=54.93 //y2=0.935
r888 (  199 200 ) resistor r=158.957 //w=0.094 //l=0.31 //layer=ply \
 //thickness=0.18 //x=54.97 //y=1.09 //x2=54.97 //y2=1.4
r889 (  194 276 ) resistor r=5.52526 //w=0.168 //l=0.115 //layer=ply \
 //thickness=0.18 //x=54.6 //y=1.555 //x2=54.485 //y2=1.555
r890 (  193 283 ) resistor r=11.4558 //w=0.217 //l=0.115 //layer=ply \
 //thickness=0.18 //x=54.815 //y=1.555 //x2=54.93 //y2=1.555
r891 (  192 275 ) resistor r=5.52526 //w=0.168 //l=0.115 //layer=ply \
 //thickness=0.18 //x=54.6 //y=0.935 //x2=54.485 //y2=0.935
r892 (  191 282 ) resistor r=5.52526 //w=0.168 //l=0.115 //layer=ply \
 //thickness=0.18 //x=54.815 //y=0.935 //x2=54.93 //y2=0.935
r893 (  191 192 ) resistor r=110.245 //w=0.094 //l=0.215 //layer=ply \
 //thickness=0.18 //x=54.815 //y=0.935 //x2=54.6 //y2=0.935
r894 (  190 276 ) resistor r=45.1352 //w=0.168 //l=0.173853 //layer=ply \
 //thickness=0.18 //x=54.445 //y=1.4 //x2=54.485 //y2=1.555
r895 (  189 275 ) resistor r=45.1352 //w=0.168 //l=0.173853 //layer=ply \
 //thickness=0.18 //x=54.445 //y=1.09 //x2=54.485 //y2=0.935
r896 (  189 190 ) resistor r=158.957 //w=0.094 //l=0.31 //layer=ply \
 //thickness=0.18 //x=54.445 //y=1.09 //x2=54.445 //y2=1.4
r897 (  188 274 ) resistor r=45.1352 //w=0.168 //l=0.173853 //layer=ply \
 //thickness=0.18 //x=40.275 //y=1.43 //x2=40.235 //y2=1.585
r898 (  187 273 ) resistor r=45.1352 //w=0.168 //l=0.173853 //layer=ply \
 //thickness=0.18 //x=40.275 //y=1.085 //x2=40.235 //y2=0.93
r899 (  187 188 ) resistor r=176.904 //w=0.094 //l=0.345 //layer=ply \
 //thickness=0.18 //x=40.275 //y=1.085 //x2=40.275 //y2=1.43
r900 (  182 272 ) resistor r=10.701 //w=0.21 //l=0.115 //layer=ply \
 //thickness=0.18 //x=39.9 //y=1.585 //x2=39.785 //y2=1.585
r901 (  181 274 ) resistor r=5.52526 //w=0.168 //l=0.115 //layer=ply \
 //thickness=0.18 //x=40.12 //y=1.585 //x2=40.235 //y2=1.585
r902 (  180 271 ) resistor r=5.52526 //w=0.168 //l=0.115 //layer=ply \
 //thickness=0.18 //x=39.9 //y=0.93 //x2=39.785 //y2=0.93
r903 (  179 273 ) resistor r=5.52526 //w=0.168 //l=0.115 //layer=ply \
 //thickness=0.18 //x=40.12 //y=0.93 //x2=40.235 //y2=0.93
r904 (  179 180 ) resistor r=112.809 //w=0.094 //l=0.22 //layer=ply \
 //thickness=0.18 //x=40.12 //y=0.93 //x2=39.9 //y2=0.93
r905 (  178 269 ) resistor r=16.5046 //w=0.27 //l=0.135 //layer=ply \
 //thickness=0.18 //x=39.875 //y=4.97 //x2=39.74 //y2=4.97
r906 (  177 184 ) resistor r=26.9307 //w=0.15 //l=0.106066 //layer=ply \
 //thickness=0.18 //x=40.115 //y=4.97 //x2=40.19 //y2=5.045
r907 (  177 178 ) resistor r=123.064 //w=0.094 //l=0.24 //layer=ply \
 //thickness=0.18 //x=40.115 //y=4.97 //x2=39.875 //y2=4.97
r908 (  172 272 ) resistor r=39.5823 //w=0.21 //l=0.173853 //layer=ply \
 //thickness=0.18 //x=39.745 //y=1.74 //x2=39.785 //y2=1.585
r909 (  172 264 ) resistor r=182.032 //w=0.094 //l=0.355 //layer=ply \
 //thickness=0.18 //x=39.745 //y=1.74 //x2=39.745 //y2=2.095
r910 (  171 272 ) resistor r=39.5823 //w=0.21 //l=0.173853 //layer=ply \
 //thickness=0.18 //x=39.745 //y=1.43 //x2=39.785 //y2=1.585
r911 (  170 271 ) resistor r=45.1352 //w=0.168 //l=0.173853 //layer=ply \
 //thickness=0.18 //x=39.745 //y=1.085 //x2=39.785 //y2=0.93
r912 (  170 171 ) resistor r=176.904 //w=0.094 //l=0.345 //layer=ply \
 //thickness=0.18 //x=39.745 //y=1.085 //x2=39.745 //y2=1.43
r913 (  166 256 ) resistor r=16.5046 //w=0.27 //l=0.135 //layer=ply \
 //thickness=0.18 //x=30.595 //y=4.97 //x2=30.46 //y2=4.97
r914 (  165 167 ) resistor r=26.9307 //w=0.15 //l=0.106066 //layer=ply \
 //thickness=0.18 //x=30.795 //y=4.97 //x2=30.87 //y2=5.045
r915 (  165 166 ) resistor r=102.553 //w=0.094 //l=0.2 //layer=ply \
 //thickness=0.18 //x=30.795 //y=4.97 //x2=30.595 //y2=4.97
r916 (  164 261 ) resistor r=38.6777 //w=0.284 //l=0.198997 //layer=ply \
 //thickness=0.18 //x=30.55 //y=2.095 //x2=30.475 //y2=2.26
r917 (  163 259 ) resistor r=21.2976 //w=0.217 //l=0.0928709 //layer=ply \
 //thickness=0.18 //x=30.55 //y=1.63 //x2=30.51 //y2=1.555
r918 (  163 164 ) resistor r=238.436 //w=0.094 //l=0.465 //layer=ply \
 //thickness=0.18 //x=30.55 //y=1.63 //x2=30.55 //y2=2.095
r919 (  162 259 ) resistor r=39.0671 //w=0.217 //l=0.173853 //layer=ply \
 //thickness=0.18 //x=30.55 //y=1.4 //x2=30.51 //y2=1.555
r920 (  161 258 ) resistor r=45.1352 //w=0.168 //l=0.173853 //layer=ply \
 //thickness=0.18 //x=30.55 //y=1.09 //x2=30.51 //y2=0.935
r921 (  161 162 ) resistor r=158.957 //w=0.094 //l=0.31 //layer=ply \
 //thickness=0.18 //x=30.55 //y=1.09 //x2=30.55 //y2=1.4
r922 (  156 252 ) resistor r=5.52526 //w=0.168 //l=0.115 //layer=ply \
 //thickness=0.18 //x=30.18 //y=1.555 //x2=30.065 //y2=1.555
r923 (  155 259 ) resistor r=11.4558 //w=0.217 //l=0.115 //layer=ply \
 //thickness=0.18 //x=30.395 //y=1.555 //x2=30.51 //y2=1.555
r924 (  154 251 ) resistor r=5.52526 //w=0.168 //l=0.115 //layer=ply \
 //thickness=0.18 //x=30.18 //y=0.935 //x2=30.065 //y2=0.935
r925 (  153 258 ) resistor r=5.52526 //w=0.168 //l=0.115 //layer=ply \
 //thickness=0.18 //x=30.395 //y=0.935 //x2=30.51 //y2=0.935
r926 (  153 154 ) resistor r=110.245 //w=0.094 //l=0.215 //layer=ply \
 //thickness=0.18 //x=30.395 //y=0.935 //x2=30.18 //y2=0.935
r927 (  152 252 ) resistor r=45.1352 //w=0.168 //l=0.173853 //layer=ply \
 //thickness=0.18 //x=30.025 //y=1.4 //x2=30.065 //y2=1.555
r928 (  151 251 ) resistor r=45.1352 //w=0.168 //l=0.173853 //layer=ply \
 //thickness=0.18 //x=30.025 //y=1.09 //x2=30.065 //y2=0.935
r929 (  151 152 ) resistor r=158.957 //w=0.094 //l=0.31 //layer=ply \
 //thickness=0.18 //x=30.025 //y=1.09 //x2=30.025 //y2=1.4
r930 (  150 250 ) resistor r=45.1352 //w=0.168 //l=0.173853 //layer=ply \
 //thickness=0.18 //x=15.855 //y=1.43 //x2=15.815 //y2=1.585
r931 (  149 249 ) resistor r=45.1352 //w=0.168 //l=0.173853 //layer=ply \
 //thickness=0.18 //x=15.855 //y=1.085 //x2=15.815 //y2=0.93
r932 (  149 150 ) resistor r=176.904 //w=0.094 //l=0.345 //layer=ply \
 //thickness=0.18 //x=15.855 //y=1.085 //x2=15.855 //y2=1.43
r933 (  144 248 ) resistor r=10.701 //w=0.21 //l=0.115 //layer=ply \
 //thickness=0.18 //x=15.48 //y=1.585 //x2=15.365 //y2=1.585
r934 (  143 250 ) resistor r=5.52526 //w=0.168 //l=0.115 //layer=ply \
 //thickness=0.18 //x=15.7 //y=1.585 //x2=15.815 //y2=1.585
r935 (  142 247 ) resistor r=5.52526 //w=0.168 //l=0.115 //layer=ply \
 //thickness=0.18 //x=15.48 //y=0.93 //x2=15.365 //y2=0.93
r936 (  141 249 ) resistor r=5.52526 //w=0.168 //l=0.115 //layer=ply \
 //thickness=0.18 //x=15.7 //y=0.93 //x2=15.815 //y2=0.93
r937 (  141 142 ) resistor r=112.809 //w=0.094 //l=0.22 //layer=ply \
 //thickness=0.18 //x=15.7 //y=0.93 //x2=15.48 //y2=0.93
r938 (  140 245 ) resistor r=16.5046 //w=0.27 //l=0.135 //layer=ply \
 //thickness=0.18 //x=15.455 //y=4.97 //x2=15.32 //y2=4.97
r939 (  139 146 ) resistor r=26.9307 //w=0.15 //l=0.106066 //layer=ply \
 //thickness=0.18 //x=15.695 //y=4.97 //x2=15.77 //y2=5.045
r940 (  139 140 ) resistor r=123.064 //w=0.094 //l=0.24 //layer=ply \
 //thickness=0.18 //x=15.695 //y=4.97 //x2=15.455 //y2=4.97
r941 (  134 248 ) resistor r=39.5823 //w=0.21 //l=0.173853 //layer=ply \
 //thickness=0.18 //x=15.325 //y=1.74 //x2=15.365 //y2=1.585
r942 (  134 240 ) resistor r=182.032 //w=0.094 //l=0.355 //layer=ply \
 //thickness=0.18 //x=15.325 //y=1.74 //x2=15.325 //y2=2.095
r943 (  133 248 ) resistor r=39.5823 //w=0.21 //l=0.173853 //layer=ply \
 //thickness=0.18 //x=15.325 //y=1.43 //x2=15.365 //y2=1.585
r944 (  132 247 ) resistor r=45.1352 //w=0.168 //l=0.173853 //layer=ply \
 //thickness=0.18 //x=15.325 //y=1.085 //x2=15.365 //y2=0.93
r945 (  132 133 ) resistor r=176.904 //w=0.094 //l=0.345 //layer=ply \
 //thickness=0.18 //x=15.325 //y=1.085 //x2=15.325 //y2=1.43
r946 (  128 232 ) resistor r=16.5046 //w=0.27 //l=0.135 //layer=ply \
 //thickness=0.18 //x=6.175 //y=4.97 //x2=6.04 //y2=4.97
r947 (  127 129 ) resistor r=26.9307 //w=0.15 //l=0.106066 //layer=ply \
 //thickness=0.18 //x=6.375 //y=4.97 //x2=6.45 //y2=5.045
r948 (  127 128 ) resistor r=102.553 //w=0.094 //l=0.2 //layer=ply \
 //thickness=0.18 //x=6.375 //y=4.97 //x2=6.175 //y2=4.97
r949 (  126 237 ) resistor r=38.6777 //w=0.284 //l=0.198997 //layer=ply \
 //thickness=0.18 //x=6.13 //y=2.095 //x2=6.055 //y2=2.26
r950 (  125 235 ) resistor r=21.2976 //w=0.217 //l=0.0928709 //layer=ply \
 //thickness=0.18 //x=6.13 //y=1.63 //x2=6.09 //y2=1.555
r951 (  125 126 ) resistor r=238.436 //w=0.094 //l=0.465 //layer=ply \
 //thickness=0.18 //x=6.13 //y=1.63 //x2=6.13 //y2=2.095
r952 (  124 235 ) resistor r=39.0671 //w=0.217 //l=0.173853 //layer=ply \
 //thickness=0.18 //x=6.13 //y=1.4 //x2=6.09 //y2=1.555
r953 (  123 234 ) resistor r=45.1352 //w=0.168 //l=0.173853 //layer=ply \
 //thickness=0.18 //x=6.13 //y=1.09 //x2=6.09 //y2=0.935
r954 (  123 124 ) resistor r=158.957 //w=0.094 //l=0.31 //layer=ply \
 //thickness=0.18 //x=6.13 //y=1.09 //x2=6.13 //y2=1.4
r955 (  118 228 ) resistor r=5.52526 //w=0.168 //l=0.115 //layer=ply \
 //thickness=0.18 //x=5.76 //y=1.555 //x2=5.645 //y2=1.555
r956 (  117 235 ) resistor r=11.4558 //w=0.217 //l=0.115 //layer=ply \
 //thickness=0.18 //x=5.975 //y=1.555 //x2=6.09 //y2=1.555
r957 (  116 227 ) resistor r=5.52526 //w=0.168 //l=0.115 //layer=ply \
 //thickness=0.18 //x=5.76 //y=0.935 //x2=5.645 //y2=0.935
r958 (  115 234 ) resistor r=5.52526 //w=0.168 //l=0.115 //layer=ply \
 //thickness=0.18 //x=5.975 //y=0.935 //x2=6.09 //y2=0.935
r959 (  115 116 ) resistor r=110.245 //w=0.094 //l=0.215 //layer=ply \
 //thickness=0.18 //x=5.975 //y=0.935 //x2=5.76 //y2=0.935
r960 (  114 228 ) resistor r=45.1352 //w=0.168 //l=0.173853 //layer=ply \
 //thickness=0.18 //x=5.605 //y=1.4 //x2=5.645 //y2=1.555
r961 (  113 227 ) resistor r=45.1352 //w=0.168 //l=0.173853 //layer=ply \
 //thickness=0.18 //x=5.605 //y=1.09 //x2=5.645 //y2=0.935
r962 (  113 114 ) resistor r=158.957 //w=0.094 //l=0.31 //layer=ply \
 //thickness=0.18 //x=5.605 //y=1.09 //x2=5.605 //y2=1.4
r963 (  112 222 ) resistor r=592.245 //w=0.094 //l=1.155 //layer=ply \
 //thickness=0.18 //x=64.61 //y=6.2 //x2=64.61 //y2=5.045
r964 (  111 294 ) resistor r=592.245 //w=0.094 //l=1.155 //layer=ply \
 //thickness=0.18 //x=64.17 //y=6.2 //x2=64.17 //y2=5.045
r965 (  110 205 ) resistor r=592.245 //w=0.094 //l=1.155 //layer=ply \
 //thickness=0.18 //x=55.29 //y=6.2 //x2=55.29 //y2=5.045
r966 (  109 281 ) resistor r=592.245 //w=0.094 //l=1.155 //layer=ply \
 //thickness=0.18 //x=54.85 //y=6.2 //x2=54.85 //y2=5.045
r967 (  108 184 ) resistor r=592.245 //w=0.094 //l=1.155 //layer=ply \
 //thickness=0.18 //x=40.19 //y=6.2 //x2=40.19 //y2=5.045
r968 (  107 270 ) resistor r=592.245 //w=0.094 //l=1.155 //layer=ply \
 //thickness=0.18 //x=39.75 //y=6.2 //x2=39.75 //y2=5.045
r969 (  106 167 ) resistor r=592.245 //w=0.094 //l=1.155 //layer=ply \
 //thickness=0.18 //x=30.87 //y=6.2 //x2=30.87 //y2=5.045
r970 (  105 257 ) resistor r=592.245 //w=0.094 //l=1.155 //layer=ply \
 //thickness=0.18 //x=30.43 //y=6.2 //x2=30.43 //y2=5.045
r971 (  104 146 ) resistor r=592.245 //w=0.094 //l=1.155 //layer=ply \
 //thickness=0.18 //x=15.77 //y=6.2 //x2=15.77 //y2=5.045
r972 (  103 246 ) resistor r=592.245 //w=0.094 //l=1.155 //layer=ply \
 //thickness=0.18 //x=15.33 //y=6.2 //x2=15.33 //y2=5.045
r973 (  102 129 ) resistor r=592.245 //w=0.094 //l=1.155 //layer=ply \
 //thickness=0.18 //x=6.45 //y=6.2 //x2=6.45 //y2=5.045
r974 (  101 233 ) resistor r=592.245 //w=0.094 //l=1.155 //layer=ply \
 //thickness=0.18 //x=6.01 //y=6.2 //x2=6.01 //y2=5.045
r975 (  100 219 ) resistor r=56.4043 //w=0.094 //l=0.11 //layer=ply \
 //thickness=0.18 //x=64.43 //y=1.585 //x2=64.54 //y2=1.585
r976 (  100 220 ) resistor r=56.4043 //w=0.094 //l=0.11 //layer=ply \
 //thickness=0.18 //x=64.43 //y=1.585 //x2=64.32 //y2=1.585
r977 (  99 193 ) resistor r=55.3787 //w=0.094 //l=0.108 //layer=ply \
 //thickness=0.18 //x=54.707 //y=1.555 //x2=54.815 //y2=1.555
r978 (  99 194 ) resistor r=54.866 //w=0.094 //l=0.107 //layer=ply \
 //thickness=0.18 //x=54.707 //y=1.555 //x2=54.6 //y2=1.555
r979 (  98 181 ) resistor r=56.4043 //w=0.094 //l=0.11 //layer=ply \
 //thickness=0.18 //x=40.01 //y=1.585 //x2=40.12 //y2=1.585
r980 (  98 182 ) resistor r=56.4043 //w=0.094 //l=0.11 //layer=ply \
 //thickness=0.18 //x=40.01 //y=1.585 //x2=39.9 //y2=1.585
r981 (  97 155 ) resistor r=55.3787 //w=0.094 //l=0.108 //layer=ply \
 //thickness=0.18 //x=30.287 //y=1.555 //x2=30.395 //y2=1.555
r982 (  97 156 ) resistor r=54.866 //w=0.094 //l=0.107 //layer=ply \
 //thickness=0.18 //x=30.287 //y=1.555 //x2=30.18 //y2=1.555
r983 (  96 143 ) resistor r=56.4043 //w=0.094 //l=0.11 //layer=ply \
 //thickness=0.18 //x=15.59 //y=1.585 //x2=15.7 //y2=1.585
r984 (  96 144 ) resistor r=56.4043 //w=0.094 //l=0.11 //layer=ply \
 //thickness=0.18 //x=15.59 //y=1.585 //x2=15.48 //y2=1.585
r985 (  95 117 ) resistor r=55.3787 //w=0.094 //l=0.108 //layer=ply \
 //thickness=0.18 //x=5.867 //y=1.555 //x2=5.975 //y2=1.555
r986 (  95 118 ) resistor r=54.866 //w=0.094 //l=0.107 //layer=ply \
 //thickness=0.18 //x=5.867 //y=1.555 //x2=5.76 //y2=1.555
r987 (  94 291 ) resistor r=152 //w=0.17 //l=0.17 //layer=licon //count=1 \
 //x=64.16 //y=4.88 //x2=64.16 //y2=4.88
r988 (  92 267 ) resistor r=152 //w=0.17 //l=0.17 //layer=licon //count=1 \
 //x=39.74 //y=4.88 //x2=39.74 //y2=4.88
r989 (  90 243 ) resistor r=152 //w=0.17 //l=0.17 //layer=licon //count=1 \
 //x=15.32 //y=4.88 //x2=15.32 //y2=4.88
r990 (  84 287 ) resistor r=152 //w=0.17 //l=0.17 //layer=licon //count=1 \
 //x=64.13 //y=2.26 //x2=64.13 //y2=2.26
r991 (  82 94 ) resistor r=11.4737 //w=0.186 //l=0.172337 //layer=li \
 //thickness=0.1 //x=64.13 //y=4.715 //x2=64.145 //y2=4.88
r992 (  80 278 ) resistor r=152 //w=0.17 //l=0.17 //layer=licon //count=1 \
 //x=54.88 //y=4.88 //x2=54.88 //y2=4.88
r993 (  74 285 ) resistor r=152 //w=0.17 //l=0.17 //layer=licon //count=1 \
 //x=54.88 //y=2.26 //x2=54.88 //y2=2.26
r994 (  68 263 ) resistor r=152 //w=0.17 //l=0.17 //layer=licon //count=1 \
 //x=39.71 //y=2.26 //x2=39.71 //y2=2.26
r995 (  66 92 ) resistor r=11.4737 //w=0.186 //l=0.172337 //layer=li \
 //thickness=0.1 //x=39.71 //y=4.715 //x2=39.725 //y2=4.88
r996 (  64 254 ) resistor r=152 //w=0.17 //l=0.17 //layer=licon //count=1 \
 //x=30.46 //y=4.88 //x2=30.46 //y2=4.88
r997 (  58 261 ) resistor r=152 //w=0.17 //l=0.17 //layer=licon //count=1 \
 //x=30.46 //y=2.26 //x2=30.46 //y2=2.26
r998 (  51 239 ) resistor r=152 //w=0.17 //l=0.17 //layer=licon //count=1 \
 //x=15.29 //y=2.26 //x2=15.29 //y2=2.26
r999 (  49 90 ) resistor r=11.4737 //w=0.186 //l=0.172337 //layer=li \
 //thickness=0.1 //x=15.29 //y=4.715 //x2=15.305 //y2=4.88
r1000 (  47 230 ) resistor r=152 //w=0.17 //l=0.17 //layer=licon //count=1 \
 //x=6.04 //y=4.88 //x2=6.04 //y2=4.88
r1001 (  39 237 ) resistor r=152 //w=0.17 //l=0.17 //layer=licon //count=1 \
 //x=6.04 //y=2.26 //x2=6.04 //y2=2.26
r1002 (  37 82 ) resistor r=6.50267 //w=0.187 //l=0.095 //layer=li \
 //thickness=0.1 //x=64.13 //y=4.62 //x2=64.13 //y2=4.715
r1003 (  36 37 ) resistor r=126.631 //w=0.187 //l=1.85 //layer=li \
 //thickness=0.1 //x=64.13 //y=2.77 //x2=64.13 //y2=4.62
r1004 (  36 84 ) resistor r=34.9091 //w=0.187 //l=0.51 //layer=li \
 //thickness=0.1 //x=64.13 //y=2.77 //x2=64.13 //y2=2.26
r1005 (  35 80 ) resistor r=17.7968 //w=0.187 //l=0.26 //layer=li \
 //thickness=0.1 //x=54.88 //y=4.62 //x2=54.88 //y2=4.88
r1006 (  34 35 ) resistor r=50.6524 //w=0.187 //l=0.74 //layer=li \
 //thickness=0.1 //x=54.88 //y=3.88 //x2=54.88 //y2=4.62
r1007 (  34 74 ) resistor r=110.888 //w=0.187 //l=1.62 //layer=li \
 //thickness=0.1 //x=54.88 //y=3.88 //x2=54.88 //y2=2.26
r1008 (  33 66 ) resistor r=6.50267 //w=0.187 //l=0.095 //layer=li \
 //thickness=0.1 //x=39.71 //y=4.62 //x2=39.71 //y2=4.715
r1009 (  32 33 ) resistor r=126.631 //w=0.187 //l=1.85 //layer=li \
 //thickness=0.1 //x=39.71 //y=2.77 //x2=39.71 //y2=4.62
r1010 (  32 68 ) resistor r=34.9091 //w=0.187 //l=0.51 //layer=li \
 //thickness=0.1 //x=39.71 //y=2.77 //x2=39.71 //y2=2.26
r1011 (  31 64 ) resistor r=17.7968 //w=0.187 //l=0.26 //layer=li \
 //thickness=0.1 //x=30.46 //y=4.62 //x2=30.46 //y2=4.88
r1012 (  30 31 ) resistor r=50.6524 //w=0.187 //l=0.74 //layer=li \
 //thickness=0.1 //x=30.46 //y=3.88 //x2=30.46 //y2=4.62
r1013 (  30 58 ) resistor r=110.888 //w=0.187 //l=1.62 //layer=li \
 //thickness=0.1 //x=30.46 //y=3.88 //x2=30.46 //y2=2.26
r1014 (  29 49 ) resistor r=6.50267 //w=0.187 //l=0.095 //layer=li \
 //thickness=0.1 //x=15.29 //y=4.62 //x2=15.29 //y2=4.715
r1015 (  28 29 ) resistor r=75.9786 //w=0.187 //l=1.11 //layer=li \
 //thickness=0.1 //x=15.29 //y=3.51 //x2=15.29 //y2=4.62
r1016 (  27 28 ) resistor r=50.6524 //w=0.187 //l=0.74 //layer=li \
 //thickness=0.1 //x=15.29 //y=2.77 //x2=15.29 //y2=3.51
r1017 (  27 51 ) resistor r=34.9091 //w=0.187 //l=0.51 //layer=li \
 //thickness=0.1 //x=15.29 //y=2.77 //x2=15.29 //y2=2.26
r1018 (  26 47 ) resistor r=17.7968 //w=0.187 //l=0.26 //layer=li \
 //thickness=0.1 //x=6.04 //y=4.62 //x2=6.04 //y2=4.88
r1019 (  25 26 ) resistor r=50.6524 //w=0.187 //l=0.74 //layer=li \
 //thickness=0.1 //x=6.04 //y=3.88 //x2=6.04 //y2=4.62
r1020 (  24 25 ) resistor r=25.3262 //w=0.187 //l=0.37 //layer=li \
 //thickness=0.1 //x=6.04 //y=3.51 //x2=6.04 //y2=3.88
r1021 (  23 24 ) resistor r=75.9786 //w=0.187 //l=1.11 //layer=li \
 //thickness=0.1 //x=6.04 //y=2.4 //x2=6.04 //y2=3.51
r1022 (  23 39 ) resistor r=9.58289 //w=0.187 //l=0.14 //layer=li \
 //thickness=0.1 //x=6.04 //y=2.4 //x2=6.04 //y2=2.26
r1023 (  22 37 ) resistor r=9.3 //w=0.17 //l=0.17 //layer=mcon //count=1 \
 //x=64.13 //y=4.62 //x2=64.13 //y2=4.62
r1024 (  20 35 ) resistor r=9.3 //w=0.17 //l=0.17 //layer=mcon //count=1 \
 //x=54.88 //y=4.62 //x2=54.88 //y2=4.62
r1025 (  18 33 ) resistor r=9.3 //w=0.17 //l=0.17 //layer=mcon //count=1 \
 //x=39.71 //y=4.62 //x2=39.71 //y2=4.62
r1026 (  16 31 ) resistor r=9.3 //w=0.17 //l=0.17 //layer=mcon //count=1 \
 //x=30.46 //y=4.62 //x2=30.46 //y2=4.62
r1027 (  14 29 ) resistor r=9.3 //w=0.17 //l=0.17 //layer=mcon //count=1 \
 //x=15.29 //y=4.62 //x2=15.29 //y2=4.62
r1028 (  12 26 ) resistor r=9.3 //w=0.17 //l=0.17 //layer=mcon //count=1 \
 //x=6.04 //y=4.62 //x2=6.04 //y2=4.62
r1029 (  10 20 ) resistor r=0.0880901 //w=0.191 //l=0.115 //layer=m1 \
 //thickness=0.36 //x=54.995 //y=4.62 //x2=54.88 //y2=4.62
r1030 (  9 22 ) resistor r=0.0717383 //w=0.224 //l=0.115 //layer=m1 \
 //thickness=0.36 //x=64.015 //y=4.62 //x2=64.13 //y2=4.62
r1031 (  9 10 ) resistor r=8.60687 //w=0.131 //l=9.02 //layer=m1 \
 //thickness=0.36 //x=64.015 //y=4.62 //x2=54.995 //y2=4.62
r1032 (  8 18 ) resistor r=0.0880901 //w=0.191 //l=0.115 //layer=m1 \
 //thickness=0.36 //x=39.825 //y=4.62 //x2=39.71 //y2=4.62
r1033 (  7 20 ) resistor r=0.0880901 //w=0.191 //l=0.115 //layer=m1 \
 //thickness=0.36 //x=54.765 //y=4.62 //x2=54.88 //y2=4.62
r1034 (  7 8 ) resistor r=14.2557 //w=0.131 //l=14.94 //layer=m1 \
 //thickness=0.36 //x=54.765 //y=4.62 //x2=39.825 //y2=4.62
r1035 (  6 16 ) resistor r=0.0880901 //w=0.191 //l=0.115 //layer=m1 \
 //thickness=0.36 //x=30.575 //y=4.62 //x2=30.46 //y2=4.62
r1036 (  5 18 ) resistor r=0.0880901 //w=0.191 //l=0.115 //layer=m1 \
 //thickness=0.36 //x=39.595 //y=4.62 //x2=39.71 //y2=4.62
r1037 (  5 6 ) resistor r=8.60687 //w=0.131 //l=9.02 //layer=m1 \
 //thickness=0.36 //x=39.595 //y=4.62 //x2=30.575 //y2=4.62
r1038 (  4 14 ) resistor r=0.0880901 //w=0.191 //l=0.115 //layer=m1 \
 //thickness=0.36 //x=15.405 //y=4.62 //x2=15.29 //y2=4.62
r1039 (  3 16 ) resistor r=0.0880901 //w=0.191 //l=0.115 //layer=m1 \
 //thickness=0.36 //x=30.345 //y=4.62 //x2=30.46 //y2=4.62
r1040 (  3 4 ) resistor r=14.2557 //w=0.131 //l=14.94 //layer=m1 \
 //thickness=0.36 //x=30.345 //y=4.62 //x2=15.405 //y2=4.62
r1041 (  2 12 ) resistor r=0.0717383 //w=0.224 //l=0.115 //layer=m1 \
 //thickness=0.36 //x=6.155 //y=4.62 //x2=6.04 //y2=4.62
r1042 (  1 14 ) resistor r=0.0880901 //w=0.191 //l=0.115 //layer=m1 \
 //thickness=0.36 //x=15.175 //y=4.62 //x2=15.29 //y2=4.62
r1043 (  1 2 ) resistor r=8.60687 //w=0.131 //l=9.02 //layer=m1 \
 //thickness=0.36 //x=15.175 //y=4.62 //x2=6.155 //y2=4.62
ends PM_TMRDFFSNQX1\%CLK

subckt PM_TMRDFFSNQX1\%noxref_18 ( 1 2 3 4 11 13 23 24 31 39 45 46 50 52 61 62 \
 64 65 67 68 69 70 71 72 73 74 75 80 82 84 90 91 92 93 94 95 99 101 104 105 \
 110 111 114 128 131 133 134 135 )
c291 ( 135 0 ) capacitor c=0.023087f //x=55.805 //y=5.2
c292 ( 134 0 ) capacitor c=0.023519f //x=54.925 //y=5.2
c293 ( 133 0 ) capacitor c=0.0224735f //x=54.045 //y=5.2
c294 ( 131 0 ) capacitor c=0.00853354f //x=56.055 //y=1.095
c295 ( 128 0 ) capacitor c=0.0597793f //x=66.72 //y=4.88
c296 ( 114 0 ) capacitor c=0.0331095f //x=51.21 //y=4.88
c297 ( 111 0 ) capacitor c=0.0279499f //x=51.18 //y=2.095
c298 ( 110 0 ) capacitor c=0.0421676f //x=51.18 //y=2.26
c299 ( 105 0 ) capacitor c=0.0318948f //x=67.055 //y=1.39
c300 ( 104 0 ) capacitor c=0.0187384f //x=67.055 //y=1.045
c301 ( 101 0 ) capacitor c=0.0141798f //x=66.9 //y=1.545
c302 ( 99 0 ) capacitor c=0.0149844f //x=66.9 //y=0.89
c303 ( 95 0 ) capacitor c=0.0813322f //x=66.525 //y=2.095
c304 ( 94 0 ) capacitor c=0.0229267f //x=66.525 //y=1.7
c305 ( 93 0 ) capacitor c=0.0234352f //x=66.525 //y=1.39
c306 ( 92 0 ) capacitor c=0.0199343f //x=66.525 //y=1.045
c307 ( 91 0 ) capacitor c=0.0429696f //x=51.745 //y=1.43
c308 ( 90 0 ) capacitor c=0.0192208f //x=51.745 //y=1.085
c309 ( 84 0 ) capacitor c=0.0148884f //x=51.59 //y=1.585
c310 ( 82 0 ) capacitor c=0.0157803f //x=51.59 //y=0.93
c311 ( 80 0 ) capacitor c=0.0295235f //x=51.585 //y=4.97
c312 ( 75 0 ) capacitor c=0.0205163f //x=51.215 //y=1.74
c313 ( 74 0 ) capacitor c=0.0168481f //x=51.215 //y=1.43
c314 ( 73 0 ) capacitor c=0.0174783f //x=51.215 //y=1.085
c315 ( 72 0 ) capacitor c=0.110141f //x=67.06 //y=6.2
c316 ( 71 0 ) capacitor c=0.154305f //x=66.62 //y=6.2
c317 ( 70 0 ) capacitor c=0.15358f //x=51.66 //y=6.2
c318 ( 69 0 ) capacitor c=0.110281f //x=51.22 //y=6.2
c319 ( 65 0 ) capacitor c=0.0715637f //x=56.727 //y=4.085
c320 ( 64 0 ) capacitor c=0.0101843f //x=56.725 //y=4.25
c321 ( 62 0 ) capacitor c=0.00106608f //x=55.95 //y=5.335
c322 ( 61 0 ) capacitor c=0.00207162f //x=55.07 //y=5.335
c323 ( 52 0 ) capacitor c=0.0873188f //x=66.72 //y=2.26
c324 ( 50 0 ) capacitor c=0.0236247f //x=56.73 //y=5.25
c325 ( 46 0 ) capacitor c=0.00398962f //x=56.33 //y=1.845
c326 ( 45 0 ) capacitor c=0.0135805f //x=56.645 //y=1.845
c327 ( 39 0 ) capacitor c=0.0281378f //x=56.645 //y=5.335
c328 ( 31 0 ) capacitor c=0.0176454f //x=55.865 //y=5.335
c329 ( 24 0 ) capacitor c=0.00332903f //x=54.275 //y=5.335
c330 ( 23 0 ) capacitor c=0.014837f //x=54.985 //y=5.335
c331 ( 13 0 ) capacitor c=0.0676912f //x=51.18 //y=2.26
c332 ( 11 0 ) capacitor c=0.00453889f //x=51.18 //y=4.715
c333 ( 4 0 ) capacitor c=0.00551102f //x=56.84 //y=4.25
c334 ( 3 0 ) capacitor c=0.180782f //x=66.605 //y=4.25
c335 ( 2 0 ) capacitor c=0.0100678f //x=51.295 //y=4.25
c336 ( 1 0 ) capacitor c=0.0882171f //x=56.61 //y=4.25
r337 (  126 128 ) resistor r=20.6867 //w=0.233 //l=0.1 //layer=ply \
 //thickness=0.18 //x=66.62 //y=4.88 //x2=66.72 //y2=4.88
r338 (  116 117 ) resistor r=32.4568 //w=0.214 //l=0.075 //layer=ply \
 //thickness=0.18 //x=51.21 //y=4.97 //x2=51.21 //y2=5.045
r339 (  114 116 ) resistor r=20.271 //w=0.214 //l=0.09 //layer=ply \
 //thickness=0.18 //x=51.21 //y=4.88 //x2=51.21 //y2=4.97
r340 (  110 111 ) resistor r=52.7279 //w=0.214 //l=0.165 //layer=ply \
 //thickness=0.18 //x=51.18 //y=2.26 //x2=51.18 //y2=2.095
r341 (  106 128 ) resistor r=70.3348 //w=0.233 //l=0.414367 //layer=ply \
 //thickness=0.18 //x=67.06 //y=5.045 //x2=66.72 //y2=4.88
r342 (  105 130 ) resistor r=45.1352 //w=0.168 //l=0.173853 //layer=ply \
 //thickness=0.18 //x=67.055 //y=1.39 //x2=67.015 //y2=1.545
r343 (  104 129 ) resistor r=45.1352 //w=0.168 //l=0.173853 //layer=ply \
 //thickness=0.18 //x=67.055 //y=1.045 //x2=67.015 //y2=0.89
r344 (  104 105 ) resistor r=176.904 //w=0.094 //l=0.345 //layer=ply \
 //thickness=0.18 //x=67.055 //y=1.045 //x2=67.055 //y2=1.39
r345 (  102 125 ) resistor r=10.701 //w=0.21 //l=0.115 //layer=ply \
 //thickness=0.18 //x=66.68 //y=1.545 //x2=66.565 //y2=1.545
r346 (  101 130 ) resistor r=5.52526 //w=0.168 //l=0.115 //layer=ply \
 //thickness=0.18 //x=66.9 //y=1.545 //x2=67.015 //y2=1.545
r347 (  100 124 ) resistor r=5.52526 //w=0.168 //l=0.115 //layer=ply \
 //thickness=0.18 //x=66.68 //y=0.89 //x2=66.565 //y2=0.89
r348 (  99 129 ) resistor r=5.52526 //w=0.168 //l=0.115 //layer=ply \
 //thickness=0.18 //x=66.9 //y=0.89 //x2=67.015 //y2=0.89
r349 (  99 100 ) resistor r=112.809 //w=0.094 //l=0.22 //layer=ply \
 //thickness=0.18 //x=66.9 //y=0.89 //x2=66.68 //y2=0.89
r350 (  96 126 ) resistor r=13.0941 //w=0.233 //l=0.165 //layer=ply \
 //thickness=0.18 //x=66.62 //y=5.045 //x2=66.62 //y2=4.88
r351 (  95 123 ) resistor r=34.8111 //w=0.27 //l=0.264953 //layer=ply \
 //thickness=0.18 //x=66.525 //y=2.095 //x2=66.72 //y2=2.26
r352 (  94 125 ) resistor r=39.5823 //w=0.21 //l=0.173853 //layer=ply \
 //thickness=0.18 //x=66.525 //y=1.7 //x2=66.565 //y2=1.545
r353 (  94 95 ) resistor r=202.543 //w=0.094 //l=0.395 //layer=ply \
 //thickness=0.18 //x=66.525 //y=1.7 //x2=66.525 //y2=2.095
r354 (  93 125 ) resistor r=39.5823 //w=0.21 //l=0.173853 //layer=ply \
 //thickness=0.18 //x=66.525 //y=1.39 //x2=66.565 //y2=1.545
r355 (  92 124 ) resistor r=45.1352 //w=0.168 //l=0.173853 //layer=ply \
 //thickness=0.18 //x=66.525 //y=1.045 //x2=66.565 //y2=0.89
r356 (  92 93 ) resistor r=176.904 //w=0.094 //l=0.345 //layer=ply \
 //thickness=0.18 //x=66.525 //y=1.045 //x2=66.525 //y2=1.39
r357 (  91 121 ) resistor r=45.1352 //w=0.168 //l=0.173853 //layer=ply \
 //thickness=0.18 //x=51.745 //y=1.43 //x2=51.705 //y2=1.585
r358 (  90 120 ) resistor r=45.1352 //w=0.168 //l=0.173853 //layer=ply \
 //thickness=0.18 //x=51.745 //y=1.085 //x2=51.705 //y2=0.93
r359 (  90 91 ) resistor r=176.904 //w=0.094 //l=0.345 //layer=ply \
 //thickness=0.18 //x=51.745 //y=1.085 //x2=51.745 //y2=1.43
r360 (  85 119 ) resistor r=10.701 //w=0.21 //l=0.115 //layer=ply \
 //thickness=0.18 //x=51.37 //y=1.585 //x2=51.255 //y2=1.585
r361 (  84 121 ) resistor r=5.52526 //w=0.168 //l=0.115 //layer=ply \
 //thickness=0.18 //x=51.59 //y=1.585 //x2=51.705 //y2=1.585
r362 (  83 118 ) resistor r=5.52526 //w=0.168 //l=0.115 //layer=ply \
 //thickness=0.18 //x=51.37 //y=0.93 //x2=51.255 //y2=0.93
r363 (  82 120 ) resistor r=5.52526 //w=0.168 //l=0.115 //layer=ply \
 //thickness=0.18 //x=51.59 //y=0.93 //x2=51.705 //y2=0.93
r364 (  82 83 ) resistor r=112.809 //w=0.094 //l=0.22 //layer=ply \
 //thickness=0.18 //x=51.59 //y=0.93 //x2=51.37 //y2=0.93
r365 (  81 116 ) resistor r=16.5046 //w=0.27 //l=0.135 //layer=ply \
 //thickness=0.18 //x=51.345 //y=4.97 //x2=51.21 //y2=4.97
r366 (  80 87 ) resistor r=26.9307 //w=0.15 //l=0.106066 //layer=ply \
 //thickness=0.18 //x=51.585 //y=4.97 //x2=51.66 //y2=5.045
r367 (  80 81 ) resistor r=123.064 //w=0.094 //l=0.24 //layer=ply \
 //thickness=0.18 //x=51.585 //y=4.97 //x2=51.345 //y2=4.97
r368 (  75 119 ) resistor r=39.5823 //w=0.21 //l=0.173853 //layer=ply \
 //thickness=0.18 //x=51.215 //y=1.74 //x2=51.255 //y2=1.585
r369 (  75 111 ) resistor r=182.032 //w=0.094 //l=0.355 //layer=ply \
 //thickness=0.18 //x=51.215 //y=1.74 //x2=51.215 //y2=2.095
r370 (  74 119 ) resistor r=39.5823 //w=0.21 //l=0.173853 //layer=ply \
 //thickness=0.18 //x=51.215 //y=1.43 //x2=51.255 //y2=1.585
r371 (  73 118 ) resistor r=45.1352 //w=0.168 //l=0.173853 //layer=ply \
 //thickness=0.18 //x=51.215 //y=1.085 //x2=51.255 //y2=0.93
r372 (  73 74 ) resistor r=176.904 //w=0.094 //l=0.345 //layer=ply \
 //thickness=0.18 //x=51.215 //y=1.085 //x2=51.215 //y2=1.43
r373 (  72 106 ) resistor r=592.245 //w=0.094 //l=1.155 //layer=ply \
 //thickness=0.18 //x=67.06 //y=6.2 //x2=67.06 //y2=5.045
r374 (  71 96 ) resistor r=592.245 //w=0.094 //l=1.155 //layer=ply \
 //thickness=0.18 //x=66.62 //y=6.2 //x2=66.62 //y2=5.045
r375 (  70 87 ) resistor r=592.245 //w=0.094 //l=1.155 //layer=ply \
 //thickness=0.18 //x=51.66 //y=6.2 //x2=51.66 //y2=5.045
r376 (  69 117 ) resistor r=592.245 //w=0.094 //l=1.155 //layer=ply \
 //thickness=0.18 //x=51.22 //y=6.2 //x2=51.22 //y2=5.045
r377 (  68 101 ) resistor r=56.4043 //w=0.094 //l=0.11 //layer=ply \
 //thickness=0.18 //x=66.79 //y=1.545 //x2=66.9 //y2=1.545
r378 (  68 102 ) resistor r=56.4043 //w=0.094 //l=0.11 //layer=ply \
 //thickness=0.18 //x=66.79 //y=1.545 //x2=66.68 //y2=1.545
r379 (  67 84 ) resistor r=56.4043 //w=0.094 //l=0.11 //layer=ply \
 //thickness=0.18 //x=51.48 //y=1.585 //x2=51.59 //y2=1.585
r380 (  67 85 ) resistor r=56.4043 //w=0.094 //l=0.11 //layer=ply \
 //thickness=0.18 //x=51.48 //y=1.585 //x2=51.37 //y2=1.585
r381 (  64 66 ) resistor r=11 //w=0.192 //l=0.165 //layer=li //thickness=0.1 \
 //x=56.727 //y=4.25 //x2=56.727 //y2=4.415
r382 (  64 65 ) resistor r=11 //w=0.192 //l=0.165 //layer=li //thickness=0.1 \
 //x=56.727 //y=4.25 //x2=56.727 //y2=4.085
r383 (  60 114 ) resistor r=152 //w=0.17 //l=0.17 //layer=licon //count=1 \
 //x=51.21 //y=4.88 //x2=51.21 //y2=4.88
r384 (  57 128 ) resistor r=152 //w=0.17 //l=0.17 //layer=licon //count=1 \
 //x=66.72 //y=4.88 //x2=66.72 //y2=4.88
r385 (  55 57 ) resistor r=43.123 //w=0.187 //l=0.63 //layer=li \
 //thickness=0.1 //x=66.72 //y=4.25 //x2=66.72 //y2=4.88
r386 (  52 123 ) resistor r=152 //w=0.17 //l=0.17 //layer=licon //count=1 \
 //x=66.72 //y=2.26 //x2=66.72 //y2=2.26
r387 (  52 55 ) resistor r=136.214 //w=0.187 //l=1.99 //layer=li \
 //thickness=0.1 //x=66.72 //y=2.26 //x2=66.72 //y2=4.25
r388 (  50 66 ) resistor r=57.1551 //w=0.187 //l=0.835 //layer=li \
 //thickness=0.1 //x=56.73 //y=5.25 //x2=56.73 //y2=4.415
r389 (  47 65 ) resistor r=147.508 //w=0.187 //l=2.155 //layer=li \
 //thickness=0.1 //x=56.73 //y=1.93 //x2=56.73 //y2=4.085
r390 (  45 47 ) resistor r=7.15173 //w=0.17 //l=0.120208 //layer=li \
 //thickness=0.1 //x=56.645 //y=1.845 //x2=56.73 //y2=1.93
r391 (  45 46 ) resistor r=21.5615 //w=0.187 //l=0.315 //layer=li \
 //thickness=0.1 //x=56.645 //y=1.845 //x2=56.33 //y2=1.845
r392 (  41 46 ) resistor r=7.15173 //w=0.17 //l=0.120208 //layer=li \
 //thickness=0.1 //x=56.245 //y=1.76 //x2=56.33 //y2=1.845
r393 (  41 131 ) resistor r=39.016 //w=0.187 //l=0.57 //layer=li \
 //thickness=0.1 //x=56.245 //y=1.76 //x2=56.245 //y2=1.19
r394 (  40 62 ) resistor r=5.4201 //w=0.17 //l=0.085 //layer=li \
 //thickness=0.1 //x=56.035 //y=5.335 //x2=55.95 //y2=5.335
r395 (  39 50 ) resistor r=7.15173 //w=0.17 //l=0.120208 //layer=li \
 //thickness=0.1 //x=56.645 //y=5.335 //x2=56.73 //y2=5.25
r396 (  39 40 ) resistor r=41.754 //w=0.187 //l=0.61 //layer=li \
 //thickness=0.1 //x=56.645 //y=5.335 //x2=56.035 //y2=5.335
r397 (  33 62 ) resistor r=1.40859 //w=0.34 //l=0.085 //layer=li \
 //thickness=0.1 //x=55.95 //y=5.42 //x2=55.95 //y2=5.335
r398 (  33 135 ) resistor r=33.1979 //w=0.187 //l=0.485 //layer=li \
 //thickness=0.1 //x=55.95 //y=5.42 //x2=55.95 //y2=5.905
r399 (  32 61 ) resistor r=5.4201 //w=0.17 //l=0.085 //layer=li \
 //thickness=0.1 //x=55.155 //y=5.335 //x2=55.07 //y2=5.335
r400 (  31 62 ) resistor r=5.4201 //w=0.17 //l=0.085 //layer=li \
 //thickness=0.1 //x=55.865 //y=5.335 //x2=55.95 //y2=5.335
r401 (  31 32 ) resistor r=48.5989 //w=0.187 //l=0.71 //layer=li \
 //thickness=0.1 //x=55.865 //y=5.335 //x2=55.155 //y2=5.335
r402 (  25 61 ) resistor r=1.40859 //w=0.34 //l=0.085 //layer=li \
 //thickness=0.1 //x=55.07 //y=5.42 //x2=55.07 //y2=5.335
r403 (  25 134 ) resistor r=33.1979 //w=0.187 //l=0.485 //layer=li \
 //thickness=0.1 //x=55.07 //y=5.42 //x2=55.07 //y2=5.905
r404 (  23 61 ) resistor r=5.4201 //w=0.17 //l=0.085 //layer=li \
 //thickness=0.1 //x=54.985 //y=5.335 //x2=55.07 //y2=5.335
r405 (  23 24 ) resistor r=48.5989 //w=0.187 //l=0.71 //layer=li \
 //thickness=0.1 //x=54.985 //y=5.335 //x2=54.275 //y2=5.335
r406 (  17 24 ) resistor r=7.15173 //w=0.17 //l=0.120208 //layer=li \
 //thickness=0.1 //x=54.19 //y=5.42 //x2=54.275 //y2=5.335
r407 (  17 133 ) resistor r=33.1979 //w=0.187 //l=0.485 //layer=li \
 //thickness=0.1 //x=54.19 //y=5.42 //x2=54.19 //y2=5.905
r408 (  13 110 ) resistor r=152 //w=0.17 //l=0.17 //layer=licon //count=1 \
 //x=51.18 //y=2.26 //x2=51.18 //y2=2.26
r409 (  13 16 ) resistor r=136.214 //w=0.187 //l=1.99 //layer=li \
 //thickness=0.1 //x=51.18 //y=2.26 //x2=51.18 //y2=4.25
r410 (  11 60 ) resistor r=11.4737 //w=0.186 //l=0.172337 //layer=li \
 //thickness=0.1 //x=51.18 //y=4.715 //x2=51.195 //y2=4.88
r411 (  11 16 ) resistor r=31.8289 //w=0.187 //l=0.465 //layer=li \
 //thickness=0.1 //x=51.18 //y=4.715 //x2=51.18 //y2=4.25
r412 (  10 55 ) resistor r=9.3 //w=0.17 //l=0.17 //layer=mcon //count=1 \
 //x=66.72 //y=4.25 //x2=66.72 //y2=4.25
r413 (  8 64 ) resistor r=9.3 //w=0.17 //l=0.17 //layer=mcon //count=1 \
 //x=56.725 //y=4.25 //x2=56.725 //y2=4.25
r414 (  6 16 ) resistor r=9.3 //w=0.17 //l=0.17 //layer=mcon //count=1 \
 //x=51.18 //y=4.25 //x2=51.18 //y2=4.25
r415 (  4 8 ) resistor r=0.0880901 //w=0.191 //l=0.115 //layer=m1 \
 //thickness=0.36 //x=56.84 //y=4.25 //x2=56.725 //y2=4.25
r416 (  3 10 ) resistor r=0.0717383 //w=0.224 //l=0.115 //layer=m1 \
 //thickness=0.36 //x=66.605 //y=4.25 //x2=66.72 //y2=4.25
r417 (  3 4 ) resistor r=9.31775 //w=0.131 //l=9.765 //layer=m1 \
 //thickness=0.36 //x=66.605 //y=4.25 //x2=56.84 //y2=4.25
r418 (  2 6 ) resistor r=0.0717383 //w=0.224 //l=0.115 //layer=m1 \
 //thickness=0.36 //x=51.295 //y=4.25 //x2=51.18 //y2=4.25
r419 (  1 8 ) resistor r=0.0880901 //w=0.191 //l=0.115 //layer=m1 \
 //thickness=0.36 //x=56.61 //y=4.25 //x2=56.725 //y2=4.25
r420 (  1 2 ) resistor r=5.07156 //w=0.131 //l=5.315 //layer=m1 \
 //thickness=0.36 //x=56.61 //y=4.25 //x2=51.295 //y2=4.25
ends PM_TMRDFFSNQX1\%noxref_18

subckt PM_TMRDFFSNQX1\%noxref_19 ( 1 2 13 14 25 27 28 32 34 41 42 43 44 45 46 \
 47 48 49 51 57 58 59 60 72 74 75 )
c165 ( 75 0 ) capacitor c=0.0220291f //x=67.575 //y=5.2
c166 ( 74 0 ) capacitor c=0.0217503f //x=66.695 //y=5.2
c167 ( 72 0 ) capacitor c=0.0084702f //x=67.57 //y=1.085
c168 ( 60 0 ) capacitor c=0.0546771f //x=70.325 //y=4.97
c169 ( 59 0 ) capacitor c=0.0293157f //x=70.615 //y=4.97
c170 ( 58 0 ) capacitor c=0.0347816f //x=70.28 //y=1.4
c171 ( 57 0 ) capacitor c=0.0187487f //x=70.28 //y=1.055
c172 ( 51 0 ) capacitor c=0.0137055f //x=70.125 //y=1.555
c173 ( 49 0 ) capacitor c=0.0149861f //x=70.125 //y=0.9
c174 ( 48 0 ) capacitor c=0.096037f //x=69.75 //y=2.095
c175 ( 47 0 ) capacitor c=0.0228993f //x=69.75 //y=1.71
c176 ( 46 0 ) capacitor c=0.0234352f //x=69.75 //y=1.4
c177 ( 45 0 ) capacitor c=0.0198724f //x=69.75 //y=1.055
c178 ( 44 0 ) capacitor c=0.110114f //x=70.69 //y=6.2
c179 ( 43 0 ) capacitor c=0.15724f //x=70.25 //y=6.2
c180 ( 41 0 ) capacitor c=0.00211606f //x=67.72 //y=5.38
c181 ( 34 0 ) capacitor c=0.101814f //x=70.05 //y=2.26
c182 ( 32 0 ) capacitor c=0.107182f //x=68.2 //y=4.99
c183 ( 28 0 ) capacitor c=0.00404073f //x=67.845 //y=1.835
c184 ( 27 0 ) capacitor c=0.0122201f //x=68.115 //y=1.835
c185 ( 25 0 ) capacitor c=0.0136983f //x=68.115 //y=5.38
c186 ( 14 0 ) capacitor c=0.00272496f //x=66.925 //y=5.38
c187 ( 13 0 ) capacitor c=0.0151328f //x=67.635 //y=5.38
c188 ( 2 0 ) capacitor c=0.0137739f //x=68.315 //y=4.99
c189 ( 1 0 ) capacitor c=0.0535064f //x=69.935 //y=4.99
r190 (  59 61 ) resistor r=26.9307 //w=0.15 //l=0.106066 //layer=ply \
 //thickness=0.18 //x=70.615 //y=4.97 //x2=70.69 //y2=5.045
r191 (  59 60 ) resistor r=148.702 //w=0.094 //l=0.29 //layer=ply \
 //thickness=0.18 //x=70.615 //y=4.97 //x2=70.325 //y2=4.97
r192 (  58 71 ) resistor r=45.1352 //w=0.168 //l=0.173853 //layer=ply \
 //thickness=0.18 //x=70.28 //y=1.4 //x2=70.24 //y2=1.555
r193 (  57 70 ) resistor r=45.1352 //w=0.168 //l=0.173853 //layer=ply \
 //thickness=0.18 //x=70.28 //y=1.055 //x2=70.24 //y2=0.9
r194 (  57 58 ) resistor r=176.904 //w=0.094 //l=0.345 //layer=ply \
 //thickness=0.18 //x=70.28 //y=1.055 //x2=70.28 //y2=1.4
r195 (  54 60 ) resistor r=22.7971 //w=0.269 //l=0.106066 //layer=ply \
 //thickness=0.18 //x=70.25 //y=5.045 //x2=70.325 //y2=4.97
r196 (  54 69 ) resistor r=35.8364 //w=0.269 //l=0.270185 //layer=ply \
 //thickness=0.18 //x=70.25 //y=5.045 //x2=70.05 //y2=4.88
r197 (  52 65 ) resistor r=10.701 //w=0.21 //l=0.115 //layer=ply \
 //thickness=0.18 //x=69.905 //y=1.555 //x2=69.79 //y2=1.555
r198 (  51 71 ) resistor r=5.52526 //w=0.168 //l=0.115 //layer=ply \
 //thickness=0.18 //x=70.125 //y=1.555 //x2=70.24 //y2=1.555
r199 (  50 64 ) resistor r=5.52526 //w=0.168 //l=0.115 //layer=ply \
 //thickness=0.18 //x=69.905 //y=0.9 //x2=69.79 //y2=0.9
r200 (  49 70 ) resistor r=5.52526 //w=0.168 //l=0.115 //layer=ply \
 //thickness=0.18 //x=70.125 //y=0.9 //x2=70.24 //y2=0.9
r201 (  49 50 ) resistor r=112.809 //w=0.094 //l=0.22 //layer=ply \
 //thickness=0.18 //x=70.125 //y=0.9 //x2=69.905 //y2=0.9
r202 (  48 67 ) resistor r=58.7805 //w=0.246 //l=0.373497 //layer=ply \
 //thickness=0.18 //x=69.75 //y=2.095 //x2=70.05 //y2=2.26
r203 (  47 65 ) resistor r=39.5823 //w=0.21 //l=0.173853 //layer=ply \
 //thickness=0.18 //x=69.75 //y=1.71 //x2=69.79 //y2=1.555
r204 (  47 48 ) resistor r=197.415 //w=0.094 //l=0.385 //layer=ply \
 //thickness=0.18 //x=69.75 //y=1.71 //x2=69.75 //y2=2.095
r205 (  46 65 ) resistor r=39.5823 //w=0.21 //l=0.173853 //layer=ply \
 //thickness=0.18 //x=69.75 //y=1.4 //x2=69.79 //y2=1.555
r206 (  45 64 ) resistor r=45.1352 //w=0.168 //l=0.173853 //layer=ply \
 //thickness=0.18 //x=69.75 //y=1.055 //x2=69.79 //y2=0.9
r207 (  45 46 ) resistor r=176.904 //w=0.094 //l=0.345 //layer=ply \
 //thickness=0.18 //x=69.75 //y=1.055 //x2=69.75 //y2=1.4
r208 (  44 61 ) resistor r=592.245 //w=0.094 //l=1.155 //layer=ply \
 //thickness=0.18 //x=70.69 //y=6.2 //x2=70.69 //y2=5.045
r209 (  43 54 ) resistor r=592.245 //w=0.094 //l=1.155 //layer=ply \
 //thickness=0.18 //x=70.25 //y=6.2 //x2=70.25 //y2=5.045
r210 (  42 51 ) resistor r=56.4043 //w=0.094 //l=0.11 //layer=ply \
 //thickness=0.18 //x=70.015 //y=1.555 //x2=70.125 //y2=1.555
r211 (  42 52 ) resistor r=56.4043 //w=0.094 //l=0.11 //layer=ply \
 //thickness=0.18 //x=70.015 //y=1.555 //x2=69.905 //y2=1.555
r212 (  37 69 ) resistor r=152 //w=0.17 //l=0.17 //layer=licon //count=1 \
 //x=70.05 //y=4.88 //x2=70.05 //y2=4.88
r213 (  37 39 ) resistor r=7.52941 //w=0.187 //l=0.11 //layer=li \
 //thickness=0.1 //x=70.05 //y=4.88 //x2=70.05 //y2=4.99
r214 (  34 67 ) resistor r=152 //w=0.17 //l=0.17 //layer=licon //count=1 \
 //x=70.05 //y=2.26 //x2=70.05 //y2=2.26
r215 (  34 37 ) resistor r=179.337 //w=0.187 //l=2.62 //layer=li \
 //thickness=0.1 //x=70.05 //y=2.26 //x2=70.05 //y2=4.88
r216 (  30 32 ) resistor r=20.877 //w=0.187 //l=0.305 //layer=li \
 //thickness=0.1 //x=68.2 //y=5.295 //x2=68.2 //y2=4.99
r217 (  29 32 ) resistor r=210.139 //w=0.187 //l=3.07 //layer=li \
 //thickness=0.1 //x=68.2 //y=1.92 //x2=68.2 //y2=4.99
r218 (  27 29 ) resistor r=7.15173 //w=0.17 //l=0.120208 //layer=li \
 //thickness=0.1 //x=68.115 //y=1.835 //x2=68.2 //y2=1.92
r219 (  27 28 ) resistor r=18.4813 //w=0.187 //l=0.27 //layer=li \
 //thickness=0.1 //x=68.115 //y=1.835 //x2=67.845 //y2=1.835
r220 (  26 41 ) resistor r=5.4201 //w=0.17 //l=0.085 //layer=li \
 //thickness=0.1 //x=67.805 //y=5.38 //x2=67.72 //y2=5.38
r221 (  25 30 ) resistor r=7.15173 //w=0.17 //l=0.120208 //layer=li \
 //thickness=0.1 //x=68.115 //y=5.38 //x2=68.2 //y2=5.295
r222 (  25 26 ) resistor r=21.2193 //w=0.187 //l=0.31 //layer=li \
 //thickness=0.1 //x=68.115 //y=5.38 //x2=67.805 //y2=5.38
r223 (  21 28 ) resistor r=7.15173 //w=0.17 //l=0.120208 //layer=li \
 //thickness=0.1 //x=67.76 //y=1.75 //x2=67.845 //y2=1.835
r224 (  21 72 ) resistor r=39.016 //w=0.187 //l=0.57 //layer=li \
 //thickness=0.1 //x=67.76 //y=1.75 //x2=67.76 //y2=1.18
r225 (  15 41 ) resistor r=1.40859 //w=0.34 //l=0.085 //layer=li \
 //thickness=0.1 //x=67.72 //y=5.465 //x2=67.72 //y2=5.38
r226 (  15 75 ) resistor r=30.1176 //w=0.187 //l=0.44 //layer=li \
 //thickness=0.1 //x=67.72 //y=5.465 //x2=67.72 //y2=5.905
r227 (  13 41 ) resistor r=5.4201 //w=0.17 //l=0.085 //layer=li \
 //thickness=0.1 //x=67.635 //y=5.38 //x2=67.72 //y2=5.38
r228 (  13 14 ) resistor r=48.5989 //w=0.187 //l=0.71 //layer=li \
 //thickness=0.1 //x=67.635 //y=5.38 //x2=66.925 //y2=5.38
r229 (  7 14 ) resistor r=7.15173 //w=0.17 //l=0.120208 //layer=li \
 //thickness=0.1 //x=66.84 //y=5.465 //x2=66.925 //y2=5.38
r230 (  7 74 ) resistor r=30.1176 //w=0.187 //l=0.44 //layer=li \
 //thickness=0.1 //x=66.84 //y=5.465 //x2=66.84 //y2=5.905
r231 (  6 39 ) resistor r=9.3 //w=0.17 //l=0.17 //layer=mcon //count=1 \
 //x=70.05 //y=4.99 //x2=70.05 //y2=4.99
r232 (  4 32 ) resistor r=9.3 //w=0.17 //l=0.17 //layer=mcon //count=1 \
 //x=68.2 //y=4.99 //x2=68.2 //y2=4.99
r233 (  2 4 ) resistor r=0.0717383 //w=0.224 //l=0.115 //layer=m1 \
 //thickness=0.36 //x=68.315 //y=4.99 //x2=68.2 //y2=4.99
r234 (  1 6 ) resistor r=0.0717383 //w=0.224 //l=0.115 //layer=m1 \
 //thickness=0.36 //x=69.935 //y=4.99 //x2=70.05 //y2=4.99
r235 (  1 2 ) resistor r=1.5458 //w=0.131 //l=1.62 //layer=m1 //thickness=0.36 \
 //x=69.935 //y=4.99 //x2=68.315 //y2=4.99
ends PM_TMRDFFSNQX1\%noxref_19

subckt PM_TMRDFFSNQX1\%SN ( 1 2 3 4 5 6 7 8 9 10 23 24 25 26 27 28 29 30 31 32 \
 34 44 54 62 70 79 86 87 88 89 90 91 92 93 94 95 96 97 98 99 100 101 102 103 \
 104 105 106 108 114 115 116 117 118 123 124 125 127 133 134 135 136 137 142 \
 143 144 146 152 153 154 155 156 161 162 163 165 171 172 173 174 175 180 181 \
 182 184 190 191 192 193 194 199 200 201 203 209 210 211 212 213 221 232 243 \
 254 265 276 )
c815 ( 276 0 ) capacitor c=0.0335551f //x=71.16 //y=4.88
c816 ( 265 0 ) capacitor c=0.0335551f //x=59.69 //y=4.88
c817 ( 254 0 ) capacitor c=0.0335551f //x=46.74 //y=4.88
c818 ( 243 0 ) capacitor c=0.0335551f //x=35.27 //y=4.88
c819 ( 232 0 ) capacitor c=0.0335551f //x=22.32 //y=4.88
c820 ( 221 0 ) capacitor c=0.0335551f //x=10.85 //y=4.88
c821 ( 213 0 ) capacitor c=0.0245352f //x=71.495 //y=4.97
c822 ( 212 0 ) capacitor c=0.0827272f //x=71.25 //y=2.095
c823 ( 211 0 ) capacitor c=0.0170266f //x=71.25 //y=1.63
c824 ( 210 0 ) capacitor c=0.018609f //x=71.25 //y=1.4
c825 ( 209 0 ) capacitor c=0.0187309f //x=71.25 //y=1.09
c826 ( 203 0 ) capacitor c=0.014725f //x=71.095 //y=1.555
c827 ( 201 0 ) capacitor c=0.0146567f //x=71.095 //y=0.935
c828 ( 200 0 ) capacitor c=0.0335408f //x=70.725 //y=1.4
c829 ( 199 0 ) capacitor c=0.0173761f //x=70.725 //y=1.09
c830 ( 194 0 ) capacitor c=0.0245352f //x=60.025 //y=4.97
c831 ( 193 0 ) capacitor c=0.0825033f //x=59.78 //y=2.095
c832 ( 192 0 ) capacitor c=0.0170266f //x=59.78 //y=1.63
c833 ( 191 0 ) capacitor c=0.018609f //x=59.78 //y=1.4
c834 ( 190 0 ) capacitor c=0.0187309f //x=59.78 //y=1.09
c835 ( 184 0 ) capacitor c=0.014725f //x=59.625 //y=1.555
c836 ( 182 0 ) capacitor c=0.0146567f //x=59.625 //y=0.935
c837 ( 181 0 ) capacitor c=0.0335408f //x=59.255 //y=1.4
c838 ( 180 0 ) capacitor c=0.0173761f //x=59.255 //y=1.09
c839 ( 175 0 ) capacitor c=0.0245352f //x=47.075 //y=4.97
c840 ( 174 0 ) capacitor c=0.0825033f //x=46.83 //y=2.095
c841 ( 173 0 ) capacitor c=0.0170266f //x=46.83 //y=1.63
c842 ( 172 0 ) capacitor c=0.018609f //x=46.83 //y=1.4
c843 ( 171 0 ) capacitor c=0.0187309f //x=46.83 //y=1.09
c844 ( 165 0 ) capacitor c=0.014725f //x=46.675 //y=1.555
c845 ( 163 0 ) capacitor c=0.0146567f //x=46.675 //y=0.935
c846 ( 162 0 ) capacitor c=0.0335408f //x=46.305 //y=1.4
c847 ( 161 0 ) capacitor c=0.0173761f //x=46.305 //y=1.09
c848 ( 156 0 ) capacitor c=0.0245352f //x=35.605 //y=4.97
c849 ( 155 0 ) capacitor c=0.0825033f //x=35.36 //y=2.095
c850 ( 154 0 ) capacitor c=0.0170266f //x=35.36 //y=1.63
c851 ( 153 0 ) capacitor c=0.018609f //x=35.36 //y=1.4
c852 ( 152 0 ) capacitor c=0.0187309f //x=35.36 //y=1.09
c853 ( 146 0 ) capacitor c=0.014725f //x=35.205 //y=1.555
c854 ( 144 0 ) capacitor c=0.0146567f //x=35.205 //y=0.935
c855 ( 143 0 ) capacitor c=0.0335408f //x=34.835 //y=1.4
c856 ( 142 0 ) capacitor c=0.0173761f //x=34.835 //y=1.09
c857 ( 137 0 ) capacitor c=0.0245352f //x=22.655 //y=4.97
c858 ( 136 0 ) capacitor c=0.0825033f //x=22.41 //y=2.095
c859 ( 135 0 ) capacitor c=0.0170266f //x=22.41 //y=1.63
c860 ( 134 0 ) capacitor c=0.018609f //x=22.41 //y=1.4
c861 ( 133 0 ) capacitor c=0.0187309f //x=22.41 //y=1.09
c862 ( 127 0 ) capacitor c=0.014725f //x=22.255 //y=1.555
c863 ( 125 0 ) capacitor c=0.0146567f //x=22.255 //y=0.935
c864 ( 124 0 ) capacitor c=0.0335408f //x=21.885 //y=1.4
c865 ( 123 0 ) capacitor c=0.0173761f //x=21.885 //y=1.09
c866 ( 118 0 ) capacitor c=0.0245352f //x=11.185 //y=4.97
c867 ( 117 0 ) capacitor c=0.0826756f //x=10.94 //y=2.095
c868 ( 116 0 ) capacitor c=0.0170266f //x=10.94 //y=1.63
c869 ( 115 0 ) capacitor c=0.018609f //x=10.94 //y=1.4
c870 ( 114 0 ) capacitor c=0.0187309f //x=10.94 //y=1.09
c871 ( 108 0 ) capacitor c=0.014725f //x=10.785 //y=1.555
c872 ( 106 0 ) capacitor c=0.0146567f //x=10.785 //y=0.935
c873 ( 105 0 ) capacitor c=0.0335408f //x=10.415 //y=1.4
c874 ( 104 0 ) capacitor c=0.0173761f //x=10.415 //y=1.09
c875 ( 103 0 ) capacitor c=0.110114f //x=71.57 //y=6.2
c876 ( 102 0 ) capacitor c=0.109821f //x=71.13 //y=6.2
c877 ( 101 0 ) capacitor c=0.110114f //x=60.1 //y=6.2
c878 ( 100 0 ) capacitor c=0.11012f //x=59.66 //y=6.2
c879 ( 99 0 ) capacitor c=0.110114f //x=47.15 //y=6.2
c880 ( 98 0 ) capacitor c=0.11012f //x=46.71 //y=6.2
c881 ( 97 0 ) capacitor c=0.110114f //x=35.68 //y=6.2
c882 ( 96 0 ) capacitor c=0.11012f //x=35.24 //y=6.2
c883 ( 95 0 ) capacitor c=0.110114f //x=22.73 //y=6.2
c884 ( 94 0 ) capacitor c=0.11012f //x=22.29 //y=6.2
c885 ( 93 0 ) capacitor c=0.110114f //x=11.26 //y=6.2
c886 ( 92 0 ) capacitor c=0.11012f //x=10.82 //y=6.2
c887 ( 79 0 ) capacitor c=0.0933884f //x=71.16 //y=2.26
c888 ( 70 0 ) capacitor c=0.0895052f //x=59.69 //y=2.26
c889 ( 62 0 ) capacitor c=0.0894348f //x=46.74 //y=2.26
c890 ( 54 0 ) capacitor c=0.0895052f //x=35.27 //y=2.26
c891 ( 44 0 ) capacitor c=0.0925216f //x=22.32 //y=2.26
c892 ( 34 0 ) capacitor c=0.0921487f //x=10.85 //y=2.26
c893 ( 10 0 ) capacitor c=0.00692137f //x=59.805 //y=2.4
c894 ( 9 0 ) capacitor c=0.263609f //x=71.045 //y=2.4
c895 ( 8 0 ) capacitor c=0.00692137f //x=46.855 //y=2.4
c896 ( 7 0 ) capacitor c=0.257357f //x=59.575 //y=2.4
c897 ( 6 0 ) capacitor c=0.00692137f //x=35.385 //y=2.4
c898 ( 5 0 ) capacitor c=0.240835f //x=46.625 //y=2.4
c899 ( 4 0 ) capacitor c=0.00692137f //x=22.435 //y=2.4
c900 ( 3 0 ) capacitor c=0.266406f //x=35.155 //y=2.4
c901 ( 2 0 ) capacitor c=0.0154797f //x=10.965 //y=2.4
c902 ( 1 0 ) capacitor c=0.248273f //x=22.205 //y=2.4
r903 (  278 279 ) resistor r=32.4568 //w=0.214 //l=0.075 //layer=ply \
 //thickness=0.18 //x=71.16 //y=4.97 //x2=71.16 //y2=5.045
r904 (  276 278 ) resistor r=20.271 //w=0.214 //l=0.09 //layer=ply \
 //thickness=0.18 //x=71.16 //y=4.88 //x2=71.16 //y2=4.97
r905 (  267 268 ) resistor r=32.4568 //w=0.214 //l=0.075 //layer=ply \
 //thickness=0.18 //x=59.69 //y=4.97 //x2=59.69 //y2=5.045
r906 (  265 267 ) resistor r=20.271 //w=0.214 //l=0.09 //layer=ply \
 //thickness=0.18 //x=59.69 //y=4.88 //x2=59.69 //y2=4.97
r907 (  256 257 ) resistor r=32.4568 //w=0.214 //l=0.075 //layer=ply \
 //thickness=0.18 //x=46.74 //y=4.97 //x2=46.74 //y2=5.045
r908 (  254 256 ) resistor r=20.271 //w=0.214 //l=0.09 //layer=ply \
 //thickness=0.18 //x=46.74 //y=4.88 //x2=46.74 //y2=4.97
r909 (  245 246 ) resistor r=32.4568 //w=0.214 //l=0.075 //layer=ply \
 //thickness=0.18 //x=35.27 //y=4.97 //x2=35.27 //y2=5.045
r910 (  243 245 ) resistor r=20.271 //w=0.214 //l=0.09 //layer=ply \
 //thickness=0.18 //x=35.27 //y=4.88 //x2=35.27 //y2=4.97
r911 (  234 235 ) resistor r=32.4568 //w=0.214 //l=0.075 //layer=ply \
 //thickness=0.18 //x=22.32 //y=4.97 //x2=22.32 //y2=5.045
r912 (  232 234 ) resistor r=20.271 //w=0.214 //l=0.09 //layer=ply \
 //thickness=0.18 //x=22.32 //y=4.88 //x2=22.32 //y2=4.97
r913 (  223 224 ) resistor r=32.4568 //w=0.214 //l=0.075 //layer=ply \
 //thickness=0.18 //x=10.85 //y=4.97 //x2=10.85 //y2=5.045
r914 (  221 223 ) resistor r=20.271 //w=0.214 //l=0.09 //layer=ply \
 //thickness=0.18 //x=10.85 //y=4.88 //x2=10.85 //y2=4.97
r915 (  214 278 ) resistor r=16.5046 //w=0.27 //l=0.135 //layer=ply \
 //thickness=0.18 //x=71.295 //y=4.97 //x2=71.16 //y2=4.97
r916 (  213 215 ) resistor r=26.9307 //w=0.15 //l=0.106066 //layer=ply \
 //thickness=0.18 //x=71.495 //y=4.97 //x2=71.57 //y2=5.045
r917 (  213 214 ) resistor r=102.553 //w=0.094 //l=0.2 //layer=ply \
 //thickness=0.18 //x=71.495 //y=4.97 //x2=71.295 //y2=4.97
r918 (  212 283 ) resistor r=38.6777 //w=0.284 //l=0.198997 //layer=ply \
 //thickness=0.18 //x=71.25 //y=2.095 //x2=71.175 //y2=2.26
r919 (  211 281 ) resistor r=21.2976 //w=0.217 //l=0.0928709 //layer=ply \
 //thickness=0.18 //x=71.25 //y=1.63 //x2=71.21 //y2=1.555
r920 (  211 212 ) resistor r=238.436 //w=0.094 //l=0.465 //layer=ply \
 //thickness=0.18 //x=71.25 //y=1.63 //x2=71.25 //y2=2.095
r921 (  210 281 ) resistor r=39.0671 //w=0.217 //l=0.173853 //layer=ply \
 //thickness=0.18 //x=71.25 //y=1.4 //x2=71.21 //y2=1.555
r922 (  209 280 ) resistor r=45.1352 //w=0.168 //l=0.173853 //layer=ply \
 //thickness=0.18 //x=71.25 //y=1.09 //x2=71.21 //y2=0.935
r923 (  209 210 ) resistor r=158.957 //w=0.094 //l=0.31 //layer=ply \
 //thickness=0.18 //x=71.25 //y=1.09 //x2=71.25 //y2=1.4
r924 (  204 274 ) resistor r=5.52526 //w=0.168 //l=0.115 //layer=ply \
 //thickness=0.18 //x=70.88 //y=1.555 //x2=70.765 //y2=1.555
r925 (  203 281 ) resistor r=11.4558 //w=0.217 //l=0.115 //layer=ply \
 //thickness=0.18 //x=71.095 //y=1.555 //x2=71.21 //y2=1.555
r926 (  202 273 ) resistor r=5.52526 //w=0.168 //l=0.115 //layer=ply \
 //thickness=0.18 //x=70.88 //y=0.935 //x2=70.765 //y2=0.935
r927 (  201 280 ) resistor r=5.52526 //w=0.168 //l=0.115 //layer=ply \
 //thickness=0.18 //x=71.095 //y=0.935 //x2=71.21 //y2=0.935
r928 (  201 202 ) resistor r=110.245 //w=0.094 //l=0.215 //layer=ply \
 //thickness=0.18 //x=71.095 //y=0.935 //x2=70.88 //y2=0.935
r929 (  200 274 ) resistor r=45.1352 //w=0.168 //l=0.173853 //layer=ply \
 //thickness=0.18 //x=70.725 //y=1.4 //x2=70.765 //y2=1.555
r930 (  199 273 ) resistor r=45.1352 //w=0.168 //l=0.173853 //layer=ply \
 //thickness=0.18 //x=70.725 //y=1.09 //x2=70.765 //y2=0.935
r931 (  199 200 ) resistor r=158.957 //w=0.094 //l=0.31 //layer=ply \
 //thickness=0.18 //x=70.725 //y=1.09 //x2=70.725 //y2=1.4
r932 (  195 267 ) resistor r=16.5046 //w=0.27 //l=0.135 //layer=ply \
 //thickness=0.18 //x=59.825 //y=4.97 //x2=59.69 //y2=4.97
r933 (  194 196 ) resistor r=26.9307 //w=0.15 //l=0.106066 //layer=ply \
 //thickness=0.18 //x=60.025 //y=4.97 //x2=60.1 //y2=5.045
r934 (  194 195 ) resistor r=102.553 //w=0.094 //l=0.2 //layer=ply \
 //thickness=0.18 //x=60.025 //y=4.97 //x2=59.825 //y2=4.97
r935 (  193 272 ) resistor r=38.6777 //w=0.284 //l=0.198997 //layer=ply \
 //thickness=0.18 //x=59.78 //y=2.095 //x2=59.705 //y2=2.26
r936 (  192 270 ) resistor r=21.2976 //w=0.217 //l=0.0928709 //layer=ply \
 //thickness=0.18 //x=59.78 //y=1.63 //x2=59.74 //y2=1.555
r937 (  192 193 ) resistor r=238.436 //w=0.094 //l=0.465 //layer=ply \
 //thickness=0.18 //x=59.78 //y=1.63 //x2=59.78 //y2=2.095
r938 (  191 270 ) resistor r=39.0671 //w=0.217 //l=0.173853 //layer=ply \
 //thickness=0.18 //x=59.78 //y=1.4 //x2=59.74 //y2=1.555
r939 (  190 269 ) resistor r=45.1352 //w=0.168 //l=0.173853 //layer=ply \
 //thickness=0.18 //x=59.78 //y=1.09 //x2=59.74 //y2=0.935
r940 (  190 191 ) resistor r=158.957 //w=0.094 //l=0.31 //layer=ply \
 //thickness=0.18 //x=59.78 //y=1.09 //x2=59.78 //y2=1.4
r941 (  185 263 ) resistor r=5.52526 //w=0.168 //l=0.115 //layer=ply \
 //thickness=0.18 //x=59.41 //y=1.555 //x2=59.295 //y2=1.555
r942 (  184 270 ) resistor r=11.4558 //w=0.217 //l=0.115 //layer=ply \
 //thickness=0.18 //x=59.625 //y=1.555 //x2=59.74 //y2=1.555
r943 (  183 262 ) resistor r=5.52526 //w=0.168 //l=0.115 //layer=ply \
 //thickness=0.18 //x=59.41 //y=0.935 //x2=59.295 //y2=0.935
r944 (  182 269 ) resistor r=5.52526 //w=0.168 //l=0.115 //layer=ply \
 //thickness=0.18 //x=59.625 //y=0.935 //x2=59.74 //y2=0.935
r945 (  182 183 ) resistor r=110.245 //w=0.094 //l=0.215 //layer=ply \
 //thickness=0.18 //x=59.625 //y=0.935 //x2=59.41 //y2=0.935
r946 (  181 263 ) resistor r=45.1352 //w=0.168 //l=0.173853 //layer=ply \
 //thickness=0.18 //x=59.255 //y=1.4 //x2=59.295 //y2=1.555
r947 (  180 262 ) resistor r=45.1352 //w=0.168 //l=0.173853 //layer=ply \
 //thickness=0.18 //x=59.255 //y=1.09 //x2=59.295 //y2=0.935
r948 (  180 181 ) resistor r=158.957 //w=0.094 //l=0.31 //layer=ply \
 //thickness=0.18 //x=59.255 //y=1.09 //x2=59.255 //y2=1.4
r949 (  176 256 ) resistor r=16.5046 //w=0.27 //l=0.135 //layer=ply \
 //thickness=0.18 //x=46.875 //y=4.97 //x2=46.74 //y2=4.97
r950 (  175 177 ) resistor r=26.9307 //w=0.15 //l=0.106066 //layer=ply \
 //thickness=0.18 //x=47.075 //y=4.97 //x2=47.15 //y2=5.045
r951 (  175 176 ) resistor r=102.553 //w=0.094 //l=0.2 //layer=ply \
 //thickness=0.18 //x=47.075 //y=4.97 //x2=46.875 //y2=4.97
r952 (  174 261 ) resistor r=38.6777 //w=0.284 //l=0.198997 //layer=ply \
 //thickness=0.18 //x=46.83 //y=2.095 //x2=46.755 //y2=2.26
r953 (  173 259 ) resistor r=21.2976 //w=0.217 //l=0.0928709 //layer=ply \
 //thickness=0.18 //x=46.83 //y=1.63 //x2=46.79 //y2=1.555
r954 (  173 174 ) resistor r=238.436 //w=0.094 //l=0.465 //layer=ply \
 //thickness=0.18 //x=46.83 //y=1.63 //x2=46.83 //y2=2.095
r955 (  172 259 ) resistor r=39.0671 //w=0.217 //l=0.173853 //layer=ply \
 //thickness=0.18 //x=46.83 //y=1.4 //x2=46.79 //y2=1.555
r956 (  171 258 ) resistor r=45.1352 //w=0.168 //l=0.173853 //layer=ply \
 //thickness=0.18 //x=46.83 //y=1.09 //x2=46.79 //y2=0.935
r957 (  171 172 ) resistor r=158.957 //w=0.094 //l=0.31 //layer=ply \
 //thickness=0.18 //x=46.83 //y=1.09 //x2=46.83 //y2=1.4
r958 (  166 252 ) resistor r=5.52526 //w=0.168 //l=0.115 //layer=ply \
 //thickness=0.18 //x=46.46 //y=1.555 //x2=46.345 //y2=1.555
r959 (  165 259 ) resistor r=11.4558 //w=0.217 //l=0.115 //layer=ply \
 //thickness=0.18 //x=46.675 //y=1.555 //x2=46.79 //y2=1.555
r960 (  164 251 ) resistor r=5.52526 //w=0.168 //l=0.115 //layer=ply \
 //thickness=0.18 //x=46.46 //y=0.935 //x2=46.345 //y2=0.935
r961 (  163 258 ) resistor r=5.52526 //w=0.168 //l=0.115 //layer=ply \
 //thickness=0.18 //x=46.675 //y=0.935 //x2=46.79 //y2=0.935
r962 (  163 164 ) resistor r=110.245 //w=0.094 //l=0.215 //layer=ply \
 //thickness=0.18 //x=46.675 //y=0.935 //x2=46.46 //y2=0.935
r963 (  162 252 ) resistor r=45.1352 //w=0.168 //l=0.173853 //layer=ply \
 //thickness=0.18 //x=46.305 //y=1.4 //x2=46.345 //y2=1.555
r964 (  161 251 ) resistor r=45.1352 //w=0.168 //l=0.173853 //layer=ply \
 //thickness=0.18 //x=46.305 //y=1.09 //x2=46.345 //y2=0.935
r965 (  161 162 ) resistor r=158.957 //w=0.094 //l=0.31 //layer=ply \
 //thickness=0.18 //x=46.305 //y=1.09 //x2=46.305 //y2=1.4
r966 (  157 245 ) resistor r=16.5046 //w=0.27 //l=0.135 //layer=ply \
 //thickness=0.18 //x=35.405 //y=4.97 //x2=35.27 //y2=4.97
r967 (  156 158 ) resistor r=26.9307 //w=0.15 //l=0.106066 //layer=ply \
 //thickness=0.18 //x=35.605 //y=4.97 //x2=35.68 //y2=5.045
r968 (  156 157 ) resistor r=102.553 //w=0.094 //l=0.2 //layer=ply \
 //thickness=0.18 //x=35.605 //y=4.97 //x2=35.405 //y2=4.97
r969 (  155 250 ) resistor r=38.6777 //w=0.284 //l=0.198997 //layer=ply \
 //thickness=0.18 //x=35.36 //y=2.095 //x2=35.285 //y2=2.26
r970 (  154 248 ) resistor r=21.2976 //w=0.217 //l=0.0928709 //layer=ply \
 //thickness=0.18 //x=35.36 //y=1.63 //x2=35.32 //y2=1.555
r971 (  154 155 ) resistor r=238.436 //w=0.094 //l=0.465 //layer=ply \
 //thickness=0.18 //x=35.36 //y=1.63 //x2=35.36 //y2=2.095
r972 (  153 248 ) resistor r=39.0671 //w=0.217 //l=0.173853 //layer=ply \
 //thickness=0.18 //x=35.36 //y=1.4 //x2=35.32 //y2=1.555
r973 (  152 247 ) resistor r=45.1352 //w=0.168 //l=0.173853 //layer=ply \
 //thickness=0.18 //x=35.36 //y=1.09 //x2=35.32 //y2=0.935
r974 (  152 153 ) resistor r=158.957 //w=0.094 //l=0.31 //layer=ply \
 //thickness=0.18 //x=35.36 //y=1.09 //x2=35.36 //y2=1.4
r975 (  147 241 ) resistor r=5.52526 //w=0.168 //l=0.115 //layer=ply \
 //thickness=0.18 //x=34.99 //y=1.555 //x2=34.875 //y2=1.555
r976 (  146 248 ) resistor r=11.4558 //w=0.217 //l=0.115 //layer=ply \
 //thickness=0.18 //x=35.205 //y=1.555 //x2=35.32 //y2=1.555
r977 (  145 240 ) resistor r=5.52526 //w=0.168 //l=0.115 //layer=ply \
 //thickness=0.18 //x=34.99 //y=0.935 //x2=34.875 //y2=0.935
r978 (  144 247 ) resistor r=5.52526 //w=0.168 //l=0.115 //layer=ply \
 //thickness=0.18 //x=35.205 //y=0.935 //x2=35.32 //y2=0.935
r979 (  144 145 ) resistor r=110.245 //w=0.094 //l=0.215 //layer=ply \
 //thickness=0.18 //x=35.205 //y=0.935 //x2=34.99 //y2=0.935
r980 (  143 241 ) resistor r=45.1352 //w=0.168 //l=0.173853 //layer=ply \
 //thickness=0.18 //x=34.835 //y=1.4 //x2=34.875 //y2=1.555
r981 (  142 240 ) resistor r=45.1352 //w=0.168 //l=0.173853 //layer=ply \
 //thickness=0.18 //x=34.835 //y=1.09 //x2=34.875 //y2=0.935
r982 (  142 143 ) resistor r=158.957 //w=0.094 //l=0.31 //layer=ply \
 //thickness=0.18 //x=34.835 //y=1.09 //x2=34.835 //y2=1.4
r983 (  138 234 ) resistor r=16.5046 //w=0.27 //l=0.135 //layer=ply \
 //thickness=0.18 //x=22.455 //y=4.97 //x2=22.32 //y2=4.97
r984 (  137 139 ) resistor r=26.9307 //w=0.15 //l=0.106066 //layer=ply \
 //thickness=0.18 //x=22.655 //y=4.97 //x2=22.73 //y2=5.045
r985 (  137 138 ) resistor r=102.553 //w=0.094 //l=0.2 //layer=ply \
 //thickness=0.18 //x=22.655 //y=4.97 //x2=22.455 //y2=4.97
r986 (  136 239 ) resistor r=38.6777 //w=0.284 //l=0.198997 //layer=ply \
 //thickness=0.18 //x=22.41 //y=2.095 //x2=22.335 //y2=2.26
r987 (  135 237 ) resistor r=21.2976 //w=0.217 //l=0.0928709 //layer=ply \
 //thickness=0.18 //x=22.41 //y=1.63 //x2=22.37 //y2=1.555
r988 (  135 136 ) resistor r=238.436 //w=0.094 //l=0.465 //layer=ply \
 //thickness=0.18 //x=22.41 //y=1.63 //x2=22.41 //y2=2.095
r989 (  134 237 ) resistor r=39.0671 //w=0.217 //l=0.173853 //layer=ply \
 //thickness=0.18 //x=22.41 //y=1.4 //x2=22.37 //y2=1.555
r990 (  133 236 ) resistor r=45.1352 //w=0.168 //l=0.173853 //layer=ply \
 //thickness=0.18 //x=22.41 //y=1.09 //x2=22.37 //y2=0.935
r991 (  133 134 ) resistor r=158.957 //w=0.094 //l=0.31 //layer=ply \
 //thickness=0.18 //x=22.41 //y=1.09 //x2=22.41 //y2=1.4
r992 (  128 230 ) resistor r=5.52526 //w=0.168 //l=0.115 //layer=ply \
 //thickness=0.18 //x=22.04 //y=1.555 //x2=21.925 //y2=1.555
r993 (  127 237 ) resistor r=11.4558 //w=0.217 //l=0.115 //layer=ply \
 //thickness=0.18 //x=22.255 //y=1.555 //x2=22.37 //y2=1.555
r994 (  126 229 ) resistor r=5.52526 //w=0.168 //l=0.115 //layer=ply \
 //thickness=0.18 //x=22.04 //y=0.935 //x2=21.925 //y2=0.935
r995 (  125 236 ) resistor r=5.52526 //w=0.168 //l=0.115 //layer=ply \
 //thickness=0.18 //x=22.255 //y=0.935 //x2=22.37 //y2=0.935
r996 (  125 126 ) resistor r=110.245 //w=0.094 //l=0.215 //layer=ply \
 //thickness=0.18 //x=22.255 //y=0.935 //x2=22.04 //y2=0.935
r997 (  124 230 ) resistor r=45.1352 //w=0.168 //l=0.173853 //layer=ply \
 //thickness=0.18 //x=21.885 //y=1.4 //x2=21.925 //y2=1.555
r998 (  123 229 ) resistor r=45.1352 //w=0.168 //l=0.173853 //layer=ply \
 //thickness=0.18 //x=21.885 //y=1.09 //x2=21.925 //y2=0.935
r999 (  123 124 ) resistor r=158.957 //w=0.094 //l=0.31 //layer=ply \
 //thickness=0.18 //x=21.885 //y=1.09 //x2=21.885 //y2=1.4
r1000 (  119 223 ) resistor r=16.5046 //w=0.27 //l=0.135 //layer=ply \
 //thickness=0.18 //x=10.985 //y=4.97 //x2=10.85 //y2=4.97
r1001 (  118 120 ) resistor r=26.9307 //w=0.15 //l=0.106066 //layer=ply \
 //thickness=0.18 //x=11.185 //y=4.97 //x2=11.26 //y2=5.045
r1002 (  118 119 ) resistor r=102.553 //w=0.094 //l=0.2 //layer=ply \
 //thickness=0.18 //x=11.185 //y=4.97 //x2=10.985 //y2=4.97
r1003 (  117 228 ) resistor r=38.6777 //w=0.284 //l=0.198997 //layer=ply \
 //thickness=0.18 //x=10.94 //y=2.095 //x2=10.865 //y2=2.26
r1004 (  116 226 ) resistor r=21.2976 //w=0.217 //l=0.0928709 //layer=ply \
 //thickness=0.18 //x=10.94 //y=1.63 //x2=10.9 //y2=1.555
r1005 (  116 117 ) resistor r=238.436 //w=0.094 //l=0.465 //layer=ply \
 //thickness=0.18 //x=10.94 //y=1.63 //x2=10.94 //y2=2.095
r1006 (  115 226 ) resistor r=39.0671 //w=0.217 //l=0.173853 //layer=ply \
 //thickness=0.18 //x=10.94 //y=1.4 //x2=10.9 //y2=1.555
r1007 (  114 225 ) resistor r=45.1352 //w=0.168 //l=0.173853 //layer=ply \
 //thickness=0.18 //x=10.94 //y=1.09 //x2=10.9 //y2=0.935
r1008 (  114 115 ) resistor r=158.957 //w=0.094 //l=0.31 //layer=ply \
 //thickness=0.18 //x=10.94 //y=1.09 //x2=10.94 //y2=1.4
r1009 (  109 219 ) resistor r=5.52526 //w=0.168 //l=0.115 //layer=ply \
 //thickness=0.18 //x=10.57 //y=1.555 //x2=10.455 //y2=1.555
r1010 (  108 226 ) resistor r=11.4558 //w=0.217 //l=0.115 //layer=ply \
 //thickness=0.18 //x=10.785 //y=1.555 //x2=10.9 //y2=1.555
r1011 (  107 218 ) resistor r=5.52526 //w=0.168 //l=0.115 //layer=ply \
 //thickness=0.18 //x=10.57 //y=0.935 //x2=10.455 //y2=0.935
r1012 (  106 225 ) resistor r=5.52526 //w=0.168 //l=0.115 //layer=ply \
 //thickness=0.18 //x=10.785 //y=0.935 //x2=10.9 //y2=0.935
r1013 (  106 107 ) resistor r=110.245 //w=0.094 //l=0.215 //layer=ply \
 //thickness=0.18 //x=10.785 //y=0.935 //x2=10.57 //y2=0.935
r1014 (  105 219 ) resistor r=45.1352 //w=0.168 //l=0.173853 //layer=ply \
 //thickness=0.18 //x=10.415 //y=1.4 //x2=10.455 //y2=1.555
r1015 (  104 218 ) resistor r=45.1352 //w=0.168 //l=0.173853 //layer=ply \
 //thickness=0.18 //x=10.415 //y=1.09 //x2=10.455 //y2=0.935
r1016 (  104 105 ) resistor r=158.957 //w=0.094 //l=0.31 //layer=ply \
 //thickness=0.18 //x=10.415 //y=1.09 //x2=10.415 //y2=1.4
r1017 (  103 215 ) resistor r=592.245 //w=0.094 //l=1.155 //layer=ply \
 //thickness=0.18 //x=71.57 //y=6.2 //x2=71.57 //y2=5.045
r1018 (  102 279 ) resistor r=592.245 //w=0.094 //l=1.155 //layer=ply \
 //thickness=0.18 //x=71.13 //y=6.2 //x2=71.13 //y2=5.045
r1019 (  101 196 ) resistor r=592.245 //w=0.094 //l=1.155 //layer=ply \
 //thickness=0.18 //x=60.1 //y=6.2 //x2=60.1 //y2=5.045
r1020 (  100 268 ) resistor r=592.245 //w=0.094 //l=1.155 //layer=ply \
 //thickness=0.18 //x=59.66 //y=6.2 //x2=59.66 //y2=5.045
r1021 (  99 177 ) resistor r=592.245 //w=0.094 //l=1.155 //layer=ply \
 //thickness=0.18 //x=47.15 //y=6.2 //x2=47.15 //y2=5.045
r1022 (  98 257 ) resistor r=592.245 //w=0.094 //l=1.155 //layer=ply \
 //thickness=0.18 //x=46.71 //y=6.2 //x2=46.71 //y2=5.045
r1023 (  97 158 ) resistor r=592.245 //w=0.094 //l=1.155 //layer=ply \
 //thickness=0.18 //x=35.68 //y=6.2 //x2=35.68 //y2=5.045
r1024 (  96 246 ) resistor r=592.245 //w=0.094 //l=1.155 //layer=ply \
 //thickness=0.18 //x=35.24 //y=6.2 //x2=35.24 //y2=5.045
r1025 (  95 139 ) resistor r=592.245 //w=0.094 //l=1.155 //layer=ply \
 //thickness=0.18 //x=22.73 //y=6.2 //x2=22.73 //y2=5.045
r1026 (  94 235 ) resistor r=592.245 //w=0.094 //l=1.155 //layer=ply \
 //thickness=0.18 //x=22.29 //y=6.2 //x2=22.29 //y2=5.045
r1027 (  93 120 ) resistor r=592.245 //w=0.094 //l=1.155 //layer=ply \
 //thickness=0.18 //x=11.26 //y=6.2 //x2=11.26 //y2=5.045
r1028 (  92 224 ) resistor r=592.245 //w=0.094 //l=1.155 //layer=ply \
 //thickness=0.18 //x=10.82 //y=6.2 //x2=10.82 //y2=5.045
r1029 (  91 203 ) resistor r=55.3787 //w=0.094 //l=0.108 //layer=ply \
 //thickness=0.18 //x=70.987 //y=1.555 //x2=71.095 //y2=1.555
r1030 (  91 204 ) resistor r=54.866 //w=0.094 //l=0.107 //layer=ply \
 //thickness=0.18 //x=70.987 //y=1.555 //x2=70.88 //y2=1.555
r1031 (  90 184 ) resistor r=55.3787 //w=0.094 //l=0.108 //layer=ply \
 //thickness=0.18 //x=59.517 //y=1.555 //x2=59.625 //y2=1.555
r1032 (  90 185 ) resistor r=54.866 //w=0.094 //l=0.107 //layer=ply \
 //thickness=0.18 //x=59.517 //y=1.555 //x2=59.41 //y2=1.555
r1033 (  89 165 ) resistor r=55.3787 //w=0.094 //l=0.108 //layer=ply \
 //thickness=0.18 //x=46.567 //y=1.555 //x2=46.675 //y2=1.555
r1034 (  89 166 ) resistor r=54.866 //w=0.094 //l=0.107 //layer=ply \
 //thickness=0.18 //x=46.567 //y=1.555 //x2=46.46 //y2=1.555
r1035 (  88 146 ) resistor r=55.3787 //w=0.094 //l=0.108 //layer=ply \
 //thickness=0.18 //x=35.097 //y=1.555 //x2=35.205 //y2=1.555
r1036 (  88 147 ) resistor r=54.866 //w=0.094 //l=0.107 //layer=ply \
 //thickness=0.18 //x=35.097 //y=1.555 //x2=34.99 //y2=1.555
r1037 (  87 127 ) resistor r=55.3787 //w=0.094 //l=0.108 //layer=ply \
 //thickness=0.18 //x=22.147 //y=1.555 //x2=22.255 //y2=1.555
r1038 (  87 128 ) resistor r=54.866 //w=0.094 //l=0.107 //layer=ply \
 //thickness=0.18 //x=22.147 //y=1.555 //x2=22.04 //y2=1.555
r1039 (  86 108 ) resistor r=55.3787 //w=0.094 //l=0.108 //layer=ply \
 //thickness=0.18 //x=10.677 //y=1.555 //x2=10.785 //y2=1.555
r1040 (  86 109 ) resistor r=54.866 //w=0.094 //l=0.107 //layer=ply \
 //thickness=0.18 //x=10.677 //y=1.555 //x2=10.57 //y2=1.555
r1041 (  84 276 ) resistor r=152 //w=0.17 //l=0.17 //layer=licon //count=1 \
 //x=71.16 //y=4.88 //x2=71.16 //y2=4.88
r1042 (  79 283 ) resistor r=152 //w=0.17 //l=0.17 //layer=licon //count=1 \
 //x=71.16 //y=2.26 //x2=71.16 //y2=2.26
r1043 (  76 265 ) resistor r=152 //w=0.17 //l=0.17 //layer=licon //count=1 \
 //x=59.69 //y=4.88 //x2=59.69 //y2=4.88
r1044 (  70 272 ) resistor r=152 //w=0.17 //l=0.17 //layer=licon //count=1 \
 //x=59.69 //y=2.26 //x2=59.69 //y2=2.26
r1045 (  67 254 ) resistor r=152 //w=0.17 //l=0.17 //layer=licon //count=1 \
 //x=46.74 //y=4.88 //x2=46.74 //y2=4.88
r1046 (  65 67 ) resistor r=169.754 //w=0.187 //l=2.48 //layer=li \
 //thickness=0.1 //x=46.74 //y=2.4 //x2=46.74 //y2=4.88
r1047 (  62 261 ) resistor r=152 //w=0.17 //l=0.17 //layer=licon //count=1 \
 //x=46.74 //y=2.26 //x2=46.74 //y2=2.26
r1048 (  62 65 ) resistor r=9.58289 //w=0.187 //l=0.14 //layer=li \
 //thickness=0.1 //x=46.74 //y=2.26 //x2=46.74 //y2=2.4
r1049 (  59 243 ) resistor r=152 //w=0.17 //l=0.17 //layer=licon //count=1 \
 //x=35.27 //y=4.88 //x2=35.27 //y2=4.88
r1050 (  54 250 ) resistor r=152 //w=0.17 //l=0.17 //layer=licon //count=1 \
 //x=35.27 //y=2.26 //x2=35.27 //y2=2.26
r1051 (  51 232 ) resistor r=152 //w=0.17 //l=0.17 //layer=licon //count=1 \
 //x=22.32 //y=4.88 //x2=22.32 //y2=4.88
r1052 (  44 239 ) resistor r=152 //w=0.17 //l=0.17 //layer=licon //count=1 \
 //x=22.32 //y=2.26 //x2=22.32 //y2=2.26
r1053 (  41 221 ) resistor r=152 //w=0.17 //l=0.17 //layer=licon //count=1 \
 //x=10.85 //y=4.88 //x2=10.85 //y2=4.88
r1054 (  34 228 ) resistor r=152 //w=0.17 //l=0.17 //layer=licon //count=1 \
 //x=10.85 //y=2.26 //x2=10.85 //y2=2.26
r1055 (  32 84 ) resistor r=169.754 //w=0.187 //l=2.48 //layer=li \
 //thickness=0.1 //x=71.16 //y=2.4 //x2=71.16 //y2=4.88
r1056 (  32 79 ) resistor r=9.58289 //w=0.187 //l=0.14 //layer=li \
 //thickness=0.1 //x=71.16 //y=2.4 //x2=71.16 //y2=2.26
r1057 (  31 76 ) resistor r=144.428 //w=0.187 //l=2.11 //layer=li \
 //thickness=0.1 //x=59.69 //y=2.77 //x2=59.69 //y2=4.88
r1058 (  30 31 ) resistor r=25.3262 //w=0.187 //l=0.37 //layer=li \
 //thickness=0.1 //x=59.69 //y=2.4 //x2=59.69 //y2=2.77
r1059 (  30 70 ) resistor r=9.58289 //w=0.187 //l=0.14 //layer=li \
 //thickness=0.1 //x=59.69 //y=2.4 //x2=59.69 //y2=2.26
r1060 (  29 59 ) resistor r=169.754 //w=0.187 //l=2.48 //layer=li \
 //thickness=0.1 //x=35.27 //y=2.4 //x2=35.27 //y2=4.88
r1061 (  29 54 ) resistor r=9.58289 //w=0.187 //l=0.14 //layer=li \
 //thickness=0.1 //x=35.27 //y=2.4 //x2=35.27 //y2=2.26
r1062 (  28 51 ) resistor r=43.123 //w=0.187 //l=0.63 //layer=li \
 //thickness=0.1 //x=22.32 //y=4.25 //x2=22.32 //y2=4.88
r1063 (  27 28 ) resistor r=101.305 //w=0.187 //l=1.48 //layer=li \
 //thickness=0.1 //x=22.32 //y=2.77 //x2=22.32 //y2=4.25
r1064 (  26 27 ) resistor r=25.3262 //w=0.187 //l=0.37 //layer=li \
 //thickness=0.1 //x=22.32 //y=2.4 //x2=22.32 //y2=2.77
r1065 (  26 44 ) resistor r=9.58289 //w=0.187 //l=0.14 //layer=li \
 //thickness=0.1 //x=22.32 //y=2.4 //x2=22.32 //y2=2.26
r1066 (  25 41 ) resistor r=93.7754 //w=0.187 //l=1.37 //layer=li \
 //thickness=0.1 //x=10.85 //y=3.51 //x2=10.85 //y2=4.88
r1067 (  24 25 ) resistor r=50.6524 //w=0.187 //l=0.74 //layer=li \
 //thickness=0.1 //x=10.85 //y=2.77 //x2=10.85 //y2=3.51
r1068 (  23 24 ) resistor r=25.3262 //w=0.187 //l=0.37 //layer=li \
 //thickness=0.1 //x=10.85 //y=2.4 //x2=10.85 //y2=2.77
r1069 (  23 34 ) resistor r=9.58289 //w=0.187 //l=0.14 //layer=li \
 //thickness=0.1 //x=10.85 //y=2.4 //x2=10.85 //y2=2.26
r1070 (  22 32 ) resistor r=9.3 //w=0.17 //l=0.17 //layer=mcon //count=1 \
 //x=71.16 //y=2.4 //x2=71.16 //y2=2.4
r1071 (  20 30 ) resistor r=9.3 //w=0.17 //l=0.17 //layer=mcon //count=1 \
 //x=59.69 //y=2.4 //x2=59.69 //y2=2.4
r1072 (  18 65 ) resistor r=9.3 //w=0.17 //l=0.17 //layer=mcon //count=1 \
 //x=46.74 //y=2.4 //x2=46.74 //y2=2.4
r1073 (  16 29 ) resistor r=9.3 //w=0.17 //l=0.17 //layer=mcon //count=1 \
 //x=35.27 //y=2.4 //x2=35.27 //y2=2.4
r1074 (  14 26 ) resistor r=9.3 //w=0.17 //l=0.17 //layer=mcon //count=1 \
 //x=22.32 //y=2.4 //x2=22.32 //y2=2.4
r1075 (  12 23 ) resistor r=9.3 //w=0.17 //l=0.17 //layer=mcon //count=1 \
 //x=10.85 //y=2.4 //x2=10.85 //y2=2.4
r1076 (  10 20 ) resistor r=0.0880901 //w=0.191 //l=0.115 //layer=m1 \
 //thickness=0.36 //x=59.805 //y=2.4 //x2=59.69 //y2=2.4
r1077 (  9 22 ) resistor r=0.0717383 //w=0.224 //l=0.115 //layer=m1 \
 //thickness=0.36 //x=71.045 //y=2.4 //x2=71.16 //y2=2.4
r1078 (  9 10 ) resistor r=10.7252 //w=0.131 //l=11.24 //layer=m1 \
 //thickness=0.36 //x=71.045 //y=2.4 //x2=59.805 //y2=2.4
r1079 (  8 18 ) resistor r=0.0880901 //w=0.191 //l=0.115 //layer=m1 \
 //thickness=0.36 //x=46.855 //y=2.4 //x2=46.74 //y2=2.4
r1080 (  7 20 ) resistor r=0.0880901 //w=0.191 //l=0.115 //layer=m1 \
 //thickness=0.36 //x=59.575 //y=2.4 //x2=59.69 //y2=2.4
r1081 (  7 8 ) resistor r=12.1374 //w=0.131 //l=12.72 //layer=m1 \
 //thickness=0.36 //x=59.575 //y=2.4 //x2=46.855 //y2=2.4
r1082 (  6 16 ) resistor r=0.0880901 //w=0.191 //l=0.115 //layer=m1 \
 //thickness=0.36 //x=35.385 //y=2.4 //x2=35.27 //y2=2.4
r1083 (  5 18 ) resistor r=0.0880901 //w=0.191 //l=0.115 //layer=m1 \
 //thickness=0.36 //x=46.625 //y=2.4 //x2=46.74 //y2=2.4
r1084 (  5 6 ) resistor r=10.7252 //w=0.131 //l=11.24 //layer=m1 \
 //thickness=0.36 //x=46.625 //y=2.4 //x2=35.385 //y2=2.4
r1085 (  4 14 ) resistor r=0.0880901 //w=0.191 //l=0.115 //layer=m1 \
 //thickness=0.36 //x=22.435 //y=2.4 //x2=22.32 //y2=2.4
r1086 (  3 16 ) resistor r=0.0880901 //w=0.191 //l=0.115 //layer=m1 \
 //thickness=0.36 //x=35.155 //y=2.4 //x2=35.27 //y2=2.4
r1087 (  3 4 ) resistor r=12.1374 //w=0.131 //l=12.72 //layer=m1 \
 //thickness=0.36 //x=35.155 //y=2.4 //x2=22.435 //y2=2.4
r1088 (  2 12 ) resistor r=0.0717383 //w=0.224 //l=0.115 //layer=m1 \
 //thickness=0.36 //x=10.965 //y=2.4 //x2=10.85 //y2=2.4
r1089 (  1 14 ) resistor r=0.0880901 //w=0.191 //l=0.115 //layer=m1 \
 //thickness=0.36 //x=22.205 //y=2.4 //x2=22.32 //y2=2.4
r1090 (  1 2 ) resistor r=10.7252 //w=0.131 //l=11.24 //layer=m1 \
 //thickness=0.36 //x=22.205 //y=2.4 //x2=10.965 //y2=2.4
ends PM_TMRDFFSNQX1\%SN

subckt PM_TMRDFFSNQX1\%noxref_21 ( 1 2 3 4 5 6 16 24 37 38 49 51 52 56 58 65 \
 66 67 68 69 70 71 72 73 74 78 79 80 85 87 90 91 95 96 97 102 104 107 108 112 \
 113 114 119 121 124 125 127 128 133 137 138 143 147 148 153 156 158 159 )
c321 ( 159 0 ) capacitor c=0.0220291f //x=64.245 //y=5.2
c322 ( 158 0 ) capacitor c=0.0217503f //x=63.365 //y=5.2
c323 ( 156 0 ) capacitor c=0.00866655f //x=64.24 //y=1.085
c324 ( 153 0 ) capacitor c=0.0587755f //x=72.27 //y=4.88
c325 ( 148 0 ) capacitor c=0.0273931f //x=72.27 //y=2.095
c326 ( 147 0 ) capacitor c=0.0458323f //x=72.27 //y=2.26
c327 ( 143 0 ) capacitor c=0.0587755f //x=60.8 //y=4.88
c328 ( 138 0 ) capacitor c=0.0273931f //x=60.8 //y=2.095
c329 ( 137 0 ) capacitor c=0.0456313f //x=60.8 //y=2.26
c330 ( 133 0 ) capacitor c=0.058931f //x=55.99 //y=4.88
c331 ( 128 0 ) capacitor c=0.0267105f //x=55.99 //y=2.095
c332 ( 127 0 ) capacitor c=0.0456313f //x=55.99 //y=2.26
c333 ( 125 0 ) capacitor c=0.0432517f //x=72.79 //y=1.44
c334 ( 124 0 ) capacitor c=0.0200379f //x=72.79 //y=1.095
c335 ( 121 0 ) capacitor c=0.0158629f //x=72.635 //y=1.595
c336 ( 119 0 ) capacitor c=0.0157803f //x=72.635 //y=0.94
c337 ( 114 0 ) capacitor c=0.0218028f //x=72.26 //y=1.75
c338 ( 113 0 ) capacitor c=0.0207459f //x=72.26 //y=1.44
c339 ( 112 0 ) capacitor c=0.0194308f //x=72.26 //y=1.095
c340 ( 108 0 ) capacitor c=0.0432517f //x=61.32 //y=1.44
c341 ( 107 0 ) capacitor c=0.0200379f //x=61.32 //y=1.095
c342 ( 104 0 ) capacitor c=0.0148873f //x=61.165 //y=1.595
c343 ( 102 0 ) capacitor c=0.0157803f //x=61.165 //y=0.94
c344 ( 97 0 ) capacitor c=0.0218028f //x=60.79 //y=1.75
c345 ( 96 0 ) capacitor c=0.0207459f //x=60.79 //y=1.44
c346 ( 95 0 ) capacitor c=0.0194308f //x=60.79 //y=1.095
c347 ( 91 0 ) capacitor c=0.0432517f //x=56.51 //y=1.44
c348 ( 90 0 ) capacitor c=0.0200379f //x=56.51 //y=1.095
c349 ( 87 0 ) capacitor c=0.0148873f //x=56.355 //y=1.595
c350 ( 85 0 ) capacitor c=0.0157803f //x=56.355 //y=0.94
c351 ( 80 0 ) capacitor c=0.0218028f //x=55.98 //y=1.75
c352 ( 79 0 ) capacitor c=0.0207459f //x=55.98 //y=1.44
c353 ( 78 0 ) capacitor c=0.0194308f //x=55.98 //y=1.095
c354 ( 74 0 ) capacitor c=0.158794f //x=72.45 //y=6.2
c355 ( 73 0 ) capacitor c=0.110114f //x=72.01 //y=6.2
c356 ( 72 0 ) capacitor c=0.158794f //x=60.98 //y=6.2
c357 ( 71 0 ) capacitor c=0.110114f //x=60.54 //y=6.2
c358 ( 70 0 ) capacitor c=0.158048f //x=56.17 //y=6.2
c359 ( 69 0 ) capacitor c=0.110114f //x=55.73 //y=6.2
c360 ( 65 0 ) capacitor c=0.0023043f //x=64.39 //y=5.38
c361 ( 58 0 ) capacitor c=0.08651f //x=72.27 //y=2.26
c362 ( 56 0 ) capacitor c=0.104743f //x=64.87 //y=3.88
c363 ( 52 0 ) capacitor c=0.00404073f //x=64.515 //y=1.835
c364 ( 51 0 ) capacitor c=0.0122201f //x=64.785 //y=1.835
c365 ( 49 0 ) capacitor c=0.0140462f //x=64.785 //y=5.38
c366 ( 38 0 ) capacitor c=0.00251635f //x=63.595 //y=5.38
c367 ( 37 0 ) capacitor c=0.0143111f //x=64.305 //y=5.38
c368 ( 24 0 ) capacitor c=0.0811636f //x=60.8 //y=2.26
c369 ( 16 0 ) capacitor c=0.0796434f //x=55.99 //y=2.26
c370 ( 6 0 ) capacitor c=0.00405261f //x=64.985 //y=3.88
c371 ( 5 0 ) capacitor c=0.139723f //x=72.155 //y=3.88
c372 ( 4 0 ) capacitor c=0.00412452f //x=60.915 //y=3.88
c373 ( 3 0 ) capacitor c=0.0546427f //x=64.755 //y=3.88
c374 ( 2 0 ) capacitor c=0.0138772f //x=56.105 //y=3.88
c375 ( 1 0 ) capacitor c=0.0670382f //x=60.685 //y=3.88
r376 (  147 148 ) resistor r=52.7279 //w=0.214 //l=0.165 //layer=ply \
 //thickness=0.18 //x=72.27 //y=2.26 //x2=72.27 //y2=2.095
r377 (  137 138 ) resistor r=52.7279 //w=0.214 //l=0.165 //layer=ply \
 //thickness=0.18 //x=60.8 //y=2.26 //x2=60.8 //y2=2.095
r378 (  127 128 ) resistor r=52.7279 //w=0.214 //l=0.165 //layer=ply \
 //thickness=0.18 //x=55.99 //y=2.26 //x2=55.99 //y2=2.095
r379 (  125 155 ) resistor r=45.1352 //w=0.168 //l=0.173853 //layer=ply \
 //thickness=0.18 //x=72.79 //y=1.44 //x2=72.75 //y2=1.595
r380 (  124 154 ) resistor r=45.1352 //w=0.168 //l=0.173853 //layer=ply \
 //thickness=0.18 //x=72.79 //y=1.095 //x2=72.75 //y2=0.94
r381 (  124 125 ) resistor r=176.904 //w=0.094 //l=0.345 //layer=ply \
 //thickness=0.18 //x=72.79 //y=1.095 //x2=72.79 //y2=1.44
r382 (  122 151 ) resistor r=10.701 //w=0.21 //l=0.115 //layer=ply \
 //thickness=0.18 //x=72.415 //y=1.595 //x2=72.3 //y2=1.595
r383 (  121 155 ) resistor r=5.52526 //w=0.168 //l=0.115 //layer=ply \
 //thickness=0.18 //x=72.635 //y=1.595 //x2=72.75 //y2=1.595
r384 (  120 150 ) resistor r=5.52526 //w=0.168 //l=0.115 //layer=ply \
 //thickness=0.18 //x=72.415 //y=0.94 //x2=72.3 //y2=0.94
r385 (  119 154 ) resistor r=5.52526 //w=0.168 //l=0.115 //layer=ply \
 //thickness=0.18 //x=72.635 //y=0.94 //x2=72.75 //y2=0.94
r386 (  119 120 ) resistor r=112.809 //w=0.094 //l=0.22 //layer=ply \
 //thickness=0.18 //x=72.635 //y=0.94 //x2=72.415 //y2=0.94
r387 (  116 153 ) resistor r=37.236 //w=0.233 //l=0.249199 //layer=ply \
 //thickness=0.18 //x=72.45 //y=5.045 //x2=72.27 //y2=4.88
r388 (  114 151 ) resistor r=39.5823 //w=0.21 //l=0.173853 //layer=ply \
 //thickness=0.18 //x=72.26 //y=1.75 //x2=72.3 //y2=1.595
r389 (  114 148 ) resistor r=176.904 //w=0.094 //l=0.345 //layer=ply \
 //thickness=0.18 //x=72.26 //y=1.75 //x2=72.26 //y2=2.095
r390 (  113 151 ) resistor r=39.5823 //w=0.21 //l=0.173853 //layer=ply \
 //thickness=0.18 //x=72.26 //y=1.44 //x2=72.3 //y2=1.595
r391 (  112 150 ) resistor r=45.1352 //w=0.168 //l=0.173853 //layer=ply \
 //thickness=0.18 //x=72.26 //y=1.095 //x2=72.3 //y2=0.94
r392 (  112 113 ) resistor r=176.904 //w=0.094 //l=0.345 //layer=ply \
 //thickness=0.18 //x=72.26 //y=1.095 //x2=72.26 //y2=1.44
r393 (  109 153 ) resistor r=53.7854 //w=0.233 //l=0.332415 //layer=ply \
 //thickness=0.18 //x=72.01 //y=5.045 //x2=72.27 //y2=4.88
r394 (  108 145 ) resistor r=45.1352 //w=0.168 //l=0.173853 //layer=ply \
 //thickness=0.18 //x=61.32 //y=1.44 //x2=61.28 //y2=1.595
r395 (  107 144 ) resistor r=45.1352 //w=0.168 //l=0.173853 //layer=ply \
 //thickness=0.18 //x=61.32 //y=1.095 //x2=61.28 //y2=0.94
r396 (  107 108 ) resistor r=176.904 //w=0.094 //l=0.345 //layer=ply \
 //thickness=0.18 //x=61.32 //y=1.095 //x2=61.32 //y2=1.44
r397 (  105 141 ) resistor r=10.701 //w=0.21 //l=0.115 //layer=ply \
 //thickness=0.18 //x=60.945 //y=1.595 //x2=60.83 //y2=1.595
r398 (  104 145 ) resistor r=5.52526 //w=0.168 //l=0.115 //layer=ply \
 //thickness=0.18 //x=61.165 //y=1.595 //x2=61.28 //y2=1.595
r399 (  103 140 ) resistor r=5.52526 //w=0.168 //l=0.115 //layer=ply \
 //thickness=0.18 //x=60.945 //y=0.94 //x2=60.83 //y2=0.94
r400 (  102 144 ) resistor r=5.52526 //w=0.168 //l=0.115 //layer=ply \
 //thickness=0.18 //x=61.165 //y=0.94 //x2=61.28 //y2=0.94
r401 (  102 103 ) resistor r=112.809 //w=0.094 //l=0.22 //layer=ply \
 //thickness=0.18 //x=61.165 //y=0.94 //x2=60.945 //y2=0.94
r402 (  99 143 ) resistor r=37.236 //w=0.233 //l=0.249199 //layer=ply \
 //thickness=0.18 //x=60.98 //y=5.045 //x2=60.8 //y2=4.88
r403 (  97 141 ) resistor r=39.5823 //w=0.21 //l=0.173853 //layer=ply \
 //thickness=0.18 //x=60.79 //y=1.75 //x2=60.83 //y2=1.595
r404 (  97 138 ) resistor r=176.904 //w=0.094 //l=0.345 //layer=ply \
 //thickness=0.18 //x=60.79 //y=1.75 //x2=60.79 //y2=2.095
r405 (  96 141 ) resistor r=39.5823 //w=0.21 //l=0.173853 //layer=ply \
 //thickness=0.18 //x=60.79 //y=1.44 //x2=60.83 //y2=1.595
r406 (  95 140 ) resistor r=45.1352 //w=0.168 //l=0.173853 //layer=ply \
 //thickness=0.18 //x=60.79 //y=1.095 //x2=60.83 //y2=0.94
r407 (  95 96 ) resistor r=176.904 //w=0.094 //l=0.345 //layer=ply \
 //thickness=0.18 //x=60.79 //y=1.095 //x2=60.79 //y2=1.44
r408 (  92 143 ) resistor r=53.7854 //w=0.233 //l=0.332415 //layer=ply \
 //thickness=0.18 //x=60.54 //y=5.045 //x2=60.8 //y2=4.88
r409 (  91 135 ) resistor r=45.1352 //w=0.168 //l=0.173853 //layer=ply \
 //thickness=0.18 //x=56.51 //y=1.44 //x2=56.47 //y2=1.595
r410 (  90 134 ) resistor r=45.1352 //w=0.168 //l=0.173853 //layer=ply \
 //thickness=0.18 //x=56.51 //y=1.095 //x2=56.47 //y2=0.94
r411 (  90 91 ) resistor r=176.904 //w=0.094 //l=0.345 //layer=ply \
 //thickness=0.18 //x=56.51 //y=1.095 //x2=56.51 //y2=1.44
r412 (  88 131 ) resistor r=10.701 //w=0.21 //l=0.115 //layer=ply \
 //thickness=0.18 //x=56.135 //y=1.595 //x2=56.02 //y2=1.595
r413 (  87 135 ) resistor r=5.52526 //w=0.168 //l=0.115 //layer=ply \
 //thickness=0.18 //x=56.355 //y=1.595 //x2=56.47 //y2=1.595
r414 (  86 130 ) resistor r=5.52526 //w=0.168 //l=0.115 //layer=ply \
 //thickness=0.18 //x=56.135 //y=0.94 //x2=56.02 //y2=0.94
r415 (  85 134 ) resistor r=5.52526 //w=0.168 //l=0.115 //layer=ply \
 //thickness=0.18 //x=56.355 //y=0.94 //x2=56.47 //y2=0.94
r416 (  85 86 ) resistor r=112.809 //w=0.094 //l=0.22 //layer=ply \
 //thickness=0.18 //x=56.355 //y=0.94 //x2=56.135 //y2=0.94
r417 (  82 133 ) resistor r=37.236 //w=0.233 //l=0.249199 //layer=ply \
 //thickness=0.18 //x=56.17 //y=5.045 //x2=55.99 //y2=4.88
r418 (  80 131 ) resistor r=39.5823 //w=0.21 //l=0.173853 //layer=ply \
 //thickness=0.18 //x=55.98 //y=1.75 //x2=56.02 //y2=1.595
r419 (  80 128 ) resistor r=176.904 //w=0.094 //l=0.345 //layer=ply \
 //thickness=0.18 //x=55.98 //y=1.75 //x2=55.98 //y2=2.095
r420 (  79 131 ) resistor r=39.5823 //w=0.21 //l=0.173853 //layer=ply \
 //thickness=0.18 //x=55.98 //y=1.44 //x2=56.02 //y2=1.595
r421 (  78 130 ) resistor r=45.1352 //w=0.168 //l=0.173853 //layer=ply \
 //thickness=0.18 //x=55.98 //y=1.095 //x2=56.02 //y2=0.94
r422 (  78 79 ) resistor r=176.904 //w=0.094 //l=0.345 //layer=ply \
 //thickness=0.18 //x=55.98 //y=1.095 //x2=55.98 //y2=1.44
r423 (  75 133 ) resistor r=53.7854 //w=0.233 //l=0.332415 //layer=ply \
 //thickness=0.18 //x=55.73 //y=5.045 //x2=55.99 //y2=4.88
r424 (  74 116 ) resistor r=592.245 //w=0.094 //l=1.155 //layer=ply \
 //thickness=0.18 //x=72.45 //y=6.2 //x2=72.45 //y2=5.045
r425 (  73 109 ) resistor r=592.245 //w=0.094 //l=1.155 //layer=ply \
 //thickness=0.18 //x=72.01 //y=6.2 //x2=72.01 //y2=5.045
r426 (  72 99 ) resistor r=592.245 //w=0.094 //l=1.155 //layer=ply \
 //thickness=0.18 //x=60.98 //y=6.2 //x2=60.98 //y2=5.045
r427 (  71 92 ) resistor r=592.245 //w=0.094 //l=1.155 //layer=ply \
 //thickness=0.18 //x=60.54 //y=6.2 //x2=60.54 //y2=5.045
r428 (  70 82 ) resistor r=592.245 //w=0.094 //l=1.155 //layer=ply \
 //thickness=0.18 //x=56.17 //y=6.2 //x2=56.17 //y2=5.045
r429 (  69 75 ) resistor r=592.245 //w=0.094 //l=1.155 //layer=ply \
 //thickness=0.18 //x=55.73 //y=6.2 //x2=55.73 //y2=5.045
r430 (  68 121 ) resistor r=56.4043 //w=0.094 //l=0.11 //layer=ply \
 //thickness=0.18 //x=72.525 //y=1.595 //x2=72.635 //y2=1.595
r431 (  68 122 ) resistor r=56.4043 //w=0.094 //l=0.11 //layer=ply \
 //thickness=0.18 //x=72.525 //y=1.595 //x2=72.415 //y2=1.595
r432 (  67 104 ) resistor r=56.4043 //w=0.094 //l=0.11 //layer=ply \
 //thickness=0.18 //x=61.055 //y=1.595 //x2=61.165 //y2=1.595
r433 (  67 105 ) resistor r=56.4043 //w=0.094 //l=0.11 //layer=ply \
 //thickness=0.18 //x=61.055 //y=1.595 //x2=60.945 //y2=1.595
r434 (  66 87 ) resistor r=56.4043 //w=0.094 //l=0.11 //layer=ply \
 //thickness=0.18 //x=56.245 //y=1.595 //x2=56.355 //y2=1.595
r435 (  66 88 ) resistor r=56.4043 //w=0.094 //l=0.11 //layer=ply \
 //thickness=0.18 //x=56.245 //y=1.595 //x2=56.135 //y2=1.595
r436 (  63 153 ) resistor r=152 //w=0.17 //l=0.17 //layer=licon //count=1 \
 //x=72.27 //y=4.88 //x2=72.27 //y2=4.88
r437 (  61 63 ) resistor r=68.4492 //w=0.187 //l=1 //layer=li //thickness=0.1 \
 //x=72.27 //y=3.88 //x2=72.27 //y2=4.88
r438 (  58 147 ) resistor r=152 //w=0.17 //l=0.17 //layer=licon //count=1 \
 //x=72.27 //y=2.26 //x2=72.27 //y2=2.26
r439 (  58 61 ) resistor r=110.888 //w=0.187 //l=1.62 //layer=li \
 //thickness=0.1 //x=72.27 //y=2.26 //x2=72.27 //y2=3.88
r440 (  54 56 ) resistor r=96.8556 //w=0.187 //l=1.415 //layer=li \
 //thickness=0.1 //x=64.87 //y=5.295 //x2=64.87 //y2=3.88
r441 (  53 56 ) resistor r=134.16 //w=0.187 //l=1.96 //layer=li \
 //thickness=0.1 //x=64.87 //y=1.92 //x2=64.87 //y2=3.88
r442 (  51 53 ) resistor r=7.15173 //w=0.17 //l=0.120208 //layer=li \
 //thickness=0.1 //x=64.785 //y=1.835 //x2=64.87 //y2=1.92
r443 (  51 52 ) resistor r=18.4813 //w=0.187 //l=0.27 //layer=li \
 //thickness=0.1 //x=64.785 //y=1.835 //x2=64.515 //y2=1.835
r444 (  50 65 ) resistor r=5.4201 //w=0.17 //l=0.085 //layer=li \
 //thickness=0.1 //x=64.475 //y=5.38 //x2=64.39 //y2=5.38
r445 (  49 54 ) resistor r=7.15173 //w=0.17 //l=0.120208 //layer=li \
 //thickness=0.1 //x=64.785 //y=5.38 //x2=64.87 //y2=5.295
r446 (  49 50 ) resistor r=21.2193 //w=0.187 //l=0.31 //layer=li \
 //thickness=0.1 //x=64.785 //y=5.38 //x2=64.475 //y2=5.38
r447 (  45 52 ) resistor r=7.15173 //w=0.17 //l=0.120208 //layer=li \
 //thickness=0.1 //x=64.43 //y=1.75 //x2=64.515 //y2=1.835
r448 (  45 156 ) resistor r=39.016 //w=0.187 //l=0.57 //layer=li \
 //thickness=0.1 //x=64.43 //y=1.75 //x2=64.43 //y2=1.18
r449 (  39 65 ) resistor r=1.40859 //w=0.34 //l=0.085 //layer=li \
 //thickness=0.1 //x=64.39 //y=5.465 //x2=64.39 //y2=5.38
r450 (  39 159 ) resistor r=30.1176 //w=0.187 //l=0.44 //layer=li \
 //thickness=0.1 //x=64.39 //y=5.465 //x2=64.39 //y2=5.905
r451 (  37 65 ) resistor r=5.4201 //w=0.17 //l=0.085 //layer=li \
 //thickness=0.1 //x=64.305 //y=5.38 //x2=64.39 //y2=5.38
r452 (  37 38 ) resistor r=48.5989 //w=0.187 //l=0.71 //layer=li \
 //thickness=0.1 //x=64.305 //y=5.38 //x2=63.595 //y2=5.38
r453 (  31 38 ) resistor r=7.15173 //w=0.17 //l=0.120208 //layer=li \
 //thickness=0.1 //x=63.51 //y=5.465 //x2=63.595 //y2=5.38
r454 (  31 158 ) resistor r=30.1176 //w=0.187 //l=0.44 //layer=li \
 //thickness=0.1 //x=63.51 //y=5.465 //x2=63.51 //y2=5.905
r455 (  29 143 ) resistor r=152 //w=0.17 //l=0.17 //layer=licon //count=1 \
 //x=60.8 //y=4.88 //x2=60.8 //y2=4.88
r456 (  27 29 ) resistor r=68.4492 //w=0.187 //l=1 //layer=li //thickness=0.1 \
 //x=60.8 //y=3.88 //x2=60.8 //y2=4.88
r457 (  24 137 ) resistor r=152 //w=0.17 //l=0.17 //layer=licon //count=1 \
 //x=60.8 //y=2.26 //x2=60.8 //y2=2.26
r458 (  24 27 ) resistor r=110.888 //w=0.187 //l=1.62 //layer=li \
 //thickness=0.1 //x=60.8 //y=2.26 //x2=60.8 //y2=3.88
r459 (  21 133 ) resistor r=152 //w=0.17 //l=0.17 //layer=licon //count=1 \
 //x=55.99 //y=4.88 //x2=55.99 //y2=4.88
r460 (  19 21 ) resistor r=68.4492 //w=0.187 //l=1 //layer=li //thickness=0.1 \
 //x=55.99 //y=3.88 //x2=55.99 //y2=4.88
r461 (  16 127 ) resistor r=152 //w=0.17 //l=0.17 //layer=licon //count=1 \
 //x=55.99 //y=2.26 //x2=55.99 //y2=2.26
r462 (  16 19 ) resistor r=110.888 //w=0.187 //l=1.62 //layer=li \
 //thickness=0.1 //x=55.99 //y=2.26 //x2=55.99 //y2=3.88
r463 (  14 61 ) resistor r=9.3 //w=0.17 //l=0.17 //layer=mcon //count=1 \
 //x=72.27 //y=3.88 //x2=72.27 //y2=3.88
r464 (  12 56 ) resistor r=9.3 //w=0.17 //l=0.17 //layer=mcon //count=1 \
 //x=64.87 //y=3.88 //x2=64.87 //y2=3.88
r465 (  10 27 ) resistor r=9.3 //w=0.17 //l=0.17 //layer=mcon //count=1 \
 //x=60.8 //y=3.88 //x2=60.8 //y2=3.88
r466 (  8 19 ) resistor r=9.3 //w=0.17 //l=0.17 //layer=mcon //count=1 \
 //x=55.99 //y=3.88 //x2=55.99 //y2=3.88
r467 (  6 12 ) resistor r=0.0880901 //w=0.191 //l=0.115 //layer=m1 \
 //thickness=0.36 //x=64.985 //y=3.88 //x2=64.87 //y2=3.88
r468 (  5 14 ) resistor r=0.0717383 //w=0.224 //l=0.115 //layer=m1 \
 //thickness=0.36 //x=72.155 //y=3.88 //x2=72.27 //y2=3.88
r469 (  5 6 ) resistor r=6.8416 //w=0.131 //l=7.17 //layer=m1 //thickness=0.36 \
 //x=72.155 //y=3.88 //x2=64.985 //y2=3.88
r470 (  4 10 ) resistor r=0.0880901 //w=0.191 //l=0.115 //layer=m1 \
 //thickness=0.36 //x=60.915 //y=3.88 //x2=60.8 //y2=3.88
r471 (  3 12 ) resistor r=0.0880901 //w=0.191 //l=0.115 //layer=m1 \
 //thickness=0.36 //x=64.755 //y=3.88 //x2=64.87 //y2=3.88
r472 (  3 4 ) resistor r=3.66412 //w=0.131 //l=3.84 //layer=m1 \
 //thickness=0.36 //x=64.755 //y=3.88 //x2=60.915 //y2=3.88
r473 (  2 8 ) resistor r=0.0717383 //w=0.224 //l=0.115 //layer=m1 \
 //thickness=0.36 //x=56.105 //y=3.88 //x2=55.99 //y2=3.88
r474 (  1 10 ) resistor r=0.0880901 //w=0.191 //l=0.115 //layer=m1 \
 //thickness=0.36 //x=60.685 //y=3.88 //x2=60.8 //y2=3.88
r475 (  1 2 ) resistor r=4.37023 //w=0.131 //l=4.58 //layer=m1 \
 //thickness=0.36 //x=60.685 //y=3.88 //x2=56.105 //y2=3.88
ends PM_TMRDFFSNQX1\%noxref_21

subckt PM_TMRDFFSNQX1\%noxref_22 ( 1 2 13 14 15 23 29 30 37 50 51 52 53 54 )
c91 ( 54 0 ) capacitor c=0.034295f //x=79.475 //y=5.205
c92 ( 53 0 ) capacitor c=0.0174957f //x=78.595 //y=5.205
c93 ( 51 0 ) capacitor c=0.0214849f //x=75.715 //y=5.205
c94 ( 50 0 ) capacitor c=0.0217161f //x=74.835 //y=5.205
c95 ( 49 0 ) capacitor c=0.00115294f //x=78.74 //y=7.09
c96 ( 37 0 ) capacitor c=0.0131238f //x=79.535 //y=7.09
c97 ( 30 0 ) capacitor c=0.00386507f //x=77.945 //y=7.09
c98 ( 29 0 ) capacitor c=0.00951687f //x=78.655 //y=7.09
c99 ( 23 0 ) capacitor c=0.0455351f //x=77.86 //y=5.39
c100 ( 15 0 ) capacitor c=0.00871244f //x=75.86 //y=5.475
c101 ( 14 0 ) capacitor c=0.00290434f //x=75.065 //y=5.39
c102 ( 13 0 ) capacitor c=0.0139202f //x=75.775 //y=5.39
c103 ( 2 0 ) capacitor c=0.0091252f //x=75.975 //y=5.39
c104 ( 1 0 ) capacitor c=0.0484159f //x=77.745 //y=5.39
r105 (  39 54 ) resistor r=5.81818 //w=0.187 //l=0.085 //layer=li \
 //thickness=0.1 //x=79.62 //y=7.005 //x2=79.62 //y2=6.92
r106 (  38 49 ) resistor r=5.4201 //w=0.17 //l=0.085 //layer=li \
 //thickness=0.1 //x=78.825 //y=7.09 //x2=78.74 //y2=7.09
r107 (  37 39 ) resistor r=7.15173 //w=0.17 //l=0.120208 //layer=li \
 //thickness=0.1 //x=79.535 //y=7.09 //x2=79.62 //y2=7.005
r108 (  37 38 ) resistor r=48.5989 //w=0.187 //l=0.71 //layer=li \
 //thickness=0.1 //x=79.535 //y=7.09 //x2=78.825 //y2=7.09
r109 (  31 49 ) resistor r=1.40859 //w=0.34 //l=0.085 //layer=li \
 //thickness=0.1 //x=78.74 //y=7.005 //x2=78.74 //y2=7.09
r110 (  31 53 ) resistor r=5.81818 //w=0.187 //l=0.085 //layer=li \
 //thickness=0.1 //x=78.74 //y=7.005 //x2=78.74 //y2=6.92
r111 (  29 49 ) resistor r=5.4201 //w=0.17 //l=0.085 //layer=li \
 //thickness=0.1 //x=78.655 //y=7.09 //x2=78.74 //y2=7.09
r112 (  29 30 ) resistor r=48.5989 //w=0.187 //l=0.71 //layer=li \
 //thickness=0.1 //x=78.655 //y=7.09 //x2=77.945 //y2=7.09
r113 (  23 52 ) resistor r=58.1818 //w=0.187 //l=0.85 //layer=li \
 //thickness=0.1 //x=77.86 //y=5.39 //x2=77.86 //y2=6.24
r114 (  21 30 ) resistor r=7.15173 //w=0.17 //l=0.120208 //layer=li \
 //thickness=0.1 //x=77.86 //y=7.005 //x2=77.945 //y2=7.09
r115 (  21 52 ) resistor r=5.81818 //w=0.187 //l=0.085 //layer=li \
 //thickness=0.1 //x=77.86 //y=7.005 //x2=77.86 //y2=6.92
r116 (  15 48 ) resistor r=3.57586 //w=0.17 //l=0.125 //layer=li \
 //thickness=0.1 //x=75.86 //y=5.475 //x2=75.86 //y2=5.35
r117 (  15 51 ) resistor r=52.3636 //w=0.187 //l=0.765 //layer=li \
 //thickness=0.1 //x=75.86 //y=5.475 //x2=75.86 //y2=6.24
r118 (  13 48 ) resistor r=3.57586 //w=0.17 //l=0.103078 //layer=li \
 //thickness=0.1 //x=75.775 //y=5.39 //x2=75.86 //y2=5.35
r119 (  13 14 ) resistor r=48.5989 //w=0.187 //l=0.71 //layer=li \
 //thickness=0.1 //x=75.775 //y=5.39 //x2=75.065 //y2=5.39
r120 (  7 14 ) resistor r=7.15173 //w=0.17 //l=0.120208 //layer=li \
 //thickness=0.1 //x=74.98 //y=5.475 //x2=75.065 //y2=5.39
r121 (  7 50 ) resistor r=29.0909 //w=0.187 //l=0.425 //layer=li \
 //thickness=0.1 //x=74.98 //y=5.475 //x2=74.98 //y2=5.9
r122 (  6 23 ) resistor r=9.3 //w=0.17 //l=0.17 //layer=mcon //count=1 \
 //x=77.86 //y=5.39 //x2=77.86 //y2=5.39
r123 (  4 48 ) resistor r=9.3 //w=0.17 //l=0.17 //layer=mcon //count=1 \
 //x=75.86 //y=5.39 //x2=75.86 //y2=5.39
r124 (  2 4 ) resistor r=0.0717383 //w=0.224 //l=0.115 //layer=m1 \
 //thickness=0.36 //x=75.975 //y=5.39 //x2=75.86 //y2=5.39
r125 (  1 6 ) resistor r=0.0717383 //w=0.224 //l=0.115 //layer=m1 \
 //thickness=0.36 //x=77.745 //y=5.39 //x2=77.86 //y2=5.39
r126 (  1 2 ) resistor r=1.68893 //w=0.131 //l=1.77 //layer=m1 \
 //thickness=0.36 //x=77.745 //y=5.39 //x2=75.975 //y2=5.39
ends PM_TMRDFFSNQX1\%noxref_22

subckt PM_TMRDFFSNQX1\%noxref_23 ( 1 2 3 4 5 6 15 17 27 28 35 43 49 50 54 56 \
 64 73 74 75 76 77 78 79 80 81 82 83 84 85 86 91 93 95 101 102 103 104 105 106 \
 110 112 115 116 117 118 122 123 124 125 129 131 137 138 140 141 144 153 166 \
 169 171 172 173 )
c364 ( 173 0 ) capacitor c=0.023087f //x=72.085 //y=5.2
c365 ( 172 0 ) capacitor c=0.023519f //x=71.205 //y=5.2
c366 ( 171 0 ) capacitor c=0.0224735f //x=70.325 //y=5.2
c367 ( 169 0 ) capacitor c=0.0087111f //x=72.335 //y=1.095
c368 ( 166 0 ) capacitor c=0.0655948f //x=78.19 //y=4.885
c369 ( 153 0 ) capacitor c=0.0545009f //x=74.49 //y=2.26
c370 ( 144 0 ) capacitor c=0.0331706f //x=67.49 //y=4.88
c371 ( 141 0 ) capacitor c=0.0279499f //x=67.46 //y=2.095
c372 ( 140 0 ) capacitor c=0.0421676f //x=67.46 //y=2.26
c373 ( 138 0 ) capacitor c=0.0342409f //x=78.525 //y=1.39
c374 ( 137 0 ) capacitor c=0.0187384f //x=78.525 //y=1.045
c375 ( 131 0 ) capacitor c=0.0141797f //x=78.37 //y=1.545
c376 ( 129 0 ) capacitor c=0.0149844f //x=78.37 //y=0.89
c377 ( 125 0 ) capacitor c=0.10193f //x=77.995 //y=2.095
c378 ( 124 0 ) capacitor c=0.0225105f //x=77.995 //y=1.7
c379 ( 123 0 ) capacitor c=0.0234376f //x=77.995 //y=1.39
c380 ( 122 0 ) capacitor c=0.0199343f //x=77.995 //y=1.045
c381 ( 118 0 ) capacitor c=0.0318948f //x=75.195 //y=1.39
c382 ( 117 0 ) capacitor c=0.0187384f //x=75.195 //y=1.045
c383 ( 116 0 ) capacitor c=0.0607141f //x=74.835 //y=4.975
c384 ( 115 0 ) capacitor c=0.0292043f //x=75.125 //y=4.975
c385 ( 112 0 ) capacitor c=0.0157913f //x=75.04 //y=1.545
c386 ( 110 0 ) capacitor c=0.0149844f //x=75.04 //y=0.89
c387 ( 106 0 ) capacitor c=0.0302441f //x=74.665 //y=2.095
c388 ( 105 0 ) capacitor c=0.0238107f //x=74.665 //y=1.7
c389 ( 104 0 ) capacitor c=0.0234352f //x=74.665 //y=1.39
c390 ( 103 0 ) capacitor c=0.0199931f //x=74.665 //y=1.045
c391 ( 102 0 ) capacitor c=0.0429696f //x=68.025 //y=1.43
c392 ( 101 0 ) capacitor c=0.0192208f //x=68.025 //y=1.085
c393 ( 95 0 ) capacitor c=0.0148884f //x=67.87 //y=1.585
c394 ( 93 0 ) capacitor c=0.0157803f //x=67.87 //y=0.93
c395 ( 91 0 ) capacitor c=0.0295235f //x=67.865 //y=4.97
c396 ( 86 0 ) capacitor c=0.0205163f //x=67.495 //y=1.74
c397 ( 85 0 ) capacitor c=0.0168481f //x=67.495 //y=1.43
c398 ( 84 0 ) capacitor c=0.0174783f //x=67.495 //y=1.085
c399 ( 83 0 ) capacitor c=0.110336f //x=78.52 //y=6.205
c400 ( 82 0 ) capacitor c=0.154049f //x=78.08 //y=6.205
c401 ( 81 0 ) capacitor c=0.110003f //x=75.2 //y=6.205
c402 ( 80 0 ) capacitor c=0.15424f //x=74.76 //y=6.205
c403 ( 79 0 ) capacitor c=0.15358f //x=67.94 //y=6.2
c404 ( 78 0 ) capacitor c=0.110281f //x=67.5 //y=6.2
c405 ( 74 0 ) capacitor c=0.00106608f //x=72.23 //y=5.335
c406 ( 73 0 ) capacitor c=0.00207319f //x=71.35 //y=5.335
c407 ( 64 0 ) capacitor c=0.117496f //x=78.19 //y=2.26
c408 ( 56 0 ) capacitor c=0.0977815f //x=74.49 //y=2.26
c409 ( 54 0 ) capacitor c=0.107824f //x=73.01 //y=4.62
c410 ( 50 0 ) capacitor c=0.00463522f //x=72.61 //y=1.845
c411 ( 49 0 ) capacitor c=0.0148737f //x=72.925 //y=1.845
c412 ( 43 0 ) capacitor c=0.0281823f //x=72.925 //y=5.335
c413 ( 35 0 ) capacitor c=0.0176454f //x=72.145 //y=5.335
c414 ( 28 0 ) capacitor c=0.00332903f //x=70.555 //y=5.335
c415 ( 27 0 ) capacitor c=0.0148427f //x=71.265 //y=5.335
c416 ( 17 0 ) capacitor c=0.0713479f //x=67.46 //y=2.26
c417 ( 15 0 ) capacitor c=0.00369614f //x=67.46 //y=4.715
c418 ( 6 0 ) capacitor c=0.00522811f //x=74.605 //y=4.62
c419 ( 5 0 ) capacitor c=0.085624f //x=78.075 //y=4.62
c420 ( 4 0 ) capacitor c=0.0060226f //x=73.125 //y=4.62
c421 ( 3 0 ) capacitor c=0.0410264f //x=74.375 //y=4.62
c422 ( 2 0 ) capacitor c=0.0120792f //x=67.575 //y=4.62
c423 ( 1 0 ) capacitor c=0.11349f //x=72.895 //y=4.62
r424 (  164 166 ) resistor r=22.7554 //w=0.233 //l=0.11 //layer=ply \
 //thickness=0.18 //x=78.08 //y=4.885 //x2=78.19 //y2=4.885
r425 (  146 147 ) resistor r=32.4568 //w=0.214 //l=0.075 //layer=ply \
 //thickness=0.18 //x=67.49 //y=4.97 //x2=67.49 //y2=5.045
r426 (  144 146 ) resistor r=20.271 //w=0.214 //l=0.09 //layer=ply \
 //thickness=0.18 //x=67.49 //y=4.88 //x2=67.49 //y2=4.97
r427 (  140 141 ) resistor r=52.7279 //w=0.214 //l=0.165 //layer=ply \
 //thickness=0.18 //x=67.46 //y=2.26 //x2=67.46 //y2=2.095
r428 (  138 168 ) resistor r=45.1352 //w=0.168 //l=0.173853 //layer=ply \
 //thickness=0.18 //x=78.525 //y=1.39 //x2=78.485 //y2=1.545
r429 (  137 167 ) resistor r=45.1352 //w=0.168 //l=0.173853 //layer=ply \
 //thickness=0.18 //x=78.525 //y=1.045 //x2=78.485 //y2=0.89
r430 (  137 138 ) resistor r=176.904 //w=0.094 //l=0.345 //layer=ply \
 //thickness=0.18 //x=78.525 //y=1.045 //x2=78.525 //y2=1.39
r431 (  134 166 ) resistor r=68.2661 //w=0.233 //l=0.404166 //layer=ply \
 //thickness=0.18 //x=78.52 //y=5.05 //x2=78.19 //y2=4.885
r432 (  132 163 ) resistor r=10.701 //w=0.21 //l=0.115 //layer=ply \
 //thickness=0.18 //x=78.15 //y=1.545 //x2=78.035 //y2=1.545
r433 (  131 168 ) resistor r=5.52526 //w=0.168 //l=0.115 //layer=ply \
 //thickness=0.18 //x=78.37 //y=1.545 //x2=78.485 //y2=1.545
r434 (  130 162 ) resistor r=5.52526 //w=0.168 //l=0.115 //layer=ply \
 //thickness=0.18 //x=78.15 //y=0.89 //x2=78.035 //y2=0.89
r435 (  129 167 ) resistor r=5.52526 //w=0.168 //l=0.115 //layer=ply \
 //thickness=0.18 //x=78.37 //y=0.89 //x2=78.485 //y2=0.89
r436 (  129 130 ) resistor r=112.809 //w=0.094 //l=0.22 //layer=ply \
 //thickness=0.18 //x=78.37 //y=0.89 //x2=78.15 //y2=0.89
r437 (  126 164 ) resistor r=13.0941 //w=0.233 //l=0.165 //layer=ply \
 //thickness=0.18 //x=78.08 //y=5.05 //x2=78.08 //y2=4.885
r438 (  125 161 ) resistor r=34.8111 //w=0.27 //l=0.264953 //layer=ply \
 //thickness=0.18 //x=77.995 //y=2.095 //x2=78.19 //y2=2.26
r439 (  124 163 ) resistor r=39.5823 //w=0.21 //l=0.173853 //layer=ply \
 //thickness=0.18 //x=77.995 //y=1.7 //x2=78.035 //y2=1.545
r440 (  124 125 ) resistor r=202.543 //w=0.094 //l=0.395 //layer=ply \
 //thickness=0.18 //x=77.995 //y=1.7 //x2=77.995 //y2=2.095
r441 (  123 163 ) resistor r=39.5823 //w=0.21 //l=0.173853 //layer=ply \
 //thickness=0.18 //x=77.995 //y=1.39 //x2=78.035 //y2=1.545
r442 (  122 162 ) resistor r=45.1352 //w=0.168 //l=0.173853 //layer=ply \
 //thickness=0.18 //x=77.995 //y=1.045 //x2=78.035 //y2=0.89
r443 (  122 123 ) resistor r=176.904 //w=0.094 //l=0.345 //layer=ply \
 //thickness=0.18 //x=77.995 //y=1.045 //x2=77.995 //y2=1.39
r444 (  118 159 ) resistor r=45.1352 //w=0.168 //l=0.173853 //layer=ply \
 //thickness=0.18 //x=75.195 //y=1.39 //x2=75.155 //y2=1.545
r445 (  117 158 ) resistor r=45.1352 //w=0.168 //l=0.173853 //layer=ply \
 //thickness=0.18 //x=75.195 //y=1.045 //x2=75.155 //y2=0.89
r446 (  117 118 ) resistor r=176.904 //w=0.094 //l=0.345 //layer=ply \
 //thickness=0.18 //x=75.195 //y=1.045 //x2=75.195 //y2=1.39
r447 (  115 119 ) resistor r=26.9307 //w=0.15 //l=0.106066 //layer=ply \
 //thickness=0.18 //x=75.125 //y=4.975 //x2=75.2 //y2=5.05
r448 (  115 116 ) resistor r=148.702 //w=0.094 //l=0.29 //layer=ply \
 //thickness=0.18 //x=75.125 //y=4.975 //x2=74.835 //y2=4.975
r449 (  113 157 ) resistor r=10.701 //w=0.21 //l=0.115 //layer=ply \
 //thickness=0.18 //x=74.82 //y=1.545 //x2=74.705 //y2=1.545
r450 (  112 159 ) resistor r=5.52526 //w=0.168 //l=0.115 //layer=ply \
 //thickness=0.18 //x=75.04 //y=1.545 //x2=75.155 //y2=1.545
r451 (  111 156 ) resistor r=5.52526 //w=0.168 //l=0.115 //layer=ply \
 //thickness=0.18 //x=74.82 //y=0.89 //x2=74.705 //y2=0.89
r452 (  110 158 ) resistor r=5.52526 //w=0.168 //l=0.115 //layer=ply \
 //thickness=0.18 //x=75.04 //y=0.89 //x2=75.155 //y2=0.89
r453 (  110 111 ) resistor r=112.809 //w=0.094 //l=0.22 //layer=ply \
 //thickness=0.18 //x=75.04 //y=0.89 //x2=74.82 //y2=0.89
r454 (  107 116 ) resistor r=22.1787 //w=0.252 //l=0.106066 //layer=ply \
 //thickness=0.18 //x=74.76 //y=5.05 //x2=74.835 //y2=4.975
r455 (  107 155 ) resistor r=51.6429 //w=0.252 //l=0.34271 //layer=ply \
 //thickness=0.18 //x=74.76 //y=5.05 //x2=74.49 //y2=4.885
r456 (  106 153 ) resistor r=30.4513 //w=0.277 //l=0.243926 //layer=ply \
 //thickness=0.18 //x=74.665 //y=2.095 //x2=74.49 //y2=2.26
r457 (  105 157 ) resistor r=39.5823 //w=0.21 //l=0.173853 //layer=ply \
 //thickness=0.18 //x=74.665 //y=1.7 //x2=74.705 //y2=1.545
r458 (  105 106 ) resistor r=202.543 //w=0.094 //l=0.395 //layer=ply \
 //thickness=0.18 //x=74.665 //y=1.7 //x2=74.665 //y2=2.095
r459 (  104 157 ) resistor r=39.5823 //w=0.21 //l=0.173853 //layer=ply \
 //thickness=0.18 //x=74.665 //y=1.39 //x2=74.705 //y2=1.545
r460 (  103 156 ) resistor r=45.1352 //w=0.168 //l=0.173853 //layer=ply \
 //thickness=0.18 //x=74.665 //y=1.045 //x2=74.705 //y2=0.89
r461 (  103 104 ) resistor r=176.904 //w=0.094 //l=0.345 //layer=ply \
 //thickness=0.18 //x=74.665 //y=1.045 //x2=74.665 //y2=1.39
r462 (  102 151 ) resistor r=45.1352 //w=0.168 //l=0.173853 //layer=ply \
 //thickness=0.18 //x=68.025 //y=1.43 //x2=67.985 //y2=1.585
r463 (  101 150 ) resistor r=45.1352 //w=0.168 //l=0.173853 //layer=ply \
 //thickness=0.18 //x=68.025 //y=1.085 //x2=67.985 //y2=0.93
r464 (  101 102 ) resistor r=176.904 //w=0.094 //l=0.345 //layer=ply \
 //thickness=0.18 //x=68.025 //y=1.085 //x2=68.025 //y2=1.43
r465 (  96 149 ) resistor r=10.701 //w=0.21 //l=0.115 //layer=ply \
 //thickness=0.18 //x=67.65 //y=1.585 //x2=67.535 //y2=1.585
r466 (  95 151 ) resistor r=5.52526 //w=0.168 //l=0.115 //layer=ply \
 //thickness=0.18 //x=67.87 //y=1.585 //x2=67.985 //y2=1.585
r467 (  94 148 ) resistor r=5.52526 //w=0.168 //l=0.115 //layer=ply \
 //thickness=0.18 //x=67.65 //y=0.93 //x2=67.535 //y2=0.93
r468 (  93 150 ) resistor r=5.52526 //w=0.168 //l=0.115 //layer=ply \
 //thickness=0.18 //x=67.87 //y=0.93 //x2=67.985 //y2=0.93
r469 (  93 94 ) resistor r=112.809 //w=0.094 //l=0.22 //layer=ply \
 //thickness=0.18 //x=67.87 //y=0.93 //x2=67.65 //y2=0.93
r470 (  92 146 ) resistor r=16.5046 //w=0.27 //l=0.135 //layer=ply \
 //thickness=0.18 //x=67.625 //y=4.97 //x2=67.49 //y2=4.97
r471 (  91 98 ) resistor r=26.9307 //w=0.15 //l=0.106066 //layer=ply \
 //thickness=0.18 //x=67.865 //y=4.97 //x2=67.94 //y2=5.045
r472 (  91 92 ) resistor r=123.064 //w=0.094 //l=0.24 //layer=ply \
 //thickness=0.18 //x=67.865 //y=4.97 //x2=67.625 //y2=4.97
r473 (  86 149 ) resistor r=39.5823 //w=0.21 //l=0.173853 //layer=ply \
 //thickness=0.18 //x=67.495 //y=1.74 //x2=67.535 //y2=1.585
r474 (  86 141 ) resistor r=182.032 //w=0.094 //l=0.355 //layer=ply \
 //thickness=0.18 //x=67.495 //y=1.74 //x2=67.495 //y2=2.095
r475 (  85 149 ) resistor r=39.5823 //w=0.21 //l=0.173853 //layer=ply \
 //thickness=0.18 //x=67.495 //y=1.43 //x2=67.535 //y2=1.585
r476 (  84 148 ) resistor r=45.1352 //w=0.168 //l=0.173853 //layer=ply \
 //thickness=0.18 //x=67.495 //y=1.085 //x2=67.535 //y2=0.93
r477 (  84 85 ) resistor r=176.904 //w=0.094 //l=0.345 //layer=ply \
 //thickness=0.18 //x=67.495 //y=1.085 //x2=67.495 //y2=1.43
r478 (  83 134 ) resistor r=592.245 //w=0.094 //l=1.155 //layer=ply \
 //thickness=0.18 //x=78.52 //y=6.205 //x2=78.52 //y2=5.05
r479 (  82 126 ) resistor r=592.245 //w=0.094 //l=1.155 //layer=ply \
 //thickness=0.18 //x=78.08 //y=6.205 //x2=78.08 //y2=5.05
r480 (  81 119 ) resistor r=592.245 //w=0.094 //l=1.155 //layer=ply \
 //thickness=0.18 //x=75.2 //y=6.205 //x2=75.2 //y2=5.05
r481 (  80 107 ) resistor r=592.245 //w=0.094 //l=1.155 //layer=ply \
 //thickness=0.18 //x=74.76 //y=6.205 //x2=74.76 //y2=5.05
r482 (  79 98 ) resistor r=592.245 //w=0.094 //l=1.155 //layer=ply \
 //thickness=0.18 //x=67.94 //y=6.2 //x2=67.94 //y2=5.045
r483 (  78 147 ) resistor r=592.245 //w=0.094 //l=1.155 //layer=ply \
 //thickness=0.18 //x=67.5 //y=6.2 //x2=67.5 //y2=5.045
r484 (  77 131 ) resistor r=56.4043 //w=0.094 //l=0.11 //layer=ply \
 //thickness=0.18 //x=78.26 //y=1.545 //x2=78.37 //y2=1.545
r485 (  77 132 ) resistor r=56.4043 //w=0.094 //l=0.11 //layer=ply \
 //thickness=0.18 //x=78.26 //y=1.545 //x2=78.15 //y2=1.545
r486 (  76 112 ) resistor r=56.4043 //w=0.094 //l=0.11 //layer=ply \
 //thickness=0.18 //x=74.93 //y=1.545 //x2=75.04 //y2=1.545
r487 (  76 113 ) resistor r=56.4043 //w=0.094 //l=0.11 //layer=ply \
 //thickness=0.18 //x=74.93 //y=1.545 //x2=74.82 //y2=1.545
r488 (  75 95 ) resistor r=56.4043 //w=0.094 //l=0.11 //layer=ply \
 //thickness=0.18 //x=67.76 //y=1.585 //x2=67.87 //y2=1.585
r489 (  75 96 ) resistor r=56.4043 //w=0.094 //l=0.11 //layer=ply \
 //thickness=0.18 //x=67.76 //y=1.585 //x2=67.65 //y2=1.585
r490 (  72 144 ) resistor r=152 //w=0.17 //l=0.17 //layer=licon //count=1 \
 //x=67.49 //y=4.88 //x2=67.49 //y2=4.88
r491 (  69 166 ) resistor r=152 //w=0.17 //l=0.17 //layer=licon //count=1 \
 //x=78.19 //y=4.885 //x2=78.19 //y2=4.885
r492 (  67 69 ) resistor r=18.139 //w=0.187 //l=0.265 //layer=li \
 //thickness=0.1 //x=78.19 //y=4.62 //x2=78.19 //y2=4.885
r493 (  64 161 ) resistor r=152 //w=0.17 //l=0.17 //layer=licon //count=1 \
 //x=78.19 //y=2.26 //x2=78.19 //y2=2.26
r494 (  64 67 ) resistor r=161.54 //w=0.187 //l=2.36 //layer=li \
 //thickness=0.1 //x=78.19 //y=2.26 //x2=78.19 //y2=4.62
r495 (  61 155 ) resistor r=152 //w=0.17 //l=0.17 //layer=licon //count=1 \
 //x=74.49 //y=4.885 //x2=74.49 //y2=4.885
r496 (  59 61 ) resistor r=18.139 //w=0.187 //l=0.265 //layer=li \
 //thickness=0.1 //x=74.49 //y=4.62 //x2=74.49 //y2=4.885
r497 (  56 153 ) resistor r=152 //w=0.17 //l=0.17 //layer=licon //count=1 \
 //x=74.49 //y=2.26 //x2=74.49 //y2=2.26
r498 (  56 59 ) resistor r=161.54 //w=0.187 //l=2.36 //layer=li \
 //thickness=0.1 //x=74.49 //y=2.26 //x2=74.49 //y2=4.62
r499 (  52 54 ) resistor r=43.123 //w=0.187 //l=0.63 //layer=li \
 //thickness=0.1 //x=73.01 //y=5.25 //x2=73.01 //y2=4.62
r500 (  51 54 ) resistor r=184.128 //w=0.187 //l=2.69 //layer=li \
 //thickness=0.1 //x=73.01 //y=1.93 //x2=73.01 //y2=4.62
r501 (  49 51 ) resistor r=7.15173 //w=0.17 //l=0.120208 //layer=li \
 //thickness=0.1 //x=72.925 //y=1.845 //x2=73.01 //y2=1.93
r502 (  49 50 ) resistor r=21.5615 //w=0.187 //l=0.315 //layer=li \
 //thickness=0.1 //x=72.925 //y=1.845 //x2=72.61 //y2=1.845
r503 (  45 50 ) resistor r=7.15173 //w=0.17 //l=0.120208 //layer=li \
 //thickness=0.1 //x=72.525 //y=1.76 //x2=72.61 //y2=1.845
r504 (  45 169 ) resistor r=39.016 //w=0.187 //l=0.57 //layer=li \
 //thickness=0.1 //x=72.525 //y=1.76 //x2=72.525 //y2=1.19
r505 (  44 74 ) resistor r=5.4201 //w=0.17 //l=0.085 //layer=li \
 //thickness=0.1 //x=72.315 //y=5.335 //x2=72.23 //y2=5.335
r506 (  43 52 ) resistor r=7.15173 //w=0.17 //l=0.120208 //layer=li \
 //thickness=0.1 //x=72.925 //y=5.335 //x2=73.01 //y2=5.25
r507 (  43 44 ) resistor r=41.754 //w=0.187 //l=0.61 //layer=li \
 //thickness=0.1 //x=72.925 //y=5.335 //x2=72.315 //y2=5.335
r508 (  37 74 ) resistor r=1.40859 //w=0.34 //l=0.085 //layer=li \
 //thickness=0.1 //x=72.23 //y=5.42 //x2=72.23 //y2=5.335
r509 (  37 173 ) resistor r=33.1979 //w=0.187 //l=0.485 //layer=li \
 //thickness=0.1 //x=72.23 //y=5.42 //x2=72.23 //y2=5.905
r510 (  36 73 ) resistor r=5.4201 //w=0.17 //l=0.085 //layer=li \
 //thickness=0.1 //x=71.435 //y=5.335 //x2=71.35 //y2=5.335
r511 (  35 74 ) resistor r=5.4201 //w=0.17 //l=0.085 //layer=li \
 //thickness=0.1 //x=72.145 //y=5.335 //x2=72.23 //y2=5.335
r512 (  35 36 ) resistor r=48.5989 //w=0.187 //l=0.71 //layer=li \
 //thickness=0.1 //x=72.145 //y=5.335 //x2=71.435 //y2=5.335
r513 (  29 73 ) resistor r=1.40859 //w=0.34 //l=0.085 //layer=li \
 //thickness=0.1 //x=71.35 //y=5.42 //x2=71.35 //y2=5.335
r514 (  29 172 ) resistor r=33.1979 //w=0.187 //l=0.485 //layer=li \
 //thickness=0.1 //x=71.35 //y=5.42 //x2=71.35 //y2=5.905
r515 (  27 73 ) resistor r=5.4201 //w=0.17 //l=0.085 //layer=li \
 //thickness=0.1 //x=71.265 //y=5.335 //x2=71.35 //y2=5.335
r516 (  27 28 ) resistor r=48.5989 //w=0.187 //l=0.71 //layer=li \
 //thickness=0.1 //x=71.265 //y=5.335 //x2=70.555 //y2=5.335
r517 (  21 28 ) resistor r=7.15173 //w=0.17 //l=0.120208 //layer=li \
 //thickness=0.1 //x=70.47 //y=5.42 //x2=70.555 //y2=5.335
r518 (  21 171 ) resistor r=33.1979 //w=0.187 //l=0.485 //layer=li \
 //thickness=0.1 //x=70.47 //y=5.42 //x2=70.47 //y2=5.905
r519 (  17 140 ) resistor r=152 //w=0.17 //l=0.17 //layer=licon //count=1 \
 //x=67.46 //y=2.26 //x2=67.46 //y2=2.26
r520 (  17 20 ) resistor r=161.54 //w=0.187 //l=2.36 //layer=li \
 //thickness=0.1 //x=67.46 //y=2.26 //x2=67.46 //y2=4.62
r521 (  15 72 ) resistor r=11.4737 //w=0.186 //l=0.172337 //layer=li \
 //thickness=0.1 //x=67.46 //y=4.715 //x2=67.475 //y2=4.88
r522 (  15 20 ) resistor r=6.50267 //w=0.187 //l=0.095 //layer=li \
 //thickness=0.1 //x=67.46 //y=4.715 //x2=67.46 //y2=4.62
r523 (  14 67 ) resistor r=9.3 //w=0.17 //l=0.17 //layer=mcon //count=1 \
 //x=78.19 //y=4.62 //x2=78.19 //y2=4.62
r524 (  12 59 ) resistor r=9.3 //w=0.17 //l=0.17 //layer=mcon //count=1 \
 //x=74.49 //y=4.62 //x2=74.49 //y2=4.62
r525 (  10 54 ) resistor r=9.3 //w=0.17 //l=0.17 //layer=mcon //count=1 \
 //x=73.01 //y=4.62 //x2=73.01 //y2=4.62
r526 (  8 20 ) resistor r=9.3 //w=0.17 //l=0.17 //layer=mcon //count=1 \
 //x=67.46 //y=4.62 //x2=67.46 //y2=4.62
r527 (  6 12 ) resistor r=0.0880901 //w=0.191 //l=0.115 //layer=m1 \
 //thickness=0.36 //x=74.605 //y=4.62 //x2=74.49 //y2=4.62
r528 (  5 14 ) resistor r=0.0717383 //w=0.224 //l=0.115 //layer=m1 \
 //thickness=0.36 //x=78.075 //y=4.62 //x2=78.19 //y2=4.62
r529 (  5 6 ) resistor r=3.31107 //w=0.131 //l=3.47 //layer=m1 \
 //thickness=0.36 //x=78.075 //y=4.62 //x2=74.605 //y2=4.62
r530 (  4 10 ) resistor r=0.0880901 //w=0.191 //l=0.115 //layer=m1 \
 //thickness=0.36 //x=73.125 //y=4.62 //x2=73.01 //y2=4.62
r531 (  3 12 ) resistor r=0.0880901 //w=0.191 //l=0.115 //layer=m1 \
 //thickness=0.36 //x=74.375 //y=4.62 //x2=74.49 //y2=4.62
r532 (  3 4 ) resistor r=1.19275 //w=0.131 //l=1.25 //layer=m1 \
 //thickness=0.36 //x=74.375 //y=4.62 //x2=73.125 //y2=4.62
r533 (  2 8 ) resistor r=0.0717383 //w=0.224 //l=0.115 //layer=m1 \
 //thickness=0.36 //x=67.575 //y=4.62 //x2=67.46 //y2=4.62
r534 (  1 10 ) resistor r=0.0880901 //w=0.191 //l=0.115 //layer=m1 \
 //thickness=0.36 //x=72.895 //y=4.62 //x2=73.01 //y2=4.62
r535 (  1 2 ) resistor r=5.07634 //w=0.131 //l=5.32 //layer=m1 \
 //thickness=0.36 //x=72.895 //y=4.62 //x2=67.575 //y2=4.62
ends PM_TMRDFFSNQX1\%noxref_23

subckt PM_TMRDFFSNQX1\%noxref_24 ( 1 2 3 4 5 6 17 19 29 30 37 45 51 52 56 58 \
 67 75 76 77 78 79 80 81 82 83 84 85 86 87 88 93 95 97 103 104 108 109 110 111 \
 112 114 117 120 121 122 123 124 125 126 127 131 133 136 137 138 139 144 145 \
 148 165 172 174 175 176 )
c474 ( 176 0 ) capacitor c=0.023087f //x=23.245 //y=5.2
c475 ( 175 0 ) capacitor c=0.023519f //x=22.365 //y=5.2
c476 ( 174 0 ) capacitor c=0.0224735f //x=21.485 //y=5.2
c477 ( 172 0 ) capacitor c=0.00872971f //x=23.495 //y=1.095
c478 ( 165 0 ) capacitor c=0.0583848f //x=81.15 //y=2.26
c479 ( 148 0 ) capacitor c=0.0331095f //x=18.65 //y=4.88
c480 ( 145 0 ) capacitor c=0.0279499f //x=18.62 //y=2.095
c481 ( 144 0 ) capacitor c=0.0421676f //x=18.62 //y=2.26
c482 ( 139 0 ) capacitor c=0.0316774f //x=81.855 //y=1.39
c483 ( 138 0 ) capacitor c=0.0187384f //x=81.855 //y=1.045
c484 ( 137 0 ) capacitor c=0.0590362f //x=81.495 //y=4.975
c485 ( 136 0 ) capacitor c=0.0296075f //x=81.785 //y=4.975
c486 ( 133 0 ) capacitor c=0.0157912f //x=81.7 //y=1.545
c487 ( 131 0 ) capacitor c=0.0149844f //x=81.7 //y=0.89
c488 ( 127 0 ) capacitor c=0.0302441f //x=81.325 //y=2.095
c489 ( 126 0 ) capacitor c=0.0234157f //x=81.325 //y=1.7
c490 ( 125 0 ) capacitor c=0.0234376f //x=81.325 //y=1.39
c491 ( 124 0 ) capacitor c=0.0199931f //x=81.325 //y=1.045
c492 ( 123 0 ) capacitor c=0.0962905f //x=79.495 //y=2.095
c493 ( 122 0 ) capacitor c=0.0249466f //x=79.495 //y=1.74
c494 ( 121 0 ) capacitor c=0.0234397f //x=79.495 //y=1.43
c495 ( 120 0 ) capacitor c=0.0193195f //x=79.495 //y=1.085
c496 ( 117 0 ) capacitor c=0.0631944f //x=79.4 //y=5.05
c497 ( 114 0 ) capacitor c=0.0187941f //x=79.34 //y=1.585
c498 ( 112 0 ) capacitor c=0.0157803f //x=79.34 //y=0.93
c499 ( 111 0 ) capacitor c=0.010629f //x=79.035 //y=4.975
c500 ( 110 0 ) capacitor c=0.0194269f //x=79.325 //y=4.975
c501 ( 109 0 ) capacitor c=0.0365717f //x=78.965 //y=1.43
c502 ( 108 0 ) capacitor c=0.0175988f //x=78.965 //y=1.085
c503 ( 104 0 ) capacitor c=0.0429696f //x=19.185 //y=1.43
c504 ( 103 0 ) capacitor c=0.0192208f //x=19.185 //y=1.085
c505 ( 97 0 ) capacitor c=0.0148884f //x=19.03 //y=1.585
c506 ( 95 0 ) capacitor c=0.0157803f //x=19.03 //y=0.93
c507 ( 93 0 ) capacitor c=0.0295235f //x=19.025 //y=4.97
c508 ( 88 0 ) capacitor c=0.0205163f //x=18.655 //y=1.74
c509 ( 87 0 ) capacitor c=0.0168481f //x=18.655 //y=1.43
c510 ( 86 0 ) capacitor c=0.0174783f //x=18.655 //y=1.085
c511 ( 85 0 ) capacitor c=0.110622f //x=81.86 //y=6.205
c512 ( 84 0 ) capacitor c=0.154068f //x=81.42 //y=6.205
c513 ( 83 0 ) capacitor c=0.154291f //x=79.4 //y=6.205
c514 ( 82 0 ) capacitor c=0.110404f //x=78.96 //y=6.205
c515 ( 81 0 ) capacitor c=0.15358f //x=19.1 //y=6.2
c516 ( 80 0 ) capacitor c=0.110281f //x=18.66 //y=6.2
c517 ( 76 0 ) capacitor c=0.00106608f //x=23.39 //y=5.335
c518 ( 75 0 ) capacitor c=0.00207319f //x=22.51 //y=5.335
c519 ( 67 0 ) capacitor c=0.100881f //x=81.15 //y=2.26
c520 ( 58 0 ) capacitor c=0.105667f //x=79.67 //y=2.26
c521 ( 56 0 ) capacitor c=0.110278f //x=24.17 //y=3.51
c522 ( 52 0 ) capacitor c=0.00398962f //x=23.77 //y=1.845
c523 ( 51 0 ) capacitor c=0.0137288f //x=24.085 //y=1.845
c524 ( 45 0 ) capacitor c=0.0284988f //x=24.085 //y=5.335
c525 ( 37 0 ) capacitor c=0.0176454f //x=23.305 //y=5.335
c526 ( 30 0 ) capacitor c=0.00332903f //x=21.715 //y=5.335
c527 ( 29 0 ) capacitor c=0.0148427f //x=22.425 //y=5.335
c528 ( 19 0 ) capacitor c=0.0698389f //x=18.62 //y=2.26
c529 ( 17 0 ) capacitor c=0.00453889f //x=18.62 //y=4.715
c530 ( 6 0 ) capacitor c=0.0112698f //x=79.785 //y=2.26
c531 ( 5 0 ) capacitor c=0.0463273f //x=81.035 //y=2.26
c532 ( 4 0 ) capacitor c=0.00605889f //x=24.285 //y=3.51
c533 ( 3 0 ) capacitor c=0.948787f //x=79.555 //y=3.51
c534 ( 2 0 ) capacitor c=0.0137368f //x=18.735 //y=3.51
c535 ( 1 0 ) capacitor c=0.0790615f //x=24.055 //y=3.51
r536 (  150 151 ) resistor r=32.4568 //w=0.214 //l=0.075 //layer=ply \
 //thickness=0.18 //x=18.65 //y=4.97 //x2=18.65 //y2=5.045
r537 (  148 150 ) resistor r=20.271 //w=0.214 //l=0.09 //layer=ply \
 //thickness=0.18 //x=18.65 //y=4.88 //x2=18.65 //y2=4.97
r538 (  144 145 ) resistor r=52.7279 //w=0.214 //l=0.165 //layer=ply \
 //thickness=0.18 //x=18.62 //y=2.26 //x2=18.62 //y2=2.095
r539 (  139 171 ) resistor r=45.1352 //w=0.168 //l=0.173853 //layer=ply \
 //thickness=0.18 //x=81.855 //y=1.39 //x2=81.815 //y2=1.545
r540 (  138 170 ) resistor r=45.1352 //w=0.168 //l=0.173853 //layer=ply \
 //thickness=0.18 //x=81.855 //y=1.045 //x2=81.815 //y2=0.89
r541 (  138 139 ) resistor r=176.904 //w=0.094 //l=0.345 //layer=ply \
 //thickness=0.18 //x=81.855 //y=1.045 //x2=81.855 //y2=1.39
r542 (  136 140 ) resistor r=26.9307 //w=0.15 //l=0.106066 //layer=ply \
 //thickness=0.18 //x=81.785 //y=4.975 //x2=81.86 //y2=5.05
r543 (  136 137 ) resistor r=148.702 //w=0.094 //l=0.29 //layer=ply \
 //thickness=0.18 //x=81.785 //y=4.975 //x2=81.495 //y2=4.975
r544 (  134 169 ) resistor r=10.701 //w=0.21 //l=0.115 //layer=ply \
 //thickness=0.18 //x=81.48 //y=1.545 //x2=81.365 //y2=1.545
r545 (  133 171 ) resistor r=5.52526 //w=0.168 //l=0.115 //layer=ply \
 //thickness=0.18 //x=81.7 //y=1.545 //x2=81.815 //y2=1.545
r546 (  132 168 ) resistor r=5.52526 //w=0.168 //l=0.115 //layer=ply \
 //thickness=0.18 //x=81.48 //y=0.89 //x2=81.365 //y2=0.89
r547 (  131 170 ) resistor r=5.52526 //w=0.168 //l=0.115 //layer=ply \
 //thickness=0.18 //x=81.7 //y=0.89 //x2=81.815 //y2=0.89
r548 (  131 132 ) resistor r=112.809 //w=0.094 //l=0.22 //layer=ply \
 //thickness=0.18 //x=81.7 //y=0.89 //x2=81.48 //y2=0.89
r549 (  128 137 ) resistor r=22.1787 //w=0.252 //l=0.106066 //layer=ply \
 //thickness=0.18 //x=81.42 //y=5.05 //x2=81.495 //y2=4.975
r550 (  128 167 ) resistor r=51.6429 //w=0.252 //l=0.34271 //layer=ply \
 //thickness=0.18 //x=81.42 //y=5.05 //x2=81.15 //y2=4.885
r551 (  127 165 ) resistor r=30.4513 //w=0.277 //l=0.243926 //layer=ply \
 //thickness=0.18 //x=81.325 //y=2.095 //x2=81.15 //y2=2.26
r552 (  126 169 ) resistor r=39.5823 //w=0.21 //l=0.173853 //layer=ply \
 //thickness=0.18 //x=81.325 //y=1.7 //x2=81.365 //y2=1.545
r553 (  126 127 ) resistor r=202.543 //w=0.094 //l=0.395 //layer=ply \
 //thickness=0.18 //x=81.325 //y=1.7 //x2=81.325 //y2=2.095
r554 (  125 169 ) resistor r=39.5823 //w=0.21 //l=0.173853 //layer=ply \
 //thickness=0.18 //x=81.325 //y=1.39 //x2=81.365 //y2=1.545
r555 (  124 168 ) resistor r=45.1352 //w=0.168 //l=0.173853 //layer=ply \
 //thickness=0.18 //x=81.325 //y=1.045 //x2=81.365 //y2=0.89
r556 (  124 125 ) resistor r=176.904 //w=0.094 //l=0.345 //layer=ply \
 //thickness=0.18 //x=81.325 //y=1.045 //x2=81.325 //y2=1.39
r557 (  123 161 ) resistor r=30.4513 //w=0.277 //l=0.243926 //layer=ply \
 //thickness=0.18 //x=79.495 //y=2.095 //x2=79.67 //y2=2.26
r558 (  122 159 ) resistor r=39.5823 //w=0.21 //l=0.173853 //layer=ply \
 //thickness=0.18 //x=79.495 //y=1.74 //x2=79.455 //y2=1.585
r559 (  122 123 ) resistor r=182.032 //w=0.094 //l=0.355 //layer=ply \
 //thickness=0.18 //x=79.495 //y=1.74 //x2=79.495 //y2=2.095
r560 (  121 159 ) resistor r=39.5823 //w=0.21 //l=0.173853 //layer=ply \
 //thickness=0.18 //x=79.495 //y=1.43 //x2=79.455 //y2=1.585
r561 (  120 158 ) resistor r=45.1352 //w=0.168 //l=0.173853 //layer=ply \
 //thickness=0.18 //x=79.495 //y=1.085 //x2=79.455 //y2=0.93
r562 (  120 121 ) resistor r=176.904 //w=0.094 //l=0.345 //layer=ply \
 //thickness=0.18 //x=79.495 //y=1.085 //x2=79.495 //y2=1.43
r563 (  117 163 ) resistor r=51.6429 //w=0.252 //l=0.34271 //layer=ply \
 //thickness=0.18 //x=79.4 //y=5.05 //x2=79.67 //y2=4.885
r564 (  115 157 ) resistor r=5.52526 //w=0.168 //l=0.115 //layer=ply \
 //thickness=0.18 //x=79.12 //y=1.585 //x2=79.005 //y2=1.585
r565 (  114 159 ) resistor r=10.701 //w=0.21 //l=0.115 //layer=ply \
 //thickness=0.18 //x=79.34 //y=1.585 //x2=79.455 //y2=1.585
r566 (  113 156 ) resistor r=5.52526 //w=0.168 //l=0.115 //layer=ply \
 //thickness=0.18 //x=79.12 //y=0.93 //x2=79.005 //y2=0.93
r567 (  112 158 ) resistor r=5.52526 //w=0.168 //l=0.115 //layer=ply \
 //thickness=0.18 //x=79.34 //y=0.93 //x2=79.455 //y2=0.93
r568 (  112 113 ) resistor r=112.809 //w=0.094 //l=0.22 //layer=ply \
 //thickness=0.18 //x=79.34 //y=0.93 //x2=79.12 //y2=0.93
r569 (  110 117 ) resistor r=22.1787 //w=0.252 //l=0.106066 //layer=ply \
 //thickness=0.18 //x=79.325 //y=4.975 //x2=79.4 //y2=5.05
r570 (  110 111 ) resistor r=148.702 //w=0.094 //l=0.29 //layer=ply \
 //thickness=0.18 //x=79.325 //y=4.975 //x2=79.035 //y2=4.975
r571 (  109 157 ) resistor r=45.1352 //w=0.168 //l=0.173853 //layer=ply \
 //thickness=0.18 //x=78.965 //y=1.43 //x2=79.005 //y2=1.585
r572 (  108 156 ) resistor r=45.1352 //w=0.168 //l=0.173853 //layer=ply \
 //thickness=0.18 //x=78.965 //y=1.085 //x2=79.005 //y2=0.93
r573 (  108 109 ) resistor r=176.904 //w=0.094 //l=0.345 //layer=ply \
 //thickness=0.18 //x=78.965 //y=1.085 //x2=78.965 //y2=1.43
r574 (  105 111 ) resistor r=26.9307 //w=0.15 //l=0.106066 //layer=ply \
 //thickness=0.18 //x=78.96 //y=5.05 //x2=79.035 //y2=4.975
r575 (  104 155 ) resistor r=45.1352 //w=0.168 //l=0.173853 //layer=ply \
 //thickness=0.18 //x=19.185 //y=1.43 //x2=19.145 //y2=1.585
r576 (  103 154 ) resistor r=45.1352 //w=0.168 //l=0.173853 //layer=ply \
 //thickness=0.18 //x=19.185 //y=1.085 //x2=19.145 //y2=0.93
r577 (  103 104 ) resistor r=176.904 //w=0.094 //l=0.345 //layer=ply \
 //thickness=0.18 //x=19.185 //y=1.085 //x2=19.185 //y2=1.43
r578 (  98 153 ) resistor r=10.701 //w=0.21 //l=0.115 //layer=ply \
 //thickness=0.18 //x=18.81 //y=1.585 //x2=18.695 //y2=1.585
r579 (  97 155 ) resistor r=5.52526 //w=0.168 //l=0.115 //layer=ply \
 //thickness=0.18 //x=19.03 //y=1.585 //x2=19.145 //y2=1.585
r580 (  96 152 ) resistor r=5.52526 //w=0.168 //l=0.115 //layer=ply \
 //thickness=0.18 //x=18.81 //y=0.93 //x2=18.695 //y2=0.93
r581 (  95 154 ) resistor r=5.52526 //w=0.168 //l=0.115 //layer=ply \
 //thickness=0.18 //x=19.03 //y=0.93 //x2=19.145 //y2=0.93
r582 (  95 96 ) resistor r=112.809 //w=0.094 //l=0.22 //layer=ply \
 //thickness=0.18 //x=19.03 //y=0.93 //x2=18.81 //y2=0.93
r583 (  94 150 ) resistor r=16.5046 //w=0.27 //l=0.135 //layer=ply \
 //thickness=0.18 //x=18.785 //y=4.97 //x2=18.65 //y2=4.97
r584 (  93 100 ) resistor r=26.9307 //w=0.15 //l=0.106066 //layer=ply \
 //thickness=0.18 //x=19.025 //y=4.97 //x2=19.1 //y2=5.045
r585 (  93 94 ) resistor r=123.064 //w=0.094 //l=0.24 //layer=ply \
 //thickness=0.18 //x=19.025 //y=4.97 //x2=18.785 //y2=4.97
r586 (  88 153 ) resistor r=39.5823 //w=0.21 //l=0.173853 //layer=ply \
 //thickness=0.18 //x=18.655 //y=1.74 //x2=18.695 //y2=1.585
r587 (  88 145 ) resistor r=182.032 //w=0.094 //l=0.355 //layer=ply \
 //thickness=0.18 //x=18.655 //y=1.74 //x2=18.655 //y2=2.095
r588 (  87 153 ) resistor r=39.5823 //w=0.21 //l=0.173853 //layer=ply \
 //thickness=0.18 //x=18.655 //y=1.43 //x2=18.695 //y2=1.585
r589 (  86 152 ) resistor r=45.1352 //w=0.168 //l=0.173853 //layer=ply \
 //thickness=0.18 //x=18.655 //y=1.085 //x2=18.695 //y2=0.93
r590 (  86 87 ) resistor r=176.904 //w=0.094 //l=0.345 //layer=ply \
 //thickness=0.18 //x=18.655 //y=1.085 //x2=18.655 //y2=1.43
r591 (  85 140 ) resistor r=592.245 //w=0.094 //l=1.155 //layer=ply \
 //thickness=0.18 //x=81.86 //y=6.205 //x2=81.86 //y2=5.05
r592 (  84 128 ) resistor r=592.245 //w=0.094 //l=1.155 //layer=ply \
 //thickness=0.18 //x=81.42 //y=6.205 //x2=81.42 //y2=5.05
r593 (  83 117 ) resistor r=592.245 //w=0.094 //l=1.155 //layer=ply \
 //thickness=0.18 //x=79.4 //y=6.205 //x2=79.4 //y2=5.05
r594 (  82 105 ) resistor r=592.245 //w=0.094 //l=1.155 //layer=ply \
 //thickness=0.18 //x=78.96 //y=6.205 //x2=78.96 //y2=5.05
r595 (  81 100 ) resistor r=592.245 //w=0.094 //l=1.155 //layer=ply \
 //thickness=0.18 //x=19.1 //y=6.2 //x2=19.1 //y2=5.045
r596 (  80 151 ) resistor r=592.245 //w=0.094 //l=1.155 //layer=ply \
 //thickness=0.18 //x=18.66 //y=6.2 //x2=18.66 //y2=5.045
r597 (  79 133 ) resistor r=56.4043 //w=0.094 //l=0.11 //layer=ply \
 //thickness=0.18 //x=81.59 //y=1.545 //x2=81.7 //y2=1.545
r598 (  79 134 ) resistor r=56.4043 //w=0.094 //l=0.11 //layer=ply \
 //thickness=0.18 //x=81.59 //y=1.545 //x2=81.48 //y2=1.545
r599 (  78 114 ) resistor r=56.4043 //w=0.094 //l=0.11 //layer=ply \
 //thickness=0.18 //x=79.23 //y=1.585 //x2=79.34 //y2=1.585
r600 (  78 115 ) resistor r=56.4043 //w=0.094 //l=0.11 //layer=ply \
 //thickness=0.18 //x=79.23 //y=1.585 //x2=79.12 //y2=1.585
r601 (  77 97 ) resistor r=56.4043 //w=0.094 //l=0.11 //layer=ply \
 //thickness=0.18 //x=18.92 //y=1.585 //x2=19.03 //y2=1.585
r602 (  77 98 ) resistor r=56.4043 //w=0.094 //l=0.11 //layer=ply \
 //thickness=0.18 //x=18.92 //y=1.585 //x2=18.81 //y2=1.585
r603 (  74 148 ) resistor r=152 //w=0.17 //l=0.17 //layer=licon //count=1 \
 //x=18.65 //y=4.88 //x2=18.65 //y2=4.88
r604 (  71 167 ) resistor r=152 //w=0.17 //l=0.17 //layer=licon //count=1 \
 //x=81.15 //y=4.885 //x2=81.15 //y2=4.885
r605 (  67 165 ) resistor r=152 //w=0.17 //l=0.17 //layer=licon //count=1 \
 //x=81.15 //y=2.26 //x2=81.15 //y2=2.26
r606 (  67 71 ) resistor r=179.679 //w=0.187 //l=2.625 //layer=li \
 //thickness=0.1 //x=81.15 //y=2.26 //x2=81.15 //y2=4.885
r607 (  64 163 ) resistor r=152 //w=0.17 //l=0.17 //layer=licon //count=1 \
 //x=79.67 //y=4.885 //x2=79.67 //y2=4.885
r608 (  62 64 ) resistor r=94.1176 //w=0.187 //l=1.375 //layer=li \
 //thickness=0.1 //x=79.67 //y=3.51 //x2=79.67 //y2=4.885
r609 (  58 161 ) resistor r=152 //w=0.17 //l=0.17 //layer=licon //count=1 \
 //x=79.67 //y=2.26 //x2=79.67 //y2=2.26
r610 (  58 62 ) resistor r=85.5615 //w=0.187 //l=1.25 //layer=li \
 //thickness=0.1 //x=79.67 //y=2.26 //x2=79.67 //y2=3.51
r611 (  54 56 ) resistor r=119.102 //w=0.187 //l=1.74 //layer=li \
 //thickness=0.1 //x=24.17 //y=5.25 //x2=24.17 //y2=3.51
r612 (  53 56 ) resistor r=108.15 //w=0.187 //l=1.58 //layer=li \
 //thickness=0.1 //x=24.17 //y=1.93 //x2=24.17 //y2=3.51
r613 (  51 53 ) resistor r=7.15173 //w=0.17 //l=0.120208 //layer=li \
 //thickness=0.1 //x=24.085 //y=1.845 //x2=24.17 //y2=1.93
r614 (  51 52 ) resistor r=21.5615 //w=0.187 //l=0.315 //layer=li \
 //thickness=0.1 //x=24.085 //y=1.845 //x2=23.77 //y2=1.845
r615 (  47 52 ) resistor r=7.15173 //w=0.17 //l=0.120208 //layer=li \
 //thickness=0.1 //x=23.685 //y=1.76 //x2=23.77 //y2=1.845
r616 (  47 172 ) resistor r=39.016 //w=0.187 //l=0.57 //layer=li \
 //thickness=0.1 //x=23.685 //y=1.76 //x2=23.685 //y2=1.19
r617 (  46 76 ) resistor r=5.4201 //w=0.17 //l=0.085 //layer=li \
 //thickness=0.1 //x=23.475 //y=5.335 //x2=23.39 //y2=5.335
r618 (  45 54 ) resistor r=7.15173 //w=0.17 //l=0.120208 //layer=li \
 //thickness=0.1 //x=24.085 //y=5.335 //x2=24.17 //y2=5.25
r619 (  45 46 ) resistor r=41.754 //w=0.187 //l=0.61 //layer=li \
 //thickness=0.1 //x=24.085 //y=5.335 //x2=23.475 //y2=5.335
r620 (  39 76 ) resistor r=1.40859 //w=0.34 //l=0.085 //layer=li \
 //thickness=0.1 //x=23.39 //y=5.42 //x2=23.39 //y2=5.335
r621 (  39 176 ) resistor r=33.1979 //w=0.187 //l=0.485 //layer=li \
 //thickness=0.1 //x=23.39 //y=5.42 //x2=23.39 //y2=5.905
r622 (  38 75 ) resistor r=5.4201 //w=0.17 //l=0.085 //layer=li \
 //thickness=0.1 //x=22.595 //y=5.335 //x2=22.51 //y2=5.335
r623 (  37 76 ) resistor r=5.4201 //w=0.17 //l=0.085 //layer=li \
 //thickness=0.1 //x=23.305 //y=5.335 //x2=23.39 //y2=5.335
r624 (  37 38 ) resistor r=48.5989 //w=0.187 //l=0.71 //layer=li \
 //thickness=0.1 //x=23.305 //y=5.335 //x2=22.595 //y2=5.335
r625 (  31 75 ) resistor r=1.40859 //w=0.34 //l=0.085 //layer=li \
 //thickness=0.1 //x=22.51 //y=5.42 //x2=22.51 //y2=5.335
r626 (  31 175 ) resistor r=33.1979 //w=0.187 //l=0.485 //layer=li \
 //thickness=0.1 //x=22.51 //y=5.42 //x2=22.51 //y2=5.905
r627 (  29 75 ) resistor r=5.4201 //w=0.17 //l=0.085 //layer=li \
 //thickness=0.1 //x=22.425 //y=5.335 //x2=22.51 //y2=5.335
r628 (  29 30 ) resistor r=48.5989 //w=0.187 //l=0.71 //layer=li \
 //thickness=0.1 //x=22.425 //y=5.335 //x2=21.715 //y2=5.335
r629 (  23 30 ) resistor r=7.15173 //w=0.17 //l=0.120208 //layer=li \
 //thickness=0.1 //x=21.63 //y=5.42 //x2=21.715 //y2=5.335
r630 (  23 174 ) resistor r=33.1979 //w=0.187 //l=0.485 //layer=li \
 //thickness=0.1 //x=21.63 //y=5.42 //x2=21.63 //y2=5.905
r631 (  19 144 ) resistor r=152 //w=0.17 //l=0.17 //layer=licon //count=1 \
 //x=18.62 //y=2.26 //x2=18.62 //y2=2.26
r632 (  19 22 ) resistor r=85.5615 //w=0.187 //l=1.25 //layer=li \
 //thickness=0.1 //x=18.62 //y=2.26 //x2=18.62 //y2=3.51
r633 (  17 74 ) resistor r=11.4737 //w=0.186 //l=0.172337 //layer=li \
 //thickness=0.1 //x=18.62 //y=4.715 //x2=18.635 //y2=4.88
r634 (  17 22 ) resistor r=82.4813 //w=0.187 //l=1.205 //layer=li \
 //thickness=0.1 //x=18.62 //y=4.715 //x2=18.62 //y2=3.51
r635 (  16 67 ) resistor r=9.3 //w=0.17 //l=0.17 //layer=mcon //count=1 \
 //x=81.15 //y=2.26 //x2=81.15 //y2=2.26
r636 (  14 62 ) resistor r=9.3 //w=0.17 //l=0.17 //layer=mcon //count=1 \
 //x=79.67 //y=3.51 //x2=79.67 //y2=3.51
r637 (  12 58 ) resistor r=9.3 //w=0.17 //l=0.17 //layer=mcon //count=1 \
 //x=79.67 //y=2.26 //x2=79.67 //y2=2.26
r638 (  10 56 ) resistor r=9.3 //w=0.17 //l=0.17 //layer=mcon //count=1 \
 //x=24.17 //y=3.51 //x2=24.17 //y2=3.51
r639 (  8 22 ) resistor r=9.3 //w=0.17 //l=0.17 //layer=mcon //count=1 \
 //x=18.62 //y=3.51 //x2=18.62 //y2=3.51
r640 (  6 12 ) resistor r=0.0717383 //w=0.224 //l=0.115 //layer=m1 \
 //thickness=0.36 //x=79.785 //y=2.26 //x2=79.67 //y2=2.26
r641 (  5 16 ) resistor r=0.0717383 //w=0.224 //l=0.115 //layer=m1 \
 //thickness=0.36 //x=81.035 //y=2.26 //x2=81.15 //y2=2.26
r642 (  5 6 ) resistor r=1.19275 //w=0.131 //l=1.25 //layer=m1 \
 //thickness=0.36 //x=81.035 //y=2.26 //x2=79.785 //y2=2.26
r643 (  4 10 ) resistor r=0.0880901 //w=0.191 //l=0.115 //layer=m1 \
 //thickness=0.36 //x=24.285 //y=3.51 //x2=24.17 //y2=3.51
r644 (  3 14 ) resistor r=0.0717383 //w=0.224 //l=0.115 //layer=m1 \
 //thickness=0.36 //x=79.555 //y=3.51 //x2=79.67 //y2=3.51
r645 (  3 4 ) resistor r=52.7385 //w=0.131 //l=55.27 //layer=m1 \
 //thickness=0.36 //x=79.555 //y=3.51 //x2=24.285 //y2=3.51
r646 (  2 8 ) resistor r=0.0717383 //w=0.224 //l=0.115 //layer=m1 \
 //thickness=0.36 //x=18.735 //y=3.51 //x2=18.62 //y2=3.51
r647 (  1 10 ) resistor r=0.0880901 //w=0.191 //l=0.115 //layer=m1 \
 //thickness=0.36 //x=24.055 //y=3.51 //x2=24.17 //y2=3.51
r648 (  1 2 ) resistor r=5.07634 //w=0.131 //l=5.32 //layer=m1 \
 //thickness=0.36 //x=24.055 //y=3.51 //x2=18.735 //y2=3.51
ends PM_TMRDFFSNQX1\%noxref_24

subckt PM_TMRDFFSNQX1\%noxref_25 ( 1 2 13 14 15 21 27 28 35 46 47 48 49 50 )
c90 ( 50 0 ) capacitor c=0.0306574f //x=82.815 //y=5.205
c91 ( 49 0 ) capacitor c=0.0173945f //x=81.935 //y=5.205
c92 ( 47 0 ) capacitor c=0.0169278f //x=79.035 //y=5.205
c93 ( 46 0 ) capacitor c=0.0166762f //x=78.155 //y=5.205
c94 ( 45 0 ) capacitor c=0.00115294f //x=82.08 //y=7.09
c95 ( 35 0 ) capacitor c=0.0132983f //x=82.875 //y=7.09
c96 ( 28 0 ) capacitor c=0.00388794f //x=81.285 //y=7.09
c97 ( 27 0 ) capacitor c=0.00985708f //x=81.995 //y=7.09
c98 ( 21 0 ) capacitor c=0.0442221f //x=81.2 //y=5.39
c99 ( 15 0 ) capacitor c=0.0105083f //x=79.18 //y=5.475
c100 ( 14 0 ) capacitor c=0.00227812f //x=78.385 //y=5.39
c101 ( 13 0 ) capacitor c=0.0174384f //x=79.095 //y=5.39
c102 ( 2 0 ) capacitor c=0.00682032f //x=79.295 //y=5.39
c103 ( 1 0 ) capacitor c=0.0573196f //x=81.085 //y=5.39
r104 (  37 50 ) resistor r=5.81818 //w=0.187 //l=0.085 //layer=li \
 //thickness=0.1 //x=82.96 //y=7.005 //x2=82.96 //y2=6.92
r105 (  36 45 ) resistor r=5.4201 //w=0.17 //l=0.085 //layer=li \
 //thickness=0.1 //x=82.165 //y=7.09 //x2=82.08 //y2=7.09
r106 (  35 37 ) resistor r=7.15173 //w=0.17 //l=0.120208 //layer=li \
 //thickness=0.1 //x=82.875 //y=7.09 //x2=82.96 //y2=7.005
r107 (  35 36 ) resistor r=48.5989 //w=0.187 //l=0.71 //layer=li \
 //thickness=0.1 //x=82.875 //y=7.09 //x2=82.165 //y2=7.09
r108 (  29 45 ) resistor r=1.40859 //w=0.34 //l=0.085 //layer=li \
 //thickness=0.1 //x=82.08 //y=7.005 //x2=82.08 //y2=7.09
r109 (  29 49 ) resistor r=5.81818 //w=0.187 //l=0.085 //layer=li \
 //thickness=0.1 //x=82.08 //y=7.005 //x2=82.08 //y2=6.92
r110 (  27 45 ) resistor r=5.4201 //w=0.17 //l=0.085 //layer=li \
 //thickness=0.1 //x=81.995 //y=7.09 //x2=82.08 //y2=7.09
r111 (  27 28 ) resistor r=48.5989 //w=0.187 //l=0.71 //layer=li \
 //thickness=0.1 //x=81.995 //y=7.09 //x2=81.285 //y2=7.09
r112 (  21 48 ) resistor r=58.1818 //w=0.187 //l=0.85 //layer=li \
 //thickness=0.1 //x=81.2 //y=5.39 //x2=81.2 //y2=6.24
r113 (  19 28 ) resistor r=7.15173 //w=0.17 //l=0.120208 //layer=li \
 //thickness=0.1 //x=81.2 //y=7.005 //x2=81.285 //y2=7.09
r114 (  19 48 ) resistor r=5.81818 //w=0.187 //l=0.085 //layer=li \
 //thickness=0.1 //x=81.2 //y=7.005 //x2=81.2 //y2=6.92
r115 (  15 44 ) resistor r=3.57586 //w=0.17 //l=0.125 //layer=li \
 //thickness=0.1 //x=79.18 //y=5.475 //x2=79.18 //y2=5.35
r116 (  15 47 ) resistor r=52.3636 //w=0.187 //l=0.765 //layer=li \
 //thickness=0.1 //x=79.18 //y=5.475 //x2=79.18 //y2=6.24
r117 (  13 44 ) resistor r=3.57586 //w=0.17 //l=0.103078 //layer=li \
 //thickness=0.1 //x=79.095 //y=5.39 //x2=79.18 //y2=5.35
r118 (  13 14 ) resistor r=48.5989 //w=0.187 //l=0.71 //layer=li \
 //thickness=0.1 //x=79.095 //y=5.39 //x2=78.385 //y2=5.39
r119 (  7 14 ) resistor r=7.15173 //w=0.17 //l=0.120208 //layer=li \
 //thickness=0.1 //x=78.3 //y=5.475 //x2=78.385 //y2=5.39
r120 (  7 46 ) resistor r=29.0909 //w=0.187 //l=0.425 //layer=li \
 //thickness=0.1 //x=78.3 //y=5.475 //x2=78.3 //y2=5.9
r121 (  6 21 ) resistor r=9.3 //w=0.17 //l=0.17 //layer=mcon //count=1 \
 //x=81.2 //y=5.39 //x2=81.2 //y2=5.39
r122 (  4 44 ) resistor r=9.3 //w=0.17 //l=0.17 //layer=mcon //count=1 \
 //x=79.18 //y=5.39 //x2=79.18 //y2=5.39
r123 (  2 4 ) resistor r=0.0717383 //w=0.224 //l=0.115 //layer=m1 \
 //thickness=0.36 //x=79.295 //y=5.39 //x2=79.18 //y2=5.39
r124 (  1 6 ) resistor r=0.0717383 //w=0.224 //l=0.115 //layer=m1 \
 //thickness=0.36 //x=81.085 //y=5.39 //x2=81.2 //y2=5.39
r125 (  1 2 ) resistor r=1.70802 //w=0.131 //l=1.79 //layer=m1 \
 //thickness=0.36 //x=81.085 //y=5.39 //x2=79.295 //y2=5.39
ends PM_TMRDFFSNQX1\%noxref_25

subckt PM_TMRDFFSNQX1\%noxref_26 ( 1 2 3 4 5 6 29 30 43 45 46 50 52 63 64 65 \
 66 67 68 69 70 74 75 76 78 84 85 87 95 96 97 101 102 )
c240 ( 102 0 ) capacitor c=0.0167617f //x=82.375 //y=5.205
c241 ( 101 0 ) capacitor c=0.0164812f //x=81.495 //y=5.205
c242 ( 97 0 ) capacitor c=0.0110092f //x=82.37 //y=1.085
c243 ( 96 0 ) capacitor c=0.0131637f //x=79.04 //y=1.085
c244 ( 95 0 ) capacitor c=0.0131367f //x=75.71 //y=1.085
c245 ( 87 0 ) capacitor c=0.0537799f //x=84.48 //y=2.265
c246 ( 85 0 ) capacitor c=0.0435629f //x=85.12 //y=1.435
c247 ( 84 0 ) capacitor c=0.0200386f //x=85.12 //y=1.09
c248 ( 78 0 ) capacitor c=0.0152946f //x=84.965 //y=1.59
c249 ( 76 0 ) capacitor c=0.0157804f //x=84.965 //y=0.935
c250 ( 75 0 ) capacitor c=0.05065f //x=84.71 //y=4.97
c251 ( 74 0 ) capacitor c=0.0322983f //x=85 //y=4.97
c252 ( 70 0 ) capacitor c=0.0290017f //x=84.59 //y=2.1
c253 ( 69 0 ) capacitor c=0.0250027f //x=84.59 //y=1.745
c254 ( 68 0 ) capacitor c=0.0234316f //x=84.59 //y=1.435
c255 ( 67 0 ) capacitor c=0.0200596f //x=84.59 //y=1.09
c256 ( 66 0 ) capacitor c=0.154218f //x=85.075 //y=6.2
c257 ( 65 0 ) capacitor c=0.154243f //x=84.635 //y=6.2
c258 ( 63 0 ) capacitor c=0.00421476f //x=82.52 //y=5.39
c259 ( 52 0 ) capacitor c=0.094257f //x=84.48 //y=2.265
c260 ( 50 0 ) capacitor c=0.112965f //x=83 //y=4.25
c261 ( 46 0 ) capacitor c=0.00775877f //x=82.645 //y=1.825
c262 ( 45 0 ) capacitor c=0.0161066f //x=82.915 //y=1.825
c263 ( 43 0 ) capacitor c=0.0151634f //x=82.915 //y=5.39
c264 ( 30 0 ) capacitor c=0.0029383f //x=81.725 //y=5.39
c265 ( 29 0 ) capacitor c=0.0155464f //x=82.435 //y=5.39
c266 ( 6 0 ) capacitor c=0.00867855f //x=83.115 //y=4.25
c267 ( 5 0 ) capacitor c=0.0786471f //x=84.365 //y=4.25
c268 ( 4 0 ) capacitor c=0.0054338f //x=79.345 //y=1.36
c269 ( 3 0 ) capacitor c=0.0704773f //x=82.445 //y=1.36
c270 ( 2 0 ) capacitor c=0.0153777f //x=76.015 //y=1.36
c271 ( 1 0 ) capacitor c=0.0651236f //x=79.115 //y=1.36
r272 (  87 88 ) resistor r=17.5563 //w=0.302 //l=0.11 //layer=ply \
 //thickness=0.18 //x=84.48 //y=2.265 //x2=84.59 //y2=2.265
r273 (  85 94 ) resistor r=45.1352 //w=0.168 //l=0.173853 //layer=ply \
 //thickness=0.18 //x=85.12 //y=1.435 //x2=85.08 //y2=1.59
r274 (  84 93 ) resistor r=45.1352 //w=0.168 //l=0.173853 //layer=ply \
 //thickness=0.18 //x=85.12 //y=1.09 //x2=85.08 //y2=0.935
r275 (  84 85 ) resistor r=176.904 //w=0.094 //l=0.345 //layer=ply \
 //thickness=0.18 //x=85.12 //y=1.09 //x2=85.12 //y2=1.435
r276 (  79 92 ) resistor r=10.701 //w=0.21 //l=0.115 //layer=ply \
 //thickness=0.18 //x=84.745 //y=1.59 //x2=84.63 //y2=1.59
r277 (  78 94 ) resistor r=5.52526 //w=0.168 //l=0.115 //layer=ply \
 //thickness=0.18 //x=84.965 //y=1.59 //x2=85.08 //y2=1.59
r278 (  77 91 ) resistor r=5.52526 //w=0.168 //l=0.115 //layer=ply \
 //thickness=0.18 //x=84.745 //y=0.935 //x2=84.63 //y2=0.935
r279 (  76 93 ) resistor r=5.52526 //w=0.168 //l=0.115 //layer=ply \
 //thickness=0.18 //x=84.965 //y=0.935 //x2=85.08 //y2=0.935
r280 (  76 77 ) resistor r=112.809 //w=0.094 //l=0.22 //layer=ply \
 //thickness=0.18 //x=84.965 //y=0.935 //x2=84.745 //y2=0.935
r281 (  74 81 ) resistor r=26.9307 //w=0.15 //l=0.106066 //layer=ply \
 //thickness=0.18 //x=85 //y=4.97 //x2=85.075 //y2=5.045
r282 (  74 75 ) resistor r=148.702 //w=0.094 //l=0.29 //layer=ply \
 //thickness=0.18 //x=85 //y=4.97 //x2=84.71 //y2=4.97
r283 (  71 75 ) resistor r=23.403 //w=0.284 //l=0.106066 //layer=ply \
 //thickness=0.18 //x=84.635 //y=5.045 //x2=84.71 //y2=4.97
r284 (  71 90 ) resistor r=26.3063 //w=0.284 //l=0.229783 //layer=ply \
 //thickness=0.18 //x=84.635 //y=5.045 //x2=84.48 //y2=4.88
r285 (  70 88 ) resistor r=19.1248 //w=0.302 //l=0.165 //layer=ply \
 //thickness=0.18 //x=84.59 //y=2.1 //x2=84.59 //y2=2.265
r286 (  69 92 ) resistor r=39.5823 //w=0.21 //l=0.173853 //layer=ply \
 //thickness=0.18 //x=84.59 //y=1.745 //x2=84.63 //y2=1.59
r287 (  69 70 ) resistor r=182.032 //w=0.094 //l=0.355 //layer=ply \
 //thickness=0.18 //x=84.59 //y=1.745 //x2=84.59 //y2=2.1
r288 (  68 92 ) resistor r=39.5823 //w=0.21 //l=0.173853 //layer=ply \
 //thickness=0.18 //x=84.59 //y=1.435 //x2=84.63 //y2=1.59
r289 (  67 91 ) resistor r=45.1352 //w=0.168 //l=0.173853 //layer=ply \
 //thickness=0.18 //x=84.59 //y=1.09 //x2=84.63 //y2=0.935
r290 (  67 68 ) resistor r=176.904 //w=0.094 //l=0.345 //layer=ply \
 //thickness=0.18 //x=84.59 //y=1.09 //x2=84.59 //y2=1.435
r291 (  66 81 ) resistor r=592.245 //w=0.094 //l=1.155 //layer=ply \
 //thickness=0.18 //x=85.075 //y=6.2 //x2=85.075 //y2=5.045
r292 (  65 71 ) resistor r=592.245 //w=0.094 //l=1.155 //layer=ply \
 //thickness=0.18 //x=84.635 //y=6.2 //x2=84.635 //y2=5.045
r293 (  64 78 ) resistor r=56.4043 //w=0.094 //l=0.11 //layer=ply \
 //thickness=0.18 //x=84.855 //y=1.59 //x2=84.965 //y2=1.59
r294 (  64 79 ) resistor r=56.4043 //w=0.094 //l=0.11 //layer=ply \
 //thickness=0.18 //x=84.855 //y=1.59 //x2=84.745 //y2=1.59
r295 (  62 95 ) resistor r=13.3953 //w=0.172 //l=0.18 //layer=li \
 //thickness=0.1 //x=75.897 //y=1.36 //x2=75.897 //y2=1.18
r296 (  57 90 ) resistor r=152 //w=0.17 //l=0.17 //layer=licon //count=1 \
 //x=84.48 //y=4.88 //x2=84.48 //y2=4.88
r297 (  55 57 ) resistor r=43.123 //w=0.187 //l=0.63 //layer=li \
 //thickness=0.1 //x=84.48 //y=4.25 //x2=84.48 //y2=4.88
r298 (  52 87 ) resistor r=152 //w=0.17 //l=0.17 //layer=licon //count=1 \
 //x=84.48 //y=2.265 //x2=84.48 //y2=2.265
r299 (  52 55 ) resistor r=135.872 //w=0.187 //l=1.985 //layer=li \
 //thickness=0.1 //x=84.48 //y=2.265 //x2=84.48 //y2=4.25
r300 (  48 50 ) resistor r=72.2139 //w=0.187 //l=1.055 //layer=li \
 //thickness=0.1 //x=83 //y=5.305 //x2=83 //y2=4.25
r301 (  47 50 ) resistor r=160.171 //w=0.187 //l=2.34 //layer=li \
 //thickness=0.1 //x=83 //y=1.91 //x2=83 //y2=4.25
r302 (  45 47 ) resistor r=7.15173 //w=0.17 //l=0.120208 //layer=li \
 //thickness=0.1 //x=82.915 //y=1.825 //x2=83 //y2=1.91
r303 (  45 46 ) resistor r=18.4813 //w=0.187 //l=0.27 //layer=li \
 //thickness=0.1 //x=82.915 //y=1.825 //x2=82.645 //y2=1.825
r304 (  44 63 ) resistor r=5.4201 //w=0.17 //l=0.085 //layer=li \
 //thickness=0.1 //x=82.605 //y=5.39 //x2=82.52 //y2=5.39
r305 (  43 48 ) resistor r=7.15173 //w=0.17 //l=0.120208 //layer=li \
 //thickness=0.1 //x=82.915 //y=5.39 //x2=83 //y2=5.305
r306 (  43 44 ) resistor r=21.2193 //w=0.187 //l=0.31 //layer=li \
 //thickness=0.1 //x=82.915 //y=5.39 //x2=82.605 //y2=5.39
r307 (  42 97 ) resistor r=12.3209 //w=0.187 //l=0.18 //layer=li \
 //thickness=0.1 //x=82.56 //y=1.36 //x2=82.56 //y2=1.18
r308 (  37 46 ) resistor r=7.15173 //w=0.17 //l=0.120208 //layer=li \
 //thickness=0.1 //x=82.56 //y=1.74 //x2=82.645 //y2=1.825
r309 (  37 42 ) resistor r=26.0107 //w=0.187 //l=0.38 //layer=li \
 //thickness=0.1 //x=82.56 //y=1.74 //x2=82.56 //y2=1.36
r310 (  31 63 ) resistor r=1.40859 //w=0.34 //l=0.085 //layer=li \
 //thickness=0.1 //x=82.52 //y=5.475 //x2=82.52 //y2=5.39
r311 (  31 102 ) resistor r=29.0909 //w=0.187 //l=0.425 //layer=li \
 //thickness=0.1 //x=82.52 //y=5.475 //x2=82.52 //y2=5.9
r312 (  29 63 ) resistor r=5.4201 //w=0.17 //l=0.085 //layer=li \
 //thickness=0.1 //x=82.435 //y=5.39 //x2=82.52 //y2=5.39
r313 (  29 30 ) resistor r=48.5989 //w=0.187 //l=0.71 //layer=li \
 //thickness=0.1 //x=82.435 //y=5.39 //x2=81.725 //y2=5.39
r314 (  23 30 ) resistor r=7.15173 //w=0.17 //l=0.120208 //layer=li \
 //thickness=0.1 //x=81.64 //y=5.475 //x2=81.725 //y2=5.39
r315 (  23 101 ) resistor r=29.0909 //w=0.187 //l=0.425 //layer=li \
 //thickness=0.1 //x=81.64 //y=5.475 //x2=81.64 //y2=5.9
r316 (  21 96 ) resistor r=12.3209 //w=0.187 //l=0.18 //layer=li \
 //thickness=0.1 //x=79.23 //y=1.36 //x2=79.23 //y2=1.18
r317 (  16 55 ) resistor r=9.3 //w=0.17 //l=0.17 //layer=mcon //count=1 \
 //x=84.48 //y=4.25 //x2=84.48 //y2=4.25
r318 (  14 50 ) resistor r=9.3 //w=0.17 //l=0.17 //layer=mcon //count=1 //x=83 \
 //y=4.25 //x2=83 //y2=4.25
r319 (  12 42 ) resistor r=9.3 //w=0.17 //l=0.17 //layer=mcon //count=1 \
 //x=82.56 //y=1.36 //x2=82.56 //y2=1.36
r320 (  10 21 ) resistor r=9.3 //w=0.17 //l=0.17 //layer=mcon //count=1 \
 //x=79.23 //y=1.36 //x2=79.23 //y2=1.36
r321 (  8 62 ) resistor r=9.3 //w=0.17 //l=0.17 //layer=mcon //count=1 \
 //x=75.9 //y=1.36 //x2=75.9 //y2=1.36
r322 (  6 14 ) resistor r=0.0717383 //w=0.224 //l=0.115 //layer=m1 \
 //thickness=0.36 //x=83.115 //y=4.25 //x2=83 //y2=4.25
r323 (  5 16 ) resistor r=0.0717383 //w=0.224 //l=0.115 //layer=m1 \
 //thickness=0.36 //x=84.365 //y=4.25 //x2=84.48 //y2=4.25
r324 (  5 6 ) resistor r=1.19275 //w=0.131 //l=1.25 //layer=m1 \
 //thickness=0.36 //x=84.365 //y=4.25 //x2=83.115 //y2=4.25
r325 (  4 10 ) resistor r=0.0880901 //w=0.191 //l=0.115 //layer=m1 \
 //thickness=0.36 //x=79.345 //y=1.36 //x2=79.23 //y2=1.36
r326 (  3 12 ) resistor r=0.0717383 //w=0.224 //l=0.115 //layer=m1 \
 //thickness=0.36 //x=82.445 //y=1.36 //x2=82.56 //y2=1.36
r327 (  3 4 ) resistor r=2.95802 //w=0.131 //l=3.1 //layer=m1 //thickness=0.36 \
 //x=82.445 //y=1.36 //x2=79.345 //y2=1.36
r328 (  2 8 ) resistor r=0.0717383 //w=0.224 //l=0.115 //layer=m1 \
 //thickness=0.36 //x=76.015 //y=1.36 //x2=75.9 //y2=1.36
r329 (  1 10 ) resistor r=0.0880901 //w=0.191 //l=0.115 //layer=m1 \
 //thickness=0.36 //x=79.115 //y=1.36 //x2=79.23 //y2=1.36
r330 (  1 2 ) resistor r=2.95802 //w=0.131 //l=3.1 //layer=m1 //thickness=0.36 \
 //x=79.115 //y=1.36 //x2=76.015 //y2=1.36
ends PM_TMRDFFSNQX1\%noxref_26

subckt PM_TMRDFFSNQX1\%noxref_27 ( 1 5 9 10 13 17 29 )
c50 ( 29 0 ) capacitor c=0.0632971f //x=1.05 //y=0.545
c51 ( 17 0 ) capacitor c=0.0072343f //x=3.125 //y=0.795
c52 ( 13 0 ) capacitor c=0.0147753f //x=3.04 //y=0.71
c53 ( 10 0 ) capacitor c=0.00638095f //x=2.155 //y=1.675
c54 ( 9 0 ) capacitor c=0.006761f //x=2.155 //y=0.795
c55 ( 5 0 ) capacitor c=0.02021f //x=2.07 //y=1.76
c56 ( 1 0 ) capacitor c=0.0113547f //x=1.185 //y=1.675
r57 (  17 29 ) resistor r=3.57586 //w=0.17 //l=0.125 //layer=li \
 //thickness=0.1 //x=3.125 //y=0.795 //x2=3.125 //y2=0.67
r58 (  17 29 ) resistor r=18.139 //w=0.187 //l=0.265 //layer=li \
 //thickness=0.1 //x=3.125 //y=0.795 //x2=3.125 //y2=1.06
r59 (  14 29 ) resistor r=3.57586 //w=0.17 //l=0.103078 //layer=li \
 //thickness=0.1 //x=2.24 //y=0.71 //x2=2.155 //y2=0.67
r60 (  14 29 ) resistor r=27.3797 //w=0.187 //l=0.4 //layer=li //thickness=0.1 \
 //x=2.24 //y=0.71 //x2=2.64 //y2=0.71
r61 (  13 29 ) resistor r=3.57586 //w=0.17 //l=0.103078 //layer=li \
 //thickness=0.1 //x=3.04 //y=0.71 //x2=3.125 //y2=0.67
r62 (  13 29 ) resistor r=27.3797 //w=0.187 //l=0.4 //layer=li //thickness=0.1 \
 //x=3.04 //y=0.71 //x2=2.64 //y2=0.71
r63 (  10 29 ) resistor r=3.57586 //w=0.17 //l=0.125 //layer=li \
 //thickness=0.1 //x=2.155 //y=1.675 //x2=2.155 //y2=1.8
r64 (  10 29 ) resistor r=42.0963 //w=0.187 //l=0.615 //layer=li \
 //thickness=0.1 //x=2.155 //y=1.675 //x2=2.155 //y2=1.06
r65 (  9 29 ) resistor r=3.57586 //w=0.17 //l=0.125 //layer=li //thickness=0.1 \
 //x=2.155 //y=0.795 //x2=2.155 //y2=0.67
r66 (  9 29 ) resistor r=18.139 //w=0.187 //l=0.265 //layer=li //thickness=0.1 \
 //x=2.155 //y=0.795 //x2=2.155 //y2=1.06
r67 (  6 29 ) resistor r=3.57586 //w=0.17 //l=0.103078 //layer=li \
 //thickness=0.1 //x=1.27 //y=1.76 //x2=1.185 //y2=1.8
r68 (  6 29 ) resistor r=27.3797 //w=0.187 //l=0.4 //layer=li //thickness=0.1 \
 //x=1.27 //y=1.76 //x2=1.67 //y2=1.76
r69 (  5 29 ) resistor r=3.57586 //w=0.17 //l=0.103078 //layer=li \
 //thickness=0.1 //x=2.07 //y=1.76 //x2=2.155 //y2=1.8
r70 (  5 29 ) resistor r=27.3797 //w=0.187 //l=0.4 //layer=li //thickness=0.1 \
 //x=2.07 //y=1.76 //x2=1.67 //y2=1.76
r71 (  1 29 ) resistor r=3.57586 //w=0.17 //l=0.125 //layer=li //thickness=0.1 \
 //x=1.185 //y=1.675 //x2=1.185 //y2=1.8
r72 (  1 29 ) resistor r=42.0963 //w=0.187 //l=0.615 //layer=li \
 //thickness=0.1 //x=1.185 //y=1.675 //x2=1.185 //y2=1.06
ends PM_TMRDFFSNQX1\%noxref_27

subckt PM_TMRDFFSNQX1\%noxref_28 ( 1 5 9 13 17 35 )
c51 ( 35 0 ) capacitor c=0.0680128f //x=4.275 //y=0.555
c52 ( 17 0 ) capacitor c=0.018806f //x=6.265 //y=1.77
c53 ( 13 0 ) capacitor c=0.0155484f //x=6.265 //y=0.72
c54 ( 9 0 ) capacitor c=0.00678203f //x=5.38 //y=0.805
c55 ( 5 0 ) capacitor c=0.017077f //x=5.295 //y=1.77
c56 ( 1 0 ) capacitor c=0.00729042f //x=4.41 //y=1.685
r57 (  18 35 ) resistor r=5.4201 //w=0.17 //l=0.103078 //layer=li \
 //thickness=0.1 //x=5.465 //y=1.77 //x2=5.38 //y2=1.81
r58 (  18 35 ) resistor r=27.3797 //w=0.187 //l=0.4 //layer=li //thickness=0.1 \
 //x=5.465 //y=1.77 //x2=5.865 //y2=1.77
r59 (  17 35 ) resistor r=0.751729 //w=0.17 //l=0.085 //layer=li \
 //thickness=0.1 //x=6.265 //y=1.77 //x2=6.35 //y2=1.77
r60 (  17 35 ) resistor r=27.3797 //w=0.187 //l=0.4 //layer=li //thickness=0.1 \
 //x=6.265 //y=1.77 //x2=5.865 //y2=1.77
r61 (  14 35 ) resistor r=3.57586 //w=0.17 //l=0.103078 //layer=li \
 //thickness=0.1 //x=5.465 //y=0.72 //x2=5.38 //y2=0.68
r62 (  14 35 ) resistor r=27.3797 //w=0.187 //l=0.4 //layer=li //thickness=0.1 \
 //x=5.465 //y=0.72 //x2=5.865 //y2=0.72
r63 (  13 35 ) resistor r=0.751729 //w=0.17 //l=0.085 //layer=li \
 //thickness=0.1 //x=6.265 //y=0.72 //x2=6.35 //y2=0.72
r64 (  13 35 ) resistor r=27.3797 //w=0.187 //l=0.4 //layer=li //thickness=0.1 \
 //x=6.265 //y=0.72 //x2=5.865 //y2=0.72
r65 (  10 35 ) resistor r=1.40859 //w=0.34 //l=0.125 //layer=li \
 //thickness=0.1 //x=5.38 //y=1.685 //x2=5.38 //y2=1.81
r66 (  10 35 ) resistor r=42.0963 //w=0.187 //l=0.615 //layer=li \
 //thickness=0.1 //x=5.38 //y=1.685 //x2=5.38 //y2=1.07
r67 (  9 35 ) resistor r=3.57586 //w=0.17 //l=0.125 //layer=li //thickness=0.1 \
 //x=5.38 //y=0.805 //x2=5.38 //y2=0.68
r68 (  9 35 ) resistor r=18.139 //w=0.187 //l=0.265 //layer=li //thickness=0.1 \
 //x=5.38 //y=0.805 //x2=5.38 //y2=1.07
r69 (  6 35 ) resistor r=3.57586 //w=0.17 //l=0.103078 //layer=li \
 //thickness=0.1 //x=4.495 //y=1.77 //x2=4.41 //y2=1.81
r70 (  6 35 ) resistor r=27.3797 //w=0.187 //l=0.4 //layer=li //thickness=0.1 \
 //x=4.495 //y=1.77 //x2=4.895 //y2=1.77
r71 (  5 35 ) resistor r=5.4201 //w=0.17 //l=0.103078 //layer=li \
 //thickness=0.1 //x=5.295 //y=1.77 //x2=5.38 //y2=1.81
r72 (  5 35 ) resistor r=27.3797 //w=0.187 //l=0.4 //layer=li //thickness=0.1 \
 //x=5.295 //y=1.77 //x2=4.895 //y2=1.77
r73 (  1 35 ) resistor r=3.57586 //w=0.17 //l=0.125 //layer=li //thickness=0.1 \
 //x=4.41 //y=1.685 //x2=4.41 //y2=1.81
r74 (  1 35 ) resistor r=42.0963 //w=0.187 //l=0.615 //layer=li \
 //thickness=0.1 //x=4.41 //y=1.685 //x2=4.41 //y2=1.07
ends PM_TMRDFFSNQX1\%noxref_28

subckt PM_TMRDFFSNQX1\%noxref_29 ( 1 3 11 15 25 28 29 )
c52 ( 29 0 ) capacitor c=0.041888f //x=6.785 //y=0.555
c53 ( 28 0 ) capacitor c=0.00460056f //x=5.68 //y=1.09
c54 ( 25 0 ) capacitor c=0.00156479f //x=6.92 //y=1.175
c55 ( 15 0 ) capacitor c=0.00737666f //x=7.89 //y=0.805
c56 ( 11 0 ) capacitor c=0.0145763f //x=7.805 //y=0.72
c57 ( 3 0 ) capacitor c=0.00718386f //x=6.92 //y=0.805
c58 ( 1 0 ) capacitor c=0.022715f //x=6.835 //y=1.175
r59 (  15 29 ) resistor r=3.57586 //w=0.17 //l=0.125 //layer=li \
 //thickness=0.1 //x=7.89 //y=0.805 //x2=7.89 //y2=0.68
r60 (  15 29 ) resistor r=18.139 //w=0.187 //l=0.265 //layer=li \
 //thickness=0.1 //x=7.89 //y=0.805 //x2=7.89 //y2=1.07
r61 (  12 29 ) resistor r=3.57586 //w=0.17 //l=0.103078 //layer=li \
 //thickness=0.1 //x=7.005 //y=0.72 //x2=6.92 //y2=0.68
r62 (  12 29 ) resistor r=27.3797 //w=0.187 //l=0.4 //layer=li //thickness=0.1 \
 //x=7.005 //y=0.72 //x2=7.405 //y2=0.72
r63 (  11 29 ) resistor r=3.57586 //w=0.17 //l=0.103078 //layer=li \
 //thickness=0.1 //x=7.805 //y=0.72 //x2=7.89 //y2=0.68
r64 (  11 29 ) resistor r=27.3797 //w=0.187 //l=0.4 //layer=li //thickness=0.1 \
 //x=7.805 //y=0.72 //x2=7.405 //y2=0.72
r65 (  7 25 ) resistor r=5.4201 //w=0.17 //l=0.085 //layer=li //thickness=0.1 \
 //x=6.92 //y=1.26 //x2=6.92 //y2=1.175
r66 (  7 29 ) resistor r=10.2674 //w=0.187 //l=0.15 //layer=li //thickness=0.1 \
 //x=6.92 //y=1.26 //x2=6.92 //y2=1.41
r67 (  4 25 ) resistor r=5.4201 //w=0.17 //l=0.085 //layer=li //thickness=0.1 \
 //x=6.92 //y=1.09 //x2=6.92 //y2=1.175
r68 (  4 29 ) resistor r=1.36898 //w=0.187 //l=0.02 //layer=li //thickness=0.1 \
 //x=6.92 //y=1.09 //x2=6.92 //y2=1.07
r69 (  3 29 ) resistor r=3.57586 //w=0.17 //l=0.125 //layer=li //thickness=0.1 \
 //x=6.92 //y=0.805 //x2=6.92 //y2=0.68
r70 (  3 29 ) resistor r=18.139 //w=0.187 //l=0.265 //layer=li //thickness=0.1 \
 //x=6.92 //y=0.805 //x2=6.92 //y2=1.07
r71 (  2 28 ) resistor r=0.751729 //w=0.17 //l=0.085 //layer=li \
 //thickness=0.1 //x=5.955 //y=1.175 //x2=5.87 //y2=1.175
r72 (  1 25 ) resistor r=1.40859 //w=0.34 //l=0.085 //layer=li //thickness=0.1 \
 //x=6.835 //y=1.175 //x2=6.92 //y2=1.175
r73 (  1 2 ) resistor r=60.2353 //w=0.187 //l=0.88 //layer=li //thickness=0.1 \
 //x=6.835 //y=1.175 //x2=5.955 //y2=1.175
ends PM_TMRDFFSNQX1\%noxref_29

subckt PM_TMRDFFSNQX1\%noxref_30 ( 1 5 9 13 17 35 )
c53 ( 35 0 ) capacitor c=0.0679545f //x=9.085 //y=0.555
c54 ( 17 0 ) capacitor c=0.0193993f //x=11.075 //y=1.77
c55 ( 13 0 ) capacitor c=0.0155066f //x=11.075 //y=0.72
c56 ( 9 0 ) capacitor c=0.00678203f //x=10.19 //y=0.805
c57 ( 5 0 ) capacitor c=0.0174845f //x=10.105 //y=1.77
c58 ( 1 0 ) capacitor c=0.00729042f //x=9.22 //y=1.685
r59 (  18 35 ) resistor r=5.4201 //w=0.17 //l=0.103078 //layer=li \
 //thickness=0.1 //x=10.275 //y=1.77 //x2=10.19 //y2=1.81
r60 (  18 35 ) resistor r=27.3797 //w=0.187 //l=0.4 //layer=li //thickness=0.1 \
 //x=10.275 //y=1.77 //x2=10.675 //y2=1.77
r61 (  17 35 ) resistor r=0.751729 //w=0.17 //l=0.085 //layer=li \
 //thickness=0.1 //x=11.075 //y=1.77 //x2=11.16 //y2=1.77
r62 (  17 35 ) resistor r=27.3797 //w=0.187 //l=0.4 //layer=li //thickness=0.1 \
 //x=11.075 //y=1.77 //x2=10.675 //y2=1.77
r63 (  14 35 ) resistor r=3.57586 //w=0.17 //l=0.103078 //layer=li \
 //thickness=0.1 //x=10.275 //y=0.72 //x2=10.19 //y2=0.68
r64 (  14 35 ) resistor r=27.3797 //w=0.187 //l=0.4 //layer=li //thickness=0.1 \
 //x=10.275 //y=0.72 //x2=10.675 //y2=0.72
r65 (  13 35 ) resistor r=0.751729 //w=0.17 //l=0.085 //layer=li \
 //thickness=0.1 //x=11.075 //y=0.72 //x2=11.16 //y2=0.72
r66 (  13 35 ) resistor r=27.3797 //w=0.187 //l=0.4 //layer=li //thickness=0.1 \
 //x=11.075 //y=0.72 //x2=10.675 //y2=0.72
r67 (  10 35 ) resistor r=1.40859 //w=0.34 //l=0.125 //layer=li \
 //thickness=0.1 //x=10.19 //y=1.685 //x2=10.19 //y2=1.81
r68 (  10 35 ) resistor r=42.0963 //w=0.187 //l=0.615 //layer=li \
 //thickness=0.1 //x=10.19 //y=1.685 //x2=10.19 //y2=1.07
r69 (  9 35 ) resistor r=3.57586 //w=0.17 //l=0.125 //layer=li //thickness=0.1 \
 //x=10.19 //y=0.805 //x2=10.19 //y2=0.68
r70 (  9 35 ) resistor r=18.139 //w=0.187 //l=0.265 //layer=li //thickness=0.1 \
 //x=10.19 //y=0.805 //x2=10.19 //y2=1.07
r71 (  6 35 ) resistor r=3.57586 //w=0.17 //l=0.103078 //layer=li \
 //thickness=0.1 //x=9.305 //y=1.77 //x2=9.22 //y2=1.81
r72 (  6 35 ) resistor r=27.3797 //w=0.187 //l=0.4 //layer=li //thickness=0.1 \
 //x=9.305 //y=1.77 //x2=9.705 //y2=1.77
r73 (  5 35 ) resistor r=5.4201 //w=0.17 //l=0.103078 //layer=li \
 //thickness=0.1 //x=10.105 //y=1.77 //x2=10.19 //y2=1.81
r74 (  5 35 ) resistor r=27.3797 //w=0.187 //l=0.4 //layer=li //thickness=0.1 \
 //x=10.105 //y=1.77 //x2=9.705 //y2=1.77
r75 (  1 35 ) resistor r=3.57586 //w=0.17 //l=0.125 //layer=li //thickness=0.1 \
 //x=9.22 //y=1.685 //x2=9.22 //y2=1.81
r76 (  1 35 ) resistor r=42.0963 //w=0.187 //l=0.615 //layer=li \
 //thickness=0.1 //x=9.22 //y=1.685 //x2=9.22 //y2=1.07
ends PM_TMRDFFSNQX1\%noxref_30

subckt PM_TMRDFFSNQX1\%noxref_31 ( 1 3 11 15 25 28 29 )
c52 ( 29 0 ) capacitor c=0.0414744f //x=11.595 //y=0.555
c53 ( 28 0 ) capacitor c=0.00460343f //x=10.49 //y=1.09
c54 ( 25 0 ) capacitor c=0.00156479f //x=11.73 //y=1.175
c55 ( 15 0 ) capacitor c=0.00737666f //x=12.7 //y=0.805
c56 ( 11 0 ) capacitor c=0.0144274f //x=12.615 //y=0.72
c57 ( 3 0 ) capacitor c=0.00718386f //x=11.73 //y=0.805
c58 ( 1 0 ) capacitor c=0.0218873f //x=11.645 //y=1.175
r59 (  15 29 ) resistor r=3.57586 //w=0.17 //l=0.125 //layer=li \
 //thickness=0.1 //x=12.7 //y=0.805 //x2=12.7 //y2=0.68
r60 (  15 29 ) resistor r=18.139 //w=0.187 //l=0.265 //layer=li \
 //thickness=0.1 //x=12.7 //y=0.805 //x2=12.7 //y2=1.07
r61 (  12 29 ) resistor r=3.57586 //w=0.17 //l=0.103078 //layer=li \
 //thickness=0.1 //x=11.815 //y=0.72 //x2=11.73 //y2=0.68
r62 (  12 29 ) resistor r=27.3797 //w=0.187 //l=0.4 //layer=li //thickness=0.1 \
 //x=11.815 //y=0.72 //x2=12.215 //y2=0.72
r63 (  11 29 ) resistor r=3.57586 //w=0.17 //l=0.103078 //layer=li \
 //thickness=0.1 //x=12.615 //y=0.72 //x2=12.7 //y2=0.68
r64 (  11 29 ) resistor r=27.3797 //w=0.187 //l=0.4 //layer=li //thickness=0.1 \
 //x=12.615 //y=0.72 //x2=12.215 //y2=0.72
r65 (  7 25 ) resistor r=5.4201 //w=0.17 //l=0.085 //layer=li //thickness=0.1 \
 //x=11.73 //y=1.26 //x2=11.73 //y2=1.175
r66 (  7 29 ) resistor r=10.2674 //w=0.187 //l=0.15 //layer=li //thickness=0.1 \
 //x=11.73 //y=1.26 //x2=11.73 //y2=1.41
r67 (  4 25 ) resistor r=5.4201 //w=0.17 //l=0.085 //layer=li //thickness=0.1 \
 //x=11.73 //y=1.09 //x2=11.73 //y2=1.175
r68 (  4 29 ) resistor r=1.36898 //w=0.187 //l=0.02 //layer=li //thickness=0.1 \
 //x=11.73 //y=1.09 //x2=11.73 //y2=1.07
r69 (  3 29 ) resistor r=3.57586 //w=0.17 //l=0.125 //layer=li //thickness=0.1 \
 //x=11.73 //y=0.805 //x2=11.73 //y2=0.68
r70 (  3 29 ) resistor r=18.139 //w=0.187 //l=0.265 //layer=li //thickness=0.1 \
 //x=11.73 //y=0.805 //x2=11.73 //y2=1.07
r71 (  2 28 ) resistor r=0.751729 //w=0.17 //l=0.085 //layer=li \
 //thickness=0.1 //x=10.765 //y=1.175 //x2=10.68 //y2=1.175
r72 (  1 25 ) resistor r=1.40859 //w=0.34 //l=0.085 //layer=li //thickness=0.1 \
 //x=11.645 //y=1.175 //x2=11.73 //y2=1.175
r73 (  1 2 ) resistor r=60.2353 //w=0.187 //l=0.88 //layer=li //thickness=0.1 \
 //x=11.645 //y=1.175 //x2=10.765 //y2=1.175
ends PM_TMRDFFSNQX1\%noxref_31

subckt PM_TMRDFFSNQX1\%noxref_32 ( 1 5 9 10 13 17 29 )
c51 ( 29 0 ) capacitor c=0.0632682f //x=14 //y=0.545
c52 ( 17 0 ) capacitor c=0.00722223f //x=16.075 //y=0.795
c53 ( 13 0 ) capacitor c=0.0145084f //x=15.99 //y=0.71
c54 ( 10 0 ) capacitor c=0.00582081f //x=15.105 //y=1.675
c55 ( 9 0 ) capacitor c=0.006761f //x=15.105 //y=0.795
c56 ( 5 0 ) capacitor c=0.0173046f //x=15.02 //y=1.76
c57 ( 1 0 ) capacitor c=0.00733328f //x=14.135 //y=1.675
r58 (  17 29 ) resistor r=3.57586 //w=0.17 //l=0.125 //layer=li \
 //thickness=0.1 //x=16.075 //y=0.795 //x2=16.075 //y2=0.67
r59 (  17 29 ) resistor r=18.139 //w=0.187 //l=0.265 //layer=li \
 //thickness=0.1 //x=16.075 //y=0.795 //x2=16.075 //y2=1.06
r60 (  14 29 ) resistor r=3.57586 //w=0.17 //l=0.103078 //layer=li \
 //thickness=0.1 //x=15.19 //y=0.71 //x2=15.105 //y2=0.67
r61 (  14 29 ) resistor r=27.3797 //w=0.187 //l=0.4 //layer=li //thickness=0.1 \
 //x=15.19 //y=0.71 //x2=15.59 //y2=0.71
r62 (  13 29 ) resistor r=3.57586 //w=0.17 //l=0.103078 //layer=li \
 //thickness=0.1 //x=15.99 //y=0.71 //x2=16.075 //y2=0.67
r63 (  13 29 ) resistor r=27.3797 //w=0.187 //l=0.4 //layer=li //thickness=0.1 \
 //x=15.99 //y=0.71 //x2=15.59 //y2=0.71
r64 (  10 29 ) resistor r=3.57586 //w=0.17 //l=0.125 //layer=li \
 //thickness=0.1 //x=15.105 //y=1.675 //x2=15.105 //y2=1.8
r65 (  10 29 ) resistor r=42.0963 //w=0.187 //l=0.615 //layer=li \
 //thickness=0.1 //x=15.105 //y=1.675 //x2=15.105 //y2=1.06
r66 (  9 29 ) resistor r=3.57586 //w=0.17 //l=0.125 //layer=li //thickness=0.1 \
 //x=15.105 //y=0.795 //x2=15.105 //y2=0.67
r67 (  9 29 ) resistor r=18.139 //w=0.187 //l=0.265 //layer=li //thickness=0.1 \
 //x=15.105 //y=0.795 //x2=15.105 //y2=1.06
r68 (  6 29 ) resistor r=3.57586 //w=0.17 //l=0.103078 //layer=li \
 //thickness=0.1 //x=14.22 //y=1.76 //x2=14.135 //y2=1.8
r69 (  6 29 ) resistor r=27.3797 //w=0.187 //l=0.4 //layer=li //thickness=0.1 \
 //x=14.22 //y=1.76 //x2=14.62 //y2=1.76
r70 (  5 29 ) resistor r=3.57586 //w=0.17 //l=0.103078 //layer=li \
 //thickness=0.1 //x=15.02 //y=1.76 //x2=15.105 //y2=1.8
r71 (  5 29 ) resistor r=27.3797 //w=0.187 //l=0.4 //layer=li //thickness=0.1 \
 //x=15.02 //y=1.76 //x2=14.62 //y2=1.76
r72 (  1 29 ) resistor r=3.57586 //w=0.17 //l=0.125 //layer=li //thickness=0.1 \
 //x=14.135 //y=1.675 //x2=14.135 //y2=1.8
r73 (  1 29 ) resistor r=42.0963 //w=0.187 //l=0.615 //layer=li \
 //thickness=0.1 //x=14.135 //y=1.675 //x2=14.135 //y2=1.06
ends PM_TMRDFFSNQX1\%noxref_32

subckt PM_TMRDFFSNQX1\%noxref_33 ( 1 5 9 10 13 17 29 )
c51 ( 29 0 ) capacitor c=0.0632684f //x=17.33 //y=0.545
c52 ( 17 0 ) capacitor c=0.0072343f //x=19.405 //y=0.795
c53 ( 13 0 ) capacitor c=0.0145084f //x=19.32 //y=0.71
c54 ( 10 0 ) capacitor c=0.00582081f //x=18.435 //y=1.675
c55 ( 9 0 ) capacitor c=0.006761f //x=18.435 //y=0.795
c56 ( 5 0 ) capacitor c=0.0173046f //x=18.35 //y=1.76
c57 ( 1 0 ) capacitor c=0.00733328f //x=17.465 //y=1.675
r58 (  17 29 ) resistor r=3.57586 //w=0.17 //l=0.125 //layer=li \
 //thickness=0.1 //x=19.405 //y=0.795 //x2=19.405 //y2=0.67
r59 (  17 29 ) resistor r=18.139 //w=0.187 //l=0.265 //layer=li \
 //thickness=0.1 //x=19.405 //y=0.795 //x2=19.405 //y2=1.06
r60 (  14 29 ) resistor r=3.57586 //w=0.17 //l=0.103078 //layer=li \
 //thickness=0.1 //x=18.52 //y=0.71 //x2=18.435 //y2=0.67
r61 (  14 29 ) resistor r=27.3797 //w=0.187 //l=0.4 //layer=li //thickness=0.1 \
 //x=18.52 //y=0.71 //x2=18.92 //y2=0.71
r62 (  13 29 ) resistor r=3.57586 //w=0.17 //l=0.103078 //layer=li \
 //thickness=0.1 //x=19.32 //y=0.71 //x2=19.405 //y2=0.67
r63 (  13 29 ) resistor r=27.3797 //w=0.187 //l=0.4 //layer=li //thickness=0.1 \
 //x=19.32 //y=0.71 //x2=18.92 //y2=0.71
r64 (  10 29 ) resistor r=3.57586 //w=0.17 //l=0.125 //layer=li \
 //thickness=0.1 //x=18.435 //y=1.675 //x2=18.435 //y2=1.8
r65 (  10 29 ) resistor r=42.0963 //w=0.187 //l=0.615 //layer=li \
 //thickness=0.1 //x=18.435 //y=1.675 //x2=18.435 //y2=1.06
r66 (  9 29 ) resistor r=3.57586 //w=0.17 //l=0.125 //layer=li //thickness=0.1 \
 //x=18.435 //y=0.795 //x2=18.435 //y2=0.67
r67 (  9 29 ) resistor r=18.139 //w=0.187 //l=0.265 //layer=li //thickness=0.1 \
 //x=18.435 //y=0.795 //x2=18.435 //y2=1.06
r68 (  6 29 ) resistor r=3.57586 //w=0.17 //l=0.103078 //layer=li \
 //thickness=0.1 //x=17.55 //y=1.76 //x2=17.465 //y2=1.8
r69 (  6 29 ) resistor r=27.3797 //w=0.187 //l=0.4 //layer=li //thickness=0.1 \
 //x=17.55 //y=1.76 //x2=17.95 //y2=1.76
r70 (  5 29 ) resistor r=3.57586 //w=0.17 //l=0.103078 //layer=li \
 //thickness=0.1 //x=18.35 //y=1.76 //x2=18.435 //y2=1.8
r71 (  5 29 ) resistor r=27.3797 //w=0.187 //l=0.4 //layer=li //thickness=0.1 \
 //x=18.35 //y=1.76 //x2=17.95 //y2=1.76
r72 (  1 29 ) resistor r=3.57586 //w=0.17 //l=0.125 //layer=li //thickness=0.1 \
 //x=17.465 //y=1.675 //x2=17.465 //y2=1.8
r73 (  1 29 ) resistor r=42.0963 //w=0.187 //l=0.615 //layer=li \
 //thickness=0.1 //x=17.465 //y=1.675 //x2=17.465 //y2=1.06
ends PM_TMRDFFSNQX1\%noxref_33

subckt PM_TMRDFFSNQX1\%noxref_34 ( 1 5 9 13 17 35 )
c52 ( 35 0 ) capacitor c=0.0673029f //x=20.555 //y=0.555
c53 ( 17 0 ) capacitor c=0.0178286f //x=22.545 //y=1.77
c54 ( 13 0 ) capacitor c=0.0154917f //x=22.545 //y=0.72
c55 ( 9 0 ) capacitor c=0.00678203f //x=21.66 //y=0.805
c56 ( 5 0 ) capacitor c=0.0164013f //x=21.575 //y=1.77
c57 ( 1 0 ) capacitor c=0.00696517f //x=20.69 //y=1.685
r58 (  18 35 ) resistor r=5.4201 //w=0.17 //l=0.103078 //layer=li \
 //thickness=0.1 //x=21.745 //y=1.77 //x2=21.66 //y2=1.81
r59 (  18 35 ) resistor r=27.3797 //w=0.187 //l=0.4 //layer=li //thickness=0.1 \
 //x=21.745 //y=1.77 //x2=22.145 //y2=1.77
r60 (  17 35 ) resistor r=0.751729 //w=0.17 //l=0.085 //layer=li \
 //thickness=0.1 //x=22.545 //y=1.77 //x2=22.63 //y2=1.77
r61 (  17 35 ) resistor r=27.3797 //w=0.187 //l=0.4 //layer=li //thickness=0.1 \
 //x=22.545 //y=1.77 //x2=22.145 //y2=1.77
r62 (  14 35 ) resistor r=3.57586 //w=0.17 //l=0.103078 //layer=li \
 //thickness=0.1 //x=21.745 //y=0.72 //x2=21.66 //y2=0.68
r63 (  14 35 ) resistor r=27.3797 //w=0.187 //l=0.4 //layer=li //thickness=0.1 \
 //x=21.745 //y=0.72 //x2=22.145 //y2=0.72
r64 (  13 35 ) resistor r=0.751729 //w=0.17 //l=0.085 //layer=li \
 //thickness=0.1 //x=22.545 //y=0.72 //x2=22.63 //y2=0.72
r65 (  13 35 ) resistor r=27.3797 //w=0.187 //l=0.4 //layer=li //thickness=0.1 \
 //x=22.545 //y=0.72 //x2=22.145 //y2=0.72
r66 (  10 35 ) resistor r=1.40859 //w=0.34 //l=0.125 //layer=li \
 //thickness=0.1 //x=21.66 //y=1.685 //x2=21.66 //y2=1.81
r67 (  10 35 ) resistor r=42.0963 //w=0.187 //l=0.615 //layer=li \
 //thickness=0.1 //x=21.66 //y=1.685 //x2=21.66 //y2=1.07
r68 (  9 35 ) resistor r=3.57586 //w=0.17 //l=0.125 //layer=li //thickness=0.1 \
 //x=21.66 //y=0.805 //x2=21.66 //y2=0.68
r69 (  9 35 ) resistor r=18.139 //w=0.187 //l=0.265 //layer=li //thickness=0.1 \
 //x=21.66 //y=0.805 //x2=21.66 //y2=1.07
r70 (  6 35 ) resistor r=3.57586 //w=0.17 //l=0.103078 //layer=li \
 //thickness=0.1 //x=20.775 //y=1.77 //x2=20.69 //y2=1.81
r71 (  6 35 ) resistor r=27.3797 //w=0.187 //l=0.4 //layer=li //thickness=0.1 \
 //x=20.775 //y=1.77 //x2=21.175 //y2=1.77
r72 (  5 35 ) resistor r=5.4201 //w=0.17 //l=0.103078 //layer=li \
 //thickness=0.1 //x=21.575 //y=1.77 //x2=21.66 //y2=1.81
r73 (  5 35 ) resistor r=27.3797 //w=0.187 //l=0.4 //layer=li //thickness=0.1 \
 //x=21.575 //y=1.77 //x2=21.175 //y2=1.77
r74 (  1 35 ) resistor r=3.57586 //w=0.17 //l=0.125 //layer=li //thickness=0.1 \
 //x=20.69 //y=1.685 //x2=20.69 //y2=1.81
r75 (  1 35 ) resistor r=42.0963 //w=0.187 //l=0.615 //layer=li \
 //thickness=0.1 //x=20.69 //y=1.685 //x2=20.69 //y2=1.07
ends PM_TMRDFFSNQX1\%noxref_34

subckt PM_TMRDFFSNQX1\%noxref_35 ( 1 3 11 15 25 28 29 )
c52 ( 29 0 ) capacitor c=0.0413887f //x=23.065 //y=0.555
c53 ( 28 0 ) capacitor c=0.00457437f //x=21.96 //y=1.09
c54 ( 25 0 ) capacitor c=0.00156479f //x=23.2 //y=1.175
c55 ( 15 0 ) capacitor c=0.00737666f //x=24.17 //y=0.805
c56 ( 11 0 ) capacitor c=0.0144274f //x=24.085 //y=0.72
c57 ( 3 0 ) capacitor c=0.00718386f //x=23.2 //y=0.805
c58 ( 1 0 ) capacitor c=0.0218873f //x=23.115 //y=1.175
r59 (  15 29 ) resistor r=3.57586 //w=0.17 //l=0.125 //layer=li \
 //thickness=0.1 //x=24.17 //y=0.805 //x2=24.17 //y2=0.68
r60 (  15 29 ) resistor r=18.139 //w=0.187 //l=0.265 //layer=li \
 //thickness=0.1 //x=24.17 //y=0.805 //x2=24.17 //y2=1.07
r61 (  12 29 ) resistor r=3.57586 //w=0.17 //l=0.103078 //layer=li \
 //thickness=0.1 //x=23.285 //y=0.72 //x2=23.2 //y2=0.68
r62 (  12 29 ) resistor r=27.3797 //w=0.187 //l=0.4 //layer=li //thickness=0.1 \
 //x=23.285 //y=0.72 //x2=23.685 //y2=0.72
r63 (  11 29 ) resistor r=3.57586 //w=0.17 //l=0.103078 //layer=li \
 //thickness=0.1 //x=24.085 //y=0.72 //x2=24.17 //y2=0.68
r64 (  11 29 ) resistor r=27.3797 //w=0.187 //l=0.4 //layer=li //thickness=0.1 \
 //x=24.085 //y=0.72 //x2=23.685 //y2=0.72
r65 (  7 25 ) resistor r=5.4201 //w=0.17 //l=0.085 //layer=li //thickness=0.1 \
 //x=23.2 //y=1.26 //x2=23.2 //y2=1.175
r66 (  7 29 ) resistor r=10.2674 //w=0.187 //l=0.15 //layer=li //thickness=0.1 \
 //x=23.2 //y=1.26 //x2=23.2 //y2=1.41
r67 (  4 25 ) resistor r=5.4201 //w=0.17 //l=0.085 //layer=li //thickness=0.1 \
 //x=23.2 //y=1.09 //x2=23.2 //y2=1.175
r68 (  4 29 ) resistor r=1.36898 //w=0.187 //l=0.02 //layer=li //thickness=0.1 \
 //x=23.2 //y=1.09 //x2=23.2 //y2=1.07
r69 (  3 29 ) resistor r=3.57586 //w=0.17 //l=0.125 //layer=li //thickness=0.1 \
 //x=23.2 //y=0.805 //x2=23.2 //y2=0.68
r70 (  3 29 ) resistor r=18.139 //w=0.187 //l=0.265 //layer=li //thickness=0.1 \
 //x=23.2 //y=0.805 //x2=23.2 //y2=1.07
r71 (  2 28 ) resistor r=0.751729 //w=0.17 //l=0.085 //layer=li \
 //thickness=0.1 //x=22.235 //y=1.175 //x2=22.15 //y2=1.175
r72 (  1 25 ) resistor r=1.40859 //w=0.34 //l=0.085 //layer=li //thickness=0.1 \
 //x=23.115 //y=1.175 //x2=23.2 //y2=1.175
r73 (  1 2 ) resistor r=60.2353 //w=0.187 //l=0.88 //layer=li //thickness=0.1 \
 //x=23.115 //y=1.175 //x2=22.235 //y2=1.175
ends PM_TMRDFFSNQX1\%noxref_35

subckt PM_TMRDFFSNQX1\%noxref_36 ( 1 5 9 10 13 17 29 )
c51 ( 29 0 ) capacitor c=0.0633518f //x=25.47 //y=0.545
c52 ( 17 0 ) capacitor c=0.0072343f //x=27.545 //y=0.795
c53 ( 13 0 ) capacitor c=0.0145084f //x=27.46 //y=0.71
c54 ( 10 0 ) capacitor c=0.00582081f //x=26.575 //y=1.675
c55 ( 9 0 ) capacitor c=0.006761f //x=26.575 //y=0.795
c56 ( 5 0 ) capacitor c=0.0173046f //x=26.49 //y=1.76
c57 ( 1 0 ) capacitor c=0.00733328f //x=25.605 //y=1.675
r58 (  17 29 ) resistor r=3.57586 //w=0.17 //l=0.125 //layer=li \
 //thickness=0.1 //x=27.545 //y=0.795 //x2=27.545 //y2=0.67
r59 (  17 29 ) resistor r=18.139 //w=0.187 //l=0.265 //layer=li \
 //thickness=0.1 //x=27.545 //y=0.795 //x2=27.545 //y2=1.06
r60 (  14 29 ) resistor r=3.57586 //w=0.17 //l=0.103078 //layer=li \
 //thickness=0.1 //x=26.66 //y=0.71 //x2=26.575 //y2=0.67
r61 (  14 29 ) resistor r=27.3797 //w=0.187 //l=0.4 //layer=li //thickness=0.1 \
 //x=26.66 //y=0.71 //x2=27.06 //y2=0.71
r62 (  13 29 ) resistor r=3.57586 //w=0.17 //l=0.103078 //layer=li \
 //thickness=0.1 //x=27.46 //y=0.71 //x2=27.545 //y2=0.67
r63 (  13 29 ) resistor r=27.3797 //w=0.187 //l=0.4 //layer=li //thickness=0.1 \
 //x=27.46 //y=0.71 //x2=27.06 //y2=0.71
r64 (  10 29 ) resistor r=3.57586 //w=0.17 //l=0.125 //layer=li \
 //thickness=0.1 //x=26.575 //y=1.675 //x2=26.575 //y2=1.8
r65 (  10 29 ) resistor r=42.0963 //w=0.187 //l=0.615 //layer=li \
 //thickness=0.1 //x=26.575 //y=1.675 //x2=26.575 //y2=1.06
r66 (  9 29 ) resistor r=3.57586 //w=0.17 //l=0.125 //layer=li //thickness=0.1 \
 //x=26.575 //y=0.795 //x2=26.575 //y2=0.67
r67 (  9 29 ) resistor r=18.139 //w=0.187 //l=0.265 //layer=li //thickness=0.1 \
 //x=26.575 //y=0.795 //x2=26.575 //y2=1.06
r68 (  6 29 ) resistor r=3.57586 //w=0.17 //l=0.103078 //layer=li \
 //thickness=0.1 //x=25.69 //y=1.76 //x2=25.605 //y2=1.8
r69 (  6 29 ) resistor r=27.3797 //w=0.187 //l=0.4 //layer=li //thickness=0.1 \
 //x=25.69 //y=1.76 //x2=26.09 //y2=1.76
r70 (  5 29 ) resistor r=3.57586 //w=0.17 //l=0.103078 //layer=li \
 //thickness=0.1 //x=26.49 //y=1.76 //x2=26.575 //y2=1.8
r71 (  5 29 ) resistor r=27.3797 //w=0.187 //l=0.4 //layer=li //thickness=0.1 \
 //x=26.49 //y=1.76 //x2=26.09 //y2=1.76
r72 (  1 29 ) resistor r=3.57586 //w=0.17 //l=0.125 //layer=li //thickness=0.1 \
 //x=25.605 //y=1.675 //x2=25.605 //y2=1.8
r73 (  1 29 ) resistor r=42.0963 //w=0.187 //l=0.615 //layer=li \
 //thickness=0.1 //x=25.605 //y=1.675 //x2=25.605 //y2=1.06
ends PM_TMRDFFSNQX1\%noxref_36

subckt PM_TMRDFFSNQX1\%noxref_37 ( 1 5 9 13 17 35 )
c49 ( 35 0 ) capacitor c=0.0673195f //x=28.695 //y=0.555
c50 ( 17 0 ) capacitor c=0.0178317f //x=30.685 //y=1.77
c51 ( 13 0 ) capacitor c=0.0154936f //x=30.685 //y=0.72
c52 ( 9 0 ) capacitor c=0.00678203f //x=29.8 //y=0.805
c53 ( 5 0 ) capacitor c=0.0164013f //x=29.715 //y=1.77
c54 ( 1 0 ) capacitor c=0.00696517f //x=28.83 //y=1.685
r55 (  18 35 ) resistor r=5.4201 //w=0.17 //l=0.103078 //layer=li \
 //thickness=0.1 //x=29.885 //y=1.77 //x2=29.8 //y2=1.81
r56 (  18 35 ) resistor r=27.3797 //w=0.187 //l=0.4 //layer=li //thickness=0.1 \
 //x=29.885 //y=1.77 //x2=30.285 //y2=1.77
r57 (  17 35 ) resistor r=0.751729 //w=0.17 //l=0.085 //layer=li \
 //thickness=0.1 //x=30.685 //y=1.77 //x2=30.77 //y2=1.77
r58 (  17 35 ) resistor r=27.3797 //w=0.187 //l=0.4 //layer=li //thickness=0.1 \
 //x=30.685 //y=1.77 //x2=30.285 //y2=1.77
r59 (  14 35 ) resistor r=3.57586 //w=0.17 //l=0.103078 //layer=li \
 //thickness=0.1 //x=29.885 //y=0.72 //x2=29.8 //y2=0.68
r60 (  14 35 ) resistor r=27.3797 //w=0.187 //l=0.4 //layer=li //thickness=0.1 \
 //x=29.885 //y=0.72 //x2=30.285 //y2=0.72
r61 (  13 35 ) resistor r=0.751729 //w=0.17 //l=0.085 //layer=li \
 //thickness=0.1 //x=30.685 //y=0.72 //x2=30.77 //y2=0.72
r62 (  13 35 ) resistor r=27.3797 //w=0.187 //l=0.4 //layer=li //thickness=0.1 \
 //x=30.685 //y=0.72 //x2=30.285 //y2=0.72
r63 (  10 35 ) resistor r=1.40859 //w=0.34 //l=0.125 //layer=li \
 //thickness=0.1 //x=29.8 //y=1.685 //x2=29.8 //y2=1.81
r64 (  10 35 ) resistor r=42.0963 //w=0.187 //l=0.615 //layer=li \
 //thickness=0.1 //x=29.8 //y=1.685 //x2=29.8 //y2=1.07
r65 (  9 35 ) resistor r=3.57586 //w=0.17 //l=0.125 //layer=li //thickness=0.1 \
 //x=29.8 //y=0.805 //x2=29.8 //y2=0.68
r66 (  9 35 ) resistor r=18.139 //w=0.187 //l=0.265 //layer=li //thickness=0.1 \
 //x=29.8 //y=0.805 //x2=29.8 //y2=1.07
r67 (  6 35 ) resistor r=3.57586 //w=0.17 //l=0.103078 //layer=li \
 //thickness=0.1 //x=28.915 //y=1.77 //x2=28.83 //y2=1.81
r68 (  6 35 ) resistor r=27.3797 //w=0.187 //l=0.4 //layer=li //thickness=0.1 \
 //x=28.915 //y=1.77 //x2=29.315 //y2=1.77
r69 (  5 35 ) resistor r=5.4201 //w=0.17 //l=0.103078 //layer=li \
 //thickness=0.1 //x=29.715 //y=1.77 //x2=29.8 //y2=1.81
r70 (  5 35 ) resistor r=27.3797 //w=0.187 //l=0.4 //layer=li //thickness=0.1 \
 //x=29.715 //y=1.77 //x2=29.315 //y2=1.77
r71 (  1 35 ) resistor r=3.57586 //w=0.17 //l=0.125 //layer=li //thickness=0.1 \
 //x=28.83 //y=1.685 //x2=28.83 //y2=1.81
r72 (  1 35 ) resistor r=42.0963 //w=0.187 //l=0.615 //layer=li \
 //thickness=0.1 //x=28.83 //y=1.685 //x2=28.83 //y2=1.07
ends PM_TMRDFFSNQX1\%noxref_37

subckt PM_TMRDFFSNQX1\%noxref_38 ( 1 3 11 15 25 28 29 )
c52 ( 29 0 ) capacitor c=0.0414739f //x=31.205 //y=0.555
c53 ( 28 0 ) capacitor c=0.0045748f //x=30.1 //y=1.09
c54 ( 25 0 ) capacitor c=0.00156479f //x=31.34 //y=1.175
c55 ( 15 0 ) capacitor c=0.00737666f //x=32.31 //y=0.805
c56 ( 11 0 ) capacitor c=0.0144274f //x=32.225 //y=0.72
c57 ( 3 0 ) capacitor c=0.00718386f //x=31.34 //y=0.805
c58 ( 1 0 ) capacitor c=0.0218888f //x=31.255 //y=1.175
r59 (  15 29 ) resistor r=3.57586 //w=0.17 //l=0.125 //layer=li \
 //thickness=0.1 //x=32.31 //y=0.805 //x2=32.31 //y2=0.68
r60 (  15 29 ) resistor r=18.139 //w=0.187 //l=0.265 //layer=li \
 //thickness=0.1 //x=32.31 //y=0.805 //x2=32.31 //y2=1.07
r61 (  12 29 ) resistor r=3.57586 //w=0.17 //l=0.103078 //layer=li \
 //thickness=0.1 //x=31.425 //y=0.72 //x2=31.34 //y2=0.68
r62 (  12 29 ) resistor r=27.3797 //w=0.187 //l=0.4 //layer=li //thickness=0.1 \
 //x=31.425 //y=0.72 //x2=31.825 //y2=0.72
r63 (  11 29 ) resistor r=3.57586 //w=0.17 //l=0.103078 //layer=li \
 //thickness=0.1 //x=32.225 //y=0.72 //x2=32.31 //y2=0.68
r64 (  11 29 ) resistor r=27.3797 //w=0.187 //l=0.4 //layer=li //thickness=0.1 \
 //x=32.225 //y=0.72 //x2=31.825 //y2=0.72
r65 (  7 25 ) resistor r=5.4201 //w=0.17 //l=0.085 //layer=li //thickness=0.1 \
 //x=31.34 //y=1.26 //x2=31.34 //y2=1.175
r66 (  7 29 ) resistor r=10.2674 //w=0.187 //l=0.15 //layer=li //thickness=0.1 \
 //x=31.34 //y=1.26 //x2=31.34 //y2=1.41
r67 (  4 25 ) resistor r=5.4201 //w=0.17 //l=0.085 //layer=li //thickness=0.1 \
 //x=31.34 //y=1.09 //x2=31.34 //y2=1.175
r68 (  4 29 ) resistor r=1.36898 //w=0.187 //l=0.02 //layer=li //thickness=0.1 \
 //x=31.34 //y=1.09 //x2=31.34 //y2=1.07
r69 (  3 29 ) resistor r=3.57586 //w=0.17 //l=0.125 //layer=li //thickness=0.1 \
 //x=31.34 //y=0.805 //x2=31.34 //y2=0.68
r70 (  3 29 ) resistor r=18.139 //w=0.187 //l=0.265 //layer=li //thickness=0.1 \
 //x=31.34 //y=0.805 //x2=31.34 //y2=1.07
r71 (  2 28 ) resistor r=0.751729 //w=0.17 //l=0.085 //layer=li \
 //thickness=0.1 //x=30.375 //y=1.175 //x2=30.29 //y2=1.175
r72 (  1 25 ) resistor r=1.40859 //w=0.34 //l=0.085 //layer=li //thickness=0.1 \
 //x=31.255 //y=1.175 //x2=31.34 //y2=1.175
r73 (  1 2 ) resistor r=60.2353 //w=0.187 //l=0.88 //layer=li //thickness=0.1 \
 //x=31.255 //y=1.175 //x2=30.375 //y2=1.175
ends PM_TMRDFFSNQX1\%noxref_38

subckt PM_TMRDFFSNQX1\%noxref_39 ( 1 5 9 13 17 35 )
c52 ( 35 0 ) capacitor c=0.0673029f //x=33.505 //y=0.555
c53 ( 17 0 ) capacitor c=0.0178286f //x=35.495 //y=1.77
c54 ( 13 0 ) capacitor c=0.0154917f //x=35.495 //y=0.72
c55 ( 9 0 ) capacitor c=0.00678203f //x=34.61 //y=0.805
c56 ( 5 0 ) capacitor c=0.0164013f //x=34.525 //y=1.77
c57 ( 1 0 ) capacitor c=0.00696517f //x=33.64 //y=1.685
r58 (  18 35 ) resistor r=5.4201 //w=0.17 //l=0.103078 //layer=li \
 //thickness=0.1 //x=34.695 //y=1.77 //x2=34.61 //y2=1.81
r59 (  18 35 ) resistor r=27.3797 //w=0.187 //l=0.4 //layer=li //thickness=0.1 \
 //x=34.695 //y=1.77 //x2=35.095 //y2=1.77
r60 (  17 35 ) resistor r=0.751729 //w=0.17 //l=0.085 //layer=li \
 //thickness=0.1 //x=35.495 //y=1.77 //x2=35.58 //y2=1.77
r61 (  17 35 ) resistor r=27.3797 //w=0.187 //l=0.4 //layer=li //thickness=0.1 \
 //x=35.495 //y=1.77 //x2=35.095 //y2=1.77
r62 (  14 35 ) resistor r=3.57586 //w=0.17 //l=0.103078 //layer=li \
 //thickness=0.1 //x=34.695 //y=0.72 //x2=34.61 //y2=0.68
r63 (  14 35 ) resistor r=27.3797 //w=0.187 //l=0.4 //layer=li //thickness=0.1 \
 //x=34.695 //y=0.72 //x2=35.095 //y2=0.72
r64 (  13 35 ) resistor r=0.751729 //w=0.17 //l=0.085 //layer=li \
 //thickness=0.1 //x=35.495 //y=0.72 //x2=35.58 //y2=0.72
r65 (  13 35 ) resistor r=27.3797 //w=0.187 //l=0.4 //layer=li //thickness=0.1 \
 //x=35.495 //y=0.72 //x2=35.095 //y2=0.72
r66 (  10 35 ) resistor r=1.40859 //w=0.34 //l=0.125 //layer=li \
 //thickness=0.1 //x=34.61 //y=1.685 //x2=34.61 //y2=1.81
r67 (  10 35 ) resistor r=42.0963 //w=0.187 //l=0.615 //layer=li \
 //thickness=0.1 //x=34.61 //y=1.685 //x2=34.61 //y2=1.07
r68 (  9 35 ) resistor r=3.57586 //w=0.17 //l=0.125 //layer=li //thickness=0.1 \
 //x=34.61 //y=0.805 //x2=34.61 //y2=0.68
r69 (  9 35 ) resistor r=18.139 //w=0.187 //l=0.265 //layer=li //thickness=0.1 \
 //x=34.61 //y=0.805 //x2=34.61 //y2=1.07
r70 (  6 35 ) resistor r=3.57586 //w=0.17 //l=0.103078 //layer=li \
 //thickness=0.1 //x=33.725 //y=1.77 //x2=33.64 //y2=1.81
r71 (  6 35 ) resistor r=27.3797 //w=0.187 //l=0.4 //layer=li //thickness=0.1 \
 //x=33.725 //y=1.77 //x2=34.125 //y2=1.77
r72 (  5 35 ) resistor r=5.4201 //w=0.17 //l=0.103078 //layer=li \
 //thickness=0.1 //x=34.525 //y=1.77 //x2=34.61 //y2=1.81
r73 (  5 35 ) resistor r=27.3797 //w=0.187 //l=0.4 //layer=li //thickness=0.1 \
 //x=34.525 //y=1.77 //x2=34.125 //y2=1.77
r74 (  1 35 ) resistor r=3.57586 //w=0.17 //l=0.125 //layer=li //thickness=0.1 \
 //x=33.64 //y=1.685 //x2=33.64 //y2=1.81
r75 (  1 35 ) resistor r=42.0963 //w=0.187 //l=0.615 //layer=li \
 //thickness=0.1 //x=33.64 //y=1.685 //x2=33.64 //y2=1.07
ends PM_TMRDFFSNQX1\%noxref_39

subckt PM_TMRDFFSNQX1\%noxref_40 ( 1 3 11 15 25 28 29 )
c52 ( 29 0 ) capacitor c=0.0414744f //x=36.015 //y=0.555
c53 ( 28 0 ) capacitor c=0.00457437f //x=34.91 //y=1.09
c54 ( 25 0 ) capacitor c=0.00156479f //x=36.15 //y=1.175
c55 ( 15 0 ) capacitor c=0.00737666f //x=37.12 //y=0.805
c56 ( 11 0 ) capacitor c=0.0144274f //x=37.035 //y=0.72
c57 ( 3 0 ) capacitor c=0.00718386f //x=36.15 //y=0.805
c58 ( 1 0 ) capacitor c=0.0218873f //x=36.065 //y=1.175
r59 (  15 29 ) resistor r=3.57586 //w=0.17 //l=0.125 //layer=li \
 //thickness=0.1 //x=37.12 //y=0.805 //x2=37.12 //y2=0.68
r60 (  15 29 ) resistor r=18.139 //w=0.187 //l=0.265 //layer=li \
 //thickness=0.1 //x=37.12 //y=0.805 //x2=37.12 //y2=1.07
r61 (  12 29 ) resistor r=3.57586 //w=0.17 //l=0.103078 //layer=li \
 //thickness=0.1 //x=36.235 //y=0.72 //x2=36.15 //y2=0.68
r62 (  12 29 ) resistor r=27.3797 //w=0.187 //l=0.4 //layer=li //thickness=0.1 \
 //x=36.235 //y=0.72 //x2=36.635 //y2=0.72
r63 (  11 29 ) resistor r=3.57586 //w=0.17 //l=0.103078 //layer=li \
 //thickness=0.1 //x=37.035 //y=0.72 //x2=37.12 //y2=0.68
r64 (  11 29 ) resistor r=27.3797 //w=0.187 //l=0.4 //layer=li //thickness=0.1 \
 //x=37.035 //y=0.72 //x2=36.635 //y2=0.72
r65 (  7 25 ) resistor r=5.4201 //w=0.17 //l=0.085 //layer=li //thickness=0.1 \
 //x=36.15 //y=1.26 //x2=36.15 //y2=1.175
r66 (  7 29 ) resistor r=10.2674 //w=0.187 //l=0.15 //layer=li //thickness=0.1 \
 //x=36.15 //y=1.26 //x2=36.15 //y2=1.41
r67 (  4 25 ) resistor r=5.4201 //w=0.17 //l=0.085 //layer=li //thickness=0.1 \
 //x=36.15 //y=1.09 //x2=36.15 //y2=1.175
r68 (  4 29 ) resistor r=1.36898 //w=0.187 //l=0.02 //layer=li //thickness=0.1 \
 //x=36.15 //y=1.09 //x2=36.15 //y2=1.07
r69 (  3 29 ) resistor r=3.57586 //w=0.17 //l=0.125 //layer=li //thickness=0.1 \
 //x=36.15 //y=0.805 //x2=36.15 //y2=0.68
r70 (  3 29 ) resistor r=18.139 //w=0.187 //l=0.265 //layer=li //thickness=0.1 \
 //x=36.15 //y=0.805 //x2=36.15 //y2=1.07
r71 (  2 28 ) resistor r=0.751729 //w=0.17 //l=0.085 //layer=li \
 //thickness=0.1 //x=35.185 //y=1.175 //x2=35.1 //y2=1.175
r72 (  1 25 ) resistor r=1.40859 //w=0.34 //l=0.085 //layer=li //thickness=0.1 \
 //x=36.065 //y=1.175 //x2=36.15 //y2=1.175
r73 (  1 2 ) resistor r=60.2353 //w=0.187 //l=0.88 //layer=li //thickness=0.1 \
 //x=36.065 //y=1.175 //x2=35.185 //y2=1.175
ends PM_TMRDFFSNQX1\%noxref_40

subckt PM_TMRDFFSNQX1\%noxref_41 ( 1 5 9 10 13 17 29 )
c51 ( 29 0 ) capacitor c=0.0632682f //x=38.42 //y=0.545
c52 ( 17 0 ) capacitor c=0.00722223f //x=40.495 //y=0.795
c53 ( 13 0 ) capacitor c=0.0145084f //x=40.41 //y=0.71
c54 ( 10 0 ) capacitor c=0.00582081f //x=39.525 //y=1.675
c55 ( 9 0 ) capacitor c=0.006761f //x=39.525 //y=0.795
c56 ( 5 0 ) capacitor c=0.0173046f //x=39.44 //y=1.76
c57 ( 1 0 ) capacitor c=0.00733328f //x=38.555 //y=1.675
r58 (  17 29 ) resistor r=3.57586 //w=0.17 //l=0.125 //layer=li \
 //thickness=0.1 //x=40.495 //y=0.795 //x2=40.495 //y2=0.67
r59 (  17 29 ) resistor r=18.139 //w=0.187 //l=0.265 //layer=li \
 //thickness=0.1 //x=40.495 //y=0.795 //x2=40.495 //y2=1.06
r60 (  14 29 ) resistor r=3.57586 //w=0.17 //l=0.103078 //layer=li \
 //thickness=0.1 //x=39.61 //y=0.71 //x2=39.525 //y2=0.67
r61 (  14 29 ) resistor r=27.3797 //w=0.187 //l=0.4 //layer=li //thickness=0.1 \
 //x=39.61 //y=0.71 //x2=40.01 //y2=0.71
r62 (  13 29 ) resistor r=3.57586 //w=0.17 //l=0.103078 //layer=li \
 //thickness=0.1 //x=40.41 //y=0.71 //x2=40.495 //y2=0.67
r63 (  13 29 ) resistor r=27.3797 //w=0.187 //l=0.4 //layer=li //thickness=0.1 \
 //x=40.41 //y=0.71 //x2=40.01 //y2=0.71
r64 (  10 29 ) resistor r=3.57586 //w=0.17 //l=0.125 //layer=li \
 //thickness=0.1 //x=39.525 //y=1.675 //x2=39.525 //y2=1.8
r65 (  10 29 ) resistor r=42.0963 //w=0.187 //l=0.615 //layer=li \
 //thickness=0.1 //x=39.525 //y=1.675 //x2=39.525 //y2=1.06
r66 (  9 29 ) resistor r=3.57586 //w=0.17 //l=0.125 //layer=li //thickness=0.1 \
 //x=39.525 //y=0.795 //x2=39.525 //y2=0.67
r67 (  9 29 ) resistor r=18.139 //w=0.187 //l=0.265 //layer=li //thickness=0.1 \
 //x=39.525 //y=0.795 //x2=39.525 //y2=1.06
r68 (  6 29 ) resistor r=3.57586 //w=0.17 //l=0.103078 //layer=li \
 //thickness=0.1 //x=38.64 //y=1.76 //x2=38.555 //y2=1.8
r69 (  6 29 ) resistor r=27.3797 //w=0.187 //l=0.4 //layer=li //thickness=0.1 \
 //x=38.64 //y=1.76 //x2=39.04 //y2=1.76
r70 (  5 29 ) resistor r=3.57586 //w=0.17 //l=0.103078 //layer=li \
 //thickness=0.1 //x=39.44 //y=1.76 //x2=39.525 //y2=1.8
r71 (  5 29 ) resistor r=27.3797 //w=0.187 //l=0.4 //layer=li //thickness=0.1 \
 //x=39.44 //y=1.76 //x2=39.04 //y2=1.76
r72 (  1 29 ) resistor r=3.57586 //w=0.17 //l=0.125 //layer=li //thickness=0.1 \
 //x=38.555 //y=1.675 //x2=38.555 //y2=1.8
r73 (  1 29 ) resistor r=42.0963 //w=0.187 //l=0.615 //layer=li \
 //thickness=0.1 //x=38.555 //y=1.675 //x2=38.555 //y2=1.06
ends PM_TMRDFFSNQX1\%noxref_41

subckt PM_TMRDFFSNQX1\%noxref_42 ( 1 5 9 10 13 17 29 )
c51 ( 29 0 ) capacitor c=0.063352f //x=41.75 //y=0.545
c52 ( 17 0 ) capacitor c=0.0072343f //x=43.825 //y=0.795
c53 ( 13 0 ) capacitor c=0.0145084f //x=43.74 //y=0.71
c54 ( 10 0 ) capacitor c=0.00582081f //x=42.855 //y=1.675
c55 ( 9 0 ) capacitor c=0.006761f //x=42.855 //y=0.795
c56 ( 5 0 ) capacitor c=0.0173046f //x=42.77 //y=1.76
c57 ( 1 0 ) capacitor c=0.00733328f //x=41.885 //y=1.675
r58 (  17 29 ) resistor r=3.57586 //w=0.17 //l=0.125 //layer=li \
 //thickness=0.1 //x=43.825 //y=0.795 //x2=43.825 //y2=0.67
r59 (  17 29 ) resistor r=18.139 //w=0.187 //l=0.265 //layer=li \
 //thickness=0.1 //x=43.825 //y=0.795 //x2=43.825 //y2=1.06
r60 (  14 29 ) resistor r=3.57586 //w=0.17 //l=0.103078 //layer=li \
 //thickness=0.1 //x=42.94 //y=0.71 //x2=42.855 //y2=0.67
r61 (  14 29 ) resistor r=27.3797 //w=0.187 //l=0.4 //layer=li //thickness=0.1 \
 //x=42.94 //y=0.71 //x2=43.34 //y2=0.71
r62 (  13 29 ) resistor r=3.57586 //w=0.17 //l=0.103078 //layer=li \
 //thickness=0.1 //x=43.74 //y=0.71 //x2=43.825 //y2=0.67
r63 (  13 29 ) resistor r=27.3797 //w=0.187 //l=0.4 //layer=li //thickness=0.1 \
 //x=43.74 //y=0.71 //x2=43.34 //y2=0.71
r64 (  10 29 ) resistor r=3.57586 //w=0.17 //l=0.125 //layer=li \
 //thickness=0.1 //x=42.855 //y=1.675 //x2=42.855 //y2=1.8
r65 (  10 29 ) resistor r=42.0963 //w=0.187 //l=0.615 //layer=li \
 //thickness=0.1 //x=42.855 //y=1.675 //x2=42.855 //y2=1.06
r66 (  9 29 ) resistor r=3.57586 //w=0.17 //l=0.125 //layer=li //thickness=0.1 \
 //x=42.855 //y=0.795 //x2=42.855 //y2=0.67
r67 (  9 29 ) resistor r=18.139 //w=0.187 //l=0.265 //layer=li //thickness=0.1 \
 //x=42.855 //y=0.795 //x2=42.855 //y2=1.06
r68 (  6 29 ) resistor r=3.57586 //w=0.17 //l=0.103078 //layer=li \
 //thickness=0.1 //x=41.97 //y=1.76 //x2=41.885 //y2=1.8
r69 (  6 29 ) resistor r=27.3797 //w=0.187 //l=0.4 //layer=li //thickness=0.1 \
 //x=41.97 //y=1.76 //x2=42.37 //y2=1.76
r70 (  5 29 ) resistor r=3.57586 //w=0.17 //l=0.103078 //layer=li \
 //thickness=0.1 //x=42.77 //y=1.76 //x2=42.855 //y2=1.8
r71 (  5 29 ) resistor r=27.3797 //w=0.187 //l=0.4 //layer=li //thickness=0.1 \
 //x=42.77 //y=1.76 //x2=42.37 //y2=1.76
r72 (  1 29 ) resistor r=3.57586 //w=0.17 //l=0.125 //layer=li //thickness=0.1 \
 //x=41.885 //y=1.675 //x2=41.885 //y2=1.8
r73 (  1 29 ) resistor r=42.0963 //w=0.187 //l=0.615 //layer=li \
 //thickness=0.1 //x=41.885 //y=1.675 //x2=41.885 //y2=1.06
ends PM_TMRDFFSNQX1\%noxref_42

subckt PM_TMRDFFSNQX1\%noxref_43 ( 1 5 9 13 17 35 )
c52 ( 35 0 ) capacitor c=0.0673029f //x=44.975 //y=0.555
c53 ( 17 0 ) capacitor c=0.0178286f //x=46.965 //y=1.77
c54 ( 13 0 ) capacitor c=0.0154917f //x=46.965 //y=0.72
c55 ( 9 0 ) capacitor c=0.00678203f //x=46.08 //y=0.805
c56 ( 5 0 ) capacitor c=0.0164013f //x=45.995 //y=1.77
c57 ( 1 0 ) capacitor c=0.00696517f //x=45.11 //y=1.685
r58 (  18 35 ) resistor r=5.4201 //w=0.17 //l=0.103078 //layer=li \
 //thickness=0.1 //x=46.165 //y=1.77 //x2=46.08 //y2=1.81
r59 (  18 35 ) resistor r=27.3797 //w=0.187 //l=0.4 //layer=li //thickness=0.1 \
 //x=46.165 //y=1.77 //x2=46.565 //y2=1.77
r60 (  17 35 ) resistor r=0.751729 //w=0.17 //l=0.085 //layer=li \
 //thickness=0.1 //x=46.965 //y=1.77 //x2=47.05 //y2=1.77
r61 (  17 35 ) resistor r=27.3797 //w=0.187 //l=0.4 //layer=li //thickness=0.1 \
 //x=46.965 //y=1.77 //x2=46.565 //y2=1.77
r62 (  14 35 ) resistor r=3.57586 //w=0.17 //l=0.103078 //layer=li \
 //thickness=0.1 //x=46.165 //y=0.72 //x2=46.08 //y2=0.68
r63 (  14 35 ) resistor r=27.3797 //w=0.187 //l=0.4 //layer=li //thickness=0.1 \
 //x=46.165 //y=0.72 //x2=46.565 //y2=0.72
r64 (  13 35 ) resistor r=0.751729 //w=0.17 //l=0.085 //layer=li \
 //thickness=0.1 //x=46.965 //y=0.72 //x2=47.05 //y2=0.72
r65 (  13 35 ) resistor r=27.3797 //w=0.187 //l=0.4 //layer=li //thickness=0.1 \
 //x=46.965 //y=0.72 //x2=46.565 //y2=0.72
r66 (  10 35 ) resistor r=1.40859 //w=0.34 //l=0.125 //layer=li \
 //thickness=0.1 //x=46.08 //y=1.685 //x2=46.08 //y2=1.81
r67 (  10 35 ) resistor r=42.0963 //w=0.187 //l=0.615 //layer=li \
 //thickness=0.1 //x=46.08 //y=1.685 //x2=46.08 //y2=1.07
r68 (  9 35 ) resistor r=3.57586 //w=0.17 //l=0.125 //layer=li //thickness=0.1 \
 //x=46.08 //y=0.805 //x2=46.08 //y2=0.68
r69 (  9 35 ) resistor r=18.139 //w=0.187 //l=0.265 //layer=li //thickness=0.1 \
 //x=46.08 //y=0.805 //x2=46.08 //y2=1.07
r70 (  6 35 ) resistor r=3.57586 //w=0.17 //l=0.103078 //layer=li \
 //thickness=0.1 //x=45.195 //y=1.77 //x2=45.11 //y2=1.81
r71 (  6 35 ) resistor r=27.3797 //w=0.187 //l=0.4 //layer=li //thickness=0.1 \
 //x=45.195 //y=1.77 //x2=45.595 //y2=1.77
r72 (  5 35 ) resistor r=5.4201 //w=0.17 //l=0.103078 //layer=li \
 //thickness=0.1 //x=45.995 //y=1.77 //x2=46.08 //y2=1.81
r73 (  5 35 ) resistor r=27.3797 //w=0.187 //l=0.4 //layer=li //thickness=0.1 \
 //x=45.995 //y=1.77 //x2=45.595 //y2=1.77
r74 (  1 35 ) resistor r=3.57586 //w=0.17 //l=0.125 //layer=li //thickness=0.1 \
 //x=45.11 //y=1.685 //x2=45.11 //y2=1.81
r75 (  1 35 ) resistor r=42.0963 //w=0.187 //l=0.615 //layer=li \
 //thickness=0.1 //x=45.11 //y=1.685 //x2=45.11 //y2=1.07
ends PM_TMRDFFSNQX1\%noxref_43

subckt PM_TMRDFFSNQX1\%noxref_44 ( 1 3 11 15 25 28 29 )
c52 ( 29 0 ) capacitor c=0.0414744f //x=47.485 //y=0.555
c53 ( 28 0 ) capacitor c=0.00457437f //x=46.38 //y=1.09
c54 ( 25 0 ) capacitor c=0.00156479f //x=47.62 //y=1.175
c55 ( 15 0 ) capacitor c=0.00737666f //x=48.59 //y=0.805
c56 ( 11 0 ) capacitor c=0.0144274f //x=48.505 //y=0.72
c57 ( 3 0 ) capacitor c=0.00718386f //x=47.62 //y=0.805
c58 ( 1 0 ) capacitor c=0.0218873f //x=47.535 //y=1.175
r59 (  15 29 ) resistor r=3.57586 //w=0.17 //l=0.125 //layer=li \
 //thickness=0.1 //x=48.59 //y=0.805 //x2=48.59 //y2=0.68
r60 (  15 29 ) resistor r=18.139 //w=0.187 //l=0.265 //layer=li \
 //thickness=0.1 //x=48.59 //y=0.805 //x2=48.59 //y2=1.07
r61 (  12 29 ) resistor r=3.57586 //w=0.17 //l=0.103078 //layer=li \
 //thickness=0.1 //x=47.705 //y=0.72 //x2=47.62 //y2=0.68
r62 (  12 29 ) resistor r=27.3797 //w=0.187 //l=0.4 //layer=li //thickness=0.1 \
 //x=47.705 //y=0.72 //x2=48.105 //y2=0.72
r63 (  11 29 ) resistor r=3.57586 //w=0.17 //l=0.103078 //layer=li \
 //thickness=0.1 //x=48.505 //y=0.72 //x2=48.59 //y2=0.68
r64 (  11 29 ) resistor r=27.3797 //w=0.187 //l=0.4 //layer=li //thickness=0.1 \
 //x=48.505 //y=0.72 //x2=48.105 //y2=0.72
r65 (  7 25 ) resistor r=5.4201 //w=0.17 //l=0.085 //layer=li //thickness=0.1 \
 //x=47.62 //y=1.26 //x2=47.62 //y2=1.175
r66 (  7 29 ) resistor r=10.2674 //w=0.187 //l=0.15 //layer=li //thickness=0.1 \
 //x=47.62 //y=1.26 //x2=47.62 //y2=1.41
r67 (  4 25 ) resistor r=5.4201 //w=0.17 //l=0.085 //layer=li //thickness=0.1 \
 //x=47.62 //y=1.09 //x2=47.62 //y2=1.175
r68 (  4 29 ) resistor r=1.36898 //w=0.187 //l=0.02 //layer=li //thickness=0.1 \
 //x=47.62 //y=1.09 //x2=47.62 //y2=1.07
r69 (  3 29 ) resistor r=3.57586 //w=0.17 //l=0.125 //layer=li //thickness=0.1 \
 //x=47.62 //y=0.805 //x2=47.62 //y2=0.68
r70 (  3 29 ) resistor r=18.139 //w=0.187 //l=0.265 //layer=li //thickness=0.1 \
 //x=47.62 //y=0.805 //x2=47.62 //y2=1.07
r71 (  2 28 ) resistor r=0.751729 //w=0.17 //l=0.085 //layer=li \
 //thickness=0.1 //x=46.655 //y=1.175 //x2=46.57 //y2=1.175
r72 (  1 25 ) resistor r=1.40859 //w=0.34 //l=0.085 //layer=li //thickness=0.1 \
 //x=47.535 //y=1.175 //x2=47.62 //y2=1.175
r73 (  1 2 ) resistor r=60.2353 //w=0.187 //l=0.88 //layer=li //thickness=0.1 \
 //x=47.535 //y=1.175 //x2=46.655 //y2=1.175
ends PM_TMRDFFSNQX1\%noxref_44

subckt PM_TMRDFFSNQX1\%noxref_45 ( 1 5 9 10 13 17 29 )
c51 ( 29 0 ) capacitor c=0.0633518f //x=49.89 //y=0.545
c52 ( 17 0 ) capacitor c=0.0072343f //x=51.965 //y=0.795
c53 ( 13 0 ) capacitor c=0.0145084f //x=51.88 //y=0.71
c54 ( 10 0 ) capacitor c=0.00582081f //x=50.995 //y=1.675
c55 ( 9 0 ) capacitor c=0.006761f //x=50.995 //y=0.795
c56 ( 5 0 ) capacitor c=0.0173046f //x=50.91 //y=1.76
c57 ( 1 0 ) capacitor c=0.00733328f //x=50.025 //y=1.675
r58 (  17 29 ) resistor r=3.57586 //w=0.17 //l=0.125 //layer=li \
 //thickness=0.1 //x=51.965 //y=0.795 //x2=51.965 //y2=0.67
r59 (  17 29 ) resistor r=18.139 //w=0.187 //l=0.265 //layer=li \
 //thickness=0.1 //x=51.965 //y=0.795 //x2=51.965 //y2=1.06
r60 (  14 29 ) resistor r=3.57586 //w=0.17 //l=0.103078 //layer=li \
 //thickness=0.1 //x=51.08 //y=0.71 //x2=50.995 //y2=0.67
r61 (  14 29 ) resistor r=27.3797 //w=0.187 //l=0.4 //layer=li //thickness=0.1 \
 //x=51.08 //y=0.71 //x2=51.48 //y2=0.71
r62 (  13 29 ) resistor r=3.57586 //w=0.17 //l=0.103078 //layer=li \
 //thickness=0.1 //x=51.88 //y=0.71 //x2=51.965 //y2=0.67
r63 (  13 29 ) resistor r=27.3797 //w=0.187 //l=0.4 //layer=li //thickness=0.1 \
 //x=51.88 //y=0.71 //x2=51.48 //y2=0.71
r64 (  10 29 ) resistor r=3.57586 //w=0.17 //l=0.125 //layer=li \
 //thickness=0.1 //x=50.995 //y=1.675 //x2=50.995 //y2=1.8
r65 (  10 29 ) resistor r=42.0963 //w=0.187 //l=0.615 //layer=li \
 //thickness=0.1 //x=50.995 //y=1.675 //x2=50.995 //y2=1.06
r66 (  9 29 ) resistor r=3.57586 //w=0.17 //l=0.125 //layer=li //thickness=0.1 \
 //x=50.995 //y=0.795 //x2=50.995 //y2=0.67
r67 (  9 29 ) resistor r=18.139 //w=0.187 //l=0.265 //layer=li //thickness=0.1 \
 //x=50.995 //y=0.795 //x2=50.995 //y2=1.06
r68 (  6 29 ) resistor r=3.57586 //w=0.17 //l=0.103078 //layer=li \
 //thickness=0.1 //x=50.11 //y=1.76 //x2=50.025 //y2=1.8
r69 (  6 29 ) resistor r=27.3797 //w=0.187 //l=0.4 //layer=li //thickness=0.1 \
 //x=50.11 //y=1.76 //x2=50.51 //y2=1.76
r70 (  5 29 ) resistor r=3.57586 //w=0.17 //l=0.103078 //layer=li \
 //thickness=0.1 //x=50.91 //y=1.76 //x2=50.995 //y2=1.8
r71 (  5 29 ) resistor r=27.3797 //w=0.187 //l=0.4 //layer=li //thickness=0.1 \
 //x=50.91 //y=1.76 //x2=50.51 //y2=1.76
r72 (  1 29 ) resistor r=3.57586 //w=0.17 //l=0.125 //layer=li //thickness=0.1 \
 //x=50.025 //y=1.675 //x2=50.025 //y2=1.8
r73 (  1 29 ) resistor r=42.0963 //w=0.187 //l=0.615 //layer=li \
 //thickness=0.1 //x=50.025 //y=1.675 //x2=50.025 //y2=1.06
ends PM_TMRDFFSNQX1\%noxref_45

subckt PM_TMRDFFSNQX1\%noxref_46 ( 1 5 9 13 17 35 )
c49 ( 35 0 ) capacitor c=0.0673195f //x=53.115 //y=0.555
c50 ( 17 0 ) capacitor c=0.0178317f //x=55.105 //y=1.77
c51 ( 13 0 ) capacitor c=0.0154936f //x=55.105 //y=0.72
c52 ( 9 0 ) capacitor c=0.00678203f //x=54.22 //y=0.805
c53 ( 5 0 ) capacitor c=0.0164013f //x=54.135 //y=1.77
c54 ( 1 0 ) capacitor c=0.00696517f //x=53.25 //y=1.685
r55 (  18 35 ) resistor r=5.4201 //w=0.17 //l=0.103078 //layer=li \
 //thickness=0.1 //x=54.305 //y=1.77 //x2=54.22 //y2=1.81
r56 (  18 35 ) resistor r=27.3797 //w=0.187 //l=0.4 //layer=li //thickness=0.1 \
 //x=54.305 //y=1.77 //x2=54.705 //y2=1.77
r57 (  17 35 ) resistor r=0.751729 //w=0.17 //l=0.085 //layer=li \
 //thickness=0.1 //x=55.105 //y=1.77 //x2=55.19 //y2=1.77
r58 (  17 35 ) resistor r=27.3797 //w=0.187 //l=0.4 //layer=li //thickness=0.1 \
 //x=55.105 //y=1.77 //x2=54.705 //y2=1.77
r59 (  14 35 ) resistor r=3.57586 //w=0.17 //l=0.103078 //layer=li \
 //thickness=0.1 //x=54.305 //y=0.72 //x2=54.22 //y2=0.68
r60 (  14 35 ) resistor r=27.3797 //w=0.187 //l=0.4 //layer=li //thickness=0.1 \
 //x=54.305 //y=0.72 //x2=54.705 //y2=0.72
r61 (  13 35 ) resistor r=0.751729 //w=0.17 //l=0.085 //layer=li \
 //thickness=0.1 //x=55.105 //y=0.72 //x2=55.19 //y2=0.72
r62 (  13 35 ) resistor r=27.3797 //w=0.187 //l=0.4 //layer=li //thickness=0.1 \
 //x=55.105 //y=0.72 //x2=54.705 //y2=0.72
r63 (  10 35 ) resistor r=1.40859 //w=0.34 //l=0.125 //layer=li \
 //thickness=0.1 //x=54.22 //y=1.685 //x2=54.22 //y2=1.81
r64 (  10 35 ) resistor r=42.0963 //w=0.187 //l=0.615 //layer=li \
 //thickness=0.1 //x=54.22 //y=1.685 //x2=54.22 //y2=1.07
r65 (  9 35 ) resistor r=3.57586 //w=0.17 //l=0.125 //layer=li //thickness=0.1 \
 //x=54.22 //y=0.805 //x2=54.22 //y2=0.68
r66 (  9 35 ) resistor r=18.139 //w=0.187 //l=0.265 //layer=li //thickness=0.1 \
 //x=54.22 //y=0.805 //x2=54.22 //y2=1.07
r67 (  6 35 ) resistor r=3.57586 //w=0.17 //l=0.103078 //layer=li \
 //thickness=0.1 //x=53.335 //y=1.77 //x2=53.25 //y2=1.81
r68 (  6 35 ) resistor r=27.3797 //w=0.187 //l=0.4 //layer=li //thickness=0.1 \
 //x=53.335 //y=1.77 //x2=53.735 //y2=1.77
r69 (  5 35 ) resistor r=5.4201 //w=0.17 //l=0.103078 //layer=li \
 //thickness=0.1 //x=54.135 //y=1.77 //x2=54.22 //y2=1.81
r70 (  5 35 ) resistor r=27.3797 //w=0.187 //l=0.4 //layer=li //thickness=0.1 \
 //x=54.135 //y=1.77 //x2=53.735 //y2=1.77
r71 (  1 35 ) resistor r=3.57586 //w=0.17 //l=0.125 //layer=li //thickness=0.1 \
 //x=53.25 //y=1.685 //x2=53.25 //y2=1.81
r72 (  1 35 ) resistor r=42.0963 //w=0.187 //l=0.615 //layer=li \
 //thickness=0.1 //x=53.25 //y=1.685 //x2=53.25 //y2=1.07
ends PM_TMRDFFSNQX1\%noxref_46

subckt PM_TMRDFFSNQX1\%noxref_47 ( 1 3 11 15 25 28 29 )
c52 ( 29 0 ) capacitor c=0.0414739f //x=55.625 //y=0.555
c53 ( 28 0 ) capacitor c=0.0045748f //x=54.52 //y=1.09
c54 ( 25 0 ) capacitor c=0.00156479f //x=55.76 //y=1.175
c55 ( 15 0 ) capacitor c=0.00737666f //x=56.73 //y=0.805
c56 ( 11 0 ) capacitor c=0.0144274f //x=56.645 //y=0.72
c57 ( 3 0 ) capacitor c=0.00718386f //x=55.76 //y=0.805
c58 ( 1 0 ) capacitor c=0.0218888f //x=55.675 //y=1.175
r59 (  15 29 ) resistor r=3.57586 //w=0.17 //l=0.125 //layer=li \
 //thickness=0.1 //x=56.73 //y=0.805 //x2=56.73 //y2=0.68
r60 (  15 29 ) resistor r=18.139 //w=0.187 //l=0.265 //layer=li \
 //thickness=0.1 //x=56.73 //y=0.805 //x2=56.73 //y2=1.07
r61 (  12 29 ) resistor r=3.57586 //w=0.17 //l=0.103078 //layer=li \
 //thickness=0.1 //x=55.845 //y=0.72 //x2=55.76 //y2=0.68
r62 (  12 29 ) resistor r=27.3797 //w=0.187 //l=0.4 //layer=li //thickness=0.1 \
 //x=55.845 //y=0.72 //x2=56.245 //y2=0.72
r63 (  11 29 ) resistor r=3.57586 //w=0.17 //l=0.103078 //layer=li \
 //thickness=0.1 //x=56.645 //y=0.72 //x2=56.73 //y2=0.68
r64 (  11 29 ) resistor r=27.3797 //w=0.187 //l=0.4 //layer=li //thickness=0.1 \
 //x=56.645 //y=0.72 //x2=56.245 //y2=0.72
r65 (  7 25 ) resistor r=5.4201 //w=0.17 //l=0.085 //layer=li //thickness=0.1 \
 //x=55.76 //y=1.26 //x2=55.76 //y2=1.175
r66 (  7 29 ) resistor r=10.2674 //w=0.187 //l=0.15 //layer=li //thickness=0.1 \
 //x=55.76 //y=1.26 //x2=55.76 //y2=1.41
r67 (  4 25 ) resistor r=5.4201 //w=0.17 //l=0.085 //layer=li //thickness=0.1 \
 //x=55.76 //y=1.09 //x2=55.76 //y2=1.175
r68 (  4 29 ) resistor r=1.36898 //w=0.187 //l=0.02 //layer=li //thickness=0.1 \
 //x=55.76 //y=1.09 //x2=55.76 //y2=1.07
r69 (  3 29 ) resistor r=3.57586 //w=0.17 //l=0.125 //layer=li //thickness=0.1 \
 //x=55.76 //y=0.805 //x2=55.76 //y2=0.68
r70 (  3 29 ) resistor r=18.139 //w=0.187 //l=0.265 //layer=li //thickness=0.1 \
 //x=55.76 //y=0.805 //x2=55.76 //y2=1.07
r71 (  2 28 ) resistor r=0.751729 //w=0.17 //l=0.085 //layer=li \
 //thickness=0.1 //x=54.795 //y=1.175 //x2=54.71 //y2=1.175
r72 (  1 25 ) resistor r=1.40859 //w=0.34 //l=0.085 //layer=li //thickness=0.1 \
 //x=55.675 //y=1.175 //x2=55.76 //y2=1.175
r73 (  1 2 ) resistor r=60.2353 //w=0.187 //l=0.88 //layer=li //thickness=0.1 \
 //x=55.675 //y=1.175 //x2=54.795 //y2=1.175
ends PM_TMRDFFSNQX1\%noxref_47

subckt PM_TMRDFFSNQX1\%noxref_48 ( 1 5 9 13 17 35 )
c52 ( 35 0 ) capacitor c=0.0673029f //x=57.925 //y=0.555
c53 ( 17 0 ) capacitor c=0.0178286f //x=59.915 //y=1.77
c54 ( 13 0 ) capacitor c=0.0154917f //x=59.915 //y=0.72
c55 ( 9 0 ) capacitor c=0.00678203f //x=59.03 //y=0.805
c56 ( 5 0 ) capacitor c=0.0164013f //x=58.945 //y=1.77
c57 ( 1 0 ) capacitor c=0.00696517f //x=58.06 //y=1.685
r58 (  18 35 ) resistor r=5.4201 //w=0.17 //l=0.103078 //layer=li \
 //thickness=0.1 //x=59.115 //y=1.77 //x2=59.03 //y2=1.81
r59 (  18 35 ) resistor r=27.3797 //w=0.187 //l=0.4 //layer=li //thickness=0.1 \
 //x=59.115 //y=1.77 //x2=59.515 //y2=1.77
r60 (  17 35 ) resistor r=0.751729 //w=0.17 //l=0.085 //layer=li \
 //thickness=0.1 //x=59.915 //y=1.77 //x2=60 //y2=1.77
r61 (  17 35 ) resistor r=27.3797 //w=0.187 //l=0.4 //layer=li //thickness=0.1 \
 //x=59.915 //y=1.77 //x2=59.515 //y2=1.77
r62 (  14 35 ) resistor r=3.57586 //w=0.17 //l=0.103078 //layer=li \
 //thickness=0.1 //x=59.115 //y=0.72 //x2=59.03 //y2=0.68
r63 (  14 35 ) resistor r=27.3797 //w=0.187 //l=0.4 //layer=li //thickness=0.1 \
 //x=59.115 //y=0.72 //x2=59.515 //y2=0.72
r64 (  13 35 ) resistor r=0.751729 //w=0.17 //l=0.085 //layer=li \
 //thickness=0.1 //x=59.915 //y=0.72 //x2=60 //y2=0.72
r65 (  13 35 ) resistor r=27.3797 //w=0.187 //l=0.4 //layer=li //thickness=0.1 \
 //x=59.915 //y=0.72 //x2=59.515 //y2=0.72
r66 (  10 35 ) resistor r=1.40859 //w=0.34 //l=0.125 //layer=li \
 //thickness=0.1 //x=59.03 //y=1.685 //x2=59.03 //y2=1.81
r67 (  10 35 ) resistor r=42.0963 //w=0.187 //l=0.615 //layer=li \
 //thickness=0.1 //x=59.03 //y=1.685 //x2=59.03 //y2=1.07
r68 (  9 35 ) resistor r=3.57586 //w=0.17 //l=0.125 //layer=li //thickness=0.1 \
 //x=59.03 //y=0.805 //x2=59.03 //y2=0.68
r69 (  9 35 ) resistor r=18.139 //w=0.187 //l=0.265 //layer=li //thickness=0.1 \
 //x=59.03 //y=0.805 //x2=59.03 //y2=1.07
r70 (  6 35 ) resistor r=3.57586 //w=0.17 //l=0.103078 //layer=li \
 //thickness=0.1 //x=58.145 //y=1.77 //x2=58.06 //y2=1.81
r71 (  6 35 ) resistor r=27.3797 //w=0.187 //l=0.4 //layer=li //thickness=0.1 \
 //x=58.145 //y=1.77 //x2=58.545 //y2=1.77
r72 (  5 35 ) resistor r=5.4201 //w=0.17 //l=0.103078 //layer=li \
 //thickness=0.1 //x=58.945 //y=1.77 //x2=59.03 //y2=1.81
r73 (  5 35 ) resistor r=27.3797 //w=0.187 //l=0.4 //layer=li //thickness=0.1 \
 //x=58.945 //y=1.77 //x2=58.545 //y2=1.77
r74 (  1 35 ) resistor r=3.57586 //w=0.17 //l=0.125 //layer=li //thickness=0.1 \
 //x=58.06 //y=1.685 //x2=58.06 //y2=1.81
r75 (  1 35 ) resistor r=42.0963 //w=0.187 //l=0.615 //layer=li \
 //thickness=0.1 //x=58.06 //y=1.685 //x2=58.06 //y2=1.07
ends PM_TMRDFFSNQX1\%noxref_48

subckt PM_TMRDFFSNQX1\%noxref_49 ( 1 3 11 15 25 28 29 )
c52 ( 29 0 ) capacitor c=0.0414744f //x=60.435 //y=0.555
c53 ( 28 0 ) capacitor c=0.00457437f //x=59.33 //y=1.09
c54 ( 25 0 ) capacitor c=0.00156479f //x=60.57 //y=1.175
c55 ( 15 0 ) capacitor c=0.00737666f //x=61.54 //y=0.805
c56 ( 11 0 ) capacitor c=0.0144274f //x=61.455 //y=0.72
c57 ( 3 0 ) capacitor c=0.00718386f //x=60.57 //y=0.805
c58 ( 1 0 ) capacitor c=0.0218873f //x=60.485 //y=1.175
r59 (  15 29 ) resistor r=3.57586 //w=0.17 //l=0.125 //layer=li \
 //thickness=0.1 //x=61.54 //y=0.805 //x2=61.54 //y2=0.68
r60 (  15 29 ) resistor r=18.139 //w=0.187 //l=0.265 //layer=li \
 //thickness=0.1 //x=61.54 //y=0.805 //x2=61.54 //y2=1.07
r61 (  12 29 ) resistor r=3.57586 //w=0.17 //l=0.103078 //layer=li \
 //thickness=0.1 //x=60.655 //y=0.72 //x2=60.57 //y2=0.68
r62 (  12 29 ) resistor r=27.3797 //w=0.187 //l=0.4 //layer=li //thickness=0.1 \
 //x=60.655 //y=0.72 //x2=61.055 //y2=0.72
r63 (  11 29 ) resistor r=3.57586 //w=0.17 //l=0.103078 //layer=li \
 //thickness=0.1 //x=61.455 //y=0.72 //x2=61.54 //y2=0.68
r64 (  11 29 ) resistor r=27.3797 //w=0.187 //l=0.4 //layer=li //thickness=0.1 \
 //x=61.455 //y=0.72 //x2=61.055 //y2=0.72
r65 (  7 25 ) resistor r=5.4201 //w=0.17 //l=0.085 //layer=li //thickness=0.1 \
 //x=60.57 //y=1.26 //x2=60.57 //y2=1.175
r66 (  7 29 ) resistor r=10.2674 //w=0.187 //l=0.15 //layer=li //thickness=0.1 \
 //x=60.57 //y=1.26 //x2=60.57 //y2=1.41
r67 (  4 25 ) resistor r=5.4201 //w=0.17 //l=0.085 //layer=li //thickness=0.1 \
 //x=60.57 //y=1.09 //x2=60.57 //y2=1.175
r68 (  4 29 ) resistor r=1.36898 //w=0.187 //l=0.02 //layer=li //thickness=0.1 \
 //x=60.57 //y=1.09 //x2=60.57 //y2=1.07
r69 (  3 29 ) resistor r=3.57586 //w=0.17 //l=0.125 //layer=li //thickness=0.1 \
 //x=60.57 //y=0.805 //x2=60.57 //y2=0.68
r70 (  3 29 ) resistor r=18.139 //w=0.187 //l=0.265 //layer=li //thickness=0.1 \
 //x=60.57 //y=0.805 //x2=60.57 //y2=1.07
r71 (  2 28 ) resistor r=0.751729 //w=0.17 //l=0.085 //layer=li \
 //thickness=0.1 //x=59.605 //y=1.175 //x2=59.52 //y2=1.175
r72 (  1 25 ) resistor r=1.40859 //w=0.34 //l=0.085 //layer=li //thickness=0.1 \
 //x=60.485 //y=1.175 //x2=60.57 //y2=1.175
r73 (  1 2 ) resistor r=60.2353 //w=0.187 //l=0.88 //layer=li //thickness=0.1 \
 //x=60.485 //y=1.175 //x2=59.605 //y2=1.175
ends PM_TMRDFFSNQX1\%noxref_49

subckt PM_TMRDFFSNQX1\%noxref_50 ( 1 5 9 10 13 17 29 )
c51 ( 29 0 ) capacitor c=0.0632682f //x=62.84 //y=0.545
c52 ( 17 0 ) capacitor c=0.00722223f //x=64.915 //y=0.795
c53 ( 13 0 ) capacitor c=0.0145084f //x=64.83 //y=0.71
c54 ( 10 0 ) capacitor c=0.00582081f //x=63.945 //y=1.675
c55 ( 9 0 ) capacitor c=0.006761f //x=63.945 //y=0.795
c56 ( 5 0 ) capacitor c=0.0173046f //x=63.86 //y=1.76
c57 ( 1 0 ) capacitor c=0.00733328f //x=62.975 //y=1.675
r58 (  17 29 ) resistor r=3.57586 //w=0.17 //l=0.125 //layer=li \
 //thickness=0.1 //x=64.915 //y=0.795 //x2=64.915 //y2=0.67
r59 (  17 29 ) resistor r=18.139 //w=0.187 //l=0.265 //layer=li \
 //thickness=0.1 //x=64.915 //y=0.795 //x2=64.915 //y2=1.06
r60 (  14 29 ) resistor r=3.57586 //w=0.17 //l=0.103078 //layer=li \
 //thickness=0.1 //x=64.03 //y=0.71 //x2=63.945 //y2=0.67
r61 (  14 29 ) resistor r=27.3797 //w=0.187 //l=0.4 //layer=li //thickness=0.1 \
 //x=64.03 //y=0.71 //x2=64.43 //y2=0.71
r62 (  13 29 ) resistor r=3.57586 //w=0.17 //l=0.103078 //layer=li \
 //thickness=0.1 //x=64.83 //y=0.71 //x2=64.915 //y2=0.67
r63 (  13 29 ) resistor r=27.3797 //w=0.187 //l=0.4 //layer=li //thickness=0.1 \
 //x=64.83 //y=0.71 //x2=64.43 //y2=0.71
r64 (  10 29 ) resistor r=3.57586 //w=0.17 //l=0.125 //layer=li \
 //thickness=0.1 //x=63.945 //y=1.675 //x2=63.945 //y2=1.8
r65 (  10 29 ) resistor r=42.0963 //w=0.187 //l=0.615 //layer=li \
 //thickness=0.1 //x=63.945 //y=1.675 //x2=63.945 //y2=1.06
r66 (  9 29 ) resistor r=3.57586 //w=0.17 //l=0.125 //layer=li //thickness=0.1 \
 //x=63.945 //y=0.795 //x2=63.945 //y2=0.67
r67 (  9 29 ) resistor r=18.139 //w=0.187 //l=0.265 //layer=li //thickness=0.1 \
 //x=63.945 //y=0.795 //x2=63.945 //y2=1.06
r68 (  6 29 ) resistor r=3.57586 //w=0.17 //l=0.103078 //layer=li \
 //thickness=0.1 //x=63.06 //y=1.76 //x2=62.975 //y2=1.8
r69 (  6 29 ) resistor r=27.3797 //w=0.187 //l=0.4 //layer=li //thickness=0.1 \
 //x=63.06 //y=1.76 //x2=63.46 //y2=1.76
r70 (  5 29 ) resistor r=3.57586 //w=0.17 //l=0.103078 //layer=li \
 //thickness=0.1 //x=63.86 //y=1.76 //x2=63.945 //y2=1.8
r71 (  5 29 ) resistor r=27.3797 //w=0.187 //l=0.4 //layer=li //thickness=0.1 \
 //x=63.86 //y=1.76 //x2=63.46 //y2=1.76
r72 (  1 29 ) resistor r=3.57586 //w=0.17 //l=0.125 //layer=li //thickness=0.1 \
 //x=62.975 //y=1.675 //x2=62.975 //y2=1.8
r73 (  1 29 ) resistor r=42.0963 //w=0.187 //l=0.615 //layer=li \
 //thickness=0.1 //x=62.975 //y=1.675 //x2=62.975 //y2=1.06
ends PM_TMRDFFSNQX1\%noxref_50

subckt PM_TMRDFFSNQX1\%noxref_51 ( 1 5 9 10 13 17 29 )
c51 ( 29 0 ) capacitor c=0.0632684f //x=66.17 //y=0.545
c52 ( 17 0 ) capacitor c=0.0072343f //x=68.245 //y=0.795
c53 ( 13 0 ) capacitor c=0.0145084f //x=68.16 //y=0.71
c54 ( 10 0 ) capacitor c=0.00582081f //x=67.275 //y=1.675
c55 ( 9 0 ) capacitor c=0.006761f //x=67.275 //y=0.795
c56 ( 5 0 ) capacitor c=0.0173046f //x=67.19 //y=1.76
c57 ( 1 0 ) capacitor c=0.00733328f //x=66.305 //y=1.675
r58 (  17 29 ) resistor r=3.57586 //w=0.17 //l=0.125 //layer=li \
 //thickness=0.1 //x=68.245 //y=0.795 //x2=68.245 //y2=0.67
r59 (  17 29 ) resistor r=18.139 //w=0.187 //l=0.265 //layer=li \
 //thickness=0.1 //x=68.245 //y=0.795 //x2=68.245 //y2=1.06
r60 (  14 29 ) resistor r=3.57586 //w=0.17 //l=0.103078 //layer=li \
 //thickness=0.1 //x=67.36 //y=0.71 //x2=67.275 //y2=0.67
r61 (  14 29 ) resistor r=27.3797 //w=0.187 //l=0.4 //layer=li //thickness=0.1 \
 //x=67.36 //y=0.71 //x2=67.76 //y2=0.71
r62 (  13 29 ) resistor r=3.57586 //w=0.17 //l=0.103078 //layer=li \
 //thickness=0.1 //x=68.16 //y=0.71 //x2=68.245 //y2=0.67
r63 (  13 29 ) resistor r=27.3797 //w=0.187 //l=0.4 //layer=li //thickness=0.1 \
 //x=68.16 //y=0.71 //x2=67.76 //y2=0.71
r64 (  10 29 ) resistor r=3.57586 //w=0.17 //l=0.125 //layer=li \
 //thickness=0.1 //x=67.275 //y=1.675 //x2=67.275 //y2=1.8
r65 (  10 29 ) resistor r=42.0963 //w=0.187 //l=0.615 //layer=li \
 //thickness=0.1 //x=67.275 //y=1.675 //x2=67.275 //y2=1.06
r66 (  9 29 ) resistor r=3.57586 //w=0.17 //l=0.125 //layer=li //thickness=0.1 \
 //x=67.275 //y=0.795 //x2=67.275 //y2=0.67
r67 (  9 29 ) resistor r=18.139 //w=0.187 //l=0.265 //layer=li //thickness=0.1 \
 //x=67.275 //y=0.795 //x2=67.275 //y2=1.06
r68 (  6 29 ) resistor r=3.57586 //w=0.17 //l=0.103078 //layer=li \
 //thickness=0.1 //x=66.39 //y=1.76 //x2=66.305 //y2=1.8
r69 (  6 29 ) resistor r=27.3797 //w=0.187 //l=0.4 //layer=li //thickness=0.1 \
 //x=66.39 //y=1.76 //x2=66.79 //y2=1.76
r70 (  5 29 ) resistor r=3.57586 //w=0.17 //l=0.103078 //layer=li \
 //thickness=0.1 //x=67.19 //y=1.76 //x2=67.275 //y2=1.8
r71 (  5 29 ) resistor r=27.3797 //w=0.187 //l=0.4 //layer=li //thickness=0.1 \
 //x=67.19 //y=1.76 //x2=66.79 //y2=1.76
r72 (  1 29 ) resistor r=3.57586 //w=0.17 //l=0.125 //layer=li //thickness=0.1 \
 //x=66.305 //y=1.675 //x2=66.305 //y2=1.8
r73 (  1 29 ) resistor r=42.0963 //w=0.187 //l=0.615 //layer=li \
 //thickness=0.1 //x=66.305 //y=1.675 //x2=66.305 //y2=1.06
ends PM_TMRDFFSNQX1\%noxref_51

subckt PM_TMRDFFSNQX1\%noxref_52 ( 1 5 9 13 17 35 )
c51 ( 35 0 ) capacitor c=0.0680259f //x=69.395 //y=0.555
c52 ( 17 0 ) capacitor c=0.0180446f //x=71.385 //y=1.77
c53 ( 13 0 ) capacitor c=0.0155283f //x=71.385 //y=0.72
c54 ( 9 0 ) capacitor c=0.00678203f //x=70.5 //y=0.805
c55 ( 5 0 ) capacitor c=0.0164013f //x=70.415 //y=1.77
c56 ( 1 0 ) capacitor c=0.00696517f //x=69.53 //y=1.685
r57 (  18 35 ) resistor r=5.4201 //w=0.17 //l=0.103078 //layer=li \
 //thickness=0.1 //x=70.585 //y=1.77 //x2=70.5 //y2=1.81
r58 (  18 35 ) resistor r=27.3797 //w=0.187 //l=0.4 //layer=li //thickness=0.1 \
 //x=70.585 //y=1.77 //x2=70.985 //y2=1.77
r59 (  17 35 ) resistor r=0.751729 //w=0.17 //l=0.085 //layer=li \
 //thickness=0.1 //x=71.385 //y=1.77 //x2=71.47 //y2=1.77
r60 (  17 35 ) resistor r=27.3797 //w=0.187 //l=0.4 //layer=li //thickness=0.1 \
 //x=71.385 //y=1.77 //x2=70.985 //y2=1.77
r61 (  14 35 ) resistor r=3.57586 //w=0.17 //l=0.103078 //layer=li \
 //thickness=0.1 //x=70.585 //y=0.72 //x2=70.5 //y2=0.68
r62 (  14 35 ) resistor r=27.3797 //w=0.187 //l=0.4 //layer=li //thickness=0.1 \
 //x=70.585 //y=0.72 //x2=70.985 //y2=0.72
r63 (  13 35 ) resistor r=0.751729 //w=0.17 //l=0.085 //layer=li \
 //thickness=0.1 //x=71.385 //y=0.72 //x2=71.47 //y2=0.72
r64 (  13 35 ) resistor r=27.3797 //w=0.187 //l=0.4 //layer=li //thickness=0.1 \
 //x=71.385 //y=0.72 //x2=70.985 //y2=0.72
r65 (  10 35 ) resistor r=1.40859 //w=0.34 //l=0.125 //layer=li \
 //thickness=0.1 //x=70.5 //y=1.685 //x2=70.5 //y2=1.81
r66 (  10 35 ) resistor r=42.0963 //w=0.187 //l=0.615 //layer=li \
 //thickness=0.1 //x=70.5 //y=1.685 //x2=70.5 //y2=1.07
r67 (  9 35 ) resistor r=3.57586 //w=0.17 //l=0.125 //layer=li //thickness=0.1 \
 //x=70.5 //y=0.805 //x2=70.5 //y2=0.68
r68 (  9 35 ) resistor r=18.139 //w=0.187 //l=0.265 //layer=li //thickness=0.1 \
 //x=70.5 //y=0.805 //x2=70.5 //y2=1.07
r69 (  6 35 ) resistor r=3.57586 //w=0.17 //l=0.103078 //layer=li \
 //thickness=0.1 //x=69.615 //y=1.77 //x2=69.53 //y2=1.81
r70 (  6 35 ) resistor r=27.3797 //w=0.187 //l=0.4 //layer=li //thickness=0.1 \
 //x=69.615 //y=1.77 //x2=70.015 //y2=1.77
r71 (  5 35 ) resistor r=5.4201 //w=0.17 //l=0.103078 //layer=li \
 //thickness=0.1 //x=70.415 //y=1.77 //x2=70.5 //y2=1.81
r72 (  5 35 ) resistor r=27.3797 //w=0.187 //l=0.4 //layer=li //thickness=0.1 \
 //x=70.415 //y=1.77 //x2=70.015 //y2=1.77
r73 (  1 35 ) resistor r=3.57586 //w=0.17 //l=0.125 //layer=li //thickness=0.1 \
 //x=69.53 //y=1.685 //x2=69.53 //y2=1.81
r74 (  1 35 ) resistor r=42.0963 //w=0.187 //l=0.615 //layer=li \
 //thickness=0.1 //x=69.53 //y=1.685 //x2=69.53 //y2=1.07
ends PM_TMRDFFSNQX1\%noxref_52

subckt PM_TMRDFFSNQX1\%noxref_53 ( 1 3 11 15 25 28 29 )
c52 ( 29 0 ) capacitor c=0.042068f //x=71.905 //y=0.555
c53 ( 28 0 ) capacitor c=0.00457437f //x=70.8 //y=1.09
c54 ( 25 0 ) capacitor c=0.00156479f //x=72.04 //y=1.175
c55 ( 15 0 ) capacitor c=0.00737666f //x=73.01 //y=0.805
c56 ( 11 0 ) capacitor c=0.014695f //x=72.925 //y=0.72
c57 ( 3 0 ) capacitor c=0.00718386f //x=72.04 //y=0.805
c58 ( 1 0 ) capacitor c=0.0234159f //x=71.955 //y=1.175
r59 (  15 29 ) resistor r=3.57586 //w=0.17 //l=0.125 //layer=li \
 //thickness=0.1 //x=73.01 //y=0.805 //x2=73.01 //y2=0.68
r60 (  15 29 ) resistor r=18.139 //w=0.187 //l=0.265 //layer=li \
 //thickness=0.1 //x=73.01 //y=0.805 //x2=73.01 //y2=1.07
r61 (  12 29 ) resistor r=3.57586 //w=0.17 //l=0.103078 //layer=li \
 //thickness=0.1 //x=72.125 //y=0.72 //x2=72.04 //y2=0.68
r62 (  12 29 ) resistor r=27.3797 //w=0.187 //l=0.4 //layer=li //thickness=0.1 \
 //x=72.125 //y=0.72 //x2=72.525 //y2=0.72
r63 (  11 29 ) resistor r=3.57586 //w=0.17 //l=0.103078 //layer=li \
 //thickness=0.1 //x=72.925 //y=0.72 //x2=73.01 //y2=0.68
r64 (  11 29 ) resistor r=27.3797 //w=0.187 //l=0.4 //layer=li //thickness=0.1 \
 //x=72.925 //y=0.72 //x2=72.525 //y2=0.72
r65 (  7 25 ) resistor r=5.4201 //w=0.17 //l=0.085 //layer=li //thickness=0.1 \
 //x=72.04 //y=1.26 //x2=72.04 //y2=1.175
r66 (  7 29 ) resistor r=10.2674 //w=0.187 //l=0.15 //layer=li //thickness=0.1 \
 //x=72.04 //y=1.26 //x2=72.04 //y2=1.41
r67 (  4 25 ) resistor r=5.4201 //w=0.17 //l=0.085 //layer=li //thickness=0.1 \
 //x=72.04 //y=1.09 //x2=72.04 //y2=1.175
r68 (  4 29 ) resistor r=1.36898 //w=0.187 //l=0.02 //layer=li //thickness=0.1 \
 //x=72.04 //y=1.09 //x2=72.04 //y2=1.07
r69 (  3 29 ) resistor r=3.57586 //w=0.17 //l=0.125 //layer=li //thickness=0.1 \
 //x=72.04 //y=0.805 //x2=72.04 //y2=0.68
r70 (  3 29 ) resistor r=18.139 //w=0.187 //l=0.265 //layer=li //thickness=0.1 \
 //x=72.04 //y=0.805 //x2=72.04 //y2=1.07
r71 (  2 28 ) resistor r=0.751729 //w=0.17 //l=0.085 //layer=li \
 //thickness=0.1 //x=71.075 //y=1.175 //x2=70.99 //y2=1.175
r72 (  1 25 ) resistor r=1.40859 //w=0.34 //l=0.085 //layer=li //thickness=0.1 \
 //x=71.955 //y=1.175 //x2=72.04 //y2=1.175
r73 (  1 2 ) resistor r=60.2353 //w=0.187 //l=0.88 //layer=li //thickness=0.1 \
 //x=71.955 //y=1.175 //x2=71.075 //y2=1.175
ends PM_TMRDFFSNQX1\%noxref_53

subckt PM_TMRDFFSNQX1\%noxref_54 ( 1 5 9 10 13 17 29 )
c57 ( 29 0 ) capacitor c=0.0761166f //x=74.31 //y=0.545
c58 ( 17 0 ) capacitor c=0.0072249f //x=76.385 //y=0.795
c59 ( 13 0 ) capacitor c=0.0154142f //x=76.3 //y=0.71
c60 ( 10 0 ) capacitor c=0.00754234f //x=75.415 //y=1.675
c61 ( 9 0 ) capacitor c=0.006761f //x=75.415 //y=0.795
c62 ( 5 0 ) capacitor c=0.0213241f //x=75.33 //y=1.76
c63 ( 1 0 ) capacitor c=0.00492513f //x=74.445 //y=1.675
r64 (  17 29 ) resistor r=3.57586 //w=0.17 //l=0.125 //layer=li \
 //thickness=0.1 //x=76.385 //y=0.795 //x2=76.385 //y2=0.67
r65 (  17 29 ) resistor r=41.4118 //w=0.187 //l=0.605 //layer=li \
 //thickness=0.1 //x=76.385 //y=0.795 //x2=76.385 //y2=1.4
r66 (  14 29 ) resistor r=3.57586 //w=0.17 //l=0.103078 //layer=li \
 //thickness=0.1 //x=75.5 //y=0.71 //x2=75.415 //y2=0.67
r67 (  14 29 ) resistor r=27.0374 //w=0.187 //l=0.395 //layer=li \
 //thickness=0.1 //x=75.5 //y=0.71 //x2=75.895 //y2=0.71
r68 (  13 29 ) resistor r=3.57586 //w=0.17 //l=0.103078 //layer=li \
 //thickness=0.1 //x=76.3 //y=0.71 //x2=76.385 //y2=0.67
r69 (  13 29 ) resistor r=27.7219 //w=0.187 //l=0.405 //layer=li \
 //thickness=0.1 //x=76.3 //y=0.71 //x2=75.895 //y2=0.71
r70 (  10 29 ) resistor r=3.57586 //w=0.17 //l=0.125 //layer=li \
 //thickness=0.1 //x=75.415 //y=1.675 //x2=75.415 //y2=1.8
r71 (  10 29 ) resistor r=42.0963 //w=0.187 //l=0.615 //layer=li \
 //thickness=0.1 //x=75.415 //y=1.675 //x2=75.415 //y2=1.06
r72 (  9 29 ) resistor r=3.57586 //w=0.17 //l=0.125 //layer=li //thickness=0.1 \
 //x=75.415 //y=0.795 //x2=75.415 //y2=0.67
r73 (  9 29 ) resistor r=18.139 //w=0.187 //l=0.265 //layer=li //thickness=0.1 \
 //x=75.415 //y=0.795 //x2=75.415 //y2=1.06
r74 (  6 29 ) resistor r=3.57586 //w=0.17 //l=0.103078 //layer=li \
 //thickness=0.1 //x=74.53 //y=1.76 //x2=74.445 //y2=1.8
r75 (  6 29 ) resistor r=27.3797 //w=0.187 //l=0.4 //layer=li //thickness=0.1 \
 //x=74.53 //y=1.76 //x2=74.93 //y2=1.76
r76 (  5 29 ) resistor r=3.57586 //w=0.17 //l=0.103078 //layer=li \
 //thickness=0.1 //x=75.33 //y=1.76 //x2=75.415 //y2=1.8
r77 (  5 29 ) resistor r=27.3797 //w=0.187 //l=0.4 //layer=li //thickness=0.1 \
 //x=75.33 //y=1.76 //x2=74.93 //y2=1.76
r78 (  1 29 ) resistor r=3.57586 //w=0.17 //l=0.125 //layer=li //thickness=0.1 \
 //x=74.445 //y=1.675 //x2=74.445 //y2=1.8
r79 (  1 29 ) resistor r=42.0963 //w=0.187 //l=0.615 //layer=li \
 //thickness=0.1 //x=74.445 //y=1.675 //x2=74.445 //y2=1.06
ends PM_TMRDFFSNQX1\%noxref_54

subckt PM_TMRDFFSNQX1\%noxref_55 ( 1 5 9 10 13 17 29 )
c55 ( 29 0 ) capacitor c=0.0723103f //x=77.64 //y=0.545
c56 ( 17 0 ) capacitor c=0.0072249f //x=79.715 //y=0.795
c57 ( 13 0 ) capacitor c=0.0155051f //x=79.63 //y=0.71
c58 ( 10 0 ) capacitor c=0.00907139f //x=78.745 //y=1.675
c59 ( 9 0 ) capacitor c=0.006761f //x=78.745 //y=0.795
c60 ( 5 0 ) capacitor c=0.019003f //x=78.66 //y=1.76
c61 ( 1 0 ) capacitor c=0.00885385f //x=77.775 //y=1.675
r62 (  17 29 ) resistor r=3.57586 //w=0.17 //l=0.125 //layer=li \
 //thickness=0.1 //x=79.715 //y=0.795 //x2=79.715 //y2=0.67
r63 (  17 29 ) resistor r=41.4118 //w=0.187 //l=0.605 //layer=li \
 //thickness=0.1 //x=79.715 //y=0.795 //x2=79.715 //y2=1.4
r64 (  14 29 ) resistor r=3.57586 //w=0.17 //l=0.103078 //layer=li \
 //thickness=0.1 //x=78.83 //y=0.71 //x2=78.745 //y2=0.67
r65 (  14 29 ) resistor r=27.3797 //w=0.187 //l=0.4 //layer=li //thickness=0.1 \
 //x=78.83 //y=0.71 //x2=79.23 //y2=0.71
r66 (  13 29 ) resistor r=3.57586 //w=0.17 //l=0.103078 //layer=li \
 //thickness=0.1 //x=79.63 //y=0.71 //x2=79.715 //y2=0.67
r67 (  13 29 ) resistor r=27.3797 //w=0.187 //l=0.4 //layer=li //thickness=0.1 \
 //x=79.63 //y=0.71 //x2=79.23 //y2=0.71
r68 (  10 29 ) resistor r=3.57586 //w=0.17 //l=0.125 //layer=li \
 //thickness=0.1 //x=78.745 //y=1.675 //x2=78.745 //y2=1.8
r69 (  10 29 ) resistor r=42.0963 //w=0.187 //l=0.615 //layer=li \
 //thickness=0.1 //x=78.745 //y=1.675 //x2=78.745 //y2=1.06
r70 (  9 29 ) resistor r=3.57586 //w=0.17 //l=0.125 //layer=li //thickness=0.1 \
 //x=78.745 //y=0.795 //x2=78.745 //y2=0.67
r71 (  9 29 ) resistor r=18.139 //w=0.187 //l=0.265 //layer=li //thickness=0.1 \
 //x=78.745 //y=0.795 //x2=78.745 //y2=1.06
r72 (  6 29 ) resistor r=3.57586 //w=0.17 //l=0.103078 //layer=li \
 //thickness=0.1 //x=77.86 //y=1.76 //x2=77.775 //y2=1.8
r73 (  6 29 ) resistor r=27.3797 //w=0.187 //l=0.4 //layer=li //thickness=0.1 \
 //x=77.86 //y=1.76 //x2=78.26 //y2=1.76
r74 (  5 29 ) resistor r=3.57586 //w=0.17 //l=0.103078 //layer=li \
 //thickness=0.1 //x=78.66 //y=1.76 //x2=78.745 //y2=1.8
r75 (  5 29 ) resistor r=27.3797 //w=0.187 //l=0.4 //layer=li //thickness=0.1 \
 //x=78.66 //y=1.76 //x2=78.26 //y2=1.76
r76 (  1 29 ) resistor r=3.57586 //w=0.17 //l=0.125 //layer=li //thickness=0.1 \
 //x=77.775 //y=1.675 //x2=77.775 //y2=1.8
r77 (  1 29 ) resistor r=42.0963 //w=0.187 //l=0.615 //layer=li \
 //thickness=0.1 //x=77.775 //y=1.675 //x2=77.775 //y2=1.06
ends PM_TMRDFFSNQX1\%noxref_55

subckt PM_TMRDFFSNQX1\%noxref_56 ( 1 5 9 10 13 17 29 )
c56 ( 29 0 ) capacitor c=0.0637832f //x=80.97 //y=0.545
c57 ( 17 0 ) capacitor c=0.00722228f //x=83.045 //y=0.795
c58 ( 13 0 ) capacitor c=0.0141607f //x=82.96 //y=0.71
c59 ( 10 0 ) capacitor c=0.00712138f //x=82.075 //y=1.675
c60 ( 9 0 ) capacitor c=0.006761f //x=82.075 //y=0.795
c61 ( 5 0 ) capacitor c=0.0233454f //x=81.99 //y=1.76
c62 ( 1 0 ) capacitor c=0.00481264f //x=81.105 //y=1.675
r63 (  17 29 ) resistor r=3.57586 //w=0.17 //l=0.125 //layer=li \
 //thickness=0.1 //x=83.045 //y=0.795 //x2=83.045 //y2=0.67
r64 (  17 29 ) resistor r=18.139 //w=0.187 //l=0.265 //layer=li \
 //thickness=0.1 //x=83.045 //y=0.795 //x2=83.045 //y2=1.06
r65 (  14 29 ) resistor r=3.57586 //w=0.17 //l=0.103078 //layer=li \
 //thickness=0.1 //x=82.16 //y=0.71 //x2=82.075 //y2=0.67
r66 (  14 29 ) resistor r=27.3797 //w=0.187 //l=0.4 //layer=li //thickness=0.1 \
 //x=82.16 //y=0.71 //x2=82.56 //y2=0.71
r67 (  13 29 ) resistor r=3.57586 //w=0.17 //l=0.103078 //layer=li \
 //thickness=0.1 //x=82.96 //y=0.71 //x2=83.045 //y2=0.67
r68 (  13 29 ) resistor r=27.3797 //w=0.187 //l=0.4 //layer=li //thickness=0.1 \
 //x=82.96 //y=0.71 //x2=82.56 //y2=0.71
r69 (  10 29 ) resistor r=3.57586 //w=0.17 //l=0.125 //layer=li \
 //thickness=0.1 //x=82.075 //y=1.675 //x2=82.075 //y2=1.8
r70 (  10 29 ) resistor r=42.0963 //w=0.187 //l=0.615 //layer=li \
 //thickness=0.1 //x=82.075 //y=1.675 //x2=82.075 //y2=1.06
r71 (  9 29 ) resistor r=3.57586 //w=0.17 //l=0.125 //layer=li //thickness=0.1 \
 //x=82.075 //y=0.795 //x2=82.075 //y2=0.67
r72 (  9 29 ) resistor r=18.139 //w=0.187 //l=0.265 //layer=li //thickness=0.1 \
 //x=82.075 //y=0.795 //x2=82.075 //y2=1.06
r73 (  6 29 ) resistor r=3.57586 //w=0.17 //l=0.103078 //layer=li \
 //thickness=0.1 //x=81.19 //y=1.76 //x2=81.105 //y2=1.8
r74 (  6 29 ) resistor r=27.3797 //w=0.187 //l=0.4 //layer=li //thickness=0.1 \
 //x=81.19 //y=1.76 //x2=81.59 //y2=1.76
r75 (  5 29 ) resistor r=3.57586 //w=0.17 //l=0.103078 //layer=li \
 //thickness=0.1 //x=81.99 //y=1.76 //x2=82.075 //y2=1.8
r76 (  5 29 ) resistor r=27.3797 //w=0.187 //l=0.4 //layer=li //thickness=0.1 \
 //x=81.99 //y=1.76 //x2=81.59 //y2=1.76
r77 (  1 29 ) resistor r=3.57586 //w=0.17 //l=0.125 //layer=li //thickness=0.1 \
 //x=81.105 //y=1.675 //x2=81.105 //y2=1.8
r78 (  1 29 ) resistor r=42.0963 //w=0.187 //l=0.615 //layer=li \
 //thickness=0.1 //x=81.105 //y=1.675 //x2=81.105 //y2=1.06
ends PM_TMRDFFSNQX1\%noxref_56

subckt PM_TMRDFFSNQX1\%Q ( 1 2 3 4 5 6 7 18 19 20 21 31 33 )
c44 ( 33 0 ) capacitor c=0.028734f //x=84.71 //y=5.2
c45 ( 31 0 ) capacitor c=0.0172744f //x=84.665 //y=1.09
c46 ( 21 0 ) capacitor c=0.00575887f //x=84.94 //y=4.76
c47 ( 20 0 ) capacitor c=0.0136889f //x=85.135 //y=4.76
c48 ( 19 0 ) capacitor c=0.00636159f //x=84.935 //y=2.26
c49 ( 18 0 ) capacitor c=0.0140707f //x=85.135 //y=2.26
c50 ( 1 0 ) capacitor c=0.105613f //x=85.22 //y=2.4
r51 (  20 23 ) resistor r=7.15173 //w=0.17 //l=0.120208 //layer=li \
 //thickness=0.1 //x=85.135 //y=4.76 //x2=85.22 //y2=4.675
r52 (  20 21 ) resistor r=13.3476 //w=0.187 //l=0.195 //layer=li \
 //thickness=0.1 //x=85.135 //y=4.76 //x2=84.94 //y2=4.76
r53 (  18 22 ) resistor r=7.15173 //w=0.17 //l=0.120208 //layer=li \
 //thickness=0.1 //x=85.135 //y=2.26 //x2=85.22 //y2=2.345
r54 (  18 19 ) resistor r=13.6898 //w=0.187 //l=0.2 //layer=li //thickness=0.1 \
 //x=85.135 //y=2.26 //x2=84.935 //y2=2.26
r55 (  12 21 ) resistor r=7.15173 //w=0.17 //l=0.120208 //layer=li \
 //thickness=0.1 //x=84.855 //y=4.845 //x2=84.94 //y2=4.76
r56 (  12 33 ) resistor r=72.5562 //w=0.187 //l=1.06 //layer=li \
 //thickness=0.1 //x=84.855 //y=4.845 //x2=84.855 //y2=5.905
r57 (  8 19 ) resistor r=7.15173 //w=0.17 //l=0.120208 //layer=li \
 //thickness=0.1 //x=84.85 //y=2.175 //x2=84.935 //y2=2.26
r58 (  8 31 ) resistor r=67.7647 //w=0.187 //l=0.99 //layer=li //thickness=0.1 \
 //x=84.85 //y=2.175 //x2=84.85 //y2=1.185
r59 (  7 23 ) resistor r=3.76471 //w=0.187 //l=0.055 //layer=li \
 //thickness=0.1 //x=85.22 //y=4.62 //x2=85.22 //y2=4.675
r60 (  6 7 ) resistor r=25.3262 //w=0.187 //l=0.37 //layer=li //thickness=0.1 \
 //x=85.22 //y=4.25 //x2=85.22 //y2=4.62
r61 (  5 6 ) resistor r=25.3262 //w=0.187 //l=0.37 //layer=li //thickness=0.1 \
 //x=85.22 //y=3.88 //x2=85.22 //y2=4.25
r62 (  4 5 ) resistor r=25.3262 //w=0.187 //l=0.37 //layer=li //thickness=0.1 \
 //x=85.22 //y=3.51 //x2=85.22 //y2=3.88
r63 (  3 4 ) resistor r=25.3262 //w=0.187 //l=0.37 //layer=li //thickness=0.1 \
 //x=85.22 //y=3.14 //x2=85.22 //y2=3.51
r64 (  2 3 ) resistor r=25.3262 //w=0.187 //l=0.37 //layer=li //thickness=0.1 \
 //x=85.22 //y=2.77 //x2=85.22 //y2=3.14
r65 (  1 2 ) resistor r=25.3262 //w=0.187 //l=0.37 //layer=li //thickness=0.1 \
 //x=85.22 //y=2.4 //x2=85.22 //y2=2.77
r66 (  1 22 ) resistor r=3.76471 //w=0.187 //l=0.055 //layer=li \
 //thickness=0.1 //x=85.22 //y=2.4 //x2=85.22 //y2=2.345
ends PM_TMRDFFSNQX1\%Q
