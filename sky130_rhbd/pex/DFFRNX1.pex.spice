// File: DFFRNX1.spi.pex
// Created: Tue Apr 29 10:40:14 2025
// Program "Calibre xRC"
// Version "v2023.2_27.15"
// Nominal Temperature: 30C
// Circuit Temperature: 30C
//
simulator lang=spectre
subckt PM_DFFRNX1\%GND ( 1 47 51 54 59 69 77 87 95 103 109 119 125 135 146 150 \
 152 154 157 160 163 164 165 166 167 168 )
c292 ( 168 0 ) capacitor c=0.0208018f //x=24.05 //y=1.045
c293 ( 167 0 ) capacitor c=0.0225954f //x=19.135 //y=1.055
c294 ( 166 0 ) capacitor c=0.0226075f //x=14.325 //y=1.055
c295 ( 165 0 ) capacitor c=0.0207408f //x=11.1 //y=1.045
c296 ( 164 0 ) capacitor c=0.0226571f //x=6.185 //y=1.055
c297 ( 163 0 ) capacitor c=0.022675f //x=1.375 //y=1.055
c298 ( 162 0 ) capacitor c=0.00446416f //x=24.17 //y=0.18
c299 ( 160 0 ) capacitor c=0.109941f //x=23.06 //y=0.175
c300 ( 159 0 ) capacitor c=0.00446464f //x=19.36 //y=0.18
c301 ( 157 0 ) capacitor c=0.10808f //x=18.25 //y=0.175
c302 ( 156 0 ) capacitor c=0.00446464f //x=14.55 //y=0.18
c303 ( 154 0 ) capacitor c=0.104775f //x=13.44 //y=0.175
c304 ( 153 0 ) capacitor c=0.00446416f //x=11.29 //y=0.175
c305 ( 152 0 ) capacitor c=0.108831f //x=10.11 //y=0.175
c306 ( 151 0 ) capacitor c=0.00446464f //x=6.375 //y=0.175
c307 ( 150 0 ) capacitor c=0.108816f //x=5.3 //y=0.175
c308 ( 149 0 ) capacitor c=0.00446464f //x=1.565 //y=0.175
c309 ( 146 0 ) capacitor c=0.279439f //x=26.02 //y=0.18
c310 ( 135 0 ) capacitor c=0.0392803f //x=24.155 //y=0.175
c311 ( 125 0 ) capacitor c=0.133328f //x=22.89 //y=0.175
c312 ( 119 0 ) capacitor c=0.0342713f //x=19.24 //y=0.175
c313 ( 109 0 ) capacitor c=0.135264f //x=18.08 //y=0.175
c314 ( 103 0 ) capacitor c=0.0342713f //x=14.43 //y=0.175
c315 ( 95 0 ) capacitor c=0.0727058f //x=13.27 //y=0.175
c316 ( 87 0 ) capacitor c=0.0392405f //x=11.205 //y=0.175
c317 ( 77 0 ) capacitor c=0.135402f //x=9.94 //y=0.175
c318 ( 69 0 ) capacitor c=0.0343125f //x=6.29 //y=0.175
c319 ( 59 0 ) capacitor c=0.133468f //x=5.13 //y=0.175
c320 ( 54 0 ) capacitor c=0.196955f //x=1.23 //y=0.18
c321 ( 51 0 ) capacitor c=0.0370791f //x=1.48 //y=0.175
c322 ( 47 0 ) capacitor c=0.853454f //x=26.02 //y=0.18
r323 (  144 146 ) resistor r=25.8093 //w=0.367 //l=0.74 //layer=li \
 //thickness=0.1 //x=25.28 //y=0.175 //x2=26.02 //y2=0.175
r324 (  142 162 ) resistor r=2.87058 //w=0.35 //l=0.085 //layer=li \
 //thickness=0.1 //x=24.325 //y=0.175 //x2=24.24 //y2=0.175
r325 (  142 144 ) resistor r=33.3079 //w=0.367 //l=0.955 //layer=li \
 //thickness=0.1 //x=24.325 //y=0.175 //x2=25.28 //y2=0.175
r326 (  137 162 ) resistor r=4.23183 //w=0.7 //l=0.175 //layer=li \
 //thickness=0.1 //x=24.24 //y=0.35 //x2=24.24 //y2=0.175
r327 (  137 168 ) resistor r=53.7326 //w=0.187 //l=0.785 //layer=li \
 //thickness=0.1 //x=24.24 //y=0.35 //x2=24.24 //y2=1.135
r328 (  136 160 ) resistor r=5.29055 //w=0.35 //l=0.17 //layer=li \
 //thickness=0.1 //x=23.23 //y=0.175 //x2=23.06 //y2=0.175
r329 (  135 162 ) resistor r=2.87058 //w=0.35 //l=0.085 //layer=li \
 //thickness=0.1 //x=24.155 //y=0.175 //x2=24.24 //y2=0.175
r330 (  135 136 ) resistor r=32.2616 //w=0.367 //l=0.925 //layer=li \
 //thickness=0.1 //x=24.155 //y=0.175 //x2=23.23 //y2=0.175
r331 (  130 132 ) resistor r=38.7139 //w=0.367 //l=1.11 //layer=li \
 //thickness=0.1 //x=21.58 //y=0.175 //x2=22.69 //y2=0.175
r332 (  128 130 ) resistor r=38.7139 //w=0.367 //l=1.11 //layer=li \
 //thickness=0.1 //x=20.47 //y=0.175 //x2=21.58 //y2=0.175
r333 (  126 159 ) resistor r=2.87058 //w=0.35 //l=0.085 //layer=li \
 //thickness=0.1 //x=19.41 //y=0.175 //x2=19.325 //y2=0.175
r334 (  126 128 ) resistor r=36.97 //w=0.367 //l=1.06 //layer=li \
 //thickness=0.1 //x=19.41 //y=0.175 //x2=20.47 //y2=0.175
r335 (  125 160 ) resistor r=5.29055 //w=0.35 //l=0.17 //layer=li \
 //thickness=0.1 //x=22.89 //y=0.175 //x2=23.06 //y2=0.175
r336 (  125 132 ) resistor r=6.97548 //w=0.367 //l=0.2 //layer=li \
 //thickness=0.1 //x=22.89 //y=0.175 //x2=22.69 //y2=0.175
r337 (  121 159 ) resistor r=4.23183 //w=0.7 //l=0.175 //layer=li \
 //thickness=0.1 //x=19.325 //y=0.35 //x2=19.325 //y2=0.175
r338 (  121 167 ) resistor r=54.4171 //w=0.187 //l=0.795 //layer=li \
 //thickness=0.1 //x=19.325 //y=0.35 //x2=19.325 //y2=1.145
r339 (  120 157 ) resistor r=5.29055 //w=0.35 //l=0.17 //layer=li \
 //thickness=0.1 //x=18.42 //y=0.175 //x2=18.25 //y2=0.175
r340 (  119 159 ) resistor r=2.87058 //w=0.35 //l=0.085 //layer=li \
 //thickness=0.1 //x=19.24 //y=0.175 //x2=19.325 //y2=0.175
r341 (  119 120 ) resistor r=28.5995 //w=0.367 //l=0.82 //layer=li \
 //thickness=0.1 //x=19.24 //y=0.175 //x2=18.42 //y2=0.175
r342 (  114 116 ) resistor r=38.7139 //w=0.367 //l=1.11 //layer=li \
 //thickness=0.1 //x=16.77 //y=0.175 //x2=17.88 //y2=0.175
r343 (  112 114 ) resistor r=38.7139 //w=0.367 //l=1.11 //layer=li \
 //thickness=0.1 //x=15.66 //y=0.175 //x2=16.77 //y2=0.175
r344 (  110 156 ) resistor r=2.87058 //w=0.35 //l=0.085 //layer=li \
 //thickness=0.1 //x=14.6 //y=0.175 //x2=14.515 //y2=0.175
r345 (  110 112 ) resistor r=36.97 //w=0.367 //l=1.06 //layer=li \
 //thickness=0.1 //x=14.6 //y=0.175 //x2=15.66 //y2=0.175
r346 (  109 157 ) resistor r=5.29055 //w=0.35 //l=0.17 //layer=li \
 //thickness=0.1 //x=18.08 //y=0.175 //x2=18.25 //y2=0.175
r347 (  109 116 ) resistor r=6.97548 //w=0.367 //l=0.2 //layer=li \
 //thickness=0.1 //x=18.08 //y=0.175 //x2=17.88 //y2=0.175
r348 (  105 156 ) resistor r=4.23183 //w=0.7 //l=0.175 //layer=li \
 //thickness=0.1 //x=14.515 //y=0.35 //x2=14.515 //y2=0.175
r349 (  105 166 ) resistor r=54.4171 //w=0.187 //l=0.795 //layer=li \
 //thickness=0.1 //x=14.515 //y=0.35 //x2=14.515 //y2=1.145
r350 (  104 154 ) resistor r=5.29055 //w=0.35 //l=0.17 //layer=li \
 //thickness=0.1 //x=13.61 //y=0.175 //x2=13.44 //y2=0.175
r351 (  103 156 ) resistor r=2.87058 //w=0.35 //l=0.085 //layer=li \
 //thickness=0.1 //x=14.43 //y=0.175 //x2=14.515 //y2=0.175
r352 (  103 104 ) resistor r=28.5995 //w=0.367 //l=0.82 //layer=li \
 //thickness=0.1 //x=14.43 //y=0.175 //x2=13.61 //y2=0.175
r353 (  98 100 ) resistor r=38.7139 //w=0.367 //l=1.11 //layer=li \
 //thickness=0.1 //x=11.96 //y=0.175 //x2=13.07 //y2=0.175
r354 (  96 153 ) resistor r=2.87058 //w=0.35 //l=0.085 //layer=li \
 //thickness=0.1 //x=11.375 //y=0.175 //x2=11.29 //y2=0.175
r355 (  96 98 ) resistor r=20.4033 //w=0.367 //l=0.585 //layer=li \
 //thickness=0.1 //x=11.375 //y=0.175 //x2=11.96 //y2=0.175
r356 (  95 154 ) resistor r=5.29055 //w=0.35 //l=0.17 //layer=li \
 //thickness=0.1 //x=13.27 //y=0.175 //x2=13.44 //y2=0.175
r357 (  95 100 ) resistor r=6.97548 //w=0.367 //l=0.2 //layer=li \
 //thickness=0.1 //x=13.27 //y=0.175 //x2=13.07 //y2=0.175
r358 (  91 153 ) resistor r=4.23183 //w=0.7 //l=0.175 //layer=li \
 //thickness=0.1 //x=11.29 //y=0.35 //x2=11.29 //y2=0.175
r359 (  91 165 ) resistor r=53.7326 //w=0.187 //l=0.785 //layer=li \
 //thickness=0.1 //x=11.29 //y=0.35 //x2=11.29 //y2=1.135
r360 (  88 152 ) resistor r=5.29055 //w=0.35 //l=0.17 //layer=li \
 //thickness=0.1 //x=10.28 //y=0.175 //x2=10.11 //y2=0.175
r361 (  88 90 ) resistor r=19.8801 //w=0.367 //l=0.57 //layer=li \
 //thickness=0.1 //x=10.28 //y=0.175 //x2=10.85 //y2=0.175
r362 (  87 153 ) resistor r=2.87058 //w=0.35 //l=0.085 //layer=li \
 //thickness=0.1 //x=11.205 //y=0.175 //x2=11.29 //y2=0.175
r363 (  87 90 ) resistor r=12.3815 //w=0.367 //l=0.355 //layer=li \
 //thickness=0.1 //x=11.205 //y=0.175 //x2=10.85 //y2=0.175
r364 (  82 84 ) resistor r=38.7139 //w=0.367 //l=1.11 //layer=li \
 //thickness=0.1 //x=8.26 //y=0.175 //x2=9.37 //y2=0.175
r365 (  80 82 ) resistor r=38.7139 //w=0.367 //l=1.11 //layer=li \
 //thickness=0.1 //x=7.15 //y=0.175 //x2=8.26 //y2=0.175
r366 (  78 151 ) resistor r=2.87058 //w=0.35 //l=0.085 //layer=li \
 //thickness=0.1 //x=6.46 //y=0.175 //x2=6.375 //y2=0.175
r367 (  78 80 ) resistor r=24.0654 //w=0.367 //l=0.69 //layer=li \
 //thickness=0.1 //x=6.46 //y=0.175 //x2=7.15 //y2=0.175
r368 (  77 152 ) resistor r=5.29055 //w=0.35 //l=0.17 //layer=li \
 //thickness=0.1 //x=9.94 //y=0.175 //x2=10.11 //y2=0.175
r369 (  77 84 ) resistor r=19.8801 //w=0.367 //l=0.57 //layer=li \
 //thickness=0.1 //x=9.94 //y=0.175 //x2=9.37 //y2=0.175
r370 (  73 151 ) resistor r=4.23183 //w=0.7 //l=0.175 //layer=li \
 //thickness=0.1 //x=6.375 //y=0.35 //x2=6.375 //y2=0.175
r371 (  73 164 ) resistor r=54.4171 //w=0.187 //l=0.795 //layer=li \
 //thickness=0.1 //x=6.375 //y=0.35 //x2=6.375 //y2=1.145
r372 (  70 150 ) resistor r=5.29055 //w=0.35 //l=0.17 //layer=li \
 //thickness=0.1 //x=5.47 //y=0.175 //x2=5.3 //y2=0.175
r373 (  70 72 ) resistor r=19.8801 //w=0.367 //l=0.57 //layer=li \
 //thickness=0.1 //x=5.47 //y=0.175 //x2=6.04 //y2=0.175
r374 (  69 151 ) resistor r=2.87058 //w=0.35 //l=0.085 //layer=li \
 //thickness=0.1 //x=6.29 //y=0.175 //x2=6.375 //y2=0.175
r375 (  69 72 ) resistor r=8.71935 //w=0.367 //l=0.25 //layer=li \
 //thickness=0.1 //x=6.29 //y=0.175 //x2=6.04 //y2=0.175
r376 (  64 66 ) resistor r=38.7139 //w=0.367 //l=1.11 //layer=li \
 //thickness=0.1 //x=3.45 //y=0.175 //x2=4.56 //y2=0.175
r377 (  62 64 ) resistor r=38.7139 //w=0.367 //l=1.11 //layer=li \
 //thickness=0.1 //x=2.34 //y=0.175 //x2=3.45 //y2=0.175
r378 (  60 149 ) resistor r=2.87058 //w=0.35 //l=0.085 //layer=li \
 //thickness=0.1 //x=1.65 //y=0.175 //x2=1.565 //y2=0.175
r379 (  60 62 ) resistor r=24.0654 //w=0.367 //l=0.69 //layer=li \
 //thickness=0.1 //x=1.65 //y=0.175 //x2=2.34 //y2=0.175
r380 (  59 150 ) resistor r=5.29055 //w=0.35 //l=0.17 //layer=li \
 //thickness=0.1 //x=5.13 //y=0.175 //x2=5.3 //y2=0.175
r381 (  59 66 ) resistor r=19.8801 //w=0.367 //l=0.57 //layer=li \
 //thickness=0.1 //x=5.13 //y=0.175 //x2=4.56 //y2=0.175
r382 (  55 149 ) resistor r=4.23183 //w=0.7 //l=0.175 //layer=li \
 //thickness=0.1 //x=1.565 //y=0.35 //x2=1.565 //y2=0.175
r383 (  55 163 ) resistor r=54.4171 //w=0.187 //l=0.795 //layer=li \
 //thickness=0.1 //x=1.565 //y=0.35 //x2=1.565 //y2=1.145
r384 (  51 149 ) resistor r=2.87058 //w=0.35 //l=0.085 //layer=li \
 //thickness=0.1 //x=1.48 //y=0.175 //x2=1.565 //y2=0.175
r385 (  51 54 ) resistor r=8.71935 //w=0.367 //l=0.25 //layer=li \
 //thickness=0.1 //x=1.48 //y=0.175 //x2=1.23 //y2=0.175
r386 (  47 146 ) resistor r=9.3 //w=0.17 //l=0.17 //layer=mcon //count=1 \
 //x=26.02 //y=0.18 //x2=26.02 //y2=0.18
r387 (  45 144 ) resistor r=3.1 //w=0.17 //l=0.51 //layer=mcon //count=3 \
 //x=25.28 //y=0.18 //x2=25.28 //y2=0.18
r388 (  45 47 ) resistor r=0.297428 //w=0.311 //l=0.74 //layer=m1 \
 //thickness=0.36 //x=25.28 //y=0.175 //x2=26.02 //y2=0.175
r389 (  43 162 ) resistor r=3.1 //w=0.17 //l=0.51 //layer=mcon //count=3 \
 //x=24.17 //y=0.18 //x2=24.17 //y2=0.18
r390 (  43 45 ) resistor r=0.446141 //w=0.311 //l=1.11 //layer=m1 \
 //thickness=0.36 //x=24.17 //y=0.175 //x2=25.28 //y2=0.175
r391 (  41 132 ) resistor r=3.1 //w=0.17 //l=0.51 //layer=mcon //count=3 \
 //x=22.69 //y=0.18 //x2=22.69 //y2=0.18
r392 (  41 43 ) resistor r=0.594855 //w=0.311 //l=1.48 //layer=m1 \
 //thickness=0.36 //x=22.69 //y=0.175 //x2=24.17 //y2=0.175
r393 (  39 130 ) resistor r=3.1 //w=0.17 //l=0.51 //layer=mcon //count=3 \
 //x=21.58 //y=0.18 //x2=21.58 //y2=0.18
r394 (  39 41 ) resistor r=0.446141 //w=0.311 //l=1.11 //layer=m1 \
 //thickness=0.36 //x=21.58 //y=0.175 //x2=22.69 //y2=0.175
r395 (  37 128 ) resistor r=3.1 //w=0.17 //l=0.51 //layer=mcon //count=3 \
 //x=20.47 //y=0.18 //x2=20.47 //y2=0.18
r396 (  37 39 ) resistor r=0.446141 //w=0.311 //l=1.11 //layer=m1 \
 //thickness=0.36 //x=20.47 //y=0.175 //x2=21.58 //y2=0.175
r397 (  35 159 ) resistor r=3.1 //w=0.17 //l=0.51 //layer=mcon //count=3 \
 //x=19.36 //y=0.18 //x2=19.36 //y2=0.18
r398 (  35 37 ) resistor r=0.446141 //w=0.311 //l=1.11 //layer=m1 \
 //thickness=0.36 //x=19.36 //y=0.175 //x2=20.47 //y2=0.175
r399 (  33 116 ) resistor r=3.1 //w=0.17 //l=0.51 //layer=mcon //count=3 \
 //x=17.88 //y=0.18 //x2=17.88 //y2=0.18
r400 (  33 35 ) resistor r=0.594855 //w=0.311 //l=1.48 //layer=m1 \
 //thickness=0.36 //x=17.88 //y=0.175 //x2=19.36 //y2=0.175
r401 (  31 114 ) resistor r=3.1 //w=0.17 //l=0.51 //layer=mcon //count=3 \
 //x=16.77 //y=0.18 //x2=16.77 //y2=0.18
r402 (  31 33 ) resistor r=0.446141 //w=0.311 //l=1.11 //layer=m1 \
 //thickness=0.36 //x=16.77 //y=0.175 //x2=17.88 //y2=0.175
r403 (  29 112 ) resistor r=3.1 //w=0.17 //l=0.51 //layer=mcon //count=3 \
 //x=15.66 //y=0.18 //x2=15.66 //y2=0.18
r404 (  29 31 ) resistor r=0.446141 //w=0.311 //l=1.11 //layer=m1 \
 //thickness=0.36 //x=15.66 //y=0.175 //x2=16.77 //y2=0.175
r405 (  27 156 ) resistor r=3.1 //w=0.17 //l=0.51 //layer=mcon //count=3 \
 //x=14.55 //y=0.18 //x2=14.55 //y2=0.18
r406 (  27 29 ) resistor r=0.446141 //w=0.311 //l=1.11 //layer=m1 \
 //thickness=0.36 //x=14.55 //y=0.175 //x2=15.66 //y2=0.175
r407 (  24 100 ) resistor r=3.1 //w=0.17 //l=0.51 //layer=mcon //count=3 \
 //x=13.07 //y=0.18 //x2=13.07 //y2=0.18
r408 (  22 98 ) resistor r=3.1 //w=0.17 //l=0.51 //layer=mcon //count=3 \
 //x=11.96 //y=0.18 //x2=11.96 //y2=0.18
r409 (  22 24 ) resistor r=0.446141 //w=0.311 //l=1.11 //layer=m1 \
 //thickness=0.36 //x=11.96 //y=0.175 //x2=13.07 //y2=0.175
r410 (  20 90 ) resistor r=3.1 //w=0.17 //l=0.51 //layer=mcon //count=3 \
 //x=10.85 //y=0.18 //x2=10.85 //y2=0.18
r411 (  20 22 ) resistor r=0.446141 //w=0.311 //l=1.11 //layer=m1 \
 //thickness=0.36 //x=10.85 //y=0.175 //x2=11.96 //y2=0.175
r412 (  18 84 ) resistor r=3.1 //w=0.17 //l=0.51 //layer=mcon //count=3 \
 //x=9.37 //y=0.18 //x2=9.37 //y2=0.18
r413 (  18 20 ) resistor r=0.594855 //w=0.311 //l=1.48 //layer=m1 \
 //thickness=0.36 //x=9.37 //y=0.175 //x2=10.85 //y2=0.175
r414 (  16 82 ) resistor r=3.1 //w=0.17 //l=0.51 //layer=mcon //count=3 \
 //x=8.26 //y=0.18 //x2=8.26 //y2=0.18
r415 (  16 18 ) resistor r=0.446141 //w=0.311 //l=1.11 //layer=m1 \
 //thickness=0.36 //x=8.26 //y=0.175 //x2=9.37 //y2=0.175
r416 (  14 80 ) resistor r=3.1 //w=0.17 //l=0.51 //layer=mcon //count=3 \
 //x=7.15 //y=0.18 //x2=7.15 //y2=0.18
r417 (  14 16 ) resistor r=0.446141 //w=0.311 //l=1.11 //layer=m1 \
 //thickness=0.36 //x=7.15 //y=0.175 //x2=8.26 //y2=0.175
r418 (  12 72 ) resistor r=3.1 //w=0.17 //l=0.51 //layer=mcon //count=3 \
 //x=6.04 //y=0.18 //x2=6.04 //y2=0.18
r419 (  12 14 ) resistor r=0.446141 //w=0.311 //l=1.11 //layer=m1 \
 //thickness=0.36 //x=6.04 //y=0.175 //x2=7.15 //y2=0.175
r420 (  10 66 ) resistor r=3.1 //w=0.17 //l=0.51 //layer=mcon //count=3 \
 //x=4.56 //y=0.18 //x2=4.56 //y2=0.18
r421 (  10 12 ) resistor r=0.594855 //w=0.311 //l=1.48 //layer=m1 \
 //thickness=0.36 //x=4.56 //y=0.175 //x2=6.04 //y2=0.175
r422 (  8 64 ) resistor r=3.1 //w=0.17 //l=0.51 //layer=mcon //count=3 \
 //x=3.45 //y=0.18 //x2=3.45 //y2=0.18
r423 (  8 10 ) resistor r=0.446141 //w=0.311 //l=1.11 //layer=m1 \
 //thickness=0.36 //x=3.45 //y=0.175 //x2=4.56 //y2=0.175
r424 (  6 62 ) resistor r=3.1 //w=0.17 //l=0.51 //layer=mcon //count=3 \
 //x=2.34 //y=0.18 //x2=2.34 //y2=0.18
r425 (  6 8 ) resistor r=0.446141 //w=0.311 //l=1.11 //layer=m1 \
 //thickness=0.36 //x=2.34 //y=0.175 //x2=3.45 //y2=0.175
r426 (  3 54 ) resistor r=3.1 //w=0.17 //l=0.51 //layer=mcon //count=3 \
 //x=1.23 //y=0.18 //x2=1.23 //y2=0.18
r427 (  3 6 ) resistor r=0.446141 //w=0.311 //l=1.11 //layer=m1 \
 //thickness=0.36 //x=1.23 //y=0.175 //x2=2.34 //y2=0.175
r428 (  1 27 ) resistor r=0.446141 //w=0.311 //l=1.11 //layer=m1 \
 //thickness=0.36 //x=13.44 //y=0.175 //x2=14.55 //y2=0.175
r429 (  1 24 ) resistor r=0.148714 //w=0.311 //l=0.37 //layer=m1 \
 //thickness=0.36 //x=13.44 //y=0.175 //x2=13.07 //y2=0.175
ends PM_DFFRNX1\%GND

subckt PM_DFFRNX1\%VDD ( 1 47 54 61 71 79 89 95 105 115 123 133 139 147 155 \
 165 171 179 187 197 207 213 221 229 239 249 255 263 273 286 293 298 303 309 \
 315 319 320 321 322 323 324 325 326 327 328 329 330 331 332 333 334 335 336 \
 337 338 339 340 )
c323 ( 340 0 ) capacitor c=0.0382077f //x=25.465 //y=5.2
c324 ( 339 0 ) capacitor c=0.0240874f //x=24.585 //y=5.2
c325 ( 338 0 ) capacitor c=0.0495447f //x=23.715 //y=5.2
c326 ( 337 0 ) capacitor c=0.045306f //x=21.835 //y=5.2
c327 ( 336 0 ) capacitor c=0.0242401f //x=20.955 //y=5.2
c328 ( 335 0 ) capacitor c=0.0242401f //x=20.075 //y=5.2
c329 ( 334 0 ) capacitor c=0.0531794f //x=19.205 //y=5.2
c330 ( 333 0 ) capacitor c=0.045306f //x=17.025 //y=5.2
c331 ( 332 0 ) capacitor c=0.0242401f //x=16.145 //y=5.2
c332 ( 331 0 ) capacitor c=0.0241521f //x=15.265 //y=5.2
c333 ( 330 0 ) capacitor c=0.0531894f //x=14.395 //y=5.2
c334 ( 329 0 ) capacitor c=0.038068f //x=12.515 //y=5.2
c335 ( 328 0 ) capacitor c=0.0240081f //x=11.635 //y=5.2
c336 ( 327 0 ) capacitor c=0.0492093f //x=10.765 //y=5.2
c337 ( 326 0 ) capacitor c=0.045218f //x=8.885 //y=5.2
c338 ( 325 0 ) capacitor c=0.0241521f //x=8.005 //y=5.2
c339 ( 324 0 ) capacitor c=0.0241521f //x=7.125 //y=5.2
c340 ( 323 0 ) capacitor c=0.053132f //x=6.255 //y=5.2
c341 ( 322 0 ) capacitor c=0.045218f //x=4.075 //y=5.2
c342 ( 321 0 ) capacitor c=0.0241521f //x=3.195 //y=5.2
c343 ( 320 0 ) capacitor c=0.0242401f //x=2.315 //y=5.2
c344 ( 319 0 ) capacitor c=0.0531407f //x=1.445 //y=5.2
c345 ( 318 0 ) capacitor c=0.00597439f //x=25.61 //y=7.585
c346 ( 317 0 ) capacitor c=0.00597439f //x=24.73 //y=7.585
c347 ( 316 0 ) capacitor c=0.00597439f //x=23.85 //y=7.585
c348 ( 315 0 ) capacitor c=0.136875f //x=23.06 //y=7.585
c349 ( 314 0 ) capacitor c=0.00597439f //x=21.98 //y=7.585
c350 ( 313 0 ) capacitor c=0.00597439f //x=21.1 //y=7.585
c351 ( 312 0 ) capacitor c=0.00597439f //x=20.22 //y=7.585
c352 ( 311 0 ) capacitor c=0.00597439f //x=19.36 //y=7.58
c353 ( 309 0 ) capacitor c=0.157263f //x=18.25 //y=7.585
c354 ( 308 0 ) capacitor c=0.00597439f //x=17.17 //y=7.585
c355 ( 307 0 ) capacitor c=0.00597439f //x=16.29 //y=7.585
c356 ( 306 0 ) capacitor c=0.00597439f //x=15.41 //y=7.585
c357 ( 305 0 ) capacitor c=0.00597439f //x=14.55 //y=7.58
c358 ( 303 0 ) capacitor c=0.135162f //x=13.44 //y=7.585
c359 ( 302 0 ) capacitor c=0.00597439f //x=12.66 //y=7.585
c360 ( 301 0 ) capacitor c=0.00597439f //x=11.78 //y=7.585
c361 ( 300 0 ) capacitor c=0.00597439f //x=10.85 //y=7.58
c362 ( 298 0 ) capacitor c=0.134682f //x=10.11 //y=7.585
c363 ( 297 0 ) capacitor c=0.00597439f //x=9.03 //y=7.585
c364 ( 296 0 ) capacitor c=0.00597439f //x=8.15 //y=7.585
c365 ( 295 0 ) capacitor c=0.00597439f //x=7.27 //y=7.585
c366 ( 294 0 ) capacitor c=0.00597439f //x=6.39 //y=7.585
c367 ( 293 0 ) capacitor c=0.155314f //x=5.3 //y=7.585
c368 ( 292 0 ) capacitor c=0.00597439f //x=4.22 //y=7.585
c369 ( 291 0 ) capacitor c=0.00597439f //x=3.34 //y=7.585
c370 ( 290 0 ) capacitor c=0.00597439f //x=2.46 //y=7.585
c371 ( 289 0 ) capacitor c=0.00597439f //x=1.58 //y=7.585
c372 ( 286 0 ) capacitor c=0.25658f //x=26.02 //y=7.58
c373 ( 273 0 ) capacitor c=0.028702f //x=25.525 //y=7.585
c374 ( 263 0 ) capacitor c=0.0291291f //x=24.645 //y=7.585
c375 ( 255 0 ) capacitor c=0.024303f //x=23.765 //y=7.585
c376 ( 249 0 ) capacitor c=0.0398302f //x=22.89 //y=7.585
c377 ( 239 0 ) capacitor c=0.0291418f //x=21.895 //y=7.585
c378 ( 229 0 ) capacitor c=0.0290414f //x=21.015 //y=7.585
c379 ( 221 0 ) capacitor c=0.0287792f //x=20.135 //y=7.585
c380 ( 213 0 ) capacitor c=0.0386886f //x=19.255 //y=7.585
c381 ( 207 0 ) capacitor c=0.0398272f //x=18.08 //y=7.585
c382 ( 197 0 ) capacitor c=0.0291418f //x=17.085 //y=7.585
c383 ( 187 0 ) capacitor c=0.0290281f //x=16.205 //y=7.585
c384 ( 179 0 ) capacitor c=0.0287649f //x=15.325 //y=7.585
c385 ( 171 0 ) capacitor c=0.0386886f //x=14.445 //y=7.585
c386 ( 165 0 ) capacitor c=0.0238235f //x=13.27 //y=7.585
c387 ( 155 0 ) capacitor c=0.0291008f //x=12.575 //y=7.585
c388 ( 147 0 ) capacitor c=0.0291028f //x=11.695 //y=7.585
c389 ( 139 0 ) capacitor c=0.024303f //x=10.815 //y=7.585
c390 ( 133 0 ) capacitor c=0.0397734f //x=9.94 //y=7.585
c391 ( 123 0 ) capacitor c=0.0291138f //x=8.945 //y=7.585
c392 ( 115 0 ) capacitor c=0.0290172f //x=8.065 //y=7.585
c393 ( 105 0 ) capacitor c=0.0287649f //x=7.185 //y=7.585
c394 ( 95 0 ) capacitor c=0.0386886f //x=6.305 //y=7.585
c395 ( 89 0 ) capacitor c=0.0397734f //x=5.13 //y=7.585
c396 ( 79 0 ) capacitor c=0.0291138f //x=4.135 //y=7.585
c397 ( 71 0 ) capacitor c=0.0290163f //x=3.255 //y=7.585
c398 ( 61 0 ) capacitor c=0.0287792f //x=2.375 //y=7.585
c399 ( 54 0 ) capacitor c=0.253096f //x=1.23 //y=7.58
c400 ( 51 0 ) capacitor c=0.0455283f //x=1.495 //y=7.585
c401 ( 47 0 ) capacitor c=0.936793f //x=26.02 //y=7.58
r402 (  284 318 ) resistor r=2.87058 //w=0.35 //l=0.085 //layer=li \
 //thickness=0.1 //x=25.695 //y=7.585 //x2=25.61 //y2=7.585
r403 (  284 286 ) resistor r=11.3351 //w=0.367 //l=0.325 //layer=li \
 //thickness=0.1 //x=25.695 //y=7.585 //x2=26.02 //y2=7.585
r404 (  277 318 ) resistor r=4.23183 //w=0.7 //l=0.175 //layer=li \
 //thickness=0.1 //x=25.61 //y=7.41 //x2=25.61 //y2=7.585
r405 (  277 340 ) resistor r=33.1979 //w=0.187 //l=0.485 //layer=li \
 //thickness=0.1 //x=25.61 //y=7.41 //x2=25.61 //y2=6.925
r406 (  274 317 ) resistor r=2.87058 //w=0.35 //l=0.085 //layer=li \
 //thickness=0.1 //x=24.815 //y=7.585 //x2=24.73 //y2=7.585
r407 (  274 276 ) resistor r=16.218 //w=0.367 //l=0.465 //layer=li \
 //thickness=0.1 //x=24.815 //y=7.585 //x2=25.28 //y2=7.585
r408 (  273 318 ) resistor r=2.87058 //w=0.35 //l=0.085 //layer=li \
 //thickness=0.1 //x=25.525 //y=7.585 //x2=25.61 //y2=7.585
r409 (  273 276 ) resistor r=8.54496 //w=0.367 //l=0.245 //layer=li \
 //thickness=0.1 //x=25.525 //y=7.585 //x2=25.28 //y2=7.585
r410 (  267 317 ) resistor r=4.23183 //w=0.7 //l=0.175 //layer=li \
 //thickness=0.1 //x=24.73 //y=7.41 //x2=24.73 //y2=7.585
r411 (  267 339 ) resistor r=33.1979 //w=0.187 //l=0.485 //layer=li \
 //thickness=0.1 //x=24.73 //y=7.41 //x2=24.73 //y2=6.925
r412 (  264 316 ) resistor r=2.87058 //w=0.35 //l=0.085 //layer=li \
 //thickness=0.1 //x=23.935 //y=7.585 //x2=23.85 //y2=7.585
r413 (  264 266 ) resistor r=8.19619 //w=0.367 //l=0.235 //layer=li \
 //thickness=0.1 //x=23.935 //y=7.585 //x2=24.17 //y2=7.585
r414 (  263 317 ) resistor r=2.87058 //w=0.35 //l=0.085 //layer=li \
 //thickness=0.1 //x=24.645 //y=7.585 //x2=24.73 //y2=7.585
r415 (  263 266 ) resistor r=16.5668 //w=0.367 //l=0.475 //layer=li \
 //thickness=0.1 //x=24.645 //y=7.585 //x2=24.17 //y2=7.585
r416 (  257 316 ) resistor r=4.23183 //w=0.7 //l=0.175 //layer=li \
 //thickness=0.1 //x=23.85 //y=7.41 //x2=23.85 //y2=7.585
r417 (  257 338 ) resistor r=56.4706 //w=0.187 //l=0.825 //layer=li \
 //thickness=0.1 //x=23.85 //y=7.41 //x2=23.85 //y2=6.585
r418 (  256 315 ) resistor r=5.29055 //w=0.35 //l=0.17 //layer=li \
 //thickness=0.1 //x=23.23 //y=7.585 //x2=23.06 //y2=7.585
r419 (  255 316 ) resistor r=2.87058 //w=0.35 //l=0.085 //layer=li \
 //thickness=0.1 //x=23.765 //y=7.585 //x2=23.85 //y2=7.585
r420 (  255 256 ) resistor r=18.6594 //w=0.367 //l=0.535 //layer=li \
 //thickness=0.1 //x=23.765 //y=7.585 //x2=23.23 //y2=7.585
r421 (  250 314 ) resistor r=2.87058 //w=0.35 //l=0.085 //layer=li \
 //thickness=0.1 //x=22.065 //y=7.585 //x2=21.98 //y2=7.585
r422 (  250 252 ) resistor r=21.7984 //w=0.367 //l=0.625 //layer=li \
 //thickness=0.1 //x=22.065 //y=7.585 //x2=22.69 //y2=7.585
r423 (  249 315 ) resistor r=5.29055 //w=0.35 //l=0.17 //layer=li \
 //thickness=0.1 //x=22.89 //y=7.585 //x2=23.06 //y2=7.585
r424 (  249 252 ) resistor r=6.97548 //w=0.367 //l=0.2 //layer=li \
 //thickness=0.1 //x=22.89 //y=7.585 //x2=22.69 //y2=7.585
r425 (  243 314 ) resistor r=4.23183 //w=0.7 //l=0.175 //layer=li \
 //thickness=0.1 //x=21.98 //y=7.41 //x2=21.98 //y2=7.585
r426 (  243 337 ) resistor r=33.1979 //w=0.187 //l=0.485 //layer=li \
 //thickness=0.1 //x=21.98 //y=7.41 //x2=21.98 //y2=6.925
r427 (  240 313 ) resistor r=2.87058 //w=0.35 //l=0.085 //layer=li \
 //thickness=0.1 //x=21.185 //y=7.585 //x2=21.1 //y2=7.585
r428 (  240 242 ) resistor r=13.7766 //w=0.367 //l=0.395 //layer=li \
 //thickness=0.1 //x=21.185 //y=7.585 //x2=21.58 //y2=7.585
r429 (  239 314 ) resistor r=2.87058 //w=0.35 //l=0.085 //layer=li \
 //thickness=0.1 //x=21.895 //y=7.585 //x2=21.98 //y2=7.585
r430 (  239 242 ) resistor r=10.9864 //w=0.367 //l=0.315 //layer=li \
 //thickness=0.1 //x=21.895 //y=7.585 //x2=21.58 //y2=7.585
r431 (  233 313 ) resistor r=4.23183 //w=0.7 //l=0.175 //layer=li \
 //thickness=0.1 //x=21.1 //y=7.41 //x2=21.1 //y2=7.585
r432 (  233 336 ) resistor r=33.1979 //w=0.187 //l=0.485 //layer=li \
 //thickness=0.1 //x=21.1 //y=7.41 //x2=21.1 //y2=6.925
r433 (  230 312 ) resistor r=2.87058 //w=0.35 //l=0.085 //layer=li \
 //thickness=0.1 //x=20.305 //y=7.585 //x2=20.22 //y2=7.585
r434 (  230 232 ) resistor r=5.75477 //w=0.367 //l=0.165 //layer=li \
 //thickness=0.1 //x=20.305 //y=7.585 //x2=20.47 //y2=7.585
r435 (  229 313 ) resistor r=2.87058 //w=0.35 //l=0.085 //layer=li \
 //thickness=0.1 //x=21.015 //y=7.585 //x2=21.1 //y2=7.585
r436 (  229 232 ) resistor r=19.0082 //w=0.367 //l=0.545 //layer=li \
 //thickness=0.1 //x=21.015 //y=7.585 //x2=20.47 //y2=7.585
r437 (  223 312 ) resistor r=4.23183 //w=0.7 //l=0.175 //layer=li \
 //thickness=0.1 //x=20.22 //y=7.41 //x2=20.22 //y2=7.585
r438 (  223 335 ) resistor r=33.1979 //w=0.187 //l=0.485 //layer=li \
 //thickness=0.1 //x=20.22 //y=7.41 //x2=20.22 //y2=6.925
r439 (  222 311 ) resistor r=2.87058 //w=0.35 //l=0.085 //layer=li \
 //thickness=0.1 //x=19.425 //y=7.585 //x2=19.34 //y2=7.585
r440 (  221 312 ) resistor r=2.87058 //w=0.35 //l=0.085 //layer=li \
 //thickness=0.1 //x=20.135 //y=7.585 //x2=20.22 //y2=7.585
r441 (  221 222 ) resistor r=24.7629 //w=0.367 //l=0.71 //layer=li \
 //thickness=0.1 //x=20.135 //y=7.585 //x2=19.425 //y2=7.585
r442 (  215 311 ) resistor r=4.23183 //w=0.7 //l=0.175 //layer=li \
 //thickness=0.1 //x=19.34 //y=7.41 //x2=19.34 //y2=7.585
r443 (  215 334 ) resistor r=56.4706 //w=0.187 //l=0.825 //layer=li \
 //thickness=0.1 //x=19.34 //y=7.41 //x2=19.34 //y2=6.585
r444 (  214 309 ) resistor r=5.29055 //w=0.35 //l=0.17 //layer=li \
 //thickness=0.1 //x=18.42 //y=7.585 //x2=18.25 //y2=7.585
r445 (  213 311 ) resistor r=2.87058 //w=0.35 //l=0.085 //layer=li \
 //thickness=0.1 //x=19.255 //y=7.585 //x2=19.34 //y2=7.585
r446 (  213 214 ) resistor r=29.1226 //w=0.367 //l=0.835 //layer=li \
 //thickness=0.1 //x=19.255 //y=7.585 //x2=18.42 //y2=7.585
r447 (  208 308 ) resistor r=2.87058 //w=0.35 //l=0.085 //layer=li \
 //thickness=0.1 //x=17.255 //y=7.585 //x2=17.17 //y2=7.585
r448 (  208 210 ) resistor r=21.7984 //w=0.367 //l=0.625 //layer=li \
 //thickness=0.1 //x=17.255 //y=7.585 //x2=17.88 //y2=7.585
r449 (  207 309 ) resistor r=5.29055 //w=0.35 //l=0.17 //layer=li \
 //thickness=0.1 //x=18.08 //y=7.585 //x2=18.25 //y2=7.585
r450 (  207 210 ) resistor r=6.97548 //w=0.367 //l=0.2 //layer=li \
 //thickness=0.1 //x=18.08 //y=7.585 //x2=17.88 //y2=7.585
r451 (  201 308 ) resistor r=4.23183 //w=0.7 //l=0.175 //layer=li \
 //thickness=0.1 //x=17.17 //y=7.41 //x2=17.17 //y2=7.585
r452 (  201 333 ) resistor r=33.1979 //w=0.187 //l=0.485 //layer=li \
 //thickness=0.1 //x=17.17 //y=7.41 //x2=17.17 //y2=6.925
r453 (  198 307 ) resistor r=2.87058 //w=0.35 //l=0.085 //layer=li \
 //thickness=0.1 //x=16.375 //y=7.585 //x2=16.29 //y2=7.585
r454 (  198 200 ) resistor r=13.7766 //w=0.367 //l=0.395 //layer=li \
 //thickness=0.1 //x=16.375 //y=7.585 //x2=16.77 //y2=7.585
r455 (  197 308 ) resistor r=2.87058 //w=0.35 //l=0.085 //layer=li \
 //thickness=0.1 //x=17.085 //y=7.585 //x2=17.17 //y2=7.585
r456 (  197 200 ) resistor r=10.9864 //w=0.367 //l=0.315 //layer=li \
 //thickness=0.1 //x=17.085 //y=7.585 //x2=16.77 //y2=7.585
r457 (  191 307 ) resistor r=4.23183 //w=0.7 //l=0.175 //layer=li \
 //thickness=0.1 //x=16.29 //y=7.41 //x2=16.29 //y2=7.585
r458 (  191 332 ) resistor r=33.1979 //w=0.187 //l=0.485 //layer=li \
 //thickness=0.1 //x=16.29 //y=7.41 //x2=16.29 //y2=6.925
r459 (  188 306 ) resistor r=2.87058 //w=0.35 //l=0.085 //layer=li \
 //thickness=0.1 //x=15.495 //y=7.585 //x2=15.41 //y2=7.585
r460 (  188 190 ) resistor r=5.75477 //w=0.367 //l=0.165 //layer=li \
 //thickness=0.1 //x=15.495 //y=7.585 //x2=15.66 //y2=7.585
r461 (  187 307 ) resistor r=2.87058 //w=0.35 //l=0.085 //layer=li \
 //thickness=0.1 //x=16.205 //y=7.585 //x2=16.29 //y2=7.585
r462 (  187 190 ) resistor r=19.0082 //w=0.367 //l=0.545 //layer=li \
 //thickness=0.1 //x=16.205 //y=7.585 //x2=15.66 //y2=7.585
r463 (  181 306 ) resistor r=4.23183 //w=0.7 //l=0.175 //layer=li \
 //thickness=0.1 //x=15.41 //y=7.41 //x2=15.41 //y2=7.585
r464 (  181 331 ) resistor r=33.1979 //w=0.187 //l=0.485 //layer=li \
 //thickness=0.1 //x=15.41 //y=7.41 //x2=15.41 //y2=6.925
r465 (  180 305 ) resistor r=2.87058 //w=0.35 //l=0.085 //layer=li \
 //thickness=0.1 //x=14.615 //y=7.585 //x2=14.53 //y2=7.585
r466 (  179 306 ) resistor r=2.87058 //w=0.35 //l=0.085 //layer=li \
 //thickness=0.1 //x=15.325 //y=7.585 //x2=15.41 //y2=7.585
r467 (  179 180 ) resistor r=24.7629 //w=0.367 //l=0.71 //layer=li \
 //thickness=0.1 //x=15.325 //y=7.585 //x2=14.615 //y2=7.585
r468 (  173 305 ) resistor r=4.23183 //w=0.7 //l=0.175 //layer=li \
 //thickness=0.1 //x=14.53 //y=7.41 //x2=14.53 //y2=7.585
r469 (  173 330 ) resistor r=56.4706 //w=0.187 //l=0.825 //layer=li \
 //thickness=0.1 //x=14.53 //y=7.41 //x2=14.53 //y2=6.585
r470 (  172 303 ) resistor r=5.29055 //w=0.35 //l=0.17 //layer=li \
 //thickness=0.1 //x=13.61 //y=7.585 //x2=13.44 //y2=7.585
r471 (  171 305 ) resistor r=2.87058 //w=0.35 //l=0.085 //layer=li \
 //thickness=0.1 //x=14.445 //y=7.585 //x2=14.53 //y2=7.585
r472 (  171 172 ) resistor r=29.1226 //w=0.367 //l=0.835 //layer=li \
 //thickness=0.1 //x=14.445 //y=7.585 //x2=13.61 //y2=7.585
r473 (  166 302 ) resistor r=2.87058 //w=0.35 //l=0.085 //layer=li \
 //thickness=0.1 //x=12.745 //y=7.585 //x2=12.66 //y2=7.585
r474 (  166 168 ) resistor r=11.3351 //w=0.367 //l=0.325 //layer=li \
 //thickness=0.1 //x=12.745 //y=7.585 //x2=13.07 //y2=7.585
r475 (  165 303 ) resistor r=5.29055 //w=0.35 //l=0.17 //layer=li \
 //thickness=0.1 //x=13.27 //y=7.585 //x2=13.44 //y2=7.585
r476 (  165 168 ) resistor r=6.97548 //w=0.367 //l=0.2 //layer=li \
 //thickness=0.1 //x=13.27 //y=7.585 //x2=13.07 //y2=7.585
r477 (  159 302 ) resistor r=4.23183 //w=0.7 //l=0.175 //layer=li \
 //thickness=0.1 //x=12.66 //y=7.41 //x2=12.66 //y2=7.585
r478 (  159 329 ) resistor r=33.1979 //w=0.187 //l=0.485 //layer=li \
 //thickness=0.1 //x=12.66 //y=7.41 //x2=12.66 //y2=6.925
r479 (  156 301 ) resistor r=2.87058 //w=0.35 //l=0.085 //layer=li \
 //thickness=0.1 //x=11.865 //y=7.585 //x2=11.78 //y2=7.585
r480 (  156 158 ) resistor r=3.31335 //w=0.367 //l=0.095 //layer=li \
 //thickness=0.1 //x=11.865 //y=7.585 //x2=11.96 //y2=7.585
r481 (  155 302 ) resistor r=2.87058 //w=0.35 //l=0.085 //layer=li \
 //thickness=0.1 //x=12.575 //y=7.585 //x2=12.66 //y2=7.585
r482 (  155 158 ) resistor r=21.4496 //w=0.367 //l=0.615 //layer=li \
 //thickness=0.1 //x=12.575 //y=7.585 //x2=11.96 //y2=7.585
r483 (  149 301 ) resistor r=4.23183 //w=0.7 //l=0.175 //layer=li \
 //thickness=0.1 //x=11.78 //y=7.41 //x2=11.78 //y2=7.585
r484 (  149 328 ) resistor r=33.1979 //w=0.187 //l=0.485 //layer=li \
 //thickness=0.1 //x=11.78 //y=7.41 //x2=11.78 //y2=6.925
r485 (  148 300 ) resistor r=2.87058 //w=0.35 //l=0.085 //layer=li \
 //thickness=0.1 //x=10.985 //y=7.585 //x2=10.9 //y2=7.585
r486 (  147 301 ) resistor r=2.87058 //w=0.35 //l=0.085 //layer=li \
 //thickness=0.1 //x=11.695 //y=7.585 //x2=11.78 //y2=7.585
r487 (  147 148 ) resistor r=24.7629 //w=0.367 //l=0.71 //layer=li \
 //thickness=0.1 //x=11.695 //y=7.585 //x2=10.985 //y2=7.585
r488 (  141 300 ) resistor r=4.23183 //w=0.7 //l=0.175 //layer=li \
 //thickness=0.1 //x=10.9 //y=7.41 //x2=10.9 //y2=7.585
r489 (  141 327 ) resistor r=56.4706 //w=0.187 //l=0.825 //layer=li \
 //thickness=0.1 //x=10.9 //y=7.41 //x2=10.9 //y2=6.585
r490 (  140 298 ) resistor r=5.29055 //w=0.35 //l=0.17 //layer=li \
 //thickness=0.1 //x=10.28 //y=7.585 //x2=10.11 //y2=7.585
r491 (  139 300 ) resistor r=2.87058 //w=0.35 //l=0.085 //layer=li \
 //thickness=0.1 //x=10.815 //y=7.585 //x2=10.9 //y2=7.585
r492 (  139 140 ) resistor r=18.6594 //w=0.367 //l=0.535 //layer=li \
 //thickness=0.1 //x=10.815 //y=7.585 //x2=10.28 //y2=7.585
r493 (  134 297 ) resistor r=2.87058 //w=0.35 //l=0.085 //layer=li \
 //thickness=0.1 //x=9.115 //y=7.585 //x2=9.03 //y2=7.585
r494 (  134 136 ) resistor r=8.89373 //w=0.367 //l=0.255 //layer=li \
 //thickness=0.1 //x=9.115 //y=7.585 //x2=9.37 //y2=7.585
r495 (  133 298 ) resistor r=5.29055 //w=0.35 //l=0.17 //layer=li \
 //thickness=0.1 //x=9.94 //y=7.585 //x2=10.11 //y2=7.585
r496 (  133 136 ) resistor r=19.8801 //w=0.367 //l=0.57 //layer=li \
 //thickness=0.1 //x=9.94 //y=7.585 //x2=9.37 //y2=7.585
r497 (  127 297 ) resistor r=4.23183 //w=0.7 //l=0.175 //layer=li \
 //thickness=0.1 //x=9.03 //y=7.41 //x2=9.03 //y2=7.585
r498 (  127 326 ) resistor r=33.1979 //w=0.187 //l=0.485 //layer=li \
 //thickness=0.1 //x=9.03 //y=7.41 //x2=9.03 //y2=6.925
r499 (  124 296 ) resistor r=2.87058 //w=0.35 //l=0.085 //layer=li \
 //thickness=0.1 //x=8.235 //y=7.585 //x2=8.15 //y2=7.585
r500 (  124 126 ) resistor r=0.871935 //w=0.367 //l=0.025 //layer=li \
 //thickness=0.1 //x=8.235 //y=7.585 //x2=8.26 //y2=7.585
r501 (  123 297 ) resistor r=2.87058 //w=0.35 //l=0.085 //layer=li \
 //thickness=0.1 //x=8.945 //y=7.585 //x2=9.03 //y2=7.585
r502 (  123 126 ) resistor r=23.891 //w=0.367 //l=0.685 //layer=li \
 //thickness=0.1 //x=8.945 //y=7.585 //x2=8.26 //y2=7.585
r503 (  117 296 ) resistor r=4.23183 //w=0.7 //l=0.175 //layer=li \
 //thickness=0.1 //x=8.15 //y=7.41 //x2=8.15 //y2=7.585
r504 (  117 325 ) resistor r=33.1979 //w=0.187 //l=0.485 //layer=li \
 //thickness=0.1 //x=8.15 //y=7.41 //x2=8.15 //y2=6.925
r505 (  116 295 ) resistor r=2.87058 //w=0.35 //l=0.085 //layer=li \
 //thickness=0.1 //x=7.355 //y=7.585 //x2=7.27 //y2=7.585
r506 (  115 296 ) resistor r=2.87058 //w=0.35 //l=0.085 //layer=li \
 //thickness=0.1 //x=8.065 //y=7.585 //x2=8.15 //y2=7.585
r507 (  115 116 ) resistor r=24.7629 //w=0.367 //l=0.71 //layer=li \
 //thickness=0.1 //x=8.065 //y=7.585 //x2=7.355 //y2=7.585
r508 (  109 295 ) resistor r=4.23183 //w=0.7 //l=0.175 //layer=li \
 //thickness=0.1 //x=7.27 //y=7.41 //x2=7.27 //y2=7.585
r509 (  109 324 ) resistor r=33.1979 //w=0.187 //l=0.485 //layer=li \
 //thickness=0.1 //x=7.27 //y=7.41 //x2=7.27 //y2=6.925
r510 (  106 294 ) resistor r=2.87058 //w=0.35 //l=0.085 //layer=li \
 //thickness=0.1 //x=6.475 //y=7.585 //x2=6.39 //y2=7.585
r511 (  106 108 ) resistor r=23.5422 //w=0.367 //l=0.675 //layer=li \
 //thickness=0.1 //x=6.475 //y=7.585 //x2=7.15 //y2=7.585
r512 (  105 295 ) resistor r=2.87058 //w=0.35 //l=0.085 //layer=li \
 //thickness=0.1 //x=7.185 //y=7.585 //x2=7.27 //y2=7.585
r513 (  105 108 ) resistor r=1.22071 //w=0.367 //l=0.035 //layer=li \
 //thickness=0.1 //x=7.185 //y=7.585 //x2=7.15 //y2=7.585
r514 (  99 294 ) resistor r=4.23183 //w=0.7 //l=0.175 //layer=li \
 //thickness=0.1 //x=6.39 //y=7.41 //x2=6.39 //y2=7.585
r515 (  99 323 ) resistor r=56.4706 //w=0.187 //l=0.825 //layer=li \
 //thickness=0.1 //x=6.39 //y=7.41 //x2=6.39 //y2=6.585
r516 (  96 293 ) resistor r=5.29055 //w=0.35 //l=0.17 //layer=li \
 //thickness=0.1 //x=5.47 //y=7.585 //x2=5.3 //y2=7.585
r517 (  96 98 ) resistor r=19.8801 //w=0.367 //l=0.57 //layer=li \
 //thickness=0.1 //x=5.47 //y=7.585 //x2=6.04 //y2=7.585
r518 (  95 294 ) resistor r=2.87058 //w=0.35 //l=0.085 //layer=li \
 //thickness=0.1 //x=6.305 //y=7.585 //x2=6.39 //y2=7.585
r519 (  95 98 ) resistor r=9.24251 //w=0.367 //l=0.265 //layer=li \
 //thickness=0.1 //x=6.305 //y=7.585 //x2=6.04 //y2=7.585
r520 (  90 292 ) resistor r=2.87058 //w=0.35 //l=0.085 //layer=li \
 //thickness=0.1 //x=4.305 //y=7.585 //x2=4.22 //y2=7.585
r521 (  90 92 ) resistor r=8.89373 //w=0.367 //l=0.255 //layer=li \
 //thickness=0.1 //x=4.305 //y=7.585 //x2=4.56 //y2=7.585
r522 (  89 293 ) resistor r=5.29055 //w=0.35 //l=0.17 //layer=li \
 //thickness=0.1 //x=5.13 //y=7.585 //x2=5.3 //y2=7.585
r523 (  89 92 ) resistor r=19.8801 //w=0.367 //l=0.57 //layer=li \
 //thickness=0.1 //x=5.13 //y=7.585 //x2=4.56 //y2=7.585
r524 (  83 292 ) resistor r=4.23183 //w=0.7 //l=0.175 //layer=li \
 //thickness=0.1 //x=4.22 //y=7.41 //x2=4.22 //y2=7.585
r525 (  83 322 ) resistor r=33.1979 //w=0.187 //l=0.485 //layer=li \
 //thickness=0.1 //x=4.22 //y=7.41 //x2=4.22 //y2=6.925
r526 (  80 291 ) resistor r=2.87058 //w=0.35 //l=0.085 //layer=li \
 //thickness=0.1 //x=3.425 //y=7.585 //x2=3.34 //y2=7.585
r527 (  80 82 ) resistor r=0.871935 //w=0.367 //l=0.025 //layer=li \
 //thickness=0.1 //x=3.425 //y=7.585 //x2=3.45 //y2=7.585
r528 (  79 292 ) resistor r=2.87058 //w=0.35 //l=0.085 //layer=li \
 //thickness=0.1 //x=4.135 //y=7.585 //x2=4.22 //y2=7.585
r529 (  79 82 ) resistor r=23.891 //w=0.367 //l=0.685 //layer=li \
 //thickness=0.1 //x=4.135 //y=7.585 //x2=3.45 //y2=7.585
r530 (  73 291 ) resistor r=4.23183 //w=0.7 //l=0.175 //layer=li \
 //thickness=0.1 //x=3.34 //y=7.41 //x2=3.34 //y2=7.585
r531 (  73 321 ) resistor r=33.1979 //w=0.187 //l=0.485 //layer=li \
 //thickness=0.1 //x=3.34 //y=7.41 //x2=3.34 //y2=6.925
r532 (  72 290 ) resistor r=2.87058 //w=0.35 //l=0.085 //layer=li \
 //thickness=0.1 //x=2.545 //y=7.585 //x2=2.46 //y2=7.585
r533 (  71 291 ) resistor r=2.87058 //w=0.35 //l=0.085 //layer=li \
 //thickness=0.1 //x=3.255 //y=7.585 //x2=3.34 //y2=7.585
r534 (  71 72 ) resistor r=24.7629 //w=0.367 //l=0.71 //layer=li \
 //thickness=0.1 //x=3.255 //y=7.585 //x2=2.545 //y2=7.585
r535 (  65 290 ) resistor r=4.23183 //w=0.7 //l=0.175 //layer=li \
 //thickness=0.1 //x=2.46 //y=7.41 //x2=2.46 //y2=7.585
r536 (  65 320 ) resistor r=33.1979 //w=0.187 //l=0.485 //layer=li \
 //thickness=0.1 //x=2.46 //y=7.41 //x2=2.46 //y2=6.925
r537 (  62 289 ) resistor r=2.87058 //w=0.35 //l=0.085 //layer=li \
 //thickness=0.1 //x=1.665 //y=7.585 //x2=1.58 //y2=7.585
r538 (  62 64 ) resistor r=23.5422 //w=0.367 //l=0.675 //layer=li \
 //thickness=0.1 //x=1.665 //y=7.585 //x2=2.34 //y2=7.585
r539 (  61 290 ) resistor r=2.87058 //w=0.35 //l=0.085 //layer=li \
 //thickness=0.1 //x=2.375 //y=7.585 //x2=2.46 //y2=7.585
r540 (  61 64 ) resistor r=1.22071 //w=0.367 //l=0.035 //layer=li \
 //thickness=0.1 //x=2.375 //y=7.585 //x2=2.34 //y2=7.585
r541 (  55 289 ) resistor r=4.23183 //w=0.7 //l=0.175 //layer=li \
 //thickness=0.1 //x=1.58 //y=7.41 //x2=1.58 //y2=7.585
r542 (  55 319 ) resistor r=56.4706 //w=0.187 //l=0.825 //layer=li \
 //thickness=0.1 //x=1.58 //y=7.41 //x2=1.58 //y2=6.585
r543 (  51 289 ) resistor r=2.87058 //w=0.35 //l=0.085 //layer=li \
 //thickness=0.1 //x=1.495 //y=7.585 //x2=1.58 //y2=7.585
r544 (  51 54 ) resistor r=9.24251 //w=0.367 //l=0.265 //layer=li \
 //thickness=0.1 //x=1.495 //y=7.585 //x2=1.23 //y2=7.585
r545 (  47 286 ) resistor r=9.3 //w=0.17 //l=0.17 //layer=mcon //count=1 \
 //x=26.02 //y=7.58 //x2=26.02 //y2=7.58
r546 (  45 276 ) resistor r=3.1 //w=0.17 //l=0.51 //layer=mcon //count=3 \
 //x=25.28 //y=7.58 //x2=25.28 //y2=7.58
r547 (  45 47 ) resistor r=0.297428 //w=0.311 //l=0.74 //layer=m1 \
 //thickness=0.36 //x=25.28 //y=7.585 //x2=26.02 //y2=7.585
r548 (  43 266 ) resistor r=3.1 //w=0.17 //l=0.51 //layer=mcon //count=3 \
 //x=24.17 //y=7.58 //x2=24.17 //y2=7.58
r549 (  43 45 ) resistor r=0.446141 //w=0.311 //l=1.11 //layer=m1 \
 //thickness=0.36 //x=24.17 //y=7.585 //x2=25.28 //y2=7.585
r550 (  41 252 ) resistor r=3.1 //w=0.17 //l=0.51 //layer=mcon //count=3 \
 //x=22.69 //y=7.58 //x2=22.69 //y2=7.58
r551 (  41 43 ) resistor r=0.594855 //w=0.311 //l=1.48 //layer=m1 \
 //thickness=0.36 //x=22.69 //y=7.585 //x2=24.17 //y2=7.585
r552 (  39 242 ) resistor r=3.1 //w=0.17 //l=0.51 //layer=mcon //count=3 \
 //x=21.58 //y=7.58 //x2=21.58 //y2=7.58
r553 (  39 41 ) resistor r=0.446141 //w=0.311 //l=1.11 //layer=m1 \
 //thickness=0.36 //x=21.58 //y=7.585 //x2=22.69 //y2=7.585
r554 (  37 232 ) resistor r=3.1 //w=0.17 //l=0.51 //layer=mcon //count=3 \
 //x=20.47 //y=7.58 //x2=20.47 //y2=7.58
r555 (  37 39 ) resistor r=0.446141 //w=0.311 //l=1.11 //layer=m1 \
 //thickness=0.36 //x=20.47 //y=7.585 //x2=21.58 //y2=7.585
r556 (  35 311 ) resistor r=3.1 //w=0.17 //l=0.51 //layer=mcon //count=3 \
 //x=19.36 //y=7.58 //x2=19.36 //y2=7.58
r557 (  35 37 ) resistor r=0.446141 //w=0.311 //l=1.11 //layer=m1 \
 //thickness=0.36 //x=19.36 //y=7.585 //x2=20.47 //y2=7.585
r558 (  33 210 ) resistor r=3.1 //w=0.17 //l=0.51 //layer=mcon //count=3 \
 //x=17.88 //y=7.58 //x2=17.88 //y2=7.58
r559 (  33 35 ) resistor r=0.594855 //w=0.311 //l=1.48 //layer=m1 \
 //thickness=0.36 //x=17.88 //y=7.585 //x2=19.36 //y2=7.585
r560 (  31 200 ) resistor r=3.1 //w=0.17 //l=0.51 //layer=mcon //count=3 \
 //x=16.77 //y=7.58 //x2=16.77 //y2=7.58
r561 (  31 33 ) resistor r=0.446141 //w=0.311 //l=1.11 //layer=m1 \
 //thickness=0.36 //x=16.77 //y=7.585 //x2=17.88 //y2=7.585
r562 (  29 190 ) resistor r=3.1 //w=0.17 //l=0.51 //layer=mcon //count=3 \
 //x=15.66 //y=7.58 //x2=15.66 //y2=7.58
r563 (  29 31 ) resistor r=0.446141 //w=0.311 //l=1.11 //layer=m1 \
 //thickness=0.36 //x=15.66 //y=7.585 //x2=16.77 //y2=7.585
r564 (  27 305 ) resistor r=3.1 //w=0.17 //l=0.51 //layer=mcon //count=3 \
 //x=14.55 //y=7.58 //x2=14.55 //y2=7.58
r565 (  27 29 ) resistor r=0.446141 //w=0.311 //l=1.11 //layer=m1 \
 //thickness=0.36 //x=14.55 //y=7.585 //x2=15.66 //y2=7.585
r566 (  24 168 ) resistor r=3.1 //w=0.17 //l=0.51 //layer=mcon //count=3 \
 //x=13.07 //y=7.58 //x2=13.07 //y2=7.58
r567 (  22 158 ) resistor r=3.1 //w=0.17 //l=0.51 //layer=mcon //count=3 \
 //x=11.96 //y=7.58 //x2=11.96 //y2=7.58
r568 (  22 24 ) resistor r=0.446141 //w=0.311 //l=1.11 //layer=m1 \
 //thickness=0.36 //x=11.96 //y=7.585 //x2=13.07 //y2=7.585
r569 (  20 300 ) resistor r=3.1 //w=0.17 //l=0.51 //layer=mcon //count=3 \
 //x=10.85 //y=7.58 //x2=10.85 //y2=7.58
r570 (  20 22 ) resistor r=0.446141 //w=0.311 //l=1.11 //layer=m1 \
 //thickness=0.36 //x=10.85 //y=7.585 //x2=11.96 //y2=7.585
r571 (  18 136 ) resistor r=3.1 //w=0.17 //l=0.51 //layer=mcon //count=3 \
 //x=9.37 //y=7.58 //x2=9.37 //y2=7.58
r572 (  18 20 ) resistor r=0.594855 //w=0.311 //l=1.48 //layer=m1 \
 //thickness=0.36 //x=9.37 //y=7.585 //x2=10.85 //y2=7.585
r573 (  16 126 ) resistor r=3.1 //w=0.17 //l=0.51 //layer=mcon //count=3 \
 //x=8.26 //y=7.58 //x2=8.26 //y2=7.58
r574 (  16 18 ) resistor r=0.446141 //w=0.311 //l=1.11 //layer=m1 \
 //thickness=0.36 //x=8.26 //y=7.585 //x2=9.37 //y2=7.585
r575 (  14 108 ) resistor r=3.1 //w=0.17 //l=0.51 //layer=mcon //count=3 \
 //x=7.15 //y=7.58 //x2=7.15 //y2=7.58
r576 (  14 16 ) resistor r=0.446141 //w=0.311 //l=1.11 //layer=m1 \
 //thickness=0.36 //x=7.15 //y=7.585 //x2=8.26 //y2=7.585
r577 (  12 98 ) resistor r=3.1 //w=0.17 //l=0.51 //layer=mcon //count=3 \
 //x=6.04 //y=7.58 //x2=6.04 //y2=7.58
r578 (  12 14 ) resistor r=0.446141 //w=0.311 //l=1.11 //layer=m1 \
 //thickness=0.36 //x=6.04 //y=7.585 //x2=7.15 //y2=7.585
r579 (  10 92 ) resistor r=3.1 //w=0.17 //l=0.51 //layer=mcon //count=3 \
 //x=4.56 //y=7.58 //x2=4.56 //y2=7.58
r580 (  10 12 ) resistor r=0.594855 //w=0.311 //l=1.48 //layer=m1 \
 //thickness=0.36 //x=4.56 //y=7.585 //x2=6.04 //y2=7.585
r581 (  8 82 ) resistor r=3.1 //w=0.17 //l=0.51 //layer=mcon //count=3 \
 //x=3.45 //y=7.58 //x2=3.45 //y2=7.58
r582 (  8 10 ) resistor r=0.446141 //w=0.311 //l=1.11 //layer=m1 \
 //thickness=0.36 //x=3.45 //y=7.585 //x2=4.56 //y2=7.585
r583 (  6 64 ) resistor r=3.1 //w=0.17 //l=0.51 //layer=mcon //count=3 \
 //x=2.34 //y=7.58 //x2=2.34 //y2=7.58
r584 (  6 8 ) resistor r=0.446141 //w=0.311 //l=1.11 //layer=m1 \
 //thickness=0.36 //x=2.34 //y=7.585 //x2=3.45 //y2=7.585
r585 (  3 54 ) resistor r=3.1 //w=0.17 //l=0.51 //layer=mcon //count=3 \
 //x=1.23 //y=7.58 //x2=1.23 //y2=7.58
r586 (  3 6 ) resistor r=0.446141 //w=0.311 //l=1.11 //layer=m1 \
 //thickness=0.36 //x=1.23 //y=7.585 //x2=2.34 //y2=7.585
r587 (  1 27 ) resistor r=0.446141 //w=0.311 //l=1.11 //layer=m1 \
 //thickness=0.36 //x=13.44 //y=7.585 //x2=14.55 //y2=7.585
r588 (  1 24 ) resistor r=0.148714 //w=0.311 //l=0.37 //layer=m1 \
 //thickness=0.36 //x=13.44 //y=7.585 //x2=13.07 //y2=7.585
ends PM_DFFRNX1\%VDD

subckt PM_DFFRNX1\%noxref_3 ( 1 2 3 4 12 25 26 33 41 47 48 52 54 61 62 63 64 \
 65 66 67 68 72 73 74 79 81 84 85 86 87 88 89 93 95 98 99 104 105 110 119 122 \
 124 125 126 )
c246 ( 126 0 ) capacitor c=0.023087f //x=8.445 //y=5.2
c247 ( 125 0 ) capacitor c=0.023519f //x=7.565 //y=5.2
c248 ( 124 0 ) capacitor c=0.0224735f //x=6.685 //y=5.2
c249 ( 122 0 ) capacitor c=0.00872971f //x=8.695 //y=1.095
c250 ( 119 0 ) capacitor c=0.0588816f //x=11.22 //y=4.88
c251 ( 110 0 ) capacitor c=0.058931f //x=3.82 //y=4.88
c252 ( 105 0 ) capacitor c=0.0273931f //x=3.82 //y=2.095
c253 ( 104 0 ) capacitor c=0.0464411f //x=3.82 //y=2.26
c254 ( 99 0 ) capacitor c=0.0318948f //x=11.555 //y=1.39
c255 ( 98 0 ) capacitor c=0.0187384f //x=11.555 //y=1.045
c256 ( 95 0 ) capacitor c=0.0141798f //x=11.4 //y=1.545
c257 ( 93 0 ) capacitor c=0.0149844f //x=11.4 //y=0.89
c258 ( 89 0 ) capacitor c=0.0813322f //x=11.025 //y=2.095
c259 ( 88 0 ) capacitor c=0.0229267f //x=11.025 //y=1.7
c260 ( 87 0 ) capacitor c=0.0234352f //x=11.025 //y=1.39
c261 ( 86 0 ) capacitor c=0.0199343f //x=11.025 //y=1.045
c262 ( 85 0 ) capacitor c=0.0432517f //x=4.34 //y=1.44
c263 ( 84 0 ) capacitor c=0.0200379f //x=4.34 //y=1.095
c264 ( 81 0 ) capacitor c=0.0158629f //x=4.185 //y=1.595
c265 ( 79 0 ) capacitor c=0.0157803f //x=4.185 //y=0.94
c266 ( 74 0 ) capacitor c=0.0218028f //x=3.81 //y=1.75
c267 ( 73 0 ) capacitor c=0.0207459f //x=3.81 //y=1.44
c268 ( 72 0 ) capacitor c=0.0194308f //x=3.81 //y=1.095
c269 ( 68 0 ) capacitor c=0.110275f //x=11.56 //y=6.2
c270 ( 67 0 ) capacitor c=0.154305f //x=11.12 //y=6.2
c271 ( 66 0 ) capacitor c=0.158794f //x=4 //y=6.2
c272 ( 65 0 ) capacitor c=0.110114f //x=3.56 //y=6.2
c273 ( 62 0 ) capacitor c=0.00106608f //x=8.59 //y=5.335
c274 ( 61 0 ) capacitor c=0.00207319f //x=7.71 //y=5.335
c275 ( 54 0 ) capacitor c=0.0894789f //x=11.22 //y=2.26
c276 ( 52 0 ) capacitor c=0.108812f //x=9.37 //y=3.51
c277 ( 48 0 ) capacitor c=0.00398962f //x=8.97 //y=1.845
c278 ( 47 0 ) capacitor c=0.0137288f //x=9.285 //y=1.845
c279 ( 41 0 ) capacitor c=0.0284988f //x=9.285 //y=5.335
c280 ( 33 0 ) capacitor c=0.0176454f //x=8.505 //y=5.335
c281 ( 26 0 ) capacitor c=0.00332903f //x=6.915 //y=5.335
c282 ( 25 0 ) capacitor c=0.0148427f //x=7.625 //y=5.335
c283 ( 12 0 ) capacitor c=0.0883349f //x=3.82 //y=2.26
c284 ( 4 0 ) capacitor c=0.00479603f //x=9.485 //y=3.51
c285 ( 3 0 ) capacitor c=0.0449509f //x=11.105 //y=3.51
c286 ( 2 0 ) capacitor c=0.0164246f //x=3.935 //y=3.51
c287 ( 1 0 ) capacitor c=0.144217f //x=9.255 //y=3.51
r288 (  117 119 ) resistor r=20.6867 //w=0.233 //l=0.1 //layer=ply \
 //thickness=0.18 //x=11.12 //y=4.88 //x2=11.22 //y2=4.88
r289 (  104 105 ) resistor r=52.7279 //w=0.214 //l=0.165 //layer=ply \
 //thickness=0.18 //x=3.82 //y=2.26 //x2=3.82 //y2=2.095
r290 (  100 119 ) resistor r=70.3348 //w=0.233 //l=0.414367 //layer=ply \
 //thickness=0.18 //x=11.56 //y=5.045 //x2=11.22 //y2=4.88
r291 (  99 121 ) resistor r=45.1352 //w=0.168 //l=0.173853 //layer=ply \
 //thickness=0.18 //x=11.555 //y=1.39 //x2=11.515 //y2=1.545
r292 (  98 120 ) resistor r=45.1352 //w=0.168 //l=0.173853 //layer=ply \
 //thickness=0.18 //x=11.555 //y=1.045 //x2=11.515 //y2=0.89
r293 (  98 99 ) resistor r=176.904 //w=0.094 //l=0.345 //layer=ply \
 //thickness=0.18 //x=11.555 //y=1.045 //x2=11.555 //y2=1.39
r294 (  96 116 ) resistor r=10.701 //w=0.21 //l=0.115 //layer=ply \
 //thickness=0.18 //x=11.18 //y=1.545 //x2=11.065 //y2=1.545
r295 (  95 121 ) resistor r=5.52526 //w=0.168 //l=0.115 //layer=ply \
 //thickness=0.18 //x=11.4 //y=1.545 //x2=11.515 //y2=1.545
r296 (  94 115 ) resistor r=5.52526 //w=0.168 //l=0.115 //layer=ply \
 //thickness=0.18 //x=11.18 //y=0.89 //x2=11.065 //y2=0.89
r297 (  93 120 ) resistor r=5.52526 //w=0.168 //l=0.115 //layer=ply \
 //thickness=0.18 //x=11.4 //y=0.89 //x2=11.515 //y2=0.89
r298 (  93 94 ) resistor r=112.809 //w=0.094 //l=0.22 //layer=ply \
 //thickness=0.18 //x=11.4 //y=0.89 //x2=11.18 //y2=0.89
r299 (  90 117 ) resistor r=13.0941 //w=0.233 //l=0.165 //layer=ply \
 //thickness=0.18 //x=11.12 //y=5.045 //x2=11.12 //y2=4.88
r300 (  89 114 ) resistor r=34.8111 //w=0.27 //l=0.264953 //layer=ply \
 //thickness=0.18 //x=11.025 //y=2.095 //x2=11.22 //y2=2.26
r301 (  88 116 ) resistor r=39.5823 //w=0.21 //l=0.173853 //layer=ply \
 //thickness=0.18 //x=11.025 //y=1.7 //x2=11.065 //y2=1.545
r302 (  88 89 ) resistor r=202.543 //w=0.094 //l=0.395 //layer=ply \
 //thickness=0.18 //x=11.025 //y=1.7 //x2=11.025 //y2=2.095
r303 (  87 116 ) resistor r=39.5823 //w=0.21 //l=0.173853 //layer=ply \
 //thickness=0.18 //x=11.025 //y=1.39 //x2=11.065 //y2=1.545
r304 (  86 115 ) resistor r=45.1352 //w=0.168 //l=0.173853 //layer=ply \
 //thickness=0.18 //x=11.025 //y=1.045 //x2=11.065 //y2=0.89
r305 (  86 87 ) resistor r=176.904 //w=0.094 //l=0.345 //layer=ply \
 //thickness=0.18 //x=11.025 //y=1.045 //x2=11.025 //y2=1.39
r306 (  85 112 ) resistor r=45.1352 //w=0.168 //l=0.173853 //layer=ply \
 //thickness=0.18 //x=4.34 //y=1.44 //x2=4.3 //y2=1.595
r307 (  84 111 ) resistor r=45.1352 //w=0.168 //l=0.173853 //layer=ply \
 //thickness=0.18 //x=4.34 //y=1.095 //x2=4.3 //y2=0.94
r308 (  84 85 ) resistor r=176.904 //w=0.094 //l=0.345 //layer=ply \
 //thickness=0.18 //x=4.34 //y=1.095 //x2=4.34 //y2=1.44
r309 (  82 108 ) resistor r=10.701 //w=0.21 //l=0.115 //layer=ply \
 //thickness=0.18 //x=3.965 //y=1.595 //x2=3.85 //y2=1.595
r310 (  81 112 ) resistor r=5.52526 //w=0.168 //l=0.115 //layer=ply \
 //thickness=0.18 //x=4.185 //y=1.595 //x2=4.3 //y2=1.595
r311 (  80 107 ) resistor r=5.52526 //w=0.168 //l=0.115 //layer=ply \
 //thickness=0.18 //x=3.965 //y=0.94 //x2=3.85 //y2=0.94
r312 (  79 111 ) resistor r=5.52526 //w=0.168 //l=0.115 //layer=ply \
 //thickness=0.18 //x=4.185 //y=0.94 //x2=4.3 //y2=0.94
r313 (  79 80 ) resistor r=112.809 //w=0.094 //l=0.22 //layer=ply \
 //thickness=0.18 //x=4.185 //y=0.94 //x2=3.965 //y2=0.94
r314 (  76 110 ) resistor r=37.236 //w=0.233 //l=0.249199 //layer=ply \
 //thickness=0.18 //x=4 //y=5.045 //x2=3.82 //y2=4.88
r315 (  74 108 ) resistor r=39.5823 //w=0.21 //l=0.173853 //layer=ply \
 //thickness=0.18 //x=3.81 //y=1.75 //x2=3.85 //y2=1.595
r316 (  74 105 ) resistor r=176.904 //w=0.094 //l=0.345 //layer=ply \
 //thickness=0.18 //x=3.81 //y=1.75 //x2=3.81 //y2=2.095
r317 (  73 108 ) resistor r=39.5823 //w=0.21 //l=0.173853 //layer=ply \
 //thickness=0.18 //x=3.81 //y=1.44 //x2=3.85 //y2=1.595
r318 (  72 107 ) resistor r=45.1352 //w=0.168 //l=0.173853 //layer=ply \
 //thickness=0.18 //x=3.81 //y=1.095 //x2=3.85 //y2=0.94
r319 (  72 73 ) resistor r=176.904 //w=0.094 //l=0.345 //layer=ply \
 //thickness=0.18 //x=3.81 //y=1.095 //x2=3.81 //y2=1.44
r320 (  69 110 ) resistor r=53.7854 //w=0.233 //l=0.332415 //layer=ply \
 //thickness=0.18 //x=3.56 //y=5.045 //x2=3.82 //y2=4.88
r321 (  68 100 ) resistor r=592.245 //w=0.094 //l=1.155 //layer=ply \
 //thickness=0.18 //x=11.56 //y=6.2 //x2=11.56 //y2=5.045
r322 (  67 90 ) resistor r=592.245 //w=0.094 //l=1.155 //layer=ply \
 //thickness=0.18 //x=11.12 //y=6.2 //x2=11.12 //y2=5.045
r323 (  66 76 ) resistor r=592.245 //w=0.094 //l=1.155 //layer=ply \
 //thickness=0.18 //x=4 //y=6.2 //x2=4 //y2=5.045
r324 (  65 69 ) resistor r=592.245 //w=0.094 //l=1.155 //layer=ply \
 //thickness=0.18 //x=3.56 //y=6.2 //x2=3.56 //y2=5.045
r325 (  64 95 ) resistor r=56.4043 //w=0.094 //l=0.11 //layer=ply \
 //thickness=0.18 //x=11.29 //y=1.545 //x2=11.4 //y2=1.545
r326 (  64 96 ) resistor r=56.4043 //w=0.094 //l=0.11 //layer=ply \
 //thickness=0.18 //x=11.29 //y=1.545 //x2=11.18 //y2=1.545
r327 (  63 81 ) resistor r=56.4043 //w=0.094 //l=0.11 //layer=ply \
 //thickness=0.18 //x=4.075 //y=1.595 //x2=4.185 //y2=1.595
r328 (  63 82 ) resistor r=56.4043 //w=0.094 //l=0.11 //layer=ply \
 //thickness=0.18 //x=4.075 //y=1.595 //x2=3.965 //y2=1.595
r329 (  59 119 ) resistor r=152 //w=0.17 //l=0.17 //layer=licon //count=1 \
 //x=11.22 //y=4.88 //x2=11.22 //y2=4.88
r330 (  57 59 ) resistor r=93.7754 //w=0.187 //l=1.37 //layer=li \
 //thickness=0.1 //x=11.22 //y=3.51 //x2=11.22 //y2=4.88
r331 (  54 114 ) resistor r=152 //w=0.17 //l=0.17 //layer=licon //count=1 \
 //x=11.22 //y=2.26 //x2=11.22 //y2=2.26
r332 (  54 57 ) resistor r=85.5615 //w=0.187 //l=1.25 //layer=li \
 //thickness=0.1 //x=11.22 //y=2.26 //x2=11.22 //y2=3.51
r333 (  50 52 ) resistor r=119.102 //w=0.187 //l=1.74 //layer=li \
 //thickness=0.1 //x=9.37 //y=5.25 //x2=9.37 //y2=3.51
r334 (  49 52 ) resistor r=108.15 //w=0.187 //l=1.58 //layer=li \
 //thickness=0.1 //x=9.37 //y=1.93 //x2=9.37 //y2=3.51
r335 (  47 49 ) resistor r=7.15173 //w=0.17 //l=0.120208 //layer=li \
 //thickness=0.1 //x=9.285 //y=1.845 //x2=9.37 //y2=1.93
r336 (  47 48 ) resistor r=21.5615 //w=0.187 //l=0.315 //layer=li \
 //thickness=0.1 //x=9.285 //y=1.845 //x2=8.97 //y2=1.845
r337 (  43 48 ) resistor r=7.15173 //w=0.17 //l=0.120208 //layer=li \
 //thickness=0.1 //x=8.885 //y=1.76 //x2=8.97 //y2=1.845
r338 (  43 122 ) resistor r=39.016 //w=0.187 //l=0.57 //layer=li \
 //thickness=0.1 //x=8.885 //y=1.76 //x2=8.885 //y2=1.19
r339 (  42 62 ) resistor r=5.4201 //w=0.17 //l=0.085 //layer=li \
 //thickness=0.1 //x=8.675 //y=5.335 //x2=8.59 //y2=5.335
r340 (  41 50 ) resistor r=7.15173 //w=0.17 //l=0.120208 //layer=li \
 //thickness=0.1 //x=9.285 //y=5.335 //x2=9.37 //y2=5.25
r341 (  41 42 ) resistor r=41.754 //w=0.187 //l=0.61 //layer=li \
 //thickness=0.1 //x=9.285 //y=5.335 //x2=8.675 //y2=5.335
r342 (  35 62 ) resistor r=1.40859 //w=0.34 //l=0.085 //layer=li \
 //thickness=0.1 //x=8.59 //y=5.42 //x2=8.59 //y2=5.335
r343 (  35 126 ) resistor r=33.1979 //w=0.187 //l=0.485 //layer=li \
 //thickness=0.1 //x=8.59 //y=5.42 //x2=8.59 //y2=5.905
r344 (  34 61 ) resistor r=5.4201 //w=0.17 //l=0.085 //layer=li \
 //thickness=0.1 //x=7.795 //y=5.335 //x2=7.71 //y2=5.335
r345 (  33 62 ) resistor r=5.4201 //w=0.17 //l=0.085 //layer=li \
 //thickness=0.1 //x=8.505 //y=5.335 //x2=8.59 //y2=5.335
r346 (  33 34 ) resistor r=48.5989 //w=0.187 //l=0.71 //layer=li \
 //thickness=0.1 //x=8.505 //y=5.335 //x2=7.795 //y2=5.335
r347 (  27 61 ) resistor r=1.40859 //w=0.34 //l=0.085 //layer=li \
 //thickness=0.1 //x=7.71 //y=5.42 //x2=7.71 //y2=5.335
r348 (  27 125 ) resistor r=33.1979 //w=0.187 //l=0.485 //layer=li \
 //thickness=0.1 //x=7.71 //y=5.42 //x2=7.71 //y2=5.905
r349 (  25 61 ) resistor r=5.4201 //w=0.17 //l=0.085 //layer=li \
 //thickness=0.1 //x=7.625 //y=5.335 //x2=7.71 //y2=5.335
r350 (  25 26 ) resistor r=48.5989 //w=0.187 //l=0.71 //layer=li \
 //thickness=0.1 //x=7.625 //y=5.335 //x2=6.915 //y2=5.335
r351 (  19 26 ) resistor r=7.15173 //w=0.17 //l=0.120208 //layer=li \
 //thickness=0.1 //x=6.83 //y=5.42 //x2=6.915 //y2=5.335
r352 (  19 124 ) resistor r=33.1979 //w=0.187 //l=0.485 //layer=li \
 //thickness=0.1 //x=6.83 //y=5.42 //x2=6.83 //y2=5.905
r353 (  17 110 ) resistor r=152 //w=0.17 //l=0.17 //layer=licon //count=1 \
 //x=3.82 //y=4.88 //x2=3.82 //y2=4.88
r354 (  15 17 ) resistor r=93.7754 //w=0.187 //l=1.37 //layer=li \
 //thickness=0.1 //x=3.82 //y=3.51 //x2=3.82 //y2=4.88
r355 (  12 104 ) resistor r=152 //w=0.17 //l=0.17 //layer=licon //count=1 \
 //x=3.82 //y=2.26 //x2=3.82 //y2=2.26
r356 (  12 15 ) resistor r=85.5615 //w=0.187 //l=1.25 //layer=li \
 //thickness=0.1 //x=3.82 //y=2.26 //x2=3.82 //y2=3.51
r357 (  10 57 ) resistor r=9.3 //w=0.17 //l=0.17 //layer=mcon //count=1 \
 //x=11.22 //y=3.51 //x2=11.22 //y2=3.51
r358 (  8 52 ) resistor r=9.3 //w=0.17 //l=0.17 //layer=mcon //count=1 \
 //x=9.37 //y=3.51 //x2=9.37 //y2=3.51
r359 (  6 15 ) resistor r=9.3 //w=0.17 //l=0.17 //layer=mcon //count=1 \
 //x=3.82 //y=3.51 //x2=3.82 //y2=3.51
r360 (  4 8 ) resistor r=0.0880901 //w=0.191 //l=0.115 //layer=m1 \
 //thickness=0.36 //x=9.485 //y=3.51 //x2=9.37 //y2=3.51
r361 (  3 10 ) resistor r=0.0717383 //w=0.224 //l=0.115 //layer=m1 \
 //thickness=0.36 //x=11.105 //y=3.51 //x2=11.22 //y2=3.51
r362 (  3 4 ) resistor r=1.5458 //w=0.131 //l=1.62 //layer=m1 //thickness=0.36 \
 //x=11.105 //y=3.51 //x2=9.485 //y2=3.51
r363 (  2 6 ) resistor r=0.0717383 //w=0.224 //l=0.115 //layer=m1 \
 //thickness=0.36 //x=3.935 //y=3.51 //x2=3.82 //y2=3.51
r364 (  1 8 ) resistor r=0.0880901 //w=0.191 //l=0.115 //layer=m1 \
 //thickness=0.36 //x=9.255 //y=3.51 //x2=9.37 //y2=3.51
r365 (  1 2 ) resistor r=5.07634 //w=0.131 //l=5.32 //layer=m1 \
 //thickness=0.36 //x=9.255 //y=3.51 //x2=3.935 //y2=3.51
ends PM_DFFRNX1\%noxref_3

subckt PM_DFFRNX1\%noxref_4 ( 1 2 13 14 25 27 28 32 34 41 42 43 44 45 46 47 48 \
 49 51 57 58 59 60 72 74 75 )
c147 ( 75 0 ) capacitor c=0.0220291f //x=12.075 //y=5.2
c148 ( 74 0 ) capacitor c=0.0217503f //x=11.195 //y=5.2
c149 ( 72 0 ) capacitor c=0.0084702f //x=12.07 //y=1.085
c150 ( 60 0 ) capacitor c=0.0556143f //x=14.825 //y=4.97
c151 ( 59 0 ) capacitor c=0.0293157f //x=15.115 //y=4.97
c152 ( 58 0 ) capacitor c=0.0347816f //x=14.78 //y=1.4
c153 ( 57 0 ) capacitor c=0.0187487f //x=14.78 //y=1.055
c154 ( 51 0 ) capacitor c=0.0137055f //x=14.625 //y=1.555
c155 ( 49 0 ) capacitor c=0.0149861f //x=14.625 //y=0.9
c156 ( 48 0 ) capacitor c=0.096037f //x=14.25 //y=2.095
c157 ( 47 0 ) capacitor c=0.0228993f //x=14.25 //y=1.71
c158 ( 46 0 ) capacitor c=0.0234352f //x=14.25 //y=1.4
c159 ( 45 0 ) capacitor c=0.0198724f //x=14.25 //y=1.055
c160 ( 44 0 ) capacitor c=0.110114f //x=15.19 //y=6.2
c161 ( 43 0 ) capacitor c=0.158956f //x=14.75 //y=6.2
c162 ( 41 0 ) capacitor c=0.00211606f //x=12.22 //y=5.38
c163 ( 34 0 ) capacitor c=0.0995893f //x=14.55 //y=2.26
c164 ( 32 0 ) capacitor c=0.10775f //x=12.7 //y=3.51
c165 ( 28 0 ) capacitor c=0.00404073f //x=12.345 //y=1.835
c166 ( 27 0 ) capacitor c=0.0122201f //x=12.615 //y=1.835
c167 ( 25 0 ) capacitor c=0.0137995f //x=12.615 //y=5.38
c168 ( 14 0 ) capacitor c=0.00251635f //x=11.425 //y=5.38
c169 ( 13 0 ) capacitor c=0.0143649f //x=12.135 //y=5.38
c170 ( 2 0 ) capacitor c=0.00733653f //x=12.815 //y=3.51
c171 ( 1 0 ) capacitor c=0.0503252f //x=14.435 //y=3.51
r172 (  59 61 ) resistor r=26.9307 //w=0.15 //l=0.106066 //layer=ply \
 //thickness=0.18 //x=15.115 //y=4.97 //x2=15.19 //y2=5.045
r173 (  59 60 ) resistor r=148.702 //w=0.094 //l=0.29 //layer=ply \
 //thickness=0.18 //x=15.115 //y=4.97 //x2=14.825 //y2=4.97
r174 (  58 71 ) resistor r=45.1352 //w=0.168 //l=0.173853 //layer=ply \
 //thickness=0.18 //x=14.78 //y=1.4 //x2=14.74 //y2=1.555
r175 (  57 70 ) resistor r=45.1352 //w=0.168 //l=0.173853 //layer=ply \
 //thickness=0.18 //x=14.78 //y=1.055 //x2=14.74 //y2=0.9
r176 (  57 58 ) resistor r=176.904 //w=0.094 //l=0.345 //layer=ply \
 //thickness=0.18 //x=14.78 //y=1.055 //x2=14.78 //y2=1.4
r177 (  54 60 ) resistor r=22.7971 //w=0.269 //l=0.106066 //layer=ply \
 //thickness=0.18 //x=14.75 //y=5.045 //x2=14.825 //y2=4.97
r178 (  54 69 ) resistor r=35.8364 //w=0.269 //l=0.270185 //layer=ply \
 //thickness=0.18 //x=14.75 //y=5.045 //x2=14.55 //y2=4.88
r179 (  52 65 ) resistor r=10.701 //w=0.21 //l=0.115 //layer=ply \
 //thickness=0.18 //x=14.405 //y=1.555 //x2=14.29 //y2=1.555
r180 (  51 71 ) resistor r=5.52526 //w=0.168 //l=0.115 //layer=ply \
 //thickness=0.18 //x=14.625 //y=1.555 //x2=14.74 //y2=1.555
r181 (  50 64 ) resistor r=5.52526 //w=0.168 //l=0.115 //layer=ply \
 //thickness=0.18 //x=14.405 //y=0.9 //x2=14.29 //y2=0.9
r182 (  49 70 ) resistor r=5.52526 //w=0.168 //l=0.115 //layer=ply \
 //thickness=0.18 //x=14.625 //y=0.9 //x2=14.74 //y2=0.9
r183 (  49 50 ) resistor r=112.809 //w=0.094 //l=0.22 //layer=ply \
 //thickness=0.18 //x=14.625 //y=0.9 //x2=14.405 //y2=0.9
r184 (  48 67 ) resistor r=58.7805 //w=0.246 //l=0.373497 //layer=ply \
 //thickness=0.18 //x=14.25 //y=2.095 //x2=14.55 //y2=2.26
r185 (  47 65 ) resistor r=39.5823 //w=0.21 //l=0.173853 //layer=ply \
 //thickness=0.18 //x=14.25 //y=1.71 //x2=14.29 //y2=1.555
r186 (  47 48 ) resistor r=197.415 //w=0.094 //l=0.385 //layer=ply \
 //thickness=0.18 //x=14.25 //y=1.71 //x2=14.25 //y2=2.095
r187 (  46 65 ) resistor r=39.5823 //w=0.21 //l=0.173853 //layer=ply \
 //thickness=0.18 //x=14.25 //y=1.4 //x2=14.29 //y2=1.555
r188 (  45 64 ) resistor r=45.1352 //w=0.168 //l=0.173853 //layer=ply \
 //thickness=0.18 //x=14.25 //y=1.055 //x2=14.29 //y2=0.9
r189 (  45 46 ) resistor r=176.904 //w=0.094 //l=0.345 //layer=ply \
 //thickness=0.18 //x=14.25 //y=1.055 //x2=14.25 //y2=1.4
r190 (  44 61 ) resistor r=592.245 //w=0.094 //l=1.155 //layer=ply \
 //thickness=0.18 //x=15.19 //y=6.2 //x2=15.19 //y2=5.045
r191 (  43 54 ) resistor r=592.245 //w=0.094 //l=1.155 //layer=ply \
 //thickness=0.18 //x=14.75 //y=6.2 //x2=14.75 //y2=5.045
r192 (  42 51 ) resistor r=56.4043 //w=0.094 //l=0.11 //layer=ply \
 //thickness=0.18 //x=14.515 //y=1.555 //x2=14.625 //y2=1.555
r193 (  42 52 ) resistor r=56.4043 //w=0.094 //l=0.11 //layer=ply \
 //thickness=0.18 //x=14.515 //y=1.555 //x2=14.405 //y2=1.555
r194 (  39 69 ) resistor r=152 //w=0.17 //l=0.17 //layer=licon //count=1 \
 //x=14.55 //y=4.88 //x2=14.55 //y2=4.88
r195 (  37 39 ) resistor r=93.7754 //w=0.187 //l=1.37 //layer=li \
 //thickness=0.1 //x=14.55 //y=3.51 //x2=14.55 //y2=4.88
r196 (  34 67 ) resistor r=152 //w=0.17 //l=0.17 //layer=licon //count=1 \
 //x=14.55 //y=2.26 //x2=14.55 //y2=2.26
r197 (  34 37 ) resistor r=85.5615 //w=0.187 //l=1.25 //layer=li \
 //thickness=0.1 //x=14.55 //y=2.26 //x2=14.55 //y2=3.51
r198 (  30 32 ) resistor r=122.182 //w=0.187 //l=1.785 //layer=li \
 //thickness=0.1 //x=12.7 //y=5.295 //x2=12.7 //y2=3.51
r199 (  29 32 ) resistor r=108.834 //w=0.187 //l=1.59 //layer=li \
 //thickness=0.1 //x=12.7 //y=1.92 //x2=12.7 //y2=3.51
r200 (  27 29 ) resistor r=7.15173 //w=0.17 //l=0.120208 //layer=li \
 //thickness=0.1 //x=12.615 //y=1.835 //x2=12.7 //y2=1.92
r201 (  27 28 ) resistor r=18.4813 //w=0.187 //l=0.27 //layer=li \
 //thickness=0.1 //x=12.615 //y=1.835 //x2=12.345 //y2=1.835
r202 (  26 41 ) resistor r=5.4201 //w=0.17 //l=0.085 //layer=li \
 //thickness=0.1 //x=12.305 //y=5.38 //x2=12.22 //y2=5.38
r203 (  25 30 ) resistor r=7.15173 //w=0.17 //l=0.120208 //layer=li \
 //thickness=0.1 //x=12.615 //y=5.38 //x2=12.7 //y2=5.295
r204 (  25 26 ) resistor r=21.2193 //w=0.187 //l=0.31 //layer=li \
 //thickness=0.1 //x=12.615 //y=5.38 //x2=12.305 //y2=5.38
r205 (  21 28 ) resistor r=7.15173 //w=0.17 //l=0.120208 //layer=li \
 //thickness=0.1 //x=12.26 //y=1.75 //x2=12.345 //y2=1.835
r206 (  21 72 ) resistor r=39.016 //w=0.187 //l=0.57 //layer=li \
 //thickness=0.1 //x=12.26 //y=1.75 //x2=12.26 //y2=1.18
r207 (  15 41 ) resistor r=1.40859 //w=0.34 //l=0.085 //layer=li \
 //thickness=0.1 //x=12.22 //y=5.465 //x2=12.22 //y2=5.38
r208 (  15 75 ) resistor r=30.1176 //w=0.187 //l=0.44 //layer=li \
 //thickness=0.1 //x=12.22 //y=5.465 //x2=12.22 //y2=5.905
r209 (  13 41 ) resistor r=5.4201 //w=0.17 //l=0.085 //layer=li \
 //thickness=0.1 //x=12.135 //y=5.38 //x2=12.22 //y2=5.38
r210 (  13 14 ) resistor r=48.5989 //w=0.187 //l=0.71 //layer=li \
 //thickness=0.1 //x=12.135 //y=5.38 //x2=11.425 //y2=5.38
r211 (  7 14 ) resistor r=7.15173 //w=0.17 //l=0.120208 //layer=li \
 //thickness=0.1 //x=11.34 //y=5.465 //x2=11.425 //y2=5.38
r212 (  7 74 ) resistor r=30.1176 //w=0.187 //l=0.44 //layer=li \
 //thickness=0.1 //x=11.34 //y=5.465 //x2=11.34 //y2=5.905
r213 (  6 37 ) resistor r=9.3 //w=0.17 //l=0.17 //layer=mcon //count=1 \
 //x=14.55 //y=3.51 //x2=14.55 //y2=3.51
r214 (  4 32 ) resistor r=9.3 //w=0.17 //l=0.17 //layer=mcon //count=1 \
 //x=12.7 //y=3.51 //x2=12.7 //y2=3.51
r215 (  2 4 ) resistor r=0.0717383 //w=0.224 //l=0.115 //layer=m1 \
 //thickness=0.36 //x=12.815 //y=3.51 //x2=12.7 //y2=3.51
r216 (  1 6 ) resistor r=0.0717383 //w=0.224 //l=0.115 //layer=m1 \
 //thickness=0.36 //x=14.435 //y=3.51 //x2=14.55 //y2=3.51
r217 (  1 2 ) resistor r=1.5458 //w=0.131 //l=1.62 //layer=m1 //thickness=0.36 \
 //x=14.435 //y=3.51 //x2=12.815 //y2=3.51
ends PM_DFFRNX1\%noxref_4

subckt PM_DFFRNX1\%CLK ( 1 2 7 8 9 10 11 12 13 14 15 16 17 19 32 43 44 45 46 \
 47 48 49 50 51 53 59 60 61 62 63 68 69 70 72 78 79 80 81 82 90 101 )
c215 ( 101 0 ) capacitor c=0.0334842f //x=15.66 //y=4.88
c216 ( 90 0 ) capacitor c=0.0334842f //x=2.71 //y=4.88
c217 ( 82 0 ) capacitor c=0.0249231f //x=15.995 //y=4.97
c218 ( 81 0 ) capacitor c=0.0825763f //x=15.75 //y=2.095
c219 ( 80 0 ) capacitor c=0.0170266f //x=15.75 //y=1.63
c220 ( 79 0 ) capacitor c=0.018609f //x=15.75 //y=1.4
c221 ( 78 0 ) capacitor c=0.0187309f //x=15.75 //y=1.09
c222 ( 72 0 ) capacitor c=0.014725f //x=15.595 //y=1.555
c223 ( 70 0 ) capacitor c=0.0146567f //x=15.595 //y=0.935
c224 ( 69 0 ) capacitor c=0.0335408f //x=15.225 //y=1.4
c225 ( 68 0 ) capacitor c=0.0173761f //x=15.225 //y=1.09
c226 ( 63 0 ) capacitor c=0.0245352f //x=3.045 //y=4.97
c227 ( 62 0 ) capacitor c=0.0850619f //x=2.8 //y=2.095
c228 ( 61 0 ) capacitor c=0.0170266f //x=2.8 //y=1.63
c229 ( 60 0 ) capacitor c=0.018609f //x=2.8 //y=1.4
c230 ( 59 0 ) capacitor c=0.0187309f //x=2.8 //y=1.09
c231 ( 53 0 ) capacitor c=0.014725f //x=2.645 //y=1.555
c232 ( 51 0 ) capacitor c=0.0146567f //x=2.645 //y=0.935
c233 ( 50 0 ) capacitor c=0.0335408f //x=2.275 //y=1.4
c234 ( 49 0 ) capacitor c=0.0173761f //x=2.275 //y=1.09
c235 ( 48 0 ) capacitor c=0.110114f //x=16.07 //y=6.2
c236 ( 47 0 ) capacitor c=0.11012f //x=15.63 //y=6.2
c237 ( 46 0 ) capacitor c=0.110114f //x=3.12 //y=6.2
c238 ( 45 0 ) capacitor c=0.11012f //x=2.68 //y=6.2
c239 ( 32 0 ) capacitor c=0.0952742f //x=15.66 //y=2.26
c240 ( 19 0 ) capacitor c=0.100158f //x=2.71 //y=2.26
c241 ( 2 0 ) capacitor c=0.0154455f //x=2.825 //y=4.62
c242 ( 1 0 ) capacitor c=0.301662f //x=15.545 //y=4.62
r243 (  103 104 ) resistor r=32.4568 //w=0.214 //l=0.075 //layer=ply \
 //thickness=0.18 //x=15.66 //y=4.97 //x2=15.66 //y2=5.045
r244 (  101 103 ) resistor r=20.271 //w=0.214 //l=0.09 //layer=ply \
 //thickness=0.18 //x=15.66 //y=4.88 //x2=15.66 //y2=4.97
r245 (  92 93 ) resistor r=32.4568 //w=0.214 //l=0.075 //layer=ply \
 //thickness=0.18 //x=2.71 //y=4.97 //x2=2.71 //y2=5.045
r246 (  90 92 ) resistor r=20.271 //w=0.214 //l=0.09 //layer=ply \
 //thickness=0.18 //x=2.71 //y=4.88 //x2=2.71 //y2=4.97
r247 (  83 103 ) resistor r=16.5046 //w=0.27 //l=0.135 //layer=ply \
 //thickness=0.18 //x=15.795 //y=4.97 //x2=15.66 //y2=4.97
r248 (  82 84 ) resistor r=26.9307 //w=0.15 //l=0.106066 //layer=ply \
 //thickness=0.18 //x=15.995 //y=4.97 //x2=16.07 //y2=5.045
r249 (  82 83 ) resistor r=102.553 //w=0.094 //l=0.2 //layer=ply \
 //thickness=0.18 //x=15.995 //y=4.97 //x2=15.795 //y2=4.97
r250 (  81 108 ) resistor r=38.6777 //w=0.284 //l=0.198997 //layer=ply \
 //thickness=0.18 //x=15.75 //y=2.095 //x2=15.675 //y2=2.26
r251 (  80 106 ) resistor r=21.2976 //w=0.217 //l=0.0928709 //layer=ply \
 //thickness=0.18 //x=15.75 //y=1.63 //x2=15.71 //y2=1.555
r252 (  80 81 ) resistor r=238.436 //w=0.094 //l=0.465 //layer=ply \
 //thickness=0.18 //x=15.75 //y=1.63 //x2=15.75 //y2=2.095
r253 (  79 106 ) resistor r=39.0671 //w=0.217 //l=0.173853 //layer=ply \
 //thickness=0.18 //x=15.75 //y=1.4 //x2=15.71 //y2=1.555
r254 (  78 105 ) resistor r=45.1352 //w=0.168 //l=0.173853 //layer=ply \
 //thickness=0.18 //x=15.75 //y=1.09 //x2=15.71 //y2=0.935
r255 (  78 79 ) resistor r=158.957 //w=0.094 //l=0.31 //layer=ply \
 //thickness=0.18 //x=15.75 //y=1.09 //x2=15.75 //y2=1.4
r256 (  73 99 ) resistor r=5.52526 //w=0.168 //l=0.115 //layer=ply \
 //thickness=0.18 //x=15.38 //y=1.555 //x2=15.265 //y2=1.555
r257 (  72 106 ) resistor r=11.4558 //w=0.217 //l=0.115 //layer=ply \
 //thickness=0.18 //x=15.595 //y=1.555 //x2=15.71 //y2=1.555
r258 (  71 98 ) resistor r=5.52526 //w=0.168 //l=0.115 //layer=ply \
 //thickness=0.18 //x=15.38 //y=0.935 //x2=15.265 //y2=0.935
r259 (  70 105 ) resistor r=5.52526 //w=0.168 //l=0.115 //layer=ply \
 //thickness=0.18 //x=15.595 //y=0.935 //x2=15.71 //y2=0.935
r260 (  70 71 ) resistor r=110.245 //w=0.094 //l=0.215 //layer=ply \
 //thickness=0.18 //x=15.595 //y=0.935 //x2=15.38 //y2=0.935
r261 (  69 99 ) resistor r=45.1352 //w=0.168 //l=0.173853 //layer=ply \
 //thickness=0.18 //x=15.225 //y=1.4 //x2=15.265 //y2=1.555
r262 (  68 98 ) resistor r=45.1352 //w=0.168 //l=0.173853 //layer=ply \
 //thickness=0.18 //x=15.225 //y=1.09 //x2=15.265 //y2=0.935
r263 (  68 69 ) resistor r=158.957 //w=0.094 //l=0.31 //layer=ply \
 //thickness=0.18 //x=15.225 //y=1.09 //x2=15.225 //y2=1.4
r264 (  64 92 ) resistor r=16.5046 //w=0.27 //l=0.135 //layer=ply \
 //thickness=0.18 //x=2.845 //y=4.97 //x2=2.71 //y2=4.97
r265 (  63 65 ) resistor r=26.9307 //w=0.15 //l=0.106066 //layer=ply \
 //thickness=0.18 //x=3.045 //y=4.97 //x2=3.12 //y2=5.045
r266 (  63 64 ) resistor r=102.553 //w=0.094 //l=0.2 //layer=ply \
 //thickness=0.18 //x=3.045 //y=4.97 //x2=2.845 //y2=4.97
r267 (  62 97 ) resistor r=38.6777 //w=0.284 //l=0.198997 //layer=ply \
 //thickness=0.18 //x=2.8 //y=2.095 //x2=2.725 //y2=2.26
r268 (  61 95 ) resistor r=21.2976 //w=0.217 //l=0.0928709 //layer=ply \
 //thickness=0.18 //x=2.8 //y=1.63 //x2=2.76 //y2=1.555
r269 (  61 62 ) resistor r=238.436 //w=0.094 //l=0.465 //layer=ply \
 //thickness=0.18 //x=2.8 //y=1.63 //x2=2.8 //y2=2.095
r270 (  60 95 ) resistor r=39.0671 //w=0.217 //l=0.173853 //layer=ply \
 //thickness=0.18 //x=2.8 //y=1.4 //x2=2.76 //y2=1.555
r271 (  59 94 ) resistor r=45.1352 //w=0.168 //l=0.173853 //layer=ply \
 //thickness=0.18 //x=2.8 //y=1.09 //x2=2.76 //y2=0.935
r272 (  59 60 ) resistor r=158.957 //w=0.094 //l=0.31 //layer=ply \
 //thickness=0.18 //x=2.8 //y=1.09 //x2=2.8 //y2=1.4
r273 (  54 88 ) resistor r=5.52526 //w=0.168 //l=0.115 //layer=ply \
 //thickness=0.18 //x=2.43 //y=1.555 //x2=2.315 //y2=1.555
r274 (  53 95 ) resistor r=11.4558 //w=0.217 //l=0.115 //layer=ply \
 //thickness=0.18 //x=2.645 //y=1.555 //x2=2.76 //y2=1.555
r275 (  52 87 ) resistor r=5.52526 //w=0.168 //l=0.115 //layer=ply \
 //thickness=0.18 //x=2.43 //y=0.935 //x2=2.315 //y2=0.935
r276 (  51 94 ) resistor r=5.52526 //w=0.168 //l=0.115 //layer=ply \
 //thickness=0.18 //x=2.645 //y=0.935 //x2=2.76 //y2=0.935
r277 (  51 52 ) resistor r=110.245 //w=0.094 //l=0.215 //layer=ply \
 //thickness=0.18 //x=2.645 //y=0.935 //x2=2.43 //y2=0.935
r278 (  50 88 ) resistor r=45.1352 //w=0.168 //l=0.173853 //layer=ply \
 //thickness=0.18 //x=2.275 //y=1.4 //x2=2.315 //y2=1.555
r279 (  49 87 ) resistor r=45.1352 //w=0.168 //l=0.173853 //layer=ply \
 //thickness=0.18 //x=2.275 //y=1.09 //x2=2.315 //y2=0.935
r280 (  49 50 ) resistor r=158.957 //w=0.094 //l=0.31 //layer=ply \
 //thickness=0.18 //x=2.275 //y=1.09 //x2=2.275 //y2=1.4
r281 (  48 84 ) resistor r=592.245 //w=0.094 //l=1.155 //layer=ply \
 //thickness=0.18 //x=16.07 //y=6.2 //x2=16.07 //y2=5.045
r282 (  47 104 ) resistor r=592.245 //w=0.094 //l=1.155 //layer=ply \
 //thickness=0.18 //x=15.63 //y=6.2 //x2=15.63 //y2=5.045
r283 (  46 65 ) resistor r=592.245 //w=0.094 //l=1.155 //layer=ply \
 //thickness=0.18 //x=3.12 //y=6.2 //x2=3.12 //y2=5.045
r284 (  45 93 ) resistor r=592.245 //w=0.094 //l=1.155 //layer=ply \
 //thickness=0.18 //x=2.68 //y=6.2 //x2=2.68 //y2=5.045
r285 (  44 72 ) resistor r=55.3787 //w=0.094 //l=0.108 //layer=ply \
 //thickness=0.18 //x=15.487 //y=1.555 //x2=15.595 //y2=1.555
r286 (  44 73 ) resistor r=54.866 //w=0.094 //l=0.107 //layer=ply \
 //thickness=0.18 //x=15.487 //y=1.555 //x2=15.38 //y2=1.555
r287 (  43 53 ) resistor r=55.3787 //w=0.094 //l=0.108 //layer=ply \
 //thickness=0.18 //x=2.537 //y=1.555 //x2=2.645 //y2=1.555
r288 (  43 54 ) resistor r=54.866 //w=0.094 //l=0.107 //layer=ply \
 //thickness=0.18 //x=2.537 //y=1.555 //x2=2.43 //y2=1.555
r289 (  41 101 ) resistor r=152 //w=0.17 //l=0.17 //layer=licon //count=1 \
 //x=15.66 //y=4.88 //x2=15.66 //y2=4.88
r290 (  32 108 ) resistor r=152 //w=0.17 //l=0.17 //layer=licon //count=1 \
 //x=15.66 //y=2.26 //x2=15.66 //y2=2.26
r291 (  29 90 ) resistor r=152 //w=0.17 //l=0.17 //layer=licon //count=1 \
 //x=2.71 //y=4.88 //x2=2.71 //y2=4.88
r292 (  19 97 ) resistor r=152 //w=0.17 //l=0.17 //layer=licon //count=1 \
 //x=2.71 //y=2.26 //x2=2.71 //y2=2.26
r293 (  17 41 ) resistor r=17.7968 //w=0.187 //l=0.26 //layer=li \
 //thickness=0.1 //x=15.66 //y=4.62 //x2=15.66 //y2=4.88
r294 (  16 17 ) resistor r=75.9786 //w=0.187 //l=1.11 //layer=li \
 //thickness=0.1 //x=15.66 //y=3.51 //x2=15.66 //y2=4.62
r295 (  15 16 ) resistor r=25.3262 //w=0.187 //l=0.37 //layer=li \
 //thickness=0.1 //x=15.66 //y=3.14 //x2=15.66 //y2=3.51
r296 (  14 15 ) resistor r=25.3262 //w=0.187 //l=0.37 //layer=li \
 //thickness=0.1 //x=15.66 //y=2.77 //x2=15.66 //y2=3.14
r297 (  13 14 ) resistor r=25.3262 //w=0.187 //l=0.37 //layer=li \
 //thickness=0.1 //x=15.66 //y=2.4 //x2=15.66 //y2=2.77
r298 (  13 32 ) resistor r=9.58289 //w=0.187 //l=0.14 //layer=li \
 //thickness=0.1 //x=15.66 //y=2.4 //x2=15.66 //y2=2.26
r299 (  12 29 ) resistor r=17.7968 //w=0.187 //l=0.26 //layer=li \
 //thickness=0.1 //x=2.71 //y=4.62 //x2=2.71 //y2=4.88
r300 (  11 12 ) resistor r=50.6524 //w=0.187 //l=0.74 //layer=li \
 //thickness=0.1 //x=2.71 //y=3.88 //x2=2.71 //y2=4.62
r301 (  10 11 ) resistor r=25.3262 //w=0.187 //l=0.37 //layer=li \
 //thickness=0.1 //x=2.71 //y=3.51 //x2=2.71 //y2=3.88
r302 (  9 10 ) resistor r=25.3262 //w=0.187 //l=0.37 //layer=li \
 //thickness=0.1 //x=2.71 //y=3.14 //x2=2.71 //y2=3.51
r303 (  8 9 ) resistor r=25.3262 //w=0.187 //l=0.37 //layer=li //thickness=0.1 \
 //x=2.71 //y=2.77 //x2=2.71 //y2=3.14
r304 (  7 8 ) resistor r=25.3262 //w=0.187 //l=0.37 //layer=li //thickness=0.1 \
 //x=2.71 //y=2.4 //x2=2.71 //y2=2.77
r305 (  7 19 ) resistor r=9.58289 //w=0.187 //l=0.14 //layer=li \
 //thickness=0.1 //x=2.71 //y=2.4 //x2=2.71 //y2=2.26
r306 (  6 17 ) resistor r=9.3 //w=0.17 //l=0.17 //layer=mcon //count=1 \
 //x=15.66 //y=4.62 //x2=15.66 //y2=4.62
r307 (  4 12 ) resistor r=9.3 //w=0.17 //l=0.17 //layer=mcon //count=1 \
 //x=2.71 //y=4.62 //x2=2.71 //y2=4.62
r308 (  2 4 ) resistor r=0.0717383 //w=0.224 //l=0.115 //layer=m1 \
 //thickness=0.36 //x=2.825 //y=4.62 //x2=2.71 //y2=4.62
r309 (  1 6 ) resistor r=0.0717383 //w=0.224 //l=0.115 //layer=m1 \
 //thickness=0.36 //x=15.545 //y=4.62 //x2=15.66 //y2=4.62
r310 (  1 2 ) resistor r=12.1374 //w=0.131 //l=12.72 //layer=m1 \
 //thickness=0.36 //x=15.545 //y=4.62 //x2=2.825 //y2=4.62
ends PM_DFFRNX1\%CLK

subckt PM_DFFRNX1\%noxref_6 ( 1 2 3 4 17 18 25 33 39 40 44 46 54 61 62 63 64 \
 65 66 67 68 69 70 71 72 73 75 81 82 83 84 88 89 90 91 92 94 100 101 102 103 \
 123 125 126 127 )
c246 ( 127 0 ) capacitor c=0.023087f //x=3.635 //y=5.2
c247 ( 126 0 ) capacitor c=0.023519f //x=2.755 //y=5.2
c248 ( 125 0 ) capacitor c=0.0224735f //x=1.875 //y=5.2
c249 ( 123 0 ) capacitor c=0.00853354f //x=3.885 //y=1.095
c250 ( 103 0 ) capacitor c=0.0558396f //x=19.635 //y=4.97
c251 ( 102 0 ) capacitor c=0.0298189f //x=19.925 //y=4.97
c252 ( 101 0 ) capacitor c=0.0347816f //x=19.59 //y=1.4
c253 ( 100 0 ) capacitor c=0.0187487f //x=19.59 //y=1.055
c254 ( 94 0 ) capacitor c=0.0137055f //x=19.435 //y=1.555
c255 ( 92 0 ) capacitor c=0.0149861f //x=19.435 //y=0.9
c256 ( 91 0 ) capacitor c=0.096037f //x=19.06 //y=2.095
c257 ( 90 0 ) capacitor c=0.0228993f //x=19.06 //y=1.71
c258 ( 89 0 ) capacitor c=0.0234352f //x=19.06 //y=1.4
c259 ( 88 0 ) capacitor c=0.0198724f //x=19.06 //y=1.055
c260 ( 84 0 ) capacitor c=0.0556143f //x=6.685 //y=4.97
c261 ( 83 0 ) capacitor c=0.0293157f //x=6.975 //y=4.97
c262 ( 82 0 ) capacitor c=0.0347816f //x=6.64 //y=1.4
c263 ( 81 0 ) capacitor c=0.0187487f //x=6.64 //y=1.055
c264 ( 75 0 ) capacitor c=0.0137055f //x=6.485 //y=1.555
c265 ( 73 0 ) capacitor c=0.0149861f //x=6.485 //y=0.9
c266 ( 72 0 ) capacitor c=0.102158f //x=6.11 //y=2.095
c267 ( 71 0 ) capacitor c=0.0229444f //x=6.11 //y=1.71
c268 ( 70 0 ) capacitor c=0.0234352f //x=6.11 //y=1.4
c269 ( 69 0 ) capacitor c=0.0198724f //x=6.11 //y=1.055
c270 ( 68 0 ) capacitor c=0.110114f //x=20 //y=6.2
c271 ( 67 0 ) capacitor c=0.158956f //x=19.56 //y=6.2
c272 ( 66 0 ) capacitor c=0.110114f //x=7.05 //y=6.2
c273 ( 65 0 ) capacitor c=0.158956f //x=6.61 //y=6.2
c274 ( 62 0 ) capacitor c=0.00106608f //x=3.78 //y=5.335
c275 ( 61 0 ) capacitor c=0.00207162f //x=2.9 //y=5.335
c276 ( 54 0 ) capacitor c=0.106024f //x=19.36 //y=2.26
c277 ( 46 0 ) capacitor c=0.102261f //x=6.41 //y=2.26
c278 ( 44 0 ) capacitor c=0.109709f //x=4.56 //y=3.88
c279 ( 40 0 ) capacitor c=0.00493499f //x=4.16 //y=1.845
c280 ( 39 0 ) capacitor c=0.0154052f //x=4.475 //y=1.845
c281 ( 33 0 ) capacitor c=0.0283082f //x=4.475 //y=5.335
c282 ( 25 0 ) capacitor c=0.0176454f //x=3.695 //y=5.335
c283 ( 18 0 ) capacitor c=0.00351598f //x=2.105 //y=5.335
c284 ( 17 0 ) capacitor c=0.0154196f //x=2.815 //y=5.335
c285 ( 4 0 ) capacitor c=0.00424246f //x=6.525 //y=3.88
c286 ( 3 0 ) capacitor c=0.237637f //x=19.245 //y=3.88
c287 ( 2 0 ) capacitor c=0.0125346f //x=4.675 //y=3.88
c288 ( 1 0 ) capacitor c=0.0288301f //x=6.295 //y=3.88
r289 (  102 104 ) resistor r=26.9307 //w=0.15 //l=0.106066 //layer=ply \
 //thickness=0.18 //x=19.925 //y=4.97 //x2=20 //y2=5.045
r290 (  102 103 ) resistor r=148.702 //w=0.094 //l=0.29 //layer=ply \
 //thickness=0.18 //x=19.925 //y=4.97 //x2=19.635 //y2=4.97
r291 (  101 122 ) resistor r=45.1352 //w=0.168 //l=0.173853 //layer=ply \
 //thickness=0.18 //x=19.59 //y=1.4 //x2=19.55 //y2=1.555
r292 (  100 121 ) resistor r=45.1352 //w=0.168 //l=0.173853 //layer=ply \
 //thickness=0.18 //x=19.59 //y=1.055 //x2=19.55 //y2=0.9
r293 (  100 101 ) resistor r=176.904 //w=0.094 //l=0.345 //layer=ply \
 //thickness=0.18 //x=19.59 //y=1.055 //x2=19.59 //y2=1.4
r294 (  97 103 ) resistor r=22.7971 //w=0.269 //l=0.106066 //layer=ply \
 //thickness=0.18 //x=19.56 //y=5.045 //x2=19.635 //y2=4.97
r295 (  97 120 ) resistor r=35.8364 //w=0.269 //l=0.270185 //layer=ply \
 //thickness=0.18 //x=19.56 //y=5.045 //x2=19.36 //y2=4.88
r296 (  95 116 ) resistor r=10.701 //w=0.21 //l=0.115 //layer=ply \
 //thickness=0.18 //x=19.215 //y=1.555 //x2=19.1 //y2=1.555
r297 (  94 122 ) resistor r=5.52526 //w=0.168 //l=0.115 //layer=ply \
 //thickness=0.18 //x=19.435 //y=1.555 //x2=19.55 //y2=1.555
r298 (  93 115 ) resistor r=5.52526 //w=0.168 //l=0.115 //layer=ply \
 //thickness=0.18 //x=19.215 //y=0.9 //x2=19.1 //y2=0.9
r299 (  92 121 ) resistor r=5.52526 //w=0.168 //l=0.115 //layer=ply \
 //thickness=0.18 //x=19.435 //y=0.9 //x2=19.55 //y2=0.9
r300 (  92 93 ) resistor r=112.809 //w=0.094 //l=0.22 //layer=ply \
 //thickness=0.18 //x=19.435 //y=0.9 //x2=19.215 //y2=0.9
r301 (  91 118 ) resistor r=58.7805 //w=0.246 //l=0.373497 //layer=ply \
 //thickness=0.18 //x=19.06 //y=2.095 //x2=19.36 //y2=2.26
r302 (  90 116 ) resistor r=39.5823 //w=0.21 //l=0.173853 //layer=ply \
 //thickness=0.18 //x=19.06 //y=1.71 //x2=19.1 //y2=1.555
r303 (  90 91 ) resistor r=197.415 //w=0.094 //l=0.385 //layer=ply \
 //thickness=0.18 //x=19.06 //y=1.71 //x2=19.06 //y2=2.095
r304 (  89 116 ) resistor r=39.5823 //w=0.21 //l=0.173853 //layer=ply \
 //thickness=0.18 //x=19.06 //y=1.4 //x2=19.1 //y2=1.555
r305 (  88 115 ) resistor r=45.1352 //w=0.168 //l=0.173853 //layer=ply \
 //thickness=0.18 //x=19.06 //y=1.055 //x2=19.1 //y2=0.9
r306 (  88 89 ) resistor r=176.904 //w=0.094 //l=0.345 //layer=ply \
 //thickness=0.18 //x=19.06 //y=1.055 //x2=19.06 //y2=1.4
r307 (  83 85 ) resistor r=26.9307 //w=0.15 //l=0.106066 //layer=ply \
 //thickness=0.18 //x=6.975 //y=4.97 //x2=7.05 //y2=5.045
r308 (  83 84 ) resistor r=148.702 //w=0.094 //l=0.29 //layer=ply \
 //thickness=0.18 //x=6.975 //y=4.97 //x2=6.685 //y2=4.97
r309 (  82 114 ) resistor r=45.1352 //w=0.168 //l=0.173853 //layer=ply \
 //thickness=0.18 //x=6.64 //y=1.4 //x2=6.6 //y2=1.555
r310 (  81 113 ) resistor r=45.1352 //w=0.168 //l=0.173853 //layer=ply \
 //thickness=0.18 //x=6.64 //y=1.055 //x2=6.6 //y2=0.9
r311 (  81 82 ) resistor r=176.904 //w=0.094 //l=0.345 //layer=ply \
 //thickness=0.18 //x=6.64 //y=1.055 //x2=6.64 //y2=1.4
r312 (  78 84 ) resistor r=22.7971 //w=0.269 //l=0.106066 //layer=ply \
 //thickness=0.18 //x=6.61 //y=5.045 //x2=6.685 //y2=4.97
r313 (  78 112 ) resistor r=35.8364 //w=0.269 //l=0.270185 //layer=ply \
 //thickness=0.18 //x=6.61 //y=5.045 //x2=6.41 //y2=4.88
r314 (  76 108 ) resistor r=10.701 //w=0.21 //l=0.115 //layer=ply \
 //thickness=0.18 //x=6.265 //y=1.555 //x2=6.15 //y2=1.555
r315 (  75 114 ) resistor r=5.52526 //w=0.168 //l=0.115 //layer=ply \
 //thickness=0.18 //x=6.485 //y=1.555 //x2=6.6 //y2=1.555
r316 (  74 107 ) resistor r=5.52526 //w=0.168 //l=0.115 //layer=ply \
 //thickness=0.18 //x=6.265 //y=0.9 //x2=6.15 //y2=0.9
r317 (  73 113 ) resistor r=5.52526 //w=0.168 //l=0.115 //layer=ply \
 //thickness=0.18 //x=6.485 //y=0.9 //x2=6.6 //y2=0.9
r318 (  73 74 ) resistor r=112.809 //w=0.094 //l=0.22 //layer=ply \
 //thickness=0.18 //x=6.485 //y=0.9 //x2=6.265 //y2=0.9
r319 (  72 110 ) resistor r=58.7805 //w=0.246 //l=0.373497 //layer=ply \
 //thickness=0.18 //x=6.11 //y=2.095 //x2=6.41 //y2=2.26
r320 (  71 108 ) resistor r=39.5823 //w=0.21 //l=0.173853 //layer=ply \
 //thickness=0.18 //x=6.11 //y=1.71 //x2=6.15 //y2=1.555
r321 (  71 72 ) resistor r=197.415 //w=0.094 //l=0.385 //layer=ply \
 //thickness=0.18 //x=6.11 //y=1.71 //x2=6.11 //y2=2.095
r322 (  70 108 ) resistor r=39.5823 //w=0.21 //l=0.173853 //layer=ply \
 //thickness=0.18 //x=6.11 //y=1.4 //x2=6.15 //y2=1.555
r323 (  69 107 ) resistor r=45.1352 //w=0.168 //l=0.173853 //layer=ply \
 //thickness=0.18 //x=6.11 //y=1.055 //x2=6.15 //y2=0.9
r324 (  69 70 ) resistor r=176.904 //w=0.094 //l=0.345 //layer=ply \
 //thickness=0.18 //x=6.11 //y=1.055 //x2=6.11 //y2=1.4
r325 (  68 104 ) resistor r=592.245 //w=0.094 //l=1.155 //layer=ply \
 //thickness=0.18 //x=20 //y=6.2 //x2=20 //y2=5.045
r326 (  67 97 ) resistor r=592.245 //w=0.094 //l=1.155 //layer=ply \
 //thickness=0.18 //x=19.56 //y=6.2 //x2=19.56 //y2=5.045
r327 (  66 85 ) resistor r=592.245 //w=0.094 //l=1.155 //layer=ply \
 //thickness=0.18 //x=7.05 //y=6.2 //x2=7.05 //y2=5.045
r328 (  65 78 ) resistor r=592.245 //w=0.094 //l=1.155 //layer=ply \
 //thickness=0.18 //x=6.61 //y=6.2 //x2=6.61 //y2=5.045
r329 (  64 94 ) resistor r=56.4043 //w=0.094 //l=0.11 //layer=ply \
 //thickness=0.18 //x=19.325 //y=1.555 //x2=19.435 //y2=1.555
r330 (  64 95 ) resistor r=56.4043 //w=0.094 //l=0.11 //layer=ply \
 //thickness=0.18 //x=19.325 //y=1.555 //x2=19.215 //y2=1.555
r331 (  63 75 ) resistor r=56.4043 //w=0.094 //l=0.11 //layer=ply \
 //thickness=0.18 //x=6.375 //y=1.555 //x2=6.485 //y2=1.555
r332 (  63 76 ) resistor r=56.4043 //w=0.094 //l=0.11 //layer=ply \
 //thickness=0.18 //x=6.375 //y=1.555 //x2=6.265 //y2=1.555
r333 (  59 120 ) resistor r=152 //w=0.17 //l=0.17 //layer=licon //count=1 \
 //x=19.36 //y=4.88 //x2=19.36 //y2=4.88
r334 (  57 59 ) resistor r=68.4492 //w=0.187 //l=1 //layer=li //thickness=0.1 \
 //x=19.36 //y=3.88 //x2=19.36 //y2=4.88
r335 (  54 118 ) resistor r=152 //w=0.17 //l=0.17 //layer=licon //count=1 \
 //x=19.36 //y=2.26 //x2=19.36 //y2=2.26
r336 (  54 57 ) resistor r=110.888 //w=0.187 //l=1.62 //layer=li \
 //thickness=0.1 //x=19.36 //y=2.26 //x2=19.36 //y2=3.88
r337 (  51 112 ) resistor r=152 //w=0.17 //l=0.17 //layer=licon //count=1 \
 //x=6.41 //y=4.88 //x2=6.41 //y2=4.88
r338 (  49 51 ) resistor r=68.4492 //w=0.187 //l=1 //layer=li //thickness=0.1 \
 //x=6.41 //y=3.88 //x2=6.41 //y2=4.88
r339 (  46 110 ) resistor r=152 //w=0.17 //l=0.17 //layer=licon //count=1 \
 //x=6.41 //y=2.26 //x2=6.41 //y2=2.26
r340 (  46 49 ) resistor r=110.888 //w=0.187 //l=1.62 //layer=li \
 //thickness=0.1 //x=6.41 //y=2.26 //x2=6.41 //y2=3.88
r341 (  42 44 ) resistor r=93.7754 //w=0.187 //l=1.37 //layer=li \
 //thickness=0.1 //x=4.56 //y=5.25 //x2=4.56 //y2=3.88
r342 (  41 44 ) resistor r=133.476 //w=0.187 //l=1.95 //layer=li \
 //thickness=0.1 //x=4.56 //y=1.93 //x2=4.56 //y2=3.88
r343 (  39 41 ) resistor r=7.15173 //w=0.17 //l=0.120208 //layer=li \
 //thickness=0.1 //x=4.475 //y=1.845 //x2=4.56 //y2=1.93
r344 (  39 40 ) resistor r=21.5615 //w=0.187 //l=0.315 //layer=li \
 //thickness=0.1 //x=4.475 //y=1.845 //x2=4.16 //y2=1.845
r345 (  35 40 ) resistor r=7.15173 //w=0.17 //l=0.120208 //layer=li \
 //thickness=0.1 //x=4.075 //y=1.76 //x2=4.16 //y2=1.845
r346 (  35 123 ) resistor r=39.016 //w=0.187 //l=0.57 //layer=li \
 //thickness=0.1 //x=4.075 //y=1.76 //x2=4.075 //y2=1.19
r347 (  34 62 ) resistor r=5.4201 //w=0.17 //l=0.085 //layer=li \
 //thickness=0.1 //x=3.865 //y=5.335 //x2=3.78 //y2=5.335
r348 (  33 42 ) resistor r=7.15173 //w=0.17 //l=0.120208 //layer=li \
 //thickness=0.1 //x=4.475 //y=5.335 //x2=4.56 //y2=5.25
r349 (  33 34 ) resistor r=41.754 //w=0.187 //l=0.61 //layer=li \
 //thickness=0.1 //x=4.475 //y=5.335 //x2=3.865 //y2=5.335
r350 (  27 62 ) resistor r=1.40859 //w=0.34 //l=0.085 //layer=li \
 //thickness=0.1 //x=3.78 //y=5.42 //x2=3.78 //y2=5.335
r351 (  27 127 ) resistor r=33.1979 //w=0.187 //l=0.485 //layer=li \
 //thickness=0.1 //x=3.78 //y=5.42 //x2=3.78 //y2=5.905
r352 (  26 61 ) resistor r=5.4201 //w=0.17 //l=0.085 //layer=li \
 //thickness=0.1 //x=2.985 //y=5.335 //x2=2.9 //y2=5.335
r353 (  25 62 ) resistor r=5.4201 //w=0.17 //l=0.085 //layer=li \
 //thickness=0.1 //x=3.695 //y=5.335 //x2=3.78 //y2=5.335
r354 (  25 26 ) resistor r=48.5989 //w=0.187 //l=0.71 //layer=li \
 //thickness=0.1 //x=3.695 //y=5.335 //x2=2.985 //y2=5.335
r355 (  19 61 ) resistor r=1.40859 //w=0.34 //l=0.085 //layer=li \
 //thickness=0.1 //x=2.9 //y=5.42 //x2=2.9 //y2=5.335
r356 (  19 126 ) resistor r=33.1979 //w=0.187 //l=0.485 //layer=li \
 //thickness=0.1 //x=2.9 //y=5.42 //x2=2.9 //y2=5.905
r357 (  17 61 ) resistor r=5.4201 //w=0.17 //l=0.085 //layer=li \
 //thickness=0.1 //x=2.815 //y=5.335 //x2=2.9 //y2=5.335
r358 (  17 18 ) resistor r=48.5989 //w=0.187 //l=0.71 //layer=li \
 //thickness=0.1 //x=2.815 //y=5.335 //x2=2.105 //y2=5.335
r359 (  11 18 ) resistor r=7.15173 //w=0.17 //l=0.120208 //layer=li \
 //thickness=0.1 //x=2.02 //y=5.42 //x2=2.105 //y2=5.335
r360 (  11 125 ) resistor r=33.1979 //w=0.187 //l=0.485 //layer=li \
 //thickness=0.1 //x=2.02 //y=5.42 //x2=2.02 //y2=5.905
r361 (  10 57 ) resistor r=9.3 //w=0.17 //l=0.17 //layer=mcon //count=1 \
 //x=19.36 //y=3.88 //x2=19.36 //y2=3.88
r362 (  8 49 ) resistor r=9.3 //w=0.17 //l=0.17 //layer=mcon //count=1 \
 //x=6.41 //y=3.88 //x2=6.41 //y2=3.88
r363 (  6 44 ) resistor r=9.3 //w=0.17 //l=0.17 //layer=mcon //count=1 \
 //x=4.56 //y=3.88 //x2=4.56 //y2=3.88
r364 (  4 8 ) resistor r=0.0880901 //w=0.191 //l=0.115 //layer=m1 \
 //thickness=0.36 //x=6.525 //y=3.88 //x2=6.41 //y2=3.88
r365 (  3 10 ) resistor r=0.0717383 //w=0.224 //l=0.115 //layer=m1 \
 //thickness=0.36 //x=19.245 //y=3.88 //x2=19.36 //y2=3.88
r366 (  3 4 ) resistor r=12.1374 //w=0.131 //l=12.72 //layer=m1 \
 //thickness=0.36 //x=19.245 //y=3.88 //x2=6.525 //y2=3.88
r367 (  2 6 ) resistor r=0.0717383 //w=0.224 //l=0.115 //layer=m1 \
 //thickness=0.36 //x=4.675 //y=3.88 //x2=4.56 //y2=3.88
r368 (  1 8 ) resistor r=0.0880901 //w=0.191 //l=0.115 //layer=m1 \
 //thickness=0.36 //x=6.295 //y=3.88 //x2=6.41 //y2=3.88
r369 (  1 2 ) resistor r=1.5458 //w=0.131 //l=1.62 //layer=m1 //thickness=0.36 \
 //x=6.295 //y=3.88 //x2=4.675 //y2=3.88
ends PM_DFFRNX1\%noxref_6

subckt PM_DFFRNX1\%RN ( 1 2 3 4 11 12 13 14 15 16 17 18 20 30 38 49 50 51 52 \
 53 54 55 56 57 61 62 63 68 70 73 74 78 79 80 85 87 90 91 92 93 94 96 102 103 \
 104 105 106 112 113 118 122 123 128 134 )
c269 ( 134 0 ) capacitor c=0.0336203f //x=20.47 //y=4.88
c270 ( 128 0 ) capacitor c=0.0593675f //x=16.77 //y=4.88
c271 ( 123 0 ) capacitor c=0.0273931f //x=16.77 //y=2.095
c272 ( 122 0 ) capacitor c=0.0461462f //x=16.77 //y=2.26
c273 ( 118 0 ) capacitor c=0.0587755f //x=8.63 //y=4.88
c274 ( 113 0 ) capacitor c=0.0273931f //x=8.63 //y=2.095
c275 ( 112 0 ) capacitor c=0.0463246f //x=8.63 //y=2.26
c276 ( 106 0 ) capacitor c=0.024933f //x=20.805 //y=4.97
c277 ( 105 0 ) capacitor c=0.0831166f //x=20.56 //y=2.095
c278 ( 104 0 ) capacitor c=0.0170266f //x=20.56 //y=1.63
c279 ( 103 0 ) capacitor c=0.018609f //x=20.56 //y=1.4
c280 ( 102 0 ) capacitor c=0.0187309f //x=20.56 //y=1.09
c281 ( 96 0 ) capacitor c=0.014725f //x=20.405 //y=1.555
c282 ( 94 0 ) capacitor c=0.0146567f //x=20.405 //y=0.935
c283 ( 93 0 ) capacitor c=0.0335408f //x=20.035 //y=1.4
c284 ( 92 0 ) capacitor c=0.0173761f //x=20.035 //y=1.09
c285 ( 91 0 ) capacitor c=0.0432517f //x=17.29 //y=1.44
c286 ( 90 0 ) capacitor c=0.0200379f //x=17.29 //y=1.095
c287 ( 87 0 ) capacitor c=0.0148873f //x=17.135 //y=1.595
c288 ( 85 0 ) capacitor c=0.0157803f //x=17.135 //y=0.94
c289 ( 80 0 ) capacitor c=0.0218028f //x=16.76 //y=1.75
c290 ( 79 0 ) capacitor c=0.0207459f //x=16.76 //y=1.44
c291 ( 78 0 ) capacitor c=0.0194308f //x=16.76 //y=1.095
c292 ( 74 0 ) capacitor c=0.0432517f //x=9.15 //y=1.44
c293 ( 73 0 ) capacitor c=0.0200379f //x=9.15 //y=1.095
c294 ( 70 0 ) capacitor c=0.0148873f //x=8.995 //y=1.595
c295 ( 68 0 ) capacitor c=0.0157803f //x=8.995 //y=0.94
c296 ( 63 0 ) capacitor c=0.0218028f //x=8.62 //y=1.75
c297 ( 62 0 ) capacitor c=0.0207459f //x=8.62 //y=1.44
c298 ( 61 0 ) capacitor c=0.0194308f //x=8.62 //y=1.095
c299 ( 57 0 ) capacitor c=0.110114f //x=20.88 //y=6.2
c300 ( 56 0 ) capacitor c=0.11012f //x=20.44 //y=6.2
c301 ( 55 0 ) capacitor c=0.158794f //x=16.95 //y=6.2
c302 ( 54 0 ) capacitor c=0.110114f //x=16.51 //y=6.2
c303 ( 53 0 ) capacitor c=0.158794f //x=8.81 //y=6.2
c304 ( 52 0 ) capacitor c=0.110114f //x=8.37 //y=6.2
c305 ( 38 0 ) capacitor c=0.0994642f //x=20.47 //y=2.26
c306 ( 30 0 ) capacitor c=0.0881589f //x=16.77 //y=2.26
c307 ( 20 0 ) capacitor c=0.0845523f //x=8.63 //y=2.26
c308 ( 4 0 ) capacitor c=0.00668194f //x=16.885 //y=2.4
c309 ( 3 0 ) capacitor c=0.115719f //x=20.355 //y=2.4
c310 ( 2 0 ) capacitor c=0.0160747f //x=8.745 //y=2.4
c311 ( 1 0 ) capacitor c=0.209784f //x=16.655 //y=2.4
r312 (  136 137 ) resistor r=32.4568 //w=0.214 //l=0.075 //layer=ply \
 //thickness=0.18 //x=20.47 //y=4.97 //x2=20.47 //y2=5.045
r313 (  134 136 ) resistor r=20.271 //w=0.214 //l=0.09 //layer=ply \
 //thickness=0.18 //x=20.47 //y=4.88 //x2=20.47 //y2=4.97
r314 (  122 123 ) resistor r=52.7279 //w=0.214 //l=0.165 //layer=ply \
 //thickness=0.18 //x=16.77 //y=2.26 //x2=16.77 //y2=2.095
r315 (  112 113 ) resistor r=52.7279 //w=0.214 //l=0.165 //layer=ply \
 //thickness=0.18 //x=8.63 //y=2.26 //x2=8.63 //y2=2.095
r316 (  107 136 ) resistor r=16.5046 //w=0.27 //l=0.135 //layer=ply \
 //thickness=0.18 //x=20.605 //y=4.97 //x2=20.47 //y2=4.97
r317 (  106 108 ) resistor r=26.9307 //w=0.15 //l=0.106066 //layer=ply \
 //thickness=0.18 //x=20.805 //y=4.97 //x2=20.88 //y2=5.045
r318 (  106 107 ) resistor r=102.553 //w=0.094 //l=0.2 //layer=ply \
 //thickness=0.18 //x=20.805 //y=4.97 //x2=20.605 //y2=4.97
r319 (  105 141 ) resistor r=38.6777 //w=0.284 //l=0.198997 //layer=ply \
 //thickness=0.18 //x=20.56 //y=2.095 //x2=20.485 //y2=2.26
r320 (  104 139 ) resistor r=21.2976 //w=0.217 //l=0.0928709 //layer=ply \
 //thickness=0.18 //x=20.56 //y=1.63 //x2=20.52 //y2=1.555
r321 (  104 105 ) resistor r=238.436 //w=0.094 //l=0.465 //layer=ply \
 //thickness=0.18 //x=20.56 //y=1.63 //x2=20.56 //y2=2.095
r322 (  103 139 ) resistor r=39.0671 //w=0.217 //l=0.173853 //layer=ply \
 //thickness=0.18 //x=20.56 //y=1.4 //x2=20.52 //y2=1.555
r323 (  102 138 ) resistor r=45.1352 //w=0.168 //l=0.173853 //layer=ply \
 //thickness=0.18 //x=20.56 //y=1.09 //x2=20.52 //y2=0.935
r324 (  102 103 ) resistor r=158.957 //w=0.094 //l=0.31 //layer=ply \
 //thickness=0.18 //x=20.56 //y=1.09 //x2=20.56 //y2=1.4
r325 (  97 132 ) resistor r=5.52526 //w=0.168 //l=0.115 //layer=ply \
 //thickness=0.18 //x=20.19 //y=1.555 //x2=20.075 //y2=1.555
r326 (  96 139 ) resistor r=11.4558 //w=0.217 //l=0.115 //layer=ply \
 //thickness=0.18 //x=20.405 //y=1.555 //x2=20.52 //y2=1.555
r327 (  95 131 ) resistor r=5.52526 //w=0.168 //l=0.115 //layer=ply \
 //thickness=0.18 //x=20.19 //y=0.935 //x2=20.075 //y2=0.935
r328 (  94 138 ) resistor r=5.52526 //w=0.168 //l=0.115 //layer=ply \
 //thickness=0.18 //x=20.405 //y=0.935 //x2=20.52 //y2=0.935
r329 (  94 95 ) resistor r=110.245 //w=0.094 //l=0.215 //layer=ply \
 //thickness=0.18 //x=20.405 //y=0.935 //x2=20.19 //y2=0.935
r330 (  93 132 ) resistor r=45.1352 //w=0.168 //l=0.173853 //layer=ply \
 //thickness=0.18 //x=20.035 //y=1.4 //x2=20.075 //y2=1.555
r331 (  92 131 ) resistor r=45.1352 //w=0.168 //l=0.173853 //layer=ply \
 //thickness=0.18 //x=20.035 //y=1.09 //x2=20.075 //y2=0.935
r332 (  92 93 ) resistor r=158.957 //w=0.094 //l=0.31 //layer=ply \
 //thickness=0.18 //x=20.035 //y=1.09 //x2=20.035 //y2=1.4
r333 (  91 130 ) resistor r=45.1352 //w=0.168 //l=0.173853 //layer=ply \
 //thickness=0.18 //x=17.29 //y=1.44 //x2=17.25 //y2=1.595
r334 (  90 129 ) resistor r=45.1352 //w=0.168 //l=0.173853 //layer=ply \
 //thickness=0.18 //x=17.29 //y=1.095 //x2=17.25 //y2=0.94
r335 (  90 91 ) resistor r=176.904 //w=0.094 //l=0.345 //layer=ply \
 //thickness=0.18 //x=17.29 //y=1.095 //x2=17.29 //y2=1.44
r336 (  88 126 ) resistor r=10.701 //w=0.21 //l=0.115 //layer=ply \
 //thickness=0.18 //x=16.915 //y=1.595 //x2=16.8 //y2=1.595
r337 (  87 130 ) resistor r=5.52526 //w=0.168 //l=0.115 //layer=ply \
 //thickness=0.18 //x=17.135 //y=1.595 //x2=17.25 //y2=1.595
r338 (  86 125 ) resistor r=5.52526 //w=0.168 //l=0.115 //layer=ply \
 //thickness=0.18 //x=16.915 //y=0.94 //x2=16.8 //y2=0.94
r339 (  85 129 ) resistor r=5.52526 //w=0.168 //l=0.115 //layer=ply \
 //thickness=0.18 //x=17.135 //y=0.94 //x2=17.25 //y2=0.94
r340 (  85 86 ) resistor r=112.809 //w=0.094 //l=0.22 //layer=ply \
 //thickness=0.18 //x=17.135 //y=0.94 //x2=16.915 //y2=0.94
r341 (  82 128 ) resistor r=37.236 //w=0.233 //l=0.249199 //layer=ply \
 //thickness=0.18 //x=16.95 //y=5.045 //x2=16.77 //y2=4.88
r342 (  80 126 ) resistor r=39.5823 //w=0.21 //l=0.173853 //layer=ply \
 //thickness=0.18 //x=16.76 //y=1.75 //x2=16.8 //y2=1.595
r343 (  80 123 ) resistor r=176.904 //w=0.094 //l=0.345 //layer=ply \
 //thickness=0.18 //x=16.76 //y=1.75 //x2=16.76 //y2=2.095
r344 (  79 126 ) resistor r=39.5823 //w=0.21 //l=0.173853 //layer=ply \
 //thickness=0.18 //x=16.76 //y=1.44 //x2=16.8 //y2=1.595
r345 (  78 125 ) resistor r=45.1352 //w=0.168 //l=0.173853 //layer=ply \
 //thickness=0.18 //x=16.76 //y=1.095 //x2=16.8 //y2=0.94
r346 (  78 79 ) resistor r=176.904 //w=0.094 //l=0.345 //layer=ply \
 //thickness=0.18 //x=16.76 //y=1.095 //x2=16.76 //y2=1.44
r347 (  75 128 ) resistor r=53.7854 //w=0.233 //l=0.332415 //layer=ply \
 //thickness=0.18 //x=16.51 //y=5.045 //x2=16.77 //y2=4.88
r348 (  74 120 ) resistor r=45.1352 //w=0.168 //l=0.173853 //layer=ply \
 //thickness=0.18 //x=9.15 //y=1.44 //x2=9.11 //y2=1.595
r349 (  73 119 ) resistor r=45.1352 //w=0.168 //l=0.173853 //layer=ply \
 //thickness=0.18 //x=9.15 //y=1.095 //x2=9.11 //y2=0.94
r350 (  73 74 ) resistor r=176.904 //w=0.094 //l=0.345 //layer=ply \
 //thickness=0.18 //x=9.15 //y=1.095 //x2=9.15 //y2=1.44
r351 (  71 116 ) resistor r=10.701 //w=0.21 //l=0.115 //layer=ply \
 //thickness=0.18 //x=8.775 //y=1.595 //x2=8.66 //y2=1.595
r352 (  70 120 ) resistor r=5.52526 //w=0.168 //l=0.115 //layer=ply \
 //thickness=0.18 //x=8.995 //y=1.595 //x2=9.11 //y2=1.595
r353 (  69 115 ) resistor r=5.52526 //w=0.168 //l=0.115 //layer=ply \
 //thickness=0.18 //x=8.775 //y=0.94 //x2=8.66 //y2=0.94
r354 (  68 119 ) resistor r=5.52526 //w=0.168 //l=0.115 //layer=ply \
 //thickness=0.18 //x=8.995 //y=0.94 //x2=9.11 //y2=0.94
r355 (  68 69 ) resistor r=112.809 //w=0.094 //l=0.22 //layer=ply \
 //thickness=0.18 //x=8.995 //y=0.94 //x2=8.775 //y2=0.94
r356 (  65 118 ) resistor r=37.236 //w=0.233 //l=0.249199 //layer=ply \
 //thickness=0.18 //x=8.81 //y=5.045 //x2=8.63 //y2=4.88
r357 (  63 116 ) resistor r=39.5823 //w=0.21 //l=0.173853 //layer=ply \
 //thickness=0.18 //x=8.62 //y=1.75 //x2=8.66 //y2=1.595
r358 (  63 113 ) resistor r=176.904 //w=0.094 //l=0.345 //layer=ply \
 //thickness=0.18 //x=8.62 //y=1.75 //x2=8.62 //y2=2.095
r359 (  62 116 ) resistor r=39.5823 //w=0.21 //l=0.173853 //layer=ply \
 //thickness=0.18 //x=8.62 //y=1.44 //x2=8.66 //y2=1.595
r360 (  61 115 ) resistor r=45.1352 //w=0.168 //l=0.173853 //layer=ply \
 //thickness=0.18 //x=8.62 //y=1.095 //x2=8.66 //y2=0.94
r361 (  61 62 ) resistor r=176.904 //w=0.094 //l=0.345 //layer=ply \
 //thickness=0.18 //x=8.62 //y=1.095 //x2=8.62 //y2=1.44
r362 (  58 118 ) resistor r=53.7854 //w=0.233 //l=0.332415 //layer=ply \
 //thickness=0.18 //x=8.37 //y=5.045 //x2=8.63 //y2=4.88
r363 (  57 108 ) resistor r=592.245 //w=0.094 //l=1.155 //layer=ply \
 //thickness=0.18 //x=20.88 //y=6.2 //x2=20.88 //y2=5.045
r364 (  56 137 ) resistor r=592.245 //w=0.094 //l=1.155 //layer=ply \
 //thickness=0.18 //x=20.44 //y=6.2 //x2=20.44 //y2=5.045
r365 (  55 82 ) resistor r=592.245 //w=0.094 //l=1.155 //layer=ply \
 //thickness=0.18 //x=16.95 //y=6.2 //x2=16.95 //y2=5.045
r366 (  54 75 ) resistor r=592.245 //w=0.094 //l=1.155 //layer=ply \
 //thickness=0.18 //x=16.51 //y=6.2 //x2=16.51 //y2=5.045
r367 (  53 65 ) resistor r=592.245 //w=0.094 //l=1.155 //layer=ply \
 //thickness=0.18 //x=8.81 //y=6.2 //x2=8.81 //y2=5.045
r368 (  52 58 ) resistor r=592.245 //w=0.094 //l=1.155 //layer=ply \
 //thickness=0.18 //x=8.37 //y=6.2 //x2=8.37 //y2=5.045
r369 (  51 96 ) resistor r=55.3787 //w=0.094 //l=0.108 //layer=ply \
 //thickness=0.18 //x=20.297 //y=1.555 //x2=20.405 //y2=1.555
r370 (  51 97 ) resistor r=54.866 //w=0.094 //l=0.107 //layer=ply \
 //thickness=0.18 //x=20.297 //y=1.555 //x2=20.19 //y2=1.555
r371 (  50 87 ) resistor r=56.4043 //w=0.094 //l=0.11 //layer=ply \
 //thickness=0.18 //x=17.025 //y=1.595 //x2=17.135 //y2=1.595
r372 (  50 88 ) resistor r=56.4043 //w=0.094 //l=0.11 //layer=ply \
 //thickness=0.18 //x=17.025 //y=1.595 //x2=16.915 //y2=1.595
r373 (  49 70 ) resistor r=56.4043 //w=0.094 //l=0.11 //layer=ply \
 //thickness=0.18 //x=8.885 //y=1.595 //x2=8.995 //y2=1.595
r374 (  49 71 ) resistor r=56.4043 //w=0.094 //l=0.11 //layer=ply \
 //thickness=0.18 //x=8.885 //y=1.595 //x2=8.775 //y2=1.595
r375 (  47 134 ) resistor r=152 //w=0.17 //l=0.17 //layer=licon //count=1 \
 //x=20.47 //y=4.88 //x2=20.47 //y2=4.88
r376 (  38 141 ) resistor r=152 //w=0.17 //l=0.17 //layer=licon //count=1 \
 //x=20.47 //y=2.26 //x2=20.47 //y2=2.26
r377 (  35 128 ) resistor r=152 //w=0.17 //l=0.17 //layer=licon //count=1 \
 //x=16.77 //y=4.88 //x2=16.77 //y2=4.88
r378 (  33 35 ) resistor r=169.754 //w=0.187 //l=2.48 //layer=li \
 //thickness=0.1 //x=16.77 //y=2.4 //x2=16.77 //y2=4.88
r379 (  30 122 ) resistor r=152 //w=0.17 //l=0.17 //layer=licon //count=1 \
 //x=16.77 //y=2.26 //x2=16.77 //y2=2.26
r380 (  30 33 ) resistor r=9.58289 //w=0.187 //l=0.14 //layer=li \
 //thickness=0.1 //x=16.77 //y=2.26 //x2=16.77 //y2=2.4
r381 (  27 118 ) resistor r=152 //w=0.17 //l=0.17 //layer=licon //count=1 \
 //x=8.63 //y=4.88 //x2=8.63 //y2=4.88
r382 (  20 112 ) resistor r=152 //w=0.17 //l=0.17 //layer=licon //count=1 \
 //x=8.63 //y=2.26 //x2=8.63 //y2=2.26
r383 (  18 47 ) resistor r=68.4492 //w=0.187 //l=1 //layer=li //thickness=0.1 \
 //x=20.47 //y=3.88 //x2=20.47 //y2=4.88
r384 (  17 18 ) resistor r=25.3262 //w=0.187 //l=0.37 //layer=li \
 //thickness=0.1 //x=20.47 //y=3.51 //x2=20.47 //y2=3.88
r385 (  16 17 ) resistor r=25.3262 //w=0.187 //l=0.37 //layer=li \
 //thickness=0.1 //x=20.47 //y=3.14 //x2=20.47 //y2=3.51
r386 (  15 16 ) resistor r=25.3262 //w=0.187 //l=0.37 //layer=li \
 //thickness=0.1 //x=20.47 //y=2.77 //x2=20.47 //y2=3.14
r387 (  14 15 ) resistor r=25.3262 //w=0.187 //l=0.37 //layer=li \
 //thickness=0.1 //x=20.47 //y=2.4 //x2=20.47 //y2=2.77
r388 (  14 38 ) resistor r=9.58289 //w=0.187 //l=0.14 //layer=li \
 //thickness=0.1 //x=20.47 //y=2.4 //x2=20.47 //y2=2.26
r389 (  13 27 ) resistor r=119.102 //w=0.187 //l=1.74 //layer=li \
 //thickness=0.1 //x=8.63 //y=3.14 //x2=8.63 //y2=4.88
r390 (  12 13 ) resistor r=25.3262 //w=0.187 //l=0.37 //layer=li \
 //thickness=0.1 //x=8.63 //y=2.77 //x2=8.63 //y2=3.14
r391 (  11 12 ) resistor r=25.3262 //w=0.187 //l=0.37 //layer=li \
 //thickness=0.1 //x=8.63 //y=2.4 //x2=8.63 //y2=2.77
r392 (  11 20 ) resistor r=9.58289 //w=0.187 //l=0.14 //layer=li \
 //thickness=0.1 //x=8.63 //y=2.4 //x2=8.63 //y2=2.26
r393 (  10 14 ) resistor r=9.3 //w=0.17 //l=0.17 //layer=mcon //count=1 \
 //x=20.47 //y=2.4 //x2=20.47 //y2=2.4
r394 (  8 33 ) resistor r=9.3 //w=0.17 //l=0.17 //layer=mcon //count=1 \
 //x=16.77 //y=2.4 //x2=16.77 //y2=2.4
r395 (  6 11 ) resistor r=9.3 //w=0.17 //l=0.17 //layer=mcon //count=1 \
 //x=8.63 //y=2.4 //x2=8.63 //y2=2.4
r396 (  4 8 ) resistor r=0.0880901 //w=0.191 //l=0.115 //layer=m1 \
 //thickness=0.36 //x=16.885 //y=2.4 //x2=16.77 //y2=2.4
r397 (  3 10 ) resistor r=0.0717383 //w=0.224 //l=0.115 //layer=m1 \
 //thickness=0.36 //x=20.355 //y=2.4 //x2=20.47 //y2=2.4
r398 (  3 4 ) resistor r=3.31107 //w=0.131 //l=3.47 //layer=m1 \
 //thickness=0.36 //x=20.355 //y=2.4 //x2=16.885 //y2=2.4
r399 (  2 6 ) resistor r=0.0717383 //w=0.224 //l=0.115 //layer=m1 \
 //thickness=0.36 //x=8.745 //y=2.4 //x2=8.63 //y2=2.4
r400 (  1 8 ) resistor r=0.0880901 //w=0.191 //l=0.115 //layer=m1 \
 //thickness=0.36 //x=16.655 //y=2.4 //x2=16.77 //y2=2.4
r401 (  1 2 ) resistor r=7.54771 //w=0.131 //l=7.91 //layer=m1 \
 //thickness=0.36 //x=16.655 //y=2.4 //x2=8.745 //y2=2.4
ends PM_DFFRNX1\%RN

subckt PM_DFFRNX1\%QN ( 1 2 7 8 9 10 11 12 13 14 15 16 23 24 31 39 45 46 57 67 \
 68 69 70 71 72 73 74 75 79 81 84 85 95 98 100 101 102 )
c156 ( 102 0 ) capacitor c=0.023087f //x=21.395 //y=5.2
c157 ( 101 0 ) capacitor c=0.023519f //x=20.515 //y=5.2
c158 ( 100 0 ) capacitor c=0.0224735f //x=19.635 //y=5.2
c159 ( 98 0 ) capacitor c=0.00872971f //x=21.645 //y=1.095
c160 ( 95 0 ) capacitor c=0.0593152f //x=24.17 //y=4.88
c161 ( 85 0 ) capacitor c=0.0318948f //x=24.505 //y=1.39
c162 ( 84 0 ) capacitor c=0.0187384f //x=24.505 //y=1.045
c163 ( 81 0 ) capacitor c=0.0141798f //x=24.35 //y=1.545
c164 ( 79 0 ) capacitor c=0.0149844f //x=24.35 //y=0.89
c165 ( 75 0 ) capacitor c=0.0853292f //x=23.975 //y=2.095
c166 ( 74 0 ) capacitor c=0.0229722f //x=23.975 //y=1.7
c167 ( 73 0 ) capacitor c=0.0234352f //x=23.975 //y=1.39
c168 ( 72 0 ) capacitor c=0.0199343f //x=23.975 //y=1.045
c169 ( 71 0 ) capacitor c=0.110275f //x=24.51 //y=6.2
c170 ( 70 0 ) capacitor c=0.154305f //x=24.07 //y=6.2
c171 ( 68 0 ) capacitor c=0.00116729f //x=21.54 //y=5.335
c172 ( 67 0 ) capacitor c=0.00226015f //x=20.66 //y=5.335
c173 ( 57 0 ) capacitor c=0.0933903f //x=24.17 //y=2.26
c174 ( 46 0 ) capacitor c=0.0052078f //x=21.92 //y=1.845
c175 ( 45 0 ) capacitor c=0.015794f //x=22.235 //y=1.845
c176 ( 39 0 ) capacitor c=0.0293025f //x=22.235 //y=5.335
c177 ( 31 0 ) capacitor c=0.0184197f //x=21.455 //y=5.335
c178 ( 24 0 ) capacitor c=0.00351598f //x=19.865 //y=5.335
c179 ( 23 0 ) capacitor c=0.0155255f //x=20.575 //y=5.335
c180 ( 7 0 ) capacitor c=0.111457f //x=22.32 //y=2.4
c181 ( 2 0 ) capacitor c=0.0140459f //x=22.435 //y=3.51
c182 ( 1 0 ) capacitor c=0.0669949f //x=24.055 //y=3.51
r183 (  93 95 ) resistor r=20.6867 //w=0.233 //l=0.1 //layer=ply \
 //thickness=0.18 //x=24.07 //y=4.88 //x2=24.17 //y2=4.88
r184 (  86 95 ) resistor r=70.3348 //w=0.233 //l=0.414367 //layer=ply \
 //thickness=0.18 //x=24.51 //y=5.045 //x2=24.17 //y2=4.88
r185 (  85 97 ) resistor r=45.1352 //w=0.168 //l=0.173853 //layer=ply \
 //thickness=0.18 //x=24.505 //y=1.39 //x2=24.465 //y2=1.545
r186 (  84 96 ) resistor r=45.1352 //w=0.168 //l=0.173853 //layer=ply \
 //thickness=0.18 //x=24.505 //y=1.045 //x2=24.465 //y2=0.89
r187 (  84 85 ) resistor r=176.904 //w=0.094 //l=0.345 //layer=ply \
 //thickness=0.18 //x=24.505 //y=1.045 //x2=24.505 //y2=1.39
r188 (  82 92 ) resistor r=10.701 //w=0.21 //l=0.115 //layer=ply \
 //thickness=0.18 //x=24.13 //y=1.545 //x2=24.015 //y2=1.545
r189 (  81 97 ) resistor r=5.52526 //w=0.168 //l=0.115 //layer=ply \
 //thickness=0.18 //x=24.35 //y=1.545 //x2=24.465 //y2=1.545
r190 (  80 91 ) resistor r=5.52526 //w=0.168 //l=0.115 //layer=ply \
 //thickness=0.18 //x=24.13 //y=0.89 //x2=24.015 //y2=0.89
r191 (  79 96 ) resistor r=5.52526 //w=0.168 //l=0.115 //layer=ply \
 //thickness=0.18 //x=24.35 //y=0.89 //x2=24.465 //y2=0.89
r192 (  79 80 ) resistor r=112.809 //w=0.094 //l=0.22 //layer=ply \
 //thickness=0.18 //x=24.35 //y=0.89 //x2=24.13 //y2=0.89
r193 (  76 93 ) resistor r=13.0941 //w=0.233 //l=0.165 //layer=ply \
 //thickness=0.18 //x=24.07 //y=5.045 //x2=24.07 //y2=4.88
r194 (  75 90 ) resistor r=34.8111 //w=0.27 //l=0.264953 //layer=ply \
 //thickness=0.18 //x=23.975 //y=2.095 //x2=24.17 //y2=2.26
r195 (  74 92 ) resistor r=39.5823 //w=0.21 //l=0.173853 //layer=ply \
 //thickness=0.18 //x=23.975 //y=1.7 //x2=24.015 //y2=1.545
r196 (  74 75 ) resistor r=202.543 //w=0.094 //l=0.395 //layer=ply \
 //thickness=0.18 //x=23.975 //y=1.7 //x2=23.975 //y2=2.095
r197 (  73 92 ) resistor r=39.5823 //w=0.21 //l=0.173853 //layer=ply \
 //thickness=0.18 //x=23.975 //y=1.39 //x2=24.015 //y2=1.545
r198 (  72 91 ) resistor r=45.1352 //w=0.168 //l=0.173853 //layer=ply \
 //thickness=0.18 //x=23.975 //y=1.045 //x2=24.015 //y2=0.89
r199 (  72 73 ) resistor r=176.904 //w=0.094 //l=0.345 //layer=ply \
 //thickness=0.18 //x=23.975 //y=1.045 //x2=23.975 //y2=1.39
r200 (  71 86 ) resistor r=592.245 //w=0.094 //l=1.155 //layer=ply \
 //thickness=0.18 //x=24.51 //y=6.2 //x2=24.51 //y2=5.045
r201 (  70 76 ) resistor r=592.245 //w=0.094 //l=1.155 //layer=ply \
 //thickness=0.18 //x=24.07 //y=6.2 //x2=24.07 //y2=5.045
r202 (  69 81 ) resistor r=56.4043 //w=0.094 //l=0.11 //layer=ply \
 //thickness=0.18 //x=24.24 //y=1.545 //x2=24.35 //y2=1.545
r203 (  69 82 ) resistor r=56.4043 //w=0.094 //l=0.11 //layer=ply \
 //thickness=0.18 //x=24.24 //y=1.545 //x2=24.13 //y2=1.545
r204 (  65 95 ) resistor r=152 //w=0.17 //l=0.17 //layer=licon //count=1 \
 //x=24.17 //y=4.88 //x2=24.17 //y2=4.88
r205 (  57 90 ) resistor r=152 //w=0.17 //l=0.17 //layer=licon //count=1 \
 //x=24.17 //y=2.26 //x2=24.17 //y2=2.26
r206 (  45 47 ) resistor r=7.15173 //w=0.17 //l=0.120208 //layer=li \
 //thickness=0.1 //x=22.235 //y=1.845 //x2=22.32 //y2=1.93
r207 (  45 46 ) resistor r=21.5615 //w=0.187 //l=0.315 //layer=li \
 //thickness=0.1 //x=22.235 //y=1.845 //x2=21.92 //y2=1.845
r208 (  41 46 ) resistor r=7.15173 //w=0.17 //l=0.120208 //layer=li \
 //thickness=0.1 //x=21.835 //y=1.76 //x2=21.92 //y2=1.845
r209 (  41 98 ) resistor r=39.016 //w=0.187 //l=0.57 //layer=li \
 //thickness=0.1 //x=21.835 //y=1.76 //x2=21.835 //y2=1.19
r210 (  40 68 ) resistor r=5.4201 //w=0.17 //l=0.085 //layer=li \
 //thickness=0.1 //x=21.625 //y=5.335 //x2=21.54 //y2=5.335
r211 (  39 48 ) resistor r=7.15173 //w=0.17 //l=0.120208 //layer=li \
 //thickness=0.1 //x=22.235 //y=5.335 //x2=22.32 //y2=5.25
r212 (  39 40 ) resistor r=41.754 //w=0.187 //l=0.61 //layer=li \
 //thickness=0.1 //x=22.235 //y=5.335 //x2=21.625 //y2=5.335
r213 (  33 68 ) resistor r=1.40859 //w=0.34 //l=0.085 //layer=li \
 //thickness=0.1 //x=21.54 //y=5.42 //x2=21.54 //y2=5.335
r214 (  33 102 ) resistor r=33.1979 //w=0.187 //l=0.485 //layer=li \
 //thickness=0.1 //x=21.54 //y=5.42 //x2=21.54 //y2=5.905
r215 (  32 67 ) resistor r=5.4201 //w=0.17 //l=0.085 //layer=li \
 //thickness=0.1 //x=20.745 //y=5.335 //x2=20.66 //y2=5.335
r216 (  31 68 ) resistor r=5.4201 //w=0.17 //l=0.085 //layer=li \
 //thickness=0.1 //x=21.455 //y=5.335 //x2=21.54 //y2=5.335
r217 (  31 32 ) resistor r=48.5989 //w=0.187 //l=0.71 //layer=li \
 //thickness=0.1 //x=21.455 //y=5.335 //x2=20.745 //y2=5.335
r218 (  25 67 ) resistor r=1.40859 //w=0.34 //l=0.085 //layer=li \
 //thickness=0.1 //x=20.66 //y=5.42 //x2=20.66 //y2=5.335
r219 (  25 101 ) resistor r=33.1979 //w=0.187 //l=0.485 //layer=li \
 //thickness=0.1 //x=20.66 //y=5.42 //x2=20.66 //y2=5.905
r220 (  23 67 ) resistor r=5.4201 //w=0.17 //l=0.085 //layer=li \
 //thickness=0.1 //x=20.575 //y=5.335 //x2=20.66 //y2=5.335
r221 (  23 24 ) resistor r=48.5989 //w=0.187 //l=0.71 //layer=li \
 //thickness=0.1 //x=20.575 //y=5.335 //x2=19.865 //y2=5.335
r222 (  17 24 ) resistor r=7.15173 //w=0.17 //l=0.120208 //layer=li \
 //thickness=0.1 //x=19.78 //y=5.42 //x2=19.865 //y2=5.335
r223 (  17 100 ) resistor r=33.1979 //w=0.187 //l=0.485 //layer=li \
 //thickness=0.1 //x=19.78 //y=5.42 //x2=19.78 //y2=5.905
r224 (  16 65 ) resistor r=17.7968 //w=0.187 //l=0.26 //layer=li \
 //thickness=0.1 //x=24.17 //y=4.62 //x2=24.17 //y2=4.88
r225 (  15 16 ) resistor r=75.9786 //w=0.187 //l=1.11 //layer=li \
 //thickness=0.1 //x=24.17 //y=3.51 //x2=24.17 //y2=4.62
r226 (  14 15 ) resistor r=25.3262 //w=0.187 //l=0.37 //layer=li \
 //thickness=0.1 //x=24.17 //y=3.14 //x2=24.17 //y2=3.51
r227 (  13 14 ) resistor r=25.3262 //w=0.187 //l=0.37 //layer=li \
 //thickness=0.1 //x=24.17 //y=2.77 //x2=24.17 //y2=3.14
r228 (  13 57 ) resistor r=34.9091 //w=0.187 //l=0.51 //layer=li \
 //thickness=0.1 //x=24.17 //y=2.77 //x2=24.17 //y2=2.26
r229 (  12 48 ) resistor r=17.7968 //w=0.187 //l=0.26 //layer=li \
 //thickness=0.1 //x=22.32 //y=4.99 //x2=22.32 //y2=5.25
r230 (  11 12 ) resistor r=25.3262 //w=0.187 //l=0.37 //layer=li \
 //thickness=0.1 //x=22.32 //y=4.62 //x2=22.32 //y2=4.99
r231 (  10 11 ) resistor r=75.9786 //w=0.187 //l=1.11 //layer=li \
 //thickness=0.1 //x=22.32 //y=3.51 //x2=22.32 //y2=4.62
r232 (  9 10 ) resistor r=25.3262 //w=0.187 //l=0.37 //layer=li \
 //thickness=0.1 //x=22.32 //y=3.14 //x2=22.32 //y2=3.51
r233 (  8 9 ) resistor r=25.3262 //w=0.187 //l=0.37 //layer=li //thickness=0.1 \
 //x=22.32 //y=2.77 //x2=22.32 //y2=3.14
r234 (  7 8 ) resistor r=25.3262 //w=0.187 //l=0.37 //layer=li //thickness=0.1 \
 //x=22.32 //y=2.4 //x2=22.32 //y2=2.77
r235 (  7 47 ) resistor r=32.1711 //w=0.187 //l=0.47 //layer=li \
 //thickness=0.1 //x=22.32 //y=2.4 //x2=22.32 //y2=1.93
r236 (  6 15 ) resistor r=9.3 //w=0.17 //l=0.17 //layer=mcon //count=1 \
 //x=24.17 //y=3.51 //x2=24.17 //y2=3.51
r237 (  4 10 ) resistor r=9.3 //w=0.17 //l=0.17 //layer=mcon //count=1 \
 //x=22.32 //y=3.51 //x2=22.32 //y2=3.51
r238 (  2 4 ) resistor r=0.0717383 //w=0.224 //l=0.115 //layer=m1 \
 //thickness=0.36 //x=22.435 //y=3.51 //x2=22.32 //y2=3.51
r239 (  1 6 ) resistor r=0.0717383 //w=0.224 //l=0.115 //layer=m1 \
 //thickness=0.36 //x=24.055 //y=3.51 //x2=24.17 //y2=3.51
r240 (  1 2 ) resistor r=1.5458 //w=0.131 //l=1.62 //layer=m1 //thickness=0.36 \
 //x=24.055 //y=3.51 //x2=22.435 //y2=3.51
ends PM_DFFRNX1\%QN

subckt PM_DFFRNX1\%noxref_9 ( 1 2 3 4 5 6 16 23 25 35 36 43 51 57 58 62 63 65 \
 71 72 75 76 77 78 79 80 81 82 83 84 85 86 87 88 90 96 97 98 99 103 104 105 \
 110 112 114 120 121 122 123 124 129 131 133 139 140 150 151 154 163 164 167 \
 175 177 178 179 )
c384 ( 179 0 ) capacitor c=0.023087f //x=16.585 //y=5.2
c385 ( 178 0 ) capacitor c=0.023519f //x=15.705 //y=5.2
c386 ( 177 0 ) capacitor c=0.0224735f //x=14.825 //y=5.2
c387 ( 175 0 ) capacitor c=0.00853354f //x=16.835 //y=1.095
c388 ( 167 0 ) capacitor c=0.0331844f //x=24.94 //y=4.88
c389 ( 164 0 ) capacitor c=0.0279499f //x=24.91 //y=2.095
c390 ( 163 0 ) capacitor c=0.0437302f //x=24.91 //y=2.26
c391 ( 154 0 ) capacitor c=0.0331095f //x=11.99 //y=4.88
c392 ( 151 0 ) capacitor c=0.0279499f //x=11.96 //y=2.095
c393 ( 150 0 ) capacitor c=0.0425269f //x=11.96 //y=2.26
c394 ( 140 0 ) capacitor c=0.0429696f //x=25.475 //y=1.43
c395 ( 139 0 ) capacitor c=0.0192208f //x=25.475 //y=1.085
c396 ( 133 0 ) capacitor c=0.0158629f //x=25.32 //y=1.585
c397 ( 131 0 ) capacitor c=0.0157803f //x=25.32 //y=0.93
c398 ( 129 0 ) capacitor c=0.0306375f //x=25.315 //y=4.97
c399 ( 124 0 ) capacitor c=0.0205163f //x=24.945 //y=1.74
c400 ( 123 0 ) capacitor c=0.0168481f //x=24.945 //y=1.43
c401 ( 122 0 ) capacitor c=0.0174783f //x=24.945 //y=1.085
c402 ( 121 0 ) capacitor c=0.0429696f //x=12.525 //y=1.43
c403 ( 120 0 ) capacitor c=0.0192208f //x=12.525 //y=1.085
c404 ( 114 0 ) capacitor c=0.0148884f //x=12.37 //y=1.585
c405 ( 112 0 ) capacitor c=0.0157803f //x=12.37 //y=0.93
c406 ( 110 0 ) capacitor c=0.0295235f //x=12.365 //y=4.97
c407 ( 105 0 ) capacitor c=0.0205163f //x=11.995 //y=1.74
c408 ( 104 0 ) capacitor c=0.0168481f //x=11.995 //y=1.43
c409 ( 103 0 ) capacitor c=0.0174783f //x=11.995 //y=1.085
c410 ( 99 0 ) capacitor c=0.0559896f //x=1.875 //y=4.97
c411 ( 98 0 ) capacitor c=0.0298189f //x=2.165 //y=4.97
c412 ( 97 0 ) capacitor c=0.0347816f //x=1.83 //y=1.4
c413 ( 96 0 ) capacitor c=0.0187487f //x=1.83 //y=1.055
c414 ( 90 0 ) capacitor c=0.0137055f //x=1.675 //y=1.555
c415 ( 88 0 ) capacitor c=0.0149861f //x=1.675 //y=0.9
c416 ( 87 0 ) capacitor c=0.102158f //x=1.3 //y=2.095
c417 ( 86 0 ) capacitor c=0.0229444f //x=1.3 //y=1.71
c418 ( 85 0 ) capacitor c=0.0234352f //x=1.3 //y=1.4
c419 ( 84 0 ) capacitor c=0.0198724f //x=1.3 //y=1.055
c420 ( 83 0 ) capacitor c=0.15358f //x=25.39 //y=6.2
c421 ( 82 0 ) capacitor c=0.110281f //x=24.95 //y=6.2
c422 ( 81 0 ) capacitor c=0.15358f //x=12.44 //y=6.2
c423 ( 80 0 ) capacitor c=0.110281f //x=12 //y=6.2
c424 ( 79 0 ) capacitor c=0.110114f //x=2.24 //y=6.2
c425 ( 78 0 ) capacitor c=0.158956f //x=1.8 //y=6.2
c426 ( 72 0 ) capacitor c=0.00116729f //x=16.73 //y=5.335
c427 ( 71 0 ) capacitor c=0.0021933f //x=15.85 //y=5.335
c428 ( 65 0 ) capacitor c=0.0765697f //x=24.91 //y=2.26
c429 ( 63 0 ) capacitor c=0.00453889f //x=24.91 //y=4.715
c430 ( 62 0 ) capacitor c=0.113069f //x=17.51 //y=4.25
c431 ( 58 0 ) capacitor c=0.00398962f //x=17.11 //y=1.845
c432 ( 57 0 ) capacitor c=0.0137288f //x=17.425 //y=1.845
c433 ( 51 0 ) capacitor c=0.0291076f //x=17.425 //y=5.335
c434 ( 43 0 ) capacitor c=0.0184197f //x=16.645 //y=5.335
c435 ( 36 0 ) capacitor c=0.00332903f //x=15.055 //y=5.335
c436 ( 35 0 ) capacitor c=0.014837f //x=15.765 //y=5.335
c437 ( 25 0 ) capacitor c=0.0719943f //x=11.96 //y=2.26
c438 ( 23 0 ) capacitor c=0.00453889f //x=11.96 //y=4.715
c439 ( 16 0 ) capacitor c=0.124161f //x=1.6 //y=2.26
c440 ( 6 0 ) capacitor c=0.00720076f //x=17.625 //y=4.25
c441 ( 5 0 ) capacitor c=0.228202f //x=24.795 //y=4.25
c442 ( 4 0 ) capacitor c=0.00557292f //x=12.075 //y=4.25
c443 ( 3 0 ) capacitor c=0.0897132f //x=17.395 //y=4.25
c444 ( 2 0 ) capacitor c=0.0160831f //x=1.715 //y=4.25
c445 ( 1 0 ) capacitor c=0.183938f //x=11.845 //y=4.25
r446 (  169 170 ) resistor r=32.4568 //w=0.214 //l=0.075 //layer=ply \
 //thickness=0.18 //x=24.94 //y=4.97 //x2=24.94 //y2=5.045
r447 (  167 169 ) resistor r=20.271 //w=0.214 //l=0.09 //layer=ply \
 //thickness=0.18 //x=24.94 //y=4.88 //x2=24.94 //y2=4.97
r448 (  163 164 ) resistor r=52.7279 //w=0.214 //l=0.165 //layer=ply \
 //thickness=0.18 //x=24.91 //y=2.26 //x2=24.91 //y2=2.095
r449 (  156 157 ) resistor r=32.4568 //w=0.214 //l=0.075 //layer=ply \
 //thickness=0.18 //x=11.99 //y=4.97 //x2=11.99 //y2=5.045
r450 (  154 156 ) resistor r=20.271 //w=0.214 //l=0.09 //layer=ply \
 //thickness=0.18 //x=11.99 //y=4.88 //x2=11.99 //y2=4.97
r451 (  150 151 ) resistor r=52.7279 //w=0.214 //l=0.165 //layer=ply \
 //thickness=0.18 //x=11.96 //y=2.26 //x2=11.96 //y2=2.095
r452 (  140 174 ) resistor r=45.1352 //w=0.168 //l=0.173853 //layer=ply \
 //thickness=0.18 //x=25.475 //y=1.43 //x2=25.435 //y2=1.585
r453 (  139 173 ) resistor r=45.1352 //w=0.168 //l=0.173853 //layer=ply \
 //thickness=0.18 //x=25.475 //y=1.085 //x2=25.435 //y2=0.93
r454 (  139 140 ) resistor r=176.904 //w=0.094 //l=0.345 //layer=ply \
 //thickness=0.18 //x=25.475 //y=1.085 //x2=25.475 //y2=1.43
r455 (  134 172 ) resistor r=10.701 //w=0.21 //l=0.115 //layer=ply \
 //thickness=0.18 //x=25.1 //y=1.585 //x2=24.985 //y2=1.585
r456 (  133 174 ) resistor r=5.52526 //w=0.168 //l=0.115 //layer=ply \
 //thickness=0.18 //x=25.32 //y=1.585 //x2=25.435 //y2=1.585
r457 (  132 171 ) resistor r=5.52526 //w=0.168 //l=0.115 //layer=ply \
 //thickness=0.18 //x=25.1 //y=0.93 //x2=24.985 //y2=0.93
r458 (  131 173 ) resistor r=5.52526 //w=0.168 //l=0.115 //layer=ply \
 //thickness=0.18 //x=25.32 //y=0.93 //x2=25.435 //y2=0.93
r459 (  131 132 ) resistor r=112.809 //w=0.094 //l=0.22 //layer=ply \
 //thickness=0.18 //x=25.32 //y=0.93 //x2=25.1 //y2=0.93
r460 (  130 169 ) resistor r=16.5046 //w=0.27 //l=0.135 //layer=ply \
 //thickness=0.18 //x=25.075 //y=4.97 //x2=24.94 //y2=4.97
r461 (  129 136 ) resistor r=26.9307 //w=0.15 //l=0.106066 //layer=ply \
 //thickness=0.18 //x=25.315 //y=4.97 //x2=25.39 //y2=5.045
r462 (  129 130 ) resistor r=123.064 //w=0.094 //l=0.24 //layer=ply \
 //thickness=0.18 //x=25.315 //y=4.97 //x2=25.075 //y2=4.97
r463 (  124 172 ) resistor r=39.5823 //w=0.21 //l=0.173853 //layer=ply \
 //thickness=0.18 //x=24.945 //y=1.74 //x2=24.985 //y2=1.585
r464 (  124 164 ) resistor r=182.032 //w=0.094 //l=0.355 //layer=ply \
 //thickness=0.18 //x=24.945 //y=1.74 //x2=24.945 //y2=2.095
r465 (  123 172 ) resistor r=39.5823 //w=0.21 //l=0.173853 //layer=ply \
 //thickness=0.18 //x=24.945 //y=1.43 //x2=24.985 //y2=1.585
r466 (  122 171 ) resistor r=45.1352 //w=0.168 //l=0.173853 //layer=ply \
 //thickness=0.18 //x=24.945 //y=1.085 //x2=24.985 //y2=0.93
r467 (  122 123 ) resistor r=176.904 //w=0.094 //l=0.345 //layer=ply \
 //thickness=0.18 //x=24.945 //y=1.085 //x2=24.945 //y2=1.43
r468 (  121 161 ) resistor r=45.1352 //w=0.168 //l=0.173853 //layer=ply \
 //thickness=0.18 //x=12.525 //y=1.43 //x2=12.485 //y2=1.585
r469 (  120 160 ) resistor r=45.1352 //w=0.168 //l=0.173853 //layer=ply \
 //thickness=0.18 //x=12.525 //y=1.085 //x2=12.485 //y2=0.93
r470 (  120 121 ) resistor r=176.904 //w=0.094 //l=0.345 //layer=ply \
 //thickness=0.18 //x=12.525 //y=1.085 //x2=12.525 //y2=1.43
r471 (  115 159 ) resistor r=10.701 //w=0.21 //l=0.115 //layer=ply \
 //thickness=0.18 //x=12.15 //y=1.585 //x2=12.035 //y2=1.585
r472 (  114 161 ) resistor r=5.52526 //w=0.168 //l=0.115 //layer=ply \
 //thickness=0.18 //x=12.37 //y=1.585 //x2=12.485 //y2=1.585
r473 (  113 158 ) resistor r=5.52526 //w=0.168 //l=0.115 //layer=ply \
 //thickness=0.18 //x=12.15 //y=0.93 //x2=12.035 //y2=0.93
r474 (  112 160 ) resistor r=5.52526 //w=0.168 //l=0.115 //layer=ply \
 //thickness=0.18 //x=12.37 //y=0.93 //x2=12.485 //y2=0.93
r475 (  112 113 ) resistor r=112.809 //w=0.094 //l=0.22 //layer=ply \
 //thickness=0.18 //x=12.37 //y=0.93 //x2=12.15 //y2=0.93
r476 (  111 156 ) resistor r=16.5046 //w=0.27 //l=0.135 //layer=ply \
 //thickness=0.18 //x=12.125 //y=4.97 //x2=11.99 //y2=4.97
r477 (  110 117 ) resistor r=26.9307 //w=0.15 //l=0.106066 //layer=ply \
 //thickness=0.18 //x=12.365 //y=4.97 //x2=12.44 //y2=5.045
r478 (  110 111 ) resistor r=123.064 //w=0.094 //l=0.24 //layer=ply \
 //thickness=0.18 //x=12.365 //y=4.97 //x2=12.125 //y2=4.97
r479 (  105 159 ) resistor r=39.5823 //w=0.21 //l=0.173853 //layer=ply \
 //thickness=0.18 //x=11.995 //y=1.74 //x2=12.035 //y2=1.585
r480 (  105 151 ) resistor r=182.032 //w=0.094 //l=0.355 //layer=ply \
 //thickness=0.18 //x=11.995 //y=1.74 //x2=11.995 //y2=2.095
r481 (  104 159 ) resistor r=39.5823 //w=0.21 //l=0.173853 //layer=ply \
 //thickness=0.18 //x=11.995 //y=1.43 //x2=12.035 //y2=1.585
r482 (  103 158 ) resistor r=45.1352 //w=0.168 //l=0.173853 //layer=ply \
 //thickness=0.18 //x=11.995 //y=1.085 //x2=12.035 //y2=0.93
r483 (  103 104 ) resistor r=176.904 //w=0.094 //l=0.345 //layer=ply \
 //thickness=0.18 //x=11.995 //y=1.085 //x2=11.995 //y2=1.43
r484 (  98 100 ) resistor r=26.9307 //w=0.15 //l=0.106066 //layer=ply \
 //thickness=0.18 //x=2.165 //y=4.97 //x2=2.24 //y2=5.045
r485 (  98 99 ) resistor r=148.702 //w=0.094 //l=0.29 //layer=ply \
 //thickness=0.18 //x=2.165 //y=4.97 //x2=1.875 //y2=4.97
r486 (  97 148 ) resistor r=45.1352 //w=0.168 //l=0.173853 //layer=ply \
 //thickness=0.18 //x=1.83 //y=1.4 //x2=1.79 //y2=1.555
r487 (  96 147 ) resistor r=45.1352 //w=0.168 //l=0.173853 //layer=ply \
 //thickness=0.18 //x=1.83 //y=1.055 //x2=1.79 //y2=0.9
r488 (  96 97 ) resistor r=176.904 //w=0.094 //l=0.345 //layer=ply \
 //thickness=0.18 //x=1.83 //y=1.055 //x2=1.83 //y2=1.4
r489 (  93 99 ) resistor r=22.7971 //w=0.269 //l=0.106066 //layer=ply \
 //thickness=0.18 //x=1.8 //y=5.045 //x2=1.875 //y2=4.97
r490 (  93 146 ) resistor r=35.8364 //w=0.269 //l=0.270185 //layer=ply \
 //thickness=0.18 //x=1.8 //y=5.045 //x2=1.6 //y2=4.88
r491 (  91 142 ) resistor r=10.701 //w=0.21 //l=0.115 //layer=ply \
 //thickness=0.18 //x=1.455 //y=1.555 //x2=1.34 //y2=1.555
r492 (  90 148 ) resistor r=5.52526 //w=0.168 //l=0.115 //layer=ply \
 //thickness=0.18 //x=1.675 //y=1.555 //x2=1.79 //y2=1.555
r493 (  89 141 ) resistor r=5.52526 //w=0.168 //l=0.115 //layer=ply \
 //thickness=0.18 //x=1.455 //y=0.9 //x2=1.34 //y2=0.9
r494 (  88 147 ) resistor r=5.52526 //w=0.168 //l=0.115 //layer=ply \
 //thickness=0.18 //x=1.675 //y=0.9 //x2=1.79 //y2=0.9
r495 (  88 89 ) resistor r=112.809 //w=0.094 //l=0.22 //layer=ply \
 //thickness=0.18 //x=1.675 //y=0.9 //x2=1.455 //y2=0.9
r496 (  87 144 ) resistor r=58.7805 //w=0.246 //l=0.373497 //layer=ply \
 //thickness=0.18 //x=1.3 //y=2.095 //x2=1.6 //y2=2.26
r497 (  86 142 ) resistor r=39.5823 //w=0.21 //l=0.173853 //layer=ply \
 //thickness=0.18 //x=1.3 //y=1.71 //x2=1.34 //y2=1.555
r498 (  86 87 ) resistor r=197.415 //w=0.094 //l=0.385 //layer=ply \
 //thickness=0.18 //x=1.3 //y=1.71 //x2=1.3 //y2=2.095
r499 (  85 142 ) resistor r=39.5823 //w=0.21 //l=0.173853 //layer=ply \
 //thickness=0.18 //x=1.3 //y=1.4 //x2=1.34 //y2=1.555
r500 (  84 141 ) resistor r=45.1352 //w=0.168 //l=0.173853 //layer=ply \
 //thickness=0.18 //x=1.3 //y=1.055 //x2=1.34 //y2=0.9
r501 (  84 85 ) resistor r=176.904 //w=0.094 //l=0.345 //layer=ply \
 //thickness=0.18 //x=1.3 //y=1.055 //x2=1.3 //y2=1.4
r502 (  83 136 ) resistor r=592.245 //w=0.094 //l=1.155 //layer=ply \
 //thickness=0.18 //x=25.39 //y=6.2 //x2=25.39 //y2=5.045
r503 (  82 170 ) resistor r=592.245 //w=0.094 //l=1.155 //layer=ply \
 //thickness=0.18 //x=24.95 //y=6.2 //x2=24.95 //y2=5.045
r504 (  81 117 ) resistor r=592.245 //w=0.094 //l=1.155 //layer=ply \
 //thickness=0.18 //x=12.44 //y=6.2 //x2=12.44 //y2=5.045
r505 (  80 157 ) resistor r=592.245 //w=0.094 //l=1.155 //layer=ply \
 //thickness=0.18 //x=12 //y=6.2 //x2=12 //y2=5.045
r506 (  79 100 ) resistor r=592.245 //w=0.094 //l=1.155 //layer=ply \
 //thickness=0.18 //x=2.24 //y=6.2 //x2=2.24 //y2=5.045
r507 (  78 93 ) resistor r=592.245 //w=0.094 //l=1.155 //layer=ply \
 //thickness=0.18 //x=1.8 //y=6.2 //x2=1.8 //y2=5.045
r508 (  77 133 ) resistor r=56.4043 //w=0.094 //l=0.11 //layer=ply \
 //thickness=0.18 //x=25.21 //y=1.585 //x2=25.32 //y2=1.585
r509 (  77 134 ) resistor r=56.4043 //w=0.094 //l=0.11 //layer=ply \
 //thickness=0.18 //x=25.21 //y=1.585 //x2=25.1 //y2=1.585
r510 (  76 114 ) resistor r=56.4043 //w=0.094 //l=0.11 //layer=ply \
 //thickness=0.18 //x=12.26 //y=1.585 //x2=12.37 //y2=1.585
r511 (  76 115 ) resistor r=56.4043 //w=0.094 //l=0.11 //layer=ply \
 //thickness=0.18 //x=12.26 //y=1.585 //x2=12.15 //y2=1.585
r512 (  75 90 ) resistor r=56.4043 //w=0.094 //l=0.11 //layer=ply \
 //thickness=0.18 //x=1.565 //y=1.555 //x2=1.675 //y2=1.555
r513 (  75 91 ) resistor r=56.4043 //w=0.094 //l=0.11 //layer=ply \
 //thickness=0.18 //x=1.565 //y=1.555 //x2=1.455 //y2=1.555
r514 (  74 167 ) resistor r=152 //w=0.17 //l=0.17 //layer=licon //count=1 \
 //x=24.94 //y=4.88 //x2=24.94 //y2=4.88
r515 (  70 154 ) resistor r=152 //w=0.17 //l=0.17 //layer=licon //count=1 \
 //x=11.99 //y=4.88 //x2=11.99 //y2=4.88
r516 (  65 163 ) resistor r=152 //w=0.17 //l=0.17 //layer=licon //count=1 \
 //x=24.91 //y=2.26 //x2=24.91 //y2=2.26
r517 (  65 68 ) resistor r=136.214 //w=0.187 //l=1.99 //layer=li \
 //thickness=0.1 //x=24.91 //y=2.26 //x2=24.91 //y2=4.25
r518 (  63 74 ) resistor r=11.4737 //w=0.186 //l=0.172337 //layer=li \
 //thickness=0.1 //x=24.91 //y=4.715 //x2=24.925 //y2=4.88
r519 (  63 68 ) resistor r=31.8289 //w=0.187 //l=0.465 //layer=li \
 //thickness=0.1 //x=24.91 //y=4.715 //x2=24.91 //y2=4.25
r520 (  60 62 ) resistor r=68.4492 //w=0.187 //l=1 //layer=li //thickness=0.1 \
 //x=17.51 //y=5.25 //x2=17.51 //y2=4.25
r521 (  59 62 ) resistor r=158.802 //w=0.187 //l=2.32 //layer=li \
 //thickness=0.1 //x=17.51 //y=1.93 //x2=17.51 //y2=4.25
r522 (  57 59 ) resistor r=7.15173 //w=0.17 //l=0.120208 //layer=li \
 //thickness=0.1 //x=17.425 //y=1.845 //x2=17.51 //y2=1.93
r523 (  57 58 ) resistor r=21.5615 //w=0.187 //l=0.315 //layer=li \
 //thickness=0.1 //x=17.425 //y=1.845 //x2=17.11 //y2=1.845
r524 (  53 58 ) resistor r=7.15173 //w=0.17 //l=0.120208 //layer=li \
 //thickness=0.1 //x=17.025 //y=1.76 //x2=17.11 //y2=1.845
r525 (  53 175 ) resistor r=39.016 //w=0.187 //l=0.57 //layer=li \
 //thickness=0.1 //x=17.025 //y=1.76 //x2=17.025 //y2=1.19
r526 (  52 72 ) resistor r=5.4201 //w=0.17 //l=0.085 //layer=li \
 //thickness=0.1 //x=16.815 //y=5.335 //x2=16.73 //y2=5.335
r527 (  51 60 ) resistor r=7.15173 //w=0.17 //l=0.120208 //layer=li \
 //thickness=0.1 //x=17.425 //y=5.335 //x2=17.51 //y2=5.25
r528 (  51 52 ) resistor r=41.754 //w=0.187 //l=0.61 //layer=li \
 //thickness=0.1 //x=17.425 //y=5.335 //x2=16.815 //y2=5.335
r529 (  45 72 ) resistor r=1.40859 //w=0.34 //l=0.085 //layer=li \
 //thickness=0.1 //x=16.73 //y=5.42 //x2=16.73 //y2=5.335
r530 (  45 179 ) resistor r=33.1979 //w=0.187 //l=0.485 //layer=li \
 //thickness=0.1 //x=16.73 //y=5.42 //x2=16.73 //y2=5.905
r531 (  44 71 ) resistor r=5.4201 //w=0.17 //l=0.085 //layer=li \
 //thickness=0.1 //x=15.935 //y=5.335 //x2=15.85 //y2=5.335
r532 (  43 72 ) resistor r=5.4201 //w=0.17 //l=0.085 //layer=li \
 //thickness=0.1 //x=16.645 //y=5.335 //x2=16.73 //y2=5.335
r533 (  43 44 ) resistor r=48.5989 //w=0.187 //l=0.71 //layer=li \
 //thickness=0.1 //x=16.645 //y=5.335 //x2=15.935 //y2=5.335
r534 (  37 71 ) resistor r=1.40859 //w=0.34 //l=0.085 //layer=li \
 //thickness=0.1 //x=15.85 //y=5.42 //x2=15.85 //y2=5.335
r535 (  37 178 ) resistor r=33.1979 //w=0.187 //l=0.485 //layer=li \
 //thickness=0.1 //x=15.85 //y=5.42 //x2=15.85 //y2=5.905
r536 (  35 71 ) resistor r=5.4201 //w=0.17 //l=0.085 //layer=li \
 //thickness=0.1 //x=15.765 //y=5.335 //x2=15.85 //y2=5.335
r537 (  35 36 ) resistor r=48.5989 //w=0.187 //l=0.71 //layer=li \
 //thickness=0.1 //x=15.765 //y=5.335 //x2=15.055 //y2=5.335
r538 (  29 36 ) resistor r=7.15173 //w=0.17 //l=0.120208 //layer=li \
 //thickness=0.1 //x=14.97 //y=5.42 //x2=15.055 //y2=5.335
r539 (  29 177 ) resistor r=33.1979 //w=0.187 //l=0.485 //layer=li \
 //thickness=0.1 //x=14.97 //y=5.42 //x2=14.97 //y2=5.905
r540 (  25 150 ) resistor r=152 //w=0.17 //l=0.17 //layer=licon //count=1 \
 //x=11.96 //y=2.26 //x2=11.96 //y2=2.26
r541 (  25 28 ) resistor r=136.214 //w=0.187 //l=1.99 //layer=li \
 //thickness=0.1 //x=11.96 //y=2.26 //x2=11.96 //y2=4.25
r542 (  23 70 ) resistor r=11.4737 //w=0.186 //l=0.172337 //layer=li \
 //thickness=0.1 //x=11.96 //y=4.715 //x2=11.975 //y2=4.88
r543 (  23 28 ) resistor r=31.8289 //w=0.187 //l=0.465 //layer=li \
 //thickness=0.1 //x=11.96 //y=4.715 //x2=11.96 //y2=4.25
r544 (  21 146 ) resistor r=152 //w=0.17 //l=0.17 //layer=licon //count=1 \
 //x=1.6 //y=4.88 //x2=1.6 //y2=4.88
r545 (  19 21 ) resistor r=43.123 //w=0.187 //l=0.63 //layer=li \
 //thickness=0.1 //x=1.6 //y=4.25 //x2=1.6 //y2=4.88
r546 (  16 144 ) resistor r=152 //w=0.17 //l=0.17 //layer=licon //count=1 \
 //x=1.6 //y=2.26 //x2=1.6 //y2=2.26
r547 (  16 19 ) resistor r=136.214 //w=0.187 //l=1.99 //layer=li \
 //thickness=0.1 //x=1.6 //y=2.26 //x2=1.6 //y2=4.25
r548 (  14 68 ) resistor r=9.3 //w=0.17 //l=0.17 //layer=mcon //count=1 \
 //x=24.91 //y=4.25 //x2=24.91 //y2=4.25
r549 (  12 62 ) resistor r=9.3 //w=0.17 //l=0.17 //layer=mcon //count=1 \
 //x=17.51 //y=4.25 //x2=17.51 //y2=4.25
r550 (  10 28 ) resistor r=9.3 //w=0.17 //l=0.17 //layer=mcon //count=1 \
 //x=11.96 //y=4.25 //x2=11.96 //y2=4.25
r551 (  8 19 ) resistor r=9.3 //w=0.17 //l=0.17 //layer=mcon //count=1 //x=1.6 \
 //y=4.25 //x2=1.6 //y2=4.25
r552 (  6 12 ) resistor r=0.0880901 //w=0.191 //l=0.115 //layer=m1 \
 //thickness=0.36 //x=17.625 //y=4.25 //x2=17.51 //y2=4.25
r553 (  5 14 ) resistor r=0.0717383 //w=0.224 //l=0.115 //layer=m1 \
 //thickness=0.36 //x=24.795 //y=4.25 //x2=24.91 //y2=4.25
r554 (  5 6 ) resistor r=6.8416 //w=0.131 //l=7.17 //layer=m1 //thickness=0.36 \
 //x=24.795 //y=4.25 //x2=17.625 //y2=4.25
r555 (  4 10 ) resistor r=0.0880901 //w=0.191 //l=0.115 //layer=m1 \
 //thickness=0.36 //x=12.075 //y=4.25 //x2=11.96 //y2=4.25
r556 (  3 12 ) resistor r=0.0880901 //w=0.191 //l=0.115 //layer=m1 \
 //thickness=0.36 //x=17.395 //y=4.25 //x2=17.51 //y2=4.25
r557 (  3 4 ) resistor r=5.07634 //w=0.131 //l=5.32 //layer=m1 \
 //thickness=0.36 //x=17.395 //y=4.25 //x2=12.075 //y2=4.25
r558 (  2 8 ) resistor r=0.0717383 //w=0.224 //l=0.115 //layer=m1 \
 //thickness=0.36 //x=1.715 //y=4.25 //x2=1.6 //y2=4.25
r559 (  1 10 ) resistor r=0.0880901 //w=0.191 //l=0.115 //layer=m1 \
 //thickness=0.36 //x=11.845 //y=4.25 //x2=11.96 //y2=4.25
r560 (  1 2 ) resistor r=9.66603 //w=0.131 //l=10.13 //layer=m1 \
 //thickness=0.36 //x=11.845 //y=4.25 //x2=1.715 //y2=4.25
ends PM_DFFRNX1\%noxref_9

subckt PM_DFFRNX1\%Q ( 1 2 7 8 9 10 11 12 13 14 15 16 17 18 19 20 22 40 41 52 \
 54 55 67 68 69 70 74 75 76 81 83 86 87 89 90 95 98 100 101 )
c144 ( 101 0 ) capacitor c=0.0220291f //x=25.025 //y=5.2
c145 ( 100 0 ) capacitor c=0.0217503f //x=24.145 //y=5.2
c146 ( 98 0 ) capacitor c=0.0084702f //x=25.02 //y=1.085
c147 ( 95 0 ) capacitor c=0.059212f //x=21.58 //y=4.88
c148 ( 90 0 ) capacitor c=0.0273931f //x=21.58 //y=2.095
c149 ( 89 0 ) capacitor c=0.0471168f //x=21.58 //y=2.26
c150 ( 87 0 ) capacitor c=0.0432517f //x=22.1 //y=1.44
c151 ( 86 0 ) capacitor c=0.0200379f //x=22.1 //y=1.095
c152 ( 83 0 ) capacitor c=0.0158629f //x=21.945 //y=1.595
c153 ( 81 0 ) capacitor c=0.0157803f //x=21.945 //y=0.94
c154 ( 76 0 ) capacitor c=0.0218028f //x=21.57 //y=1.75
c155 ( 75 0 ) capacitor c=0.0207459f //x=21.57 //y=1.44
c156 ( 74 0 ) capacitor c=0.0194308f //x=21.57 //y=1.095
c157 ( 70 0 ) capacitor c=0.158794f //x=21.76 //y=6.2
c158 ( 69 0 ) capacitor c=0.110114f //x=21.32 //y=6.2
c159 ( 67 0 ) capacitor c=0.0024826f //x=25.17 //y=5.38
c160 ( 55 0 ) capacitor c=0.00525782f //x=25.295 //y=1.835
c161 ( 54 0 ) capacitor c=0.0140375f //x=25.565 //y=1.835
c162 ( 52 0 ) capacitor c=0.0142754f //x=25.565 //y=5.38
c163 ( 41 0 ) capacitor c=0.00265593f //x=24.375 //y=5.38
c164 ( 40 0 ) capacitor c=0.0150834f //x=25.085 //y=5.38
c165 ( 22 0 ) capacitor c=0.0910244f //x=21.58 //y=2.26
c166 ( 13 0 ) capacitor c=0.128349f //x=25.65 //y=2.4
c167 ( 2 0 ) capacitor c=0.0101384f //x=21.695 //y=3.88
c168 ( 1 0 ) capacitor c=0.102069f //x=25.535 //y=3.88
r169 (  89 90 ) resistor r=52.7279 //w=0.214 //l=0.165 //layer=ply \
 //thickness=0.18 //x=21.58 //y=2.26 //x2=21.58 //y2=2.095
r170 (  87 97 ) resistor r=45.1352 //w=0.168 //l=0.173853 //layer=ply \
 //thickness=0.18 //x=22.1 //y=1.44 //x2=22.06 //y2=1.595
r171 (  86 96 ) resistor r=45.1352 //w=0.168 //l=0.173853 //layer=ply \
 //thickness=0.18 //x=22.1 //y=1.095 //x2=22.06 //y2=0.94
r172 (  86 87 ) resistor r=176.904 //w=0.094 //l=0.345 //layer=ply \
 //thickness=0.18 //x=22.1 //y=1.095 //x2=22.1 //y2=1.44
r173 (  84 93 ) resistor r=10.701 //w=0.21 //l=0.115 //layer=ply \
 //thickness=0.18 //x=21.725 //y=1.595 //x2=21.61 //y2=1.595
r174 (  83 97 ) resistor r=5.52526 //w=0.168 //l=0.115 //layer=ply \
 //thickness=0.18 //x=21.945 //y=1.595 //x2=22.06 //y2=1.595
r175 (  82 92 ) resistor r=5.52526 //w=0.168 //l=0.115 //layer=ply \
 //thickness=0.18 //x=21.725 //y=0.94 //x2=21.61 //y2=0.94
r176 (  81 96 ) resistor r=5.52526 //w=0.168 //l=0.115 //layer=ply \
 //thickness=0.18 //x=21.945 //y=0.94 //x2=22.06 //y2=0.94
r177 (  81 82 ) resistor r=112.809 //w=0.094 //l=0.22 //layer=ply \
 //thickness=0.18 //x=21.945 //y=0.94 //x2=21.725 //y2=0.94
r178 (  78 95 ) resistor r=37.236 //w=0.233 //l=0.249199 //layer=ply \
 //thickness=0.18 //x=21.76 //y=5.045 //x2=21.58 //y2=4.88
r179 (  76 93 ) resistor r=39.5823 //w=0.21 //l=0.173853 //layer=ply \
 //thickness=0.18 //x=21.57 //y=1.75 //x2=21.61 //y2=1.595
r180 (  76 90 ) resistor r=176.904 //w=0.094 //l=0.345 //layer=ply \
 //thickness=0.18 //x=21.57 //y=1.75 //x2=21.57 //y2=2.095
r181 (  75 93 ) resistor r=39.5823 //w=0.21 //l=0.173853 //layer=ply \
 //thickness=0.18 //x=21.57 //y=1.44 //x2=21.61 //y2=1.595
r182 (  74 92 ) resistor r=45.1352 //w=0.168 //l=0.173853 //layer=ply \
 //thickness=0.18 //x=21.57 //y=1.095 //x2=21.61 //y2=0.94
r183 (  74 75 ) resistor r=176.904 //w=0.094 //l=0.345 //layer=ply \
 //thickness=0.18 //x=21.57 //y=1.095 //x2=21.57 //y2=1.44
r184 (  71 95 ) resistor r=53.7854 //w=0.233 //l=0.332415 //layer=ply \
 //thickness=0.18 //x=21.32 //y=5.045 //x2=21.58 //y2=4.88
r185 (  70 78 ) resistor r=592.245 //w=0.094 //l=1.155 //layer=ply \
 //thickness=0.18 //x=21.76 //y=6.2 //x2=21.76 //y2=5.045
r186 (  69 71 ) resistor r=592.245 //w=0.094 //l=1.155 //layer=ply \
 //thickness=0.18 //x=21.32 //y=6.2 //x2=21.32 //y2=5.045
r187 (  68 83 ) resistor r=56.4043 //w=0.094 //l=0.11 //layer=ply \
 //thickness=0.18 //x=21.835 //y=1.595 //x2=21.945 //y2=1.595
r188 (  68 84 ) resistor r=56.4043 //w=0.094 //l=0.11 //layer=ply \
 //thickness=0.18 //x=21.835 //y=1.595 //x2=21.725 //y2=1.595
r189 (  54 56 ) resistor r=7.15173 //w=0.17 //l=0.120208 //layer=li \
 //thickness=0.1 //x=25.565 //y=1.835 //x2=25.65 //y2=1.92
r190 (  54 55 ) resistor r=18.4813 //w=0.187 //l=0.27 //layer=li \
 //thickness=0.1 //x=25.565 //y=1.835 //x2=25.295 //y2=1.835
r191 (  53 67 ) resistor r=5.4201 //w=0.17 //l=0.085 //layer=li \
 //thickness=0.1 //x=25.255 //y=5.38 //x2=25.17 //y2=5.38
r192 (  52 57 ) resistor r=7.15173 //w=0.17 //l=0.120208 //layer=li \
 //thickness=0.1 //x=25.565 //y=5.38 //x2=25.65 //y2=5.295
r193 (  52 53 ) resistor r=21.2193 //w=0.187 //l=0.31 //layer=li \
 //thickness=0.1 //x=25.565 //y=5.38 //x2=25.255 //y2=5.38
r194 (  48 55 ) resistor r=7.15173 //w=0.17 //l=0.120208 //layer=li \
 //thickness=0.1 //x=25.21 //y=1.75 //x2=25.295 //y2=1.835
r195 (  48 98 ) resistor r=39.016 //w=0.187 //l=0.57 //layer=li \
 //thickness=0.1 //x=25.21 //y=1.75 //x2=25.21 //y2=1.18
r196 (  42 67 ) resistor r=1.40859 //w=0.34 //l=0.085 //layer=li \
 //thickness=0.1 //x=25.17 //y=5.465 //x2=25.17 //y2=5.38
r197 (  42 101 ) resistor r=30.1176 //w=0.187 //l=0.44 //layer=li \
 //thickness=0.1 //x=25.17 //y=5.465 //x2=25.17 //y2=5.905
r198 (  40 67 ) resistor r=5.4201 //w=0.17 //l=0.085 //layer=li \
 //thickness=0.1 //x=25.085 //y=5.38 //x2=25.17 //y2=5.38
r199 (  40 41 ) resistor r=48.5989 //w=0.187 //l=0.71 //layer=li \
 //thickness=0.1 //x=25.085 //y=5.38 //x2=24.375 //y2=5.38
r200 (  34 41 ) resistor r=7.15173 //w=0.17 //l=0.120208 //layer=li \
 //thickness=0.1 //x=24.29 //y=5.465 //x2=24.375 //y2=5.38
r201 (  34 100 ) resistor r=30.1176 //w=0.187 //l=0.44 //layer=li \
 //thickness=0.1 //x=24.29 //y=5.465 //x2=24.29 //y2=5.905
r202 (  32 95 ) resistor r=152 //w=0.17 //l=0.17 //layer=licon //count=1 \
 //x=21.58 //y=4.88 //x2=21.58 //y2=4.88
r203 (  22 89 ) resistor r=152 //w=0.17 //l=0.17 //layer=licon //count=1 \
 //x=21.58 //y=2.26 //x2=21.58 //y2=2.26
r204 (  20 57 ) resistor r=20.877 //w=0.187 //l=0.305 //layer=li \
 //thickness=0.1 //x=25.65 //y=4.99 //x2=25.65 //y2=5.295
r205 (  19 20 ) resistor r=25.3262 //w=0.187 //l=0.37 //layer=li \
 //thickness=0.1 //x=25.65 //y=4.62 //x2=25.65 //y2=4.99
r206 (  18 19 ) resistor r=25.3262 //w=0.187 //l=0.37 //layer=li \
 //thickness=0.1 //x=25.65 //y=4.25 //x2=25.65 //y2=4.62
r207 (  17 18 ) resistor r=25.3262 //w=0.187 //l=0.37 //layer=li \
 //thickness=0.1 //x=25.65 //y=3.88 //x2=25.65 //y2=4.25
r208 (  16 17 ) resistor r=25.3262 //w=0.187 //l=0.37 //layer=li \
 //thickness=0.1 //x=25.65 //y=3.51 //x2=25.65 //y2=3.88
r209 (  15 16 ) resistor r=25.3262 //w=0.187 //l=0.37 //layer=li \
 //thickness=0.1 //x=25.65 //y=3.14 //x2=25.65 //y2=3.51
r210 (  14 15 ) resistor r=25.3262 //w=0.187 //l=0.37 //layer=li \
 //thickness=0.1 //x=25.65 //y=2.77 //x2=25.65 //y2=3.14
r211 (  13 14 ) resistor r=25.3262 //w=0.187 //l=0.37 //layer=li \
 //thickness=0.1 //x=25.65 //y=2.4 //x2=25.65 //y2=2.77
r212 (  13 56 ) resistor r=32.8556 //w=0.187 //l=0.48 //layer=li \
 //thickness=0.1 //x=25.65 //y=2.4 //x2=25.65 //y2=1.92
r213 (  12 32 ) resistor r=17.7968 //w=0.187 //l=0.26 //layer=li \
 //thickness=0.1 //x=21.58 //y=4.62 //x2=21.58 //y2=4.88
r214 (  11 12 ) resistor r=50.6524 //w=0.187 //l=0.74 //layer=li \
 //thickness=0.1 //x=21.58 //y=3.88 //x2=21.58 //y2=4.62
r215 (  10 11 ) resistor r=25.3262 //w=0.187 //l=0.37 //layer=li \
 //thickness=0.1 //x=21.58 //y=3.51 //x2=21.58 //y2=3.88
r216 (  9 10 ) resistor r=25.3262 //w=0.187 //l=0.37 //layer=li \
 //thickness=0.1 //x=21.58 //y=3.14 //x2=21.58 //y2=3.51
r217 (  8 9 ) resistor r=25.3262 //w=0.187 //l=0.37 //layer=li //thickness=0.1 \
 //x=21.58 //y=2.77 //x2=21.58 //y2=3.14
r218 (  7 8 ) resistor r=25.3262 //w=0.187 //l=0.37 //layer=li //thickness=0.1 \
 //x=21.58 //y=2.4 //x2=21.58 //y2=2.77
r219 (  7 22 ) resistor r=9.58289 //w=0.187 //l=0.14 //layer=li \
 //thickness=0.1 //x=21.58 //y=2.4 //x2=21.58 //y2=2.26
r220 (  6 17 ) resistor r=9.3 //w=0.17 //l=0.17 //layer=mcon //count=1 \
 //x=25.65 //y=3.88 //x2=25.65 //y2=3.88
r221 (  4 11 ) resistor r=9.3 //w=0.17 //l=0.17 //layer=mcon //count=1 \
 //x=21.58 //y=3.88 //x2=21.58 //y2=3.88
r222 (  2 4 ) resistor r=0.0717383 //w=0.224 //l=0.115 //layer=m1 \
 //thickness=0.36 //x=21.695 //y=3.88 //x2=21.58 //y2=3.88
r223 (  1 6 ) resistor r=0.0717383 //w=0.224 //l=0.115 //layer=m1 \
 //thickness=0.36 //x=25.535 //y=3.88 //x2=25.65 //y2=3.88
r224 (  1 2 ) resistor r=3.66412 //w=0.131 //l=3.84 //layer=m1 \
 //thickness=0.36 //x=25.535 //y=3.88 //x2=21.695 //y2=3.88
ends PM_DFFRNX1\%Q

subckt PM_DFFRNX1\%noxref_11 ( 1 5 9 13 17 35 )
c47 ( 35 0 ) capacitor c=0.0703709f //x=0.945 //y=0.555
c48 ( 17 0 ) capacitor c=0.0221229f //x=2.935 //y=1.77
c49 ( 13 0 ) capacitor c=0.0156939f //x=2.935 //y=0.72
c50 ( 9 0 ) capacitor c=0.00678203f //x=2.05 //y=0.805
c51 ( 5 0 ) capacitor c=0.0206412f //x=1.965 //y=1.77
c52 ( 1 0 ) capacitor c=0.0109947f //x=1.08 //y=1.685
r53 (  18 35 ) resistor r=5.4201 //w=0.17 //l=0.103078 //layer=li \
 //thickness=0.1 //x=2.135 //y=1.77 //x2=2.05 //y2=1.81
r54 (  18 35 ) resistor r=27.3797 //w=0.187 //l=0.4 //layer=li //thickness=0.1 \
 //x=2.135 //y=1.77 //x2=2.535 //y2=1.77
r55 (  17 35 ) resistor r=0.751729 //w=0.17 //l=0.085 //layer=li \
 //thickness=0.1 //x=2.935 //y=1.77 //x2=3.02 //y2=1.77
r56 (  17 35 ) resistor r=27.3797 //w=0.187 //l=0.4 //layer=li //thickness=0.1 \
 //x=2.935 //y=1.77 //x2=2.535 //y2=1.77
r57 (  14 35 ) resistor r=3.57586 //w=0.17 //l=0.103078 //layer=li \
 //thickness=0.1 //x=2.135 //y=0.72 //x2=2.05 //y2=0.68
r58 (  14 35 ) resistor r=27.3797 //w=0.187 //l=0.4 //layer=li //thickness=0.1 \
 //x=2.135 //y=0.72 //x2=2.535 //y2=0.72
r59 (  13 35 ) resistor r=0.751729 //w=0.17 //l=0.085 //layer=li \
 //thickness=0.1 //x=2.935 //y=0.72 //x2=3.02 //y2=0.72
r60 (  13 35 ) resistor r=27.3797 //w=0.187 //l=0.4 //layer=li //thickness=0.1 \
 //x=2.935 //y=0.72 //x2=2.535 //y2=0.72
r61 (  10 35 ) resistor r=1.40859 //w=0.34 //l=0.125 //layer=li \
 //thickness=0.1 //x=2.05 //y=1.685 //x2=2.05 //y2=1.81
r62 (  10 35 ) resistor r=42.0963 //w=0.187 //l=0.615 //layer=li \
 //thickness=0.1 //x=2.05 //y=1.685 //x2=2.05 //y2=1.07
r63 (  9 35 ) resistor r=3.57586 //w=0.17 //l=0.125 //layer=li //thickness=0.1 \
 //x=2.05 //y=0.805 //x2=2.05 //y2=0.68
r64 (  9 35 ) resistor r=18.139 //w=0.187 //l=0.265 //layer=li //thickness=0.1 \
 //x=2.05 //y=0.805 //x2=2.05 //y2=1.07
r65 (  6 35 ) resistor r=3.57586 //w=0.17 //l=0.103078 //layer=li \
 //thickness=0.1 //x=1.165 //y=1.77 //x2=1.08 //y2=1.81
r66 (  6 35 ) resistor r=27.3797 //w=0.187 //l=0.4 //layer=li //thickness=0.1 \
 //x=1.165 //y=1.77 //x2=1.565 //y2=1.77
r67 (  5 35 ) resistor r=5.4201 //w=0.17 //l=0.103078 //layer=li \
 //thickness=0.1 //x=1.965 //y=1.77 //x2=2.05 //y2=1.81
r68 (  5 35 ) resistor r=27.3797 //w=0.187 //l=0.4 //layer=li //thickness=0.1 \
 //x=1.965 //y=1.77 //x2=1.565 //y2=1.77
r69 (  1 35 ) resistor r=3.57586 //w=0.17 //l=0.125 //layer=li //thickness=0.1 \
 //x=1.08 //y=1.685 //x2=1.08 //y2=1.81
r70 (  1 35 ) resistor r=42.0963 //w=0.187 //l=0.615 //layer=li \
 //thickness=0.1 //x=1.08 //y=1.685 //x2=1.08 //y2=1.07
ends PM_DFFRNX1\%noxref_11

subckt PM_DFFRNX1\%noxref_12 ( 1 3 11 15 25 28 29 )
c53 ( 29 0 ) capacitor c=0.043074f //x=3.455 //y=0.555
c54 ( 28 0 ) capacitor c=0.00465142f //x=2.35 //y=1.09
c55 ( 25 0 ) capacitor c=0.00156479f //x=3.59 //y=1.175
c56 ( 15 0 ) capacitor c=0.00737666f //x=4.56 //y=0.805
c57 ( 11 0 ) capacitor c=0.0149771f //x=4.475 //y=0.72
c58 ( 3 0 ) capacitor c=0.00718386f //x=3.59 //y=0.805
c59 ( 1 0 ) capacitor c=0.0253322f //x=3.505 //y=1.175
r60 (  15 29 ) resistor r=3.57586 //w=0.17 //l=0.125 //layer=li \
 //thickness=0.1 //x=4.56 //y=0.805 //x2=4.56 //y2=0.68
r61 (  15 29 ) resistor r=18.139 //w=0.187 //l=0.265 //layer=li \
 //thickness=0.1 //x=4.56 //y=0.805 //x2=4.56 //y2=1.07
r62 (  12 29 ) resistor r=3.57586 //w=0.17 //l=0.103078 //layer=li \
 //thickness=0.1 //x=3.675 //y=0.72 //x2=3.59 //y2=0.68
r63 (  12 29 ) resistor r=27.3797 //w=0.187 //l=0.4 //layer=li //thickness=0.1 \
 //x=3.675 //y=0.72 //x2=4.075 //y2=0.72
r64 (  11 29 ) resistor r=3.57586 //w=0.17 //l=0.103078 //layer=li \
 //thickness=0.1 //x=4.475 //y=0.72 //x2=4.56 //y2=0.68
r65 (  11 29 ) resistor r=27.3797 //w=0.187 //l=0.4 //layer=li //thickness=0.1 \
 //x=4.475 //y=0.72 //x2=4.075 //y2=0.72
r66 (  7 25 ) resistor r=5.4201 //w=0.17 //l=0.085 //layer=li //thickness=0.1 \
 //x=3.59 //y=1.26 //x2=3.59 //y2=1.175
r67 (  7 29 ) resistor r=10.2674 //w=0.187 //l=0.15 //layer=li //thickness=0.1 \
 //x=3.59 //y=1.26 //x2=3.59 //y2=1.41
r68 (  4 25 ) resistor r=5.4201 //w=0.17 //l=0.085 //layer=li //thickness=0.1 \
 //x=3.59 //y=1.09 //x2=3.59 //y2=1.175
r69 (  4 29 ) resistor r=1.36898 //w=0.187 //l=0.02 //layer=li //thickness=0.1 \
 //x=3.59 //y=1.09 //x2=3.59 //y2=1.07
r70 (  3 29 ) resistor r=3.57586 //w=0.17 //l=0.125 //layer=li //thickness=0.1 \
 //x=3.59 //y=0.805 //x2=3.59 //y2=0.68
r71 (  3 29 ) resistor r=18.139 //w=0.187 //l=0.265 //layer=li //thickness=0.1 \
 //x=3.59 //y=0.805 //x2=3.59 //y2=1.07
r72 (  2 28 ) resistor r=0.751729 //w=0.17 //l=0.085 //layer=li \
 //thickness=0.1 //x=2.625 //y=1.175 //x2=2.54 //y2=1.175
r73 (  1 25 ) resistor r=1.40859 //w=0.34 //l=0.085 //layer=li //thickness=0.1 \
 //x=3.505 //y=1.175 //x2=3.59 //y2=1.175
r74 (  1 2 ) resistor r=60.2353 //w=0.187 //l=0.88 //layer=li //thickness=0.1 \
 //x=3.505 //y=1.175 //x2=2.625 //y2=1.175
ends PM_DFFRNX1\%noxref_12

subckt PM_DFFRNX1\%D ( 1 2 3 5 13 14 15 16 17 18 20 26 27 28 29 30 38 )
c80 ( 38 0 ) capacitor c=0.0335551f //x=7.52 //y=4.88
c81 ( 30 0 ) capacitor c=0.0245352f //x=7.855 //y=4.97
c82 ( 29 0 ) capacitor c=0.0850619f //x=7.61 //y=2.095
c83 ( 28 0 ) capacitor c=0.0170266f //x=7.61 //y=1.63
c84 ( 27 0 ) capacitor c=0.018609f //x=7.61 //y=1.4
c85 ( 26 0 ) capacitor c=0.0187309f //x=7.61 //y=1.09
c86 ( 20 0 ) capacitor c=0.014725f //x=7.455 //y=1.555
c87 ( 18 0 ) capacitor c=0.0146567f //x=7.455 //y=0.935
c88 ( 17 0 ) capacitor c=0.0335408f //x=7.085 //y=1.4
c89 ( 16 0 ) capacitor c=0.0173761f //x=7.085 //y=1.09
c90 ( 15 0 ) capacitor c=0.110114f //x=7.93 //y=6.2
c91 ( 14 0 ) capacitor c=0.11012f //x=7.49 //y=6.2
c92 ( 5 0 ) capacitor c=0.0956955f //x=7.52 //y=2.26
r93 (  40 41 ) resistor r=32.4568 //w=0.214 //l=0.075 //layer=ply \
 //thickness=0.18 //x=7.52 //y=4.97 //x2=7.52 //y2=5.045
r94 (  38 40 ) resistor r=20.271 //w=0.214 //l=0.09 //layer=ply \
 //thickness=0.18 //x=7.52 //y=4.88 //x2=7.52 //y2=4.97
r95 (  31 40 ) resistor r=16.5046 //w=0.27 //l=0.135 //layer=ply \
 //thickness=0.18 //x=7.655 //y=4.97 //x2=7.52 //y2=4.97
r96 (  30 32 ) resistor r=26.9307 //w=0.15 //l=0.106066 //layer=ply \
 //thickness=0.18 //x=7.855 //y=4.97 //x2=7.93 //y2=5.045
r97 (  30 31 ) resistor r=102.553 //w=0.094 //l=0.2 //layer=ply \
 //thickness=0.18 //x=7.855 //y=4.97 //x2=7.655 //y2=4.97
r98 (  29 45 ) resistor r=38.6777 //w=0.284 //l=0.198997 //layer=ply \
 //thickness=0.18 //x=7.61 //y=2.095 //x2=7.535 //y2=2.26
r99 (  28 43 ) resistor r=21.2976 //w=0.217 //l=0.0928709 //layer=ply \
 //thickness=0.18 //x=7.61 //y=1.63 //x2=7.57 //y2=1.555
r100 (  28 29 ) resistor r=238.436 //w=0.094 //l=0.465 //layer=ply \
 //thickness=0.18 //x=7.61 //y=1.63 //x2=7.61 //y2=2.095
r101 (  27 43 ) resistor r=39.0671 //w=0.217 //l=0.173853 //layer=ply \
 //thickness=0.18 //x=7.61 //y=1.4 //x2=7.57 //y2=1.555
r102 (  26 42 ) resistor r=45.1352 //w=0.168 //l=0.173853 //layer=ply \
 //thickness=0.18 //x=7.61 //y=1.09 //x2=7.57 //y2=0.935
r103 (  26 27 ) resistor r=158.957 //w=0.094 //l=0.31 //layer=ply \
 //thickness=0.18 //x=7.61 //y=1.09 //x2=7.61 //y2=1.4
r104 (  21 36 ) resistor r=5.52526 //w=0.168 //l=0.115 //layer=ply \
 //thickness=0.18 //x=7.24 //y=1.555 //x2=7.125 //y2=1.555
r105 (  20 43 ) resistor r=11.4558 //w=0.217 //l=0.115 //layer=ply \
 //thickness=0.18 //x=7.455 //y=1.555 //x2=7.57 //y2=1.555
r106 (  19 35 ) resistor r=5.52526 //w=0.168 //l=0.115 //layer=ply \
 //thickness=0.18 //x=7.24 //y=0.935 //x2=7.125 //y2=0.935
r107 (  18 42 ) resistor r=5.52526 //w=0.168 //l=0.115 //layer=ply \
 //thickness=0.18 //x=7.455 //y=0.935 //x2=7.57 //y2=0.935
r108 (  18 19 ) resistor r=110.245 //w=0.094 //l=0.215 //layer=ply \
 //thickness=0.18 //x=7.455 //y=0.935 //x2=7.24 //y2=0.935
r109 (  17 36 ) resistor r=45.1352 //w=0.168 //l=0.173853 //layer=ply \
 //thickness=0.18 //x=7.085 //y=1.4 //x2=7.125 //y2=1.555
r110 (  16 35 ) resistor r=45.1352 //w=0.168 //l=0.173853 //layer=ply \
 //thickness=0.18 //x=7.085 //y=1.09 //x2=7.125 //y2=0.935
r111 (  16 17 ) resistor r=158.957 //w=0.094 //l=0.31 //layer=ply \
 //thickness=0.18 //x=7.085 //y=1.09 //x2=7.085 //y2=1.4
r112 (  15 32 ) resistor r=592.245 //w=0.094 //l=1.155 //layer=ply \
 //thickness=0.18 //x=7.93 //y=6.2 //x2=7.93 //y2=5.045
r113 (  14 41 ) resistor r=592.245 //w=0.094 //l=1.155 //layer=ply \
 //thickness=0.18 //x=7.49 //y=6.2 //x2=7.49 //y2=5.045
r114 (  13 20 ) resistor r=55.3787 //w=0.094 //l=0.108 //layer=ply \
 //thickness=0.18 //x=7.347 //y=1.555 //x2=7.455 //y2=1.555
r115 (  13 21 ) resistor r=54.866 //w=0.094 //l=0.107 //layer=ply \
 //thickness=0.18 //x=7.347 //y=1.555 //x2=7.24 //y2=1.555
r116 (  11 38 ) resistor r=152 //w=0.17 //l=0.17 //layer=licon //count=1 \
 //x=7.52 //y=4.88 //x2=7.52 //y2=4.88
r117 (  5 45 ) resistor r=152 //w=0.17 //l=0.17 //layer=licon //count=1 \
 //x=7.52 //y=2.26 //x2=7.52 //y2=2.26
r118 (  3 11 ) resistor r=119.102 //w=0.187 //l=1.74 //layer=li \
 //thickness=0.1 //x=7.52 //y=3.14 //x2=7.52 //y2=4.88
r119 (  2 3 ) resistor r=25.3262 //w=0.187 //l=0.37 //layer=li //thickness=0.1 \
 //x=7.52 //y=2.77 //x2=7.52 //y2=3.14
r120 (  1 2 ) resistor r=25.3262 //w=0.187 //l=0.37 //layer=li //thickness=0.1 \
 //x=7.52 //y=2.4 //x2=7.52 //y2=2.77
r121 (  1 5 ) resistor r=9.58289 //w=0.187 //l=0.14 //layer=li //thickness=0.1 \
 //x=7.52 //y=2.4 //x2=7.52 //y2=2.26
ends PM_DFFRNX1\%D

subckt PM_DFFRNX1\%noxref_14 ( 1 5 9 13 17 35 )
c50 ( 35 0 ) capacitor c=0.0693021f //x=5.755 //y=0.555
c51 ( 17 0 ) capacitor c=0.0206235f //x=7.745 //y=1.77
c52 ( 13 0 ) capacitor c=0.0156174f //x=7.745 //y=0.72
c53 ( 9 0 ) capacitor c=0.00678203f //x=6.86 //y=0.805
c54 ( 5 0 ) capacitor c=0.0183576f //x=6.775 //y=1.77
c55 ( 1 0 ) capacitor c=0.00791969f //x=5.89 //y=1.685
r56 (  18 35 ) resistor r=5.4201 //w=0.17 //l=0.103078 //layer=li \
 //thickness=0.1 //x=6.945 //y=1.77 //x2=6.86 //y2=1.81
r57 (  18 35 ) resistor r=27.3797 //w=0.187 //l=0.4 //layer=li //thickness=0.1 \
 //x=6.945 //y=1.77 //x2=7.345 //y2=1.77
r58 (  17 35 ) resistor r=0.751729 //w=0.17 //l=0.085 //layer=li \
 //thickness=0.1 //x=7.745 //y=1.77 //x2=7.83 //y2=1.77
r59 (  17 35 ) resistor r=27.3797 //w=0.187 //l=0.4 //layer=li //thickness=0.1 \
 //x=7.745 //y=1.77 //x2=7.345 //y2=1.77
r60 (  14 35 ) resistor r=3.57586 //w=0.17 //l=0.103078 //layer=li \
 //thickness=0.1 //x=6.945 //y=0.72 //x2=6.86 //y2=0.68
r61 (  14 35 ) resistor r=27.3797 //w=0.187 //l=0.4 //layer=li //thickness=0.1 \
 //x=6.945 //y=0.72 //x2=7.345 //y2=0.72
r62 (  13 35 ) resistor r=0.751729 //w=0.17 //l=0.085 //layer=li \
 //thickness=0.1 //x=7.745 //y=0.72 //x2=7.83 //y2=0.72
r63 (  13 35 ) resistor r=27.3797 //w=0.187 //l=0.4 //layer=li //thickness=0.1 \
 //x=7.745 //y=0.72 //x2=7.345 //y2=0.72
r64 (  10 35 ) resistor r=1.40859 //w=0.34 //l=0.125 //layer=li \
 //thickness=0.1 //x=6.86 //y=1.685 //x2=6.86 //y2=1.81
r65 (  10 35 ) resistor r=42.0963 //w=0.187 //l=0.615 //layer=li \
 //thickness=0.1 //x=6.86 //y=1.685 //x2=6.86 //y2=1.07
r66 (  9 35 ) resistor r=3.57586 //w=0.17 //l=0.125 //layer=li //thickness=0.1 \
 //x=6.86 //y=0.805 //x2=6.86 //y2=0.68
r67 (  9 35 ) resistor r=18.139 //w=0.187 //l=0.265 //layer=li //thickness=0.1 \
 //x=6.86 //y=0.805 //x2=6.86 //y2=1.07
r68 (  6 35 ) resistor r=3.57586 //w=0.17 //l=0.103078 //layer=li \
 //thickness=0.1 //x=5.975 //y=1.77 //x2=5.89 //y2=1.81
r69 (  6 35 ) resistor r=27.3797 //w=0.187 //l=0.4 //layer=li //thickness=0.1 \
 //x=5.975 //y=1.77 //x2=6.375 //y2=1.77
r70 (  5 35 ) resistor r=5.4201 //w=0.17 //l=0.103078 //layer=li \
 //thickness=0.1 //x=6.775 //y=1.77 //x2=6.86 //y2=1.81
r71 (  5 35 ) resistor r=27.3797 //w=0.187 //l=0.4 //layer=li //thickness=0.1 \
 //x=6.775 //y=1.77 //x2=6.375 //y2=1.77
r72 (  1 35 ) resistor r=3.57586 //w=0.17 //l=0.125 //layer=li //thickness=0.1 \
 //x=5.89 //y=1.685 //x2=5.89 //y2=1.81
r73 (  1 35 ) resistor r=42.0963 //w=0.187 //l=0.615 //layer=li \
 //thickness=0.1 //x=5.89 //y=1.685 //x2=5.89 //y2=1.07
ends PM_DFFRNX1\%noxref_14

subckt PM_DFFRNX1\%noxref_15 ( 1 3 11 15 25 28 29 )
c54 ( 29 0 ) capacitor c=0.0423432f //x=8.265 //y=0.555
c55 ( 28 0 ) capacitor c=0.00463374f //x=7.16 //y=1.09
c56 ( 25 0 ) capacitor c=0.00156479f //x=8.4 //y=1.175
c57 ( 15 0 ) capacitor c=0.00737666f //x=9.37 //y=0.805
c58 ( 11 0 ) capacitor c=0.0144218f //x=9.285 //y=0.72
c59 ( 3 0 ) capacitor c=0.00718386f //x=8.4 //y=0.805
c60 ( 1 0 ) capacitor c=0.0242666f //x=8.315 //y=1.175
r61 (  15 29 ) resistor r=3.57586 //w=0.17 //l=0.125 //layer=li \
 //thickness=0.1 //x=9.37 //y=0.805 //x2=9.37 //y2=0.68
r62 (  15 29 ) resistor r=18.139 //w=0.187 //l=0.265 //layer=li \
 //thickness=0.1 //x=9.37 //y=0.805 //x2=9.37 //y2=1.07
r63 (  12 29 ) resistor r=3.57586 //w=0.17 //l=0.103078 //layer=li \
 //thickness=0.1 //x=8.485 //y=0.72 //x2=8.4 //y2=0.68
r64 (  12 29 ) resistor r=27.3797 //w=0.187 //l=0.4 //layer=li //thickness=0.1 \
 //x=8.485 //y=0.72 //x2=8.885 //y2=0.72
r65 (  11 29 ) resistor r=3.57586 //w=0.17 //l=0.103078 //layer=li \
 //thickness=0.1 //x=9.285 //y=0.72 //x2=9.37 //y2=0.68
r66 (  11 29 ) resistor r=27.3797 //w=0.187 //l=0.4 //layer=li //thickness=0.1 \
 //x=9.285 //y=0.72 //x2=8.885 //y2=0.72
r67 (  7 25 ) resistor r=5.4201 //w=0.17 //l=0.085 //layer=li //thickness=0.1 \
 //x=8.4 //y=1.26 //x2=8.4 //y2=1.175
r68 (  7 29 ) resistor r=10.2674 //w=0.187 //l=0.15 //layer=li //thickness=0.1 \
 //x=8.4 //y=1.26 //x2=8.4 //y2=1.41
r69 (  4 25 ) resistor r=5.4201 //w=0.17 //l=0.085 //layer=li //thickness=0.1 \
 //x=8.4 //y=1.09 //x2=8.4 //y2=1.175
r70 (  4 29 ) resistor r=1.36898 //w=0.187 //l=0.02 //layer=li //thickness=0.1 \
 //x=8.4 //y=1.09 //x2=8.4 //y2=1.07
r71 (  3 29 ) resistor r=3.57586 //w=0.17 //l=0.125 //layer=li //thickness=0.1 \
 //x=8.4 //y=0.805 //x2=8.4 //y2=0.68
r72 (  3 29 ) resistor r=18.139 //w=0.187 //l=0.265 //layer=li //thickness=0.1 \
 //x=8.4 //y=0.805 //x2=8.4 //y2=1.07
r73 (  2 28 ) resistor r=0.751729 //w=0.17 //l=0.085 //layer=li \
 //thickness=0.1 //x=7.435 //y=1.175 //x2=7.35 //y2=1.175
r74 (  1 25 ) resistor r=1.40859 //w=0.34 //l=0.085 //layer=li //thickness=0.1 \
 //x=8.315 //y=1.175 //x2=8.4 //y2=1.175
r75 (  1 2 ) resistor r=60.2353 //w=0.187 //l=0.88 //layer=li //thickness=0.1 \
 //x=8.315 //y=1.175 //x2=7.435 //y2=1.175
ends PM_DFFRNX1\%noxref_15

subckt PM_DFFRNX1\%noxref_16 ( 1 5 9 10 13 17 29 )
c52 ( 29 0 ) capacitor c=0.0632682f //x=10.67 //y=0.545
c53 ( 17 0 ) capacitor c=0.0072343f //x=12.745 //y=0.795
c54 ( 13 0 ) capacitor c=0.0145084f //x=12.66 //y=0.71
c55 ( 10 0 ) capacitor c=0.00582081f //x=11.775 //y=1.675
c56 ( 9 0 ) capacitor c=0.006761f //x=11.775 //y=0.795
c57 ( 5 0 ) capacitor c=0.0173046f //x=11.69 //y=1.76
c58 ( 1 0 ) capacitor c=0.00733328f //x=10.805 //y=1.675
r59 (  17 29 ) resistor r=3.57586 //w=0.17 //l=0.125 //layer=li \
 //thickness=0.1 //x=12.745 //y=0.795 //x2=12.745 //y2=0.67
r60 (  17 29 ) resistor r=18.139 //w=0.187 //l=0.265 //layer=li \
 //thickness=0.1 //x=12.745 //y=0.795 //x2=12.745 //y2=1.06
r61 (  14 29 ) resistor r=3.57586 //w=0.17 //l=0.103078 //layer=li \
 //thickness=0.1 //x=11.86 //y=0.71 //x2=11.775 //y2=0.67
r62 (  14 29 ) resistor r=27.3797 //w=0.187 //l=0.4 //layer=li //thickness=0.1 \
 //x=11.86 //y=0.71 //x2=12.26 //y2=0.71
r63 (  13 29 ) resistor r=3.57586 //w=0.17 //l=0.103078 //layer=li \
 //thickness=0.1 //x=12.66 //y=0.71 //x2=12.745 //y2=0.67
r64 (  13 29 ) resistor r=27.3797 //w=0.187 //l=0.4 //layer=li //thickness=0.1 \
 //x=12.66 //y=0.71 //x2=12.26 //y2=0.71
r65 (  10 29 ) resistor r=3.57586 //w=0.17 //l=0.125 //layer=li \
 //thickness=0.1 //x=11.775 //y=1.675 //x2=11.775 //y2=1.8
r66 (  10 29 ) resistor r=42.0963 //w=0.187 //l=0.615 //layer=li \
 //thickness=0.1 //x=11.775 //y=1.675 //x2=11.775 //y2=1.06
r67 (  9 29 ) resistor r=3.57586 //w=0.17 //l=0.125 //layer=li //thickness=0.1 \
 //x=11.775 //y=0.795 //x2=11.775 //y2=0.67
r68 (  9 29 ) resistor r=18.139 //w=0.187 //l=0.265 //layer=li //thickness=0.1 \
 //x=11.775 //y=0.795 //x2=11.775 //y2=1.06
r69 (  6 29 ) resistor r=3.57586 //w=0.17 //l=0.103078 //layer=li \
 //thickness=0.1 //x=10.89 //y=1.76 //x2=10.805 //y2=1.8
r70 (  6 29 ) resistor r=27.3797 //w=0.187 //l=0.4 //layer=li //thickness=0.1 \
 //x=10.89 //y=1.76 //x2=11.29 //y2=1.76
r71 (  5 29 ) resistor r=3.57586 //w=0.17 //l=0.103078 //layer=li \
 //thickness=0.1 //x=11.69 //y=1.76 //x2=11.775 //y2=1.8
r72 (  5 29 ) resistor r=27.3797 //w=0.187 //l=0.4 //layer=li //thickness=0.1 \
 //x=11.69 //y=1.76 //x2=11.29 //y2=1.76
r73 (  1 29 ) resistor r=3.57586 //w=0.17 //l=0.125 //layer=li //thickness=0.1 \
 //x=10.805 //y=1.675 //x2=10.805 //y2=1.8
r74 (  1 29 ) resistor r=42.0963 //w=0.187 //l=0.615 //layer=li \
 //thickness=0.1 //x=10.805 //y=1.675 //x2=10.805 //y2=1.06
ends PM_DFFRNX1\%noxref_16

subckt PM_DFFRNX1\%noxref_17 ( 1 5 9 13 17 35 )
c50 ( 35 0 ) capacitor c=0.0673029f //x=13.895 //y=0.555
c51 ( 17 0 ) capacitor c=0.0178317f //x=15.885 //y=1.77
c52 ( 13 0 ) capacitor c=0.0154936f //x=15.885 //y=0.72
c53 ( 9 0 ) capacitor c=0.00678203f //x=15 //y=0.805
c54 ( 5 0 ) capacitor c=0.0164013f //x=14.915 //y=1.77
c55 ( 1 0 ) capacitor c=0.00696517f //x=14.03 //y=1.685
r56 (  18 35 ) resistor r=5.4201 //w=0.17 //l=0.103078 //layer=li \
 //thickness=0.1 //x=15.085 //y=1.77 //x2=15 //y2=1.81
r57 (  18 35 ) resistor r=27.3797 //w=0.187 //l=0.4 //layer=li //thickness=0.1 \
 //x=15.085 //y=1.77 //x2=15.485 //y2=1.77
r58 (  17 35 ) resistor r=0.751729 //w=0.17 //l=0.085 //layer=li \
 //thickness=0.1 //x=15.885 //y=1.77 //x2=15.97 //y2=1.77
r59 (  17 35 ) resistor r=27.3797 //w=0.187 //l=0.4 //layer=li //thickness=0.1 \
 //x=15.885 //y=1.77 //x2=15.485 //y2=1.77
r60 (  14 35 ) resistor r=3.57586 //w=0.17 //l=0.103078 //layer=li \
 //thickness=0.1 //x=15.085 //y=0.72 //x2=15 //y2=0.68
r61 (  14 35 ) resistor r=27.3797 //w=0.187 //l=0.4 //layer=li //thickness=0.1 \
 //x=15.085 //y=0.72 //x2=15.485 //y2=0.72
r62 (  13 35 ) resistor r=0.751729 //w=0.17 //l=0.085 //layer=li \
 //thickness=0.1 //x=15.885 //y=0.72 //x2=15.97 //y2=0.72
r63 (  13 35 ) resistor r=27.3797 //w=0.187 //l=0.4 //layer=li //thickness=0.1 \
 //x=15.885 //y=0.72 //x2=15.485 //y2=0.72
r64 (  10 35 ) resistor r=1.40859 //w=0.34 //l=0.125 //layer=li \
 //thickness=0.1 //x=15 //y=1.685 //x2=15 //y2=1.81
r65 (  10 35 ) resistor r=42.0963 //w=0.187 //l=0.615 //layer=li \
 //thickness=0.1 //x=15 //y=1.685 //x2=15 //y2=1.07
r66 (  9 35 ) resistor r=3.57586 //w=0.17 //l=0.125 //layer=li //thickness=0.1 \
 //x=15 //y=0.805 //x2=15 //y2=0.68
r67 (  9 35 ) resistor r=18.139 //w=0.187 //l=0.265 //layer=li //thickness=0.1 \
 //x=15 //y=0.805 //x2=15 //y2=1.07
r68 (  6 35 ) resistor r=3.57586 //w=0.17 //l=0.103078 //layer=li \
 //thickness=0.1 //x=14.115 //y=1.77 //x2=14.03 //y2=1.81
r69 (  6 35 ) resistor r=27.3797 //w=0.187 //l=0.4 //layer=li //thickness=0.1 \
 //x=14.115 //y=1.77 //x2=14.515 //y2=1.77
r70 (  5 35 ) resistor r=5.4201 //w=0.17 //l=0.103078 //layer=li \
 //thickness=0.1 //x=14.915 //y=1.77 //x2=15 //y2=1.81
r71 (  5 35 ) resistor r=27.3797 //w=0.187 //l=0.4 //layer=li //thickness=0.1 \
 //x=14.915 //y=1.77 //x2=14.515 //y2=1.77
r72 (  1 35 ) resistor r=3.57586 //w=0.17 //l=0.125 //layer=li //thickness=0.1 \
 //x=14.03 //y=1.685 //x2=14.03 //y2=1.81
r73 (  1 35 ) resistor r=42.0963 //w=0.187 //l=0.615 //layer=li \
 //thickness=0.1 //x=14.03 //y=1.685 //x2=14.03 //y2=1.07
ends PM_DFFRNX1\%noxref_17

subckt PM_DFFRNX1\%noxref_18 ( 1 3 11 15 25 28 29 )
c54 ( 29 0 ) capacitor c=0.0413887f //x=16.405 //y=0.555
c55 ( 28 0 ) capacitor c=0.0045748f //x=15.3 //y=1.09
c56 ( 25 0 ) capacitor c=0.00156479f //x=16.54 //y=1.175
c57 ( 15 0 ) capacitor c=0.00737666f //x=17.51 //y=0.805
c58 ( 11 0 ) capacitor c=0.0144218f //x=17.425 //y=0.72
c59 ( 3 0 ) capacitor c=0.00718386f //x=16.54 //y=0.805
c60 ( 1 0 ) capacitor c=0.0220678f //x=16.455 //y=1.175
r61 (  15 29 ) resistor r=3.57586 //w=0.17 //l=0.125 //layer=li \
 //thickness=0.1 //x=17.51 //y=0.805 //x2=17.51 //y2=0.68
r62 (  15 29 ) resistor r=18.139 //w=0.187 //l=0.265 //layer=li \
 //thickness=0.1 //x=17.51 //y=0.805 //x2=17.51 //y2=1.07
r63 (  12 29 ) resistor r=3.57586 //w=0.17 //l=0.103078 //layer=li \
 //thickness=0.1 //x=16.625 //y=0.72 //x2=16.54 //y2=0.68
r64 (  12 29 ) resistor r=27.3797 //w=0.187 //l=0.4 //layer=li //thickness=0.1 \
 //x=16.625 //y=0.72 //x2=17.025 //y2=0.72
r65 (  11 29 ) resistor r=3.57586 //w=0.17 //l=0.103078 //layer=li \
 //thickness=0.1 //x=17.425 //y=0.72 //x2=17.51 //y2=0.68
r66 (  11 29 ) resistor r=27.3797 //w=0.187 //l=0.4 //layer=li //thickness=0.1 \
 //x=17.425 //y=0.72 //x2=17.025 //y2=0.72
r67 (  7 25 ) resistor r=5.4201 //w=0.17 //l=0.085 //layer=li //thickness=0.1 \
 //x=16.54 //y=1.26 //x2=16.54 //y2=1.175
r68 (  7 29 ) resistor r=10.2674 //w=0.187 //l=0.15 //layer=li //thickness=0.1 \
 //x=16.54 //y=1.26 //x2=16.54 //y2=1.41
r69 (  4 25 ) resistor r=5.4201 //w=0.17 //l=0.085 //layer=li //thickness=0.1 \
 //x=16.54 //y=1.09 //x2=16.54 //y2=1.175
r70 (  4 29 ) resistor r=1.36898 //w=0.187 //l=0.02 //layer=li //thickness=0.1 \
 //x=16.54 //y=1.09 //x2=16.54 //y2=1.07
r71 (  3 29 ) resistor r=3.57586 //w=0.17 //l=0.125 //layer=li //thickness=0.1 \
 //x=16.54 //y=0.805 //x2=16.54 //y2=0.68
r72 (  3 29 ) resistor r=18.139 //w=0.187 //l=0.265 //layer=li //thickness=0.1 \
 //x=16.54 //y=0.805 //x2=16.54 //y2=1.07
r73 (  2 28 ) resistor r=0.751729 //w=0.17 //l=0.085 //layer=li \
 //thickness=0.1 //x=15.575 //y=1.175 //x2=15.49 //y2=1.175
r74 (  1 25 ) resistor r=1.40859 //w=0.34 //l=0.085 //layer=li //thickness=0.1 \
 //x=16.455 //y=1.175 //x2=16.54 //y2=1.175
r75 (  1 2 ) resistor r=60.2353 //w=0.187 //l=0.88 //layer=li //thickness=0.1 \
 //x=16.455 //y=1.175 //x2=15.575 //y2=1.175
ends PM_DFFRNX1\%noxref_18

subckt PM_DFFRNX1\%noxref_19 ( 1 5 9 13 17 35 )
c52 ( 35 0 ) capacitor c=0.0688914f //x=18.705 //y=0.555
c53 ( 17 0 ) capacitor c=0.018313f //x=20.695 //y=1.77
c54 ( 13 0 ) capacitor c=0.0155692f //x=20.695 //y=0.72
c55 ( 9 0 ) capacitor c=0.00678203f //x=19.81 //y=0.805
c56 ( 5 0 ) capacitor c=0.0164013f //x=19.725 //y=1.77
c57 ( 1 0 ) capacitor c=0.00696517f //x=18.84 //y=1.685
r58 (  18 35 ) resistor r=5.4201 //w=0.17 //l=0.103078 //layer=li \
 //thickness=0.1 //x=19.895 //y=1.77 //x2=19.81 //y2=1.81
r59 (  18 35 ) resistor r=27.3797 //w=0.187 //l=0.4 //layer=li //thickness=0.1 \
 //x=19.895 //y=1.77 //x2=20.295 //y2=1.77
r60 (  17 35 ) resistor r=0.751729 //w=0.17 //l=0.085 //layer=li \
 //thickness=0.1 //x=20.695 //y=1.77 //x2=20.78 //y2=1.77
r61 (  17 35 ) resistor r=27.3797 //w=0.187 //l=0.4 //layer=li //thickness=0.1 \
 //x=20.695 //y=1.77 //x2=20.295 //y2=1.77
r62 (  14 35 ) resistor r=3.57586 //w=0.17 //l=0.103078 //layer=li \
 //thickness=0.1 //x=19.895 //y=0.72 //x2=19.81 //y2=0.68
r63 (  14 35 ) resistor r=27.3797 //w=0.187 //l=0.4 //layer=li //thickness=0.1 \
 //x=19.895 //y=0.72 //x2=20.295 //y2=0.72
r64 (  13 35 ) resistor r=0.751729 //w=0.17 //l=0.085 //layer=li \
 //thickness=0.1 //x=20.695 //y=0.72 //x2=20.78 //y2=0.72
r65 (  13 35 ) resistor r=27.3797 //w=0.187 //l=0.4 //layer=li //thickness=0.1 \
 //x=20.695 //y=0.72 //x2=20.295 //y2=0.72
r66 (  10 35 ) resistor r=1.40859 //w=0.34 //l=0.125 //layer=li \
 //thickness=0.1 //x=19.81 //y=1.685 //x2=19.81 //y2=1.81
r67 (  10 35 ) resistor r=42.0963 //w=0.187 //l=0.615 //layer=li \
 //thickness=0.1 //x=19.81 //y=1.685 //x2=19.81 //y2=1.07
r68 (  9 35 ) resistor r=3.57586 //w=0.17 //l=0.125 //layer=li //thickness=0.1 \
 //x=19.81 //y=0.805 //x2=19.81 //y2=0.68
r69 (  9 35 ) resistor r=18.139 //w=0.187 //l=0.265 //layer=li //thickness=0.1 \
 //x=19.81 //y=0.805 //x2=19.81 //y2=1.07
r70 (  6 35 ) resistor r=3.57586 //w=0.17 //l=0.103078 //layer=li \
 //thickness=0.1 //x=18.925 //y=1.77 //x2=18.84 //y2=1.81
r71 (  6 35 ) resistor r=27.3797 //w=0.187 //l=0.4 //layer=li //thickness=0.1 \
 //x=18.925 //y=1.77 //x2=19.325 //y2=1.77
r72 (  5 35 ) resistor r=5.4201 //w=0.17 //l=0.103078 //layer=li \
 //thickness=0.1 //x=19.725 //y=1.77 //x2=19.81 //y2=1.81
r73 (  5 35 ) resistor r=27.3797 //w=0.187 //l=0.4 //layer=li //thickness=0.1 \
 //x=19.725 //y=1.77 //x2=19.325 //y2=1.77
r74 (  1 35 ) resistor r=3.57586 //w=0.17 //l=0.125 //layer=li //thickness=0.1 \
 //x=18.84 //y=1.685 //x2=18.84 //y2=1.81
r75 (  1 35 ) resistor r=42.0963 //w=0.187 //l=0.615 //layer=li \
 //thickness=0.1 //x=18.84 //y=1.685 //x2=18.84 //y2=1.07
ends PM_DFFRNX1\%noxref_19

subckt PM_DFFRNX1\%noxref_20 ( 1 3 11 15 25 28 29 )
c52 ( 29 0 ) capacitor c=0.0430705f //x=21.215 //y=0.555
c53 ( 28 0 ) capacitor c=0.00457437f //x=20.11 //y=1.09
c54 ( 25 0 ) capacitor c=0.00156479f //x=21.35 //y=1.175
c55 ( 15 0 ) capacitor c=0.00737666f //x=22.32 //y=0.805
c56 ( 11 0 ) capacitor c=0.0152164f //x=22.235 //y=0.72
c57 ( 3 0 ) capacitor c=0.00718386f //x=21.35 //y=0.805
c58 ( 1 0 ) capacitor c=0.0252837f //x=21.265 //y=1.175
r59 (  15 29 ) resistor r=3.57586 //w=0.17 //l=0.125 //layer=li \
 //thickness=0.1 //x=22.32 //y=0.805 //x2=22.32 //y2=0.68
r60 (  15 29 ) resistor r=18.139 //w=0.187 //l=0.265 //layer=li \
 //thickness=0.1 //x=22.32 //y=0.805 //x2=22.32 //y2=1.07
r61 (  12 29 ) resistor r=3.57586 //w=0.17 //l=0.103078 //layer=li \
 //thickness=0.1 //x=21.435 //y=0.72 //x2=21.35 //y2=0.68
r62 (  12 29 ) resistor r=27.3797 //w=0.187 //l=0.4 //layer=li //thickness=0.1 \
 //x=21.435 //y=0.72 //x2=21.835 //y2=0.72
r63 (  11 29 ) resistor r=3.57586 //w=0.17 //l=0.103078 //layer=li \
 //thickness=0.1 //x=22.235 //y=0.72 //x2=22.32 //y2=0.68
r64 (  11 29 ) resistor r=27.3797 //w=0.187 //l=0.4 //layer=li //thickness=0.1 \
 //x=22.235 //y=0.72 //x2=21.835 //y2=0.72
r65 (  7 25 ) resistor r=5.4201 //w=0.17 //l=0.085 //layer=li //thickness=0.1 \
 //x=21.35 //y=1.26 //x2=21.35 //y2=1.175
r66 (  7 29 ) resistor r=10.2674 //w=0.187 //l=0.15 //layer=li //thickness=0.1 \
 //x=21.35 //y=1.26 //x2=21.35 //y2=1.41
r67 (  4 25 ) resistor r=5.4201 //w=0.17 //l=0.085 //layer=li //thickness=0.1 \
 //x=21.35 //y=1.09 //x2=21.35 //y2=1.175
r68 (  4 29 ) resistor r=1.36898 //w=0.187 //l=0.02 //layer=li //thickness=0.1 \
 //x=21.35 //y=1.09 //x2=21.35 //y2=1.07
r69 (  3 29 ) resistor r=3.57586 //w=0.17 //l=0.125 //layer=li //thickness=0.1 \
 //x=21.35 //y=0.805 //x2=21.35 //y2=0.68
r70 (  3 29 ) resistor r=18.139 //w=0.187 //l=0.265 //layer=li //thickness=0.1 \
 //x=21.35 //y=0.805 //x2=21.35 //y2=1.07
r71 (  2 28 ) resistor r=0.751729 //w=0.17 //l=0.085 //layer=li \
 //thickness=0.1 //x=20.385 //y=1.175 //x2=20.3 //y2=1.175
r72 (  1 25 ) resistor r=1.40859 //w=0.34 //l=0.085 //layer=li //thickness=0.1 \
 //x=21.265 //y=1.175 //x2=21.35 //y2=1.175
r73 (  1 2 ) resistor r=60.2353 //w=0.187 //l=0.88 //layer=li //thickness=0.1 \
 //x=21.265 //y=1.175 //x2=20.385 //y2=1.175
ends PM_DFFRNX1\%noxref_20

subckt PM_DFFRNX1\%noxref_21 ( 1 5 9 10 13 17 29 )
c50 ( 29 0 ) capacitor c=0.0637432f //x=23.62 //y=0.545
c51 ( 17 0 ) capacitor c=0.00722223f //x=25.695 //y=0.795
c52 ( 13 0 ) capacitor c=0.0149664f //x=25.61 //y=0.71
c53 ( 10 0 ) capacitor c=0.00687696f //x=24.725 //y=1.675
c54 ( 9 0 ) capacitor c=0.006761f //x=24.725 //y=0.795
c55 ( 5 0 ) capacitor c=0.0201208f //x=24.64 //y=1.76
c56 ( 1 0 ) capacitor c=0.00828748f //x=23.755 //y=1.675
r57 (  17 29 ) resistor r=3.57586 //w=0.17 //l=0.125 //layer=li \
 //thickness=0.1 //x=25.695 //y=0.795 //x2=25.695 //y2=0.67
r58 (  17 29 ) resistor r=18.139 //w=0.187 //l=0.265 //layer=li \
 //thickness=0.1 //x=25.695 //y=0.795 //x2=25.695 //y2=1.06
r59 (  14 29 ) resistor r=3.57586 //w=0.17 //l=0.103078 //layer=li \
 //thickness=0.1 //x=24.81 //y=0.71 //x2=24.725 //y2=0.67
r60 (  14 29 ) resistor r=27.3797 //w=0.187 //l=0.4 //layer=li //thickness=0.1 \
 //x=24.81 //y=0.71 //x2=25.21 //y2=0.71
r61 (  13 29 ) resistor r=3.57586 //w=0.17 //l=0.103078 //layer=li \
 //thickness=0.1 //x=25.61 //y=0.71 //x2=25.695 //y2=0.67
r62 (  13 29 ) resistor r=27.3797 //w=0.187 //l=0.4 //layer=li //thickness=0.1 \
 //x=25.61 //y=0.71 //x2=25.21 //y2=0.71
r63 (  10 29 ) resistor r=3.57586 //w=0.17 //l=0.125 //layer=li \
 //thickness=0.1 //x=24.725 //y=1.675 //x2=24.725 //y2=1.8
r64 (  10 29 ) resistor r=42.0963 //w=0.187 //l=0.615 //layer=li \
 //thickness=0.1 //x=24.725 //y=1.675 //x2=24.725 //y2=1.06
r65 (  9 29 ) resistor r=3.57586 //w=0.17 //l=0.125 //layer=li //thickness=0.1 \
 //x=24.725 //y=0.795 //x2=24.725 //y2=0.67
r66 (  9 29 ) resistor r=18.139 //w=0.187 //l=0.265 //layer=li //thickness=0.1 \
 //x=24.725 //y=0.795 //x2=24.725 //y2=1.06
r67 (  6 29 ) resistor r=3.57586 //w=0.17 //l=0.103078 //layer=li \
 //thickness=0.1 //x=23.84 //y=1.76 //x2=23.755 //y2=1.8
r68 (  6 29 ) resistor r=27.3797 //w=0.187 //l=0.4 //layer=li //thickness=0.1 \
 //x=23.84 //y=1.76 //x2=24.24 //y2=1.76
r69 (  5 29 ) resistor r=3.57586 //w=0.17 //l=0.103078 //layer=li \
 //thickness=0.1 //x=24.64 //y=1.76 //x2=24.725 //y2=1.8
r70 (  5 29 ) resistor r=27.3797 //w=0.187 //l=0.4 //layer=li //thickness=0.1 \
 //x=24.64 //y=1.76 //x2=24.24 //y2=1.76
r71 (  1 29 ) resistor r=3.57586 //w=0.17 //l=0.125 //layer=li //thickness=0.1 \
 //x=23.755 //y=1.675 //x2=23.755 //y2=1.8
r72 (  1 29 ) resistor r=42.0963 //w=0.187 //l=0.615 //layer=li \
 //thickness=0.1 //x=23.755 //y=1.675 //x2=23.755 //y2=1.06
ends PM_DFFRNX1\%noxref_21
