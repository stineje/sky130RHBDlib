// File: DFFRNX1.spi.pex
// Created: Thu Jan 22 07:04:01 2026
// Program "Calibre xRC"
// Version "v2023.2_27.15"
// Nominal Temperature: 30C
// Circuit Temperature: 30C
//
simulator lang=spectre
subckt PM_DFFRNX1\%noxref_1 ( 1 2 3 4 5 7 10 11 13 14 15 16 18 19 20 22 23 30 \
 32 35 38 44 47 50 53 54 56 57 58 60 62 64 65 72 75 84 89 97 105 122 131 135 \
 136 137 138 139 140 144 145 146 151 153 156 157 158 159 160 161 165 167 170 \
 171 176 177 182 191 194 196 197 198 )
c431 ( 194 0 ) capacitor c=0.00885916f //x=8.695 //y=1.095
c432 ( 191 0 ) capacitor c=0.0682508f //x=11.22 //y=4.88
c433 ( 182 0 ) capacitor c=0.0710579f //x=3.82 //y=4.88
c434 ( 177 0 ) capacitor c=0.0278202f //x=3.82 //y=2.095
c435 ( 176 0 ) capacitor c=0.0479324f //x=3.82 //y=2.26
c436 ( 171 0 ) capacitor c=0.0318956f //x=11.555 //y=1.39
c437 ( 170 0 ) capacitor c=0.0186809f //x=11.555 //y=1.045
c438 ( 167 0 ) capacitor c=0.0141821f //x=11.4 //y=1.545
c439 ( 165 0 ) capacitor c=0.0158553f //x=11.4 //y=0.89
c440 ( 161 0 ) capacitor c=0.0854195f //x=11.025 //y=2.095
c441 ( 160 0 ) capacitor c=0.0229235f //x=11.025 //y=1.7
c442 ( 159 0 ) capacitor c=0.0234359f //x=11.025 //y=1.39
c443 ( 158 0 ) capacitor c=0.0198759f //x=11.025 //y=1.045
c444 ( 157 0 ) capacitor c=0.0443175f //x=4.34 //y=1.44
c445 ( 156 0 ) capacitor c=0.0199703f //x=4.34 //y=1.095
c446 ( 153 0 ) capacitor c=0.0162526f //x=4.185 //y=1.595
c447 ( 151 0 ) capacitor c=0.0157807f //x=4.185 //y=0.94
c448 ( 146 0 ) capacitor c=0.0220935f //x=3.81 //y=1.75
c449 ( 145 0 ) capacitor c=0.0207489f //x=3.81 //y=1.44
c450 ( 144 0 ) capacitor c=0.0194091f //x=3.81 //y=1.095
c451 ( 140 0 ) capacitor c=0.110369f //x=11.56 //y=6.2
c452 ( 139 0 ) capacitor c=0.154619f //x=11.12 //y=6.2
c453 ( 138 0 ) capacitor c=0.159671f //x=4 //y=6.2
c454 ( 137 0 ) capacitor c=0.110208f //x=3.56 //y=6.2
c455 ( 131 0 ) capacitor c=8.13425e-19 //x=11.22 //y=4.88
c456 ( 122 0 ) capacitor c=7.85889e-19 //x=11.22 //y=2.26
c457 ( 105 0 ) capacitor c=0.0292634f //x=8.59 //y=5.56
c458 ( 97 0 ) capacitor c=0.029137f //x=7.71 //y=5.56
c459 ( 89 0 ) capacitor c=0.0278099f //x=6.83 //y=5.56
c460 ( 84 0 ) capacitor c=7.7417e-19 //x=3.82 //y=4.88
c461 ( 75 0 ) capacitor c=0.00101179f //x=3.82 //y=2.26
c462 ( 72 0 ) capacitor c=5.96651e-19 //x=11.22 //y=3.51
c463 ( 65 0 ) capacitor c=0.057578f //x=9.535 //y=3.51
c464 ( 64 0 ) capacitor c=0.0258251f //x=11.06 //y=3.51
c465 ( 62 0 ) capacitor c=0.00710937f //x=6.63 //y=3.495
c466 ( 60 0 ) capacitor c=0.0381622f //x=6.03 //y=3.51
c467 ( 58 0 ) capacitor c=0.0188644f //x=4.78 //y=3.5
c468 ( 57 0 ) capacitor c=0.00331832f //x=3.98 //y=3.51
c469 ( 56 0 ) capacitor c=0.00718343f //x=4.18 //y=3.51
c470 ( 54 0 ) capacitor c=0.0268056f //x=11.222 //y=4.74
c471 ( 53 0 ) capacitor c=0.00611114f //x=11.22 //y=4.88
c472 ( 50 0 ) capacitor c=0.00463527f //x=11.22 //y=2.26
c473 ( 47 0 ) capacitor c=0.0161834f //x=11.22 //y=3.51
c474 ( 44 0 ) capacitor c=0.0170515f //x=9.37 //y=3.51
c475 ( 38 0 ) capacitor c=0.00112339f //x=8.59 //y=5.335
c476 ( 35 0 ) capacitor c=0.00824259f //x=7.71 //y=5.335
c477 ( 32 0 ) capacitor c=0.0111234f //x=6.832 //y=5.335
c478 ( 30 0 ) capacitor c=0.0148558f //x=3.82 //y=3.51
c479 ( 23 0 ) capacitor c=0.0133355f //x=11.22 //y=3.67
c480 ( 22 0 ) capacitor c=0.0282347f //x=11.22 //y=3.35
c481 ( 20 0 ) capacitor c=0.0423878f //x=9.37 //y=5.25
c482 ( 19 0 ) capacitor c=0.0130115f //x=9.37 //y=3.67
c483 ( 18 0 ) capacitor c=0.0411393f //x=9.37 //y=3.35
c484 ( 16 0 ) capacitor c=0.00493487f //x=8.97 //y=1.845
c485 ( 15 0 ) capacitor c=0.012936f //x=9.285 //y=1.845
c486 ( 14 0 ) capacitor c=0.0136149f //x=8.885 //y=1.76
c487 ( 13 0 ) capacitor c=0.0112307f //x=8.885 //y=1.305
c488 ( 11 0 ) capacitor c=0.023884f //x=9.285 //y=5.335
c489 ( 10 0 ) capacitor c=0.00906713f //x=8.59 //y=5.56
c490 ( 7 0 ) capacitor c=0.019596f //x=8.475 //y=5.335
c491 ( 5 0 ) capacitor c=0.0153086f //x=7.59 //y=5.335
c492 ( 4 0 ) capacitor c=0.0286297f //x=3.82 //y=4.75
c493 ( 3 0 ) capacitor c=0.0128763f //x=3.82 //y=3.67
c494 ( 2 0 ) capacitor c=0.0274817f //x=3.82 //y=3.35
c495 ( 1 0 ) capacitor c=0.00685053f //x=3.82 //y=2.375
r496 (  189 191 ) resistor r=20.6867 //w=0.233 //l=0.1 //layer=ply \
 //thickness=0.18 //x=11.12 //y=4.88 //x2=11.22 //y2=4.88
r497 (  176 177 ) resistor r=52.7279 //w=0.214 //l=0.165 //layer=ply \
 //thickness=0.18 //x=3.82 //y=2.26 //x2=3.82 //y2=2.095
r498 (  172 191 ) resistor r=70.3348 //w=0.233 //l=0.414367 //layer=ply \
 //thickness=0.18 //x=11.56 //y=5.045 //x2=11.22 //y2=4.88
r499 (  171 193 ) resistor r=45.1352 //w=0.168 //l=0.173853 //layer=ply \
 //thickness=0.18 //x=11.555 //y=1.39 //x2=11.515 //y2=1.545
r500 (  170 192 ) resistor r=45.1352 //w=0.168 //l=0.173853 //layer=ply \
 //thickness=0.18 //x=11.555 //y=1.045 //x2=11.515 //y2=0.89
r501 (  170 171 ) resistor r=176.904 //w=0.094 //l=0.345 //layer=ply \
 //thickness=0.18 //x=11.555 //y=1.045 //x2=11.555 //y2=1.39
r502 (  168 188 ) resistor r=10.701 //w=0.21 //l=0.115 //layer=ply \
 //thickness=0.18 //x=11.18 //y=1.545 //x2=11.065 //y2=1.545
r503 (  167 193 ) resistor r=5.52526 //w=0.168 //l=0.115 //layer=ply \
 //thickness=0.18 //x=11.4 //y=1.545 //x2=11.515 //y2=1.545
r504 (  166 187 ) resistor r=5.52526 //w=0.168 //l=0.115 //layer=ply \
 //thickness=0.18 //x=11.18 //y=0.89 //x2=11.065 //y2=0.89
r505 (  165 192 ) resistor r=5.52526 //w=0.168 //l=0.115 //layer=ply \
 //thickness=0.18 //x=11.4 //y=0.89 //x2=11.515 //y2=0.89
r506 (  165 166 ) resistor r=112.809 //w=0.094 //l=0.22 //layer=ply \
 //thickness=0.18 //x=11.4 //y=0.89 //x2=11.18 //y2=0.89
r507 (  162 189 ) resistor r=13.0941 //w=0.233 //l=0.165 //layer=ply \
 //thickness=0.18 //x=11.12 //y=5.045 //x2=11.12 //y2=4.88
r508 (  161 186 ) resistor r=34.8111 //w=0.27 //l=0.264953 //layer=ply \
 //thickness=0.18 //x=11.025 //y=2.095 //x2=11.22 //y2=2.26
r509 (  160 188 ) resistor r=39.5823 //w=0.21 //l=0.173853 //layer=ply \
 //thickness=0.18 //x=11.025 //y=1.7 //x2=11.065 //y2=1.545
r510 (  160 161 ) resistor r=202.543 //w=0.094 //l=0.395 //layer=ply \
 //thickness=0.18 //x=11.025 //y=1.7 //x2=11.025 //y2=2.095
r511 (  159 188 ) resistor r=39.5823 //w=0.21 //l=0.173853 //layer=ply \
 //thickness=0.18 //x=11.025 //y=1.39 //x2=11.065 //y2=1.545
r512 (  158 187 ) resistor r=45.1352 //w=0.168 //l=0.173853 //layer=ply \
 //thickness=0.18 //x=11.025 //y=1.045 //x2=11.065 //y2=0.89
r513 (  158 159 ) resistor r=176.904 //w=0.094 //l=0.345 //layer=ply \
 //thickness=0.18 //x=11.025 //y=1.045 //x2=11.025 //y2=1.39
r514 (  157 184 ) resistor r=45.1352 //w=0.168 //l=0.173853 //layer=ply \
 //thickness=0.18 //x=4.34 //y=1.44 //x2=4.3 //y2=1.595
r515 (  156 183 ) resistor r=45.1352 //w=0.168 //l=0.173853 //layer=ply \
 //thickness=0.18 //x=4.34 //y=1.095 //x2=4.3 //y2=0.94
r516 (  156 157 ) resistor r=176.904 //w=0.094 //l=0.345 //layer=ply \
 //thickness=0.18 //x=4.34 //y=1.095 //x2=4.34 //y2=1.44
r517 (  154 180 ) resistor r=10.701 //w=0.21 //l=0.115 //layer=ply \
 //thickness=0.18 //x=3.965 //y=1.595 //x2=3.85 //y2=1.595
r518 (  153 184 ) resistor r=5.52526 //w=0.168 //l=0.115 //layer=ply \
 //thickness=0.18 //x=4.185 //y=1.595 //x2=4.3 //y2=1.595
r519 (  152 179 ) resistor r=5.52526 //w=0.168 //l=0.115 //layer=ply \
 //thickness=0.18 //x=3.965 //y=0.94 //x2=3.85 //y2=0.94
r520 (  151 183 ) resistor r=5.52526 //w=0.168 //l=0.115 //layer=ply \
 //thickness=0.18 //x=4.185 //y=0.94 //x2=4.3 //y2=0.94
r521 (  151 152 ) resistor r=112.809 //w=0.094 //l=0.22 //layer=ply \
 //thickness=0.18 //x=4.185 //y=0.94 //x2=3.965 //y2=0.94
r522 (  148 182 ) resistor r=37.236 //w=0.233 //l=0.249199 //layer=ply \
 //thickness=0.18 //x=4 //y=5.045 //x2=3.82 //y2=4.88
r523 (  146 180 ) resistor r=39.5823 //w=0.21 //l=0.173853 //layer=ply \
 //thickness=0.18 //x=3.81 //y=1.75 //x2=3.85 //y2=1.595
r524 (  146 177 ) resistor r=176.904 //w=0.094 //l=0.345 //layer=ply \
 //thickness=0.18 //x=3.81 //y=1.75 //x2=3.81 //y2=2.095
r525 (  145 180 ) resistor r=39.5823 //w=0.21 //l=0.173853 //layer=ply \
 //thickness=0.18 //x=3.81 //y=1.44 //x2=3.85 //y2=1.595
r526 (  144 179 ) resistor r=45.1352 //w=0.168 //l=0.173853 //layer=ply \
 //thickness=0.18 //x=3.81 //y=1.095 //x2=3.85 //y2=0.94
r527 (  144 145 ) resistor r=176.904 //w=0.094 //l=0.345 //layer=ply \
 //thickness=0.18 //x=3.81 //y=1.095 //x2=3.81 //y2=1.44
r528 (  141 182 ) resistor r=53.7854 //w=0.233 //l=0.332415 //layer=ply \
 //thickness=0.18 //x=3.56 //y=5.045 //x2=3.82 //y2=4.88
r529 (  140 172 ) resistor r=592.245 //w=0.094 //l=1.155 //layer=ply \
 //thickness=0.18 //x=11.56 //y=6.2 //x2=11.56 //y2=5.045
r530 (  139 162 ) resistor r=592.245 //w=0.094 //l=1.155 //layer=ply \
 //thickness=0.18 //x=11.12 //y=6.2 //x2=11.12 //y2=5.045
r531 (  138 148 ) resistor r=592.245 //w=0.094 //l=1.155 //layer=ply \
 //thickness=0.18 //x=4 //y=6.2 //x2=4 //y2=5.045
r532 (  137 141 ) resistor r=592.245 //w=0.094 //l=1.155 //layer=ply \
 //thickness=0.18 //x=3.56 //y=6.2 //x2=3.56 //y2=5.045
r533 (  136 167 ) resistor r=56.4043 //w=0.094 //l=0.11 //layer=ply \
 //thickness=0.18 //x=11.29 //y=1.545 //x2=11.4 //y2=1.545
r534 (  136 168 ) resistor r=56.4043 //w=0.094 //l=0.11 //layer=ply \
 //thickness=0.18 //x=11.29 //y=1.545 //x2=11.18 //y2=1.545
r535 (  135 153 ) resistor r=56.4043 //w=0.094 //l=0.11 //layer=ply \
 //thickness=0.18 //x=4.075 //y=1.595 //x2=4.185 //y2=1.595
r536 (  135 154 ) resistor r=56.4043 //w=0.094 //l=0.11 //layer=ply \
 //thickness=0.18 //x=4.075 //y=1.595 //x2=3.965 //y2=1.595
r537 (  131 191 ) resistor r=152 //w=0.17 //l=0.17 //layer=licon //count=1 \
 //x=11.22 //y=4.88 //x2=11.22 //y2=4.88
r538 (  122 186 ) resistor r=152 //w=0.17 //l=0.17 //layer=licon //count=1 \
 //x=11.22 //y=2.26 //x2=11.22 //y2=2.26
r539 (  105 198 ) resistor r=23.615 //w=0.187 //l=0.345 //layer=li \
 //thickness=0.1 //x=8.59 //y=5.56 //x2=8.59 //y2=5.905
r540 (  97 197 ) resistor r=23.615 //w=0.187 //l=0.345 //layer=li \
 //thickness=0.1 //x=7.71 //y=5.56 //x2=7.71 //y2=5.905
r541 (  89 196 ) resistor r=23.615 //w=0.187 //l=0.345 //layer=li \
 //thickness=0.1 //x=6.83 //y=5.56 //x2=6.83 //y2=5.905
r542 (  84 182 ) resistor r=152 //w=0.17 //l=0.17 //layer=licon //count=1 \
 //x=3.82 //y=4.88 //x2=3.82 //y2=4.88
r543 (  75 176 ) resistor r=152 //w=0.17 //l=0.17 //layer=licon //count=1 \
 //x=3.82 //y=2.26 //x2=3.82 //y2=2.26
r544 (  65 70 ) resistor r=0.108234 //w=0.187 //l=0.16 //layer=m2 \
 //thickness=0.36 //x=9.535 //y=3.51 //x2=9.375 //y2=3.51
r545 (  64 72 ) resistor r=0.10734 //w=0.281 //l=0.16 //layer=m2 \
 //thickness=0.36 //x=11.06 //y=3.51 //x2=11.22 //y2=3.51
r546 (  64 65 ) resistor r=1.45515 //w=0.131 //l=1.525 //layer=m2 \
 //thickness=0.36 //x=11.06 //y=3.51 //x2=9.535 //y2=3.51
r547 (  62 70 ) resistor r=1.83617 //w=0.187 //l=2.75249 //layer=m2 \
 //thickness=0.36 //x=6.63 //y=3.495 //x2=9.375 //y2=3.51
r548 (  62 63 ) resistor r=0.410305 //w=0.131 //l=0.43 //layer=m2 \
 //thickness=0.36 //x=6.63 //y=3.495 //x2=6.2 //y2=3.495
r549 (  60 63 ) resistor r=0.125 //w=0.17 //l=0.177341 //layer=m2 \
 //thickness=0.36 //x=6.03 //y=3.51 //x2=6.2 //y2=3.495
r550 (  60 61 ) resistor r=0.949427 //w=0.131 //l=0.995 //layer=m2 \
 //thickness=0.36 //x=6.03 //y=3.51 //x2=5.035 //y2=3.51
r551 (  58 61 ) resistor r=0.1875 //w=0.17 //l=0.259952 //layer=m2 \
 //thickness=0.36 //x=4.78 //y=3.5 //x2=5.035 //y2=3.51
r552 (  58 59 ) resistor r=0.410305 //w=0.131 //l=0.43 //layer=m2 \
 //thickness=0.36 //x=4.78 //y=3.5 //x2=4.35 //y2=3.5
r553 (  57 67 ) resistor r=0.10734 //w=0.281 //l=0.16 //layer=m2 \
 //thickness=0.36 //x=3.98 //y=3.51 //x2=3.82 //y2=3.51
r554 (  56 59 ) resistor r=0.125 //w=0.17 //l=0.174929 //layer=m2 \
 //thickness=0.36 //x=4.18 //y=3.51 //x2=4.35 //y2=3.5
r555 (  56 57 ) resistor r=0.19084 //w=0.131 //l=0.2 //layer=m2 \
 //thickness=0.36 //x=4.18 //y=3.51 //x2=3.98 //y2=3.51
r556 (  53 131 ) resistor r=9.3 //w=0.17 //l=0.17 //layer=mcon //count=1 \
 //x=11.22 //y=4.88 //x2=11.22 //y2=4.88
r557 (  53 54 ) resistor r=0.103207 //w=0.196 //l=0.14 //layer=m1 \
 //thickness=0.36 //x=11.222 //y=4.88 //x2=11.222 //y2=4.74
r558 (  50 122 ) resistor r=9.3 //w=0.17 //l=0.17 //layer=mcon //count=1 \
 //x=11.22 //y=2.26 //x2=11.22 //y2=2.26
r559 (  47 72 ) resistor r=4.5 //w=0.15 //l=0.15 //layer=via1 //count=1 \
 //x=11.22 //y=3.51 //x2=11.22 //y2=3.51
r560 (  44 70 ) resistor r=4.5 //w=0.15 //l=0.15 //layer=via1 //count=1 \
 //x=9.375 //y=3.51 //x2=9.375 //y2=3.51
r561 (  42 194 ) resistor r=9.3 //w=0.17 //l=0.17 //layer=mcon //count=1 \
 //x=8.885 //y=1.19 //x2=8.885 //y2=1.19
r562 (  40 105 ) resistor r=9.3 //w=0.17 //l=0.17 //layer=mcon //count=1 \
 //x=8.59 //y=5.56 //x2=8.59 //y2=5.56
r563 (  37 97 ) resistor r=9.3 //w=0.17 //l=0.17 //layer=mcon //count=1 \
 //x=7.71 //y=5.56 //x2=7.71 //y2=5.56
r564 (  35 37 ) resistor r=0.121228 //w=0.232 //l=0.225 //layer=m1 \
 //thickness=0.36 //x=7.71 //y=5.335 //x2=7.71 //y2=5.56
r565 (  34 89 ) resistor r=9.3 //w=0.17 //l=0.17 //layer=mcon //count=1 \
 //x=6.83 //y=5.56 //x2=6.83 //y2=5.56
r566 (  32 34 ) resistor r=0.129608 //w=0.217 //l=0.225 //layer=m1 \
 //thickness=0.36 //x=6.832 //y=5.335 //x2=6.832 //y2=5.56
r567 (  30 67 ) resistor r=4.5 //w=0.15 //l=0.15 //layer=via1 //count=1 \
 //x=3.82 //y=3.51 //x2=3.82 //y2=3.51
r568 (  28 84 ) resistor r=9.3 //w=0.17 //l=0.17 //layer=mcon //count=1 \
 //x=3.82 //y=4.88 //x2=3.82 //y2=4.88
r569 (  26 75 ) resistor r=9.3 //w=0.17 //l=0.17 //layer=mcon //count=1 \
 //x=3.82 //y=2.26 //x2=3.82 //y2=2.26
r570 (  23 47 ) resistor r=0.0911593 //w=0.376 //l=0.184608 //layer=m1 \
 //thickness=0.36 //x=11.22 //y=3.67 //x2=11.167 //y2=3.51
r571 (  23 54 ) resistor r=1.02099 //w=0.131 //l=1.07 //layer=m1 \
 //thickness=0.36 //x=11.22 //y=3.67 //x2=11.22 //y2=4.74
r572 (  22 47 ) resistor r=0.0911593 //w=0.376 //l=0.184608 //layer=m1 \
 //thickness=0.36 //x=11.22 //y=3.35 //x2=11.167 //y2=3.51
r573 (  21 50 ) resistor r=0.0933015 //w=0.201 //l=0.125 //layer=m1 \
 //thickness=0.36 //x=11.22 //y=2.385 //x2=11.22 //y2=2.26
r574 (  21 22 ) resistor r=0.920802 //w=0.131 //l=0.965 //layer=m1 \
 //thickness=0.36 //x=11.22 //y=2.385 //x2=11.22 //y2=3.35
r575 (  19 44 ) resistor r=0.0910802 //w=0.374 //l=0.185472 //layer=m1 \
 //thickness=0.36 //x=9.37 //y=3.67 //x2=9.425 //y2=3.51
r576 (  19 20 ) resistor r=1.50763 //w=0.131 //l=1.58 //layer=m1 \
 //thickness=0.36 //x=9.37 //y=3.67 //x2=9.37 //y2=5.25
r577 (  18 44 ) resistor r=0.0910802 //w=0.374 //l=0.185472 //layer=m1 \
 //thickness=0.36 //x=9.37 //y=3.35 //x2=9.425 //y2=3.51
r578 (  17 18 ) resistor r=1.35496 //w=0.131 //l=1.42 //layer=m1 \
 //thickness=0.36 //x=9.37 //y=1.93 //x2=9.37 //y2=3.35
r579 (  15 17 ) resistor r=0.0698411 //w=0.17 //l=0.120208 //layer=m1 \
 //thickness=0.36 //x=9.285 //y=1.845 //x2=9.37 //y2=1.93
r580 (  15 16 ) resistor r=0.300573 //w=0.131 //l=0.315 //layer=m1 \
 //thickness=0.36 //x=9.285 //y=1.845 //x2=8.97 //y2=1.845
r581 (  14 16 ) resistor r=0.0698411 //w=0.17 //l=0.120208 //layer=m1 \
 //thickness=0.36 //x=8.885 //y=1.76 //x2=8.97 //y2=1.845
r582 (  13 42 ) resistor r=0.0717383 //w=0.224 //l=0.115 //layer=m1 \
 //thickness=0.36 //x=8.885 //y=1.305 //x2=8.885 //y2=1.19
r583 (  13 14 ) resistor r=0.43416 //w=0.131 //l=0.455 //layer=m1 \
 //thickness=0.36 //x=8.885 //y=1.305 //x2=8.885 //y2=1.76
r584 (  12 38 ) resistor r=0.0675342 //w=0.23 //l=0.115 //layer=m1 \
 //thickness=0.36 //x=8.705 //y=5.335 //x2=8.59 //y2=5.335
r585 (  11 20 ) resistor r=0.0698411 //w=0.17 //l=0.120208 //layer=m1 \
 //thickness=0.36 //x=9.285 //y=5.335 //x2=9.37 //y2=5.25
r586 (  11 12 ) resistor r=0.553435 //w=0.131 //l=0.58 //layer=m1 \
 //thickness=0.36 //x=9.285 //y=5.335 //x2=8.705 //y2=5.335
r587 (  10 40 ) resistor r=0.00118313 //w=0.23 //layer=m1 //thickness=0.36 \
 //x=8.59 //y=5.56 //x2=8.59 //y2=5.56
r588 (  9 38 ) resistor r=0.002872 //w=0.34 //l=0.085 //layer=m1 \
 //thickness=0.36 //x=8.59 //y=5.42 //x2=8.59 //y2=5.335
r589 (  9 10 ) resistor r=0.091623 //w=0.191 //l=0.14 //layer=m1 \
 //thickness=0.36 //x=8.59 //y=5.42 //x2=8.59 //y2=5.56
r590 (  8 35 ) resistor r=0.0262263 //w=0.232 //l=0.12 //layer=m1 \
 //thickness=0.36 //x=7.83 //y=5.335 //x2=7.71 //y2=5.335
r591 (  7 38 ) resistor r=0.0675342 //w=0.23 //l=0.115 //layer=m1 \
 //thickness=0.36 //x=8.475 //y=5.335 //x2=8.59 //y2=5.335
r592 (  7 8 ) resistor r=0.615458 //w=0.131 //l=0.645 //layer=m1 \
 //thickness=0.36 //x=8.475 //y=5.335 //x2=7.83 //y2=5.335
r593 (  6 32 ) resistor r=0.0222262 //w=0.217 //l=0.118 //layer=m1 \
 //thickness=0.36 //x=6.95 //y=5.335 //x2=6.832 //y2=5.335
r594 (  5 35 ) resistor r=0.0262263 //w=0.232 //l=0.12 //layer=m1 \
 //thickness=0.36 //x=7.59 //y=5.335 //x2=7.71 //y2=5.335
r595 (  5 6 ) resistor r=0.610687 //w=0.131 //l=0.64 //layer=m1 \
 //thickness=0.36 //x=7.59 //y=5.335 //x2=6.95 //y2=5.335
r596 (  4 28 ) resistor r=0.0801089 //w=0.224 //l=0.13 //layer=m1 \
 //thickness=0.36 //x=3.82 //y=4.75 //x2=3.82 //y2=4.88
r597 (  3 30 ) resistor r=0.0911593 //w=0.376 //l=0.184174 //layer=m1 \
 //thickness=0.36 //x=3.82 //y=3.67 //x2=3.872 //y2=3.51
r598 (  3 4 ) resistor r=1.03053 //w=0.131 //l=1.08 //layer=m1 \
 //thickness=0.36 //x=3.82 //y=3.67 //x2=3.82 //y2=4.75
r599 (  2 30 ) resistor r=0.0911593 //w=0.376 //l=0.184174 //layer=m1 \
 //thickness=0.36 //x=3.82 //y=3.35 //x2=3.872 //y2=3.51
r600 (  1 26 ) resistor r=0.0719237 //w=0.222 //l=0.115 //layer=m1 \
 //thickness=0.36 //x=3.82 //y=2.375 //x2=3.82 //y2=2.26
r601 (  1 2 ) resistor r=0.930344 //w=0.131 //l=0.975 //layer=m1 \
 //thickness=0.36 //x=3.82 //y=2.375 //x2=3.82 //y2=3.35
ends PM_DFFRNX1\%noxref_1

subckt PM_DFFRNX1\%noxref_2 ( 3 8 9 11 12 14 15 16 17 18 19 20 23 24 27 29 32 \
 36 48 50 51 54 62 79 88 92 93 94 95 96 97 98 99 101 107 108 109 110 122 124 \
 125 )
c272 ( 122 0 ) capacitor c=0.00878249f //x=12.07 //y=1.085
c273 ( 110 0 ) capacitor c=0.0612936f //x=14.825 //y=4.97
c274 ( 109 0 ) capacitor c=0.0376642f //x=15.115 //y=4.97
c275 ( 108 0 ) capacitor c=0.0346489f //x=14.78 //y=1.4
c276 ( 107 0 ) capacitor c=0.018692f //x=14.78 //y=1.055
c277 ( 101 0 ) capacitor c=0.0137077f //x=14.625 //y=1.555
c278 ( 99 0 ) capacitor c=0.0158585f //x=14.625 //y=0.9
c279 ( 98 0 ) capacitor c=0.101012f //x=14.25 //y=2.095
c280 ( 97 0 ) capacitor c=0.0229444f //x=14.25 //y=1.71
c281 ( 96 0 ) capacitor c=0.0234359f //x=14.25 //y=1.4
c282 ( 95 0 ) capacitor c=0.019815f //x=14.25 //y=1.055
c283 ( 94 0 ) capacitor c=0.110208f //x=15.19 //y=6.2
c284 ( 93 0 ) capacitor c=0.158957f //x=14.75 //y=6.2
c285 ( 88 0 ) capacitor c=0.0014751f //x=14.55 //y=4.88
c286 ( 79 0 ) capacitor c=0.0012618f //x=14.55 //y=2.26
c287 ( 62 0 ) capacitor c=0.0322017f //x=12.22 //y=5.56
c288 ( 54 0 ) capacitor c=0.0291938f //x=11.34 //y=5.56
c289 ( 51 0 ) capacitor c=0.0259909f //x=14.395 //y=3.515
c290 ( 50 0 ) capacitor c=6.22456e-19 //x=14.555 //y=3.515
c291 ( 48 0 ) capacitor c=9.69366e-19 //x=12.86 //y=3.515
c292 ( 36 0 ) capacitor c=0.0170693f //x=14.55 //y=3.51
c293 ( 32 0 ) capacitor c=0.016938f //x=12.7 //y=3.51
c294 ( 29 0 ) capacitor c=0.0112415f //x=12.26 //y=1.18
c295 ( 27 0 ) capacitor c=5.78613e-19 //x=12.22 //y=5.56
c296 ( 24 0 ) capacitor c=0.010659f //x=12.22 //y=5.38
c297 ( 23 0 ) capacitor c=0.00926978f //x=11.34 //y=5.56
c298 ( 20 0 ) capacitor c=0.038207f //x=14.55 //y=4.755
c299 ( 19 0 ) capacitor c=0.0145934f //x=14.55 //y=3.675
c300 ( 18 0 ) capacitor c=0.0328082f //x=14.55 //y=3.355
c301 ( 17 0 ) capacitor c=0.00495287f //x=14.55 //y=2.375
c302 ( 16 0 ) capacitor c=0.0418029f //x=12.7 //y=5.295
c303 ( 15 0 ) capacitor c=0.0134342f //x=12.7 //y=3.675
c304 ( 14 0 ) capacitor c=0.0413556f //x=12.7 //y=3.355
c305 ( 12 0 ) capacitor c=0.00466468f //x=12.345 //y=1.835
c306 ( 11 0 ) capacitor c=0.0120653f //x=12.615 //y=1.835
c307 ( 9 0 ) capacitor c=0.0116495f //x=12.615 //y=5.38
c308 ( 8 0 ) capacitor c=0.0134844f //x=12.26 //y=1.75
c309 ( 3 0 ) capacitor c=0.013452f //x=12.105 //y=5.38
r310 (  109 111 ) resistor r=26.9307 //w=0.15 //l=0.106066 //layer=ply \
 //thickness=0.18 //x=15.115 //y=4.97 //x2=15.19 //y2=5.045
r311 (  109 110 ) resistor r=148.702 //w=0.094 //l=0.29 //layer=ply \
 //thickness=0.18 //x=15.115 //y=4.97 //x2=14.825 //y2=4.97
r312 (  108 121 ) resistor r=45.1352 //w=0.168 //l=0.173853 //layer=ply \
 //thickness=0.18 //x=14.78 //y=1.4 //x2=14.74 //y2=1.555
r313 (  107 120 ) resistor r=45.1352 //w=0.168 //l=0.173853 //layer=ply \
 //thickness=0.18 //x=14.78 //y=1.055 //x2=14.74 //y2=0.9
r314 (  107 108 ) resistor r=176.904 //w=0.094 //l=0.345 //layer=ply \
 //thickness=0.18 //x=14.78 //y=1.055 //x2=14.78 //y2=1.4
r315 (  104 110 ) resistor r=22.7971 //w=0.269 //l=0.106066 //layer=ply \
 //thickness=0.18 //x=14.75 //y=5.045 //x2=14.825 //y2=4.97
r316 (  104 119 ) resistor r=35.8364 //w=0.269 //l=0.270185 //layer=ply \
 //thickness=0.18 //x=14.75 //y=5.045 //x2=14.55 //y2=4.88
r317 (  102 115 ) resistor r=10.701 //w=0.21 //l=0.115 //layer=ply \
 //thickness=0.18 //x=14.405 //y=1.555 //x2=14.29 //y2=1.555
r318 (  101 121 ) resistor r=5.52526 //w=0.168 //l=0.115 //layer=ply \
 //thickness=0.18 //x=14.625 //y=1.555 //x2=14.74 //y2=1.555
r319 (  100 114 ) resistor r=5.52526 //w=0.168 //l=0.115 //layer=ply \
 //thickness=0.18 //x=14.405 //y=0.9 //x2=14.29 //y2=0.9
r320 (  99 120 ) resistor r=5.52526 //w=0.168 //l=0.115 //layer=ply \
 //thickness=0.18 //x=14.625 //y=0.9 //x2=14.74 //y2=0.9
r321 (  99 100 ) resistor r=112.809 //w=0.094 //l=0.22 //layer=ply \
 //thickness=0.18 //x=14.625 //y=0.9 //x2=14.405 //y2=0.9
r322 (  98 117 ) resistor r=58.7805 //w=0.246 //l=0.373497 //layer=ply \
 //thickness=0.18 //x=14.25 //y=2.095 //x2=14.55 //y2=2.26
r323 (  97 115 ) resistor r=39.5823 //w=0.21 //l=0.173853 //layer=ply \
 //thickness=0.18 //x=14.25 //y=1.71 //x2=14.29 //y2=1.555
r324 (  97 98 ) resistor r=197.415 //w=0.094 //l=0.385 //layer=ply \
 //thickness=0.18 //x=14.25 //y=1.71 //x2=14.25 //y2=2.095
r325 (  96 115 ) resistor r=39.5823 //w=0.21 //l=0.173853 //layer=ply \
 //thickness=0.18 //x=14.25 //y=1.4 //x2=14.29 //y2=1.555
r326 (  95 114 ) resistor r=45.1352 //w=0.168 //l=0.173853 //layer=ply \
 //thickness=0.18 //x=14.25 //y=1.055 //x2=14.29 //y2=0.9
r327 (  95 96 ) resistor r=176.904 //w=0.094 //l=0.345 //layer=ply \
 //thickness=0.18 //x=14.25 //y=1.055 //x2=14.25 //y2=1.4
r328 (  94 111 ) resistor r=592.245 //w=0.094 //l=1.155 //layer=ply \
 //thickness=0.18 //x=15.19 //y=6.2 //x2=15.19 //y2=5.045
r329 (  93 104 ) resistor r=592.245 //w=0.094 //l=1.155 //layer=ply \
 //thickness=0.18 //x=14.75 //y=6.2 //x2=14.75 //y2=5.045
r330 (  92 101 ) resistor r=56.4043 //w=0.094 //l=0.11 //layer=ply \
 //thickness=0.18 //x=14.515 //y=1.555 //x2=14.625 //y2=1.555
r331 (  92 102 ) resistor r=56.4043 //w=0.094 //l=0.11 //layer=ply \
 //thickness=0.18 //x=14.515 //y=1.555 //x2=14.405 //y2=1.555
r332 (  88 119 ) resistor r=152 //w=0.17 //l=0.17 //layer=licon //count=1 \
 //x=14.55 //y=4.88 //x2=14.55 //y2=4.88
r333 (  79 117 ) resistor r=152 //w=0.17 //l=0.17 //layer=licon //count=1 \
 //x=14.55 //y=2.26 //x2=14.55 //y2=2.26
r334 (  62 125 ) resistor r=23.615 //w=0.187 //l=0.345 //layer=li \
 //thickness=0.1 //x=12.22 //y=5.56 //x2=12.22 //y2=5.905
r335 (  54 124 ) resistor r=23.615 //w=0.187 //l=0.345 //layer=li \
 //thickness=0.1 //x=11.34 //y=5.56 //x2=11.34 //y2=5.905
r336 (  50 51 ) resistor r=0.10734 //w=0.281 //l=0.16 //layer=m2 \
 //thickness=0.36 //x=14.555 //y=3.515 //x2=14.395 //y2=3.515
r337 (  48 51 ) resistor r=1.46469 //w=0.131 //l=1.535 //layer=m2 \
 //thickness=0.36 //x=12.86 //y=3.51 //x2=14.395 //y2=3.51
r338 (  46 48 ) resistor r=0.10734 //w=0.281 //l=0.16 //layer=m2 \
 //thickness=0.36 //x=12.7 //y=3.515 //x2=12.86 //y2=3.515
r339 (  42 88 ) resistor r=9.3 //w=0.17 //l=0.17 //layer=mcon //count=1 \
 //x=14.55 //y=4.88 //x2=14.55 //y2=4.88
r340 (  40 79 ) resistor r=9.3 //w=0.17 //l=0.17 //layer=mcon //count=1 \
 //x=14.55 //y=2.26 //x2=14.55 //y2=2.26
r341 (  38 50 ) resistor r=4.5 //w=0.15 //l=0.15 //layer=via1 //count=1 \
 //x=14.555 //y=3.515 //x2=14.555 //y2=3.515
r342 (  36 38 ) resistor r=0.00164908 //w=0.379 //l=0.005 //layer=m1 \
 //thickness=0.36 //x=14.5 //y=3.51 //x2=14.5 //y2=3.515
r343 (  34 46 ) resistor r=4.5 //w=0.15 //l=0.15 //layer=via1 //count=1 \
 //x=12.7 //y=3.515 //x2=12.7 //y2=3.515
r344 (  32 34 ) resistor r=0.00166223 //w=0.376 //l=0.005 //layer=m1 \
 //thickness=0.36 //x=12.752 //y=3.51 //x2=12.752 //y2=3.515
r345 (  29 122 ) resistor r=9.3 //w=0.17 //l=0.17 //layer=mcon //count=1 \
 //x=12.26 //y=1.18 //x2=12.26 //y2=1.18
r346 (  27 62 ) resistor r=9.3 //w=0.17 //l=0.17 //layer=mcon //count=1 \
 //x=12.22 //y=5.56 //x2=12.22 //y2=5.56
r347 (  24 27 ) resistor r=0.117801 //w=0.191 //l=0.18 //layer=m1 \
 //thickness=0.36 //x=12.22 //y=5.38 //x2=12.22 //y2=5.56
r348 (  23 54 ) resistor r=9.3 //w=0.17 //l=0.17 //layer=mcon //count=1 \
 //x=11.34 //y=5.56 //x2=11.34 //y2=5.56
r349 (  21 23 ) resistor r=0.10274 //w=0.219 //l=0.18 //layer=m1 \
 //thickness=0.36 //x=11.34 //y=5.38 //x2=11.34 //y2=5.56
r350 (  20 42 ) resistor r=0.0760407 //w=0.238 //l=0.125 //layer=m1 \
 //thickness=0.36 //x=14.55 //y=4.755 //x2=14.55 //y2=4.88
r351 (  19 38 ) resistor r=0.0912814 //w=0.379 //l=0.183303 //layer=m1 \
 //thickness=0.36 //x=14.55 //y=3.675 //x2=14.5 //y2=3.515
r352 (  19 20 ) resistor r=1.03053 //w=0.131 //l=1.08 //layer=m1 \
 //thickness=0.36 //x=14.55 //y=3.675 //x2=14.55 //y2=4.755
r353 (  18 36 ) resistor r=0.0896323 //w=0.379 //l=0.178255 //layer=m1 \
 //thickness=0.36 //x=14.55 //y=3.355 //x2=14.5 //y2=3.51
r354 (  17 40 ) resistor r=0.0719237 //w=0.222 //l=0.115 //layer=m1 \
 //thickness=0.36 //x=14.55 //y=2.375 //x2=14.55 //y2=2.26
r355 (  17 18 ) resistor r=0.935115 //w=0.131 //l=0.98 //layer=m1 \
 //thickness=0.36 //x=14.55 //y=2.375 //x2=14.55 //y2=3.355
r356 (  15 34 ) resistor r=0.0911593 //w=0.376 //l=0.184174 //layer=m1 \
 //thickness=0.36 //x=12.7 //y=3.675 //x2=12.752 //y2=3.515
r357 (  15 16 ) resistor r=1.5458 //w=0.131 //l=1.62 //layer=m1 \
 //thickness=0.36 //x=12.7 //y=3.675 //x2=12.7 //y2=5.295
r358 (  14 32 ) resistor r=0.0894971 //w=0.376 //l=0.179123 //layer=m1 \
 //thickness=0.36 //x=12.7 //y=3.355 //x2=12.752 //y2=3.51
r359 (  13 14 ) resistor r=1.36927 //w=0.131 //l=1.435 //layer=m1 \
 //thickness=0.36 //x=12.7 //y=1.92 //x2=12.7 //y2=3.355
r360 (  11 13 ) resistor r=0.0698411 //w=0.17 //l=0.120208 //layer=m1 \
 //thickness=0.36 //x=12.615 //y=1.835 //x2=12.7 //y2=1.92
r361 (  11 12 ) resistor r=0.257634 //w=0.131 //l=0.27 //layer=m1 \
 //thickness=0.36 //x=12.615 //y=1.835 //x2=12.345 //y2=1.835
r362 (  10 24 ) resistor r=0.0257089 //w=0.23 //l=0.115 //layer=m1 \
 //thickness=0.36 //x=12.335 //y=5.38 //x2=12.22 //y2=5.38
r363 (  9 16 ) resistor r=0.0698411 //w=0.17 //l=0.120208 //layer=m1 \
 //thickness=0.36 //x=12.615 //y=5.38 //x2=12.7 //y2=5.295
r364 (  9 10 ) resistor r=0.267176 //w=0.131 //l=0.28 //layer=m1 \
 //thickness=0.36 //x=12.615 //y=5.38 //x2=12.335 //y2=5.38
r365 (  8 12 ) resistor r=0.0698411 //w=0.17 //l=0.120208 //layer=m1 \
 //thickness=0.36 //x=12.26 //y=1.75 //x2=12.345 //y2=1.835
r366 (  7 29 ) resistor r=0.0913624 //w=0.191 //l=0.12 //layer=m1 \
 //thickness=0.36 //x=12.26 //y=1.3 //x2=12.26 //y2=1.18
r367 (  7 8 ) resistor r=0.429389 //w=0.131 //l=0.45 //layer=m1 \
 //thickness=0.36 //x=12.26 //y=1.3 //x2=12.26 //y2=1.75
r368 (  4 21 ) resistor r=0.0227762 //w=0.219 //l=0.115 //layer=m1 \
 //thickness=0.36 //x=11.455 //y=5.38 //x2=11.34 //y2=5.38
r369 (  3 24 ) resistor r=0.0257089 //w=0.23 //l=0.115 //layer=m1 \
 //thickness=0.36 //x=12.105 //y=5.38 //x2=12.22 //y2=5.38
r370 (  3 4 ) resistor r=0.620229 //w=0.131 //l=0.65 //layer=m1 \
 //thickness=0.36 //x=12.105 //y=5.38 //x2=11.455 //y2=5.38
ends PM_DFFRNX1\%noxref_2

subckt PM_DFFRNX1\%CLK ( 1 2 3 4 5 6 7 8 9 10 11 12 20 29 36 39 41 43 49 54 59 \
 64 68 69 70 71 72 73 74 75 76 78 84 85 86 87 88 93 94 95 97 103 104 105 106 \
 107 115 126 )
c296 ( 126 0 ) capacitor c=0.0356502f //x=15.66 //y=4.88
c297 ( 115 0 ) capacitor c=0.0356344f //x=2.71 //y=4.88
c298 ( 107 0 ) capacitor c=0.0306876f //x=15.995 //y=4.97
c299 ( 106 0 ) capacitor c=0.0863671f //x=15.75 //y=2.095
c300 ( 105 0 ) capacitor c=0.0170266f //x=15.75 //y=1.63
c301 ( 104 0 ) capacitor c=0.018609f //x=15.75 //y=1.4
c302 ( 103 0 ) capacitor c=0.0186599f //x=15.75 //y=1.09
c303 ( 97 0 ) capacitor c=0.0146988f //x=15.595 //y=1.555
c304 ( 95 0 ) capacitor c=0.0148531f //x=15.595 //y=0.935
c305 ( 94 0 ) capacitor c=0.0334406f //x=15.225 //y=1.4
c306 ( 93 0 ) capacitor c=0.0173191f //x=15.225 //y=1.09
c307 ( 88 0 ) capacitor c=0.0306608f //x=3.045 //y=4.97
c308 ( 87 0 ) capacitor c=0.0863671f //x=2.8 //y=2.095
c309 ( 86 0 ) capacitor c=0.0170266f //x=2.8 //y=1.63
c310 ( 85 0 ) capacitor c=0.018609f //x=2.8 //y=1.4
c311 ( 84 0 ) capacitor c=0.0186599f //x=2.8 //y=1.09
c312 ( 78 0 ) capacitor c=0.0146988f //x=2.645 //y=1.555
c313 ( 76 0 ) capacitor c=0.0148531f //x=2.645 //y=0.935
c314 ( 75 0 ) capacitor c=0.0334406f //x=2.275 //y=1.4
c315 ( 74 0 ) capacitor c=0.0173191f //x=2.275 //y=1.09
c316 ( 73 0 ) capacitor c=0.110208f //x=16.07 //y=6.2
c317 ( 72 0 ) capacitor c=0.110214f //x=15.63 //y=6.2
c318 ( 71 0 ) capacitor c=0.110208f //x=3.12 //y=6.2
c319 ( 70 0 ) capacitor c=0.110214f //x=2.68 //y=6.2
c320 ( 64 0 ) capacitor c=0.00129935f //x=15.66 //y=4.88
c321 ( 59 0 ) capacitor c=0.00121786f //x=15.66 //y=2.26
c322 ( 54 0 ) capacitor c=0.00129935f //x=2.71 //y=4.88
c323 ( 49 0 ) capacitor c=0.00121786f //x=2.71 //y=2.26
c324 ( 43 0 ) capacitor c=0.0045011f //x=2.705 //y=4.62
c325 ( 41 0 ) capacitor c=0.0999657f //x=12.18 //y=4.635
c326 ( 39 0 ) capacitor c=0.218639f //x=11.58 //y=4.62
c327 ( 36 0 ) capacitor c=0.0115855f //x=15.655 //y=4.695
c328 ( 29 0 ) capacitor c=0.00785249f //x=2.705 //y=4.835
c329 ( 20 0 ) capacitor c=0.00382585f //x=15.66 //y=2.375
c330 ( 12 0 ) capacitor c=0.0056477f //x=2.71 //y=2.375
c331 ( 7 0 ) capacitor c=0.0633406f //x=15.66 //y=2.4
c332 ( 1 0 ) capacitor c=0.0668824f //x=2.71 //y=2.4
r333 (  128 129 ) resistor r=32.4568 //w=0.214 //l=0.075 //layer=ply \
 //thickness=0.18 //x=15.66 //y=4.97 //x2=15.66 //y2=5.045
r334 (  126 128 ) resistor r=20.271 //w=0.214 //l=0.09 //layer=ply \
 //thickness=0.18 //x=15.66 //y=4.88 //x2=15.66 //y2=4.97
r335 (  117 118 ) resistor r=32.4568 //w=0.214 //l=0.075 //layer=ply \
 //thickness=0.18 //x=2.71 //y=4.97 //x2=2.71 //y2=5.045
r336 (  115 117 ) resistor r=20.271 //w=0.214 //l=0.09 //layer=ply \
 //thickness=0.18 //x=2.71 //y=4.88 //x2=2.71 //y2=4.97
r337 (  108 128 ) resistor r=16.5046 //w=0.27 //l=0.135 //layer=ply \
 //thickness=0.18 //x=15.795 //y=4.97 //x2=15.66 //y2=4.97
r338 (  107 109 ) resistor r=26.9307 //w=0.15 //l=0.106066 //layer=ply \
 //thickness=0.18 //x=15.995 //y=4.97 //x2=16.07 //y2=5.045
r339 (  107 108 ) resistor r=102.553 //w=0.094 //l=0.2 //layer=ply \
 //thickness=0.18 //x=15.995 //y=4.97 //x2=15.795 //y2=4.97
r340 (  106 133 ) resistor r=38.6777 //w=0.284 //l=0.198997 //layer=ply \
 //thickness=0.18 //x=15.75 //y=2.095 //x2=15.675 //y2=2.26
r341 (  105 131 ) resistor r=21.2976 //w=0.217 //l=0.0928709 //layer=ply \
 //thickness=0.18 //x=15.75 //y=1.63 //x2=15.71 //y2=1.555
r342 (  105 106 ) resistor r=238.436 //w=0.094 //l=0.465 //layer=ply \
 //thickness=0.18 //x=15.75 //y=1.63 //x2=15.75 //y2=2.095
r343 (  104 131 ) resistor r=39.0671 //w=0.217 //l=0.173853 //layer=ply \
 //thickness=0.18 //x=15.75 //y=1.4 //x2=15.71 //y2=1.555
r344 (  103 130 ) resistor r=45.1352 //w=0.168 //l=0.173853 //layer=ply \
 //thickness=0.18 //x=15.75 //y=1.09 //x2=15.71 //y2=0.935
r345 (  103 104 ) resistor r=158.957 //w=0.094 //l=0.31 //layer=ply \
 //thickness=0.18 //x=15.75 //y=1.09 //x2=15.75 //y2=1.4
r346 (  98 124 ) resistor r=5.52526 //w=0.168 //l=0.115 //layer=ply \
 //thickness=0.18 //x=15.38 //y=1.555 //x2=15.265 //y2=1.555
r347 (  97 131 ) resistor r=11.4558 //w=0.217 //l=0.115 //layer=ply \
 //thickness=0.18 //x=15.595 //y=1.555 //x2=15.71 //y2=1.555
r348 (  96 123 ) resistor r=5.52526 //w=0.168 //l=0.115 //layer=ply \
 //thickness=0.18 //x=15.38 //y=0.935 //x2=15.265 //y2=0.935
r349 (  95 130 ) resistor r=5.52526 //w=0.168 //l=0.115 //layer=ply \
 //thickness=0.18 //x=15.595 //y=0.935 //x2=15.71 //y2=0.935
r350 (  95 96 ) resistor r=110.245 //w=0.094 //l=0.215 //layer=ply \
 //thickness=0.18 //x=15.595 //y=0.935 //x2=15.38 //y2=0.935
r351 (  94 124 ) resistor r=45.1352 //w=0.168 //l=0.173853 //layer=ply \
 //thickness=0.18 //x=15.225 //y=1.4 //x2=15.265 //y2=1.555
r352 (  93 123 ) resistor r=45.1352 //w=0.168 //l=0.173853 //layer=ply \
 //thickness=0.18 //x=15.225 //y=1.09 //x2=15.265 //y2=0.935
r353 (  93 94 ) resistor r=158.957 //w=0.094 //l=0.31 //layer=ply \
 //thickness=0.18 //x=15.225 //y=1.09 //x2=15.225 //y2=1.4
r354 (  89 117 ) resistor r=16.5046 //w=0.27 //l=0.135 //layer=ply \
 //thickness=0.18 //x=2.845 //y=4.97 //x2=2.71 //y2=4.97
r355 (  88 90 ) resistor r=26.9307 //w=0.15 //l=0.106066 //layer=ply \
 //thickness=0.18 //x=3.045 //y=4.97 //x2=3.12 //y2=5.045
r356 (  88 89 ) resistor r=102.553 //w=0.094 //l=0.2 //layer=ply \
 //thickness=0.18 //x=3.045 //y=4.97 //x2=2.845 //y2=4.97
r357 (  87 122 ) resistor r=38.6777 //w=0.284 //l=0.198997 //layer=ply \
 //thickness=0.18 //x=2.8 //y=2.095 //x2=2.725 //y2=2.26
r358 (  86 120 ) resistor r=21.2976 //w=0.217 //l=0.0928709 //layer=ply \
 //thickness=0.18 //x=2.8 //y=1.63 //x2=2.76 //y2=1.555
r359 (  86 87 ) resistor r=238.436 //w=0.094 //l=0.465 //layer=ply \
 //thickness=0.18 //x=2.8 //y=1.63 //x2=2.8 //y2=2.095
r360 (  85 120 ) resistor r=39.0671 //w=0.217 //l=0.173853 //layer=ply \
 //thickness=0.18 //x=2.8 //y=1.4 //x2=2.76 //y2=1.555
r361 (  84 119 ) resistor r=45.1352 //w=0.168 //l=0.173853 //layer=ply \
 //thickness=0.18 //x=2.8 //y=1.09 //x2=2.76 //y2=0.935
r362 (  84 85 ) resistor r=158.957 //w=0.094 //l=0.31 //layer=ply \
 //thickness=0.18 //x=2.8 //y=1.09 //x2=2.8 //y2=1.4
r363 (  79 113 ) resistor r=5.52526 //w=0.168 //l=0.115 //layer=ply \
 //thickness=0.18 //x=2.43 //y=1.555 //x2=2.315 //y2=1.555
r364 (  78 120 ) resistor r=11.4558 //w=0.217 //l=0.115 //layer=ply \
 //thickness=0.18 //x=2.645 //y=1.555 //x2=2.76 //y2=1.555
r365 (  77 112 ) resistor r=5.52526 //w=0.168 //l=0.115 //layer=ply \
 //thickness=0.18 //x=2.43 //y=0.935 //x2=2.315 //y2=0.935
r366 (  76 119 ) resistor r=5.52526 //w=0.168 //l=0.115 //layer=ply \
 //thickness=0.18 //x=2.645 //y=0.935 //x2=2.76 //y2=0.935
r367 (  76 77 ) resistor r=110.245 //w=0.094 //l=0.215 //layer=ply \
 //thickness=0.18 //x=2.645 //y=0.935 //x2=2.43 //y2=0.935
r368 (  75 113 ) resistor r=45.1352 //w=0.168 //l=0.173853 //layer=ply \
 //thickness=0.18 //x=2.275 //y=1.4 //x2=2.315 //y2=1.555
r369 (  74 112 ) resistor r=45.1352 //w=0.168 //l=0.173853 //layer=ply \
 //thickness=0.18 //x=2.275 //y=1.09 //x2=2.315 //y2=0.935
r370 (  74 75 ) resistor r=158.957 //w=0.094 //l=0.31 //layer=ply \
 //thickness=0.18 //x=2.275 //y=1.09 //x2=2.275 //y2=1.4
r371 (  73 109 ) resistor r=592.245 //w=0.094 //l=1.155 //layer=ply \
 //thickness=0.18 //x=16.07 //y=6.2 //x2=16.07 //y2=5.045
r372 (  72 129 ) resistor r=592.245 //w=0.094 //l=1.155 //layer=ply \
 //thickness=0.18 //x=15.63 //y=6.2 //x2=15.63 //y2=5.045
r373 (  71 90 ) resistor r=592.245 //w=0.094 //l=1.155 //layer=ply \
 //thickness=0.18 //x=3.12 //y=6.2 //x2=3.12 //y2=5.045
r374 (  70 118 ) resistor r=592.245 //w=0.094 //l=1.155 //layer=ply \
 //thickness=0.18 //x=2.68 //y=6.2 //x2=2.68 //y2=5.045
r375 (  69 97 ) resistor r=55.3787 //w=0.094 //l=0.108 //layer=ply \
 //thickness=0.18 //x=15.487 //y=1.555 //x2=15.595 //y2=1.555
r376 (  69 98 ) resistor r=54.866 //w=0.094 //l=0.107 //layer=ply \
 //thickness=0.18 //x=15.487 //y=1.555 //x2=15.38 //y2=1.555
r377 (  68 78 ) resistor r=55.3787 //w=0.094 //l=0.108 //layer=ply \
 //thickness=0.18 //x=2.537 //y=1.555 //x2=2.645 //y2=1.555
r378 (  68 79 ) resistor r=54.866 //w=0.094 //l=0.107 //layer=ply \
 //thickness=0.18 //x=2.537 //y=1.555 //x2=2.43 //y2=1.555
r379 (  64 126 ) resistor r=152 //w=0.17 //l=0.17 //layer=licon //count=1 \
 //x=15.66 //y=4.88 //x2=15.66 //y2=4.88
r380 (  59 133 ) resistor r=152 //w=0.17 //l=0.17 //layer=licon //count=1 \
 //x=15.66 //y=2.26 //x2=15.66 //y2=2.26
r381 (  54 115 ) resistor r=152 //w=0.17 //l=0.17 //layer=licon //count=1 \
 //x=2.71 //y=4.88 //x2=2.71 //y2=4.88
r382 (  49 122 ) resistor r=152 //w=0.17 //l=0.17 //layer=licon //count=1 \
 //x=2.71 //y=2.26 //x2=2.71 //y2=2.26
r383 (  43 45 ) resistor r=0.0904882 //w=0.297 //l=0.215 //layer=m2 \
 //thickness=0.36 //x=2.705 //y=4.62 //x2=2.705 //y2=4.835
r384 (  41 47 ) resistor r=2.36166 //w=0.184 //l=3.50487 //layer=m2 \
 //thickness=0.36 //x=12.18 //y=4.635 //x2=15.655 //y2=4.695
r385 (  41 42 ) resistor r=0.329198 //w=0.131 //l=0.345 //layer=m2 \
 //thickness=0.36 //x=12.18 //y=4.635 //x2=11.835 //y2=4.635
r386 (  40 43 ) resistor r=0.0410036 //w=0.297 //l=0.16 //layer=m2 \
 //thickness=0.36 //x=2.865 //y=4.62 //x2=2.705 //y2=4.62
r387 (  39 42 ) resistor r=0.1875 //w=0.17 //l=0.262393 //layer=m2 \
 //thickness=0.36 //x=11.58 //y=4.62 //x2=11.835 //y2=4.635
r388 (  39 40 ) resistor r=8.31584 //w=0.131 //l=8.715 //layer=m2 \
 //thickness=0.36 //x=11.58 //y=4.62 //x2=2.865 //y2=4.62
r389 (  38 64 ) resistor r=9.3 //w=0.17 //l=0.17 //layer=mcon //count=1 \
 //x=15.66 //y=4.88 //x2=15.66 //y2=4.88
r390 (  36 47 ) resistor r=4.5 //w=0.15 //l=0.15 //layer=via1 //count=1 \
 //x=15.655 //y=4.695 //x2=15.655 //y2=4.695
r391 (  36 38 ) resistor r=0.0808566 //w=0.286 //l=0.185 //layer=m1 \
 //thickness=0.36 //x=15.655 //y=4.695 //x2=15.655 //y2=4.88
r392 (  33 59 ) resistor r=9.3 //w=0.17 //l=0.17 //layer=mcon //count=1 \
 //x=15.66 //y=2.26 //x2=15.66 //y2=2.26
r393 (  31 54 ) resistor r=9.3 //w=0.17 //l=0.17 //layer=mcon //count=1 \
 //x=2.71 //y=4.88 //x2=2.71 //y2=4.88
r394 (  29 45 ) resistor r=4.5 //w=0.15 //l=0.15 //layer=via1 //count=1 \
 //x=2.705 //y=4.835 //x2=2.705 //y2=4.835
r395 (  29 31 ) resistor r=0.018263 //w=0.308 //l=0.045 //layer=m1 \
 //thickness=0.36 //x=2.705 //y=4.835 //x2=2.705 //y2=4.88
r396 (  27 49 ) resistor r=9.3 //w=0.17 //l=0.17 //layer=mcon //count=1 \
 //x=2.71 //y=2.26 //x2=2.71 //y2=2.26
r397 (  20 33 ) resistor r=0.0715665 //w=0.226 //l=0.115996 //layer=m1 \
 //thickness=0.36 //x=15.66 //y=2.375 //x2=15.662 //y2=2.26
r398 (  13 29 ) resistor r=0.0898396 //w=0.308 //l=0.162481 //layer=m1 \
 //thickness=0.36 //x=2.71 //y=4.675 //x2=2.705 //y2=4.835
r399 (  12 27 ) resistor r=0.0715665 //w=0.226 //l=0.115996 //layer=m1 \
 //thickness=0.36 //x=2.71 //y=2.375 //x2=2.712 //y2=2.26
r400 (  11 36 ) resistor r=0.0327797 //w=0.286 //l=0.075 //layer=m1 \
 //thickness=0.36 //x=15.655 //y=4.62 //x2=15.655 //y2=4.695
r401 (  11 21 ) resistor r=0.0575483 //w=0.286 //l=0.0874643 //layer=m1 \
 //thickness=0.36 //x=15.655 //y=4.62 //x2=15.66 //y2=4.535
r402 (  10 21 ) resistor r=0.978053 //w=0.131 //l=1.025 //layer=m1 \
 //thickness=0.36 //x=15.66 //y=3.51 //x2=15.66 //y2=4.535
r403 (  9 10 ) resistor r=0.353053 //w=0.131 //l=0.37 //layer=m1 \
 //thickness=0.36 //x=15.66 //y=3.14 //x2=15.66 //y2=3.51
r404 (  8 9 ) resistor r=0.353053 //w=0.131 //l=0.37 //layer=m1 \
 //thickness=0.36 //x=15.66 //y=2.77 //x2=15.66 //y2=3.14
r405 (  7 8 ) resistor r=0.353053 //w=0.131 //l=0.37 //layer=m1 \
 //thickness=0.36 //x=15.66 //y=2.4 //x2=15.66 //y2=2.77
r406 (  7 20 ) resistor r=0.023855 //w=0.131 //l=0.025 //layer=m1 \
 //thickness=0.36 //x=15.66 //y=2.4 //x2=15.66 //y2=2.375
r407 (  6 13 ) resistor r=0.0524809 //w=0.131 //l=0.055 //layer=m1 \
 //thickness=0.36 //x=2.71 //y=4.62 //x2=2.71 //y2=4.675
r408 (  5 6 ) resistor r=0.706107 //w=0.131 //l=0.74 //layer=m1 \
 //thickness=0.36 //x=2.71 //y=3.88 //x2=2.71 //y2=4.62
r409 (  4 5 ) resistor r=0.353053 //w=0.131 //l=0.37 //layer=m1 \
 //thickness=0.36 //x=2.71 //y=3.51 //x2=2.71 //y2=3.88
r410 (  3 4 ) resistor r=0.353053 //w=0.131 //l=0.37 //layer=m1 \
 //thickness=0.36 //x=2.71 //y=3.14 //x2=2.71 //y2=3.51
r411 (  2 3 ) resistor r=0.353053 //w=0.131 //l=0.37 //layer=m1 \
 //thickness=0.36 //x=2.71 //y=2.77 //x2=2.71 //y2=3.14
r412 (  1 2 ) resistor r=0.353053 //w=0.131 //l=0.37 //layer=m1 \
 //thickness=0.36 //x=2.71 //y=2.4 //x2=2.71 //y2=2.77
r413 (  1 12 ) resistor r=0.023855 //w=0.131 //l=0.025 //layer=m1 \
 //thickness=0.36 //x=2.71 //y=2.4 //x2=2.71 //y2=2.375
ends PM_DFFRNX1\%CLK

subckt PM_DFFRNX1\%noxref_4 ( 1 3 6 7 9 10 11 12 14 15 16 17 18 19 20 21 22 23 \
 24 25 28 31 37 45 48 54 56 57 58 60 62 64 66 68 70 72 77 83 91 99 116 125 130 \
 139 143 144 145 146 147 148 149 150 151 152 153 155 161 162 163 164 168 169 \
 170 171 172 174 180 181 182 183 203 205 206 207 )
c463 ( 203 0 ) capacitor c=0.00885916f //x=3.885 //y=1.095
c464 ( 183 0 ) capacitor c=0.0583399f //x=19.635 //y=4.97
c465 ( 182 0 ) capacitor c=0.0376642f //x=19.925 //y=4.97
c466 ( 181 0 ) capacitor c=0.0346489f //x=19.59 //y=1.4
c467 ( 180 0 ) capacitor c=0.018692f //x=19.59 //y=1.055
c468 ( 174 0 ) capacitor c=0.0137077f //x=19.435 //y=1.555
c469 ( 172 0 ) capacitor c=0.0158585f //x=19.435 //y=0.9
c470 ( 171 0 ) capacitor c=0.103534f //x=19.06 //y=2.095
c471 ( 170 0 ) capacitor c=0.0229444f //x=19.06 //y=1.71
c472 ( 169 0 ) capacitor c=0.0234359f //x=19.06 //y=1.4
c473 ( 168 0 ) capacitor c=0.019815f //x=19.06 //y=1.055
c474 ( 164 0 ) capacitor c=0.0564069f //x=6.685 //y=4.97
c475 ( 163 0 ) capacitor c=0.0376642f //x=6.975 //y=4.97
c476 ( 162 0 ) capacitor c=0.0346489f //x=6.64 //y=1.4
c477 ( 161 0 ) capacitor c=0.018692f //x=6.64 //y=1.055
c478 ( 155 0 ) capacitor c=0.0137077f //x=6.485 //y=1.555
c479 ( 153 0 ) capacitor c=0.0158585f //x=6.485 //y=0.9
c480 ( 152 0 ) capacitor c=0.103534f //x=6.11 //y=2.095
c481 ( 151 0 ) capacitor c=0.0229444f //x=6.11 //y=1.71
c482 ( 150 0 ) capacitor c=0.0234359f //x=6.11 //y=1.4
c483 ( 149 0 ) capacitor c=0.019815f //x=6.11 //y=1.055
c484 ( 148 0 ) capacitor c=0.110208f //x=20 //y=6.2
c485 ( 147 0 ) capacitor c=0.158957f //x=19.56 //y=6.2
c486 ( 146 0 ) capacitor c=0.110208f //x=7.05 //y=6.2
c487 ( 145 0 ) capacitor c=0.158957f //x=6.61 //y=6.2
c488 ( 139 0 ) capacitor c=0.0014751f //x=19.36 //y=4.88
c489 ( 130 0 ) capacitor c=0.0012618f //x=19.36 //y=2.26
c490 ( 125 0 ) capacitor c=0.0014751f //x=6.41 //y=4.88
c491 ( 116 0 ) capacitor c=0.0012618f //x=6.41 //y=2.26
c492 ( 99 0 ) capacitor c=0.0293561f //x=3.78 //y=5.56
c493 ( 91 0 ) capacitor c=0.029137f //x=2.9 //y=5.56
c494 ( 83 0 ) capacitor c=0.0278099f //x=2.02 //y=5.56
c495 ( 77 0 ) capacitor c=7.36606e-19 //x=4.725 //y=3.885
c496 ( 72 0 ) capacitor c=0.0356523f //x=17.73 //y=3.87
c497 ( 70 0 ) capacitor c=0.0338299f //x=17.13 //y=3.88
c498 ( 68 0 ) capacitor c=0.00527642f //x=14.77 //y=3.9
c499 ( 66 0 ) capacitor c=0.018225f //x=14.17 //y=3.88
c500 ( 64 0 ) capacitor c=0.00410098f //x=12.915 //y=3.9
c501 ( 62 0 ) capacitor c=0.0100086f //x=12.18 //y=3.865
c502 ( 60 0 ) capacitor c=0.00684159f //x=11.435 //y=3.895
c503 ( 58 0 ) capacitor c=0.0174986f //x=10.835 //y=3.88
c504 ( 57 0 ) capacitor c=0.0248309f //x=9.245 //y=3.895
c505 ( 56 0 ) capacitor c=0.00423161f //x=9.59 //y=3.895
c506 ( 54 0 ) capacitor c=0.0209003f //x=6.255 //y=3.88
c507 ( 48 0 ) capacitor c=0.0168323f //x=19.35 //y=3.88
c508 ( 45 0 ) capacitor c=0.0167936f //x=6.41 //y=3.88
c509 ( 37 0 ) capacitor c=0.0172565f //x=4.56 //y=3.88
c510 ( 31 0 ) capacitor c=9.55882e-19 //x=3.78 //y=5.335
c511 ( 28 0 ) capacitor c=0.00740623f //x=2.9 //y=5.335
c512 ( 25 0 ) capacitor c=0.0123281f //x=2.022 //y=5.335
c513 ( 24 0 ) capacitor c=0.0267106f //x=19.36 //y=4.755
c514 ( 23 0 ) capacitor c=0.0136306f //x=19.36 //y=4.04
c515 ( 22 0 ) capacitor c=0.0475542f //x=19.36 //y=3.72
c516 ( 21 0 ) capacitor c=0.00489532f //x=19.36 //y=2.375
c517 ( 20 0 ) capacitor c=0.0266326f //x=6.41 //y=4.755
c518 ( 19 0 ) capacitor c=0.0127337f //x=6.41 //y=4.04
c519 ( 18 0 ) capacitor c=0.0455792f //x=6.41 //y=3.72
c520 ( 17 0 ) capacitor c=0.00670383f //x=6.41 //y=2.375
c521 ( 16 0 ) capacitor c=0.0325919f //x=4.56 //y=5.25
c522 ( 15 0 ) capacitor c=0.0131885f //x=4.56 //y=4.045
c523 ( 14 0 ) capacitor c=0.052475f //x=4.56 //y=3.725
c524 ( 12 0 ) capacitor c=0.00686157f //x=4.16 //y=1.845
c525 ( 11 0 ) capacitor c=0.0163455f //x=4.475 //y=1.845
c526 ( 10 0 ) capacitor c=0.0167992f //x=4.075 //y=1.76
c527 ( 9 0 ) capacitor c=0.0113317f //x=4.075 //y=1.305
c528 ( 7 0 ) capacitor c=0.0229543f //x=4.475 //y=5.335
c529 ( 6 0 ) capacitor c=0.00933983f //x=3.78 //y=5.56
c530 ( 3 0 ) capacitor c=0.019444f //x=3.665 //y=5.335
c531 ( 1 0 ) capacitor c=0.0149475f //x=2.78 //y=5.335
r532 (  182 184 ) resistor r=26.9307 //w=0.15 //l=0.106066 //layer=ply \
 //thickness=0.18 //x=19.925 //y=4.97 //x2=20 //y2=5.045
r533 (  182 183 ) resistor r=148.702 //w=0.094 //l=0.29 //layer=ply \
 //thickness=0.18 //x=19.925 //y=4.97 //x2=19.635 //y2=4.97
r534 (  181 202 ) resistor r=45.1352 //w=0.168 //l=0.173853 //layer=ply \
 //thickness=0.18 //x=19.59 //y=1.4 //x2=19.55 //y2=1.555
r535 (  180 201 ) resistor r=45.1352 //w=0.168 //l=0.173853 //layer=ply \
 //thickness=0.18 //x=19.59 //y=1.055 //x2=19.55 //y2=0.9
r536 (  180 181 ) resistor r=176.904 //w=0.094 //l=0.345 //layer=ply \
 //thickness=0.18 //x=19.59 //y=1.055 //x2=19.59 //y2=1.4
r537 (  177 183 ) resistor r=22.7971 //w=0.269 //l=0.106066 //layer=ply \
 //thickness=0.18 //x=19.56 //y=5.045 //x2=19.635 //y2=4.97
r538 (  177 200 ) resistor r=35.8364 //w=0.269 //l=0.270185 //layer=ply \
 //thickness=0.18 //x=19.56 //y=5.045 //x2=19.36 //y2=4.88
r539 (  175 196 ) resistor r=10.701 //w=0.21 //l=0.115 //layer=ply \
 //thickness=0.18 //x=19.215 //y=1.555 //x2=19.1 //y2=1.555
r540 (  174 202 ) resistor r=5.52526 //w=0.168 //l=0.115 //layer=ply \
 //thickness=0.18 //x=19.435 //y=1.555 //x2=19.55 //y2=1.555
r541 (  173 195 ) resistor r=5.52526 //w=0.168 //l=0.115 //layer=ply \
 //thickness=0.18 //x=19.215 //y=0.9 //x2=19.1 //y2=0.9
r542 (  172 201 ) resistor r=5.52526 //w=0.168 //l=0.115 //layer=ply \
 //thickness=0.18 //x=19.435 //y=0.9 //x2=19.55 //y2=0.9
r543 (  172 173 ) resistor r=112.809 //w=0.094 //l=0.22 //layer=ply \
 //thickness=0.18 //x=19.435 //y=0.9 //x2=19.215 //y2=0.9
r544 (  171 198 ) resistor r=58.7805 //w=0.246 //l=0.373497 //layer=ply \
 //thickness=0.18 //x=19.06 //y=2.095 //x2=19.36 //y2=2.26
r545 (  170 196 ) resistor r=39.5823 //w=0.21 //l=0.173853 //layer=ply \
 //thickness=0.18 //x=19.06 //y=1.71 //x2=19.1 //y2=1.555
r546 (  170 171 ) resistor r=197.415 //w=0.094 //l=0.385 //layer=ply \
 //thickness=0.18 //x=19.06 //y=1.71 //x2=19.06 //y2=2.095
r547 (  169 196 ) resistor r=39.5823 //w=0.21 //l=0.173853 //layer=ply \
 //thickness=0.18 //x=19.06 //y=1.4 //x2=19.1 //y2=1.555
r548 (  168 195 ) resistor r=45.1352 //w=0.168 //l=0.173853 //layer=ply \
 //thickness=0.18 //x=19.06 //y=1.055 //x2=19.1 //y2=0.9
r549 (  168 169 ) resistor r=176.904 //w=0.094 //l=0.345 //layer=ply \
 //thickness=0.18 //x=19.06 //y=1.055 //x2=19.06 //y2=1.4
r550 (  163 165 ) resistor r=26.9307 //w=0.15 //l=0.106066 //layer=ply \
 //thickness=0.18 //x=6.975 //y=4.97 //x2=7.05 //y2=5.045
r551 (  163 164 ) resistor r=148.702 //w=0.094 //l=0.29 //layer=ply \
 //thickness=0.18 //x=6.975 //y=4.97 //x2=6.685 //y2=4.97
r552 (  162 194 ) resistor r=45.1352 //w=0.168 //l=0.173853 //layer=ply \
 //thickness=0.18 //x=6.64 //y=1.4 //x2=6.6 //y2=1.555
r553 (  161 193 ) resistor r=45.1352 //w=0.168 //l=0.173853 //layer=ply \
 //thickness=0.18 //x=6.64 //y=1.055 //x2=6.6 //y2=0.9
r554 (  161 162 ) resistor r=176.904 //w=0.094 //l=0.345 //layer=ply \
 //thickness=0.18 //x=6.64 //y=1.055 //x2=6.64 //y2=1.4
r555 (  158 164 ) resistor r=22.7971 //w=0.269 //l=0.106066 //layer=ply \
 //thickness=0.18 //x=6.61 //y=5.045 //x2=6.685 //y2=4.97
r556 (  158 192 ) resistor r=35.8364 //w=0.269 //l=0.270185 //layer=ply \
 //thickness=0.18 //x=6.61 //y=5.045 //x2=6.41 //y2=4.88
r557 (  156 188 ) resistor r=10.701 //w=0.21 //l=0.115 //layer=ply \
 //thickness=0.18 //x=6.265 //y=1.555 //x2=6.15 //y2=1.555
r558 (  155 194 ) resistor r=5.52526 //w=0.168 //l=0.115 //layer=ply \
 //thickness=0.18 //x=6.485 //y=1.555 //x2=6.6 //y2=1.555
r559 (  154 187 ) resistor r=5.52526 //w=0.168 //l=0.115 //layer=ply \
 //thickness=0.18 //x=6.265 //y=0.9 //x2=6.15 //y2=0.9
r560 (  153 193 ) resistor r=5.52526 //w=0.168 //l=0.115 //layer=ply \
 //thickness=0.18 //x=6.485 //y=0.9 //x2=6.6 //y2=0.9
r561 (  153 154 ) resistor r=112.809 //w=0.094 //l=0.22 //layer=ply \
 //thickness=0.18 //x=6.485 //y=0.9 //x2=6.265 //y2=0.9
r562 (  152 190 ) resistor r=58.7805 //w=0.246 //l=0.373497 //layer=ply \
 //thickness=0.18 //x=6.11 //y=2.095 //x2=6.41 //y2=2.26
r563 (  151 188 ) resistor r=39.5823 //w=0.21 //l=0.173853 //layer=ply \
 //thickness=0.18 //x=6.11 //y=1.71 //x2=6.15 //y2=1.555
r564 (  151 152 ) resistor r=197.415 //w=0.094 //l=0.385 //layer=ply \
 //thickness=0.18 //x=6.11 //y=1.71 //x2=6.11 //y2=2.095
r565 (  150 188 ) resistor r=39.5823 //w=0.21 //l=0.173853 //layer=ply \
 //thickness=0.18 //x=6.11 //y=1.4 //x2=6.15 //y2=1.555
r566 (  149 187 ) resistor r=45.1352 //w=0.168 //l=0.173853 //layer=ply \
 //thickness=0.18 //x=6.11 //y=1.055 //x2=6.15 //y2=0.9
r567 (  149 150 ) resistor r=176.904 //w=0.094 //l=0.345 //layer=ply \
 //thickness=0.18 //x=6.11 //y=1.055 //x2=6.11 //y2=1.4
r568 (  148 184 ) resistor r=592.245 //w=0.094 //l=1.155 //layer=ply \
 //thickness=0.18 //x=20 //y=6.2 //x2=20 //y2=5.045
r569 (  147 177 ) resistor r=592.245 //w=0.094 //l=1.155 //layer=ply \
 //thickness=0.18 //x=19.56 //y=6.2 //x2=19.56 //y2=5.045
r570 (  146 165 ) resistor r=592.245 //w=0.094 //l=1.155 //layer=ply \
 //thickness=0.18 //x=7.05 //y=6.2 //x2=7.05 //y2=5.045
r571 (  145 158 ) resistor r=592.245 //w=0.094 //l=1.155 //layer=ply \
 //thickness=0.18 //x=6.61 //y=6.2 //x2=6.61 //y2=5.045
r572 (  144 174 ) resistor r=56.4043 //w=0.094 //l=0.11 //layer=ply \
 //thickness=0.18 //x=19.325 //y=1.555 //x2=19.435 //y2=1.555
r573 (  144 175 ) resistor r=56.4043 //w=0.094 //l=0.11 //layer=ply \
 //thickness=0.18 //x=19.325 //y=1.555 //x2=19.215 //y2=1.555
r574 (  143 155 ) resistor r=56.4043 //w=0.094 //l=0.11 //layer=ply \
 //thickness=0.18 //x=6.375 //y=1.555 //x2=6.485 //y2=1.555
r575 (  143 156 ) resistor r=56.4043 //w=0.094 //l=0.11 //layer=ply \
 //thickness=0.18 //x=6.375 //y=1.555 //x2=6.265 //y2=1.555
r576 (  139 200 ) resistor r=152 //w=0.17 //l=0.17 //layer=licon //count=1 \
 //x=19.36 //y=4.88 //x2=19.36 //y2=4.88
r577 (  130 198 ) resistor r=152 //w=0.17 //l=0.17 //layer=licon //count=1 \
 //x=19.36 //y=2.26 //x2=19.36 //y2=2.26
r578 (  125 192 ) resistor r=152 //w=0.17 //l=0.17 //layer=licon //count=1 \
 //x=6.41 //y=4.88 //x2=6.41 //y2=4.88
r579 (  116 190 ) resistor r=152 //w=0.17 //l=0.17 //layer=licon //count=1 \
 //x=6.41 //y=2.26 //x2=6.41 //y2=2.26
r580 (  99 207 ) resistor r=23.615 //w=0.187 //l=0.345 //layer=li \
 //thickness=0.1 //x=3.78 //y=5.56 //x2=3.78 //y2=5.905
r581 (  91 206 ) resistor r=23.615 //w=0.187 //l=0.345 //layer=li \
 //thickness=0.1 //x=2.9 //y=5.56 //x2=2.9 //y2=5.905
r582 (  83 205 ) resistor r=23.615 //w=0.187 //l=0.345 //layer=li \
 //thickness=0.1 //x=2.02 //y=5.56 //x2=2.02 //y2=5.905
r583 (  75 77 ) resistor r=0.10734 //w=0.281 //l=0.16 //layer=m2 \
 //thickness=0.36 //x=4.565 //y=3.885 //x2=4.725 //y2=3.885
r584 (  72 81 ) resistor r=1.03061 //w=0.197 //l=1.62499 //layer=m2 \
 //thickness=0.36 //x=17.73 //y=3.87 //x2=19.35 //y2=3.88
r585 (  72 73 ) resistor r=0.410305 //w=0.131 //l=0.43 //layer=m2 \
 //thickness=0.36 //x=17.73 //y=3.87 //x2=17.3 //y2=3.87
r586 (  70 73 ) resistor r=0.125 //w=0.17 //l=0.174929 //layer=m2 \
 //thickness=0.36 //x=17.13 //y=3.88 //x2=17.3 //y2=3.87
r587 (  70 71 ) resistor r=2.08969 //w=0.131 //l=2.19 //layer=m2 \
 //thickness=0.36 //x=17.13 //y=3.88 //x2=14.94 //y2=3.88
r588 (  68 71 ) resistor r=0.125 //w=0.17 //l=0.179722 //layer=m2 \
 //thickness=0.36 //x=14.77 //y=3.9 //x2=14.94 //y2=3.88
r589 (  68 69 ) resistor r=0.329198 //w=0.131 //l=0.345 //layer=m2 \
 //thickness=0.36 //x=14.77 //y=3.9 //x2=14.425 //y2=3.9
r590 (  66 69 ) resistor r=0.1875 //w=0.17 //l=0.264811 //layer=m2 \
 //thickness=0.36 //x=14.17 //y=3.88 //x2=14.425 //y2=3.9
r591 (  66 67 ) resistor r=1.03531 //w=0.131 //l=1.085 //layer=m2 \
 //thickness=0.36 //x=14.17 //y=3.88 //x2=13.085 //y2=3.88
r592 (  64 67 ) resistor r=0.125 //w=0.17 //l=0.179722 //layer=m2 \
 //thickness=0.36 //x=12.915 //y=3.9 //x2=13.085 //y2=3.88
r593 (  64 65 ) resistor r=0.329198 //w=0.131 //l=0.345 //layer=m2 \
 //thickness=0.36 //x=12.915 //y=3.9 //x2=12.57 //y2=3.9
r594 (  62 65 ) resistor r=0.286765 //w=0.17 //l=0.407124 //layer=m2 \
 //thickness=0.36 //x=12.18 //y=3.865 //x2=12.57 //y2=3.9
r595 (  62 63 ) resistor r=0.410305 //w=0.131 //l=0.43 //layer=m2 \
 //thickness=0.36 //x=12.18 //y=3.865 //x2=11.75 //y2=3.865
r596 (  60 63 ) resistor r=0.231618 //w=0.17 //l=0.329659 //layer=m2 \
 //thickness=0.36 //x=11.435 //y=3.895 //x2=11.75 //y2=3.865
r597 (  60 61 ) resistor r=0.329198 //w=0.131 //l=0.345 //layer=m2 \
 //thickness=0.36 //x=11.435 //y=3.895 //x2=11.09 //y2=3.895
r598 (  58 61 ) resistor r=0.1875 //w=0.17 //l=0.262393 //layer=m2 \
 //thickness=0.36 //x=10.835 //y=3.88 //x2=11.09 //y2=3.895
r599 (  58 59 ) resistor r=1.02576 //w=0.131 //l=1.075 //layer=m2 \
 //thickness=0.36 //x=10.835 //y=3.88 //x2=9.76 //y2=3.88
r600 (  57 79 ) resistor r=1.89299 //w=0.187 //l=2.83749 //layer=m2 \
 //thickness=0.36 //x=9.245 //y=3.895 //x2=6.415 //y2=3.88
r601 (  56 59 ) resistor r=0.125 //w=0.17 //l=0.177341 //layer=m2 \
 //thickness=0.36 //x=9.59 //y=3.895 //x2=9.76 //y2=3.88
r602 (  56 57 ) resistor r=0.329198 //w=0.131 //l=0.345 //layer=m2 \
 //thickness=0.36 //x=9.59 //y=3.895 //x2=9.245 //y2=3.895
r603 (  54 79 ) resistor r=0.108234 //w=0.187 //l=0.16 //layer=m2 \
 //thickness=0.36 //x=6.255 //y=3.88 //x2=6.415 //y2=3.88
r604 (  54 77 ) resistor r=1.45992 //w=0.131 //l=1.53 //layer=m2 \
 //thickness=0.36 //x=6.255 //y=3.88 //x2=4.725 //y2=3.88
r605 (  53 139 ) resistor r=9.3 //w=0.17 //l=0.17 //layer=mcon //count=1 \
 //x=19.36 //y=4.88 //x2=19.36 //y2=4.88
r606 (  51 130 ) resistor r=9.3 //w=0.17 //l=0.17 //layer=mcon //count=1 \
 //x=19.36 //y=2.26 //x2=19.36 //y2=2.26
r607 (  48 81 ) resistor r=4.5 //w=0.15 //l=0.15 //layer=via1 //count=1 \
 //x=19.35 //y=3.88 //x2=19.35 //y2=3.88
r608 (  45 79 ) resistor r=4.5 //w=0.15 //l=0.15 //layer=via1 //count=1 \
 //x=6.415 //y=3.88 //x2=6.415 //y2=3.88
r609 (  43 125 ) resistor r=9.3 //w=0.17 //l=0.17 //layer=mcon //count=1 \
 //x=6.41 //y=4.88 //x2=6.41 //y2=4.88
r610 (  41 116 ) resistor r=9.3 //w=0.17 //l=0.17 //layer=mcon //count=1 \
 //x=6.41 //y=2.26 //x2=6.41 //y2=2.26
r611 (  39 75 ) resistor r=4.5 //w=0.15 //l=0.15 //layer=via1 //count=1 \
 //x=4.565 //y=3.885 //x2=4.565 //y2=3.885
r612 (  37 39 ) resistor r=0.00167112 //w=0.374 //l=0.005 //layer=m1 \
 //thickness=0.36 //x=4.615 //y=3.88 //x2=4.615 //y2=3.885
r613 (  35 203 ) resistor r=9.3 //w=0.17 //l=0.17 //layer=mcon //count=1 \
 //x=4.075 //y=1.19 //x2=4.075 //y2=1.19
r614 (  33 99 ) resistor r=9.3 //w=0.17 //l=0.17 //layer=mcon //count=1 \
 //x=3.78 //y=5.56 //x2=3.78 //y2=5.56
r615 (  30 91 ) resistor r=9.3 //w=0.17 //l=0.17 //layer=mcon //count=1 \
 //x=2.9 //y=5.56 //x2=2.9 //y2=5.56
r616 (  28 30 ) resistor r=0.121228 //w=0.232 //l=0.225 //layer=m1 \
 //thickness=0.36 //x=2.9 //y=5.335 //x2=2.9 //y2=5.56
r617 (  27 83 ) resistor r=9.3 //w=0.17 //l=0.17 //layer=mcon //count=1 \
 //x=2.02 //y=5.56 //x2=2.02 //y2=5.56
r618 (  25 27 ) resistor r=0.129608 //w=0.217 //l=0.225 //layer=m1 \
 //thickness=0.36 //x=2.022 //y=5.335 //x2=2.022 //y2=5.56
r619 (  24 53 ) resistor r=0.0760407 //w=0.238 //l=0.125 //layer=m1 \
 //thickness=0.36 //x=19.36 //y=4.755 //x2=19.36 //y2=4.88
r620 (  23 48 ) resistor r=0.0909648 //w=0.371 //l=0.186762 //layer=m1 \
 //thickness=0.36 //x=19.36 //y=4.04 //x2=19.302 //y2=3.88
r621 (  23 24 ) resistor r=0.682252 //w=0.131 //l=0.715 //layer=m1 \
 //thickness=0.36 //x=19.36 //y=4.04 //x2=19.36 //y2=4.755
r622 (  22 48 ) resistor r=0.0909648 //w=0.371 //l=0.186762 //layer=m1 \
 //thickness=0.36 //x=19.36 //y=3.72 //x2=19.302 //y2=3.88
r623 (  21 51 ) resistor r=0.0719237 //w=0.222 //l=0.115 //layer=m1 \
 //thickness=0.36 //x=19.36 //y=2.375 //x2=19.36 //y2=2.26
r624 (  21 22 ) resistor r=1.2834 //w=0.131 //l=1.345 //layer=m1 \
 //thickness=0.36 //x=19.36 //y=2.375 //x2=19.36 //y2=3.72
r625 (  20 43 ) resistor r=0.0760407 //w=0.238 //l=0.125 //layer=m1 \
 //thickness=0.36 //x=6.41 //y=4.755 //x2=6.41 //y2=4.88
r626 (  19 45 ) resistor r=0.0910802 //w=0.374 //l=0.185472 //layer=m1 \
 //thickness=0.36 //x=6.41 //y=4.04 //x2=6.465 //y2=3.88
r627 (  19 20 ) resistor r=0.682252 //w=0.131 //l=0.715 //layer=m1 \
 //thickness=0.36 //x=6.41 //y=4.04 //x2=6.41 //y2=4.755
r628 (  18 45 ) resistor r=0.0910802 //w=0.374 //l=0.185472 //layer=m1 \
 //thickness=0.36 //x=6.41 //y=3.72 //x2=6.465 //y2=3.88
r629 (  17 41 ) resistor r=0.0719237 //w=0.222 //l=0.115 //layer=m1 \
 //thickness=0.36 //x=6.41 //y=2.375 //x2=6.41 //y2=2.26
r630 (  17 18 ) resistor r=1.2834 //w=0.131 //l=1.345 //layer=m1 \
 //thickness=0.36 //x=6.41 //y=2.375 //x2=6.41 //y2=3.72
r631 (  15 39 ) resistor r=0.0910802 //w=0.374 //l=0.185472 //layer=m1 \
 //thickness=0.36 //x=4.56 //y=4.045 //x2=4.615 //y2=3.885
r632 (  15 16 ) resistor r=1.14981 //w=0.131 //l=1.205 //layer=m1 \
 //thickness=0.36 //x=4.56 //y=4.045 //x2=4.56 //y2=5.25
r633 (  14 37 ) resistor r=0.089409 //w=0.374 //l=0.180416 //layer=m1 \
 //thickness=0.36 //x=4.56 //y=3.725 //x2=4.615 //y2=3.88
r634 (  13 14 ) resistor r=1.71279 //w=0.131 //l=1.795 //layer=m1 \
 //thickness=0.36 //x=4.56 //y=1.93 //x2=4.56 //y2=3.725
r635 (  11 13 ) resistor r=0.0698411 //w=0.17 //l=0.120208 //layer=m1 \
 //thickness=0.36 //x=4.475 //y=1.845 //x2=4.56 //y2=1.93
r636 (  11 12 ) resistor r=0.300573 //w=0.131 //l=0.315 //layer=m1 \
 //thickness=0.36 //x=4.475 //y=1.845 //x2=4.16 //y2=1.845
r637 (  10 12 ) resistor r=0.0698411 //w=0.17 //l=0.120208 //layer=m1 \
 //thickness=0.36 //x=4.075 //y=1.76 //x2=4.16 //y2=1.845
r638 (  9 35 ) resistor r=0.0717383 //w=0.224 //l=0.115 //layer=m1 \
 //thickness=0.36 //x=4.075 //y=1.305 //x2=4.075 //y2=1.19
r639 (  9 10 ) resistor r=0.43416 //w=0.131 //l=0.455 //layer=m1 \
 //thickness=0.36 //x=4.075 //y=1.305 //x2=4.075 //y2=1.76
r640 (  8 31 ) resistor r=0.0675342 //w=0.23 //l=0.115 //layer=m1 \
 //thickness=0.36 //x=3.895 //y=5.335 //x2=3.78 //y2=5.335
r641 (  7 16 ) resistor r=0.0698411 //w=0.17 //l=0.120208 //layer=m1 \
 //thickness=0.36 //x=4.475 //y=5.335 //x2=4.56 //y2=5.25
r642 (  7 8 ) resistor r=0.553435 //w=0.131 //l=0.58 //layer=m1 \
 //thickness=0.36 //x=4.475 //y=5.335 //x2=3.895 //y2=5.335
r643 (  6 33 ) resistor r=0.00118313 //w=0.23 //layer=m1 //thickness=0.36 \
 //x=3.78 //y=5.56 //x2=3.78 //y2=5.56
r644 (  5 31 ) resistor r=0.002872 //w=0.34 //l=0.085 //layer=m1 \
 //thickness=0.36 //x=3.78 //y=5.42 //x2=3.78 //y2=5.335
r645 (  5 6 ) resistor r=0.091623 //w=0.191 //l=0.14 //layer=m1 \
 //thickness=0.36 //x=3.78 //y=5.42 //x2=3.78 //y2=5.56
r646 (  4 28 ) resistor r=0.0262263 //w=0.232 //l=0.12 //layer=m1 \
 //thickness=0.36 //x=3.02 //y=5.335 //x2=2.9 //y2=5.335
r647 (  3 31 ) resistor r=0.0675342 //w=0.23 //l=0.115 //layer=m1 \
 //thickness=0.36 //x=3.665 //y=5.335 //x2=3.78 //y2=5.335
r648 (  3 4 ) resistor r=0.615458 //w=0.131 //l=0.645 //layer=m1 \
 //thickness=0.36 //x=3.665 //y=5.335 //x2=3.02 //y2=5.335
r649 (  2 25 ) resistor r=0.0222262 //w=0.217 //l=0.118 //layer=m1 \
 //thickness=0.36 //x=2.14 //y=5.335 //x2=2.022 //y2=5.335
r650 (  1 28 ) resistor r=0.0262263 //w=0.232 //l=0.12 //layer=m1 \
 //thickness=0.36 //x=2.78 //y=5.335 //x2=2.9 //y2=5.335
r651 (  1 2 ) resistor r=0.610687 //w=0.131 //l=0.64 //layer=m1 \
 //thickness=0.36 //x=2.78 //y=5.335 //x2=2.14 //y2=5.335
ends PM_DFFRNX1\%noxref_4

subckt PM_DFFRNX1\%RN ( 1 2 3 4 5 6 7 8 10 13 14 15 16 45 49 50 52 53 56 61 66 \
 71 76 81 85 86 87 88 89 90 91 92 93 97 98 99 104 106 109 110 114 115 116 121 \
 123 126 127 128 129 130 132 138 139 140 141 142 148 149 154 158 159 164 170 )
c427 ( 170 0 ) capacitor c=0.0369044f //x=20.47 //y=4.88
c428 ( 164 0 ) capacitor c=0.0710579f //x=16.77 //y=4.88
c429 ( 159 0 ) capacitor c=0.0278202f //x=16.77 //y=2.095
c430 ( 158 0 ) capacitor c=0.0490597f //x=16.77 //y=2.26
c431 ( 154 0 ) capacitor c=0.0710579f //x=8.63 //y=4.88
c432 ( 149 0 ) capacitor c=0.0278202f //x=8.63 //y=2.095
c433 ( 148 0 ) capacitor c=0.0490597f //x=8.63 //y=2.26
c434 ( 142 0 ) capacitor c=0.0309248f //x=20.805 //y=4.97
c435 ( 141 0 ) capacitor c=0.0852528f //x=20.56 //y=2.095
c436 ( 140 0 ) capacitor c=0.0170266f //x=20.56 //y=1.63
c437 ( 139 0 ) capacitor c=0.018609f //x=20.56 //y=1.4
c438 ( 138 0 ) capacitor c=0.0186599f //x=20.56 //y=1.09
c439 ( 132 0 ) capacitor c=0.0146988f //x=20.405 //y=1.555
c440 ( 130 0 ) capacitor c=0.0148531f //x=20.405 //y=0.935
c441 ( 129 0 ) capacitor c=0.0334406f //x=20.035 //y=1.4
c442 ( 128 0 ) capacitor c=0.0173191f //x=20.035 //y=1.09
c443 ( 127 0 ) capacitor c=0.0443175f //x=17.29 //y=1.44
c444 ( 126 0 ) capacitor c=0.0199703f //x=17.29 //y=1.095
c445 ( 123 0 ) capacitor c=0.0160331f //x=17.135 //y=1.595
c446 ( 121 0 ) capacitor c=0.0157807f //x=17.135 //y=0.94
c447 ( 116 0 ) capacitor c=0.0219045f //x=16.76 //y=1.75
c448 ( 115 0 ) capacitor c=0.0207489f //x=16.76 //y=1.44
c449 ( 114 0 ) capacitor c=0.0194091f //x=16.76 //y=1.095
c450 ( 110 0 ) capacitor c=0.0443175f //x=9.15 //y=1.44
c451 ( 109 0 ) capacitor c=0.0199703f //x=9.15 //y=1.095
c452 ( 106 0 ) capacitor c=0.0160331f //x=8.995 //y=1.595
c453 ( 104 0 ) capacitor c=0.0157807f //x=8.995 //y=0.94
c454 ( 99 0 ) capacitor c=0.0219045f //x=8.62 //y=1.75
c455 ( 98 0 ) capacitor c=0.0207489f //x=8.62 //y=1.44
c456 ( 97 0 ) capacitor c=0.0194091f //x=8.62 //y=1.095
c457 ( 93 0 ) capacitor c=0.110208f //x=20.88 //y=6.2
c458 ( 92 0 ) capacitor c=0.110214f //x=20.44 //y=6.2
c459 ( 91 0 ) capacitor c=0.159671f //x=16.95 //y=6.2
c460 ( 90 0 ) capacitor c=0.110208f //x=16.51 //y=6.2
c461 ( 89 0 ) capacitor c=0.159671f //x=8.81 //y=6.2
c462 ( 88 0 ) capacitor c=0.110208f //x=8.37 //y=6.2
c463 ( 81 0 ) capacitor c=0.00129935f //x=20.47 //y=4.88
c464 ( 76 0 ) capacitor c=0.00121786f //x=20.47 //y=2.26
c465 ( 71 0 ) capacitor c=7.7417e-19 //x=16.77 //y=4.88
c466 ( 66 0 ) capacitor c=0.00118671f //x=16.77 //y=2.26
c467 ( 61 0 ) capacitor c=7.7417e-19 //x=8.63 //y=4.88
c468 ( 56 0 ) capacitor c=0.00118671f //x=8.63 //y=2.26
c469 ( 53 0 ) capacitor c=0.0960316f //x=20.265 //y=2.355
c470 ( 52 0 ) capacitor c=0.00565742f //x=20.425 //y=2.355
c471 ( 50 0 ) capacitor c=0.0061184f //x=16.935 //y=2.315
c472 ( 49 0 ) capacitor c=0.212759f //x=16.615 //y=2.315
c473 ( 45 0 ) capacitor c=0.00623589f //x=8.635 //y=2.305
c474 ( 16 0 ) capacitor c=0.00506049f //x=20.47 //y=4.765
c475 ( 15 0 ) capacitor c=0.00939356f //x=20.47 //y=2.515
c476 ( 14 0 ) capacitor c=0.0645818f //x=16.77 //y=4.75
c477 ( 13 0 ) capacitor c=0.0110145f //x=16.77 //y=2.465
c478 ( 10 0 ) capacitor c=0.00452448f //x=8.63 //y=4.75
c479 ( 7 0 ) capacitor c=0.0111886f //x=8.63 //y=2.4
c480 ( 3 0 ) capacitor c=0.0644988f //x=20.47 //y=2.77
c481 ( 1 0 ) capacitor c=0.0588754f //x=8.63 //y=2.77
r482 (  172 173 ) resistor r=32.4568 //w=0.214 //l=0.075 //layer=ply \
 //thickness=0.18 //x=20.47 //y=4.97 //x2=20.47 //y2=5.045
r483 (  170 172 ) resistor r=20.271 //w=0.214 //l=0.09 //layer=ply \
 //thickness=0.18 //x=20.47 //y=4.88 //x2=20.47 //y2=4.97
r484 (  158 159 ) resistor r=52.7279 //w=0.214 //l=0.165 //layer=ply \
 //thickness=0.18 //x=16.77 //y=2.26 //x2=16.77 //y2=2.095
r485 (  148 149 ) resistor r=52.7279 //w=0.214 //l=0.165 //layer=ply \
 //thickness=0.18 //x=8.63 //y=2.26 //x2=8.63 //y2=2.095
r486 (  143 172 ) resistor r=16.5046 //w=0.27 //l=0.135 //layer=ply \
 //thickness=0.18 //x=20.605 //y=4.97 //x2=20.47 //y2=4.97
r487 (  142 144 ) resistor r=26.9307 //w=0.15 //l=0.106066 //layer=ply \
 //thickness=0.18 //x=20.805 //y=4.97 //x2=20.88 //y2=5.045
r488 (  142 143 ) resistor r=102.553 //w=0.094 //l=0.2 //layer=ply \
 //thickness=0.18 //x=20.805 //y=4.97 //x2=20.605 //y2=4.97
r489 (  141 177 ) resistor r=38.6777 //w=0.284 //l=0.198997 //layer=ply \
 //thickness=0.18 //x=20.56 //y=2.095 //x2=20.485 //y2=2.26
r490 (  140 175 ) resistor r=21.2976 //w=0.217 //l=0.0928709 //layer=ply \
 //thickness=0.18 //x=20.56 //y=1.63 //x2=20.52 //y2=1.555
r491 (  140 141 ) resistor r=238.436 //w=0.094 //l=0.465 //layer=ply \
 //thickness=0.18 //x=20.56 //y=1.63 //x2=20.56 //y2=2.095
r492 (  139 175 ) resistor r=39.0671 //w=0.217 //l=0.173853 //layer=ply \
 //thickness=0.18 //x=20.56 //y=1.4 //x2=20.52 //y2=1.555
r493 (  138 174 ) resistor r=45.1352 //w=0.168 //l=0.173853 //layer=ply \
 //thickness=0.18 //x=20.56 //y=1.09 //x2=20.52 //y2=0.935
r494 (  138 139 ) resistor r=158.957 //w=0.094 //l=0.31 //layer=ply \
 //thickness=0.18 //x=20.56 //y=1.09 //x2=20.56 //y2=1.4
r495 (  133 168 ) resistor r=5.52526 //w=0.168 //l=0.115 //layer=ply \
 //thickness=0.18 //x=20.19 //y=1.555 //x2=20.075 //y2=1.555
r496 (  132 175 ) resistor r=11.4558 //w=0.217 //l=0.115 //layer=ply \
 //thickness=0.18 //x=20.405 //y=1.555 //x2=20.52 //y2=1.555
r497 (  131 167 ) resistor r=5.52526 //w=0.168 //l=0.115 //layer=ply \
 //thickness=0.18 //x=20.19 //y=0.935 //x2=20.075 //y2=0.935
r498 (  130 174 ) resistor r=5.52526 //w=0.168 //l=0.115 //layer=ply \
 //thickness=0.18 //x=20.405 //y=0.935 //x2=20.52 //y2=0.935
r499 (  130 131 ) resistor r=110.245 //w=0.094 //l=0.215 //layer=ply \
 //thickness=0.18 //x=20.405 //y=0.935 //x2=20.19 //y2=0.935
r500 (  129 168 ) resistor r=45.1352 //w=0.168 //l=0.173853 //layer=ply \
 //thickness=0.18 //x=20.035 //y=1.4 //x2=20.075 //y2=1.555
r501 (  128 167 ) resistor r=45.1352 //w=0.168 //l=0.173853 //layer=ply \
 //thickness=0.18 //x=20.035 //y=1.09 //x2=20.075 //y2=0.935
r502 (  128 129 ) resistor r=158.957 //w=0.094 //l=0.31 //layer=ply \
 //thickness=0.18 //x=20.035 //y=1.09 //x2=20.035 //y2=1.4
r503 (  127 166 ) resistor r=45.1352 //w=0.168 //l=0.173853 //layer=ply \
 //thickness=0.18 //x=17.29 //y=1.44 //x2=17.25 //y2=1.595
r504 (  126 165 ) resistor r=45.1352 //w=0.168 //l=0.173853 //layer=ply \
 //thickness=0.18 //x=17.29 //y=1.095 //x2=17.25 //y2=0.94
r505 (  126 127 ) resistor r=176.904 //w=0.094 //l=0.345 //layer=ply \
 //thickness=0.18 //x=17.29 //y=1.095 //x2=17.29 //y2=1.44
r506 (  124 162 ) resistor r=10.701 //w=0.21 //l=0.115 //layer=ply \
 //thickness=0.18 //x=16.915 //y=1.595 //x2=16.8 //y2=1.595
r507 (  123 166 ) resistor r=5.52526 //w=0.168 //l=0.115 //layer=ply \
 //thickness=0.18 //x=17.135 //y=1.595 //x2=17.25 //y2=1.595
r508 (  122 161 ) resistor r=5.52526 //w=0.168 //l=0.115 //layer=ply \
 //thickness=0.18 //x=16.915 //y=0.94 //x2=16.8 //y2=0.94
r509 (  121 165 ) resistor r=5.52526 //w=0.168 //l=0.115 //layer=ply \
 //thickness=0.18 //x=17.135 //y=0.94 //x2=17.25 //y2=0.94
r510 (  121 122 ) resistor r=112.809 //w=0.094 //l=0.22 //layer=ply \
 //thickness=0.18 //x=17.135 //y=0.94 //x2=16.915 //y2=0.94
r511 (  118 164 ) resistor r=37.236 //w=0.233 //l=0.249199 //layer=ply \
 //thickness=0.18 //x=16.95 //y=5.045 //x2=16.77 //y2=4.88
r512 (  116 162 ) resistor r=39.5823 //w=0.21 //l=0.173853 //layer=ply \
 //thickness=0.18 //x=16.76 //y=1.75 //x2=16.8 //y2=1.595
r513 (  116 159 ) resistor r=176.904 //w=0.094 //l=0.345 //layer=ply \
 //thickness=0.18 //x=16.76 //y=1.75 //x2=16.76 //y2=2.095
r514 (  115 162 ) resistor r=39.5823 //w=0.21 //l=0.173853 //layer=ply \
 //thickness=0.18 //x=16.76 //y=1.44 //x2=16.8 //y2=1.595
r515 (  114 161 ) resistor r=45.1352 //w=0.168 //l=0.173853 //layer=ply \
 //thickness=0.18 //x=16.76 //y=1.095 //x2=16.8 //y2=0.94
r516 (  114 115 ) resistor r=176.904 //w=0.094 //l=0.345 //layer=ply \
 //thickness=0.18 //x=16.76 //y=1.095 //x2=16.76 //y2=1.44
r517 (  111 164 ) resistor r=53.7854 //w=0.233 //l=0.332415 //layer=ply \
 //thickness=0.18 //x=16.51 //y=5.045 //x2=16.77 //y2=4.88
r518 (  110 156 ) resistor r=45.1352 //w=0.168 //l=0.173853 //layer=ply \
 //thickness=0.18 //x=9.15 //y=1.44 //x2=9.11 //y2=1.595
r519 (  109 155 ) resistor r=45.1352 //w=0.168 //l=0.173853 //layer=ply \
 //thickness=0.18 //x=9.15 //y=1.095 //x2=9.11 //y2=0.94
r520 (  109 110 ) resistor r=176.904 //w=0.094 //l=0.345 //layer=ply \
 //thickness=0.18 //x=9.15 //y=1.095 //x2=9.15 //y2=1.44
r521 (  107 152 ) resistor r=10.701 //w=0.21 //l=0.115 //layer=ply \
 //thickness=0.18 //x=8.775 //y=1.595 //x2=8.66 //y2=1.595
r522 (  106 156 ) resistor r=5.52526 //w=0.168 //l=0.115 //layer=ply \
 //thickness=0.18 //x=8.995 //y=1.595 //x2=9.11 //y2=1.595
r523 (  105 151 ) resistor r=5.52526 //w=0.168 //l=0.115 //layer=ply \
 //thickness=0.18 //x=8.775 //y=0.94 //x2=8.66 //y2=0.94
r524 (  104 155 ) resistor r=5.52526 //w=0.168 //l=0.115 //layer=ply \
 //thickness=0.18 //x=8.995 //y=0.94 //x2=9.11 //y2=0.94
r525 (  104 105 ) resistor r=112.809 //w=0.094 //l=0.22 //layer=ply \
 //thickness=0.18 //x=8.995 //y=0.94 //x2=8.775 //y2=0.94
r526 (  101 154 ) resistor r=37.236 //w=0.233 //l=0.249199 //layer=ply \
 //thickness=0.18 //x=8.81 //y=5.045 //x2=8.63 //y2=4.88
r527 (  99 152 ) resistor r=39.5823 //w=0.21 //l=0.173853 //layer=ply \
 //thickness=0.18 //x=8.62 //y=1.75 //x2=8.66 //y2=1.595
r528 (  99 149 ) resistor r=176.904 //w=0.094 //l=0.345 //layer=ply \
 //thickness=0.18 //x=8.62 //y=1.75 //x2=8.62 //y2=2.095
r529 (  98 152 ) resistor r=39.5823 //w=0.21 //l=0.173853 //layer=ply \
 //thickness=0.18 //x=8.62 //y=1.44 //x2=8.66 //y2=1.595
r530 (  97 151 ) resistor r=45.1352 //w=0.168 //l=0.173853 //layer=ply \
 //thickness=0.18 //x=8.62 //y=1.095 //x2=8.66 //y2=0.94
r531 (  97 98 ) resistor r=176.904 //w=0.094 //l=0.345 //layer=ply \
 //thickness=0.18 //x=8.62 //y=1.095 //x2=8.62 //y2=1.44
r532 (  94 154 ) resistor r=53.7854 //w=0.233 //l=0.332415 //layer=ply \
 //thickness=0.18 //x=8.37 //y=5.045 //x2=8.63 //y2=4.88
r533 (  93 144 ) resistor r=592.245 //w=0.094 //l=1.155 //layer=ply \
 //thickness=0.18 //x=20.88 //y=6.2 //x2=20.88 //y2=5.045
r534 (  92 173 ) resistor r=592.245 //w=0.094 //l=1.155 //layer=ply \
 //thickness=0.18 //x=20.44 //y=6.2 //x2=20.44 //y2=5.045
r535 (  91 118 ) resistor r=592.245 //w=0.094 //l=1.155 //layer=ply \
 //thickness=0.18 //x=16.95 //y=6.2 //x2=16.95 //y2=5.045
r536 (  90 111 ) resistor r=592.245 //w=0.094 //l=1.155 //layer=ply \
 //thickness=0.18 //x=16.51 //y=6.2 //x2=16.51 //y2=5.045
r537 (  89 101 ) resistor r=592.245 //w=0.094 //l=1.155 //layer=ply \
 //thickness=0.18 //x=8.81 //y=6.2 //x2=8.81 //y2=5.045
r538 (  88 94 ) resistor r=592.245 //w=0.094 //l=1.155 //layer=ply \
 //thickness=0.18 //x=8.37 //y=6.2 //x2=8.37 //y2=5.045
r539 (  87 132 ) resistor r=55.3787 //w=0.094 //l=0.108 //layer=ply \
 //thickness=0.18 //x=20.297 //y=1.555 //x2=20.405 //y2=1.555
r540 (  87 133 ) resistor r=54.866 //w=0.094 //l=0.107 //layer=ply \
 //thickness=0.18 //x=20.297 //y=1.555 //x2=20.19 //y2=1.555
r541 (  86 123 ) resistor r=56.4043 //w=0.094 //l=0.11 //layer=ply \
 //thickness=0.18 //x=17.025 //y=1.595 //x2=17.135 //y2=1.595
r542 (  86 124 ) resistor r=56.4043 //w=0.094 //l=0.11 //layer=ply \
 //thickness=0.18 //x=17.025 //y=1.595 //x2=16.915 //y2=1.595
r543 (  85 106 ) resistor r=56.4043 //w=0.094 //l=0.11 //layer=ply \
 //thickness=0.18 //x=8.885 //y=1.595 //x2=8.995 //y2=1.595
r544 (  85 107 ) resistor r=56.4043 //w=0.094 //l=0.11 //layer=ply \
 //thickness=0.18 //x=8.885 //y=1.595 //x2=8.775 //y2=1.595
r545 (  81 170 ) resistor r=152 //w=0.17 //l=0.17 //layer=licon //count=1 \
 //x=20.47 //y=4.88 //x2=20.47 //y2=4.88
r546 (  76 177 ) resistor r=152 //w=0.17 //l=0.17 //layer=licon //count=1 \
 //x=20.47 //y=2.26 //x2=20.47 //y2=2.26
r547 (  71 164 ) resistor r=152 //w=0.17 //l=0.17 //layer=licon //count=1 \
 //x=16.77 //y=4.88 //x2=16.77 //y2=4.88
r548 (  66 158 ) resistor r=152 //w=0.17 //l=0.17 //layer=licon //count=1 \
 //x=16.77 //y=2.26 //x2=16.77 //y2=2.26
r549 (  61 154 ) resistor r=152 //w=0.17 //l=0.17 //layer=licon //count=1 \
 //x=8.63 //y=4.88 //x2=8.63 //y2=4.88
r550 (  56 148 ) resistor r=152 //w=0.17 //l=0.17 //layer=licon //count=1 \
 //x=8.63 //y=2.26 //x2=8.63 //y2=2.26
r551 (  52 53 ) resistor r=0.10734 //w=0.281 //l=0.16 //layer=m2 \
 //thickness=0.36 //x=20.425 //y=2.355 //x2=20.265 //y2=2.355
r552 (  50 53 ) resistor r=3.17748 //w=0.131 //l=3.33 //layer=m2 \
 //thickness=0.36 //x=16.935 //y=2.4 //x2=20.265 //y2=2.4
r553 (  48 50 ) resistor r=0.107331 //w=0.301 //l=0.16 //layer=m2 \
 //thickness=0.36 //x=16.775 //y=2.315 //x2=16.935 //y2=2.315
r554 (  48 49 ) resistor r=0.107331 //w=0.301 //l=0.16 //layer=m2 \
 //thickness=0.36 //x=16.775 //y=2.315 //x2=16.615 //y2=2.315
r555 (  45 46 ) resistor r=0.0373428 //w=0.318 //l=0.095 //layer=m2 \
 //thickness=0.36 //x=8.635 //y=2.305 //x2=8.635 //y2=2.4
r556 (  41 46 ) resistor r=0.0451273 //w=0.318 //l=0.16 //layer=m2 \
 //thickness=0.36 //x=8.795 //y=2.4 //x2=8.635 //y2=2.4
r557 (  41 49 ) resistor r=7.46183 //w=0.131 //l=7.82 //layer=m2 \
 //thickness=0.36 //x=8.795 //y=2.4 //x2=16.615 //y2=2.4
r558 (  38 52 ) resistor r=4.5 //w=0.15 //l=0.15 //layer=via1 //count=1 \
 //x=20.425 //y=2.355 //x2=20.425 //y2=2.355
r559 (  36 76 ) resistor r=9.3 //w=0.17 //l=0.17 //layer=mcon //count=1 \
 //x=20.47 //y=2.26 //x2=20.47 //y2=2.26
r560 (  36 38 ) resistor r=0.0401182 //w=0.296 //l=0.095 //layer=m1 \
 //thickness=0.36 //x=20.427 //y=2.26 //x2=20.427 //y2=2.355
r561 (  34 81 ) resistor r=9.3 //w=0.17 //l=0.17 //layer=mcon //count=1 \
 //x=20.47 //y=4.88 //x2=20.47 //y2=4.88
r562 (  32 48 ) resistor r=4.5 //w=0.15 //l=0.15 //layer=via1 //count=1 \
 //x=16.775 //y=2.305 //x2=16.775 //y2=2.305
r563 (  30 66 ) resistor r=9.3 //w=0.17 //l=0.17 //layer=mcon //count=1 \
 //x=16.77 //y=2.26 //x2=16.77 //y2=2.26
r564 (  30 32 ) resistor r=0.0186258 //w=0.302 //l=0.045 //layer=m1 \
 //thickness=0.36 //x=16.775 //y=2.26 //x2=16.775 //y2=2.305
r565 (  28 71 ) resistor r=9.3 //w=0.17 //l=0.17 //layer=mcon //count=1 \
 //x=16.77 //y=4.88 //x2=16.77 //y2=4.88
r566 (  26 45 ) resistor r=4.5 //w=0.15 //l=0.15 //layer=via1 //count=1 \
 //x=8.635 //y=2.305 //x2=8.635 //y2=2.305
r567 (  22 61 ) resistor r=9.3 //w=0.17 //l=0.17 //layer=mcon //count=1 \
 //x=8.63 //y=4.88 //x2=8.63 //y2=4.88
r568 (  16 34 ) resistor r=0.0717383 //w=0.224 //l=0.115 //layer=m1 \
 //thickness=0.36 //x=20.47 //y=4.765 //x2=20.47 //y2=4.88
r569 (  14 28 ) resistor r=0.0801089 //w=0.224 //l=0.13 //layer=m1 \
 //thickness=0.36 //x=16.77 //y=4.75 //x2=16.77 //y2=4.88
r570 (  13 32 ) resistor r=0.0899119 //w=0.302 //l=0.162481 //layer=m1 \
 //thickness=0.36 //x=16.77 //y=2.465 //x2=16.775 //y2=2.305
r571 (  13 14 ) resistor r=2.18034 //w=0.131 //l=2.285 //layer=m1 \
 //thickness=0.36 //x=16.77 //y=2.465 //x2=16.77 //y2=4.75
r572 (  10 22 ) resistor r=0.0801089 //w=0.224 //l=0.13 //layer=m1 \
 //thickness=0.36 //x=8.63 //y=4.75 //x2=8.63 //y2=4.88
r573 (  8 15 ) resistor r=0.0710242 //w=0.296 //l=0.134796 //layer=m1 \
 //thickness=0.36 //x=20.427 //y=2.4 //x2=20.47 //y2=2.515
r574 (  8 38 ) resistor r=0.0190034 //w=0.296 //l=0.045 //layer=m1 \
 //thickness=0.36 //x=20.427 //y=2.4 //x2=20.427 //y2=2.355
r575 (  7 56 ) resistor r=9.3 //w=0.17 //l=0.17 //layer=mcon //count=1 \
 //x=8.63 //y=2.26 //x2=8.63 //y2=2.26
r576 (  7 26 ) resistor r=0.00179083 //w=0.349 //l=0.005 //layer=m1 \
 //thickness=0.36 //x=8.63 //y=2.28 //x2=8.635 //y2=2.28
r577 (  7 9 ) resistor r=0.050788 //w=0.349 //l=0.185 //layer=m1 \
 //thickness=0.36 //x=8.63 //y=2.28 //x2=8.63 //y2=2.465
r578 (  6 16 ) resistor r=0.844466 //w=0.131 //l=0.885 //layer=m1 \
 //thickness=0.36 //x=20.47 //y=3.88 //x2=20.47 //y2=4.765
r579 (  5 6 ) resistor r=0.353053 //w=0.131 //l=0.37 //layer=m1 \
 //thickness=0.36 //x=20.47 //y=3.51 //x2=20.47 //y2=3.88
r580 (  4 5 ) resistor r=0.353053 //w=0.131 //l=0.37 //layer=m1 \
 //thickness=0.36 //x=20.47 //y=3.14 //x2=20.47 //y2=3.51
r581 (  3 4 ) resistor r=0.353053 //w=0.131 //l=0.37 //layer=m1 \
 //thickness=0.36 //x=20.47 //y=2.77 //x2=20.47 //y2=3.14
r582 (  3 15 ) resistor r=0.243321 //w=0.131 //l=0.255 //layer=m1 \
 //thickness=0.36 //x=20.47 //y=2.77 //x2=20.47 //y2=2.515
r583 (  2 10 ) resistor r=1.53626 //w=0.131 //l=1.61 //layer=m1 \
 //thickness=0.36 //x=8.63 //y=3.14 //x2=8.63 //y2=4.75
r584 (  1 2 ) resistor r=0.353053 //w=0.131 //l=0.37 //layer=m1 \
 //thickness=0.36 //x=8.63 //y=2.77 //x2=8.63 //y2=3.14
r585 (  1 9 ) resistor r=0.291031 //w=0.131 //l=0.305 //layer=m1 \
 //thickness=0.36 //x=8.63 //y=2.77 //x2=8.63 //y2=2.465
ends PM_DFFRNX1\%RN

subckt PM_DFFRNX1\%QN ( 1 2 3 4 5 6 7 8 9 10 11 13 16 17 19 20 21 22 28 36 39 \
 42 45 59 62 70 72 73 76 84 92 109 118 122 123 124 125 126 127 128 132 134 137 \
 138 148 151 153 154 155 )
c276 ( 151 0 ) capacitor c=0.00885916f //x=21.645 //y=1.095
c277 ( 148 0 ) capacitor c=0.0682508f //x=24.17 //y=4.88
c278 ( 138 0 ) capacitor c=0.0318956f //x=24.505 //y=1.39
c279 ( 137 0 ) capacitor c=0.0186809f //x=24.505 //y=1.045
c280 ( 134 0 ) capacitor c=0.0141821f //x=24.35 //y=1.545
c281 ( 132 0 ) capacitor c=0.0158553f //x=24.35 //y=0.89
c282 ( 128 0 ) capacitor c=0.0854122f //x=23.975 //y=2.095
c283 ( 127 0 ) capacitor c=0.0229235f //x=23.975 //y=1.7
c284 ( 126 0 ) capacitor c=0.0234359f //x=23.975 //y=1.39
c285 ( 125 0 ) capacitor c=0.0198759f //x=23.975 //y=1.045
c286 ( 124 0 ) capacitor c=0.110369f //x=24.51 //y=6.2
c287 ( 123 0 ) capacitor c=0.154619f //x=24.07 //y=6.2
c288 ( 118 0 ) capacitor c=8.13425e-19 //x=24.17 //y=4.88
c289 ( 109 0 ) capacitor c=7.85889e-19 //x=24.17 //y=2.26
c290 ( 92 0 ) capacitor c=0.0293219f //x=21.54 //y=5.56
c291 ( 84 0 ) capacitor c=0.029137f //x=20.66 //y=5.56
c292 ( 76 0 ) capacitor c=0.0278099f //x=19.78 //y=5.56
c293 ( 73 0 ) capacitor c=0.0482322f //x=24.015 //y=3.495
c294 ( 72 0 ) capacitor c=0.00160636f //x=24.175 //y=3.495
c295 ( 70 0 ) capacitor c=0.00294786f //x=22.475 //y=3.495
c296 ( 62 0 ) capacitor c=0.00611632f //x=24.17 //y=4.88
c297 ( 59 0 ) capacitor c=0.00640017f //x=24.17 //y=2.26
c298 ( 45 0 ) capacitor c=9.35422e-19 //x=21.54 //y=5.335
c299 ( 42 0 ) capacitor c=0.00825613f //x=20.66 //y=5.335
c300 ( 39 0 ) capacitor c=0.0113499f //x=19.782 //y=5.335
c301 ( 36 0 ) capacitor c=0.0136451f //x=24.17 //y=3.655
c302 ( 28 0 ) capacitor c=0.0133931f //x=22.32 //y=3.655
c303 ( 22 0 ) capacitor c=0.00606427f //x=21.92 //y=1.845
c304 ( 21 0 ) capacitor c=0.0159979f //x=22.235 //y=1.845
c305 ( 20 0 ) capacitor c=0.0136149f //x=21.835 //y=1.76
c306 ( 19 0 ) capacitor c=0.0113476f //x=21.835 //y=1.305
c307 ( 17 0 ) capacitor c=0.024315f //x=22.235 //y=5.335
c308 ( 16 0 ) capacitor c=0.00906713f //x=21.54 //y=5.56
c309 ( 13 0 ) capacitor c=0.0199606f //x=21.425 //y=5.335
c310 ( 11 0 ) capacitor c=0.0154206f //x=20.54 //y=5.335
c311 ( 10 0 ) capacitor c=0.0167171f //x=24.17 //y=3.51
c312 ( 9 0 ) capacitor c=0.0173254f //x=22.32 //y=3.51
c313 ( 8 0 ) capacitor c=0.0267631f //x=24.17 //y=4.62
c314 ( 6 0 ) capacitor c=0.0285574f //x=24.17 //y=2.77
c315 ( 4 0 ) capacitor c=0.0418622f //x=22.32 //y=4.62
c316 ( 1 0 ) capacitor c=0.0402951f //x=22.32 //y=2.4
r317 (  146 148 ) resistor r=20.6867 //w=0.233 //l=0.1 //layer=ply \
 //thickness=0.18 //x=24.07 //y=4.88 //x2=24.17 //y2=4.88
r318 (  139 148 ) resistor r=70.3348 //w=0.233 //l=0.414367 //layer=ply \
 //thickness=0.18 //x=24.51 //y=5.045 //x2=24.17 //y2=4.88
r319 (  138 150 ) resistor r=45.1352 //w=0.168 //l=0.173853 //layer=ply \
 //thickness=0.18 //x=24.505 //y=1.39 //x2=24.465 //y2=1.545
r320 (  137 149 ) resistor r=45.1352 //w=0.168 //l=0.173853 //layer=ply \
 //thickness=0.18 //x=24.505 //y=1.045 //x2=24.465 //y2=0.89
r321 (  137 138 ) resistor r=176.904 //w=0.094 //l=0.345 //layer=ply \
 //thickness=0.18 //x=24.505 //y=1.045 //x2=24.505 //y2=1.39
r322 (  135 145 ) resistor r=10.701 //w=0.21 //l=0.115 //layer=ply \
 //thickness=0.18 //x=24.13 //y=1.545 //x2=24.015 //y2=1.545
r323 (  134 150 ) resistor r=5.52526 //w=0.168 //l=0.115 //layer=ply \
 //thickness=0.18 //x=24.35 //y=1.545 //x2=24.465 //y2=1.545
r324 (  133 144 ) resistor r=5.52526 //w=0.168 //l=0.115 //layer=ply \
 //thickness=0.18 //x=24.13 //y=0.89 //x2=24.015 //y2=0.89
r325 (  132 149 ) resistor r=5.52526 //w=0.168 //l=0.115 //layer=ply \
 //thickness=0.18 //x=24.35 //y=0.89 //x2=24.465 //y2=0.89
r326 (  132 133 ) resistor r=112.809 //w=0.094 //l=0.22 //layer=ply \
 //thickness=0.18 //x=24.35 //y=0.89 //x2=24.13 //y2=0.89
r327 (  129 146 ) resistor r=13.0941 //w=0.233 //l=0.165 //layer=ply \
 //thickness=0.18 //x=24.07 //y=5.045 //x2=24.07 //y2=4.88
r328 (  128 143 ) resistor r=34.8111 //w=0.27 //l=0.264953 //layer=ply \
 //thickness=0.18 //x=23.975 //y=2.095 //x2=24.17 //y2=2.26
r329 (  127 145 ) resistor r=39.5823 //w=0.21 //l=0.173853 //layer=ply \
 //thickness=0.18 //x=23.975 //y=1.7 //x2=24.015 //y2=1.545
r330 (  127 128 ) resistor r=202.543 //w=0.094 //l=0.395 //layer=ply \
 //thickness=0.18 //x=23.975 //y=1.7 //x2=23.975 //y2=2.095
r331 (  126 145 ) resistor r=39.5823 //w=0.21 //l=0.173853 //layer=ply \
 //thickness=0.18 //x=23.975 //y=1.39 //x2=24.015 //y2=1.545
r332 (  125 144 ) resistor r=45.1352 //w=0.168 //l=0.173853 //layer=ply \
 //thickness=0.18 //x=23.975 //y=1.045 //x2=24.015 //y2=0.89
r333 (  125 126 ) resistor r=176.904 //w=0.094 //l=0.345 //layer=ply \
 //thickness=0.18 //x=23.975 //y=1.045 //x2=23.975 //y2=1.39
r334 (  124 139 ) resistor r=592.245 //w=0.094 //l=1.155 //layer=ply \
 //thickness=0.18 //x=24.51 //y=6.2 //x2=24.51 //y2=5.045
r335 (  123 129 ) resistor r=592.245 //w=0.094 //l=1.155 //layer=ply \
 //thickness=0.18 //x=24.07 //y=6.2 //x2=24.07 //y2=5.045
r336 (  122 134 ) resistor r=56.4043 //w=0.094 //l=0.11 //layer=ply \
 //thickness=0.18 //x=24.24 //y=1.545 //x2=24.35 //y2=1.545
r337 (  122 135 ) resistor r=56.4043 //w=0.094 //l=0.11 //layer=ply \
 //thickness=0.18 //x=24.24 //y=1.545 //x2=24.13 //y2=1.545
r338 (  118 148 ) resistor r=152 //w=0.17 //l=0.17 //layer=licon //count=1 \
 //x=24.17 //y=4.88 //x2=24.17 //y2=4.88
r339 (  109 143 ) resistor r=152 //w=0.17 //l=0.17 //layer=licon //count=1 \
 //x=24.17 //y=2.26 //x2=24.17 //y2=2.26
r340 (  92 155 ) resistor r=23.615 //w=0.187 //l=0.345 //layer=li \
 //thickness=0.1 //x=21.54 //y=5.56 //x2=21.54 //y2=5.905
r341 (  84 154 ) resistor r=23.615 //w=0.187 //l=0.345 //layer=li \
 //thickness=0.1 //x=20.66 //y=5.56 //x2=20.66 //y2=5.905
r342 (  76 153 ) resistor r=23.615 //w=0.187 //l=0.345 //layer=li \
 //thickness=0.1 //x=19.78 //y=5.56 //x2=19.78 //y2=5.905
r343 (  72 73 ) resistor r=0.10734 //w=0.281 //l=0.16 //layer=m2 \
 //thickness=0.36 //x=24.175 //y=3.495 //x2=24.015 //y2=3.495
r344 (  70 73 ) resistor r=1.46947 //w=0.131 //l=1.54 //layer=m2 \
 //thickness=0.36 //x=22.475 //y=3.51 //x2=24.015 //y2=3.51
r345 (  68 70 ) resistor r=0.10734 //w=0.281 //l=0.16 //layer=m2 \
 //thickness=0.36 //x=22.315 //y=3.495 //x2=22.475 //y2=3.495
r346 (  62 118 ) resistor r=9.3 //w=0.17 //l=0.17 //layer=mcon //count=1 \
 //x=24.17 //y=4.88 //x2=24.17 //y2=4.88
r347 (  62 63 ) resistor r=0.103207 //w=0.196 //l=0.14 //layer=m1 \
 //thickness=0.36 //x=24.172 //y=4.88 //x2=24.172 //y2=4.74
r348 (  59 109 ) resistor r=9.3 //w=0.17 //l=0.17 //layer=mcon //count=1 \
 //x=24.17 //y=2.26 //x2=24.17 //y2=2.26
r349 (  55 72 ) resistor r=4.5 //w=0.15 //l=0.15 //layer=via1 //count=1 \
 //x=24.175 //y=3.495 //x2=24.175 //y2=3.495
r350 (  51 68 ) resistor r=4.5 //w=0.15 //l=0.15 //layer=via1 //count=1 \
 //x=22.315 //y=3.495 //x2=22.315 //y2=3.495
r351 (  49 151 ) resistor r=9.3 //w=0.17 //l=0.17 //layer=mcon //count=1 \
 //x=21.835 //y=1.19 //x2=21.835 //y2=1.19
r352 (  47 92 ) resistor r=9.3 //w=0.17 //l=0.17 //layer=mcon //count=1 \
 //x=21.54 //y=5.56 //x2=21.54 //y2=5.56
r353 (  44 84 ) resistor r=9.3 //w=0.17 //l=0.17 //layer=mcon //count=1 \
 //x=20.66 //y=5.56 //x2=20.66 //y2=5.56
r354 (  42 44 ) resistor r=0.121228 //w=0.232 //l=0.225 //layer=m1 \
 //thickness=0.36 //x=20.66 //y=5.335 //x2=20.66 //y2=5.56
r355 (  41 76 ) resistor r=9.3 //w=0.17 //l=0.17 //layer=mcon //count=1 \
 //x=19.78 //y=5.56 //x2=19.78 //y2=5.56
r356 (  39 41 ) resistor r=0.129608 //w=0.217 //l=0.225 //layer=m1 \
 //thickness=0.36 //x=19.782 //y=5.335 //x2=19.782 //y2=5.56
r357 (  33 55 ) resistor r=0.0912814 //w=0.379 //l=0.183303 //layer=m1 \
 //thickness=0.36 //x=24.17 //y=3.335 //x2=24.12 //y2=3.495
r358 (  32 59 ) resistor r=0.0933015 //w=0.201 //l=0.125 //layer=m1 \
 //thickness=0.36 //x=24.17 //y=2.385 //x2=24.17 //y2=2.26
r359 (  24 51 ) resistor r=0.0912814 //w=0.379 //l=0.183303 //layer=m1 \
 //thickness=0.36 //x=22.32 //y=3.335 //x2=22.37 //y2=3.495
r360 (  21 23 ) resistor r=0.0698411 //w=0.17 //l=0.120208 //layer=m1 \
 //thickness=0.36 //x=22.235 //y=1.845 //x2=22.32 //y2=1.93
r361 (  21 22 ) resistor r=0.300573 //w=0.131 //l=0.315 //layer=m1 \
 //thickness=0.36 //x=22.235 //y=1.845 //x2=21.92 //y2=1.845
r362 (  20 22 ) resistor r=0.0698411 //w=0.17 //l=0.120208 //layer=m1 \
 //thickness=0.36 //x=21.835 //y=1.76 //x2=21.92 //y2=1.845
r363 (  19 49 ) resistor r=0.0717383 //w=0.224 //l=0.115 //layer=m1 \
 //thickness=0.36 //x=21.835 //y=1.305 //x2=21.835 //y2=1.19
r364 (  19 20 ) resistor r=0.43416 //w=0.131 //l=0.455 //layer=m1 \
 //thickness=0.36 //x=21.835 //y=1.305 //x2=21.835 //y2=1.76
r365 (  18 45 ) resistor r=0.0675342 //w=0.23 //l=0.115 //layer=m1 \
 //thickness=0.36 //x=21.655 //y=5.335 //x2=21.54 //y2=5.335
r366 (  17 29 ) resistor r=0.0698411 //w=0.17 //l=0.120208 //layer=m1 \
 //thickness=0.36 //x=22.235 //y=5.335 //x2=22.32 //y2=5.25
r367 (  17 18 ) resistor r=0.553435 //w=0.131 //l=0.58 //layer=m1 \
 //thickness=0.36 //x=22.235 //y=5.335 //x2=21.655 //y2=5.335
r368 (  16 47 ) resistor r=0.00118313 //w=0.23 //layer=m1 //thickness=0.36 \
 //x=21.54 //y=5.56 //x2=21.54 //y2=5.56
r369 (  15 45 ) resistor r=0.002872 //w=0.34 //l=0.085 //layer=m1 \
 //thickness=0.36 //x=21.54 //y=5.42 //x2=21.54 //y2=5.335
r370 (  15 16 ) resistor r=0.091623 //w=0.191 //l=0.14 //layer=m1 \
 //thickness=0.36 //x=21.54 //y=5.42 //x2=21.54 //y2=5.56
r371 (  14 42 ) resistor r=0.0262263 //w=0.232 //l=0.12 //layer=m1 \
 //thickness=0.36 //x=20.78 //y=5.335 //x2=20.66 //y2=5.335
r372 (  13 45 ) resistor r=0.0675342 //w=0.23 //l=0.115 //layer=m1 \
 //thickness=0.36 //x=21.425 //y=5.335 //x2=21.54 //y2=5.335
r373 (  13 14 ) resistor r=0.615458 //w=0.131 //l=0.645 //layer=m1 \
 //thickness=0.36 //x=21.425 //y=5.335 //x2=20.78 //y2=5.335
r374 (  12 39 ) resistor r=0.0222262 //w=0.217 //l=0.118 //layer=m1 \
 //thickness=0.36 //x=19.9 //y=5.335 //x2=19.782 //y2=5.335
r375 (  11 42 ) resistor r=0.0262263 //w=0.232 //l=0.12 //layer=m1 \
 //thickness=0.36 //x=20.54 //y=5.335 //x2=20.66 //y2=5.335
r376 (  11 12 ) resistor r=0.610687 //w=0.131 //l=0.64 //layer=m1 \
 //thickness=0.36 //x=20.54 //y=5.335 //x2=19.9 //y2=5.335
r377 (  10 36 ) resistor r=0.0863342 //w=0.379 //l=0.168152 //layer=m1 \
 //thickness=0.36 //x=24.12 //y=3.51 //x2=24.17 //y2=3.655
r378 (  10 55 ) resistor r=0.00494723 //w=0.379 //l=0.015 //layer=m1 \
 //thickness=0.36 //x=24.12 //y=3.51 //x2=24.12 //y2=3.495
r379 (  9 28 ) resistor r=0.0863342 //w=0.379 //l=0.168152 //layer=m1 \
 //thickness=0.36 //x=22.37 //y=3.51 //x2=22.32 //y2=3.655
r380 (  9 51 ) resistor r=0.00494723 //w=0.379 //l=0.015 //layer=m1 \
 //thickness=0.36 //x=22.37 //y=3.51 //x2=22.37 //y2=3.495
r381 (  8 63 ) resistor r=0.114504 //w=0.131 //l=0.12 //layer=m1 \
 //thickness=0.36 //x=24.17 //y=4.62 //x2=24.17 //y2=4.74
r382 (  8 36 ) resistor r=0.920802 //w=0.131 //l=0.965 //layer=m1 \
 //thickness=0.36 //x=24.17 //y=4.62 //x2=24.17 //y2=3.655
r383 (  7 33 ) resistor r=0.186069 //w=0.131 //l=0.195 //layer=m1 \
 //thickness=0.36 //x=24.17 //y=3.14 //x2=24.17 //y2=3.335
r384 (  6 7 ) resistor r=0.353053 //w=0.131 //l=0.37 //layer=m1 \
 //thickness=0.36 //x=24.17 //y=2.77 //x2=24.17 //y2=3.14
r385 (  6 32 ) resistor r=0.367366 //w=0.131 //l=0.385 //layer=m1 \
 //thickness=0.36 //x=24.17 //y=2.77 //x2=24.17 //y2=2.385
r386 (  5 29 ) resistor r=0.248092 //w=0.131 //l=0.26 //layer=m1 \
 //thickness=0.36 //x=22.32 //y=4.99 //x2=22.32 //y2=5.25
r387 (  4 5 ) resistor r=0.353053 //w=0.131 //l=0.37 //layer=m1 \
 //thickness=0.36 //x=22.32 //y=4.62 //x2=22.32 //y2=4.99
r388 (  4 28 ) resistor r=0.920802 //w=0.131 //l=0.965 //layer=m1 \
 //thickness=0.36 //x=22.32 //y=4.62 //x2=22.32 //y2=3.655
r389 (  3 24 ) resistor r=0.186069 //w=0.131 //l=0.195 //layer=m1 \
 //thickness=0.36 //x=22.32 //y=3.14 //x2=22.32 //y2=3.335
r390 (  2 3 ) resistor r=0.353053 //w=0.131 //l=0.37 //layer=m1 \
 //thickness=0.36 //x=22.32 //y=2.77 //x2=22.32 //y2=3.14
r391 (  1 2 ) resistor r=0.353053 //w=0.131 //l=0.37 //layer=m1 \
 //thickness=0.36 //x=22.32 //y=2.4 //x2=22.32 //y2=2.77
r392 (  1 23 ) resistor r=0.448473 //w=0.131 //l=0.47 //layer=m1 \
 //thickness=0.36 //x=22.32 //y=2.4 //x2=22.32 //y2=1.93
ends PM_DFFRNX1\%QN

subckt PM_DFFRNX1\%noxref_7 ( 1 2 3 4 6 7 8 9 11 14 15 17 18 19 20 22 23 24 26 \
 27 28 34 38 41 46 49 52 58 62 66 71 73 75 77 79 80 81 82 86 94 103 108 117 \
 122 130 138 155 164 168 169 170 171 172 173 174 175 176 177 178 179 180 181 \
 183 189 190 191 192 196 197 198 203 205 207 213 214 215 216 217 222 224 226 \
 232 233 243 244 247 256 257 260 268 270 271 272 )
c608 ( 268 0 ) capacitor c=0.00885916f //x=16.835 //y=1.095
c609 ( 260 0 ) capacitor c=0.0358148f //x=24.94 //y=4.88
c610 ( 257 0 ) capacitor c=0.0284095f //x=24.91 //y=2.095
c611 ( 256 0 ) capacitor c=0.0476356f //x=24.91 //y=2.26
c612 ( 247 0 ) capacitor c=0.0354929f //x=11.99 //y=4.88
c613 ( 244 0 ) capacitor c=0.0284095f //x=11.96 //y=2.095
c614 ( 243 0 ) capacitor c=0.0476356f //x=11.96 //y=2.26
c615 ( 233 0 ) capacitor c=0.0439708f //x=25.475 //y=1.43
c616 ( 232 0 ) capacitor c=0.0192582f //x=25.475 //y=1.085
c617 ( 226 0 ) capacitor c=0.0162526f //x=25.32 //y=1.585
c618 ( 224 0 ) capacitor c=0.0157807f //x=25.32 //y=0.93
c619 ( 222 0 ) capacitor c=0.035926f //x=25.315 //y=4.97
c620 ( 217 0 ) capacitor c=0.0210762f //x=24.945 //y=1.74
c621 ( 216 0 ) capacitor c=0.0168511f //x=24.945 //y=1.43
c622 ( 215 0 ) capacitor c=0.0175485f //x=24.945 //y=1.085
c623 ( 214 0 ) capacitor c=0.0439708f //x=12.525 //y=1.43
c624 ( 213 0 ) capacitor c=0.0192582f //x=12.525 //y=1.085
c625 ( 207 0 ) capacitor c=0.0162526f //x=12.37 //y=1.585
c626 ( 205 0 ) capacitor c=0.0157807f //x=12.37 //y=0.93
c627 ( 203 0 ) capacitor c=0.0372668f //x=12.365 //y=4.97
c628 ( 198 0 ) capacitor c=0.0210762f //x=11.995 //y=1.74
c629 ( 197 0 ) capacitor c=0.0168511f //x=11.995 //y=1.43
c630 ( 196 0 ) capacitor c=0.0175485f //x=11.995 //y=1.085
c631 ( 192 0 ) capacitor c=0.0551642f //x=1.875 //y=4.97
c632 ( 191 0 ) capacitor c=0.0376642f //x=2.165 //y=4.97
c633 ( 190 0 ) capacitor c=0.0346489f //x=1.83 //y=1.4
c634 ( 189 0 ) capacitor c=0.018692f //x=1.83 //y=1.055
c635 ( 183 0 ) capacitor c=0.0137077f //x=1.675 //y=1.555
c636 ( 181 0 ) capacitor c=0.0158585f //x=1.675 //y=0.9
c637 ( 180 0 ) capacitor c=0.103534f //x=1.3 //y=2.095
c638 ( 179 0 ) capacitor c=0.0229444f //x=1.3 //y=1.71
c639 ( 178 0 ) capacitor c=0.0234359f //x=1.3 //y=1.4
c640 ( 177 0 ) capacitor c=0.019815f //x=1.3 //y=1.055
c641 ( 176 0 ) capacitor c=0.155269f //x=25.39 //y=6.2
c642 ( 175 0 ) capacitor c=0.110375f //x=24.95 //y=6.2
c643 ( 174 0 ) capacitor c=0.155269f //x=12.44 //y=6.2
c644 ( 173 0 ) capacitor c=0.110375f //x=12 //y=6.2
c645 ( 172 0 ) capacitor c=0.110208f //x=2.24 //y=6.2
c646 ( 171 0 ) capacitor c=0.158957f //x=1.8 //y=6.2
c647 ( 164 0 ) capacitor c=5.80994e-19 //x=24.94 //y=4.88
c648 ( 155 0 ) capacitor c=5.78095e-19 //x=24.91 //y=2.26
c649 ( 138 0 ) capacitor c=0.0293124f //x=16.73 //y=5.56
c650 ( 130 0 ) capacitor c=0.029137f //x=15.85 //y=5.56
c651 ( 122 0 ) capacitor c=0.0277605f //x=14.97 //y=5.56
c652 ( 117 0 ) capacitor c=5.80994e-19 //x=11.99 //y=4.88
c653 ( 108 0 ) capacitor c=5.78095e-19 //x=11.96 //y=2.26
c654 ( 103 0 ) capacitor c=0.00120653f //x=1.6 //y=4.88
c655 ( 94 0 ) capacitor c=0.0012618f //x=1.6 //y=2.26
c656 ( 86 0 ) capacitor c=0.0109595f //x=1.76 //y=4.26
c657 ( 82 0 ) capacitor c=0.0547f //x=19.22 //y=4.265
c658 ( 81 0 ) capacitor c=0.163025f //x=19.565 //y=4.265
c659 ( 80 0 ) capacitor c=0.0519986f //x=12.125 //y=4.25
c660 ( 79 0 ) capacitor c=0.0706046f //x=17.355 //y=4.25
c661 ( 77 0 ) capacitor c=0.00150627f //x=6.63 //y=4.265
c662 ( 75 0 ) capacitor c=0.0170341f //x=6.03 //y=4.25
c663 ( 73 0 ) capacitor c=0.00487194f //x=4.815 //y=4.27
c664 ( 71 0 ) capacitor c=0.0809012f //x=4.175 //y=4.25
c665 ( 66 0 ) capacitor c=0.00661943f //x=24.91 //y=2.26
c666 ( 62 0 ) capacitor c=0.0143744f //x=24.91 //y=4.25
c667 ( 58 0 ) capacitor c=0.0152032f //x=17.51 //y=4.25
c668 ( 52 0 ) capacitor c=0.00118259f //x=16.73 //y=5.335
c669 ( 49 0 ) capacitor c=0.00758117f //x=15.85 //y=5.335
c670 ( 46 0 ) capacitor c=0.0112819f //x=14.972 //y=5.335
c671 ( 41 0 ) capacitor c=0.00504845f //x=11.96 //y=2.26
c672 ( 38 0 ) capacitor c=0.0141348f //x=11.96 //y=4.25
c673 ( 34 0 ) capacitor c=0.0160313f //x=1.6 //y=4.25
c674 ( 28 0 ) capacitor c=0.00983657f //x=24.91 //y=4.735
c675 ( 27 0 ) capacitor c=0.00938877f //x=24.91 //y=4.415
c676 ( 26 0 ) capacitor c=0.0379926f //x=24.91 //y=4.095
c677 ( 24 0 ) capacitor c=0.0221841f //x=17.51 //y=5.25
c678 ( 23 0 ) capacitor c=0.0126978f //x=17.51 //y=4.415
c679 ( 22 0 ) capacitor c=0.0663769f //x=17.51 //y=4.095
c680 ( 20 0 ) capacitor c=0.00493487f //x=17.11 //y=1.845
c681 ( 19 0 ) capacitor c=0.0134344f //x=17.425 //y=1.845
c682 ( 18 0 ) capacitor c=0.0167333f //x=17.025 //y=1.76
c683 ( 17 0 ) capacitor c=0.0111392f //x=17.025 //y=1.305
c684 ( 15 0 ) capacitor c=0.0240505f //x=17.425 //y=5.335
c685 ( 14 0 ) capacitor c=0.00933983f //x=16.73 //y=5.56
c686 ( 11 0 ) capacitor c=0.0200404f //x=16.615 //y=5.335
c687 ( 9 0 ) capacitor c=0.0147103f //x=15.73 //y=5.335
c688 ( 8 0 ) capacitor c=0.00917813f //x=11.96 //y=4.735
c689 ( 7 0 ) capacitor c=0.00994911f //x=11.96 //y=4.41
c690 ( 6 0 ) capacitor c=0.0360742f //x=11.96 //y=4.09
c691 ( 4 0 ) capacitor c=0.0226005f //x=1.6 //y=4.755
c692 ( 3 0 ) capacitor c=0.0130233f //x=1.6 //y=4.42
c693 ( 2 0 ) capacitor c=0.0864232f //x=1.6 //y=4.1
c694 ( 1 0 ) capacitor c=0.011342f //x=1.6 //y=2.375
r695 (  262 263 ) resistor r=32.4568 //w=0.214 //l=0.075 //layer=ply \
 //thickness=0.18 //x=24.94 //y=4.97 //x2=24.94 //y2=5.045
r696 (  260 262 ) resistor r=20.271 //w=0.214 //l=0.09 //layer=ply \
 //thickness=0.18 //x=24.94 //y=4.88 //x2=24.94 //y2=4.97
r697 (  256 257 ) resistor r=52.7279 //w=0.214 //l=0.165 //layer=ply \
 //thickness=0.18 //x=24.91 //y=2.26 //x2=24.91 //y2=2.095
r698 (  249 250 ) resistor r=32.4568 //w=0.214 //l=0.075 //layer=ply \
 //thickness=0.18 //x=11.99 //y=4.97 //x2=11.99 //y2=5.045
r699 (  247 249 ) resistor r=20.271 //w=0.214 //l=0.09 //layer=ply \
 //thickness=0.18 //x=11.99 //y=4.88 //x2=11.99 //y2=4.97
r700 (  243 244 ) resistor r=52.7279 //w=0.214 //l=0.165 //layer=ply \
 //thickness=0.18 //x=11.96 //y=2.26 //x2=11.96 //y2=2.095
r701 (  233 267 ) resistor r=45.1352 //w=0.168 //l=0.173853 //layer=ply \
 //thickness=0.18 //x=25.475 //y=1.43 //x2=25.435 //y2=1.585
r702 (  232 266 ) resistor r=45.1352 //w=0.168 //l=0.173853 //layer=ply \
 //thickness=0.18 //x=25.475 //y=1.085 //x2=25.435 //y2=0.93
r703 (  232 233 ) resistor r=176.904 //w=0.094 //l=0.345 //layer=ply \
 //thickness=0.18 //x=25.475 //y=1.085 //x2=25.475 //y2=1.43
r704 (  227 265 ) resistor r=10.701 //w=0.21 //l=0.115 //layer=ply \
 //thickness=0.18 //x=25.1 //y=1.585 //x2=24.985 //y2=1.585
r705 (  226 267 ) resistor r=5.52526 //w=0.168 //l=0.115 //layer=ply \
 //thickness=0.18 //x=25.32 //y=1.585 //x2=25.435 //y2=1.585
r706 (  225 264 ) resistor r=5.52526 //w=0.168 //l=0.115 //layer=ply \
 //thickness=0.18 //x=25.1 //y=0.93 //x2=24.985 //y2=0.93
r707 (  224 266 ) resistor r=5.52526 //w=0.168 //l=0.115 //layer=ply \
 //thickness=0.18 //x=25.32 //y=0.93 //x2=25.435 //y2=0.93
r708 (  224 225 ) resistor r=112.809 //w=0.094 //l=0.22 //layer=ply \
 //thickness=0.18 //x=25.32 //y=0.93 //x2=25.1 //y2=0.93
r709 (  223 262 ) resistor r=16.5046 //w=0.27 //l=0.135 //layer=ply \
 //thickness=0.18 //x=25.075 //y=4.97 //x2=24.94 //y2=4.97
r710 (  222 229 ) resistor r=26.9307 //w=0.15 //l=0.106066 //layer=ply \
 //thickness=0.18 //x=25.315 //y=4.97 //x2=25.39 //y2=5.045
r711 (  222 223 ) resistor r=123.064 //w=0.094 //l=0.24 //layer=ply \
 //thickness=0.18 //x=25.315 //y=4.97 //x2=25.075 //y2=4.97
r712 (  217 265 ) resistor r=39.5823 //w=0.21 //l=0.173853 //layer=ply \
 //thickness=0.18 //x=24.945 //y=1.74 //x2=24.985 //y2=1.585
r713 (  217 257 ) resistor r=182.032 //w=0.094 //l=0.355 //layer=ply \
 //thickness=0.18 //x=24.945 //y=1.74 //x2=24.945 //y2=2.095
r714 (  216 265 ) resistor r=39.5823 //w=0.21 //l=0.173853 //layer=ply \
 //thickness=0.18 //x=24.945 //y=1.43 //x2=24.985 //y2=1.585
r715 (  215 264 ) resistor r=45.1352 //w=0.168 //l=0.173853 //layer=ply \
 //thickness=0.18 //x=24.945 //y=1.085 //x2=24.985 //y2=0.93
r716 (  215 216 ) resistor r=176.904 //w=0.094 //l=0.345 //layer=ply \
 //thickness=0.18 //x=24.945 //y=1.085 //x2=24.945 //y2=1.43
r717 (  214 254 ) resistor r=45.1352 //w=0.168 //l=0.173853 //layer=ply \
 //thickness=0.18 //x=12.525 //y=1.43 //x2=12.485 //y2=1.585
r718 (  213 253 ) resistor r=45.1352 //w=0.168 //l=0.173853 //layer=ply \
 //thickness=0.18 //x=12.525 //y=1.085 //x2=12.485 //y2=0.93
r719 (  213 214 ) resistor r=176.904 //w=0.094 //l=0.345 //layer=ply \
 //thickness=0.18 //x=12.525 //y=1.085 //x2=12.525 //y2=1.43
r720 (  208 252 ) resistor r=10.701 //w=0.21 //l=0.115 //layer=ply \
 //thickness=0.18 //x=12.15 //y=1.585 //x2=12.035 //y2=1.585
r721 (  207 254 ) resistor r=5.52526 //w=0.168 //l=0.115 //layer=ply \
 //thickness=0.18 //x=12.37 //y=1.585 //x2=12.485 //y2=1.585
r722 (  206 251 ) resistor r=5.52526 //w=0.168 //l=0.115 //layer=ply \
 //thickness=0.18 //x=12.15 //y=0.93 //x2=12.035 //y2=0.93
r723 (  205 253 ) resistor r=5.52526 //w=0.168 //l=0.115 //layer=ply \
 //thickness=0.18 //x=12.37 //y=0.93 //x2=12.485 //y2=0.93
r724 (  205 206 ) resistor r=112.809 //w=0.094 //l=0.22 //layer=ply \
 //thickness=0.18 //x=12.37 //y=0.93 //x2=12.15 //y2=0.93
r725 (  204 249 ) resistor r=16.5046 //w=0.27 //l=0.135 //layer=ply \
 //thickness=0.18 //x=12.125 //y=4.97 //x2=11.99 //y2=4.97
r726 (  203 210 ) resistor r=26.9307 //w=0.15 //l=0.106066 //layer=ply \
 //thickness=0.18 //x=12.365 //y=4.97 //x2=12.44 //y2=5.045
r727 (  203 204 ) resistor r=123.064 //w=0.094 //l=0.24 //layer=ply \
 //thickness=0.18 //x=12.365 //y=4.97 //x2=12.125 //y2=4.97
r728 (  198 252 ) resistor r=39.5823 //w=0.21 //l=0.173853 //layer=ply \
 //thickness=0.18 //x=11.995 //y=1.74 //x2=12.035 //y2=1.585
r729 (  198 244 ) resistor r=182.032 //w=0.094 //l=0.355 //layer=ply \
 //thickness=0.18 //x=11.995 //y=1.74 //x2=11.995 //y2=2.095
r730 (  197 252 ) resistor r=39.5823 //w=0.21 //l=0.173853 //layer=ply \
 //thickness=0.18 //x=11.995 //y=1.43 //x2=12.035 //y2=1.585
r731 (  196 251 ) resistor r=45.1352 //w=0.168 //l=0.173853 //layer=ply \
 //thickness=0.18 //x=11.995 //y=1.085 //x2=12.035 //y2=0.93
r732 (  196 197 ) resistor r=176.904 //w=0.094 //l=0.345 //layer=ply \
 //thickness=0.18 //x=11.995 //y=1.085 //x2=11.995 //y2=1.43
r733 (  191 193 ) resistor r=26.9307 //w=0.15 //l=0.106066 //layer=ply \
 //thickness=0.18 //x=2.165 //y=4.97 //x2=2.24 //y2=5.045
r734 (  191 192 ) resistor r=148.702 //w=0.094 //l=0.29 //layer=ply \
 //thickness=0.18 //x=2.165 //y=4.97 //x2=1.875 //y2=4.97
r735 (  190 241 ) resistor r=45.1352 //w=0.168 //l=0.173853 //layer=ply \
 //thickness=0.18 //x=1.83 //y=1.4 //x2=1.79 //y2=1.555
r736 (  189 240 ) resistor r=45.1352 //w=0.168 //l=0.173853 //layer=ply \
 //thickness=0.18 //x=1.83 //y=1.055 //x2=1.79 //y2=0.9
r737 (  189 190 ) resistor r=176.904 //w=0.094 //l=0.345 //layer=ply \
 //thickness=0.18 //x=1.83 //y=1.055 //x2=1.83 //y2=1.4
r738 (  186 192 ) resistor r=22.7971 //w=0.269 //l=0.106066 //layer=ply \
 //thickness=0.18 //x=1.8 //y=5.045 //x2=1.875 //y2=4.97
r739 (  186 239 ) resistor r=35.8364 //w=0.269 //l=0.270185 //layer=ply \
 //thickness=0.18 //x=1.8 //y=5.045 //x2=1.6 //y2=4.88
r740 (  184 235 ) resistor r=10.701 //w=0.21 //l=0.115 //layer=ply \
 //thickness=0.18 //x=1.455 //y=1.555 //x2=1.34 //y2=1.555
r741 (  183 241 ) resistor r=5.52526 //w=0.168 //l=0.115 //layer=ply \
 //thickness=0.18 //x=1.675 //y=1.555 //x2=1.79 //y2=1.555
r742 (  182 234 ) resistor r=5.52526 //w=0.168 //l=0.115 //layer=ply \
 //thickness=0.18 //x=1.455 //y=0.9 //x2=1.34 //y2=0.9
r743 (  181 240 ) resistor r=5.52526 //w=0.168 //l=0.115 //layer=ply \
 //thickness=0.18 //x=1.675 //y=0.9 //x2=1.79 //y2=0.9
r744 (  181 182 ) resistor r=112.809 //w=0.094 //l=0.22 //layer=ply \
 //thickness=0.18 //x=1.675 //y=0.9 //x2=1.455 //y2=0.9
r745 (  180 237 ) resistor r=58.7805 //w=0.246 //l=0.373497 //layer=ply \
 //thickness=0.18 //x=1.3 //y=2.095 //x2=1.6 //y2=2.26
r746 (  179 235 ) resistor r=39.5823 //w=0.21 //l=0.173853 //layer=ply \
 //thickness=0.18 //x=1.3 //y=1.71 //x2=1.34 //y2=1.555
r747 (  179 180 ) resistor r=197.415 //w=0.094 //l=0.385 //layer=ply \
 //thickness=0.18 //x=1.3 //y=1.71 //x2=1.3 //y2=2.095
r748 (  178 235 ) resistor r=39.5823 //w=0.21 //l=0.173853 //layer=ply \
 //thickness=0.18 //x=1.3 //y=1.4 //x2=1.34 //y2=1.555
r749 (  177 234 ) resistor r=45.1352 //w=0.168 //l=0.173853 //layer=ply \
 //thickness=0.18 //x=1.3 //y=1.055 //x2=1.34 //y2=0.9
r750 (  177 178 ) resistor r=176.904 //w=0.094 //l=0.345 //layer=ply \
 //thickness=0.18 //x=1.3 //y=1.055 //x2=1.3 //y2=1.4
r751 (  176 229 ) resistor r=592.245 //w=0.094 //l=1.155 //layer=ply \
 //thickness=0.18 //x=25.39 //y=6.2 //x2=25.39 //y2=5.045
r752 (  175 263 ) resistor r=592.245 //w=0.094 //l=1.155 //layer=ply \
 //thickness=0.18 //x=24.95 //y=6.2 //x2=24.95 //y2=5.045
r753 (  174 210 ) resistor r=592.245 //w=0.094 //l=1.155 //layer=ply \
 //thickness=0.18 //x=12.44 //y=6.2 //x2=12.44 //y2=5.045
r754 (  173 250 ) resistor r=592.245 //w=0.094 //l=1.155 //layer=ply \
 //thickness=0.18 //x=12 //y=6.2 //x2=12 //y2=5.045
r755 (  172 193 ) resistor r=592.245 //w=0.094 //l=1.155 //layer=ply \
 //thickness=0.18 //x=2.24 //y=6.2 //x2=2.24 //y2=5.045
r756 (  171 186 ) resistor r=592.245 //w=0.094 //l=1.155 //layer=ply \
 //thickness=0.18 //x=1.8 //y=6.2 //x2=1.8 //y2=5.045
r757 (  170 226 ) resistor r=56.4043 //w=0.094 //l=0.11 //layer=ply \
 //thickness=0.18 //x=25.21 //y=1.585 //x2=25.32 //y2=1.585
r758 (  170 227 ) resistor r=56.4043 //w=0.094 //l=0.11 //layer=ply \
 //thickness=0.18 //x=25.21 //y=1.585 //x2=25.1 //y2=1.585
r759 (  169 207 ) resistor r=56.4043 //w=0.094 //l=0.11 //layer=ply \
 //thickness=0.18 //x=12.26 //y=1.585 //x2=12.37 //y2=1.585
r760 (  169 208 ) resistor r=56.4043 //w=0.094 //l=0.11 //layer=ply \
 //thickness=0.18 //x=12.26 //y=1.585 //x2=12.15 //y2=1.585
r761 (  168 183 ) resistor r=56.4043 //w=0.094 //l=0.11 //layer=ply \
 //thickness=0.18 //x=1.565 //y=1.555 //x2=1.675 //y2=1.555
r762 (  168 184 ) resistor r=56.4043 //w=0.094 //l=0.11 //layer=ply \
 //thickness=0.18 //x=1.565 //y=1.555 //x2=1.455 //y2=1.555
r763 (  164 260 ) resistor r=152 //w=0.17 //l=0.17 //layer=licon //count=1 \
 //x=24.94 //y=4.88 //x2=24.94 //y2=4.88
r764 (  155 256 ) resistor r=152 //w=0.17 //l=0.17 //layer=licon //count=1 \
 //x=24.91 //y=2.26 //x2=24.91 //y2=2.26
r765 (  138 272 ) resistor r=23.615 //w=0.187 //l=0.345 //layer=li \
 //thickness=0.1 //x=16.73 //y=5.56 //x2=16.73 //y2=5.905
r766 (  130 271 ) resistor r=23.615 //w=0.187 //l=0.345 //layer=li \
 //thickness=0.1 //x=15.85 //y=5.56 //x2=15.85 //y2=5.905
r767 (  122 270 ) resistor r=23.615 //w=0.187 //l=0.345 //layer=li \
 //thickness=0.1 //x=14.97 //y=5.56 //x2=14.97 //y2=5.905
r768 (  117 247 ) resistor r=152 //w=0.17 //l=0.17 //layer=licon //count=1 \
 //x=11.99 //y=4.88 //x2=11.99 //y2=4.88
r769 (  108 243 ) resistor r=152 //w=0.17 //l=0.17 //layer=licon //count=1 \
 //x=11.96 //y=2.26 //x2=11.96 //y2=2.26
r770 (  103 239 ) resistor r=152 //w=0.17 //l=0.17 //layer=licon //count=1 \
 //x=1.6 //y=4.88 //x2=1.6 //y2=4.88
r771 (  94 237 ) resistor r=152 //w=0.17 //l=0.17 //layer=licon //count=1 \
 //x=1.6 //y=2.26 //x2=1.6 //y2=2.26
r772 (  84 86 ) resistor r=0.10734 //w=0.281 //l=0.16 //layer=m2 \
 //thickness=0.36 //x=1.6 //y=4.26 //x2=1.76 //y2=4.26
r773 (  82 90 ) resistor r=1.08991 //w=0.196 //l=1.70999 //layer=m2 \
 //thickness=0.36 //x=19.22 //y=4.265 //x2=17.515 //y2=4.255
r774 (  81 92 ) resistor r=3.726 //w=0.179 //l=5.34 //layer=m2 \
 //thickness=0.36 //x=19.565 //y=4.265 //x2=24.9 //y2=4.255
r775 (  81 82 ) resistor r=0.329198 //w=0.131 //l=0.345 //layer=m2 \
 //thickness=0.36 //x=19.565 //y=4.265 //x2=19.22 //y2=4.265
r776 (  80 88 ) resistor r=0.112172 //w=0.179 //l=0.16 //layer=m2 \
 //thickness=0.36 //x=12.125 //y=4.25 //x2=11.965 //y2=4.25
r777 (  79 90 ) resistor r=0.104578 //w=0.196 //l=0.162481 //layer=m2 \
 //thickness=0.36 //x=17.355 //y=4.25 //x2=17.515 //y2=4.255
r778 (  79 80 ) resistor r=4.99046 //w=0.131 //l=5.23 //layer=m2 \
 //thickness=0.36 //x=17.355 //y=4.25 //x2=12.125 //y2=4.25
r779 (  77 88 ) resistor r=3.726 //w=0.179 //l=5.34249 //layer=m2 \
 //thickness=0.36 //x=6.63 //y=4.265 //x2=11.965 //y2=4.25
r780 (  77 78 ) resistor r=0.329198 //w=0.131 //l=0.345 //layer=m2 \
 //thickness=0.36 //x=6.63 //y=4.265 //x2=6.285 //y2=4.265
r781 (  75 78 ) resistor r=0.1875 //w=0.17 //l=0.262393 //layer=m2 \
 //thickness=0.36 //x=6.03 //y=4.25 //x2=6.285 //y2=4.265
r782 (  75 76 ) resistor r=0.997137 //w=0.131 //l=1.045 //layer=m2 \
 //thickness=0.36 //x=6.03 //y=4.25 //x2=4.985 //y2=4.25
r783 (  73 76 ) resistor r=0.125 //w=0.17 //l=0.179722 //layer=m2 \
 //thickness=0.36 //x=4.815 //y=4.27 //x2=4.985 //y2=4.25
r784 (  73 74 ) resistor r=0.367366 //w=0.131 //l=0.385 //layer=m2 \
 //thickness=0.36 //x=4.815 //y=4.27 //x2=4.43 //y2=4.27
r785 (  71 74 ) resistor r=0.1875 //w=0.17 //l=0.264811 //layer=m2 \
 //thickness=0.36 //x=4.175 //y=4.25 //x2=4.43 //y2=4.27
r786 (  71 86 ) resistor r=2.30439 //w=0.131 //l=2.415 //layer=m2 \
 //thickness=0.36 //x=4.175 //y=4.25 //x2=1.76 //y2=4.25
r787 (  70 164 ) resistor r=9.3 //w=0.17 //l=0.17 //layer=mcon //count=1 \
 //x=24.94 //y=4.88 //x2=24.94 //y2=4.88
r788 (  66 155 ) resistor r=9.3 //w=0.17 //l=0.17 //layer=mcon //count=1 \
 //x=24.91 //y=2.26 //x2=24.91 //y2=2.26
r789 (  66 68 ) resistor r=0.0936408 //w=0.196 //l=0.125 //layer=m1 \
 //thickness=0.36 //x=24.912 //y=2.26 //x2=24.912 //y2=2.385
r790 (  64 92 ) resistor r=4.5 //w=0.15 //l=0.15 //layer=via1 //count=1 \
 //x=24.9 //y=4.255 //x2=24.9 //y2=4.255
r791 (  62 64 ) resistor r=0.00168464 //w=0.371 //l=0.005 //layer=m1 \
 //thickness=0.36 //x=24.852 //y=4.25 //x2=24.852 //y2=4.255
r792 (  60 90 ) resistor r=4.5 //w=0.15 //l=0.15 //layer=via1 //count=1 \
 //x=17.515 //y=4.255 //x2=17.515 //y2=4.255
r793 (  58 60 ) resistor r=0.00164908 //w=0.379 //l=0.005 //layer=m1 \
 //thickness=0.36 //x=17.46 //y=4.25 //x2=17.46 //y2=4.255
r794 (  56 268 ) resistor r=9.3 //w=0.17 //l=0.17 //layer=mcon //count=1 \
 //x=17.025 //y=1.19 //x2=17.025 //y2=1.19
r795 (  54 138 ) resistor r=9.3 //w=0.17 //l=0.17 //layer=mcon //count=1 \
 //x=16.73 //y=5.56 //x2=16.73 //y2=5.56
r796 (  51 130 ) resistor r=9.3 //w=0.17 //l=0.17 //layer=mcon //count=1 \
 //x=15.85 //y=5.56 //x2=15.85 //y2=5.56
r797 (  49 51 ) resistor r=0.121228 //w=0.232 //l=0.225 //layer=m1 \
 //thickness=0.36 //x=15.85 //y=5.335 //x2=15.85 //y2=5.56
r798 (  48 122 ) resistor r=9.3 //w=0.17 //l=0.17 //layer=mcon //count=1 \
 //x=14.97 //y=5.56 //x2=14.97 //y2=5.56
r799 (  46 48 ) resistor r=0.129608 //w=0.217 //l=0.225 //layer=m1 \
 //thickness=0.36 //x=14.972 //y=5.335 //x2=14.972 //y2=5.56
r800 (  45 117 ) resistor r=9.3 //w=0.17 //l=0.17 //layer=mcon //count=1 \
 //x=11.99 //y=4.88 //x2=11.99 //y2=4.88
r801 (  41 108 ) resistor r=9.3 //w=0.17 //l=0.17 //layer=mcon //count=1 \
 //x=11.96 //y=2.26 //x2=11.96 //y2=2.26
r802 (  41 43 ) resistor r=0.0936408 //w=0.196 //l=0.125 //layer=m1 \
 //thickness=0.36 //x=11.962 //y=2.26 //x2=11.962 //y2=2.385
r803 (  38 88 ) resistor r=4.5 //w=0.15 //l=0.15 //layer=via1 //count=1 \
 //x=11.965 //y=4.25 //x2=11.965 //y2=4.25
r804 (  36 84 ) resistor r=4.5 //w=0.15 //l=0.15 //layer=via1 //count=1 \
 //x=1.6 //y=4.26 //x2=1.6 //y2=4.26
r805 (  34 36 ) resistor r=0.00332447 //w=0.376 //l=0.01 //layer=m1 \
 //thickness=0.36 //x=1.652 //y=4.25 //x2=1.652 //y2=4.26
r806 (  32 103 ) resistor r=9.3 //w=0.17 //l=0.17 //layer=mcon //count=1 \
 //x=1.6 //y=4.88 //x2=1.6 //y2=4.88
r807 (  30 94 ) resistor r=9.3 //w=0.17 //l=0.17 //layer=mcon //count=1 \
 //x=1.6 //y=2.26 //x2=1.6 //y2=2.26
r808 (  28 70 ) resistor r=0.0878548 //w=0.228 //l=0.159295 //layer=m1 \
 //thickness=0.36 //x=24.91 //y=4.735 //x2=24.94 //y2=4.88
r809 (  27 64 ) resistor r=0.0909648 //w=0.371 //l=0.186762 //layer=m1 \
 //thickness=0.36 //x=24.91 //y=4.415 //x2=24.852 //y2=4.255
r810 (  27 28 ) resistor r=0.305344 //w=0.131 //l=0.32 //layer=m1 \
 //thickness=0.36 //x=24.91 //y=4.415 //x2=24.91 //y2=4.735
r811 (  26 62 ) resistor r=0.0892801 //w=0.371 //l=0.1817 //layer=m1 \
 //thickness=0.36 //x=24.91 //y=4.095 //x2=24.852 //y2=4.25
r812 (  26 68 ) resistor r=1.63168 //w=0.131 //l=1.71 //layer=m1 \
 //thickness=0.36 //x=24.91 //y=4.095 //x2=24.91 //y2=2.385
r813 (  23 60 ) resistor r=0.0912814 //w=0.379 //l=0.183303 //layer=m1 \
 //thickness=0.36 //x=17.51 //y=4.415 //x2=17.46 //y2=4.255
r814 (  23 24 ) resistor r=0.796756 //w=0.131 //l=0.835 //layer=m1 \
 //thickness=0.36 //x=17.51 //y=4.415 //x2=17.51 //y2=5.25
r815 (  22 58 ) resistor r=0.0896323 //w=0.379 //l=0.178255 //layer=m1 \
 //thickness=0.36 //x=17.51 //y=4.095 //x2=17.46 //y2=4.25
r816 (  21 22 ) resistor r=2.06584 //w=0.131 //l=2.165 //layer=m1 \
 //thickness=0.36 //x=17.51 //y=1.93 //x2=17.51 //y2=4.095
r817 (  19 21 ) resistor r=0.0698411 //w=0.17 //l=0.120208 //layer=m1 \
 //thickness=0.36 //x=17.425 //y=1.845 //x2=17.51 //y2=1.93
r818 (  19 20 ) resistor r=0.300573 //w=0.131 //l=0.315 //layer=m1 \
 //thickness=0.36 //x=17.425 //y=1.845 //x2=17.11 //y2=1.845
r819 (  18 20 ) resistor r=0.0698411 //w=0.17 //l=0.120208 //layer=m1 \
 //thickness=0.36 //x=17.025 //y=1.76 //x2=17.11 //y2=1.845
r820 (  17 56 ) resistor r=0.0717383 //w=0.224 //l=0.115 //layer=m1 \
 //thickness=0.36 //x=17.025 //y=1.305 //x2=17.025 //y2=1.19
r821 (  17 18 ) resistor r=0.43416 //w=0.131 //l=0.455 //layer=m1 \
 //thickness=0.36 //x=17.025 //y=1.305 //x2=17.025 //y2=1.76
r822 (  16 52 ) resistor r=0.0675342 //w=0.23 //l=0.115 //layer=m1 \
 //thickness=0.36 //x=16.845 //y=5.335 //x2=16.73 //y2=5.335
r823 (  15 24 ) resistor r=0.0698411 //w=0.17 //l=0.120208 //layer=m1 \
 //thickness=0.36 //x=17.425 //y=5.335 //x2=17.51 //y2=5.25
r824 (  15 16 ) resistor r=0.553435 //w=0.131 //l=0.58 //layer=m1 \
 //thickness=0.36 //x=17.425 //y=5.335 //x2=16.845 //y2=5.335
r825 (  14 54 ) resistor r=0.00118313 //w=0.23 //layer=m1 //thickness=0.36 \
 //x=16.73 //y=5.56 //x2=16.73 //y2=5.56
r826 (  13 52 ) resistor r=0.002872 //w=0.34 //l=0.085 //layer=m1 \
 //thickness=0.36 //x=16.73 //y=5.42 //x2=16.73 //y2=5.335
r827 (  13 14 ) resistor r=0.091623 //w=0.191 //l=0.14 //layer=m1 \
 //thickness=0.36 //x=16.73 //y=5.42 //x2=16.73 //y2=5.56
r828 (  12 49 ) resistor r=0.0262263 //w=0.232 //l=0.12 //layer=m1 \
 //thickness=0.36 //x=15.97 //y=5.335 //x2=15.85 //y2=5.335
r829 (  11 52 ) resistor r=0.0675342 //w=0.23 //l=0.115 //layer=m1 \
 //thickness=0.36 //x=16.615 //y=5.335 //x2=16.73 //y2=5.335
r830 (  11 12 ) resistor r=0.615458 //w=0.131 //l=0.645 //layer=m1 \
 //thickness=0.36 //x=16.615 //y=5.335 //x2=15.97 //y2=5.335
r831 (  10 46 ) resistor r=0.0222262 //w=0.217 //l=0.118 //layer=m1 \
 //thickness=0.36 //x=15.09 //y=5.335 //x2=14.972 //y2=5.335
r832 (  9 49 ) resistor r=0.0262263 //w=0.232 //l=0.12 //layer=m1 \
 //thickness=0.36 //x=15.73 //y=5.335 //x2=15.85 //y2=5.335
r833 (  9 10 ) resistor r=0.610687 //w=0.131 //l=0.64 //layer=m1 \
 //thickness=0.36 //x=15.73 //y=5.335 //x2=15.09 //y2=5.335
r834 (  8 45 ) resistor r=0.0878548 //w=0.228 //l=0.159295 //layer=m1 \
 //thickness=0.36 //x=11.96 //y=4.735 //x2=11.99 //y2=4.88
r835 (  7 38 ) resistor r=0.0912814 //w=0.379 //l=0.183303 //layer=m1 \
 //thickness=0.36 //x=11.96 //y=4.41 //x2=11.91 //y2=4.25
r836 (  7 8 ) resistor r=0.310115 //w=0.131 //l=0.325 //layer=m1 \
 //thickness=0.36 //x=11.96 //y=4.41 //x2=11.96 //y2=4.735
r837 (  6 38 ) resistor r=0.0912814 //w=0.379 //l=0.183303 //layer=m1 \
 //thickness=0.36 //x=11.96 //y=4.09 //x2=11.91 //y2=4.25
r838 (  6 43 ) resistor r=1.62691 //w=0.131 //l=1.705 //layer=m1 \
 //thickness=0.36 //x=11.96 //y=4.09 //x2=11.96 //y2=2.385
r839 (  4 32 ) resistor r=0.0760407 //w=0.238 //l=0.125 //layer=m1 \
 //thickness=0.36 //x=1.6 //y=4.755 //x2=1.6 //y2=4.88
r840 (  3 36 ) resistor r=0.0911593 //w=0.376 //l=0.184174 //layer=m1 \
 //thickness=0.36 //x=1.6 //y=4.42 //x2=1.652 //y2=4.26
r841 (  3 4 ) resistor r=0.319656 //w=0.131 //l=0.335 //layer=m1 \
 //thickness=0.36 //x=1.6 //y=4.42 //x2=1.6 //y2=4.755
r842 (  2 34 ) resistor r=0.0878349 //w=0.376 //l=0.174069 //layer=m1 \
 //thickness=0.36 //x=1.6 //y=4.1 //x2=1.652 //y2=4.25
r843 (  1 30 ) resistor r=0.0719237 //w=0.222 //l=0.115 //layer=m1 \
 //thickness=0.36 //x=1.6 //y=2.375 //x2=1.6 //y2=2.26
r844 (  1 2 ) resistor r=1.64599 //w=0.131 //l=1.725 //layer=m1 \
 //thickness=0.36 //x=1.6 //y=2.375 //x2=1.6 //y2=4.1
ends PM_DFFRNX1\%noxref_7

subckt PM_DFFRNX1\%Q ( 1 2 3 4 5 6 7 8 9 10 11 12 13 14 15 21 22 26 31 32 34 \
 35 42 57 58 61 63 68 70 75 79 88 93 101 117 118 119 123 124 125 130 132 135 \
 136 138 139 144 147 149 150 )
c262 ( 147 0 ) capacitor c=0.00878249f //x=25.02 //y=1.085
c263 ( 144 0 ) capacitor c=0.0652878f //x=21.58 //y=4.88
c264 ( 139 0 ) capacitor c=0.0278202f //x=21.58 //y=2.095
c265 ( 138 0 ) capacitor c=0.0502771f //x=21.58 //y=2.26
c266 ( 136 0 ) capacitor c=0.0443175f //x=22.1 //y=1.44
c267 ( 135 0 ) capacitor c=0.0199703f //x=22.1 //y=1.095
c268 ( 132 0 ) capacitor c=0.0162526f //x=21.945 //y=1.595
c269 ( 130 0 ) capacitor c=0.0157807f //x=21.945 //y=0.94
c270 ( 125 0 ) capacitor c=0.0220935f //x=21.57 //y=1.75
c271 ( 124 0 ) capacitor c=0.0207489f //x=21.57 //y=1.44
c272 ( 123 0 ) capacitor c=0.0194091f //x=21.57 //y=1.095
c273 ( 119 0 ) capacitor c=0.159671f //x=21.76 //y=6.2
c274 ( 118 0 ) capacitor c=0.110208f //x=21.32 //y=6.2
c275 ( 101 0 ) capacitor c=0.0322017f //x=25.17 //y=5.56
c276 ( 93 0 ) capacitor c=0.0292136f //x=24.29 //y=5.56
c277 ( 88 0 ) capacitor c=7.7417e-19 //x=21.58 //y=4.88
c278 ( 79 0 ) capacitor c=0.00101179f //x=21.58 //y=2.26
c279 ( 75 0 ) capacitor c=0.00325198f //x=21.735 //y=3.865
c280 ( 70 0 ) capacitor c=0.0325386f //x=25.115 //y=3.87
c281 ( 68 0 ) capacitor c=0.0396918f //x=24.515 //y=3.88
c282 ( 63 0 ) capacitor c=0.0148964f //x=25.21 //y=1.18
c283 ( 61 0 ) capacitor c=5.78613e-19 //x=25.17 //y=5.56
c284 ( 58 0 ) capacitor c=0.0149033f //x=25.17 //y=5.38
c285 ( 57 0 ) capacitor c=0.00908961f //x=24.29 //y=5.56
c286 ( 42 0 ) capacitor c=0.0126194f //x=25.65 //y=4.04
c287 ( 35 0 ) capacitor c=0.00672485f //x=25.295 //y=1.835
c288 ( 34 0 ) capacitor c=0.0151232f //x=25.565 //y=1.835
c289 ( 32 0 ) capacitor c=0.0125833f //x=25.565 //y=5.38
c290 ( 31 0 ) capacitor c=0.0134844f //x=25.21 //y=1.75
c291 ( 26 0 ) capacitor c=0.0136546f //x=25.055 //y=5.38
c292 ( 22 0 ) capacitor c=0.00406775f //x=21.58 //y=4.75
c293 ( 21 0 ) capacitor c=0.0112819f //x=21.58 //y=4.025
c294 ( 15 0 ) capacitor c=0.00690423f //x=21.58 //y=2.375
c295 ( 14 0 ) capacitor c=0.0181357f //x=25.65 //y=3.88
c296 ( 13 0 ) capacitor c=0.0165507f //x=21.58 //y=3.88
c297 ( 10 0 ) capacitor c=0.0431711f //x=25.65 //y=4.25
c298 ( 6 0 ) capacitor c=0.0739475f //x=25.65 //y=2.4
c299 ( 5 0 ) capacitor c=0.017301f //x=21.58 //y=4.62
c300 ( 1 0 ) capacitor c=0.03602f //x=21.58 //y=2.4
r301 (  138 139 ) resistor r=52.7279 //w=0.214 //l=0.165 //layer=ply \
 //thickness=0.18 //x=21.58 //y=2.26 //x2=21.58 //y2=2.095
r302 (  136 146 ) resistor r=45.1352 //w=0.168 //l=0.173853 //layer=ply \
 //thickness=0.18 //x=22.1 //y=1.44 //x2=22.06 //y2=1.595
r303 (  135 145 ) resistor r=45.1352 //w=0.168 //l=0.173853 //layer=ply \
 //thickness=0.18 //x=22.1 //y=1.095 //x2=22.06 //y2=0.94
r304 (  135 136 ) resistor r=176.904 //w=0.094 //l=0.345 //layer=ply \
 //thickness=0.18 //x=22.1 //y=1.095 //x2=22.1 //y2=1.44
r305 (  133 142 ) resistor r=10.701 //w=0.21 //l=0.115 //layer=ply \
 //thickness=0.18 //x=21.725 //y=1.595 //x2=21.61 //y2=1.595
r306 (  132 146 ) resistor r=5.52526 //w=0.168 //l=0.115 //layer=ply \
 //thickness=0.18 //x=21.945 //y=1.595 //x2=22.06 //y2=1.595
r307 (  131 141 ) resistor r=5.52526 //w=0.168 //l=0.115 //layer=ply \
 //thickness=0.18 //x=21.725 //y=0.94 //x2=21.61 //y2=0.94
r308 (  130 145 ) resistor r=5.52526 //w=0.168 //l=0.115 //layer=ply \
 //thickness=0.18 //x=21.945 //y=0.94 //x2=22.06 //y2=0.94
r309 (  130 131 ) resistor r=112.809 //w=0.094 //l=0.22 //layer=ply \
 //thickness=0.18 //x=21.945 //y=0.94 //x2=21.725 //y2=0.94
r310 (  127 144 ) resistor r=37.236 //w=0.233 //l=0.249199 //layer=ply \
 //thickness=0.18 //x=21.76 //y=5.045 //x2=21.58 //y2=4.88
r311 (  125 142 ) resistor r=39.5823 //w=0.21 //l=0.173853 //layer=ply \
 //thickness=0.18 //x=21.57 //y=1.75 //x2=21.61 //y2=1.595
r312 (  125 139 ) resistor r=176.904 //w=0.094 //l=0.345 //layer=ply \
 //thickness=0.18 //x=21.57 //y=1.75 //x2=21.57 //y2=2.095
r313 (  124 142 ) resistor r=39.5823 //w=0.21 //l=0.173853 //layer=ply \
 //thickness=0.18 //x=21.57 //y=1.44 //x2=21.61 //y2=1.595
r314 (  123 141 ) resistor r=45.1352 //w=0.168 //l=0.173853 //layer=ply \
 //thickness=0.18 //x=21.57 //y=1.095 //x2=21.61 //y2=0.94
r315 (  123 124 ) resistor r=176.904 //w=0.094 //l=0.345 //layer=ply \
 //thickness=0.18 //x=21.57 //y=1.095 //x2=21.57 //y2=1.44
r316 (  120 144 ) resistor r=53.7854 //w=0.233 //l=0.332415 //layer=ply \
 //thickness=0.18 //x=21.32 //y=5.045 //x2=21.58 //y2=4.88
r317 (  119 127 ) resistor r=592.245 //w=0.094 //l=1.155 //layer=ply \
 //thickness=0.18 //x=21.76 //y=6.2 //x2=21.76 //y2=5.045
r318 (  118 120 ) resistor r=592.245 //w=0.094 //l=1.155 //layer=ply \
 //thickness=0.18 //x=21.32 //y=6.2 //x2=21.32 //y2=5.045
r319 (  117 132 ) resistor r=56.4043 //w=0.094 //l=0.11 //layer=ply \
 //thickness=0.18 //x=21.835 //y=1.595 //x2=21.945 //y2=1.595
r320 (  117 133 ) resistor r=56.4043 //w=0.094 //l=0.11 //layer=ply \
 //thickness=0.18 //x=21.835 //y=1.595 //x2=21.725 //y2=1.595
r321 (  101 150 ) resistor r=23.615 //w=0.187 //l=0.345 //layer=li \
 //thickness=0.1 //x=25.17 //y=5.56 //x2=25.17 //y2=5.905
r322 (  93 149 ) resistor r=23.615 //w=0.187 //l=0.345 //layer=li \
 //thickness=0.1 //x=24.29 //y=5.56 //x2=24.29 //y2=5.905
r323 (  88 144 ) resistor r=152 //w=0.17 //l=0.17 //layer=licon //count=1 \
 //x=21.58 //y=4.88 //x2=21.58 //y2=4.88
r324 (  79 138 ) resistor r=152 //w=0.17 //l=0.17 //layer=licon //count=1 \
 //x=21.58 //y=2.26 //x2=21.58 //y2=2.26
r325 (  73 75 ) resistor r=0.10734 //w=0.281 //l=0.16 //layer=m2 \
 //thickness=0.36 //x=21.575 //y=3.865 //x2=21.735 //y2=3.865
r326 (  70 77 ) resistor r=0.286843 //w=0.24 //l=0.534977 //layer=m2 \
 //thickness=0.36 //x=25.115 //y=3.87 //x2=25.645 //y2=3.88
r327 (  70 71 ) resistor r=0.410305 //w=0.131 //l=0.43 //layer=m2 \
 //thickness=0.36 //x=25.115 //y=3.87 //x2=24.685 //y2=3.87
r328 (  68 71 ) resistor r=0.125 //w=0.17 //l=0.174929 //layer=m2 \
 //thickness=0.36 //x=24.515 //y=3.88 //x2=24.685 //y2=3.87
r329 (  68 75 ) resistor r=2.65267 //w=0.131 //l=2.78 //layer=m2 \
 //thickness=0.36 //x=24.515 //y=3.88 //x2=21.735 //y2=3.88
r330 (  63 147 ) resistor r=9.3 //w=0.17 //l=0.17 //layer=mcon //count=1 \
 //x=25.21 //y=1.18 //x2=25.21 //y2=1.18
r331 (  61 101 ) resistor r=9.3 //w=0.17 //l=0.17 //layer=mcon //count=1 \
 //x=25.17 //y=5.56 //x2=25.17 //y2=5.56
r332 (  58 61 ) resistor r=0.117801 //w=0.191 //l=0.18 //layer=m1 \
 //thickness=0.36 //x=25.17 //y=5.38 //x2=25.17 //y2=5.56
r333 (  57 93 ) resistor r=9.3 //w=0.17 //l=0.17 //layer=mcon //count=1 \
 //x=24.29 //y=5.56 //x2=24.29 //y2=5.56
r334 (  55 57 ) resistor r=0.10274 //w=0.219 //l=0.18 //layer=m1 \
 //thickness=0.36 //x=24.29 //y=5.38 //x2=24.29 //y2=5.56
r335 (  52 73 ) resistor r=4.5 //w=0.15 //l=0.15 //layer=via1 //count=1 \
 //x=21.575 //y=3.865 //x2=21.575 //y2=3.865
r336 (  50 88 ) resistor r=9.3 //w=0.17 //l=0.17 //layer=mcon //count=1 \
 //x=21.58 //y=4.88 //x2=21.58 //y2=4.88
r337 (  48 79 ) resistor r=9.3 //w=0.17 //l=0.17 //layer=mcon //count=1 \
 //x=21.58 //y=2.26 //x2=21.58 //y2=2.26
r338 (  34 36 ) resistor r=0.0698411 //w=0.17 //l=0.120208 //layer=m1 \
 //thickness=0.36 //x=25.565 //y=1.835 //x2=25.65 //y2=1.92
r339 (  34 35 ) resistor r=0.257634 //w=0.131 //l=0.27 //layer=m1 \
 //thickness=0.36 //x=25.565 //y=1.835 //x2=25.295 //y2=1.835
r340 (  33 58 ) resistor r=0.0257089 //w=0.23 //l=0.115 //layer=m1 \
 //thickness=0.36 //x=25.285 //y=5.38 //x2=25.17 //y2=5.38
r341 (  32 43 ) resistor r=0.0698411 //w=0.17 //l=0.120208 //layer=m1 \
 //thickness=0.36 //x=25.565 //y=5.38 //x2=25.65 //y2=5.295
r342 (  32 33 ) resistor r=0.267176 //w=0.131 //l=0.28 //layer=m1 \
 //thickness=0.36 //x=25.565 //y=5.38 //x2=25.285 //y2=5.38
r343 (  31 35 ) resistor r=0.0698411 //w=0.17 //l=0.120208 //layer=m1 \
 //thickness=0.36 //x=25.21 //y=1.75 //x2=25.295 //y2=1.835
r344 (  30 63 ) resistor r=0.0913624 //w=0.191 //l=0.12 //layer=m1 \
 //thickness=0.36 //x=25.21 //y=1.3 //x2=25.21 //y2=1.18
r345 (  30 31 ) resistor r=0.429389 //w=0.131 //l=0.45 //layer=m1 \
 //thickness=0.36 //x=25.21 //y=1.3 //x2=25.21 //y2=1.75
r346 (  27 55 ) resistor r=0.0227762 //w=0.219 //l=0.115 //layer=m1 \
 //thickness=0.36 //x=24.405 //y=5.38 //x2=24.29 //y2=5.38
r347 (  26 58 ) resistor r=0.0257089 //w=0.23 //l=0.115 //layer=m1 \
 //thickness=0.36 //x=25.055 //y=5.38 //x2=25.17 //y2=5.38
r348 (  26 27 ) resistor r=0.620229 //w=0.131 //l=0.65 //layer=m1 \
 //thickness=0.36 //x=25.055 //y=5.38 //x2=24.405 //y2=5.38
r349 (  22 50 ) resistor r=0.0801089 //w=0.224 //l=0.13 //layer=m1 \
 //thickness=0.36 //x=21.58 //y=4.75 //x2=21.58 //y2=4.88
r350 (  16 52 ) resistor r=0.0912814 //w=0.379 //l=0.183303 //layer=m1 \
 //thickness=0.36 //x=21.58 //y=3.705 //x2=21.63 //y2=3.865
r351 (  15 48 ) resistor r=0.0719237 //w=0.222 //l=0.115 //layer=m1 \
 //thickness=0.36 //x=21.58 //y=2.375 //x2=21.58 //y2=2.26
r352 (  14 77 ) resistor r=4.5 //w=0.15 //l=0.15 //layer=via1 //count=1 \
 //x=25.645 //y=3.88 //x2=25.645 //y2=3.88
r353 (  14 42 ) resistor r=0.0910802 //w=0.374 //l=0.185472 //layer=m1 \
 //thickness=0.36 //x=25.595 //y=3.88 //x2=25.65 //y2=4.04
r354 (  14 37 ) resistor r=0.0910802 //w=0.374 //l=0.185472 //layer=m1 \
 //thickness=0.36 //x=25.595 //y=3.88 //x2=25.65 //y2=3.72
r355 (  13 21 ) resistor r=0.0863342 //w=0.379 //l=0.168152 //layer=m1 \
 //thickness=0.36 //x=21.63 //y=3.88 //x2=21.58 //y2=4.025
r356 (  13 52 ) resistor r=0.00494723 //w=0.379 //l=0.015 //layer=m1 \
 //thickness=0.36 //x=21.63 //y=3.88 //x2=21.63 //y2=3.865
r357 (  12 43 ) resistor r=0.291031 //w=0.131 //l=0.305 //layer=m1 \
 //thickness=0.36 //x=25.65 //y=4.99 //x2=25.65 //y2=5.295
r358 (  11 12 ) resistor r=0.353053 //w=0.131 //l=0.37 //layer=m1 \
 //thickness=0.36 //x=25.65 //y=4.62 //x2=25.65 //y2=4.99
r359 (  10 11 ) resistor r=0.353053 //w=0.131 //l=0.37 //layer=m1 \
 //thickness=0.36 //x=25.65 //y=4.25 //x2=25.65 //y2=4.62
r360 (  10 42 ) resistor r=0.200382 //w=0.131 //l=0.21 //layer=m1 \
 //thickness=0.36 //x=25.65 //y=4.25 //x2=25.65 //y2=4.04
r361 (  9 37 ) resistor r=0.200382 //w=0.131 //l=0.21 //layer=m1 \
 //thickness=0.36 //x=25.65 //y=3.51 //x2=25.65 //y2=3.72
r362 (  8 9 ) resistor r=0.353053 //w=0.131 //l=0.37 //layer=m1 \
 //thickness=0.36 //x=25.65 //y=3.14 //x2=25.65 //y2=3.51
r363 (  7 8 ) resistor r=0.353053 //w=0.131 //l=0.37 //layer=m1 \
 //thickness=0.36 //x=25.65 //y=2.77 //x2=25.65 //y2=3.14
r364 (  6 7 ) resistor r=0.353053 //w=0.131 //l=0.37 //layer=m1 \
 //thickness=0.36 //x=25.65 //y=2.4 //x2=25.65 //y2=2.77
r365 (  6 36 ) resistor r=0.458015 //w=0.131 //l=0.48 //layer=m1 \
 //thickness=0.36 //x=25.65 //y=2.4 //x2=25.65 //y2=1.92
r366 (  5 22 ) resistor r=0.124046 //w=0.131 //l=0.13 //layer=m1 \
 //thickness=0.36 //x=21.58 //y=4.62 //x2=21.58 //y2=4.75
r367 (  5 21 ) resistor r=0.567748 //w=0.131 //l=0.595 //layer=m1 \
 //thickness=0.36 //x=21.58 //y=4.62 //x2=21.58 //y2=4.025
r368 (  4 16 ) resistor r=0.186069 //w=0.131 //l=0.195 //layer=m1 \
 //thickness=0.36 //x=21.58 //y=3.51 //x2=21.58 //y2=3.705
r369 (  3 4 ) resistor r=0.353053 //w=0.131 //l=0.37 //layer=m1 \
 //thickness=0.36 //x=21.58 //y=3.14 //x2=21.58 //y2=3.51
r370 (  2 3 ) resistor r=0.353053 //w=0.131 //l=0.37 //layer=m1 \
 //thickness=0.36 //x=21.58 //y=2.77 //x2=21.58 //y2=3.14
r371 (  1 2 ) resistor r=0.353053 //w=0.131 //l=0.37 //layer=m1 \
 //thickness=0.36 //x=21.58 //y=2.4 //x2=21.58 //y2=2.77
r372 (  1 15 ) resistor r=0.023855 //w=0.131 //l=0.025 //layer=m1 \
 //thickness=0.36 //x=21.58 //y=2.4 //x2=21.58 //y2=2.375
ends PM_DFFRNX1\%Q

subckt PM_DFFRNX1\%VDD ( 1 47 66 75 85 93 103 121 131 139 149 165 173 199 207 \
 217 227 243 251 261 271 287 297 310 317 322 327 333 339 343 344 345 346 347 \
 348 349 350 351 352 353 354 355 356 357 358 359 360 361 362 363 364 )
c396 ( 364 0 ) capacitor c=0.0393089f //x=25.465 //y=5.2
c397 ( 363 0 ) capacitor c=0.0248174f //x=24.585 //y=5.2
c398 ( 362 0 ) capacitor c=0.0630539f //x=23.715 //y=5.2
c399 ( 361 0 ) capacitor c=0.0466891f //x=21.835 //y=5.2
c400 ( 360 0 ) capacitor c=0.0255836f //x=20.955 //y=5.2
c401 ( 359 0 ) capacitor c=0.0256114f //x=20.075 //y=5.2
c402 ( 358 0 ) capacitor c=0.0676554f //x=19.205 //y=5.2
c403 ( 357 0 ) capacitor c=0.0466891f //x=17.025 //y=5.2
c404 ( 356 0 ) capacitor c=0.025617f //x=16.145 //y=5.2
c405 ( 355 0 ) capacitor c=0.0255777f //x=15.265 //y=5.2
c406 ( 354 0 ) capacitor c=0.0674699f //x=14.395 //y=5.2
c407 ( 353 0 ) capacitor c=0.039544f //x=12.515 //y=5.2
c408 ( 352 0 ) capacitor c=0.0248174f //x=11.635 //y=5.2
c409 ( 351 0 ) capacitor c=0.0628113f //x=10.765 //y=5.2
c410 ( 350 0 ) capacitor c=0.0466891f //x=8.885 //y=5.2
c411 ( 349 0 ) capacitor c=0.0255836f //x=8.005 //y=5.2
c412 ( 348 0 ) capacitor c=0.0256114f //x=7.125 //y=5.2
c413 ( 347 0 ) capacitor c=0.0675756f //x=6.255 //y=5.2
c414 ( 346 0 ) capacitor c=0.0466891f //x=4.075 //y=5.2
c415 ( 345 0 ) capacitor c=0.025617f //x=3.195 //y=5.2
c416 ( 344 0 ) capacitor c=0.0256114f //x=2.315 //y=5.2
c417 ( 343 0 ) capacitor c=0.0693233f //x=1.445 //y=5.2
c418 ( 342 0 ) capacitor c=0.00597439f //x=25.61 //y=7.585
c419 ( 341 0 ) capacitor c=0.00597439f //x=24.73 //y=7.585
c420 ( 340 0 ) capacitor c=0.00597439f //x=23.85 //y=7.585
c421 ( 339 0 ) capacitor c=0.145935f //x=23.06 //y=7.585
c422 ( 338 0 ) capacitor c=0.00597439f //x=21.98 //y=7.585
c423 ( 337 0 ) capacitor c=0.00597439f //x=21.1 //y=7.585
c424 ( 336 0 ) capacitor c=0.00597439f //x=20.22 //y=7.585
c425 ( 335 0 ) capacitor c=0.00597439f //x=19.36 //y=7.58
c426 ( 333 0 ) capacitor c=0.16206f //x=18.25 //y=7.585
c427 ( 332 0 ) capacitor c=0.00597439f //x=17.17 //y=7.585
c428 ( 331 0 ) capacitor c=0.00597439f //x=16.29 //y=7.585
c429 ( 330 0 ) capacitor c=0.00597439f //x=15.41 //y=7.585
c430 ( 329 0 ) capacitor c=0.00597439f //x=14.55 //y=7.58
c431 ( 327 0 ) capacitor c=0.144432f //x=13.44 //y=7.585
c432 ( 326 0 ) capacitor c=0.00597439f //x=12.66 //y=7.585
c433 ( 325 0 ) capacitor c=0.00597439f //x=11.78 //y=7.585
c434 ( 324 0 ) capacitor c=0.00597439f //x=10.85 //y=7.58
c435 ( 322 0 ) capacitor c=0.145153f //x=10.11 //y=7.585
c436 ( 321 0 ) capacitor c=0.00597439f //x=9.03 //y=7.585
c437 ( 320 0 ) capacitor c=0.00597439f //x=8.15 //y=7.585
c438 ( 319 0 ) capacitor c=0.00597439f //x=7.27 //y=7.585
c439 ( 318 0 ) capacitor c=0.00597439f //x=6.39 //y=7.585
c440 ( 317 0 ) capacitor c=0.163341f //x=5.3 //y=7.585
c441 ( 316 0 ) capacitor c=0.00597439f //x=4.22 //y=7.585
c442 ( 315 0 ) capacitor c=0.00597439f //x=3.34 //y=7.585
c443 ( 314 0 ) capacitor c=0.00597439f //x=2.46 //y=7.585
c444 ( 313 0 ) capacitor c=0.00597439f //x=1.58 //y=7.585
c445 ( 310 0 ) capacitor c=0.261935f //x=26.02 //y=7.58
c446 ( 297 0 ) capacitor c=0.0287376f //x=25.525 //y=7.585
c447 ( 287 0 ) capacitor c=0.0291078f //x=24.645 //y=7.585
c448 ( 277 0 ) capacitor c=0.0283511f //x=23.765 //y=7.585
c449 ( 271 0 ) capacitor c=0.042257f //x=22.89 //y=7.585
c450 ( 261 0 ) capacitor c=0.0288858f //x=21.895 //y=7.585
c451 ( 251 0 ) capacitor c=0.0289326f //x=21.015 //y=7.585
c452 ( 243 0 ) capacitor c=0.0290299f //x=20.135 //y=7.585
c453 ( 233 0 ) capacitor c=0.0455283f //x=19.255 //y=7.585
c454 ( 227 0 ) capacitor c=0.0427734f //x=18.08 //y=7.585
c455 ( 217 0 ) capacitor c=0.0288858f //x=17.085 //y=7.585
c456 ( 207 0 ) capacitor c=0.0289326f //x=16.205 //y=7.585
c457 ( 199 0 ) capacitor c=0.0290299f //x=15.325 //y=7.585
c458 ( 189 0 ) capacitor c=0.0455283f //x=14.445 //y=7.585
c459 ( 183 0 ) capacitor c=0.0277785f //x=13.27 //y=7.585
c460 ( 173 0 ) capacitor c=0.0287376f //x=12.575 //y=7.585
c461 ( 165 0 ) capacitor c=0.0291078f //x=11.695 //y=7.585
c462 ( 155 0 ) capacitor c=0.0283511f //x=10.815 //y=7.585
c463 ( 149 0 ) capacitor c=0.042257f //x=9.94 //y=7.585
c464 ( 139 0 ) capacitor c=0.0288858f //x=8.945 //y=7.585
c465 ( 131 0 ) capacitor c=0.0289326f //x=8.065 //y=7.585
c466 ( 121 0 ) capacitor c=0.0290299f //x=7.185 //y=7.585
c467 ( 109 0 ) capacitor c=0.0455283f //x=6.305 //y=7.585
c468 ( 103 0 ) capacitor c=0.042257f //x=5.13 //y=7.585
c469 ( 93 0 ) capacitor c=0.0288858f //x=4.135 //y=7.585
c470 ( 85 0 ) capacitor c=0.0289326f //x=3.255 //y=7.585
c471 ( 75 0 ) capacitor c=0.0289834f //x=2.375 //y=7.585
c472 ( 66 0 ) capacitor c=0.253533f //x=1.23 //y=7.58
c473 ( 63 0 ) capacitor c=0.0454931f //x=1.495 //y=7.585
c474 ( 47 0 ) capacitor c=0.983194f //x=26.02 //y=7.58
r475 (  308 342 ) resistor r=2.87058 //w=0.35 //l=0.085 //layer=li \
 //thickness=0.1 //x=25.695 //y=7.585 //x2=25.61 //y2=7.585
r476 (  308 310 ) resistor r=11.3351 //w=0.367 //l=0.325 //layer=li \
 //thickness=0.1 //x=25.695 //y=7.585 //x2=26.02 //y2=7.585
r477 (  301 342 ) resistor r=4.23183 //w=0.7 //l=0.175 //layer=li \
 //thickness=0.1 //x=25.61 //y=7.41 //x2=25.61 //y2=7.585
r478 (  301 364 ) resistor r=33.1979 //w=0.187 //l=0.485 //layer=li \
 //thickness=0.1 //x=25.61 //y=7.41 //x2=25.61 //y2=6.925
r479 (  298 341 ) resistor r=2.87058 //w=0.35 //l=0.085 //layer=li \
 //thickness=0.1 //x=24.815 //y=7.585 //x2=24.73 //y2=7.585
r480 (  298 300 ) resistor r=16.218 //w=0.367 //l=0.465 //layer=li \
 //thickness=0.1 //x=24.815 //y=7.585 //x2=25.28 //y2=7.585
r481 (  297 342 ) resistor r=2.87058 //w=0.35 //l=0.085 //layer=li \
 //thickness=0.1 //x=25.525 //y=7.585 //x2=25.61 //y2=7.585
r482 (  297 300 ) resistor r=8.54496 //w=0.367 //l=0.245 //layer=li \
 //thickness=0.1 //x=25.525 //y=7.585 //x2=25.28 //y2=7.585
r483 (  291 341 ) resistor r=4.23183 //w=0.7 //l=0.175 //layer=li \
 //thickness=0.1 //x=24.73 //y=7.41 //x2=24.73 //y2=7.585
r484 (  291 363 ) resistor r=33.1979 //w=0.187 //l=0.485 //layer=li \
 //thickness=0.1 //x=24.73 //y=7.41 //x2=24.73 //y2=6.925
r485 (  288 340 ) resistor r=2.87058 //w=0.35 //l=0.085 //layer=li \
 //thickness=0.1 //x=23.935 //y=7.585 //x2=23.85 //y2=7.585
r486 (  288 290 ) resistor r=8.19619 //w=0.367 //l=0.235 //layer=li \
 //thickness=0.1 //x=23.935 //y=7.585 //x2=24.17 //y2=7.585
r487 (  287 341 ) resistor r=2.87058 //w=0.35 //l=0.085 //layer=li \
 //thickness=0.1 //x=24.645 //y=7.585 //x2=24.73 //y2=7.585
r488 (  287 290 ) resistor r=16.5668 //w=0.367 //l=0.475 //layer=li \
 //thickness=0.1 //x=24.645 //y=7.585 //x2=24.17 //y2=7.585
r489 (  279 340 ) resistor r=4.23183 //w=0.7 //l=0.175 //layer=li \
 //thickness=0.1 //x=23.85 //y=7.41 //x2=23.85 //y2=7.585
r490 (  279 362 ) resistor r=56.4706 //w=0.187 //l=0.825 //layer=li \
 //thickness=0.1 //x=23.85 //y=7.41 //x2=23.85 //y2=6.585
r491 (  278 339 ) resistor r=5.29055 //w=0.35 //l=0.17 //layer=li \
 //thickness=0.1 //x=23.23 //y=7.585 //x2=23.06 //y2=7.585
r492 (  277 340 ) resistor r=2.87058 //w=0.35 //l=0.085 //layer=li \
 //thickness=0.1 //x=23.765 //y=7.585 //x2=23.85 //y2=7.585
r493 (  277 278 ) resistor r=18.6594 //w=0.367 //l=0.535 //layer=li \
 //thickness=0.1 //x=23.765 //y=7.585 //x2=23.23 //y2=7.585
r494 (  272 338 ) resistor r=2.87058 //w=0.35 //l=0.085 //layer=li \
 //thickness=0.1 //x=22.065 //y=7.585 //x2=21.98 //y2=7.585
r495 (  272 274 ) resistor r=21.7984 //w=0.367 //l=0.625 //layer=li \
 //thickness=0.1 //x=22.065 //y=7.585 //x2=22.69 //y2=7.585
r496 (  271 339 ) resistor r=5.29055 //w=0.35 //l=0.17 //layer=li \
 //thickness=0.1 //x=22.89 //y=7.585 //x2=23.06 //y2=7.585
r497 (  271 274 ) resistor r=6.97548 //w=0.367 //l=0.2 //layer=li \
 //thickness=0.1 //x=22.89 //y=7.585 //x2=22.69 //y2=7.585
r498 (  265 338 ) resistor r=4.23183 //w=0.7 //l=0.175 //layer=li \
 //thickness=0.1 //x=21.98 //y=7.41 //x2=21.98 //y2=7.585
r499 (  265 361 ) resistor r=33.1979 //w=0.187 //l=0.485 //layer=li \
 //thickness=0.1 //x=21.98 //y=7.41 //x2=21.98 //y2=6.925
r500 (  262 337 ) resistor r=2.87058 //w=0.35 //l=0.085 //layer=li \
 //thickness=0.1 //x=21.185 //y=7.585 //x2=21.1 //y2=7.585
r501 (  262 264 ) resistor r=13.7766 //w=0.367 //l=0.395 //layer=li \
 //thickness=0.1 //x=21.185 //y=7.585 //x2=21.58 //y2=7.585
r502 (  261 338 ) resistor r=2.87058 //w=0.35 //l=0.085 //layer=li \
 //thickness=0.1 //x=21.895 //y=7.585 //x2=21.98 //y2=7.585
r503 (  261 264 ) resistor r=10.9864 //w=0.367 //l=0.315 //layer=li \
 //thickness=0.1 //x=21.895 //y=7.585 //x2=21.58 //y2=7.585
r504 (  255 337 ) resistor r=4.23183 //w=0.7 //l=0.175 //layer=li \
 //thickness=0.1 //x=21.1 //y=7.41 //x2=21.1 //y2=7.585
r505 (  255 360 ) resistor r=33.1979 //w=0.187 //l=0.485 //layer=li \
 //thickness=0.1 //x=21.1 //y=7.41 //x2=21.1 //y2=6.925
r506 (  252 336 ) resistor r=2.87058 //w=0.35 //l=0.085 //layer=li \
 //thickness=0.1 //x=20.305 //y=7.585 //x2=20.22 //y2=7.585
r507 (  252 254 ) resistor r=5.75477 //w=0.367 //l=0.165 //layer=li \
 //thickness=0.1 //x=20.305 //y=7.585 //x2=20.47 //y2=7.585
r508 (  251 337 ) resistor r=2.87058 //w=0.35 //l=0.085 //layer=li \
 //thickness=0.1 //x=21.015 //y=7.585 //x2=21.1 //y2=7.585
r509 (  251 254 ) resistor r=19.0082 //w=0.367 //l=0.545 //layer=li \
 //thickness=0.1 //x=21.015 //y=7.585 //x2=20.47 //y2=7.585
r510 (  245 336 ) resistor r=4.23183 //w=0.7 //l=0.175 //layer=li \
 //thickness=0.1 //x=20.22 //y=7.41 //x2=20.22 //y2=7.585
r511 (  245 359 ) resistor r=33.1979 //w=0.187 //l=0.485 //layer=li \
 //thickness=0.1 //x=20.22 //y=7.41 //x2=20.22 //y2=6.925
r512 (  244 335 ) resistor r=2.87058 //w=0.35 //l=0.085 //layer=li \
 //thickness=0.1 //x=19.425 //y=7.585 //x2=19.34 //y2=7.585
r513 (  243 336 ) resistor r=2.87058 //w=0.35 //l=0.085 //layer=li \
 //thickness=0.1 //x=20.135 //y=7.585 //x2=20.22 //y2=7.585
r514 (  243 244 ) resistor r=24.7629 //w=0.367 //l=0.71 //layer=li \
 //thickness=0.1 //x=20.135 //y=7.585 //x2=19.425 //y2=7.585
r515 (  235 335 ) resistor r=4.23183 //w=0.7 //l=0.175 //layer=li \
 //thickness=0.1 //x=19.34 //y=7.41 //x2=19.34 //y2=7.585
r516 (  235 358 ) resistor r=56.4706 //w=0.187 //l=0.825 //layer=li \
 //thickness=0.1 //x=19.34 //y=7.41 //x2=19.34 //y2=6.585
r517 (  234 333 ) resistor r=5.29055 //w=0.35 //l=0.17 //layer=li \
 //thickness=0.1 //x=18.42 //y=7.585 //x2=18.25 //y2=7.585
r518 (  233 335 ) resistor r=2.87058 //w=0.35 //l=0.085 //layer=li \
 //thickness=0.1 //x=19.255 //y=7.585 //x2=19.34 //y2=7.585
r519 (  233 234 ) resistor r=29.1226 //w=0.367 //l=0.835 //layer=li \
 //thickness=0.1 //x=19.255 //y=7.585 //x2=18.42 //y2=7.585
r520 (  228 332 ) resistor r=2.87058 //w=0.35 //l=0.085 //layer=li \
 //thickness=0.1 //x=17.255 //y=7.585 //x2=17.17 //y2=7.585
r521 (  228 230 ) resistor r=21.7984 //w=0.367 //l=0.625 //layer=li \
 //thickness=0.1 //x=17.255 //y=7.585 //x2=17.88 //y2=7.585
r522 (  227 333 ) resistor r=5.29055 //w=0.35 //l=0.17 //layer=li \
 //thickness=0.1 //x=18.08 //y=7.585 //x2=18.25 //y2=7.585
r523 (  227 230 ) resistor r=6.97548 //w=0.367 //l=0.2 //layer=li \
 //thickness=0.1 //x=18.08 //y=7.585 //x2=17.88 //y2=7.585
r524 (  221 332 ) resistor r=4.23183 //w=0.7 //l=0.175 //layer=li \
 //thickness=0.1 //x=17.17 //y=7.41 //x2=17.17 //y2=7.585
r525 (  221 357 ) resistor r=33.1979 //w=0.187 //l=0.485 //layer=li \
 //thickness=0.1 //x=17.17 //y=7.41 //x2=17.17 //y2=6.925
r526 (  218 331 ) resistor r=2.87058 //w=0.35 //l=0.085 //layer=li \
 //thickness=0.1 //x=16.375 //y=7.585 //x2=16.29 //y2=7.585
r527 (  218 220 ) resistor r=13.7766 //w=0.367 //l=0.395 //layer=li \
 //thickness=0.1 //x=16.375 //y=7.585 //x2=16.77 //y2=7.585
r528 (  217 332 ) resistor r=2.87058 //w=0.35 //l=0.085 //layer=li \
 //thickness=0.1 //x=17.085 //y=7.585 //x2=17.17 //y2=7.585
r529 (  217 220 ) resistor r=10.9864 //w=0.367 //l=0.315 //layer=li \
 //thickness=0.1 //x=17.085 //y=7.585 //x2=16.77 //y2=7.585
r530 (  211 331 ) resistor r=4.23183 //w=0.7 //l=0.175 //layer=li \
 //thickness=0.1 //x=16.29 //y=7.41 //x2=16.29 //y2=7.585
r531 (  211 356 ) resistor r=33.1979 //w=0.187 //l=0.485 //layer=li \
 //thickness=0.1 //x=16.29 //y=7.41 //x2=16.29 //y2=6.925
r532 (  208 330 ) resistor r=2.87058 //w=0.35 //l=0.085 //layer=li \
 //thickness=0.1 //x=15.495 //y=7.585 //x2=15.41 //y2=7.585
r533 (  208 210 ) resistor r=5.75477 //w=0.367 //l=0.165 //layer=li \
 //thickness=0.1 //x=15.495 //y=7.585 //x2=15.66 //y2=7.585
r534 (  207 331 ) resistor r=2.87058 //w=0.35 //l=0.085 //layer=li \
 //thickness=0.1 //x=16.205 //y=7.585 //x2=16.29 //y2=7.585
r535 (  207 210 ) resistor r=19.0082 //w=0.367 //l=0.545 //layer=li \
 //thickness=0.1 //x=16.205 //y=7.585 //x2=15.66 //y2=7.585
r536 (  201 330 ) resistor r=4.23183 //w=0.7 //l=0.175 //layer=li \
 //thickness=0.1 //x=15.41 //y=7.41 //x2=15.41 //y2=7.585
r537 (  201 355 ) resistor r=33.1979 //w=0.187 //l=0.485 //layer=li \
 //thickness=0.1 //x=15.41 //y=7.41 //x2=15.41 //y2=6.925
r538 (  200 329 ) resistor r=2.87058 //w=0.35 //l=0.085 //layer=li \
 //thickness=0.1 //x=14.615 //y=7.585 //x2=14.53 //y2=7.585
r539 (  199 330 ) resistor r=2.87058 //w=0.35 //l=0.085 //layer=li \
 //thickness=0.1 //x=15.325 //y=7.585 //x2=15.41 //y2=7.585
r540 (  199 200 ) resistor r=24.7629 //w=0.367 //l=0.71 //layer=li \
 //thickness=0.1 //x=15.325 //y=7.585 //x2=14.615 //y2=7.585
r541 (  191 329 ) resistor r=4.23183 //w=0.7 //l=0.175 //layer=li \
 //thickness=0.1 //x=14.53 //y=7.41 //x2=14.53 //y2=7.585
r542 (  191 354 ) resistor r=56.4706 //w=0.187 //l=0.825 //layer=li \
 //thickness=0.1 //x=14.53 //y=7.41 //x2=14.53 //y2=6.585
r543 (  190 327 ) resistor r=5.29055 //w=0.35 //l=0.17 //layer=li \
 //thickness=0.1 //x=13.61 //y=7.585 //x2=13.44 //y2=7.585
r544 (  189 329 ) resistor r=2.87058 //w=0.35 //l=0.085 //layer=li \
 //thickness=0.1 //x=14.445 //y=7.585 //x2=14.53 //y2=7.585
r545 (  189 190 ) resistor r=29.1226 //w=0.367 //l=0.835 //layer=li \
 //thickness=0.1 //x=14.445 //y=7.585 //x2=13.61 //y2=7.585
r546 (  184 326 ) resistor r=2.87058 //w=0.35 //l=0.085 //layer=li \
 //thickness=0.1 //x=12.745 //y=7.585 //x2=12.66 //y2=7.585
r547 (  184 186 ) resistor r=11.3351 //w=0.367 //l=0.325 //layer=li \
 //thickness=0.1 //x=12.745 //y=7.585 //x2=13.07 //y2=7.585
r548 (  183 327 ) resistor r=5.29055 //w=0.35 //l=0.17 //layer=li \
 //thickness=0.1 //x=13.27 //y=7.585 //x2=13.44 //y2=7.585
r549 (  183 186 ) resistor r=6.97548 //w=0.367 //l=0.2 //layer=li \
 //thickness=0.1 //x=13.27 //y=7.585 //x2=13.07 //y2=7.585
r550 (  177 326 ) resistor r=4.23183 //w=0.7 //l=0.175 //layer=li \
 //thickness=0.1 //x=12.66 //y=7.41 //x2=12.66 //y2=7.585
r551 (  177 353 ) resistor r=33.1979 //w=0.187 //l=0.485 //layer=li \
 //thickness=0.1 //x=12.66 //y=7.41 //x2=12.66 //y2=6.925
r552 (  174 325 ) resistor r=2.87058 //w=0.35 //l=0.085 //layer=li \
 //thickness=0.1 //x=11.865 //y=7.585 //x2=11.78 //y2=7.585
r553 (  174 176 ) resistor r=3.31335 //w=0.367 //l=0.095 //layer=li \
 //thickness=0.1 //x=11.865 //y=7.585 //x2=11.96 //y2=7.585
r554 (  173 326 ) resistor r=2.87058 //w=0.35 //l=0.085 //layer=li \
 //thickness=0.1 //x=12.575 //y=7.585 //x2=12.66 //y2=7.585
r555 (  173 176 ) resistor r=21.4496 //w=0.367 //l=0.615 //layer=li \
 //thickness=0.1 //x=12.575 //y=7.585 //x2=11.96 //y2=7.585
r556 (  167 325 ) resistor r=4.23183 //w=0.7 //l=0.175 //layer=li \
 //thickness=0.1 //x=11.78 //y=7.41 //x2=11.78 //y2=7.585
r557 (  167 352 ) resistor r=33.1979 //w=0.187 //l=0.485 //layer=li \
 //thickness=0.1 //x=11.78 //y=7.41 //x2=11.78 //y2=6.925
r558 (  166 324 ) resistor r=2.87058 //w=0.35 //l=0.085 //layer=li \
 //thickness=0.1 //x=10.985 //y=7.585 //x2=10.9 //y2=7.585
r559 (  165 325 ) resistor r=2.87058 //w=0.35 //l=0.085 //layer=li \
 //thickness=0.1 //x=11.695 //y=7.585 //x2=11.78 //y2=7.585
r560 (  165 166 ) resistor r=24.7629 //w=0.367 //l=0.71 //layer=li \
 //thickness=0.1 //x=11.695 //y=7.585 //x2=10.985 //y2=7.585
r561 (  157 324 ) resistor r=4.23183 //w=0.7 //l=0.175 //layer=li \
 //thickness=0.1 //x=10.9 //y=7.41 //x2=10.9 //y2=7.585
r562 (  157 351 ) resistor r=56.4706 //w=0.187 //l=0.825 //layer=li \
 //thickness=0.1 //x=10.9 //y=7.41 //x2=10.9 //y2=6.585
r563 (  156 322 ) resistor r=5.29055 //w=0.35 //l=0.17 //layer=li \
 //thickness=0.1 //x=10.28 //y=7.585 //x2=10.11 //y2=7.585
r564 (  155 324 ) resistor r=2.87058 //w=0.35 //l=0.085 //layer=li \
 //thickness=0.1 //x=10.815 //y=7.585 //x2=10.9 //y2=7.585
r565 (  155 156 ) resistor r=18.6594 //w=0.367 //l=0.535 //layer=li \
 //thickness=0.1 //x=10.815 //y=7.585 //x2=10.28 //y2=7.585
r566 (  150 321 ) resistor r=2.87058 //w=0.35 //l=0.085 //layer=li \
 //thickness=0.1 //x=9.115 //y=7.585 //x2=9.03 //y2=7.585
r567 (  150 152 ) resistor r=8.89373 //w=0.367 //l=0.255 //layer=li \
 //thickness=0.1 //x=9.115 //y=7.585 //x2=9.37 //y2=7.585
r568 (  149 322 ) resistor r=5.29055 //w=0.35 //l=0.17 //layer=li \
 //thickness=0.1 //x=9.94 //y=7.585 //x2=10.11 //y2=7.585
r569 (  149 152 ) resistor r=19.8801 //w=0.367 //l=0.57 //layer=li \
 //thickness=0.1 //x=9.94 //y=7.585 //x2=9.37 //y2=7.585
r570 (  143 321 ) resistor r=4.23183 //w=0.7 //l=0.175 //layer=li \
 //thickness=0.1 //x=9.03 //y=7.41 //x2=9.03 //y2=7.585
r571 (  143 350 ) resistor r=33.1979 //w=0.187 //l=0.485 //layer=li \
 //thickness=0.1 //x=9.03 //y=7.41 //x2=9.03 //y2=6.925
r572 (  140 320 ) resistor r=2.87058 //w=0.35 //l=0.085 //layer=li \
 //thickness=0.1 //x=8.235 //y=7.585 //x2=8.15 //y2=7.585
r573 (  140 142 ) resistor r=0.871935 //w=0.367 //l=0.025 //layer=li \
 //thickness=0.1 //x=8.235 //y=7.585 //x2=8.26 //y2=7.585
r574 (  139 321 ) resistor r=2.87058 //w=0.35 //l=0.085 //layer=li \
 //thickness=0.1 //x=8.945 //y=7.585 //x2=9.03 //y2=7.585
r575 (  139 142 ) resistor r=23.891 //w=0.367 //l=0.685 //layer=li \
 //thickness=0.1 //x=8.945 //y=7.585 //x2=8.26 //y2=7.585
r576 (  133 320 ) resistor r=4.23183 //w=0.7 //l=0.175 //layer=li \
 //thickness=0.1 //x=8.15 //y=7.41 //x2=8.15 //y2=7.585
r577 (  133 349 ) resistor r=33.1979 //w=0.187 //l=0.485 //layer=li \
 //thickness=0.1 //x=8.15 //y=7.41 //x2=8.15 //y2=6.925
r578 (  132 319 ) resistor r=2.87058 //w=0.35 //l=0.085 //layer=li \
 //thickness=0.1 //x=7.355 //y=7.585 //x2=7.27 //y2=7.585
r579 (  131 320 ) resistor r=2.87058 //w=0.35 //l=0.085 //layer=li \
 //thickness=0.1 //x=8.065 //y=7.585 //x2=8.15 //y2=7.585
r580 (  131 132 ) resistor r=24.7629 //w=0.367 //l=0.71 //layer=li \
 //thickness=0.1 //x=8.065 //y=7.585 //x2=7.355 //y2=7.585
r581 (  125 319 ) resistor r=4.23183 //w=0.7 //l=0.175 //layer=li \
 //thickness=0.1 //x=7.27 //y=7.41 //x2=7.27 //y2=7.585
r582 (  125 348 ) resistor r=33.1979 //w=0.187 //l=0.485 //layer=li \
 //thickness=0.1 //x=7.27 //y=7.41 //x2=7.27 //y2=6.925
r583 (  122 318 ) resistor r=2.87058 //w=0.35 //l=0.085 //layer=li \
 //thickness=0.1 //x=6.475 //y=7.585 //x2=6.39 //y2=7.585
r584 (  122 124 ) resistor r=23.5422 //w=0.367 //l=0.675 //layer=li \
 //thickness=0.1 //x=6.475 //y=7.585 //x2=7.15 //y2=7.585
r585 (  121 319 ) resistor r=2.87058 //w=0.35 //l=0.085 //layer=li \
 //thickness=0.1 //x=7.185 //y=7.585 //x2=7.27 //y2=7.585
r586 (  121 124 ) resistor r=1.22071 //w=0.367 //l=0.035 //layer=li \
 //thickness=0.1 //x=7.185 //y=7.585 //x2=7.15 //y2=7.585
r587 (  113 318 ) resistor r=4.23183 //w=0.7 //l=0.175 //layer=li \
 //thickness=0.1 //x=6.39 //y=7.41 //x2=6.39 //y2=7.585
r588 (  113 347 ) resistor r=56.4706 //w=0.187 //l=0.825 //layer=li \
 //thickness=0.1 //x=6.39 //y=7.41 //x2=6.39 //y2=6.585
r589 (  110 317 ) resistor r=5.29055 //w=0.35 //l=0.17 //layer=li \
 //thickness=0.1 //x=5.47 //y=7.585 //x2=5.3 //y2=7.585
r590 (  110 112 ) resistor r=19.8801 //w=0.367 //l=0.57 //layer=li \
 //thickness=0.1 //x=5.47 //y=7.585 //x2=6.04 //y2=7.585
r591 (  109 318 ) resistor r=2.87058 //w=0.35 //l=0.085 //layer=li \
 //thickness=0.1 //x=6.305 //y=7.585 //x2=6.39 //y2=7.585
r592 (  109 112 ) resistor r=9.24251 //w=0.367 //l=0.265 //layer=li \
 //thickness=0.1 //x=6.305 //y=7.585 //x2=6.04 //y2=7.585
r593 (  104 316 ) resistor r=2.87058 //w=0.35 //l=0.085 //layer=li \
 //thickness=0.1 //x=4.305 //y=7.585 //x2=4.22 //y2=7.585
r594 (  104 106 ) resistor r=8.89373 //w=0.367 //l=0.255 //layer=li \
 //thickness=0.1 //x=4.305 //y=7.585 //x2=4.56 //y2=7.585
r595 (  103 317 ) resistor r=5.29055 //w=0.35 //l=0.17 //layer=li \
 //thickness=0.1 //x=5.13 //y=7.585 //x2=5.3 //y2=7.585
r596 (  103 106 ) resistor r=19.8801 //w=0.367 //l=0.57 //layer=li \
 //thickness=0.1 //x=5.13 //y=7.585 //x2=4.56 //y2=7.585
r597 (  97 316 ) resistor r=4.23183 //w=0.7 //l=0.175 //layer=li \
 //thickness=0.1 //x=4.22 //y=7.41 //x2=4.22 //y2=7.585
r598 (  97 346 ) resistor r=33.1979 //w=0.187 //l=0.485 //layer=li \
 //thickness=0.1 //x=4.22 //y=7.41 //x2=4.22 //y2=6.925
r599 (  94 315 ) resistor r=2.87058 //w=0.35 //l=0.085 //layer=li \
 //thickness=0.1 //x=3.425 //y=7.585 //x2=3.34 //y2=7.585
r600 (  94 96 ) resistor r=0.871935 //w=0.367 //l=0.025 //layer=li \
 //thickness=0.1 //x=3.425 //y=7.585 //x2=3.45 //y2=7.585
r601 (  93 316 ) resistor r=2.87058 //w=0.35 //l=0.085 //layer=li \
 //thickness=0.1 //x=4.135 //y=7.585 //x2=4.22 //y2=7.585
r602 (  93 96 ) resistor r=23.891 //w=0.367 //l=0.685 //layer=li \
 //thickness=0.1 //x=4.135 //y=7.585 //x2=3.45 //y2=7.585
r603 (  87 315 ) resistor r=4.23183 //w=0.7 //l=0.175 //layer=li \
 //thickness=0.1 //x=3.34 //y=7.41 //x2=3.34 //y2=7.585
r604 (  87 345 ) resistor r=33.1979 //w=0.187 //l=0.485 //layer=li \
 //thickness=0.1 //x=3.34 //y=7.41 //x2=3.34 //y2=6.925
r605 (  86 314 ) resistor r=2.87058 //w=0.35 //l=0.085 //layer=li \
 //thickness=0.1 //x=2.545 //y=7.585 //x2=2.46 //y2=7.585
r606 (  85 315 ) resistor r=2.87058 //w=0.35 //l=0.085 //layer=li \
 //thickness=0.1 //x=3.255 //y=7.585 //x2=3.34 //y2=7.585
r607 (  85 86 ) resistor r=24.7629 //w=0.367 //l=0.71 //layer=li \
 //thickness=0.1 //x=3.255 //y=7.585 //x2=2.545 //y2=7.585
r608 (  79 314 ) resistor r=4.23183 //w=0.7 //l=0.175 //layer=li \
 //thickness=0.1 //x=2.46 //y=7.41 //x2=2.46 //y2=7.585
r609 (  79 344 ) resistor r=33.1979 //w=0.187 //l=0.485 //layer=li \
 //thickness=0.1 //x=2.46 //y=7.41 //x2=2.46 //y2=6.925
r610 (  76 313 ) resistor r=2.87058 //w=0.35 //l=0.085 //layer=li \
 //thickness=0.1 //x=1.665 //y=7.585 //x2=1.58 //y2=7.585
r611 (  76 78 ) resistor r=23.5422 //w=0.367 //l=0.675 //layer=li \
 //thickness=0.1 //x=1.665 //y=7.585 //x2=2.34 //y2=7.585
r612 (  75 314 ) resistor r=2.87058 //w=0.35 //l=0.085 //layer=li \
 //thickness=0.1 //x=2.375 //y=7.585 //x2=2.46 //y2=7.585
r613 (  75 78 ) resistor r=1.22071 //w=0.367 //l=0.035 //layer=li \
 //thickness=0.1 //x=2.375 //y=7.585 //x2=2.34 //y2=7.585
r614 (  67 313 ) resistor r=4.23183 //w=0.7 //l=0.175 //layer=li \
 //thickness=0.1 //x=1.58 //y=7.41 //x2=1.58 //y2=7.585
r615 (  67 343 ) resistor r=56.4706 //w=0.187 //l=0.825 //layer=li \
 //thickness=0.1 //x=1.58 //y=7.41 //x2=1.58 //y2=6.585
r616 (  63 313 ) resistor r=2.87058 //w=0.35 //l=0.085 //layer=li \
 //thickness=0.1 //x=1.495 //y=7.585 //x2=1.58 //y2=7.585
r617 (  63 66 ) resistor r=9.24251 //w=0.367 //l=0.265 //layer=li \
 //thickness=0.1 //x=1.495 //y=7.585 //x2=1.23 //y2=7.585
r618 (  47 310 ) resistor r=9.3 //w=0.17 //l=0.17 //layer=mcon //count=1 \
 //x=26.02 //y=7.58 //x2=26.02 //y2=7.58
r619 (  45 300 ) resistor r=3.1 //w=0.17 //l=0.51 //layer=mcon //count=3 \
 //x=25.28 //y=7.58 //x2=25.28 //y2=7.58
r620 (  45 47 ) resistor r=0.297428 //w=0.311 //l=0.74 //layer=m1 \
 //thickness=0.36 //x=25.28 //y=7.585 //x2=26.02 //y2=7.585
r621 (  43 290 ) resistor r=3.1 //w=0.17 //l=0.51 //layer=mcon //count=3 \
 //x=24.17 //y=7.58 //x2=24.17 //y2=7.58
r622 (  43 45 ) resistor r=0.446141 //w=0.311 //l=1.11 //layer=m1 \
 //thickness=0.36 //x=24.17 //y=7.585 //x2=25.28 //y2=7.585
r623 (  41 274 ) resistor r=3.1 //w=0.17 //l=0.51 //layer=mcon //count=3 \
 //x=22.69 //y=7.58 //x2=22.69 //y2=7.58
r624 (  41 43 ) resistor r=0.594855 //w=0.311 //l=1.48 //layer=m1 \
 //thickness=0.36 //x=22.69 //y=7.585 //x2=24.17 //y2=7.585
r625 (  39 264 ) resistor r=3.1 //w=0.17 //l=0.51 //layer=mcon //count=3 \
 //x=21.58 //y=7.58 //x2=21.58 //y2=7.58
r626 (  39 41 ) resistor r=0.446141 //w=0.311 //l=1.11 //layer=m1 \
 //thickness=0.36 //x=21.58 //y=7.585 //x2=22.69 //y2=7.585
r627 (  37 254 ) resistor r=3.1 //w=0.17 //l=0.51 //layer=mcon //count=3 \
 //x=20.47 //y=7.58 //x2=20.47 //y2=7.58
r628 (  37 39 ) resistor r=0.446141 //w=0.311 //l=1.11 //layer=m1 \
 //thickness=0.36 //x=20.47 //y=7.585 //x2=21.58 //y2=7.585
r629 (  35 335 ) resistor r=3.1 //w=0.17 //l=0.51 //layer=mcon //count=3 \
 //x=19.36 //y=7.58 //x2=19.36 //y2=7.58
r630 (  35 37 ) resistor r=0.446141 //w=0.311 //l=1.11 //layer=m1 \
 //thickness=0.36 //x=19.36 //y=7.585 //x2=20.47 //y2=7.585
r631 (  33 230 ) resistor r=3.1 //w=0.17 //l=0.51 //layer=mcon //count=3 \
 //x=17.88 //y=7.58 //x2=17.88 //y2=7.58
r632 (  33 35 ) resistor r=0.594855 //w=0.311 //l=1.48 //layer=m1 \
 //thickness=0.36 //x=17.88 //y=7.585 //x2=19.36 //y2=7.585
r633 (  31 220 ) resistor r=3.1 //w=0.17 //l=0.51 //layer=mcon //count=3 \
 //x=16.77 //y=7.58 //x2=16.77 //y2=7.58
r634 (  31 33 ) resistor r=0.446141 //w=0.311 //l=1.11 //layer=m1 \
 //thickness=0.36 //x=16.77 //y=7.585 //x2=17.88 //y2=7.585
r635 (  29 210 ) resistor r=3.1 //w=0.17 //l=0.51 //layer=mcon //count=3 \
 //x=15.66 //y=7.58 //x2=15.66 //y2=7.58
r636 (  29 31 ) resistor r=0.446141 //w=0.311 //l=1.11 //layer=m1 \
 //thickness=0.36 //x=15.66 //y=7.585 //x2=16.77 //y2=7.585
r637 (  27 329 ) resistor r=3.1 //w=0.17 //l=0.51 //layer=mcon //count=3 \
 //x=14.55 //y=7.58 //x2=14.55 //y2=7.58
r638 (  27 29 ) resistor r=0.446141 //w=0.311 //l=1.11 //layer=m1 \
 //thickness=0.36 //x=14.55 //y=7.585 //x2=15.66 //y2=7.585
r639 (  24 186 ) resistor r=3.1 //w=0.17 //l=0.51 //layer=mcon //count=3 \
 //x=13.07 //y=7.58 //x2=13.07 //y2=7.58
r640 (  22 176 ) resistor r=3.1 //w=0.17 //l=0.51 //layer=mcon //count=3 \
 //x=11.96 //y=7.58 //x2=11.96 //y2=7.58
r641 (  22 24 ) resistor r=0.446141 //w=0.311 //l=1.11 //layer=m1 \
 //thickness=0.36 //x=11.96 //y=7.585 //x2=13.07 //y2=7.585
r642 (  20 324 ) resistor r=3.1 //w=0.17 //l=0.51 //layer=mcon //count=3 \
 //x=10.85 //y=7.58 //x2=10.85 //y2=7.58
r643 (  20 22 ) resistor r=0.446141 //w=0.311 //l=1.11 //layer=m1 \
 //thickness=0.36 //x=10.85 //y=7.585 //x2=11.96 //y2=7.585
r644 (  18 152 ) resistor r=3.1 //w=0.17 //l=0.51 //layer=mcon //count=3 \
 //x=9.37 //y=7.58 //x2=9.37 //y2=7.58
r645 (  18 20 ) resistor r=0.594855 //w=0.311 //l=1.48 //layer=m1 \
 //thickness=0.36 //x=9.37 //y=7.585 //x2=10.85 //y2=7.585
r646 (  16 142 ) resistor r=3.1 //w=0.17 //l=0.51 //layer=mcon //count=3 \
 //x=8.26 //y=7.58 //x2=8.26 //y2=7.58
r647 (  16 18 ) resistor r=0.446141 //w=0.311 //l=1.11 //layer=m1 \
 //thickness=0.36 //x=8.26 //y=7.585 //x2=9.37 //y2=7.585
r648 (  14 124 ) resistor r=3.1 //w=0.17 //l=0.51 //layer=mcon //count=3 \
 //x=7.15 //y=7.58 //x2=7.15 //y2=7.58
r649 (  14 16 ) resistor r=0.446141 //w=0.311 //l=1.11 //layer=m1 \
 //thickness=0.36 //x=7.15 //y=7.585 //x2=8.26 //y2=7.585
r650 (  12 112 ) resistor r=3.1 //w=0.17 //l=0.51 //layer=mcon //count=3 \
 //x=6.04 //y=7.58 //x2=6.04 //y2=7.58
r651 (  12 14 ) resistor r=0.446141 //w=0.311 //l=1.11 //layer=m1 \
 //thickness=0.36 //x=6.04 //y=7.585 //x2=7.15 //y2=7.585
r652 (  10 106 ) resistor r=3.1 //w=0.17 //l=0.51 //layer=mcon //count=3 \
 //x=4.56 //y=7.58 //x2=4.56 //y2=7.58
r653 (  10 12 ) resistor r=0.594855 //w=0.311 //l=1.48 //layer=m1 \
 //thickness=0.36 //x=4.56 //y=7.585 //x2=6.04 //y2=7.585
r654 (  8 96 ) resistor r=3.1 //w=0.17 //l=0.51 //layer=mcon //count=3 \
 //x=3.45 //y=7.58 //x2=3.45 //y2=7.58
r655 (  8 10 ) resistor r=0.446141 //w=0.311 //l=1.11 //layer=m1 \
 //thickness=0.36 //x=3.45 //y=7.585 //x2=4.56 //y2=7.585
r656 (  6 78 ) resistor r=3.1 //w=0.17 //l=0.51 //layer=mcon //count=3 \
 //x=2.34 //y=7.58 //x2=2.34 //y2=7.58
r657 (  6 8 ) resistor r=0.446141 //w=0.311 //l=1.11 //layer=m1 \
 //thickness=0.36 //x=2.34 //y=7.585 //x2=3.45 //y2=7.585
r658 (  3 66 ) resistor r=3.1 //w=0.17 //l=0.51 //layer=mcon //count=3 \
 //x=1.23 //y=7.58 //x2=1.23 //y2=7.58
r659 (  3 6 ) resistor r=0.446141 //w=0.311 //l=1.11 //layer=m1 \
 //thickness=0.36 //x=1.23 //y=7.585 //x2=2.34 //y2=7.585
r660 (  1 27 ) resistor r=0.446141 //w=0.311 //l=1.11 //layer=m1 \
 //thickness=0.36 //x=13.44 //y=7.585 //x2=14.55 //y2=7.585
r661 (  1 24 ) resistor r=0.148714 //w=0.311 //l=0.37 //layer=m1 \
 //thickness=0.36 //x=13.44 //y=7.585 //x2=13.07 //y2=7.585
ends PM_DFFRNX1\%VDD

subckt PM_DFFRNX1\%noxref_10 ( 5 7 15 19 30 33 34 )
c64 ( 34 0 ) capacitor c=0.0487212f //x=3.455 //y=0.555
c65 ( 33 0 ) capacitor c=0.0198861f //x=2.35 //y=1.09
c66 ( 30 0 ) capacitor c=0.00141302f //x=3.59 //y=1.175
c67 ( 19 0 ) capacitor c=0.00692795f //x=4.56 //y=0.805
c68 ( 15 0 ) capacitor c=0.0154966f //x=4.475 //y=0.72
c69 ( 7 0 ) capacitor c=0.00689459f //x=3.59 //y=0.805
c70 ( 5 0 ) capacitor c=0.0290436f //x=3.505 //y=1.175
r71 (  19 34 ) resistor r=3.57586 //w=0.17 //l=0.125 //layer=li \
 //thickness=0.1 //x=4.56 //y=0.805 //x2=4.56 //y2=0.68
r72 (  19 34 ) resistor r=18.139 //w=0.187 //l=0.265 //layer=li \
 //thickness=0.1 //x=4.56 //y=0.805 //x2=4.56 //y2=1.07
r73 (  16 34 ) resistor r=3.57586 //w=0.17 //l=0.103078 //layer=li \
 //thickness=0.1 //x=3.675 //y=0.72 //x2=3.59 //y2=0.68
r74 (  16 34 ) resistor r=27.3797 //w=0.187 //l=0.4 //layer=li //thickness=0.1 \
 //x=3.675 //y=0.72 //x2=4.075 //y2=0.72
r75 (  15 34 ) resistor r=3.57586 //w=0.17 //l=0.103078 //layer=li \
 //thickness=0.1 //x=4.475 //y=0.72 //x2=4.56 //y2=0.68
r76 (  15 34 ) resistor r=27.3797 //w=0.187 //l=0.4 //layer=li //thickness=0.1 \
 //x=4.475 //y=0.72 //x2=4.075 //y2=0.72
r77 (  11 30 ) resistor r=5.4201 //w=0.17 //l=0.085 //layer=li //thickness=0.1 \
 //x=3.59 //y=1.26 //x2=3.59 //y2=1.175
r78 (  11 34 ) resistor r=10.2674 //w=0.187 //l=0.15 //layer=li \
 //thickness=0.1 //x=3.59 //y=1.26 //x2=3.59 //y2=1.41
r79 (  8 30 ) resistor r=5.4201 //w=0.17 //l=0.085 //layer=li //thickness=0.1 \
 //x=3.59 //y=1.09 //x2=3.59 //y2=1.175
r80 (  8 34 ) resistor r=1.36898 //w=0.187 //l=0.02 //layer=li //thickness=0.1 \
 //x=3.59 //y=1.09 //x2=3.59 //y2=1.07
r81 (  7 34 ) resistor r=3.57586 //w=0.17 //l=0.125 //layer=li //thickness=0.1 \
 //x=3.59 //y=0.805 //x2=3.59 //y2=0.68
r82 (  7 34 ) resistor r=18.139 //w=0.187 //l=0.265 //layer=li //thickness=0.1 \
 //x=3.59 //y=0.805 //x2=3.59 //y2=1.07
r83 (  6 33 ) resistor r=0.751729 //w=0.17 //l=0.085 //layer=li \
 //thickness=0.1 //x=2.625 //y=1.175 //x2=2.54 //y2=1.175
r84 (  5 30 ) resistor r=1.40859 //w=0.34 //l=0.085 //layer=li //thickness=0.1 \
 //x=3.505 //y=1.175 //x2=3.59 //y2=1.175
r85 (  5 6 ) resistor r=60.2353 //w=0.187 //l=0.88 //layer=li //thickness=0.1 \
 //x=3.505 //y=1.175 //x2=2.625 //y2=1.175
ends PM_DFFRNX1\%noxref_10

subckt PM_DFFRNX1\%noxref_11 ( 5 7 15 19 30 33 34 )
c67 ( 34 0 ) capacitor c=0.0454839f //x=8.265 //y=0.555
c68 ( 33 0 ) capacitor c=0.0198007f //x=7.16 //y=1.09
c69 ( 30 0 ) capacitor c=0.00141302f //x=8.4 //y=1.175
c70 ( 19 0 ) capacitor c=0.00695768f //x=9.37 //y=0.805
c71 ( 15 0 ) capacitor c=0.0153419f //x=9.285 //y=0.72
c72 ( 7 0 ) capacitor c=0.00689476f //x=8.4 //y=0.805
c73 ( 5 0 ) capacitor c=0.0290436f //x=8.315 //y=1.175
r74 (  19 34 ) resistor r=3.57586 //w=0.17 //l=0.125 //layer=li \
 //thickness=0.1 //x=9.37 //y=0.805 //x2=9.37 //y2=0.68
r75 (  19 34 ) resistor r=18.139 //w=0.187 //l=0.265 //layer=li \
 //thickness=0.1 //x=9.37 //y=0.805 //x2=9.37 //y2=1.07
r76 (  16 34 ) resistor r=3.57586 //w=0.17 //l=0.103078 //layer=li \
 //thickness=0.1 //x=8.485 //y=0.72 //x2=8.4 //y2=0.68
r77 (  16 34 ) resistor r=27.3797 //w=0.187 //l=0.4 //layer=li //thickness=0.1 \
 //x=8.485 //y=0.72 //x2=8.885 //y2=0.72
r78 (  15 34 ) resistor r=3.57586 //w=0.17 //l=0.103078 //layer=li \
 //thickness=0.1 //x=9.285 //y=0.72 //x2=9.37 //y2=0.68
r79 (  15 34 ) resistor r=27.3797 //w=0.187 //l=0.4 //layer=li //thickness=0.1 \
 //x=9.285 //y=0.72 //x2=8.885 //y2=0.72
r80 (  11 30 ) resistor r=5.4201 //w=0.17 //l=0.085 //layer=li //thickness=0.1 \
 //x=8.4 //y=1.26 //x2=8.4 //y2=1.175
r81 (  11 34 ) resistor r=10.2674 //w=0.187 //l=0.15 //layer=li \
 //thickness=0.1 //x=8.4 //y=1.26 //x2=8.4 //y2=1.41
r82 (  8 30 ) resistor r=5.4201 //w=0.17 //l=0.085 //layer=li //thickness=0.1 \
 //x=8.4 //y=1.09 //x2=8.4 //y2=1.175
r83 (  8 34 ) resistor r=1.36898 //w=0.187 //l=0.02 //layer=li //thickness=0.1 \
 //x=8.4 //y=1.09 //x2=8.4 //y2=1.07
r84 (  7 34 ) resistor r=3.57586 //w=0.17 //l=0.125 //layer=li //thickness=0.1 \
 //x=8.4 //y=0.805 //x2=8.4 //y2=0.68
r85 (  7 34 ) resistor r=18.139 //w=0.187 //l=0.265 //layer=li //thickness=0.1 \
 //x=8.4 //y=0.805 //x2=8.4 //y2=1.07
r86 (  6 33 ) resistor r=0.751729 //w=0.17 //l=0.085 //layer=li \
 //thickness=0.1 //x=7.435 //y=1.175 //x2=7.35 //y2=1.175
r87 (  5 30 ) resistor r=1.40859 //w=0.34 //l=0.085 //layer=li //thickness=0.1 \
 //x=8.315 //y=1.175 //x2=8.4 //y2=1.175
r88 (  5 6 ) resistor r=60.2353 //w=0.187 //l=0.88 //layer=li //thickness=0.1 \
 //x=8.315 //y=1.175 //x2=7.435 //y2=1.175
ends PM_DFFRNX1\%noxref_11

subckt PM_DFFRNX1\%D ( 1 2 3 4 5 14 19 23 24 25 26 27 28 30 36 37 38 39 40 48 )
c124 ( 48 0 ) capacitor c=0.0369044f //x=7.52 //y=4.88
c125 ( 40 0 ) capacitor c=0.0309248f //x=7.855 //y=4.97
c126 ( 39 0 ) capacitor c=0.0863671f //x=7.61 //y=2.095
c127 ( 38 0 ) capacitor c=0.0170266f //x=7.61 //y=1.63
c128 ( 37 0 ) capacitor c=0.018609f //x=7.61 //y=1.4
c129 ( 36 0 ) capacitor c=0.0186599f //x=7.61 //y=1.09
c130 ( 30 0 ) capacitor c=0.0146988f //x=7.455 //y=1.555
c131 ( 28 0 ) capacitor c=0.0148531f //x=7.455 //y=0.935
c132 ( 27 0 ) capacitor c=0.0334406f //x=7.085 //y=1.4
c133 ( 26 0 ) capacitor c=0.0173191f //x=7.085 //y=1.09
c134 ( 25 0 ) capacitor c=0.110208f //x=7.93 //y=6.2
c135 ( 24 0 ) capacitor c=0.110214f //x=7.49 //y=6.2
c136 ( 19 0 ) capacitor c=0.00129935f //x=7.52 //y=4.88
c137 ( 14 0 ) capacitor c=0.00121786f //x=7.52 //y=2.26
c138 ( 5 0 ) capacitor c=0.0050946f //x=7.52 //y=4.765
c139 ( 4 0 ) capacitor c=0.00586341f //x=7.52 //y=2.375
c140 ( 1 0 ) capacitor c=0.0677231f //x=7.52 //y=2.4
r141 (  50 51 ) resistor r=32.4568 //w=0.214 //l=0.075 //layer=ply \
 //thickness=0.18 //x=7.52 //y=4.97 //x2=7.52 //y2=5.045
r142 (  48 50 ) resistor r=20.271 //w=0.214 //l=0.09 //layer=ply \
 //thickness=0.18 //x=7.52 //y=4.88 //x2=7.52 //y2=4.97
r143 (  41 50 ) resistor r=16.5046 //w=0.27 //l=0.135 //layer=ply \
 //thickness=0.18 //x=7.655 //y=4.97 //x2=7.52 //y2=4.97
r144 (  40 42 ) resistor r=26.9307 //w=0.15 //l=0.106066 //layer=ply \
 //thickness=0.18 //x=7.855 //y=4.97 //x2=7.93 //y2=5.045
r145 (  40 41 ) resistor r=102.553 //w=0.094 //l=0.2 //layer=ply \
 //thickness=0.18 //x=7.855 //y=4.97 //x2=7.655 //y2=4.97
r146 (  39 55 ) resistor r=38.6777 //w=0.284 //l=0.198997 //layer=ply \
 //thickness=0.18 //x=7.61 //y=2.095 //x2=7.535 //y2=2.26
r147 (  38 53 ) resistor r=21.2976 //w=0.217 //l=0.0928709 //layer=ply \
 //thickness=0.18 //x=7.61 //y=1.63 //x2=7.57 //y2=1.555
r148 (  38 39 ) resistor r=238.436 //w=0.094 //l=0.465 //layer=ply \
 //thickness=0.18 //x=7.61 //y=1.63 //x2=7.61 //y2=2.095
r149 (  37 53 ) resistor r=39.0671 //w=0.217 //l=0.173853 //layer=ply \
 //thickness=0.18 //x=7.61 //y=1.4 //x2=7.57 //y2=1.555
r150 (  36 52 ) resistor r=45.1352 //w=0.168 //l=0.173853 //layer=ply \
 //thickness=0.18 //x=7.61 //y=1.09 //x2=7.57 //y2=0.935
r151 (  36 37 ) resistor r=158.957 //w=0.094 //l=0.31 //layer=ply \
 //thickness=0.18 //x=7.61 //y=1.09 //x2=7.61 //y2=1.4
r152 (  31 46 ) resistor r=5.52526 //w=0.168 //l=0.115 //layer=ply \
 //thickness=0.18 //x=7.24 //y=1.555 //x2=7.125 //y2=1.555
r153 (  30 53 ) resistor r=11.4558 //w=0.217 //l=0.115 //layer=ply \
 //thickness=0.18 //x=7.455 //y=1.555 //x2=7.57 //y2=1.555
r154 (  29 45 ) resistor r=5.52526 //w=0.168 //l=0.115 //layer=ply \
 //thickness=0.18 //x=7.24 //y=0.935 //x2=7.125 //y2=0.935
r155 (  28 52 ) resistor r=5.52526 //w=0.168 //l=0.115 //layer=ply \
 //thickness=0.18 //x=7.455 //y=0.935 //x2=7.57 //y2=0.935
r156 (  28 29 ) resistor r=110.245 //w=0.094 //l=0.215 //layer=ply \
 //thickness=0.18 //x=7.455 //y=0.935 //x2=7.24 //y2=0.935
r157 (  27 46 ) resistor r=45.1352 //w=0.168 //l=0.173853 //layer=ply \
 //thickness=0.18 //x=7.085 //y=1.4 //x2=7.125 //y2=1.555
r158 (  26 45 ) resistor r=45.1352 //w=0.168 //l=0.173853 //layer=ply \
 //thickness=0.18 //x=7.085 //y=1.09 //x2=7.125 //y2=0.935
r159 (  26 27 ) resistor r=158.957 //w=0.094 //l=0.31 //layer=ply \
 //thickness=0.18 //x=7.085 //y=1.09 //x2=7.085 //y2=1.4
r160 (  25 42 ) resistor r=592.245 //w=0.094 //l=1.155 //layer=ply \
 //thickness=0.18 //x=7.93 //y=6.2 //x2=7.93 //y2=5.045
r161 (  24 51 ) resistor r=592.245 //w=0.094 //l=1.155 //layer=ply \
 //thickness=0.18 //x=7.49 //y=6.2 //x2=7.49 //y2=5.045
r162 (  23 30 ) resistor r=55.3787 //w=0.094 //l=0.108 //layer=ply \
 //thickness=0.18 //x=7.347 //y=1.555 //x2=7.455 //y2=1.555
r163 (  23 31 ) resistor r=54.866 //w=0.094 //l=0.107 //layer=ply \
 //thickness=0.18 //x=7.347 //y=1.555 //x2=7.24 //y2=1.555
r164 (  19 48 ) resistor r=152 //w=0.17 //l=0.17 //layer=licon //count=1 \
 //x=7.52 //y=4.88 //x2=7.52 //y2=4.88
r165 (  14 55 ) resistor r=152 //w=0.17 //l=0.17 //layer=licon //count=1 \
 //x=7.52 //y=2.26 //x2=7.52 //y2=2.26
r166 (  12 19 ) resistor r=9.3 //w=0.17 //l=0.17 //layer=mcon //count=1 \
 //x=7.52 //y=4.88 //x2=7.52 //y2=4.88
r167 (  10 14 ) resistor r=9.3 //w=0.17 //l=0.17 //layer=mcon //count=1 \
 //x=7.52 //y=2.26 //x2=7.52 //y2=2.26
r168 (  5 12 ) resistor r=0.0717383 //w=0.224 //l=0.115 //layer=m1 \
 //thickness=0.36 //x=7.52 //y=4.765 //x2=7.52 //y2=4.88
r169 (  4 10 ) resistor r=0.0715665 //w=0.226 //l=0.115996 //layer=m1 \
 //thickness=0.36 //x=7.52 //y=2.375 //x2=7.522 //y2=2.26
r170 (  3 5 ) resistor r=1.55057 //w=0.131 //l=1.625 //layer=m1 \
 //thickness=0.36 //x=7.52 //y=3.14 //x2=7.52 //y2=4.765
r171 (  2 3 ) resistor r=0.353053 //w=0.131 //l=0.37 //layer=m1 \
 //thickness=0.36 //x=7.52 //y=2.77 //x2=7.52 //y2=3.14
r172 (  1 2 ) resistor r=0.353053 //w=0.131 //l=0.37 //layer=m1 \
 //thickness=0.36 //x=7.52 //y=2.4 //x2=7.52 //y2=2.77
r173 (  1 4 ) resistor r=0.023855 //w=0.131 //l=0.025 //layer=m1 \
 //thickness=0.36 //x=7.52 //y=2.4 //x2=7.52 //y2=2.375
ends PM_DFFRNX1\%D

subckt PM_DFFRNX1\%noxref_13 ( 5 7 15 19 30 33 34 )
c69 ( 34 0 ) capacitor c=0.0455032f //x=16.405 //y=0.555
c70 ( 33 0 ) capacitor c=0.019478f //x=15.3 //y=1.09
c71 ( 30 0 ) capacitor c=0.00141302f //x=16.54 //y=1.175
c72 ( 19 0 ) capacitor c=0.00692795f //x=17.51 //y=0.805
c73 ( 15 0 ) capacitor c=0.0153419f //x=17.425 //y=0.72
c74 ( 7 0 ) capacitor c=0.00689459f //x=16.54 //y=0.805
c75 ( 5 0 ) capacitor c=0.0237752f //x=16.455 //y=1.175
r76 (  19 34 ) resistor r=3.57586 //w=0.17 //l=0.125 //layer=li \
 //thickness=0.1 //x=17.51 //y=0.805 //x2=17.51 //y2=0.68
r77 (  19 34 ) resistor r=18.139 //w=0.187 //l=0.265 //layer=li \
 //thickness=0.1 //x=17.51 //y=0.805 //x2=17.51 //y2=1.07
r78 (  16 34 ) resistor r=3.57586 //w=0.17 //l=0.103078 //layer=li \
 //thickness=0.1 //x=16.625 //y=0.72 //x2=16.54 //y2=0.68
r79 (  16 34 ) resistor r=27.3797 //w=0.187 //l=0.4 //layer=li //thickness=0.1 \
 //x=16.625 //y=0.72 //x2=17.025 //y2=0.72
r80 (  15 34 ) resistor r=3.57586 //w=0.17 //l=0.103078 //layer=li \
 //thickness=0.1 //x=17.425 //y=0.72 //x2=17.51 //y2=0.68
r81 (  15 34 ) resistor r=27.3797 //w=0.187 //l=0.4 //layer=li //thickness=0.1 \
 //x=17.425 //y=0.72 //x2=17.025 //y2=0.72
r82 (  11 30 ) resistor r=5.4201 //w=0.17 //l=0.085 //layer=li //thickness=0.1 \
 //x=16.54 //y=1.26 //x2=16.54 //y2=1.175
r83 (  11 34 ) resistor r=10.2674 //w=0.187 //l=0.15 //layer=li \
 //thickness=0.1 //x=16.54 //y=1.26 //x2=16.54 //y2=1.41
r84 (  8 30 ) resistor r=5.4201 //w=0.17 //l=0.085 //layer=li //thickness=0.1 \
 //x=16.54 //y=1.09 //x2=16.54 //y2=1.175
r85 (  8 34 ) resistor r=1.36898 //w=0.187 //l=0.02 //layer=li //thickness=0.1 \
 //x=16.54 //y=1.09 //x2=16.54 //y2=1.07
r86 (  7 34 ) resistor r=3.57586 //w=0.17 //l=0.125 //layer=li //thickness=0.1 \
 //x=16.54 //y=0.805 //x2=16.54 //y2=0.68
r87 (  7 34 ) resistor r=18.139 //w=0.187 //l=0.265 //layer=li //thickness=0.1 \
 //x=16.54 //y=0.805 //x2=16.54 //y2=1.07
r88 (  6 33 ) resistor r=0.751729 //w=0.17 //l=0.085 //layer=li \
 //thickness=0.1 //x=15.575 //y=1.175 //x2=15.49 //y2=1.175
r89 (  5 30 ) resistor r=1.40859 //w=0.34 //l=0.085 //layer=li //thickness=0.1 \
 //x=16.455 //y=1.175 //x2=16.54 //y2=1.175
r90 (  5 6 ) resistor r=60.2353 //w=0.187 //l=0.88 //layer=li //thickness=0.1 \
 //x=16.455 //y=1.175 //x2=15.575 //y2=1.175
ends PM_DFFRNX1\%noxref_13

subckt PM_DFFRNX1\%noxref_14 ( 5 7 15 19 30 33 34 )
c67 ( 34 0 ) capacitor c=0.0482957f //x=21.215 //y=0.555
c68 ( 33 0 ) capacitor c=0.0186047f //x=20.11 //y=1.09
c69 ( 30 0 ) capacitor c=0.00141302f //x=21.35 //y=1.175
c70 ( 19 0 ) capacitor c=0.00695768f //x=22.32 //y=0.805
c71 ( 15 0 ) capacitor c=0.0154874f //x=22.235 //y=0.72
c72 ( 7 0 ) capacitor c=0.00689476f //x=21.35 //y=0.805
c73 ( 5 0 ) capacitor c=0.0290436f //x=21.265 //y=1.175
r74 (  19 34 ) resistor r=3.57586 //w=0.17 //l=0.125 //layer=li \
 //thickness=0.1 //x=22.32 //y=0.805 //x2=22.32 //y2=0.68
r75 (  19 34 ) resistor r=18.139 //w=0.187 //l=0.265 //layer=li \
 //thickness=0.1 //x=22.32 //y=0.805 //x2=22.32 //y2=1.07
r76 (  16 34 ) resistor r=3.57586 //w=0.17 //l=0.103078 //layer=li \
 //thickness=0.1 //x=21.435 //y=0.72 //x2=21.35 //y2=0.68
r77 (  16 34 ) resistor r=27.3797 //w=0.187 //l=0.4 //layer=li //thickness=0.1 \
 //x=21.435 //y=0.72 //x2=21.835 //y2=0.72
r78 (  15 34 ) resistor r=3.57586 //w=0.17 //l=0.103078 //layer=li \
 //thickness=0.1 //x=22.235 //y=0.72 //x2=22.32 //y2=0.68
r79 (  15 34 ) resistor r=27.3797 //w=0.187 //l=0.4 //layer=li //thickness=0.1 \
 //x=22.235 //y=0.72 //x2=21.835 //y2=0.72
r80 (  11 30 ) resistor r=5.4201 //w=0.17 //l=0.085 //layer=li //thickness=0.1 \
 //x=21.35 //y=1.26 //x2=21.35 //y2=1.175
r81 (  11 34 ) resistor r=10.2674 //w=0.187 //l=0.15 //layer=li \
 //thickness=0.1 //x=21.35 //y=1.26 //x2=21.35 //y2=1.41
r82 (  8 30 ) resistor r=5.4201 //w=0.17 //l=0.085 //layer=li //thickness=0.1 \
 //x=21.35 //y=1.09 //x2=21.35 //y2=1.175
r83 (  8 34 ) resistor r=1.36898 //w=0.187 //l=0.02 //layer=li //thickness=0.1 \
 //x=21.35 //y=1.09 //x2=21.35 //y2=1.07
r84 (  7 34 ) resistor r=3.57586 //w=0.17 //l=0.125 //layer=li //thickness=0.1 \
 //x=21.35 //y=0.805 //x2=21.35 //y2=0.68
r85 (  7 34 ) resistor r=18.139 //w=0.187 //l=0.265 //layer=li //thickness=0.1 \
 //x=21.35 //y=0.805 //x2=21.35 //y2=1.07
r86 (  6 33 ) resistor r=0.751729 //w=0.17 //l=0.085 //layer=li \
 //thickness=0.1 //x=20.385 //y=1.175 //x2=20.3 //y2=1.175
r87 (  5 30 ) resistor r=1.40859 //w=0.34 //l=0.085 //layer=li //thickness=0.1 \
 //x=21.265 //y=1.175 //x2=21.35 //y2=1.175
r88 (  5 6 ) resistor r=60.2353 //w=0.187 //l=0.88 //layer=li //thickness=0.1 \
 //x=21.265 //y=1.175 //x2=20.385 //y2=1.175
ends PM_DFFRNX1\%noxref_14

subckt PM_DFFRNX1\%GND ( 1 2 6 7 18 19 31 39 40 49 50 64 67 71 75 76 80 85 90 \
 91 97 100 114 131 146 163 187 195 196 197 198 199 200 201 202 203 204 205 )
c460 ( 205 0 ) capacitor c=0.00843555f //x=24.05 //y=1.045
c461 ( 204 0 ) capacitor c=0.00840423f //x=19.135 //y=1.055
c462 ( 203 0 ) capacitor c=0.00840423f //x=14.325 //y=1.055
c463 ( 202 0 ) capacitor c=0.00843555f //x=11.1 //y=1.045
c464 ( 201 0 ) capacitor c=0.00840423f //x=6.185 //y=1.055
c465 ( 200 0 ) capacitor c=0.00840423f //x=1.375 //y=1.055
c466 ( 199 0 ) capacitor c=0.118839f //x=23.06 //y=0.175
c467 ( 198 0 ) capacitor c=0.11457f //x=18.25 //y=0.175
c468 ( 197 0 ) capacitor c=0.11301f //x=13.44 //y=0.175
c469 ( 196 0 ) capacitor c=0.119155f //x=10.11 //y=0.175
c470 ( 195 0 ) capacitor c=0.113716f //x=5.3 //y=0.175
c471 ( 187 0 ) capacitor c=0.336211f //x=26.02 //y=0.18
c472 ( 163 0 ) capacitor c=0.176839f //x=22.89 //y=0.175
c473 ( 146 0 ) capacitor c=0.176416f //x=18.08 //y=0.175
c474 ( 131 0 ) capacitor c=0.118875f //x=13.27 //y=0.175
c475 ( 114 0 ) capacitor c=0.177393f //x=9.94 //y=0.175
c476 ( 100 0 ) capacitor c=0.197064f //x=1.23 //y=0.18
c477 ( 97 0 ) capacitor c=0.181456f //x=5.13 //y=0.175
c478 ( 94 0 ) capacitor c=0.00509083f //x=24.17 //y=0.18
c479 ( 91 0 ) capacitor c=0.0278993f //x=24.237 //y=1.005
c480 ( 90 0 ) capacitor c=0.0138387f //x=24.24 //y=1.135
c481 ( 88 0 ) capacitor c=0.00509414f //x=19.36 //y=0.18
c482 ( 85 0 ) capacitor c=0.0140966f //x=19.325 //y=1.145
c483 ( 83 0 ) capacitor c=0.00509414f //x=14.55 //y=0.18
c484 ( 80 0 ) capacitor c=0.013104f //x=14.515 //y=1.145
c485 ( 78 0 ) capacitor c=0.00509083f //x=11.29 //y=0.175
c486 ( 76 0 ) capacitor c=0.0234055f //x=11.287 //y=1.005
c487 ( 75 0 ) capacitor c=0.01353f //x=11.29 //y=1.135
c488 ( 73 0 ) capacitor c=0.00509414f //x=6.375 //y=0.175
c489 ( 71 0 ) capacitor c=0.0143507f //x=6.375 //y=1.145
c490 ( 69 0 ) capacitor c=0.00509414f //x=1.565 //y=0.175
c491 ( 67 0 ) capacitor c=0.0170404f //x=1.565 //y=1.145
c492 ( 64 0 ) capacitor c=0.102367f //x=26.02 //y=0.18
c493 ( 50 0 ) capacitor c=0.154588f //x=24.155 //y=0.175
c494 ( 49 0 ) capacitor c=0.0302305f //x=19.325 //y=1.015
c495 ( 40 0 ) capacitor c=0.150267f //x=19.24 //y=0.175
c496 ( 39 0 ) capacitor c=0.0253397f //x=14.515 //y=1.015
c497 ( 31 0 ) capacitor c=0.105424f //x=14.43 //y=0.175
c498 ( 19 0 ) capacitor c=0.154392f //x=11.205 //y=0.175
c499 ( 18 0 ) capacitor c=0.0302305f //x=6.375 //y=1.015
c500 ( 7 0 ) capacitor c=0.149367f //x=6.29 //y=0.175
c501 ( 6 0 ) capacitor c=0.0302305f //x=1.565 //y=1.015
c502 ( 2 0 ) capacitor c=0.0710427f //x=1.48 //y=0.175
r503 (  185 187 ) resistor r=25.8093 //w=0.367 //l=0.74 //layer=li \
 //thickness=0.1 //x=25.28 //y=0.175 //x2=26.02 //y2=0.175
r504 (  183 185 ) resistor r=38.7139 //w=0.367 //l=1.11 //layer=li \
 //thickness=0.1 //x=24.17 //y=0.175 //x2=25.28 //y2=0.175
r505 (  181 199 ) resistor r=5.29055 //w=0.35 //l=0.17 //layer=li \
 //thickness=0.1 //x=23.23 //y=0.175 //x2=23.06 //y2=0.175
r506 (  181 183 ) resistor r=32.7847 //w=0.367 //l=0.94 //layer=li \
 //thickness=0.1 //x=23.23 //y=0.175 //x2=24.17 //y2=0.175
r507 (  170 172 ) resistor r=38.7139 //w=0.367 //l=1.11 //layer=li \
 //thickness=0.1 //x=21.58 //y=0.175 //x2=22.69 //y2=0.175
r508 (  168 170 ) resistor r=38.7139 //w=0.367 //l=1.11 //layer=li \
 //thickness=0.1 //x=20.47 //y=0.175 //x2=21.58 //y2=0.175
r509 (  166 168 ) resistor r=38.7139 //w=0.367 //l=1.11 //layer=li \
 //thickness=0.1 //x=19.36 //y=0.175 //x2=20.47 //y2=0.175
r510 (  164 198 ) resistor r=5.29055 //w=0.35 //l=0.17 //layer=li \
 //thickness=0.1 //x=18.42 //y=0.175 //x2=18.25 //y2=0.175
r511 (  164 166 ) resistor r=32.7847 //w=0.367 //l=0.94 //layer=li \
 //thickness=0.1 //x=18.42 //y=0.175 //x2=19.36 //y2=0.175
r512 (  163 199 ) resistor r=5.29055 //w=0.35 //l=0.17 //layer=li \
 //thickness=0.1 //x=22.89 //y=0.175 //x2=23.06 //y2=0.175
r513 (  163 172 ) resistor r=6.97548 //w=0.367 //l=0.2 //layer=li \
 //thickness=0.1 //x=22.89 //y=0.175 //x2=22.69 //y2=0.175
r514 (  153 155 ) resistor r=38.7139 //w=0.367 //l=1.11 //layer=li \
 //thickness=0.1 //x=16.77 //y=0.175 //x2=17.88 //y2=0.175
r515 (  151 153 ) resistor r=38.7139 //w=0.367 //l=1.11 //layer=li \
 //thickness=0.1 //x=15.66 //y=0.175 //x2=16.77 //y2=0.175
r516 (  149 151 ) resistor r=38.7139 //w=0.367 //l=1.11 //layer=li \
 //thickness=0.1 //x=14.55 //y=0.175 //x2=15.66 //y2=0.175
r517 (  147 197 ) resistor r=5.29055 //w=0.35 //l=0.17 //layer=li \
 //thickness=0.1 //x=13.61 //y=0.175 //x2=13.44 //y2=0.175
r518 (  147 149 ) resistor r=32.7847 //w=0.367 //l=0.94 //layer=li \
 //thickness=0.1 //x=13.61 //y=0.175 //x2=14.55 //y2=0.175
r519 (  146 198 ) resistor r=5.29055 //w=0.35 //l=0.17 //layer=li \
 //thickness=0.1 //x=18.08 //y=0.175 //x2=18.25 //y2=0.175
r520 (  146 155 ) resistor r=6.97548 //w=0.367 //l=0.2 //layer=li \
 //thickness=0.1 //x=18.08 //y=0.175 //x2=17.88 //y2=0.175
r521 (  136 138 ) resistor r=38.7139 //w=0.367 //l=1.11 //layer=li \
 //thickness=0.1 //x=11.96 //y=0.175 //x2=13.07 //y2=0.175
r522 (  134 136 ) resistor r=38.7139 //w=0.367 //l=1.11 //layer=li \
 //thickness=0.1 //x=10.85 //y=0.175 //x2=11.96 //y2=0.175
r523 (  132 196 ) resistor r=5.29055 //w=0.35 //l=0.17 //layer=li \
 //thickness=0.1 //x=10.28 //y=0.175 //x2=10.11 //y2=0.175
r524 (  132 134 ) resistor r=19.8801 //w=0.367 //l=0.57 //layer=li \
 //thickness=0.1 //x=10.28 //y=0.175 //x2=10.85 //y2=0.175
r525 (  131 197 ) resistor r=5.29055 //w=0.35 //l=0.17 //layer=li \
 //thickness=0.1 //x=13.27 //y=0.175 //x2=13.44 //y2=0.175
r526 (  131 138 ) resistor r=6.97548 //w=0.367 //l=0.2 //layer=li \
 //thickness=0.1 //x=13.27 //y=0.175 //x2=13.07 //y2=0.175
r527 (  121 123 ) resistor r=38.7139 //w=0.367 //l=1.11 //layer=li \
 //thickness=0.1 //x=8.26 //y=0.175 //x2=9.37 //y2=0.175
r528 (  119 121 ) resistor r=38.7139 //w=0.367 //l=1.11 //layer=li \
 //thickness=0.1 //x=7.15 //y=0.175 //x2=8.26 //y2=0.175
r529 (  117 119 ) resistor r=38.7139 //w=0.367 //l=1.11 //layer=li \
 //thickness=0.1 //x=6.04 //y=0.175 //x2=7.15 //y2=0.175
r530 (  115 195 ) resistor r=5.29055 //w=0.35 //l=0.17 //layer=li \
 //thickness=0.1 //x=5.47 //y=0.175 //x2=5.3 //y2=0.175
r531 (  115 117 ) resistor r=19.8801 //w=0.367 //l=0.57 //layer=li \
 //thickness=0.1 //x=5.47 //y=0.175 //x2=6.04 //y2=0.175
r532 (  114 196 ) resistor r=5.29055 //w=0.35 //l=0.17 //layer=li \
 //thickness=0.1 //x=9.94 //y=0.175 //x2=10.11 //y2=0.175
r533 (  114 123 ) resistor r=19.8801 //w=0.367 //l=0.57 //layer=li \
 //thickness=0.1 //x=9.94 //y=0.175 //x2=9.37 //y2=0.175
r534 (  104 106 ) resistor r=38.7139 //w=0.367 //l=1.11 //layer=li \
 //thickness=0.1 //x=3.45 //y=0.175 //x2=4.56 //y2=0.175
r535 (  102 104 ) resistor r=38.7139 //w=0.367 //l=1.11 //layer=li \
 //thickness=0.1 //x=2.34 //y=0.175 //x2=3.45 //y2=0.175
r536 (  100 102 ) resistor r=38.7139 //w=0.367 //l=1.11 //layer=li \
 //thickness=0.1 //x=1.23 //y=0.175 //x2=2.34 //y2=0.175
r537 (  97 195 ) resistor r=5.29055 //w=0.35 //l=0.17 //layer=li \
 //thickness=0.1 //x=5.13 //y=0.175 //x2=5.3 //y2=0.175
r538 (  97 106 ) resistor r=19.8801 //w=0.367 //l=0.57 //layer=li \
 //thickness=0.1 //x=5.13 //y=0.175 //x2=4.56 //y2=0.175
r539 (  94 183 ) resistor r=3.1 //w=0.17 //l=0.51 //layer=mcon //count=3 \
 //x=24.17 //y=0.18 //x2=24.17 //y2=0.18
r540 (  90 205 ) resistor r=9.3 //w=0.17 //l=0.17 //layer=mcon //count=1 \
 //x=24.24 //y=1.135 //x2=24.24 //y2=1.135
r541 (  90 91 ) resistor r=0.0939994 //w=0.226 //l=0.13 //layer=m1 \
 //thickness=0.36 //x=24.237 //y=1.135 //x2=24.237 //y2=1.005
r542 (  88 166 ) resistor r=3.1 //w=0.17 //l=0.51 //layer=mcon //count=3 \
 //x=19.36 //y=0.18 //x2=19.36 //y2=0.18
r543 (  85 204 ) resistor r=9.3 //w=0.17 //l=0.17 //layer=mcon //count=1 \
 //x=19.325 //y=1.145 //x2=19.325 //y2=1.145
r544 (  83 149 ) resistor r=3.1 //w=0.17 //l=0.51 //layer=mcon //count=3 \
 //x=14.55 //y=0.18 //x2=14.55 //y2=0.18
r545 (  80 203 ) resistor r=9.3 //w=0.17 //l=0.17 //layer=mcon //count=1 \
 //x=14.515 //y=1.145 //x2=14.515 //y2=1.145
r546 (  75 202 ) resistor r=9.3 //w=0.17 //l=0.17 //layer=mcon //count=1 \
 //x=11.29 //y=1.135 //x2=11.29 //y2=1.135
r547 (  75 76 ) resistor r=0.0939994 //w=0.226 //l=0.13 //layer=m1 \
 //thickness=0.36 //x=11.287 //y=1.135 //x2=11.287 //y2=1.005
r548 (  71 201 ) resistor r=9.3 //w=0.17 //l=0.17 //layer=mcon //count=1 \
 //x=6.375 //y=1.145 //x2=6.375 //y2=1.145
r549 (  67 200 ) resistor r=9.3 //w=0.17 //l=0.17 //layer=mcon //count=1 \
 //x=1.565 //y=1.145 //x2=1.565 //y2=1.145
r550 (  64 187 ) resistor r=9.3 //w=0.17 //l=0.17 //layer=mcon //count=1 \
 //x=26.02 //y=0.18 //x2=26.02 //y2=0.18
r551 (  62 185 ) resistor r=3.1 //w=0.17 //l=0.51 //layer=mcon //count=3 \
 //x=25.28 //y=0.18 //x2=25.28 //y2=0.18
r552 (  62 64 ) resistor r=0.297428 //w=0.311 //l=0.74 //layer=m1 \
 //thickness=0.36 //x=25.28 //y=0.175 //x2=26.02 //y2=0.175
r553 (  60 94 ) resistor r=0.028033 //w=0.35 //l=0.085 //layer=m1 \
 //thickness=0.36 //x=24.325 //y=0.175 //x2=24.24 //y2=0.175
r554 (  60 62 ) resistor r=0.383842 //w=0.311 //l=0.955 //layer=m1 \
 //thickness=0.36 //x=24.325 //y=0.175 //x2=25.28 //y2=0.175
r555 (  58 94 ) resistor r=0.0413265 //w=0.7 //l=0.175 //layer=m1 \
 //thickness=0.36 //x=24.24 //y=0.35 //x2=24.24 //y2=0.175
r556 (  58 91 ) resistor r=0.625 //w=0.131 //l=0.655 //layer=m1 \
 //thickness=0.36 //x=24.24 //y=0.35 //x2=24.24 //y2=1.005
r557 (  57 172 ) resistor r=3.1 //w=0.17 //l=0.51 //layer=mcon //count=3 \
 //x=22.69 //y=0.18 //x2=22.69 //y2=0.18
r558 (  55 170 ) resistor r=3.1 //w=0.17 //l=0.51 //layer=mcon //count=3 \
 //x=21.58 //y=0.18 //x2=21.58 //y2=0.18
r559 (  55 57 ) resistor r=0.446141 //w=0.311 //l=1.11 //layer=m1 \
 //thickness=0.36 //x=21.58 //y=0.175 //x2=22.69 //y2=0.175
r560 (  53 168 ) resistor r=3.1 //w=0.17 //l=0.51 //layer=mcon //count=3 \
 //x=20.47 //y=0.18 //x2=20.47 //y2=0.18
r561 (  53 55 ) resistor r=0.446141 //w=0.311 //l=1.11 //layer=m1 \
 //thickness=0.36 //x=20.47 //y=0.175 //x2=21.58 //y2=0.175
r562 (  51 88 ) resistor r=0.028033 //w=0.35 //l=0.085 //layer=m1 \
 //thickness=0.36 //x=19.41 //y=0.175 //x2=19.325 //y2=0.175
r563 (  51 53 ) resistor r=0.426045 //w=0.311 //l=1.06 //layer=m1 \
 //thickness=0.36 //x=19.41 //y=0.175 //x2=20.47 //y2=0.175
r564 (  50 94 ) resistor r=0.028033 //w=0.35 //l=0.085 //layer=m1 \
 //thickness=0.36 //x=24.155 //y=0.175 //x2=24.24 //y2=0.175
r565 (  50 57 ) resistor r=0.588826 //w=0.311 //l=1.465 //layer=m1 \
 //thickness=0.36 //x=24.155 //y=0.175 //x2=22.69 //y2=0.175
r566 (  49 85 ) resistor r=0.0942778 //w=0.221 //l=0.13 //layer=m1 \
 //thickness=0.36 //x=19.325 //y=1.015 //x2=19.325 //y2=1.145
r567 (  48 88 ) resistor r=0.0413265 //w=0.7 //l=0.175 //layer=m1 \
 //thickness=0.36 //x=19.325 //y=0.35 //x2=19.325 //y2=0.175
r568 (  48 49 ) resistor r=0.634542 //w=0.131 //l=0.665 //layer=m1 \
 //thickness=0.36 //x=19.325 //y=0.35 //x2=19.325 //y2=1.015
r569 (  47 155 ) resistor r=3.1 //w=0.17 //l=0.51 //layer=mcon //count=3 \
 //x=17.88 //y=0.18 //x2=17.88 //y2=0.18
r570 (  45 153 ) resistor r=3.1 //w=0.17 //l=0.51 //layer=mcon //count=3 \
 //x=16.77 //y=0.18 //x2=16.77 //y2=0.18
r571 (  45 47 ) resistor r=0.446141 //w=0.311 //l=1.11 //layer=m1 \
 //thickness=0.36 //x=16.77 //y=0.175 //x2=17.88 //y2=0.175
r572 (  43 151 ) resistor r=3.1 //w=0.17 //l=0.51 //layer=mcon //count=3 \
 //x=15.66 //y=0.18 //x2=15.66 //y2=0.18
r573 (  43 45 ) resistor r=0.446141 //w=0.311 //l=1.11 //layer=m1 \
 //thickness=0.36 //x=15.66 //y=0.175 //x2=16.77 //y2=0.175
r574 (  41 83 ) resistor r=0.028033 //w=0.35 //l=0.085 //layer=m1 \
 //thickness=0.36 //x=14.6 //y=0.175 //x2=14.515 //y2=0.175
r575 (  41 43 ) resistor r=0.426045 //w=0.311 //l=1.06 //layer=m1 \
 //thickness=0.36 //x=14.6 //y=0.175 //x2=15.66 //y2=0.175
r576 (  40 88 ) resistor r=0.028033 //w=0.35 //l=0.085 //layer=m1 \
 //thickness=0.36 //x=19.24 //y=0.175 //x2=19.325 //y2=0.175
r577 (  40 47 ) resistor r=0.546624 //w=0.311 //l=1.36 //layer=m1 \
 //thickness=0.36 //x=19.24 //y=0.175 //x2=17.88 //y2=0.175
r578 (  39 80 ) resistor r=0.0942778 //w=0.221 //l=0.13 //layer=m1 \
 //thickness=0.36 //x=14.515 //y=1.015 //x2=14.515 //y2=1.145
r579 (  38 83 ) resistor r=0.0413265 //w=0.7 //l=0.175 //layer=m1 \
 //thickness=0.36 //x=14.515 //y=0.35 //x2=14.515 //y2=0.175
r580 (  38 39 ) resistor r=0.634542 //w=0.131 //l=0.665 //layer=m1 \
 //thickness=0.36 //x=14.515 //y=0.35 //x2=14.515 //y2=1.015
r581 (  36 138 ) resistor r=3.1 //w=0.17 //l=0.51 //layer=mcon //count=3 \
 //x=13.07 //y=0.18 //x2=13.07 //y2=0.18
r582 (  34 136 ) resistor r=3.1 //w=0.17 //l=0.51 //layer=mcon //count=3 \
 //x=11.96 //y=0.18 //x2=11.96 //y2=0.18
r583 (  34 36 ) resistor r=0.446141 //w=0.311 //l=1.11 //layer=m1 \
 //thickness=0.36 //x=11.96 //y=0.175 //x2=13.07 //y2=0.175
r584 (  32 78 ) resistor r=0.028033 //w=0.35 //l=0.085 //layer=m1 \
 //thickness=0.36 //x=11.375 //y=0.175 //x2=11.29 //y2=0.175
r585 (  32 34 ) resistor r=0.235129 //w=0.311 //l=0.585 //layer=m1 \
 //thickness=0.36 //x=11.375 //y=0.175 //x2=11.96 //y2=0.175
r586 (  31 83 ) resistor r=0.028033 //w=0.35 //l=0.085 //layer=m1 \
 //thickness=0.36 //x=14.43 //y=0.175 //x2=14.515 //y2=0.175
r587 (  29 78 ) resistor r=0.0413265 //w=0.7 //l=0.175 //layer=m1 \
 //thickness=0.36 //x=11.29 //y=0.35 //x2=11.29 //y2=0.175
r588 (  29 76 ) resistor r=0.625 //w=0.131 //l=0.655 //layer=m1 \
 //thickness=0.36 //x=11.29 //y=0.35 //x2=11.29 //y2=1.005
r589 (  28 134 ) resistor r=3.1 //w=0.17 //l=0.51 //layer=mcon //count=3 \
 //x=10.85 //y=0.18 //x2=10.85 //y2=0.18
r590 (  26 123 ) resistor r=3.1 //w=0.17 //l=0.51 //layer=mcon //count=3 \
 //x=9.37 //y=0.18 //x2=9.37 //y2=0.18
r591 (  26 28 ) resistor r=0.594855 //w=0.311 //l=1.48 //layer=m1 \
 //thickness=0.36 //x=9.37 //y=0.175 //x2=10.85 //y2=0.175
r592 (  24 121 ) resistor r=3.1 //w=0.17 //l=0.51 //layer=mcon //count=3 \
 //x=8.26 //y=0.18 //x2=8.26 //y2=0.18
r593 (  24 26 ) resistor r=0.446141 //w=0.311 //l=1.11 //layer=m1 \
 //thickness=0.36 //x=8.26 //y=0.175 //x2=9.37 //y2=0.175
r594 (  22 119 ) resistor r=3.1 //w=0.17 //l=0.51 //layer=mcon //count=3 \
 //x=7.15 //y=0.18 //x2=7.15 //y2=0.18
r595 (  22 24 ) resistor r=0.446141 //w=0.311 //l=1.11 //layer=m1 \
 //thickness=0.36 //x=7.15 //y=0.175 //x2=8.26 //y2=0.175
r596 (  20 73 ) resistor r=0.028033 //w=0.35 //l=0.085 //layer=m1 \
 //thickness=0.36 //x=6.46 //y=0.175 //x2=6.375 //y2=0.175
r597 (  20 22 ) resistor r=0.277331 //w=0.311 //l=0.69 //layer=m1 \
 //thickness=0.36 //x=6.46 //y=0.175 //x2=7.15 //y2=0.175
r598 (  19 78 ) resistor r=0.028033 //w=0.35 //l=0.085 //layer=m1 \
 //thickness=0.36 //x=11.205 //y=0.175 //x2=11.29 //y2=0.175
r599 (  19 28 ) resistor r=0.142685 //w=0.311 //l=0.355 //layer=m1 \
 //thickness=0.36 //x=11.205 //y=0.175 //x2=10.85 //y2=0.175
r600 (  18 71 ) resistor r=0.0942778 //w=0.221 //l=0.13 //layer=m1 \
 //thickness=0.36 //x=6.375 //y=1.015 //x2=6.375 //y2=1.145
r601 (  17 73 ) resistor r=0.0413265 //w=0.7 //l=0.175 //layer=m1 \
 //thickness=0.36 //x=6.375 //y=0.35 //x2=6.375 //y2=0.175
r602 (  17 18 ) resistor r=0.634542 //w=0.131 //l=0.665 //layer=m1 \
 //thickness=0.36 //x=6.375 //y=0.35 //x2=6.375 //y2=1.015
r603 (  16 117 ) resistor r=3.1 //w=0.17 //l=0.51 //layer=mcon //count=3 \
 //x=6.04 //y=0.18 //x2=6.04 //y2=0.18
r604 (  14 106 ) resistor r=3.1 //w=0.17 //l=0.51 //layer=mcon //count=3 \
 //x=4.56 //y=0.18 //x2=4.56 //y2=0.18
r605 (  14 16 ) resistor r=0.594855 //w=0.311 //l=1.48 //layer=m1 \
 //thickness=0.36 //x=4.56 //y=0.175 //x2=6.04 //y2=0.175
r606 (  12 104 ) resistor r=3.1 //w=0.17 //l=0.51 //layer=mcon //count=3 \
 //x=3.45 //y=0.18 //x2=3.45 //y2=0.18
r607 (  12 14 ) resistor r=0.446141 //w=0.311 //l=1.11 //layer=m1 \
 //thickness=0.36 //x=3.45 //y=0.175 //x2=4.56 //y2=0.175
r608 (  10 102 ) resistor r=3.1 //w=0.17 //l=0.51 //layer=mcon //count=3 \
 //x=2.34 //y=0.18 //x2=2.34 //y2=0.18
r609 (  10 12 ) resistor r=0.446141 //w=0.311 //l=1.11 //layer=m1 \
 //thickness=0.36 //x=2.34 //y=0.175 //x2=3.45 //y2=0.175
r610 (  8 69 ) resistor r=0.028033 //w=0.35 //l=0.085 //layer=m1 \
 //thickness=0.36 //x=1.65 //y=0.175 //x2=1.565 //y2=0.175
r611 (  8 10 ) resistor r=0.277331 //w=0.311 //l=0.69 //layer=m1 \
 //thickness=0.36 //x=1.65 //y=0.175 //x2=2.34 //y2=0.175
r612 (  7 73 ) resistor r=0.028033 //w=0.35 //l=0.085 //layer=m1 \
 //thickness=0.36 //x=6.29 //y=0.175 //x2=6.375 //y2=0.175
r613 (  7 16 ) resistor r=0.100482 //w=0.311 //l=0.25 //layer=m1 \
 //thickness=0.36 //x=6.29 //y=0.175 //x2=6.04 //y2=0.175
r614 (  6 67 ) resistor r=0.0942778 //w=0.221 //l=0.13 //layer=m1 \
 //thickness=0.36 //x=1.565 //y=1.015 //x2=1.565 //y2=1.145
r615 (  5 69 ) resistor r=0.0413265 //w=0.7 //l=0.175 //layer=m1 \
 //thickness=0.36 //x=1.565 //y=0.35 //x2=1.565 //y2=0.175
r616 (  5 6 ) resistor r=0.634542 //w=0.131 //l=0.665 //layer=m1 \
 //thickness=0.36 //x=1.565 //y=0.35 //x2=1.565 //y2=1.015
r617 (  4 100 ) resistor r=3.1 //w=0.17 //l=0.51 //layer=mcon //count=3 \
 //x=1.23 //y=0.18 //x2=1.23 //y2=0.18
r618 (  2 69 ) resistor r=0.028033 //w=0.35 //l=0.085 //layer=m1 \
 //thickness=0.36 //x=1.48 //y=0.175 //x2=1.565 //y2=0.175
r619 (  2 4 ) resistor r=0.0892857 //w=0.35 //l=0.25 //layer=m1 \
 //thickness=0.36 //x=1.48 //y=0.175 //x2=1.23 //y2=0.175
r620 (  1 31 ) resistor r=0.39791 //w=0.311 //l=0.99 //layer=m1 \
 //thickness=0.36 //x=13.44 //y=0.175 //x2=14.43 //y2=0.175
r621 (  1 36 ) resistor r=0.148714 //w=0.311 //l=0.37 //layer=m1 \
 //thickness=0.36 //x=13.44 //y=0.175 //x2=13.07 //y2=0.175
ends PM_DFFRNX1\%GND

subckt PM_DFFRNX1\%noxref_16 ( 1 5 9 13 17 35 )
c52 ( 35 0 ) capacitor c=0.0762518f //x=0.945 //y=0.555
c53 ( 17 0 ) capacitor c=0.0259374f //x=2.935 //y=1.77
c54 ( 13 0 ) capacitor c=0.0153941f //x=2.935 //y=0.72
c55 ( 9 0 ) capacitor c=0.00772076f //x=2.05 //y=0.805
c56 ( 5 0 ) capacitor c=0.0211487f //x=1.965 //y=1.77
c57 ( 1 0 ) capacitor c=0.0109947f //x=1.08 //y=1.685
r58 (  18 35 ) resistor r=5.4201 //w=0.17 //l=0.103078 //layer=li \
 //thickness=0.1 //x=2.135 //y=1.77 //x2=2.05 //y2=1.81
r59 (  18 35 ) resistor r=27.3797 //w=0.187 //l=0.4 //layer=li //thickness=0.1 \
 //x=2.135 //y=1.77 //x2=2.535 //y2=1.77
r60 (  17 35 ) resistor r=0.751729 //w=0.17 //l=0.085 //layer=li \
 //thickness=0.1 //x=2.935 //y=1.77 //x2=3.02 //y2=1.77
r61 (  17 35 ) resistor r=27.3797 //w=0.187 //l=0.4 //layer=li //thickness=0.1 \
 //x=2.935 //y=1.77 //x2=2.535 //y2=1.77
r62 (  14 35 ) resistor r=3.57586 //w=0.17 //l=0.103078 //layer=li \
 //thickness=0.1 //x=2.135 //y=0.72 //x2=2.05 //y2=0.68
r63 (  14 35 ) resistor r=27.3797 //w=0.187 //l=0.4 //layer=li //thickness=0.1 \
 //x=2.135 //y=0.72 //x2=2.535 //y2=0.72
r64 (  13 35 ) resistor r=0.751729 //w=0.17 //l=0.085 //layer=li \
 //thickness=0.1 //x=2.935 //y=0.72 //x2=3.02 //y2=0.72
r65 (  13 35 ) resistor r=27.3797 //w=0.187 //l=0.4 //layer=li //thickness=0.1 \
 //x=2.935 //y=0.72 //x2=2.535 //y2=0.72
r66 (  10 35 ) resistor r=1.40859 //w=0.34 //l=0.125 //layer=li \
 //thickness=0.1 //x=2.05 //y=1.685 //x2=2.05 //y2=1.81
r67 (  10 35 ) resistor r=42.0963 //w=0.187 //l=0.615 //layer=li \
 //thickness=0.1 //x=2.05 //y=1.685 //x2=2.05 //y2=1.07
r68 (  9 35 ) resistor r=3.57586 //w=0.17 //l=0.125 //layer=li //thickness=0.1 \
 //x=2.05 //y=0.805 //x2=2.05 //y2=0.68
r69 (  9 35 ) resistor r=18.139 //w=0.187 //l=0.265 //layer=li //thickness=0.1 \
 //x=2.05 //y=0.805 //x2=2.05 //y2=1.07
r70 (  6 35 ) resistor r=3.57586 //w=0.17 //l=0.103078 //layer=li \
 //thickness=0.1 //x=1.165 //y=1.77 //x2=1.08 //y2=1.81
r71 (  6 35 ) resistor r=27.3797 //w=0.187 //l=0.4 //layer=li //thickness=0.1 \
 //x=1.165 //y=1.77 //x2=1.565 //y2=1.77
r72 (  5 35 ) resistor r=5.4201 //w=0.17 //l=0.103078 //layer=li \
 //thickness=0.1 //x=1.965 //y=1.77 //x2=2.05 //y2=1.81
r73 (  5 35 ) resistor r=27.3797 //w=0.187 //l=0.4 //layer=li //thickness=0.1 \
 //x=1.965 //y=1.77 //x2=1.565 //y2=1.77
r74 (  1 35 ) resistor r=3.57586 //w=0.17 //l=0.125 //layer=li //thickness=0.1 \
 //x=1.08 //y=1.685 //x2=1.08 //y2=1.81
r75 (  1 35 ) resistor r=42.0963 //w=0.187 //l=0.615 //layer=li \
 //thickness=0.1 //x=1.08 //y=1.685 //x2=1.08 //y2=1.07
ends PM_DFFRNX1\%noxref_16

subckt PM_DFFRNX1\%noxref_17 ( 1 5 9 13 17 35 )
c58 ( 35 0 ) capacitor c=0.0704927f //x=5.755 //y=0.555
c59 ( 17 0 ) capacitor c=0.0208678f //x=7.745 //y=1.77
c60 ( 13 0 ) capacitor c=0.0153941f //x=7.745 //y=0.72
c61 ( 9 0 ) capacitor c=0.00772076f //x=6.86 //y=0.805
c62 ( 5 0 ) capacitor c=0.0180187f //x=6.775 //y=1.77
c63 ( 1 0 ) capacitor c=0.00771772f //x=5.89 //y=1.685
r64 (  18 35 ) resistor r=5.4201 //w=0.17 //l=0.103078 //layer=li \
 //thickness=0.1 //x=6.945 //y=1.77 //x2=6.86 //y2=1.81
r65 (  18 35 ) resistor r=27.3797 //w=0.187 //l=0.4 //layer=li //thickness=0.1 \
 //x=6.945 //y=1.77 //x2=7.345 //y2=1.77
r66 (  17 35 ) resistor r=0.751729 //w=0.17 //l=0.085 //layer=li \
 //thickness=0.1 //x=7.745 //y=1.77 //x2=7.83 //y2=1.77
r67 (  17 35 ) resistor r=27.3797 //w=0.187 //l=0.4 //layer=li //thickness=0.1 \
 //x=7.745 //y=1.77 //x2=7.345 //y2=1.77
r68 (  14 35 ) resistor r=3.57586 //w=0.17 //l=0.103078 //layer=li \
 //thickness=0.1 //x=6.945 //y=0.72 //x2=6.86 //y2=0.68
r69 (  14 35 ) resistor r=27.3797 //w=0.187 //l=0.4 //layer=li //thickness=0.1 \
 //x=6.945 //y=0.72 //x2=7.345 //y2=0.72
r70 (  13 35 ) resistor r=0.751729 //w=0.17 //l=0.085 //layer=li \
 //thickness=0.1 //x=7.745 //y=0.72 //x2=7.83 //y2=0.72
r71 (  13 35 ) resistor r=27.3797 //w=0.187 //l=0.4 //layer=li //thickness=0.1 \
 //x=7.745 //y=0.72 //x2=7.345 //y2=0.72
r72 (  10 35 ) resistor r=1.40859 //w=0.34 //l=0.125 //layer=li \
 //thickness=0.1 //x=6.86 //y=1.685 //x2=6.86 //y2=1.81
r73 (  10 35 ) resistor r=42.0963 //w=0.187 //l=0.615 //layer=li \
 //thickness=0.1 //x=6.86 //y=1.685 //x2=6.86 //y2=1.07
r74 (  9 35 ) resistor r=3.57586 //w=0.17 //l=0.125 //layer=li //thickness=0.1 \
 //x=6.86 //y=0.805 //x2=6.86 //y2=0.68
r75 (  9 35 ) resistor r=18.139 //w=0.187 //l=0.265 //layer=li //thickness=0.1 \
 //x=6.86 //y=0.805 //x2=6.86 //y2=1.07
r76 (  6 35 ) resistor r=3.57586 //w=0.17 //l=0.103078 //layer=li \
 //thickness=0.1 //x=5.975 //y=1.77 //x2=5.89 //y2=1.81
r77 (  6 35 ) resistor r=27.3797 //w=0.187 //l=0.4 //layer=li //thickness=0.1 \
 //x=5.975 //y=1.77 //x2=6.375 //y2=1.77
r78 (  5 35 ) resistor r=5.4201 //w=0.17 //l=0.103078 //layer=li \
 //thickness=0.1 //x=6.775 //y=1.77 //x2=6.86 //y2=1.81
r79 (  5 35 ) resistor r=27.3797 //w=0.187 //l=0.4 //layer=li //thickness=0.1 \
 //x=6.775 //y=1.77 //x2=6.375 //y2=1.77
r80 (  1 35 ) resistor r=3.57586 //w=0.17 //l=0.125 //layer=li //thickness=0.1 \
 //x=5.89 //y=1.685 //x2=5.89 //y2=1.81
r81 (  1 35 ) resistor r=42.0963 //w=0.187 //l=0.615 //layer=li \
 //thickness=0.1 //x=5.89 //y=1.685 //x2=5.89 //y2=1.07
ends PM_DFFRNX1\%noxref_17

subckt PM_DFFRNX1\%noxref_18 ( 1 5 9 10 13 17 29 )
c68 ( 29 0 ) capacitor c=0.067062f //x=10.67 //y=0.545
c69 ( 17 0 ) capacitor c=0.00675704f //x=12.745 //y=0.795
c70 ( 13 0 ) capacitor c=0.0156329f //x=12.66 //y=0.71
c71 ( 10 0 ) capacitor c=0.00673372f //x=11.775 //y=1.675
c72 ( 9 0 ) capacitor c=0.00770028f //x=11.775 //y=0.795
c73 ( 5 0 ) capacitor c=0.0179513f //x=11.69 //y=1.76
c74 ( 1 0 ) capacitor c=0.00761099f //x=10.805 //y=1.675
r75 (  17 29 ) resistor r=3.57586 //w=0.17 //l=0.125 //layer=li \
 //thickness=0.1 //x=12.745 //y=0.795 //x2=12.745 //y2=0.67
r76 (  17 29 ) resistor r=18.139 //w=0.187 //l=0.265 //layer=li \
 //thickness=0.1 //x=12.745 //y=0.795 //x2=12.745 //y2=1.06
r77 (  14 29 ) resistor r=3.57586 //w=0.17 //l=0.103078 //layer=li \
 //thickness=0.1 //x=11.86 //y=0.71 //x2=11.775 //y2=0.67
r78 (  14 29 ) resistor r=27.3797 //w=0.187 //l=0.4 //layer=li //thickness=0.1 \
 //x=11.86 //y=0.71 //x2=12.26 //y2=0.71
r79 (  13 29 ) resistor r=3.57586 //w=0.17 //l=0.103078 //layer=li \
 //thickness=0.1 //x=12.66 //y=0.71 //x2=12.745 //y2=0.67
r80 (  13 29 ) resistor r=27.3797 //w=0.187 //l=0.4 //layer=li //thickness=0.1 \
 //x=12.66 //y=0.71 //x2=12.26 //y2=0.71
r81 (  10 29 ) resistor r=3.57586 //w=0.17 //l=0.125 //layer=li \
 //thickness=0.1 //x=11.775 //y=1.675 //x2=11.775 //y2=1.8
r82 (  10 29 ) resistor r=42.0963 //w=0.187 //l=0.615 //layer=li \
 //thickness=0.1 //x=11.775 //y=1.675 //x2=11.775 //y2=1.06
r83 (  9 29 ) resistor r=3.57586 //w=0.17 //l=0.125 //layer=li //thickness=0.1 \
 //x=11.775 //y=0.795 //x2=11.775 //y2=0.67
r84 (  9 29 ) resistor r=18.139 //w=0.187 //l=0.265 //layer=li //thickness=0.1 \
 //x=11.775 //y=0.795 //x2=11.775 //y2=1.06
r85 (  6 29 ) resistor r=3.57586 //w=0.17 //l=0.103078 //layer=li \
 //thickness=0.1 //x=10.89 //y=1.76 //x2=10.805 //y2=1.8
r86 (  6 29 ) resistor r=27.3797 //w=0.187 //l=0.4 //layer=li //thickness=0.1 \
 //x=10.89 //y=1.76 //x2=11.29 //y2=1.76
r87 (  5 29 ) resistor r=3.57586 //w=0.17 //l=0.103078 //layer=li \
 //thickness=0.1 //x=11.69 //y=1.76 //x2=11.775 //y2=1.8
r88 (  5 29 ) resistor r=27.3797 //w=0.187 //l=0.4 //layer=li //thickness=0.1 \
 //x=11.69 //y=1.76 //x2=11.29 //y2=1.76
r89 (  1 29 ) resistor r=3.57586 //w=0.17 //l=0.125 //layer=li //thickness=0.1 \
 //x=10.805 //y=1.675 //x2=10.805 //y2=1.8
r90 (  1 29 ) resistor r=42.0963 //w=0.187 //l=0.615 //layer=li \
 //thickness=0.1 //x=10.805 //y=1.675 //x2=10.805 //y2=1.06
ends PM_DFFRNX1\%noxref_18

subckt PM_DFFRNX1\%noxref_19 ( 1 5 9 13 17 35 )
c59 ( 35 0 ) capacitor c=0.068832f //x=13.895 //y=0.555
c60 ( 17 0 ) capacitor c=0.0190725f //x=15.885 //y=1.77
c61 ( 13 0 ) capacitor c=0.015325f //x=15.885 //y=0.72
c62 ( 9 0 ) capacitor c=0.00772076f //x=15 //y=0.805
c63 ( 5 0 ) capacitor c=0.0168501f //x=14.915 //y=1.77
c64 ( 1 0 ) capacitor c=0.00709556f //x=14.03 //y=1.685
r65 (  18 35 ) resistor r=5.4201 //w=0.17 //l=0.103078 //layer=li \
 //thickness=0.1 //x=15.085 //y=1.77 //x2=15 //y2=1.81
r66 (  18 35 ) resistor r=27.3797 //w=0.187 //l=0.4 //layer=li //thickness=0.1 \
 //x=15.085 //y=1.77 //x2=15.485 //y2=1.77
r67 (  17 35 ) resistor r=0.751729 //w=0.17 //l=0.085 //layer=li \
 //thickness=0.1 //x=15.885 //y=1.77 //x2=15.97 //y2=1.77
r68 (  17 35 ) resistor r=27.3797 //w=0.187 //l=0.4 //layer=li //thickness=0.1 \
 //x=15.885 //y=1.77 //x2=15.485 //y2=1.77
r69 (  14 35 ) resistor r=3.57586 //w=0.17 //l=0.103078 //layer=li \
 //thickness=0.1 //x=15.085 //y=0.72 //x2=15 //y2=0.68
r70 (  14 35 ) resistor r=27.3797 //w=0.187 //l=0.4 //layer=li //thickness=0.1 \
 //x=15.085 //y=0.72 //x2=15.485 //y2=0.72
r71 (  13 35 ) resistor r=0.751729 //w=0.17 //l=0.085 //layer=li \
 //thickness=0.1 //x=15.885 //y=0.72 //x2=15.97 //y2=0.72
r72 (  13 35 ) resistor r=27.3797 //w=0.187 //l=0.4 //layer=li //thickness=0.1 \
 //x=15.885 //y=0.72 //x2=15.485 //y2=0.72
r73 (  10 35 ) resistor r=1.40859 //w=0.34 //l=0.125 //layer=li \
 //thickness=0.1 //x=15 //y=1.685 //x2=15 //y2=1.81
r74 (  10 35 ) resistor r=42.0963 //w=0.187 //l=0.615 //layer=li \
 //thickness=0.1 //x=15 //y=1.685 //x2=15 //y2=1.07
r75 (  9 35 ) resistor r=3.57586 //w=0.17 //l=0.125 //layer=li //thickness=0.1 \
 //x=15 //y=0.805 //x2=15 //y2=0.68
r76 (  9 35 ) resistor r=18.139 //w=0.187 //l=0.265 //layer=li //thickness=0.1 \
 //x=15 //y=0.805 //x2=15 //y2=1.07
r77 (  6 35 ) resistor r=3.57586 //w=0.17 //l=0.103078 //layer=li \
 //thickness=0.1 //x=14.115 //y=1.77 //x2=14.03 //y2=1.81
r78 (  6 35 ) resistor r=27.3797 //w=0.187 //l=0.4 //layer=li //thickness=0.1 \
 //x=14.115 //y=1.77 //x2=14.515 //y2=1.77
r79 (  5 35 ) resistor r=5.4201 //w=0.17 //l=0.103078 //layer=li \
 //thickness=0.1 //x=14.915 //y=1.77 //x2=15 //y2=1.81
r80 (  5 35 ) resistor r=27.3797 //w=0.187 //l=0.4 //layer=li //thickness=0.1 \
 //x=14.915 //y=1.77 //x2=14.515 //y2=1.77
r81 (  1 35 ) resistor r=3.57586 //w=0.17 //l=0.125 //layer=li //thickness=0.1 \
 //x=14.03 //y=1.685 //x2=14.03 //y2=1.81
r82 (  1 35 ) resistor r=42.0963 //w=0.187 //l=0.615 //layer=li \
 //thickness=0.1 //x=14.03 //y=1.685 //x2=14.03 //y2=1.07
ends PM_DFFRNX1\%noxref_19

subckt PM_DFFRNX1\%noxref_20 ( 1 5 9 13 17 35 )
c57 ( 35 0 ) capacitor c=0.0720266f //x=18.705 //y=0.555
c58 ( 17 0 ) capacitor c=0.0196483f //x=20.695 //y=1.77
c59 ( 13 0 ) capacitor c=0.015394f //x=20.695 //y=0.72
c60 ( 9 0 ) capacitor c=0.00772076f //x=19.81 //y=0.805
c61 ( 5 0 ) capacitor c=0.0168501f //x=19.725 //y=1.77
c62 ( 1 0 ) capacitor c=0.00710458f //x=18.84 //y=1.685
r63 (  18 35 ) resistor r=5.4201 //w=0.17 //l=0.103078 //layer=li \
 //thickness=0.1 //x=19.895 //y=1.77 //x2=19.81 //y2=1.81
r64 (  18 35 ) resistor r=27.3797 //w=0.187 //l=0.4 //layer=li //thickness=0.1 \
 //x=19.895 //y=1.77 //x2=20.295 //y2=1.77
r65 (  17 35 ) resistor r=0.751729 //w=0.17 //l=0.085 //layer=li \
 //thickness=0.1 //x=20.695 //y=1.77 //x2=20.78 //y2=1.77
r66 (  17 35 ) resistor r=27.3797 //w=0.187 //l=0.4 //layer=li //thickness=0.1 \
 //x=20.695 //y=1.77 //x2=20.295 //y2=1.77
r67 (  14 35 ) resistor r=3.57586 //w=0.17 //l=0.103078 //layer=li \
 //thickness=0.1 //x=19.895 //y=0.72 //x2=19.81 //y2=0.68
r68 (  14 35 ) resistor r=27.3797 //w=0.187 //l=0.4 //layer=li //thickness=0.1 \
 //x=19.895 //y=0.72 //x2=20.295 //y2=0.72
r69 (  13 35 ) resistor r=0.751729 //w=0.17 //l=0.085 //layer=li \
 //thickness=0.1 //x=20.695 //y=0.72 //x2=20.78 //y2=0.72
r70 (  13 35 ) resistor r=27.3797 //w=0.187 //l=0.4 //layer=li //thickness=0.1 \
 //x=20.695 //y=0.72 //x2=20.295 //y2=0.72
r71 (  10 35 ) resistor r=1.40859 //w=0.34 //l=0.125 //layer=li \
 //thickness=0.1 //x=19.81 //y=1.685 //x2=19.81 //y2=1.81
r72 (  10 35 ) resistor r=42.0963 //w=0.187 //l=0.615 //layer=li \
 //thickness=0.1 //x=19.81 //y=1.685 //x2=19.81 //y2=1.07
r73 (  9 35 ) resistor r=3.57586 //w=0.17 //l=0.125 //layer=li //thickness=0.1 \
 //x=19.81 //y=0.805 //x2=19.81 //y2=0.68
r74 (  9 35 ) resistor r=18.139 //w=0.187 //l=0.265 //layer=li //thickness=0.1 \
 //x=19.81 //y=0.805 //x2=19.81 //y2=1.07
r75 (  6 35 ) resistor r=3.57586 //w=0.17 //l=0.103078 //layer=li \
 //thickness=0.1 //x=18.925 //y=1.77 //x2=18.84 //y2=1.81
r76 (  6 35 ) resistor r=27.3797 //w=0.187 //l=0.4 //layer=li //thickness=0.1 \
 //x=18.925 //y=1.77 //x2=19.325 //y2=1.77
r77 (  5 35 ) resistor r=5.4201 //w=0.17 //l=0.103078 //layer=li \
 //thickness=0.1 //x=19.725 //y=1.77 //x2=19.81 //y2=1.81
r78 (  5 35 ) resistor r=27.3797 //w=0.187 //l=0.4 //layer=li //thickness=0.1 \
 //x=19.725 //y=1.77 //x2=19.325 //y2=1.77
r79 (  1 35 ) resistor r=3.57586 //w=0.17 //l=0.125 //layer=li //thickness=0.1 \
 //x=18.84 //y=1.685 //x2=18.84 //y2=1.81
r80 (  1 35 ) resistor r=42.0963 //w=0.187 //l=0.615 //layer=li \
 //thickness=0.1 //x=18.84 //y=1.685 //x2=18.84 //y2=1.07
ends PM_DFFRNX1\%noxref_20

subckt PM_DFFRNX1\%noxref_21 ( 1 5 9 10 13 17 29 )
c60 ( 29 0 ) capacitor c=0.0681402f //x=23.62 //y=0.545
c61 ( 17 0 ) capacitor c=0.00709791f //x=25.695 //y=0.795
c62 ( 13 0 ) capacitor c=0.0157577f //x=25.61 //y=0.71
c63 ( 10 0 ) capacitor c=0.00742952f //x=24.725 //y=1.675
c64 ( 9 0 ) capacitor c=0.00770028f //x=24.725 //y=0.795
c65 ( 5 0 ) capacitor c=0.0196296f //x=24.64 //y=1.76
c66 ( 1 0 ) capacitor c=0.00822695f //x=23.755 //y=1.675
r67 (  17 29 ) resistor r=3.57586 //w=0.17 //l=0.125 //layer=li \
 //thickness=0.1 //x=25.695 //y=0.795 //x2=25.695 //y2=0.67
r68 (  17 29 ) resistor r=18.139 //w=0.187 //l=0.265 //layer=li \
 //thickness=0.1 //x=25.695 //y=0.795 //x2=25.695 //y2=1.06
r69 (  14 29 ) resistor r=3.57586 //w=0.17 //l=0.103078 //layer=li \
 //thickness=0.1 //x=24.81 //y=0.71 //x2=24.725 //y2=0.67
r70 (  14 29 ) resistor r=27.3797 //w=0.187 //l=0.4 //layer=li //thickness=0.1 \
 //x=24.81 //y=0.71 //x2=25.21 //y2=0.71
r71 (  13 29 ) resistor r=3.57586 //w=0.17 //l=0.103078 //layer=li \
 //thickness=0.1 //x=25.61 //y=0.71 //x2=25.695 //y2=0.67
r72 (  13 29 ) resistor r=27.3797 //w=0.187 //l=0.4 //layer=li //thickness=0.1 \
 //x=25.61 //y=0.71 //x2=25.21 //y2=0.71
r73 (  10 29 ) resistor r=3.57586 //w=0.17 //l=0.125 //layer=li \
 //thickness=0.1 //x=24.725 //y=1.675 //x2=24.725 //y2=1.8
r74 (  10 29 ) resistor r=42.0963 //w=0.187 //l=0.615 //layer=li \
 //thickness=0.1 //x=24.725 //y=1.675 //x2=24.725 //y2=1.06
r75 (  9 29 ) resistor r=3.57586 //w=0.17 //l=0.125 //layer=li //thickness=0.1 \
 //x=24.725 //y=0.795 //x2=24.725 //y2=0.67
r76 (  9 29 ) resistor r=18.139 //w=0.187 //l=0.265 //layer=li //thickness=0.1 \
 //x=24.725 //y=0.795 //x2=24.725 //y2=1.06
r77 (  6 29 ) resistor r=3.57586 //w=0.17 //l=0.103078 //layer=li \
 //thickness=0.1 //x=23.84 //y=1.76 //x2=23.755 //y2=1.8
r78 (  6 29 ) resistor r=27.3797 //w=0.187 //l=0.4 //layer=li //thickness=0.1 \
 //x=23.84 //y=1.76 //x2=24.24 //y2=1.76
r79 (  5 29 ) resistor r=3.57586 //w=0.17 //l=0.103078 //layer=li \
 //thickness=0.1 //x=24.64 //y=1.76 //x2=24.725 //y2=1.8
r80 (  5 29 ) resistor r=27.3797 //w=0.187 //l=0.4 //layer=li //thickness=0.1 \
 //x=24.64 //y=1.76 //x2=24.24 //y2=1.76
r81 (  1 29 ) resistor r=3.57586 //w=0.17 //l=0.125 //layer=li //thickness=0.1 \
 //x=23.755 //y=1.675 //x2=23.755 //y2=1.8
r82 (  1 29 ) resistor r=42.0963 //w=0.187 //l=0.615 //layer=li \
 //thickness=0.1 //x=23.755 //y=1.675 //x2=23.755 //y2=1.06
ends PM_DFFRNX1\%noxref_21
