// File: INVX1.spi.INVX1.pxi
// Created: Tue Apr 29 10:42:49 2025
//
simulator lang=spectre
x_PM_INVX1\%GND ( GND N_GND_c_3_p N_GND_c_4_p N_GND_c_12_p N_GND_c_1_p \
 N_GND_c_2_p N_GND_M0_noxref_s )  PM_INVX1\%GND
x_PM_INVX1\%VDD ( VDD N_VDD_c_45_p N_VDD_c_32_p N_VDD_c_27_n N_VDD_c_28_n \
 N_VDD_M1_noxref_s N_VDD_M2_noxref_d )  PM_INVX1\%VDD
x_PM_INVX1\%A ( A A A A A A A N_A_c_50_n N_A_M0_noxref_g N_A_M1_noxref_g \
 N_A_M2_noxref_g N_A_c_55_n N_A_c_85_p N_A_c_86_p N_A_c_57_n N_A_c_73_n \
 N_A_c_74_n N_A_c_58_n N_A_c_78_p N_A_c_59_n N_A_c_61_n N_A_c_62_n )  \
 PM_INVX1\%A
x_PM_INVX1\%Y ( Y Y Y Y Y Y Y N_Y_c_97_n N_Y_c_118_n N_Y_c_107_n N_Y_c_109_n \
 N_Y_M0_noxref_d N_Y_M1_noxref_d )  PM_INVX1\%Y
cc_1 ( N_GND_c_1_p N_VDD_c_27_n ) capacitor c=0.00989514f //x=1.12 //y=0.175 \
 //x2=1.23 //y2=7.58
cc_2 ( N_GND_c_2_p N_VDD_c_28_n ) capacitor c=0.00989514f //x=2.09 //y=0.175 \
 //x2=1.97 //y2=7.58
cc_3 ( N_GND_c_3_p N_A_c_50_n ) capacitor c=0.00203126f //x=1.97 //y=0.18 \
 //x2=1.23 //y2=2.265
cc_4 ( N_GND_c_4_p N_A_c_50_n ) capacitor c=8.01092e-19 //x=1.52 //y=0.715 \
 //x2=1.23 //y2=2.265
cc_5 ( N_GND_c_1_p N_A_c_50_n ) capacitor c=0.0293771f //x=1.12 //y=0.175 \
 //x2=1.23 //y2=2.265
cc_6 ( N_GND_c_2_p N_A_c_50_n ) capacitor c=0.00118981f //x=2.09 //y=0.175 \
 //x2=1.23 //y2=2.265
cc_7 ( N_GND_M0_noxref_s N_A_c_50_n ) capacitor c=0.0107289f //x=0.985 \
 //y=0.55 //x2=1.23 //y2=2.265
cc_8 ( N_GND_c_4_p N_A_c_55_n ) capacitor c=0.0120525f //x=1.52 //y=0.715 \
 //x2=1.34 //y2=1.09
cc_9 ( N_GND_M0_noxref_s N_A_c_55_n ) capacitor c=0.0315727f //x=0.985 \
 //y=0.55 //x2=1.34 //y2=1.09
cc_10 ( N_GND_c_1_p N_A_c_57_n ) capacitor c=0.0124051f //x=1.12 //y=0.175 \
 //x2=1.34 //y2=2.1
cc_11 ( N_GND_M0_noxref_s N_A_c_58_n ) capacitor c=0.00483567f //x=0.985 \
 //y=0.55 //x2=1.715 //y2=0.935
cc_12 ( N_GND_c_12_p N_A_c_59_n ) capacitor c=0.0118631f //x=2.005 //y=0.715 \
 //x2=1.87 //y2=1.09
cc_13 ( N_GND_M0_noxref_s N_A_c_59_n ) capacitor c=0.0143355f //x=0.985 \
 //y=0.55 //x2=1.87 //y2=1.09
cc_14 ( N_GND_M0_noxref_s N_A_c_61_n ) capacitor c=0.0074042f //x=0.985 \
 //y=0.55 //x2=1.87 //y2=1.435
cc_15 ( N_GND_c_4_p N_A_c_62_n ) capacitor c=2.1838e-19 //x=1.52 //y=0.715 \
 //x2=1.23 //y2=2.265
cc_16 ( N_GND_c_1_p N_A_c_62_n ) capacitor c=0.0108179f //x=1.12 //y=0.175 \
 //x2=1.23 //y2=2.265
cc_17 ( N_GND_M0_noxref_s N_A_c_62_n ) capacitor c=0.00650301f //x=0.985 \
 //y=0.55 //x2=1.23 //y2=2.265
cc_18 ( N_GND_c_1_p Y ) capacitor c=8.10282e-19 //x=1.12 //y=0.175 //x2=1.97 \
 //y2=2.4
cc_19 ( N_GND_c_3_p N_Y_c_97_n ) capacitor c=0.00212303f //x=1.97 //y=0.18 \
 //x2=1.885 //y2=2.26
cc_20 ( N_GND_c_2_p N_Y_c_97_n ) capacitor c=0.0301661f //x=2.09 //y=0.175 \
 //x2=1.885 //y2=2.26
cc_21 ( N_GND_M0_noxref_s N_Y_c_97_n ) capacitor c=0.0099963f //x=0.985 \
 //y=0.55 //x2=1.885 //y2=2.26
cc_22 ( N_GND_c_3_p N_Y_M0_noxref_d ) capacitor c=0.00194747f //x=1.97 \
 //y=0.18 //x2=1.415 //y2=1.09
cc_23 ( N_GND_c_4_p N_Y_M0_noxref_d ) capacitor c=0.014622f //x=1.52 //y=0.715 \
 //x2=1.415 //y2=1.09
cc_24 ( N_GND_c_1_p N_Y_M0_noxref_d ) capacitor c=0.0094373f //x=1.12 \
 //y=0.175 //x2=1.415 //y2=1.09
cc_25 ( N_GND_c_2_p N_Y_M0_noxref_d ) capacitor c=0.00973758f //x=2.09 \
 //y=0.175 //x2=1.415 //y2=1.09
cc_26 ( N_GND_M0_noxref_s N_Y_M0_noxref_d ) capacitor c=0.076995f //x=0.985 \
 //y=0.55 //x2=1.415 //y2=1.09
cc_27 ( N_VDD_c_27_n N_A_c_50_n ) capacitor c=0.0276175f //x=1.23 //y=7.58 \
 //x2=1.23 //y2=2.265
cc_28 ( N_VDD_c_28_n N_A_c_50_n ) capacitor c=0.00144809f //x=1.97 //y=7.58 \
 //x2=1.23 //y2=2.265
cc_29 ( N_VDD_M1_noxref_s N_A_c_50_n ) capacitor c=0.00938354f //x=1.03 \
 //y=5.2 //x2=1.23 //y2=2.265
cc_30 ( N_VDD_c_32_p N_A_M1_noxref_g ) capacitor c=0.00753931f //x=1.96 \
 //y=7.585 //x2=1.385 //y2=6.2
cc_31 ( N_VDD_c_27_n N_A_M1_noxref_g ) capacitor c=0.0241676f //x=1.23 \
 //y=7.58 //x2=1.385 //y2=6.2
cc_32 ( N_VDD_M1_noxref_s N_A_M1_noxref_g ) capacitor c=0.0528676f //x=1.03 \
 //y=5.2 //x2=1.385 //y2=6.2
cc_33 ( N_VDD_c_32_p N_A_M2_noxref_g ) capacitor c=0.00702238f //x=1.96 \
 //y=7.585 //x2=1.825 //y2=6.2
cc_34 ( N_VDD_M2_noxref_d N_A_M2_noxref_g ) capacitor c=0.0528676f //x=1.9 \
 //y=5.2 //x2=1.825 //y2=6.2
cc_35 ( N_VDD_c_28_n N_A_c_73_n ) capacitor c=0.0287802f //x=1.97 //y=7.58 \
 //x2=1.75 //y2=4.97
cc_36 ( N_VDD_c_27_n N_A_c_74_n ) capacitor c=0.011132f //x=1.23 //y=7.58 \
 //x2=1.46 //y2=4.97
cc_37 ( N_VDD_M1_noxref_s N_A_c_74_n ) capacitor c=0.00665885f //x=1.03 \
 //y=5.2 //x2=1.46 //y2=4.97
cc_38 ( N_VDD_c_27_n Y ) capacitor c=4.80934e-19 //x=1.23 //y=7.58 //x2=1.97 \
 //y2=2.4
cc_39 ( N_VDD_c_28_n Y ) capacitor c=0.0232778f //x=1.97 //y=7.58 //x2=1.97 \
 //y2=2.4
cc_40 ( N_VDD_c_32_p N_Y_c_107_n ) capacitor c=8.94397e-19 //x=1.96 //y=7.585 \
 //x2=1.885 //y2=4.76
cc_41 ( N_VDD_M2_noxref_d N_Y_c_107_n ) capacitor c=0.00645128f //x=1.9 \
 //y=5.2 //x2=1.885 //y2=4.76
cc_42 ( N_VDD_c_27_n N_Y_c_109_n ) capacitor c=0.0179238f //x=1.23 //y=7.58 \
 //x2=1.69 //y2=4.76
cc_43 ( N_VDD_c_45_p N_Y_M1_noxref_d ) capacitor c=0.00724309f //x=1.97 \
 //y=7.58 //x2=1.46 //y2=5.2
cc_44 ( N_VDD_c_32_p N_Y_M1_noxref_d ) capacitor c=0.0139426f //x=1.96 \
 //y=7.585 //x2=1.46 //y2=5.2
cc_45 ( N_VDD_c_28_n N_Y_M1_noxref_d ) capacitor c=0.0219131f //x=1.97 \
 //y=7.58 //x2=1.46 //y2=5.2
cc_46 ( N_VDD_M1_noxref_s N_Y_M1_noxref_d ) capacitor c=0.0843065f //x=1.03 \
 //y=5.2 //x2=1.46 //y2=5.2
cc_47 ( N_VDD_M2_noxref_d N_Y_M1_noxref_d ) capacitor c=0.0832641f //x=1.9 \
 //y=5.2 //x2=1.46 //y2=5.2
cc_48 ( N_A_c_50_n Y ) capacitor c=0.0739084f //x=1.23 //y=2.265 //x2=1.97 \
 //y2=2.4
cc_49 ( N_A_c_62_n Y ) capacitor c=8.49451e-19 //x=1.23 //y=2.265 //x2=1.97 \
 //y2=2.4
cc_50 ( N_A_c_78_p N_Y_c_97_n ) capacitor c=0.0023507f //x=1.715 //y=1.59 \
 //x2=1.885 //y2=2.26
cc_51 ( N_A_c_62_n N_Y_c_118_n ) capacitor c=0.0167852f //x=1.23 //y=2.265 \
 //x2=1.685 //y2=2.26
cc_52 ( N_A_c_73_n N_Y_c_107_n ) capacitor c=0.0107726f //x=1.75 //y=4.97 \
 //x2=1.885 //y2=4.76
cc_53 ( N_A_c_50_n N_Y_c_109_n ) capacitor c=0.0250789f //x=1.23 //y=2.265 \
 //x2=1.69 //y2=4.76
cc_54 ( N_A_c_74_n N_Y_c_109_n ) capacitor c=0.00962086f //x=1.46 //y=4.97 \
 //x2=1.69 //y2=4.76
cc_55 ( N_A_c_50_n N_Y_M0_noxref_d ) capacitor c=0.0175773f //x=1.23 //y=2.265 \
 //x2=1.415 //y2=1.09
cc_56 ( N_A_c_55_n N_Y_M0_noxref_d ) capacitor c=0.00218556f //x=1.34 //y=1.09 \
 //x2=1.415 //y2=1.09
cc_57 ( N_A_c_85_p N_Y_M0_noxref_d ) capacitor c=0.00347355f //x=1.34 \
 //y=1.435 //x2=1.415 //y2=1.09
cc_58 ( N_A_c_86_p N_Y_M0_noxref_d ) capacitor c=0.00742431f //x=1.34 \
 //y=1.745 //x2=1.415 //y2=1.09
cc_59 ( N_A_c_57_n N_Y_M0_noxref_d ) capacitor c=0.00957707f //x=1.34 //y=2.1 \
 //x2=1.415 //y2=1.09
cc_60 ( N_A_c_58_n N_Y_M0_noxref_d ) capacitor c=0.00220879f //x=1.715 \
 //y=0.935 //x2=1.415 //y2=1.09
cc_61 ( N_A_c_78_p N_Y_M0_noxref_d ) capacitor c=0.0138447f //x=1.715 //y=1.59 \
 //x2=1.415 //y2=1.09
cc_62 ( N_A_c_59_n N_Y_M0_noxref_d ) capacitor c=0.00218624f //x=1.87 //y=1.09 \
 //x2=1.415 //y2=1.09
cc_63 ( N_A_c_61_n N_Y_M0_noxref_d ) capacitor c=0.00601286f //x=1.87 \
 //y=1.435 //x2=1.415 //y2=1.09
cc_64 ( N_A_M1_noxref_g N_Y_M1_noxref_d ) capacitor c=0.0219309f //x=1.385 \
 //y=6.2 //x2=1.46 //y2=5.2
cc_65 ( N_A_M2_noxref_g N_Y_M1_noxref_d ) capacitor c=0.021902f //x=1.825 \
 //y=6.2 //x2=1.46 //y2=5.2
cc_66 ( N_A_c_73_n N_Y_M1_noxref_d ) capacitor c=0.0148755f //x=1.75 //y=4.97 \
 //x2=1.46 //y2=5.2
cc_67 ( N_A_c_74_n N_Y_M1_noxref_d ) capacitor c=0.00307344f //x=1.46 //y=4.97 \
 //x2=1.46 //y2=5.2
