// File: votern3x1_pcell.spi.pex
// Created: Thu Jan 22 07:17:12 2026
// Program "Calibre xRC"
// Version "v2023.2_27.15"
// Nominal Temperature: 30C
// Circuit Temperature: 30C
//
simulator lang=spectre
subckt PM_VOTERN3X1_PCELL\%noxref_1 ( 1 2 3 4 8 11 17 22 23 26 31 37 42 47 48 \
 49 50 51 52 53 54 55 56 60 62 65 66 67 68 72 73 74 75 79 81 87 88 90 103 )
c228 ( 103 0 ) capacitor c=0.0692896f //x=4.44 //y=4.705
c229 ( 90 0 ) capacitor c=0.0603371f //x=0.74 //y=2.08
c230 ( 88 0 ) capacitor c=0.0344584f //x=4.775 //y=1.21
c231 ( 87 0 ) capacitor c=0.0188421f //x=4.775 //y=0.865
c232 ( 81 0 ) capacitor c=0.0141798f //x=4.62 //y=1.365
c233 ( 79 0 ) capacitor c=0.0160622f //x=4.62 //y=0.71
c234 ( 75 0 ) capacitor c=0.103881f //x=4.245 //y=1.915
c235 ( 74 0 ) capacitor c=0.0227978f //x=4.245 //y=1.52
c236 ( 73 0 ) capacitor c=0.0234352f //x=4.245 //y=1.21
c237 ( 72 0 ) capacitor c=0.0200371f //x=4.245 //y=0.865
c238 ( 68 0 ) capacitor c=0.0318956f //x=1.445 //y=1.21
c239 ( 67 0 ) capacitor c=0.0186809f //x=1.445 //y=0.865
c240 ( 66 0 ) capacitor c=0.0624333f //x=1.085 //y=4.795
c241 ( 65 0 ) capacitor c=0.0375163f //x=1.375 //y=4.795
c242 ( 62 0 ) capacitor c=0.0157936f //x=1.29 //y=1.365
c243 ( 60 0 ) capacitor c=0.0158553f //x=1.29 //y=0.71
c244 ( 56 0 ) capacitor c=0.0302441f //x=0.915 //y=1.915
c245 ( 55 0 ) capacitor c=0.0238107f //x=0.915 //y=1.52
c246 ( 54 0 ) capacitor c=0.0234359f //x=0.915 //y=1.21
c247 ( 53 0 ) capacitor c=0.0199332f //x=0.915 //y=0.865
c248 ( 52 0 ) capacitor c=0.111167f //x=4.77 //y=6.025
c249 ( 51 0 ) capacitor c=0.154978f //x=4.33 //y=6.025
c250 ( 50 0 ) capacitor c=0.110282f //x=1.45 //y=6.025
c251 ( 49 0 ) capacitor c=0.155219f //x=1.01 //y=6.025
c252 ( 42 0 ) capacitor c=0.0156727f //x=4.44 //y=4.44
c253 ( 37 0 ) capacitor c=0.00133482f //x=4.44 //y=2.08
c254 ( 31 0 ) capacitor c=0.0125733f //x=0.74 //y=4.44
c255 ( 26 0 ) capacitor c=7.43216e-19 //x=0.74 //y=2.08
c256 ( 23 0 ) capacitor c=0.0876578f //x=4.285 //y=4.46
c257 ( 22 0 ) capacitor c=0.00642399f //x=4.445 //y=4.46
c258 ( 17 0 ) capacitor c=0.00920482f //x=0.905 //y=4.44
c259 ( 11 0 ) capacitor c=0.0127073f //x=4.44 //y=4.44
c260 ( 8 0 ) capacitor c=0.0139929f //x=0.74 //y=4.44
c261 ( 4 0 ) capacitor c=0.0851523f //x=4.44 //y=4.295
c262 ( 3 0 ) capacitor c=0.00894425f //x=4.44 //y=2.205
c263 ( 2 0 ) capacitor c=0.0996103f //x=0.74 //y=4.28
c264 ( 1 0 ) capacitor c=0.0100386f //x=0.74 //y=2.195
r265 (  101 103 ) resistor r=22.7554 //w=0.233 //l=0.11 //layer=ply \
 //thickness=0.18 //x=4.33 //y=4.705 //x2=4.44 //y2=4.705
r266 (  88 105 ) resistor r=45.1352 //w=0.168 //l=0.173853 //layer=ply \
 //thickness=0.18 //x=4.775 //y=1.21 //x2=4.735 //y2=1.365
r267 (  87 104 ) resistor r=45.1352 //w=0.168 //l=0.173853 //layer=ply \
 //thickness=0.18 //x=4.775 //y=0.865 //x2=4.735 //y2=0.71
r268 (  87 88 ) resistor r=176.904 //w=0.094 //l=0.345 //layer=ply \
 //thickness=0.18 //x=4.775 //y=0.865 //x2=4.775 //y2=1.21
r269 (  84 103 ) resistor r=68.2661 //w=0.233 //l=0.404166 //layer=ply \
 //thickness=0.18 //x=4.77 //y=4.87 //x2=4.44 //y2=4.705
r270 (  82 100 ) resistor r=10.701 //w=0.21 //l=0.115 //layer=ply \
 //thickness=0.18 //x=4.4 //y=1.365 //x2=4.285 //y2=1.365
r271 (  81 105 ) resistor r=5.52526 //w=0.168 //l=0.115 //layer=ply \
 //thickness=0.18 //x=4.62 //y=1.365 //x2=4.735 //y2=1.365
r272 (  80 99 ) resistor r=5.52526 //w=0.168 //l=0.115 //layer=ply \
 //thickness=0.18 //x=4.4 //y=0.71 //x2=4.285 //y2=0.71
r273 (  79 104 ) resistor r=5.52526 //w=0.168 //l=0.115 //layer=ply \
 //thickness=0.18 //x=4.62 //y=0.71 //x2=4.735 //y2=0.71
r274 (  79 80 ) resistor r=112.809 //w=0.094 //l=0.22 //layer=ply \
 //thickness=0.18 //x=4.62 //y=0.71 //x2=4.4 //y2=0.71
r275 (  76 101 ) resistor r=13.0941 //w=0.233 //l=0.165 //layer=ply \
 //thickness=0.18 //x=4.33 //y=4.87 //x2=4.33 //y2=4.705
r276 (  75 98 ) resistor r=34.8111 //w=0.27 //l=0.264953 //layer=ply \
 //thickness=0.18 //x=4.245 //y=1.915 //x2=4.44 //y2=2.08
r277 (  74 100 ) resistor r=39.5823 //w=0.21 //l=0.173853 //layer=ply \
 //thickness=0.18 //x=4.245 //y=1.52 //x2=4.285 //y2=1.365
r278 (  74 75 ) resistor r=202.543 //w=0.094 //l=0.395 //layer=ply \
 //thickness=0.18 //x=4.245 //y=1.52 //x2=4.245 //y2=1.915
r279 (  73 100 ) resistor r=39.5823 //w=0.21 //l=0.173853 //layer=ply \
 //thickness=0.18 //x=4.245 //y=1.21 //x2=4.285 //y2=1.365
r280 (  72 99 ) resistor r=45.1352 //w=0.168 //l=0.173853 //layer=ply \
 //thickness=0.18 //x=4.245 //y=0.865 //x2=4.285 //y2=0.71
r281 (  72 73 ) resistor r=176.904 //w=0.094 //l=0.345 //layer=ply \
 //thickness=0.18 //x=4.245 //y=0.865 //x2=4.245 //y2=1.21
r282 (  68 96 ) resistor r=45.1352 //w=0.168 //l=0.173853 //layer=ply \
 //thickness=0.18 //x=1.445 //y=1.21 //x2=1.405 //y2=1.365
r283 (  67 95 ) resistor r=45.1352 //w=0.168 //l=0.173853 //layer=ply \
 //thickness=0.18 //x=1.445 //y=0.865 //x2=1.405 //y2=0.71
r284 (  67 68 ) resistor r=176.904 //w=0.094 //l=0.345 //layer=ply \
 //thickness=0.18 //x=1.445 //y=0.865 //x2=1.445 //y2=1.21
r285 (  65 69 ) resistor r=26.9307 //w=0.15 //l=0.106066 //layer=ply \
 //thickness=0.18 //x=1.375 //y=4.795 //x2=1.45 //y2=4.87
r286 (  65 66 ) resistor r=148.702 //w=0.094 //l=0.29 //layer=ply \
 //thickness=0.18 //x=1.375 //y=4.795 //x2=1.085 //y2=4.795
r287 (  63 94 ) resistor r=10.701 //w=0.21 //l=0.115 //layer=ply \
 //thickness=0.18 //x=1.07 //y=1.365 //x2=0.955 //y2=1.365
r288 (  62 96 ) resistor r=5.52526 //w=0.168 //l=0.115 //layer=ply \
 //thickness=0.18 //x=1.29 //y=1.365 //x2=1.405 //y2=1.365
r289 (  61 93 ) resistor r=5.52526 //w=0.168 //l=0.115 //layer=ply \
 //thickness=0.18 //x=1.07 //y=0.71 //x2=0.955 //y2=0.71
r290 (  60 95 ) resistor r=5.52526 //w=0.168 //l=0.115 //layer=ply \
 //thickness=0.18 //x=1.29 //y=0.71 //x2=1.405 //y2=0.71
r291 (  60 61 ) resistor r=112.809 //w=0.094 //l=0.22 //layer=ply \
 //thickness=0.18 //x=1.29 //y=0.71 //x2=1.07 //y2=0.71
r292 (  57 66 ) resistor r=22.1787 //w=0.252 //l=0.106066 //layer=ply \
 //thickness=0.18 //x=1.01 //y=4.87 //x2=1.085 //y2=4.795
r293 (  57 92 ) resistor r=51.6429 //w=0.252 //l=0.34271 //layer=ply \
 //thickness=0.18 //x=1.01 //y=4.87 //x2=0.74 //y2=4.705
r294 (  56 90 ) resistor r=30.4513 //w=0.277 //l=0.243926 //layer=ply \
 //thickness=0.18 //x=0.915 //y=1.915 //x2=0.74 //y2=2.08
r295 (  55 94 ) resistor r=39.5823 //w=0.21 //l=0.173853 //layer=ply \
 //thickness=0.18 //x=0.915 //y=1.52 //x2=0.955 //y2=1.365
r296 (  55 56 ) resistor r=202.543 //w=0.094 //l=0.395 //layer=ply \
 //thickness=0.18 //x=0.915 //y=1.52 //x2=0.915 //y2=1.915
r297 (  54 94 ) resistor r=39.5823 //w=0.21 //l=0.173853 //layer=ply \
 //thickness=0.18 //x=0.915 //y=1.21 //x2=0.955 //y2=1.365
r298 (  53 93 ) resistor r=45.1352 //w=0.168 //l=0.173853 //layer=ply \
 //thickness=0.18 //x=0.915 //y=0.865 //x2=0.955 //y2=0.71
r299 (  53 54 ) resistor r=176.904 //w=0.094 //l=0.345 //layer=ply \
 //thickness=0.18 //x=0.915 //y=0.865 //x2=0.915 //y2=1.21
r300 (  52 84 ) resistor r=592.245 //w=0.094 //l=1.155 //layer=ply \
 //thickness=0.18 //x=4.77 //y=6.025 //x2=4.77 //y2=4.87
r301 (  51 76 ) resistor r=592.245 //w=0.094 //l=1.155 //layer=ply \
 //thickness=0.18 //x=4.33 //y=6.025 //x2=4.33 //y2=4.87
r302 (  50 69 ) resistor r=592.245 //w=0.094 //l=1.155 //layer=ply \
 //thickness=0.18 //x=1.45 //y=6.025 //x2=1.45 //y2=4.87
r303 (  49 57 ) resistor r=592.245 //w=0.094 //l=1.155 //layer=ply \
 //thickness=0.18 //x=1.01 //y=6.025 //x2=1.01 //y2=4.87
r304 (  48 81 ) resistor r=56.4043 //w=0.094 //l=0.11 //layer=ply \
 //thickness=0.18 //x=4.51 //y=1.365 //x2=4.62 //y2=1.365
r305 (  48 82 ) resistor r=56.4043 //w=0.094 //l=0.11 //layer=ply \
 //thickness=0.18 //x=4.51 //y=1.365 //x2=4.4 //y2=1.365
r306 (  47 62 ) resistor r=56.4043 //w=0.094 //l=0.11 //layer=ply \
 //thickness=0.18 //x=1.18 //y=1.365 //x2=1.29 //y2=1.365
r307 (  47 63 ) resistor r=56.4043 //w=0.094 //l=0.11 //layer=ply \
 //thickness=0.18 //x=1.18 //y=1.365 //x2=1.07 //y2=1.365
r308 (  45 103 ) resistor r=152 //w=0.17 //l=0.17 //layer=licon //count=1 \
 //x=4.44 //y=4.705 //x2=4.44 //y2=4.705
r309 (  42 45 ) resistor r=18.139 //w=0.187 //l=0.265 //layer=li \
 //thickness=0.1 //x=4.44 //y=4.44 //x2=4.44 //y2=4.705
r310 (  37 98 ) resistor r=152 //w=0.17 //l=0.17 //layer=licon //count=1 \
 //x=4.44 //y=2.08 //x2=4.44 //y2=2.08
r311 (  34 92 ) resistor r=152 //w=0.17 //l=0.17 //layer=licon //count=1 \
 //x=0.74 //y=4.705 //x2=0.74 //y2=4.705
r312 (  31 34 ) resistor r=18.139 //w=0.187 //l=0.265 //layer=li \
 //thickness=0.1 //x=0.74 //y=4.44 //x2=0.74 //y2=4.705
r313 (  26 90 ) resistor r=152 //w=0.17 //l=0.17 //layer=licon //count=1 \
 //x=0.74 //y=2.08 //x2=0.74 //y2=2.08
r314 (  22 23 ) resistor r=0.10734 //w=0.281 //l=0.16 //layer=m2 \
 //thickness=0.36 //x=4.445 //y=4.46 //x2=4.285 //y2=4.46
r315 (  17 19 ) resistor r=0.10734 //w=0.281 //l=0.16 //layer=m2 \
 //thickness=0.36 //x=0.905 //y=4.44 //x2=0.745 //y2=4.44
r316 (  17 23 ) resistor r=3.22519 //w=0.131 //l=3.38 //layer=m2 \
 //thickness=0.36 //x=0.905 //y=4.44 //x2=4.285 //y2=4.44
r317 (  15 37 ) resistor r=9.3 //w=0.17 //l=0.17 //layer=mcon //count=1 \
 //x=4.44 //y=2.08 //x2=4.44 //y2=2.08
r318 (  13 22 ) resistor r=4.5 //w=0.15 //l=0.15 //layer=via1 //count=1 \
 //x=4.445 //y=4.46 //x2=4.445 //y2=4.46
r319 (  11 42 ) resistor r=9.3 //w=0.17 //l=0.17 //layer=mcon //count=1 \
 //x=4.44 //y=4.44 //x2=4.44 //y2=4.44
r320 (  11 13 ) resistor r=0.00659631 //w=0.379 //l=0.02 //layer=m1 \
 //thickness=0.36 //x=4.39 //y=4.44 //x2=4.39 //y2=4.46
r321 (  8 31 ) resistor r=9.3 //w=0.17 //l=0.17 //layer=mcon //count=1 \
 //x=0.74 //y=4.44 //x2=0.74 //y2=4.44
r322 (  8 19 ) resistor r=4.5 //w=0.15 //l=0.15 //layer=via1 //count=1 \
 //x=0.745 //y=4.44 //x2=0.745 //y2=4.44
r323 (  6 26 ) resistor r=9.3 //w=0.17 //l=0.17 //layer=mcon //count=1 \
 //x=0.74 //y=2.08 //x2=0.74 //y2=2.08
r324 (  4 11 ) resistor r=0.0863342 //w=0.379 //l=0.168152 //layer=m1 \
 //thickness=0.36 //x=4.44 //y=4.295 //x2=4.39 //y2=4.44
r325 (  3 15 ) resistor r=0.0761125 //w=0.237 //l=0.126491 //layer=m1 \
 //thickness=0.36 //x=4.44 //y=2.205 //x2=4.437 //y2=2.08
r326 (  3 4 ) resistor r=1.99427 //w=0.131 //l=2.09 //layer=m1 \
 //thickness=0.36 //x=4.44 //y=2.205 //x2=4.44 //y2=4.295
r327 (  2 8 ) resistor r=0.0898201 //w=0.322 //l=0.185472 //layer=m1 \
 //thickness=0.36 //x=0.74 //y=4.28 //x2=0.795 //y2=4.44
r328 (  1 6 ) resistor r=0.0717383 //w=0.224 //l=0.115 //layer=m1 \
 //thickness=0.36 //x=0.74 //y=2.195 //x2=0.74 //y2=2.08
r329 (  1 2 ) resistor r=1.9895 //w=0.131 //l=2.085 //layer=m1 \
 //thickness=0.36 //x=0.74 //y=2.195 //x2=0.74 //y2=4.28
ends PM_VOTERN3X1_PCELL\%noxref_1

subckt PM_VOTERN3X1_PCELL\%noxref_2 ( 1 2 3 4 22 24 25 28 33 38 43 47 48 49 50 \
 51 52 56 57 58 59 60 62 65 68 69 70 71 72 73 74 75 79 81 84 85 86 87 100 )
c227 ( 100 0 ) capacitor c=0.0586737f //x=7.4 //y=2.08
c228 ( 87 0 ) capacitor c=0.0318956f //x=8.105 //y=1.21
c229 ( 86 0 ) capacitor c=0.0186809f //x=8.105 //y=0.865
c230 ( 85 0 ) capacitor c=0.0659968f //x=7.745 //y=4.795
c231 ( 84 0 ) capacitor c=0.0373387f //x=8.035 //y=4.795
c232 ( 81 0 ) capacitor c=0.0157936f //x=7.95 //y=1.365
c233 ( 79 0 ) capacitor c=0.0158553f //x=7.95 //y=0.71
c234 ( 75 0 ) capacitor c=0.0302441f //x=7.575 //y=1.915
c235 ( 74 0 ) capacitor c=0.0238107f //x=7.575 //y=1.52
c236 ( 73 0 ) capacitor c=0.0234359f //x=7.575 //y=1.21
c237 ( 72 0 ) capacitor c=0.0199332f //x=7.575 //y=0.865
c238 ( 71 0 ) capacitor c=0.0972519f //x=5.745 //y=1.915
c239 ( 70 0 ) capacitor c=0.0251353f //x=5.745 //y=1.56
c240 ( 69 0 ) capacitor c=0.0234318f //x=5.745 //y=1.25
c241 ( 68 0 ) capacitor c=0.0192547f //x=5.745 //y=0.905
c242 ( 65 0 ) capacitor c=0.0714656f //x=5.65 //y=4.87
c243 ( 62 0 ) capacitor c=0.0186579f //x=5.59 //y=1.405
c244 ( 60 0 ) capacitor c=0.0157803f //x=5.59 //y=0.75
c245 ( 59 0 ) capacitor c=0.0134011f //x=5.285 //y=4.795
c246 ( 58 0 ) capacitor c=0.0243282f //x=5.575 //y=4.795
c247 ( 57 0 ) capacitor c=0.0364928f //x=5.215 //y=1.25
c248 ( 56 0 ) capacitor c=0.0174823f //x=5.215 //y=0.905
c249 ( 52 0 ) capacitor c=0.11081f //x=8.11 //y=6.025
c250 ( 51 0 ) capacitor c=0.154997f //x=7.67 //y=6.025
c251 ( 50 0 ) capacitor c=0.155934f //x=5.65 //y=6.025
c252 ( 49 0 ) capacitor c=0.110594f //x=5.21 //y=6.025
c253 ( 43 0 ) capacitor c=7.79654e-19 //x=7.4 //y=4.705
c254 ( 38 0 ) capacitor c=7.89145e-19 //x=7.4 //y=2.08
c255 ( 33 0 ) capacitor c=7.79197e-19 //x=5.92 //y=4.705
c256 ( 28 0 ) capacitor c=7.43216e-19 //x=5.92 //y=2.08
c257 ( 25 0 ) capacitor c=0.0208894f //x=7.235 //y=2.09
c258 ( 24 0 ) capacitor c=0.00241177f //x=7.395 //y=2.09
c259 ( 22 0 ) capacitor c=0.0031771f //x=6.085 //y=2.09
c260 ( 4 0 ) capacitor c=0.0784278f //x=7.4 //y=4.575
c261 ( 3 0 ) capacitor c=0.00995077f //x=7.4 //y=2.25
c262 ( 2 0 ) capacitor c=0.0865077f //x=5.92 //y=4.58
c263 ( 1 0 ) capacitor c=0.0102822f //x=5.92 //y=2.25
r264 (  87 106 ) resistor r=45.1352 //w=0.168 //l=0.173853 //layer=ply \
 //thickness=0.18 //x=8.105 //y=1.21 //x2=8.065 //y2=1.365
r265 (  86 105 ) resistor r=45.1352 //w=0.168 //l=0.173853 //layer=ply \
 //thickness=0.18 //x=8.105 //y=0.865 //x2=8.065 //y2=0.71
r266 (  86 87 ) resistor r=176.904 //w=0.094 //l=0.345 //layer=ply \
 //thickness=0.18 //x=8.105 //y=0.865 //x2=8.105 //y2=1.21
r267 (  84 88 ) resistor r=26.9307 //w=0.15 //l=0.106066 //layer=ply \
 //thickness=0.18 //x=8.035 //y=4.795 //x2=8.11 //y2=4.87
r268 (  84 85 ) resistor r=148.702 //w=0.094 //l=0.29 //layer=ply \
 //thickness=0.18 //x=8.035 //y=4.795 //x2=7.745 //y2=4.795
r269 (  82 104 ) resistor r=10.701 //w=0.21 //l=0.115 //layer=ply \
 //thickness=0.18 //x=7.73 //y=1.365 //x2=7.615 //y2=1.365
r270 (  81 106 ) resistor r=5.52526 //w=0.168 //l=0.115 //layer=ply \
 //thickness=0.18 //x=7.95 //y=1.365 //x2=8.065 //y2=1.365
r271 (  80 103 ) resistor r=5.52526 //w=0.168 //l=0.115 //layer=ply \
 //thickness=0.18 //x=7.73 //y=0.71 //x2=7.615 //y2=0.71
r272 (  79 105 ) resistor r=5.52526 //w=0.168 //l=0.115 //layer=ply \
 //thickness=0.18 //x=7.95 //y=0.71 //x2=8.065 //y2=0.71
r273 (  79 80 ) resistor r=112.809 //w=0.094 //l=0.22 //layer=ply \
 //thickness=0.18 //x=7.95 //y=0.71 //x2=7.73 //y2=0.71
r274 (  76 85 ) resistor r=22.1787 //w=0.252 //l=0.106066 //layer=ply \
 //thickness=0.18 //x=7.67 //y=4.87 //x2=7.745 //y2=4.795
r275 (  76 102 ) resistor r=51.6429 //w=0.252 //l=0.34271 //layer=ply \
 //thickness=0.18 //x=7.67 //y=4.87 //x2=7.4 //y2=4.705
r276 (  75 100 ) resistor r=30.4513 //w=0.277 //l=0.243926 //layer=ply \
 //thickness=0.18 //x=7.575 //y=1.915 //x2=7.4 //y2=2.08
r277 (  74 104 ) resistor r=39.5823 //w=0.21 //l=0.173853 //layer=ply \
 //thickness=0.18 //x=7.575 //y=1.52 //x2=7.615 //y2=1.365
r278 (  74 75 ) resistor r=202.543 //w=0.094 //l=0.395 //layer=ply \
 //thickness=0.18 //x=7.575 //y=1.52 //x2=7.575 //y2=1.915
r279 (  73 104 ) resistor r=39.5823 //w=0.21 //l=0.173853 //layer=ply \
 //thickness=0.18 //x=7.575 //y=1.21 //x2=7.615 //y2=1.365
r280 (  72 103 ) resistor r=45.1352 //w=0.168 //l=0.173853 //layer=ply \
 //thickness=0.18 //x=7.575 //y=0.865 //x2=7.615 //y2=0.71
r281 (  72 73 ) resistor r=176.904 //w=0.094 //l=0.345 //layer=ply \
 //thickness=0.18 //x=7.575 //y=0.865 //x2=7.575 //y2=1.21
r282 (  71 96 ) resistor r=30.4513 //w=0.277 //l=0.243926 //layer=ply \
 //thickness=0.18 //x=5.745 //y=1.915 //x2=5.92 //y2=2.08
r283 (  70 94 ) resistor r=39.5823 //w=0.21 //l=0.173853 //layer=ply \
 //thickness=0.18 //x=5.745 //y=1.56 //x2=5.705 //y2=1.405
r284 (  70 71 ) resistor r=182.032 //w=0.094 //l=0.355 //layer=ply \
 //thickness=0.18 //x=5.745 //y=1.56 //x2=5.745 //y2=1.915
r285 (  69 94 ) resistor r=39.5823 //w=0.21 //l=0.173853 //layer=ply \
 //thickness=0.18 //x=5.745 //y=1.25 //x2=5.705 //y2=1.405
r286 (  68 93 ) resistor r=45.1352 //w=0.168 //l=0.173853 //layer=ply \
 //thickness=0.18 //x=5.745 //y=0.905 //x2=5.705 //y2=0.75
r287 (  68 69 ) resistor r=176.904 //w=0.094 //l=0.345 //layer=ply \
 //thickness=0.18 //x=5.745 //y=0.905 //x2=5.745 //y2=1.25
r288 (  65 98 ) resistor r=51.6429 //w=0.252 //l=0.34271 //layer=ply \
 //thickness=0.18 //x=5.65 //y=4.87 //x2=5.92 //y2=4.705
r289 (  63 92 ) resistor r=5.52526 //w=0.168 //l=0.115 //layer=ply \
 //thickness=0.18 //x=5.37 //y=1.405 //x2=5.255 //y2=1.405
r290 (  62 94 ) resistor r=10.701 //w=0.21 //l=0.115 //layer=ply \
 //thickness=0.18 //x=5.59 //y=1.405 //x2=5.705 //y2=1.405
r291 (  61 91 ) resistor r=5.52526 //w=0.168 //l=0.115 //layer=ply \
 //thickness=0.18 //x=5.37 //y=0.75 //x2=5.255 //y2=0.75
r292 (  60 93 ) resistor r=5.52526 //w=0.168 //l=0.115 //layer=ply \
 //thickness=0.18 //x=5.59 //y=0.75 //x2=5.705 //y2=0.75
r293 (  60 61 ) resistor r=112.809 //w=0.094 //l=0.22 //layer=ply \
 //thickness=0.18 //x=5.59 //y=0.75 //x2=5.37 //y2=0.75
r294 (  58 65 ) resistor r=22.1787 //w=0.252 //l=0.106066 //layer=ply \
 //thickness=0.18 //x=5.575 //y=4.795 //x2=5.65 //y2=4.87
r295 (  58 59 ) resistor r=148.702 //w=0.094 //l=0.29 //layer=ply \
 //thickness=0.18 //x=5.575 //y=4.795 //x2=5.285 //y2=4.795
r296 (  57 92 ) resistor r=45.1352 //w=0.168 //l=0.173853 //layer=ply \
 //thickness=0.18 //x=5.215 //y=1.25 //x2=5.255 //y2=1.405
r297 (  56 91 ) resistor r=45.1352 //w=0.168 //l=0.173853 //layer=ply \
 //thickness=0.18 //x=5.215 //y=0.905 //x2=5.255 //y2=0.75
r298 (  56 57 ) resistor r=176.904 //w=0.094 //l=0.345 //layer=ply \
 //thickness=0.18 //x=5.215 //y=0.905 //x2=5.215 //y2=1.25
r299 (  53 59 ) resistor r=26.9307 //w=0.15 //l=0.106066 //layer=ply \
 //thickness=0.18 //x=5.21 //y=4.87 //x2=5.285 //y2=4.795
r300 (  52 88 ) resistor r=592.245 //w=0.094 //l=1.155 //layer=ply \
 //thickness=0.18 //x=8.11 //y=6.025 //x2=8.11 //y2=4.87
r301 (  51 76 ) resistor r=592.245 //w=0.094 //l=1.155 //layer=ply \
 //thickness=0.18 //x=7.67 //y=6.025 //x2=7.67 //y2=4.87
r302 (  50 65 ) resistor r=592.245 //w=0.094 //l=1.155 //layer=ply \
 //thickness=0.18 //x=5.65 //y=6.025 //x2=5.65 //y2=4.87
r303 (  49 53 ) resistor r=592.245 //w=0.094 //l=1.155 //layer=ply \
 //thickness=0.18 //x=5.21 //y=6.025 //x2=5.21 //y2=4.87
r304 (  48 81 ) resistor r=56.4043 //w=0.094 //l=0.11 //layer=ply \
 //thickness=0.18 //x=7.84 //y=1.365 //x2=7.95 //y2=1.365
r305 (  48 82 ) resistor r=56.4043 //w=0.094 //l=0.11 //layer=ply \
 //thickness=0.18 //x=7.84 //y=1.365 //x2=7.73 //y2=1.365
r306 (  47 62 ) resistor r=56.4043 //w=0.094 //l=0.11 //layer=ply \
 //thickness=0.18 //x=5.48 //y=1.405 //x2=5.59 //y2=1.405
r307 (  47 63 ) resistor r=56.4043 //w=0.094 //l=0.11 //layer=ply \
 //thickness=0.18 //x=5.48 //y=1.405 //x2=5.37 //y2=1.405
r308 (  43 102 ) resistor r=152 //w=0.17 //l=0.17 //layer=licon //count=1 \
 //x=7.4 //y=4.705 //x2=7.4 //y2=4.705
r309 (  38 100 ) resistor r=152 //w=0.17 //l=0.17 //layer=licon //count=1 \
 //x=7.4 //y=2.08 //x2=7.4 //y2=2.08
r310 (  33 98 ) resistor r=152 //w=0.17 //l=0.17 //layer=licon //count=1 \
 //x=5.92 //y=4.705 //x2=5.92 //y2=4.705
r311 (  28 96 ) resistor r=152 //w=0.17 //l=0.17 //layer=licon //count=1 \
 //x=5.92 //y=2.08 //x2=5.92 //y2=2.08
r312 (  24 25 ) resistor r=0.10734 //w=0.281 //l=0.16 //layer=m2 \
 //thickness=0.36 //x=7.395 //y=2.09 //x2=7.235 //y2=2.09
r313 (  22 25 ) resistor r=1.09733 //w=0.131 //l=1.15 //layer=m2 \
 //thickness=0.36 //x=6.085 //y=2.08 //x2=7.235 //y2=2.08
r314 (  20 22 ) resistor r=0.10734 //w=0.281 //l=0.16 //layer=m2 \
 //thickness=0.36 //x=5.925 //y=2.09 //x2=6.085 //y2=2.09
r315 (  16 43 ) resistor r=9.3 //w=0.17 //l=0.17 //layer=mcon //count=1 \
 //x=7.4 //y=4.705 //x2=7.4 //y2=4.705
r316 (  14 24 ) resistor r=4.5 //w=0.15 //l=0.15 //layer=via1 //count=1 \
 //x=7.395 //y=2.09 //x2=7.395 //y2=2.09
r317 (  12 38 ) resistor r=9.3 //w=0.17 //l=0.17 //layer=mcon //count=1 \
 //x=7.4 //y=2.08 //x2=7.4 //y2=2.08
r318 (  12 14 ) resistor r=0.00334225 //w=0.374 //l=0.01 //layer=m1 \
 //thickness=0.36 //x=7.345 //y=2.08 //x2=7.345 //y2=2.09
r319 (  10 20 ) resistor r=4.5 //w=0.15 //l=0.15 //layer=via1 //count=1 \
 //x=5.925 //y=2.09 //x2=5.925 //y2=2.09
r320 (  8 28 ) resistor r=9.3 //w=0.17 //l=0.17 //layer=mcon //count=1 \
 //x=5.92 //y=2.08 //x2=5.92 //y2=2.08
r321 (  8 10 ) resistor r=0.00334225 //w=0.374 //l=0.01 //layer=m1 \
 //thickness=0.36 //x=5.975 //y=2.08 //x2=5.975 //y2=2.09
r322 (  6 33 ) resistor r=9.3 //w=0.17 //l=0.17 //layer=mcon //count=1 \
 //x=5.92 //y=4.705 //x2=5.92 //y2=4.705
r323 (  4 16 ) resistor r=0.0777782 //w=0.252 //l=0.131491 //layer=m1 \
 //thickness=0.36 //x=7.4 //y=4.575 //x2=7.397 //y2=4.705
r324 (  3 14 ) resistor r=0.0910802 //w=0.374 //l=0.185472 //layer=m1 \
 //thickness=0.36 //x=7.4 //y=2.25 //x2=7.345 //y2=2.09
r325 (  3 4 ) resistor r=2.21851 //w=0.131 //l=2.325 //layer=m1 \
 //thickness=0.36 //x=7.4 //y=2.25 //x2=7.4 //y2=4.575
r326 (  2 6 ) resistor r=0.075298 //w=0.252 //l=0.125 //layer=m1 \
 //thickness=0.36 //x=5.92 //y=4.58 //x2=5.92 //y2=4.705
r327 (  1 10 ) resistor r=0.0910802 //w=0.374 //l=0.185472 //layer=m1 \
 //thickness=0.36 //x=5.92 //y=2.25 //x2=5.975 //y2=2.09
r328 (  1 2 ) resistor r=2.22328 //w=0.131 //l=2.33 //layer=m1 \
 //thickness=0.36 //x=5.92 //y=2.25 //x2=5.92 //y2=4.58
ends PM_VOTERN3X1_PCELL\%noxref_2

subckt PM_VOTERN3X1_PCELL\%noxref_3 ( 1 2 3 4 5 6 7 8 16 20 30 32 33 36 45 50 \
 59 63 64 65 66 67 68 69 70 71 76 78 80 86 87 88 89 90 95 97 99 105 106 108 \
 109 112 120 121 124 )
c277 ( 124 0 ) capacitor c=0.0370698f //x=8.53 //y=4.705
c278 ( 121 0 ) capacitor c=0.030265f //x=8.51 //y=1.915
c279 ( 120 0 ) capacitor c=0.0512002f //x=8.51 //y=2.08
c280 ( 112 0 ) capacitor c=0.0387879f //x=1.89 //y=4.705
c281 ( 109 0 ) capacitor c=0.0300885f //x=1.85 //y=1.915
c282 ( 108 0 ) capacitor c=0.0554483f //x=1.85 //y=2.08
c283 ( 106 0 ) capacitor c=0.0237734f //x=9.075 //y=1.255
c284 ( 105 0 ) capacitor c=0.0191782f //x=9.075 //y=0.905
c285 ( 99 0 ) capacitor c=0.0361171f //x=8.92 //y=1.405
c286 ( 97 0 ) capacitor c=0.0157803f //x=8.92 //y=0.75
c287 ( 95 0 ) capacitor c=0.0376354f //x=8.915 //y=4.795
c288 ( 90 0 ) capacitor c=0.020493f //x=8.545 //y=1.56
c289 ( 89 0 ) capacitor c=0.0167049f //x=8.545 //y=1.255
c290 ( 88 0 ) capacitor c=0.0174993f //x=8.545 //y=0.905
c291 ( 87 0 ) capacitor c=0.0443648f //x=2.415 //y=1.25
c292 ( 86 0 ) capacitor c=0.0192211f //x=2.415 //y=0.905
c293 ( 80 0 ) capacitor c=0.0186579f //x=2.26 //y=1.405
c294 ( 78 0 ) capacitor c=0.0157795f //x=2.26 //y=0.75
c295 ( 76 0 ) capacitor c=0.0351351f //x=2.255 //y=4.795
c296 ( 71 0 ) capacitor c=0.0209124f //x=1.885 //y=1.56
c297 ( 70 0 ) capacitor c=0.016848f //x=1.885 //y=1.25
c298 ( 69 0 ) capacitor c=0.0174777f //x=1.885 //y=0.905
c299 ( 68 0 ) capacitor c=0.155887f //x=8.99 //y=6.025
c300 ( 67 0 ) capacitor c=0.1106f //x=8.55 //y=6.025
c301 ( 66 0 ) capacitor c=0.154859f //x=2.33 //y=6.025
c302 ( 65 0 ) capacitor c=0.110573f //x=1.89 //y=6.025
c303 ( 59 0 ) capacitor c=8.10708e-19 //x=8.53 //y=4.705
c304 ( 50 0 ) capacitor c=0.00105273f //x=8.51 //y=2.08
c305 ( 45 0 ) capacitor c=0.00155307f //x=1.89 //y=4.705
c306 ( 36 0 ) capacitor c=0.00152737f //x=1.85 //y=2.08
c307 ( 33 0 ) capacitor c=0.208122f //x=8.365 //y=4.03
c308 ( 32 0 ) capacitor c=0.00479868f //x=8.525 //y=4.03
c309 ( 30 0 ) capacitor c=0.00579767f //x=2.01 //y=4.025
c310 ( 20 0 ) capacitor c=0.0148587f //x=8.51 //y=4.07
c311 ( 16 0 ) capacitor c=0.0153807f //x=1.85 //y=4.07
c312 ( 8 0 ) capacitor c=0.0124358f //x=8.51 //y=4.56
c313 ( 7 0 ) capacitor c=0.0110536f //x=8.51 //y=4.19
c314 ( 6 0 ) capacitor c=0.0499737f //x=8.51 //y=3.87
c315 ( 5 0 ) capacitor c=0.00651439f //x=8.51 //y=2.2
c316 ( 4 0 ) capacitor c=0.0189667f //x=1.85 //y=4.53
c317 ( 3 0 ) capacitor c=0.0126227f //x=1.85 //y=4.185
c318 ( 2 0 ) capacitor c=0.0685407f //x=1.85 //y=3.865
c319 ( 1 0 ) capacitor c=0.00920415f //x=1.85 //y=2.195
r320 (  126 127 ) resistor r=32.4568 //w=0.214 //l=0.075 //layer=ply \
 //thickness=0.18 //x=8.53 //y=4.795 //x2=8.53 //y2=4.87
r321 (  124 126 ) resistor r=20.271 //w=0.214 //l=0.09 //layer=ply \
 //thickness=0.18 //x=8.53 //y=4.705 //x2=8.53 //y2=4.795
r322 (  120 121 ) resistor r=52.7279 //w=0.214 //l=0.165 //layer=ply \
 //thickness=0.18 //x=8.51 //y=2.08 //x2=8.51 //y2=1.915
r323 (  112 114 ) resistor r=20.271 //w=0.214 //l=0.09 //layer=ply \
 //thickness=0.18 //x=1.89 //y=4.705 //x2=1.89 //y2=4.795
r324 (  108 109 ) resistor r=52.7279 //w=0.214 //l=0.165 //layer=ply \
 //thickness=0.18 //x=1.85 //y=2.08 //x2=1.85 //y2=1.915
r325 (  106 131 ) resistor r=4.95774 //w=0.164 //l=0.112 //layer=ply \
 //thickness=0.18 //x=9.075 //y=1.255 //x2=9.075 //y2=1.367
r326 (  105 130 ) resistor r=45.1352 //w=0.168 //l=0.173853 //layer=ply \
 //thickness=0.18 //x=9.075 //y=0.905 //x2=9.035 //y2=0.75
r327 (  105 106 ) resistor r=179.468 //w=0.094 //l=0.35 //layer=ply \
 //thickness=0.18 //x=9.075 //y=0.905 //x2=9.075 //y2=1.255
r328 (  100 129 ) resistor r=10.8103 //w=0.211 //l=0.115 //layer=ply \
 //thickness=0.18 //x=8.7 //y=1.405 //x2=8.585 //y2=1.405
r329 (  99 131 ) resistor r=45.9962 //w=0.164 //l=0.17296 //layer=ply \
 //thickness=0.18 //x=8.92 //y=1.405 //x2=9.075 //y2=1.367
r330 (  98 128 ) resistor r=5.52526 //w=0.168 //l=0.115 //layer=ply \
 //thickness=0.18 //x=8.7 //y=0.75 //x2=8.585 //y2=0.75
r331 (  97 130 ) resistor r=5.52526 //w=0.168 //l=0.115 //layer=ply \
 //thickness=0.18 //x=8.92 //y=0.75 //x2=9.035 //y2=0.75
r332 (  97 98 ) resistor r=112.809 //w=0.094 //l=0.22 //layer=ply \
 //thickness=0.18 //x=8.92 //y=0.75 //x2=8.7 //y2=0.75
r333 (  96 126 ) resistor r=16.5046 //w=0.27 //l=0.135 //layer=ply \
 //thickness=0.18 //x=8.665 //y=4.795 //x2=8.53 //y2=4.795
r334 (  95 102 ) resistor r=26.9307 //w=0.15 //l=0.106066 //layer=ply \
 //thickness=0.18 //x=8.915 //y=4.795 //x2=8.99 //y2=4.87
r335 (  95 96 ) resistor r=128.191 //w=0.094 //l=0.25 //layer=ply \
 //thickness=0.18 //x=8.915 //y=4.795 //x2=8.665 //y2=4.795
r336 (  90 129 ) resistor r=39.5036 //w=0.211 //l=0.173853 //layer=ply \
 //thickness=0.18 //x=8.545 //y=1.56 //x2=8.585 //y2=1.405
r337 (  90 121 ) resistor r=182.032 //w=0.094 //l=0.355 //layer=ply \
 //thickness=0.18 //x=8.545 //y=1.56 //x2=8.545 //y2=1.915
r338 (  89 129 ) resistor r=38.3614 //w=0.211 //l=0.168819 //layer=ply \
 //thickness=0.18 //x=8.545 //y=1.255 //x2=8.585 //y2=1.405
r339 (  88 128 ) resistor r=45.1352 //w=0.168 //l=0.173853 //layer=ply \
 //thickness=0.18 //x=8.545 //y=0.905 //x2=8.585 //y2=0.75
r340 (  88 89 ) resistor r=179.468 //w=0.094 //l=0.35 //layer=ply \
 //thickness=0.18 //x=8.545 //y=0.905 //x2=8.545 //y2=1.255
r341 (  87 118 ) resistor r=45.1352 //w=0.168 //l=0.173853 //layer=ply \
 //thickness=0.18 //x=2.415 //y=1.25 //x2=2.375 //y2=1.405
r342 (  86 117 ) resistor r=45.1352 //w=0.168 //l=0.173853 //layer=ply \
 //thickness=0.18 //x=2.415 //y=0.905 //x2=2.375 //y2=0.75
r343 (  86 87 ) resistor r=176.904 //w=0.094 //l=0.345 //layer=ply \
 //thickness=0.18 //x=2.415 //y=0.905 //x2=2.415 //y2=1.25
r344 (  81 116 ) resistor r=10.701 //w=0.21 //l=0.115 //layer=ply \
 //thickness=0.18 //x=2.04 //y=1.405 //x2=1.925 //y2=1.405
r345 (  80 118 ) resistor r=5.52526 //w=0.168 //l=0.115 //layer=ply \
 //thickness=0.18 //x=2.26 //y=1.405 //x2=2.375 //y2=1.405
r346 (  79 115 ) resistor r=5.52526 //w=0.168 //l=0.115 //layer=ply \
 //thickness=0.18 //x=2.04 //y=0.75 //x2=1.925 //y2=0.75
r347 (  78 117 ) resistor r=5.52526 //w=0.168 //l=0.115 //layer=ply \
 //thickness=0.18 //x=2.26 //y=0.75 //x2=2.375 //y2=0.75
r348 (  78 79 ) resistor r=112.809 //w=0.094 //l=0.22 //layer=ply \
 //thickness=0.18 //x=2.26 //y=0.75 //x2=2.04 //y2=0.75
r349 (  77 114 ) resistor r=16.5046 //w=0.27 //l=0.135 //layer=ply \
 //thickness=0.18 //x=2.025 //y=4.795 //x2=1.89 //y2=4.795
r350 (  76 83 ) resistor r=26.9307 //w=0.15 //l=0.106066 //layer=ply \
 //thickness=0.18 //x=2.255 //y=4.795 //x2=2.33 //y2=4.87
r351 (  76 77 ) resistor r=117.936 //w=0.094 //l=0.23 //layer=ply \
 //thickness=0.18 //x=2.255 //y=4.795 //x2=2.025 //y2=4.795
r352 (  73 114 ) resistor r=32.4568 //w=0.214 //l=0.075 //layer=ply \
 //thickness=0.18 //x=1.89 //y=4.87 //x2=1.89 //y2=4.795
r353 (  71 116 ) resistor r=39.5823 //w=0.21 //l=0.173853 //layer=ply \
 //thickness=0.18 //x=1.885 //y=1.56 //x2=1.925 //y2=1.405
r354 (  71 109 ) resistor r=182.032 //w=0.094 //l=0.355 //layer=ply \
 //thickness=0.18 //x=1.885 //y=1.56 //x2=1.885 //y2=1.915
r355 (  70 116 ) resistor r=39.5823 //w=0.21 //l=0.173853 //layer=ply \
 //thickness=0.18 //x=1.885 //y=1.25 //x2=1.925 //y2=1.405
r356 (  69 115 ) resistor r=45.1352 //w=0.168 //l=0.173853 //layer=ply \
 //thickness=0.18 //x=1.885 //y=0.905 //x2=1.925 //y2=0.75
r357 (  69 70 ) resistor r=176.904 //w=0.094 //l=0.345 //layer=ply \
 //thickness=0.18 //x=1.885 //y=0.905 //x2=1.885 //y2=1.25
r358 (  68 102 ) resistor r=592.245 //w=0.094 //l=1.155 //layer=ply \
 //thickness=0.18 //x=8.99 //y=6.025 //x2=8.99 //y2=4.87
r359 (  67 127 ) resistor r=592.245 //w=0.094 //l=1.155 //layer=ply \
 //thickness=0.18 //x=8.55 //y=6.025 //x2=8.55 //y2=4.87
r360 (  66 83 ) resistor r=592.245 //w=0.094 //l=1.155 //layer=ply \
 //thickness=0.18 //x=2.33 //y=6.025 //x2=2.33 //y2=4.87
r361 (  65 73 ) resistor r=592.245 //w=0.094 //l=1.155 //layer=ply \
 //thickness=0.18 //x=1.89 //y=6.025 //x2=1.89 //y2=4.87
r362 (  64 99 ) resistor r=56.4043 //w=0.094 //l=0.11 //layer=ply \
 //thickness=0.18 //x=8.81 //y=1.405 //x2=8.92 //y2=1.405
r363 (  64 100 ) resistor r=56.4043 //w=0.094 //l=0.11 //layer=ply \
 //thickness=0.18 //x=8.81 //y=1.405 //x2=8.7 //y2=1.405
r364 (  63 80 ) resistor r=56.4043 //w=0.094 //l=0.11 //layer=ply \
 //thickness=0.18 //x=2.15 //y=1.405 //x2=2.26 //y2=1.405
r365 (  63 81 ) resistor r=56.4043 //w=0.094 //l=0.11 //layer=ply \
 //thickness=0.18 //x=2.15 //y=1.405 //x2=2.04 //y2=1.405
r366 (  59 124 ) resistor r=152 //w=0.17 //l=0.17 //layer=licon //count=1 \
 //x=8.53 //y=4.705 //x2=8.53 //y2=4.705
r367 (  50 120 ) resistor r=152 //w=0.17 //l=0.17 //layer=licon //count=1 \
 //x=8.51 //y=2.08 //x2=8.51 //y2=2.08
r368 (  45 112 ) resistor r=152 //w=0.17 //l=0.17 //layer=licon //count=1 \
 //x=1.89 //y=4.705 //x2=1.89 //y2=4.705
r369 (  36 108 ) resistor r=152 //w=0.17 //l=0.17 //layer=licon //count=1 \
 //x=1.85 //y=2.08 //x2=1.85 //y2=2.08
r370 (  32 33 ) resistor r=0.104807 //w=0.281 //l=0.16 //layer=m2 \
 //thickness=0.36 //x=8.525 //y=4.03 //x2=8.365 //y2=4.03
r371 (  30 33 ) resistor r=5.84099 //w=0.136 //l=6.355 //layer=m2 \
 //thickness=0.36 //x=2.01 //y=4.072 //x2=8.365 //y2=4.072
r372 (  28 30 ) resistor r=0.104807 //w=0.281 //l=0.16 //layer=m2 \
 //thickness=0.36 //x=1.85 //y=4.025 //x2=2.01 //y2=4.025
r373 (  24 59 ) resistor r=9.3 //w=0.17 //l=0.17 //layer=mcon //count=1 \
 //x=8.53 //y=4.705 //x2=8.53 //y2=4.705
r374 (  22 50 ) resistor r=9.3 //w=0.17 //l=0.17 //layer=mcon //count=1 \
 //x=8.51 //y=2.08 //x2=8.51 //y2=2.08
r375 (  18 32 ) resistor r=4.5 //w=0.15 //l=0.15 //layer=via1 //count=1 \
 //x=8.525 //y=4.03 //x2=8.525 //y2=4.03
r376 (  18 20 ) resistor r=0.0130208 //w=0.384 //l=0.04 //layer=m1 \
 //thickness=0.36 //x=8.465 //y=4.03 //x2=8.465 //y2=4.07
r377 (  14 28 ) resistor r=4.5 //w=0.15 //l=0.15 //layer=via1 //count=1 \
 //x=1.85 //y=4.025 //x2=1.85 //y2=4.025
r378 (  14 16 ) resistor r=0.0149601 //w=0.376 //l=0.045 //layer=m1 \
 //thickness=0.36 //x=1.902 //y=4.025 //x2=1.902 //y2=4.07
r379 (  12 45 ) resistor r=9.3 //w=0.17 //l=0.17 //layer=mcon //count=1 \
 //x=1.89 //y=4.705 //x2=1.89 //y2=4.705
r380 (  10 36 ) resistor r=9.3 //w=0.17 //l=0.17 //layer=mcon //count=1 \
 //x=1.85 //y=2.08 //x2=1.85 //y2=2.08
r381 (  8 24 ) resistor r=0.0893515 //w=0.219 //l=0.154677 //layer=m1 \
 //thickness=0.36 //x=8.51 //y=4.56 //x2=8.53 //y2=4.705
r382 (  7 20 ) resistor r=0.0784723 //w=0.384 //l=0.140712 //layer=m1 \
 //thickness=0.36 //x=8.51 //y=4.19 //x2=8.465 //y2=4.07
r383 (  7 8 ) resistor r=0.353053 //w=0.131 //l=0.37 //layer=m1 \
 //thickness=0.36 //x=8.51 //y=4.19 //x2=8.51 //y2=4.56
r384 (  6 18 ) resistor r=0.0914932 //w=0.384 //l=0.181108 //layer=m1 \
 //thickness=0.36 //x=8.51 //y=3.87 //x2=8.465 //y2=4.03
r385 (  5 22 ) resistor r=0.0744285 //w=0.225 //l=0.12 //layer=m1 \
 //thickness=0.36 //x=8.51 //y=2.2 //x2=8.51 //y2=2.08
r386 (  5 6 ) resistor r=1.59351 //w=0.131 //l=1.67 //layer=m1 \
 //thickness=0.36 //x=8.51 //y=2.2 //x2=8.51 //y2=3.87
r387 (  4 12 ) resistor r=0.100665 //w=0.248 //l=0.193972 //layer=m1 \
 //thickness=0.36 //x=1.85 //y=4.53 //x2=1.89 //y2=4.705
r388 (  3 16 ) resistor r=0.0761992 //w=0.376 //l=0.138582 //layer=m1 \
 //thickness=0.36 //x=1.85 //y=4.185 //x2=1.902 //y2=4.07
r389 (  3 4 ) resistor r=0.329198 //w=0.131 //l=0.345 //layer=m1 \
 //thickness=0.36 //x=1.85 //y=4.185 //x2=1.85 //y2=4.53
r390 (  2 14 ) resistor r=0.0911593 //w=0.376 //l=0.184174 //layer=m1 \
 //thickness=0.36 //x=1.85 //y=3.865 //x2=1.902 //y2=4.025
r391 (  1 10 ) resistor r=0.0717383 //w=0.224 //l=0.115 //layer=m1 \
 //thickness=0.36 //x=1.85 //y=2.195 //x2=1.85 //y2=2.08
r392 (  1 2 ) resistor r=1.59351 //w=0.131 //l=1.67 //layer=m1 \
 //thickness=0.36 //x=1.85 //y=2.195 //x2=1.85 //y2=3.865
ends PM_VOTERN3X1_PCELL\%noxref_3

subckt PM_VOTERN3X1_PCELL\%noxref_4 ( 1 3 4 5 7 8 10 12 16 19 22 36 39 40 42 \
 43 52 60 77 78 79 83 84 )
c204 ( 79 0 ) capacitor c=0.009897f //x=8.62 //y=0.905
c205 ( 78 0 ) capacitor c=0.0110388f //x=5.29 //y=0.905
c206 ( 77 0 ) capacitor c=0.0110842f //x=1.96 //y=0.905
c207 ( 60 0 ) capacitor c=0.0265472f //x=8.77 //y=5.38
c208 ( 52 0 ) capacitor c=0.0232072f //x=7.89 //y=5.38
c209 ( 43 0 ) capacitor c=0.0867005f //x=8.645 //y=1.225
c210 ( 42 0 ) capacitor c=0.0257508f //x=8.805 //y=1.225
c211 ( 40 0 ) capacitor c=0.0121686f //x=5.61 //y=1.225
c212 ( 39 0 ) capacitor c=0.125226f //x=5.35 //y=1.225
c213 ( 36 0 ) capacitor c=0.00933361f //x=2.315 //y=1.225
c214 ( 22 0 ) capacitor c=0.01557f //x=8.767 //y=5.21
c215 ( 19 0 ) capacitor c=0.0155006f //x=7.89 //y=5.21
c216 ( 16 0 ) capacitor c=0.0087298f //x=5.48 //y=1.18
c217 ( 12 0 ) capacitor c=0.00730171f //x=2.15 //y=1.18
c218 ( 10 0 ) capacitor c=0.133093f //x=9.25 //y=5.125
c219 ( 8 0 ) capacitor c=0.00834076f //x=8.895 //y=1.645
c220 ( 7 0 ) capacitor c=0.0162177f //x=9.165 //y=1.645
c221 ( 5 0 ) capacitor c=0.0128896f //x=9.165 //y=5.21
c222 ( 4 0 ) capacitor c=0.00871794f //x=8.81 //y=1.56
c223 ( 3 0 ) capacitor c=0.00698506f //x=8.81 //y=1.355
c224 ( 1 0 ) capacitor c=0.0116295f //x=8.645 //y=5.21
r225 (  76 77 ) resistor r=13.3953 //w=0.172 //l=0.18 //layer=li \
 //thickness=0.1 //x=2.147 //y=1.18 //x2=2.147 //y2=1
r226 (  71 79 ) resistor r=12.3209 //w=0.187 //l=0.18 //layer=li \
 //thickness=0.1 //x=8.81 //y=1.18 //x2=8.81 //y2=1
r227 (  60 84 ) resistor r=23.2727 //w=0.187 //l=0.34 //layer=li \
 //thickness=0.1 //x=8.77 //y=5.38 //x2=8.77 //y2=5.72
r228 (  52 83 ) resistor r=23.2727 //w=0.187 //l=0.34 //layer=li \
 //thickness=0.1 //x=7.89 //y=5.38 //x2=7.89 //y2=5.72
r229 (  49 78 ) resistor r=12.3209 //w=0.187 //l=0.18 //layer=li \
 //thickness=0.1 //x=5.48 //y=1.18 //x2=5.48 //y2=1
r230 (  42 43 ) resistor r=0.10734 //w=0.281 //l=0.16 //layer=m2 \
 //thickness=0.36 //x=8.805 //y=1.225 //x2=8.645 //y2=1.225
r231 (  40 43 ) resistor r=2.89599 //w=0.131 //l=3.035 //layer=m2 \
 //thickness=0.36 //x=5.61 //y=1.18 //x2=8.645 //y2=1.18
r232 (  38 40 ) resistor r=0.0942778 //w=0.221 //l=0.13 //layer=m2 \
 //thickness=0.36 //x=5.48 //y=1.225 //x2=5.61 //y2=1.225
r233 (  38 39 ) resistor r=0.0942778 //w=0.221 //l=0.13 //layer=m2 \
 //thickness=0.36 //x=5.48 //y=1.225 //x2=5.35 //y2=1.225
r234 (  36 39 ) resistor r=2.89599 //w=0.131 //l=3.035 //layer=m2 \
 //thickness=0.36 //x=2.315 //y=1.18 //x2=5.35 //y2=1.18
r235 (  34 36 ) resistor r=0.10734 //w=0.281 //l=0.16 //layer=m2 \
 //thickness=0.36 //x=2.155 //y=1.225 //x2=2.315 //y2=1.225
r236 (  28 42 ) resistor r=4.5 //w=0.15 //l=0.15 //layer=via1 //count=1 \
 //x=8.805 //y=1.225 //x2=8.805 //y2=1.225
r237 (  26 71 ) resistor r=9.3 //w=0.17 //l=0.17 //layer=mcon //count=1 \
 //x=8.81 //y=1.18 //x2=8.81 //y2=1.18
r238 (  26 28 ) resistor r=0.0163043 //w=0.345 //l=0.045 //layer=m1 \
 //thickness=0.36 //x=8.75 //y=1.18 //x2=8.75 //y2=1.225
r239 (  24 60 ) resistor r=9.3 //w=0.17 //l=0.17 //layer=mcon //count=1 \
 //x=8.77 //y=5.38 //x2=8.77 //y2=5.38
r240 (  22 24 ) resistor r=0.0944444 //w=0.225 //l=0.17 //layer=m1 \
 //thickness=0.36 //x=8.767 //y=5.21 //x2=8.767 //y2=5.38
r241 (  21 52 ) resistor r=9.3 //w=0.17 //l=0.17 //layer=mcon //count=1 \
 //x=7.89 //y=5.38 //x2=7.89 //y2=5.38
r242 (  19 21 ) resistor r=0.0936123 //w=0.227 //l=0.17 //layer=m1 \
 //thickness=0.36 //x=7.89 //y=5.21 //x2=7.89 //y2=5.38
r243 (  18 38 ) resistor r=4.5 //w=0.15 //l=0.15 //layer=via1 //count=1 \
 //x=5.48 //y=1.225 //x2=5.48 //y2=1.225
r244 (  16 49 ) resistor r=9.3 //w=0.17 //l=0.17 //layer=mcon //count=1 \
 //x=5.48 //y=1.18 //x2=5.48 //y2=1.18
r245 (  16 18 ) resistor r=0.0163043 //w=0.345 //l=0.045 //layer=m1 \
 //thickness=0.36 //x=5.42 //y=1.18 //x2=5.42 //y2=1.225
r246 (  14 34 ) resistor r=4.5 //w=0.15 //l=0.15 //layer=via1 //count=1 \
 //x=2.155 //y=1.225 //x2=2.155 //y2=1.225
r247 (  12 76 ) resistor r=9.3 //w=0.17 //l=0.17 //layer=mcon //count=1 \
 //x=2.15 //y=1.18 //x2=2.15 //y2=1.18
r248 (  12 14 ) resistor r=0.0150401 //w=0.374 //l=0.045 //layer=m1 \
 //thickness=0.36 //x=2.205 //y=1.18 //x2=2.205 //y2=1.225
r249 (  9 10 ) resistor r=3.2395 //w=0.131 //l=3.395 //layer=m1 \
 //thickness=0.36 //x=9.25 //y=1.73 //x2=9.25 //y2=5.125
r250 (  7 9 ) resistor r=0.0698411 //w=0.17 //l=0.120208 //layer=m1 \
 //thickness=0.36 //x=9.165 //y=1.645 //x2=9.25 //y2=1.73
r251 (  7 8 ) resistor r=0.257634 //w=0.131 //l=0.27 //layer=m1 \
 //thickness=0.36 //x=9.165 //y=1.645 //x2=8.895 //y2=1.645
r252 (  6 22 ) resistor r=0.0243946 //w=0.225 //l=0.123 //layer=m1 \
 //thickness=0.36 //x=8.89 //y=5.21 //x2=8.767 //y2=5.21
r253 (  5 10 ) resistor r=0.0698411 //w=0.17 //l=0.120208 //layer=m1 \
 //thickness=0.36 //x=9.165 //y=5.21 //x2=9.25 //y2=5.125
r254 (  5 6 ) resistor r=0.262405 //w=0.131 //l=0.275 //layer=m1 \
 //thickness=0.36 //x=9.165 //y=5.21 //x2=8.89 //y2=5.21
r255 (  4 8 ) resistor r=0.0698411 //w=0.17 //l=0.120208 //layer=m1 \
 //thickness=0.36 //x=8.81 //y=1.56 //x2=8.895 //y2=1.645
r256 (  3 28 ) resistor r=0.0792909 //w=0.345 //l=0.157162 //layer=m1 \
 //thickness=0.36 //x=8.81 //y=1.355 //x2=8.75 //y2=1.225
r257 (  3 4 ) resistor r=0.195611 //w=0.131 //l=0.205 //layer=m1 \
 //thickness=0.36 //x=8.81 //y=1.355 //x2=8.81 //y2=1.56
r258 (  2 19 ) resistor r=0.0249239 //w=0.227 //l=0.125 //layer=m1 \
 //thickness=0.36 //x=8.015 //y=5.21 //x2=7.89 //y2=5.21
r259 (  1 22 ) resistor r=0.0243946 //w=0.225 //l=0.122 //layer=m1 \
 //thickness=0.36 //x=8.645 //y=5.21 //x2=8.767 //y2=5.21
r260 (  1 2 ) resistor r=0.601145 //w=0.131 //l=0.63 //layer=m1 \
 //thickness=0.36 //x=8.645 //y=5.21 //x2=8.015 //y2=5.21
ends PM_VOTERN3X1_PCELL\%noxref_4

subckt PM_VOTERN3X1_PCELL\%noxref_5 ( 3 4 5 7 8 9 13 14 27 30 43 46 78 93 96 \
 97 98 99 100 )
c192 ( 100 0 ) capacitor c=0.0424825f //x=2.405 //y=5.025
c193 ( 99 0 ) capacitor c=0.0224071f //x=1.525 //y=5.025
c194 ( 98 0 ) capacitor c=0.0512787f //x=0.655 //y=5.025
c195 ( 97 0 ) capacitor c=0.121126f //x=6.66 //y=7.4
c196 ( 96 0 ) capacitor c=0.126128f //x=3.33 //y=7.4
c197 ( 93 0 ) capacitor c=0.349332f //x=9.25 //y=7.4
c198 ( 78 0 ) capacitor c=0.130738f //x=6.49 //y=7.4
c199 ( 46 0 ) capacitor c=0.212909f //x=0.74 //y=7.4
c200 ( 43 0 ) capacitor c=0.13191f //x=3.16 //y=7.4
c201 ( 38 0 ) capacitor c=0.00498911f //x=2.55 //y=7.4
c202 ( 35 0 ) capacitor c=0.00498911f //x=1.67 //y=7.4
c203 ( 30 0 ) capacitor c=0.0524217f //x=0.74 //y=7.4
c204 ( 27 0 ) capacitor c=0.252782f //x=9.25 //y=7.4
c205 ( 14 0 ) capacitor c=0.00657976f //x=2.55 //y=7.23
c206 ( 13 0 ) capacitor c=0.00827249f //x=2.55 //y=6.855
c207 ( 9 0 ) capacitor c=0.0220533f //x=2.465 //y=7.4
c208 ( 8 0 ) capacitor c=0.00369726f //x=1.67 //y=7.23
c209 ( 7 0 ) capacitor c=0.00650208f //x=1.67 //y=6.855
c210 ( 5 0 ) capacitor c=0.022394f //x=1.585 //y=7.4
c211 ( 4 0 ) capacitor c=0.0090067f //x=0.79 //y=7.23
c212 ( 3 0 ) capacitor c=0.0125184f //x=0.79 //y=6.855
r213 (  91 93 ) resistor r=39.7983 //w=0.357 //l=1.11 //layer=li \
 //thickness=0.1 //x=8.14 //y=7.4 //x2=9.25 //y2=7.4
r214 (  89 91 ) resistor r=39.7983 //w=0.357 //l=1.11 //layer=li \
 //thickness=0.1 //x=7.03 //y=7.4 //x2=8.14 //y2=7.4
r215 (  87 97 ) resistor r=5.4201 //w=0.34 //l=0.17 //layer=li //thickness=0.1 \
 //x=6.83 //y=7.4 //x2=6.66 //y2=7.4
r216 (  87 89 ) resistor r=7.17087 //w=0.357 //l=0.2 //layer=li \
 //thickness=0.1 //x=6.83 //y=7.4 //x2=7.03 //y2=7.4
r217 (  81 83 ) resistor r=39.7983 //w=0.357 //l=1.11 //layer=li \
 //thickness=0.1 //x=4.44 //y=7.4 //x2=5.55 //y2=7.4
r218 (  79 96 ) resistor r=5.4201 //w=0.34 //l=0.17 //layer=li //thickness=0.1 \
 //x=3.5 //y=7.4 //x2=3.33 //y2=7.4
r219 (  79 81 ) resistor r=33.7031 //w=0.357 //l=0.94 //layer=li \
 //thickness=0.1 //x=3.5 //y=7.4 //x2=4.44 //y2=7.4
r220 (  78 97 ) resistor r=5.4201 //w=0.34 //l=0.17 //layer=li //thickness=0.1 \
 //x=6.49 //y=7.4 //x2=6.66 //y2=7.4
r221 (  78 83 ) resistor r=33.7031 //w=0.357 //l=0.94 //layer=li \
 //thickness=0.1 //x=6.49 //y=7.4 //x2=5.55 //y2=7.4
r222 (  74 100 ) resistor r=23.2727 //w=0.187 //l=0.34 //layer=li \
 //thickness=0.1 //x=2.55 //y=6.74 //x2=2.55 //y2=6.4
r223 (  59 98 ) resistor r=23.2727 //w=0.187 //l=0.34 //layer=li \
 //thickness=0.1 //x=0.79 //y=6.74 //x2=0.79 //y2=6.4
r224 (  48 50 ) resistor r=39.7983 //w=0.357 //l=1.11 //layer=li \
 //thickness=0.1 //x=1.85 //y=7.4 //x2=2.96 //y2=7.4
r225 (  46 48 ) resistor r=39.7983 //w=0.357 //l=1.11 //layer=li \
 //thickness=0.1 //x=0.74 //y=7.4 //x2=1.85 //y2=7.4
r226 (  43 96 ) resistor r=5.4201 //w=0.34 //l=0.17 //layer=li //thickness=0.1 \
 //x=3.16 //y=7.4 //x2=3.33 //y2=7.4
r227 (  43 50 ) resistor r=7.17087 //w=0.357 //l=0.2 //layer=li \
 //thickness=0.1 //x=3.16 //y=7.4 //x2=2.96 //y2=7.4
r228 (  40 74 ) resistor r=9.3 //w=0.17 //l=0.17 //layer=mcon //count=1 \
 //x=2.55 //y=6.74 //x2=2.55 //y2=6.74
r229 (  37 99 ) resistor r=9.3 //w=0.17 //l=0.17 //layer=mcon //count=1 \
 //x=1.67 //y=6.74 //x2=1.67 //y2=6.74
r230 (  34 59 ) resistor r=9.3 //w=0.17 //l=0.17 //layer=mcon //count=1 \
 //x=0.79 //y=6.74 //x2=0.79 //y2=6.74
r231 (  30 46 ) resistor r=3.1 //w=0.17 //l=0.51 //layer=mcon //count=3 \
 //x=0.74 //y=7.4 //x2=0.74 //y2=7.4
r232 (  27 93 ) resistor r=3.1 //w=0.17 //l=0.51 //layer=mcon //count=3 \
 //x=9.25 //y=7.4 //x2=9.25 //y2=7.4
r233 (  25 91 ) resistor r=3.1 //w=0.17 //l=0.51 //layer=mcon //count=3 \
 //x=8.14 //y=7.4 //x2=8.14 //y2=7.4
r234 (  25 27 ) resistor r=0.460963 //w=0.301 //l=1.11 //layer=m1 \
 //thickness=0.36 //x=8.14 //y=7.4 //x2=9.25 //y2=7.4
r235 (  23 89 ) resistor r=3.1 //w=0.17 //l=0.51 //layer=mcon //count=3 \
 //x=7.03 //y=7.4 //x2=7.03 //y2=7.4
r236 (  23 25 ) resistor r=0.460963 //w=0.301 //l=1.11 //layer=m1 \
 //thickness=0.36 //x=7.03 //y=7.4 //x2=8.14 //y2=7.4
r237 (  21 83 ) resistor r=3.1 //w=0.17 //l=0.51 //layer=mcon //count=3 \
 //x=5.55 //y=7.4 //x2=5.55 //y2=7.4
r238 (  21 23 ) resistor r=0.614618 //w=0.301 //l=1.48 //layer=m1 \
 //thickness=0.36 //x=5.55 //y=7.4 //x2=7.03 //y2=7.4
r239 (  19 81 ) resistor r=3.1 //w=0.17 //l=0.51 //layer=mcon //count=3 \
 //x=4.44 //y=7.4 //x2=4.44 //y2=7.4
r240 (  19 21 ) resistor r=0.460963 //w=0.301 //l=1.11 //layer=m1 \
 //thickness=0.36 //x=4.44 //y=7.4 //x2=5.55 //y2=7.4
r241 (  17 50 ) resistor r=3.1 //w=0.17 //l=0.51 //layer=mcon //count=3 \
 //x=2.96 //y=7.4 //x2=2.96 //y2=7.4
r242 (  17 19 ) resistor r=0.614618 //w=0.301 //l=1.48 //layer=m1 \
 //thickness=0.36 //x=2.96 //y=7.4 //x2=4.44 //y2=7.4
r243 (  15 38 ) resistor r=0.0287885 //w=0.34 //l=0.085 //layer=m1 \
 //thickness=0.36 //x=2.635 //y=7.4 //x2=2.55 //y2=7.4
r244 (  15 17 ) resistor r=0.134967 //w=0.301 //l=0.325 //layer=m1 \
 //thickness=0.36 //x=2.635 //y=7.4 //x2=2.96 //y2=7.4
r245 (  14 38 ) resistor r=0.0401957 //w=0.68 //l=0.17 //layer=m1 \
 //thickness=0.36 //x=2.55 //y=7.23 //x2=2.55 //y2=7.4
r246 (  13 40 ) resistor r=0.0715665 //w=0.226 //l=0.115 //layer=m1 \
 //thickness=0.36 //x=2.55 //y=6.855 //x2=2.55 //y2=6.74
r247 (  13 14 ) resistor r=0.357824 //w=0.131 //l=0.375 //layer=m1 \
 //thickness=0.36 //x=2.55 //y=6.855 //x2=2.55 //y2=7.23
r248 (  12 48 ) resistor r=3.1 //w=0.17 //l=0.51 //layer=mcon //count=3 \
 //x=1.85 //y=7.4 //x2=1.85 //y2=7.4
r249 (  10 35 ) resistor r=0.0287885 //w=0.34 //l=0.085 //layer=m1 \
 //thickness=0.36 //x=1.755 //y=7.4 //x2=1.67 //y2=7.4
r250 (  10 12 ) resistor r=0.0394518 //w=0.301 //l=0.095 //layer=m1 \
 //thickness=0.36 //x=1.755 //y=7.4 //x2=1.85 //y2=7.4
r251 (  9 38 ) resistor r=0.0287885 //w=0.34 //l=0.085 //layer=m1 \
 //thickness=0.36 //x=2.465 //y=7.4 //x2=2.55 //y2=7.4
r252 (  9 12 ) resistor r=0.255399 //w=0.301 //l=0.615 //layer=m1 \
 //thickness=0.36 //x=2.465 //y=7.4 //x2=1.85 //y2=7.4
r253 (  8 35 ) resistor r=0.0401957 //w=0.68 //l=0.17 //layer=m1 \
 //thickness=0.36 //x=1.67 //y=7.23 //x2=1.67 //y2=7.4
r254 (  7 37 ) resistor r=0.0715665 //w=0.226 //l=0.117473 //layer=m1 \
 //thickness=0.36 //x=1.67 //y=6.855 //x2=1.675 //y2=6.74
r255 (  7 8 ) resistor r=0.357824 //w=0.131 //l=0.375 //layer=m1 \
 //thickness=0.36 //x=1.67 //y=6.855 //x2=1.67 //y2=7.23
r256 (  6 30 ) resistor r=0.0287885 //w=0.34 //l=0.085 //layer=m1 \
 //thickness=0.36 //x=0.875 //y=7.4 //x2=0.79 //y2=7.4
r257 (  5 35 ) resistor r=0.0287885 //w=0.34 //l=0.085 //layer=m1 \
 //thickness=0.36 //x=1.585 //y=7.4 //x2=1.67 //y2=7.4
r258 (  5 6 ) resistor r=0.29485 //w=0.301 //l=0.71 //layer=m1 \
 //thickness=0.36 //x=1.585 //y=7.4 //x2=0.875 //y2=7.4
r259 (  4 30 ) resistor r=0.0401957 //w=0.68 //l=0.17 //layer=m1 \
 //thickness=0.36 //x=0.79 //y=7.23 //x2=0.79 //y2=7.4
r260 (  3 34 ) resistor r=0.0712609 //w=0.23 //l=0.11649 //layer=m1 \
 //thickness=0.36 //x=0.79 //y=6.855 //x2=0.787 //y2=6.74
r261 (  3 4 ) resistor r=0.357824 //w=0.131 //l=0.375 //layer=m1 \
 //thickness=0.36 //x=0.79 //y=6.855 //x2=0.79 //y2=7.23
ends PM_VOTERN3X1_PCELL\%noxref_5

subckt PM_VOTERN3X1_PCELL\%noxref_6 ( 1 3 4 5 7 9 19 25 27 30 40 49 71 72 73 \
 74 75 )
c166 ( 75 0 ) capacitor c=0.0354016f //x=5.725 //y=5.025
c167 ( 74 0 ) capacitor c=0.0241107f //x=4.845 //y=5.025
c168 ( 72 0 ) capacitor c=0.00544792f //x=1.965 //y=5.025
c169 ( 71 0 ) capacitor c=0.00516996f //x=1.085 //y=5.025
c170 ( 49 0 ) capacitor c=0.0508454f //x=4.11 //y=5.21
c171 ( 40 0 ) capacitor c=0.0363371f //x=2.11 //y=5.21
c172 ( 30 0 ) capacitor c=0.0294643f //x=1.23 //y=5.38
c173 ( 27 0 ) capacitor c=0.00984489f //x=5.87 //y=6.74
c174 ( 25 0 ) capacitor c=0.0059844f //x=4.987 //y=6.91
c175 ( 19 0 ) capacitor c=0.00975753f //x=4.11 //y=6.74
c176 ( 9 0 ) capacitor c=0.014892f //x=1.232 //y=5.21
c177 ( 7 0 ) capacitor c=0.00787288f //x=5.755 //y=6.91
c178 ( 5 0 ) capacitor c=0.00659042f //x=4.87 //y=6.91
c179 ( 4 0 ) capacitor c=0.00573286f //x=2.225 //y=5.21
c180 ( 3 0 ) capacitor c=0.0636102f //x=3.995 //y=5.21
c181 ( 1 0 ) capacitor c=0.0145996f //x=1.995 //y=5.21
r182 (  49 73 ) resistor r=58.1818 //w=0.187 //l=0.85 //layer=li \
 //thickness=0.1 //x=4.11 //y=5.21 //x2=4.11 //y2=6.06
r183 (  40 72 ) resistor r=58.1818 //w=0.187 //l=0.85 //layer=li \
 //thickness=0.1 //x=2.11 //y=5.21 //x2=2.11 //y2=6.06
r184 (  30 71 ) resistor r=23.2727 //w=0.187 //l=0.34 //layer=li \
 //thickness=0.1 //x=1.23 //y=5.38 //x2=1.23 //y2=5.72
r185 (  27 75 ) resistor r=9.3 //w=0.17 //l=0.17 //layer=mcon //count=1 \
 //x=5.87 //y=6.74 //x2=5.87 //y2=6.74
r186 (  27 28 ) resistor r=0.0988372 //w=0.215 //l=0.17 //layer=m1 \
 //thickness=0.36 //x=5.872 //y=6.74 //x2=5.872 //y2=6.91
r187 (  24 74 ) resistor r=9.3 //w=0.17 //l=0.17 //layer=mcon //count=1 \
 //x=4.99 //y=6.74 //x2=4.99 //y2=6.74
r188 (  24 25 ) resistor r=0.0940266 //w=0.226 //l=0.17 //layer=m1 \
 //thickness=0.36 //x=4.987 //y=6.74 //x2=4.987 //y2=6.91
r189 (  22 49 ) resistor r=9.3 //w=0.17 //l=0.17 //layer=mcon //count=1 \
 //x=4.11 //y=5.21 //x2=4.11 //y2=5.21
r190 (  19 73 ) resistor r=9.3 //w=0.17 //l=0.17 //layer=mcon //count=1 \
 //x=4.11 //y=6.74 //x2=4.11 //y2=6.74
r191 (  19 20 ) resistor r=0.0979263 //w=0.217 //l=0.17 //layer=m1 \
 //thickness=0.36 //x=4.112 //y=6.74 //x2=4.112 //y2=6.91
r192 (  15 40 ) resistor r=9.3 //w=0.17 //l=0.17 //layer=mcon //count=1 \
 //x=2.11 //y=5.21 //x2=2.11 //y2=5.21
r193 (  11 30 ) resistor r=9.3 //w=0.17 //l=0.17 //layer=mcon //count=1 \
 //x=1.23 //y=5.38 //x2=1.23 //y2=5.38
r194 (  9 11 ) resistor r=0.0944444 //w=0.225 //l=0.17 //layer=m1 \
 //thickness=0.36 //x=1.232 //y=5.21 //x2=1.232 //y2=5.38
r195 (  8 25 ) resistor r=0.0246599 //w=0.226 //l=0.118 //layer=m1 \
 //thickness=0.36 //x=5.105 //y=6.91 //x2=4.987 //y2=6.91
r196 (  7 28 ) resistor r=0.0216707 //w=0.215 //l=0.117 //layer=m1 \
 //thickness=0.36 //x=5.755 //y=6.91 //x2=5.872 //y2=6.91
r197 (  7 8 ) resistor r=0.620229 //w=0.131 //l=0.65 //layer=m1 \
 //thickness=0.36 //x=5.755 //y=6.91 //x2=5.105 //y2=6.91
r198 (  6 20 ) resistor r=0.0222262 //w=0.217 //l=0.118 //layer=m1 \
 //thickness=0.36 //x=4.23 //y=6.91 //x2=4.112 //y2=6.91
r199 (  5 25 ) resistor r=0.0246599 //w=0.226 //l=0.117 //layer=m1 \
 //thickness=0.36 //x=4.87 //y=6.91 //x2=4.987 //y2=6.91
r200 (  5 6 ) resistor r=0.610687 //w=0.131 //l=0.64 //layer=m1 \
 //thickness=0.36 //x=4.87 //y=6.91 //x2=4.23 //y2=6.91
r201 (  4 15 ) resistor r=0.0880901 //w=0.191 //l=0.115 //layer=m1 \
 //thickness=0.36 //x=2.225 //y=5.21 //x2=2.11 //y2=5.21
r202 (  3 22 ) resistor r=0.0717383 //w=0.224 //l=0.115 //layer=m1 \
 //thickness=0.36 //x=3.995 //y=5.21 //x2=4.11 //y2=5.21
r203 (  3 4 ) resistor r=1.68893 //w=0.131 //l=1.77 //layer=m1 \
 //thickness=0.36 //x=3.995 //y=5.21 //x2=2.225 //y2=5.21
r204 (  2 9 ) resistor r=0.0243946 //w=0.225 //l=0.123 //layer=m1 \
 //thickness=0.36 //x=1.355 //y=5.21 //x2=1.232 //y2=5.21
r205 (  1 15 ) resistor r=0.0880901 //w=0.191 //l=0.115 //layer=m1 \
 //thickness=0.36 //x=1.995 //y=5.21 //x2=2.11 //y2=5.21
r206 (  1 2 ) resistor r=0.610687 //w=0.131 //l=0.64 //layer=m1 \
 //thickness=0.36 //x=1.995 //y=5.21 //x2=1.355 //y2=5.21
ends PM_VOTERN3X1_PCELL\%noxref_6

subckt PM_VOTERN3X1_PCELL\%noxref_7 ( 1 3 4 5 7 9 13 15 21 23 26 38 60 61 62 \
 63 )
c124 ( 63 0 ) capacitor c=0.0346626f //x=9.065 //y=5.025
c125 ( 62 0 ) capacitor c=0.0239063f //x=8.185 //y=5.025
c126 ( 38 0 ) capacitor c=0.0496943f //x=7.45 //y=5.21
c127 ( 26 0 ) capacitor c=0.0229521f //x=4.55 //y=5.38
c128 ( 23 0 ) capacitor c=0.0159821f //x=9.21 //y=6.74
c129 ( 21 0 ) capacitor c=0.00566376f //x=8.33 //y=6.91
c130 ( 15 0 ) capacitor c=0.00945187f //x=7.45 //y=6.74
c131 ( 13 0 ) capacitor c=0.0163615f //x=5.43 //y=5.21
c132 ( 9 0 ) capacitor c=0.0150333f //x=4.55 //y=5.21
c133 ( 7 0 ) capacitor c=0.0068287f //x=9.08 //y=6.91
c134 ( 5 0 ) capacitor c=0.00878908f //x=8.215 //y=6.91
c135 ( 4 0 ) capacitor c=0.00822986f //x=5.545 //y=5.21
c136 ( 3 0 ) capacitor c=0.0577233f //x=7.335 //y=5.21
c137 ( 1 0 ) capacitor c=0.018311f //x=5.315 //y=5.21
r138 (  38 61 ) resistor r=58.1818 //w=0.187 //l=0.85 //layer=li \
 //thickness=0.1 //x=7.45 //y=5.21 //x2=7.45 //y2=6.06
r139 (  26 60 ) resistor r=23.2727 //w=0.187 //l=0.34 //layer=li \
 //thickness=0.1 //x=4.55 //y=5.38 //x2=4.55 //y2=5.72
r140 (  23 63 ) resistor r=9.3 //w=0.17 //l=0.17 //layer=mcon //count=1 \
 //x=9.21 //y=6.74 //x2=9.21 //y2=6.74
r141 (  23 24 ) resistor r=0.0923913 //w=0.23 //l=0.17 //layer=m1 \
 //thickness=0.36 //x=9.205 //y=6.74 //x2=9.205 //y2=6.91
r142 (  20 62 ) resistor r=9.3 //w=0.17 //l=0.17 //layer=mcon //count=1 \
 //x=8.33 //y=6.74 //x2=8.33 //y2=6.74
r143 (  20 21 ) resistor r=0.0957207 //w=0.222 //l=0.17 //layer=m1 \
 //thickness=0.36 //x=8.33 //y=6.74 //x2=8.33 //y2=6.91
r144 (  18 38 ) resistor r=9.3 //w=0.17 //l=0.17 //layer=mcon //count=1 \
 //x=7.45 //y=5.21 //x2=7.45 //y2=5.21
r145 (  15 61 ) resistor r=9.3 //w=0.17 //l=0.17 //layer=mcon //count=1 \
 //x=7.45 //y=6.74 //x2=7.45 //y2=6.74
r146 (  15 16 ) resistor r=0.100236 //w=0.212 //l=0.17 //layer=m1 \
 //thickness=0.36 //x=7.45 //y=6.74 //x2=7.45 //y2=6.91
r147 (  11 26 ) resistor r=9.3 //w=0.17 //l=0.17 //layer=mcon //count=1 \
 //x=4.55 //y=5.38 //x2=4.55 //y2=5.38
r148 (  9 11 ) resistor r=0.100236 //w=0.212 //l=0.17 //layer=m1 \
 //thickness=0.36 //x=4.55 //y=5.21 //x2=4.55 //y2=5.38
r149 (  8 21 ) resistor r=0.0235912 //w=0.222 //l=0.115 //layer=m1 \
 //thickness=0.36 //x=8.445 //y=6.91 //x2=8.33 //y2=6.91
r150 (  7 24 ) resistor r=0.0257089 //w=0.23 //l=0.125 //layer=m1 \
 //thickness=0.36 //x=9.08 //y=6.91 //x2=9.205 //y2=6.91
r151 (  7 8 ) resistor r=0.605916 //w=0.131 //l=0.635 //layer=m1 \
 //thickness=0.36 //x=9.08 //y=6.91 //x2=8.445 //y2=6.91
r152 (  6 16 ) resistor r=0.0208269 //w=0.212 //l=0.115 //layer=m1 \
 //thickness=0.36 //x=7.565 //y=6.91 //x2=7.45 //y2=6.91
r153 (  5 21 ) resistor r=0.0235912 //w=0.222 //l=0.115 //layer=m1 \
 //thickness=0.36 //x=8.215 //y=6.91 //x2=8.33 //y2=6.91
r154 (  5 6 ) resistor r=0.620229 //w=0.131 //l=0.65 //layer=m1 \
 //thickness=0.36 //x=8.215 //y=6.91 //x2=7.565 //y2=6.91
r155 (  4 13 ) resistor r=0.0880901 //w=0.191 //l=0.115 //layer=m1 \
 //thickness=0.36 //x=5.545 //y=5.21 //x2=5.43 //y2=5.21
r156 (  3 18 ) resistor r=0.0717383 //w=0.224 //l=0.115 //layer=m1 \
 //thickness=0.36 //x=7.335 //y=5.21 //x2=7.45 //y2=5.21
r157 (  3 4 ) resistor r=1.70802 //w=0.131 //l=1.79 //layer=m1 \
 //thickness=0.36 //x=7.335 //y=5.21 //x2=5.545 //y2=5.21
r158 (  2 9 ) resistor r=0.0208269 //w=0.212 //l=0.115 //layer=m1 \
 //thickness=0.36 //x=4.665 //y=5.21 //x2=4.55 //y2=5.21
r159 (  1 13 ) resistor r=0.0880901 //w=0.191 //l=0.115 //layer=m1 \
 //thickness=0.36 //x=5.315 //y=5.21 //x2=5.43 //y2=5.21
r160 (  1 2 ) resistor r=0.620229 //w=0.131 //l=0.65 //layer=m1 \
 //thickness=0.36 //x=5.315 //y=5.21 //x2=4.665 //y2=5.21
ends PM_VOTERN3X1_PCELL\%noxref_7

subckt PM_VOTERN3X1_PCELL\%noxref_8 ( 1 6 7 15 22 27 33 39 42 54 69 77 78 79 \
 80 )
c187 ( 80 0 ) capacitor c=0.00828027f //x=7.65 //y=0.865
c188 ( 79 0 ) capacitor c=0.0083251f //x=0.99 //y=0.865
c189 ( 78 0 ) capacitor c=0.110297f //x=6.66 //y=0
c190 ( 77 0 ) capacitor c=0.124469f //x=3.33 //y=0
c191 ( 69 0 ) capacitor c=0.311229f //x=9.25 //y=0
c192 ( 54 0 ) capacitor c=0.117502f //x=6.49 //y=0
c193 ( 42 0 ) capacitor c=0.180504f //x=0.74 //y=0
c194 ( 39 0 ) capacitor c=0.121547f //x=3.16 //y=0
c195 ( 34 0 ) capacitor c=0.0050875f //x=7.84 //y=0
c196 ( 33 0 ) capacitor c=0.0256218f //x=4.44 //y=0
c197 ( 29 0 ) capacitor c=0.0050875f //x=1.18 //y=0
c198 ( 27 0 ) capacitor c=0.0848749f //x=9.25 //y=0
c199 ( 22 0 ) capacitor c=0.0435289f //x=7.84 //y=0.84
c200 ( 15 0 ) capacitor c=0.107261f //x=7.755 //y=0
c201 ( 7 0 ) capacitor c=0.112317f //x=4.425 //y=0
c202 ( 6 0 ) capacitor c=0.044044f //x=1.18 //y=0.835
c203 ( 1 0 ) capacitor c=0.0577791f //x=1.095 //y=0
r204 (  67 69 ) resistor r=39.7983 //w=0.357 //l=1.11 //layer=li \
 //thickness=0.1 //x=8.14 //y=0 //x2=9.25 //y2=0
r205 (  65 67 ) resistor r=39.7983 //w=0.357 //l=1.11 //layer=li \
 //thickness=0.1 //x=7.03 //y=0 //x2=8.14 //y2=0
r206 (  63 78 ) resistor r=5.4201 //w=0.34 //l=0.17 //layer=li //thickness=0.1 \
 //x=6.83 //y=0 //x2=6.66 //y2=0
r207 (  63 65 ) resistor r=7.17087 //w=0.357 //l=0.2 //layer=li \
 //thickness=0.1 //x=6.83 //y=0 //x2=7.03 //y2=0
r208 (  57 59 ) resistor r=39.7983 //w=0.357 //l=1.11 //layer=li \
 //thickness=0.1 //x=4.44 //y=0 //x2=5.55 //y2=0
r209 (  55 77 ) resistor r=5.4201 //w=0.34 //l=0.17 //layer=li //thickness=0.1 \
 //x=3.5 //y=0 //x2=3.33 //y2=0
r210 (  55 57 ) resistor r=33.7031 //w=0.357 //l=0.94 //layer=li \
 //thickness=0.1 //x=3.5 //y=0 //x2=4.44 //y2=0
r211 (  54 78 ) resistor r=5.4201 //w=0.34 //l=0.17 //layer=li //thickness=0.1 \
 //x=6.49 //y=0 //x2=6.66 //y2=0
r212 (  54 59 ) resistor r=33.7031 //w=0.357 //l=0.94 //layer=li \
 //thickness=0.1 //x=6.49 //y=0 //x2=5.55 //y2=0
r213 (  44 46 ) resistor r=39.7983 //w=0.357 //l=1.11 //layer=li \
 //thickness=0.1 //x=1.85 //y=0 //x2=2.96 //y2=0
r214 (  42 44 ) resistor r=39.7983 //w=0.357 //l=1.11 //layer=li \
 //thickness=0.1 //x=0.74 //y=0 //x2=1.85 //y2=0
r215 (  39 77 ) resistor r=5.4201 //w=0.34 //l=0.17 //layer=li //thickness=0.1 \
 //x=3.16 //y=0 //x2=3.33 //y2=0
r216 (  39 46 ) resistor r=7.17087 //w=0.357 //l=0.2 //layer=li \
 //thickness=0.1 //x=3.16 //y=0 //x2=2.96 //y2=0
r217 (  36 80 ) resistor r=9.3 //w=0.17 //l=0.17 //layer=mcon //count=1 \
 //x=7.84 //y=0.955 //x2=7.84 //y2=0.955
r218 (  33 57 ) resistor r=3.1 //w=0.17 //l=0.51 //layer=mcon //count=3 \
 //x=4.44 //y=0 //x2=4.44 //y2=0
r219 (  31 79 ) resistor r=9.3 //w=0.17 //l=0.17 //layer=mcon //count=1 \
 //x=1.18 //y=0.955 //x2=1.18 //y2=0.955
r220 (  27 69 ) resistor r=3.1 //w=0.17 //l=0.51 //layer=mcon //count=3 \
 //x=9.25 //y=0 //x2=9.25 //y2=0
r221 (  25 67 ) resistor r=3.1 //w=0.17 //l=0.51 //layer=mcon //count=3 \
 //x=8.14 //y=0 //x2=8.14 //y2=0
r222 (  25 27 ) resistor r=0.460963 //w=0.301 //l=1.11 //layer=m1 \
 //thickness=0.36 //x=8.14 //y=0 //x2=9.25 //y2=0
r223 (  23 34 ) resistor r=0.0287885 //w=0.34 //l=0.085 //layer=m1 \
 //thickness=0.36 //x=7.925 //y=0 //x2=7.84 //y2=0
r224 (  23 25 ) resistor r=0.0892857 //w=0.301 //l=0.215 //layer=m1 \
 //thickness=0.36 //x=7.925 //y=0 //x2=8.14 //y2=0
r225 (  22 36 ) resistor r=0.0703067 //w=0.254 //l=0.11649 //layer=m1 \
 //thickness=0.36 //x=7.84 //y=0.84 //x2=7.837 //y2=0.955
r226 (  21 34 ) resistor r=0.0401957 //w=0.68 //l=0.17 //layer=m1 \
 //thickness=0.36 //x=7.84 //y=0.17 //x2=7.84 //y2=0
r227 (  21 22 ) resistor r=0.639313 //w=0.131 //l=0.67 //layer=m1 \
 //thickness=0.36 //x=7.84 //y=0.17 //x2=7.84 //y2=0.84
r228 (  20 65 ) resistor r=3.1 //w=0.17 //l=0.51 //layer=mcon //count=3 \
 //x=7.03 //y=0 //x2=7.03 //y2=0
r229 (  18 59 ) resistor r=3.1 //w=0.17 //l=0.51 //layer=mcon //count=3 \
 //x=5.55 //y=0 //x2=5.55 //y2=0
r230 (  18 20 ) resistor r=0.614618 //w=0.301 //l=1.48 //layer=m1 \
 //thickness=0.36 //x=5.55 //y=0 //x2=7.03 //y2=0
r231 (  16 33 ) resistor r=0.0287885 //w=0.34 //l=0.085 //layer=m1 \
 //thickness=0.36 //x=4.595 //y=0 //x2=4.51 //y2=0
r232 (  16 18 ) resistor r=0.396595 //w=0.301 //l=0.955 //layer=m1 \
 //thickness=0.36 //x=4.595 //y=0 //x2=5.55 //y2=0
r233 (  15 34 ) resistor r=0.0287885 //w=0.34 //l=0.085 //layer=m1 \
 //thickness=0.36 //x=7.755 //y=0 //x2=7.84 //y2=0
r234 (  15 20 ) resistor r=0.30108 //w=0.301 //l=0.725 //layer=m1 \
 //thickness=0.36 //x=7.755 //y=0 //x2=7.03 //y2=0
r235 (  12 46 ) resistor r=3.1 //w=0.17 //l=0.51 //layer=mcon //count=3 \
 //x=2.96 //y=0 //x2=2.96 //y2=0
r236 (  10 44 ) resistor r=3.1 //w=0.17 //l=0.51 //layer=mcon //count=3 \
 //x=1.85 //y=0 //x2=1.85 //y2=0
r237 (  10 12 ) resistor r=0.460963 //w=0.301 //l=1.11 //layer=m1 \
 //thickness=0.36 //x=1.85 //y=0 //x2=2.96 //y2=0
r238 (  8 29 ) resistor r=0.0287885 //w=0.34 //l=0.085 //layer=m1 \
 //thickness=0.36 //x=1.265 //y=0 //x2=1.18 //y2=0
r239 (  8 10 ) resistor r=0.24294 //w=0.301 //l=0.585 //layer=m1 \
 //thickness=0.36 //x=1.265 //y=0 //x2=1.85 //y2=0
r240 (  7 33 ) resistor r=0.0287885 //w=0.34 //l=0.085 //layer=m1 \
 //thickness=0.36 //x=4.425 //y=0 //x2=4.51 //y2=0
r241 (  7 12 ) resistor r=0.608389 //w=0.301 //l=1.465 //layer=m1 \
 //thickness=0.36 //x=4.425 //y=0 //x2=2.96 //y2=0
r242 (  6 31 ) resistor r=0.0729089 //w=0.249 //l=0.120996 //layer=m1 \
 //thickness=0.36 //x=1.18 //y=0.835 //x2=1.182 //y2=0.955
r243 (  5 29 ) resistor r=0.0401957 //w=0.68 //l=0.17 //layer=m1 \
 //thickness=0.36 //x=1.18 //y=0.17 //x2=1.18 //y2=0
r244 (  5 6 ) resistor r=0.634542 //w=0.131 //l=0.665 //layer=m1 \
 //thickness=0.36 //x=1.18 //y=0.17 //x2=1.18 //y2=0.835
r245 (  3 42 ) resistor r=3.1 //w=0.17 //l=0.51 //layer=mcon //count=3 \
 //x=0.74 //y=0 //x2=0.74 //y2=0
r246 (  1 29 ) resistor r=0.0287885 //w=0.34 //l=0.085 //layer=m1 \
 //thickness=0.36 //x=1.095 //y=0 //x2=1.18 //y2=0
r247 (  1 3 ) resistor r=0.147425 //w=0.301 //l=0.355 //layer=m1 \
 //thickness=0.36 //x=1.095 //y=0 //x2=0.74 //y2=0
ends PM_VOTERN3X1_PCELL\%noxref_8

subckt PM_VOTERN3X1_PCELL\%noxref_9 ( 1 5 9 10 13 17 29 )
c65 ( 29 0 ) capacitor c=0.0786297f //x=0.56 //y=0.365
c66 ( 17 0 ) capacitor c=0.00678917f //x=2.635 //y=0.615
c67 ( 13 0 ) capacitor c=0.0154169f //x=2.55 //y=0.53
c68 ( 10 0 ) capacitor c=0.00990031f //x=1.665 //y=1.495
c69 ( 9 0 ) capacitor c=0.00770028f //x=1.665 //y=0.615
c70 ( 5 0 ) capacitor c=0.028994f //x=1.58 //y=1.58
c71 ( 1 0 ) capacitor c=0.0049595f //x=0.695 //y=1.495
r72 (  17 29 ) resistor r=3.57586 //w=0.17 //l=0.125 //layer=li \
 //thickness=0.1 //x=2.635 //y=0.615 //x2=2.635 //y2=0.49
r73 (  17 29 ) resistor r=41.4118 //w=0.187 //l=0.605 //layer=li \
 //thickness=0.1 //x=2.635 //y=0.615 //x2=2.635 //y2=1.22
r74 (  14 29 ) resistor r=3.57586 //w=0.17 //l=0.103078 //layer=li \
 //thickness=0.1 //x=1.75 //y=0.53 //x2=1.665 //y2=0.49
r75 (  14 29 ) resistor r=27.0374 //w=0.187 //l=0.395 //layer=li \
 //thickness=0.1 //x=1.75 //y=0.53 //x2=2.145 //y2=0.53
r76 (  13 29 ) resistor r=3.57586 //w=0.17 //l=0.103078 //layer=li \
 //thickness=0.1 //x=2.55 //y=0.53 //x2=2.635 //y2=0.49
r77 (  13 29 ) resistor r=27.7219 //w=0.187 //l=0.405 //layer=li \
 //thickness=0.1 //x=2.55 //y=0.53 //x2=2.145 //y2=0.53
r78 (  10 29 ) resistor r=3.57586 //w=0.17 //l=0.125 //layer=li \
 //thickness=0.1 //x=1.665 //y=1.495 //x2=1.665 //y2=1.62
r79 (  10 29 ) resistor r=42.0963 //w=0.187 //l=0.615 //layer=li \
 //thickness=0.1 //x=1.665 //y=1.495 //x2=1.665 //y2=0.88
r80 (  9 29 ) resistor r=3.57586 //w=0.17 //l=0.125 //layer=li //thickness=0.1 \
 //x=1.665 //y=0.615 //x2=1.665 //y2=0.49
r81 (  9 29 ) resistor r=18.139 //w=0.187 //l=0.265 //layer=li //thickness=0.1 \
 //x=1.665 //y=0.615 //x2=1.665 //y2=0.88
r82 (  6 29 ) resistor r=3.57586 //w=0.17 //l=0.103078 //layer=li \
 //thickness=0.1 //x=0.78 //y=1.58 //x2=0.695 //y2=1.62
r83 (  6 29 ) resistor r=27.3797 //w=0.187 //l=0.4 //layer=li //thickness=0.1 \
 //x=0.78 //y=1.58 //x2=1.18 //y2=1.58
r84 (  5 29 ) resistor r=3.57586 //w=0.17 //l=0.103078 //layer=li \
 //thickness=0.1 //x=1.58 //y=1.58 //x2=1.665 //y2=1.62
r85 (  5 29 ) resistor r=27.3797 //w=0.187 //l=0.4 //layer=li //thickness=0.1 \
 //x=1.58 //y=1.58 //x2=1.18 //y2=1.58
r86 (  1 29 ) resistor r=3.57586 //w=0.17 //l=0.125 //layer=li //thickness=0.1 \
 //x=0.695 //y=1.495 //x2=0.695 //y2=1.62
r87 (  1 29 ) resistor r=42.0963 //w=0.187 //l=0.615 //layer=li \
 //thickness=0.1 //x=0.695 //y=1.495 //x2=0.695 //y2=0.88
ends PM_VOTERN3X1_PCELL\%noxref_9

subckt PM_VOTERN3X1_PCELL\%noxref_12 ( 1 5 9 10 13 17 29 )
c66 ( 29 0 ) capacitor c=0.07461f //x=3.89 //y=0.365
c67 ( 17 0 ) capacitor c=0.00678917f //x=5.965 //y=0.615
c68 ( 13 0 ) capacitor c=0.0158009f //x=5.88 //y=0.53
c69 ( 10 0 ) capacitor c=0.009705f //x=4.995 //y=1.495
c70 ( 9 0 ) capacitor c=0.00770028f //x=4.995 //y=0.615
c71 ( 5 0 ) capacitor c=0.0202311f //x=4.91 //y=1.58
c72 ( 1 0 ) capacitor c=0.00935657f //x=4.025 //y=1.495
r73 (  17 29 ) resistor r=3.57586 //w=0.17 //l=0.125 //layer=li \
 //thickness=0.1 //x=5.965 //y=0.615 //x2=5.965 //y2=0.49
r74 (  17 29 ) resistor r=41.4118 //w=0.187 //l=0.605 //layer=li \
 //thickness=0.1 //x=5.965 //y=0.615 //x2=5.965 //y2=1.22
r75 (  14 29 ) resistor r=3.57586 //w=0.17 //l=0.103078 //layer=li \
 //thickness=0.1 //x=5.08 //y=0.53 //x2=4.995 //y2=0.49
r76 (  14 29 ) resistor r=27.3797 //w=0.187 //l=0.4 //layer=li //thickness=0.1 \
 //x=5.08 //y=0.53 //x2=5.48 //y2=0.53
r77 (  13 29 ) resistor r=3.57586 //w=0.17 //l=0.103078 //layer=li \
 //thickness=0.1 //x=5.88 //y=0.53 //x2=5.965 //y2=0.49
r78 (  13 29 ) resistor r=27.3797 //w=0.187 //l=0.4 //layer=li //thickness=0.1 \
 //x=5.88 //y=0.53 //x2=5.48 //y2=0.53
r79 (  10 29 ) resistor r=3.57586 //w=0.17 //l=0.125 //layer=li \
 //thickness=0.1 //x=4.995 //y=1.495 //x2=4.995 //y2=1.62
r80 (  10 29 ) resistor r=42.0963 //w=0.187 //l=0.615 //layer=li \
 //thickness=0.1 //x=4.995 //y=1.495 //x2=4.995 //y2=0.88
r81 (  9 29 ) resistor r=3.57586 //w=0.17 //l=0.125 //layer=li //thickness=0.1 \
 //x=4.995 //y=0.615 //x2=4.995 //y2=0.49
r82 (  9 29 ) resistor r=18.139 //w=0.187 //l=0.265 //layer=li //thickness=0.1 \
 //x=4.995 //y=0.615 //x2=4.995 //y2=0.88
r83 (  6 29 ) resistor r=3.57586 //w=0.17 //l=0.103078 //layer=li \
 //thickness=0.1 //x=4.11 //y=1.58 //x2=4.025 //y2=1.62
r84 (  6 29 ) resistor r=27.3797 //w=0.187 //l=0.4 //layer=li //thickness=0.1 \
 //x=4.11 //y=1.58 //x2=4.51 //y2=1.58
r85 (  5 29 ) resistor r=3.57586 //w=0.17 //l=0.103078 //layer=li \
 //thickness=0.1 //x=4.91 //y=1.58 //x2=4.995 //y2=1.62
r86 (  5 29 ) resistor r=27.3797 //w=0.187 //l=0.4 //layer=li //thickness=0.1 \
 //x=4.91 //y=1.58 //x2=4.51 //y2=1.58
r87 (  1 29 ) resistor r=3.57586 //w=0.17 //l=0.125 //layer=li //thickness=0.1 \
 //x=4.025 //y=1.495 //x2=4.025 //y2=1.62
r88 (  1 29 ) resistor r=42.0963 //w=0.187 //l=0.615 //layer=li \
 //thickness=0.1 //x=4.025 //y=1.495 //x2=4.025 //y2=0.88
ends PM_VOTERN3X1_PCELL\%noxref_12

subckt PM_VOTERN3X1_PCELL\%noxref_13 ( 1 5 9 10 13 17 29 )
c62 ( 29 0 ) capacitor c=0.0687486f //x=7.22 //y=0.365
c63 ( 17 0 ) capacitor c=0.00709795f //x=9.295 //y=0.615
c64 ( 13 0 ) capacitor c=0.0152565f //x=9.21 //y=0.53
c65 ( 10 0 ) capacitor c=0.0075177f //x=8.325 //y=1.495
c66 ( 9 0 ) capacitor c=0.00770028f //x=8.325 //y=0.615
c67 ( 5 0 ) capacitor c=0.0236235f //x=8.24 //y=1.58
c68 ( 1 0 ) capacitor c=0.00498306f //x=7.355 //y=1.495
r69 (  17 29 ) resistor r=3.57586 //w=0.17 //l=0.125 //layer=li \
 //thickness=0.1 //x=9.295 //y=0.615 //x2=9.295 //y2=0.49
r70 (  17 29 ) resistor r=18.139 //w=0.187 //l=0.265 //layer=li \
 //thickness=0.1 //x=9.295 //y=0.615 //x2=9.295 //y2=0.88
r71 (  14 29 ) resistor r=3.57586 //w=0.17 //l=0.103078 //layer=li \
 //thickness=0.1 //x=8.41 //y=0.53 //x2=8.325 //y2=0.49
r72 (  14 29 ) resistor r=27.3797 //w=0.187 //l=0.4 //layer=li //thickness=0.1 \
 //x=8.41 //y=0.53 //x2=8.81 //y2=0.53
r73 (  13 29 ) resistor r=3.57586 //w=0.17 //l=0.103078 //layer=li \
 //thickness=0.1 //x=9.21 //y=0.53 //x2=9.295 //y2=0.49
r74 (  13 29 ) resistor r=27.3797 //w=0.187 //l=0.4 //layer=li //thickness=0.1 \
 //x=9.21 //y=0.53 //x2=8.81 //y2=0.53
r75 (  10 29 ) resistor r=3.57586 //w=0.17 //l=0.125 //layer=li \
 //thickness=0.1 //x=8.325 //y=1.495 //x2=8.325 //y2=1.62
r76 (  10 29 ) resistor r=42.0963 //w=0.187 //l=0.615 //layer=li \
 //thickness=0.1 //x=8.325 //y=1.495 //x2=8.325 //y2=0.88
r77 (  9 29 ) resistor r=3.57586 //w=0.17 //l=0.125 //layer=li //thickness=0.1 \
 //x=8.325 //y=0.615 //x2=8.325 //y2=0.49
r78 (  9 29 ) resistor r=18.139 //w=0.187 //l=0.265 //layer=li //thickness=0.1 \
 //x=8.325 //y=0.615 //x2=8.325 //y2=0.88
r79 (  6 29 ) resistor r=3.57586 //w=0.17 //l=0.103078 //layer=li \
 //thickness=0.1 //x=7.44 //y=1.58 //x2=7.355 //y2=1.62
r80 (  6 29 ) resistor r=27.3797 //w=0.187 //l=0.4 //layer=li //thickness=0.1 \
 //x=7.44 //y=1.58 //x2=7.84 //y2=1.58
r81 (  5 29 ) resistor r=3.57586 //w=0.17 //l=0.103078 //layer=li \
 //thickness=0.1 //x=8.24 //y=1.58 //x2=8.325 //y2=1.62
r82 (  5 29 ) resistor r=27.3797 //w=0.187 //l=0.4 //layer=li //thickness=0.1 \
 //x=8.24 //y=1.58 //x2=7.84 //y2=1.58
r83 (  1 29 ) resistor r=3.57586 //w=0.17 //l=0.125 //layer=li //thickness=0.1 \
 //x=7.355 //y=1.495 //x2=7.355 //y2=1.62
r84 (  1 29 ) resistor r=42.0963 //w=0.187 //l=0.615 //layer=li \
 //thickness=0.1 //x=7.355 //y=1.495 //x2=7.355 //y2=0.88
ends PM_VOTERN3X1_PCELL\%noxref_13
