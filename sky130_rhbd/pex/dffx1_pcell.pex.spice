// File: dffx1_pcell.spi.pex
// Created: Sun Mar 15 12:49:24 2026
// Program "Calibre xRC"
// Version "v2023.2_27.15"
// Nominal Temperature: 30C
// Circuit Temperature: 30C
//
simulator lang=spectre
subckt PM_DFFX1_PCELL\%noxref_1 ( 1 2 3 4 7 12 13 15 16 18 19 20 22 23 30 34 \
 35 38 40 43 48 50 53 54 56 57 58 60 62 65 72 73 76 85 90 98 115 124 128 129 \
 130 131 132 133 137 138 139 144 146 149 150 151 152 153 154 158 160 163 164 \
 169 170 175 184 187 189 190 )
c410 ( 187 0 ) capacitor c=0.00878249f //x=6.77 //y=0.905
c411 ( 184 0 ) capacitor c=0.0682508f //x=9.25 //y=4.7
c412 ( 175 0 ) capacitor c=0.0710066f //x=3.33 //y=4.7
c413 ( 170 0 ) capacitor c=0.0278202f //x=3.33 //y=1.915
c414 ( 169 0 ) capacitor c=0.0479324f //x=3.33 //y=2.08
c415 ( 164 0 ) capacitor c=0.0318956f //x=9.585 //y=1.21
c416 ( 163 0 ) capacitor c=0.0186809f //x=9.585 //y=0.865
c417 ( 160 0 ) capacitor c=0.0141821f //x=9.43 //y=1.365
c418 ( 158 0 ) capacitor c=0.0158553f //x=9.43 //y=0.71
c419 ( 154 0 ) capacitor c=0.0854171f //x=9.055 //y=1.915
c420 ( 153 0 ) capacitor c=0.0229235f //x=9.055 //y=1.52
c421 ( 152 0 ) capacitor c=0.0234359f //x=9.055 //y=1.21
c422 ( 151 0 ) capacitor c=0.0198759f //x=9.055 //y=0.865
c423 ( 150 0 ) capacitor c=0.0443175f //x=3.85 //y=1.26
c424 ( 149 0 ) capacitor c=0.0199703f //x=3.85 //y=0.915
c425 ( 146 0 ) capacitor c=0.0162526f //x=3.695 //y=1.415
c426 ( 144 0 ) capacitor c=0.0157807f //x=3.695 //y=0.76
c427 ( 139 0 ) capacitor c=0.0220935f //x=3.32 //y=1.57
c428 ( 138 0 ) capacitor c=0.0207489f //x=3.32 //y=1.26
c429 ( 137 0 ) capacitor c=0.0194091f //x=3.32 //y=0.915
c430 ( 133 0 ) capacitor c=0.110369f //x=9.59 //y=6.02
c431 ( 132 0 ) capacitor c=0.154619f //x=9.15 //y=6.02
c432 ( 131 0 ) capacitor c=0.159671f //x=3.51 //y=6.02
c433 ( 130 0 ) capacitor c=0.110208f //x=3.07 //y=6.02
c434 ( 124 0 ) capacitor c=8.13451e-19 //x=9.25 //y=4.7
c435 ( 115 0 ) capacitor c=7.85889e-19 //x=9.25 //y=2.08
c436 ( 98 0 ) capacitor c=0.0322017f //x=6.92 //y=5.38
c437 ( 90 0 ) capacitor c=0.0290186f //x=6.04 //y=5.38
c438 ( 85 0 ) capacitor c=8.10973e-19 //x=3.33 //y=4.7
c439 ( 76 0 ) capacitor c=0.00101179f //x=3.33 //y=2.08
c440 ( 73 0 ) capacitor c=0.0504173f //x=9.085 //y=3.325
c441 ( 72 0 ) capacitor c=0.00163142f //x=9.245 //y=3.325
c442 ( 65 0 ) capacitor c=0.0259007f //x=7.555 //y=3.33
c443 ( 62 0 ) capacitor c=0.00684519f //x=6.13 //y=3.315
c444 ( 60 0 ) capacitor c=0.0382613f //x=5.53 //y=3.33
c445 ( 58 0 ) capacitor c=0.018822f //x=4.285 //y=3.315
c446 ( 57 0 ) capacitor c=0.00325528f //x=3.495 //y=3.33
c447 ( 56 0 ) capacitor c=0.00669908f //x=3.685 //y=3.33
c448 ( 54 0 ) capacitor c=0.0267314f //x=9.252 //y=4.56
c449 ( 53 0 ) capacitor c=0.00611287f //x=9.25 //y=4.7
c450 ( 50 0 ) capacitor c=0.0064096f //x=9.25 //y=2.08
c451 ( 48 0 ) capacitor c=0.0163473f //x=9.25 //y=3.33
c452 ( 43 0 ) capacitor c=0.0170489f //x=7.395 //y=3.33
c453 ( 40 0 ) capacitor c=0.0114531f //x=6.96 //y=1
c454 ( 38 0 ) capacitor c=5.78613e-19 //x=6.92 //y=5.38
c455 ( 35 0 ) capacitor c=0.0105334f //x=6.92 //y=5.2
c456 ( 34 0 ) capacitor c=0.00923791f //x=6.04 //y=5.38
c457 ( 30 0 ) capacitor c=0.0148558f //x=3.33 //y=3.33
c458 ( 23 0 ) capacitor c=0.0133021f //x=9.25 //y=3.485
c459 ( 22 0 ) capacitor c=0.0288905f //x=9.25 //y=3.165
c460 ( 20 0 ) capacitor c=0.0405859f //x=7.4 //y=5.115
c461 ( 19 0 ) capacitor c=0.0134934f //x=7.4 //y=3.49
c462 ( 18 0 ) capacitor c=0.0397593f //x=7.4 //y=3.17
c463 ( 16 0 ) capacitor c=0.00653562f //x=7.045 //y=1.655
c464 ( 15 0 ) capacitor c=0.013278f //x=7.315 //y=1.655
c465 ( 13 0 ) capacitor c=0.0108105f //x=7.315 //y=5.2
c466 ( 12 0 ) capacitor c=0.0102514f //x=6.96 //y=1.57
c467 ( 7 0 ) capacitor c=0.0150818f //x=6.805 //y=5.2
c468 ( 4 0 ) capacitor c=0.0286377f //x=3.33 //y=4.57
c469 ( 3 0 ) capacitor c=0.0126136f //x=3.33 //y=3.49
c470 ( 2 0 ) capacitor c=0.0274817f //x=3.33 //y=3.17
c471 ( 1 0 ) capacitor c=0.00685053f //x=3.33 //y=2.195
r472 (  182 184 ) resistor r=20.6867 //w=0.233 //l=0.1 //layer=ply \
 //thickness=0.18 //x=9.15 //y=4.7 //x2=9.25 //y2=4.7
r473 (  169 170 ) resistor r=52.7279 //w=0.214 //l=0.165 //layer=ply \
 //thickness=0.18 //x=3.33 //y=2.08 //x2=3.33 //y2=1.915
r474 (  165 184 ) resistor r=70.3348 //w=0.233 //l=0.414367 //layer=ply \
 //thickness=0.18 //x=9.59 //y=4.865 //x2=9.25 //y2=4.7
r475 (  164 186 ) resistor r=45.1352 //w=0.168 //l=0.173853 //layer=ply \
 //thickness=0.18 //x=9.585 //y=1.21 //x2=9.545 //y2=1.365
r476 (  163 185 ) resistor r=45.1352 //w=0.168 //l=0.173853 //layer=ply \
 //thickness=0.18 //x=9.585 //y=0.865 //x2=9.545 //y2=0.71
r477 (  163 164 ) resistor r=176.904 //w=0.094 //l=0.345 //layer=ply \
 //thickness=0.18 //x=9.585 //y=0.865 //x2=9.585 //y2=1.21
r478 (  161 181 ) resistor r=10.701 //w=0.21 //l=0.115 //layer=ply \
 //thickness=0.18 //x=9.21 //y=1.365 //x2=9.095 //y2=1.365
r479 (  160 186 ) resistor r=5.52526 //w=0.168 //l=0.115 //layer=ply \
 //thickness=0.18 //x=9.43 //y=1.365 //x2=9.545 //y2=1.365
r480 (  159 180 ) resistor r=5.52526 //w=0.168 //l=0.115 //layer=ply \
 //thickness=0.18 //x=9.21 //y=0.71 //x2=9.095 //y2=0.71
r481 (  158 185 ) resistor r=5.52526 //w=0.168 //l=0.115 //layer=ply \
 //thickness=0.18 //x=9.43 //y=0.71 //x2=9.545 //y2=0.71
r482 (  158 159 ) resistor r=112.809 //w=0.094 //l=0.22 //layer=ply \
 //thickness=0.18 //x=9.43 //y=0.71 //x2=9.21 //y2=0.71
r483 (  155 182 ) resistor r=13.0941 //w=0.233 //l=0.165 //layer=ply \
 //thickness=0.18 //x=9.15 //y=4.865 //x2=9.15 //y2=4.7
r484 (  154 179 ) resistor r=34.8111 //w=0.27 //l=0.264953 //layer=ply \
 //thickness=0.18 //x=9.055 //y=1.915 //x2=9.25 //y2=2.08
r485 (  153 181 ) resistor r=39.5823 //w=0.21 //l=0.173853 //layer=ply \
 //thickness=0.18 //x=9.055 //y=1.52 //x2=9.095 //y2=1.365
r486 (  153 154 ) resistor r=202.543 //w=0.094 //l=0.395 //layer=ply \
 //thickness=0.18 //x=9.055 //y=1.52 //x2=9.055 //y2=1.915
r487 (  152 181 ) resistor r=39.5823 //w=0.21 //l=0.173853 //layer=ply \
 //thickness=0.18 //x=9.055 //y=1.21 //x2=9.095 //y2=1.365
r488 (  151 180 ) resistor r=45.1352 //w=0.168 //l=0.173853 //layer=ply \
 //thickness=0.18 //x=9.055 //y=0.865 //x2=9.095 //y2=0.71
r489 (  151 152 ) resistor r=176.904 //w=0.094 //l=0.345 //layer=ply \
 //thickness=0.18 //x=9.055 //y=0.865 //x2=9.055 //y2=1.21
r490 (  150 177 ) resistor r=45.1352 //w=0.168 //l=0.173853 //layer=ply \
 //thickness=0.18 //x=3.85 //y=1.26 //x2=3.81 //y2=1.415
r491 (  149 176 ) resistor r=45.1352 //w=0.168 //l=0.173853 //layer=ply \
 //thickness=0.18 //x=3.85 //y=0.915 //x2=3.81 //y2=0.76
r492 (  149 150 ) resistor r=176.904 //w=0.094 //l=0.345 //layer=ply \
 //thickness=0.18 //x=3.85 //y=0.915 //x2=3.85 //y2=1.26
r493 (  147 173 ) resistor r=10.701 //w=0.21 //l=0.115 //layer=ply \
 //thickness=0.18 //x=3.475 //y=1.415 //x2=3.36 //y2=1.415
r494 (  146 177 ) resistor r=5.52526 //w=0.168 //l=0.115 //layer=ply \
 //thickness=0.18 //x=3.695 //y=1.415 //x2=3.81 //y2=1.415
r495 (  145 172 ) resistor r=5.52526 //w=0.168 //l=0.115 //layer=ply \
 //thickness=0.18 //x=3.475 //y=0.76 //x2=3.36 //y2=0.76
r496 (  144 176 ) resistor r=5.52526 //w=0.168 //l=0.115 //layer=ply \
 //thickness=0.18 //x=3.695 //y=0.76 //x2=3.81 //y2=0.76
r497 (  144 145 ) resistor r=112.809 //w=0.094 //l=0.22 //layer=ply \
 //thickness=0.18 //x=3.695 //y=0.76 //x2=3.475 //y2=0.76
r498 (  141 175 ) resistor r=37.236 //w=0.233 //l=0.249199 //layer=ply \
 //thickness=0.18 //x=3.51 //y=4.865 //x2=3.33 //y2=4.7
r499 (  139 173 ) resistor r=39.5823 //w=0.21 //l=0.173853 //layer=ply \
 //thickness=0.18 //x=3.32 //y=1.57 //x2=3.36 //y2=1.415
r500 (  139 170 ) resistor r=176.904 //w=0.094 //l=0.345 //layer=ply \
 //thickness=0.18 //x=3.32 //y=1.57 //x2=3.32 //y2=1.915
r501 (  138 173 ) resistor r=39.5823 //w=0.21 //l=0.173853 //layer=ply \
 //thickness=0.18 //x=3.32 //y=1.26 //x2=3.36 //y2=1.415
r502 (  137 172 ) resistor r=45.1352 //w=0.168 //l=0.173853 //layer=ply \
 //thickness=0.18 //x=3.32 //y=0.915 //x2=3.36 //y2=0.76
r503 (  137 138 ) resistor r=176.904 //w=0.094 //l=0.345 //layer=ply \
 //thickness=0.18 //x=3.32 //y=0.915 //x2=3.32 //y2=1.26
r504 (  134 175 ) resistor r=53.7854 //w=0.233 //l=0.332415 //layer=ply \
 //thickness=0.18 //x=3.07 //y=4.865 //x2=3.33 //y2=4.7
r505 (  133 165 ) resistor r=592.245 //w=0.094 //l=1.155 //layer=ply \
 //thickness=0.18 //x=9.59 //y=6.02 //x2=9.59 //y2=4.865
r506 (  132 155 ) resistor r=592.245 //w=0.094 //l=1.155 //layer=ply \
 //thickness=0.18 //x=9.15 //y=6.02 //x2=9.15 //y2=4.865
r507 (  131 141 ) resistor r=592.245 //w=0.094 //l=1.155 //layer=ply \
 //thickness=0.18 //x=3.51 //y=6.02 //x2=3.51 //y2=4.865
r508 (  130 134 ) resistor r=592.245 //w=0.094 //l=1.155 //layer=ply \
 //thickness=0.18 //x=3.07 //y=6.02 //x2=3.07 //y2=4.865
r509 (  129 160 ) resistor r=56.4043 //w=0.094 //l=0.11 //layer=ply \
 //thickness=0.18 //x=9.32 //y=1.365 //x2=9.43 //y2=1.365
r510 (  129 161 ) resistor r=56.4043 //w=0.094 //l=0.11 //layer=ply \
 //thickness=0.18 //x=9.32 //y=1.365 //x2=9.21 //y2=1.365
r511 (  128 146 ) resistor r=56.4043 //w=0.094 //l=0.11 //layer=ply \
 //thickness=0.18 //x=3.585 //y=1.415 //x2=3.695 //y2=1.415
r512 (  128 147 ) resistor r=56.4043 //w=0.094 //l=0.11 //layer=ply \
 //thickness=0.18 //x=3.585 //y=1.415 //x2=3.475 //y2=1.415
r513 (  124 184 ) resistor r=152 //w=0.17 //l=0.17 //layer=licon //count=1 \
 //x=9.25 //y=4.7 //x2=9.25 //y2=4.7
r514 (  115 179 ) resistor r=152 //w=0.17 //l=0.17 //layer=licon //count=1 \
 //x=9.25 //y=2.08 //x2=9.25 //y2=2.08
r515 (  98 190 ) resistor r=23.615 //w=0.187 //l=0.345 //layer=li \
 //thickness=0.1 //x=6.92 //y=5.38 //x2=6.92 //y2=5.725
r516 (  90 189 ) resistor r=23.615 //w=0.187 //l=0.345 //layer=li \
 //thickness=0.1 //x=6.04 //y=5.38 //x2=6.04 //y2=5.725
r517 (  85 175 ) resistor r=152 //w=0.17 //l=0.17 //layer=licon //count=1 \
 //x=3.33 //y=4.7 //x2=3.33 //y2=4.7
r518 (  76 169 ) resistor r=152 //w=0.17 //l=0.17 //layer=licon //count=1 \
 //x=3.33 //y=2.08 //x2=3.33 //y2=2.08
r519 (  72 73 ) resistor r=0.10734 //w=0.281 //l=0.16 //layer=m2 \
 //thickness=0.36 //x=9.245 //y=3.325 //x2=9.085 //y2=3.325
r520 (  65 70 ) resistor r=0.10188 //w=0.204 //l=0.16 //layer=m2 \
 //thickness=0.36 //x=7.555 //y=3.33 //x2=7.395 //y2=3.33
r521 (  65 73 ) resistor r=1.45992 //w=0.131 //l=1.53 //layer=m2 \
 //thickness=0.36 //x=7.555 //y=3.33 //x2=9.085 //y2=3.33
r522 (  62 70 ) resistor r=0.778963 //w=0.204 //l=1.27248 //layer=m2 \
 //thickness=0.36 //x=6.13 //y=3.315 //x2=7.395 //y2=3.33
r523 (  62 63 ) resistor r=0.410305 //w=0.131 //l=0.43 //layer=m2 \
 //thickness=0.36 //x=6.13 //y=3.315 //x2=5.7 //y2=3.315
r524 (  60 63 ) resistor r=0.125 //w=0.17 //l=0.177341 //layer=m2 \
 //thickness=0.36 //x=5.53 //y=3.33 //x2=5.7 //y2=3.315
r525 (  60 61 ) resistor r=0.944656 //w=0.131 //l=0.99 //layer=m2 \
 //thickness=0.36 //x=5.53 //y=3.33 //x2=4.54 //y2=3.33
r526 (  58 61 ) resistor r=0.1875 //w=0.17 //l=0.262393 //layer=m2 \
 //thickness=0.36 //x=4.285 //y=3.315 //x2=4.54 //y2=3.33
r527 (  58 59 ) resistor r=0.410305 //w=0.131 //l=0.43 //layer=m2 \
 //thickness=0.36 //x=4.285 //y=3.315 //x2=3.855 //y2=3.315
r528 (  57 67 ) resistor r=0.10734 //w=0.281 //l=0.16 //layer=m2 \
 //thickness=0.36 //x=3.495 //y=3.33 //x2=3.335 //y2=3.33
r529 (  56 59 ) resistor r=0.125 //w=0.17 //l=0.177341 //layer=m2 \
 //thickness=0.36 //x=3.685 //y=3.33 //x2=3.855 //y2=3.315
r530 (  56 57 ) resistor r=0.181298 //w=0.131 //l=0.19 //layer=m2 \
 //thickness=0.36 //x=3.685 //y=3.33 //x2=3.495 //y2=3.33
r531 (  53 124 ) resistor r=9.3 //w=0.17 //l=0.17 //layer=mcon //count=1 \
 //x=9.25 //y=4.7 //x2=9.25 //y2=4.7
r532 (  53 54 ) resistor r=0.103207 //w=0.196 //l=0.14 //layer=m1 \
 //thickness=0.36 //x=9.252 //y=4.7 //x2=9.252 //y2=4.56
r533 (  50 115 ) resistor r=9.3 //w=0.17 //l=0.17 //layer=mcon //count=1 \
 //x=9.25 //y=2.08 //x2=9.25 //y2=2.08
r534 (  46 72 ) resistor r=4.5 //w=0.15 //l=0.15 //layer=via1 //count=1 \
 //x=9.245 //y=3.325 //x2=9.245 //y2=3.325
r535 (  46 48 ) resistor r=0.00167112 //w=0.374 //l=0.005 //layer=m1 \
 //thickness=0.36 //x=9.195 //y=3.325 //x2=9.195 //y2=3.33
r536 (  43 70 ) resistor r=4.5 //w=0.15 //l=0.15 //layer=via1 //count=1 \
 //x=7.395 //y=3.33 //x2=7.395 //y2=3.33
r537 (  40 187 ) resistor r=9.3 //w=0.17 //l=0.17 //layer=mcon //count=1 \
 //x=6.96 //y=1 //x2=6.96 //y2=1
r538 (  38 98 ) resistor r=9.3 //w=0.17 //l=0.17 //layer=mcon //count=1 \
 //x=6.92 //y=5.38 //x2=6.92 //y2=5.38
r539 (  35 38 ) resistor r=0.117801 //w=0.191 //l=0.18 //layer=m1 \
 //thickness=0.36 //x=6.92 //y=5.2 //x2=6.92 //y2=5.38
r540 (  34 90 ) resistor r=9.3 //w=0.17 //l=0.17 //layer=mcon //count=1 \
 //x=6.04 //y=5.38 //x2=6.04 //y2=5.38
r541 (  32 34 ) resistor r=0.10274 //w=0.219 //l=0.18 //layer=m1 \
 //thickness=0.36 //x=6.04 //y=5.2 //x2=6.04 //y2=5.38
r542 (  30 67 ) resistor r=4.5 //w=0.15 //l=0.15 //layer=via1 //count=1 \
 //x=3.335 //y=3.33 //x2=3.335 //y2=3.33
r543 (  28 85 ) resistor r=9.3 //w=0.17 //l=0.17 //layer=mcon //count=1 \
 //x=3.33 //y=4.7 //x2=3.33 //y2=4.7
r544 (  26 76 ) resistor r=9.3 //w=0.17 //l=0.17 //layer=mcon //count=1 \
 //x=3.33 //y=2.08 //x2=3.33 //y2=2.08
r545 (  23 48 ) resistor r=0.089409 //w=0.374 //l=0.180416 //layer=m1 \
 //thickness=0.36 //x=9.25 //y=3.485 //x2=9.195 //y2=3.33
r546 (  23 54 ) resistor r=1.02576 //w=0.131 //l=1.075 //layer=m1 \
 //thickness=0.36 //x=9.25 //y=3.485 //x2=9.25 //y2=4.56
r547 (  22 46 ) resistor r=0.0910802 //w=0.374 //l=0.185472 //layer=m1 \
 //thickness=0.36 //x=9.25 //y=3.165 //x2=9.195 //y2=3.325
r548 (  21 50 ) resistor r=0.0933015 //w=0.201 //l=0.125 //layer=m1 \
 //thickness=0.36 //x=9.25 //y=2.205 //x2=9.25 //y2=2.08
r549 (  21 22 ) resistor r=0.916031 //w=0.131 //l=0.96 //layer=m1 \
 //thickness=0.36 //x=9.25 //y=2.205 //x2=9.25 //y2=3.165
r550 (  19 43 ) resistor r=0.0910802 //w=0.374 //l=0.185472 //layer=m1 \
 //thickness=0.36 //x=7.4 //y=3.49 //x2=7.345 //y2=3.33
r551 (  19 20 ) resistor r=1.55057 //w=0.131 //l=1.625 //layer=m1 \
 //thickness=0.36 //x=7.4 //y=3.49 //x2=7.4 //y2=5.115
r552 (  18 43 ) resistor r=0.0910802 //w=0.374 //l=0.185472 //layer=m1 \
 //thickness=0.36 //x=7.4 //y=3.17 //x2=7.345 //y2=3.33
r553 (  17 18 ) resistor r=1.3645 //w=0.131 //l=1.43 //layer=m1 \
 //thickness=0.36 //x=7.4 //y=1.74 //x2=7.4 //y2=3.17
r554 (  15 17 ) resistor r=0.0698411 //w=0.17 //l=0.120208 //layer=m1 \
 //thickness=0.36 //x=7.315 //y=1.655 //x2=7.4 //y2=1.74
r555 (  15 16 ) resistor r=0.257634 //w=0.131 //l=0.27 //layer=m1 \
 //thickness=0.36 //x=7.315 //y=1.655 //x2=7.045 //y2=1.655
r556 (  14 35 ) resistor r=0.0257089 //w=0.23 //l=0.115 //layer=m1 \
 //thickness=0.36 //x=7.035 //y=5.2 //x2=6.92 //y2=5.2
r557 (  13 20 ) resistor r=0.0698411 //w=0.17 //l=0.120208 //layer=m1 \
 //thickness=0.36 //x=7.315 //y=5.2 //x2=7.4 //y2=5.115
r558 (  13 14 ) resistor r=0.267176 //w=0.131 //l=0.28 //layer=m1 \
 //thickness=0.36 //x=7.315 //y=5.2 //x2=7.035 //y2=5.2
r559 (  12 16 ) resistor r=0.0698411 //w=0.17 //l=0.120208 //layer=m1 \
 //thickness=0.36 //x=6.96 //y=1.57 //x2=7.045 //y2=1.655
r560 (  11 40 ) resistor r=0.0913624 //w=0.191 //l=0.12 //layer=m1 \
 //thickness=0.36 //x=6.96 //y=1.12 //x2=6.96 //y2=1
r561 (  11 12 ) resistor r=0.429389 //w=0.131 //l=0.45 //layer=m1 \
 //thickness=0.36 //x=6.96 //y=1.12 //x2=6.96 //y2=1.57
r562 (  8 32 ) resistor r=0.0227762 //w=0.219 //l=0.115 //layer=m1 \
 //thickness=0.36 //x=6.155 //y=5.2 //x2=6.04 //y2=5.2
r563 (  7 35 ) resistor r=0.0257089 //w=0.23 //l=0.115 //layer=m1 \
 //thickness=0.36 //x=6.805 //y=5.2 //x2=6.92 //y2=5.2
r564 (  7 8 ) resistor r=0.620229 //w=0.131 //l=0.65 //layer=m1 \
 //thickness=0.36 //x=6.805 //y=5.2 //x2=6.155 //y2=5.2
r565 (  4 28 ) resistor r=0.0801089 //w=0.224 //l=0.13 //layer=m1 \
 //thickness=0.36 //x=3.33 //y=4.57 //x2=3.33 //y2=4.7
r566 (  3 30 ) resistor r=0.0910802 //w=0.374 //l=0.185472 //layer=m1 \
 //thickness=0.36 //x=3.33 //y=3.49 //x2=3.385 //y2=3.33
r567 (  3 4 ) resistor r=1.03053 //w=0.131 //l=1.08 //layer=m1 \
 //thickness=0.36 //x=3.33 //y=3.49 //x2=3.33 //y2=4.57
r568 (  2 30 ) resistor r=0.0910802 //w=0.374 //l=0.185472 //layer=m1 \
 //thickness=0.36 //x=3.33 //y=3.17 //x2=3.385 //y2=3.33
r569 (  1 26 ) resistor r=0.0719237 //w=0.222 //l=0.115 //layer=m1 \
 //thickness=0.36 //x=3.33 //y=2.195 //x2=3.33 //y2=2.08
r570 (  1 2 ) resistor r=0.930344 //w=0.131 //l=0.975 //layer=m1 \
 //thickness=0.36 //x=3.33 //y=2.195 //x2=3.33 //y2=3.17
ends PM_DFFX1_PCELL\%noxref_1

subckt PM_DFFX1_PCELL\%noxref_2 ( 3 8 9 11 12 14 15 16 18 19 23 24 27 29 32 35 \
 38 41 42 44 45 50 53 61 78 87 91 92 93 94 95 96 97 101 103 106 107 117 120 \
 122 123 )
c276 ( 120 0 ) capacitor c=0.00878249f //x=10.1 //y=0.905
c277 ( 117 0 ) capacitor c=0.0682508f //x=12.58 //y=4.7
c278 ( 107 0 ) capacitor c=0.0318956f //x=12.915 //y=1.21
c279 ( 106 0 ) capacitor c=0.0186809f //x=12.915 //y=0.865
c280 ( 103 0 ) capacitor c=0.0141821f //x=12.76 //y=1.365
c281 ( 101 0 ) capacitor c=0.0158553f //x=12.76 //y=0.71
c282 ( 97 0 ) capacitor c=0.0854195f //x=12.385 //y=1.915
c283 ( 96 0 ) capacitor c=0.0229235f //x=12.385 //y=1.52
c284 ( 95 0 ) capacitor c=0.0234359f //x=12.385 //y=1.21
c285 ( 94 0 ) capacitor c=0.0198759f //x=12.385 //y=0.865
c286 ( 93 0 ) capacitor c=0.110369f //x=12.92 //y=6.02
c287 ( 92 0 ) capacitor c=0.154619f //x=12.48 //y=6.02
c288 ( 87 0 ) capacitor c=8.13451e-19 //x=12.58 //y=4.7
c289 ( 78 0 ) capacitor c=7.85889e-19 //x=12.58 //y=2.08
c290 ( 61 0 ) capacitor c=0.0322017f //x=10.25 //y=5.38
c291 ( 53 0 ) capacitor c=0.0291714f //x=9.37 //y=5.38
c292 ( 50 0 ) capacitor c=0.00162839f //x=12.575 //y=3.33
c293 ( 45 0 ) capacitor c=0.00317997f //x=10.895 //y=3.33
c294 ( 44 0 ) capacitor c=0.0479792f //x=12.415 //y=3.33
c295 ( 42 0 ) capacitor c=0.0270867f //x=12.582 //y=4.56
c296 ( 41 0 ) capacitor c=0.0060492f //x=12.58 //y=4.7
c297 ( 38 0 ) capacitor c=0.00641145f //x=12.58 //y=2.08
c298 ( 35 0 ) capacitor c=0.0164425f //x=12.575 //y=3.33
c299 ( 32 0 ) capacitor c=0.0167895f //x=10.73 //y=3.33
c300 ( 29 0 ) capacitor c=0.0114498f //x=10.29 //y=1
c301 ( 27 0 ) capacitor c=5.78613e-19 //x=10.25 //y=5.38
c302 ( 24 0 ) capacitor c=0.0103127f //x=10.25 //y=5.2
c303 ( 23 0 ) capacitor c=0.00933334f //x=9.37 //y=5.38
c304 ( 19 0 ) capacitor c=0.0132502f //x=12.58 //y=3.49
c305 ( 18 0 ) capacitor c=0.0289239f //x=12.58 //y=3.17
c306 ( 16 0 ) capacitor c=0.0402153f //x=10.73 //y=5.115
c307 ( 15 0 ) capacitor c=0.0132747f //x=10.73 //y=3.49
c308 ( 14 0 ) capacitor c=0.0397593f //x=10.73 //y=3.17
c309 ( 12 0 ) capacitor c=0.00671763f //x=10.375 //y=1.655
c310 ( 11 0 ) capacitor c=0.0143344f //x=10.645 //y=1.655
c311 ( 9 0 ) capacitor c=0.0112475f //x=10.645 //y=5.2
c312 ( 8 0 ) capacitor c=0.0101547f //x=10.29 //y=1.57
c313 ( 3 0 ) capacitor c=0.0134484f //x=10.135 //y=5.2
r314 (  115 117 ) resistor r=20.6867 //w=0.233 //l=0.1 //layer=ply \
 //thickness=0.18 //x=12.48 //y=4.7 //x2=12.58 //y2=4.7
r315 (  108 117 ) resistor r=70.3348 //w=0.233 //l=0.414367 //layer=ply \
 //thickness=0.18 //x=12.92 //y=4.865 //x2=12.58 //y2=4.7
r316 (  107 119 ) resistor r=45.1352 //w=0.168 //l=0.173853 //layer=ply \
 //thickness=0.18 //x=12.915 //y=1.21 //x2=12.875 //y2=1.365
r317 (  106 118 ) resistor r=45.1352 //w=0.168 //l=0.173853 //layer=ply \
 //thickness=0.18 //x=12.915 //y=0.865 //x2=12.875 //y2=0.71
r318 (  106 107 ) resistor r=176.904 //w=0.094 //l=0.345 //layer=ply \
 //thickness=0.18 //x=12.915 //y=0.865 //x2=12.915 //y2=1.21
r319 (  104 114 ) resistor r=10.701 //w=0.21 //l=0.115 //layer=ply \
 //thickness=0.18 //x=12.54 //y=1.365 //x2=12.425 //y2=1.365
r320 (  103 119 ) resistor r=5.52526 //w=0.168 //l=0.115 //layer=ply \
 //thickness=0.18 //x=12.76 //y=1.365 //x2=12.875 //y2=1.365
r321 (  102 113 ) resistor r=5.52526 //w=0.168 //l=0.115 //layer=ply \
 //thickness=0.18 //x=12.54 //y=0.71 //x2=12.425 //y2=0.71
r322 (  101 118 ) resistor r=5.52526 //w=0.168 //l=0.115 //layer=ply \
 //thickness=0.18 //x=12.76 //y=0.71 //x2=12.875 //y2=0.71
r323 (  101 102 ) resistor r=112.809 //w=0.094 //l=0.22 //layer=ply \
 //thickness=0.18 //x=12.76 //y=0.71 //x2=12.54 //y2=0.71
r324 (  98 115 ) resistor r=13.0941 //w=0.233 //l=0.165 //layer=ply \
 //thickness=0.18 //x=12.48 //y=4.865 //x2=12.48 //y2=4.7
r325 (  97 112 ) resistor r=34.8111 //w=0.27 //l=0.264953 //layer=ply \
 //thickness=0.18 //x=12.385 //y=1.915 //x2=12.58 //y2=2.08
r326 (  96 114 ) resistor r=39.5823 //w=0.21 //l=0.173853 //layer=ply \
 //thickness=0.18 //x=12.385 //y=1.52 //x2=12.425 //y2=1.365
r327 (  96 97 ) resistor r=202.543 //w=0.094 //l=0.395 //layer=ply \
 //thickness=0.18 //x=12.385 //y=1.52 //x2=12.385 //y2=1.915
r328 (  95 114 ) resistor r=39.5823 //w=0.21 //l=0.173853 //layer=ply \
 //thickness=0.18 //x=12.385 //y=1.21 //x2=12.425 //y2=1.365
r329 (  94 113 ) resistor r=45.1352 //w=0.168 //l=0.173853 //layer=ply \
 //thickness=0.18 //x=12.385 //y=0.865 //x2=12.425 //y2=0.71
r330 (  94 95 ) resistor r=176.904 //w=0.094 //l=0.345 //layer=ply \
 //thickness=0.18 //x=12.385 //y=0.865 //x2=12.385 //y2=1.21
r331 (  93 108 ) resistor r=592.245 //w=0.094 //l=1.155 //layer=ply \
 //thickness=0.18 //x=12.92 //y=6.02 //x2=12.92 //y2=4.865
r332 (  92 98 ) resistor r=592.245 //w=0.094 //l=1.155 //layer=ply \
 //thickness=0.18 //x=12.48 //y=6.02 //x2=12.48 //y2=4.865
r333 (  91 103 ) resistor r=56.4043 //w=0.094 //l=0.11 //layer=ply \
 //thickness=0.18 //x=12.65 //y=1.365 //x2=12.76 //y2=1.365
r334 (  91 104 ) resistor r=56.4043 //w=0.094 //l=0.11 //layer=ply \
 //thickness=0.18 //x=12.65 //y=1.365 //x2=12.54 //y2=1.365
r335 (  87 117 ) resistor r=152 //w=0.17 //l=0.17 //layer=licon //count=1 \
 //x=12.58 //y=4.7 //x2=12.58 //y2=4.7
r336 (  78 112 ) resistor r=152 //w=0.17 //l=0.17 //layer=licon //count=1 \
 //x=12.58 //y=2.08 //x2=12.58 //y2=2.08
r337 (  61 123 ) resistor r=23.615 //w=0.187 //l=0.345 //layer=li \
 //thickness=0.1 //x=10.25 //y=5.38 //x2=10.25 //y2=5.725
r338 (  53 122 ) resistor r=23.615 //w=0.187 //l=0.345 //layer=li \
 //thickness=0.1 //x=9.37 //y=5.38 //x2=9.37 //y2=5.725
r339 (  45 47 ) resistor r=0.10734 //w=0.281 //l=0.16 //layer=m2 \
 //thickness=0.36 //x=10.895 //y=3.33 //x2=10.735 //y2=3.33
r340 (  44 50 ) resistor r=0.10734 //w=0.281 //l=0.16 //layer=m2 \
 //thickness=0.36 //x=12.415 //y=3.33 //x2=12.575 //y2=3.33
r341 (  44 45 ) resistor r=1.45038 //w=0.131 //l=1.52 //layer=m2 \
 //thickness=0.36 //x=12.415 //y=3.33 //x2=10.895 //y2=3.33
r342 (  41 87 ) resistor r=9.3 //w=0.17 //l=0.17 //layer=mcon //count=1 \
 //x=12.58 //y=4.7 //x2=12.58 //y2=4.7
r343 (  41 42 ) resistor r=0.103207 //w=0.196 //l=0.14 //layer=m1 \
 //thickness=0.36 //x=12.582 //y=4.7 //x2=12.582 //y2=4.56
r344 (  38 78 ) resistor r=9.3 //w=0.17 //l=0.17 //layer=mcon //count=1 \
 //x=12.58 //y=2.08 //x2=12.58 //y2=2.08
r345 (  35 50 ) resistor r=4.5 //w=0.15 //l=0.15 //layer=via1 //count=1 \
 //x=12.575 //y=3.33 //x2=12.575 //y2=3.33
r346 (  32 47 ) resistor r=4.5 //w=0.15 //l=0.15 //layer=via1 //count=1 \
 //x=10.735 //y=3.33 //x2=10.735 //y2=3.33
r347 (  29 120 ) resistor r=9.3 //w=0.17 //l=0.17 //layer=mcon //count=1 \
 //x=10.29 //y=1 //x2=10.29 //y2=1
r348 (  27 61 ) resistor r=9.3 //w=0.17 //l=0.17 //layer=mcon //count=1 \
 //x=10.25 //y=5.38 //x2=10.25 //y2=5.38
r349 (  24 27 ) resistor r=0.117801 //w=0.191 //l=0.18 //layer=m1 \
 //thickness=0.36 //x=10.25 //y=5.2 //x2=10.25 //y2=5.38
r350 (  23 53 ) resistor r=9.3 //w=0.17 //l=0.17 //layer=mcon //count=1 \
 //x=9.37 //y=5.38 //x2=9.37 //y2=5.38
r351 (  21 23 ) resistor r=0.10274 //w=0.219 //l=0.18 //layer=m1 \
 //thickness=0.36 //x=9.37 //y=5.2 //x2=9.37 //y2=5.38
r352 (  19 35 ) resistor r=0.0910802 //w=0.374 //l=0.185472 //layer=m1 \
 //thickness=0.36 //x=12.58 //y=3.49 //x2=12.525 //y2=3.33
r353 (  19 42 ) resistor r=1.02099 //w=0.131 //l=1.07 //layer=m1 \
 //thickness=0.36 //x=12.58 //y=3.49 //x2=12.58 //y2=4.56
r354 (  18 35 ) resistor r=0.0910802 //w=0.374 //l=0.185472 //layer=m1 \
 //thickness=0.36 //x=12.58 //y=3.17 //x2=12.525 //y2=3.33
r355 (  17 38 ) resistor r=0.0933015 //w=0.201 //l=0.125 //layer=m1 \
 //thickness=0.36 //x=12.58 //y=2.205 //x2=12.58 //y2=2.08
r356 (  17 18 ) resistor r=0.920802 //w=0.131 //l=0.965 //layer=m1 \
 //thickness=0.36 //x=12.58 //y=2.205 //x2=12.58 //y2=3.17
r357 (  15 32 ) resistor r=0.0910802 //w=0.374 //l=0.185472 //layer=m1 \
 //thickness=0.36 //x=10.73 //y=3.49 //x2=10.785 //y2=3.33
r358 (  15 16 ) resistor r=1.55057 //w=0.131 //l=1.625 //layer=m1 \
 //thickness=0.36 //x=10.73 //y=3.49 //x2=10.73 //y2=5.115
r359 (  14 32 ) resistor r=0.0910802 //w=0.374 //l=0.185472 //layer=m1 \
 //thickness=0.36 //x=10.73 //y=3.17 //x2=10.785 //y2=3.33
r360 (  13 14 ) resistor r=1.3645 //w=0.131 //l=1.43 //layer=m1 \
 //thickness=0.36 //x=10.73 //y=1.74 //x2=10.73 //y2=3.17
r361 (  11 13 ) resistor r=0.0698411 //w=0.17 //l=0.120208 //layer=m1 \
 //thickness=0.36 //x=10.645 //y=1.655 //x2=10.73 //y2=1.74
r362 (  11 12 ) resistor r=0.257634 //w=0.131 //l=0.27 //layer=m1 \
 //thickness=0.36 //x=10.645 //y=1.655 //x2=10.375 //y2=1.655
r363 (  10 24 ) resistor r=0.0257089 //w=0.23 //l=0.115 //layer=m1 \
 //thickness=0.36 //x=10.365 //y=5.2 //x2=10.25 //y2=5.2
r364 (  9 16 ) resistor r=0.0698411 //w=0.17 //l=0.120208 //layer=m1 \
 //thickness=0.36 //x=10.645 //y=5.2 //x2=10.73 //y2=5.115
r365 (  9 10 ) resistor r=0.267176 //w=0.131 //l=0.28 //layer=m1 \
 //thickness=0.36 //x=10.645 //y=5.2 //x2=10.365 //y2=5.2
r366 (  8 12 ) resistor r=0.0698411 //w=0.17 //l=0.120208 //layer=m1 \
 //thickness=0.36 //x=10.29 //y=1.57 //x2=10.375 //y2=1.655
r367 (  7 29 ) resistor r=0.0913624 //w=0.191 //l=0.12 //layer=m1 \
 //thickness=0.36 //x=10.29 //y=1.12 //x2=10.29 //y2=1
r368 (  7 8 ) resistor r=0.429389 //w=0.131 //l=0.45 //layer=m1 \
 //thickness=0.36 //x=10.29 //y=1.12 //x2=10.29 //y2=1.57
r369 (  4 21 ) resistor r=0.0227762 //w=0.219 //l=0.115 //layer=m1 \
 //thickness=0.36 //x=9.485 //y=5.2 //x2=9.37 //y2=5.2
r370 (  3 24 ) resistor r=0.0257089 //w=0.23 //l=0.115 //layer=m1 \
 //thickness=0.36 //x=10.135 //y=5.2 //x2=10.25 //y2=5.2
r371 (  3 4 ) resistor r=0.620229 //w=0.131 //l=0.65 //layer=m1 \
 //thickness=0.36 //x=10.135 //y=5.2 //x2=9.485 //y2=5.2
ends PM_DFFX1_PCELL\%noxref_2

subckt PM_DFFX1_PCELL\%noxref_3 ( 1 2 6 12 13 18 21 23 25 31 36 41 46 50 51 52 \
 53 54 55 56 57 58 60 66 67 68 69 70 75 76 77 82 84 86 92 93 97 106 107 110 )
c286 ( 110 0 ) capacitor c=0.0366322f //x=13.35 //y=4.7
c287 ( 107 0 ) capacitor c=0.0284095f //x=13.32 //y=1.915
c288 ( 106 0 ) capacitor c=0.0476356f //x=13.32 //y=2.08
c289 ( 97 0 ) capacitor c=0.0372825f //x=2.22 //y=4.7
c290 ( 93 0 ) capacitor c=0.0439708f //x=13.885 //y=1.25
c291 ( 92 0 ) capacitor c=0.0192582f //x=13.885 //y=0.905
c292 ( 86 0 ) capacitor c=0.0162526f //x=13.73 //y=1.405
c293 ( 84 0 ) capacitor c=0.0157807f //x=13.73 //y=0.75
c294 ( 82 0 ) capacitor c=0.0353784f //x=13.725 //y=4.79
c295 ( 77 0 ) capacitor c=0.0210762f //x=13.355 //y=1.56
c296 ( 76 0 ) capacitor c=0.0168511f //x=13.355 //y=1.25
c297 ( 75 0 ) capacitor c=0.0175485f //x=13.355 //y=0.905
c298 ( 70 0 ) capacitor c=0.0305913f //x=2.555 //y=4.79
c299 ( 69 0 ) capacitor c=0.0863671f //x=2.31 //y=1.915
c300 ( 68 0 ) capacitor c=0.0170266f //x=2.31 //y=1.45
c301 ( 67 0 ) capacitor c=0.018609f //x=2.31 //y=1.22
c302 ( 66 0 ) capacitor c=0.0186599f //x=2.31 //y=0.91
c303 ( 60 0 ) capacitor c=0.0146988f //x=2.155 //y=1.375
c304 ( 58 0 ) capacitor c=0.0148531f //x=2.155 //y=0.755
c305 ( 57 0 ) capacitor c=0.0334406f //x=1.785 //y=1.22
c306 ( 56 0 ) capacitor c=0.0173191f //x=1.785 //y=0.91
c307 ( 55 0 ) capacitor c=0.155269f //x=13.8 //y=6.02
c308 ( 54 0 ) capacitor c=0.110375f //x=13.36 //y=6.02
c309 ( 53 0 ) capacitor c=0.110208f //x=2.63 //y=6.02
c310 ( 52 0 ) capacitor c=0.110214f //x=2.19 //y=6.02
c311 ( 46 0 ) capacitor c=8.63366e-19 //x=13.35 //y=4.7
c312 ( 41 0 ) capacitor c=7.72439e-19 //x=13.32 //y=2.08
c313 ( 36 0 ) capacitor c=0.00143826f //x=2.22 //y=4.7
c314 ( 31 0 ) capacitor c=0.00121786f //x=2.22 //y=2.08
c315 ( 25 0 ) capacitor c=0.00183922f //x=2.22 //y=4.44
c316 ( 23 0 ) capacitor c=0.0886214f //x=10.21 //y=4.46
c317 ( 21 0 ) capacitor c=0.178908f //x=9.61 //y=4.44
c318 ( 18 0 ) capacitor c=0.00680024f //x=13.32 //y=2.08
c319 ( 13 0 ) capacitor c=0.0509274f //x=13.345 //y=4.525
c320 ( 12 0 ) capacitor c=0.00622136f //x=13.345 //y=4.685
c321 ( 6 0 ) capacitor c=0.00551503f //x=2.22 //y=4.7
c322 ( 2 0 ) capacitor c=0.0678123f //x=2.22 //y=4.54
c323 ( 1 0 ) capacitor c=0.00565957f //x=2.22 //y=2.195
r324 (  112 113 ) resistor r=32.4568 //w=0.214 //l=0.075 //layer=ply \
 //thickness=0.18 //x=13.35 //y=4.79 //x2=13.35 //y2=4.865
r325 (  110 112 ) resistor r=20.271 //w=0.214 //l=0.09 //layer=ply \
 //thickness=0.18 //x=13.35 //y=4.7 //x2=13.35 //y2=4.79
r326 (  106 107 ) resistor r=52.7279 //w=0.214 //l=0.165 //layer=ply \
 //thickness=0.18 //x=13.32 //y=2.08 //x2=13.32 //y2=1.915
r327 (  99 100 ) resistor r=32.4568 //w=0.214 //l=0.075 //layer=ply \
 //thickness=0.18 //x=2.22 //y=4.79 //x2=2.22 //y2=4.865
r328 (  97 99 ) resistor r=20.271 //w=0.214 //l=0.09 //layer=ply \
 //thickness=0.18 //x=2.22 //y=4.7 //x2=2.22 //y2=4.79
r329 (  93 117 ) resistor r=45.1352 //w=0.168 //l=0.173853 //layer=ply \
 //thickness=0.18 //x=13.885 //y=1.25 //x2=13.845 //y2=1.405
r330 (  92 116 ) resistor r=45.1352 //w=0.168 //l=0.173853 //layer=ply \
 //thickness=0.18 //x=13.885 //y=0.905 //x2=13.845 //y2=0.75
r331 (  92 93 ) resistor r=176.904 //w=0.094 //l=0.345 //layer=ply \
 //thickness=0.18 //x=13.885 //y=0.905 //x2=13.885 //y2=1.25
r332 (  87 115 ) resistor r=10.701 //w=0.21 //l=0.115 //layer=ply \
 //thickness=0.18 //x=13.51 //y=1.405 //x2=13.395 //y2=1.405
r333 (  86 117 ) resistor r=5.52526 //w=0.168 //l=0.115 //layer=ply \
 //thickness=0.18 //x=13.73 //y=1.405 //x2=13.845 //y2=1.405
r334 (  85 114 ) resistor r=5.52526 //w=0.168 //l=0.115 //layer=ply \
 //thickness=0.18 //x=13.51 //y=0.75 //x2=13.395 //y2=0.75
r335 (  84 116 ) resistor r=5.52526 //w=0.168 //l=0.115 //layer=ply \
 //thickness=0.18 //x=13.73 //y=0.75 //x2=13.845 //y2=0.75
r336 (  84 85 ) resistor r=112.809 //w=0.094 //l=0.22 //layer=ply \
 //thickness=0.18 //x=13.73 //y=0.75 //x2=13.51 //y2=0.75
r337 (  83 112 ) resistor r=16.5046 //w=0.27 //l=0.135 //layer=ply \
 //thickness=0.18 //x=13.485 //y=4.79 //x2=13.35 //y2=4.79
r338 (  82 89 ) resistor r=26.9307 //w=0.15 //l=0.106066 //layer=ply \
 //thickness=0.18 //x=13.725 //y=4.79 //x2=13.8 //y2=4.865
r339 (  82 83 ) resistor r=123.064 //w=0.094 //l=0.24 //layer=ply \
 //thickness=0.18 //x=13.725 //y=4.79 //x2=13.485 //y2=4.79
r340 (  77 115 ) resistor r=39.5823 //w=0.21 //l=0.173853 //layer=ply \
 //thickness=0.18 //x=13.355 //y=1.56 //x2=13.395 //y2=1.405
r341 (  77 107 ) resistor r=182.032 //w=0.094 //l=0.355 //layer=ply \
 //thickness=0.18 //x=13.355 //y=1.56 //x2=13.355 //y2=1.915
r342 (  76 115 ) resistor r=39.5823 //w=0.21 //l=0.173853 //layer=ply \
 //thickness=0.18 //x=13.355 //y=1.25 //x2=13.395 //y2=1.405
r343 (  75 114 ) resistor r=45.1352 //w=0.168 //l=0.173853 //layer=ply \
 //thickness=0.18 //x=13.355 //y=0.905 //x2=13.395 //y2=0.75
r344 (  75 76 ) resistor r=176.904 //w=0.094 //l=0.345 //layer=ply \
 //thickness=0.18 //x=13.355 //y=0.905 //x2=13.355 //y2=1.25
r345 (  71 99 ) resistor r=16.5046 //w=0.27 //l=0.135 //layer=ply \
 //thickness=0.18 //x=2.355 //y=4.79 //x2=2.22 //y2=4.79
r346 (  70 72 ) resistor r=26.9307 //w=0.15 //l=0.106066 //layer=ply \
 //thickness=0.18 //x=2.555 //y=4.79 //x2=2.63 //y2=4.865
r347 (  70 71 ) resistor r=102.553 //w=0.094 //l=0.2 //layer=ply \
 //thickness=0.18 //x=2.555 //y=4.79 //x2=2.355 //y2=4.79
r348 (  69 104 ) resistor r=38.6777 //w=0.284 //l=0.198997 //layer=ply \
 //thickness=0.18 //x=2.31 //y=1.915 //x2=2.235 //y2=2.08
r349 (  68 102 ) resistor r=21.2976 //w=0.217 //l=0.0928709 //layer=ply \
 //thickness=0.18 //x=2.31 //y=1.45 //x2=2.27 //y2=1.375
r350 (  68 69 ) resistor r=238.436 //w=0.094 //l=0.465 //layer=ply \
 //thickness=0.18 //x=2.31 //y=1.45 //x2=2.31 //y2=1.915
r351 (  67 102 ) resistor r=39.0671 //w=0.217 //l=0.173853 //layer=ply \
 //thickness=0.18 //x=2.31 //y=1.22 //x2=2.27 //y2=1.375
r352 (  66 101 ) resistor r=45.1352 //w=0.168 //l=0.173853 //layer=ply \
 //thickness=0.18 //x=2.31 //y=0.91 //x2=2.27 //y2=0.755
r353 (  66 67 ) resistor r=158.957 //w=0.094 //l=0.31 //layer=ply \
 //thickness=0.18 //x=2.31 //y=0.91 //x2=2.31 //y2=1.22
r354 (  61 95 ) resistor r=5.52526 //w=0.168 //l=0.115 //layer=ply \
 //thickness=0.18 //x=1.94 //y=1.375 //x2=1.825 //y2=1.375
r355 (  60 102 ) resistor r=11.4558 //w=0.217 //l=0.115 //layer=ply \
 //thickness=0.18 //x=2.155 //y=1.375 //x2=2.27 //y2=1.375
r356 (  59 94 ) resistor r=5.52526 //w=0.168 //l=0.115 //layer=ply \
 //thickness=0.18 //x=1.94 //y=0.755 //x2=1.825 //y2=0.755
r357 (  58 101 ) resistor r=5.52526 //w=0.168 //l=0.115 //layer=ply \
 //thickness=0.18 //x=2.155 //y=0.755 //x2=2.27 //y2=0.755
r358 (  58 59 ) resistor r=110.245 //w=0.094 //l=0.215 //layer=ply \
 //thickness=0.18 //x=2.155 //y=0.755 //x2=1.94 //y2=0.755
r359 (  57 95 ) resistor r=45.1352 //w=0.168 //l=0.173853 //layer=ply \
 //thickness=0.18 //x=1.785 //y=1.22 //x2=1.825 //y2=1.375
r360 (  56 94 ) resistor r=45.1352 //w=0.168 //l=0.173853 //layer=ply \
 //thickness=0.18 //x=1.785 //y=0.91 //x2=1.825 //y2=0.755
r361 (  56 57 ) resistor r=158.957 //w=0.094 //l=0.31 //layer=ply \
 //thickness=0.18 //x=1.785 //y=0.91 //x2=1.785 //y2=1.22
r362 (  55 89 ) resistor r=592.245 //w=0.094 //l=1.155 //layer=ply \
 //thickness=0.18 //x=13.8 //y=6.02 //x2=13.8 //y2=4.865
r363 (  54 113 ) resistor r=592.245 //w=0.094 //l=1.155 //layer=ply \
 //thickness=0.18 //x=13.36 //y=6.02 //x2=13.36 //y2=4.865
r364 (  53 72 ) resistor r=592.245 //w=0.094 //l=1.155 //layer=ply \
 //thickness=0.18 //x=2.63 //y=6.02 //x2=2.63 //y2=4.865
r365 (  52 100 ) resistor r=592.245 //w=0.094 //l=1.155 //layer=ply \
 //thickness=0.18 //x=2.19 //y=6.02 //x2=2.19 //y2=4.865
r366 (  51 86 ) resistor r=56.4043 //w=0.094 //l=0.11 //layer=ply \
 //thickness=0.18 //x=13.62 //y=1.405 //x2=13.73 //y2=1.405
r367 (  51 87 ) resistor r=56.4043 //w=0.094 //l=0.11 //layer=ply \
 //thickness=0.18 //x=13.62 //y=1.405 //x2=13.51 //y2=1.405
r368 (  50 60 ) resistor r=55.3787 //w=0.094 //l=0.108 //layer=ply \
 //thickness=0.18 //x=2.047 //y=1.375 //x2=2.155 //y2=1.375
r369 (  50 61 ) resistor r=54.866 //w=0.094 //l=0.107 //layer=ply \
 //thickness=0.18 //x=2.047 //y=1.375 //x2=1.94 //y2=1.375
r370 (  46 110 ) resistor r=152 //w=0.17 //l=0.17 //layer=licon //count=1 \
 //x=13.35 //y=4.7 //x2=13.35 //y2=4.7
r371 (  41 106 ) resistor r=152 //w=0.17 //l=0.17 //layer=licon //count=1 \
 //x=13.32 //y=2.08 //x2=13.32 //y2=2.08
r372 (  36 97 ) resistor r=152 //w=0.17 //l=0.17 //layer=licon //count=1 \
 //x=2.22 //y=4.7 //x2=2.22 //y2=4.7
r373 (  31 104 ) resistor r=152 //w=0.17 //l=0.17 //layer=licon //count=1 \
 //x=2.22 //y=2.08 //x2=2.22 //y2=2.08
r374 (  25 27 ) resistor r=0.110922 //w=0.293 //l=0.26 //layer=m2 \
 //thickness=0.36 //x=2.22 //y=4.44 //x2=2.22 //y2=4.7
r375 (  23 29 ) resistor r=1.99191 //w=0.197 //l=3.16733 //layer=m2 \
 //thickness=0.36 //x=10.21 //y=4.46 //x2=13.345 //y2=4.525
r376 (  23 24 ) resistor r=0.329198 //w=0.131 //l=0.345 //layer=m2 \
 //thickness=0.36 //x=10.21 //y=4.46 //x2=9.865 //y2=4.46
r377 (  22 25 ) resistor r=0.040188 //w=0.293 //l=0.16 //layer=m2 \
 //thickness=0.36 //x=2.38 //y=4.44 //x2=2.22 //y2=4.44
r378 (  21 24 ) resistor r=0.1875 //w=0.17 //l=0.264811 //layer=m2 \
 //thickness=0.36 //x=9.61 //y=4.44 //x2=9.865 //y2=4.46
r379 (  21 22 ) resistor r=6.89885 //w=0.131 //l=7.23 //layer=m2 \
 //thickness=0.36 //x=9.61 //y=4.44 //x2=2.38 //y2=4.44
r380 (  18 41 ) resistor r=9.3 //w=0.17 //l=0.17 //layer=mcon //count=1 \
 //x=13.32 //y=2.08 //x2=13.32 //y2=2.08
r381 (  18 20 ) resistor r=0.0936408 //w=0.196 //l=0.125 //layer=m1 \
 //thickness=0.36 //x=13.322 //y=2.08 //x2=13.322 //y2=2.205
r382 (  15 46 ) resistor r=9.3 //w=0.17 //l=0.17 //layer=mcon //count=1 \
 //x=13.35 //y=4.7 //x2=13.35 //y2=4.7
r383 (  13 20 ) resistor r=2.21374 //w=0.131 //l=2.32 //layer=m1 \
 //thickness=0.36 //x=13.32 //y=4.525 //x2=13.32 //y2=2.205
r384 (  12 29 ) resistor r=4.5 //w=0.15 //l=0.15 //layer=via1 //count=1 \
 //x=13.345 //y=4.685 //x2=13.345 //y2=4.685
r385 (  12 15 ) resistor r=0.0066726 //w=0.281 //l=0.015 //layer=m1 \
 //thickness=0.36 //x=13.345 //y=4.685 //x2=13.345 //y2=4.7
r386 (  12 13 ) resistor r=0.10734 //w=0.281 //l=0.16 //layer=m1 \
 //thickness=0.36 //x=13.345 //y=4.685 //x2=13.345 //y2=4.525
r387 (  10 31 ) resistor r=9.3 //w=0.17 //l=0.17 //layer=mcon //count=1 \
 //x=2.22 //y=2.08 //x2=2.22 //y2=2.08
r388 (  6 36 ) resistor r=9.3 //w=0.17 //l=0.17 //layer=mcon //count=1 \
 //x=2.22 //y=4.7 //x2=2.22 //y2=4.7
r389 (  6 27 ) resistor r=4.5 //w=0.15 //l=0.15 //layer=via1 //count=1 \
 //x=2.22 //y=4.7 //x2=2.22 //y2=4.7
r390 (  2 6 ) resistor r=0.10734 //w=0.281 //l=0.16 //layer=m1 \
 //thickness=0.36 //x=2.22 //y=4.54 //x2=2.22 //y2=4.7
r391 (  1 10 ) resistor r=0.0715665 //w=0.226 //l=0.115996 //layer=m1 \
 //thickness=0.36 //x=2.22 //y=2.195 //x2=2.222 //y2=2.08
r392 (  1 2 ) resistor r=2.2376 //w=0.131 //l=2.345 //layer=m1 \
 //thickness=0.36 //x=2.22 //y=2.195 //x2=2.22 //y2=4.54
ends PM_DFFX1_PCELL\%noxref_3

subckt PM_DFFX1_PCELL\%noxref_4 ( 1 3 6 7 9 10 11 12 14 15 16 18 19 22 23 25 \
 28 31 37 40 43 46 47 50 54 57 58 60 61 62 63 64 66 68 70 72 74 84 92 100 117 \
 126 131 140 144 145 146 147 148 149 150 151 152 153 157 159 162 163 167 168 \
 169 170 174 176 179 180 190 199 202 204 205 206 )
c465 ( 202 0 ) capacitor c=0.00885916f //x=3.395 //y=0.915
c466 ( 199 0 ) capacitor c=0.0645411f //x=15.91 //y=4.7
c467 ( 190 0 ) capacitor c=0.0645923f //x=5.92 //y=4.7
c468 ( 180 0 ) capacitor c=0.0318956f //x=16.245 //y=1.21
c469 ( 179 0 ) capacitor c=0.0186809f //x=16.245 //y=0.865
c470 ( 176 0 ) capacitor c=0.0141821f //x=16.09 //y=1.365
c471 ( 174 0 ) capacitor c=0.0158553f //x=16.09 //y=0.71
c472 ( 170 0 ) capacitor c=0.088055f //x=15.715 //y=1.915
c473 ( 169 0 ) capacitor c=0.0229235f //x=15.715 //y=1.52
c474 ( 168 0 ) capacitor c=0.0234359f //x=15.715 //y=1.21
c475 ( 167 0 ) capacitor c=0.0198759f //x=15.715 //y=0.865
c476 ( 163 0 ) capacitor c=0.0318956f //x=6.255 //y=1.21
c477 ( 162 0 ) capacitor c=0.0186809f //x=6.255 //y=0.865
c478 ( 159 0 ) capacitor c=0.0141821f //x=6.1 //y=1.365
c479 ( 157 0 ) capacitor c=0.0158553f //x=6.1 //y=0.71
c480 ( 153 0 ) capacitor c=0.088055f //x=5.725 //y=1.915
c481 ( 152 0 ) capacitor c=0.0229235f //x=5.725 //y=1.52
c482 ( 151 0 ) capacitor c=0.0234359f //x=5.725 //y=1.21
c483 ( 150 0 ) capacitor c=0.0198759f //x=5.725 //y=0.865
c484 ( 149 0 ) capacitor c=0.110369f //x=16.25 //y=6.02
c485 ( 148 0 ) capacitor c=0.154619f //x=15.81 //y=6.02
c486 ( 147 0 ) capacitor c=0.110369f //x=6.26 //y=6.02
c487 ( 146 0 ) capacitor c=0.154619f //x=5.82 //y=6.02
c488 ( 140 0 ) capacitor c=8.13451e-19 //x=15.91 //y=4.7
c489 ( 131 0 ) capacitor c=7.85889e-19 //x=15.91 //y=2.08
c490 ( 126 0 ) capacitor c=8.13451e-19 //x=5.92 //y=4.7
c491 ( 117 0 ) capacitor c=7.85889e-19 //x=5.92 //y=2.08
c492 ( 100 0 ) capacitor c=0.0293071f //x=3.29 //y=5.38
c493 ( 92 0 ) capacitor c=0.029137f //x=2.41 //y=5.38
c494 ( 84 0 ) capacitor c=0.0278099f //x=1.53 //y=5.38
c495 ( 74 0 ) capacitor c=0.0891228f //x=12.79 //y=3.715
c496 ( 72 0 ) capacitor c=0.0175525f //x=12.19 //y=3.7
c497 ( 70 0 ) capacitor c=0.00410953f //x=10.95 //y=3.715
c498 ( 68 0 ) capacitor c=0.0176014f //x=10.21 //y=3.69
c499 ( 66 0 ) capacitor c=0.0106365f //x=9.46 //y=3.71
c500 ( 64 0 ) capacitor c=0.0178779f //x=8.86 //y=3.7
c501 ( 63 0 ) capacitor c=0.0105169f //x=7.265 //y=3.715
c502 ( 62 0 ) capacitor c=0.00467954f //x=7.61 //y=3.715
c503 ( 61 0 ) capacitor c=7.05145e-19 //x=4.23 //y=3.7
c504 ( 60 0 ) capacitor c=0.0193144f //x=5.755 //y=3.7
c505 ( 58 0 ) capacitor c=0.0167537f //x=15.912 //y=4.56
c506 ( 57 0 ) capacitor c=0.00598189f //x=15.91 //y=4.7
c507 ( 54 0 ) capacitor c=0.00654828f //x=15.91 //y=2.08
c508 ( 50 0 ) capacitor c=0.0150408f //x=15.91 //y=3.7
c509 ( 47 0 ) capacitor c=0.0172769f //x=5.922 //y=4.56
c510 ( 46 0 ) capacitor c=0.00598357f //x=5.92 //y=4.7
c511 ( 43 0 ) capacitor c=0.00654649f //x=5.92 //y=2.08
c512 ( 40 0 ) capacitor c=0.0163193f //x=5.915 //y=3.7
c513 ( 37 0 ) capacitor c=0.0170864f //x=4.07 //y=3.7
c514 ( 31 0 ) capacitor c=9.55882e-19 //x=3.29 //y=5.155
c515 ( 28 0 ) capacitor c=0.00753245f //x=2.41 //y=5.155
c516 ( 25 0 ) capacitor c=0.0123281f //x=1.532 //y=5.155
c517 ( 23 0 ) capacitor c=0.0126867f //x=15.91 //y=3.865
c518 ( 22 0 ) capacitor c=0.0430019f //x=15.91 //y=3.545
c519 ( 19 0 ) capacitor c=0.0124833f //x=5.92 //y=3.86
c520 ( 18 0 ) capacitor c=0.0389536f //x=5.92 //y=3.54
c521 ( 16 0 ) capacitor c=0.0309857f //x=4.07 //y=5.07
c522 ( 15 0 ) capacitor c=0.0132732f //x=4.07 //y=3.86
c523 ( 14 0 ) capacitor c=0.0507527f //x=4.07 //y=3.54
c524 ( 12 0 ) capacitor c=0.00686157f //x=3.67 //y=1.665
c525 ( 11 0 ) capacitor c=0.0159771f //x=3.985 //y=1.665
c526 ( 10 0 ) capacitor c=0.0136149f //x=3.585 //y=1.58
c527 ( 9 0 ) capacitor c=0.0112344f //x=3.585 //y=1.125
c528 ( 7 0 ) capacitor c=0.0228253f //x=3.985 //y=5.155
c529 ( 6 0 ) capacitor c=0.00906713f //x=3.29 //y=5.38
c530 ( 3 0 ) capacitor c=0.019596f //x=3.175 //y=5.155
c531 ( 1 0 ) capacitor c=0.0150747f //x=2.29 //y=5.155
r532 (  197 199 ) resistor r=20.6867 //w=0.233 //l=0.1 //layer=ply \
 //thickness=0.18 //x=15.81 //y=4.7 //x2=15.91 //y2=4.7
r533 (  188 190 ) resistor r=20.6867 //w=0.233 //l=0.1 //layer=ply \
 //thickness=0.18 //x=5.82 //y=4.7 //x2=5.92 //y2=4.7
r534 (  181 199 ) resistor r=70.3348 //w=0.233 //l=0.414367 //layer=ply \
 //thickness=0.18 //x=16.25 //y=4.865 //x2=15.91 //y2=4.7
r535 (  180 201 ) resistor r=45.1352 //w=0.168 //l=0.173853 //layer=ply \
 //thickness=0.18 //x=16.245 //y=1.21 //x2=16.205 //y2=1.365
r536 (  179 200 ) resistor r=45.1352 //w=0.168 //l=0.173853 //layer=ply \
 //thickness=0.18 //x=16.245 //y=0.865 //x2=16.205 //y2=0.71
r537 (  179 180 ) resistor r=176.904 //w=0.094 //l=0.345 //layer=ply \
 //thickness=0.18 //x=16.245 //y=0.865 //x2=16.245 //y2=1.21
r538 (  177 196 ) resistor r=10.701 //w=0.21 //l=0.115 //layer=ply \
 //thickness=0.18 //x=15.87 //y=1.365 //x2=15.755 //y2=1.365
r539 (  176 201 ) resistor r=5.52526 //w=0.168 //l=0.115 //layer=ply \
 //thickness=0.18 //x=16.09 //y=1.365 //x2=16.205 //y2=1.365
r540 (  175 195 ) resistor r=5.52526 //w=0.168 //l=0.115 //layer=ply \
 //thickness=0.18 //x=15.87 //y=0.71 //x2=15.755 //y2=0.71
r541 (  174 200 ) resistor r=5.52526 //w=0.168 //l=0.115 //layer=ply \
 //thickness=0.18 //x=16.09 //y=0.71 //x2=16.205 //y2=0.71
r542 (  174 175 ) resistor r=112.809 //w=0.094 //l=0.22 //layer=ply \
 //thickness=0.18 //x=16.09 //y=0.71 //x2=15.87 //y2=0.71
r543 (  171 197 ) resistor r=13.0941 //w=0.233 //l=0.165 //layer=ply \
 //thickness=0.18 //x=15.81 //y=4.865 //x2=15.81 //y2=4.7
r544 (  170 194 ) resistor r=34.8111 //w=0.27 //l=0.264953 //layer=ply \
 //thickness=0.18 //x=15.715 //y=1.915 //x2=15.91 //y2=2.08
r545 (  169 196 ) resistor r=39.5823 //w=0.21 //l=0.173853 //layer=ply \
 //thickness=0.18 //x=15.715 //y=1.52 //x2=15.755 //y2=1.365
r546 (  169 170 ) resistor r=202.543 //w=0.094 //l=0.395 //layer=ply \
 //thickness=0.18 //x=15.715 //y=1.52 //x2=15.715 //y2=1.915
r547 (  168 196 ) resistor r=39.5823 //w=0.21 //l=0.173853 //layer=ply \
 //thickness=0.18 //x=15.715 //y=1.21 //x2=15.755 //y2=1.365
r548 (  167 195 ) resistor r=45.1352 //w=0.168 //l=0.173853 //layer=ply \
 //thickness=0.18 //x=15.715 //y=0.865 //x2=15.755 //y2=0.71
r549 (  167 168 ) resistor r=176.904 //w=0.094 //l=0.345 //layer=ply \
 //thickness=0.18 //x=15.715 //y=0.865 //x2=15.715 //y2=1.21
r550 (  164 190 ) resistor r=70.3348 //w=0.233 //l=0.414367 //layer=ply \
 //thickness=0.18 //x=6.26 //y=4.865 //x2=5.92 //y2=4.7
r551 (  163 192 ) resistor r=45.1352 //w=0.168 //l=0.173853 //layer=ply \
 //thickness=0.18 //x=6.255 //y=1.21 //x2=6.215 //y2=1.365
r552 (  162 191 ) resistor r=45.1352 //w=0.168 //l=0.173853 //layer=ply \
 //thickness=0.18 //x=6.255 //y=0.865 //x2=6.215 //y2=0.71
r553 (  162 163 ) resistor r=176.904 //w=0.094 //l=0.345 //layer=ply \
 //thickness=0.18 //x=6.255 //y=0.865 //x2=6.255 //y2=1.21
r554 (  160 187 ) resistor r=10.701 //w=0.21 //l=0.115 //layer=ply \
 //thickness=0.18 //x=5.88 //y=1.365 //x2=5.765 //y2=1.365
r555 (  159 192 ) resistor r=5.52526 //w=0.168 //l=0.115 //layer=ply \
 //thickness=0.18 //x=6.1 //y=1.365 //x2=6.215 //y2=1.365
r556 (  158 186 ) resistor r=5.52526 //w=0.168 //l=0.115 //layer=ply \
 //thickness=0.18 //x=5.88 //y=0.71 //x2=5.765 //y2=0.71
r557 (  157 191 ) resistor r=5.52526 //w=0.168 //l=0.115 //layer=ply \
 //thickness=0.18 //x=6.1 //y=0.71 //x2=6.215 //y2=0.71
r558 (  157 158 ) resistor r=112.809 //w=0.094 //l=0.22 //layer=ply \
 //thickness=0.18 //x=6.1 //y=0.71 //x2=5.88 //y2=0.71
r559 (  154 188 ) resistor r=13.0941 //w=0.233 //l=0.165 //layer=ply \
 //thickness=0.18 //x=5.82 //y=4.865 //x2=5.82 //y2=4.7
r560 (  153 185 ) resistor r=34.8111 //w=0.27 //l=0.264953 //layer=ply \
 //thickness=0.18 //x=5.725 //y=1.915 //x2=5.92 //y2=2.08
r561 (  152 187 ) resistor r=39.5823 //w=0.21 //l=0.173853 //layer=ply \
 //thickness=0.18 //x=5.725 //y=1.52 //x2=5.765 //y2=1.365
r562 (  152 153 ) resistor r=202.543 //w=0.094 //l=0.395 //layer=ply \
 //thickness=0.18 //x=5.725 //y=1.52 //x2=5.725 //y2=1.915
r563 (  151 187 ) resistor r=39.5823 //w=0.21 //l=0.173853 //layer=ply \
 //thickness=0.18 //x=5.725 //y=1.21 //x2=5.765 //y2=1.365
r564 (  150 186 ) resistor r=45.1352 //w=0.168 //l=0.173853 //layer=ply \
 //thickness=0.18 //x=5.725 //y=0.865 //x2=5.765 //y2=0.71
r565 (  150 151 ) resistor r=176.904 //w=0.094 //l=0.345 //layer=ply \
 //thickness=0.18 //x=5.725 //y=0.865 //x2=5.725 //y2=1.21
r566 (  149 181 ) resistor r=592.245 //w=0.094 //l=1.155 //layer=ply \
 //thickness=0.18 //x=16.25 //y=6.02 //x2=16.25 //y2=4.865
r567 (  148 171 ) resistor r=592.245 //w=0.094 //l=1.155 //layer=ply \
 //thickness=0.18 //x=15.81 //y=6.02 //x2=15.81 //y2=4.865
r568 (  147 164 ) resistor r=592.245 //w=0.094 //l=1.155 //layer=ply \
 //thickness=0.18 //x=6.26 //y=6.02 //x2=6.26 //y2=4.865
r569 (  146 154 ) resistor r=592.245 //w=0.094 //l=1.155 //layer=ply \
 //thickness=0.18 //x=5.82 //y=6.02 //x2=5.82 //y2=4.865
r570 (  145 176 ) resistor r=56.4043 //w=0.094 //l=0.11 //layer=ply \
 //thickness=0.18 //x=15.98 //y=1.365 //x2=16.09 //y2=1.365
r571 (  145 177 ) resistor r=56.4043 //w=0.094 //l=0.11 //layer=ply \
 //thickness=0.18 //x=15.98 //y=1.365 //x2=15.87 //y2=1.365
r572 (  144 159 ) resistor r=56.4043 //w=0.094 //l=0.11 //layer=ply \
 //thickness=0.18 //x=5.99 //y=1.365 //x2=6.1 //y2=1.365
r573 (  144 160 ) resistor r=56.4043 //w=0.094 //l=0.11 //layer=ply \
 //thickness=0.18 //x=5.99 //y=1.365 //x2=5.88 //y2=1.365
r574 (  140 199 ) resistor r=152 //w=0.17 //l=0.17 //layer=licon //count=1 \
 //x=15.91 //y=4.7 //x2=15.91 //y2=4.7
r575 (  131 194 ) resistor r=152 //w=0.17 //l=0.17 //layer=licon //count=1 \
 //x=15.91 //y=2.08 //x2=15.91 //y2=2.08
r576 (  126 190 ) resistor r=152 //w=0.17 //l=0.17 //layer=licon //count=1 \
 //x=5.92 //y=4.7 //x2=5.92 //y2=4.7
r577 (  117 185 ) resistor r=152 //w=0.17 //l=0.17 //layer=licon //count=1 \
 //x=5.92 //y=2.08 //x2=5.92 //y2=2.08
r578 (  100 206 ) resistor r=23.615 //w=0.187 //l=0.345 //layer=li \
 //thickness=0.1 //x=3.29 //y=5.38 //x2=3.29 //y2=5.725
r579 (  92 205 ) resistor r=23.615 //w=0.187 //l=0.345 //layer=li \
 //thickness=0.1 //x=2.41 //y=5.38 //x2=2.41 //y2=5.725
r580 (  84 204 ) resistor r=23.615 //w=0.187 //l=0.345 //layer=li \
 //thickness=0.1 //x=1.53 //y=5.38 //x2=1.53 //y2=5.725
r581 (  74 82 ) resistor r=2.10915 //w=0.185 //l=3.125 //layer=m2 \
 //thickness=0.36 //x=12.79 //y=3.715 //x2=15.91 //y2=3.705
r582 (  74 75 ) resistor r=0.329198 //w=0.131 //l=0.345 //layer=m2 \
 //thickness=0.36 //x=12.79 //y=3.715 //x2=12.445 //y2=3.715
r583 (  72 75 ) resistor r=0.1875 //w=0.17 //l=0.262393 //layer=m2 \
 //thickness=0.36 //x=12.19 //y=3.7 //x2=12.445 //y2=3.715
r584 (  72 73 ) resistor r=1.02099 //w=0.131 //l=1.07 //layer=m2 \
 //thickness=0.36 //x=12.19 //y=3.7 //x2=11.12 //y2=3.7
r585 (  70 73 ) resistor r=0.125 //w=0.17 //l=0.177341 //layer=m2 \
 //thickness=0.36 //x=10.95 //y=3.715 //x2=11.12 //y2=3.7
r586 (  70 71 ) resistor r=0.329198 //w=0.131 //l=0.345 //layer=m2 \
 //thickness=0.36 //x=10.95 //y=3.715 //x2=10.605 //y2=3.715
r587 (  68 71 ) resistor r=0.290441 //w=0.17 //l=0.407308 //layer=m2 \
 //thickness=0.36 //x=10.21 //y=3.69 //x2=10.605 //y2=3.715
r588 (  68 69 ) resistor r=0.410305 //w=0.131 //l=0.43 //layer=m2 \
 //thickness=0.36 //x=10.21 //y=3.69 //x2=9.78 //y2=3.69
r589 (  66 69 ) resistor r=0.235294 //w=0.17 //l=0.329848 //layer=m2 \
 //thickness=0.36 //x=9.46 //y=3.71 //x2=9.78 //y2=3.69
r590 (  66 67 ) resistor r=0.329198 //w=0.131 //l=0.345 //layer=m2 \
 //thickness=0.36 //x=9.46 //y=3.71 //x2=9.115 //y2=3.71
r591 (  64 67 ) resistor r=0.1875 //w=0.17 //l=0.259952 //layer=m2 \
 //thickness=0.36 //x=8.86 //y=3.7 //x2=9.115 //y2=3.71
r592 (  64 65 ) resistor r=1.03053 //w=0.131 //l=1.08 //layer=m2 \
 //thickness=0.36 //x=8.86 //y=3.7 //x2=7.78 //y2=3.7
r593 (  63 80 ) resistor r=0.838898 //w=0.202 //l=1.35748 //layer=m2 \
 //thickness=0.36 //x=7.265 //y=3.715 //x2=5.915 //y2=3.7
r594 (  62 65 ) resistor r=0.125 //w=0.17 //l=0.177341 //layer=m2 \
 //thickness=0.36 //x=7.61 //y=3.715 //x2=7.78 //y2=3.7
r595 (  62 63 ) resistor r=0.329198 //w=0.131 //l=0.345 //layer=m2 \
 //thickness=0.36 //x=7.61 //y=3.715 //x2=7.265 //y2=3.715
r596 (  61 77 ) resistor r=0.10734 //w=0.281 //l=0.16 //layer=m2 \
 //thickness=0.36 //x=4.23 //y=3.7 //x2=4.07 //y2=3.7
r597 (  60 80 ) resistor r=0.102512 //w=0.202 //l=0.16 //layer=m2 \
 //thickness=0.36 //x=5.755 //y=3.7 //x2=5.915 //y2=3.7
r598 (  60 61 ) resistor r=1.45515 //w=0.131 //l=1.525 //layer=m2 \
 //thickness=0.36 //x=5.755 //y=3.7 //x2=4.23 //y2=3.7
r599 (  57 140 ) resistor r=9.3 //w=0.17 //l=0.17 //layer=mcon //count=1 \
 //x=15.91 //y=4.7 //x2=15.91 //y2=4.7
r600 (  57 58 ) resistor r=0.103207 //w=0.196 //l=0.14 //layer=m1 \
 //thickness=0.36 //x=15.912 //y=4.7 //x2=15.912 //y2=4.56
r601 (  54 131 ) resistor r=9.3 //w=0.17 //l=0.17 //layer=mcon //count=1 \
 //x=15.91 //y=2.08 //x2=15.91 //y2=2.08
r602 (  52 82 ) resistor r=4.5 //w=0.15 //l=0.15 //layer=via1 //count=1 \
 //x=15.91 //y=3.705 //x2=15.91 //y2=3.705
r603 (  50 52 ) resistor r=0.00166223 //w=0.376 //l=0.005 //layer=m1 \
 //thickness=0.36 //x=15.857 //y=3.7 //x2=15.857 //y2=3.705
r604 (  46 126 ) resistor r=9.3 //w=0.17 //l=0.17 //layer=mcon //count=1 \
 //x=5.92 //y=4.7 //x2=5.92 //y2=4.7
r605 (  46 47 ) resistor r=0.103207 //w=0.196 //l=0.14 //layer=m1 \
 //thickness=0.36 //x=5.922 //y=4.7 //x2=5.922 //y2=4.56
r606 (  43 117 ) resistor r=9.3 //w=0.17 //l=0.17 //layer=mcon //count=1 \
 //x=5.92 //y=2.08 //x2=5.92 //y2=2.08
r607 (  40 80 ) resistor r=4.5 //w=0.15 //l=0.15 //layer=via1 //count=1 \
 //x=5.915 //y=3.7 //x2=5.915 //y2=3.7
r608 (  37 77 ) resistor r=4.5 //w=0.15 //l=0.15 //layer=via1 //count=1 \
 //x=4.07 //y=3.7 //x2=4.07 //y2=3.7
r609 (  35 202 ) resistor r=9.3 //w=0.17 //l=0.17 //layer=mcon //count=1 \
 //x=3.585 //y=1.01 //x2=3.585 //y2=1.01
r610 (  33 100 ) resistor r=9.3 //w=0.17 //l=0.17 //layer=mcon //count=1 \
 //x=3.29 //y=5.38 //x2=3.29 //y2=5.38
r611 (  30 92 ) resistor r=9.3 //w=0.17 //l=0.17 //layer=mcon //count=1 \
 //x=2.41 //y=5.38 //x2=2.41 //y2=5.38
r612 (  28 30 ) resistor r=0.121228 //w=0.232 //l=0.225 //layer=m1 \
 //thickness=0.36 //x=2.41 //y=5.155 //x2=2.41 //y2=5.38
r613 (  27 84 ) resistor r=9.3 //w=0.17 //l=0.17 //layer=mcon //count=1 \
 //x=1.53 //y=5.38 //x2=1.53 //y2=5.38
r614 (  25 27 ) resistor r=0.129608 //w=0.217 //l=0.225 //layer=m1 \
 //thickness=0.36 //x=1.532 //y=5.155 //x2=1.532 //y2=5.38
r615 (  23 52 ) resistor r=0.0911593 //w=0.376 //l=0.184608 //layer=m1 \
 //thickness=0.36 //x=15.91 //y=3.865 //x2=15.857 //y2=3.705
r616 (  23 58 ) resistor r=0.663168 //w=0.131 //l=0.695 //layer=m1 \
 //thickness=0.36 //x=15.91 //y=3.865 //x2=15.91 //y2=4.56
r617 (  22 50 ) resistor r=0.0894971 //w=0.376 //l=0.179555 //layer=m1 \
 //thickness=0.36 //x=15.91 //y=3.545 //x2=15.857 //y2=3.7
r618 (  21 54 ) resistor r=0.0933015 //w=0.201 //l=0.125 //layer=m1 \
 //thickness=0.36 //x=15.91 //y=2.205 //x2=15.91 //y2=2.08
r619 (  21 22 ) resistor r=1.27863 //w=0.131 //l=1.34 //layer=m1 \
 //thickness=0.36 //x=15.91 //y=2.205 //x2=15.91 //y2=3.545
r620 (  19 40 ) resistor r=0.0910802 //w=0.374 //l=0.185472 //layer=m1 \
 //thickness=0.36 //x=5.92 //y=3.86 //x2=5.865 //y2=3.7
r621 (  19 47 ) resistor r=0.667939 //w=0.131 //l=0.7 //layer=m1 \
 //thickness=0.36 //x=5.92 //y=3.86 //x2=5.92 //y2=4.56
r622 (  18 40 ) resistor r=0.0910802 //w=0.374 //l=0.185472 //layer=m1 \
 //thickness=0.36 //x=5.92 //y=3.54 //x2=5.865 //y2=3.7
r623 (  17 43 ) resistor r=0.0933015 //w=0.201 //l=0.125 //layer=m1 \
 //thickness=0.36 //x=5.92 //y=2.205 //x2=5.92 //y2=2.08
r624 (  17 18 ) resistor r=1.27385 //w=0.131 //l=1.335 //layer=m1 \
 //thickness=0.36 //x=5.92 //y=2.205 //x2=5.92 //y2=3.54
r625 (  15 37 ) resistor r=0.0911593 //w=0.376 //l=0.184174 //layer=m1 \
 //thickness=0.36 //x=4.07 //y=3.86 //x2=4.122 //y2=3.7
r626 (  15 16 ) resistor r=1.15458 //w=0.131 //l=1.21 //layer=m1 \
 //thickness=0.36 //x=4.07 //y=3.86 //x2=4.07 //y2=5.07
r627 (  14 37 ) resistor r=0.0911593 //w=0.376 //l=0.184174 //layer=m1 \
 //thickness=0.36 //x=4.07 //y=3.54 //x2=4.122 //y2=3.7
r628 (  13 14 ) resistor r=1.70802 //w=0.131 //l=1.79 //layer=m1 \
 //thickness=0.36 //x=4.07 //y=1.75 //x2=4.07 //y2=3.54
r629 (  11 13 ) resistor r=0.0698411 //w=0.17 //l=0.120208 //layer=m1 \
 //thickness=0.36 //x=3.985 //y=1.665 //x2=4.07 //y2=1.75
r630 (  11 12 ) resistor r=0.300573 //w=0.131 //l=0.315 //layer=m1 \
 //thickness=0.36 //x=3.985 //y=1.665 //x2=3.67 //y2=1.665
r631 (  10 12 ) resistor r=0.0698411 //w=0.17 //l=0.120208 //layer=m1 \
 //thickness=0.36 //x=3.585 //y=1.58 //x2=3.67 //y2=1.665
r632 (  9 35 ) resistor r=0.0717383 //w=0.224 //l=0.115 //layer=m1 \
 //thickness=0.36 //x=3.585 //y=1.125 //x2=3.585 //y2=1.01
r633 (  9 10 ) resistor r=0.43416 //w=0.131 //l=0.455 //layer=m1 \
 //thickness=0.36 //x=3.585 //y=1.125 //x2=3.585 //y2=1.58
r634 (  8 31 ) resistor r=0.0675342 //w=0.23 //l=0.115 //layer=m1 \
 //thickness=0.36 //x=3.405 //y=5.155 //x2=3.29 //y2=5.155
r635 (  7 16 ) resistor r=0.0698411 //w=0.17 //l=0.120208 //layer=m1 \
 //thickness=0.36 //x=3.985 //y=5.155 //x2=4.07 //y2=5.07
r636 (  7 8 ) resistor r=0.553435 //w=0.131 //l=0.58 //layer=m1 \
 //thickness=0.36 //x=3.985 //y=5.155 //x2=3.405 //y2=5.155
r637 (  6 33 ) resistor r=0.00118313 //w=0.23 //layer=m1 //thickness=0.36 \
 //x=3.29 //y=5.38 //x2=3.29 //y2=5.38
r638 (  5 31 ) resistor r=0.002872 //w=0.34 //l=0.085 //layer=m1 \
 //thickness=0.36 //x=3.29 //y=5.24 //x2=3.29 //y2=5.155
r639 (  5 6 ) resistor r=0.091623 //w=0.191 //l=0.14 //layer=m1 \
 //thickness=0.36 //x=3.29 //y=5.24 //x2=3.29 //y2=5.38
r640 (  4 28 ) resistor r=0.0262263 //w=0.232 //l=0.12 //layer=m1 \
 //thickness=0.36 //x=2.53 //y=5.155 //x2=2.41 //y2=5.155
r641 (  3 31 ) resistor r=0.0675342 //w=0.23 //l=0.115 //layer=m1 \
 //thickness=0.36 //x=3.175 //y=5.155 //x2=3.29 //y2=5.155
r642 (  3 4 ) resistor r=0.615458 //w=0.131 //l=0.645 //layer=m1 \
 //thickness=0.36 //x=3.175 //y=5.155 //x2=2.53 //y2=5.155
r643 (  2 25 ) resistor r=0.0222262 //w=0.217 //l=0.118 //layer=m1 \
 //thickness=0.36 //x=1.65 //y=5.155 //x2=1.532 //y2=5.155
r644 (  1 28 ) resistor r=0.0262263 //w=0.232 //l=0.12 //layer=m1 \
 //thickness=0.36 //x=2.29 //y=5.155 //x2=2.41 //y2=5.155
r645 (  1 2 ) resistor r=0.610687 //w=0.131 //l=0.64 //layer=m1 \
 //thickness=0.36 //x=2.29 //y=5.155 //x2=1.65 //y2=5.155
ends PM_DFFX1_PCELL\%noxref_4

subckt PM_DFFX1_PCELL\%noxref_5 ( 1 2 3 4 6 7 8 11 16 17 19 20 22 23 24 26 27 \
 28 34 38 42 49 50 53 55 58 62 65 70 72 74 76 78 79 80 81 85 93 102 107 116 \
 121 129 146 155 159 160 161 162 163 164 165 166 167 168 169 170 171 172 174 \
 180 181 182 183 187 188 189 194 196 198 204 205 206 207 208 213 215 217 223 \
 224 234 235 238 247 248 251 259 261 262 )
c572 ( 259 0 ) capacitor c=0.00878249f //x=13.43 //y=0.905
c573 ( 251 0 ) capacitor c=0.0356006f //x=20.01 //y=4.7
c574 ( 248 0 ) capacitor c=0.0303735f //x=19.98 //y=1.915
c575 ( 247 0 ) capacitor c=0.0476996f //x=19.98 //y=2.08
c576 ( 238 0 ) capacitor c=0.0354915f //x=10.02 //y=4.7
c577 ( 235 0 ) capacitor c=0.0284095f //x=9.99 //y=1.915
c578 ( 234 0 ) capacitor c=0.0476356f //x=9.99 //y=2.08
c579 ( 224 0 ) capacitor c=0.0439708f //x=20.545 //y=1.25
c580 ( 223 0 ) capacitor c=0.0192582f //x=20.545 //y=0.905
c581 ( 217 0 ) capacitor c=0.0162526f //x=20.39 //y=1.405
c582 ( 215 0 ) capacitor c=0.0157807f //x=20.39 //y=0.75
c583 ( 213 0 ) capacitor c=0.0372668f //x=20.385 //y=4.79
c584 ( 208 0 ) capacitor c=0.0210762f //x=20.015 //y=1.56
c585 ( 207 0 ) capacitor c=0.0168511f //x=20.015 //y=1.25
c586 ( 206 0 ) capacitor c=0.0175485f //x=20.015 //y=0.905
c587 ( 205 0 ) capacitor c=0.0439708f //x=10.555 //y=1.25
c588 ( 204 0 ) capacitor c=0.0192582f //x=10.555 //y=0.905
c589 ( 198 0 ) capacitor c=0.0162526f //x=10.4 //y=1.405
c590 ( 196 0 ) capacitor c=0.0157807f //x=10.4 //y=0.75
c591 ( 194 0 ) capacitor c=0.0372668f //x=10.395 //y=4.79
c592 ( 189 0 ) capacitor c=0.0210762f //x=10.025 //y=1.56
c593 ( 188 0 ) capacitor c=0.0168511f //x=10.025 //y=1.25
c594 ( 187 0 ) capacitor c=0.0175485f //x=10.025 //y=0.905
c595 ( 183 0 ) capacitor c=0.0551643f //x=1.385 //y=4.79
c596 ( 182 0 ) capacitor c=0.0376038f //x=1.675 //y=4.79
c597 ( 181 0 ) capacitor c=0.0346489f //x=1.34 //y=1.22
c598 ( 180 0 ) capacitor c=0.018692f //x=1.34 //y=0.875
c599 ( 174 0 ) capacitor c=0.0137077f //x=1.185 //y=1.375
c600 ( 172 0 ) capacitor c=0.0158585f //x=1.185 //y=0.72
c601 ( 171 0 ) capacitor c=0.103534f //x=0.81 //y=1.915
c602 ( 170 0 ) capacitor c=0.0229444f //x=0.81 //y=1.53
c603 ( 169 0 ) capacitor c=0.0234359f //x=0.81 //y=1.22
c604 ( 168 0 ) capacitor c=0.019815f //x=0.81 //y=0.875
c605 ( 167 0 ) capacitor c=0.155269f //x=20.46 //y=6.02
c606 ( 166 0 ) capacitor c=0.110375f //x=20.02 //y=6.02
c607 ( 165 0 ) capacitor c=0.155269f //x=10.47 //y=6.02
c608 ( 164 0 ) capacitor c=0.110375f //x=10.03 //y=6.02
c609 ( 163 0 ) capacitor c=0.110208f //x=1.75 //y=6.02
c610 ( 162 0 ) capacitor c=0.158957f //x=1.31 //y=6.02
c611 ( 155 0 ) capacitor c=5.80955e-19 //x=20.01 //y=4.7
c612 ( 146 0 ) capacitor c=5.78095e-19 //x=19.98 //y=2.08
c613 ( 129 0 ) capacitor c=0.0319332f //x=13.58 //y=5.38
c614 ( 121 0 ) capacitor c=0.0291719f //x=12.7 //y=5.38
c615 ( 116 0 ) capacitor c=5.80955e-19 //x=10.02 //y=4.7
c616 ( 107 0 ) capacitor c=5.78095e-19 //x=9.99 //y=2.08
c617 ( 102 0 ) capacitor c=0.0012433f //x=1.11 //y=4.7
c618 ( 93 0 ) capacitor c=0.0012618f //x=1.11 //y=2.08
c619 ( 85 0 ) capacitor c=0.0110688f //x=1.275 //y=4.075
c620 ( 81 0 ) capacitor c=0.0516669f //x=15.78 //y=4.09
c621 ( 80 0 ) capacitor c=0.181271f //x=16.125 //y=4.09
c622 ( 79 0 ) capacitor c=0.0371529f //x=10.155 //y=4.07
c623 ( 78 0 ) capacitor c=0.0401039f //x=13.89 //y=4.07
c624 ( 76 0 ) capacitor c=0.00148682f //x=6.13 //y=4.085
c625 ( 74 0 ) capacitor c=0.0158261f //x=5.53 //y=4.07
c626 ( 72 0 ) capacitor c=0.00410955f //x=4.285 //y=4.085
c627 ( 70 0 ) capacitor c=0.0805297f //x=3.685 //y=4.07
c628 ( 65 0 ) capacitor c=0.0066236f //x=19.98 //y=2.08
c629 ( 62 0 ) capacitor c=0.0141348f //x=19.98 //y=4.07
c630 ( 58 0 ) capacitor c=0.015184f //x=14.06 //y=4.07
c631 ( 55 0 ) capacitor c=0.0114498f //x=13.62 //y=1
c632 ( 53 0 ) capacitor c=5.78613e-19 //x=13.58 //y=5.38
c633 ( 50 0 ) capacitor c=0.0106343f //x=13.58 //y=5.2
c634 ( 49 0 ) capacitor c=0.00933207f //x=12.7 //y=5.38
c635 ( 42 0 ) capacitor c=0.00662515f //x=9.99 //y=2.08
c636 ( 38 0 ) capacitor c=0.0143744f //x=9.99 //y=4.07
c637 ( 34 0 ) capacitor c=0.0160407f //x=1.11 //y=4.07
c638 ( 28 0 ) capacitor c=0.00985447f //x=19.98 //y=4.555
c639 ( 27 0 ) capacitor c=0.00951355f //x=19.98 //y=4.23
c640 ( 26 0 ) capacitor c=0.0453343f //x=19.98 //y=3.91
c641 ( 24 0 ) capacitor c=0.0199975f //x=14.06 //y=5.115
c642 ( 23 0 ) capacitor c=0.012869f //x=14.06 //y=4.245
c643 ( 22 0 ) capacitor c=0.0637724f //x=14.06 //y=3.925
c644 ( 20 0 ) capacitor c=0.00671966f //x=13.705 //y=1.655
c645 ( 19 0 ) capacitor c=0.0142356f //x=13.975 //y=1.655
c646 ( 17 0 ) capacitor c=0.0102685f //x=13.975 //y=5.2
c647 ( 16 0 ) capacitor c=0.0101547f //x=13.62 //y=1.57
c648 ( 11 0 ) capacitor c=0.0142466f //x=13.465 //y=5.2
c649 ( 8 0 ) capacitor c=0.00908133f //x=9.99 //y=4.555
c650 ( 7 0 ) capacitor c=0.00971944f //x=9.99 //y=4.235
c651 ( 6 0 ) capacitor c=0.0367292f //x=9.99 //y=3.915
c652 ( 4 0 ) capacitor c=0.0228116f //x=1.11 //y=4.575
c653 ( 3 0 ) capacitor c=0.0128906f //x=1.11 //y=4.235
c654 ( 2 0 ) capacitor c=0.0862595f //x=1.11 //y=3.915
c655 ( 1 0 ) capacitor c=0.0113406f //x=1.11 //y=2.195
r656 (  253 254 ) resistor r=32.4568 //w=0.214 //l=0.075 //layer=ply \
 //thickness=0.18 //x=20.01 //y=4.79 //x2=20.01 //y2=4.865
r657 (  251 253 ) resistor r=20.271 //w=0.214 //l=0.09 //layer=ply \
 //thickness=0.18 //x=20.01 //y=4.7 //x2=20.01 //y2=4.79
r658 (  247 248 ) resistor r=52.7279 //w=0.214 //l=0.165 //layer=ply \
 //thickness=0.18 //x=19.98 //y=2.08 //x2=19.98 //y2=1.915
r659 (  240 241 ) resistor r=32.4568 //w=0.214 //l=0.075 //layer=ply \
 //thickness=0.18 //x=10.02 //y=4.79 //x2=10.02 //y2=4.865
r660 (  238 240 ) resistor r=20.271 //w=0.214 //l=0.09 //layer=ply \
 //thickness=0.18 //x=10.02 //y=4.7 //x2=10.02 //y2=4.79
r661 (  234 235 ) resistor r=52.7279 //w=0.214 //l=0.165 //layer=ply \
 //thickness=0.18 //x=9.99 //y=2.08 //x2=9.99 //y2=1.915
r662 (  224 258 ) resistor r=45.1352 //w=0.168 //l=0.173853 //layer=ply \
 //thickness=0.18 //x=20.545 //y=1.25 //x2=20.505 //y2=1.405
r663 (  223 257 ) resistor r=45.1352 //w=0.168 //l=0.173853 //layer=ply \
 //thickness=0.18 //x=20.545 //y=0.905 //x2=20.505 //y2=0.75
r664 (  223 224 ) resistor r=176.904 //w=0.094 //l=0.345 //layer=ply \
 //thickness=0.18 //x=20.545 //y=0.905 //x2=20.545 //y2=1.25
r665 (  218 256 ) resistor r=10.701 //w=0.21 //l=0.115 //layer=ply \
 //thickness=0.18 //x=20.17 //y=1.405 //x2=20.055 //y2=1.405
r666 (  217 258 ) resistor r=5.52526 //w=0.168 //l=0.115 //layer=ply \
 //thickness=0.18 //x=20.39 //y=1.405 //x2=20.505 //y2=1.405
r667 (  216 255 ) resistor r=5.52526 //w=0.168 //l=0.115 //layer=ply \
 //thickness=0.18 //x=20.17 //y=0.75 //x2=20.055 //y2=0.75
r668 (  215 257 ) resistor r=5.52526 //w=0.168 //l=0.115 //layer=ply \
 //thickness=0.18 //x=20.39 //y=0.75 //x2=20.505 //y2=0.75
r669 (  215 216 ) resistor r=112.809 //w=0.094 //l=0.22 //layer=ply \
 //thickness=0.18 //x=20.39 //y=0.75 //x2=20.17 //y2=0.75
r670 (  214 253 ) resistor r=16.5046 //w=0.27 //l=0.135 //layer=ply \
 //thickness=0.18 //x=20.145 //y=4.79 //x2=20.01 //y2=4.79
r671 (  213 220 ) resistor r=26.9307 //w=0.15 //l=0.106066 //layer=ply \
 //thickness=0.18 //x=20.385 //y=4.79 //x2=20.46 //y2=4.865
r672 (  213 214 ) resistor r=123.064 //w=0.094 //l=0.24 //layer=ply \
 //thickness=0.18 //x=20.385 //y=4.79 //x2=20.145 //y2=4.79
r673 (  208 256 ) resistor r=39.5823 //w=0.21 //l=0.173853 //layer=ply \
 //thickness=0.18 //x=20.015 //y=1.56 //x2=20.055 //y2=1.405
r674 (  208 248 ) resistor r=182.032 //w=0.094 //l=0.355 //layer=ply \
 //thickness=0.18 //x=20.015 //y=1.56 //x2=20.015 //y2=1.915
r675 (  207 256 ) resistor r=39.5823 //w=0.21 //l=0.173853 //layer=ply \
 //thickness=0.18 //x=20.015 //y=1.25 //x2=20.055 //y2=1.405
r676 (  206 255 ) resistor r=45.1352 //w=0.168 //l=0.173853 //layer=ply \
 //thickness=0.18 //x=20.015 //y=0.905 //x2=20.055 //y2=0.75
r677 (  206 207 ) resistor r=176.904 //w=0.094 //l=0.345 //layer=ply \
 //thickness=0.18 //x=20.015 //y=0.905 //x2=20.015 //y2=1.25
r678 (  205 245 ) resistor r=45.1352 //w=0.168 //l=0.173853 //layer=ply \
 //thickness=0.18 //x=10.555 //y=1.25 //x2=10.515 //y2=1.405
r679 (  204 244 ) resistor r=45.1352 //w=0.168 //l=0.173853 //layer=ply \
 //thickness=0.18 //x=10.555 //y=0.905 //x2=10.515 //y2=0.75
r680 (  204 205 ) resistor r=176.904 //w=0.094 //l=0.345 //layer=ply \
 //thickness=0.18 //x=10.555 //y=0.905 //x2=10.555 //y2=1.25
r681 (  199 243 ) resistor r=10.701 //w=0.21 //l=0.115 //layer=ply \
 //thickness=0.18 //x=10.18 //y=1.405 //x2=10.065 //y2=1.405
r682 (  198 245 ) resistor r=5.52526 //w=0.168 //l=0.115 //layer=ply \
 //thickness=0.18 //x=10.4 //y=1.405 //x2=10.515 //y2=1.405
r683 (  197 242 ) resistor r=5.52526 //w=0.168 //l=0.115 //layer=ply \
 //thickness=0.18 //x=10.18 //y=0.75 //x2=10.065 //y2=0.75
r684 (  196 244 ) resistor r=5.52526 //w=0.168 //l=0.115 //layer=ply \
 //thickness=0.18 //x=10.4 //y=0.75 //x2=10.515 //y2=0.75
r685 (  196 197 ) resistor r=112.809 //w=0.094 //l=0.22 //layer=ply \
 //thickness=0.18 //x=10.4 //y=0.75 //x2=10.18 //y2=0.75
r686 (  195 240 ) resistor r=16.5046 //w=0.27 //l=0.135 //layer=ply \
 //thickness=0.18 //x=10.155 //y=4.79 //x2=10.02 //y2=4.79
r687 (  194 201 ) resistor r=26.9307 //w=0.15 //l=0.106066 //layer=ply \
 //thickness=0.18 //x=10.395 //y=4.79 //x2=10.47 //y2=4.865
r688 (  194 195 ) resistor r=123.064 //w=0.094 //l=0.24 //layer=ply \
 //thickness=0.18 //x=10.395 //y=4.79 //x2=10.155 //y2=4.79
r689 (  189 243 ) resistor r=39.5823 //w=0.21 //l=0.173853 //layer=ply \
 //thickness=0.18 //x=10.025 //y=1.56 //x2=10.065 //y2=1.405
r690 (  189 235 ) resistor r=182.032 //w=0.094 //l=0.355 //layer=ply \
 //thickness=0.18 //x=10.025 //y=1.56 //x2=10.025 //y2=1.915
r691 (  188 243 ) resistor r=39.5823 //w=0.21 //l=0.173853 //layer=ply \
 //thickness=0.18 //x=10.025 //y=1.25 //x2=10.065 //y2=1.405
r692 (  187 242 ) resistor r=45.1352 //w=0.168 //l=0.173853 //layer=ply \
 //thickness=0.18 //x=10.025 //y=0.905 //x2=10.065 //y2=0.75
r693 (  187 188 ) resistor r=176.904 //w=0.094 //l=0.345 //layer=ply \
 //thickness=0.18 //x=10.025 //y=0.905 //x2=10.025 //y2=1.25
r694 (  182 184 ) resistor r=26.9307 //w=0.15 //l=0.106066 //layer=ply \
 //thickness=0.18 //x=1.675 //y=4.79 //x2=1.75 //y2=4.865
r695 (  182 183 ) resistor r=148.702 //w=0.094 //l=0.29 //layer=ply \
 //thickness=0.18 //x=1.675 //y=4.79 //x2=1.385 //y2=4.79
r696 (  181 232 ) resistor r=45.1352 //w=0.168 //l=0.173853 //layer=ply \
 //thickness=0.18 //x=1.34 //y=1.22 //x2=1.3 //y2=1.375
r697 (  180 231 ) resistor r=45.1352 //w=0.168 //l=0.173853 //layer=ply \
 //thickness=0.18 //x=1.34 //y=0.875 //x2=1.3 //y2=0.72
r698 (  180 181 ) resistor r=176.904 //w=0.094 //l=0.345 //layer=ply \
 //thickness=0.18 //x=1.34 //y=0.875 //x2=1.34 //y2=1.22
r699 (  177 183 ) resistor r=22.7971 //w=0.269 //l=0.106066 //layer=ply \
 //thickness=0.18 //x=1.31 //y=4.865 //x2=1.385 //y2=4.79
r700 (  177 230 ) resistor r=35.8364 //w=0.269 //l=0.270185 //layer=ply \
 //thickness=0.18 //x=1.31 //y=4.865 //x2=1.11 //y2=4.7
r701 (  175 226 ) resistor r=10.701 //w=0.21 //l=0.115 //layer=ply \
 //thickness=0.18 //x=0.965 //y=1.375 //x2=0.85 //y2=1.375
r702 (  174 232 ) resistor r=5.52526 //w=0.168 //l=0.115 //layer=ply \
 //thickness=0.18 //x=1.185 //y=1.375 //x2=1.3 //y2=1.375
r703 (  173 225 ) resistor r=5.52526 //w=0.168 //l=0.115 //layer=ply \
 //thickness=0.18 //x=0.965 //y=0.72 //x2=0.85 //y2=0.72
r704 (  172 231 ) resistor r=5.52526 //w=0.168 //l=0.115 //layer=ply \
 //thickness=0.18 //x=1.185 //y=0.72 //x2=1.3 //y2=0.72
r705 (  172 173 ) resistor r=112.809 //w=0.094 //l=0.22 //layer=ply \
 //thickness=0.18 //x=1.185 //y=0.72 //x2=0.965 //y2=0.72
r706 (  171 228 ) resistor r=58.7805 //w=0.246 //l=0.373497 //layer=ply \
 //thickness=0.18 //x=0.81 //y=1.915 //x2=1.11 //y2=2.08
r707 (  170 226 ) resistor r=39.5823 //w=0.21 //l=0.173853 //layer=ply \
 //thickness=0.18 //x=0.81 //y=1.53 //x2=0.85 //y2=1.375
r708 (  170 171 ) resistor r=197.415 //w=0.094 //l=0.385 //layer=ply \
 //thickness=0.18 //x=0.81 //y=1.53 //x2=0.81 //y2=1.915
r709 (  169 226 ) resistor r=39.5823 //w=0.21 //l=0.173853 //layer=ply \
 //thickness=0.18 //x=0.81 //y=1.22 //x2=0.85 //y2=1.375
r710 (  168 225 ) resistor r=45.1352 //w=0.168 //l=0.173853 //layer=ply \
 //thickness=0.18 //x=0.81 //y=0.875 //x2=0.85 //y2=0.72
r711 (  168 169 ) resistor r=176.904 //w=0.094 //l=0.345 //layer=ply \
 //thickness=0.18 //x=0.81 //y=0.875 //x2=0.81 //y2=1.22
r712 (  167 220 ) resistor r=592.245 //w=0.094 //l=1.155 //layer=ply \
 //thickness=0.18 //x=20.46 //y=6.02 //x2=20.46 //y2=4.865
r713 (  166 254 ) resistor r=592.245 //w=0.094 //l=1.155 //layer=ply \
 //thickness=0.18 //x=20.02 //y=6.02 //x2=20.02 //y2=4.865
r714 (  165 201 ) resistor r=592.245 //w=0.094 //l=1.155 //layer=ply \
 //thickness=0.18 //x=10.47 //y=6.02 //x2=10.47 //y2=4.865
r715 (  164 241 ) resistor r=592.245 //w=0.094 //l=1.155 //layer=ply \
 //thickness=0.18 //x=10.03 //y=6.02 //x2=10.03 //y2=4.865
r716 (  163 184 ) resistor r=592.245 //w=0.094 //l=1.155 //layer=ply \
 //thickness=0.18 //x=1.75 //y=6.02 //x2=1.75 //y2=4.865
r717 (  162 177 ) resistor r=592.245 //w=0.094 //l=1.155 //layer=ply \
 //thickness=0.18 //x=1.31 //y=6.02 //x2=1.31 //y2=4.865
r718 (  161 217 ) resistor r=56.4043 //w=0.094 //l=0.11 //layer=ply \
 //thickness=0.18 //x=20.28 //y=1.405 //x2=20.39 //y2=1.405
r719 (  161 218 ) resistor r=56.4043 //w=0.094 //l=0.11 //layer=ply \
 //thickness=0.18 //x=20.28 //y=1.405 //x2=20.17 //y2=1.405
r720 (  160 198 ) resistor r=56.4043 //w=0.094 //l=0.11 //layer=ply \
 //thickness=0.18 //x=10.29 //y=1.405 //x2=10.4 //y2=1.405
r721 (  160 199 ) resistor r=56.4043 //w=0.094 //l=0.11 //layer=ply \
 //thickness=0.18 //x=10.29 //y=1.405 //x2=10.18 //y2=1.405
r722 (  159 174 ) resistor r=56.4043 //w=0.094 //l=0.11 //layer=ply \
 //thickness=0.18 //x=1.075 //y=1.375 //x2=1.185 //y2=1.375
r723 (  159 175 ) resistor r=56.4043 //w=0.094 //l=0.11 //layer=ply \
 //thickness=0.18 //x=1.075 //y=1.375 //x2=0.965 //y2=1.375
r724 (  155 251 ) resistor r=152 //w=0.17 //l=0.17 //layer=licon //count=1 \
 //x=20.01 //y=4.7 //x2=20.01 //y2=4.7
r725 (  146 247 ) resistor r=152 //w=0.17 //l=0.17 //layer=licon //count=1 \
 //x=19.98 //y=2.08 //x2=19.98 //y2=2.08
r726 (  129 262 ) resistor r=23.615 //w=0.187 //l=0.345 //layer=li \
 //thickness=0.1 //x=13.58 //y=5.38 //x2=13.58 //y2=5.725
r727 (  121 261 ) resistor r=23.615 //w=0.187 //l=0.345 //layer=li \
 //thickness=0.1 //x=12.7 //y=5.38 //x2=12.7 //y2=5.725
r728 (  116 238 ) resistor r=152 //w=0.17 //l=0.17 //layer=licon //count=1 \
 //x=10.02 //y=4.7 //x2=10.02 //y2=4.7
r729 (  107 234 ) resistor r=152 //w=0.17 //l=0.17 //layer=licon //count=1 \
 //x=9.99 //y=2.08 //x2=9.99 //y2=2.08
r730 (  102 230 ) resistor r=152 //w=0.17 //l=0.17 //layer=licon //count=1 \
 //x=1.11 //y=4.7 //x2=1.11 //y2=4.7
r731 (  93 228 ) resistor r=152 //w=0.17 //l=0.17 //layer=licon //count=1 \
 //x=1.11 //y=2.08 //x2=1.11 //y2=2.08
r732 (  83 85 ) resistor r=0.10734 //w=0.281 //l=0.16 //layer=m2 \
 //thickness=0.36 //x=1.115 //y=4.075 //x2=1.275 //y2=4.075
r733 (  81 89 ) resistor r=1.10585 //w=0.196 //l=1.7325 //layer=m2 \
 //thickness=0.36 //x=15.78 //y=4.09 //x2=14.05 //y2=4.085
r734 (  80 91 ) resistor r=2.64838 //w=0.182 //l=3.86499 //layer=m2 \
 //thickness=0.36 //x=16.125 //y=4.09 //x2=19.98 //y2=4.07
r735 (  80 81 ) resistor r=0.329198 //w=0.131 //l=0.345 //layer=m2 \
 //thickness=0.36 //x=16.125 //y=4.09 //x2=15.78 //y2=4.09
r736 (  79 87 ) resistor r=0.110608 //w=0.182 //l=0.162481 //layer=m2 \
 //thickness=0.36 //x=10.155 //y=4.07 //x2=9.995 //y2=4.075
r737 (  78 89 ) resistor r=0.104578 //w=0.196 //l=0.167332 //layer=m2 \
 //thickness=0.36 //x=13.89 //y=4.07 //x2=14.05 //y2=4.085
r738 (  78 79 ) resistor r=3.56393 //w=0.131 //l=3.735 //layer=m2 \
 //thickness=0.36 //x=13.89 //y=4.07 //x2=10.155 //y2=4.07
r739 (  76 87 ) resistor r=2.65525 //w=0.182 //l=3.87 //layer=m2 \
 //thickness=0.36 //x=6.13 //y=4.085 //x2=9.995 //y2=4.075
r740 (  76 77 ) resistor r=0.329198 //w=0.131 //l=0.345 //layer=m2 \
 //thickness=0.36 //x=6.13 //y=4.085 //x2=5.785 //y2=4.085
r741 (  74 77 ) resistor r=0.1875 //w=0.17 //l=0.262393 //layer=m2 \
 //thickness=0.36 //x=5.53 //y=4.07 //x2=5.785 //y2=4.085
r742 (  74 75 ) resistor r=1.02576 //w=0.131 //l=1.075 //layer=m2 \
 //thickness=0.36 //x=5.53 //y=4.07 //x2=4.455 //y2=4.07
r743 (  72 75 ) resistor r=0.125 //w=0.17 //l=0.177341 //layer=m2 \
 //thickness=0.36 //x=4.285 //y=4.085 //x2=4.455 //y2=4.07
r744 (  72 73 ) resistor r=0.329198 //w=0.131 //l=0.345 //layer=m2 \
 //thickness=0.36 //x=4.285 //y=4.085 //x2=3.94 //y2=4.085
r745 (  70 73 ) resistor r=0.1875 //w=0.17 //l=0.262393 //layer=m2 \
 //thickness=0.36 //x=3.685 //y=4.07 //x2=3.94 //y2=4.085
r746 (  70 85 ) resistor r=2.29962 //w=0.131 //l=2.41 //layer=m2 \
 //thickness=0.36 //x=3.685 //y=4.07 //x2=1.275 //y2=4.07
r747 (  69 155 ) resistor r=9.3 //w=0.17 //l=0.17 //layer=mcon //count=1 \
 //x=20.01 //y=4.7 //x2=20.01 //y2=4.7
r748 (  65 146 ) resistor r=9.3 //w=0.17 //l=0.17 //layer=mcon //count=1 \
 //x=19.98 //y=2.08 //x2=19.98 //y2=2.08
r749 (  65 67 ) resistor r=0.0936408 //w=0.196 //l=0.125 //layer=m1 \
 //thickness=0.36 //x=19.982 //y=2.08 //x2=19.982 //y2=2.205
r750 (  62 91 ) resistor r=4.5 //w=0.15 //l=0.15 //layer=via1 //count=1 \
 //x=19.98 //y=4.07 //x2=19.98 //y2=4.07
r751 (  60 89 ) resistor r=4.5 //w=0.15 //l=0.15 //layer=via1 //count=1 \
 //x=14.05 //y=4.085 //x2=14.05 //y2=4.085
r752 (  58 60 ) resistor r=0.00505391 //w=0.371 //l=0.015 //layer=m1 \
 //thickness=0.36 //x=14.002 //y=4.07 //x2=14.002 //y2=4.085
r753 (  55 259 ) resistor r=9.3 //w=0.17 //l=0.17 //layer=mcon //count=1 \
 //x=13.62 //y=1 //x2=13.62 //y2=1
r754 (  53 129 ) resistor r=9.3 //w=0.17 //l=0.17 //layer=mcon //count=1 \
 //x=13.58 //y=5.38 //x2=13.58 //y2=5.38
r755 (  50 53 ) resistor r=0.117801 //w=0.191 //l=0.18 //layer=m1 \
 //thickness=0.36 //x=13.58 //y=5.2 //x2=13.58 //y2=5.38
r756 (  49 121 ) resistor r=9.3 //w=0.17 //l=0.17 //layer=mcon //count=1 \
 //x=12.7 //y=5.38 //x2=12.7 //y2=5.38
r757 (  47 49 ) resistor r=0.10274 //w=0.219 //l=0.18 //layer=m1 \
 //thickness=0.36 //x=12.7 //y=5.2 //x2=12.7 //y2=5.38
r758 (  46 116 ) resistor r=9.3 //w=0.17 //l=0.17 //layer=mcon //count=1 \
 //x=10.02 //y=4.7 //x2=10.02 //y2=4.7
r759 (  42 107 ) resistor r=9.3 //w=0.17 //l=0.17 //layer=mcon //count=1 \
 //x=9.99 //y=2.08 //x2=9.99 //y2=2.08
r760 (  42 44 ) resistor r=0.0936408 //w=0.196 //l=0.125 //layer=m1 \
 //thickness=0.36 //x=9.992 //y=2.08 //x2=9.992 //y2=2.205
r761 (  40 87 ) resistor r=4.5 //w=0.15 //l=0.15 //layer=via1 //count=1 \
 //x=9.995 //y=4.075 //x2=9.995 //y2=4.075
r762 (  38 40 ) resistor r=0.00164908 //w=0.379 //l=0.005 //layer=m1 \
 //thickness=0.36 //x=9.94 //y=4.07 //x2=9.94 //y2=4.075
r763 (  36 83 ) resistor r=4.5 //w=0.15 //l=0.15 //layer=via1 //count=1 \
 //x=1.115 //y=4.075 //x2=1.115 //y2=4.075
r764 (  34 36 ) resistor r=0.00167112 //w=0.374 //l=0.005 //layer=m1 \
 //thickness=0.36 //x=1.165 //y=4.07 //x2=1.165 //y2=4.075
r765 (  32 102 ) resistor r=9.3 //w=0.17 //l=0.17 //layer=mcon //count=1 \
 //x=1.11 //y=4.7 //x2=1.11 //y2=4.7
r766 (  30 93 ) resistor r=9.3 //w=0.17 //l=0.17 //layer=mcon //count=1 \
 //x=1.11 //y=2.08 //x2=1.11 //y2=2.08
r767 (  28 69 ) resistor r=0.0878548 //w=0.228 //l=0.159295 //layer=m1 \
 //thickness=0.36 //x=19.98 //y=4.555 //x2=20.01 //y2=4.7
r768 (  27 62 ) resistor r=0.0911593 //w=0.376 //l=0.184608 //layer=m1 \
 //thickness=0.36 //x=19.98 //y=4.23 //x2=19.927 //y2=4.07
r769 (  27 28 ) resistor r=0.310115 //w=0.131 //l=0.325 //layer=m1 \
 //thickness=0.36 //x=19.98 //y=4.23 //x2=19.98 //y2=4.555
r770 (  26 62 ) resistor r=0.0911593 //w=0.376 //l=0.184608 //layer=m1 \
 //thickness=0.36 //x=19.98 //y=3.91 //x2=19.927 //y2=4.07
r771 (  26 67 ) resistor r=1.62691 //w=0.131 //l=1.705 //layer=m1 \
 //thickness=0.36 //x=19.98 //y=3.91 //x2=19.98 //y2=2.205
r772 (  23 60 ) resistor r=0.0909648 //w=0.371 //l=0.186762 //layer=m1 \
 //thickness=0.36 //x=14.06 //y=4.245 //x2=14.002 //y2=4.085
r773 (  23 24 ) resistor r=0.830153 //w=0.131 //l=0.87 //layer=m1 \
 //thickness=0.36 //x=14.06 //y=4.245 //x2=14.06 //y2=5.115
r774 (  22 58 ) resistor r=0.0859108 //w=0.371 //l=0.171566 //layer=m1 \
 //thickness=0.36 //x=14.06 //y=3.925 //x2=14.002 //y2=4.07
r775 (  21 22 ) resistor r=2.08492 //w=0.131 //l=2.185 //layer=m1 \
 //thickness=0.36 //x=14.06 //y=1.74 //x2=14.06 //y2=3.925
r776 (  19 21 ) resistor r=0.0698411 //w=0.17 //l=0.120208 //layer=m1 \
 //thickness=0.36 //x=13.975 //y=1.655 //x2=14.06 //y2=1.74
r777 (  19 20 ) resistor r=0.257634 //w=0.131 //l=0.27 //layer=m1 \
 //thickness=0.36 //x=13.975 //y=1.655 //x2=13.705 //y2=1.655
r778 (  18 50 ) resistor r=0.0257089 //w=0.23 //l=0.115 //layer=m1 \
 //thickness=0.36 //x=13.695 //y=5.2 //x2=13.58 //y2=5.2
r779 (  17 24 ) resistor r=0.0698411 //w=0.17 //l=0.120208 //layer=m1 \
 //thickness=0.36 //x=13.975 //y=5.2 //x2=14.06 //y2=5.115
r780 (  17 18 ) resistor r=0.267176 //w=0.131 //l=0.28 //layer=m1 \
 //thickness=0.36 //x=13.975 //y=5.2 //x2=13.695 //y2=5.2
r781 (  16 20 ) resistor r=0.0698411 //w=0.17 //l=0.120208 //layer=m1 \
 //thickness=0.36 //x=13.62 //y=1.57 //x2=13.705 //y2=1.655
r782 (  15 55 ) resistor r=0.0913624 //w=0.191 //l=0.12 //layer=m1 \
 //thickness=0.36 //x=13.62 //y=1.12 //x2=13.62 //y2=1
r783 (  15 16 ) resistor r=0.429389 //w=0.131 //l=0.45 //layer=m1 \
 //thickness=0.36 //x=13.62 //y=1.12 //x2=13.62 //y2=1.57
r784 (  12 47 ) resistor r=0.0227762 //w=0.219 //l=0.115 //layer=m1 \
 //thickness=0.36 //x=12.815 //y=5.2 //x2=12.7 //y2=5.2
r785 (  11 50 ) resistor r=0.0257089 //w=0.23 //l=0.115 //layer=m1 \
 //thickness=0.36 //x=13.465 //y=5.2 //x2=13.58 //y2=5.2
r786 (  11 12 ) resistor r=0.620229 //w=0.131 //l=0.65 //layer=m1 \
 //thickness=0.36 //x=13.465 //y=5.2 //x2=12.815 //y2=5.2
r787 (  8 46 ) resistor r=0.0878548 //w=0.228 //l=0.159295 //layer=m1 \
 //thickness=0.36 //x=9.99 //y=4.555 //x2=10.02 //y2=4.7
r788 (  7 40 ) resistor r=0.0912814 //w=0.379 //l=0.183303 //layer=m1 \
 //thickness=0.36 //x=9.99 //y=4.235 //x2=9.94 //y2=4.075
r789 (  7 8 ) resistor r=0.305344 //w=0.131 //l=0.32 //layer=m1 \
 //thickness=0.36 //x=9.99 //y=4.235 //x2=9.99 //y2=4.555
r790 (  6 38 ) resistor r=0.0896323 //w=0.379 //l=0.178255 //layer=m1 \
 //thickness=0.36 //x=9.99 //y=3.915 //x2=9.94 //y2=4.07
r791 (  6 44 ) resistor r=1.63168 //w=0.131 //l=1.71 //layer=m1 \
 //thickness=0.36 //x=9.99 //y=3.915 //x2=9.99 //y2=2.205
r792 (  4 32 ) resistor r=0.0760407 //w=0.238 //l=0.125 //layer=m1 \
 //thickness=0.36 //x=1.11 //y=4.575 //x2=1.11 //y2=4.7
r793 (  3 36 ) resistor r=0.0910802 //w=0.374 //l=0.185472 //layer=m1 \
 //thickness=0.36 //x=1.11 //y=4.235 //x2=1.165 //y2=4.075
r794 (  3 4 ) resistor r=0.324427 //w=0.131 //l=0.34 //layer=m1 \
 //thickness=0.36 //x=1.11 //y=4.235 //x2=1.11 //y2=4.575
r795 (  2 34 ) resistor r=0.089409 //w=0.374 //l=0.180416 //layer=m1 \
 //thickness=0.36 //x=1.11 //y=3.915 //x2=1.165 //y2=4.07
r796 (  1 30 ) resistor r=0.0719237 //w=0.222 //l=0.115 //layer=m1 \
 //thickness=0.36 //x=1.11 //y=2.195 //x2=1.11 //y2=2.08
r797 (  1 2 ) resistor r=1.64122 //w=0.131 //l=1.72 //layer=m1 \
 //thickness=0.36 //x=1.11 //y=2.195 //x2=1.11 //y2=3.915
ends PM_DFFX1_PCELL\%noxref_5

subckt PM_DFFX1_PCELL\%noxref_6 ( 37 56 65 75 83 93 109 117 143 153 179 189 \
 211 219 245 255 268 275 280 284 289 294 298 299 300 301 302 303 304 305 306 \
 307 308 309 310 311 312 313 314 315 316 )
c381 ( 316 0 ) capacitor c=0.039252f //x=20.535 //y=5.02
c382 ( 315 0 ) capacitor c=0.0248171f //x=19.655 //y=5.02
c383 ( 314 0 ) capacitor c=0.062611f //x=18.785 //y=5.02
c384 ( 313 0 ) capacitor c=0.039252f //x=17.205 //y=5.02
c385 ( 312 0 ) capacitor c=0.0248171f //x=16.325 //y=5.02
c386 ( 311 0 ) capacitor c=0.0624868f //x=15.455 //y=5.02
c387 ( 310 0 ) capacitor c=0.0390279f //x=13.875 //y=5.02
c388 ( 309 0 ) capacitor c=0.0248171f //x=12.995 //y=5.02
c389 ( 308 0 ) capacitor c=0.0623359f //x=12.125 //y=5.02
c390 ( 307 0 ) capacitor c=0.0395436f //x=10.545 //y=5.02
c391 ( 306 0 ) capacitor c=0.0248171f //x=9.665 //y=5.02
c392 ( 305 0 ) capacitor c=0.0623359f //x=8.795 //y=5.02
c393 ( 304 0 ) capacitor c=0.0395436f //x=7.215 //y=5.02
c394 ( 303 0 ) capacitor c=0.0248171f //x=6.335 //y=5.02
c395 ( 302 0 ) capacitor c=0.0627252f //x=5.465 //y=5.02
c396 ( 301 0 ) capacitor c=0.0466888f //x=3.585 //y=5.02
c397 ( 300 0 ) capacitor c=0.0255832f //x=2.705 //y=5.02
c398 ( 299 0 ) capacitor c=0.0256111f //x=1.825 //y=5.02
c399 ( 298 0 ) capacitor c=0.0693238f //x=0.955 //y=5.02
c400 ( 297 0 ) capacitor c=0.00591168f //x=20.68 //y=7.4
c401 ( 296 0 ) capacitor c=0.00591168f //x=19.8 //y=7.4
c402 ( 295 0 ) capacitor c=0.00591168f //x=18.92 //y=7.4
c403 ( 294 0 ) capacitor c=0.128404f //x=18.13 //y=7.4
c404 ( 293 0 ) capacitor c=0.00591168f //x=17.35 //y=7.4
c405 ( 292 0 ) capacitor c=0.00591168f //x=16.47 //y=7.4
c406 ( 291 0 ) capacitor c=0.00591168f //x=15.54 //y=7.4
c407 ( 289 0 ) capacitor c=0.127112f //x=14.8 //y=7.4
c408 ( 288 0 ) capacitor c=0.00591168f //x=14.06 //y=7.4
c409 ( 286 0 ) capacitor c=0.00591168f //x=13.14 //y=7.4
c410 ( 285 0 ) capacitor c=0.00591168f //x=12.26 //y=7.4
c411 ( 284 0 ) capacitor c=0.126486f //x=11.47 //y=7.4
c412 ( 283 0 ) capacitor c=0.00591168f //x=10.69 //y=7.4
c413 ( 282 0 ) capacitor c=0.00591168f //x=9.81 //y=7.4
c414 ( 281 0 ) capacitor c=0.00591168f //x=8.93 //y=7.4
c415 ( 280 0 ) capacitor c=0.126644f //x=8.14 //y=7.4
c416 ( 279 0 ) capacitor c=0.00591168f //x=7.36 //y=7.4
c417 ( 278 0 ) capacitor c=0.00591168f //x=6.48 //y=7.4
c418 ( 277 0 ) capacitor c=0.00591168f //x=5.55 //y=7.4
c419 ( 275 0 ) capacitor c=0.145599f //x=4.81 //y=7.4
c420 ( 274 0 ) capacitor c=0.00591168f //x=3.73 //y=7.4
c421 ( 273 0 ) capacitor c=0.00591168f //x=2.85 //y=7.4
c422 ( 272 0 ) capacitor c=0.00591168f //x=1.97 //y=7.4
c423 ( 271 0 ) capacitor c=0.00591168f //x=1.09 //y=7.4
c424 ( 268 0 ) capacitor c=0.243082f //x=21.09 //y=7.4
c425 ( 255 0 ) capacitor c=0.0284688f //x=20.595 //y=7.4
c426 ( 245 0 ) capacitor c=0.0288404f //x=19.715 //y=7.4
c427 ( 235 0 ) capacitor c=0.0281468f //x=18.835 //y=7.4
c428 ( 229 0 ) capacitor c=0.0275781f //x=17.96 //y=7.4
c429 ( 219 0 ) capacitor c=0.0284687f //x=17.265 //y=7.4
c430 ( 211 0 ) capacitor c=0.0288404f //x=16.385 //y=7.4
c431 ( 201 0 ) capacitor c=0.0281468f //x=15.505 //y=7.4
c432 ( 197 0 ) capacitor c=0.0271916f //x=14.63 //y=7.4
c433 ( 189 0 ) capacitor c=0.0284688f //x=13.935 //y=7.4
c434 ( 179 0 ) capacitor c=0.0288404f //x=13.055 //y=7.4
c435 ( 167 0 ) capacitor c=0.0281468f //x=12.175 //y=7.4
c436 ( 163 0 ) capacitor c=0.0275781f //x=11.3 //y=7.4
c437 ( 153 0 ) capacitor c=0.0284688f //x=10.605 //y=7.4
c438 ( 143 0 ) capacitor c=0.0288404f //x=9.725 //y=7.4
c439 ( 133 0 ) capacitor c=0.0281468f //x=8.845 //y=7.4
c440 ( 127 0 ) capacitor c=0.0275781f //x=7.97 //y=7.4
c441 ( 117 0 ) capacitor c=0.0284687f //x=7.275 //y=7.4
c442 ( 109 0 ) capacitor c=0.0288404f //x=6.395 //y=7.4
c443 ( 99 0 ) capacitor c=0.0281468f //x=5.515 //y=7.4
c444 ( 93 0 ) capacitor c=0.0419403f //x=4.64 //y=7.4
c445 ( 83 0 ) capacitor c=0.0286174f //x=3.645 //y=7.4
c446 ( 75 0 ) capacitor c=0.0285763f //x=2.765 //y=7.4
c447 ( 65 0 ) capacitor c=0.0287137f //x=1.885 //y=7.4
c448 ( 56 0 ) capacitor c=0.234801f //x=0.74 //y=7.4
c449 ( 53 0 ) capacitor c=0.0452081f //x=1.005 //y=7.4
c450 ( 37 0 ) capacitor c=0.789379f //x=21.09 //y=7.4
r451 (  266 297 ) resistor r=2.94794 //w=0.34 //l=0.085 //layer=li \
 //thickness=0.1 //x=20.765 //y=7.4 //x2=20.68 //y2=7.4
r452 (  266 268 ) resistor r=11.6527 //w=0.357 //l=0.325 //layer=li \
 //thickness=0.1 //x=20.765 //y=7.4 //x2=21.09 //y2=7.4
r453 (  259 297 ) resistor r=4.11603 //w=0.68 //l=0.17 //layer=li \
 //thickness=0.1 //x=20.68 //y=7.23 //x2=20.68 //y2=7.4
r454 (  259 316 ) resistor r=33.1979 //w=0.187 //l=0.485 //layer=li \
 //thickness=0.1 //x=20.68 //y=7.23 //x2=20.68 //y2=6.745
r455 (  256 296 ) resistor r=2.94794 //w=0.34 //l=0.085 //layer=li \
 //thickness=0.1 //x=19.885 //y=7.4 //x2=19.8 //y2=7.4
r456 (  256 258 ) resistor r=16.6723 //w=0.357 //l=0.465 //layer=li \
 //thickness=0.1 //x=19.885 //y=7.4 //x2=20.35 //y2=7.4
r457 (  255 297 ) resistor r=2.94794 //w=0.34 //l=0.085 //layer=li \
 //thickness=0.1 //x=20.595 //y=7.4 //x2=20.68 //y2=7.4
r458 (  255 258 ) resistor r=8.78431 //w=0.357 //l=0.245 //layer=li \
 //thickness=0.1 //x=20.595 //y=7.4 //x2=20.35 //y2=7.4
r459 (  249 296 ) resistor r=4.11603 //w=0.68 //l=0.17 //layer=li \
 //thickness=0.1 //x=19.8 //y=7.23 //x2=19.8 //y2=7.4
r460 (  249 315 ) resistor r=33.1979 //w=0.187 //l=0.485 //layer=li \
 //thickness=0.1 //x=19.8 //y=7.23 //x2=19.8 //y2=6.745
r461 (  246 295 ) resistor r=2.94794 //w=0.34 //l=0.085 //layer=li \
 //thickness=0.1 //x=19.005 //y=7.4 //x2=18.92 //y2=7.4
r462 (  246 248 ) resistor r=8.42577 //w=0.357 //l=0.235 //layer=li \
 //thickness=0.1 //x=19.005 //y=7.4 //x2=19.24 //y2=7.4
r463 (  245 296 ) resistor r=2.94794 //w=0.34 //l=0.085 //layer=li \
 //thickness=0.1 //x=19.715 //y=7.4 //x2=19.8 //y2=7.4
r464 (  245 248 ) resistor r=17.0308 //w=0.357 //l=0.475 //layer=li \
 //thickness=0.1 //x=19.715 //y=7.4 //x2=19.24 //y2=7.4
r465 (  237 295 ) resistor r=4.11603 //w=0.68 //l=0.17 //layer=li \
 //thickness=0.1 //x=18.92 //y=7.23 //x2=18.92 //y2=7.4
r466 (  237 314 ) resistor r=56.4706 //w=0.187 //l=0.825 //layer=li \
 //thickness=0.1 //x=18.92 //y=7.23 //x2=18.92 //y2=6.405
r467 (  236 294 ) resistor r=5.4201 //w=0.34 //l=0.17 //layer=li \
 //thickness=0.1 //x=18.3 //y=7.4 //x2=18.13 //y2=7.4
r468 (  235 295 ) resistor r=2.94794 //w=0.34 //l=0.085 //layer=li \
 //thickness=0.1 //x=18.835 //y=7.4 //x2=18.92 //y2=7.4
r469 (  235 236 ) resistor r=19.1821 //w=0.357 //l=0.535 //layer=li \
 //thickness=0.1 //x=18.835 //y=7.4 //x2=18.3 //y2=7.4
r470 (  230 293 ) resistor r=2.94794 //w=0.34 //l=0.085 //layer=li \
 //thickness=0.1 //x=17.435 //y=7.4 //x2=17.35 //y2=7.4
r471 (  230 232 ) resistor r=11.6527 //w=0.357 //l=0.325 //layer=li \
 //thickness=0.1 //x=17.435 //y=7.4 //x2=17.76 //y2=7.4
r472 (  229 294 ) resistor r=5.4201 //w=0.34 //l=0.17 //layer=li \
 //thickness=0.1 //x=17.96 //y=7.4 //x2=18.13 //y2=7.4
r473 (  229 232 ) resistor r=7.17087 //w=0.357 //l=0.2 //layer=li \
 //thickness=0.1 //x=17.96 //y=7.4 //x2=17.76 //y2=7.4
r474 (  223 293 ) resistor r=4.11603 //w=0.68 //l=0.17 //layer=li \
 //thickness=0.1 //x=17.35 //y=7.23 //x2=17.35 //y2=7.4
r475 (  223 313 ) resistor r=33.1979 //w=0.187 //l=0.485 //layer=li \
 //thickness=0.1 //x=17.35 //y=7.23 //x2=17.35 //y2=6.745
r476 (  220 292 ) resistor r=2.94794 //w=0.34 //l=0.085 //layer=li \
 //thickness=0.1 //x=16.555 //y=7.4 //x2=16.47 //y2=7.4
r477 (  220 222 ) resistor r=3.40616 //w=0.357 //l=0.095 //layer=li \
 //thickness=0.1 //x=16.555 //y=7.4 //x2=16.65 //y2=7.4
r478 (  219 293 ) resistor r=2.94794 //w=0.34 //l=0.085 //layer=li \
 //thickness=0.1 //x=17.265 //y=7.4 //x2=17.35 //y2=7.4
r479 (  219 222 ) resistor r=22.0504 //w=0.357 //l=0.615 //layer=li \
 //thickness=0.1 //x=17.265 //y=7.4 //x2=16.65 //y2=7.4
r480 (  213 292 ) resistor r=4.11603 //w=0.68 //l=0.17 //layer=li \
 //thickness=0.1 //x=16.47 //y=7.23 //x2=16.47 //y2=7.4
r481 (  213 312 ) resistor r=33.1979 //w=0.187 //l=0.485 //layer=li \
 //thickness=0.1 //x=16.47 //y=7.23 //x2=16.47 //y2=6.745
r482 (  212 291 ) resistor r=2.94794 //w=0.34 //l=0.085 //layer=li \
 //thickness=0.1 //x=15.675 //y=7.4 //x2=15.59 //y2=7.4
r483 (  211 292 ) resistor r=2.94794 //w=0.34 //l=0.085 //layer=li \
 //thickness=0.1 //x=16.385 //y=7.4 //x2=16.47 //y2=7.4
r484 (  211 212 ) resistor r=25.4566 //w=0.357 //l=0.71 //layer=li \
 //thickness=0.1 //x=16.385 //y=7.4 //x2=15.675 //y2=7.4
r485 (  203 291 ) resistor r=4.11603 //w=0.68 //l=0.17 //layer=li \
 //thickness=0.1 //x=15.59 //y=7.23 //x2=15.59 //y2=7.4
r486 (  203 311 ) resistor r=56.4706 //w=0.187 //l=0.825 //layer=li \
 //thickness=0.1 //x=15.59 //y=7.23 //x2=15.59 //y2=6.405
r487 (  202 289 ) resistor r=5.4201 //w=0.34 //l=0.17 //layer=li \
 //thickness=0.1 //x=14.97 //y=7.4 //x2=14.8 //y2=7.4
r488 (  201 291 ) resistor r=2.94794 //w=0.34 //l=0.085 //layer=li \
 //thickness=0.1 //x=15.505 //y=7.4 //x2=15.59 //y2=7.4
r489 (  201 202 ) resistor r=19.1821 //w=0.357 //l=0.535 //layer=li \
 //thickness=0.1 //x=15.505 //y=7.4 //x2=14.97 //y2=7.4
r490 (  198 288 ) resistor r=2.94794 //w=0.34 //l=0.085 //layer=li \
 //thickness=0.1 //x=14.105 //y=7.4 //x2=14.02 //y2=7.4
r491 (  197 289 ) resistor r=5.4201 //w=0.34 //l=0.17 //layer=li \
 //thickness=0.1 //x=14.63 //y=7.4 //x2=14.8 //y2=7.4
r492 (  197 198 ) resistor r=18.8235 //w=0.357 //l=0.525 //layer=li \
 //thickness=0.1 //x=14.63 //y=7.4 //x2=14.105 //y2=7.4
r493 (  191 288 ) resistor r=4.11603 //w=0.68 //l=0.17 //layer=li \
 //thickness=0.1 //x=14.02 //y=7.23 //x2=14.02 //y2=7.4
r494 (  191 310 ) resistor r=33.1979 //w=0.187 //l=0.485 //layer=li \
 //thickness=0.1 //x=14.02 //y=7.23 //x2=14.02 //y2=6.745
r495 (  190 286 ) resistor r=2.94794 //w=0.34 //l=0.085 //layer=li \
 //thickness=0.1 //x=13.225 //y=7.4 //x2=13.14 //y2=7.4
r496 (  189 288 ) resistor r=2.94794 //w=0.34 //l=0.085 //layer=li \
 //thickness=0.1 //x=13.935 //y=7.4 //x2=14.02 //y2=7.4
r497 (  189 190 ) resistor r=25.4566 //w=0.357 //l=0.71 //layer=li \
 //thickness=0.1 //x=13.935 //y=7.4 //x2=13.225 //y2=7.4
r498 (  183 286 ) resistor r=4.11603 //w=0.68 //l=0.17 //layer=li \
 //thickness=0.1 //x=13.14 //y=7.23 //x2=13.14 //y2=7.4
r499 (  183 309 ) resistor r=33.1979 //w=0.187 //l=0.485 //layer=li \
 //thickness=0.1 //x=13.14 //y=7.23 //x2=13.14 //y2=6.745
r500 (  180 285 ) resistor r=2.94794 //w=0.34 //l=0.085 //layer=li \
 //thickness=0.1 //x=12.345 //y=7.4 //x2=12.26 //y2=7.4
r501 (  180 182 ) resistor r=21.6919 //w=0.357 //l=0.605 //layer=li \
 //thickness=0.1 //x=12.345 //y=7.4 //x2=12.95 //y2=7.4
r502 (  179 286 ) resistor r=2.94794 //w=0.34 //l=0.085 //layer=li \
 //thickness=0.1 //x=13.055 //y=7.4 //x2=13.14 //y2=7.4
r503 (  179 182 ) resistor r=3.76471 //w=0.357 //l=0.105 //layer=li \
 //thickness=0.1 //x=13.055 //y=7.4 //x2=12.95 //y2=7.4
r504 (  171 285 ) resistor r=4.11603 //w=0.68 //l=0.17 //layer=li \
 //thickness=0.1 //x=12.26 //y=7.23 //x2=12.26 //y2=7.4
r505 (  171 308 ) resistor r=56.4706 //w=0.187 //l=0.825 //layer=li \
 //thickness=0.1 //x=12.26 //y=7.23 //x2=12.26 //y2=6.405
r506 (  168 284 ) resistor r=5.4201 //w=0.34 //l=0.17 //layer=li \
 //thickness=0.1 //x=11.64 //y=7.4 //x2=11.47 //y2=7.4
r507 (  168 170 ) resistor r=7.17087 //w=0.357 //l=0.2 //layer=li \
 //thickness=0.1 //x=11.64 //y=7.4 //x2=11.84 //y2=7.4
r508 (  167 285 ) resistor r=2.94794 //w=0.34 //l=0.085 //layer=li \
 //thickness=0.1 //x=12.175 //y=7.4 //x2=12.26 //y2=7.4
r509 (  167 170 ) resistor r=12.0112 //w=0.357 //l=0.335 //layer=li \
 //thickness=0.1 //x=12.175 //y=7.4 //x2=11.84 //y2=7.4
r510 (  164 283 ) resistor r=2.94794 //w=0.34 //l=0.085 //layer=li \
 //thickness=0.1 //x=10.775 //y=7.4 //x2=10.69 //y2=7.4
r511 (  163 284 ) resistor r=5.4201 //w=0.34 //l=0.17 //layer=li \
 //thickness=0.1 //x=11.3 //y=7.4 //x2=11.47 //y2=7.4
r512 (  163 164 ) resistor r=18.8235 //w=0.357 //l=0.525 //layer=li \
 //thickness=0.1 //x=11.3 //y=7.4 //x2=10.775 //y2=7.4
r513 (  157 283 ) resistor r=4.11603 //w=0.68 //l=0.17 //layer=li \
 //thickness=0.1 //x=10.69 //y=7.23 //x2=10.69 //y2=7.4
r514 (  157 307 ) resistor r=33.1979 //w=0.187 //l=0.485 //layer=li \
 //thickness=0.1 //x=10.69 //y=7.23 //x2=10.69 //y2=6.745
r515 (  154 282 ) resistor r=2.94794 //w=0.34 //l=0.085 //layer=li \
 //thickness=0.1 //x=9.895 //y=7.4 //x2=9.81 //y2=7.4
r516 (  154 156 ) resistor r=16.6723 //w=0.357 //l=0.465 //layer=li \
 //thickness=0.1 //x=9.895 //y=7.4 //x2=10.36 //y2=7.4
r517 (  153 283 ) resistor r=2.94794 //w=0.34 //l=0.085 //layer=li \
 //thickness=0.1 //x=10.605 //y=7.4 //x2=10.69 //y2=7.4
r518 (  153 156 ) resistor r=8.78431 //w=0.357 //l=0.245 //layer=li \
 //thickness=0.1 //x=10.605 //y=7.4 //x2=10.36 //y2=7.4
r519 (  147 282 ) resistor r=4.11603 //w=0.68 //l=0.17 //layer=li \
 //thickness=0.1 //x=9.81 //y=7.23 //x2=9.81 //y2=7.4
r520 (  147 306 ) resistor r=33.1979 //w=0.187 //l=0.485 //layer=li \
 //thickness=0.1 //x=9.81 //y=7.23 //x2=9.81 //y2=6.745
r521 (  144 281 ) resistor r=2.94794 //w=0.34 //l=0.085 //layer=li \
 //thickness=0.1 //x=9.015 //y=7.4 //x2=8.93 //y2=7.4
r522 (  144 146 ) resistor r=8.42577 //w=0.357 //l=0.235 //layer=li \
 //thickness=0.1 //x=9.015 //y=7.4 //x2=9.25 //y2=7.4
r523 (  143 282 ) resistor r=2.94794 //w=0.34 //l=0.085 //layer=li \
 //thickness=0.1 //x=9.725 //y=7.4 //x2=9.81 //y2=7.4
r524 (  143 146 ) resistor r=17.0308 //w=0.357 //l=0.475 //layer=li \
 //thickness=0.1 //x=9.725 //y=7.4 //x2=9.25 //y2=7.4
r525 (  135 281 ) resistor r=4.11603 //w=0.68 //l=0.17 //layer=li \
 //thickness=0.1 //x=8.93 //y=7.23 //x2=8.93 //y2=7.4
r526 (  135 305 ) resistor r=56.4706 //w=0.187 //l=0.825 //layer=li \
 //thickness=0.1 //x=8.93 //y=7.23 //x2=8.93 //y2=6.405
r527 (  134 280 ) resistor r=5.4201 //w=0.34 //l=0.17 //layer=li \
 //thickness=0.1 //x=8.31 //y=7.4 //x2=8.14 //y2=7.4
r528 (  133 281 ) resistor r=2.94794 //w=0.34 //l=0.085 //layer=li \
 //thickness=0.1 //x=8.845 //y=7.4 //x2=8.93 //y2=7.4
r529 (  133 134 ) resistor r=19.1821 //w=0.357 //l=0.535 //layer=li \
 //thickness=0.1 //x=8.845 //y=7.4 //x2=8.31 //y2=7.4
r530 (  128 279 ) resistor r=2.94794 //w=0.34 //l=0.085 //layer=li \
 //thickness=0.1 //x=7.445 //y=7.4 //x2=7.36 //y2=7.4
r531 (  128 130 ) resistor r=11.6527 //w=0.357 //l=0.325 //layer=li \
 //thickness=0.1 //x=7.445 //y=7.4 //x2=7.77 //y2=7.4
r532 (  127 280 ) resistor r=5.4201 //w=0.34 //l=0.17 //layer=li \
 //thickness=0.1 //x=7.97 //y=7.4 //x2=8.14 //y2=7.4
r533 (  127 130 ) resistor r=7.17087 //w=0.357 //l=0.2 //layer=li \
 //thickness=0.1 //x=7.97 //y=7.4 //x2=7.77 //y2=7.4
r534 (  121 279 ) resistor r=4.11603 //w=0.68 //l=0.17 //layer=li \
 //thickness=0.1 //x=7.36 //y=7.23 //x2=7.36 //y2=7.4
r535 (  121 304 ) resistor r=33.1979 //w=0.187 //l=0.485 //layer=li \
 //thickness=0.1 //x=7.36 //y=7.23 //x2=7.36 //y2=6.745
r536 (  118 278 ) resistor r=2.94794 //w=0.34 //l=0.085 //layer=li \
 //thickness=0.1 //x=6.565 //y=7.4 //x2=6.48 //y2=7.4
r537 (  118 120 ) resistor r=3.40616 //w=0.357 //l=0.095 //layer=li \
 //thickness=0.1 //x=6.565 //y=7.4 //x2=6.66 //y2=7.4
r538 (  117 279 ) resistor r=2.94794 //w=0.34 //l=0.085 //layer=li \
 //thickness=0.1 //x=7.275 //y=7.4 //x2=7.36 //y2=7.4
r539 (  117 120 ) resistor r=22.0504 //w=0.357 //l=0.615 //layer=li \
 //thickness=0.1 //x=7.275 //y=7.4 //x2=6.66 //y2=7.4
r540 (  111 278 ) resistor r=4.11603 //w=0.68 //l=0.17 //layer=li \
 //thickness=0.1 //x=6.48 //y=7.23 //x2=6.48 //y2=7.4
r541 (  111 303 ) resistor r=33.1979 //w=0.187 //l=0.485 //layer=li \
 //thickness=0.1 //x=6.48 //y=7.23 //x2=6.48 //y2=6.745
r542 (  110 277 ) resistor r=2.94794 //w=0.34 //l=0.085 //layer=li \
 //thickness=0.1 //x=5.685 //y=7.4 //x2=5.6 //y2=7.4
r543 (  109 278 ) resistor r=2.94794 //w=0.34 //l=0.085 //layer=li \
 //thickness=0.1 //x=6.395 //y=7.4 //x2=6.48 //y2=7.4
r544 (  109 110 ) resistor r=25.4566 //w=0.357 //l=0.71 //layer=li \
 //thickness=0.1 //x=6.395 //y=7.4 //x2=5.685 //y2=7.4
r545 (  101 277 ) resistor r=4.11603 //w=0.68 //l=0.17 //layer=li \
 //thickness=0.1 //x=5.6 //y=7.23 //x2=5.6 //y2=7.4
r546 (  101 302 ) resistor r=56.4706 //w=0.187 //l=0.825 //layer=li \
 //thickness=0.1 //x=5.6 //y=7.23 //x2=5.6 //y2=6.405
r547 (  100 275 ) resistor r=5.4201 //w=0.34 //l=0.17 //layer=li \
 //thickness=0.1 //x=4.98 //y=7.4 //x2=4.81 //y2=7.4
r548 (  99 277 ) resistor r=2.94794 //w=0.34 //l=0.085 //layer=li \
 //thickness=0.1 //x=5.515 //y=7.4 //x2=5.6 //y2=7.4
r549 (  99 100 ) resistor r=19.1821 //w=0.357 //l=0.535 //layer=li \
 //thickness=0.1 //x=5.515 //y=7.4 //x2=4.98 //y2=7.4
r550 (  94 274 ) resistor r=2.94794 //w=0.34 //l=0.085 //layer=li \
 //thickness=0.1 //x=3.815 //y=7.4 //x2=3.73 //y2=7.4
r551 (  94 96 ) resistor r=9.14286 //w=0.357 //l=0.255 //layer=li \
 //thickness=0.1 //x=3.815 //y=7.4 //x2=4.07 //y2=7.4
r552 (  93 275 ) resistor r=5.4201 //w=0.34 //l=0.17 //layer=li \
 //thickness=0.1 //x=4.64 //y=7.4 //x2=4.81 //y2=7.4
r553 (  93 96 ) resistor r=20.437 //w=0.357 //l=0.57 //layer=li \
 //thickness=0.1 //x=4.64 //y=7.4 //x2=4.07 //y2=7.4
r554 (  87 274 ) resistor r=4.11603 //w=0.68 //l=0.17 //layer=li \
 //thickness=0.1 //x=3.73 //y=7.23 //x2=3.73 //y2=7.4
r555 (  87 301 ) resistor r=33.1979 //w=0.187 //l=0.485 //layer=li \
 //thickness=0.1 //x=3.73 //y=7.23 //x2=3.73 //y2=6.745
r556 (  84 273 ) resistor r=2.94794 //w=0.34 //l=0.085 //layer=li \
 //thickness=0.1 //x=2.935 //y=7.4 //x2=2.85 //y2=7.4
r557 (  84 86 ) resistor r=0.896359 //w=0.357 //l=0.025 //layer=li \
 //thickness=0.1 //x=2.935 //y=7.4 //x2=2.96 //y2=7.4
r558 (  83 274 ) resistor r=2.94794 //w=0.34 //l=0.085 //layer=li \
 //thickness=0.1 //x=3.645 //y=7.4 //x2=3.73 //y2=7.4
r559 (  83 86 ) resistor r=24.5602 //w=0.357 //l=0.685 //layer=li \
 //thickness=0.1 //x=3.645 //y=7.4 //x2=2.96 //y2=7.4
r560 (  77 273 ) resistor r=4.11603 //w=0.68 //l=0.17 //layer=li \
 //thickness=0.1 //x=2.85 //y=7.23 //x2=2.85 //y2=7.4
r561 (  77 300 ) resistor r=33.1979 //w=0.187 //l=0.485 //layer=li \
 //thickness=0.1 //x=2.85 //y=7.23 //x2=2.85 //y2=6.745
r562 (  76 272 ) resistor r=2.94794 //w=0.34 //l=0.085 //layer=li \
 //thickness=0.1 //x=2.055 //y=7.4 //x2=1.97 //y2=7.4
r563 (  75 273 ) resistor r=2.94794 //w=0.34 //l=0.085 //layer=li \
 //thickness=0.1 //x=2.765 //y=7.4 //x2=2.85 //y2=7.4
r564 (  75 76 ) resistor r=25.4566 //w=0.357 //l=0.71 //layer=li \
 //thickness=0.1 //x=2.765 //y=7.4 //x2=2.055 //y2=7.4
r565 (  69 272 ) resistor r=4.11603 //w=0.68 //l=0.17 //layer=li \
 //thickness=0.1 //x=1.97 //y=7.23 //x2=1.97 //y2=7.4
r566 (  69 299 ) resistor r=33.1979 //w=0.187 //l=0.485 //layer=li \
 //thickness=0.1 //x=1.97 //y=7.23 //x2=1.97 //y2=6.745
r567 (  66 271 ) resistor r=2.94794 //w=0.34 //l=0.085 //layer=li \
 //thickness=0.1 //x=1.175 //y=7.4 //x2=1.09 //y2=7.4
r568 (  66 68 ) resistor r=24.2017 //w=0.357 //l=0.675 //layer=li \
 //thickness=0.1 //x=1.175 //y=7.4 //x2=1.85 //y2=7.4
r569 (  65 272 ) resistor r=2.94794 //w=0.34 //l=0.085 //layer=li \
 //thickness=0.1 //x=1.885 //y=7.4 //x2=1.97 //y2=7.4
r570 (  65 68 ) resistor r=1.2549 //w=0.357 //l=0.035 //layer=li \
 //thickness=0.1 //x=1.885 //y=7.4 //x2=1.85 //y2=7.4
r571 (  57 271 ) resistor r=4.11603 //w=0.68 //l=0.17 //layer=li \
 //thickness=0.1 //x=1.09 //y=7.23 //x2=1.09 //y2=7.4
r572 (  57 298 ) resistor r=56.4706 //w=0.187 //l=0.825 //layer=li \
 //thickness=0.1 //x=1.09 //y=7.23 //x2=1.09 //y2=6.405
r573 (  53 271 ) resistor r=2.94794 //w=0.34 //l=0.085 //layer=li \
 //thickness=0.1 //x=1.005 //y=7.4 //x2=1.09 //y2=7.4
r574 (  53 56 ) resistor r=9.5014 //w=0.357 //l=0.265 //layer=li \
 //thickness=0.1 //x=1.005 //y=7.4 //x2=0.74 //y2=7.4
r575 (  37 268 ) resistor r=9.3 //w=0.17 //l=0.17 //layer=mcon //count=1 \
 //x=21.09 //y=7.4 //x2=21.09 //y2=7.4
r576 (  35 258 ) resistor r=3.1 //w=0.17 //l=0.51 //layer=mcon //count=3 \
 //x=20.35 //y=7.4 //x2=20.35 //y2=7.4
r577 (  35 37 ) resistor r=0.307309 //w=0.301 //l=0.74 //layer=m1 \
 //thickness=0.36 //x=20.35 //y=7.4 //x2=21.09 //y2=7.4
r578 (  33 248 ) resistor r=3.1 //w=0.17 //l=0.51 //layer=mcon //count=3 \
 //x=19.24 //y=7.4 //x2=19.24 //y2=7.4
r579 (  33 35 ) resistor r=0.460963 //w=0.301 //l=1.11 //layer=m1 \
 //thickness=0.36 //x=19.24 //y=7.4 //x2=20.35 //y2=7.4
r580 (  31 232 ) resistor r=3.1 //w=0.17 //l=0.51 //layer=mcon //count=3 \
 //x=17.76 //y=7.4 //x2=17.76 //y2=7.4
r581 (  31 33 ) resistor r=0.614618 //w=0.301 //l=1.48 //layer=m1 \
 //thickness=0.36 //x=17.76 //y=7.4 //x2=19.24 //y2=7.4
r582 (  29 222 ) resistor r=3.1 //w=0.17 //l=0.51 //layer=mcon //count=3 \
 //x=16.65 //y=7.4 //x2=16.65 //y2=7.4
r583 (  29 31 ) resistor r=0.460963 //w=0.301 //l=1.11 //layer=m1 \
 //thickness=0.36 //x=16.65 //y=7.4 //x2=17.76 //y2=7.4
r584 (  27 291 ) resistor r=3.1 //w=0.17 //l=0.51 //layer=mcon //count=3 \
 //x=15.54 //y=7.4 //x2=15.54 //y2=7.4
r585 (  27 29 ) resistor r=0.460963 //w=0.301 //l=1.11 //layer=m1 \
 //thickness=0.36 //x=15.54 //y=7.4 //x2=16.65 //y2=7.4
r586 (  25 288 ) resistor r=3.1 //w=0.17 //l=0.51 //layer=mcon //count=3 \
 //x=14.06 //y=7.4 //x2=14.06 //y2=7.4
r587 (  25 27 ) resistor r=0.614618 //w=0.301 //l=1.48 //layer=m1 \
 //thickness=0.36 //x=14.06 //y=7.4 //x2=15.54 //y2=7.4
r588 (  23 182 ) resistor r=3.1 //w=0.17 //l=0.51 //layer=mcon //count=3 \
 //x=12.95 //y=7.4 //x2=12.95 //y2=7.4
r589 (  23 25 ) resistor r=0.460963 //w=0.301 //l=1.11 //layer=m1 \
 //thickness=0.36 //x=12.95 //y=7.4 //x2=14.06 //y2=7.4
r590 (  21 170 ) resistor r=3.1 //w=0.17 //l=0.51 //layer=mcon //count=3 \
 //x=11.84 //y=7.4 //x2=11.84 //y2=7.4
r591 (  21 23 ) resistor r=0.460963 //w=0.301 //l=1.11 //layer=m1 \
 //thickness=0.36 //x=11.84 //y=7.4 //x2=12.95 //y2=7.4
r592 (  19 156 ) resistor r=3.1 //w=0.17 //l=0.51 //layer=mcon //count=3 \
 //x=10.36 //y=7.4 //x2=10.36 //y2=7.4
r593 (  19 21 ) resistor r=0.614618 //w=0.301 //l=1.48 //layer=m1 \
 //thickness=0.36 //x=10.36 //y=7.4 //x2=11.84 //y2=7.4
r594 (  17 146 ) resistor r=3.1 //w=0.17 //l=0.51 //layer=mcon //count=3 \
 //x=9.25 //y=7.4 //x2=9.25 //y2=7.4
r595 (  17 19 ) resistor r=0.460963 //w=0.301 //l=1.11 //layer=m1 \
 //thickness=0.36 //x=9.25 //y=7.4 //x2=10.36 //y2=7.4
r596 (  15 130 ) resistor r=3.1 //w=0.17 //l=0.51 //layer=mcon //count=3 \
 //x=7.77 //y=7.4 //x2=7.77 //y2=7.4
r597 (  15 17 ) resistor r=0.614618 //w=0.301 //l=1.48 //layer=m1 \
 //thickness=0.36 //x=7.77 //y=7.4 //x2=9.25 //y2=7.4
r598 (  13 120 ) resistor r=3.1 //w=0.17 //l=0.51 //layer=mcon //count=3 \
 //x=6.66 //y=7.4 //x2=6.66 //y2=7.4
r599 (  13 15 ) resistor r=0.460963 //w=0.301 //l=1.11 //layer=m1 \
 //thickness=0.36 //x=6.66 //y=7.4 //x2=7.77 //y2=7.4
r600 (  11 277 ) resistor r=3.1 //w=0.17 //l=0.51 //layer=mcon //count=3 \
 //x=5.55 //y=7.4 //x2=5.55 //y2=7.4
r601 (  11 13 ) resistor r=0.460963 //w=0.301 //l=1.11 //layer=m1 \
 //thickness=0.36 //x=5.55 //y=7.4 //x2=6.66 //y2=7.4
r602 (  9 96 ) resistor r=3.1 //w=0.17 //l=0.51 //layer=mcon //count=3 \
 //x=4.07 //y=7.4 //x2=4.07 //y2=7.4
r603 (  9 11 ) resistor r=0.614618 //w=0.301 //l=1.48 //layer=m1 \
 //thickness=0.36 //x=4.07 //y=7.4 //x2=5.55 //y2=7.4
r604 (  7 86 ) resistor r=3.1 //w=0.17 //l=0.51 //layer=mcon //count=3 \
 //x=2.96 //y=7.4 //x2=2.96 //y2=7.4
r605 (  7 9 ) resistor r=0.460963 //w=0.301 //l=1.11 //layer=m1 \
 //thickness=0.36 //x=2.96 //y=7.4 //x2=4.07 //y2=7.4
r606 (  5 68 ) resistor r=3.1 //w=0.17 //l=0.51 //layer=mcon //count=3 \
 //x=1.85 //y=7.4 //x2=1.85 //y2=7.4
r607 (  5 7 ) resistor r=0.460963 //w=0.301 //l=1.11 //layer=m1 \
 //thickness=0.36 //x=1.85 //y=7.4 //x2=2.96 //y2=7.4
r608 (  2 56 ) resistor r=3.1 //w=0.17 //l=0.51 //layer=mcon //count=3 \
 //x=0.74 //y=7.4 //x2=0.74 //y2=7.4
r609 (  2 5 ) resistor r=0.460963 //w=0.301 //l=1.11 //layer=m1 \
 //thickness=0.36 //x=0.74 //y=7.4 //x2=1.85 //y2=7.4
ends PM_DFFX1_PCELL\%noxref_6

subckt PM_DFFX1_PCELL\%noxref_7 ( 5 7 15 19 30 33 34 )
c64 ( 34 0 ) capacitor c=0.0486635f //x=2.965 //y=0.375
c65 ( 33 0 ) capacitor c=0.0198746f //x=1.86 //y=0.91
c66 ( 30 0 ) capacitor c=0.00141302f //x=3.1 //y=0.995
c67 ( 19 0 ) capacitor c=0.00695768f //x=4.07 //y=0.625
c68 ( 15 0 ) capacitor c=0.0154966f //x=3.985 //y=0.54
c69 ( 7 0 ) capacitor c=0.00689476f //x=3.1 //y=0.625
c70 ( 5 0 ) capacitor c=0.0290436f //x=3.015 //y=0.995
r71 (  19 34 ) resistor r=3.57586 //w=0.17 //l=0.125 //layer=li \
 //thickness=0.1 //x=4.07 //y=0.625 //x2=4.07 //y2=0.5
r72 (  19 34 ) resistor r=18.139 //w=0.187 //l=0.265 //layer=li \
 //thickness=0.1 //x=4.07 //y=0.625 //x2=4.07 //y2=0.89
r73 (  16 34 ) resistor r=3.57586 //w=0.17 //l=0.103078 //layer=li \
 //thickness=0.1 //x=3.185 //y=0.54 //x2=3.1 //y2=0.5
r74 (  16 34 ) resistor r=27.3797 //w=0.187 //l=0.4 //layer=li //thickness=0.1 \
 //x=3.185 //y=0.54 //x2=3.585 //y2=0.54
r75 (  15 34 ) resistor r=3.57586 //w=0.17 //l=0.103078 //layer=li \
 //thickness=0.1 //x=3.985 //y=0.54 //x2=4.07 //y2=0.5
r76 (  15 34 ) resistor r=27.3797 //w=0.187 //l=0.4 //layer=li //thickness=0.1 \
 //x=3.985 //y=0.54 //x2=3.585 //y2=0.54
r77 (  11 30 ) resistor r=5.4201 //w=0.17 //l=0.085 //layer=li //thickness=0.1 \
 //x=3.1 //y=1.08 //x2=3.1 //y2=0.995
r78 (  11 34 ) resistor r=10.2674 //w=0.187 //l=0.15 //layer=li \
 //thickness=0.1 //x=3.1 //y=1.08 //x2=3.1 //y2=1.23
r79 (  8 30 ) resistor r=5.4201 //w=0.17 //l=0.085 //layer=li //thickness=0.1 \
 //x=3.1 //y=0.91 //x2=3.1 //y2=0.995
r80 (  8 34 ) resistor r=1.36898 //w=0.187 //l=0.02 //layer=li //thickness=0.1 \
 //x=3.1 //y=0.91 //x2=3.1 //y2=0.89
r81 (  7 34 ) resistor r=3.57586 //w=0.17 //l=0.125 //layer=li //thickness=0.1 \
 //x=3.1 //y=0.625 //x2=3.1 //y2=0.5
r82 (  7 34 ) resistor r=18.139 //w=0.187 //l=0.265 //layer=li //thickness=0.1 \
 //x=3.1 //y=0.625 //x2=3.1 //y2=0.89
r83 (  6 33 ) resistor r=0.751729 //w=0.17 //l=0.085 //layer=li \
 //thickness=0.1 //x=2.135 //y=0.995 //x2=2.05 //y2=0.995
r84 (  5 30 ) resistor r=1.40859 //w=0.34 //l=0.085 //layer=li //thickness=0.1 \
 //x=3.015 //y=0.995 //x2=3.1 //y2=0.995
r85 (  5 6 ) resistor r=60.2353 //w=0.187 //l=0.88 //layer=li //thickness=0.1 \
 //x=3.015 //y=0.995 //x2=2.135 //y2=0.995
ends PM_DFFX1_PCELL\%noxref_7

subckt PM_DFFX1_PCELL\%noxref_8 ( 2 4 10 15 19 20 21 22 23 24 29 31 33 39 40 \
 42 43 46 )
c111 ( 46 0 ) capacitor c=0.0393541f //x=6.69 //y=4.7
c112 ( 43 0 ) capacitor c=0.0284095f //x=6.66 //y=1.915
c113 ( 42 0 ) capacitor c=0.0476356f //x=6.66 //y=2.08
c114 ( 40 0 ) capacitor c=0.0439708f //x=7.225 //y=1.25
c115 ( 39 0 ) capacitor c=0.0192582f //x=7.225 //y=0.905
c116 ( 33 0 ) capacitor c=0.0162526f //x=7.07 //y=1.405
c117 ( 31 0 ) capacitor c=0.0157807f //x=7.07 //y=0.75
c118 ( 29 0 ) capacitor c=0.0372668f //x=7.065 //y=4.79
c119 ( 24 0 ) capacitor c=0.0210762f //x=6.695 //y=1.56
c120 ( 23 0 ) capacitor c=0.0168511f //x=6.695 //y=1.25
c121 ( 22 0 ) capacitor c=0.0175485f //x=6.695 //y=0.905
c122 ( 21 0 ) capacitor c=0.155269f //x=7.14 //y=6.02
c123 ( 20 0 ) capacitor c=0.110375f //x=6.7 //y=6.02
c124 ( 15 0 ) capacitor c=8.9038e-19 //x=6.69 //y=4.7
c125 ( 10 0 ) capacitor c=7.72439e-19 //x=6.66 //y=2.08
c126 ( 4 0 ) capacitor c=0.00706019f //x=6.66 //y=2.08
c127 ( 2 0 ) capacitor c=0.0553422f //x=6.66 //y=4.555
r128 (  48 49 ) resistor r=32.4568 //w=0.214 //l=0.075 //layer=ply \
 //thickness=0.18 //x=6.69 //y=4.79 //x2=6.69 //y2=4.865
r129 (  46 48 ) resistor r=20.271 //w=0.214 //l=0.09 //layer=ply \
 //thickness=0.18 //x=6.69 //y=4.7 //x2=6.69 //y2=4.79
r130 (  42 43 ) resistor r=52.7279 //w=0.214 //l=0.165 //layer=ply \
 //thickness=0.18 //x=6.66 //y=2.08 //x2=6.66 //y2=1.915
r131 (  40 53 ) resistor r=45.1352 //w=0.168 //l=0.173853 //layer=ply \
 //thickness=0.18 //x=7.225 //y=1.25 //x2=7.185 //y2=1.405
r132 (  39 52 ) resistor r=45.1352 //w=0.168 //l=0.173853 //layer=ply \
 //thickness=0.18 //x=7.225 //y=0.905 //x2=7.185 //y2=0.75
r133 (  39 40 ) resistor r=176.904 //w=0.094 //l=0.345 //layer=ply \
 //thickness=0.18 //x=7.225 //y=0.905 //x2=7.225 //y2=1.25
r134 (  34 51 ) resistor r=10.701 //w=0.21 //l=0.115 //layer=ply \
 //thickness=0.18 //x=6.85 //y=1.405 //x2=6.735 //y2=1.405
r135 (  33 53 ) resistor r=5.52526 //w=0.168 //l=0.115 //layer=ply \
 //thickness=0.18 //x=7.07 //y=1.405 //x2=7.185 //y2=1.405
r136 (  32 50 ) resistor r=5.52526 //w=0.168 //l=0.115 //layer=ply \
 //thickness=0.18 //x=6.85 //y=0.75 //x2=6.735 //y2=0.75
r137 (  31 52 ) resistor r=5.52526 //w=0.168 //l=0.115 //layer=ply \
 //thickness=0.18 //x=7.07 //y=0.75 //x2=7.185 //y2=0.75
r138 (  31 32 ) resistor r=112.809 //w=0.094 //l=0.22 //layer=ply \
 //thickness=0.18 //x=7.07 //y=0.75 //x2=6.85 //y2=0.75
r139 (  30 48 ) resistor r=16.5046 //w=0.27 //l=0.135 //layer=ply \
 //thickness=0.18 //x=6.825 //y=4.79 //x2=6.69 //y2=4.79
r140 (  29 36 ) resistor r=26.9307 //w=0.15 //l=0.106066 //layer=ply \
 //thickness=0.18 //x=7.065 //y=4.79 //x2=7.14 //y2=4.865
r141 (  29 30 ) resistor r=123.064 //w=0.094 //l=0.24 //layer=ply \
 //thickness=0.18 //x=7.065 //y=4.79 //x2=6.825 //y2=4.79
r142 (  24 51 ) resistor r=39.5823 //w=0.21 //l=0.173853 //layer=ply \
 //thickness=0.18 //x=6.695 //y=1.56 //x2=6.735 //y2=1.405
r143 (  24 43 ) resistor r=182.032 //w=0.094 //l=0.355 //layer=ply \
 //thickness=0.18 //x=6.695 //y=1.56 //x2=6.695 //y2=1.915
r144 (  23 51 ) resistor r=39.5823 //w=0.21 //l=0.173853 //layer=ply \
 //thickness=0.18 //x=6.695 //y=1.25 //x2=6.735 //y2=1.405
r145 (  22 50 ) resistor r=45.1352 //w=0.168 //l=0.173853 //layer=ply \
 //thickness=0.18 //x=6.695 //y=0.905 //x2=6.735 //y2=0.75
r146 (  22 23 ) resistor r=176.904 //w=0.094 //l=0.345 //layer=ply \
 //thickness=0.18 //x=6.695 //y=0.905 //x2=6.695 //y2=1.25
r147 (  21 36 ) resistor r=592.245 //w=0.094 //l=1.155 //layer=ply \
 //thickness=0.18 //x=7.14 //y=6.02 //x2=7.14 //y2=4.865
r148 (  20 49 ) resistor r=592.245 //w=0.094 //l=1.155 //layer=ply \
 //thickness=0.18 //x=6.7 //y=6.02 //x2=6.7 //y2=4.865
r149 (  19 33 ) resistor r=56.4043 //w=0.094 //l=0.11 //layer=ply \
 //thickness=0.18 //x=6.96 //y=1.405 //x2=7.07 //y2=1.405
r150 (  19 34 ) resistor r=56.4043 //w=0.094 //l=0.11 //layer=ply \
 //thickness=0.18 //x=6.96 //y=1.405 //x2=6.85 //y2=1.405
r151 (  15 46 ) resistor r=152 //w=0.17 //l=0.17 //layer=licon //count=1 \
 //x=6.69 //y=4.7 //x2=6.69 //y2=4.7
r152 (  10 42 ) resistor r=152 //w=0.17 //l=0.17 //layer=licon //count=1 \
 //x=6.66 //y=2.08 //x2=6.66 //y2=2.08
r153 (  8 15 ) resistor r=9.3 //w=0.17 //l=0.17 //layer=mcon //count=1 \
 //x=6.69 //y=4.7 //x2=6.69 //y2=4.7
r154 (  4 10 ) resistor r=9.3 //w=0.17 //l=0.17 //layer=mcon //count=1 \
 //x=6.66 //y=2.08 //x2=6.66 //y2=2.08
r155 (  4 6 ) resistor r=0.0936408 //w=0.196 //l=0.125 //layer=m1 \
 //thickness=0.36 //x=6.662 //y=2.08 //x2=6.662 //y2=2.205
r156 (  2 8 ) resistor r=0.0878548 //w=0.228 //l=0.159295 //layer=m1 \
 //thickness=0.36 //x=6.66 //y=4.555 //x2=6.69 //y2=4.7
r157 (  2 6 ) resistor r=2.24237 //w=0.131 //l=2.35 //layer=m1 \
 //thickness=0.36 //x=6.66 //y=4.555 //x2=6.66 //y2=2.205
ends PM_DFFX1_PCELL\%noxref_8

subckt PM_DFFX1_PCELL\%noxref_9 ( 2 4 10 15 19 20 21 22 23 24 29 31 33 39 40 \
 42 43 46 )
c105 ( 46 0 ) capacitor c=0.0393541f //x=16.68 //y=4.7
c106 ( 43 0 ) capacitor c=0.0303735f //x=16.65 //y=1.915
c107 ( 42 0 ) capacitor c=0.0476996f //x=16.65 //y=2.08
c108 ( 40 0 ) capacitor c=0.0439708f //x=17.215 //y=1.25
c109 ( 39 0 ) capacitor c=0.0192582f //x=17.215 //y=0.905
c110 ( 33 0 ) capacitor c=0.0162526f //x=17.06 //y=1.405
c111 ( 31 0 ) capacitor c=0.0157807f //x=17.06 //y=0.75
c112 ( 29 0 ) capacitor c=0.0372668f //x=17.055 //y=4.79
c113 ( 24 0 ) capacitor c=0.0210762f //x=16.685 //y=1.56
c114 ( 23 0 ) capacitor c=0.0168511f //x=16.685 //y=1.25
c115 ( 22 0 ) capacitor c=0.0175485f //x=16.685 //y=0.905
c116 ( 21 0 ) capacitor c=0.155269f //x=17.13 //y=6.02
c117 ( 20 0 ) capacitor c=0.110375f //x=16.69 //y=6.02
c118 ( 15 0 ) capacitor c=8.9038e-19 //x=16.68 //y=4.7
c119 ( 10 0 ) capacitor c=7.72439e-19 //x=16.65 //y=2.08
c120 ( 4 0 ) capacitor c=0.00687137f //x=16.65 //y=2.08
c121 ( 2 0 ) capacitor c=0.0604397f //x=16.65 //y=4.555
r122 (  48 49 ) resistor r=32.4568 //w=0.214 //l=0.075 //layer=ply \
 //thickness=0.18 //x=16.68 //y=4.79 //x2=16.68 //y2=4.865
r123 (  46 48 ) resistor r=20.271 //w=0.214 //l=0.09 //layer=ply \
 //thickness=0.18 //x=16.68 //y=4.7 //x2=16.68 //y2=4.79
r124 (  42 43 ) resistor r=52.7279 //w=0.214 //l=0.165 //layer=ply \
 //thickness=0.18 //x=16.65 //y=2.08 //x2=16.65 //y2=1.915
r125 (  40 53 ) resistor r=45.1352 //w=0.168 //l=0.173853 //layer=ply \
 //thickness=0.18 //x=17.215 //y=1.25 //x2=17.175 //y2=1.405
r126 (  39 52 ) resistor r=45.1352 //w=0.168 //l=0.173853 //layer=ply \
 //thickness=0.18 //x=17.215 //y=0.905 //x2=17.175 //y2=0.75
r127 (  39 40 ) resistor r=176.904 //w=0.094 //l=0.345 //layer=ply \
 //thickness=0.18 //x=17.215 //y=0.905 //x2=17.215 //y2=1.25
r128 (  34 51 ) resistor r=10.701 //w=0.21 //l=0.115 //layer=ply \
 //thickness=0.18 //x=16.84 //y=1.405 //x2=16.725 //y2=1.405
r129 (  33 53 ) resistor r=5.52526 //w=0.168 //l=0.115 //layer=ply \
 //thickness=0.18 //x=17.06 //y=1.405 //x2=17.175 //y2=1.405
r130 (  32 50 ) resistor r=5.52526 //w=0.168 //l=0.115 //layer=ply \
 //thickness=0.18 //x=16.84 //y=0.75 //x2=16.725 //y2=0.75
r131 (  31 52 ) resistor r=5.52526 //w=0.168 //l=0.115 //layer=ply \
 //thickness=0.18 //x=17.06 //y=0.75 //x2=17.175 //y2=0.75
r132 (  31 32 ) resistor r=112.809 //w=0.094 //l=0.22 //layer=ply \
 //thickness=0.18 //x=17.06 //y=0.75 //x2=16.84 //y2=0.75
r133 (  30 48 ) resistor r=16.5046 //w=0.27 //l=0.135 //layer=ply \
 //thickness=0.18 //x=16.815 //y=4.79 //x2=16.68 //y2=4.79
r134 (  29 36 ) resistor r=26.9307 //w=0.15 //l=0.106066 //layer=ply \
 //thickness=0.18 //x=17.055 //y=4.79 //x2=17.13 //y2=4.865
r135 (  29 30 ) resistor r=123.064 //w=0.094 //l=0.24 //layer=ply \
 //thickness=0.18 //x=17.055 //y=4.79 //x2=16.815 //y2=4.79
r136 (  24 51 ) resistor r=39.5823 //w=0.21 //l=0.173853 //layer=ply \
 //thickness=0.18 //x=16.685 //y=1.56 //x2=16.725 //y2=1.405
r137 (  24 43 ) resistor r=182.032 //w=0.094 //l=0.355 //layer=ply \
 //thickness=0.18 //x=16.685 //y=1.56 //x2=16.685 //y2=1.915
r138 (  23 51 ) resistor r=39.5823 //w=0.21 //l=0.173853 //layer=ply \
 //thickness=0.18 //x=16.685 //y=1.25 //x2=16.725 //y2=1.405
r139 (  22 50 ) resistor r=45.1352 //w=0.168 //l=0.173853 //layer=ply \
 //thickness=0.18 //x=16.685 //y=0.905 //x2=16.725 //y2=0.75
r140 (  22 23 ) resistor r=176.904 //w=0.094 //l=0.345 //layer=ply \
 //thickness=0.18 //x=16.685 //y=0.905 //x2=16.685 //y2=1.25
r141 (  21 36 ) resistor r=592.245 //w=0.094 //l=1.155 //layer=ply \
 //thickness=0.18 //x=17.13 //y=6.02 //x2=17.13 //y2=4.865
r142 (  20 49 ) resistor r=592.245 //w=0.094 //l=1.155 //layer=ply \
 //thickness=0.18 //x=16.69 //y=6.02 //x2=16.69 //y2=4.865
r143 (  19 33 ) resistor r=56.4043 //w=0.094 //l=0.11 //layer=ply \
 //thickness=0.18 //x=16.95 //y=1.405 //x2=17.06 //y2=1.405
r144 (  19 34 ) resistor r=56.4043 //w=0.094 //l=0.11 //layer=ply \
 //thickness=0.18 //x=16.95 //y=1.405 //x2=16.84 //y2=1.405
r145 (  15 46 ) resistor r=152 //w=0.17 //l=0.17 //layer=licon //count=1 \
 //x=16.68 //y=4.7 //x2=16.68 //y2=4.7
r146 (  10 42 ) resistor r=152 //w=0.17 //l=0.17 //layer=licon //count=1 \
 //x=16.65 //y=2.08 //x2=16.65 //y2=2.08
r147 (  8 15 ) resistor r=9.3 //w=0.17 //l=0.17 //layer=mcon //count=1 \
 //x=16.68 //y=4.7 //x2=16.68 //y2=4.7
r148 (  4 10 ) resistor r=9.3 //w=0.17 //l=0.17 //layer=mcon //count=1 \
 //x=16.65 //y=2.08 //x2=16.65 //y2=2.08
r149 (  4 6 ) resistor r=0.0936408 //w=0.196 //l=0.125 //layer=m1 \
 //thickness=0.36 //x=16.652 //y=2.08 //x2=16.652 //y2=2.205
r150 (  2 8 ) resistor r=0.0878548 //w=0.228 //l=0.159295 //layer=m1 \
 //thickness=0.36 //x=16.65 //y=4.555 //x2=16.68 //y2=4.7
r151 (  2 6 ) resistor r=2.24237 //w=0.131 //l=2.35 //layer=m1 \
 //thickness=0.36 //x=16.65 //y=4.555 //x2=16.65 //y2=2.205
ends PM_DFFX1_PCELL\%noxref_9

subckt PM_DFFX1_PCELL\%noxref_10 ( 3 8 9 11 12 14 17 18 21 23 26 34 46 48 49 )
c132 ( 46 0 ) capacitor c=0.00878249f //x=16.76 //y=0.905
c133 ( 34 0 ) capacitor c=0.0322017f //x=16.91 //y=5.38
c134 ( 26 0 ) capacitor c=0.0290186f //x=16.03 //y=5.38
c135 ( 23 0 ) capacitor c=0.0114498f //x=16.95 //y=1
c136 ( 21 0 ) capacitor c=5.78613e-19 //x=16.91 //y=5.38
c137 ( 18 0 ) capacitor c=0.0112205f //x=16.91 //y=5.2
c138 ( 17 0 ) capacitor c=0.00921781f //x=16.03 //y=5.38
c139 ( 14 0 ) capacitor c=0.0930466f //x=17.39 //y=5.115
c140 ( 12 0 ) capacitor c=0.0069619f //x=17.035 //y=1.655
c141 ( 11 0 ) capacitor c=0.0153038f //x=17.305 //y=1.655
c142 ( 9 0 ) capacitor c=0.0118813f //x=17.305 //y=5.2
c143 ( 8 0 ) capacitor c=0.0101547f //x=16.95 //y=1.57
c144 ( 3 0 ) capacitor c=0.0152343f //x=16.795 //y=5.2
r145 (  34 49 ) resistor r=23.615 //w=0.187 //l=0.345 //layer=li \
 //thickness=0.1 //x=16.91 //y=5.38 //x2=16.91 //y2=5.725
r146 (  26 48 ) resistor r=23.615 //w=0.187 //l=0.345 //layer=li \
 //thickness=0.1 //x=16.03 //y=5.38 //x2=16.03 //y2=5.725
r147 (  23 46 ) resistor r=9.3 //w=0.17 //l=0.17 //layer=mcon //count=1 \
 //x=16.95 //y=1 //x2=16.95 //y2=1
r148 (  21 34 ) resistor r=9.3 //w=0.17 //l=0.17 //layer=mcon //count=1 \
 //x=16.91 //y=5.38 //x2=16.91 //y2=5.38
r149 (  18 21 ) resistor r=0.117801 //w=0.191 //l=0.18 //layer=m1 \
 //thickness=0.36 //x=16.91 //y=5.2 //x2=16.91 //y2=5.38
r150 (  17 26 ) resistor r=9.3 //w=0.17 //l=0.17 //layer=mcon //count=1 \
 //x=16.03 //y=5.38 //x2=16.03 //y2=5.38
r151 (  15 17 ) resistor r=0.10274 //w=0.219 //l=0.18 //layer=m1 \
 //thickness=0.36 //x=16.03 //y=5.2 //x2=16.03 //y2=5.38
r152 (  13 14 ) resistor r=3.22042 //w=0.131 //l=3.375 //layer=m1 \
 //thickness=0.36 //x=17.39 //y=1.74 //x2=17.39 //y2=5.115
r153 (  11 13 ) resistor r=0.0698411 //w=0.17 //l=0.120208 //layer=m1 \
 //thickness=0.36 //x=17.305 //y=1.655 //x2=17.39 //y2=1.74
r154 (  11 12 ) resistor r=0.257634 //w=0.131 //l=0.27 //layer=m1 \
 //thickness=0.36 //x=17.305 //y=1.655 //x2=17.035 //y2=1.655
r155 (  10 18 ) resistor r=0.0257089 //w=0.23 //l=0.115 //layer=m1 \
 //thickness=0.36 //x=17.025 //y=5.2 //x2=16.91 //y2=5.2
r156 (  9 14 ) resistor r=0.0698411 //w=0.17 //l=0.120208 //layer=m1 \
 //thickness=0.36 //x=17.305 //y=5.2 //x2=17.39 //y2=5.115
r157 (  9 10 ) resistor r=0.267176 //w=0.131 //l=0.28 //layer=m1 \
 //thickness=0.36 //x=17.305 //y=5.2 //x2=17.025 //y2=5.2
r158 (  8 12 ) resistor r=0.0698411 //w=0.17 //l=0.120208 //layer=m1 \
 //thickness=0.36 //x=16.95 //y=1.57 //x2=17.035 //y2=1.655
r159 (  7 23 ) resistor r=0.0913624 //w=0.191 //l=0.12 //layer=m1 \
 //thickness=0.36 //x=16.95 //y=1.12 //x2=16.95 //y2=1
r160 (  7 8 ) resistor r=0.429389 //w=0.131 //l=0.45 //layer=m1 \
 //thickness=0.36 //x=16.95 //y=1.12 //x2=16.95 //y2=1.57
r161 (  4 15 ) resistor r=0.0227762 //w=0.219 //l=0.115 //layer=m1 \
 //thickness=0.36 //x=16.145 //y=5.2 //x2=16.03 //y2=5.2
r162 (  3 18 ) resistor r=0.0257089 //w=0.23 //l=0.115 //layer=m1 \
 //thickness=0.36 //x=16.795 //y=5.2 //x2=16.91 //y2=5.2
r163 (  3 4 ) resistor r=0.620229 //w=0.131 //l=0.65 //layer=m1 \
 //thickness=0.36 //x=16.795 //y=5.2 //x2=16.145 //y2=5.2
ends PM_DFFX1_PCELL\%noxref_10

subckt PM_DFFX1_PCELL\%noxref_11 ( 4 7 8 11 16 20 21 22 23 24 25 26 30 32 35 \
 36 46 )
c103 ( 46 0 ) capacitor c=0.0682508f //x=19.24 //y=4.7
c104 ( 36 0 ) capacitor c=0.0318956f //x=19.575 //y=1.21
c105 ( 35 0 ) capacitor c=0.0186809f //x=19.575 //y=0.865
c106 ( 32 0 ) capacitor c=0.0141821f //x=19.42 //y=1.365
c107 ( 30 0 ) capacitor c=0.0158553f //x=19.42 //y=0.71
c108 ( 26 0 ) capacitor c=0.088055f //x=19.045 //y=1.915
c109 ( 25 0 ) capacitor c=0.0229235f //x=19.045 //y=1.52
c110 ( 24 0 ) capacitor c=0.0234359f //x=19.045 //y=1.21
c111 ( 23 0 ) capacitor c=0.0198759f //x=19.045 //y=0.865
c112 ( 22 0 ) capacitor c=0.110369f //x=19.58 //y=6.02
c113 ( 21 0 ) capacitor c=0.154619f //x=19.14 //y=6.02
c114 ( 16 0 ) capacitor c=8.13451e-19 //x=19.24 //y=4.7
c115 ( 11 0 ) capacitor c=7.85889e-19 //x=19.24 //y=2.08
c116 ( 8 0 ) capacitor c=0.0726744f //x=19.242 //y=4.56
c117 ( 7 0 ) capacitor c=0.0065088f //x=19.24 //y=4.7
c118 ( 4 0 ) capacitor c=0.00694592f //x=19.24 //y=2.08
r119 (  44 46 ) resistor r=20.6867 //w=0.233 //l=0.1 //layer=ply \
 //thickness=0.18 //x=19.14 //y=4.7 //x2=19.24 //y2=4.7
r120 (  37 46 ) resistor r=70.3348 //w=0.233 //l=0.414367 //layer=ply \
 //thickness=0.18 //x=19.58 //y=4.865 //x2=19.24 //y2=4.7
r121 (  36 48 ) resistor r=45.1352 //w=0.168 //l=0.173853 //layer=ply \
 //thickness=0.18 //x=19.575 //y=1.21 //x2=19.535 //y2=1.365
r122 (  35 47 ) resistor r=45.1352 //w=0.168 //l=0.173853 //layer=ply \
 //thickness=0.18 //x=19.575 //y=0.865 //x2=19.535 //y2=0.71
r123 (  35 36 ) resistor r=176.904 //w=0.094 //l=0.345 //layer=ply \
 //thickness=0.18 //x=19.575 //y=0.865 //x2=19.575 //y2=1.21
r124 (  33 43 ) resistor r=10.701 //w=0.21 //l=0.115 //layer=ply \
 //thickness=0.18 //x=19.2 //y=1.365 //x2=19.085 //y2=1.365
r125 (  32 48 ) resistor r=5.52526 //w=0.168 //l=0.115 //layer=ply \
 //thickness=0.18 //x=19.42 //y=1.365 //x2=19.535 //y2=1.365
r126 (  31 42 ) resistor r=5.52526 //w=0.168 //l=0.115 //layer=ply \
 //thickness=0.18 //x=19.2 //y=0.71 //x2=19.085 //y2=0.71
r127 (  30 47 ) resistor r=5.52526 //w=0.168 //l=0.115 //layer=ply \
 //thickness=0.18 //x=19.42 //y=0.71 //x2=19.535 //y2=0.71
r128 (  30 31 ) resistor r=112.809 //w=0.094 //l=0.22 //layer=ply \
 //thickness=0.18 //x=19.42 //y=0.71 //x2=19.2 //y2=0.71
r129 (  27 44 ) resistor r=13.0941 //w=0.233 //l=0.165 //layer=ply \
 //thickness=0.18 //x=19.14 //y=4.865 //x2=19.14 //y2=4.7
r130 (  26 41 ) resistor r=34.8111 //w=0.27 //l=0.264953 //layer=ply \
 //thickness=0.18 //x=19.045 //y=1.915 //x2=19.24 //y2=2.08
r131 (  25 43 ) resistor r=39.5823 //w=0.21 //l=0.173853 //layer=ply \
 //thickness=0.18 //x=19.045 //y=1.52 //x2=19.085 //y2=1.365
r132 (  25 26 ) resistor r=202.543 //w=0.094 //l=0.395 //layer=ply \
 //thickness=0.18 //x=19.045 //y=1.52 //x2=19.045 //y2=1.915
r133 (  24 43 ) resistor r=39.5823 //w=0.21 //l=0.173853 //layer=ply \
 //thickness=0.18 //x=19.045 //y=1.21 //x2=19.085 //y2=1.365
r134 (  23 42 ) resistor r=45.1352 //w=0.168 //l=0.173853 //layer=ply \
 //thickness=0.18 //x=19.045 //y=0.865 //x2=19.085 //y2=0.71
r135 (  23 24 ) resistor r=176.904 //w=0.094 //l=0.345 //layer=ply \
 //thickness=0.18 //x=19.045 //y=0.865 //x2=19.045 //y2=1.21
r136 (  22 37 ) resistor r=592.245 //w=0.094 //l=1.155 //layer=ply \
 //thickness=0.18 //x=19.58 //y=6.02 //x2=19.58 //y2=4.865
r137 (  21 27 ) resistor r=592.245 //w=0.094 //l=1.155 //layer=ply \
 //thickness=0.18 //x=19.14 //y=6.02 //x2=19.14 //y2=4.865
r138 (  20 32 ) resistor r=56.4043 //w=0.094 //l=0.11 //layer=ply \
 //thickness=0.18 //x=19.31 //y=1.365 //x2=19.42 //y2=1.365
r139 (  20 33 ) resistor r=56.4043 //w=0.094 //l=0.11 //layer=ply \
 //thickness=0.18 //x=19.31 //y=1.365 //x2=19.2 //y2=1.365
r140 (  16 46 ) resistor r=152 //w=0.17 //l=0.17 //layer=licon //count=1 \
 //x=19.24 //y=4.7 //x2=19.24 //y2=4.7
r141 (  11 41 ) resistor r=152 //w=0.17 //l=0.17 //layer=licon //count=1 \
 //x=19.24 //y=2.08 //x2=19.24 //y2=2.08
r142 (  7 16 ) resistor r=9.3 //w=0.17 //l=0.17 //layer=mcon //count=1 \
 //x=19.24 //y=4.7 //x2=19.24 //y2=4.7
r143 (  7 8 ) resistor r=0.103207 //w=0.196 //l=0.14 //layer=m1 \
 //thickness=0.36 //x=19.242 //y=4.7 //x2=19.242 //y2=4.56
r144 (  4 11 ) resistor r=9.3 //w=0.17 //l=0.17 //layer=mcon //count=1 \
 //x=19.24 //y=2.08 //x2=19.24 //y2=2.08
r145 (  1 4 ) resistor r=0.0933015 //w=0.201 //l=0.125 //layer=m1 \
 //thickness=0.36 //x=19.24 //y=2.205 //x2=19.24 //y2=2.08
r146 (  1 8 ) resistor r=2.24714 //w=0.131 //l=2.355 //layer=m1 \
 //thickness=0.36 //x=19.24 //y=2.205 //x2=19.24 //y2=4.56
ends PM_DFFX1_PCELL\%noxref_11

subckt PM_DFFX1_PCELL\%noxref_12 ( 1 6 7 19 27 35 45 57 60 64 65 69 70 75 76 \
 80 81 85 86 92 95 109 124 137 152 174 182 183 184 185 186 187 188 189 190 191 \
 192 )
c420 ( 192 0 ) capacitor c=0.00843555f //x=19.12 //y=0.865
c421 ( 191 0 ) capacitor c=0.00843555f //x=15.79 //y=0.865
c422 ( 190 0 ) capacitor c=0.00843555f //x=12.46 //y=0.865
c423 ( 189 0 ) capacitor c=0.00843555f //x=9.13 //y=0.865
c424 ( 188 0 ) capacitor c=0.00843555f //x=5.8 //y=0.865
c425 ( 187 0 ) capacitor c=0.00840423f //x=0.885 //y=0.875
c426 ( 186 0 ) capacitor c=0.1181f //x=18.13 //y=0
c427 ( 185 0 ) capacitor c=0.117929f //x=14.8 //y=0
c428 ( 184 0 ) capacitor c=0.117565f //x=11.47 //y=0
c429 ( 183 0 ) capacitor c=0.117565f //x=8.14 //y=0
c430 ( 182 0 ) capacitor c=0.118735f //x=4.81 //y=0
c431 ( 174 0 ) capacitor c=0.315514f //x=21.09 //y=0
c432 ( 152 0 ) capacitor c=0.125109f //x=17.96 //y=0
c433 ( 137 0 ) capacitor c=0.125109f //x=14.63 //y=0
c434 ( 124 0 ) capacitor c=0.123931f //x=11.3 //y=0
c435 ( 109 0 ) capacitor c=0.125032f //x=7.97 //y=0
c436 ( 95 0 ) capacitor c=0.178393f //x=0.74 //y=0
c437 ( 92 0 ) capacitor c=0.179315f //x=4.64 //y=0
c438 ( 89 0 ) capacitor c=0.0050875f //x=19.24 //y=0
c439 ( 86 0 ) capacitor c=0.0232551f //x=19.307 //y=0.825
c440 ( 85 0 ) capacitor c=0.0128942f //x=19.31 //y=0.955
c441 ( 83 0 ) capacitor c=0.0050875f //x=15.98 //y=0
c442 ( 81 0 ) capacitor c=0.0188922f //x=15.977 //y=0.825
c443 ( 80 0 ) capacitor c=0.012752f //x=15.98 //y=0.955
c444 ( 78 0 ) capacitor c=0.0050875f //x=12.65 //y=0
c445 ( 76 0 ) capacitor c=0.0188922f //x=12.647 //y=0.825
c446 ( 75 0 ) capacitor c=0.0127968f //x=12.65 //y=0.955
c447 ( 73 0 ) capacitor c=0.0050875f //x=9.25 //y=0
c448 ( 70 0 ) capacitor c=0.0188922f //x=9.317 //y=0.825
c449 ( 69 0 ) capacitor c=0.0127973f //x=9.32 //y=0.955
c450 ( 67 0 ) capacitor c=0.0050875f //x=5.99 //y=0
c451 ( 65 0 ) capacitor c=0.0235363f //x=5.987 //y=0.825
c452 ( 64 0 ) capacitor c=0.0138363f //x=5.99 //y=0.955
c453 ( 62 0 ) capacitor c=0.00509083f //x=1.075 //y=0
c454 ( 60 0 ) capacitor c=0.017081f //x=1.075 //y=0.965
c455 ( 57 0 ) capacitor c=0.0847673f //x=21.09 //y=0
c456 ( 45 0 ) capacitor c=0.111883f //x=19.225 //y=0
c457 ( 35 0 ) capacitor c=0.112169f //x=15.895 //y=0
c458 ( 27 0 ) capacitor c=0.110654f //x=12.565 //y=0
c459 ( 19 0 ) capacitor c=0.112042f //x=9.235 //y=0
c460 ( 7 0 ) capacitor c=0.154521f //x=5.905 //y=0
c461 ( 6 0 ) capacitor c=0.0302305f //x=1.075 //y=0.835
c462 ( 1 0 ) capacitor c=0.0533996f //x=0.99 //y=0
r463 (  172 174 ) resistor r=26.5322 //w=0.357 //l=0.74 //layer=li \
 //thickness=0.1 //x=20.35 //y=0 //x2=21.09 //y2=0
r464 (  170 172 ) resistor r=39.7983 //w=0.357 //l=1.11 //layer=li \
 //thickness=0.1 //x=19.24 //y=0 //x2=20.35 //y2=0
r465 (  168 186 ) resistor r=5.4201 //w=0.34 //l=0.17 //layer=li \
 //thickness=0.1 //x=18.3 //y=0 //x2=18.13 //y2=0
r466 (  168 170 ) resistor r=33.7031 //w=0.357 //l=0.94 //layer=li \
 //thickness=0.1 //x=18.3 //y=0 //x2=19.24 //y2=0
r467 (  157 159 ) resistor r=39.7983 //w=0.357 //l=1.11 //layer=li \
 //thickness=0.1 //x=16.65 //y=0 //x2=17.76 //y2=0
r468 (  155 157 ) resistor r=39.7983 //w=0.357 //l=1.11 //layer=li \
 //thickness=0.1 //x=15.54 //y=0 //x2=16.65 //y2=0
r469 (  153 185 ) resistor r=5.4201 //w=0.34 //l=0.17 //layer=li \
 //thickness=0.1 //x=14.97 //y=0 //x2=14.8 //y2=0
r470 (  153 155 ) resistor r=20.437 //w=0.357 //l=0.57 //layer=li \
 //thickness=0.1 //x=14.97 //y=0 //x2=15.54 //y2=0
r471 (  152 186 ) resistor r=5.4201 //w=0.34 //l=0.17 //layer=li \
 //thickness=0.1 //x=17.96 //y=0 //x2=18.13 //y2=0
r472 (  152 159 ) resistor r=7.17087 //w=0.357 //l=0.2 //layer=li \
 //thickness=0.1 //x=17.96 //y=0 //x2=17.76 //y2=0
r473 (  142 144 ) resistor r=39.7983 //w=0.357 //l=1.11 //layer=li \
 //thickness=0.1 //x=12.95 //y=0 //x2=14.06 //y2=0
r474 (  140 142 ) resistor r=39.7983 //w=0.357 //l=1.11 //layer=li \
 //thickness=0.1 //x=11.84 //y=0 //x2=12.95 //y2=0
r475 (  138 184 ) resistor r=5.4201 //w=0.34 //l=0.17 //layer=li \
 //thickness=0.1 //x=11.64 //y=0 //x2=11.47 //y2=0
r476 (  138 140 ) resistor r=7.17087 //w=0.357 //l=0.2 //layer=li \
 //thickness=0.1 //x=11.64 //y=0 //x2=11.84 //y2=0
r477 (  137 185 ) resistor r=5.4201 //w=0.34 //l=0.17 //layer=li \
 //thickness=0.1 //x=14.63 //y=0 //x2=14.8 //y2=0
r478 (  137 144 ) resistor r=20.437 //w=0.357 //l=0.57 //layer=li \
 //thickness=0.1 //x=14.63 //y=0 //x2=14.06 //y2=0
r479 (  127 129 ) resistor r=39.7983 //w=0.357 //l=1.11 //layer=li \
 //thickness=0.1 //x=9.25 //y=0 //x2=10.36 //y2=0
r480 (  125 183 ) resistor r=5.4201 //w=0.34 //l=0.17 //layer=li \
 //thickness=0.1 //x=8.31 //y=0 //x2=8.14 //y2=0
r481 (  125 127 ) resistor r=33.7031 //w=0.357 //l=0.94 //layer=li \
 //thickness=0.1 //x=8.31 //y=0 //x2=9.25 //y2=0
r482 (  124 184 ) resistor r=5.4201 //w=0.34 //l=0.17 //layer=li \
 //thickness=0.1 //x=11.3 //y=0 //x2=11.47 //y2=0
r483 (  124 129 ) resistor r=33.7031 //w=0.357 //l=0.94 //layer=li \
 //thickness=0.1 //x=11.3 //y=0 //x2=10.36 //y2=0
r484 (  114 116 ) resistor r=39.7983 //w=0.357 //l=1.11 //layer=li \
 //thickness=0.1 //x=6.66 //y=0 //x2=7.77 //y2=0
r485 (  112 114 ) resistor r=39.7983 //w=0.357 //l=1.11 //layer=li \
 //thickness=0.1 //x=5.55 //y=0 //x2=6.66 //y2=0
r486 (  110 182 ) resistor r=5.4201 //w=0.34 //l=0.17 //layer=li \
 //thickness=0.1 //x=4.98 //y=0 //x2=4.81 //y2=0
r487 (  110 112 ) resistor r=20.437 //w=0.357 //l=0.57 //layer=li \
 //thickness=0.1 //x=4.98 //y=0 //x2=5.55 //y2=0
r488 (  109 183 ) resistor r=5.4201 //w=0.34 //l=0.17 //layer=li \
 //thickness=0.1 //x=7.97 //y=0 //x2=8.14 //y2=0
r489 (  109 116 ) resistor r=7.17087 //w=0.357 //l=0.2 //layer=li \
 //thickness=0.1 //x=7.97 //y=0 //x2=7.77 //y2=0
r490 (  99 101 ) resistor r=39.7983 //w=0.357 //l=1.11 //layer=li \
 //thickness=0.1 //x=2.96 //y=0 //x2=4.07 //y2=0
r491 (  97 99 ) resistor r=39.7983 //w=0.357 //l=1.11 //layer=li \
 //thickness=0.1 //x=1.85 //y=0 //x2=2.96 //y2=0
r492 (  95 97 ) resistor r=39.7983 //w=0.357 //l=1.11 //layer=li \
 //thickness=0.1 //x=0.74 //y=0 //x2=1.85 //y2=0
r493 (  92 182 ) resistor r=5.4201 //w=0.34 //l=0.17 //layer=li \
 //thickness=0.1 //x=4.64 //y=0 //x2=4.81 //y2=0
r494 (  92 101 ) resistor r=20.437 //w=0.357 //l=0.57 //layer=li \
 //thickness=0.1 //x=4.64 //y=0 //x2=4.07 //y2=0
r495 (  89 170 ) resistor r=3.1 //w=0.17 //l=0.51 //layer=mcon //count=3 \
 //x=19.24 //y=0 //x2=19.24 //y2=0
r496 (  85 192 ) resistor r=9.3 //w=0.17 //l=0.17 //layer=mcon //count=1 \
 //x=19.31 //y=0.955 //x2=19.31 //y2=0.955
r497 (  85 86 ) resistor r=0.0939994 //w=0.226 //l=0.13 //layer=m1 \
 //thickness=0.36 //x=19.307 //y=0.955 //x2=19.307 //y2=0.825
r498 (  80 191 ) resistor r=9.3 //w=0.17 //l=0.17 //layer=mcon //count=1 \
 //x=15.98 //y=0.955 //x2=15.98 //y2=0.955
r499 (  80 81 ) resistor r=0.0939994 //w=0.226 //l=0.13 //layer=m1 \
 //thickness=0.36 //x=15.977 //y=0.955 //x2=15.977 //y2=0.825
r500 (  75 190 ) resistor r=9.3 //w=0.17 //l=0.17 //layer=mcon //count=1 \
 //x=12.65 //y=0.955 //x2=12.65 //y2=0.955
r501 (  75 76 ) resistor r=0.0939994 //w=0.226 //l=0.13 //layer=m1 \
 //thickness=0.36 //x=12.647 //y=0.955 //x2=12.647 //y2=0.825
r502 (  73 127 ) resistor r=3.1 //w=0.17 //l=0.51 //layer=mcon //count=3 \
 //x=9.25 //y=0 //x2=9.25 //y2=0
r503 (  69 189 ) resistor r=9.3 //w=0.17 //l=0.17 //layer=mcon //count=1 \
 //x=9.32 //y=0.955 //x2=9.32 //y2=0.955
r504 (  69 70 ) resistor r=0.0939994 //w=0.226 //l=0.13 //layer=m1 \
 //thickness=0.36 //x=9.317 //y=0.955 //x2=9.317 //y2=0.825
r505 (  64 188 ) resistor r=9.3 //w=0.17 //l=0.17 //layer=mcon //count=1 \
 //x=5.99 //y=0.955 //x2=5.99 //y2=0.955
r506 (  64 65 ) resistor r=0.0939994 //w=0.226 //l=0.13 //layer=m1 \
 //thickness=0.36 //x=5.987 //y=0.955 //x2=5.987 //y2=0.825
r507 (  60 187 ) resistor r=9.3 //w=0.17 //l=0.17 //layer=mcon //count=1 \
 //x=1.075 //y=0.965 //x2=1.075 //y2=0.965
r508 (  57 174 ) resistor r=9.3 //w=0.17 //l=0.17 //layer=mcon //count=1 \
 //x=21.09 //y=0 //x2=21.09 //y2=0
r509 (  55 172 ) resistor r=3.1 //w=0.17 //l=0.51 //layer=mcon //count=3 \
 //x=20.35 //y=0 //x2=20.35 //y2=0
r510 (  55 57 ) resistor r=0.307309 //w=0.301 //l=0.74 //layer=m1 \
 //thickness=0.36 //x=20.35 //y=0 //x2=21.09 //y2=0
r511 (  53 89 ) resistor r=0.0287885 //w=0.34 //l=0.085 //layer=m1 \
 //thickness=0.36 //x=19.395 //y=0 //x2=19.31 //y2=0
r512 (  53 55 ) resistor r=0.396595 //w=0.301 //l=0.955 //layer=m1 \
 //thickness=0.36 //x=19.395 //y=0 //x2=20.35 //y2=0
r513 (  51 89 ) resistor r=0.0401957 //w=0.68 //l=0.17 //layer=m1 \
 //thickness=0.36 //x=19.31 //y=0.17 //x2=19.31 //y2=0
r514 (  51 86 ) resistor r=0.625 //w=0.131 //l=0.655 //layer=m1 \
 //thickness=0.36 //x=19.31 //y=0.17 //x2=19.31 //y2=0.825
r515 (  50 159 ) resistor r=3.1 //w=0.17 //l=0.51 //layer=mcon //count=3 \
 //x=17.76 //y=0 //x2=17.76 //y2=0
r516 (  48 157 ) resistor r=3.1 //w=0.17 //l=0.51 //layer=mcon //count=3 \
 //x=16.65 //y=0 //x2=16.65 //y2=0
r517 (  48 50 ) resistor r=0.460963 //w=0.301 //l=1.11 //layer=m1 \
 //thickness=0.36 //x=16.65 //y=0 //x2=17.76 //y2=0
r518 (  46 83 ) resistor r=0.0287885 //w=0.34 //l=0.085 //layer=m1 \
 //thickness=0.36 //x=16.065 //y=0 //x2=15.98 //y2=0
r519 (  46 48 ) resistor r=0.24294 //w=0.301 //l=0.585 //layer=m1 \
 //thickness=0.36 //x=16.065 //y=0 //x2=16.65 //y2=0
r520 (  45 89 ) resistor r=0.0287885 //w=0.34 //l=0.085 //layer=m1 \
 //thickness=0.36 //x=19.225 //y=0 //x2=19.31 //y2=0
r521 (  45 50 ) resistor r=0.608389 //w=0.301 //l=1.465 //layer=m1 \
 //thickness=0.36 //x=19.225 //y=0 //x2=17.76 //y2=0
r522 (  43 83 ) resistor r=0.0401957 //w=0.68 //l=0.17 //layer=m1 \
 //thickness=0.36 //x=15.98 //y=0.17 //x2=15.98 //y2=0
r523 (  43 81 ) resistor r=0.625 //w=0.131 //l=0.655 //layer=m1 \
 //thickness=0.36 //x=15.98 //y=0.17 //x2=15.98 //y2=0.825
r524 (  42 155 ) resistor r=3.1 //w=0.17 //l=0.51 //layer=mcon //count=3 \
 //x=15.54 //y=0 //x2=15.54 //y2=0
r525 (  40 144 ) resistor r=3.1 //w=0.17 //l=0.51 //layer=mcon //count=3 \
 //x=14.06 //y=0 //x2=14.06 //y2=0
r526 (  40 42 ) resistor r=0.614618 //w=0.301 //l=1.48 //layer=m1 \
 //thickness=0.36 //x=14.06 //y=0 //x2=15.54 //y2=0
r527 (  38 142 ) resistor r=3.1 //w=0.17 //l=0.51 //layer=mcon //count=3 \
 //x=12.95 //y=0 //x2=12.95 //y2=0
r528 (  38 40 ) resistor r=0.460963 //w=0.301 //l=1.11 //layer=m1 \
 //thickness=0.36 //x=12.95 //y=0 //x2=14.06 //y2=0
r529 (  36 78 ) resistor r=0.0287885 //w=0.34 //l=0.085 //layer=m1 \
 //thickness=0.36 //x=12.735 //y=0 //x2=12.65 //y2=0
r530 (  36 38 ) resistor r=0.0892857 //w=0.301 //l=0.215 //layer=m1 \
 //thickness=0.36 //x=12.735 //y=0 //x2=12.95 //y2=0
r531 (  35 83 ) resistor r=0.0287885 //w=0.34 //l=0.085 //layer=m1 \
 //thickness=0.36 //x=15.895 //y=0 //x2=15.98 //y2=0
r532 (  35 42 ) resistor r=0.147425 //w=0.301 //l=0.355 //layer=m1 \
 //thickness=0.36 //x=15.895 //y=0 //x2=15.54 //y2=0
r533 (  33 78 ) resistor r=0.0401957 //w=0.68 //l=0.17 //layer=m1 \
 //thickness=0.36 //x=12.65 //y=0.17 //x2=12.65 //y2=0
r534 (  33 76 ) resistor r=0.625 //w=0.131 //l=0.655 //layer=m1 \
 //thickness=0.36 //x=12.65 //y=0.17 //x2=12.65 //y2=0.825
r535 (  32 140 ) resistor r=3.1 //w=0.17 //l=0.51 //layer=mcon //count=3 \
 //x=11.84 //y=0 //x2=11.84 //y2=0
r536 (  30 129 ) resistor r=3.1 //w=0.17 //l=0.51 //layer=mcon //count=3 \
 //x=10.36 //y=0 //x2=10.36 //y2=0
r537 (  30 32 ) resistor r=0.614618 //w=0.301 //l=1.48 //layer=m1 \
 //thickness=0.36 //x=10.36 //y=0 //x2=11.84 //y2=0
r538 (  28 73 ) resistor r=0.0287885 //w=0.34 //l=0.085 //layer=m1 \
 //thickness=0.36 //x=9.405 //y=0 //x2=9.32 //y2=0
r539 (  28 30 ) resistor r=0.396595 //w=0.301 //l=0.955 //layer=m1 \
 //thickness=0.36 //x=9.405 //y=0 //x2=10.36 //y2=0
r540 (  27 78 ) resistor r=0.0287885 //w=0.34 //l=0.085 //layer=m1 \
 //thickness=0.36 //x=12.565 //y=0 //x2=12.65 //y2=0
r541 (  27 32 ) resistor r=0.30108 //w=0.301 //l=0.725 //layer=m1 \
 //thickness=0.36 //x=12.565 //y=0 //x2=11.84 //y2=0
r542 (  25 73 ) resistor r=0.0401957 //w=0.68 //l=0.17 //layer=m1 \
 //thickness=0.36 //x=9.32 //y=0.17 //x2=9.32 //y2=0
r543 (  25 70 ) resistor r=0.625 //w=0.131 //l=0.655 //layer=m1 \
 //thickness=0.36 //x=9.32 //y=0.17 //x2=9.32 //y2=0.825
r544 (  24 116 ) resistor r=3.1 //w=0.17 //l=0.51 //layer=mcon //count=3 \
 //x=7.77 //y=0 //x2=7.77 //y2=0
r545 (  22 114 ) resistor r=3.1 //w=0.17 //l=0.51 //layer=mcon //count=3 \
 //x=6.66 //y=0 //x2=6.66 //y2=0
r546 (  22 24 ) resistor r=0.460963 //w=0.301 //l=1.11 //layer=m1 \
 //thickness=0.36 //x=6.66 //y=0 //x2=7.77 //y2=0
r547 (  20 67 ) resistor r=0.0287885 //w=0.34 //l=0.085 //layer=m1 \
 //thickness=0.36 //x=6.075 //y=0 //x2=5.99 //y2=0
r548 (  20 22 ) resistor r=0.24294 //w=0.301 //l=0.585 //layer=m1 \
 //thickness=0.36 //x=6.075 //y=0 //x2=6.66 //y2=0
r549 (  19 73 ) resistor r=0.0287885 //w=0.34 //l=0.085 //layer=m1 \
 //thickness=0.36 //x=9.235 //y=0 //x2=9.32 //y2=0
r550 (  19 24 ) resistor r=0.608389 //w=0.301 //l=1.465 //layer=m1 \
 //thickness=0.36 //x=9.235 //y=0 //x2=7.77 //y2=0
r551 (  17 67 ) resistor r=0.0401957 //w=0.68 //l=0.17 //layer=m1 \
 //thickness=0.36 //x=5.99 //y=0.17 //x2=5.99 //y2=0
r552 (  17 65 ) resistor r=0.625 //w=0.131 //l=0.655 //layer=m1 \
 //thickness=0.36 //x=5.99 //y=0.17 //x2=5.99 //y2=0.825
r553 (  16 112 ) resistor r=3.1 //w=0.17 //l=0.51 //layer=mcon //count=3 \
 //x=5.55 //y=0 //x2=5.55 //y2=0
r554 (  14 101 ) resistor r=3.1 //w=0.17 //l=0.51 //layer=mcon //count=3 \
 //x=4.07 //y=0 //x2=4.07 //y2=0
r555 (  14 16 ) resistor r=0.614618 //w=0.301 //l=1.48 //layer=m1 \
 //thickness=0.36 //x=4.07 //y=0 //x2=5.55 //y2=0
r556 (  12 99 ) resistor r=3.1 //w=0.17 //l=0.51 //layer=mcon //count=3 \
 //x=2.96 //y=0 //x2=2.96 //y2=0
r557 (  12 14 ) resistor r=0.460963 //w=0.301 //l=1.11 //layer=m1 \
 //thickness=0.36 //x=2.96 //y=0 //x2=4.07 //y2=0
r558 (  10 97 ) resistor r=3.1 //w=0.17 //l=0.51 //layer=mcon //count=3 \
 //x=1.85 //y=0 //x2=1.85 //y2=0
r559 (  10 12 ) resistor r=0.460963 //w=0.301 //l=1.11 //layer=m1 \
 //thickness=0.36 //x=1.85 //y=0 //x2=2.96 //y2=0
r560 (  8 62 ) resistor r=0.0287885 //w=0.34 //l=0.085 //layer=m1 \
 //thickness=0.36 //x=1.16 //y=0 //x2=1.075 //y2=0
r561 (  8 10 ) resistor r=0.286545 //w=0.301 //l=0.69 //layer=m1 \
 //thickness=0.36 //x=1.16 //y=0 //x2=1.85 //y2=0
r562 (  7 67 ) resistor r=0.0287885 //w=0.34 //l=0.085 //layer=m1 \
 //thickness=0.36 //x=5.905 //y=0 //x2=5.99 //y2=0
r563 (  7 16 ) resistor r=0.147425 //w=0.301 //l=0.355 //layer=m1 \
 //thickness=0.36 //x=5.905 //y=0 //x2=5.55 //y2=0
r564 (  6 60 ) resistor r=0.0942778 //w=0.221 //l=0.13 //layer=m1 \
 //thickness=0.36 //x=1.075 //y=0.835 //x2=1.075 //y2=0.965
r565 (  5 62 ) resistor r=0.0401957 //w=0.68 //l=0.17 //layer=m1 \
 //thickness=0.36 //x=1.075 //y=0.17 //x2=1.075 //y2=0
r566 (  5 6 ) resistor r=0.634542 //w=0.131 //l=0.665 //layer=m1 \
 //thickness=0.36 //x=1.075 //y=0.17 //x2=1.075 //y2=0.835
r567 (  3 95 ) resistor r=3.1 //w=0.17 //l=0.51 //layer=mcon //count=3 \
 //x=0.74 //y=0 //x2=0.74 //y2=0
r568 (  1 62 ) resistor r=0.0287885 //w=0.34 //l=0.085 //layer=m1 \
 //thickness=0.36 //x=0.99 //y=0 //x2=1.075 //y2=0
r569 (  1 3 ) resistor r=0.103821 //w=0.301 //l=0.25 //layer=m1 \
 //thickness=0.36 //x=0.99 //y=0 //x2=0.74 //y2=0
ends PM_DFFX1_PCELL\%noxref_12

subckt PM_DFFX1_PCELL\%noxref_13 ( 3 8 9 11 12 14 17 18 21 23 26 34 46 48 49 )
c116 ( 46 0 ) capacitor c=0.00878249f //x=20.09 //y=0.905
c117 ( 34 0 ) capacitor c=0.0326476f //x=20.24 //y=5.38
c118 ( 26 0 ) capacitor c=0.0290186f //x=19.36 //y=5.38
c119 ( 23 0 ) capacitor c=0.014893f //x=20.28 //y=1
c120 ( 21 0 ) capacitor c=5.78613e-19 //x=20.24 //y=5.38
c121 ( 18 0 ) capacitor c=0.0155366f //x=20.24 //y=5.2
c122 ( 17 0 ) capacitor c=0.00955402f //x=19.36 //y=5.38
c123 ( 14 0 ) capacitor c=0.13236f //x=20.72 //y=5.115
c124 ( 12 0 ) capacitor c=0.0069619f //x=20.365 //y=1.655
c125 ( 11 0 ) capacitor c=0.0165738f //x=20.635 //y=1.655
c126 ( 9 0 ) capacitor c=0.0143926f //x=20.635 //y=5.2
c127 ( 8 0 ) capacitor c=0.0133876f //x=20.28 //y=1.57
c128 ( 3 0 ) capacitor c=0.0136628f //x=20.125 //y=5.2
r129 (  34 49 ) resistor r=23.615 //w=0.187 //l=0.345 //layer=li \
 //thickness=0.1 //x=20.24 //y=5.38 //x2=20.24 //y2=5.725
r130 (  26 48 ) resistor r=23.615 //w=0.187 //l=0.345 //layer=li \
 //thickness=0.1 //x=19.36 //y=5.38 //x2=19.36 //y2=5.725
r131 (  23 46 ) resistor r=9.3 //w=0.17 //l=0.17 //layer=mcon //count=1 \
 //x=20.28 //y=1 //x2=20.28 //y2=1
r132 (  21 34 ) resistor r=9.3 //w=0.17 //l=0.17 //layer=mcon //count=1 \
 //x=20.24 //y=5.38 //x2=20.24 //y2=5.38
r133 (  18 21 ) resistor r=0.117801 //w=0.191 //l=0.18 //layer=m1 \
 //thickness=0.36 //x=20.24 //y=5.2 //x2=20.24 //y2=5.38
r134 (  17 26 ) resistor r=9.3 //w=0.17 //l=0.17 //layer=mcon //count=1 \
 //x=19.36 //y=5.38 //x2=19.36 //y2=5.38
r135 (  15 17 ) resistor r=0.10274 //w=0.219 //l=0.18 //layer=m1 \
 //thickness=0.36 //x=19.36 //y=5.2 //x2=19.36 //y2=5.38
r136 (  13 14 ) resistor r=3.22042 //w=0.131 //l=3.375 //layer=m1 \
 //thickness=0.36 //x=20.72 //y=1.74 //x2=20.72 //y2=5.115
r137 (  11 13 ) resistor r=0.0698411 //w=0.17 //l=0.120208 //layer=m1 \
 //thickness=0.36 //x=20.635 //y=1.655 //x2=20.72 //y2=1.74
r138 (  11 12 ) resistor r=0.257634 //w=0.131 //l=0.27 //layer=m1 \
 //thickness=0.36 //x=20.635 //y=1.655 //x2=20.365 //y2=1.655
r139 (  10 18 ) resistor r=0.0257089 //w=0.23 //l=0.115 //layer=m1 \
 //thickness=0.36 //x=20.355 //y=5.2 //x2=20.24 //y2=5.2
r140 (  9 14 ) resistor r=0.0698411 //w=0.17 //l=0.120208 //layer=m1 \
 //thickness=0.36 //x=20.635 //y=5.2 //x2=20.72 //y2=5.115
r141 (  9 10 ) resistor r=0.267176 //w=0.131 //l=0.28 //layer=m1 \
 //thickness=0.36 //x=20.635 //y=5.2 //x2=20.355 //y2=5.2
r142 (  8 12 ) resistor r=0.0698411 //w=0.17 //l=0.120208 //layer=m1 \
 //thickness=0.36 //x=20.28 //y=1.57 //x2=20.365 //y2=1.655
r143 (  7 23 ) resistor r=0.0913624 //w=0.191 //l=0.12 //layer=m1 \
 //thickness=0.36 //x=20.28 //y=1.12 //x2=20.28 //y2=1
r144 (  7 8 ) resistor r=0.429389 //w=0.131 //l=0.45 //layer=m1 \
 //thickness=0.36 //x=20.28 //y=1.12 //x2=20.28 //y2=1.57
r145 (  4 15 ) resistor r=0.0227762 //w=0.219 //l=0.115 //layer=m1 \
 //thickness=0.36 //x=19.475 //y=5.2 //x2=19.36 //y2=5.2
r146 (  3 18 ) resistor r=0.0257089 //w=0.23 //l=0.115 //layer=m1 \
 //thickness=0.36 //x=20.125 //y=5.2 //x2=20.24 //y2=5.2
r147 (  3 4 ) resistor r=0.620229 //w=0.131 //l=0.65 //layer=m1 \
 //thickness=0.36 //x=20.125 //y=5.2 //x2=19.475 //y2=5.2
ends PM_DFFX1_PCELL\%noxref_13

subckt PM_DFFX1_PCELL\%noxref_14 ( 1 5 9 13 17 35 )
c52 ( 35 0 ) capacitor c=0.076261f //x=0.455 //y=0.375
c53 ( 17 0 ) capacitor c=0.0259769f //x=2.445 //y=1.59
c54 ( 13 0 ) capacitor c=0.0153941f //x=2.445 //y=0.54
c55 ( 9 0 ) capacitor c=0.00772076f //x=1.56 //y=0.625
c56 ( 5 0 ) capacitor c=0.0211674f //x=1.475 //y=1.59
c57 ( 1 0 ) capacitor c=0.0109947f //x=0.59 //y=1.505
r58 (  18 35 ) resistor r=5.4201 //w=0.17 //l=0.103078 //layer=li \
 //thickness=0.1 //x=1.645 //y=1.59 //x2=1.56 //y2=1.63
r59 (  18 35 ) resistor r=27.3797 //w=0.187 //l=0.4 //layer=li //thickness=0.1 \
 //x=1.645 //y=1.59 //x2=2.045 //y2=1.59
r60 (  17 35 ) resistor r=0.751729 //w=0.17 //l=0.085 //layer=li \
 //thickness=0.1 //x=2.445 //y=1.59 //x2=2.53 //y2=1.59
r61 (  17 35 ) resistor r=27.3797 //w=0.187 //l=0.4 //layer=li //thickness=0.1 \
 //x=2.445 //y=1.59 //x2=2.045 //y2=1.59
r62 (  14 35 ) resistor r=3.57586 //w=0.17 //l=0.103078 //layer=li \
 //thickness=0.1 //x=1.645 //y=0.54 //x2=1.56 //y2=0.5
r63 (  14 35 ) resistor r=27.3797 //w=0.187 //l=0.4 //layer=li //thickness=0.1 \
 //x=1.645 //y=0.54 //x2=2.045 //y2=0.54
r64 (  13 35 ) resistor r=0.751729 //w=0.17 //l=0.085 //layer=li \
 //thickness=0.1 //x=2.445 //y=0.54 //x2=2.53 //y2=0.54
r65 (  13 35 ) resistor r=27.3797 //w=0.187 //l=0.4 //layer=li //thickness=0.1 \
 //x=2.445 //y=0.54 //x2=2.045 //y2=0.54
r66 (  10 35 ) resistor r=1.40859 //w=0.34 //l=0.125 //layer=li \
 //thickness=0.1 //x=1.56 //y=1.505 //x2=1.56 //y2=1.63
r67 (  10 35 ) resistor r=42.0963 //w=0.187 //l=0.615 //layer=li \
 //thickness=0.1 //x=1.56 //y=1.505 //x2=1.56 //y2=0.89
r68 (  9 35 ) resistor r=3.57586 //w=0.17 //l=0.125 //layer=li //thickness=0.1 \
 //x=1.56 //y=0.625 //x2=1.56 //y2=0.5
r69 (  9 35 ) resistor r=18.139 //w=0.187 //l=0.265 //layer=li //thickness=0.1 \
 //x=1.56 //y=0.625 //x2=1.56 //y2=0.89
r70 (  6 35 ) resistor r=3.57586 //w=0.17 //l=0.103078 //layer=li \
 //thickness=0.1 //x=0.675 //y=1.59 //x2=0.59 //y2=1.63
r71 (  6 35 ) resistor r=27.3797 //w=0.187 //l=0.4 //layer=li //thickness=0.1 \
 //x=0.675 //y=1.59 //x2=1.075 //y2=1.59
r72 (  5 35 ) resistor r=5.4201 //w=0.17 //l=0.103078 //layer=li \
 //thickness=0.1 //x=1.475 //y=1.59 //x2=1.56 //y2=1.63
r73 (  5 35 ) resistor r=27.3797 //w=0.187 //l=0.4 //layer=li //thickness=0.1 \
 //x=1.475 //y=1.59 //x2=1.075 //y2=1.59
r74 (  1 35 ) resistor r=3.57586 //w=0.17 //l=0.125 //layer=li //thickness=0.1 \
 //x=0.59 //y=1.505 //x2=0.59 //y2=1.63
r75 (  1 35 ) resistor r=42.0963 //w=0.187 //l=0.615 //layer=li \
 //thickness=0.1 //x=0.59 //y=1.505 //x2=0.59 //y2=0.89
ends PM_DFFX1_PCELL\%noxref_14

subckt PM_DFFX1_PCELL\%noxref_15 ( 1 5 9 10 13 17 29 )
c66 ( 29 0 ) capacitor c=0.0671084f //x=5.37 //y=0.365
c67 ( 17 0 ) capacitor c=0.0067865f //x=7.445 //y=0.615
c68 ( 13 0 ) capacitor c=0.0157877f //x=7.36 //y=0.53
c69 ( 10 0 ) capacitor c=0.00724577f //x=6.475 //y=1.495
c70 ( 9 0 ) capacitor c=0.00770028f //x=6.475 //y=0.615
c71 ( 5 0 ) capacitor c=0.0193892f //x=6.39 //y=1.58
c72 ( 1 0 ) capacitor c=0.00822695f //x=5.505 //y=1.495
r73 (  17 29 ) resistor r=3.57586 //w=0.17 //l=0.125 //layer=li \
 //thickness=0.1 //x=7.445 //y=0.615 //x2=7.445 //y2=0.49
r74 (  17 29 ) resistor r=18.139 //w=0.187 //l=0.265 //layer=li \
 //thickness=0.1 //x=7.445 //y=0.615 //x2=7.445 //y2=0.88
r75 (  14 29 ) resistor r=3.57586 //w=0.17 //l=0.103078 //layer=li \
 //thickness=0.1 //x=6.56 //y=0.53 //x2=6.475 //y2=0.49
r76 (  14 29 ) resistor r=27.3797 //w=0.187 //l=0.4 //layer=li //thickness=0.1 \
 //x=6.56 //y=0.53 //x2=6.96 //y2=0.53
r77 (  13 29 ) resistor r=3.57586 //w=0.17 //l=0.103078 //layer=li \
 //thickness=0.1 //x=7.36 //y=0.53 //x2=7.445 //y2=0.49
r78 (  13 29 ) resistor r=27.3797 //w=0.187 //l=0.4 //layer=li //thickness=0.1 \
 //x=7.36 //y=0.53 //x2=6.96 //y2=0.53
r79 (  10 29 ) resistor r=3.57586 //w=0.17 //l=0.125 //layer=li \
 //thickness=0.1 //x=6.475 //y=1.495 //x2=6.475 //y2=1.62
r80 (  10 29 ) resistor r=42.0963 //w=0.187 //l=0.615 //layer=li \
 //thickness=0.1 //x=6.475 //y=1.495 //x2=6.475 //y2=0.88
r81 (  9 29 ) resistor r=3.57586 //w=0.17 //l=0.125 //layer=li //thickness=0.1 \
 //x=6.475 //y=0.615 //x2=6.475 //y2=0.49
r82 (  9 29 ) resistor r=18.139 //w=0.187 //l=0.265 //layer=li //thickness=0.1 \
 //x=6.475 //y=0.615 //x2=6.475 //y2=0.88
r83 (  6 29 ) resistor r=3.57586 //w=0.17 //l=0.103078 //layer=li \
 //thickness=0.1 //x=5.59 //y=1.58 //x2=5.505 //y2=1.62
r84 (  6 29 ) resistor r=27.3797 //w=0.187 //l=0.4 //layer=li //thickness=0.1 \
 //x=5.59 //y=1.58 //x2=5.99 //y2=1.58
r85 (  5 29 ) resistor r=3.57586 //w=0.17 //l=0.103078 //layer=li \
 //thickness=0.1 //x=6.39 //y=1.58 //x2=6.475 //y2=1.62
r86 (  5 29 ) resistor r=27.3797 //w=0.187 //l=0.4 //layer=li //thickness=0.1 \
 //x=6.39 //y=1.58 //x2=5.99 //y2=1.58
r87 (  1 29 ) resistor r=3.57586 //w=0.17 //l=0.125 //layer=li //thickness=0.1 \
 //x=5.505 //y=1.495 //x2=5.505 //y2=1.62
r88 (  1 29 ) resistor r=42.0963 //w=0.187 //l=0.615 //layer=li \
 //thickness=0.1 //x=5.505 //y=1.495 //x2=5.505 //y2=0.88
ends PM_DFFX1_PCELL\%noxref_15

subckt PM_DFFX1_PCELL\%noxref_16 ( 1 5 9 10 13 17 29 )
c68 ( 29 0 ) capacitor c=0.0668051f //x=8.7 //y=0.365
c69 ( 17 0 ) capacitor c=0.0067865f //x=10.775 //y=0.615
c70 ( 13 0 ) capacitor c=0.0157426f //x=10.69 //y=0.53
c71 ( 10 0 ) capacitor c=0.00742952f //x=9.805 //y=1.495
c72 ( 9 0 ) capacitor c=0.00770028f //x=9.805 //y=0.615
c73 ( 5 0 ) capacitor c=0.0197708f //x=9.72 //y=1.58
c74 ( 1 0 ) capacitor c=0.00821716f //x=8.835 //y=1.495
r75 (  17 29 ) resistor r=3.57586 //w=0.17 //l=0.125 //layer=li \
 //thickness=0.1 //x=10.775 //y=0.615 //x2=10.775 //y2=0.49
r76 (  17 29 ) resistor r=18.139 //w=0.187 //l=0.265 //layer=li \
 //thickness=0.1 //x=10.775 //y=0.615 //x2=10.775 //y2=0.88
r77 (  14 29 ) resistor r=3.57586 //w=0.17 //l=0.103078 //layer=li \
 //thickness=0.1 //x=9.89 //y=0.53 //x2=9.805 //y2=0.49
r78 (  14 29 ) resistor r=27.3797 //w=0.187 //l=0.4 //layer=li //thickness=0.1 \
 //x=9.89 //y=0.53 //x2=10.29 //y2=0.53
r79 (  13 29 ) resistor r=3.57586 //w=0.17 //l=0.103078 //layer=li \
 //thickness=0.1 //x=10.69 //y=0.53 //x2=10.775 //y2=0.49
r80 (  13 29 ) resistor r=27.3797 //w=0.187 //l=0.4 //layer=li //thickness=0.1 \
 //x=10.69 //y=0.53 //x2=10.29 //y2=0.53
r81 (  10 29 ) resistor r=3.57586 //w=0.17 //l=0.125 //layer=li \
 //thickness=0.1 //x=9.805 //y=1.495 //x2=9.805 //y2=1.62
r82 (  10 29 ) resistor r=42.0963 //w=0.187 //l=0.615 //layer=li \
 //thickness=0.1 //x=9.805 //y=1.495 //x2=9.805 //y2=0.88
r83 (  9 29 ) resistor r=3.57586 //w=0.17 //l=0.125 //layer=li //thickness=0.1 \
 //x=9.805 //y=0.615 //x2=9.805 //y2=0.49
r84 (  9 29 ) resistor r=18.139 //w=0.187 //l=0.265 //layer=li //thickness=0.1 \
 //x=9.805 //y=0.615 //x2=9.805 //y2=0.88
r85 (  6 29 ) resistor r=3.57586 //w=0.17 //l=0.103078 //layer=li \
 //thickness=0.1 //x=8.92 //y=1.58 //x2=8.835 //y2=1.62
r86 (  6 29 ) resistor r=27.3797 //w=0.187 //l=0.4 //layer=li //thickness=0.1 \
 //x=8.92 //y=1.58 //x2=9.32 //y2=1.58
r87 (  5 29 ) resistor r=3.57586 //w=0.17 //l=0.103078 //layer=li \
 //thickness=0.1 //x=9.72 //y=1.58 //x2=9.805 //y2=1.62
r88 (  5 29 ) resistor r=27.3797 //w=0.187 //l=0.4 //layer=li //thickness=0.1 \
 //x=9.72 //y=1.58 //x2=9.32 //y2=1.58
r89 (  1 29 ) resistor r=3.57586 //w=0.17 //l=0.125 //layer=li //thickness=0.1 \
 //x=8.835 //y=1.495 //x2=8.835 //y2=1.62
r90 (  1 29 ) resistor r=42.0963 //w=0.187 //l=0.615 //layer=li \
 //thickness=0.1 //x=8.835 //y=1.495 //x2=8.835 //y2=0.88
ends PM_DFFX1_PCELL\%noxref_16

subckt PM_DFFX1_PCELL\%noxref_17 ( 1 5 9 10 13 17 29 )
c66 ( 29 0 ) capacitor c=0.0675014f //x=12.03 //y=0.365
c67 ( 17 0 ) capacitor c=0.0067865f //x=14.105 //y=0.615
c68 ( 13 0 ) capacitor c=0.0157877f //x=14.02 //y=0.53
c69 ( 10 0 ) capacitor c=0.00753446f //x=13.135 //y=1.495
c70 ( 9 0 ) capacitor c=0.00770028f //x=13.135 //y=0.615
c71 ( 5 0 ) capacitor c=0.0197745f //x=13.05 //y=1.58
c72 ( 1 0 ) capacitor c=0.00821716f //x=12.165 //y=1.495
r73 (  17 29 ) resistor r=3.57586 //w=0.17 //l=0.125 //layer=li \
 //thickness=0.1 //x=14.105 //y=0.615 //x2=14.105 //y2=0.49
r74 (  17 29 ) resistor r=18.139 //w=0.187 //l=0.265 //layer=li \
 //thickness=0.1 //x=14.105 //y=0.615 //x2=14.105 //y2=0.88
r75 (  14 29 ) resistor r=3.57586 //w=0.17 //l=0.103078 //layer=li \
 //thickness=0.1 //x=13.22 //y=0.53 //x2=13.135 //y2=0.49
r76 (  14 29 ) resistor r=27.3797 //w=0.187 //l=0.4 //layer=li //thickness=0.1 \
 //x=13.22 //y=0.53 //x2=13.62 //y2=0.53
r77 (  13 29 ) resistor r=3.57586 //w=0.17 //l=0.103078 //layer=li \
 //thickness=0.1 //x=14.02 //y=0.53 //x2=14.105 //y2=0.49
r78 (  13 29 ) resistor r=27.3797 //w=0.187 //l=0.4 //layer=li //thickness=0.1 \
 //x=14.02 //y=0.53 //x2=13.62 //y2=0.53
r79 (  10 29 ) resistor r=3.57586 //w=0.17 //l=0.125 //layer=li \
 //thickness=0.1 //x=13.135 //y=1.495 //x2=13.135 //y2=1.62
r80 (  10 29 ) resistor r=42.0963 //w=0.187 //l=0.615 //layer=li \
 //thickness=0.1 //x=13.135 //y=1.495 //x2=13.135 //y2=0.88
r81 (  9 29 ) resistor r=3.57586 //w=0.17 //l=0.125 //layer=li //thickness=0.1 \
 //x=13.135 //y=0.615 //x2=13.135 //y2=0.49
r82 (  9 29 ) resistor r=18.139 //w=0.187 //l=0.265 //layer=li //thickness=0.1 \
 //x=13.135 //y=0.615 //x2=13.135 //y2=0.88
r83 (  6 29 ) resistor r=3.57586 //w=0.17 //l=0.103078 //layer=li \
 //thickness=0.1 //x=12.25 //y=1.58 //x2=12.165 //y2=1.62
r84 (  6 29 ) resistor r=27.3797 //w=0.187 //l=0.4 //layer=li //thickness=0.1 \
 //x=12.25 //y=1.58 //x2=12.65 //y2=1.58
r85 (  5 29 ) resistor r=3.57586 //w=0.17 //l=0.103078 //layer=li \
 //thickness=0.1 //x=13.05 //y=1.58 //x2=13.135 //y2=1.62
r86 (  5 29 ) resistor r=27.3797 //w=0.187 //l=0.4 //layer=li //thickness=0.1 \
 //x=13.05 //y=1.58 //x2=12.65 //y2=1.58
r87 (  1 29 ) resistor r=3.57586 //w=0.17 //l=0.125 //layer=li //thickness=0.1 \
 //x=12.165 //y=1.495 //x2=12.165 //y2=1.62
r88 (  1 29 ) resistor r=42.0963 //w=0.187 //l=0.615 //layer=li \
 //thickness=0.1 //x=12.165 //y=1.495 //x2=12.165 //y2=0.88
ends PM_DFFX1_PCELL\%noxref_17

subckt PM_DFFX1_PCELL\%noxref_18 ( 1 5 9 10 13 17 29 )
c63 ( 29 0 ) capacitor c=0.067409f //x=15.36 //y=0.365
c64 ( 17 0 ) capacitor c=0.0067865f //x=17.435 //y=0.615
c65 ( 13 0 ) capacitor c=0.0157877f //x=17.35 //y=0.53
c66 ( 10 0 ) capacitor c=0.00955329f //x=16.465 //y=1.495
c67 ( 9 0 ) capacitor c=0.00770028f //x=16.465 //y=0.615
c68 ( 5 0 ) capacitor c=0.0232545f //x=16.38 //y=1.58
c69 ( 1 0 ) capacitor c=0.00844445f //x=15.495 //y=1.495
r70 (  17 29 ) resistor r=3.57586 //w=0.17 //l=0.125 //layer=li \
 //thickness=0.1 //x=17.435 //y=0.615 //x2=17.435 //y2=0.49
r71 (  17 29 ) resistor r=18.139 //w=0.187 //l=0.265 //layer=li \
 //thickness=0.1 //x=17.435 //y=0.615 //x2=17.435 //y2=0.88
r72 (  14 29 ) resistor r=3.57586 //w=0.17 //l=0.103078 //layer=li \
 //thickness=0.1 //x=16.55 //y=0.53 //x2=16.465 //y2=0.49
r73 (  14 29 ) resistor r=27.3797 //w=0.187 //l=0.4 //layer=li //thickness=0.1 \
 //x=16.55 //y=0.53 //x2=16.95 //y2=0.53
r74 (  13 29 ) resistor r=3.57586 //w=0.17 //l=0.103078 //layer=li \
 //thickness=0.1 //x=17.35 //y=0.53 //x2=17.435 //y2=0.49
r75 (  13 29 ) resistor r=27.3797 //w=0.187 //l=0.4 //layer=li //thickness=0.1 \
 //x=17.35 //y=0.53 //x2=16.95 //y2=0.53
r76 (  10 29 ) resistor r=3.57586 //w=0.17 //l=0.125 //layer=li \
 //thickness=0.1 //x=16.465 //y=1.495 //x2=16.465 //y2=1.62
r77 (  10 29 ) resistor r=42.0963 //w=0.187 //l=0.615 //layer=li \
 //thickness=0.1 //x=16.465 //y=1.495 //x2=16.465 //y2=0.88
r78 (  9 29 ) resistor r=3.57586 //w=0.17 //l=0.125 //layer=li //thickness=0.1 \
 //x=16.465 //y=0.615 //x2=16.465 //y2=0.49
r79 (  9 29 ) resistor r=18.139 //w=0.187 //l=0.265 //layer=li //thickness=0.1 \
 //x=16.465 //y=0.615 //x2=16.465 //y2=0.88
r80 (  6 29 ) resistor r=3.57586 //w=0.17 //l=0.103078 //layer=li \
 //thickness=0.1 //x=15.58 //y=1.58 //x2=15.495 //y2=1.62
r81 (  6 29 ) resistor r=27.3797 //w=0.187 //l=0.4 //layer=li //thickness=0.1 \
 //x=15.58 //y=1.58 //x2=15.98 //y2=1.58
r82 (  5 29 ) resistor r=3.57586 //w=0.17 //l=0.103078 //layer=li \
 //thickness=0.1 //x=16.38 //y=1.58 //x2=16.465 //y2=1.62
r83 (  5 29 ) resistor r=27.3797 //w=0.187 //l=0.4 //layer=li //thickness=0.1 \
 //x=16.38 //y=1.58 //x2=15.98 //y2=1.58
r84 (  1 29 ) resistor r=3.57586 //w=0.17 //l=0.125 //layer=li //thickness=0.1 \
 //x=15.495 //y=1.495 //x2=15.495 //y2=1.62
r85 (  1 29 ) resistor r=42.0963 //w=0.187 //l=0.615 //layer=li \
 //thickness=0.1 //x=15.495 //y=1.495 //x2=15.495 //y2=0.88
ends PM_DFFX1_PCELL\%noxref_18

subckt PM_DFFX1_PCELL\%noxref_19 ( 1 5 9 10 13 17 29 )
c54 ( 29 0 ) capacitor c=0.0681699f //x=18.69 //y=0.365
c55 ( 17 0 ) capacitor c=0.00709791f //x=20.765 //y=0.615
c56 ( 13 0 ) capacitor c=0.0157477f //x=20.68 //y=0.53
c57 ( 10 0 ) capacitor c=0.00751901f //x=19.795 //y=1.495
c58 ( 9 0 ) capacitor c=0.00770028f //x=19.795 //y=0.615
c59 ( 5 0 ) capacitor c=0.0245319f //x=19.71 //y=1.58
c60 ( 1 0 ) capacitor c=0.0110931f //x=18.825 //y=1.495
r61 (  17 29 ) resistor r=3.57586 //w=0.17 //l=0.125 //layer=li \
 //thickness=0.1 //x=20.765 //y=0.615 //x2=20.765 //y2=0.49
r62 (  17 29 ) resistor r=18.139 //w=0.187 //l=0.265 //layer=li \
 //thickness=0.1 //x=20.765 //y=0.615 //x2=20.765 //y2=0.88
r63 (  14 29 ) resistor r=3.57586 //w=0.17 //l=0.103078 //layer=li \
 //thickness=0.1 //x=19.88 //y=0.53 //x2=19.795 //y2=0.49
r64 (  14 29 ) resistor r=27.3797 //w=0.187 //l=0.4 //layer=li //thickness=0.1 \
 //x=19.88 //y=0.53 //x2=20.28 //y2=0.53
r65 (  13 29 ) resistor r=3.57586 //w=0.17 //l=0.103078 //layer=li \
 //thickness=0.1 //x=20.68 //y=0.53 //x2=20.765 //y2=0.49
r66 (  13 29 ) resistor r=27.3797 //w=0.187 //l=0.4 //layer=li //thickness=0.1 \
 //x=20.68 //y=0.53 //x2=20.28 //y2=0.53
r67 (  10 29 ) resistor r=3.57586 //w=0.17 //l=0.125 //layer=li \
 //thickness=0.1 //x=19.795 //y=1.495 //x2=19.795 //y2=1.62
r68 (  10 29 ) resistor r=42.0963 //w=0.187 //l=0.615 //layer=li \
 //thickness=0.1 //x=19.795 //y=1.495 //x2=19.795 //y2=0.88
r69 (  9 29 ) resistor r=3.57586 //w=0.17 //l=0.125 //layer=li //thickness=0.1 \
 //x=19.795 //y=0.615 //x2=19.795 //y2=0.49
r70 (  9 29 ) resistor r=18.139 //w=0.187 //l=0.265 //layer=li //thickness=0.1 \
 //x=19.795 //y=0.615 //x2=19.795 //y2=0.88
r71 (  6 29 ) resistor r=3.57586 //w=0.17 //l=0.103078 //layer=li \
 //thickness=0.1 //x=18.91 //y=1.58 //x2=18.825 //y2=1.62
r72 (  6 29 ) resistor r=27.3797 //w=0.187 //l=0.4 //layer=li //thickness=0.1 \
 //x=18.91 //y=1.58 //x2=19.31 //y2=1.58
r73 (  5 29 ) resistor r=3.57586 //w=0.17 //l=0.103078 //layer=li \
 //thickness=0.1 //x=19.71 //y=1.58 //x2=19.795 //y2=1.62
r74 (  5 29 ) resistor r=27.3797 //w=0.187 //l=0.4 //layer=li //thickness=0.1 \
 //x=19.71 //y=1.58 //x2=19.31 //y2=1.58
r75 (  1 29 ) resistor r=3.57586 //w=0.17 //l=0.125 //layer=li //thickness=0.1 \
 //x=18.825 //y=1.495 //x2=18.825 //y2=1.62
r76 (  1 29 ) resistor r=42.0963 //w=0.187 //l=0.615 //layer=li \
 //thickness=0.1 //x=18.825 //y=1.495 //x2=18.825 //y2=0.88
ends PM_DFFX1_PCELL\%noxref_19
