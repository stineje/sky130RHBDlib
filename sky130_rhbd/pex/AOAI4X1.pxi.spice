// File: AOAI4X1.spi.AOAI4X1.pxi
// Created: Thu Jan 22 07:02:35 2026
//
simulator lang=spectre
x_PM_AOAI4X1\%noxref_1 ( N_noxref_1_c_42_p N_noxref_1_c_10_p N_noxref_1_c_30_p \
 N_noxref_1_c_17_p N_noxref_1_c_255_p N_noxref_1_c_25_p N_noxref_1_c_109_p \
 N_noxref_1_c_27_p N_noxref_1_c_26_p N_noxref_1_c_18_p N_noxref_1_c_28_p \
 N_noxref_1_c_44_p N_noxref_1_c_45_p N_noxref_1_c_46_p N_noxref_1_c_1_p \
 N_noxref_1_c_89_p N_noxref_1_c_31_p N_noxref_1_c_2_p N_noxref_1_c_70_p \
 N_noxref_1_c_114_p N_noxref_1_c_20_p N_noxref_1_c_71_p N_noxref_1_c_47_p \
 N_noxref_1_c_48_p N_noxref_1_c_29_p N_noxref_1_c_3_p N_noxref_1_M2_noxref_g \
 N_noxref_1_M10_noxref_g N_noxref_1_M11_noxref_g N_noxref_1_c_4_p \
 N_noxref_1_c_5_p N_noxref_1_c_12_p N_noxref_1_c_13_p N_noxref_1_c_6_p \
 N_noxref_1_c_7_p N_noxref_1_c_94_p N_noxref_1_c_8_p N_noxref_1_c_9_p \
 N_noxref_1_c_75_p N_noxref_1_M1_noxref_d N_noxref_1_M6_noxref_d \
 N_noxref_1_M8_noxref_d )  PM_AOAI4X1\%noxref_1
x_PM_AOAI4X1\%noxref_2 ( N_noxref_2_c_265_n N_noxref_2_c_274_n \
 N_noxref_2_c_280_n N_noxref_2_c_281_n N_noxref_2_c_365_p N_noxref_2_c_287_n \
 N_noxref_2_c_306_p N_noxref_2_c_379_p N_noxref_2_c_289_n N_noxref_2_c_346_p \
 N_noxref_2_c_291_n N_noxref_2_c_348_p N_noxref_2_c_326_p N_noxref_2_c_294_n \
 N_noxref_2_c_295_n N_noxref_2_c_425_p N_noxref_2_c_402_p N_noxref_2_c_307_p \
 N_noxref_2_c_318_p N_noxref_2_c_296_n N_noxref_2_c_403_p N_noxref_2_c_319_p \
 N_noxref_2_c_310_p N_noxref_2_c_404_p N_noxref_2_c_308_p \
 N_noxref_2_M4_noxref_g N_noxref_2_M14_noxref_g N_noxref_2_M15_noxref_g \
 N_noxref_2_c_405_p N_noxref_2_c_406_p N_noxref_2_c_407_p N_noxref_2_c_439_p \
 N_noxref_2_c_408_p N_noxref_2_c_409_p N_noxref_2_c_410_p N_noxref_2_c_411_p \
 N_noxref_2_c_322_p N_noxref_2_M2_noxref_d N_noxref_2_M3_noxref_d \
 N_noxref_2_M12_noxref_d )  PM_AOAI4X1\%noxref_2
x_PM_AOAI4X1\%VDD ( VDD N_VDD_c_534_n N_VDD_c_541_n N_VDD_c_543_n \
 N_VDD_c_587_n N_VDD_c_545_n N_VDD_c_548_n N_VDD_c_553_n N_VDD_c_592_n \
 N_VDD_c_686_p N_VDD_c_555_n N_VDD_c_558_n N_VDD_c_568_n N_VDD_c_569_n \
 N_VDD_M6_noxref_s N_VDD_M7_noxref_d N_VDD_M9_noxref_d N_VDD_M10_noxref_d \
 N_VDD_M14_noxref_s N_VDD_M15_noxref_d N_VDD_M17_noxref_d )  PM_AOAI4X1\%VDD
x_PM_AOAI4X1\%A ( A A A A A A A N_A_c_758_p N_A_c_729_n N_A_c_752_p \
 N_A_c_731_n N_A_M0_noxref_g N_A_M6_noxref_g N_A_M7_noxref_g N_A_c_772_p \
 N_A_c_773_p N_A_c_775_p N_A_c_760_p N_A_c_794_p N_A_c_795_p N_A_c_774_p \
 N_A_c_776_p N_A_c_738_n )  PM_AOAI4X1\%A
x_PM_AOAI4X1\%B ( B B B B B B B N_B_c_832_n N_B_c_834_n N_B_c_836_n \
 N_B_c_837_n N_B_M1_noxref_g N_B_M8_noxref_g N_B_M9_noxref_g N_B_c_845_n \
 N_B_c_847_n N_B_c_850_n N_B_c_851_n N_B_c_854_n N_B_c_856_n N_B_c_860_n \
 N_B_c_862_n N_B_c_866_n N_B_c_867_n N_B_c_869_n )  PM_AOAI4X1\%B
x_PM_AOAI4X1\%noxref_6 ( N_noxref_6_c_932_n N_noxref_6_c_955_n \
 N_noxref_6_c_938_n N_noxref_6_c_945_n N_noxref_6_c_946_n N_noxref_6_c_962_n \
 N_noxref_6_c_947_n N_noxref_6_c_951_n N_noxref_6_M10_noxref_s \
 N_noxref_6_M11_noxref_d N_noxref_6_M13_noxref_d )  PM_AOAI4X1\%noxref_6
x_PM_AOAI4X1\%C ( C C C C C C C N_C_c_1034_n N_C_c_1037_n N_C_c_1040_n \
 N_C_c_1044_n N_C_M3_noxref_g N_C_M12_noxref_g N_C_M13_noxref_g N_C_c_1051_n \
 N_C_c_1053_n N_C_c_1056_n N_C_c_1097_n N_C_c_1100_n N_C_c_1058_n N_C_c_1059_n \
 N_C_c_1060_n N_C_c_1061_n N_C_c_1064_n N_C_c_1065_n )  PM_AOAI4X1\%C
x_PM_AOAI4X1\%GND ( GND N_GND_c_1251_n N_GND_c_1145_n N_GND_c_1294_p \
 N_GND_c_1151_n N_GND_c_1261_n N_GND_c_1191_n N_GND_c_1202_n N_GND_c_1154_n \
 N_GND_c_1156_n N_GND_c_1326_p N_GND_c_1158_n N_GND_c_1208_n N_GND_c_1355_p \
 N_GND_c_1212_n N_GND_c_1164_n N_GND_c_1165_n N_GND_c_1218_n N_GND_M0_noxref_d \
 N_GND_M2_noxref_s N_GND_M4_noxref_d )  PM_AOAI4X1\%GND
x_PM_AOAI4X1\%D ( D D D D D D D N_D_c_1370_n N_D_c_1373_n N_D_c_1376_n \
 N_D_c_1380_n N_D_M5_noxref_g N_D_M16_noxref_g N_D_M17_noxref_g N_D_c_1386_n \
 N_D_c_1389_n N_D_c_1391_n N_D_c_1407_n N_D_c_1441_p N_D_c_1430_p N_D_c_1394_n \
 N_D_c_1395_n N_D_c_1396_n N_D_c_1432_p N_D_c_1399_n )  PM_AOAI4X1\%D
x_PM_AOAI4X1\%YN ( YN YN YN YN YN YN YN YN N_YN_c_1468_n N_YN_c_1469_n \
 N_YN_c_1492_n N_YN_c_1521_n N_YN_c_1471_n N_YN_c_1472_n N_YN_c_1500_n \
 N_YN_c_1504_n N_YN_c_1480_n N_YN_c_1481_n N_YN_c_1515_n N_YN_M5_noxref_d \
 N_YN_M14_noxref_d N_YN_M16_noxref_d )  PM_AOAI4X1\%YN
x_PM_AOAI4X1\%noxref_11 ( N_noxref_11_c_1587_n N_noxref_11_c_1588_n \
 N_noxref_11_c_1614_n N_noxref_11_c_1577_n N_noxref_11_c_1578_n \
 N_noxref_11_c_1624_n N_noxref_11_M0_noxref_s )  PM_AOAI4X1\%noxref_11
x_PM_AOAI4X1\%noxref_12 ( N_noxref_12_c_1638_n N_noxref_12_c_1640_n \
 N_noxref_12_c_1657_n N_noxref_12_c_1648_n N_noxref_12_c_1662_n \
 N_noxref_12_c_1664_n N_noxref_12_M4_noxref_s )  PM_AOAI4X1\%noxref_12
cc_1 ( N_noxref_1_c_1_p N_noxref_2_c_265_n ) capacitor c=0.00604284f //x=2.64 \
 //y=1.18 //x2=5 //y2=1.305
cc_2 ( N_noxref_1_c_2_p N_noxref_2_c_265_n ) capacitor c=0.00116613f //x=4.93 \
 //y=2.26 //x2=5 //y2=1.305
cc_3 ( N_noxref_1_c_3_p N_noxref_2_c_265_n ) capacitor c=7.02188e-19 //x=4.93 \
 //y=2.26 //x2=5 //y2=1.305
cc_4 ( N_noxref_1_c_4_p N_noxref_2_c_265_n ) capacitor c=6.06305e-19 //x=4.735 \
 //y=1.085 //x2=5 //y2=1.305
cc_5 ( N_noxref_1_c_5_p N_noxref_2_c_265_n ) capacitor c=0.00328491f //x=4.735 \
 //y=1.43 //x2=5 //y2=1.305
cc_6 ( N_noxref_1_c_6_p N_noxref_2_c_265_n ) capacitor c=5.29726e-19 //x=5.11 \
 //y=0.93 //x2=5 //y2=1.305
cc_7 ( N_noxref_1_c_7_p N_noxref_2_c_265_n ) capacitor c=6.14781e-19 //x=5.11 \
 //y=1.585 //x2=5 //y2=1.305
cc_8 ( N_noxref_1_c_8_p N_noxref_2_c_265_n ) capacitor c=5.57259e-19 //x=5.265 \
 //y=1.085 //x2=5 //y2=1.305
cc_9 ( N_noxref_1_c_9_p N_noxref_2_c_265_n ) capacitor c=0.00212774f //x=5.265 \
 //y=1.43 //x2=5 //y2=1.305
cc_10 ( N_noxref_1_c_10_p N_noxref_2_c_274_n ) capacitor c=0.00445584f \
 //x=2.64 //y=1.75 //x2=5 //y2=1.75
cc_11 ( N_noxref_1_c_5_p N_noxref_2_c_274_n ) capacitor c=0.00109347f \
 //x=4.735 //y=1.43 //x2=5 //y2=1.75
cc_12 ( N_noxref_1_c_12_p N_noxref_2_c_274_n ) capacitor c=0.00314841f \
 //x=4.735 //y=1.74 //x2=5 //y2=1.75
cc_13 ( N_noxref_1_c_13_p N_noxref_2_c_274_n ) capacitor c=0.00309965f \
 //x=4.735 //y=2.095 //x2=5 //y2=1.75
cc_14 ( N_noxref_1_c_7_p N_noxref_2_c_274_n ) capacitor c=0.00674367f //x=5.11 \
 //y=1.585 //x2=5 //y2=1.75
cc_15 ( N_noxref_1_c_9_p N_noxref_2_c_274_n ) capacitor c=0.00253555f \
 //x=5.265 //y=1.43 //x2=5 //y2=1.75
cc_16 ( N_noxref_1_c_9_p N_noxref_2_c_280_n ) capacitor c=7.25274e-19 \
 //x=5.265 //y=1.43 //x2=5.885 //y2=1.835
cc_17 ( N_noxref_1_c_17_p N_noxref_2_c_281_n ) capacitor c=0.00351497f \
 //x=2.995 //y=1.835 //x2=5.085 //y2=1.835
cc_18 ( N_noxref_1_c_18_p N_noxref_2_c_281_n ) capacitor c=0.00127002f \
 //x=4.93 //y=2.925 //x2=5.085 //y2=1.835
cc_19 ( N_noxref_1_c_2_p N_noxref_2_c_281_n ) capacitor c=0.0161272f //x=4.93 \
 //y=2.26 //x2=5.085 //y2=1.835
cc_20 ( N_noxref_1_c_20_p N_noxref_2_c_281_n ) capacitor c=6.59793e-19 \
 //x=4.925 //y=2.765 //x2=5.085 //y2=1.835
cc_21 ( N_noxref_1_c_3_p N_noxref_2_c_281_n ) capacitor c=0.00293572f //x=4.93 \
 //y=2.26 //x2=5.085 //y2=1.835
cc_22 ( N_noxref_1_c_13_p N_noxref_2_c_281_n ) capacitor c=0.00107086f \
 //x=4.735 //y=2.095 //x2=5.085 //y2=1.835
cc_23 ( N_noxref_1_c_10_p N_noxref_2_c_287_n ) capacitor c=6.26628e-19 \
 //x=2.64 //y=1.75 //x2=5.97 //y2=1.75
cc_24 ( N_noxref_1_c_9_p N_noxref_2_c_287_n ) capacitor c=6.29838e-19 \
 //x=5.265 //y=1.43 //x2=5.97 //y2=1.75
cc_25 ( N_noxref_1_c_25_p N_noxref_2_c_289_n ) capacitor c=0.00204276f \
 //x=3.08 //y=2.605 //x2=6.41 //y2=2.605
cc_26 ( N_noxref_1_c_26_p N_noxref_2_c_289_n ) capacitor c=9.83329e-19 \
 //x=4.93 //y=2.605 //x2=6.41 //y2=2.605
cc_27 ( N_noxref_1_c_27_p N_noxref_2_c_291_n ) capacitor c=0.00294086f \
 //x=3.08 //y=5.295 //x2=6.41 //y2=5.305
cc_28 ( N_noxref_1_c_28_p N_noxref_2_c_291_n ) capacitor c=0.00558958f \
 //x=4.93 //y=4.765 //x2=6.41 //y2=5.305
cc_29 ( N_noxref_1_c_29_p N_noxref_2_c_291_n ) capacitor c=2.44646e-19 \
 //x=4.775 //y=4.885 //x2=6.41 //y2=5.305
cc_30 ( N_noxref_1_c_30_p N_noxref_2_c_294_n ) capacitor c=7.34073e-19 \
 //x=2.995 //y=5.38 //x2=5.925 //y2=5.39
cc_31 ( N_noxref_1_c_31_p N_noxref_2_c_295_n ) capacitor c=0.00251935f \
 //x=4.93 //y=2.77 //x2=6.41 //y2=2.77
cc_32 ( N_noxref_1_c_20_p N_noxref_2_c_296_n ) capacitor c=0.00542346f \
 //x=4.925 //y=2.765 //x2=6.565 //y2=2.765
cc_33 ( N_noxref_1_c_18_p N_noxref_2_M2_noxref_d ) capacitor c=3.25483e-19 \
 //x=4.93 //y=2.925 //x2=4.81 //y2=1.085
cc_34 ( N_noxref_1_c_2_p N_noxref_2_M2_noxref_d ) capacitor c=7.18966e-19 \
 //x=4.93 //y=2.26 //x2=4.81 //y2=1.085
cc_35 ( N_noxref_1_c_3_p N_noxref_2_M2_noxref_d ) capacitor c=0.00150225f \
 //x=4.93 //y=2.26 //x2=4.81 //y2=1.085
cc_36 ( N_noxref_1_c_4_p N_noxref_2_M2_noxref_d ) capacitor c=0.00124139f \
 //x=4.735 //y=1.085 //x2=4.81 //y2=1.085
cc_37 ( N_noxref_1_c_5_p N_noxref_2_M2_noxref_d ) capacitor c=0.00237422f \
 //x=4.735 //y=1.43 //x2=4.81 //y2=1.085
cc_38 ( N_noxref_1_c_6_p N_noxref_2_M2_noxref_d ) capacitor c=0.00213893f \
 //x=5.11 //y=0.93 //x2=4.81 //y2=1.085
cc_39 ( N_noxref_1_c_7_p N_noxref_2_M2_noxref_d ) capacitor c=0.00345753f \
 //x=5.11 //y=1.585 //x2=4.81 //y2=1.085
cc_40 ( N_noxref_1_c_8_p N_noxref_2_M2_noxref_d ) capacitor c=0.00211919f \
 //x=5.265 //y=1.085 //x2=4.81 //y2=1.085
cc_41 ( N_noxref_1_c_9_p N_noxref_2_M2_noxref_d ) capacitor c=0.00237422f \
 //x=5.265 //y=1.43 //x2=4.81 //y2=1.085
cc_42 ( N_noxref_1_c_42_p N_VDD_c_534_n ) capacitor c=0.00648307f //x=2.485 \
 //y=5.38 //x2=4.965 //y2=7.585
cc_43 ( N_noxref_1_c_30_p N_VDD_c_534_n ) capacitor c=0.00488503f //x=2.995 \
 //y=5.38 //x2=4.965 //y2=7.585
cc_44 ( N_noxref_1_c_44_p N_VDD_c_534_n ) capacitor c=0.00368834f //x=1.72 \
 //y=5.56 //x2=4.965 //y2=7.585
cc_45 ( N_noxref_1_c_45_p N_VDD_c_534_n ) capacitor c=8.42709e-19 //x=2.6 \
 //y=5.38 //x2=4.965 //y2=7.585
cc_46 ( N_noxref_1_c_46_p N_VDD_c_534_n ) capacitor c=0.00285853f //x=2.6 \
 //y=5.56 //x2=4.965 //y2=7.585
cc_47 ( N_noxref_1_c_47_p N_VDD_c_534_n ) capacitor c=0.00224881f //x=1.72 \
 //y=5.56 //x2=4.965 //y2=7.585
cc_48 ( N_noxref_1_c_48_p N_VDD_c_534_n ) capacitor c=0.00224881f //x=2.6 \
 //y=5.56 //x2=4.965 //y2=7.585
cc_49 ( N_noxref_1_M10_noxref_g N_VDD_c_541_n ) capacitor c=0.00122608f \
 //x=4.83 //y=6.205 //x2=5.05 //y2=7.035
cc_50 ( N_noxref_1_M11_noxref_g N_VDD_c_541_n ) capacitor c=0.00122608f \
 //x=5.27 //y=6.205 //x2=5.05 //y2=7.035
cc_51 ( N_noxref_1_M10_noxref_g N_VDD_c_543_n ) capacitor c=0.00205385f \
 //x=4.83 //y=6.205 //x2=5.05 //y2=7.41
cc_52 ( N_noxref_1_M11_noxref_g N_VDD_c_543_n ) capacitor c=0.00294739f \
 //x=5.27 //y=6.205 //x2=5.05 //y2=7.41
cc_53 ( N_noxref_1_c_42_p N_VDD_c_545_n ) capacitor c=0.00213203f //x=2.485 \
 //y=5.38 //x2=2.075 //y2=7.585
cc_54 ( N_noxref_1_c_44_p N_VDD_c_545_n ) capacitor c=9.99055e-19 //x=1.72 \
 //y=5.56 //x2=2.075 //y2=7.585
cc_55 ( N_noxref_1_c_47_p N_VDD_c_545_n ) capacitor c=0.0136705f //x=1.72 \
 //y=5.56 //x2=2.075 //y2=7.585
cc_56 ( N_noxref_1_c_42_p N_VDD_c_548_n ) capacitor c=0.00184541f //x=2.485 \
 //y=5.38 //x2=2.955 //y2=7.585
cc_57 ( N_noxref_1_c_30_p N_VDD_c_548_n ) capacitor c=0.00213203f //x=2.995 \
 //y=5.38 //x2=2.955 //y2=7.585
cc_58 ( N_noxref_1_c_45_p N_VDD_c_548_n ) capacitor c=5.39459e-19 //x=2.6 \
 //y=5.38 //x2=2.955 //y2=7.585
cc_59 ( N_noxref_1_c_46_p N_VDD_c_548_n ) capacitor c=5.77976e-19 //x=2.6 \
 //y=5.56 //x2=2.955 //y2=7.585
cc_60 ( N_noxref_1_c_48_p N_VDD_c_548_n ) capacitor c=0.0136705f //x=2.6 \
 //y=5.56 //x2=2.955 //y2=7.585
cc_61 ( N_noxref_1_M10_noxref_g N_VDD_c_553_n ) capacitor c=0.00720181f \
 //x=4.83 //y=6.205 //x2=6.98 //y2=7.585
cc_62 ( N_noxref_1_M11_noxref_g N_VDD_c_553_n ) capacitor c=0.00760847f \
 //x=5.27 //y=6.205 //x2=6.98 //y2=7.585
cc_63 ( N_noxref_1_c_27_p N_VDD_c_555_n ) capacitor c=0.00197052f //x=3.08 \
 //y=5.295 //x2=1.23 //y2=7.58
cc_64 ( N_noxref_1_c_44_p N_VDD_c_555_n ) capacitor c=6.39392e-19 //x=1.72 \
 //y=5.56 //x2=1.23 //y2=7.58
cc_65 ( N_noxref_1_c_47_p N_VDD_c_555_n ) capacitor c=0.0064135f //x=1.72 \
 //y=5.56 //x2=1.23 //y2=7.58
cc_66 ( N_noxref_1_c_27_p N_VDD_c_558_n ) capacitor c=0.0305833f //x=3.08 \
 //y=5.295 //x2=3.82 //y2=7.585
cc_67 ( N_noxref_1_c_28_p N_VDD_c_558_n ) capacitor c=0.00722719f //x=4.93 \
 //y=4.765 //x2=3.82 //y2=7.585
cc_68 ( N_noxref_1_c_45_p N_VDD_c_558_n ) capacitor c=0.00240948f //x=2.6 \
 //y=5.38 //x2=3.82 //y2=7.585
cc_69 ( N_noxref_1_c_46_p N_VDD_c_558_n ) capacitor c=4.09141e-19 //x=2.6 \
 //y=5.56 //x2=3.82 //y2=7.585
cc_70 ( N_noxref_1_c_70_p N_VDD_c_558_n ) capacitor c=0.00344941f //x=4.775 \
 //y=4.885 //x2=3.82 //y2=7.585
cc_71 ( N_noxref_1_c_71_p N_VDD_c_558_n ) capacitor c=0.00259242f //x=4.765 \
 //y=2.765 //x2=3.82 //y2=7.585
cc_72 ( N_noxref_1_c_48_p N_VDD_c_558_n ) capacitor c=0.0101448f //x=2.6 \
 //y=5.56 //x2=3.82 //y2=7.585
cc_73 ( N_noxref_1_c_29_p N_VDD_c_558_n ) capacitor c=0.00643194f //x=4.775 \
 //y=4.885 //x2=3.82 //y2=7.585
cc_74 ( N_noxref_1_M10_noxref_g N_VDD_c_558_n ) capacitor c=0.00898416f \
 //x=4.83 //y=6.205 //x2=3.82 //y2=7.585
cc_75 ( N_noxref_1_c_75_p N_VDD_c_558_n ) capacitor c=0.00438848f //x=4.775 \
 //y=4.885 //x2=3.82 //y2=7.585
cc_76 ( N_noxref_1_c_29_p N_VDD_c_568_n ) capacitor c=3.49022e-19 //x=4.775 \
 //y=4.885 //x2=7.15 //y2=7.585
cc_77 ( N_noxref_1_c_47_p N_VDD_c_569_n ) capacitor c=0.00135089f //x=1.72 \
 //y=5.56 //x2=9.74 //y2=7.58
cc_78 ( N_noxref_1_c_48_p N_VDD_c_569_n ) capacitor c=0.00135089f //x=2.6 \
 //y=5.56 //x2=9.74 //y2=7.58
cc_79 ( N_noxref_1_c_44_p N_VDD_M6_noxref_s ) capacitor c=0.062494f //x=1.72 \
 //y=5.56 //x2=1.145 //y2=5.2
cc_80 ( N_noxref_1_c_45_p N_VDD_M6_noxref_s ) capacitor c=6.52457e-19 //x=2.6 \
 //y=5.38 //x2=1.145 //y2=5.2
cc_81 ( N_noxref_1_c_47_p N_VDD_M6_noxref_s ) capacitor c=0.0906034f //x=1.72 \
 //y=5.56 //x2=1.145 //y2=5.2
cc_82 ( N_noxref_1_c_42_p N_VDD_M7_noxref_d ) capacitor c=0.00810252f \
 //x=2.485 //y=5.38 //x2=2.015 //y2=5.2
cc_83 ( N_noxref_1_c_44_p N_VDD_M7_noxref_d ) capacitor c=0.0043528f //x=1.72 \
 //y=5.56 //x2=2.015 //y2=5.2
cc_84 ( N_noxref_1_c_46_p N_VDD_M7_noxref_d ) capacitor c=0.0043528f //x=2.6 \
 //y=5.56 //x2=2.015 //y2=5.2
cc_85 ( N_noxref_1_c_47_p N_VDD_M7_noxref_d ) capacitor c=0.0654258f //x=1.72 \
 //y=5.56 //x2=2.015 //y2=5.2
cc_86 ( N_noxref_1_c_48_p N_VDD_M7_noxref_d ) capacitor c=0.0653553f //x=2.6 \
 //y=5.56 //x2=2.015 //y2=5.2
cc_87 ( N_noxref_1_c_30_p N_VDD_M9_noxref_d ) capacitor c=0.0100502f //x=2.995 \
 //y=5.38 //x2=2.895 //y2=5.2
cc_88 ( N_noxref_1_c_46_p N_VDD_M9_noxref_d ) capacitor c=0.00979407f //x=2.6 \
 //y=5.56 //x2=2.895 //y2=5.2
cc_89 ( N_noxref_1_c_89_p N_VDD_M9_noxref_d ) capacitor c=6.87256e-19 //x=3.08 \
 //y=2.77 //x2=2.895 //y2=5.2
cc_90 ( N_noxref_1_c_48_p N_VDD_M9_noxref_d ) capacitor c=0.0651828f //x=2.6 \
 //y=5.56 //x2=2.895 //y2=5.2
cc_91 ( N_noxref_1_c_31_p N_VDD_M10_noxref_d ) capacitor c=3.55297e-19 \
 //x=4.93 //y=2.77 //x2=4.905 //y2=5.205
cc_92 ( N_noxref_1_M10_noxref_g N_VDD_M10_noxref_d ) capacitor c=0.0130453f \
 //x=4.83 //y=6.205 //x2=4.905 //y2=5.205
cc_93 ( N_noxref_1_M11_noxref_g N_VDD_M10_noxref_d ) capacitor c=0.0142727f \
 //x=5.27 //y=6.205 //x2=4.905 //y2=5.205
cc_94 ( N_noxref_1_c_94_p N_VDD_M10_noxref_d ) capacitor c=0.00241874f \
 //x=5.195 //y=4.975 //x2=4.905 //y2=5.205
cc_95 ( N_noxref_1_c_25_p A ) capacitor c=0.00100975f //x=3.08 //y=2.605 \
 //x2=1.6 //y2=2.4
cc_96 ( N_noxref_1_c_27_p A ) capacitor c=0.00453113f //x=3.08 //y=5.295 \
 //x2=1.6 //y2=2.4
cc_97 ( N_noxref_1_c_44_p N_A_c_729_n ) capacitor c=0.0118546f //x=1.72 \
 //y=5.56 //x2=1.6 //y2=4.88
cc_98 ( N_noxref_1_c_47_p N_A_c_729_n ) capacitor c=0.00165549f //x=1.72 \
 //y=5.56 //x2=1.6 //y2=4.88
cc_99 ( N_noxref_1_c_44_p N_A_c_731_n ) capacitor c=0.00277154f //x=1.72 \
 //y=5.56 //x2=1.6 //y2=4.88
cc_100 ( N_noxref_1_c_47_p N_A_c_731_n ) capacitor c=0.00377369f //x=1.72 \
 //y=5.56 //x2=1.6 //y2=4.88
cc_101 ( N_noxref_1_c_44_p N_A_M6_noxref_g ) capacitor c=0.0020878f //x=1.72 \
 //y=5.56 //x2=1.5 //y2=6.2
cc_102 ( N_noxref_1_c_47_p N_A_M6_noxref_g ) capacitor c=0.0158358f //x=1.72 \
 //y=5.56 //x2=1.5 //y2=6.2
cc_103 ( N_noxref_1_c_42_p N_A_M7_noxref_g ) capacitor c=0.0129249f //x=2.485 \
 //y=5.38 //x2=1.94 //y2=6.2
cc_104 ( N_noxref_1_c_44_p N_A_M7_noxref_g ) capacitor c=0.00192712f //x=1.72 \
 //y=5.56 //x2=1.94 //y2=6.2
cc_105 ( N_noxref_1_c_47_p N_A_M7_noxref_g ) capacitor c=0.0178987f //x=1.72 \
 //y=5.56 //x2=1.94 //y2=6.2
cc_106 ( N_noxref_1_c_44_p N_A_c_738_n ) capacitor c=0.00207241f //x=1.72 \
 //y=5.56 //x2=1.6 //y2=4.88
cc_107 ( N_noxref_1_c_47_p N_A_c_738_n ) capacitor c=0.0043218f //x=1.72 \
 //y=5.56 //x2=1.6 //y2=4.88
cc_108 ( N_noxref_1_c_25_p B ) capacitor c=0.009049f //x=3.08 //y=2.605 \
 //x2=2.34 //y2=2.4
cc_109 ( N_noxref_1_c_109_p B ) capacitor c=0.0148501f //x=3.08 //y=2.925 \
 //x2=2.34 //y2=2.4
cc_110 ( N_noxref_1_c_27_p B ) capacitor c=0.0837239f //x=3.08 //y=5.295 \
 //x2=2.34 //y2=2.4
cc_111 ( N_noxref_1_c_26_p B ) capacitor c=6.23212e-19 //x=4.93 //y=2.605 \
 //x2=2.34 //y2=2.4
cc_112 ( N_noxref_1_c_28_p B ) capacitor c=0.00288721f //x=4.93 //y=4.765 \
 //x2=2.34 //y2=2.4
cc_113 ( N_noxref_1_c_89_p B ) capacitor c=6.15181e-19 //x=3.08 //y=2.77 \
 //x2=2.34 //y2=2.4
cc_114 ( N_noxref_1_c_114_p B ) capacitor c=0.00687503f //x=3.24 //y=2.765 \
 //x2=2.34 //y2=2.4
cc_115 ( N_noxref_1_c_42_p N_B_c_832_n ) capacitor c=0.0228479f //x=2.485 \
 //y=5.38 //x2=2.34 //y2=4.735
cc_116 ( N_noxref_1_c_27_p N_B_c_832_n ) capacitor c=0.016905f //x=3.08 \
 //y=5.295 //x2=2.34 //y2=4.735
cc_117 ( N_noxref_1_c_42_p N_B_c_834_n ) capacitor c=2.77624e-19 //x=2.485 \
 //y=5.38 //x2=2.34 //y2=2.26
cc_118 ( N_noxref_1_c_25_p N_B_c_834_n ) capacitor c=0.015397f //x=3.08 \
 //y=2.605 //x2=2.34 //y2=2.26
cc_119 ( N_noxref_1_c_25_p N_B_c_836_n ) capacitor c=9.90728e-19 //x=3.08 \
 //y=2.605 //x2=2.34 //y2=2.26
cc_120 ( N_noxref_1_c_42_p N_B_c_837_n ) capacitor c=0.00469257f //x=2.485 \
 //y=5.38 //x2=2.37 //y2=4.88
cc_121 ( N_noxref_1_c_27_p N_B_c_837_n ) capacitor c=0.00342433f //x=3.08 \
 //y=5.295 //x2=2.37 //y2=4.88
cc_122 ( N_noxref_1_c_42_p N_B_M8_noxref_g ) capacitor c=0.00842859f //x=2.485 \
 //y=5.38 //x2=2.38 //y2=6.2
cc_123 ( N_noxref_1_c_45_p N_B_M8_noxref_g ) capacitor c=0.00192712f //x=2.6 \
 //y=5.38 //x2=2.38 //y2=6.2
cc_124 ( N_noxref_1_c_48_p N_B_M8_noxref_g ) capacitor c=0.0178987f //x=2.6 \
 //y=5.56 //x2=2.38 //y2=6.2
cc_125 ( N_noxref_1_c_30_p N_B_M9_noxref_g ) capacitor c=0.0115937f //x=2.995 \
 //y=5.38 //x2=2.82 //y2=6.2
cc_126 ( N_noxref_1_c_45_p N_B_M9_noxref_g ) capacitor c=0.00298276f //x=2.6 \
 //y=5.38 //x2=2.82 //y2=6.2
cc_127 ( N_noxref_1_c_48_p N_B_M9_noxref_g ) capacitor c=0.0178506f //x=2.6 \
 //y=5.56 //x2=2.82 //y2=6.2
cc_128 ( N_noxref_1_c_1_p N_B_c_845_n ) capacitor c=0.00120406f //x=2.64 \
 //y=1.18 //x2=2.375 //y2=1.085
cc_129 ( N_noxref_1_M1_noxref_d N_B_c_845_n ) capacitor c=0.00137165f //x=2.45 \
 //y=1.085 //x2=2.375 //y2=1.085
cc_130 ( N_noxref_1_c_10_p N_B_c_847_n ) capacitor c=0.00127432f //x=2.64 \
 //y=1.75 //x2=2.375 //y2=1.43
cc_131 ( N_noxref_1_c_1_p N_B_c_847_n ) capacitor c=0.00220847f //x=2.64 \
 //y=1.18 //x2=2.375 //y2=1.43
cc_132 ( N_noxref_1_M1_noxref_d N_B_c_847_n ) capacitor c=0.00237422f //x=2.45 \
 //y=1.085 //x2=2.375 //y2=1.43
cc_133 ( N_noxref_1_c_10_p N_B_c_850_n ) capacitor c=0.00454577f //x=2.64 \
 //y=1.75 //x2=2.375 //y2=1.74
cc_134 ( N_noxref_1_c_27_p N_B_c_851_n ) capacitor c=0.00874009f //x=3.08 \
 //y=5.295 //x2=2.745 //y2=4.97
cc_135 ( N_noxref_1_c_45_p N_B_c_851_n ) capacitor c=0.0020909f //x=2.6 \
 //y=5.38 //x2=2.745 //y2=4.97
cc_136 ( N_noxref_1_c_48_p N_B_c_851_n ) capacitor c=0.00291714f //x=2.6 \
 //y=5.56 //x2=2.745 //y2=4.97
cc_137 ( N_noxref_1_c_1_p N_B_c_854_n ) capacitor c=5.50523e-19 //x=2.64 \
 //y=1.18 //x2=2.75 //y2=0.93
cc_138 ( N_noxref_1_M1_noxref_d N_B_c_854_n ) capacitor c=0.0020782f //x=2.45 \
 //y=1.085 //x2=2.75 //y2=0.93
cc_139 ( N_noxref_1_c_10_p N_B_c_856_n ) capacitor c=0.00912818f //x=2.64 \
 //y=1.75 //x2=2.75 //y2=1.585
cc_140 ( N_noxref_1_c_17_p N_B_c_856_n ) capacitor c=0.00194324f //x=2.995 \
 //y=1.835 //x2=2.75 //y2=1.585
cc_141 ( N_noxref_1_c_1_p N_B_c_856_n ) capacitor c=5.67071e-19 //x=2.64 \
 //y=1.18 //x2=2.75 //y2=1.585
cc_142 ( N_noxref_1_M1_noxref_d N_B_c_856_n ) capacitor c=0.00356097f //x=2.45 \
 //y=1.085 //x2=2.75 //y2=1.585
cc_143 ( N_noxref_1_c_1_p N_B_c_860_n ) capacitor c=0.0010954f //x=2.64 \
 //y=1.18 //x2=2.905 //y2=1.085
cc_144 ( N_noxref_1_M1_noxref_d N_B_c_860_n ) capacitor c=8.50095e-19 //x=2.45 \
 //y=1.085 //x2=2.905 //y2=1.085
cc_145 ( N_noxref_1_c_10_p N_B_c_862_n ) capacitor c=0.00305472f //x=2.64 \
 //y=1.75 //x2=2.905 //y2=1.43
cc_146 ( N_noxref_1_c_17_p N_B_c_862_n ) capacitor c=0.00323005f //x=2.995 \
 //y=1.835 //x2=2.905 //y2=1.43
cc_147 ( N_noxref_1_c_1_p N_B_c_862_n ) capacitor c=0.00314842f //x=2.64 \
 //y=1.18 //x2=2.905 //y2=1.43
cc_148 ( N_noxref_1_M1_noxref_d N_B_c_862_n ) capacitor c=0.00237422f //x=2.45 \
 //y=1.085 //x2=2.905 //y2=1.43
cc_149 ( N_noxref_1_c_25_p N_B_c_866_n ) capacitor c=0.00285392f //x=3.08 \
 //y=2.605 //x2=2.34 //y2=2.26
cc_150 ( N_noxref_1_c_10_p N_B_c_867_n ) capacitor c=0.00371023f //x=2.64 \
 //y=1.75 //x2=2.34 //y2=2.095
cc_151 ( N_noxref_1_c_25_p N_B_c_867_n ) capacitor c=0.00341496f //x=3.08 \
 //y=2.605 //x2=2.34 //y2=2.095
cc_152 ( N_noxref_1_c_42_p N_B_c_869_n ) capacitor c=9.8107e-19 //x=2.485 \
 //y=5.38 //x2=2.37 //y2=4.88
cc_153 ( N_noxref_1_c_27_p N_B_c_869_n ) capacitor c=0.00142201f //x=3.08 \
 //y=5.295 //x2=2.37 //y2=4.88
cc_154 ( N_noxref_1_c_18_p N_noxref_6_c_932_n ) capacitor c=4.98604e-19 \
 //x=4.93 //y=2.925 //x2=5.37 //y2=5.39
cc_155 ( N_noxref_1_c_70_p N_noxref_6_c_932_n ) capacitor c=0.0078395f \
 //x=4.775 //y=4.885 //x2=5.37 //y2=5.39
cc_156 ( N_noxref_1_c_29_p N_noxref_6_c_932_n ) capacitor c=0.00104675f \
 //x=4.775 //y=4.885 //x2=5.37 //y2=5.39
cc_157 ( N_noxref_1_M10_noxref_g N_noxref_6_c_932_n ) capacitor c=0.00996264f \
 //x=4.83 //y=6.205 //x2=5.37 //y2=5.39
cc_158 ( N_noxref_1_M11_noxref_g N_noxref_6_c_932_n ) capacitor c=0.00967241f \
 //x=5.27 //y=6.205 //x2=5.37 //y2=5.39
cc_159 ( N_noxref_1_c_94_p N_noxref_6_c_932_n ) capacitor c=0.00189947f \
 //x=5.195 //y=4.975 //x2=5.37 //y2=5.39
cc_160 ( N_noxref_1_c_30_p N_noxref_6_c_938_n ) capacitor c=0.00408808f \
 //x=2.995 //y=5.38 //x2=4.61 //y2=5.39
cc_161 ( N_noxref_1_c_45_p N_noxref_6_c_938_n ) capacitor c=0.00518363f \
 //x=2.6 //y=5.38 //x2=4.61 //y2=5.39
cc_162 ( N_noxref_1_c_46_p N_noxref_6_c_938_n ) capacitor c=3.28075e-19 \
 //x=2.6 //y=5.56 //x2=4.61 //y2=5.39
cc_163 ( N_noxref_1_c_70_p N_noxref_6_c_938_n ) capacitor c=0.0243045f \
 //x=4.775 //y=4.885 //x2=4.61 //y2=5.39
cc_164 ( N_noxref_1_c_29_p N_noxref_6_c_938_n ) capacitor c=0.00565356f \
 //x=4.775 //y=4.885 //x2=4.61 //y2=5.39
cc_165 ( N_noxref_1_M10_noxref_g N_noxref_6_c_938_n ) capacitor c=0.00403872f \
 //x=4.83 //y=6.205 //x2=4.61 //y2=5.39
cc_166 ( N_noxref_1_c_75_p N_noxref_6_c_938_n ) capacitor c=9.12041e-19 \
 //x=4.775 //y=4.885 //x2=4.61 //y2=5.39
cc_167 ( N_noxref_1_M11_noxref_g N_noxref_6_c_945_n ) capacitor c=0.0018094f \
 //x=5.27 //y=6.205 //x2=5.49 //y2=5.39
cc_168 ( N_noxref_1_M11_noxref_g N_noxref_6_c_946_n ) capacitor c=0.00180782f \
 //x=5.27 //y=6.205 //x2=5.49 //y2=6.92
cc_169 ( N_noxref_1_c_70_p N_noxref_6_c_947_n ) capacitor c=0.00154424f \
 //x=4.775 //y=4.885 //x2=4.61 //y2=5.56
cc_170 ( N_noxref_1_c_29_p N_noxref_6_c_947_n ) capacitor c=0.00126834f \
 //x=4.775 //y=4.885 //x2=4.61 //y2=5.56
cc_171 ( N_noxref_1_M10_noxref_g N_noxref_6_c_947_n ) capacitor c=0.0483843f \
 //x=4.83 //y=6.205 //x2=4.61 //y2=5.56
cc_172 ( N_noxref_1_c_75_p N_noxref_6_c_947_n ) capacitor c=0.00297041f \
 //x=4.775 //y=4.885 //x2=4.61 //y2=5.56
cc_173 ( N_noxref_1_M11_noxref_g N_noxref_6_c_951_n ) capacitor c=0.0170175f \
 //x=5.27 //y=6.205 //x2=5.49 //y2=5.56
cc_174 ( N_noxref_1_M10_noxref_g N_noxref_6_M10_noxref_s ) capacitor \
 c=0.00378422f //x=4.83 //y=6.205 //x2=4.475 //y2=5.205
cc_175 ( N_noxref_1_c_25_p C ) capacitor c=6.5122e-19 //x=3.08 //y=2.605 \
 //x2=5.67 //y2=2.4
cc_176 ( N_noxref_1_c_27_p C ) capacitor c=0.00351523f //x=3.08 //y=5.295 \
 //x2=5.67 //y2=2.4
cc_177 ( N_noxref_1_c_26_p C ) capacitor c=0.00863767f //x=4.93 //y=2.605 \
 //x2=5.67 //y2=2.4
cc_178 ( N_noxref_1_c_18_p C ) capacitor c=0.0146933f //x=4.93 //y=2.925 \
 //x2=5.67 //y2=2.4
cc_179 ( N_noxref_1_c_28_p C ) capacitor c=0.0473875f //x=4.93 //y=4.765 \
 //x2=5.67 //y2=2.4
cc_180 ( N_noxref_1_c_31_p C ) capacitor c=5.57251e-19 //x=4.93 //y=2.77 \
 //x2=5.67 //y2=2.4
cc_181 ( N_noxref_1_c_20_p C ) capacitor c=0.00359337f //x=4.925 //y=2.765 \
 //x2=5.67 //y2=2.4
cc_182 ( N_noxref_1_c_3_p C ) capacitor c=2.61947e-19 //x=4.93 //y=2.26 \
 //x2=5.67 //y2=2.4
cc_183 ( N_noxref_1_c_2_p N_C_c_1034_n ) capacitor c=0.0217252f //x=4.93 \
 //y=2.26 //x2=5.67 //y2=2.26
cc_184 ( N_noxref_1_c_3_p N_C_c_1034_n ) capacitor c=5.41079e-19 //x=4.93 \
 //y=2.26 //x2=5.67 //y2=2.26
cc_185 ( N_noxref_1_c_13_p N_C_c_1034_n ) capacitor c=0.00178181f //x=4.735 \
 //y=2.095 //x2=5.67 //y2=2.26
cc_186 ( N_noxref_1_c_70_p N_C_c_1037_n ) capacitor c=0.0486063f //x=4.775 \
 //y=4.885 //x2=5.705 //y2=4.885
cc_187 ( N_noxref_1_c_29_p N_C_c_1037_n ) capacitor c=0.00105182f //x=4.775 \
 //y=4.885 //x2=5.705 //y2=4.885
cc_188 ( N_noxref_1_c_94_p N_C_c_1037_n ) capacitor c=0.00107587f //x=5.195 \
 //y=4.975 //x2=5.705 //y2=4.885
cc_189 ( N_noxref_1_c_26_p N_C_c_1040_n ) capacitor c=2.61947e-19 //x=4.93 \
 //y=2.605 //x2=5.67 //y2=2.26
cc_190 ( N_noxref_1_c_2_p N_C_c_1040_n ) capacitor c=5.24865e-19 //x=4.93 \
 //y=2.26 //x2=5.67 //y2=2.26
cc_191 ( N_noxref_1_c_3_p N_C_c_1040_n ) capacitor c=0.00525888f //x=4.93 \
 //y=2.26 //x2=5.67 //y2=2.26
cc_192 ( N_noxref_1_c_13_p N_C_c_1040_n ) capacitor c=0.00190888f //x=4.735 \
 //y=2.095 //x2=5.67 //y2=2.26
cc_193 ( N_noxref_1_c_70_p N_C_c_1044_n ) capacitor c=4.32488e-19 //x=4.775 \
 //y=4.885 //x2=5.705 //y2=4.885
cc_194 ( N_noxref_1_c_29_p N_C_c_1044_n ) capacitor c=0.00242589f //x=4.775 \
 //y=4.885 //x2=5.705 //y2=4.885
cc_195 ( N_noxref_1_c_94_p N_C_c_1044_n ) capacitor c=0.00116837f //x=5.195 \
 //y=4.975 //x2=5.705 //y2=4.885
cc_196 ( N_noxref_1_c_75_p N_C_c_1044_n ) capacitor c=0.00121814f //x=4.775 \
 //y=4.885 //x2=5.705 //y2=4.885
cc_197 ( N_noxref_1_M10_noxref_g N_C_M12_noxref_g ) capacitor c=0.0101077f \
 //x=4.83 //y=6.205 //x2=5.71 //y2=6.205
cc_198 ( N_noxref_1_M11_noxref_g N_C_M12_noxref_g ) capacitor c=0.109254f \
 //x=5.27 //y=6.205 //x2=5.71 //y2=6.205
cc_199 ( N_noxref_1_M11_noxref_g N_C_M13_noxref_g ) capacitor c=0.00945018f \
 //x=5.27 //y=6.205 //x2=6.15 //y2=6.205
cc_200 ( N_noxref_1_c_4_p N_C_c_1051_n ) capacitor c=0.00125788f //x=4.735 \
 //y=1.085 //x2=5.705 //y2=1.085
cc_201 ( N_noxref_1_c_8_p N_C_c_1051_n ) capacitor c=0.0126654f //x=5.265 \
 //y=1.085 //x2=5.705 //y2=1.085
cc_202 ( N_noxref_1_c_5_p N_C_c_1053_n ) capacitor c=0.00149727f //x=4.735 \
 //y=1.43 //x2=5.705 //y2=1.435
cc_203 ( N_noxref_1_c_12_p N_C_c_1053_n ) capacitor c=0.00111802f //x=4.735 \
 //y=1.74 //x2=5.705 //y2=1.435
cc_204 ( N_noxref_1_c_9_p N_C_c_1053_n ) capacitor c=0.0126654f //x=5.265 \
 //y=1.43 //x2=5.705 //y2=1.435
cc_205 ( N_noxref_1_c_12_p N_C_c_1056_n ) capacitor c=0.00116305f //x=4.735 \
 //y=1.74 //x2=5.705 //y2=1.74
cc_206 ( N_noxref_1_c_9_p N_C_c_1056_n ) capacitor c=0.00938322f //x=5.265 \
 //y=1.43 //x2=5.705 //y2=1.74
cc_207 ( N_noxref_1_c_9_p N_C_c_1058_n ) capacitor c=0.00131492f //x=5.265 \
 //y=1.43 //x2=6.08 //y2=1.585
cc_208 ( N_noxref_1_c_8_p N_C_c_1059_n ) capacitor c=0.00132934f //x=5.265 \
 //y=1.085 //x2=6.235 //y2=1.085
cc_209 ( N_noxref_1_c_9_p N_C_c_1060_n ) capacitor c=0.00151998f //x=5.265 \
 //y=1.43 //x2=6.235 //y2=1.435
cc_210 ( N_noxref_1_c_2_p N_C_c_1061_n ) capacitor c=0.00173144f //x=4.93 \
 //y=2.26 //x2=5.67 //y2=2.26
cc_211 ( N_noxref_1_c_3_p N_C_c_1061_n ) capacitor c=0.0018937f //x=4.93 \
 //y=2.26 //x2=5.67 //y2=2.26
cc_212 ( N_noxref_1_c_13_p N_C_c_1061_n ) capacitor c=0.0181449f //x=4.735 \
 //y=2.095 //x2=5.67 //y2=2.26
cc_213 ( N_noxref_1_c_13_p N_C_c_1064_n ) capacitor c=0.00636965f //x=4.735 \
 //y=2.095 //x2=5.67 //y2=2.095
cc_214 ( N_noxref_1_c_28_p N_C_c_1065_n ) capacitor c=0.00117265f //x=4.93 \
 //y=4.765 //x2=5.705 //y2=4.885
cc_215 ( N_noxref_1_c_70_p N_C_c_1065_n ) capacitor c=4.8456e-19 //x=4.775 \
 //y=4.885 //x2=5.705 //y2=4.885
cc_216 ( N_noxref_1_c_29_p N_C_c_1065_n ) capacitor c=0.00211373f //x=4.775 \
 //y=4.885 //x2=5.705 //y2=4.885
cc_217 ( N_noxref_1_c_94_p N_C_c_1065_n ) capacitor c=0.0203928f //x=5.195 \
 //y=4.975 //x2=5.705 //y2=4.885
cc_218 ( N_noxref_1_c_75_p N_C_c_1065_n ) capacitor c=0.00590438f //x=4.775 \
 //y=4.885 //x2=5.705 //y2=4.885
cc_219 ( N_noxref_1_c_17_p N_GND_c_1145_n ) capacitor c=0.00654514f //x=2.995 \
 //y=1.835 //x2=8.245 //y2=0.175
cc_220 ( N_noxref_1_c_109_p N_GND_c_1145_n ) capacitor c=5.98934e-19 //x=3.08 \
 //y=2.925 //x2=8.245 //y2=0.175
cc_221 ( N_noxref_1_c_18_p N_GND_c_1145_n ) capacitor c=3.68809e-19 //x=4.93 \
 //y=2.925 //x2=8.245 //y2=0.175
cc_222 ( N_noxref_1_c_1_p N_GND_c_1145_n ) capacitor c=0.00964814f //x=2.64 \
 //y=1.18 //x2=8.245 //y2=0.175
cc_223 ( N_noxref_1_c_2_p N_GND_c_1145_n ) capacitor c=8.84449e-19 //x=4.93 \
 //y=2.26 //x2=8.245 //y2=0.175
cc_224 ( N_noxref_1_M1_noxref_d N_GND_c_1145_n ) capacitor c=3.01769e-19 \
 //x=2.45 //y=1.085 //x2=8.245 //y2=0.175
cc_225 ( N_noxref_1_c_44_p N_GND_c_1151_n ) capacitor c=9.64357e-19 //x=1.72 \
 //y=5.56 //x2=1.67 //y2=1.135
cc_226 ( N_noxref_1_c_1_p N_GND_c_1151_n ) capacitor c=0.0141894f //x=2.64 \
 //y=1.18 //x2=1.67 //y2=1.135
cc_227 ( N_noxref_1_M1_noxref_d N_GND_c_1151_n ) capacitor c=2.93544e-19 \
 //x=2.45 //y=1.085 //x2=1.67 //y2=1.135
cc_228 ( N_noxref_1_c_17_p N_GND_c_1154_n ) capacitor c=7.75992e-19 //x=2.995 \
 //y=1.835 //x2=3.65 //y2=0.175
cc_229 ( N_noxref_1_c_109_p N_GND_c_1154_n ) capacitor c=4.78725e-19 //x=3.08 \
 //y=2.925 //x2=3.65 //y2=0.175
cc_230 ( N_noxref_1_c_25_p N_GND_c_1156_n ) capacitor c=0.00139243f //x=3.08 \
 //y=2.605 //x2=1.23 //y2=0.18
cc_231 ( N_noxref_1_c_89_p N_GND_c_1156_n ) capacitor c=0.00133432f //x=3.08 \
 //y=2.77 //x2=1.23 //y2=0.18
cc_232 ( N_noxref_1_c_18_p N_GND_c_1158_n ) capacitor c=9.54331e-19 //x=4.93 \
 //y=2.925 //x2=5.4 //y2=0.71
cc_233 ( N_noxref_1_c_2_p N_GND_c_1158_n ) capacitor c=0.0010437f //x=4.93 \
 //y=2.26 //x2=5.4 //y2=0.71
cc_234 ( N_noxref_1_c_3_p N_GND_c_1158_n ) capacitor c=6.77674e-19 //x=4.93 \
 //y=2.26 //x2=5.4 //y2=0.71
cc_235 ( N_noxref_1_c_4_p N_GND_c_1158_n ) capacitor c=0.0211758f //x=4.735 \
 //y=1.085 //x2=5.4 //y2=0.71
cc_236 ( N_noxref_1_c_13_p N_GND_c_1158_n ) capacitor c=2.1838e-19 //x=4.735 \
 //y=2.095 //x2=5.4 //y2=0.71
cc_237 ( N_noxref_1_c_8_p N_GND_c_1158_n ) capacitor c=0.00805599f //x=5.265 \
 //y=1.085 //x2=5.4 //y2=0.71
cc_238 ( N_noxref_1_c_1_p N_GND_c_1164_n ) capacitor c=2.83275e-19 //x=2.64 \
 //y=1.18 //x2=9.74 //y2=0.18
cc_239 ( N_noxref_1_c_10_p N_GND_c_1165_n ) capacitor c=0.00271975f //x=2.64 \
 //y=1.75 //x2=3.82 //y2=0.175
cc_240 ( N_noxref_1_c_17_p N_GND_c_1165_n ) capacitor c=0.021518f //x=2.995 \
 //y=1.835 //x2=3.82 //y2=0.175
cc_241 ( N_noxref_1_c_109_p N_GND_c_1165_n ) capacitor c=0.00429364f //x=3.08 \
 //y=2.925 //x2=3.82 //y2=0.175
cc_242 ( N_noxref_1_c_26_p N_GND_c_1165_n ) capacitor c=0.00325281f //x=4.93 \
 //y=2.605 //x2=3.82 //y2=0.175
cc_243 ( N_noxref_1_c_18_p N_GND_c_1165_n ) capacitor c=0.00311747f //x=4.93 \
 //y=2.925 //x2=3.82 //y2=0.175
cc_244 ( N_noxref_1_c_89_p N_GND_c_1165_n ) capacitor c=0.0101726f //x=3.08 \
 //y=2.77 //x2=3.82 //y2=0.175
cc_245 ( N_noxref_1_c_31_p N_GND_c_1165_n ) capacitor c=0.00513832f //x=4.93 \
 //y=2.77 //x2=3.82 //y2=0.175
cc_246 ( N_noxref_1_c_2_p N_GND_c_1165_n ) capacitor c=0.00446799f //x=4.93 \
 //y=2.26 //x2=3.82 //y2=0.175
cc_247 ( N_noxref_1_c_71_p N_GND_c_1165_n ) capacitor c=0.0239533f //x=4.765 \
 //y=2.765 //x2=3.82 //y2=0.175
cc_248 ( N_noxref_1_c_3_p N_GND_c_1165_n ) capacitor c=0.00369203f //x=4.93 \
 //y=2.26 //x2=3.82 //y2=0.175
cc_249 ( N_noxref_1_c_13_p N_GND_c_1165_n ) capacitor c=0.0101725f //x=4.735 \
 //y=2.095 //x2=3.82 //y2=0.175
cc_250 ( N_noxref_1_c_1_p N_GND_M0_noxref_d ) capacitor c=2.82748e-19 //x=2.64 \
 //y=1.18 //x2=1.48 //y2=1.045
cc_251 ( N_noxref_1_c_71_p N_GND_M2_noxref_s ) capacitor c=0.00355168f \
 //x=4.765 //y=2.765 //x2=4.38 //y2=0.545
cc_252 ( N_noxref_1_c_4_p N_GND_M2_noxref_s ) capacitor c=0.0329097f //x=4.735 \
 //y=1.085 //x2=4.38 //y2=0.545
cc_253 ( N_noxref_1_c_8_p N_GND_M2_noxref_s ) capacitor c=0.00605785f \
 //x=5.265 //y=1.085 //x2=4.38 //y2=0.545
cc_254 ( N_noxref_1_c_9_p N_GND_M2_noxref_s ) capacitor c=0.00120103f \
 //x=5.265 //y=1.43 //x2=4.38 //y2=0.545
cc_255 ( N_noxref_1_c_255_p N_noxref_11_c_1577_n ) capacitor c=0.0103386f \
 //x=2.725 //y=1.835 //x2=2.155 //y2=1.675
cc_256 ( N_noxref_1_c_17_p N_noxref_11_c_1578_n ) capacitor c=0.00373013f \
 //x=2.995 //y=1.835 //x2=3.04 //y2=0.71
cc_257 ( N_noxref_1_c_1_p N_noxref_11_c_1578_n ) capacitor c=0.00367971f \
 //x=2.64 //y=1.18 //x2=3.04 //y2=0.71
cc_258 ( N_noxref_1_M1_noxref_d N_noxref_11_c_1578_n ) capacitor c=0.00910163f \
 //x=2.45 //y=1.085 //x2=3.04 //y2=0.71
cc_259 ( N_noxref_1_c_10_p N_noxref_11_M0_noxref_s ) capacitor c=0.0173667f \
 //x=2.64 //y=1.75 //x2=1.05 //y2=0.545
cc_260 ( N_noxref_1_c_17_p N_noxref_11_M0_noxref_s ) capacitor c=0.0055349f \
 //x=2.995 //y=1.835 //x2=1.05 //y2=0.545
cc_261 ( N_noxref_1_c_109_p N_noxref_11_M0_noxref_s ) capacitor c=7.90116e-19 \
 //x=3.08 //y=2.925 //x2=1.05 //y2=0.545
cc_262 ( N_noxref_1_c_1_p N_noxref_11_M0_noxref_s ) capacitor c=0.00907053f \
 //x=2.64 //y=1.18 //x2=1.05 //y2=0.545
cc_263 ( N_noxref_1_c_89_p N_noxref_11_M0_noxref_s ) capacitor c=0.00202552f \
 //x=3.08 //y=2.77 //x2=1.05 //y2=0.545
cc_264 ( N_noxref_1_M1_noxref_d N_noxref_11_M0_noxref_s ) capacitor \
 c=0.0275552f //x=2.45 //y=1.085 //x2=1.05 //y2=0.545
cc_265 ( N_noxref_2_c_306_p N_VDD_c_587_n ) capacitor c=2.90144e-19 //x=6.325 \
 //y=5.39 //x2=9.74 //y2=7.58
cc_266 ( N_noxref_2_c_307_p N_VDD_c_587_n ) capacitor c=9.07241e-19 //x=8.26 \
 //y=4.88 //x2=9.74 //y2=7.58
cc_267 ( N_noxref_2_c_308_p N_VDD_c_587_n ) capacitor c=6.22888e-19 //x=8.26 \
 //y=4.88 //x2=9.74 //y2=7.58
cc_268 ( N_noxref_2_c_306_p N_VDD_c_553_n ) capacitor c=0.00153182f //x=6.325 \
 //y=5.39 //x2=6.98 //y2=7.585
cc_269 ( N_noxref_2_c_310_p N_VDD_c_553_n ) capacitor c=0.00513429f //x=5.93 \
 //y=5.56 //x2=6.98 //y2=7.585
cc_270 ( N_noxref_2_c_307_p N_VDD_c_592_n ) capacitor c=6.28113e-19 //x=8.26 \
 //y=4.88 //x2=8.735 //y2=7.585
cc_271 ( N_noxref_2_M14_noxref_g N_VDD_c_592_n ) capacitor c=0.00732618f \
 //x=8.16 //y=6.2 //x2=8.735 //y2=7.585
cc_272 ( N_noxref_2_M15_noxref_g N_VDD_c_592_n ) capacitor c=0.00755544f \
 //x=8.6 //y=6.2 //x2=8.735 //y2=7.585
cc_273 ( N_noxref_2_c_291_n N_VDD_c_558_n ) capacitor c=0.00125992f //x=6.41 \
 //y=5.305 //x2=3.82 //y2=7.585
cc_274 ( N_noxref_2_c_291_n N_VDD_c_568_n ) capacitor c=0.0310672f //x=6.41 \
 //y=5.305 //x2=7.15 //y2=7.585
cc_275 ( N_noxref_2_c_294_n N_VDD_c_568_n ) capacitor c=0.00270468f //x=5.925 \
 //y=5.39 //x2=7.15 //y2=7.585
cc_276 ( N_noxref_2_c_307_p N_VDD_c_568_n ) capacitor c=0.00447349f //x=8.26 \
 //y=4.88 //x2=7.15 //y2=7.585
cc_277 ( N_noxref_2_c_318_p N_VDD_c_568_n ) capacitor c=0.00733791f //x=8.262 \
 //y=4.74 //x2=7.15 //y2=7.585
cc_278 ( N_noxref_2_c_319_p N_VDD_c_568_n ) capacitor c=0.00260419f //x=8.09 \
 //y=2.765 //x2=7.15 //y2=7.585
cc_279 ( N_noxref_2_c_310_p N_VDD_c_568_n ) capacitor c=0.0092106f //x=5.93 \
 //y=5.56 //x2=7.15 //y2=7.585
cc_280 ( N_noxref_2_c_308_p N_VDD_c_568_n ) capacitor c=0.00387138f //x=8.26 \
 //y=4.88 //x2=7.15 //y2=7.585
cc_281 ( N_noxref_2_c_322_p N_VDD_c_568_n ) capacitor c=0.0131082f //x=8.26 \
 //y=4.88 //x2=7.15 //y2=7.585
cc_282 ( N_noxref_2_c_310_p N_VDD_c_569_n ) capacitor c=2.32853e-19 //x=5.93 \
 //y=5.56 //x2=9.74 //y2=7.58
cc_283 ( N_noxref_2_c_310_p N_VDD_M10_noxref_d ) capacitor c=0.00559643f \
 //x=5.93 //y=5.56 //x2=4.905 //y2=5.205
cc_284 ( N_noxref_2_c_306_p N_VDD_M14_noxref_s ) capacitor c=0.00364f \
 //x=6.325 //y=5.39 //x2=7.805 //y2=5.2
cc_285 ( N_noxref_2_c_326_p N_VDD_M14_noxref_s ) capacitor c=7.58516e-19 \
 //x=8.26 //y=2.925 //x2=7.805 //y2=5.2
cc_286 ( N_noxref_2_c_294_n N_VDD_M14_noxref_s ) capacitor c=0.00513745f \
 //x=5.925 //y=5.39 //x2=7.805 //y2=5.2
cc_287 ( N_noxref_2_M14_noxref_g N_VDD_M14_noxref_s ) capacitor c=0.0567929f \
 //x=8.16 //y=6.2 //x2=7.805 //y2=5.2
cc_288 ( N_noxref_2_M15_noxref_g N_VDD_M15_noxref_d ) capacitor c=0.015318f \
 //x=8.6 //y=6.2 //x2=8.675 //y2=5.2
cc_289 ( N_noxref_2_c_265_n N_noxref_6_c_932_n ) capacitor c=2.9249e-19 //x=5 \
 //y=1.305 //x2=5.37 //y2=5.39
cc_290 ( N_noxref_2_c_281_n N_noxref_6_c_932_n ) capacitor c=0.00244347f \
 //x=5.085 //y=1.835 //x2=5.37 //y2=5.39
cc_291 ( N_noxref_2_c_306_p N_noxref_6_c_955_n ) capacitor c=0.00301289f \
 //x=6.325 //y=5.39 //x2=6.24 //y2=7.09
cc_292 ( N_noxref_2_c_294_n N_noxref_6_c_955_n ) capacitor c=0.00513934f \
 //x=5.925 //y=5.39 //x2=6.24 //y2=7.09
cc_293 ( N_noxref_2_c_310_p N_noxref_6_c_955_n ) capacitor c=0.00406191f \
 //x=5.93 //y=5.56 //x2=6.24 //y2=7.09
cc_294 ( N_noxref_2_c_294_n N_noxref_6_c_938_n ) capacitor c=5.08928e-19 \
 //x=5.925 //y=5.39 //x2=4.61 //y2=5.39
cc_295 ( N_noxref_2_c_280_n N_noxref_6_c_945_n ) capacitor c=0.00270061f \
 //x=5.885 //y=1.835 //x2=5.49 //y2=5.39
cc_296 ( N_noxref_2_c_294_n N_noxref_6_c_945_n ) capacitor c=0.0514662f \
 //x=5.925 //y=5.39 //x2=5.49 //y2=5.39
cc_297 ( N_noxref_2_c_310_p N_noxref_6_c_945_n ) capacitor c=0.00398527f \
 //x=5.93 //y=5.56 //x2=5.49 //y2=5.39
cc_298 ( N_noxref_2_c_306_p N_noxref_6_c_962_n ) capacitor c=0.0056963f \
 //x=6.325 //y=5.39 //x2=6.37 //y2=6.92
cc_299 ( N_noxref_2_c_294_n N_noxref_6_c_951_n ) capacitor c=0.00275395f \
 //x=5.925 //y=5.39 //x2=5.49 //y2=5.56
cc_300 ( N_noxref_2_c_310_p N_noxref_6_c_951_n ) capacitor c=0.0683237f \
 //x=5.93 //y=5.56 //x2=5.49 //y2=5.56
cc_301 ( N_noxref_2_c_306_p N_noxref_6_M13_noxref_d ) capacitor c=0.00855426f \
 //x=6.325 //y=5.39 //x2=6.225 //y2=5.205
cc_302 ( N_noxref_2_c_295_n N_noxref_6_M13_noxref_d ) capacitor c=6.7951e-19 \
 //x=6.41 //y=2.77 //x2=6.225 //y2=5.205
cc_303 ( N_noxref_2_c_310_p N_noxref_6_M13_noxref_d ) capacitor c=0.047732f \
 //x=5.93 //y=5.56 //x2=6.225 //y2=5.205
cc_304 ( N_noxref_2_c_289_n C ) capacitor c=0.00866339f //x=6.41 //y=2.605 \
 //x2=5.67 //y2=2.4
cc_305 ( N_noxref_2_c_346_p C ) capacitor c=0.0150092f //x=6.41 //y=2.925 \
 //x2=5.67 //y2=2.4
cc_306 ( N_noxref_2_c_291_n C ) capacitor c=0.0839355f //x=6.41 //y=5.305 \
 //x2=5.67 //y2=2.4
cc_307 ( N_noxref_2_c_348_p C ) capacitor c=6.23212e-19 //x=8.26 //y=2.605 \
 //x2=5.67 //y2=2.4
cc_308 ( N_noxref_2_c_295_n C ) capacitor c=5.57251e-19 //x=6.41 //y=2.77 \
 //x2=5.67 //y2=2.4
cc_309 ( N_noxref_2_c_318_p C ) capacitor c=0.00289475f //x=8.262 //y=4.74 \
 //x2=5.67 //y2=2.4
cc_310 ( N_noxref_2_c_296_n C ) capacitor c=0.00361658f //x=6.565 //y=2.765 \
 //x2=5.67 //y2=2.4
cc_311 ( N_noxref_2_c_280_n N_C_c_1034_n ) capacitor c=0.0306211f //x=5.885 \
 //y=1.835 //x2=5.67 //y2=2.26
cc_312 ( N_noxref_2_c_289_n N_C_c_1034_n ) capacitor c=0.0160491f //x=6.41 \
 //y=2.605 //x2=5.67 //y2=2.26
cc_313 ( N_noxref_2_c_280_n N_C_c_1037_n ) capacitor c=4.30382e-19 //x=5.885 \
 //y=1.835 //x2=5.705 //y2=4.885
cc_314 ( N_noxref_2_c_291_n N_C_c_1037_n ) capacitor c=0.0175188f //x=6.41 \
 //y=5.305 //x2=5.705 //y2=4.885
cc_315 ( N_noxref_2_c_294_n N_C_c_1037_n ) capacitor c=0.00207961f //x=5.925 \
 //y=5.39 //x2=5.705 //y2=4.885
cc_316 ( N_noxref_2_c_280_n N_C_c_1040_n ) capacitor c=0.00491852f //x=5.885 \
 //y=1.835 //x2=5.67 //y2=2.26
cc_317 ( N_noxref_2_c_289_n N_C_c_1040_n ) capacitor c=8.61986e-19 //x=6.41 \
 //y=2.605 //x2=5.67 //y2=2.26
cc_318 ( N_noxref_2_c_291_n N_C_c_1044_n ) capacitor c=0.00342077f //x=6.41 \
 //y=5.305 //x2=5.705 //y2=4.885
cc_319 ( N_noxref_2_c_294_n N_C_M12_noxref_g ) capacitor c=0.00184899f \
 //x=5.925 //y=5.39 //x2=5.71 //y2=6.205
cc_320 ( N_noxref_2_c_310_p N_C_M12_noxref_g ) capacitor c=0.0120591f //x=5.93 \
 //y=5.56 //x2=5.71 //y2=6.205
cc_321 ( N_noxref_2_c_306_p N_C_M13_noxref_g ) capacitor c=0.0110031f \
 //x=6.325 //y=5.39 //x2=6.15 //y2=6.205
cc_322 ( N_noxref_2_c_294_n N_C_M13_noxref_g ) capacitor c=0.0027897f \
 //x=5.925 //y=5.39 //x2=6.15 //y2=6.205
cc_323 ( N_noxref_2_c_310_p N_C_M13_noxref_g ) capacitor c=0.0140704f //x=5.93 \
 //y=5.56 //x2=6.15 //y2=6.205
cc_324 ( N_noxref_2_c_365_p N_C_c_1051_n ) capacitor c=0.00112851f //x=5.97 \
 //y=1.3 //x2=5.705 //y2=1.085
cc_325 ( N_noxref_2_M3_noxref_d N_C_c_1051_n ) capacitor c=0.00218694f \
 //x=5.78 //y=1.085 //x2=5.705 //y2=1.085
cc_326 ( N_noxref_2_c_365_p N_C_c_1053_n ) capacitor c=0.0021447f //x=5.97 \
 //y=1.3 //x2=5.705 //y2=1.435
cc_327 ( N_noxref_2_c_287_n N_C_c_1053_n ) capacitor c=7.7986e-19 //x=5.97 \
 //y=1.75 //x2=5.705 //y2=1.435
cc_328 ( N_noxref_2_M3_noxref_d N_C_c_1053_n ) capacitor c=0.00237422f \
 //x=5.78 //y=1.085 //x2=5.705 //y2=1.435
cc_329 ( N_noxref_2_c_274_n N_C_c_1056_n ) capacitor c=0.00120307f //x=5 \
 //y=1.75 //x2=5.705 //y2=1.74
cc_330 ( N_noxref_2_c_287_n N_C_c_1056_n ) capacitor c=0.00364979f //x=5.97 \
 //y=1.75 //x2=5.705 //y2=1.74
cc_331 ( N_noxref_2_c_291_n N_C_c_1097_n ) capacitor c=0.00852293f //x=6.41 \
 //y=5.305 //x2=6.075 //y2=4.975
cc_332 ( N_noxref_2_c_294_n N_C_c_1097_n ) capacitor c=0.00213157f //x=5.925 \
 //y=5.39 //x2=6.075 //y2=4.975
cc_333 ( N_noxref_2_c_310_p N_C_c_1097_n ) capacitor c=0.00293135f //x=5.93 \
 //y=5.56 //x2=6.075 //y2=4.975
cc_334 ( N_noxref_2_c_365_p N_C_c_1100_n ) capacitor c=5.32053e-19 //x=5.97 \
 //y=1.3 //x2=6.08 //y2=0.93
cc_335 ( N_noxref_2_M3_noxref_d N_C_c_1100_n ) capacitor c=0.00213893f \
 //x=5.78 //y=1.085 //x2=6.08 //y2=0.93
cc_336 ( N_noxref_2_c_365_p N_C_c_1058_n ) capacitor c=5.60411e-19 //x=5.97 \
 //y=1.3 //x2=6.08 //y2=1.585
cc_337 ( N_noxref_2_c_287_n N_C_c_1058_n ) capacitor c=0.00983535f //x=5.97 \
 //y=1.75 //x2=6.08 //y2=1.585
cc_338 ( N_noxref_2_c_379_p N_C_c_1058_n ) capacitor c=0.00500113f //x=6.325 \
 //y=1.835 //x2=6.08 //y2=1.585
cc_339 ( N_noxref_2_M3_noxref_d N_C_c_1058_n ) capacitor c=0.00357974f \
 //x=5.78 //y=1.085 //x2=6.08 //y2=1.585
cc_340 ( N_noxref_2_c_365_p N_C_c_1059_n ) capacitor c=8.06279e-19 //x=5.97 \
 //y=1.3 //x2=6.235 //y2=1.085
cc_341 ( N_noxref_2_M3_noxref_d N_C_c_1059_n ) capacitor c=0.0012513f //x=5.78 \
 //y=1.085 //x2=6.235 //y2=1.085
cc_342 ( N_noxref_2_c_365_p N_C_c_1060_n ) capacitor c=0.00327546f //x=5.97 \
 //y=1.3 //x2=6.235 //y2=1.435
cc_343 ( N_noxref_2_c_287_n N_C_c_1060_n ) capacitor c=0.00126467f //x=5.97 \
 //y=1.75 //x2=6.235 //y2=1.435
cc_344 ( N_noxref_2_M3_noxref_d N_C_c_1060_n ) capacitor c=0.00237422f \
 //x=5.78 //y=1.085 //x2=6.235 //y2=1.435
cc_345 ( N_noxref_2_c_280_n N_C_c_1061_n ) capacitor c=0.00161541f //x=5.885 \
 //y=1.835 //x2=5.67 //y2=2.26
cc_346 ( N_noxref_2_c_289_n N_C_c_1061_n ) capacitor c=0.0028062f //x=6.41 \
 //y=2.605 //x2=5.67 //y2=2.26
cc_347 ( N_noxref_2_c_280_n N_C_c_1064_n ) capacitor c=0.00817459f //x=5.885 \
 //y=1.835 //x2=5.67 //y2=2.095
cc_348 ( N_noxref_2_c_289_n N_C_c_1064_n ) capacitor c=0.00311553f //x=6.41 \
 //y=2.605 //x2=5.67 //y2=2.095
cc_349 ( N_noxref_2_c_291_n N_C_c_1065_n ) capacitor c=0.00141757f //x=6.41 \
 //y=5.305 //x2=5.705 //y2=4.885
cc_350 ( N_noxref_2_c_265_n N_GND_c_1145_n ) capacitor c=0.00996669f //x=5 \
 //y=1.305 //x2=8.245 //y2=0.175
cc_351 ( N_noxref_2_c_280_n N_GND_c_1145_n ) capacitor c=0.00677962f //x=5.885 \
 //y=1.835 //x2=8.245 //y2=0.175
cc_352 ( N_noxref_2_c_365_p N_GND_c_1145_n ) capacitor c=0.0106318f //x=5.97 \
 //y=1.3 //x2=8.245 //y2=0.175
cc_353 ( N_noxref_2_c_379_p N_GND_c_1145_n ) capacitor c=0.00667105f //x=6.325 \
 //y=1.835 //x2=8.245 //y2=0.175
cc_354 ( N_noxref_2_c_346_p N_GND_c_1145_n ) capacitor c=6.42463e-19 //x=6.41 \
 //y=2.925 //x2=8.245 //y2=0.175
cc_355 ( N_noxref_2_c_326_p N_GND_c_1145_n ) capacitor c=2.2945e-19 //x=8.26 \
 //y=2.925 //x2=8.245 //y2=0.175
cc_356 ( N_noxref_2_c_295_n N_GND_c_1145_n ) capacitor c=5.1261e-19 //x=6.41 \
 //y=2.77 //x2=8.245 //y2=0.175
cc_357 ( N_noxref_2_M2_noxref_d N_GND_c_1145_n ) capacitor c=3.01769e-19 \
 //x=4.81 //y=1.085 //x2=8.245 //y2=0.175
cc_358 ( N_noxref_2_M3_noxref_d N_GND_c_1145_n ) capacitor c=3.01769e-19 \
 //x=5.78 //y=1.085 //x2=8.245 //y2=0.175
cc_359 ( N_noxref_2_c_265_n N_GND_c_1151_n ) capacitor c=4.59693e-19 //x=5 \
 //y=1.305 //x2=1.67 //y2=1.135
cc_360 ( N_noxref_2_c_365_p N_GND_c_1191_n ) capacitor c=0.00581397f //x=5.97 \
 //y=1.3 //x2=8.33 //y2=1.135
cc_361 ( N_noxref_2_c_402_p N_GND_c_1191_n ) capacitor c=0.00662465f //x=8.26 \
 //y=2.26 //x2=8.33 //y2=1.135
cc_362 ( N_noxref_2_c_403_p N_GND_c_1191_n ) capacitor c=0.00303385f //x=8.25 \
 //y=2.765 //x2=8.33 //y2=1.135
cc_363 ( N_noxref_2_c_404_p N_GND_c_1191_n ) capacitor c=2.13705e-19 //x=8.26 \
 //y=2.26 //x2=8.33 //y2=1.135
cc_364 ( N_noxref_2_c_405_p N_GND_c_1191_n ) capacitor c=0.00169607f //x=8.065 \
 //y=1.045 //x2=8.33 //y2=1.135
cc_365 ( N_noxref_2_c_406_p N_GND_c_1191_n ) capacitor c=0.00357243f //x=8.065 \
 //y=1.39 //x2=8.33 //y2=1.135
cc_366 ( N_noxref_2_c_407_p N_GND_c_1191_n ) capacitor c=4.2764e-19 //x=8.065 \
 //y=1.7 //x2=8.33 //y2=1.135
cc_367 ( N_noxref_2_c_408_p N_GND_c_1191_n ) capacitor c=7.35788e-19 //x=8.44 \
 //y=0.89 //x2=8.33 //y2=1.135
cc_368 ( N_noxref_2_c_409_p N_GND_c_1191_n ) capacitor c=6.38426e-19 //x=8.44 \
 //y=1.545 //x2=8.33 //y2=1.135
cc_369 ( N_noxref_2_c_410_p N_GND_c_1191_n ) capacitor c=0.00158609f //x=8.595 \
 //y=1.045 //x2=8.33 //y2=1.135
cc_370 ( N_noxref_2_c_411_p N_GND_c_1191_n ) capacitor c=0.00296337f //x=8.595 \
 //y=1.39 //x2=8.33 //y2=1.135
cc_371 ( N_noxref_2_c_405_p N_GND_c_1202_n ) capacitor c=3.51399e-19 //x=8.065 \
 //y=1.045 //x2=8.327 //y2=1.005
cc_372 ( N_noxref_2_c_408_p N_GND_c_1202_n ) capacitor c=0.00864609f //x=8.44 \
 //y=0.89 //x2=8.327 //y2=1.005
cc_373 ( N_noxref_2_c_410_p N_GND_c_1202_n ) capacitor c=4.45447e-19 //x=8.595 \
 //y=1.045 //x2=8.327 //y2=1.005
cc_374 ( N_noxref_2_c_265_n N_GND_c_1158_n ) capacitor c=0.00372564f //x=5 \
 //y=1.305 //x2=5.4 //y2=0.71
cc_375 ( N_noxref_2_c_280_n N_GND_c_1158_n ) capacitor c=0.00128856f //x=5.885 \
 //y=1.835 //x2=5.4 //y2=0.71
cc_376 ( N_noxref_2_M2_noxref_d N_GND_c_1158_n ) capacitor c=0.0124264f \
 //x=4.81 //y=1.085 //x2=5.4 //y2=0.71
cc_377 ( N_noxref_2_c_280_n N_GND_c_1208_n ) capacitor c=0.00105223f //x=5.885 \
 //y=1.835 //x2=6.37 //y2=0.71
cc_378 ( N_noxref_2_c_365_p N_GND_c_1208_n ) capacitor c=0.00469733f //x=5.97 \
 //y=1.3 //x2=6.37 //y2=0.71
cc_379 ( N_noxref_2_c_379_p N_GND_c_1208_n ) capacitor c=0.00353984f //x=6.325 \
 //y=1.835 //x2=6.37 //y2=0.71
cc_380 ( N_noxref_2_M3_noxref_d N_GND_c_1208_n ) capacitor c=0.0122548f \
 //x=5.78 //y=1.085 //x2=6.37 //y2=0.71
cc_381 ( N_noxref_2_c_346_p N_GND_c_1212_n ) capacitor c=2.81168e-19 //x=6.41 \
 //y=2.925 //x2=6.98 //y2=0.175
cc_382 ( N_noxref_2_c_265_n N_GND_c_1164_n ) capacitor c=3.01913e-19 //x=5 \
 //y=1.305 //x2=9.74 //y2=0.18
cc_383 ( N_noxref_2_c_365_p N_GND_c_1164_n ) capacitor c=3.01913e-19 //x=5.97 \
 //y=1.3 //x2=9.74 //y2=0.18
cc_384 ( N_noxref_2_c_425_p N_GND_c_1164_n ) capacitor c=0.00159777f //x=8.26 \
 //y=2.77 //x2=9.74 //y2=0.18
cc_385 ( N_noxref_2_c_405_p N_GND_c_1164_n ) capacitor c=0.00691994f //x=8.065 \
 //y=1.045 //x2=9.74 //y2=0.18
cc_386 ( N_noxref_2_c_289_n N_GND_c_1165_n ) capacitor c=9.32616e-19 //x=6.41 \
 //y=2.605 //x2=3.82 //y2=0.175
cc_387 ( N_noxref_2_c_287_n N_GND_c_1218_n ) capacitor c=0.00331216f //x=5.97 \
 //y=1.75 //x2=7.15 //y2=0.175
cc_388 ( N_noxref_2_c_379_p N_GND_c_1218_n ) capacitor c=0.0240035f //x=6.325 \
 //y=1.835 //x2=7.15 //y2=0.175
cc_389 ( N_noxref_2_c_346_p N_GND_c_1218_n ) capacitor c=0.00427064f //x=6.41 \
 //y=2.925 //x2=7.15 //y2=0.175
cc_390 ( N_noxref_2_c_348_p N_GND_c_1218_n ) capacitor c=0.00333222f //x=8.26 \
 //y=2.605 //x2=7.15 //y2=0.175
cc_391 ( N_noxref_2_c_326_p N_GND_c_1218_n ) capacitor c=0.00312614f //x=8.26 \
 //y=2.925 //x2=7.15 //y2=0.175
cc_392 ( N_noxref_2_c_295_n N_GND_c_1218_n ) capacitor c=0.0101754f //x=6.41 \
 //y=2.77 //x2=7.15 //y2=0.175
cc_393 ( N_noxref_2_c_425_p N_GND_c_1218_n ) capacitor c=0.00512799f //x=8.26 \
 //y=2.77 //x2=7.15 //y2=0.175
cc_394 ( N_noxref_2_c_402_p N_GND_c_1218_n ) capacitor c=0.00427323f //x=8.26 \
 //y=2.26 //x2=7.15 //y2=0.175
cc_395 ( N_noxref_2_c_319_p N_GND_c_1218_n ) capacitor c=0.0241255f //x=8.09 \
 //y=2.765 //x2=7.15 //y2=0.175
cc_396 ( N_noxref_2_c_404_p N_GND_c_1218_n ) capacitor c=0.0038607f //x=8.26 \
 //y=2.26 //x2=7.15 //y2=0.175
cc_397 ( N_noxref_2_c_407_p N_GND_c_1218_n ) capacitor c=0.0015404f //x=8.065 \
 //y=1.7 //x2=7.15 //y2=0.175
cc_398 ( N_noxref_2_c_439_p N_GND_c_1218_n ) capacitor c=0.00908419f //x=8.065 \
 //y=2.095 //x2=7.15 //y2=0.175
cc_399 ( N_noxref_2_c_265_n N_GND_M2_noxref_s ) capacitor c=0.00926082f //x=5 \
 //y=1.305 //x2=4.38 //y2=0.545
cc_400 ( N_noxref_2_c_274_n N_GND_M2_noxref_s ) capacitor c=0.0225586f //x=5 \
 //y=1.75 //x2=4.38 //y2=0.545
cc_401 ( N_noxref_2_c_280_n N_GND_M2_noxref_s ) capacitor c=0.00857623f \
 //x=5.885 //y=1.835 //x2=4.38 //y2=0.545
cc_402 ( N_noxref_2_c_365_p N_GND_M2_noxref_s ) capacitor c=0.00932895f \
 //x=5.97 //y=1.3 //x2=4.38 //y2=0.545
cc_403 ( N_noxref_2_c_287_n N_GND_M2_noxref_s ) capacitor c=0.0111835f \
 //x=5.97 //y=1.75 //x2=4.38 //y2=0.545
cc_404 ( N_noxref_2_c_379_p N_GND_M2_noxref_s ) capacitor c=0.00607462f \
 //x=6.325 //y=1.835 //x2=4.38 //y2=0.545
cc_405 ( N_noxref_2_c_346_p N_GND_M2_noxref_s ) capacitor c=8.10232e-19 \
 //x=6.41 //y=2.925 //x2=4.38 //y2=0.545
cc_406 ( N_noxref_2_c_295_n N_GND_M2_noxref_s ) capacitor c=0.00206188f \
 //x=6.41 //y=2.77 //x2=4.38 //y2=0.545
cc_407 ( N_noxref_2_M2_noxref_d N_GND_M2_noxref_s ) capacitor c=0.0297221f \
 //x=4.81 //y=1.085 //x2=4.38 //y2=0.545
cc_408 ( N_noxref_2_M3_noxref_d N_GND_M2_noxref_s ) capacitor c=0.029747f \
 //x=5.78 //y=1.085 //x2=4.38 //y2=0.545
cc_409 ( N_noxref_2_c_402_p N_GND_M4_noxref_d ) capacitor c=2.20438e-19 \
 //x=8.26 //y=2.26 //x2=8.14 //y2=1.045
cc_410 ( N_noxref_2_c_405_p N_GND_M4_noxref_d ) capacitor c=0.00192399f \
 //x=8.065 //y=1.045 //x2=8.14 //y2=1.045
cc_411 ( N_noxref_2_c_406_p N_GND_M4_noxref_d ) capacitor c=0.00210798f \
 //x=8.065 //y=1.39 //x2=8.14 //y2=1.045
cc_412 ( N_noxref_2_c_408_p N_GND_M4_noxref_d ) capacitor c=0.00472259f \
 //x=8.44 //y=0.89 //x2=8.14 //y2=1.045
cc_413 ( N_noxref_2_c_409_p N_GND_M4_noxref_d ) capacitor c=0.00166857f \
 //x=8.44 //y=1.545 //x2=8.14 //y2=1.045
cc_414 ( N_noxref_2_c_410_p N_GND_M4_noxref_d ) capacitor c=0.00230174f \
 //x=8.595 //y=1.045 //x2=8.14 //y2=1.045
cc_415 ( N_noxref_2_c_411_p N_GND_M4_noxref_d ) capacitor c=0.00210798f \
 //x=8.595 //y=1.39 //x2=8.14 //y2=1.045
cc_416 ( N_noxref_2_c_289_n D ) capacitor c=6.60708e-19 //x=6.41 //y=2.605 \
 //x2=9 //y2=2.4
cc_417 ( N_noxref_2_c_291_n D ) capacitor c=0.00317943f //x=6.41 //y=5.305 \
 //x2=9 //y2=2.4
cc_418 ( N_noxref_2_c_348_p D ) capacitor c=0.0090111f //x=8.26 //y=2.605 \
 //x2=9 //y2=2.4
cc_419 ( N_noxref_2_c_326_p D ) capacitor c=0.0145387f //x=8.26 //y=2.925 \
 //x2=9 //y2=2.4
cc_420 ( N_noxref_2_c_425_p D ) capacitor c=6.15181e-19 //x=8.26 //y=2.77 \
 //x2=9 //y2=2.4
cc_421 ( N_noxref_2_c_318_p D ) capacitor c=0.0840415f //x=8.262 //y=4.74 \
 //x2=9 //y2=2.4
cc_422 ( N_noxref_2_c_403_p D ) capacitor c=0.00680742f //x=8.25 //y=2.765 \
 //x2=9 //y2=2.4
cc_423 ( N_noxref_2_c_404_p D ) capacitor c=3.49899e-19 //x=8.26 //y=2.26 \
 //x2=9 //y2=2.4
cc_424 ( N_noxref_2_c_308_p D ) capacitor c=3.02466e-19 //x=8.26 //y=4.88 \
 //x2=9 //y2=2.4
cc_425 ( N_noxref_2_c_322_p D ) capacitor c=0.00108965f //x=8.26 //y=4.88 \
 //x2=9 //y2=2.4
cc_426 ( N_noxref_2_c_307_p N_D_c_1370_n ) capacitor c=0.0172863f //x=8.26 \
 //y=4.88 //x2=9 //y2=4.735
cc_427 ( N_noxref_2_c_308_p N_D_c_1370_n ) capacitor c=4.73677e-19 //x=8.26 \
 //y=4.88 //x2=9 //y2=4.735
cc_428 ( N_noxref_2_c_322_p N_D_c_1370_n ) capacitor c=9.22067e-19 //x=8.26 \
 //y=4.88 //x2=9 //y2=4.735
cc_429 ( N_noxref_2_c_402_p N_D_c_1373_n ) capacitor c=0.0205342f //x=8.26 \
 //y=2.26 //x2=9 //y2=2.26
cc_430 ( N_noxref_2_c_404_p N_D_c_1373_n ) capacitor c=5.16867e-19 //x=8.26 \
 //y=2.26 //x2=9 //y2=2.26
cc_431 ( N_noxref_2_c_439_p N_D_c_1373_n ) capacitor c=0.00167888f //x=8.065 \
 //y=2.095 //x2=9 //y2=2.26
cc_432 ( N_noxref_2_c_348_p N_D_c_1376_n ) capacitor c=3.49899e-19 //x=8.26 \
 //y=2.605 //x2=9 //y2=2.26
cc_433 ( N_noxref_2_c_402_p N_D_c_1376_n ) capacitor c=5.24723e-19 //x=8.26 \
 //y=2.26 //x2=9 //y2=2.26
cc_434 ( N_noxref_2_c_404_p N_D_c_1376_n ) capacitor c=0.00445529f //x=8.26 \
 //y=2.26 //x2=9 //y2=2.26
cc_435 ( N_noxref_2_c_439_p N_D_c_1376_n ) capacitor c=0.00267961f //x=8.065 \
 //y=2.095 //x2=9 //y2=2.26
cc_436 ( N_noxref_2_c_307_p N_D_c_1380_n ) capacitor c=4.80626e-19 //x=8.26 \
 //y=4.88 //x2=9.03 //y2=4.88
cc_437 ( N_noxref_2_c_308_p N_D_c_1380_n ) capacitor c=0.00397338f //x=8.26 \
 //y=4.88 //x2=9.03 //y2=4.88
cc_438 ( N_noxref_2_c_322_p N_D_c_1380_n ) capacitor c=0.00283894f //x=8.26 \
 //y=4.88 //x2=9.03 //y2=4.88
cc_439 ( N_noxref_2_M14_noxref_g N_D_M16_noxref_g ) capacitor c=0.0104892f \
 //x=8.16 //y=6.2 //x2=9.04 //y2=6.2
cc_440 ( N_noxref_2_M15_noxref_g N_D_M16_noxref_g ) capacitor c=0.107636f \
 //x=8.6 //y=6.2 //x2=9.04 //y2=6.2
cc_441 ( N_noxref_2_M15_noxref_g N_D_M17_noxref_g ) capacitor c=0.0100341f \
 //x=8.6 //y=6.2 //x2=9.48 //y2=6.2
cc_442 ( N_noxref_2_c_405_p N_D_c_1386_n ) capacitor c=4.86545e-19 //x=8.065 \
 //y=1.045 //x2=9.035 //y2=1.085
cc_443 ( N_noxref_2_c_406_p N_D_c_1386_n ) capacitor c=0.00152405f //x=8.065 \
 //y=1.39 //x2=9.035 //y2=1.085
cc_444 ( N_noxref_2_c_410_p N_D_c_1386_n ) capacitor c=0.0151475f //x=8.595 \
 //y=1.045 //x2=9.035 //y2=1.085
cc_445 ( N_noxref_2_c_407_p N_D_c_1389_n ) capacitor c=0.00109982f //x=8.065 \
 //y=1.7 //x2=9.035 //y2=1.43
cc_446 ( N_noxref_2_c_411_p N_D_c_1389_n ) capacitor c=0.0111064f //x=8.595 \
 //y=1.39 //x2=9.035 //y2=1.43
cc_447 ( N_noxref_2_c_407_p N_D_c_1391_n ) capacitor c=9.58243e-19 //x=8.065 \
 //y=1.7 //x2=9.035 //y2=1.74
cc_448 ( N_noxref_2_c_439_p N_D_c_1391_n ) capacitor c=0.00662747f //x=8.065 \
 //y=2.095 //x2=9.035 //y2=1.74
cc_449 ( N_noxref_2_c_411_p N_D_c_1391_n ) capacitor c=0.00862358f //x=8.595 \
 //y=1.39 //x2=9.035 //y2=1.74
cc_450 ( N_noxref_2_c_410_p N_D_c_1394_n ) capacitor c=0.00127211f //x=8.595 \
 //y=1.045 //x2=9.565 //y2=1.085
cc_451 ( N_noxref_2_c_411_p N_D_c_1395_n ) capacitor c=0.00204774f //x=8.595 \
 //y=1.39 //x2=9.565 //y2=1.43
cc_452 ( N_noxref_2_c_402_p N_D_c_1396_n ) capacitor c=0.00167305f //x=8.26 \
 //y=2.26 //x2=9 //y2=2.26
cc_453 ( N_noxref_2_c_404_p N_D_c_1396_n ) capacitor c=0.00266443f //x=8.26 \
 //y=2.26 //x2=9 //y2=2.26
cc_454 ( N_noxref_2_c_439_p N_D_c_1396_n ) capacitor c=0.0181449f //x=8.065 \
 //y=2.095 //x2=9 //y2=2.26
cc_455 ( N_noxref_2_c_307_p N_D_c_1399_n ) capacitor c=0.00158715f //x=8.26 \
 //y=4.88 //x2=9.03 //y2=4.88
cc_456 ( N_noxref_2_c_308_p N_D_c_1399_n ) capacitor c=0.00237977f //x=8.26 \
 //y=4.88 //x2=9.03 //y2=4.88
cc_457 ( N_noxref_2_c_322_p N_D_c_1399_n ) capacitor c=0.0297875f //x=8.26 \
 //y=4.88 //x2=9.03 //y2=4.88
cc_458 ( N_noxref_2_c_291_n YN ) capacitor c=9.37195e-19 //x=6.41 //y=5.305 \
 //x2=9.74 //y2=2.4
cc_459 ( N_noxref_2_c_348_p YN ) capacitor c=0.00100976f //x=8.26 //y=2.605 \
 //x2=9.74 //y2=2.4
cc_460 ( N_noxref_2_c_318_p YN ) capacitor c=0.00453113f //x=8.262 //y=4.74 \
 //x2=9.74 //y2=2.4
cc_461 ( N_noxref_2_M15_noxref_g N_YN_c_1468_n ) capacitor c=0.0129249f \
 //x=8.6 //y=6.2 //x2=9.145 //y2=5.38
cc_462 ( N_noxref_2_c_274_n N_YN_c_1469_n ) capacitor c=5.51079e-19 //x=5 \
 //y=1.75 //x2=9.3 //y2=1.75
cc_463 ( N_noxref_2_c_287_n N_YN_c_1469_n ) capacitor c=0.00311198f //x=5.97 \
 //y=1.75 //x2=9.3 //y2=1.75
cc_464 ( N_noxref_2_c_379_p N_YN_c_1471_n ) capacitor c=0.00242359f //x=6.325 \
 //y=1.835 //x2=9.385 //y2=1.835
cc_465 ( N_noxref_2_c_291_n N_YN_c_1472_n ) capacitor c=9.75602e-19 //x=6.41 \
 //y=5.305 //x2=8.38 //y2=5.56
cc_466 ( N_noxref_2_c_326_p N_YN_c_1472_n ) capacitor c=3.53224e-19 //x=8.26 \
 //y=2.925 //x2=8.38 //y2=5.56
cc_467 ( N_noxref_2_c_294_n N_YN_c_1472_n ) capacitor c=4.93096e-19 //x=5.925 \
 //y=5.39 //x2=8.38 //y2=5.56
cc_468 ( N_noxref_2_c_307_p N_YN_c_1472_n ) capacitor c=0.0118546f //x=8.26 \
 //y=4.88 //x2=8.38 //y2=5.56
cc_469 ( N_noxref_2_c_308_p N_YN_c_1472_n ) capacitor c=0.00277154f //x=8.26 \
 //y=4.88 //x2=8.38 //y2=5.56
cc_470 ( N_noxref_2_M14_noxref_g N_YN_c_1472_n ) capacitor c=0.00201806f \
 //x=8.16 //y=6.2 //x2=8.38 //y2=5.56
cc_471 ( N_noxref_2_M15_noxref_g N_YN_c_1472_n ) capacitor c=0.00192712f \
 //x=8.6 //y=6.2 //x2=8.38 //y2=5.56
cc_472 ( N_noxref_2_c_322_p N_YN_c_1472_n ) capacitor c=0.00201727f //x=8.26 \
 //y=4.88 //x2=8.38 //y2=5.56
cc_473 ( N_noxref_2_c_365_p N_YN_c_1480_n ) capacitor c=6.90042e-19 //x=5.97 \
 //y=1.3 //x2=9.3 //y2=1.18
cc_474 ( N_noxref_2_c_307_p N_YN_c_1481_n ) capacitor c=0.00104426f //x=8.26 \
 //y=4.88 //x2=8.38 //y2=5.56
cc_475 ( N_noxref_2_c_308_p N_YN_c_1481_n ) capacitor c=0.00377369f //x=8.26 \
 //y=4.88 //x2=8.38 //y2=5.56
cc_476 ( N_noxref_2_M14_noxref_g N_YN_c_1481_n ) capacitor c=0.0158358f \
 //x=8.16 //y=6.2 //x2=8.38 //y2=5.56
cc_477 ( N_noxref_2_M15_noxref_g N_YN_c_1481_n ) capacitor c=0.0178987f \
 //x=8.6 //y=6.2 //x2=8.38 //y2=5.56
cc_478 ( N_noxref_2_c_322_p N_YN_c_1481_n ) capacitor c=0.0043218f //x=8.26 \
 //y=4.88 //x2=8.38 //y2=5.56
cc_479 ( N_noxref_2_c_319_p N_noxref_12_c_1638_n ) capacitor c=0.00357165f \
 //x=8.09 //y=2.765 //x2=7.845 //y2=1.675
cc_480 ( N_noxref_2_c_439_p N_noxref_12_c_1638_n ) capacitor c=0.00262672f \
 //x=8.065 //y=2.095 //x2=7.845 //y2=1.675
cc_481 ( N_noxref_2_c_326_p N_noxref_12_c_1640_n ) capacitor c=0.00524385f \
 //x=8.26 //y=2.925 //x2=8.73 //y2=1.76
cc_482 ( N_noxref_2_c_402_p N_noxref_12_c_1640_n ) capacitor c=0.00509504f \
 //x=8.26 //y=2.26 //x2=8.73 //y2=1.76
cc_483 ( N_noxref_2_c_319_p N_noxref_12_c_1640_n ) capacitor c=0.00132102f \
 //x=8.09 //y=2.765 //x2=8.73 //y2=1.76
cc_484 ( N_noxref_2_c_404_p N_noxref_12_c_1640_n ) capacitor c=0.00763108f \
 //x=8.26 //y=2.26 //x2=8.73 //y2=1.76
cc_485 ( N_noxref_2_c_407_p N_noxref_12_c_1640_n ) capacitor c=0.00697076f \
 //x=8.065 //y=1.7 //x2=8.73 //y2=1.76
cc_486 ( N_noxref_2_c_439_p N_noxref_12_c_1640_n ) capacitor c=0.0165705f \
 //x=8.065 //y=2.095 //x2=8.73 //y2=1.76
cc_487 ( N_noxref_2_c_409_p N_noxref_12_c_1640_n ) capacitor c=0.00723574f \
 //x=8.44 //y=1.545 //x2=8.73 //y2=1.76
cc_488 ( N_noxref_2_c_411_p N_noxref_12_c_1640_n ) capacitor c=0.00339872f \
 //x=8.595 //y=1.39 //x2=8.73 //y2=1.76
cc_489 ( N_noxref_2_c_439_p N_noxref_12_c_1648_n ) capacitor c=6.71402e-19 \
 //x=8.065 //y=2.095 //x2=8.815 //y2=1.675
cc_490 ( N_noxref_2_c_405_p N_noxref_12_M4_noxref_s ) capacitor c=0.029498f \
 //x=8.065 //y=1.045 //x2=7.71 //y2=0.545
cc_491 ( N_noxref_2_c_407_p N_noxref_12_M4_noxref_s ) capacitor c=3.48408e-19 \
 //x=8.065 //y=1.7 //x2=7.71 //y2=0.545
cc_492 ( N_noxref_2_c_410_p N_noxref_12_M4_noxref_s ) capacitor c=0.0125442f \
 //x=8.595 //y=1.045 //x2=7.71 //y2=0.545
cc_493 ( N_VDD_c_555_n A ) capacitor c=0.0104242f //x=1.23 //y=7.58 //x2=1.6 \
 //y2=2.4
cc_494 ( N_VDD_c_534_n N_A_c_729_n ) capacitor c=9.07241e-19 //x=4.965 \
 //y=7.585 //x2=1.6 //y2=4.88
cc_495 ( N_VDD_c_545_n N_A_c_729_n ) capacitor c=6.28113e-19 //x=2.075 \
 //y=7.585 //x2=1.6 //y2=4.88
cc_496 ( N_VDD_c_555_n N_A_c_729_n ) capacitor c=0.00867681f //x=1.23 //y=7.58 \
 //x2=1.6 //y2=4.88
cc_497 ( N_VDD_c_534_n N_A_c_731_n ) capacitor c=6.22888e-19 //x=4.965 \
 //y=7.585 //x2=1.6 //y2=4.88
cc_498 ( N_VDD_c_555_n N_A_c_731_n ) capacitor c=0.00370735f //x=1.23 //y=7.58 \
 //x2=1.6 //y2=4.88
cc_499 ( N_VDD_c_545_n N_A_M6_noxref_g ) capacitor c=0.00732618f //x=2.075 \
 //y=7.585 //x2=1.5 //y2=6.2
cc_500 ( N_VDD_M6_noxref_s N_A_M6_noxref_g ) capacitor c=0.0567929f //x=1.145 \
 //y=5.2 //x2=1.5 //y2=6.2
cc_501 ( N_VDD_c_545_n N_A_M7_noxref_g ) capacitor c=0.00755544f //x=2.075 \
 //y=7.585 //x2=1.94 //y2=6.2
cc_502 ( N_VDD_M7_noxref_d N_A_M7_noxref_g ) capacitor c=0.015318f //x=2.015 \
 //y=5.2 //x2=1.94 //y2=6.2
cc_503 ( N_VDD_c_555_n N_A_c_738_n ) capacitor c=0.0234764f //x=1.23 //y=7.58 \
 //x2=1.6 //y2=4.88
cc_504 ( N_VDD_c_558_n N_B_c_837_n ) capacitor c=0.00226427f //x=3.82 \
 //y=7.585 //x2=2.37 //y2=4.88
cc_505 ( N_VDD_c_548_n N_B_M8_noxref_g ) capacitor c=0.00697352f //x=2.955 \
 //y=7.585 //x2=2.38 //y2=6.2
cc_506 ( N_VDD_M7_noxref_d N_B_M8_noxref_g ) capacitor c=0.015318f //x=2.015 \
 //y=5.2 //x2=2.38 //y2=6.2
cc_507 ( N_VDD_c_548_n N_B_M9_noxref_g ) capacitor c=0.00755544f //x=2.955 \
 //y=7.585 //x2=2.82 //y2=6.2
cc_508 ( N_VDD_M9_noxref_d N_B_M9_noxref_g ) capacitor c=0.0430452f //x=2.895 \
 //y=5.2 //x2=2.82 //y2=6.2
cc_509 ( N_VDD_c_558_n N_B_c_851_n ) capacitor c=0.0132232f //x=3.82 //y=7.585 \
 //x2=2.745 //y2=4.97
cc_510 ( N_VDD_c_558_n N_B_c_869_n ) capacitor c=2.73429e-19 //x=3.82 \
 //y=7.585 //x2=2.37 //y2=4.88
cc_511 ( N_VDD_M7_noxref_d N_B_c_869_n ) capacitor c=3.32552e-19 //x=2.015 \
 //y=5.2 //x2=2.37 //y2=4.88
cc_512 ( N_VDD_c_534_n N_noxref_6_c_932_n ) capacitor c=0.00198753f //x=4.965 \
 //y=7.585 //x2=5.37 //y2=5.39
cc_513 ( N_VDD_c_541_n N_noxref_6_c_932_n ) capacitor c=0.00495393f //x=5.05 \
 //y=7.035 //x2=5.37 //y2=5.39
cc_514 ( N_VDD_c_587_n N_noxref_6_c_932_n ) capacitor c=0.00192799f //x=9.74 \
 //y=7.58 //x2=5.37 //y2=5.39
cc_515 ( N_VDD_c_553_n N_noxref_6_c_932_n ) capacitor c=0.00433505f //x=6.98 \
 //y=7.585 //x2=5.37 //y2=5.39
cc_516 ( N_VDD_M10_noxref_d N_noxref_6_c_932_n ) capacitor c=0.00655495f \
 //x=4.905 //y=5.205 //x2=5.37 //y2=5.39
cc_517 ( N_VDD_c_569_n N_noxref_6_c_955_n ) capacitor c=0.00222653f //x=9.74 \
 //y=7.58 //x2=6.24 //y2=7.09
cc_518 ( N_VDD_c_558_n N_noxref_6_c_938_n ) capacitor c=0.00766391f //x=3.82 \
 //y=7.585 //x2=4.61 //y2=5.39
cc_519 ( N_VDD_M6_noxref_s N_noxref_6_c_938_n ) capacitor c=5.03296e-19 \
 //x=1.145 //y=5.2 //x2=4.61 //y2=5.39
cc_520 ( N_VDD_M14_noxref_s N_noxref_6_c_945_n ) capacitor c=0.00111428f \
 //x=7.805 //y=5.2 //x2=5.49 //y2=5.39
cc_521 ( N_VDD_c_541_n N_noxref_6_c_946_n ) capacitor c=0.0377581f //x=5.05 \
 //y=7.035 //x2=5.49 //y2=6.92
cc_522 ( N_VDD_c_543_n N_noxref_6_c_946_n ) capacitor c=0.0104317f //x=5.05 \
 //y=7.41 //x2=5.49 //y2=6.92
cc_523 ( N_VDD_c_587_n N_noxref_6_c_946_n ) capacitor c=0.0975191f //x=9.74 \
 //y=7.58 //x2=5.49 //y2=6.92
cc_524 ( N_VDD_c_553_n N_noxref_6_c_946_n ) capacitor c=0.0204966f //x=6.98 \
 //y=7.585 //x2=5.49 //y2=6.92
cc_525 ( N_VDD_c_569_n N_noxref_6_c_946_n ) capacitor c=0.00112916f //x=9.74 \
 //y=7.58 //x2=5.49 //y2=6.92
cc_526 ( N_VDD_M10_noxref_d N_noxref_6_c_946_n ) capacitor c=0.00510287f \
 //x=4.905 //y=5.205 //x2=5.49 //y2=6.92
cc_527 ( N_VDD_c_541_n N_noxref_6_c_962_n ) capacitor c=6.1128e-19 //x=5.05 \
 //y=7.035 //x2=6.37 //y2=6.92
cc_528 ( N_VDD_c_587_n N_noxref_6_c_962_n ) capacitor c=0.00193184f //x=9.74 \
 //y=7.58 //x2=6.37 //y2=6.92
cc_529 ( N_VDD_c_553_n N_noxref_6_c_962_n ) capacitor c=9.3761e-19 //x=6.98 \
 //y=7.585 //x2=6.37 //y2=6.92
cc_530 ( N_VDD_c_568_n N_noxref_6_c_962_n ) capacitor c=0.0111101f //x=7.15 \
 //y=7.585 //x2=6.37 //y2=6.92
cc_531 ( N_VDD_c_569_n N_noxref_6_c_962_n ) capacitor c=0.00112713f //x=9.74 \
 //y=7.58 //x2=6.37 //y2=6.92
cc_532 ( N_VDD_c_534_n N_noxref_6_c_947_n ) capacitor c=0.00240365f //x=4.965 \
 //y=7.585 //x2=4.61 //y2=5.56
cc_533 ( N_VDD_c_541_n N_noxref_6_c_947_n ) capacitor c=0.00220777f //x=5.05 \
 //y=7.035 //x2=4.61 //y2=5.56
cc_534 ( N_VDD_c_543_n N_noxref_6_c_947_n ) capacitor c=0.00154298f //x=5.05 \
 //y=7.41 //x2=4.61 //y2=5.56
cc_535 ( N_VDD_c_553_n N_noxref_6_c_947_n ) capacitor c=0.0126473f //x=6.98 \
 //y=7.585 //x2=4.61 //y2=5.56
cc_536 ( N_VDD_c_558_n N_noxref_6_c_947_n ) capacitor c=0.0552885f //x=3.82 \
 //y=7.585 //x2=4.61 //y2=5.56
cc_537 ( N_VDD_c_569_n N_noxref_6_c_947_n ) capacitor c=0.00161681f //x=9.74 \
 //y=7.58 //x2=4.61 //y2=5.56
cc_538 ( N_VDD_M9_noxref_d N_noxref_6_c_947_n ) capacitor c=0.00271974f \
 //x=2.895 //y=5.2 //x2=4.61 //y2=5.56
cc_539 ( N_VDD_M10_noxref_d N_noxref_6_c_947_n ) capacitor c=0.0736177f \
 //x=4.905 //y=5.205 //x2=4.61 //y2=5.56
cc_540 ( N_VDD_c_541_n N_noxref_6_c_951_n ) capacitor c=0.00211426f //x=5.05 \
 //y=7.035 //x2=5.49 //y2=5.56
cc_541 ( N_VDD_c_543_n N_noxref_6_c_951_n ) capacitor c=4.62894e-19 //x=5.05 \
 //y=7.41 //x2=5.49 //y2=5.56
cc_542 ( N_VDD_c_587_n N_noxref_6_c_951_n ) capacitor c=0.00205411f //x=9.74 \
 //y=7.58 //x2=5.49 //y2=5.56
cc_543 ( N_VDD_c_553_n N_noxref_6_c_951_n ) capacitor c=0.0085453f //x=6.98 \
 //y=7.585 //x2=5.49 //y2=5.56
cc_544 ( N_VDD_c_569_n N_noxref_6_c_951_n ) capacitor c=0.00100828f //x=9.74 \
 //y=7.58 //x2=5.49 //y2=5.56
cc_545 ( N_VDD_M10_noxref_d N_noxref_6_c_951_n ) capacitor c=0.0672707f \
 //x=4.905 //y=5.205 //x2=5.49 //y2=5.56
cc_546 ( N_VDD_c_534_n N_noxref_6_M10_noxref_s ) capacitor c=0.0245962f \
 //x=4.965 //y=7.585 //x2=4.475 //y2=5.205
cc_547 ( N_VDD_c_541_n N_noxref_6_M10_noxref_s ) capacitor c=0.0378001f \
 //x=5.05 //y=7.035 //x2=4.475 //y2=5.205
cc_548 ( N_VDD_c_543_n N_noxref_6_M10_noxref_s ) capacitor c=0.0124823f \
 //x=5.05 //y=7.41 //x2=4.475 //y2=5.205
cc_549 ( N_VDD_c_553_n N_noxref_6_M10_noxref_s ) capacitor c=0.00293047f \
 //x=6.98 //y=7.585 //x2=4.475 //y2=5.205
cc_550 ( N_VDD_c_558_n N_noxref_6_M10_noxref_s ) capacitor c=0.00933367f \
 //x=3.82 //y=7.585 //x2=4.475 //y2=5.205
cc_551 ( N_VDD_c_569_n N_noxref_6_M10_noxref_s ) capacitor c=0.00129282f \
 //x=9.74 //y=7.58 //x2=4.475 //y2=5.205
cc_552 ( N_VDD_M10_noxref_d N_noxref_6_M10_noxref_s ) capacitor c=0.00566597f \
 //x=4.905 //y=5.205 //x2=4.475 //y2=5.205
cc_553 ( N_VDD_c_587_n N_noxref_6_M13_noxref_d ) capacitor c=0.00206569f \
 //x=9.74 //y=7.58 //x2=6.225 //y2=5.205
cc_554 ( N_VDD_c_553_n N_noxref_6_M13_noxref_d ) capacitor c=0.00856914f \
 //x=6.98 //y=7.585 //x2=6.225 //y2=5.205
cc_555 ( N_VDD_c_568_n N_noxref_6_M13_noxref_d ) capacitor c=0.0437918f \
 //x=7.15 //y=7.585 //x2=6.225 //y2=5.205
cc_556 ( N_VDD_c_569_n N_noxref_6_M13_noxref_d ) capacitor c=0.00100487f \
 //x=9.74 //y=7.58 //x2=6.225 //y2=5.205
cc_557 ( N_VDD_M14_noxref_s N_noxref_6_M13_noxref_d ) capacitor c=0.00249213f \
 //x=7.805 //y=5.2 //x2=6.225 //y2=5.205
cc_558 ( N_VDD_c_568_n N_C_c_1044_n ) capacitor c=0.00231379f //x=7.15 \
 //y=7.585 //x2=5.705 //y2=4.885
cc_559 ( N_VDD_c_553_n N_C_M12_noxref_g ) capacitor c=0.00724816f //x=6.98 \
 //y=7.585 //x2=5.71 //y2=6.205
cc_560 ( N_VDD_c_553_n N_C_M13_noxref_g ) capacitor c=0.00782837f //x=6.98 \
 //y=7.585 //x2=6.15 //y2=6.205
cc_561 ( N_VDD_c_568_n N_C_c_1097_n ) capacitor c=0.016784f //x=7.15 //y=7.585 \
 //x2=6.075 //y2=4.975
cc_562 ( N_VDD_c_568_n N_C_c_1065_n ) capacitor c=2.75092e-19 //x=7.15 \
 //y=7.585 //x2=5.705 //y2=4.885
cc_563 ( N_VDD_c_555_n N_GND_c_1156_n ) capacitor c=0.00989514f //x=1.23 \
 //y=7.58 //x2=1.23 //y2=0.18
cc_564 ( N_VDD_c_569_n N_GND_c_1164_n ) capacitor c=0.00989514f //x=9.74 \
 //y=7.58 //x2=9.74 //y2=0.18
cc_565 ( N_VDD_c_558_n N_GND_c_1165_n ) capacitor c=0.00970423f //x=3.82 \
 //y=7.585 //x2=3.82 //y2=0.175
cc_566 ( N_VDD_c_568_n N_GND_c_1218_n ) capacitor c=0.00970423f //x=7.15 \
 //y=7.585 //x2=7.15 //y2=0.175
cc_567 ( N_VDD_c_569_n N_D_c_1380_n ) capacitor c=0.00226427f //x=9.74 \
 //y=7.58 //x2=9.03 //y2=4.88
cc_568 ( N_VDD_c_686_p N_D_M16_noxref_g ) capacitor c=0.00697352f //x=9.615 \
 //y=7.585 //x2=9.04 //y2=6.2
cc_569 ( N_VDD_M15_noxref_d N_D_M16_noxref_g ) capacitor c=0.015318f //x=8.675 \
 //y=5.2 //x2=9.04 //y2=6.2
cc_570 ( N_VDD_c_686_p N_D_M17_noxref_g ) capacitor c=0.00755544f //x=9.615 \
 //y=7.585 //x2=9.48 //y2=6.2
cc_571 ( N_VDD_M17_noxref_d N_D_M17_noxref_g ) capacitor c=0.0430452f \
 //x=9.555 //y=5.2 //x2=9.48 //y2=6.2
cc_572 ( N_VDD_c_569_n N_D_c_1407_n ) capacitor c=0.0237963f //x=9.74 //y=7.58 \
 //x2=9.405 //y2=4.97
cc_573 ( N_VDD_c_569_n N_D_c_1399_n ) capacitor c=2.73429e-19 //x=9.74 \
 //y=7.58 //x2=9.03 //y2=4.88
cc_574 ( N_VDD_M15_noxref_d N_D_c_1399_n ) capacitor c=3.32552e-19 //x=8.675 \
 //y=5.2 //x2=9.03 //y2=4.88
cc_575 ( N_VDD_c_568_n YN ) capacitor c=6.93347e-19 //x=7.15 //y=7.585 \
 //x2=9.74 //y2=2.4
cc_576 ( N_VDD_c_569_n YN ) capacitor c=0.0392011f //x=9.74 //y=7.58 //x2=9.74 \
 //y2=2.4
cc_577 ( N_VDD_c_587_n N_YN_c_1468_n ) capacitor c=0.00648307f //x=9.74 \
 //y=7.58 //x2=9.145 //y2=5.38
cc_578 ( N_VDD_c_592_n N_YN_c_1468_n ) capacitor c=0.00213203f //x=8.735 \
 //y=7.585 //x2=9.145 //y2=5.38
cc_579 ( N_VDD_c_686_p N_YN_c_1468_n ) capacitor c=0.00184541f //x=9.615 \
 //y=7.585 //x2=9.145 //y2=5.38
cc_580 ( N_VDD_M15_noxref_d N_YN_c_1468_n ) capacitor c=0.00810252f //x=8.675 \
 //y=5.2 //x2=9.145 //y2=5.38
cc_581 ( N_VDD_c_587_n N_YN_c_1492_n ) capacitor c=0.00488503f //x=9.74 \
 //y=7.58 //x2=9.655 //y2=5.38
cc_582 ( N_VDD_c_686_p N_YN_c_1492_n ) capacitor c=0.00213203f //x=9.615 \
 //y=7.585 //x2=9.655 //y2=5.38
cc_583 ( N_VDD_M17_noxref_d N_YN_c_1492_n ) capacitor c=0.0125399f //x=9.555 \
 //y=5.2 //x2=9.655 //y2=5.38
cc_584 ( N_VDD_c_587_n N_YN_c_1472_n ) capacitor c=0.00368834f //x=9.74 \
 //y=7.58 //x2=8.38 //y2=5.56
cc_585 ( N_VDD_c_592_n N_YN_c_1472_n ) capacitor c=9.99055e-19 //x=8.735 \
 //y=7.585 //x2=8.38 //y2=5.56
cc_586 ( N_VDD_c_568_n N_YN_c_1472_n ) capacitor c=4.91377e-19 //x=7.15 \
 //y=7.585 //x2=8.38 //y2=5.56
cc_587 ( N_VDD_M14_noxref_s N_YN_c_1472_n ) capacitor c=0.0616215f //x=7.805 \
 //y=5.2 //x2=8.38 //y2=5.56
cc_588 ( N_VDD_M15_noxref_d N_YN_c_1472_n ) capacitor c=0.0043528f //x=8.675 \
 //y=5.2 //x2=8.38 //y2=5.56
cc_589 ( N_VDD_c_587_n N_YN_c_1500_n ) capacitor c=8.42709e-19 //x=9.74 \
 //y=7.58 //x2=9.26 //y2=5.38
cc_590 ( N_VDD_c_686_p N_YN_c_1500_n ) capacitor c=5.39459e-19 //x=9.615 \
 //y=7.585 //x2=9.26 //y2=5.38
cc_591 ( N_VDD_c_569_n N_YN_c_1500_n ) capacitor c=0.00379179f //x=9.74 \
 //y=7.58 //x2=9.26 //y2=5.38
cc_592 ( N_VDD_M14_noxref_s N_YN_c_1500_n ) capacitor c=6.52457e-19 //x=7.805 \
 //y=5.2 //x2=9.26 //y2=5.38
cc_593 ( N_VDD_c_587_n N_YN_c_1504_n ) capacitor c=0.00285853f //x=9.74 \
 //y=7.58 //x2=9.26 //y2=5.56
cc_594 ( N_VDD_c_686_p N_YN_c_1504_n ) capacitor c=5.77976e-19 //x=9.615 \
 //y=7.585 //x2=9.26 //y2=5.56
cc_595 ( N_VDD_c_569_n N_YN_c_1504_n ) capacitor c=0.0016115f //x=9.74 \
 //y=7.58 //x2=9.26 //y2=5.56
cc_596 ( N_VDD_M15_noxref_d N_YN_c_1504_n ) capacitor c=0.0043528f //x=8.675 \
 //y=5.2 //x2=9.26 //y2=5.56
cc_597 ( N_VDD_M17_noxref_d N_YN_c_1504_n ) capacitor c=0.00979407f //x=9.555 \
 //y=5.2 //x2=9.26 //y2=5.56
cc_598 ( N_VDD_c_587_n N_YN_c_1481_n ) capacitor c=0.00224881f //x=9.74 \
 //y=7.58 //x2=8.38 //y2=5.56
cc_599 ( N_VDD_c_592_n N_YN_c_1481_n ) capacitor c=0.0136705f //x=8.735 \
 //y=7.585 //x2=8.38 //y2=5.56
cc_600 ( N_VDD_c_568_n N_YN_c_1481_n ) capacitor c=0.00637389f //x=7.15 \
 //y=7.585 //x2=8.38 //y2=5.56
cc_601 ( N_VDD_c_569_n N_YN_c_1481_n ) capacitor c=0.00135089f //x=9.74 \
 //y=7.58 //x2=8.38 //y2=5.56
cc_602 ( N_VDD_M14_noxref_s N_YN_c_1481_n ) capacitor c=0.0884109f //x=7.805 \
 //y=5.2 //x2=8.38 //y2=5.56
cc_603 ( N_VDD_M15_noxref_d N_YN_c_1481_n ) capacitor c=0.0653657f //x=8.675 \
 //y=5.2 //x2=8.38 //y2=5.56
cc_604 ( N_VDD_c_587_n N_YN_c_1515_n ) capacitor c=0.00224881f //x=9.74 \
 //y=7.58 //x2=9.26 //y2=5.56
cc_605 ( N_VDD_c_686_p N_YN_c_1515_n ) capacitor c=0.0136705f //x=9.615 \
 //y=7.585 //x2=9.26 //y2=5.56
cc_606 ( N_VDD_c_569_n N_YN_c_1515_n ) capacitor c=0.0115375f //x=9.74 \
 //y=7.58 //x2=9.26 //y2=5.56
cc_607 ( N_VDD_M15_noxref_d N_YN_c_1515_n ) capacitor c=0.0654383f //x=8.675 \
 //y=5.2 //x2=9.26 //y2=5.56
cc_608 ( N_VDD_M17_noxref_d N_YN_c_1515_n ) capacitor c=0.0654892f //x=9.555 \
 //y=5.2 //x2=9.26 //y2=5.56
cc_609 ( A B ) capacitor c=0.109381f //x=1.6 //y=2.4 //x2=2.34 //y2=2.4
cc_610 ( N_A_c_752_p B ) capacitor c=3.49899e-19 //x=1.6 //y=2.26 //x2=2.34 \
 //y2=2.4
cc_611 ( N_A_c_731_n B ) capacitor c=3.02466e-19 //x=1.6 //y=4.88 //x2=2.34 \
 //y2=2.4
cc_612 ( N_A_c_738_n B ) capacitor c=0.00108965f //x=1.6 //y=4.88 //x2=2.34 \
 //y2=2.4
cc_613 ( N_A_c_729_n N_B_c_832_n ) capacitor c=0.0172939f //x=1.6 //y=4.88 \
 //x2=2.34 //y2=4.735
cc_614 ( N_A_c_731_n N_B_c_832_n ) capacitor c=4.73677e-19 //x=1.6 //y=4.88 \
 //x2=2.34 //y2=4.735
cc_615 ( N_A_c_738_n N_B_c_832_n ) capacitor c=9.22067e-19 //x=1.6 //y=4.88 \
 //x2=2.34 //y2=4.735
cc_616 ( N_A_c_758_p N_B_c_834_n ) capacitor c=0.0205342f //x=1.6 //y=2.26 \
 //x2=2.34 //y2=2.26
cc_617 ( N_A_c_752_p N_B_c_834_n ) capacitor c=5.16867e-19 //x=1.6 //y=2.26 \
 //x2=2.34 //y2=2.26
cc_618 ( N_A_c_760_p N_B_c_834_n ) capacitor c=0.00167888f //x=1.405 //y=2.095 \
 //x2=2.34 //y2=2.26
cc_619 ( A N_B_c_836_n ) capacitor c=3.49899e-19 //x=1.6 //y=2.4 //x2=2.34 \
 //y2=2.26
cc_620 ( N_A_c_758_p N_B_c_836_n ) capacitor c=0.00370824f //x=1.6 //y=2.26 \
 //x2=2.34 //y2=2.26
cc_621 ( N_A_c_752_p N_B_c_836_n ) capacitor c=0.00445529f //x=1.6 //y=2.26 \
 //x2=2.34 //y2=2.26
cc_622 ( N_A_c_760_p N_B_c_836_n ) capacitor c=0.00267961f //x=1.405 //y=2.095 \
 //x2=2.34 //y2=2.26
cc_623 ( A N_B_c_837_n ) capacitor c=2.1563e-19 //x=1.6 //y=2.4 //x2=2.37 \
 //y2=4.88
cc_624 ( N_A_c_729_n N_B_c_837_n ) capacitor c=0.00389735f //x=1.6 //y=4.88 \
 //x2=2.37 //y2=4.88
cc_625 ( N_A_c_731_n N_B_c_837_n ) capacitor c=0.00397338f //x=1.6 //y=4.88 \
 //x2=2.37 //y2=4.88
cc_626 ( N_A_c_738_n N_B_c_837_n ) capacitor c=0.00283894f //x=1.6 //y=4.88 \
 //x2=2.37 //y2=4.88
cc_627 ( N_A_M6_noxref_g N_B_M8_noxref_g ) capacitor c=0.0104892f //x=1.5 \
 //y=6.2 //x2=2.38 //y2=6.2
cc_628 ( N_A_M7_noxref_g N_B_M8_noxref_g ) capacitor c=0.107636f //x=1.94 \
 //y=6.2 //x2=2.38 //y2=6.2
cc_629 ( N_A_M7_noxref_g N_B_M9_noxref_g ) capacitor c=0.0100341f //x=1.94 \
 //y=6.2 //x2=2.82 //y2=6.2
cc_630 ( N_A_c_772_p N_B_c_845_n ) capacitor c=4.86545e-19 //x=1.405 //y=1.045 \
 //x2=2.375 //y2=1.085
cc_631 ( N_A_c_773_p N_B_c_845_n ) capacitor c=0.00152405f //x=1.405 //y=1.39 \
 //x2=2.375 //y2=1.085
cc_632 ( N_A_c_774_p N_B_c_845_n ) capacitor c=0.0151475f //x=1.935 //y=1.045 \
 //x2=2.375 //y2=1.085
cc_633 ( N_A_c_775_p N_B_c_847_n ) capacitor c=0.00109982f //x=1.405 //y=1.7 \
 //x2=2.375 //y2=1.43
cc_634 ( N_A_c_776_p N_B_c_847_n ) capacitor c=0.0111064f //x=1.935 //y=1.39 \
 //x2=2.375 //y2=1.43
cc_635 ( N_A_c_775_p N_B_c_850_n ) capacitor c=9.58243e-19 //x=1.405 //y=1.7 \
 //x2=2.375 //y2=1.74
cc_636 ( N_A_c_760_p N_B_c_850_n ) capacitor c=0.00662747f //x=1.405 //y=2.095 \
 //x2=2.375 //y2=1.74
cc_637 ( N_A_c_776_p N_B_c_850_n ) capacitor c=0.00862358f //x=1.935 //y=1.39 \
 //x2=2.375 //y2=1.74
cc_638 ( N_A_c_774_p N_B_c_860_n ) capacitor c=0.00127211f //x=1.935 //y=1.045 \
 //x2=2.905 //y2=1.085
cc_639 ( N_A_c_776_p N_B_c_862_n ) capacitor c=0.00204774f //x=1.935 //y=1.39 \
 //x2=2.905 //y2=1.43
cc_640 ( N_A_c_758_p N_B_c_866_n ) capacitor c=0.00167305f //x=1.6 //y=2.26 \
 //x2=2.34 //y2=2.26
cc_641 ( N_A_c_752_p N_B_c_866_n ) capacitor c=0.00266443f //x=1.6 //y=2.26 \
 //x2=2.34 //y2=2.26
cc_642 ( N_A_c_760_p N_B_c_866_n ) capacitor c=0.0181449f //x=1.405 //y=2.095 \
 //x2=2.34 //y2=2.26
cc_643 ( N_A_c_729_n N_B_c_869_n ) capacitor c=0.00158715f //x=1.6 //y=4.88 \
 //x2=2.37 //y2=4.88
cc_644 ( N_A_c_731_n N_B_c_869_n ) capacitor c=0.00237977f //x=1.6 //y=4.88 \
 //x2=2.37 //y2=4.88
cc_645 ( N_A_c_738_n N_B_c_869_n ) capacitor c=0.0297875f //x=1.6 //y=4.88 \
 //x2=2.37 //y2=4.88
cc_646 ( N_A_c_758_p N_GND_c_1251_n ) capacitor c=6.6172e-19 //x=1.6 //y=2.26 \
 //x2=1.585 //y2=0.175
cc_647 ( N_A_c_758_p N_GND_c_1151_n ) capacitor c=0.00709624f //x=1.6 //y=2.26 \
 //x2=1.67 //y2=1.135
cc_648 ( N_A_c_752_p N_GND_c_1151_n ) capacitor c=2.13705e-19 //x=1.6 //y=2.26 \
 //x2=1.67 //y2=1.135
cc_649 ( N_A_c_772_p N_GND_c_1151_n ) capacitor c=0.00156094f //x=1.405 \
 //y=1.045 //x2=1.67 //y2=1.135
cc_650 ( N_A_c_773_p N_GND_c_1151_n ) capacitor c=0.00413828f //x=1.405 \
 //y=1.39 //x2=1.67 //y2=1.135
cc_651 ( N_A_c_775_p N_GND_c_1151_n ) capacitor c=4.2764e-19 //x=1.405 //y=1.7 \
 //x2=1.67 //y2=1.135
cc_652 ( N_A_c_794_p N_GND_c_1151_n ) capacitor c=7.35788e-19 //x=1.78 \
 //y=0.89 //x2=1.67 //y2=1.135
cc_653 ( N_A_c_795_p N_GND_c_1151_n ) capacitor c=6.38426e-19 //x=1.78 \
 //y=1.545 //x2=1.67 //y2=1.135
cc_654 ( N_A_c_774_p N_GND_c_1151_n ) capacitor c=0.00172871f //x=1.935 \
 //y=1.045 //x2=1.67 //y2=1.135
cc_655 ( N_A_c_776_p N_GND_c_1151_n ) capacitor c=0.00296337f //x=1.935 \
 //y=1.39 //x2=1.67 //y2=1.135
cc_656 ( N_A_c_772_p N_GND_c_1261_n ) capacitor c=3.51399e-19 //x=1.405 \
 //y=1.045 //x2=1.667 //y2=1.005
cc_657 ( N_A_c_794_p N_GND_c_1261_n ) capacitor c=0.00864609f //x=1.78 \
 //y=0.89 //x2=1.667 //y2=1.005
cc_658 ( N_A_c_774_p N_GND_c_1261_n ) capacitor c=4.45447e-19 //x=1.935 \
 //y=1.045 //x2=1.667 //y2=1.005
cc_659 ( N_A_c_772_p N_GND_c_1154_n ) capacitor c=0.00690758f //x=1.405 \
 //y=1.045 //x2=3.65 //y2=0.175
cc_660 ( A N_GND_c_1156_n ) capacitor c=0.0113199f //x=1.6 //y=2.4 //x2=1.23 \
 //y2=0.18
cc_661 ( N_A_c_758_p N_GND_c_1156_n ) capacitor c=0.0082376f //x=1.6 //y=2.26 \
 //x2=1.23 //y2=0.18
cc_662 ( N_A_c_752_p N_GND_c_1156_n ) capacitor c=0.00369668f //x=1.6 //y=2.26 \
 //x2=1.23 //y2=0.18
cc_663 ( N_A_c_775_p N_GND_c_1156_n ) capacitor c=0.0015404f //x=1.405 //y=1.7 \
 //x2=1.23 //y2=0.18
cc_664 ( N_A_c_760_p N_GND_c_1156_n ) capacitor c=0.00950704f //x=1.405 \
 //y=2.095 //x2=1.23 //y2=0.18
cc_665 ( N_A_c_758_p N_GND_M0_noxref_d ) capacitor c=2.20438e-19 //x=1.6 \
 //y=2.26 //x2=1.48 //y2=1.045
cc_666 ( N_A_c_772_p N_GND_M0_noxref_d ) capacitor c=0.00192399f //x=1.405 \
 //y=1.045 //x2=1.48 //y2=1.045
cc_667 ( N_A_c_773_p N_GND_M0_noxref_d ) capacitor c=0.00210798f //x=1.405 \
 //y=1.39 //x2=1.48 //y2=1.045
cc_668 ( N_A_c_794_p N_GND_M0_noxref_d ) capacitor c=0.00472259f //x=1.78 \
 //y=0.89 //x2=1.48 //y2=1.045
cc_669 ( N_A_c_795_p N_GND_M0_noxref_d ) capacitor c=0.00166857f //x=1.78 \
 //y=1.545 //x2=1.48 //y2=1.045
cc_670 ( N_A_c_774_p N_GND_M0_noxref_d ) capacitor c=0.00230174f //x=1.935 \
 //y=1.045 //x2=1.48 //y2=1.045
cc_671 ( N_A_c_776_p N_GND_M0_noxref_d ) capacitor c=0.00210798f //x=1.935 \
 //y=1.39 //x2=1.48 //y2=1.045
cc_672 ( N_A_c_760_p N_noxref_11_c_1587_n ) capacitor c=0.00262672f //x=1.405 \
 //y=2.095 //x2=1.185 //y2=1.675
cc_673 ( N_A_c_758_p N_noxref_11_c_1588_n ) capacitor c=0.00459552f //x=1.6 \
 //y=2.26 //x2=2.07 //y2=1.76
cc_674 ( N_A_c_752_p N_noxref_11_c_1588_n ) capacitor c=0.00763108f //x=1.6 \
 //y=2.26 //x2=2.07 //y2=1.76
cc_675 ( N_A_c_775_p N_noxref_11_c_1588_n ) capacitor c=0.00695869f //x=1.405 \
 //y=1.7 //x2=2.07 //y2=1.76
cc_676 ( N_A_c_760_p N_noxref_11_c_1588_n ) capacitor c=0.0194861f //x=1.405 \
 //y=2.095 //x2=2.07 //y2=1.76
cc_677 ( N_A_c_795_p N_noxref_11_c_1588_n ) capacitor c=0.00723574f //x=1.78 \
 //y=1.545 //x2=2.07 //y2=1.76
cc_678 ( N_A_c_776_p N_noxref_11_c_1588_n ) capacitor c=0.00399755f //x=1.935 \
 //y=1.39 //x2=2.07 //y2=1.76
cc_679 ( N_A_c_760_p N_noxref_11_c_1577_n ) capacitor c=6.71402e-19 //x=1.405 \
 //y=2.095 //x2=2.155 //y2=1.675
cc_680 ( N_A_c_772_p N_noxref_11_M0_noxref_s ) capacitor c=0.0294925f \
 //x=1.405 //y=1.045 //x2=1.05 //y2=0.545
cc_681 ( N_A_c_775_p N_noxref_11_M0_noxref_s ) capacitor c=3.48408e-19 \
 //x=1.405 //y=1.7 //x2=1.05 //y2=0.545
cc_682 ( N_A_c_774_p N_noxref_11_M0_noxref_s ) capacitor c=0.0125442f \
 //x=1.935 //y=1.045 //x2=1.05 //y2=0.545
cc_683 ( N_B_c_834_n N_GND_c_1145_n ) capacitor c=0.00234561f //x=2.34 \
 //y=2.26 //x2=8.245 //y2=0.175
cc_684 ( N_B_c_834_n N_GND_c_1154_n ) capacitor c=3.77328e-19 //x=2.34 \
 //y=2.26 //x2=3.65 //y2=0.175
cc_685 ( N_B_c_836_n N_GND_c_1165_n ) capacitor c=0.00224736f //x=2.34 \
 //y=2.26 //x2=3.82 //y2=0.175
cc_686 ( N_B_c_862_n N_GND_c_1165_n ) capacitor c=0.00275184f //x=2.905 \
 //y=1.43 //x2=3.82 //y2=0.175
cc_687 ( N_B_c_866_n N_GND_c_1165_n ) capacitor c=2.63786e-19 //x=2.34 \
 //y=2.26 //x2=3.82 //y2=0.175
cc_688 ( N_B_c_834_n N_noxref_11_c_1577_n ) capacitor c=7.471e-19 //x=2.34 \
 //y=2.26 //x2=2.155 //y2=1.675
cc_689 ( N_B_c_850_n N_noxref_11_c_1577_n ) capacitor c=0.00888238f //x=2.375 \
 //y=1.74 //x2=2.155 //y2=1.675
cc_690 ( N_B_c_866_n N_noxref_11_c_1577_n ) capacitor c=0.00173073f //x=2.34 \
 //y=2.26 //x2=2.155 //y2=1.675
cc_691 ( N_B_c_834_n N_noxref_11_c_1578_n ) capacitor c=0.00141156f //x=2.34 \
 //y=2.26 //x2=3.04 //y2=0.71
cc_692 ( N_B_c_836_n N_noxref_11_c_1578_n ) capacitor c=8.82141e-19 //x=2.34 \
 //y=2.26 //x2=3.04 //y2=0.71
cc_693 ( N_B_c_845_n N_noxref_11_c_1578_n ) capacitor c=0.0199501f //x=2.375 \
 //y=1.085 //x2=3.04 //y2=0.71
cc_694 ( N_B_c_860_n N_noxref_11_c_1578_n ) capacitor c=0.00825432f //x=2.905 \
 //y=1.085 //x2=3.04 //y2=0.71
cc_695 ( N_B_c_866_n N_noxref_11_c_1578_n ) capacitor c=2.1838e-19 //x=2.34 \
 //y=2.26 //x2=3.04 //y2=0.71
cc_696 ( N_B_c_845_n N_noxref_11_M0_noxref_s ) capacitor c=0.00888238f \
 //x=2.375 //y=1.085 //x2=1.05 //y2=0.545
cc_697 ( N_B_c_860_n N_noxref_11_M0_noxref_s ) capacitor c=0.015333f //x=2.905 \
 //y=1.085 //x2=1.05 //y2=0.545
cc_698 ( N_B_c_862_n N_noxref_11_M0_noxref_s ) capacitor c=0.00248746f \
 //x=2.905 //y=1.43 //x2=1.05 //y2=0.545
cc_699 ( N_noxref_6_c_945_n N_C_c_1034_n ) capacitor c=7.31659e-19 //x=5.49 \
 //y=5.39 //x2=5.67 //y2=2.26
cc_700 ( N_noxref_6_c_955_n N_C_c_1037_n ) capacitor c=0.00213985f //x=6.24 \
 //y=7.09 //x2=5.705 //y2=4.885
cc_701 ( N_noxref_6_c_945_n N_C_c_1037_n ) capacitor c=0.00262304f //x=5.49 \
 //y=5.39 //x2=5.705 //y2=4.885
cc_702 ( N_noxref_6_c_955_n N_C_c_1044_n ) capacitor c=0.00233585f //x=6.24 \
 //y=7.09 //x2=5.705 //y2=4.885
cc_703 ( N_noxref_6_c_955_n N_C_M12_noxref_g ) capacitor c=0.00777443f \
 //x=6.24 //y=7.09 //x2=5.71 //y2=6.205
cc_704 ( N_noxref_6_c_945_n N_C_M12_noxref_g ) capacitor c=0.00176767f \
 //x=5.49 //y=5.39 //x2=5.71 //y2=6.205
cc_705 ( N_noxref_6_c_946_n N_C_M12_noxref_g ) capacitor c=0.00186228f \
 //x=5.49 //y=6.92 //x2=5.71 //y2=6.205
cc_706 ( N_noxref_6_c_951_n N_C_M12_noxref_g ) capacitor c=0.0170175f //x=5.49 \
 //y=5.56 //x2=5.71 //y2=6.205
cc_707 ( N_noxref_6_c_955_n N_C_M13_noxref_g ) capacitor c=0.0093887f //x=6.24 \
 //y=7.09 //x2=6.15 //y2=6.205
cc_708 ( N_noxref_6_c_962_n N_C_M13_noxref_g ) capacitor c=0.00410728f \
 //x=6.37 //y=6.92 //x2=6.15 //y2=6.205
cc_709 ( N_noxref_6_M13_noxref_d N_C_M13_noxref_g ) capacitor c=0.0365939f \
 //x=6.225 //y=5.205 //x2=6.15 //y2=6.205
cc_710 ( N_noxref_6_c_945_n N_C_c_1065_n ) capacitor c=6.45633e-19 //x=5.49 \
 //y=5.39 //x2=5.705 //y2=4.885
cc_711 ( N_C_c_1034_n N_GND_c_1208_n ) capacitor c=6.61292e-19 //x=5.67 \
 //y=2.26 //x2=6.37 //y2=0.71
cc_712 ( N_C_c_1040_n N_GND_c_1208_n ) capacitor c=8.64363e-19 //x=5.67 \
 //y=2.26 //x2=6.37 //y2=0.71
cc_713 ( N_C_c_1051_n N_GND_c_1208_n ) capacitor c=0.0210318f //x=5.705 \
 //y=1.085 //x2=6.37 //y2=0.71
cc_714 ( N_C_c_1059_n N_GND_c_1208_n ) capacitor c=0.00825432f //x=6.235 \
 //y=1.085 //x2=6.37 //y2=0.71
cc_715 ( N_C_c_1061_n N_GND_c_1208_n ) capacitor c=2.1838e-19 //x=5.67 \
 //y=2.26 //x2=6.37 //y2=0.71
cc_716 ( N_C_c_1040_n N_GND_c_1218_n ) capacitor c=0.00224736f //x=5.67 \
 //y=2.26 //x2=7.15 //y2=0.175
cc_717 ( N_C_c_1058_n N_GND_c_1218_n ) capacitor c=0.0028635f //x=6.08 \
 //y=1.585 //x2=7.15 //y2=0.175
cc_718 ( N_C_c_1061_n N_GND_c_1218_n ) capacitor c=2.63786e-19 //x=5.67 \
 //y=2.26 //x2=7.15 //y2=0.175
cc_719 ( N_C_c_1051_n N_GND_M2_noxref_s ) capacitor c=0.00720961f //x=5.705 \
 //y=1.085 //x2=4.38 //y2=0.545
cc_720 ( N_C_c_1058_n N_GND_M2_noxref_s ) capacitor c=0.00271091f //x=6.08 \
 //y=1.585 //x2=4.38 //y2=0.545
cc_721 ( N_C_c_1059_n N_GND_M2_noxref_s ) capacitor c=0.0151996f //x=6.235 \
 //y=1.085 //x2=4.38 //y2=0.545
cc_722 ( N_C_c_1061_n N_GND_M2_noxref_s ) capacitor c=0.00119136f //x=5.67 \
 //y=2.26 //x2=4.38 //y2=0.545
cc_723 ( N_GND_c_1294_p N_D_c_1373_n ) capacitor c=0.00234561f //x=9.74 \
 //y=0.18 //x2=9 //y2=2.26
cc_724 ( N_GND_c_1164_n N_D_c_1373_n ) capacitor c=3.77328e-19 //x=9.74 \
 //y=0.18 //x2=9 //y2=2.26
cc_725 ( N_GND_c_1164_n N_D_c_1376_n ) capacitor c=0.00224736f //x=9.74 \
 //y=0.18 //x2=9 //y2=2.26
cc_726 ( N_GND_c_1164_n N_D_c_1395_n ) capacitor c=0.0028807f //x=9.74 \
 //y=0.18 //x2=9.565 //y2=1.43
cc_727 ( N_GND_c_1164_n N_D_c_1396_n ) capacitor c=2.63786e-19 //x=9.74 \
 //y=0.18 //x2=9 //y2=2.26
cc_728 ( N_GND_c_1164_n N_YN_c_1469_n ) capacitor c=0.00528499f //x=9.74 \
 //y=0.18 //x2=9.3 //y2=1.75
cc_729 ( N_GND_c_1294_p N_YN_c_1521_n ) capacitor c=0.00652597f //x=9.74 \
 //y=0.18 //x2=9.655 //y2=1.835
cc_730 ( N_GND_c_1164_n N_YN_c_1521_n ) capacitor c=0.0397588f //x=9.74 \
 //y=0.18 //x2=9.655 //y2=1.835
cc_731 ( N_GND_c_1191_n N_YN_c_1472_n ) capacitor c=7.0104e-19 //x=8.33 \
 //y=1.135 //x2=8.38 //y2=5.56
cc_732 ( N_GND_c_1294_p N_YN_c_1480_n ) capacitor c=0.00964814f //x=9.74 \
 //y=0.18 //x2=9.3 //y2=1.18
cc_733 ( N_GND_c_1191_n N_YN_c_1480_n ) capacitor c=0.0141824f //x=8.33 \
 //y=1.135 //x2=9.3 //y2=1.18
cc_734 ( N_GND_c_1164_n N_YN_c_1480_n ) capacitor c=2.83275e-19 //x=9.74 \
 //y=0.18 //x2=9.3 //y2=1.18
cc_735 ( N_GND_M4_noxref_d N_YN_c_1480_n ) capacitor c=2.82748e-19 //x=8.14 \
 //y=1.045 //x2=9.3 //y2=1.18
cc_736 ( N_GND_c_1294_p N_YN_M5_noxref_d ) capacitor c=3.01769e-19 //x=9.74 \
 //y=0.18 //x2=9.11 //y2=1.085
cc_737 ( N_GND_c_1191_n N_YN_M5_noxref_d ) capacitor c=2.93544e-19 //x=8.33 \
 //y=1.135 //x2=9.11 //y2=1.085
cc_738 ( N_GND_c_1251_n N_noxref_11_c_1588_n ) capacitor c=0.00275848f \
 //x=1.585 //y=0.175 //x2=2.07 //y2=1.76
cc_739 ( N_GND_c_1145_n N_noxref_11_c_1588_n ) capacitor c=7.74325e-19 \
 //x=8.245 //y=0.175 //x2=2.07 //y2=1.76
cc_740 ( N_GND_c_1151_n N_noxref_11_c_1588_n ) capacitor c=0.00407714f \
 //x=1.67 //y=1.135 //x2=2.07 //y2=1.76
cc_741 ( N_GND_c_1154_n N_noxref_11_c_1588_n ) capacitor c=0.00375345f \
 //x=3.65 //y=0.175 //x2=2.07 //y2=1.76
cc_742 ( N_GND_M0_noxref_d N_noxref_11_c_1588_n ) capacitor c=0.00578453f \
 //x=1.48 //y=1.045 //x2=2.07 //y2=1.76
cc_743 ( N_GND_c_1145_n N_noxref_11_c_1614_n ) capacitor c=0.0068323f \
 //x=8.245 //y=0.175 //x2=2.155 //y2=0.795
cc_744 ( N_GND_c_1261_n N_noxref_11_c_1614_n ) capacitor c=0.0167642f \
 //x=1.667 //y=1.005 //x2=2.155 //y2=0.795
cc_745 ( N_GND_c_1154_n N_noxref_11_c_1614_n ) capacitor c=0.0146605f //x=3.65 \
 //y=0.175 //x2=2.155 //y2=0.795
cc_746 ( N_GND_c_1156_n N_noxref_11_c_1614_n ) capacitor c=0.00283128f \
 //x=1.23 //y=0.18 //x2=2.155 //y2=0.795
cc_747 ( N_GND_c_1164_n N_noxref_11_c_1614_n ) capacitor c=0.00145873f \
 //x=9.74 //y=0.18 //x2=2.155 //y2=0.795
cc_748 ( N_GND_c_1165_n N_noxref_11_c_1614_n ) capacitor c=2.21767e-19 \
 //x=3.82 //y=0.175 //x2=2.155 //y2=0.795
cc_749 ( N_GND_c_1156_n N_noxref_11_c_1577_n ) capacitor c=2.85935e-19 \
 //x=1.23 //y=0.18 //x2=2.155 //y2=1.675
cc_750 ( N_GND_c_1145_n N_noxref_11_c_1578_n ) capacitor c=0.0100399f \
 //x=8.245 //y=0.175 //x2=3.04 //y2=0.71
cc_751 ( N_GND_c_1154_n N_noxref_11_c_1578_n ) capacitor c=0.0374826f //x=3.65 \
 //y=0.175 //x2=3.04 //y2=0.71
cc_752 ( N_GND_c_1164_n N_noxref_11_c_1578_n ) capacitor c=0.00198596f \
 //x=9.74 //y=0.18 //x2=3.04 //y2=0.71
cc_753 ( N_GND_c_1145_n N_noxref_11_c_1624_n ) capacitor c=0.00244977f \
 //x=8.245 //y=0.175 //x2=3.125 //y2=0.795
cc_754 ( N_GND_c_1154_n N_noxref_11_c_1624_n ) capacitor c=0.0145365f //x=3.65 \
 //y=0.175 //x2=3.125 //y2=0.795
cc_755 ( N_GND_c_1326_p N_noxref_11_c_1624_n ) capacitor c=0.0019997f \
 //x=4.515 //y=0.625 //x2=3.125 //y2=0.795
cc_756 ( N_GND_c_1164_n N_noxref_11_c_1624_n ) capacitor c=0.00145015f \
 //x=9.74 //y=0.18 //x2=3.125 //y2=0.795
cc_757 ( N_GND_c_1165_n N_noxref_11_c_1624_n ) capacitor c=0.0401922f //x=3.82 \
 //y=0.175 //x2=3.125 //y2=0.795
cc_758 ( N_GND_c_1251_n N_noxref_11_M0_noxref_s ) capacitor c=0.00724992f \
 //x=1.585 //y=0.175 //x2=1.05 //y2=0.545
cc_759 ( N_GND_c_1151_n N_noxref_11_M0_noxref_s ) capacitor c=0.0113988f \
 //x=1.67 //y=1.135 //x2=1.05 //y2=0.545
cc_760 ( N_GND_c_1261_n N_noxref_11_M0_noxref_s ) capacitor c=0.0173062f \
 //x=1.667 //y=1.005 //x2=1.05 //y2=0.545
cc_761 ( N_GND_c_1154_n N_noxref_11_M0_noxref_s ) capacitor c=0.014661f \
 //x=3.65 //y=0.175 //x2=1.05 //y2=0.545
cc_762 ( N_GND_c_1156_n N_noxref_11_M0_noxref_s ) capacitor c=0.0559891f \
 //x=1.23 //y=0.18 //x2=1.05 //y2=0.545
cc_763 ( N_GND_c_1164_n N_noxref_11_M0_noxref_s ) capacitor c=0.00145873f \
 //x=9.74 //y=0.18 //x2=1.05 //y2=0.545
cc_764 ( N_GND_c_1165_n N_noxref_11_M0_noxref_s ) capacitor c=0.00642623f \
 //x=3.82 //y=0.175 //x2=1.05 //y2=0.545
cc_765 ( N_GND_M0_noxref_d N_noxref_11_M0_noxref_s ) capacitor c=0.0271276f \
 //x=1.48 //y=1.045 //x2=1.05 //y2=0.545
cc_766 ( N_GND_M2_noxref_s N_noxref_11_M0_noxref_s ) capacitor c=0.00298769f \
 //x=4.38 //y=0.545 //x2=1.05 //y2=0.545
cc_767 ( N_GND_c_1145_n N_noxref_12_c_1640_n ) capacitor c=9.58019e-19 \
 //x=8.245 //y=0.175 //x2=8.73 //y2=1.76
cc_768 ( N_GND_c_1294_p N_noxref_12_c_1640_n ) capacitor c=0.00203804f \
 //x=9.74 //y=0.18 //x2=8.73 //y2=1.76
cc_769 ( N_GND_c_1191_n N_noxref_12_c_1640_n ) capacitor c=0.00398377f \
 //x=8.33 //y=1.135 //x2=8.73 //y2=1.76
cc_770 ( N_GND_c_1164_n N_noxref_12_c_1640_n ) capacitor c=0.00387051f \
 //x=9.74 //y=0.18 //x2=8.73 //y2=1.76
cc_771 ( N_GND_M4_noxref_d N_noxref_12_c_1640_n ) capacitor c=0.00578453f \
 //x=8.14 //y=1.045 //x2=8.73 //y2=1.76
cc_772 ( N_GND_c_1294_p N_noxref_12_c_1657_n ) capacitor c=0.0068323f //x=9.74 \
 //y=0.18 //x2=8.815 //y2=0.795
cc_773 ( N_GND_c_1202_n N_noxref_12_c_1657_n ) capacitor c=0.0167642f \
 //x=8.327 //y=1.005 //x2=8.815 //y2=0.795
cc_774 ( N_GND_c_1164_n N_noxref_12_c_1657_n ) capacitor c=0.016341f //x=9.74 \
 //y=0.18 //x2=8.815 //y2=0.795
cc_775 ( N_GND_c_1218_n N_noxref_12_c_1657_n ) capacitor c=0.00282552f \
 //x=7.15 //y=0.175 //x2=8.815 //y2=0.795
cc_776 ( N_GND_c_1218_n N_noxref_12_c_1648_n ) capacitor c=2.84067e-19 \
 //x=7.15 //y=0.175 //x2=8.815 //y2=1.675
cc_777 ( N_GND_c_1294_p N_noxref_12_c_1662_n ) capacitor c=0.0100639f //x=9.74 \
 //y=0.18 //x2=9.7 //y2=0.71
cc_778 ( N_GND_c_1164_n N_noxref_12_c_1662_n ) capacitor c=0.0395462f //x=9.74 \
 //y=0.18 //x2=9.7 //y2=0.71
cc_779 ( N_GND_c_1294_p N_noxref_12_c_1664_n ) capacitor c=0.00364623f \
 //x=9.74 //y=0.18 //x2=9.785 //y2=0.795
cc_780 ( N_GND_c_1164_n N_noxref_12_c_1664_n ) capacitor c=0.0582236f //x=9.74 \
 //y=0.18 //x2=9.785 //y2=0.795
cc_781 ( N_GND_c_1145_n N_noxref_12_M4_noxref_s ) capacitor c=0.00724992f \
 //x=8.245 //y=0.175 //x2=7.71 //y2=0.545
cc_782 ( N_GND_c_1191_n N_noxref_12_M4_noxref_s ) capacitor c=0.00997186f \
 //x=8.33 //y=1.135 //x2=7.71 //y2=0.545
cc_783 ( N_GND_c_1202_n N_noxref_12_M4_noxref_s ) capacitor c=0.0173062f \
 //x=8.327 //y=1.005 //x2=7.71 //y2=0.545
cc_784 ( N_GND_c_1355_p N_noxref_12_M4_noxref_s ) capacitor c=0.00396688f \
 //x=6.455 //y=0.625 //x2=7.71 //y2=0.545
cc_785 ( N_GND_c_1164_n N_noxref_12_M4_noxref_s ) capacitor c=0.0227624f \
 //x=9.74 //y=0.18 //x2=7.71 //y2=0.545
cc_786 ( N_GND_c_1218_n N_noxref_12_M4_noxref_s ) capacitor c=0.0527066f \
 //x=7.15 //y=0.175 //x2=7.71 //y2=0.545
cc_787 ( N_GND_M2_noxref_s N_noxref_12_M4_noxref_s ) capacitor c=9.07604e-19 \
 //x=4.38 //y=0.545 //x2=7.71 //y2=0.545
cc_788 ( N_GND_M4_noxref_d N_noxref_12_M4_noxref_s ) capacitor c=0.0271276f \
 //x=8.14 //y=1.045 //x2=7.71 //y2=0.545
cc_789 ( D YN ) capacitor c=0.10901f //x=9 //y=2.4 //x2=9.74 //y2=2.4
cc_790 ( N_D_c_1370_n YN ) capacitor c=0.016905f //x=9 //y=4.735 //x2=9.74 \
 //y2=2.4
cc_791 ( N_D_c_1373_n YN ) capacitor c=0.015397f //x=9 //y=2.26 //x2=9.74 \
 //y2=2.4
cc_792 ( N_D_c_1376_n YN ) capacitor c=0.00440663f //x=9 //y=2.26 //x2=9.74 \
 //y2=2.4
cc_793 ( N_D_c_1380_n YN ) capacitor c=0.00448306f //x=9.03 //y=4.88 //x2=9.74 \
 //y2=2.4
cc_794 ( N_D_c_1407_n YN ) capacitor c=0.00461871f //x=9.405 //y=4.97 \
 //x2=9.74 //y2=2.4
cc_795 ( N_D_c_1396_n YN ) capacitor c=0.00271446f //x=9 //y=2.26 //x2=9.74 \
 //y2=2.4
cc_796 ( N_D_c_1399_n YN ) capacitor c=0.00142201f //x=9.03 //y=4.88 //x2=9.74 \
 //y2=2.4
cc_797 ( N_D_c_1370_n N_YN_c_1468_n ) capacitor c=0.0228479f //x=9 //y=4.735 \
 //x2=9.145 //y2=5.38
cc_798 ( N_D_c_1373_n N_YN_c_1468_n ) capacitor c=2.77624e-19 //x=9 //y=2.26 \
 //x2=9.145 //y2=5.38
cc_799 ( N_D_c_1380_n N_YN_c_1468_n ) capacitor c=0.00469257f //x=9.03 \
 //y=4.88 //x2=9.145 //y2=5.38
cc_800 ( N_D_M16_noxref_g N_YN_c_1468_n ) capacitor c=0.00842859f //x=9.04 \
 //y=6.2 //x2=9.145 //y2=5.38
cc_801 ( N_D_c_1399_n N_YN_c_1468_n ) capacitor c=9.8107e-19 //x=9.03 //y=4.88 \
 //x2=9.145 //y2=5.38
cc_802 ( N_D_c_1389_n N_YN_c_1469_n ) capacitor c=0.00119008f //x=9.035 \
 //y=1.43 //x2=9.3 //y2=1.75
cc_803 ( N_D_c_1391_n N_YN_c_1469_n ) capacitor c=0.00438634f //x=9.035 \
 //y=1.74 //x2=9.3 //y2=1.75
cc_804 ( N_D_c_1430_p N_YN_c_1469_n ) capacitor c=0.00929259f //x=9.41 \
 //y=1.585 //x2=9.3 //y2=1.75
cc_805 ( N_D_c_1395_n N_YN_c_1469_n ) capacitor c=0.00341295f //x=9.565 \
 //y=1.43 //x2=9.3 //y2=1.75
cc_806 ( N_D_c_1432_p N_YN_c_1469_n ) capacitor c=0.00341114f //x=9 //y=2.095 \
 //x2=9.3 //y2=1.75
cc_807 ( N_D_M17_noxref_g N_YN_c_1492_n ) capacitor c=0.0115937f //x=9.48 \
 //y=6.2 //x2=9.655 //y2=5.38
cc_808 ( N_D_c_1430_p N_YN_c_1521_n ) capacitor c=0.00194324f //x=9.41 \
 //y=1.585 //x2=9.655 //y2=1.835
cc_809 ( N_D_c_1395_n N_YN_c_1521_n ) capacitor c=0.00323005f //x=9.565 \
 //y=1.43 //x2=9.655 //y2=1.835
cc_810 ( N_D_M16_noxref_g N_YN_c_1500_n ) capacitor c=0.00192712f //x=9.04 \
 //y=6.2 //x2=9.26 //y2=5.38
cc_811 ( N_D_M17_noxref_g N_YN_c_1500_n ) capacitor c=0.00362563f //x=9.48 \
 //y=6.2 //x2=9.26 //y2=5.38
cc_812 ( N_D_c_1407_n N_YN_c_1500_n ) capacitor c=0.0020909f //x=9.405 \
 //y=4.97 //x2=9.26 //y2=5.38
cc_813 ( N_D_c_1386_n N_YN_c_1480_n ) capacitor c=0.00120406f //x=9.035 \
 //y=1.085 //x2=9.3 //y2=1.18
cc_814 ( N_D_c_1389_n N_YN_c_1480_n ) capacitor c=0.00218668f //x=9.035 \
 //y=1.43 //x2=9.3 //y2=1.18
cc_815 ( N_D_c_1441_p N_YN_c_1480_n ) capacitor c=5.50523e-19 //x=9.41 \
 //y=0.93 //x2=9.3 //y2=1.18
cc_816 ( N_D_c_1430_p N_YN_c_1480_n ) capacitor c=5.67071e-19 //x=9.41 \
 //y=1.585 //x2=9.3 //y2=1.18
cc_817 ( N_D_c_1394_n N_YN_c_1480_n ) capacitor c=0.00121175f //x=9.565 \
 //y=1.085 //x2=9.3 //y2=1.18
cc_818 ( N_D_c_1395_n N_YN_c_1480_n ) capacitor c=0.00366282f //x=9.565 \
 //y=1.43 //x2=9.3 //y2=1.18
cc_819 ( N_D_M16_noxref_g N_YN_c_1515_n ) capacitor c=0.0178987f //x=9.04 \
 //y=6.2 //x2=9.26 //y2=5.56
cc_820 ( N_D_M17_noxref_g N_YN_c_1515_n ) capacitor c=0.0178506f //x=9.48 \
 //y=6.2 //x2=9.26 //y2=5.56
cc_821 ( N_D_c_1407_n N_YN_c_1515_n ) capacitor c=0.00291714f //x=9.405 \
 //y=4.97 //x2=9.26 //y2=5.56
cc_822 ( N_D_c_1386_n N_YN_M5_noxref_d ) capacitor c=0.00137165f //x=9.035 \
 //y=1.085 //x2=9.11 //y2=1.085
cc_823 ( N_D_c_1389_n N_YN_M5_noxref_d ) capacitor c=0.00237422f //x=9.035 \
 //y=1.43 //x2=9.11 //y2=1.085
cc_824 ( N_D_c_1441_p N_YN_M5_noxref_d ) capacitor c=0.0020782f //x=9.41 \
 //y=0.93 //x2=9.11 //y2=1.085
cc_825 ( N_D_c_1430_p N_YN_M5_noxref_d ) capacitor c=0.00356097f //x=9.41 \
 //y=1.585 //x2=9.11 //y2=1.085
cc_826 ( N_D_c_1394_n N_YN_M5_noxref_d ) capacitor c=8.50095e-19 //x=9.565 \
 //y=1.085 //x2=9.11 //y2=1.085
cc_827 ( N_D_c_1395_n N_YN_M5_noxref_d ) capacitor c=0.00237422f //x=9.565 \
 //y=1.43 //x2=9.11 //y2=1.085
cc_828 ( N_D_c_1373_n N_noxref_12_c_1648_n ) capacitor c=7.471e-19 //x=9 \
 //y=2.26 //x2=8.815 //y2=1.675
cc_829 ( N_D_c_1391_n N_noxref_12_c_1648_n ) capacitor c=0.00890678f //x=9.035 \
 //y=1.74 //x2=8.815 //y2=1.675
cc_830 ( N_D_c_1396_n N_noxref_12_c_1648_n ) capacitor c=0.00173073f //x=9 \
 //y=2.26 //x2=8.815 //y2=1.675
cc_831 ( N_D_c_1373_n N_noxref_12_c_1662_n ) capacitor c=0.00141156f //x=9 \
 //y=2.26 //x2=9.7 //y2=0.71
cc_832 ( N_D_c_1376_n N_noxref_12_c_1662_n ) capacitor c=8.82141e-19 //x=9 \
 //y=2.26 //x2=9.7 //y2=0.71
cc_833 ( N_D_c_1386_n N_noxref_12_c_1662_n ) capacitor c=0.0199501f //x=9.035 \
 //y=1.085 //x2=9.7 //y2=0.71
cc_834 ( N_D_c_1394_n N_noxref_12_c_1662_n ) capacitor c=0.00825432f //x=9.565 \
 //y=1.085 //x2=9.7 //y2=0.71
cc_835 ( N_D_c_1396_n N_noxref_12_c_1662_n ) capacitor c=2.1838e-19 //x=9 \
 //y=2.26 //x2=9.7 //y2=0.71
cc_836 ( N_D_c_1386_n N_noxref_12_M4_noxref_s ) capacitor c=0.00890678f \
 //x=9.035 //y=1.085 //x2=7.71 //y2=0.545
cc_837 ( N_D_c_1394_n N_noxref_12_M4_noxref_s ) capacitor c=0.015333f \
 //x=9.565 //y=1.085 //x2=7.71 //y2=0.545
cc_838 ( N_D_c_1395_n N_noxref_12_M4_noxref_s ) capacitor c=0.00248746f \
 //x=9.565 //y=1.43 //x2=7.71 //y2=0.545
cc_839 ( N_YN_c_1471_n N_noxref_12_c_1648_n ) capacitor c=0.00911498f \
 //x=9.385 //y=1.835 //x2=8.815 //y2=1.675
cc_840 ( N_YN_c_1521_n N_noxref_12_c_1662_n ) capacitor c=0.00361884f \
 //x=9.655 //y=1.835 //x2=9.7 //y2=0.71
cc_841 ( N_YN_c_1480_n N_noxref_12_c_1662_n ) capacitor c=0.00367971f //x=9.3 \
 //y=1.18 //x2=9.7 //y2=0.71
cc_842 ( N_YN_M5_noxref_d N_noxref_12_c_1662_n ) capacitor c=0.00910163f \
 //x=9.11 //y=1.085 //x2=9.7 //y2=0.71
cc_843 ( N_YN_c_1469_n N_noxref_12_M4_noxref_s ) capacitor c=0.0175047f \
 //x=9.3 //y=1.75 //x2=7.71 //y2=0.545
cc_844 ( N_YN_c_1521_n N_noxref_12_M4_noxref_s ) capacitor c=0.0078077f \
 //x=9.655 //y=1.835 //x2=7.71 //y2=0.545
cc_845 ( N_YN_c_1480_n N_noxref_12_M4_noxref_s ) capacitor c=0.0104653f \
 //x=9.3 //y=1.18 //x2=7.71 //y2=0.545
cc_846 ( N_YN_M5_noxref_d N_noxref_12_M4_noxref_s ) capacitor c=0.0275552f \
 //x=9.11 //y=1.085 //x2=7.71 //y2=0.545
