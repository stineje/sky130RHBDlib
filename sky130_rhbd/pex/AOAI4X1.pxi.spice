// File: AOAI4X1.spi.AOAI4X1.pxi
// Created: Tue Apr 29 10:38:47 2025
//
simulator lang=spectre
x_PM_AOAI4X1\%GND ( GND N_GND_c_13_p N_GND_c_62_p N_GND_c_1_p N_GND_c_69_p \
 N_GND_c_88_p N_GND_c_5_p N_GND_c_21_p N_GND_c_33_p N_GND_c_36_p N_GND_c_126_p \
 N_GND_c_42_p N_GND_c_4_p N_GND_c_2_p N_GND_c_3_p N_GND_M0_noxref_d \
 N_GND_M2_noxref_s N_GND_M4_noxref_d )  PM_AOAI4X1\%GND
x_PM_AOAI4X1\%VDD ( VDD N_VDD_c_154_p N_VDD_c_136_p N_VDD_c_137_p \
 N_VDD_c_148_p N_VDD_c_151_p N_VDD_c_172_p N_VDD_c_222_p N_VDD_c_131_n \
 N_VDD_c_132_n N_VDD_c_133_n N_VDD_c_134_n N_VDD_M6_noxref_s N_VDD_M7_noxref_d \
 N_VDD_M9_noxref_d N_VDD_M10_noxref_d N_VDD_M14_noxref_s N_VDD_M15_noxref_d \
 N_VDD_M17_noxref_d )  PM_AOAI4X1\%VDD
x_PM_AOAI4X1\%noxref_3 ( N_noxref_3_c_246_n N_noxref_3_c_249_n \
 N_noxref_3_c_269_n N_noxref_3_c_272_n N_noxref_3_c_274_n N_noxref_3_c_250_n \
 N_noxref_3_c_345_p N_noxref_3_c_252_n N_noxref_3_c_254_n N_noxref_3_c_333_p \
 N_noxref_3_c_279_n N_noxref_3_M2_noxref_g N_noxref_3_M10_noxref_g \
 N_noxref_3_M11_noxref_g N_noxref_3_c_257_n N_noxref_3_c_307_p \
 N_noxref_3_c_308_p N_noxref_3_c_259_n N_noxref_3_c_261_n N_noxref_3_c_311_p \
 N_noxref_3_c_354_p N_noxref_3_c_262_n N_noxref_3_c_264_n N_noxref_3_c_286_n \
 N_noxref_3_M1_noxref_d N_noxref_3_M6_noxref_d N_noxref_3_M8_noxref_d )  \
 PM_AOAI4X1\%noxref_3
x_PM_AOAI4X1\%noxref_4 ( N_noxref_4_c_390_n N_noxref_4_c_392_n \
 N_noxref_4_c_394_n N_noxref_4_c_442_n N_noxref_4_c_425_n N_noxref_4_c_427_n \
 N_noxref_4_c_398_n N_noxref_4_c_402_n N_noxref_4_c_404_n \
 N_noxref_4_M4_noxref_g N_noxref_4_M14_noxref_g N_noxref_4_M15_noxref_g \
 N_noxref_4_c_405_n N_noxref_4_c_407_n N_noxref_4_c_408_n N_noxref_4_c_409_n \
 N_noxref_4_c_410_n N_noxref_4_c_411_n N_noxref_4_c_412_n N_noxref_4_c_414_n \
 N_noxref_4_c_436_n N_noxref_4_M2_noxref_d N_noxref_4_M3_noxref_d \
 N_noxref_4_M12_noxref_d )  PM_AOAI4X1\%noxref_4
x_PM_AOAI4X1\%A ( A A A A A A A N_A_c_531_n N_A_M0_noxref_g N_A_M6_noxref_g \
 N_A_M7_noxref_g N_A_c_532_n N_A_c_534_n N_A_c_535_n N_A_c_536_n N_A_c_537_n \
 N_A_c_538_n N_A_c_539_n N_A_c_541_n N_A_c_548_n )  PM_AOAI4X1\%A
x_PM_AOAI4X1\%B ( B B B B B B B N_B_c_595_n N_B_c_586_n N_B_M1_noxref_g \
 N_B_M8_noxref_g N_B_M9_noxref_g N_B_c_604_n N_B_c_605_n N_B_c_606_n \
 N_B_c_607_n N_B_c_609_n N_B_c_610_n N_B_c_612_n N_B_c_613_n N_B_c_615_n \
 N_B_c_616_n N_B_c_618_n )  PM_AOAI4X1\%B
x_PM_AOAI4X1\%noxref_7 ( N_noxref_7_c_674_n N_noxref_7_c_650_n \
 N_noxref_7_c_654_n N_noxref_7_c_658_n N_noxref_7_c_659_n N_noxref_7_c_662_n \
 N_noxref_7_M0_noxref_s )  PM_AOAI4X1\%noxref_7
x_PM_AOAI4X1\%C ( C C C C C C C N_C_c_714_n N_C_c_701_n N_C_M3_noxref_g \
 N_C_M12_noxref_g N_C_M13_noxref_g N_C_c_703_n N_C_c_726_n N_C_c_729_n \
 N_C_c_753_n N_C_c_705_n N_C_c_706_n N_C_c_707_n N_C_c_733_n N_C_c_734_n \
 N_C_c_736_n N_C_c_737_n )  PM_AOAI4X1\%C
x_PM_AOAI4X1\%noxref_9 ( N_noxref_9_c_772_n N_noxref_9_c_776_n \
 N_noxref_9_c_777_n N_noxref_9_c_778_n N_noxref_9_M10_noxref_s \
 N_noxref_9_M11_noxref_d N_noxref_9_M13_noxref_d )  PM_AOAI4X1\%noxref_9
x_PM_AOAI4X1\%D ( D D D D D D D N_D_c_824_n N_D_c_815_n N_D_M5_noxref_g \
 N_D_M16_noxref_g N_D_M17_noxref_g N_D_c_833_n N_D_c_836_n N_D_c_838_n \
 N_D_c_849_p N_D_c_863_p N_D_c_857_p N_D_c_841_n N_D_c_842_n N_D_c_843_n \
 N_D_c_851_p N_D_c_845_n )  PM_AOAI4X1\%D
x_PM_AOAI4X1\%YN ( YN YN YN YN YN YN YN YN N_YN_c_886_n N_YN_c_889_n \
 N_YN_c_891_n N_YN_c_880_n N_YN_c_933_p N_YN_c_922_n N_YN_M5_noxref_d \
 N_YN_M14_noxref_d N_YN_M16_noxref_d )  PM_AOAI4X1\%YN
x_PM_AOAI4X1\%noxref_12 ( N_noxref_12_c_957_n N_noxref_12_c_939_n \
 N_noxref_12_c_943_n N_noxref_12_c_946_n N_noxref_12_c_947_n \
 N_noxref_12_c_949_n N_noxref_12_M4_noxref_s )  PM_AOAI4X1\%noxref_12
cc_1 ( N_GND_c_1_p N_VDD_c_131_n ) capacitor c=0.00989514f //x=1.23 //y=0.18 \
 //x2=1.23 //y2=7.58
cc_2 ( N_GND_c_2_p N_VDD_c_132_n ) capacitor c=0.00963367f //x=3.82 //y=0.175 \
 //x2=3.82 //y2=7.585
cc_3 ( N_GND_c_3_p N_VDD_c_133_n ) capacitor c=0.00963367f //x=7.15 //y=0.175 \
 //x2=7.15 //y2=7.585
cc_4 ( N_GND_c_4_p N_VDD_c_134_n ) capacitor c=0.00989514f //x=9.74 //y=0.18 \
 //x2=9.74 //y2=7.58
cc_5 ( N_GND_c_5_p N_noxref_3_c_246_n ) capacitor c=7.233e-19 //x=4.915 \
 //y=0.71 //x2=4.815 //y2=2.77
cc_6 ( N_GND_c_2_p N_noxref_3_c_246_n ) capacitor c=0.0435449f //x=3.82 \
 //y=0.175 //x2=4.815 //y2=2.77
cc_7 ( N_GND_M2_noxref_s N_noxref_3_c_246_n ) capacitor c=0.00494377f //x=4.38 \
 //y=0.545 //x2=4.815 //y2=2.77
cc_8 ( N_GND_c_2_p N_noxref_3_c_249_n ) capacitor c=0.00102529f //x=3.82 \
 //y=0.175 //x2=3.195 //y2=2.77
cc_9 ( N_GND_c_2_p N_noxref_3_c_250_n ) capacitor c=0.0431271f //x=3.82 \
 //y=0.175 //x2=2.995 //y2=1.835
cc_10 ( N_GND_M2_noxref_s N_noxref_3_c_250_n ) capacitor c=3.00901e-19 \
 //x=4.38 //y=0.545 //x2=2.995 //y2=1.835
cc_11 ( N_GND_c_1_p N_noxref_3_c_252_n ) capacitor c=0.00101801f //x=1.23 \
 //y=0.18 //x2=3.08 //y2=2.77
cc_12 ( N_GND_c_2_p N_noxref_3_c_252_n ) capacitor c=5.56859e-19 //x=3.82 \
 //y=0.175 //x2=3.08 //y2=2.77
cc_13 ( N_GND_c_13_p N_noxref_3_c_254_n ) capacitor c=6.77224e-19 //x=9.74 \
 //y=0.18 //x2=4.93 //y2=2.26
cc_14 ( N_GND_c_5_p N_noxref_3_c_254_n ) capacitor c=0.00133267f //x=4.915 \
 //y=0.71 //x2=4.93 //y2=2.26
cc_15 ( N_GND_c_2_p N_noxref_3_c_254_n ) capacitor c=0.0147015f //x=3.82 \
 //y=0.175 //x2=4.93 //y2=2.26
cc_16 ( N_GND_c_5_p N_noxref_3_c_257_n ) capacitor c=0.0122588f //x=4.915 \
 //y=0.71 //x2=4.735 //y2=1.085
cc_17 ( N_GND_M2_noxref_s N_noxref_3_c_257_n ) capacitor c=0.0318086f //x=4.38 \
 //y=0.545 //x2=4.735 //y2=1.085
cc_18 ( N_GND_c_5_p N_noxref_3_c_259_n ) capacitor c=2.1838e-19 //x=4.915 \
 //y=0.71 //x2=4.735 //y2=2.095
cc_19 ( N_GND_c_2_p N_noxref_3_c_259_n ) capacitor c=0.0131707f //x=3.82 \
 //y=0.175 //x2=4.735 //y2=2.095
cc_20 ( N_GND_M2_noxref_s N_noxref_3_c_261_n ) capacitor c=0.00476604f \
 //x=4.38 //y=0.545 //x2=5.11 //y2=0.93
cc_21 ( N_GND_c_21_p N_noxref_3_c_262_n ) capacitor c=0.0113306f //x=5.4 \
 //y=0.71 //x2=5.265 //y2=1.085
cc_22 ( N_GND_M2_noxref_s N_noxref_3_c_262_n ) capacitor c=0.00514143f \
 //x=4.38 //y=0.545 //x2=5.265 //y2=1.085
cc_23 ( N_GND_M2_noxref_s N_noxref_3_c_264_n ) capacitor c=8.33128e-19 \
 //x=4.38 //y=0.545 //x2=5.265 //y2=1.43
cc_24 ( N_GND_c_1_p N_noxref_3_M1_noxref_d ) capacitor c=8.58106e-19 //x=1.23 \
 //y=0.18 //x2=2.45 //y2=1.085
cc_25 ( N_GND_c_2_p N_noxref_3_M1_noxref_d ) capacitor c=0.00616547f //x=3.82 \
 //y=0.175 //x2=2.45 //y2=1.085
cc_26 ( N_GND_M0_noxref_d N_noxref_3_M1_noxref_d ) capacitor c=0.00143464f \
 //x=1.48 //y=1.045 //x2=2.45 //y2=1.085
cc_27 ( N_GND_c_3_p N_noxref_4_c_390_n ) capacitor c=0.0435449f //x=7.15 \
 //y=0.175 //x2=8.145 //y2=2.77
cc_28 ( N_GND_M2_noxref_s N_noxref_4_c_390_n ) capacitor c=3.07352e-19 \
 //x=4.38 //y=0.545 //x2=8.145 //y2=2.77
cc_29 ( N_GND_c_3_p N_noxref_4_c_392_n ) capacitor c=0.00102529f //x=7.15 \
 //y=0.175 //x2=6.525 //y2=2.77
cc_30 ( N_GND_M2_noxref_s N_noxref_4_c_392_n ) capacitor c=0.00162167f \
 //x=4.38 //y=0.545 //x2=6.525 //y2=2.77
cc_31 ( N_GND_c_13_p N_noxref_4_c_394_n ) capacitor c=0.00359332f //x=9.74 \
 //y=0.18 //x2=5.885 //y2=1.835
cc_32 ( N_GND_c_21_p N_noxref_4_c_394_n ) capacitor c=0.00381844f //x=5.4 \
 //y=0.71 //x2=5.885 //y2=1.835
cc_33 ( N_GND_c_33_p N_noxref_4_c_394_n ) capacitor c=0.00323369f //x=5.885 \
 //y=0.71 //x2=5.885 //y2=1.835
cc_34 ( N_GND_M2_noxref_s N_noxref_4_c_394_n ) capacitor c=0.0173696f //x=4.38 \
 //y=0.545 //x2=5.885 //y2=1.835
cc_35 ( N_GND_c_13_p N_noxref_4_c_398_n ) capacitor c=0.00233035f //x=9.74 \
 //y=0.18 //x2=6.325 //y2=1.835
cc_36 ( N_GND_c_36_p N_noxref_4_c_398_n ) capacitor c=0.00479063f //x=6.37 \
 //y=0.71 //x2=6.325 //y2=1.835
cc_37 ( N_GND_c_3_p N_noxref_4_c_398_n ) capacitor c=0.04345f //x=7.15 \
 //y=0.175 //x2=6.325 //y2=1.835
cc_38 ( N_GND_M2_noxref_s N_noxref_4_c_398_n ) capacitor c=0.0145664f //x=4.38 \
 //y=0.545 //x2=6.325 //y2=1.835
cc_39 ( N_GND_c_2_p N_noxref_4_c_402_n ) capacitor c=9.64732e-19 //x=3.82 \
 //y=0.175 //x2=6.41 //y2=2.77
cc_40 ( N_GND_c_3_p N_noxref_4_c_402_n ) capacitor c=5.56859e-19 //x=7.15 \
 //y=0.175 //x2=6.41 //y2=2.77
cc_41 ( N_GND_c_3_p N_noxref_4_c_404_n ) capacitor c=0.0150626f //x=7.15 \
 //y=0.175 //x2=8.26 //y2=2.26
cc_42 ( N_GND_c_42_p N_noxref_4_c_405_n ) capacitor c=0.00135783f //x=8.245 \
 //y=0.175 //x2=8.065 //y2=1.045
cc_43 ( N_GND_M4_noxref_d N_noxref_4_c_405_n ) capacitor c=0.00220047f \
 //x=8.14 //y=1.045 //x2=8.065 //y2=1.045
cc_44 ( N_GND_M4_noxref_d N_noxref_4_c_407_n ) capacitor c=0.00255985f \
 //x=8.14 //y=1.045 //x2=8.065 //y2=1.39
cc_45 ( N_GND_c_3_p N_noxref_4_c_408_n ) capacitor c=0.0018059f //x=7.15 \
 //y=0.175 //x2=8.065 //y2=1.7
cc_46 ( N_GND_c_3_p N_noxref_4_c_409_n ) capacitor c=0.0114883f //x=7.15 \
 //y=0.175 //x2=8.065 //y2=2.095
cc_47 ( N_GND_M4_noxref_d N_noxref_4_c_410_n ) capacitor c=0.0131374f //x=8.14 \
 //y=1.045 //x2=8.44 //y2=0.89
cc_48 ( N_GND_M4_noxref_d N_noxref_4_c_411_n ) capacitor c=0.00193146f \
 //x=8.14 //y=1.045 //x2=8.44 //y2=1.545
cc_49 ( N_GND_c_4_p N_noxref_4_c_412_n ) capacitor c=0.00131234f //x=9.74 \
 //y=0.18 //x2=8.595 //y2=1.045
cc_50 ( N_GND_M4_noxref_d N_noxref_4_c_412_n ) capacitor c=0.00257848f \
 //x=8.14 //y=1.045 //x2=8.595 //y2=1.045
cc_51 ( N_GND_M4_noxref_d N_noxref_4_c_414_n ) capacitor c=0.00255985f \
 //x=8.14 //y=1.045 //x2=8.595 //y2=1.39
cc_52 ( N_GND_c_13_p N_noxref_4_M2_noxref_d ) capacitor c=0.00175671f //x=9.74 \
 //y=0.18 //x2=4.81 //y2=1.085
cc_53 ( N_GND_c_4_p N_noxref_4_M2_noxref_d ) capacitor c=2.31043e-19 //x=9.74 \
 //y=0.18 //x2=4.81 //y2=1.085
cc_54 ( N_GND_c_2_p N_noxref_4_M2_noxref_d ) capacitor c=0.00416273f //x=3.82 \
 //y=0.175 //x2=4.81 //y2=1.085
cc_55 ( N_GND_c_3_p N_noxref_4_M2_noxref_d ) capacitor c=2.57516e-19 //x=7.15 \
 //y=0.175 //x2=4.81 //y2=1.085
cc_56 ( N_GND_M2_noxref_s N_noxref_4_M2_noxref_d ) capacitor c=0.0769615f \
 //x=4.38 //y=0.545 //x2=4.81 //y2=1.085
cc_57 ( N_GND_c_13_p N_noxref_4_M3_noxref_d ) capacitor c=0.00195238f //x=9.74 \
 //y=0.18 //x2=5.78 //y2=1.085
cc_58 ( N_GND_c_4_p N_noxref_4_M3_noxref_d ) capacitor c=2.31043e-19 //x=9.74 \
 //y=0.18 //x2=5.78 //y2=1.085
cc_59 ( N_GND_c_3_p N_noxref_4_M3_noxref_d ) capacitor c=0.00609243f //x=7.15 \
 //y=0.175 //x2=5.78 //y2=1.085
cc_60 ( N_GND_M2_noxref_s N_noxref_4_M3_noxref_d ) capacitor c=0.061033f \
 //x=4.38 //y=0.545 //x2=5.78 //y2=1.085
cc_61 ( N_GND_c_1_p N_A_c_531_n ) capacitor c=0.0180518f //x=1.23 //y=0.18 \
 //x2=1.6 //y2=2.26
cc_62 ( N_GND_c_62_p N_A_c_532_n ) capacitor c=0.00135783f //x=1.585 //y=0.175 \
 //x2=1.405 //y2=1.045
cc_63 ( N_GND_M0_noxref_d N_A_c_532_n ) capacitor c=0.00220047f //x=1.48 \
 //y=1.045 //x2=1.405 //y2=1.045
cc_64 ( N_GND_M0_noxref_d N_A_c_534_n ) capacitor c=0.00255985f //x=1.48 \
 //y=1.045 //x2=1.405 //y2=1.39
cc_65 ( N_GND_c_1_p N_A_c_535_n ) capacitor c=0.00264481f //x=1.23 //y=0.18 \
 //x2=1.405 //y2=1.7
cc_66 ( N_GND_c_1_p N_A_c_536_n ) capacitor c=0.0121947f //x=1.23 //y=0.18 \
 //x2=1.405 //y2=2.095
cc_67 ( N_GND_M0_noxref_d N_A_c_537_n ) capacitor c=0.0131374f //x=1.48 \
 //y=1.045 //x2=1.78 //y2=0.89
cc_68 ( N_GND_M0_noxref_d N_A_c_538_n ) capacitor c=0.00193146f //x=1.48 \
 //y=1.045 //x2=1.78 //y2=1.545
cc_69 ( N_GND_c_69_p N_A_c_539_n ) capacitor c=0.00131234f //x=3.65 //y=0.175 \
 //x2=1.935 //y2=1.045
cc_70 ( N_GND_M0_noxref_d N_A_c_539_n ) capacitor c=0.00257848f //x=1.48 \
 //y=1.045 //x2=1.935 //y2=1.045
cc_71 ( N_GND_M0_noxref_d N_A_c_541_n ) capacitor c=0.00255985f //x=1.48 \
 //y=1.045 //x2=1.935 //y2=1.39
cc_72 ( N_GND_c_1_p N_B_c_586_n ) capacitor c=9.2064e-19 //x=1.23 //y=0.18 \
 //x2=2.34 //y2=2.26
cc_73 ( N_GND_c_2_p N_B_c_586_n ) capacitor c=0.00110071f //x=3.82 //y=0.175 \
 //x2=2.34 //y2=2.26
cc_74 ( N_GND_c_13_p N_noxref_7_c_650_n ) capacitor c=0.00711001f //x=9.74 \
 //y=0.18 //x2=2.07 //y2=1.76
cc_75 ( N_GND_c_62_p N_noxref_7_c_650_n ) capacitor c=0.00111556f //x=1.585 \
 //y=0.175 //x2=2.07 //y2=1.76
cc_76 ( N_GND_c_69_p N_noxref_7_c_650_n ) capacitor c=0.00181083f //x=3.65 \
 //y=0.175 //x2=2.07 //y2=1.76
cc_77 ( N_GND_M0_noxref_d N_noxref_7_c_650_n ) capacitor c=0.00909955f \
 //x=1.48 //y=1.045 //x2=2.07 //y2=1.76
cc_78 ( N_GND_c_13_p N_noxref_7_c_654_n ) capacitor c=0.00724992f //x=9.74 \
 //y=0.18 //x2=2.155 //y2=0.795
cc_79 ( N_GND_c_69_p N_noxref_7_c_654_n ) capacitor c=0.014661f //x=3.65 \
 //y=0.175 //x2=2.155 //y2=0.795
cc_80 ( N_GND_c_4_p N_noxref_7_c_654_n ) capacitor c=0.00145873f //x=9.74 \
 //y=0.18 //x2=2.155 //y2=0.795
cc_81 ( N_GND_M0_noxref_d N_noxref_7_c_654_n ) capacitor c=0.033812f //x=1.48 \
 //y=1.045 //x2=2.155 //y2=0.795
cc_82 ( N_GND_c_1_p N_noxref_7_c_658_n ) capacitor c=2.91423e-19 //x=1.23 \
 //y=0.18 //x2=2.155 //y2=1.675
cc_83 ( N_GND_c_13_p N_noxref_7_c_659_n ) capacitor c=0.0199827f //x=9.74 \
 //y=0.18 //x2=3.04 //y2=0.71
cc_84 ( N_GND_c_69_p N_noxref_7_c_659_n ) capacitor c=0.0371502f //x=3.65 \
 //y=0.175 //x2=3.04 //y2=0.71
cc_85 ( N_GND_c_4_p N_noxref_7_c_659_n ) capacitor c=0.00198596f //x=9.74 \
 //y=0.18 //x2=3.04 //y2=0.71
cc_86 ( N_GND_c_13_p N_noxref_7_c_662_n ) capacitor c=0.00720883f //x=9.74 \
 //y=0.18 //x2=3.125 //y2=0.795
cc_87 ( N_GND_c_69_p N_noxref_7_c_662_n ) capacitor c=0.0144635f //x=3.65 \
 //y=0.175 //x2=3.125 //y2=0.795
cc_88 ( N_GND_c_88_p N_noxref_7_c_662_n ) capacitor c=9.02073e-19 //x=4.515 \
 //y=0.625 //x2=3.125 //y2=0.795
cc_89 ( N_GND_c_4_p N_noxref_7_c_662_n ) capacitor c=0.00145015f //x=9.74 \
 //y=0.18 //x2=3.125 //y2=0.795
cc_90 ( N_GND_c_2_p N_noxref_7_c_662_n ) capacitor c=0.0431718f //x=3.82 \
 //y=0.175 //x2=3.125 //y2=0.795
cc_91 ( N_GND_c_13_p N_noxref_7_M0_noxref_s ) capacitor c=0.00724992f //x=9.74 \
 //y=0.18 //x2=1.05 //y2=0.545
cc_92 ( N_GND_c_62_p N_noxref_7_M0_noxref_s ) capacitor c=0.014661f //x=1.585 \
 //y=0.175 //x2=1.05 //y2=0.545
cc_93 ( N_GND_c_1_p N_noxref_7_M0_noxref_s ) capacitor c=0.0594057f //x=1.23 \
 //y=0.18 //x2=1.05 //y2=0.545
cc_94 ( N_GND_c_4_p N_noxref_7_M0_noxref_s ) capacitor c=0.00145873f //x=9.74 \
 //y=0.18 //x2=1.05 //y2=0.545
cc_95 ( N_GND_c_2_p N_noxref_7_M0_noxref_s ) capacitor c=0.00198043f //x=3.82 \
 //y=0.175 //x2=1.05 //y2=0.545
cc_96 ( N_GND_M0_noxref_d N_noxref_7_M0_noxref_s ) capacitor c=0.0334197f \
 //x=1.48 //y=1.045 //x2=1.05 //y2=0.545
cc_97 ( N_GND_M2_noxref_s N_noxref_7_M0_noxref_s ) capacitor c=9.02073e-19 \
 //x=4.38 //y=0.545 //x2=1.05 //y2=0.545
cc_98 ( N_GND_c_2_p N_C_c_701_n ) capacitor c=0.00112835f //x=3.82 //y=0.175 \
 //x2=5.67 //y2=2.26
cc_99 ( N_GND_c_3_p N_C_c_701_n ) capacitor c=0.00110071f //x=7.15 //y=0.175 \
 //x2=5.67 //y2=2.26
cc_100 ( N_GND_c_33_p N_C_c_703_n ) capacitor c=0.0109831f //x=5.885 //y=0.71 \
 //x2=5.705 //y2=1.085
cc_101 ( N_GND_M2_noxref_s N_C_c_703_n ) capacitor c=0.00590563f //x=4.38 \
 //y=0.545 //x2=5.705 //y2=1.085
cc_102 ( N_GND_M2_noxref_s N_C_c_705_n ) capacitor c=0.00467042f //x=4.38 \
 //y=0.545 //x2=6.08 //y2=0.93
cc_103 ( N_GND_M2_noxref_s N_C_c_706_n ) capacitor c=0.00316186f //x=4.38 \
 //y=0.545 //x2=6.08 //y2=1.585
cc_104 ( N_GND_c_36_p N_C_c_707_n ) capacitor c=0.011235f //x=6.37 //y=0.71 \
 //x2=6.235 //y2=1.085
cc_105 ( N_GND_M2_noxref_s N_C_c_707_n ) capacitor c=0.0142835f //x=4.38 \
 //y=0.545 //x2=6.235 //y2=1.085
cc_106 ( N_GND_c_4_p N_D_c_815_n ) capacitor c=9.53263e-19 //x=9.74 //y=0.18 \
 //x2=9 //y2=2.26
cc_107 ( N_GND_c_3_p N_D_c_815_n ) capacitor c=0.00112835f //x=7.15 //y=0.175 \
 //x2=9 //y2=2.26
cc_108 ( N_GND_c_3_p YN ) capacitor c=9.64732e-19 //x=7.15 //y=0.175 //x2=9.74 \
 //y2=2.4
cc_109 ( N_GND_c_4_p N_YN_c_880_n ) capacitor c=0.0468439f //x=9.74 //y=0.18 \
 //x2=9.655 //y2=1.835
cc_110 ( N_GND_c_4_p N_YN_M5_noxref_d ) capacitor c=0.00618259f //x=9.74 \
 //y=0.18 //x2=9.11 //y2=1.085
cc_111 ( N_GND_c_3_p N_YN_M5_noxref_d ) capacitor c=8.58106e-19 //x=7.15 \
 //y=0.175 //x2=9.11 //y2=1.085
cc_112 ( N_GND_M4_noxref_d N_YN_M5_noxref_d ) capacitor c=0.00143464f //x=8.14 \
 //y=1.045 //x2=9.11 //y2=1.085
cc_113 ( N_GND_c_13_p N_noxref_12_c_939_n ) capacitor c=0.00708133f //x=9.74 \
 //y=0.18 //x2=8.73 //y2=1.76
cc_114 ( N_GND_c_42_p N_noxref_12_c_939_n ) capacitor c=0.00111556f //x=8.245 \
 //y=0.175 //x2=8.73 //y2=1.76
cc_115 ( N_GND_c_4_p N_noxref_12_c_939_n ) capacitor c=0.00181083f //x=9.74 \
 //y=0.18 //x2=8.73 //y2=1.76
cc_116 ( N_GND_M4_noxref_d N_noxref_12_c_939_n ) capacitor c=0.00881064f \
 //x=8.14 //y=1.045 //x2=8.73 //y2=1.76
cc_117 ( N_GND_c_13_p N_noxref_12_c_943_n ) capacitor c=0.00724992f //x=9.74 \
 //y=0.18 //x2=8.815 //y2=0.795
cc_118 ( N_GND_c_4_p N_noxref_12_c_943_n ) capacitor c=0.0161197f //x=9.74 \
 //y=0.18 //x2=8.815 //y2=0.795
cc_119 ( N_GND_M4_noxref_d N_noxref_12_c_943_n ) capacitor c=0.033812f \
 //x=8.14 //y=1.045 //x2=8.815 //y2=0.795
cc_120 ( N_GND_c_3_p N_noxref_12_c_946_n ) capacitor c=2.91423e-19 //x=7.15 \
 //y=0.175 //x2=8.815 //y2=1.675
cc_121 ( N_GND_c_13_p N_noxref_12_c_947_n ) capacitor c=0.0199827f //x=9.74 \
 //y=0.18 //x2=9.7 //y2=0.71
cc_122 ( N_GND_c_4_p N_noxref_12_c_947_n ) capacitor c=0.0391361f //x=9.74 \
 //y=0.18 //x2=9.7 //y2=0.71
cc_123 ( N_GND_c_13_p N_noxref_12_c_949_n ) capacitor c=0.00720883f //x=9.74 \
 //y=0.18 //x2=9.785 //y2=0.795
cc_124 ( N_GND_c_4_p N_noxref_12_c_949_n ) capacitor c=0.0598951f //x=9.74 \
 //y=0.18 //x2=9.785 //y2=0.795
cc_125 ( N_GND_c_13_p N_noxref_12_M4_noxref_s ) capacitor c=0.00724992f \
 //x=9.74 //y=0.18 //x2=7.71 //y2=0.545
cc_126 ( N_GND_c_126_p N_noxref_12_M4_noxref_s ) capacitor c=0.00177507f \
 //x=6.455 //y=0.625 //x2=7.71 //y2=0.545
cc_127 ( N_GND_c_42_p N_noxref_12_M4_noxref_s ) capacitor c=0.014661f \
 //x=8.245 //y=0.175 //x2=7.71 //y2=0.545
cc_128 ( N_GND_c_4_p N_noxref_12_M4_noxref_s ) capacitor c=0.00344356f \
 //x=9.74 //y=0.18 //x2=7.71 //y2=0.545
cc_129 ( N_GND_c_3_p N_noxref_12_M4_noxref_s ) capacitor c=0.058339f //x=7.15 \
 //y=0.175 //x2=7.71 //y2=0.545
cc_130 ( N_GND_M4_noxref_d N_noxref_12_M4_noxref_s ) capacitor c=0.0334197f \
 //x=8.14 //y=1.045 //x2=7.71 //y2=0.545
cc_131 ( N_VDD_c_132_n N_noxref_3_c_246_n ) capacitor c=0.00382819f //x=3.82 \
 //y=7.585 //x2=4.815 //y2=2.77
cc_132 ( N_VDD_c_136_p N_noxref_3_c_269_n ) capacitor c=5.7743e-19 //x=2.075 \
 //y=7.585 //x2=2.515 //y2=5.38
cc_133 ( N_VDD_c_137_p N_noxref_3_c_269_n ) capacitor c=5.7743e-19 //x=2.955 \
 //y=7.585 //x2=2.515 //y2=5.38
cc_134 ( N_VDD_M7_noxref_d N_noxref_3_c_269_n ) capacitor c=0.0132783f \
 //x=2.015 //y=5.2 //x2=2.515 //y2=5.38
cc_135 ( N_VDD_c_131_n N_noxref_3_c_272_n ) capacitor c=0.00989999f //x=1.23 \
 //y=7.58 //x2=1.805 //y2=5.38
cc_136 ( N_VDD_M6_noxref_s N_noxref_3_c_272_n ) capacitor c=0.087833f \
 //x=1.145 //y=5.2 //x2=1.805 //y2=5.38
cc_137 ( N_VDD_c_137_p N_noxref_3_c_274_n ) capacitor c=8.72934e-19 //x=2.955 \
 //y=7.585 //x2=2.995 //y2=5.38
cc_138 ( N_VDD_M9_noxref_d N_noxref_3_c_274_n ) capacitor c=0.0167847f \
 //x=2.895 //y=5.2 //x2=2.995 //y2=5.38
cc_139 ( N_VDD_c_131_n N_noxref_3_c_252_n ) capacitor c=0.00159771f //x=1.23 \
 //y=7.58 //x2=3.08 //y2=2.77
cc_140 ( N_VDD_c_132_n N_noxref_3_c_252_n ) capacitor c=0.0462672f //x=3.82 \
 //y=7.585 //x2=3.08 //y2=2.77
cc_141 ( N_VDD_c_132_n N_noxref_3_c_254_n ) capacitor c=0.0103855f //x=3.82 \
 //y=7.585 //x2=4.93 //y2=2.26
cc_142 ( N_VDD_c_132_n N_noxref_3_c_279_n ) capacitor c=0.00860173f //x=3.82 \
 //y=7.585 //x2=4.775 //y2=4.885
cc_143 ( N_VDD_M10_noxref_d N_noxref_3_c_279_n ) capacitor c=2.85066e-19 \
 //x=4.905 //y=5.205 //x2=4.775 //y2=4.885
cc_144 ( N_VDD_c_148_p N_noxref_3_M10_noxref_g ) capacitor c=0.00683851f \
 //x=4.965 //y=7.585 //x2=4.83 //y2=6.205
cc_145 ( N_VDD_c_132_n N_noxref_3_M10_noxref_g ) capacitor c=0.0105272f \
 //x=3.82 //y=7.585 //x2=4.83 //y2=6.205
cc_146 ( N_VDD_M10_noxref_d N_noxref_3_M10_noxref_g ) capacitor c=0.0156786f \
 //x=4.905 //y=5.205 //x2=4.83 //y2=6.205
cc_147 ( N_VDD_c_151_p N_noxref_3_M11_noxref_g ) capacitor c=0.0068279f \
 //x=6.98 //y=7.585 //x2=5.27 //y2=6.205
cc_148 ( N_VDD_M10_noxref_d N_noxref_3_M11_noxref_g ) capacitor c=0.0183011f \
 //x=4.905 //y=5.205 //x2=5.27 //y2=6.205
cc_149 ( N_VDD_c_132_n N_noxref_3_c_286_n ) capacitor c=0.00890932f //x=3.82 \
 //y=7.585 //x2=4.775 //y2=4.885
cc_150 ( N_VDD_c_154_p N_noxref_3_M6_noxref_d ) capacitor c=0.00720906f \
 //x=9.74 //y=7.58 //x2=1.575 //y2=5.2
cc_151 ( N_VDD_c_136_p N_noxref_3_M6_noxref_d ) capacitor c=0.0138506f \
 //x=2.075 //y=7.585 //x2=1.575 //y2=5.2
cc_152 ( N_VDD_c_132_n N_noxref_3_M6_noxref_d ) capacitor c=6.94454e-19 \
 //x=3.82 //y=7.585 //x2=1.575 //y2=5.2
cc_153 ( N_VDD_c_134_n N_noxref_3_M6_noxref_d ) capacitor c=0.00135231f \
 //x=9.74 //y=7.58 //x2=1.575 //y2=5.2
cc_154 ( N_VDD_M7_noxref_d N_noxref_3_M6_noxref_d ) capacitor c=0.0664752f \
 //x=2.015 //y=5.2 //x2=1.575 //y2=5.2
cc_155 ( N_VDD_c_154_p N_noxref_3_M8_noxref_d ) capacitor c=0.00720906f \
 //x=9.74 //y=7.58 //x2=2.455 //y2=5.2
cc_156 ( N_VDD_c_137_p N_noxref_3_M8_noxref_d ) capacitor c=0.0138783f \
 //x=2.955 //y=7.585 //x2=2.455 //y2=5.2
cc_157 ( N_VDD_c_132_n N_noxref_3_M8_noxref_d ) capacitor c=0.0120541f \
 //x=3.82 //y=7.585 //x2=2.455 //y2=5.2
cc_158 ( N_VDD_c_134_n N_noxref_3_M8_noxref_d ) capacitor c=0.00135231f \
 //x=9.74 //y=7.58 //x2=2.455 //y2=5.2
cc_159 ( N_VDD_M6_noxref_s N_noxref_3_M8_noxref_d ) capacitor c=0.00111971f \
 //x=1.145 //y=5.2 //x2=2.455 //y2=5.2
cc_160 ( N_VDD_M7_noxref_d N_noxref_3_M8_noxref_d ) capacitor c=0.0664752f \
 //x=2.015 //y=5.2 //x2=2.455 //y2=5.2
cc_161 ( N_VDD_M9_noxref_d N_noxref_3_M8_noxref_d ) capacitor c=0.0664752f \
 //x=2.895 //y=5.2 //x2=2.455 //y2=5.2
cc_162 ( N_VDD_c_133_n N_noxref_4_c_390_n ) capacitor c=0.00382819f //x=7.15 \
 //y=7.585 //x2=8.145 //y2=2.77
cc_163 ( N_VDD_c_151_p N_noxref_4_c_425_n ) capacitor c=9.662e-19 //x=6.98 \
 //y=7.585 //x2=6.325 //y2=5.39
cc_164 ( N_VDD_M14_noxref_s N_noxref_4_c_425_n ) capacitor c=2.47894e-19 \
 //x=7.805 //y=5.2 //x2=6.325 //y2=5.39
cc_165 ( N_VDD_c_132_n N_noxref_4_c_427_n ) capacitor c=8.9933e-19 //x=3.82 \
 //y=7.585 //x2=6.015 //y2=5.39
cc_166 ( N_VDD_c_132_n N_noxref_4_c_402_n ) capacitor c=0.00155409f //x=3.82 \
 //y=7.585 //x2=6.41 //y2=2.77
cc_167 ( N_VDD_c_133_n N_noxref_4_c_402_n ) capacitor c=0.0462858f //x=7.15 \
 //y=7.585 //x2=6.41 //y2=2.77
cc_168 ( N_VDD_c_172_p N_noxref_4_c_404_n ) capacitor c=3.98531e-19 //x=8.735 \
 //y=7.585 //x2=8.26 //y2=2.26
cc_169 ( N_VDD_c_133_n N_noxref_4_c_404_n ) capacitor c=0.0167437f //x=7.15 \
 //y=7.585 //x2=8.26 //y2=2.26
cc_170 ( N_VDD_c_172_p N_noxref_4_M14_noxref_g ) capacitor c=0.00732332f \
 //x=8.735 //y=7.585 //x2=8.16 //y2=6.2
cc_171 ( N_VDD_M14_noxref_s N_noxref_4_M14_noxref_g ) capacitor c=0.054195f \
 //x=7.805 //y=5.2 //x2=8.16 //y2=6.2
cc_172 ( N_VDD_c_172_p N_noxref_4_M15_noxref_g ) capacitor c=0.00677553f \
 //x=8.735 //y=7.585 //x2=8.6 //y2=6.2
cc_173 ( N_VDD_M15_noxref_d N_noxref_4_M15_noxref_g ) capacitor c=0.015318f \
 //x=8.675 //y=5.2 //x2=8.6 //y2=6.2
cc_174 ( N_VDD_c_133_n N_noxref_4_c_436_n ) capacitor c=0.0162221f //x=7.15 \
 //y=7.585 //x2=8.26 //y2=4.88
cc_175 ( N_VDD_c_133_n N_noxref_4_M12_noxref_d ) capacitor c=0.00966019f \
 //x=7.15 //y=7.585 //x2=5.785 //y2=5.205
cc_176 ( N_VDD_M10_noxref_d N_noxref_4_M12_noxref_d ) capacitor c=0.00561178f \
 //x=4.905 //y=5.205 //x2=5.785 //y2=5.205
cc_177 ( N_VDD_M14_noxref_s N_noxref_4_M12_noxref_d ) capacitor c=4.37644e-19 \
 //x=7.805 //y=5.2 //x2=5.785 //y2=5.205
cc_178 ( N_VDD_c_136_p N_A_c_531_n ) capacitor c=3.98531e-19 //x=2.075 \
 //y=7.585 //x2=1.6 //y2=2.26
cc_179 ( N_VDD_c_131_n N_A_c_531_n ) capacitor c=0.016845f //x=1.23 //y=7.58 \
 //x2=1.6 //y2=2.26
cc_180 ( N_VDD_c_136_p N_A_M6_noxref_g ) capacitor c=0.00732332f //x=2.075 \
 //y=7.585 //x2=1.5 //y2=6.2
cc_181 ( N_VDD_M6_noxref_s N_A_M6_noxref_g ) capacitor c=0.054195f //x=1.145 \
 //y=5.2 //x2=1.5 //y2=6.2
cc_182 ( N_VDD_c_136_p N_A_M7_noxref_g ) capacitor c=0.00677553f //x=2.075 \
 //y=7.585 //x2=1.94 //y2=6.2
cc_183 ( N_VDD_M7_noxref_d N_A_M7_noxref_g ) capacitor c=0.015318f //x=2.015 \
 //y=5.2 //x2=1.94 //y2=6.2
cc_184 ( N_VDD_c_131_n N_A_c_548_n ) capacitor c=0.0292267f //x=1.23 //y=7.58 \
 //x2=1.6 //y2=4.88
cc_185 ( N_VDD_c_131_n N_B_c_586_n ) capacitor c=6.61004e-19 //x=1.23 //y=7.58 \
 //x2=2.34 //y2=2.26
cc_186 ( N_VDD_c_132_n N_B_c_586_n ) capacitor c=6.09526e-19 //x=3.82 \
 //y=7.585 //x2=2.34 //y2=2.26
cc_187 ( N_VDD_c_137_p N_B_M8_noxref_g ) capacitor c=0.00678607f //x=2.955 \
 //y=7.585 //x2=2.38 //y2=6.2
cc_188 ( N_VDD_M7_noxref_d N_B_M8_noxref_g ) capacitor c=0.015318f //x=2.015 \
 //y=5.2 //x2=2.38 //y2=6.2
cc_189 ( N_VDD_c_137_p N_B_M9_noxref_g ) capacitor c=0.00677553f //x=2.955 \
 //y=7.585 //x2=2.82 //y2=6.2
cc_190 ( N_VDD_c_132_n N_B_M9_noxref_g ) capacitor c=0.00954586f //x=3.82 \
 //y=7.585 //x2=2.82 //y2=6.2
cc_191 ( N_VDD_M9_noxref_d N_B_M9_noxref_g ) capacitor c=0.0430452f //x=2.895 \
 //y=5.2 //x2=2.82 //y2=6.2
cc_192 ( N_VDD_c_132_n N_C_c_701_n ) capacitor c=7.02327e-19 //x=3.82 \
 //y=7.585 //x2=5.67 //y2=2.26
cc_193 ( N_VDD_c_133_n N_C_c_701_n ) capacitor c=6.16704e-19 //x=7.15 \
 //y=7.585 //x2=5.67 //y2=2.26
cc_194 ( N_VDD_c_151_p N_C_M12_noxref_g ) capacitor c=0.00516984f //x=6.98 \
 //y=7.585 //x2=5.71 //y2=6.205
cc_195 ( N_VDD_c_151_p N_C_M13_noxref_g ) capacitor c=0.00515938f //x=6.98 \
 //y=7.585 //x2=6.15 //y2=6.205
cc_196 ( N_VDD_c_133_n N_C_M13_noxref_g ) capacitor c=0.0116195f //x=7.15 \
 //y=7.585 //x2=6.15 //y2=6.205
cc_197 ( N_VDD_c_148_p N_noxref_9_c_772_n ) capacitor c=5.82208e-19 //x=4.965 \
 //y=7.585 //x2=5.405 //y2=5.39
cc_198 ( N_VDD_c_151_p N_noxref_9_c_772_n ) capacitor c=5.82208e-19 //x=6.98 \
 //y=7.585 //x2=5.405 //y2=5.39
cc_199 ( N_VDD_c_133_n N_noxref_9_c_772_n ) capacitor c=0.00289291f //x=7.15 \
 //y=7.585 //x2=5.405 //y2=5.39
cc_200 ( N_VDD_M10_noxref_d N_noxref_9_c_772_n ) capacitor c=0.013244f \
 //x=4.905 //y=5.205 //x2=5.405 //y2=5.39
cc_201 ( N_VDD_c_132_n N_noxref_9_c_776_n ) capacitor c=0.0669114f //x=3.82 \
 //y=7.585 //x2=4.695 //y2=5.39
cc_202 ( N_VDD_c_134_n N_noxref_9_c_777_n ) capacitor c=0.00359496f //x=9.74 \
 //y=7.58 //x2=6.285 //y2=7.09
cc_203 ( N_VDD_c_154_p N_noxref_9_c_778_n ) capacitor c=0.0370795f //x=9.74 \
 //y=7.58 //x2=5.575 //y2=7.09
cc_204 ( N_VDD_c_151_p N_noxref_9_c_778_n ) capacitor c=0.0587731f //x=6.98 \
 //y=7.585 //x2=5.575 //y2=7.09
cc_205 ( N_VDD_c_134_n N_noxref_9_c_778_n ) capacitor c=0.00118659f //x=9.74 \
 //y=7.58 //x2=5.575 //y2=7.09
cc_206 ( N_VDD_c_154_p N_noxref_9_M10_noxref_s ) capacitor c=0.00727771f \
 //x=9.74 //y=7.58 //x2=4.475 //y2=5.205
cc_207 ( N_VDD_c_148_p N_noxref_9_M10_noxref_s ) capacitor c=0.0141529f \
 //x=4.965 //y=7.585 //x2=4.475 //y2=5.205
cc_208 ( N_VDD_c_134_n N_noxref_9_M10_noxref_s ) capacitor c=0.00138926f \
 //x=9.74 //y=7.58 //x2=4.475 //y2=5.205
cc_209 ( N_VDD_M9_noxref_d N_noxref_9_M10_noxref_s ) capacitor c=0.00196306f \
 //x=2.895 //y=5.2 //x2=4.475 //y2=5.205
cc_210 ( N_VDD_M10_noxref_d N_noxref_9_M10_noxref_s ) capacitor c=0.0667021f \
 //x=4.905 //y=5.205 //x2=4.475 //y2=5.205
cc_211 ( N_VDD_c_132_n N_noxref_9_M11_noxref_d ) capacitor c=8.88629e-19 \
 //x=3.82 //y=7.585 //x2=5.345 //y2=5.205
cc_212 ( N_VDD_M10_noxref_d N_noxref_9_M11_noxref_d ) capacitor c=0.0659925f \
 //x=4.905 //y=5.205 //x2=5.345 //y2=5.205
cc_213 ( N_VDD_c_133_n N_noxref_9_M13_noxref_d ) capacitor c=0.0520312f \
 //x=7.15 //y=7.585 //x2=6.225 //y2=5.205
cc_214 ( N_VDD_M10_noxref_d N_noxref_9_M13_noxref_d ) capacitor c=0.00107819f \
 //x=4.905 //y=5.205 //x2=6.225 //y2=5.205
cc_215 ( N_VDD_M14_noxref_s N_noxref_9_M13_noxref_d ) capacitor c=0.00195151f \
 //x=7.805 //y=5.2 //x2=6.225 //y2=5.205
cc_216 ( N_VDD_c_133_n N_D_c_815_n ) capacitor c=6.61004e-19 //x=7.15 \
 //y=7.585 //x2=9 //y2=2.26
cc_217 ( N_VDD_c_134_n N_D_c_815_n ) capacitor c=6.09526e-19 //x=9.74 //y=7.58 \
 //x2=9 //y2=2.26
cc_218 ( N_VDD_c_222_p N_D_M16_noxref_g ) capacitor c=0.00678607f //x=9.615 \
 //y=7.585 //x2=9.04 //y2=6.2
cc_219 ( N_VDD_M15_noxref_d N_D_M16_noxref_g ) capacitor c=0.015318f //x=8.675 \
 //y=5.2 //x2=9.04 //y2=6.2
cc_220 ( N_VDD_c_222_p N_D_M17_noxref_g ) capacitor c=0.00677553f //x=9.615 \
 //y=7.585 //x2=9.48 //y2=6.2
cc_221 ( N_VDD_c_134_n N_D_M17_noxref_g ) capacitor c=0.024326f //x=9.74 \
 //y=7.58 //x2=9.48 //y2=6.2
cc_222 ( N_VDD_M17_noxref_d N_D_M17_noxref_g ) capacitor c=0.0430452f \
 //x=9.555 //y=5.2 //x2=9.48 //y2=6.2
cc_223 ( N_VDD_c_133_n YN ) capacitor c=0.00151618f //x=7.15 //y=7.585 \
 //x2=9.74 //y2=2.4
cc_224 ( N_VDD_c_134_n YN ) capacitor c=0.0468798f //x=9.74 //y=7.58 //x2=9.74 \
 //y2=2.4
cc_225 ( N_VDD_c_172_p N_YN_c_886_n ) capacitor c=5.7743e-19 //x=8.735 \
 //y=7.585 //x2=9.175 //y2=5.38
cc_226 ( N_VDD_c_222_p N_YN_c_886_n ) capacitor c=5.7743e-19 //x=9.615 \
 //y=7.585 //x2=9.175 //y2=5.38
cc_227 ( N_VDD_M15_noxref_d N_YN_c_886_n ) capacitor c=0.0132783f //x=8.675 \
 //y=5.2 //x2=9.175 //y2=5.38
cc_228 ( N_VDD_c_133_n N_YN_c_889_n ) capacitor c=0.00985474f //x=7.15 \
 //y=7.585 //x2=8.465 //y2=5.38
cc_229 ( N_VDD_M14_noxref_s N_YN_c_889_n ) capacitor c=0.087833f //x=7.805 \
 //y=5.2 //x2=8.465 //y2=5.38
cc_230 ( N_VDD_c_222_p N_YN_c_891_n ) capacitor c=8.72934e-19 //x=9.615 \
 //y=7.585 //x2=9.655 //y2=5.38
cc_231 ( N_VDD_M17_noxref_d N_YN_c_891_n ) capacitor c=0.0167847f //x=9.555 \
 //y=5.2 //x2=9.655 //y2=5.38
cc_232 ( N_VDD_c_154_p N_YN_M14_noxref_d ) capacitor c=0.00720906f //x=9.74 \
 //y=7.58 //x2=8.235 //y2=5.2
cc_233 ( N_VDD_c_172_p N_YN_M14_noxref_d ) capacitor c=0.0138506f //x=8.735 \
 //y=7.585 //x2=8.235 //y2=5.2
cc_234 ( N_VDD_c_134_n N_YN_M14_noxref_d ) capacitor c=0.00204676f //x=9.74 \
 //y=7.58 //x2=8.235 //y2=5.2
cc_235 ( N_VDD_M15_noxref_d N_YN_M14_noxref_d ) capacitor c=0.0664752f \
 //x=8.675 //y=5.2 //x2=8.235 //y2=5.2
cc_236 ( N_VDD_c_154_p N_YN_M16_noxref_d ) capacitor c=0.00720906f //x=9.74 \
 //y=7.58 //x2=9.115 //y2=5.2
cc_237 ( N_VDD_c_222_p N_YN_M16_noxref_d ) capacitor c=0.0138783f //x=9.615 \
 //y=7.585 //x2=9.115 //y2=5.2
cc_238 ( N_VDD_c_134_n N_YN_M16_noxref_d ) capacitor c=0.0136712f //x=9.74 \
 //y=7.58 //x2=9.115 //y2=5.2
cc_239 ( N_VDD_M14_noxref_s N_YN_M16_noxref_d ) capacitor c=0.00111971f \
 //x=7.805 //y=5.2 //x2=9.115 //y2=5.2
cc_240 ( N_VDD_M15_noxref_d N_YN_M16_noxref_d ) capacitor c=0.0664752f \
 //x=8.675 //y=5.2 //x2=9.115 //y2=5.2
cc_241 ( N_VDD_M17_noxref_d N_YN_M16_noxref_d ) capacitor c=0.0664752f \
 //x=9.555 //y=5.2 //x2=9.115 //y2=5.2
cc_242 ( N_noxref_3_c_246_n N_noxref_4_c_392_n ) capacitor c=0.0114841f \
 //x=4.815 //y=2.77 //x2=6.525 //y2=2.77
cc_243 ( N_noxref_3_c_264_n N_noxref_4_c_394_n ) capacitor c=0.00431513f \
 //x=5.265 //y=1.43 //x2=5.885 //y2=1.835
cc_244 ( N_noxref_3_c_246_n N_noxref_4_c_442_n ) capacitor c=0.0018301f \
 //x=4.815 //y=2.77 //x2=5.085 //y2=1.835
cc_245 ( N_noxref_3_c_254_n N_noxref_4_c_442_n ) capacitor c=0.0107041f \
 //x=4.93 //y=2.26 //x2=5.085 //y2=1.835
cc_246 ( N_noxref_3_c_259_n N_noxref_4_c_442_n ) capacitor c=0.00524371f \
 //x=4.735 //y=2.095 //x2=5.085 //y2=1.835
cc_247 ( N_noxref_3_c_252_n N_noxref_4_c_402_n ) capacitor c=3.55699e-19 \
 //x=3.08 //y=2.77 //x2=6.41 //y2=2.77
cc_248 ( N_noxref_3_c_254_n N_noxref_4_c_402_n ) capacitor c=0.00354085f \
 //x=4.93 //y=2.26 //x2=6.41 //y2=2.77
cc_249 ( N_noxref_3_c_257_n N_noxref_4_M2_noxref_d ) capacitor c=0.0013184f \
 //x=4.735 //y=1.085 //x2=4.81 //y2=1.085
cc_250 ( N_noxref_3_c_307_p N_noxref_4_M2_noxref_d ) capacitor c=0.0034598f \
 //x=4.735 //y=1.43 //x2=4.81 //y2=1.085
cc_251 ( N_noxref_3_c_308_p N_noxref_4_M2_noxref_d ) capacitor c=0.00300148f \
 //x=4.735 //y=1.74 //x2=4.81 //y2=1.085
cc_252 ( N_noxref_3_c_259_n N_noxref_4_M2_noxref_d ) capacitor c=0.00273686f \
 //x=4.735 //y=2.095 //x2=4.81 //y2=1.085
cc_253 ( N_noxref_3_c_261_n N_noxref_4_M2_noxref_d ) capacitor c=0.00241102f \
 //x=5.11 //y=0.93 //x2=4.81 //y2=1.085
cc_254 ( N_noxref_3_c_311_p N_noxref_4_M2_noxref_d ) capacitor c=0.0123304f \
 //x=5.11 //y=1.585 //x2=4.81 //y2=1.085
cc_255 ( N_noxref_3_c_262_n N_noxref_4_M2_noxref_d ) capacitor c=0.00219619f \
 //x=5.265 //y=1.085 //x2=4.81 //y2=1.085
cc_256 ( N_noxref_3_c_264_n N_noxref_4_M2_noxref_d ) capacitor c=0.00603828f \
 //x=5.265 //y=1.43 //x2=4.81 //y2=1.085
cc_257 ( N_noxref_3_c_272_n N_A_c_531_n ) capacitor c=0.0055959f //x=1.805 \
 //y=5.38 //x2=1.6 //y2=2.26
cc_258 ( N_noxref_3_c_252_n N_A_c_531_n ) capacitor c=0.00407922f //x=3.08 \
 //y=2.77 //x2=1.6 //y2=2.26
cc_259 ( N_noxref_3_c_272_n N_A_M6_noxref_g ) capacitor c=0.0177326f //x=1.805 \
 //y=5.38 //x2=1.5 //y2=6.2
cc_260 ( N_noxref_3_c_269_n N_A_M7_noxref_g ) capacitor c=0.0204115f //x=2.515 \
 //y=5.38 //x2=1.94 //y2=6.2
cc_261 ( N_noxref_3_M6_noxref_d N_A_M7_noxref_g ) capacitor c=0.0173476f \
 //x=1.575 //y=5.2 //x2=1.94 //y2=6.2
cc_262 ( N_noxref_3_c_272_n N_A_c_548_n ) capacitor c=0.00605692f //x=1.805 \
 //y=5.38 //x2=1.6 //y2=4.88
cc_263 ( N_noxref_3_c_269_n N_B_c_595_n ) capacitor c=0.0127867f //x=2.515 \
 //y=5.38 //x2=2.34 //y2=4.715
cc_264 ( N_noxref_3_c_252_n N_B_c_595_n ) capacitor c=0.0101284f //x=3.08 \
 //y=2.77 //x2=2.34 //y2=4.715
cc_265 ( N_noxref_3_c_249_n N_B_c_586_n ) capacitor c=0.00732168f //x=3.195 \
 //y=2.77 //x2=2.34 //y2=2.26
cc_266 ( N_noxref_3_c_252_n N_B_c_586_n ) capacitor c=0.0813981f //x=3.08 \
 //y=2.77 //x2=2.34 //y2=2.26
cc_267 ( N_noxref_3_c_254_n N_B_c_586_n ) capacitor c=9.8819e-19 //x=4.93 \
 //y=2.26 //x2=2.34 //y2=2.26
cc_268 ( N_noxref_3_c_269_n N_B_M8_noxref_g ) capacitor c=0.0166699f //x=2.515 \
 //y=5.38 //x2=2.38 //y2=6.2
cc_269 ( N_noxref_3_M8_noxref_d N_B_M8_noxref_g ) capacitor c=0.0173477f \
 //x=2.455 //y=5.2 //x2=2.38 //y2=6.2
cc_270 ( N_noxref_3_c_274_n N_B_M9_noxref_g ) capacitor c=0.0223814f //x=2.995 \
 //y=5.38 //x2=2.82 //y2=6.2
cc_271 ( N_noxref_3_M8_noxref_d N_B_M9_noxref_g ) capacitor c=0.0179769f \
 //x=2.455 //y=5.2 //x2=2.82 //y2=6.2
cc_272 ( N_noxref_3_M1_noxref_d N_B_c_604_n ) capacitor c=0.00217566f //x=2.45 \
 //y=1.085 //x2=2.375 //y2=1.085
cc_273 ( N_noxref_3_M1_noxref_d N_B_c_605_n ) capacitor c=0.0034598f //x=2.45 \
 //y=1.085 //x2=2.375 //y2=1.43
cc_274 ( N_noxref_3_M1_noxref_d N_B_c_606_n ) capacitor c=0.0065582f //x=2.45 \
 //y=1.085 //x2=2.375 //y2=1.74
cc_275 ( N_noxref_3_c_252_n N_B_c_607_n ) capacitor c=0.0142673f //x=3.08 \
 //y=2.77 //x2=2.745 //y2=4.97
cc_276 ( N_noxref_3_c_333_p N_B_c_607_n ) capacitor c=0.00421574f //x=2.6 \
 //y=5.38 //x2=2.745 //y2=4.97
cc_277 ( N_noxref_3_M1_noxref_d N_B_c_609_n ) capacitor c=0.00241102f //x=2.45 \
 //y=1.085 //x2=2.75 //y2=0.93
cc_278 ( N_noxref_3_c_250_n N_B_c_610_n ) capacitor c=0.00359704f //x=2.995 \
 //y=1.835 //x2=2.75 //y2=1.585
cc_279 ( N_noxref_3_M1_noxref_d N_B_c_610_n ) capacitor c=0.0138845f //x=2.45 \
 //y=1.085 //x2=2.75 //y2=1.585
cc_280 ( N_noxref_3_M1_noxref_d N_B_c_612_n ) capacitor c=0.00132245f //x=2.45 \
 //y=1.085 //x2=2.905 //y2=1.085
cc_281 ( N_noxref_3_c_250_n N_B_c_613_n ) capacitor c=0.00457401f //x=2.995 \
 //y=1.835 //x2=2.905 //y2=1.43
cc_282 ( N_noxref_3_M1_noxref_d N_B_c_613_n ) capacitor c=0.00566463f //x=2.45 \
 //y=1.085 //x2=2.905 //y2=1.43
cc_283 ( N_noxref_3_c_252_n N_B_c_615_n ) capacitor c=0.00877984f //x=3.08 \
 //y=2.77 //x2=2.34 //y2=2.26
cc_284 ( N_noxref_3_c_252_n N_B_c_616_n ) capacitor c=0.00306024f //x=3.08 \
 //y=2.77 //x2=2.34 //y2=2.095
cc_285 ( N_noxref_3_M1_noxref_d N_B_c_616_n ) capacitor c=0.00660593f //x=2.45 \
 //y=1.085 //x2=2.34 //y2=2.095
cc_286 ( N_noxref_3_c_269_n N_B_c_618_n ) capacitor c=0.00399417f //x=2.515 \
 //y=5.38 //x2=2.37 //y2=4.88
cc_287 ( N_noxref_3_c_252_n N_B_c_618_n ) capacitor c=0.00533692f //x=3.08 \
 //y=2.77 //x2=2.37 //y2=4.88
cc_288 ( N_noxref_3_c_345_p N_noxref_7_c_674_n ) capacitor c=3.15806e-19 \
 //x=2.725 //y=1.835 //x2=1.185 //y2=1.675
cc_289 ( N_noxref_3_c_345_p N_noxref_7_c_658_n ) capacitor c=0.0201674f \
 //x=2.725 //y=1.835 //x2=2.155 //y2=1.675
cc_290 ( N_noxref_3_c_250_n N_noxref_7_c_659_n ) capacitor c=0.00468333f \
 //x=2.995 //y=1.835 //x2=3.04 //y2=0.71
cc_291 ( N_noxref_3_M1_noxref_d N_noxref_7_c_659_n ) capacitor c=0.0118355f \
 //x=2.45 //y=1.085 //x2=3.04 //y2=0.71
cc_292 ( N_noxref_3_c_246_n N_noxref_7_M0_noxref_s ) capacitor c=3.03583e-19 \
 //x=4.815 //y=2.77 //x2=1.05 //y2=0.545
cc_293 ( N_noxref_3_c_249_n N_noxref_7_M0_noxref_s ) capacitor c=6.92363e-19 \
 //x=3.195 //y=2.77 //x2=1.05 //y2=0.545
cc_294 ( N_noxref_3_c_250_n N_noxref_7_M0_noxref_s ) capacitor c=0.0129465f \
 //x=2.995 //y=1.835 //x2=1.05 //y2=0.545
cc_295 ( N_noxref_3_M1_noxref_d N_noxref_7_M0_noxref_s ) capacitor \
 c=0.0437911f //x=2.45 //y=1.085 //x2=1.05 //y2=0.545
cc_296 ( N_noxref_3_c_279_n N_C_c_714_n ) capacitor c=0.0470738f //x=4.775 \
 //y=4.885 //x2=5.67 //y2=4.72
cc_297 ( N_noxref_3_c_354_p N_C_c_714_n ) capacitor c=0.00146509f //x=5.195 \
 //y=4.975 //x2=5.67 //y2=4.72
cc_298 ( N_noxref_3_c_286_n N_C_c_714_n ) capacitor c=0.00112871f //x=4.775 \
 //y=4.885 //x2=5.67 //y2=4.72
cc_299 ( N_noxref_3_c_246_n N_C_c_701_n ) capacitor c=0.00316948f //x=4.815 \
 //y=2.77 //x2=5.67 //y2=2.26
cc_300 ( N_noxref_3_c_252_n N_C_c_701_n ) capacitor c=9.8819e-19 //x=3.08 \
 //y=2.77 //x2=5.67 //y2=2.26
cc_301 ( N_noxref_3_c_254_n N_C_c_701_n ) capacitor c=0.0447305f //x=4.93 \
 //y=2.26 //x2=5.67 //y2=2.26
cc_302 ( N_noxref_3_c_259_n N_C_c_701_n ) capacitor c=0.00308814f //x=4.735 \
 //y=2.095 //x2=5.67 //y2=2.26
cc_303 ( N_noxref_3_M10_noxref_g N_C_M12_noxref_g ) capacitor c=0.0100243f \
 //x=4.83 //y=6.205 //x2=5.71 //y2=6.205
cc_304 ( N_noxref_3_M11_noxref_g N_C_M12_noxref_g ) capacitor c=0.107798f \
 //x=5.27 //y=6.205 //x2=5.71 //y2=6.205
cc_305 ( N_noxref_3_M11_noxref_g N_C_M13_noxref_g ) capacitor c=0.0094155f \
 //x=5.27 //y=6.205 //x2=6.15 //y2=6.205
cc_306 ( N_noxref_3_c_257_n N_C_c_703_n ) capacitor c=0.00125788f //x=4.735 \
 //y=1.085 //x2=5.705 //y2=1.085
cc_307 ( N_noxref_3_c_262_n N_C_c_703_n ) capacitor c=0.0126654f //x=5.265 \
 //y=1.085 //x2=5.705 //y2=1.085
cc_308 ( N_noxref_3_c_307_p N_C_c_726_n ) capacitor c=0.00148539f //x=4.735 \
 //y=1.43 //x2=5.705 //y2=1.435
cc_309 ( N_noxref_3_c_308_p N_C_c_726_n ) capacitor c=0.00105591f //x=4.735 \
 //y=1.74 //x2=5.705 //y2=1.435
cc_310 ( N_noxref_3_c_264_n N_C_c_726_n ) capacitor c=0.0126654f //x=5.265 \
 //y=1.43 //x2=5.705 //y2=1.435
cc_311 ( N_noxref_3_c_308_p N_C_c_729_n ) capacitor c=0.00109549f //x=4.735 \
 //y=1.74 //x2=5.705 //y2=1.74
cc_312 ( N_noxref_3_c_264_n N_C_c_729_n ) capacitor c=0.00886999f //x=5.265 \
 //y=1.43 //x2=5.705 //y2=1.74
cc_313 ( N_noxref_3_c_264_n N_C_c_706_n ) capacitor c=0.00123863f //x=5.265 \
 //y=1.43 //x2=6.08 //y2=1.585
cc_314 ( N_noxref_3_c_262_n N_C_c_707_n ) capacitor c=0.00132934f //x=5.265 \
 //y=1.085 //x2=6.235 //y2=1.085
cc_315 ( N_noxref_3_c_264_n N_C_c_733_n ) capacitor c=0.00150734f //x=5.265 \
 //y=1.43 //x2=6.235 //y2=1.435
cc_316 ( N_noxref_3_c_254_n N_C_c_734_n ) capacitor c=0.00307062f //x=4.93 \
 //y=2.26 //x2=5.67 //y2=2.26
cc_317 ( N_noxref_3_c_259_n N_C_c_734_n ) capacitor c=0.0179092f //x=4.735 \
 //y=2.095 //x2=5.67 //y2=2.26
cc_318 ( N_noxref_3_c_259_n N_C_c_736_n ) capacitor c=0.00577193f //x=4.735 \
 //y=2.095 //x2=5.67 //y2=2.095
cc_319 ( N_noxref_3_c_279_n N_C_c_737_n ) capacitor c=0.00336963f //x=4.775 \
 //y=4.885 //x2=5.705 //y2=4.885
cc_320 ( N_noxref_3_c_354_p N_C_c_737_n ) capacitor c=0.020271f //x=5.195 \
 //y=4.975 //x2=5.705 //y2=4.885
cc_321 ( N_noxref_3_c_286_n N_C_c_737_n ) capacitor c=0.00546725f //x=4.775 \
 //y=4.885 //x2=5.705 //y2=4.885
cc_322 ( N_noxref_3_c_279_n N_noxref_9_c_772_n ) capacitor c=0.00630079f \
 //x=4.775 //y=4.885 //x2=5.405 //y2=5.39
cc_323 ( N_noxref_3_M10_noxref_g N_noxref_9_c_772_n ) capacitor c=0.0182669f \
 //x=4.83 //y=6.205 //x2=5.405 //y2=5.39
cc_324 ( N_noxref_3_M11_noxref_g N_noxref_9_c_772_n ) capacitor c=0.0204082f \
 //x=5.27 //y=6.205 //x2=5.405 //y2=5.39
cc_325 ( N_noxref_3_c_354_p N_noxref_9_c_772_n ) capacitor c=0.00365818f \
 //x=5.195 //y=4.975 //x2=5.405 //y2=5.39
cc_326 ( N_noxref_3_c_286_n N_noxref_9_c_772_n ) capacitor c=0.0017421f \
 //x=4.775 //y=4.885 //x2=5.405 //y2=5.39
cc_327 ( N_noxref_3_c_274_n N_noxref_9_c_776_n ) capacitor c=2.87761e-19 \
 //x=2.995 //y=5.38 //x2=4.695 //y2=5.39
cc_328 ( N_noxref_3_c_279_n N_noxref_9_c_776_n ) capacitor c=0.0118415f \
 //x=4.775 //y=4.885 //x2=4.695 //y2=5.39
cc_329 ( N_noxref_3_c_286_n N_noxref_9_c_776_n ) capacitor c=0.00613395f \
 //x=4.775 //y=4.885 //x2=4.695 //y2=5.39
cc_330 ( N_noxref_3_M8_noxref_d N_noxref_9_c_776_n ) capacitor c=4.5543e-19 \
 //x=2.455 //y=5.2 //x2=4.695 //y2=5.39
cc_331 ( N_noxref_3_M10_noxref_g N_noxref_9_M10_noxref_s ) capacitor \
 c=0.0473218f //x=4.83 //y=6.205 //x2=4.475 //y2=5.205
cc_332 ( N_noxref_3_M11_noxref_g N_noxref_9_M11_noxref_d ) capacitor \
 c=0.0170604f //x=5.27 //y=6.205 //x2=5.345 //y2=5.205
cc_333 ( N_noxref_4_c_402_n N_C_c_714_n ) capacitor c=0.0102183f //x=6.41 \
 //y=2.77 //x2=5.67 //y2=4.72
cc_334 ( N_noxref_4_c_392_n N_C_c_701_n ) capacitor c=0.00316948f //x=6.525 \
 //y=2.77 //x2=5.67 //y2=2.26
cc_335 ( N_noxref_4_c_394_n N_C_c_701_n ) capacitor c=0.0162392f //x=5.885 \
 //y=1.835 //x2=5.67 //y2=2.26
cc_336 ( N_noxref_4_c_402_n N_C_c_701_n ) capacitor c=0.0822198f //x=6.41 \
 //y=2.77 //x2=5.67 //y2=2.26
cc_337 ( N_noxref_4_c_404_n N_C_c_701_n ) capacitor c=9.8819e-19 //x=8.26 \
 //y=2.26 //x2=5.67 //y2=2.26
cc_338 ( N_noxref_4_c_427_n N_C_M12_noxref_g ) capacitor c=0.0132788f \
 //x=6.015 //y=5.39 //x2=5.71 //y2=6.205
cc_339 ( N_noxref_4_c_425_n N_C_M13_noxref_g ) capacitor c=0.0217751f \
 //x=6.325 //y=5.39 //x2=6.15 //y2=6.205
cc_340 ( N_noxref_4_M12_noxref_d N_C_M13_noxref_g ) capacitor c=0.0136385f \
 //x=5.785 //y=5.205 //x2=6.15 //y2=6.205
cc_341 ( N_noxref_4_M3_noxref_d N_C_c_703_n ) capacitor c=0.00226395f //x=5.78 \
 //y=1.085 //x2=5.705 //y2=1.085
cc_342 ( N_noxref_4_M3_noxref_d N_C_c_726_n ) capacitor c=0.0035101f //x=5.78 \
 //y=1.085 //x2=5.705 //y2=1.435
cc_343 ( N_noxref_4_c_394_n N_C_c_729_n ) capacitor c=0.00218915f //x=5.885 \
 //y=1.835 //x2=5.705 //y2=1.74
cc_344 ( N_noxref_4_M2_noxref_d N_C_c_729_n ) capacitor c=0.00148728f //x=4.81 \
 //y=1.085 //x2=5.705 //y2=1.74
cc_345 ( N_noxref_4_M3_noxref_d N_C_c_729_n ) capacitor c=0.00546704f //x=5.78 \
 //y=1.085 //x2=5.705 //y2=1.74
cc_346 ( N_noxref_4_c_427_n N_C_c_753_n ) capacitor c=0.00417892f //x=6.015 \
 //y=5.39 //x2=6.075 //y2=4.975
cc_347 ( N_noxref_4_c_402_n N_C_c_753_n ) capacitor c=0.0144455f //x=6.41 \
 //y=2.77 //x2=6.075 //y2=4.975
cc_348 ( N_noxref_4_M3_noxref_d N_C_c_705_n ) capacitor c=0.00241102f //x=5.78 \
 //y=1.085 //x2=6.08 //y2=0.93
cc_349 ( N_noxref_4_c_398_n N_C_c_706_n ) capacitor c=0.00801563f //x=6.325 \
 //y=1.835 //x2=6.08 //y2=1.585
cc_350 ( N_noxref_4_M3_noxref_d N_C_c_706_n ) capacitor c=0.0158021f //x=5.78 \
 //y=1.085 //x2=6.08 //y2=1.585
cc_351 ( N_noxref_4_M3_noxref_d N_C_c_707_n ) capacitor c=0.00132831f //x=5.78 \
 //y=1.085 //x2=6.235 //y2=1.085
cc_352 ( N_noxref_4_M3_noxref_d N_C_c_733_n ) capacitor c=0.0035101f //x=5.78 \
 //y=1.085 //x2=6.235 //y2=1.435
cc_353 ( N_noxref_4_c_394_n N_C_c_734_n ) capacitor c=0.00633758f //x=5.885 \
 //y=1.835 //x2=5.67 //y2=2.26
cc_354 ( N_noxref_4_c_402_n N_C_c_734_n ) capacitor c=0.00877984f //x=6.41 \
 //y=2.77 //x2=5.67 //y2=2.26
cc_355 ( N_noxref_4_c_394_n N_C_c_736_n ) capacitor c=0.0189958f //x=5.885 \
 //y=1.835 //x2=5.67 //y2=2.095
cc_356 ( N_noxref_4_c_402_n N_C_c_736_n ) capacitor c=0.00306024f //x=6.41 \
 //y=2.77 //x2=5.67 //y2=2.095
cc_357 ( N_noxref_4_M3_noxref_d N_C_c_736_n ) capacitor c=3.4952e-19 //x=5.78 \
 //y=1.085 //x2=5.67 //y2=2.095
cc_358 ( N_noxref_4_c_402_n N_C_c_737_n ) capacitor c=0.00537091f //x=6.41 \
 //y=2.77 //x2=5.705 //y2=4.885
cc_359 ( N_noxref_4_c_427_n N_noxref_9_c_772_n ) capacitor c=0.0348754f \
 //x=6.015 //y=5.39 //x2=5.405 //y2=5.39
cc_360 ( N_noxref_4_c_425_n N_noxref_9_c_777_n ) capacitor c=0.00194034f \
 //x=6.325 //y=5.39 //x2=6.285 //y2=7.09
cc_361 ( N_noxref_4_M12_noxref_d N_noxref_9_c_777_n ) capacitor c=0.0118172f \
 //x=5.785 //y=5.205 //x2=6.285 //y2=7.09
cc_362 ( N_noxref_4_M12_noxref_d N_noxref_9_M10_noxref_s ) capacitor \
 c=0.00107541f //x=5.785 //y=5.205 //x2=4.475 //y2=5.205
cc_363 ( N_noxref_4_M12_noxref_d N_noxref_9_M11_noxref_d ) capacitor \
 c=0.0348754f //x=5.785 //y=5.205 //x2=5.345 //y2=5.205
cc_364 ( N_noxref_4_c_425_n N_noxref_9_M13_noxref_d ) capacitor c=0.0164221f \
 //x=6.325 //y=5.39 //x2=6.225 //y2=5.205
cc_365 ( N_noxref_4_M12_noxref_d N_noxref_9_M13_noxref_d ) capacitor \
 c=0.0458293f //x=5.785 //y=5.205 //x2=6.225 //y2=5.205
cc_366 ( N_noxref_4_c_404_n N_D_c_824_n ) capacitor c=0.00400249f //x=8.26 \
 //y=2.26 //x2=9 //y2=4.715
cc_367 ( N_noxref_4_c_436_n N_D_c_824_n ) capacitor c=0.00417994f //x=8.26 \
 //y=4.88 //x2=9 //y2=4.715
cc_368 ( N_noxref_4_c_390_n N_D_c_815_n ) capacitor c=0.00732168f //x=8.145 \
 //y=2.77 //x2=9 //y2=2.26
cc_369 ( N_noxref_4_c_402_n N_D_c_815_n ) capacitor c=9.8819e-19 //x=6.41 \
 //y=2.77 //x2=9 //y2=2.26
cc_370 ( N_noxref_4_c_404_n N_D_c_815_n ) capacitor c=0.0865507f //x=8.26 \
 //y=2.26 //x2=9 //y2=2.26
cc_371 ( N_noxref_4_c_409_n N_D_c_815_n ) capacitor c=0.00308814f //x=8.065 \
 //y=2.095 //x2=9 //y2=2.26
cc_372 ( N_noxref_4_M14_noxref_g N_D_M16_noxref_g ) capacitor c=0.0104611f \
 //x=8.16 //y=6.2 //x2=9.04 //y2=6.2
cc_373 ( N_noxref_4_M15_noxref_g N_D_M16_noxref_g ) capacitor c=0.106811f \
 //x=8.6 //y=6.2 //x2=9.04 //y2=6.2
cc_374 ( N_noxref_4_M15_noxref_g N_D_M17_noxref_g ) capacitor c=0.0100341f \
 //x=8.6 //y=6.2 //x2=9.48 //y2=6.2
cc_375 ( N_noxref_4_c_405_n N_D_c_833_n ) capacitor c=4.86506e-19 //x=8.065 \
 //y=1.045 //x2=9.035 //y2=1.085
cc_376 ( N_noxref_4_c_407_n N_D_c_833_n ) capacitor c=0.00152104f //x=8.065 \
 //y=1.39 //x2=9.035 //y2=1.085
cc_377 ( N_noxref_4_c_412_n N_D_c_833_n ) capacitor c=0.0151475f //x=8.595 \
 //y=1.045 //x2=9.035 //y2=1.085
cc_378 ( N_noxref_4_c_408_n N_D_c_836_n ) capacitor c=0.00109982f //x=8.065 \
 //y=1.7 //x2=9.035 //y2=1.43
cc_379 ( N_noxref_4_c_414_n N_D_c_836_n ) capacitor c=0.0111064f //x=8.595 \
 //y=1.39 //x2=9.035 //y2=1.43
cc_380 ( N_noxref_4_c_408_n N_D_c_838_n ) capacitor c=9.57794e-19 //x=8.065 \
 //y=1.7 //x2=9.035 //y2=1.74
cc_381 ( N_noxref_4_c_409_n N_D_c_838_n ) capacitor c=0.00662747f //x=8.065 \
 //y=2.095 //x2=9.035 //y2=1.74
cc_382 ( N_noxref_4_c_414_n N_D_c_838_n ) capacitor c=0.00862358f //x=8.595 \
 //y=1.39 //x2=9.035 //y2=1.74
cc_383 ( N_noxref_4_c_412_n N_D_c_841_n ) capacitor c=0.00124821f //x=8.595 \
 //y=1.045 //x2=9.565 //y2=1.085
cc_384 ( N_noxref_4_c_414_n N_D_c_842_n ) capacitor c=0.00200715f //x=8.595 \
 //y=1.39 //x2=9.565 //y2=1.43
cc_385 ( N_noxref_4_c_404_n N_D_c_843_n ) capacitor c=0.00307062f //x=8.26 \
 //y=2.26 //x2=9 //y2=2.26
cc_386 ( N_noxref_4_c_409_n N_D_c_843_n ) capacitor c=0.0179092f //x=8.065 \
 //y=2.095 //x2=9 //y2=2.26
cc_387 ( N_noxref_4_c_404_n N_D_c_845_n ) capacitor c=0.00344981f //x=8.26 \
 //y=2.26 //x2=9.03 //y2=4.88
cc_388 ( N_noxref_4_c_436_n N_D_c_845_n ) capacitor c=0.0293367f //x=8.26 \
 //y=4.88 //x2=9.03 //y2=4.88
cc_389 ( N_noxref_4_c_402_n YN ) capacitor c=3.49822e-19 //x=6.41 //y=2.77 \
 //x2=9.74 //y2=2.4
cc_390 ( N_noxref_4_c_404_n YN ) capacitor c=0.00407922f //x=8.26 //y=2.26 \
 //x2=9.74 //y2=2.4
cc_391 ( N_noxref_4_M15_noxref_g N_YN_c_886_n ) capacitor c=0.0204115f //x=8.6 \
 //y=6.2 //x2=9.175 //y2=5.38
cc_392 ( N_noxref_4_c_404_n N_YN_c_889_n ) capacitor c=0.0055959f //x=8.26 \
 //y=2.26 //x2=8.465 //y2=5.38
cc_393 ( N_noxref_4_M14_noxref_g N_YN_c_889_n ) capacitor c=0.0177326f \
 //x=8.16 //y=6.2 //x2=8.465 //y2=5.38
cc_394 ( N_noxref_4_c_436_n N_YN_c_889_n ) capacitor c=0.00605692f //x=8.26 \
 //y=4.88 //x2=8.465 //y2=5.38
cc_395 ( N_noxref_4_M15_noxref_g N_YN_M14_noxref_d ) capacitor c=0.0173476f \
 //x=8.6 //y=6.2 //x2=8.235 //y2=5.2
cc_396 ( N_noxref_4_c_390_n N_noxref_12_c_957_n ) capacitor c=0.00491973f \
 //x=8.145 //y=2.77 //x2=7.845 //y2=1.675
cc_397 ( N_noxref_4_c_398_n N_noxref_12_c_957_n ) capacitor c=3.37788e-19 \
 //x=6.325 //y=1.835 //x2=7.845 //y2=1.675
cc_398 ( N_noxref_4_c_409_n N_noxref_12_c_957_n ) capacitor c=0.0034165f \
 //x=8.065 //y=2.095 //x2=7.845 //y2=1.675
cc_399 ( N_noxref_4_c_390_n N_noxref_12_c_939_n ) capacitor c=0.0108509f \
 //x=8.145 //y=2.77 //x2=8.73 //y2=1.76
cc_400 ( N_noxref_4_c_404_n N_noxref_12_c_939_n ) capacitor c=0.0114076f \
 //x=8.26 //y=2.26 //x2=8.73 //y2=1.76
cc_401 ( N_noxref_4_c_408_n N_noxref_12_c_939_n ) capacitor c=0.00700575f \
 //x=8.065 //y=1.7 //x2=8.73 //y2=1.76
cc_402 ( N_noxref_4_c_409_n N_noxref_12_c_939_n ) capacitor c=0.018562f \
 //x=8.065 //y=2.095 //x2=8.73 //y2=1.76
cc_403 ( N_noxref_4_c_411_n N_noxref_12_c_939_n ) capacitor c=0.00780629f \
 //x=8.44 //y=1.545 //x2=8.73 //y2=1.76
cc_404 ( N_noxref_4_c_414_n N_noxref_12_c_939_n ) capacitor c=0.00339872f \
 //x=8.595 //y=1.39 //x2=8.73 //y2=1.76
cc_405 ( N_noxref_4_c_409_n N_noxref_12_c_946_n ) capacitor c=6.71402e-19 \
 //x=8.065 //y=2.095 //x2=8.815 //y2=1.675
cc_406 ( N_noxref_4_c_405_n N_noxref_12_M4_noxref_s ) capacitor c=0.0326693f \
 //x=8.065 //y=1.045 //x2=7.71 //y2=0.545
cc_407 ( N_noxref_4_c_408_n N_noxref_12_M4_noxref_s ) capacitor c=3.48408e-19 \
 //x=8.065 //y=1.7 //x2=7.71 //y2=0.545
cc_408 ( N_noxref_4_c_412_n N_noxref_12_M4_noxref_s ) capacitor c=0.0120759f \
 //x=8.595 //y=1.045 //x2=7.71 //y2=0.545
cc_409 ( N_A_c_531_n N_B_c_595_n ) capacitor c=0.00400249f //x=1.6 //y=2.26 \
 //x2=2.34 //y2=4.715
cc_410 ( N_A_c_548_n N_B_c_595_n ) capacitor c=0.00417994f //x=1.6 //y=4.88 \
 //x2=2.34 //y2=4.715
cc_411 ( N_A_c_531_n N_B_c_586_n ) capacitor c=0.0887263f //x=1.6 //y=2.26 \
 //x2=2.34 //y2=2.26
cc_412 ( N_A_c_536_n N_B_c_586_n ) capacitor c=0.00308814f //x=1.405 //y=2.095 \
 //x2=2.34 //y2=2.26
cc_413 ( N_A_M6_noxref_g N_B_M8_noxref_g ) capacitor c=0.0104611f //x=1.5 \
 //y=6.2 //x2=2.38 //y2=6.2
cc_414 ( N_A_M7_noxref_g N_B_M8_noxref_g ) capacitor c=0.106811f //x=1.94 \
 //y=6.2 //x2=2.38 //y2=6.2
cc_415 ( N_A_M7_noxref_g N_B_M9_noxref_g ) capacitor c=0.0100341f //x=1.94 \
 //y=6.2 //x2=2.82 //y2=6.2
cc_416 ( N_A_c_532_n N_B_c_604_n ) capacitor c=4.86506e-19 //x=1.405 //y=1.045 \
 //x2=2.375 //y2=1.085
cc_417 ( N_A_c_534_n N_B_c_604_n ) capacitor c=0.00152104f //x=1.405 //y=1.39 \
 //x2=2.375 //y2=1.085
cc_418 ( N_A_c_539_n N_B_c_604_n ) capacitor c=0.0151475f //x=1.935 //y=1.045 \
 //x2=2.375 //y2=1.085
cc_419 ( N_A_c_535_n N_B_c_605_n ) capacitor c=0.00109982f //x=1.405 //y=1.7 \
 //x2=2.375 //y2=1.43
cc_420 ( N_A_c_541_n N_B_c_605_n ) capacitor c=0.0111064f //x=1.935 //y=1.39 \
 //x2=2.375 //y2=1.43
cc_421 ( N_A_c_535_n N_B_c_606_n ) capacitor c=9.57794e-19 //x=1.405 //y=1.7 \
 //x2=2.375 //y2=1.74
cc_422 ( N_A_c_536_n N_B_c_606_n ) capacitor c=0.00662747f //x=1.405 //y=2.095 \
 //x2=2.375 //y2=1.74
cc_423 ( N_A_c_541_n N_B_c_606_n ) capacitor c=0.00862358f //x=1.935 //y=1.39 \
 //x2=2.375 //y2=1.74
cc_424 ( N_A_c_539_n N_B_c_612_n ) capacitor c=0.00124821f //x=1.935 //y=1.045 \
 //x2=2.905 //y2=1.085
cc_425 ( N_A_c_541_n N_B_c_613_n ) capacitor c=0.00200715f //x=1.935 //y=1.39 \
 //x2=2.905 //y2=1.43
cc_426 ( N_A_c_531_n N_B_c_615_n ) capacitor c=0.00307062f //x=1.6 //y=2.26 \
 //x2=2.34 //y2=2.26
cc_427 ( N_A_c_536_n N_B_c_615_n ) capacitor c=0.0179092f //x=1.405 //y=2.095 \
 //x2=2.34 //y2=2.26
cc_428 ( N_A_c_531_n N_B_c_618_n ) capacitor c=0.00344981f //x=1.6 //y=2.26 \
 //x2=2.37 //y2=4.88
cc_429 ( N_A_c_548_n N_B_c_618_n ) capacitor c=0.0293367f //x=1.6 //y=4.88 \
 //x2=2.37 //y2=4.88
cc_430 ( N_A_c_536_n N_noxref_7_c_674_n ) capacitor c=0.0034165f //x=1.405 \
 //y=2.095 //x2=1.185 //y2=1.675
cc_431 ( N_A_c_531_n N_noxref_7_c_650_n ) capacitor c=0.0118986f //x=1.6 \
 //y=2.26 //x2=2.07 //y2=1.76
cc_432 ( N_A_c_535_n N_noxref_7_c_650_n ) capacitor c=0.00703567f //x=1.405 \
 //y=1.7 //x2=2.07 //y2=1.76
cc_433 ( N_A_c_536_n N_noxref_7_c_650_n ) capacitor c=0.0216532f //x=1.405 \
 //y=2.095 //x2=2.07 //y2=1.76
cc_434 ( N_A_c_538_n N_noxref_7_c_650_n ) capacitor c=0.00780629f //x=1.78 \
 //y=1.545 //x2=2.07 //y2=1.76
cc_435 ( N_A_c_541_n N_noxref_7_c_650_n ) capacitor c=0.00339872f //x=1.935 \
 //y=1.39 //x2=2.07 //y2=1.76
cc_436 ( N_A_c_536_n N_noxref_7_c_658_n ) capacitor c=6.71402e-19 //x=1.405 \
 //y=2.095 //x2=2.155 //y2=1.675
cc_437 ( N_A_c_532_n N_noxref_7_M0_noxref_s ) capacitor c=0.0326577f //x=1.405 \
 //y=1.045 //x2=1.05 //y2=0.545
cc_438 ( N_A_c_535_n N_noxref_7_M0_noxref_s ) capacitor c=3.48408e-19 \
 //x=1.405 //y=1.7 //x2=1.05 //y2=0.545
cc_439 ( N_A_c_539_n N_noxref_7_M0_noxref_s ) capacitor c=0.0120759f //x=1.935 \
 //y=1.045 //x2=1.05 //y2=0.545
cc_440 ( N_B_c_606_n N_noxref_7_c_658_n ) capacitor c=0.00623646f //x=2.375 \
 //y=1.74 //x2=2.155 //y2=1.675
cc_441 ( N_B_c_615_n N_noxref_7_c_658_n ) capacitor c=0.00172768f //x=2.34 \
 //y=2.26 //x2=2.155 //y2=1.675
cc_442 ( N_B_c_586_n N_noxref_7_c_659_n ) capacitor c=0.00161845f //x=2.34 \
 //y=2.26 //x2=3.04 //y2=0.71
cc_443 ( N_B_c_604_n N_noxref_7_c_659_n ) capacitor c=0.0186143f //x=2.375 \
 //y=1.085 //x2=3.04 //y2=0.71
cc_444 ( N_B_c_612_n N_noxref_7_c_659_n ) capacitor c=0.00656458f //x=2.905 \
 //y=1.085 //x2=3.04 //y2=0.71
cc_445 ( N_B_c_615_n N_noxref_7_c_659_n ) capacitor c=2.1838e-19 //x=2.34 \
 //y=2.26 //x2=3.04 //y2=0.71
cc_446 ( N_B_c_604_n N_noxref_7_M0_noxref_s ) capacitor c=0.00623646f \
 //x=2.375 //y=1.085 //x2=1.05 //y2=0.545
cc_447 ( N_B_c_612_n N_noxref_7_M0_noxref_s ) capacitor c=0.0143002f //x=2.905 \
 //y=1.085 //x2=1.05 //y2=0.545
cc_448 ( N_B_c_613_n N_noxref_7_M0_noxref_s ) capacitor c=0.00290153f \
 //x=2.905 //y=1.43 //x2=1.05 //y2=0.545
cc_449 ( N_C_M12_noxref_g N_noxref_9_c_772_n ) capacitor c=0.0170604f //x=5.71 \
 //y=6.205 //x2=5.405 //y2=5.39
cc_450 ( N_C_c_737_n N_noxref_9_c_772_n ) capacitor c=2.3112e-19 //x=5.705 \
 //y=4.885 //x2=5.405 //y2=5.39
cc_451 ( N_C_c_714_n N_noxref_9_c_777_n ) capacitor c=0.00109004f //x=5.67 \
 //y=4.72 //x2=6.285 //y2=7.09
cc_452 ( N_C_M12_noxref_g N_noxref_9_c_777_n ) capacitor c=0.0148484f //x=5.71 \
 //y=6.205 //x2=6.285 //y2=7.09
cc_453 ( N_C_M13_noxref_g N_noxref_9_c_777_n ) capacitor c=0.0163196f //x=6.15 \
 //y=6.205 //x2=6.285 //y2=7.09
cc_454 ( N_C_M13_noxref_g N_noxref_9_M13_noxref_d ) capacitor c=0.0351101f \
 //x=6.15 //y=6.205 //x2=6.225 //y2=5.205
cc_455 ( N_D_c_824_n YN ) capacitor c=0.0101115f //x=9 //y=4.715 //x2=9.74 \
 //y2=2.4
cc_456 ( N_D_c_815_n YN ) capacitor c=0.0835737f //x=9 //y=2.26 //x2=9.74 \
 //y2=2.4
cc_457 ( N_D_c_849_p YN ) capacitor c=0.0142673f //x=9.405 //y=4.97 //x2=9.74 \
 //y2=2.4
cc_458 ( N_D_c_843_n YN ) capacitor c=0.00877984f //x=9 //y=2.26 //x2=9.74 \
 //y2=2.4
cc_459 ( N_D_c_851_p YN ) capacitor c=0.00306024f //x=9 //y=2.095 //x2=9.74 \
 //y2=2.4
cc_460 ( N_D_c_845_n YN ) capacitor c=0.00533692f //x=9.03 //y=4.88 //x2=9.74 \
 //y2=2.4
cc_461 ( N_D_c_824_n N_YN_c_886_n ) capacitor c=0.0127867f //x=9 //y=4.715 \
 //x2=9.175 //y2=5.38
cc_462 ( N_D_M16_noxref_g N_YN_c_886_n ) capacitor c=0.0166699f //x=9.04 \
 //y=6.2 //x2=9.175 //y2=5.38
cc_463 ( N_D_c_845_n N_YN_c_886_n ) capacitor c=0.00399417f //x=9.03 //y=4.88 \
 //x2=9.175 //y2=5.38
cc_464 ( N_D_M17_noxref_g N_YN_c_891_n ) capacitor c=0.0223814f //x=9.48 \
 //y=6.2 //x2=9.655 //y2=5.38
cc_465 ( N_D_c_857_p N_YN_c_880_n ) capacitor c=0.00359704f //x=9.41 //y=1.585 \
 //x2=9.655 //y2=1.835
cc_466 ( N_D_c_842_n N_YN_c_880_n ) capacitor c=0.00457401f //x=9.565 //y=1.43 \
 //x2=9.655 //y2=1.835
cc_467 ( N_D_c_849_p N_YN_c_922_n ) capacitor c=0.00421574f //x=9.405 //y=4.97 \
 //x2=9.26 //y2=5.38
cc_468 ( N_D_c_833_n N_YN_M5_noxref_d ) capacitor c=0.00217566f //x=9.035 \
 //y=1.085 //x2=9.11 //y2=1.085
cc_469 ( N_D_c_836_n N_YN_M5_noxref_d ) capacitor c=0.0034598f //x=9.035 \
 //y=1.43 //x2=9.11 //y2=1.085
cc_470 ( N_D_c_838_n N_YN_M5_noxref_d ) capacitor c=0.0065582f //x=9.035 \
 //y=1.74 //x2=9.11 //y2=1.085
cc_471 ( N_D_c_863_p N_YN_M5_noxref_d ) capacitor c=0.00241102f //x=9.41 \
 //y=0.93 //x2=9.11 //y2=1.085
cc_472 ( N_D_c_857_p N_YN_M5_noxref_d ) capacitor c=0.0138845f //x=9.41 \
 //y=1.585 //x2=9.11 //y2=1.085
cc_473 ( N_D_c_841_n N_YN_M5_noxref_d ) capacitor c=0.00132245f //x=9.565 \
 //y=1.085 //x2=9.11 //y2=1.085
cc_474 ( N_D_c_842_n N_YN_M5_noxref_d ) capacitor c=0.00566463f //x=9.565 \
 //y=1.43 //x2=9.11 //y2=1.085
cc_475 ( N_D_c_851_p N_YN_M5_noxref_d ) capacitor c=0.00660593f //x=9 \
 //y=2.095 //x2=9.11 //y2=1.085
cc_476 ( N_D_M16_noxref_g N_YN_M16_noxref_d ) capacitor c=0.0173476f //x=9.04 \
 //y=6.2 //x2=9.115 //y2=5.2
cc_477 ( N_D_M17_noxref_g N_YN_M16_noxref_d ) capacitor c=0.0179769f //x=9.48 \
 //y=6.2 //x2=9.115 //y2=5.2
cc_478 ( N_D_c_838_n N_noxref_12_c_946_n ) capacitor c=0.00623646f //x=9.035 \
 //y=1.74 //x2=8.815 //y2=1.675
cc_479 ( N_D_c_843_n N_noxref_12_c_946_n ) capacitor c=0.00172768f //x=9 \
 //y=2.26 //x2=8.815 //y2=1.675
cc_480 ( N_D_c_815_n N_noxref_12_c_947_n ) capacitor c=0.00161845f //x=9 \
 //y=2.26 //x2=9.7 //y2=0.71
cc_481 ( N_D_c_833_n N_noxref_12_c_947_n ) capacitor c=0.0186143f //x=9.035 \
 //y=1.085 //x2=9.7 //y2=0.71
cc_482 ( N_D_c_841_n N_noxref_12_c_947_n ) capacitor c=0.00656458f //x=9.565 \
 //y=1.085 //x2=9.7 //y2=0.71
cc_483 ( N_D_c_843_n N_noxref_12_c_947_n ) capacitor c=2.1838e-19 //x=9 \
 //y=2.26 //x2=9.7 //y2=0.71
cc_484 ( N_D_c_833_n N_noxref_12_M4_noxref_s ) capacitor c=0.00623646f \
 //x=9.035 //y=1.085 //x2=7.71 //y2=0.545
cc_485 ( N_D_c_841_n N_noxref_12_M4_noxref_s ) capacitor c=0.0143002f \
 //x=9.565 //y=1.085 //x2=7.71 //y2=0.545
cc_486 ( N_D_c_842_n N_noxref_12_M4_noxref_s ) capacitor c=0.00290153f \
 //x=9.565 //y=1.43 //x2=7.71 //y2=0.545
cc_487 ( N_YN_c_933_p N_noxref_12_c_957_n ) capacitor c=3.15806e-19 //x=9.385 \
 //y=1.835 //x2=7.845 //y2=1.675
cc_488 ( N_YN_c_933_p N_noxref_12_c_946_n ) capacitor c=0.0203424f //x=9.385 \
 //y=1.835 //x2=8.815 //y2=1.675
cc_489 ( N_YN_c_880_n N_noxref_12_c_947_n ) capacitor c=0.00469114f //x=9.655 \
 //y=1.835 //x2=9.7 //y2=0.71
cc_490 ( N_YN_M5_noxref_d N_noxref_12_c_947_n ) capacitor c=0.0118355f \
 //x=9.11 //y=1.085 //x2=9.7 //y2=0.71
cc_491 ( N_YN_c_880_n N_noxref_12_M4_noxref_s ) capacitor c=0.0144625f \
 //x=9.655 //y=1.835 //x2=7.71 //y2=0.545
cc_492 ( N_YN_M5_noxref_d N_noxref_12_M4_noxref_s ) capacitor c=0.043966f \
 //x=9.11 //y=1.085 //x2=7.71 //y2=0.545
