// File: invx1_pcell.spi.INVX1_PCELL.pxi
// Created: Fri Feb 20 10:20:14 2026
//
simulator lang=spectre
x_PM_INVX1_PCELL\%noxref_2 ( N_noxref_2_c_20_p N_noxref_2_c_21_p \
 N_noxref_2_c_18_n N_noxref_2_c_19_n N_noxref_2_M1_noxref_s \
 N_noxref_2_M2_noxref_d )  PM_INVX1_PCELL\%noxref_2
x_PM_INVX1_PCELL\%noxref_3 ( N_noxref_3_c_53_n N_noxref_3_c_54_n \
 N_noxref_3_c_55_n N_noxref_3_c_67_n N_noxref_3_M0_noxref_g \
 N_noxref_3_M1_noxref_g N_noxref_3_M2_noxref_g N_noxref_3_c_56_n \
 N_noxref_3_c_80_p N_noxref_3_c_57_n N_noxref_3_c_58_n N_noxref_3_c_76_n \
 N_noxref_3_c_77_n N_noxref_3_c_59_n N_noxref_3_c_83_p N_noxref_3_c_60_n \
 N_noxref_3_c_61_n N_noxref_3_c_62_n )  PM_INVX1_PCELL\%noxref_3
x_PM_INVX1_PCELL\%noxref_4 ( N_noxref_4_c_114_n N_noxref_4_c_118_n \
 N_noxref_4_c_115_n N_noxref_4_c_142_n N_noxref_4_c_123_n N_noxref_4_c_126_n \
 N_noxref_4_c_127_n N_noxref_4_c_116_n N_noxref_4_c_128_n \
 N_noxref_4_M0_noxref_d N_noxref_4_M1_noxref_d )  PM_INVX1_PCELL\%noxref_4
cc_1 ( noxref_1 N_noxref_2_c_18_n ) capacitor c=0.00989031f //x=0.495 //y=0.37 \
 //x2=0.74 //y2=7.4
cc_2 ( noxref_1 N_noxref_2_c_19_n ) capacitor c=0.00989031f //x=0.495 //y=0.37 \
 //x2=1.48 //y2=7.4
cc_3 ( noxref_1 N_noxref_3_c_53_n ) capacitor c=0.0146622f //x=0.495 //y=0.37 \
 //x2=0.74 //y2=4.58
cc_4 ( noxref_1 N_noxref_3_c_54_n ) capacitor c=0.0166162f //x=0.495 //y=0.37 \
 //x2=0.74 //y2=2.085
cc_5 ( noxref_1 N_noxref_3_c_55_n ) capacitor c=0.0165435f //x=0.495 //y=0.37 \
 //x2=0.74 //y2=2.085
cc_6 ( noxref_1 N_noxref_3_c_56_n ) capacitor c=0.0424467f //x=0.495 //y=0.37 \
 //x2=0.85 //y2=0.91
cc_7 ( noxref_1 N_noxref_3_c_57_n ) capacitor c=0.002132f //x=0.495 //y=0.37 \
 //x2=0.85 //y2=1.565
cc_8 ( noxref_1 N_noxref_3_c_58_n ) capacitor c=0.00878957f //x=0.495 //y=0.37 \
 //x2=0.85 //y2=1.92
cc_9 ( noxref_1 N_noxref_3_c_59_n ) capacitor c=0.00517157f //x=0.495 //y=0.37 \
 //x2=1.225 //y2=0.755
cc_10 ( noxref_1 N_noxref_3_c_60_n ) capacitor c=0.0287812f //x=0.495 //y=0.37 \
 //x2=1.38 //y2=0.91
cc_11 ( noxref_1 N_noxref_3_c_61_n ) capacitor c=0.00629878f //x=0.495 \
 //y=0.37 //x2=1.38 //y2=1.255
cc_12 ( noxref_1 N_noxref_3_c_62_n ) capacitor c=0.0137649f //x=0.495 //y=0.37 \
 //x2=0.74 //y2=2.085
cc_13 ( noxref_1 N_noxref_4_c_114_n ) capacitor c=0.0446822f //x=0.495 \
 //y=0.37 //x2=1.11 //y2=1.755
cc_14 ( noxref_1 N_noxref_4_c_115_n ) capacitor c=0.0455108f //x=0.495 \
 //y=0.37 //x2=1.395 //y2=1.84
cc_15 ( noxref_1 N_noxref_4_c_116_n ) capacitor c=0.0300833f //x=0.495 \
 //y=0.37 //x2=1.11 //y2=1.005
cc_16 ( noxref_1 N_noxref_4_M0_noxref_d ) capacitor c=0.0392271f //x=0.495 \
 //y=0.37 //x2=0.925 //y2=0.91
cc_17 ( N_noxref_2_c_20_p N_noxref_3_c_53_n ) capacitor c=5.72118e-19 //x=1.48 \
 //y=7.4 //x2=0.74 //y2=4.58
cc_18 ( N_noxref_2_c_21_p N_noxref_3_c_53_n ) capacitor c=5.4912e-19 //x=1.47 \
 //y=7.4 //x2=0.74 //y2=4.58
cc_19 ( N_noxref_2_c_18_n N_noxref_3_c_53_n ) capacitor c=0.022723f //x=0.74 \
 //y=7.4 //x2=0.74 //y2=4.58
cc_20 ( N_noxref_2_M1_noxref_s N_noxref_3_c_53_n ) capacitor c=0.0218261f \
 //x=0.54 //y=5.02 //x2=0.74 //y2=4.58
cc_21 ( N_noxref_2_c_20_p N_noxref_3_c_67_n ) capacitor c=3.40875e-19 //x=1.48 \
 //y=7.4 //x2=0.74 //y2=4.7
cc_22 ( N_noxref_2_c_18_n N_noxref_3_c_67_n ) capacitor c=0.00851507f //x=0.74 \
 //y=7.4 //x2=0.74 //y2=4.7
cc_23 ( N_noxref_2_c_19_n N_noxref_3_c_67_n ) capacitor c=0.00235165f //x=1.48 \
 //y=7.4 //x2=0.74 //y2=4.7
cc_24 ( N_noxref_2_M1_noxref_s N_noxref_3_c_67_n ) capacitor c=0.00986151f \
 //x=0.54 //y=5.02 //x2=0.74 //y2=4.7
cc_25 ( N_noxref_2_c_21_p N_noxref_3_M1_noxref_g ) capacitor c=0.00748034f \
 //x=1.47 //y=7.4 //x2=0.895 //y2=6.02
cc_26 ( N_noxref_2_c_18_n N_noxref_3_M1_noxref_g ) capacitor c=0.021054f \
 //x=0.74 //y=7.4 //x2=0.895 //y2=6.02
cc_27 ( N_noxref_2_M1_noxref_s N_noxref_3_M1_noxref_g ) capacitor c=0.0573441f \
 //x=0.54 //y=5.02 //x2=0.895 //y2=6.02
cc_28 ( N_noxref_2_c_21_p N_noxref_3_M2_noxref_g ) capacitor c=0.00749619f \
 //x=1.47 //y=7.4 //x2=1.335 //y2=6.02
cc_29 ( N_noxref_2_M2_noxref_d N_noxref_3_M2_noxref_g ) capacitor c=0.0572684f \
 //x=1.41 //y=5.02 //x2=1.335 //y2=6.02
cc_30 ( N_noxref_2_c_19_n N_noxref_3_c_76_n ) capacitor c=0.0225829f //x=1.48 \
 //y=7.4 //x2=1.26 //y2=4.79
cc_31 ( N_noxref_2_c_18_n N_noxref_3_c_77_n ) capacitor c=0.00701819f //x=0.74 \
 //y=7.4 //x2=0.97 //y2=4.79
cc_32 ( N_noxref_2_c_19_n N_noxref_3_c_77_n ) capacitor c=2.63786e-19 //x=1.48 \
 //y=7.4 //x2=0.97 //y2=4.79
cc_33 ( N_noxref_2_M1_noxref_s N_noxref_3_c_77_n ) capacitor c=0.00524251f \
 //x=0.54 //y=5.02 //x2=0.97 //y2=4.79
cc_34 ( N_noxref_2_c_20_p N_noxref_4_c_118_n ) capacitor c=0.00259275f \
 //x=1.48 //y=7.4 //x2=1.115 //y2=5.24
cc_35 ( N_noxref_2_c_21_p N_noxref_4_c_118_n ) capacitor c=0.0010065f //x=1.47 \
 //y=7.4 //x2=1.115 //y2=5.24
cc_36 ( N_noxref_2_c_19_n N_noxref_4_c_118_n ) capacitor c=0.00295945f \
 //x=1.48 //y=7.4 //x2=1.115 //y2=5.24
cc_37 ( N_noxref_2_M1_noxref_s N_noxref_4_c_118_n ) capacitor c=0.0480012f \
 //x=0.54 //y=5.02 //x2=1.115 //y2=5.24
cc_38 ( N_noxref_2_M2_noxref_d N_noxref_4_c_118_n ) capacitor c=0.0486749f \
 //x=1.41 //y=5.02 //x2=1.115 //y2=5.24
cc_39 ( N_noxref_2_c_20_p N_noxref_4_c_123_n ) capacitor c=0.00199455f \
 //x=1.48 //y=7.4 //x2=1.395 //y2=4.96
cc_40 ( N_noxref_2_c_21_p N_noxref_4_c_123_n ) capacitor c=0.00207359f \
 //x=1.47 //y=7.4 //x2=1.395 //y2=4.96
cc_41 ( N_noxref_2_M2_noxref_d N_noxref_4_c_123_n ) capacitor c=0.0235605f \
 //x=1.41 //y=5.02 //x2=1.395 //y2=4.96
cc_42 ( N_noxref_2_c_18_n N_noxref_4_c_126_n ) capacitor c=0.00685597f \
 //x=0.74 //y=7.4 //x2=1.2 //y2=4.96
cc_43 ( N_noxref_2_c_19_n N_noxref_4_c_127_n ) capacitor c=0.0297606f //x=1.48 \
 //y=7.4 //x2=1.48 //y2=4.875
cc_44 ( N_noxref_2_c_20_p N_noxref_4_c_128_n ) capacitor c=0.0024144f //x=1.48 \
 //y=7.4 //x2=1.115 //y2=5.38
cc_45 ( N_noxref_2_c_21_p N_noxref_4_c_128_n ) capacitor c=0.0137788f //x=1.47 \
 //y=7.4 //x2=1.115 //y2=5.38
cc_46 ( N_noxref_2_c_18_n N_noxref_4_c_128_n ) capacitor c=0.00824382f \
 //x=0.74 //y=7.4 //x2=1.115 //y2=5.38
cc_47 ( N_noxref_2_c_19_n N_noxref_4_c_128_n ) capacitor c=0.00962126f \
 //x=1.48 //y=7.4 //x2=1.115 //y2=5.38
cc_48 ( N_noxref_2_M1_noxref_s N_noxref_4_c_128_n ) capacitor c=0.092379f \
 //x=0.54 //y=5.02 //x2=1.115 //y2=5.38
cc_49 ( N_noxref_2_M2_noxref_d N_noxref_4_c_128_n ) capacitor c=0.0935379f \
 //x=1.41 //y=5.02 //x2=1.115 //y2=5.38
cc_50 ( N_noxref_3_c_80_p N_noxref_4_c_114_n ) capacitor c=0.0012792f //x=0.85 \
 //y=1.255 //x2=1.11 //y2=1.755
cc_51 ( N_noxref_3_c_57_n N_noxref_4_c_114_n ) capacitor c=0.00561986f \
 //x=0.85 //y=1.565 //x2=1.11 //y2=1.755
cc_52 ( N_noxref_3_c_58_n N_noxref_4_c_114_n ) capacitor c=0.00440271f \
 //x=0.85 //y=1.92 //x2=1.11 //y2=1.755
cc_53 ( N_noxref_3_c_83_p N_noxref_4_c_114_n ) capacitor c=0.00967186f \
 //x=1.225 //y=1.41 //x2=1.11 //y2=1.755
cc_54 ( N_noxref_3_c_61_n N_noxref_4_c_114_n ) capacitor c=0.00362207f \
 //x=1.38 //y=1.255 //x2=1.11 //y2=1.755
cc_55 ( N_noxref_3_M1_noxref_g N_noxref_4_c_118_n ) capacitor c=0.00141266f \
 //x=0.895 //y=6.02 //x2=1.115 //y2=5.24
cc_56 ( N_noxref_3_M2_noxref_g N_noxref_4_c_118_n ) capacitor c=0.00377331f \
 //x=1.335 //y=6.02 //x2=1.115 //y2=5.24
cc_57 ( N_noxref_3_c_83_p N_noxref_4_c_115_n ) capacitor c=0.00180253f \
 //x=1.225 //y=1.41 //x2=1.395 //y2=1.84
cc_58 ( N_noxref_3_c_62_n N_noxref_4_c_142_n ) capacitor c=0.00440271f \
 //x=0.74 //y=2.085 //x2=1.195 //y2=1.84
cc_59 ( N_noxref_3_M2_noxref_g N_noxref_4_c_123_n ) capacitor c=0.00966342f \
 //x=1.335 //y=6.02 //x2=1.395 //y2=4.96
cc_60 ( N_noxref_3_M1_noxref_g N_noxref_4_c_126_n ) capacitor c=0.00534267f \
 //x=0.895 //y=6.02 //x2=1.2 //y2=4.96
cc_61 ( N_noxref_3_c_76_n N_noxref_4_c_126_n ) capacitor c=0.00262283f \
 //x=1.26 //y=4.79 //x2=1.2 //y2=4.96
cc_62 ( N_noxref_3_c_53_n N_noxref_4_c_127_n ) capacitor c=0.118761f //x=0.74 \
 //y=4.58 //x2=1.48 //y2=4.875
cc_63 ( N_noxref_3_c_54_n N_noxref_4_c_127_n ) capacitor c=0.00859794f \
 //x=0.74 //y=2.085 //x2=1.48 //y2=4.875
cc_64 ( N_noxref_3_c_55_n N_noxref_4_c_127_n ) capacitor c=0.0023016f //x=0.74 \
 //y=2.085 //x2=1.48 //y2=4.875
cc_65 ( N_noxref_3_c_67_n N_noxref_4_c_127_n ) capacitor c=0.00250262f \
 //x=0.74 //y=4.7 //x2=1.48 //y2=4.875
cc_66 ( N_noxref_3_c_76_n N_noxref_4_c_127_n ) capacitor c=4.08297e-19 \
 //x=1.26 //y=4.79 //x2=1.48 //y2=4.875
cc_67 ( N_noxref_3_c_77_n N_noxref_4_c_127_n ) capacitor c=0.00124564f \
 //x=0.97 //y=4.79 //x2=1.48 //y2=4.875
cc_68 ( N_noxref_3_c_62_n N_noxref_4_c_127_n ) capacitor c=0.00112403f \
 //x=0.74 //y=2.085 //x2=1.48 //y2=4.875
cc_69 ( N_noxref_3_c_56_n N_noxref_4_c_116_n ) capacitor c=0.00187726f \
 //x=0.85 //y=0.91 //x2=1.11 //y2=1.005
cc_70 ( N_noxref_3_c_80_p N_noxref_4_c_116_n ) capacitor c=0.00414335f \
 //x=0.85 //y=1.255 //x2=1.11 //y2=1.005
cc_71 ( N_noxref_3_c_59_n N_noxref_4_c_116_n ) capacitor c=5.57924e-19 \
 //x=1.225 //y=0.755 //x2=1.11 //y2=1.005
cc_72 ( N_noxref_3_c_83_p N_noxref_4_c_116_n ) capacitor c=5.75878e-19 \
 //x=1.225 //y=1.41 //x2=1.11 //y2=1.005
cc_73 ( N_noxref_3_c_60_n N_noxref_4_c_116_n ) capacitor c=0.00160969f \
 //x=1.38 //y=0.91 //x2=1.11 //y2=1.005
cc_74 ( N_noxref_3_c_61_n N_noxref_4_c_116_n ) capacitor c=0.00411132f \
 //x=1.38 //y=1.255 //x2=1.11 //y2=1.005
cc_75 ( N_noxref_3_M1_noxref_g N_noxref_4_c_128_n ) capacitor c=0.0162066f \
 //x=0.895 //y=6.02 //x2=1.115 //y2=5.38
cc_76 ( N_noxref_3_M2_noxref_g N_noxref_4_c_128_n ) capacitor c=0.0162066f \
 //x=1.335 //y=6.02 //x2=1.115 //y2=5.38
cc_77 ( N_noxref_3_c_76_n N_noxref_4_c_128_n ) capacitor c=0.00290963f \
 //x=1.26 //y=4.79 //x2=1.115 //y2=5.38
cc_78 ( N_noxref_3_c_56_n N_noxref_4_M0_noxref_d ) capacitor c=0.00137914f \
 //x=0.85 //y=0.91 //x2=0.925 //y2=0.91
cc_79 ( N_noxref_3_c_80_p N_noxref_4_M0_noxref_d ) capacitor c=0.0023891f \
 //x=0.85 //y=1.255 //x2=0.925 //y2=0.91
cc_80 ( N_noxref_3_c_59_n N_noxref_4_M0_noxref_d ) capacitor c=0.0020782f \
 //x=1.225 //y=0.755 //x2=0.925 //y2=0.91
cc_81 ( N_noxref_3_c_83_p N_noxref_4_M0_noxref_d ) capacitor c=0.00356097f \
 //x=1.225 //y=1.41 //x2=0.925 //y2=0.91
cc_82 ( N_noxref_3_c_60_n N_noxref_4_M0_noxref_d ) capacitor c=0.00138452f \
 //x=1.38 //y=0.91 //x2=0.925 //y2=0.91
cc_83 ( N_noxref_3_c_61_n N_noxref_4_M0_noxref_d ) capacitor c=0.00235934f \
 //x=1.38 //y=1.255 //x2=0.925 //y2=0.91
