// File: DFFQX1.spi.pex
// Created: Tue Apr 29 10:39:36 2025
// Program "Calibre xRC"
// Version "v2023.2_27.15"
// Nominal Temperature: 30C
// Circuit Temperature: 30C
//
simulator lang=spectre
subckt PM_DFFQX1\%GND ( 1 39 43 46 51 61 69 77 83 89 97 105 113 121 132 138 \
 140 143 145 147 151 152 153 154 155 156 )
c269 ( 156 0 ) capacitor c=0.0208018f //x=19.555 //y=1.045
c270 ( 155 0 ) capacitor c=0.0208124f //x=16.225 //y=1.045
c271 ( 154 0 ) capacitor c=0.0208018f //x=12.895 //y=1.045
c272 ( 153 0 ) capacitor c=0.0208018f //x=9.565 //y=1.045
c273 ( 152 0 ) capacitor c=0.0208019f //x=6.235 //y=1.045
c274 ( 151 0 ) capacitor c=0.022675f //x=1.32 //y=1.055
c275 ( 149 0 ) capacitor c=0.00446416f //x=19.675 //y=0.18
c276 ( 147 0 ) capacitor c=0.107189f //x=18.565 //y=0.175
c277 ( 146 0 ) capacitor c=0.00446416f //x=16.415 //y=0.175
c278 ( 145 0 ) capacitor c=0.10772f //x=15.235 //y=0.175
c279 ( 144 0 ) capacitor c=0.00446416f //x=13.085 //y=0.175
c280 ( 143 0 ) capacitor c=0.107189f //x=11.905 //y=0.175
c281 ( 142 0 ) capacitor c=0.00446416f //x=9.685 //y=0.18
c282 ( 140 0 ) capacitor c=0.107345f //x=8.575 //y=0.175
c283 ( 139 0 ) capacitor c=0.00446416f //x=6.425 //y=0.175
c284 ( 138 0 ) capacitor c=0.110122f //x=5.245 //y=0.175
c285 ( 137 0 ) capacitor c=0.00446464f //x=1.51 //y=0.175
c286 ( 132 0 ) capacitor c=0.281768f //x=21.525 //y=0.18
c287 ( 121 0 ) capacitor c=0.0392803f //x=19.66 //y=0.175
c288 ( 113 0 ) capacitor c=0.0733221f //x=18.395 //y=0.175
c289 ( 105 0 ) capacitor c=0.0430284f //x=16.33 //y=0.175
c290 ( 97 0 ) capacitor c=0.0760254f //x=15.065 //y=0.175
c291 ( 89 0 ) capacitor c=0.0392803f //x=13 //y=0.175
c292 ( 83 0 ) capacitor c=0.0729464f //x=11.735 //y=0.175
c293 ( 77 0 ) capacitor c=0.0392803f //x=9.67 //y=0.175
c294 ( 69 0 ) capacitor c=0.0729452f //x=8.405 //y=0.175
c295 ( 61 0 ) capacitor c=0.0392803f //x=6.34 //y=0.175
c296 ( 51 0 ) capacitor c=0.133468f //x=5.075 //y=0.175
c297 ( 46 0 ) capacitor c=0.193806f //x=1.175 //y=0.18
c298 ( 43 0 ) capacitor c=0.0370791f //x=1.425 //y=0.175
c299 ( 39 0 ) capacitor c=0.747694f //x=21.525 //y=0.18
r300 (  130 132 ) resistor r=25.8093 //w=0.367 //l=0.74 //layer=li \
 //thickness=0.1 //x=20.785 //y=0.175 //x2=21.525 //y2=0.175
r301 (  128 149 ) resistor r=2.87058 //w=0.35 //l=0.085 //layer=li \
 //thickness=0.1 //x=19.83 //y=0.175 //x2=19.745 //y2=0.175
r302 (  128 130 ) resistor r=33.3079 //w=0.367 //l=0.955 //layer=li \
 //thickness=0.1 //x=19.83 //y=0.175 //x2=20.785 //y2=0.175
r303 (  123 149 ) resistor r=4.23183 //w=0.7 //l=0.175 //layer=li \
 //thickness=0.1 //x=19.745 //y=0.35 //x2=19.745 //y2=0.175
r304 (  123 156 ) resistor r=53.7326 //w=0.187 //l=0.785 //layer=li \
 //thickness=0.1 //x=19.745 //y=0.35 //x2=19.745 //y2=1.135
r305 (  122 147 ) resistor r=5.29055 //w=0.35 //l=0.17 //layer=li \
 //thickness=0.1 //x=18.735 //y=0.175 //x2=18.565 //y2=0.175
r306 (  121 149 ) resistor r=2.87058 //w=0.35 //l=0.085 //layer=li \
 //thickness=0.1 //x=19.66 //y=0.175 //x2=19.745 //y2=0.175
r307 (  121 122 ) resistor r=32.2616 //w=0.367 //l=0.925 //layer=li \
 //thickness=0.1 //x=19.66 //y=0.175 //x2=18.735 //y2=0.175
r308 (  116 118 ) resistor r=38.7139 //w=0.367 //l=1.11 //layer=li \
 //thickness=0.1 //x=17.085 //y=0.175 //x2=18.195 //y2=0.175
r309 (  114 146 ) resistor r=2.87058 //w=0.35 //l=0.085 //layer=li \
 //thickness=0.1 //x=16.5 //y=0.175 //x2=16.415 //y2=0.175
r310 (  114 116 ) resistor r=20.4033 //w=0.367 //l=0.585 //layer=li \
 //thickness=0.1 //x=16.5 //y=0.175 //x2=17.085 //y2=0.175
r311 (  113 147 ) resistor r=5.29055 //w=0.35 //l=0.17 //layer=li \
 //thickness=0.1 //x=18.395 //y=0.175 //x2=18.565 //y2=0.175
r312 (  113 118 ) resistor r=6.97548 //w=0.367 //l=0.2 //layer=li \
 //thickness=0.1 //x=18.395 //y=0.175 //x2=18.195 //y2=0.175
r313 (  109 146 ) resistor r=4.23183 //w=0.7 //l=0.175 //layer=li \
 //thickness=0.1 //x=16.415 //y=0.35 //x2=16.415 //y2=0.175
r314 (  109 155 ) resistor r=53.7326 //w=0.187 //l=0.785 //layer=li \
 //thickness=0.1 //x=16.415 //y=0.35 //x2=16.415 //y2=1.135
r315 (  106 145 ) resistor r=5.29055 //w=0.35 //l=0.17 //layer=li \
 //thickness=0.1 //x=15.405 //y=0.175 //x2=15.235 //y2=0.175
r316 (  106 108 ) resistor r=19.8801 //w=0.367 //l=0.57 //layer=li \
 //thickness=0.1 //x=15.405 //y=0.175 //x2=15.975 //y2=0.175
r317 (  105 146 ) resistor r=2.87058 //w=0.35 //l=0.085 //layer=li \
 //thickness=0.1 //x=16.33 //y=0.175 //x2=16.415 //y2=0.175
r318 (  105 108 ) resistor r=12.3815 //w=0.367 //l=0.355 //layer=li \
 //thickness=0.1 //x=16.33 //y=0.175 //x2=15.975 //y2=0.175
r319 (  100 102 ) resistor r=38.7139 //w=0.367 //l=1.11 //layer=li \
 //thickness=0.1 //x=13.385 //y=0.175 //x2=14.495 //y2=0.175
r320 (  98 144 ) resistor r=2.87058 //w=0.35 //l=0.085 //layer=li \
 //thickness=0.1 //x=13.17 //y=0.175 //x2=13.085 //y2=0.175
r321 (  98 100 ) resistor r=7.49864 //w=0.367 //l=0.215 //layer=li \
 //thickness=0.1 //x=13.17 //y=0.175 //x2=13.385 //y2=0.175
r322 (  97 145 ) resistor r=5.29055 //w=0.35 //l=0.17 //layer=li \
 //thickness=0.1 //x=15.065 //y=0.175 //x2=15.235 //y2=0.175
r323 (  97 102 ) resistor r=19.8801 //w=0.367 //l=0.57 //layer=li \
 //thickness=0.1 //x=15.065 //y=0.175 //x2=14.495 //y2=0.175
r324 (  93 144 ) resistor r=4.23183 //w=0.7 //l=0.175 //layer=li \
 //thickness=0.1 //x=13.085 //y=0.35 //x2=13.085 //y2=0.175
r325 (  93 154 ) resistor r=53.7326 //w=0.187 //l=0.785 //layer=li \
 //thickness=0.1 //x=13.085 //y=0.35 //x2=13.085 //y2=1.135
r326 (  90 143 ) resistor r=5.29055 //w=0.35 //l=0.17 //layer=li \
 //thickness=0.1 //x=12.075 //y=0.175 //x2=11.905 //y2=0.175
r327 (  90 92 ) resistor r=6.97548 //w=0.367 //l=0.2 //layer=li \
 //thickness=0.1 //x=12.075 //y=0.175 //x2=12.275 //y2=0.175
r328 (  89 144 ) resistor r=2.87058 //w=0.35 //l=0.085 //layer=li \
 //thickness=0.1 //x=13 //y=0.175 //x2=13.085 //y2=0.175
r329 (  89 92 ) resistor r=25.2861 //w=0.367 //l=0.725 //layer=li \
 //thickness=0.1 //x=13 //y=0.175 //x2=12.275 //y2=0.175
r330 (  84 142 ) resistor r=2.87058 //w=0.35 //l=0.085 //layer=li \
 //thickness=0.1 //x=9.84 //y=0.175 //x2=9.755 //y2=0.175
r331 (  84 86 ) resistor r=33.3079 //w=0.367 //l=0.955 //layer=li \
 //thickness=0.1 //x=9.84 //y=0.175 //x2=10.795 //y2=0.175
r332 (  83 143 ) resistor r=5.29055 //w=0.35 //l=0.17 //layer=li \
 //thickness=0.1 //x=11.735 //y=0.175 //x2=11.905 //y2=0.175
r333 (  83 86 ) resistor r=32.7847 //w=0.367 //l=0.94 //layer=li \
 //thickness=0.1 //x=11.735 //y=0.175 //x2=10.795 //y2=0.175
r334 (  79 142 ) resistor r=4.23183 //w=0.7 //l=0.175 //layer=li \
 //thickness=0.1 //x=9.755 //y=0.35 //x2=9.755 //y2=0.175
r335 (  79 153 ) resistor r=53.7326 //w=0.187 //l=0.785 //layer=li \
 //thickness=0.1 //x=9.755 //y=0.35 //x2=9.755 //y2=1.135
r336 (  78 140 ) resistor r=5.29055 //w=0.35 //l=0.17 //layer=li \
 //thickness=0.1 //x=8.745 //y=0.175 //x2=8.575 //y2=0.175
r337 (  77 142 ) resistor r=2.87058 //w=0.35 //l=0.085 //layer=li \
 //thickness=0.1 //x=9.67 //y=0.175 //x2=9.755 //y2=0.175
r338 (  77 78 ) resistor r=32.2616 //w=0.367 //l=0.925 //layer=li \
 //thickness=0.1 //x=9.67 //y=0.175 //x2=8.745 //y2=0.175
r339 (  72 74 ) resistor r=38.7139 //w=0.367 //l=1.11 //layer=li \
 //thickness=0.1 //x=7.095 //y=0.175 //x2=8.205 //y2=0.175
r340 (  70 139 ) resistor r=2.87058 //w=0.35 //l=0.085 //layer=li \
 //thickness=0.1 //x=6.51 //y=0.175 //x2=6.425 //y2=0.175
r341 (  70 72 ) resistor r=20.4033 //w=0.367 //l=0.585 //layer=li \
 //thickness=0.1 //x=6.51 //y=0.175 //x2=7.095 //y2=0.175
r342 (  69 140 ) resistor r=5.29055 //w=0.35 //l=0.17 //layer=li \
 //thickness=0.1 //x=8.405 //y=0.175 //x2=8.575 //y2=0.175
r343 (  69 74 ) resistor r=6.97548 //w=0.367 //l=0.2 //layer=li \
 //thickness=0.1 //x=8.405 //y=0.175 //x2=8.205 //y2=0.175
r344 (  65 139 ) resistor r=4.23183 //w=0.7 //l=0.175 //layer=li \
 //thickness=0.1 //x=6.425 //y=0.35 //x2=6.425 //y2=0.175
r345 (  65 152 ) resistor r=53.7326 //w=0.187 //l=0.785 //layer=li \
 //thickness=0.1 //x=6.425 //y=0.35 //x2=6.425 //y2=1.135
r346 (  62 138 ) resistor r=5.29055 //w=0.35 //l=0.17 //layer=li \
 //thickness=0.1 //x=5.415 //y=0.175 //x2=5.245 //y2=0.175
r347 (  62 64 ) resistor r=19.8801 //w=0.367 //l=0.57 //layer=li \
 //thickness=0.1 //x=5.415 //y=0.175 //x2=5.985 //y2=0.175
r348 (  61 139 ) resistor r=2.87058 //w=0.35 //l=0.085 //layer=li \
 //thickness=0.1 //x=6.34 //y=0.175 //x2=6.425 //y2=0.175
r349 (  61 64 ) resistor r=12.3815 //w=0.367 //l=0.355 //layer=li \
 //thickness=0.1 //x=6.34 //y=0.175 //x2=5.985 //y2=0.175
r350 (  56 58 ) resistor r=38.7139 //w=0.367 //l=1.11 //layer=li \
 //thickness=0.1 //x=3.395 //y=0.175 //x2=4.505 //y2=0.175
r351 (  54 56 ) resistor r=38.7139 //w=0.367 //l=1.11 //layer=li \
 //thickness=0.1 //x=2.285 //y=0.175 //x2=3.395 //y2=0.175
r352 (  52 137 ) resistor r=2.87058 //w=0.35 //l=0.085 //layer=li \
 //thickness=0.1 //x=1.595 //y=0.175 //x2=1.51 //y2=0.175
r353 (  52 54 ) resistor r=24.0654 //w=0.367 //l=0.69 //layer=li \
 //thickness=0.1 //x=1.595 //y=0.175 //x2=2.285 //y2=0.175
r354 (  51 138 ) resistor r=5.29055 //w=0.35 //l=0.17 //layer=li \
 //thickness=0.1 //x=5.075 //y=0.175 //x2=5.245 //y2=0.175
r355 (  51 58 ) resistor r=19.8801 //w=0.367 //l=0.57 //layer=li \
 //thickness=0.1 //x=5.075 //y=0.175 //x2=4.505 //y2=0.175
r356 (  47 137 ) resistor r=4.23183 //w=0.7 //l=0.175 //layer=li \
 //thickness=0.1 //x=1.51 //y=0.35 //x2=1.51 //y2=0.175
r357 (  47 151 ) resistor r=54.4171 //w=0.187 //l=0.795 //layer=li \
 //thickness=0.1 //x=1.51 //y=0.35 //x2=1.51 //y2=1.145
r358 (  43 137 ) resistor r=2.87058 //w=0.35 //l=0.085 //layer=li \
 //thickness=0.1 //x=1.425 //y=0.175 //x2=1.51 //y2=0.175
r359 (  43 46 ) resistor r=8.71935 //w=0.367 //l=0.25 //layer=li \
 //thickness=0.1 //x=1.425 //y=0.175 //x2=1.175 //y2=0.175
r360 (  39 132 ) resistor r=9.3 //w=0.17 //l=0.17 //layer=mcon //count=1 \
 //x=21.525 //y=0.18 //x2=21.525 //y2=0.18
r361 (  37 130 ) resistor r=3.1 //w=0.17 //l=0.51 //layer=mcon //count=3 \
 //x=20.785 //y=0.18 //x2=20.785 //y2=0.18
r362 (  37 39 ) resistor r=0.297428 //w=0.311 //l=0.74 //layer=m1 \
 //thickness=0.36 //x=20.785 //y=0.175 //x2=21.525 //y2=0.175
r363 (  35 149 ) resistor r=3.1 //w=0.17 //l=0.51 //layer=mcon //count=3 \
 //x=19.675 //y=0.18 //x2=19.675 //y2=0.18
r364 (  35 37 ) resistor r=0.446141 //w=0.311 //l=1.11 //layer=m1 \
 //thickness=0.36 //x=19.675 //y=0.175 //x2=20.785 //y2=0.175
r365 (  33 118 ) resistor r=3.1 //w=0.17 //l=0.51 //layer=mcon //count=3 \
 //x=18.195 //y=0.18 //x2=18.195 //y2=0.18
r366 (  33 35 ) resistor r=0.594855 //w=0.311 //l=1.48 //layer=m1 \
 //thickness=0.36 //x=18.195 //y=0.175 //x2=19.675 //y2=0.175
r367 (  31 116 ) resistor r=3.1 //w=0.17 //l=0.51 //layer=mcon //count=3 \
 //x=17.085 //y=0.18 //x2=17.085 //y2=0.18
r368 (  31 33 ) resistor r=0.446141 //w=0.311 //l=1.11 //layer=m1 \
 //thickness=0.36 //x=17.085 //y=0.175 //x2=18.195 //y2=0.175
r369 (  29 108 ) resistor r=3.1 //w=0.17 //l=0.51 //layer=mcon //count=3 \
 //x=15.975 //y=0.18 //x2=15.975 //y2=0.18
r370 (  29 31 ) resistor r=0.446141 //w=0.311 //l=1.11 //layer=m1 \
 //thickness=0.36 //x=15.975 //y=0.175 //x2=17.085 //y2=0.175
r371 (  27 102 ) resistor r=3.1 //w=0.17 //l=0.51 //layer=mcon //count=3 \
 //x=14.495 //y=0.18 //x2=14.495 //y2=0.18
r372 (  27 29 ) resistor r=0.594855 //w=0.311 //l=1.48 //layer=m1 \
 //thickness=0.36 //x=14.495 //y=0.175 //x2=15.975 //y2=0.175
r373 (  25 100 ) resistor r=3.1 //w=0.17 //l=0.51 //layer=mcon //count=3 \
 //x=13.385 //y=0.18 //x2=13.385 //y2=0.18
r374 (  25 27 ) resistor r=0.446141 //w=0.311 //l=1.11 //layer=m1 \
 //thickness=0.36 //x=13.385 //y=0.175 //x2=14.495 //y2=0.175
r375 (  23 92 ) resistor r=3.1 //w=0.17 //l=0.51 //layer=mcon //count=3 \
 //x=12.275 //y=0.18 //x2=12.275 //y2=0.18
r376 (  23 25 ) resistor r=0.446141 //w=0.311 //l=1.11 //layer=m1 \
 //thickness=0.36 //x=12.275 //y=0.175 //x2=13.385 //y2=0.175
r377 (  20 86 ) resistor r=3.1 //w=0.17 //l=0.51 //layer=mcon //count=3 \
 //x=10.795 //y=0.18 //x2=10.795 //y2=0.18
r378 (  18 142 ) resistor r=3.1 //w=0.17 //l=0.51 //layer=mcon //count=3 \
 //x=9.685 //y=0.18 //x2=9.685 //y2=0.18
r379 (  18 20 ) resistor r=0.446141 //w=0.311 //l=1.11 //layer=m1 \
 //thickness=0.36 //x=9.685 //y=0.175 //x2=10.795 //y2=0.175
r380 (  16 74 ) resistor r=3.1 //w=0.17 //l=0.51 //layer=mcon //count=3 \
 //x=8.205 //y=0.18 //x2=8.205 //y2=0.18
r381 (  16 18 ) resistor r=0.594855 //w=0.311 //l=1.48 //layer=m1 \
 //thickness=0.36 //x=8.205 //y=0.175 //x2=9.685 //y2=0.175
r382 (  14 72 ) resistor r=3.1 //w=0.17 //l=0.51 //layer=mcon //count=3 \
 //x=7.095 //y=0.18 //x2=7.095 //y2=0.18
r383 (  14 16 ) resistor r=0.446141 //w=0.311 //l=1.11 //layer=m1 \
 //thickness=0.36 //x=7.095 //y=0.175 //x2=8.205 //y2=0.175
r384 (  12 64 ) resistor r=3.1 //w=0.17 //l=0.51 //layer=mcon //count=3 \
 //x=5.985 //y=0.18 //x2=5.985 //y2=0.18
r385 (  12 14 ) resistor r=0.446141 //w=0.311 //l=1.11 //layer=m1 \
 //thickness=0.36 //x=5.985 //y=0.175 //x2=7.095 //y2=0.175
r386 (  10 58 ) resistor r=3.1 //w=0.17 //l=0.51 //layer=mcon //count=3 \
 //x=4.505 //y=0.18 //x2=4.505 //y2=0.18
r387 (  10 12 ) resistor r=0.594855 //w=0.311 //l=1.48 //layer=m1 \
 //thickness=0.36 //x=4.505 //y=0.175 //x2=5.985 //y2=0.175
r388 (  8 56 ) resistor r=3.1 //w=0.17 //l=0.51 //layer=mcon //count=3 \
 //x=3.395 //y=0.18 //x2=3.395 //y2=0.18
r389 (  8 10 ) resistor r=0.446141 //w=0.311 //l=1.11 //layer=m1 \
 //thickness=0.36 //x=3.395 //y=0.175 //x2=4.505 //y2=0.175
r390 (  6 54 ) resistor r=3.1 //w=0.17 //l=0.51 //layer=mcon //count=3 \
 //x=2.285 //y=0.18 //x2=2.285 //y2=0.18
r391 (  6 8 ) resistor r=0.446141 //w=0.311 //l=1.11 //layer=m1 \
 //thickness=0.36 //x=2.285 //y=0.175 //x2=3.395 //y2=0.175
r392 (  3 46 ) resistor r=3.1 //w=0.17 //l=0.51 //layer=mcon //count=3 \
 //x=1.175 //y=0.18 //x2=1.175 //y2=0.18
r393 (  3 6 ) resistor r=0.446141 //w=0.311 //l=1.11 //layer=m1 \
 //thickness=0.36 //x=1.175 //y=0.175 //x2=2.285 //y2=0.175
r394 (  1 23 ) resistor r=0.424035 //w=0.311 //l=1.055 //layer=m1 \
 //thickness=0.36 //x=11.22 //y=0.175 //x2=12.275 //y2=0.175
r395 (  1 20 ) resistor r=0.17082 //w=0.311 //l=0.425 //layer=m1 \
 //thickness=0.36 //x=11.22 //y=0.175 //x2=10.795 //y2=0.175
ends PM_DFFQX1\%GND

subckt PM_DFFQX1\%VDD ( 1 39 46 53 63 71 81 87 95 103 113 119 127 137 147 151 \
 161 171 179 183 191 199 209 215 223 233 246 255 260 264 269 274 279 280 281 \
 282 283 284 285 286 287 288 289 290 291 292 293 294 295 296 297 )
c297 ( 297 0 ) capacitor c=0.0382077f //x=20.97 //y=5.2
c298 ( 296 0 ) capacitor c=0.0240874f //x=20.09 //y=5.2
c299 ( 295 0 ) capacitor c=0.0493661f //x=19.22 //y=5.2
c300 ( 294 0 ) capacitor c=0.0381506f //x=17.64 //y=5.2
c301 ( 293 0 ) capacitor c=0.0240879f //x=16.76 //y=5.2
c302 ( 292 0 ) capacitor c=0.0493661f //x=15.89 //y=5.2
c303 ( 291 0 ) capacitor c=0.0381451f //x=14.31 //y=5.2
c304 ( 290 0 ) capacitor c=0.0240074f //x=13.43 //y=5.2
c305 ( 289 0 ) capacitor c=0.0490306f //x=12.56 //y=5.2
c306 ( 288 0 ) capacitor c=0.038068f //x=10.98 //y=5.2
c307 ( 287 0 ) capacitor c=0.0240081f //x=10.1 //y=5.2
c308 ( 286 0 ) capacitor c=0.0490306f //x=9.23 //y=5.2
c309 ( 285 0 ) capacitor c=0.038068f //x=7.65 //y=5.2
c310 ( 284 0 ) capacitor c=0.0240081f //x=6.77 //y=5.2
c311 ( 283 0 ) capacitor c=0.0492093f //x=5.9 //y=5.2
c312 ( 282 0 ) capacitor c=0.045218f //x=4.02 //y=5.2
c313 ( 281 0 ) capacitor c=0.0241521f //x=3.14 //y=5.2
c314 ( 280 0 ) capacitor c=0.0242401f //x=2.26 //y=5.2
c315 ( 279 0 ) capacitor c=0.0531407f //x=1.39 //y=5.2
c316 ( 277 0 ) capacitor c=0.00597439f //x=21.115 //y=7.585
c317 ( 276 0 ) capacitor c=0.00597439f //x=20.235 //y=7.585
c318 ( 275 0 ) capacitor c=0.00597439f //x=19.355 //y=7.585
c319 ( 274 0 ) capacitor c=0.116807f //x=18.565 //y=7.585
c320 ( 273 0 ) capacitor c=0.00597439f //x=17.785 //y=7.585
c321 ( 272 0 ) capacitor c=0.00597439f //x=16.905 //y=7.585
c322 ( 271 0 ) capacitor c=0.00597439f //x=15.975 //y=7.58
c323 ( 269 0 ) capacitor c=0.116287f //x=15.235 //y=7.585
c324 ( 268 0 ) capacitor c=0.00597439f //x=14.495 //y=7.58
c325 ( 266 0 ) capacitor c=0.00597439f //x=13.575 //y=7.585
c326 ( 265 0 ) capacitor c=0.00597439f //x=12.695 //y=7.585
c327 ( 264 0 ) capacitor c=0.114485f //x=11.905 //y=7.585
c328 ( 263 0 ) capacitor c=0.00597439f //x=11.125 //y=7.585
c329 ( 262 0 ) capacitor c=0.00597439f //x=10.245 //y=7.585
c330 ( 261 0 ) capacitor c=0.00597439f //x=9.365 //y=7.585
c331 ( 260 0 ) capacitor c=0.114614f //x=8.575 //y=7.585
c332 ( 259 0 ) capacitor c=0.00597439f //x=7.795 //y=7.585
c333 ( 258 0 ) capacitor c=0.00597439f //x=6.915 //y=7.585
c334 ( 257 0 ) capacitor c=0.00597439f //x=5.985 //y=7.58
c335 ( 255 0 ) capacitor c=0.134694f //x=5.245 //y=7.585
c336 ( 254 0 ) capacitor c=0.00597439f //x=4.165 //y=7.585
c337 ( 253 0 ) capacitor c=0.00597439f //x=3.285 //y=7.585
c338 ( 252 0 ) capacitor c=0.00597439f //x=2.405 //y=7.585
c339 ( 251 0 ) capacitor c=0.00597439f //x=1.525 //y=7.585
c340 ( 246 0 ) capacitor c=0.259038f //x=21.525 //y=7.58
c341 ( 233 0 ) capacitor c=0.028702f //x=21.03 //y=7.585
c342 ( 223 0 ) capacitor c=0.0291291f //x=20.15 //y=7.585
c343 ( 215 0 ) capacitor c=0.024303f //x=19.27 //y=7.585
c344 ( 209 0 ) capacitor c=0.0238235f //x=18.395 //y=7.585
c345 ( 199 0 ) capacitor c=0.0291288f //x=17.7 //y=7.585
c346 ( 191 0 ) capacitor c=0.0291291f //x=16.82 //y=7.585
c347 ( 183 0 ) capacitor c=0.024303f //x=15.94 //y=7.585
c348 ( 179 0 ) capacitor c=0.0238958f //x=15.065 //y=7.585
c349 ( 171 0 ) capacitor c=0.0291247f //x=14.37 //y=7.585
c350 ( 161 0 ) capacitor c=0.0291028f //x=13.49 //y=7.585
c351 ( 151 0 ) capacitor c=0.024303f //x=12.61 //y=7.585
c352 ( 147 0 ) capacitor c=0.0238235f //x=11.735 //y=7.585
c353 ( 137 0 ) capacitor c=0.0291008f //x=11.04 //y=7.585
c354 ( 127 0 ) capacitor c=0.0291028f //x=10.16 //y=7.585
c355 ( 119 0 ) capacitor c=0.024303f //x=9.28 //y=7.585
c356 ( 113 0 ) capacitor c=0.0238235f //x=8.405 //y=7.585
c357 ( 103 0 ) capacitor c=0.0291008f //x=7.71 //y=7.585
c358 ( 95 0 ) capacitor c=0.0291028f //x=6.83 //y=7.585
c359 ( 87 0 ) capacitor c=0.024303f //x=5.95 //y=7.585
c360 ( 81 0 ) capacitor c=0.0397734f //x=5.075 //y=7.585
c361 ( 71 0 ) capacitor c=0.0291138f //x=4.08 //y=7.585
c362 ( 63 0 ) capacitor c=0.0291349f //x=3.2 //y=7.585
c363 ( 53 0 ) capacitor c=0.0287792f //x=2.32 //y=7.585
c364 ( 46 0 ) capacitor c=0.249947f //x=1.175 //y=7.58
c365 ( 43 0 ) capacitor c=0.0455283f //x=1.44 //y=7.585
c366 ( 39 0 ) capacitor c=0.782061f //x=21.525 //y=7.58
r367 (  244 277 ) resistor r=2.87058 //w=0.35 //l=0.085 //layer=li \
 //thickness=0.1 //x=21.2 //y=7.585 //x2=21.115 //y2=7.585
r368 (  244 246 ) resistor r=11.3351 //w=0.367 //l=0.325 //layer=li \
 //thickness=0.1 //x=21.2 //y=7.585 //x2=21.525 //y2=7.585
r369 (  237 277 ) resistor r=4.23183 //w=0.7 //l=0.175 //layer=li \
 //thickness=0.1 //x=21.115 //y=7.41 //x2=21.115 //y2=7.585
r370 (  237 297 ) resistor r=33.1979 //w=0.187 //l=0.485 //layer=li \
 //thickness=0.1 //x=21.115 //y=7.41 //x2=21.115 //y2=6.925
r371 (  234 276 ) resistor r=2.87058 //w=0.35 //l=0.085 //layer=li \
 //thickness=0.1 //x=20.32 //y=7.585 //x2=20.235 //y2=7.585
r372 (  234 236 ) resistor r=16.218 //w=0.367 //l=0.465 //layer=li \
 //thickness=0.1 //x=20.32 //y=7.585 //x2=20.785 //y2=7.585
r373 (  233 277 ) resistor r=2.87058 //w=0.35 //l=0.085 //layer=li \
 //thickness=0.1 //x=21.03 //y=7.585 //x2=21.115 //y2=7.585
r374 (  233 236 ) resistor r=8.54496 //w=0.367 //l=0.245 //layer=li \
 //thickness=0.1 //x=21.03 //y=7.585 //x2=20.785 //y2=7.585
r375 (  227 276 ) resistor r=4.23183 //w=0.7 //l=0.175 //layer=li \
 //thickness=0.1 //x=20.235 //y=7.41 //x2=20.235 //y2=7.585
r376 (  227 296 ) resistor r=33.1979 //w=0.187 //l=0.485 //layer=li \
 //thickness=0.1 //x=20.235 //y=7.41 //x2=20.235 //y2=6.925
r377 (  224 275 ) resistor r=2.87058 //w=0.35 //l=0.085 //layer=li \
 //thickness=0.1 //x=19.44 //y=7.585 //x2=19.355 //y2=7.585
r378 (  224 226 ) resistor r=8.19619 //w=0.367 //l=0.235 //layer=li \
 //thickness=0.1 //x=19.44 //y=7.585 //x2=19.675 //y2=7.585
r379 (  223 276 ) resistor r=2.87058 //w=0.35 //l=0.085 //layer=li \
 //thickness=0.1 //x=20.15 //y=7.585 //x2=20.235 //y2=7.585
r380 (  223 226 ) resistor r=16.5668 //w=0.367 //l=0.475 //layer=li \
 //thickness=0.1 //x=20.15 //y=7.585 //x2=19.675 //y2=7.585
r381 (  217 275 ) resistor r=4.23183 //w=0.7 //l=0.175 //layer=li \
 //thickness=0.1 //x=19.355 //y=7.41 //x2=19.355 //y2=7.585
r382 (  217 295 ) resistor r=56.4706 //w=0.187 //l=0.825 //layer=li \
 //thickness=0.1 //x=19.355 //y=7.41 //x2=19.355 //y2=6.585
r383 (  216 274 ) resistor r=5.29055 //w=0.35 //l=0.17 //layer=li \
 //thickness=0.1 //x=18.735 //y=7.585 //x2=18.565 //y2=7.585
r384 (  215 275 ) resistor r=2.87058 //w=0.35 //l=0.085 //layer=li \
 //thickness=0.1 //x=19.27 //y=7.585 //x2=19.355 //y2=7.585
r385 (  215 216 ) resistor r=18.6594 //w=0.367 //l=0.535 //layer=li \
 //thickness=0.1 //x=19.27 //y=7.585 //x2=18.735 //y2=7.585
r386 (  210 273 ) resistor r=2.87058 //w=0.35 //l=0.085 //layer=li \
 //thickness=0.1 //x=17.87 //y=7.585 //x2=17.785 //y2=7.585
r387 (  210 212 ) resistor r=11.3351 //w=0.367 //l=0.325 //layer=li \
 //thickness=0.1 //x=17.87 //y=7.585 //x2=18.195 //y2=7.585
r388 (  209 274 ) resistor r=5.29055 //w=0.35 //l=0.17 //layer=li \
 //thickness=0.1 //x=18.395 //y=7.585 //x2=18.565 //y2=7.585
r389 (  209 212 ) resistor r=6.97548 //w=0.367 //l=0.2 //layer=li \
 //thickness=0.1 //x=18.395 //y=7.585 //x2=18.195 //y2=7.585
r390 (  203 273 ) resistor r=4.23183 //w=0.7 //l=0.175 //layer=li \
 //thickness=0.1 //x=17.785 //y=7.41 //x2=17.785 //y2=7.585
r391 (  203 294 ) resistor r=33.1979 //w=0.187 //l=0.485 //layer=li \
 //thickness=0.1 //x=17.785 //y=7.41 //x2=17.785 //y2=6.925
r392 (  200 272 ) resistor r=2.87058 //w=0.35 //l=0.085 //layer=li \
 //thickness=0.1 //x=16.99 //y=7.585 //x2=16.905 //y2=7.585
r393 (  200 202 ) resistor r=3.31335 //w=0.367 //l=0.095 //layer=li \
 //thickness=0.1 //x=16.99 //y=7.585 //x2=17.085 //y2=7.585
r394 (  199 273 ) resistor r=2.87058 //w=0.35 //l=0.085 //layer=li \
 //thickness=0.1 //x=17.7 //y=7.585 //x2=17.785 //y2=7.585
r395 (  199 202 ) resistor r=21.4496 //w=0.367 //l=0.615 //layer=li \
 //thickness=0.1 //x=17.7 //y=7.585 //x2=17.085 //y2=7.585
r396 (  193 272 ) resistor r=4.23183 //w=0.7 //l=0.175 //layer=li \
 //thickness=0.1 //x=16.905 //y=7.41 //x2=16.905 //y2=7.585
r397 (  193 293 ) resistor r=33.1979 //w=0.187 //l=0.485 //layer=li \
 //thickness=0.1 //x=16.905 //y=7.41 //x2=16.905 //y2=6.925
r398 (  192 271 ) resistor r=2.87058 //w=0.35 //l=0.085 //layer=li \
 //thickness=0.1 //x=16.11 //y=7.585 //x2=16.025 //y2=7.585
r399 (  191 272 ) resistor r=2.87058 //w=0.35 //l=0.085 //layer=li \
 //thickness=0.1 //x=16.82 //y=7.585 //x2=16.905 //y2=7.585
r400 (  191 192 ) resistor r=24.7629 //w=0.367 //l=0.71 //layer=li \
 //thickness=0.1 //x=16.82 //y=7.585 //x2=16.11 //y2=7.585
r401 (  185 271 ) resistor r=4.23183 //w=0.7 //l=0.175 //layer=li \
 //thickness=0.1 //x=16.025 //y=7.41 //x2=16.025 //y2=7.585
r402 (  185 292 ) resistor r=56.4706 //w=0.187 //l=0.825 //layer=li \
 //thickness=0.1 //x=16.025 //y=7.41 //x2=16.025 //y2=6.585
r403 (  184 269 ) resistor r=5.29055 //w=0.35 //l=0.17 //layer=li \
 //thickness=0.1 //x=15.405 //y=7.585 //x2=15.235 //y2=7.585
r404 (  183 271 ) resistor r=2.87058 //w=0.35 //l=0.085 //layer=li \
 //thickness=0.1 //x=15.94 //y=7.585 //x2=16.025 //y2=7.585
r405 (  183 184 ) resistor r=18.6594 //w=0.367 //l=0.535 //layer=li \
 //thickness=0.1 //x=15.94 //y=7.585 //x2=15.405 //y2=7.585
r406 (  180 268 ) resistor r=2.87058 //w=0.35 //l=0.085 //layer=li \
 //thickness=0.1 //x=14.54 //y=7.585 //x2=14.455 //y2=7.585
r407 (  179 269 ) resistor r=5.29055 //w=0.35 //l=0.17 //layer=li \
 //thickness=0.1 //x=15.065 //y=7.585 //x2=15.235 //y2=7.585
r408 (  179 180 ) resistor r=18.3106 //w=0.367 //l=0.525 //layer=li \
 //thickness=0.1 //x=15.065 //y=7.585 //x2=14.54 //y2=7.585
r409 (  173 268 ) resistor r=4.23183 //w=0.7 //l=0.175 //layer=li \
 //thickness=0.1 //x=14.455 //y=7.41 //x2=14.455 //y2=7.585
r410 (  173 291 ) resistor r=33.1979 //w=0.187 //l=0.485 //layer=li \
 //thickness=0.1 //x=14.455 //y=7.41 //x2=14.455 //y2=6.925
r411 (  172 266 ) resistor r=2.87058 //w=0.35 //l=0.085 //layer=li \
 //thickness=0.1 //x=13.66 //y=7.585 //x2=13.575 //y2=7.585
r412 (  171 268 ) resistor r=2.87058 //w=0.35 //l=0.085 //layer=li \
 //thickness=0.1 //x=14.37 //y=7.585 //x2=14.455 //y2=7.585
r413 (  171 172 ) resistor r=24.7629 //w=0.367 //l=0.71 //layer=li \
 //thickness=0.1 //x=14.37 //y=7.585 //x2=13.66 //y2=7.585
r414 (  165 266 ) resistor r=4.23183 //w=0.7 //l=0.175 //layer=li \
 //thickness=0.1 //x=13.575 //y=7.41 //x2=13.575 //y2=7.585
r415 (  165 290 ) resistor r=33.1979 //w=0.187 //l=0.485 //layer=li \
 //thickness=0.1 //x=13.575 //y=7.41 //x2=13.575 //y2=6.925
r416 (  162 265 ) resistor r=2.87058 //w=0.35 //l=0.085 //layer=li \
 //thickness=0.1 //x=12.78 //y=7.585 //x2=12.695 //y2=7.585
r417 (  162 164 ) resistor r=21.1008 //w=0.367 //l=0.605 //layer=li \
 //thickness=0.1 //x=12.78 //y=7.585 //x2=13.385 //y2=7.585
r418 (  161 266 ) resistor r=2.87058 //w=0.35 //l=0.085 //layer=li \
 //thickness=0.1 //x=13.49 //y=7.585 //x2=13.575 //y2=7.585
r419 (  161 164 ) resistor r=3.66213 //w=0.367 //l=0.105 //layer=li \
 //thickness=0.1 //x=13.49 //y=7.585 //x2=13.385 //y2=7.585
r420 (  155 265 ) resistor r=4.23183 //w=0.7 //l=0.175 //layer=li \
 //thickness=0.1 //x=12.695 //y=7.41 //x2=12.695 //y2=7.585
r421 (  155 289 ) resistor r=56.4706 //w=0.187 //l=0.825 //layer=li \
 //thickness=0.1 //x=12.695 //y=7.41 //x2=12.695 //y2=6.585
r422 (  152 264 ) resistor r=5.29055 //w=0.35 //l=0.17 //layer=li \
 //thickness=0.1 //x=12.075 //y=7.585 //x2=11.905 //y2=7.585
r423 (  152 154 ) resistor r=6.97548 //w=0.367 //l=0.2 //layer=li \
 //thickness=0.1 //x=12.075 //y=7.585 //x2=12.275 //y2=7.585
r424 (  151 265 ) resistor r=2.87058 //w=0.35 //l=0.085 //layer=li \
 //thickness=0.1 //x=12.61 //y=7.585 //x2=12.695 //y2=7.585
r425 (  151 154 ) resistor r=11.6839 //w=0.367 //l=0.335 //layer=li \
 //thickness=0.1 //x=12.61 //y=7.585 //x2=12.275 //y2=7.585
r426 (  148 263 ) resistor r=2.87058 //w=0.35 //l=0.085 //layer=li \
 //thickness=0.1 //x=11.21 //y=7.585 //x2=11.125 //y2=7.585
r427 (  147 264 ) resistor r=5.29055 //w=0.35 //l=0.17 //layer=li \
 //thickness=0.1 //x=11.735 //y=7.585 //x2=11.905 //y2=7.585
r428 (  147 148 ) resistor r=18.3106 //w=0.367 //l=0.525 //layer=li \
 //thickness=0.1 //x=11.735 //y=7.585 //x2=11.21 //y2=7.585
r429 (  141 263 ) resistor r=4.23183 //w=0.7 //l=0.175 //layer=li \
 //thickness=0.1 //x=11.125 //y=7.41 //x2=11.125 //y2=7.585
r430 (  141 288 ) resistor r=33.1979 //w=0.187 //l=0.485 //layer=li \
 //thickness=0.1 //x=11.125 //y=7.41 //x2=11.125 //y2=6.925
r431 (  138 262 ) resistor r=2.87058 //w=0.35 //l=0.085 //layer=li \
 //thickness=0.1 //x=10.33 //y=7.585 //x2=10.245 //y2=7.585
r432 (  138 140 ) resistor r=16.218 //w=0.367 //l=0.465 //layer=li \
 //thickness=0.1 //x=10.33 //y=7.585 //x2=10.795 //y2=7.585
r433 (  137 263 ) resistor r=2.87058 //w=0.35 //l=0.085 //layer=li \
 //thickness=0.1 //x=11.04 //y=7.585 //x2=11.125 //y2=7.585
r434 (  137 140 ) resistor r=8.54496 //w=0.367 //l=0.245 //layer=li \
 //thickness=0.1 //x=11.04 //y=7.585 //x2=10.795 //y2=7.585
r435 (  131 262 ) resistor r=4.23183 //w=0.7 //l=0.175 //layer=li \
 //thickness=0.1 //x=10.245 //y=7.41 //x2=10.245 //y2=7.585
r436 (  131 287 ) resistor r=33.1979 //w=0.187 //l=0.485 //layer=li \
 //thickness=0.1 //x=10.245 //y=7.41 //x2=10.245 //y2=6.925
r437 (  128 261 ) resistor r=2.87058 //w=0.35 //l=0.085 //layer=li \
 //thickness=0.1 //x=9.45 //y=7.585 //x2=9.365 //y2=7.585
r438 (  128 130 ) resistor r=8.19619 //w=0.367 //l=0.235 //layer=li \
 //thickness=0.1 //x=9.45 //y=7.585 //x2=9.685 //y2=7.585
r439 (  127 262 ) resistor r=2.87058 //w=0.35 //l=0.085 //layer=li \
 //thickness=0.1 //x=10.16 //y=7.585 //x2=10.245 //y2=7.585
r440 (  127 130 ) resistor r=16.5668 //w=0.367 //l=0.475 //layer=li \
 //thickness=0.1 //x=10.16 //y=7.585 //x2=9.685 //y2=7.585
r441 (  121 261 ) resistor r=4.23183 //w=0.7 //l=0.175 //layer=li \
 //thickness=0.1 //x=9.365 //y=7.41 //x2=9.365 //y2=7.585
r442 (  121 286 ) resistor r=56.4706 //w=0.187 //l=0.825 //layer=li \
 //thickness=0.1 //x=9.365 //y=7.41 //x2=9.365 //y2=6.585
r443 (  120 260 ) resistor r=5.29055 //w=0.35 //l=0.17 //layer=li \
 //thickness=0.1 //x=8.745 //y=7.585 //x2=8.575 //y2=7.585
r444 (  119 261 ) resistor r=2.87058 //w=0.35 //l=0.085 //layer=li \
 //thickness=0.1 //x=9.28 //y=7.585 //x2=9.365 //y2=7.585
r445 (  119 120 ) resistor r=18.6594 //w=0.367 //l=0.535 //layer=li \
 //thickness=0.1 //x=9.28 //y=7.585 //x2=8.745 //y2=7.585
r446 (  114 259 ) resistor r=2.87058 //w=0.35 //l=0.085 //layer=li \
 //thickness=0.1 //x=7.88 //y=7.585 //x2=7.795 //y2=7.585
r447 (  114 116 ) resistor r=11.3351 //w=0.367 //l=0.325 //layer=li \
 //thickness=0.1 //x=7.88 //y=7.585 //x2=8.205 //y2=7.585
r448 (  113 260 ) resistor r=5.29055 //w=0.35 //l=0.17 //layer=li \
 //thickness=0.1 //x=8.405 //y=7.585 //x2=8.575 //y2=7.585
r449 (  113 116 ) resistor r=6.97548 //w=0.367 //l=0.2 //layer=li \
 //thickness=0.1 //x=8.405 //y=7.585 //x2=8.205 //y2=7.585
r450 (  107 259 ) resistor r=4.23183 //w=0.7 //l=0.175 //layer=li \
 //thickness=0.1 //x=7.795 //y=7.41 //x2=7.795 //y2=7.585
r451 (  107 285 ) resistor r=33.1979 //w=0.187 //l=0.485 //layer=li \
 //thickness=0.1 //x=7.795 //y=7.41 //x2=7.795 //y2=6.925
r452 (  104 258 ) resistor r=2.87058 //w=0.35 //l=0.085 //layer=li \
 //thickness=0.1 //x=7 //y=7.585 //x2=6.915 //y2=7.585
r453 (  104 106 ) resistor r=3.31335 //w=0.367 //l=0.095 //layer=li \
 //thickness=0.1 //x=7 //y=7.585 //x2=7.095 //y2=7.585
r454 (  103 259 ) resistor r=2.87058 //w=0.35 //l=0.085 //layer=li \
 //thickness=0.1 //x=7.71 //y=7.585 //x2=7.795 //y2=7.585
r455 (  103 106 ) resistor r=21.4496 //w=0.367 //l=0.615 //layer=li \
 //thickness=0.1 //x=7.71 //y=7.585 //x2=7.095 //y2=7.585
r456 (  97 258 ) resistor r=4.23183 //w=0.7 //l=0.175 //layer=li \
 //thickness=0.1 //x=6.915 //y=7.41 //x2=6.915 //y2=7.585
r457 (  97 284 ) resistor r=33.1979 //w=0.187 //l=0.485 //layer=li \
 //thickness=0.1 //x=6.915 //y=7.41 //x2=6.915 //y2=6.925
r458 (  96 257 ) resistor r=2.87058 //w=0.35 //l=0.085 //layer=li \
 //thickness=0.1 //x=6.12 //y=7.585 //x2=6.035 //y2=7.585
r459 (  95 258 ) resistor r=2.87058 //w=0.35 //l=0.085 //layer=li \
 //thickness=0.1 //x=6.83 //y=7.585 //x2=6.915 //y2=7.585
r460 (  95 96 ) resistor r=24.7629 //w=0.367 //l=0.71 //layer=li \
 //thickness=0.1 //x=6.83 //y=7.585 //x2=6.12 //y2=7.585
r461 (  89 257 ) resistor r=4.23183 //w=0.7 //l=0.175 //layer=li \
 //thickness=0.1 //x=6.035 //y=7.41 //x2=6.035 //y2=7.585
r462 (  89 283 ) resistor r=56.4706 //w=0.187 //l=0.825 //layer=li \
 //thickness=0.1 //x=6.035 //y=7.41 //x2=6.035 //y2=6.585
r463 (  88 255 ) resistor r=5.29055 //w=0.35 //l=0.17 //layer=li \
 //thickness=0.1 //x=5.415 //y=7.585 //x2=5.245 //y2=7.585
r464 (  87 257 ) resistor r=2.87058 //w=0.35 //l=0.085 //layer=li \
 //thickness=0.1 //x=5.95 //y=7.585 //x2=6.035 //y2=7.585
r465 (  87 88 ) resistor r=18.6594 //w=0.367 //l=0.535 //layer=li \
 //thickness=0.1 //x=5.95 //y=7.585 //x2=5.415 //y2=7.585
r466 (  82 254 ) resistor r=2.87058 //w=0.35 //l=0.085 //layer=li \
 //thickness=0.1 //x=4.25 //y=7.585 //x2=4.165 //y2=7.585
r467 (  82 84 ) resistor r=8.89373 //w=0.367 //l=0.255 //layer=li \
 //thickness=0.1 //x=4.25 //y=7.585 //x2=4.505 //y2=7.585
r468 (  81 255 ) resistor r=5.29055 //w=0.35 //l=0.17 //layer=li \
 //thickness=0.1 //x=5.075 //y=7.585 //x2=5.245 //y2=7.585
r469 (  81 84 ) resistor r=19.8801 //w=0.367 //l=0.57 //layer=li \
 //thickness=0.1 //x=5.075 //y=7.585 //x2=4.505 //y2=7.585
r470 (  75 254 ) resistor r=4.23183 //w=0.7 //l=0.175 //layer=li \
 //thickness=0.1 //x=4.165 //y=7.41 //x2=4.165 //y2=7.585
r471 (  75 282 ) resistor r=33.1979 //w=0.187 //l=0.485 //layer=li \
 //thickness=0.1 //x=4.165 //y=7.41 //x2=4.165 //y2=6.925
r472 (  72 253 ) resistor r=2.87058 //w=0.35 //l=0.085 //layer=li \
 //thickness=0.1 //x=3.37 //y=7.585 //x2=3.285 //y2=7.585
r473 (  72 74 ) resistor r=0.871935 //w=0.367 //l=0.025 //layer=li \
 //thickness=0.1 //x=3.37 //y=7.585 //x2=3.395 //y2=7.585
r474 (  71 254 ) resistor r=2.87058 //w=0.35 //l=0.085 //layer=li \
 //thickness=0.1 //x=4.08 //y=7.585 //x2=4.165 //y2=7.585
r475 (  71 74 ) resistor r=23.891 //w=0.367 //l=0.685 //layer=li \
 //thickness=0.1 //x=4.08 //y=7.585 //x2=3.395 //y2=7.585
r476 (  65 253 ) resistor r=4.23183 //w=0.7 //l=0.175 //layer=li \
 //thickness=0.1 //x=3.285 //y=7.41 //x2=3.285 //y2=7.585
r477 (  65 281 ) resistor r=33.1979 //w=0.187 //l=0.485 //layer=li \
 //thickness=0.1 //x=3.285 //y=7.41 //x2=3.285 //y2=6.925
r478 (  64 252 ) resistor r=2.87058 //w=0.35 //l=0.085 //layer=li \
 //thickness=0.1 //x=2.49 //y=7.585 //x2=2.405 //y2=7.585
r479 (  63 253 ) resistor r=2.87058 //w=0.35 //l=0.085 //layer=li \
 //thickness=0.1 //x=3.2 //y=7.585 //x2=3.285 //y2=7.585
r480 (  63 64 ) resistor r=24.7629 //w=0.367 //l=0.71 //layer=li \
 //thickness=0.1 //x=3.2 //y=7.585 //x2=2.49 //y2=7.585
r481 (  57 252 ) resistor r=4.23183 //w=0.7 //l=0.175 //layer=li \
 //thickness=0.1 //x=2.405 //y=7.41 //x2=2.405 //y2=7.585
r482 (  57 280 ) resistor r=33.1979 //w=0.187 //l=0.485 //layer=li \
 //thickness=0.1 //x=2.405 //y=7.41 //x2=2.405 //y2=6.925
r483 (  54 251 ) resistor r=2.87058 //w=0.35 //l=0.085 //layer=li \
 //thickness=0.1 //x=1.61 //y=7.585 //x2=1.525 //y2=7.585
r484 (  54 56 ) resistor r=23.5422 //w=0.367 //l=0.675 //layer=li \
 //thickness=0.1 //x=1.61 //y=7.585 //x2=2.285 //y2=7.585
r485 (  53 252 ) resistor r=2.87058 //w=0.35 //l=0.085 //layer=li \
 //thickness=0.1 //x=2.32 //y=7.585 //x2=2.405 //y2=7.585
r486 (  53 56 ) resistor r=1.22071 //w=0.367 //l=0.035 //layer=li \
 //thickness=0.1 //x=2.32 //y=7.585 //x2=2.285 //y2=7.585
r487 (  47 251 ) resistor r=4.23183 //w=0.7 //l=0.175 //layer=li \
 //thickness=0.1 //x=1.525 //y=7.41 //x2=1.525 //y2=7.585
r488 (  47 279 ) resistor r=56.4706 //w=0.187 //l=0.825 //layer=li \
 //thickness=0.1 //x=1.525 //y=7.41 //x2=1.525 //y2=6.585
r489 (  43 251 ) resistor r=2.87058 //w=0.35 //l=0.085 //layer=li \
 //thickness=0.1 //x=1.44 //y=7.585 //x2=1.525 //y2=7.585
r490 (  43 46 ) resistor r=9.24251 //w=0.367 //l=0.265 //layer=li \
 //thickness=0.1 //x=1.44 //y=7.585 //x2=1.175 //y2=7.585
r491 (  39 246 ) resistor r=9.3 //w=0.17 //l=0.17 //layer=mcon //count=1 \
 //x=21.525 //y=7.58 //x2=21.525 //y2=7.58
r492 (  37 236 ) resistor r=3.1 //w=0.17 //l=0.51 //layer=mcon //count=3 \
 //x=20.785 //y=7.58 //x2=20.785 //y2=7.58
r493 (  37 39 ) resistor r=0.297428 //w=0.311 //l=0.74 //layer=m1 \
 //thickness=0.36 //x=20.785 //y=7.585 //x2=21.525 //y2=7.585
r494 (  35 226 ) resistor r=3.1 //w=0.17 //l=0.51 //layer=mcon //count=3 \
 //x=19.675 //y=7.58 //x2=19.675 //y2=7.58
r495 (  35 37 ) resistor r=0.446141 //w=0.311 //l=1.11 //layer=m1 \
 //thickness=0.36 //x=19.675 //y=7.585 //x2=20.785 //y2=7.585
r496 (  33 212 ) resistor r=3.1 //w=0.17 //l=0.51 //layer=mcon //count=3 \
 //x=18.195 //y=7.58 //x2=18.195 //y2=7.58
r497 (  33 35 ) resistor r=0.594855 //w=0.311 //l=1.48 //layer=m1 \
 //thickness=0.36 //x=18.195 //y=7.585 //x2=19.675 //y2=7.585
r498 (  31 202 ) resistor r=3.1 //w=0.17 //l=0.51 //layer=mcon //count=3 \
 //x=17.085 //y=7.58 //x2=17.085 //y2=7.58
r499 (  31 33 ) resistor r=0.446141 //w=0.311 //l=1.11 //layer=m1 \
 //thickness=0.36 //x=17.085 //y=7.585 //x2=18.195 //y2=7.585
r500 (  29 271 ) resistor r=3.1 //w=0.17 //l=0.51 //layer=mcon //count=3 \
 //x=15.975 //y=7.58 //x2=15.975 //y2=7.58
r501 (  29 31 ) resistor r=0.446141 //w=0.311 //l=1.11 //layer=m1 \
 //thickness=0.36 //x=15.975 //y=7.585 //x2=17.085 //y2=7.585
r502 (  27 268 ) resistor r=3.1 //w=0.17 //l=0.51 //layer=mcon //count=3 \
 //x=14.495 //y=7.58 //x2=14.495 //y2=7.58
r503 (  27 29 ) resistor r=0.594855 //w=0.311 //l=1.48 //layer=m1 \
 //thickness=0.36 //x=14.495 //y=7.585 //x2=15.975 //y2=7.585
r504 (  25 164 ) resistor r=3.1 //w=0.17 //l=0.51 //layer=mcon //count=3 \
 //x=13.385 //y=7.58 //x2=13.385 //y2=7.58
r505 (  25 27 ) resistor r=0.446141 //w=0.311 //l=1.11 //layer=m1 \
 //thickness=0.36 //x=13.385 //y=7.585 //x2=14.495 //y2=7.585
r506 (  23 154 ) resistor r=3.1 //w=0.17 //l=0.51 //layer=mcon //count=3 \
 //x=12.275 //y=7.58 //x2=12.275 //y2=7.58
r507 (  23 25 ) resistor r=0.446141 //w=0.311 //l=1.11 //layer=m1 \
 //thickness=0.36 //x=12.275 //y=7.585 //x2=13.385 //y2=7.585
r508 (  20 140 ) resistor r=3.1 //w=0.17 //l=0.51 //layer=mcon //count=3 \
 //x=10.795 //y=7.58 //x2=10.795 //y2=7.58
r509 (  18 130 ) resistor r=3.1 //w=0.17 //l=0.51 //layer=mcon //count=3 \
 //x=9.685 //y=7.58 //x2=9.685 //y2=7.58
r510 (  18 20 ) resistor r=0.446141 //w=0.311 //l=1.11 //layer=m1 \
 //thickness=0.36 //x=9.685 //y=7.585 //x2=10.795 //y2=7.585
r511 (  16 116 ) resistor r=3.1 //w=0.17 //l=0.51 //layer=mcon //count=3 \
 //x=8.205 //y=7.58 //x2=8.205 //y2=7.58
r512 (  16 18 ) resistor r=0.594855 //w=0.311 //l=1.48 //layer=m1 \
 //thickness=0.36 //x=8.205 //y=7.585 //x2=9.685 //y2=7.585
r513 (  14 106 ) resistor r=3.1 //w=0.17 //l=0.51 //layer=mcon //count=3 \
 //x=7.095 //y=7.58 //x2=7.095 //y2=7.58
r514 (  14 16 ) resistor r=0.446141 //w=0.311 //l=1.11 //layer=m1 \
 //thickness=0.36 //x=7.095 //y=7.585 //x2=8.205 //y2=7.585
r515 (  12 257 ) resistor r=3.1 //w=0.17 //l=0.51 //layer=mcon //count=3 \
 //x=5.985 //y=7.58 //x2=5.985 //y2=7.58
r516 (  12 14 ) resistor r=0.446141 //w=0.311 //l=1.11 //layer=m1 \
 //thickness=0.36 //x=5.985 //y=7.585 //x2=7.095 //y2=7.585
r517 (  10 84 ) resistor r=3.1 //w=0.17 //l=0.51 //layer=mcon //count=3 \
 //x=4.505 //y=7.58 //x2=4.505 //y2=7.58
r518 (  10 12 ) resistor r=0.594855 //w=0.311 //l=1.48 //layer=m1 \
 //thickness=0.36 //x=4.505 //y=7.585 //x2=5.985 //y2=7.585
r519 (  8 74 ) resistor r=3.1 //w=0.17 //l=0.51 //layer=mcon //count=3 \
 //x=3.395 //y=7.58 //x2=3.395 //y2=7.58
r520 (  8 10 ) resistor r=0.446141 //w=0.311 //l=1.11 //layer=m1 \
 //thickness=0.36 //x=3.395 //y=7.585 //x2=4.505 //y2=7.585
r521 (  6 56 ) resistor r=3.1 //w=0.17 //l=0.51 //layer=mcon //count=3 \
 //x=2.285 //y=7.58 //x2=2.285 //y2=7.58
r522 (  6 8 ) resistor r=0.446141 //w=0.311 //l=1.11 //layer=m1 \
 //thickness=0.36 //x=2.285 //y=7.585 //x2=3.395 //y2=7.585
r523 (  3 46 ) resistor r=3.1 //w=0.17 //l=0.51 //layer=mcon //count=3 \
 //x=1.175 //y=7.58 //x2=1.175 //y2=7.58
r524 (  3 6 ) resistor r=0.446141 //w=0.311 //l=1.11 //layer=m1 \
 //thickness=0.36 //x=1.175 //y=7.585 //x2=2.285 //y2=7.585
r525 (  1 23 ) resistor r=0.424035 //w=0.311 //l=1.055 //layer=m1 \
 //thickness=0.36 //x=11.22 //y=7.585 //x2=12.275 //y2=7.585
r526 (  1 20 ) resistor r=0.17082 //w=0.311 //l=0.425 //layer=m1 \
 //thickness=0.36 //x=11.22 //y=7.585 //x2=10.795 //y2=7.585
ends PM_DFFQX1\%VDD

subckt PM_DFFQX1\%noxref_3 ( 1 2 3 4 12 25 26 37 39 40 44 46 53 54 55 56 57 58 \
 59 63 64 65 70 72 75 76 77 78 79 80 84 86 89 90 95 96 101 110 113 115 116 )
c250 ( 116 0 ) capacitor c=0.0220291f //x=7.21 //y=5.2
c251 ( 115 0 ) capacitor c=0.0217503f //x=6.33 //y=5.2
c252 ( 113 0 ) capacitor c=0.00866655f //x=7.205 //y=1.085
c253 ( 110 0 ) capacitor c=0.0588816f //x=9.685 //y=4.88
c254 ( 101 0 ) capacitor c=0.058931f //x=3.765 //y=4.88
c255 ( 96 0 ) capacitor c=0.0273931f //x=3.765 //y=2.095
c256 ( 95 0 ) capacitor c=0.0464411f //x=3.765 //y=2.26
c257 ( 90 0 ) capacitor c=0.0318948f //x=10.02 //y=1.39
c258 ( 89 0 ) capacitor c=0.0187384f //x=10.02 //y=1.045
c259 ( 86 0 ) capacitor c=0.0141798f //x=9.865 //y=1.545
c260 ( 84 0 ) capacitor c=0.0149844f //x=9.865 //y=0.89
c261 ( 80 0 ) capacitor c=0.0853292f //x=9.49 //y=2.095
c262 ( 79 0 ) capacitor c=0.0229722f //x=9.49 //y=1.7
c263 ( 78 0 ) capacitor c=0.0234352f //x=9.49 //y=1.39
c264 ( 77 0 ) capacitor c=0.0199343f //x=9.49 //y=1.045
c265 ( 76 0 ) capacitor c=0.0432517f //x=4.285 //y=1.44
c266 ( 75 0 ) capacitor c=0.0200379f //x=4.285 //y=1.095
c267 ( 72 0 ) capacitor c=0.0158629f //x=4.13 //y=1.595
c268 ( 70 0 ) capacitor c=0.0157803f //x=4.13 //y=0.94
c269 ( 65 0 ) capacitor c=0.0218028f //x=3.755 //y=1.75
c270 ( 64 0 ) capacitor c=0.0207459f //x=3.755 //y=1.44
c271 ( 63 0 ) capacitor c=0.0194308f //x=3.755 //y=1.095
c272 ( 59 0 ) capacitor c=0.110275f //x=10.025 //y=6.2
c273 ( 58 0 ) capacitor c=0.154305f //x=9.585 //y=6.2
c274 ( 57 0 ) capacitor c=0.158794f //x=3.945 //y=6.2
c275 ( 56 0 ) capacitor c=0.110114f //x=3.505 //y=6.2
c276 ( 53 0 ) capacitor c=0.00211606f //x=7.355 //y=5.38
c277 ( 46 0 ) capacitor c=0.0919908f //x=9.685 //y=2.26
c278 ( 44 0 ) capacitor c=0.108052f //x=7.835 //y=3.51
c279 ( 40 0 ) capacitor c=0.00498573f //x=7.48 //y=1.835
c280 ( 39 0 ) capacitor c=0.0136303f //x=7.75 //y=1.835
c281 ( 37 0 ) capacitor c=0.0137522f //x=7.75 //y=5.38
c282 ( 26 0 ) capacitor c=0.00251635f //x=6.56 //y=5.38
c283 ( 25 0 ) capacitor c=0.0143966f //x=7.27 //y=5.38
c284 ( 12 0 ) capacitor c=0.0879612f //x=3.765 //y=2.26
c285 ( 4 0 ) capacitor c=0.00429184f //x=7.95 //y=3.51
c286 ( 3 0 ) capacitor c=0.0617718f //x=9.57 //y=3.51
c287 ( 2 0 ) capacitor c=0.0149801f //x=3.88 //y=3.51
c288 ( 1 0 ) capacitor c=0.107483f //x=7.72 //y=3.51
r289 (  108 110 ) resistor r=20.6867 //w=0.233 //l=0.1 //layer=ply \
 //thickness=0.18 //x=9.585 //y=4.88 //x2=9.685 //y2=4.88
r290 (  95 96 ) resistor r=52.7279 //w=0.214 //l=0.165 //layer=ply \
 //thickness=0.18 //x=3.765 //y=2.26 //x2=3.765 //y2=2.095
r291 (  91 110 ) resistor r=70.3348 //w=0.233 //l=0.414367 //layer=ply \
 //thickness=0.18 //x=10.025 //y=5.045 //x2=9.685 //y2=4.88
r292 (  90 112 ) resistor r=45.1352 //w=0.168 //l=0.173853 //layer=ply \
 //thickness=0.18 //x=10.02 //y=1.39 //x2=9.98 //y2=1.545
r293 (  89 111 ) resistor r=45.1352 //w=0.168 //l=0.173853 //layer=ply \
 //thickness=0.18 //x=10.02 //y=1.045 //x2=9.98 //y2=0.89
r294 (  89 90 ) resistor r=176.904 //w=0.094 //l=0.345 //layer=ply \
 //thickness=0.18 //x=10.02 //y=1.045 //x2=10.02 //y2=1.39
r295 (  87 107 ) resistor r=10.701 //w=0.21 //l=0.115 //layer=ply \
 //thickness=0.18 //x=9.645 //y=1.545 //x2=9.53 //y2=1.545
r296 (  86 112 ) resistor r=5.52526 //w=0.168 //l=0.115 //layer=ply \
 //thickness=0.18 //x=9.865 //y=1.545 //x2=9.98 //y2=1.545
r297 (  85 106 ) resistor r=5.52526 //w=0.168 //l=0.115 //layer=ply \
 //thickness=0.18 //x=9.645 //y=0.89 //x2=9.53 //y2=0.89
r298 (  84 111 ) resistor r=5.52526 //w=0.168 //l=0.115 //layer=ply \
 //thickness=0.18 //x=9.865 //y=0.89 //x2=9.98 //y2=0.89
r299 (  84 85 ) resistor r=112.809 //w=0.094 //l=0.22 //layer=ply \
 //thickness=0.18 //x=9.865 //y=0.89 //x2=9.645 //y2=0.89
r300 (  81 108 ) resistor r=13.0941 //w=0.233 //l=0.165 //layer=ply \
 //thickness=0.18 //x=9.585 //y=5.045 //x2=9.585 //y2=4.88
r301 (  80 105 ) resistor r=34.8111 //w=0.27 //l=0.264953 //layer=ply \
 //thickness=0.18 //x=9.49 //y=2.095 //x2=9.685 //y2=2.26
r302 (  79 107 ) resistor r=39.5823 //w=0.21 //l=0.173853 //layer=ply \
 //thickness=0.18 //x=9.49 //y=1.7 //x2=9.53 //y2=1.545
r303 (  79 80 ) resistor r=202.543 //w=0.094 //l=0.395 //layer=ply \
 //thickness=0.18 //x=9.49 //y=1.7 //x2=9.49 //y2=2.095
r304 (  78 107 ) resistor r=39.5823 //w=0.21 //l=0.173853 //layer=ply \
 //thickness=0.18 //x=9.49 //y=1.39 //x2=9.53 //y2=1.545
r305 (  77 106 ) resistor r=45.1352 //w=0.168 //l=0.173853 //layer=ply \
 //thickness=0.18 //x=9.49 //y=1.045 //x2=9.53 //y2=0.89
r306 (  77 78 ) resistor r=176.904 //w=0.094 //l=0.345 //layer=ply \
 //thickness=0.18 //x=9.49 //y=1.045 //x2=9.49 //y2=1.39
r307 (  76 103 ) resistor r=45.1352 //w=0.168 //l=0.173853 //layer=ply \
 //thickness=0.18 //x=4.285 //y=1.44 //x2=4.245 //y2=1.595
r308 (  75 102 ) resistor r=45.1352 //w=0.168 //l=0.173853 //layer=ply \
 //thickness=0.18 //x=4.285 //y=1.095 //x2=4.245 //y2=0.94
r309 (  75 76 ) resistor r=176.904 //w=0.094 //l=0.345 //layer=ply \
 //thickness=0.18 //x=4.285 //y=1.095 //x2=4.285 //y2=1.44
r310 (  73 99 ) resistor r=10.701 //w=0.21 //l=0.115 //layer=ply \
 //thickness=0.18 //x=3.91 //y=1.595 //x2=3.795 //y2=1.595
r311 (  72 103 ) resistor r=5.52526 //w=0.168 //l=0.115 //layer=ply \
 //thickness=0.18 //x=4.13 //y=1.595 //x2=4.245 //y2=1.595
r312 (  71 98 ) resistor r=5.52526 //w=0.168 //l=0.115 //layer=ply \
 //thickness=0.18 //x=3.91 //y=0.94 //x2=3.795 //y2=0.94
r313 (  70 102 ) resistor r=5.52526 //w=0.168 //l=0.115 //layer=ply \
 //thickness=0.18 //x=4.13 //y=0.94 //x2=4.245 //y2=0.94
r314 (  70 71 ) resistor r=112.809 //w=0.094 //l=0.22 //layer=ply \
 //thickness=0.18 //x=4.13 //y=0.94 //x2=3.91 //y2=0.94
r315 (  67 101 ) resistor r=37.236 //w=0.233 //l=0.249199 //layer=ply \
 //thickness=0.18 //x=3.945 //y=5.045 //x2=3.765 //y2=4.88
r316 (  65 99 ) resistor r=39.5823 //w=0.21 //l=0.173853 //layer=ply \
 //thickness=0.18 //x=3.755 //y=1.75 //x2=3.795 //y2=1.595
r317 (  65 96 ) resistor r=176.904 //w=0.094 //l=0.345 //layer=ply \
 //thickness=0.18 //x=3.755 //y=1.75 //x2=3.755 //y2=2.095
r318 (  64 99 ) resistor r=39.5823 //w=0.21 //l=0.173853 //layer=ply \
 //thickness=0.18 //x=3.755 //y=1.44 //x2=3.795 //y2=1.595
r319 (  63 98 ) resistor r=45.1352 //w=0.168 //l=0.173853 //layer=ply \
 //thickness=0.18 //x=3.755 //y=1.095 //x2=3.795 //y2=0.94
r320 (  63 64 ) resistor r=176.904 //w=0.094 //l=0.345 //layer=ply \
 //thickness=0.18 //x=3.755 //y=1.095 //x2=3.755 //y2=1.44
r321 (  60 101 ) resistor r=53.7854 //w=0.233 //l=0.332415 //layer=ply \
 //thickness=0.18 //x=3.505 //y=5.045 //x2=3.765 //y2=4.88
r322 (  59 91 ) resistor r=592.245 //w=0.094 //l=1.155 //layer=ply \
 //thickness=0.18 //x=10.025 //y=6.2 //x2=10.025 //y2=5.045
r323 (  58 81 ) resistor r=592.245 //w=0.094 //l=1.155 //layer=ply \
 //thickness=0.18 //x=9.585 //y=6.2 //x2=9.585 //y2=5.045
r324 (  57 67 ) resistor r=592.245 //w=0.094 //l=1.155 //layer=ply \
 //thickness=0.18 //x=3.945 //y=6.2 //x2=3.945 //y2=5.045
r325 (  56 60 ) resistor r=592.245 //w=0.094 //l=1.155 //layer=ply \
 //thickness=0.18 //x=3.505 //y=6.2 //x2=3.505 //y2=5.045
r326 (  55 86 ) resistor r=56.4043 //w=0.094 //l=0.11 //layer=ply \
 //thickness=0.18 //x=9.755 //y=1.545 //x2=9.865 //y2=1.545
r327 (  55 87 ) resistor r=56.4043 //w=0.094 //l=0.11 //layer=ply \
 //thickness=0.18 //x=9.755 //y=1.545 //x2=9.645 //y2=1.545
r328 (  54 72 ) resistor r=56.4043 //w=0.094 //l=0.11 //layer=ply \
 //thickness=0.18 //x=4.02 //y=1.595 //x2=4.13 //y2=1.595
r329 (  54 73 ) resistor r=56.4043 //w=0.094 //l=0.11 //layer=ply \
 //thickness=0.18 //x=4.02 //y=1.595 //x2=3.91 //y2=1.595
r330 (  51 110 ) resistor r=152 //w=0.17 //l=0.17 //layer=licon //count=1 \
 //x=9.685 //y=4.88 //x2=9.685 //y2=4.88
r331 (  49 51 ) resistor r=93.7754 //w=0.187 //l=1.37 //layer=li \
 //thickness=0.1 //x=9.685 //y=3.51 //x2=9.685 //y2=4.88
r332 (  46 105 ) resistor r=152 //w=0.17 //l=0.17 //layer=licon //count=1 \
 //x=9.685 //y=2.26 //x2=9.685 //y2=2.26
r333 (  46 49 ) resistor r=85.5615 //w=0.187 //l=1.25 //layer=li \
 //thickness=0.1 //x=9.685 //y=2.26 //x2=9.685 //y2=3.51
r334 (  42 44 ) resistor r=122.182 //w=0.187 //l=1.785 //layer=li \
 //thickness=0.1 //x=7.835 //y=5.295 //x2=7.835 //y2=3.51
r335 (  41 44 ) resistor r=108.834 //w=0.187 //l=1.59 //layer=li \
 //thickness=0.1 //x=7.835 //y=1.92 //x2=7.835 //y2=3.51
r336 (  39 41 ) resistor r=7.15173 //w=0.17 //l=0.120208 //layer=li \
 //thickness=0.1 //x=7.75 //y=1.835 //x2=7.835 //y2=1.92
r337 (  39 40 ) resistor r=18.4813 //w=0.187 //l=0.27 //layer=li \
 //thickness=0.1 //x=7.75 //y=1.835 //x2=7.48 //y2=1.835
r338 (  38 53 ) resistor r=5.4201 //w=0.17 //l=0.085 //layer=li \
 //thickness=0.1 //x=7.44 //y=5.38 //x2=7.355 //y2=5.38
r339 (  37 42 ) resistor r=7.15173 //w=0.17 //l=0.120208 //layer=li \
 //thickness=0.1 //x=7.75 //y=5.38 //x2=7.835 //y2=5.295
r340 (  37 38 ) resistor r=21.2193 //w=0.187 //l=0.31 //layer=li \
 //thickness=0.1 //x=7.75 //y=5.38 //x2=7.44 //y2=5.38
r341 (  33 40 ) resistor r=7.15173 //w=0.17 //l=0.120208 //layer=li \
 //thickness=0.1 //x=7.395 //y=1.75 //x2=7.48 //y2=1.835
r342 (  33 113 ) resistor r=39.016 //w=0.187 //l=0.57 //layer=li \
 //thickness=0.1 //x=7.395 //y=1.75 //x2=7.395 //y2=1.18
r343 (  27 53 ) resistor r=1.40859 //w=0.34 //l=0.085 //layer=li \
 //thickness=0.1 //x=7.355 //y=5.465 //x2=7.355 //y2=5.38
r344 (  27 116 ) resistor r=30.1176 //w=0.187 //l=0.44 //layer=li \
 //thickness=0.1 //x=7.355 //y=5.465 //x2=7.355 //y2=5.905
r345 (  25 53 ) resistor r=5.4201 //w=0.17 //l=0.085 //layer=li \
 //thickness=0.1 //x=7.27 //y=5.38 //x2=7.355 //y2=5.38
r346 (  25 26 ) resistor r=48.5989 //w=0.187 //l=0.71 //layer=li \
 //thickness=0.1 //x=7.27 //y=5.38 //x2=6.56 //y2=5.38
r347 (  19 26 ) resistor r=7.15173 //w=0.17 //l=0.120208 //layer=li \
 //thickness=0.1 //x=6.475 //y=5.465 //x2=6.56 //y2=5.38
r348 (  19 115 ) resistor r=30.1176 //w=0.187 //l=0.44 //layer=li \
 //thickness=0.1 //x=6.475 //y=5.465 //x2=6.475 //y2=5.905
r349 (  17 101 ) resistor r=152 //w=0.17 //l=0.17 //layer=licon //count=1 \
 //x=3.765 //y=4.88 //x2=3.765 //y2=4.88
r350 (  15 17 ) resistor r=93.7754 //w=0.187 //l=1.37 //layer=li \
 //thickness=0.1 //x=3.765 //y=3.51 //x2=3.765 //y2=4.88
r351 (  12 95 ) resistor r=152 //w=0.17 //l=0.17 //layer=licon //count=1 \
 //x=3.765 //y=2.26 //x2=3.765 //y2=2.26
r352 (  12 15 ) resistor r=85.5615 //w=0.187 //l=1.25 //layer=li \
 //thickness=0.1 //x=3.765 //y=2.26 //x2=3.765 //y2=3.51
r353 (  10 49 ) resistor r=9.3 //w=0.17 //l=0.17 //layer=mcon //count=1 \
 //x=9.685 //y=3.51 //x2=9.685 //y2=3.51
r354 (  8 44 ) resistor r=9.3 //w=0.17 //l=0.17 //layer=mcon //count=1 \
 //x=7.835 //y=3.51 //x2=7.835 //y2=3.51
r355 (  6 15 ) resistor r=9.3 //w=0.17 //l=0.17 //layer=mcon //count=1 \
 //x=3.765 //y=3.51 //x2=3.765 //y2=3.51
r356 (  4 8 ) resistor r=0.0880901 //w=0.191 //l=0.115 //layer=m1 \
 //thickness=0.36 //x=7.95 //y=3.51 //x2=7.835 //y2=3.51
r357 (  3 10 ) resistor r=0.0717383 //w=0.224 //l=0.115 //layer=m1 \
 //thickness=0.36 //x=9.57 //y=3.51 //x2=9.685 //y2=3.51
r358 (  3 4 ) resistor r=1.5458 //w=0.131 //l=1.62 //layer=m1 //thickness=0.36 \
 //x=9.57 //y=3.51 //x2=7.95 //y2=3.51
r359 (  2 6 ) resistor r=0.0717383 //w=0.224 //l=0.115 //layer=m1 \
 //thickness=0.36 //x=3.88 //y=3.51 //x2=3.765 //y2=3.51
r360 (  1 8 ) resistor r=0.0880901 //w=0.191 //l=0.115 //layer=m1 \
 //thickness=0.36 //x=7.72 //y=3.51 //x2=7.835 //y2=3.51
r361 (  1 2 ) resistor r=3.66412 //w=0.131 //l=3.84 //layer=m1 \
 //thickness=0.36 //x=7.72 //y=3.51 //x2=3.88 //y2=3.51
ends PM_DFFQX1\%noxref_3

subckt PM_DFFQX1\%noxref_4 ( 1 2 13 14 25 27 28 32 34 41 42 43 44 45 46 47 48 \
 52 54 57 58 68 71 73 74 )
c150 ( 74 0 ) capacitor c=0.0220291f //x=10.54 //y=5.2
c151 ( 73 0 ) capacitor c=0.0217503f //x=9.66 //y=5.2
c152 ( 71 0 ) capacitor c=0.00866655f //x=10.535 //y=1.085
c153 ( 68 0 ) capacitor c=0.0588816f //x=13.015 //y=4.88
c154 ( 58 0 ) capacitor c=0.0318948f //x=13.35 //y=1.39
c155 ( 57 0 ) capacitor c=0.0187384f //x=13.35 //y=1.045
c156 ( 54 0 ) capacitor c=0.0141798f //x=13.195 //y=1.545
c157 ( 52 0 ) capacitor c=0.0149844f //x=13.195 //y=0.89
c158 ( 48 0 ) capacitor c=0.0853292f //x=12.82 //y=2.095
c159 ( 47 0 ) capacitor c=0.0229722f //x=12.82 //y=1.7
c160 ( 46 0 ) capacitor c=0.0234352f //x=12.82 //y=1.39
c161 ( 45 0 ) capacitor c=0.0199343f //x=12.82 //y=1.045
c162 ( 44 0 ) capacitor c=0.110275f //x=13.355 //y=6.2
c163 ( 43 0 ) capacitor c=0.154305f //x=12.915 //y=6.2
c164 ( 41 0 ) capacitor c=0.00211606f //x=10.685 //y=5.38
c165 ( 34 0 ) capacitor c=0.0911845f //x=13.015 //y=2.26
c166 ( 32 0 ) capacitor c=0.108686f //x=11.165 //y=3.51
c167 ( 28 0 ) capacitor c=0.00525782f //x=10.81 //y=1.835
c168 ( 27 0 ) capacitor c=0.0139525f //x=11.08 //y=1.835
c169 ( 25 0 ) capacitor c=0.0137522f //x=11.08 //y=5.38
c170 ( 14 0 ) capacitor c=0.00251459f //x=9.89 //y=5.38
c171 ( 13 0 ) capacitor c=0.0143649f //x=10.6 //y=5.38
c172 ( 2 0 ) capacitor c=0.00861287f //x=11.28 //y=3.51
c173 ( 1 0 ) capacitor c=0.067133f //x=12.9 //y=3.51
r174 (  66 68 ) resistor r=20.6867 //w=0.233 //l=0.1 //layer=ply \
 //thickness=0.18 //x=12.915 //y=4.88 //x2=13.015 //y2=4.88
r175 (  59 68 ) resistor r=70.3348 //w=0.233 //l=0.414367 //layer=ply \
 //thickness=0.18 //x=13.355 //y=5.045 //x2=13.015 //y2=4.88
r176 (  58 70 ) resistor r=45.1352 //w=0.168 //l=0.173853 //layer=ply \
 //thickness=0.18 //x=13.35 //y=1.39 //x2=13.31 //y2=1.545
r177 (  57 69 ) resistor r=45.1352 //w=0.168 //l=0.173853 //layer=ply \
 //thickness=0.18 //x=13.35 //y=1.045 //x2=13.31 //y2=0.89
r178 (  57 58 ) resistor r=176.904 //w=0.094 //l=0.345 //layer=ply \
 //thickness=0.18 //x=13.35 //y=1.045 //x2=13.35 //y2=1.39
r179 (  55 65 ) resistor r=10.701 //w=0.21 //l=0.115 //layer=ply \
 //thickness=0.18 //x=12.975 //y=1.545 //x2=12.86 //y2=1.545
r180 (  54 70 ) resistor r=5.52526 //w=0.168 //l=0.115 //layer=ply \
 //thickness=0.18 //x=13.195 //y=1.545 //x2=13.31 //y2=1.545
r181 (  53 64 ) resistor r=5.52526 //w=0.168 //l=0.115 //layer=ply \
 //thickness=0.18 //x=12.975 //y=0.89 //x2=12.86 //y2=0.89
r182 (  52 69 ) resistor r=5.52526 //w=0.168 //l=0.115 //layer=ply \
 //thickness=0.18 //x=13.195 //y=0.89 //x2=13.31 //y2=0.89
r183 (  52 53 ) resistor r=112.809 //w=0.094 //l=0.22 //layer=ply \
 //thickness=0.18 //x=13.195 //y=0.89 //x2=12.975 //y2=0.89
r184 (  49 66 ) resistor r=13.0941 //w=0.233 //l=0.165 //layer=ply \
 //thickness=0.18 //x=12.915 //y=5.045 //x2=12.915 //y2=4.88
r185 (  48 63 ) resistor r=34.8111 //w=0.27 //l=0.264953 //layer=ply \
 //thickness=0.18 //x=12.82 //y=2.095 //x2=13.015 //y2=2.26
r186 (  47 65 ) resistor r=39.5823 //w=0.21 //l=0.173853 //layer=ply \
 //thickness=0.18 //x=12.82 //y=1.7 //x2=12.86 //y2=1.545
r187 (  47 48 ) resistor r=202.543 //w=0.094 //l=0.395 //layer=ply \
 //thickness=0.18 //x=12.82 //y=1.7 //x2=12.82 //y2=2.095
r188 (  46 65 ) resistor r=39.5823 //w=0.21 //l=0.173853 //layer=ply \
 //thickness=0.18 //x=12.82 //y=1.39 //x2=12.86 //y2=1.545
r189 (  45 64 ) resistor r=45.1352 //w=0.168 //l=0.173853 //layer=ply \
 //thickness=0.18 //x=12.82 //y=1.045 //x2=12.86 //y2=0.89
r190 (  45 46 ) resistor r=176.904 //w=0.094 //l=0.345 //layer=ply \
 //thickness=0.18 //x=12.82 //y=1.045 //x2=12.82 //y2=1.39
r191 (  44 59 ) resistor r=592.245 //w=0.094 //l=1.155 //layer=ply \
 //thickness=0.18 //x=13.355 //y=6.2 //x2=13.355 //y2=5.045
r192 (  43 49 ) resistor r=592.245 //w=0.094 //l=1.155 //layer=ply \
 //thickness=0.18 //x=12.915 //y=6.2 //x2=12.915 //y2=5.045
r193 (  42 54 ) resistor r=56.4043 //w=0.094 //l=0.11 //layer=ply \
 //thickness=0.18 //x=13.085 //y=1.545 //x2=13.195 //y2=1.545
r194 (  42 55 ) resistor r=56.4043 //w=0.094 //l=0.11 //layer=ply \
 //thickness=0.18 //x=13.085 //y=1.545 //x2=12.975 //y2=1.545
r195 (  39 68 ) resistor r=152 //w=0.17 //l=0.17 //layer=licon //count=1 \
 //x=13.015 //y=4.88 //x2=13.015 //y2=4.88
r196 (  37 39 ) resistor r=93.7754 //w=0.187 //l=1.37 //layer=li \
 //thickness=0.1 //x=13.015 //y=3.51 //x2=13.015 //y2=4.88
r197 (  34 63 ) resistor r=152 //w=0.17 //l=0.17 //layer=licon //count=1 \
 //x=13.015 //y=2.26 //x2=13.015 //y2=2.26
r198 (  34 37 ) resistor r=85.5615 //w=0.187 //l=1.25 //layer=li \
 //thickness=0.1 //x=13.015 //y=2.26 //x2=13.015 //y2=3.51
r199 (  30 32 ) resistor r=122.182 //w=0.187 //l=1.785 //layer=li \
 //thickness=0.1 //x=11.165 //y=5.295 //x2=11.165 //y2=3.51
r200 (  29 32 ) resistor r=108.834 //w=0.187 //l=1.59 //layer=li \
 //thickness=0.1 //x=11.165 //y=1.92 //x2=11.165 //y2=3.51
r201 (  27 29 ) resistor r=7.15173 //w=0.17 //l=0.120208 //layer=li \
 //thickness=0.1 //x=11.08 //y=1.835 //x2=11.165 //y2=1.92
r202 (  27 28 ) resistor r=18.4813 //w=0.187 //l=0.27 //layer=li \
 //thickness=0.1 //x=11.08 //y=1.835 //x2=10.81 //y2=1.835
r203 (  26 41 ) resistor r=5.4201 //w=0.17 //l=0.085 //layer=li \
 //thickness=0.1 //x=10.77 //y=5.38 //x2=10.685 //y2=5.38
r204 (  25 30 ) resistor r=7.15173 //w=0.17 //l=0.120208 //layer=li \
 //thickness=0.1 //x=11.08 //y=5.38 //x2=11.165 //y2=5.295
r205 (  25 26 ) resistor r=21.2193 //w=0.187 //l=0.31 //layer=li \
 //thickness=0.1 //x=11.08 //y=5.38 //x2=10.77 //y2=5.38
r206 (  21 28 ) resistor r=7.15173 //w=0.17 //l=0.120208 //layer=li \
 //thickness=0.1 //x=10.725 //y=1.75 //x2=10.81 //y2=1.835
r207 (  21 71 ) resistor r=39.016 //w=0.187 //l=0.57 //layer=li \
 //thickness=0.1 //x=10.725 //y=1.75 //x2=10.725 //y2=1.18
r208 (  15 41 ) resistor r=1.40859 //w=0.34 //l=0.085 //layer=li \
 //thickness=0.1 //x=10.685 //y=5.465 //x2=10.685 //y2=5.38
r209 (  15 74 ) resistor r=30.1176 //w=0.187 //l=0.44 //layer=li \
 //thickness=0.1 //x=10.685 //y=5.465 //x2=10.685 //y2=5.905
r210 (  13 41 ) resistor r=5.4201 //w=0.17 //l=0.085 //layer=li \
 //thickness=0.1 //x=10.6 //y=5.38 //x2=10.685 //y2=5.38
r211 (  13 14 ) resistor r=48.5989 //w=0.187 //l=0.71 //layer=li \
 //thickness=0.1 //x=10.6 //y=5.38 //x2=9.89 //y2=5.38
r212 (  7 14 ) resistor r=7.15173 //w=0.17 //l=0.120208 //layer=li \
 //thickness=0.1 //x=9.805 //y=5.465 //x2=9.89 //y2=5.38
r213 (  7 73 ) resistor r=30.1176 //w=0.187 //l=0.44 //layer=li \
 //thickness=0.1 //x=9.805 //y=5.465 //x2=9.805 //y2=5.905
r214 (  6 37 ) resistor r=9.3 //w=0.17 //l=0.17 //layer=mcon //count=1 \
 //x=13.015 //y=3.51 //x2=13.015 //y2=3.51
r215 (  4 32 ) resistor r=9.3 //w=0.17 //l=0.17 //layer=mcon //count=1 \
 //x=11.165 //y=3.51 //x2=11.165 //y2=3.51
r216 (  2 4 ) resistor r=0.0717383 //w=0.224 //l=0.115 //layer=m1 \
 //thickness=0.36 //x=11.28 //y=3.51 //x2=11.165 //y2=3.51
r217 (  1 6 ) resistor r=0.0717383 //w=0.224 //l=0.115 //layer=m1 \
 //thickness=0.36 //x=12.9 //y=3.51 //x2=13.015 //y2=3.51
r218 (  1 2 ) resistor r=1.5458 //w=0.131 //l=1.62 //layer=m1 //thickness=0.36 \
 //x=12.9 //y=3.51 //x2=11.28 //y2=3.51
ends PM_DFFQX1\%noxref_4

subckt PM_DFFQX1\%CLK ( 1 2 7 8 9 10 11 14 26 28 30 38 41 44 48 52 53 54 55 56 \
 57 58 59 60 62 68 69 70 71 72 77 78 79 84 86 88 94 95 99 108 109 112 )
c223 ( 112 0 ) capacitor c=0.0331838f //x=13.785 //y=4.88
c224 ( 109 0 ) capacitor c=0.0279499f //x=13.755 //y=2.095
c225 ( 108 0 ) capacitor c=0.0437302f //x=13.755 //y=2.26
c226 ( 99 0 ) capacitor c=0.0334004f //x=2.655 //y=4.88
c227 ( 95 0 ) capacitor c=0.0429696f //x=14.32 //y=1.43
c228 ( 94 0 ) capacitor c=0.0192208f //x=14.32 //y=1.085
c229 ( 88 0 ) capacitor c=0.0158629f //x=14.165 //y=1.585
c230 ( 86 0 ) capacitor c=0.0157803f //x=14.165 //y=0.93
c231 ( 84 0 ) capacitor c=0.0299681f //x=14.16 //y=4.97
c232 ( 79 0 ) capacitor c=0.0205163f //x=13.79 //y=1.74
c233 ( 78 0 ) capacitor c=0.0168481f //x=13.79 //y=1.43
c234 ( 77 0 ) capacitor c=0.0174783f //x=13.79 //y=1.085
c235 ( 72 0 ) capacitor c=0.0242579f //x=2.99 //y=4.97
c236 ( 71 0 ) capacitor c=0.0836699f //x=2.745 //y=2.095
c237 ( 70 0 ) capacitor c=0.0170266f //x=2.745 //y=1.63
c238 ( 69 0 ) capacitor c=0.018609f //x=2.745 //y=1.4
c239 ( 68 0 ) capacitor c=0.0187309f //x=2.745 //y=1.09
c240 ( 62 0 ) capacitor c=0.014725f //x=2.59 //y=1.555
c241 ( 60 0 ) capacitor c=0.0146567f //x=2.59 //y=0.935
c242 ( 59 0 ) capacitor c=0.0335408f //x=2.22 //y=1.4
c243 ( 58 0 ) capacitor c=0.0173761f //x=2.22 //y=1.09
c244 ( 57 0 ) capacitor c=0.15358f //x=14.235 //y=6.2
c245 ( 56 0 ) capacitor c=0.110281f //x=13.795 //y=6.2
c246 ( 55 0 ) capacitor c=0.110114f //x=3.065 //y=6.2
c247 ( 54 0 ) capacitor c=0.11012f //x=2.625 //y=6.2
c248 ( 48 0 ) capacitor c=0.021333f //x=2.682 //y=4.535
c249 ( 44 0 ) capacitor c=0.00840571f //x=2.682 //y=3.795
c250 ( 41 0 ) capacitor c=0.00846054f //x=2.682 //y=3.425
c251 ( 38 0 ) capacitor c=0.00874422f //x=2.682 //y=3.055
c252 ( 30 0 ) capacitor c=0.0746615f //x=13.755 //y=2.26
c253 ( 28 0 ) capacitor c=0.00369614f //x=13.755 //y=4.715
c254 ( 26 0 ) capacitor c=0.00474631f //x=2.655 //y=4.88
c255 ( 14 0 ) capacitor c=0.0153402f //x=2.655 //y=2.26
c256 ( 11 0 ) capacitor c=0.00579039f //x=2.71 //y=4.62
c257 ( 10 0 ) capacitor c=0.00833816f //x=2.71 //y=3.88
c258 ( 9 0 ) capacitor c=0.00769643f //x=2.71 //y=3.51
c259 ( 8 0 ) capacitor c=0.00838372f //x=2.71 //y=3.14
c260 ( 7 0 ) capacitor c=0.00841072f //x=2.71 //y=2.77
c261 ( 2 0 ) capacitor c=0.0154682f //x=2.77 //y=4.62
c262 ( 1 0 ) capacitor c=0.256307f //x=13.64 //y=4.62
r263 (  114 115 ) resistor r=32.4568 //w=0.214 //l=0.075 //layer=ply \
 //thickness=0.18 //x=13.785 //y=4.97 //x2=13.785 //y2=5.045
r264 (  112 114 ) resistor r=20.271 //w=0.214 //l=0.09 //layer=ply \
 //thickness=0.18 //x=13.785 //y=4.88 //x2=13.785 //y2=4.97
r265 (  108 109 ) resistor r=52.7279 //w=0.214 //l=0.165 //layer=ply \
 //thickness=0.18 //x=13.755 //y=2.26 //x2=13.755 //y2=2.095
r266 (  101 102 ) resistor r=32.4568 //w=0.214 //l=0.075 //layer=ply \
 //thickness=0.18 //x=2.655 //y=4.97 //x2=2.655 //y2=5.045
r267 (  99 101 ) resistor r=20.271 //w=0.214 //l=0.09 //layer=ply \
 //thickness=0.18 //x=2.655 //y=4.88 //x2=2.655 //y2=4.97
r268 (  95 119 ) resistor r=45.1352 //w=0.168 //l=0.173853 //layer=ply \
 //thickness=0.18 //x=14.32 //y=1.43 //x2=14.28 //y2=1.585
r269 (  94 118 ) resistor r=45.1352 //w=0.168 //l=0.173853 //layer=ply \
 //thickness=0.18 //x=14.32 //y=1.085 //x2=14.28 //y2=0.93
r270 (  94 95 ) resistor r=176.904 //w=0.094 //l=0.345 //layer=ply \
 //thickness=0.18 //x=14.32 //y=1.085 //x2=14.32 //y2=1.43
r271 (  89 117 ) resistor r=10.701 //w=0.21 //l=0.115 //layer=ply \
 //thickness=0.18 //x=13.945 //y=1.585 //x2=13.83 //y2=1.585
r272 (  88 119 ) resistor r=5.52526 //w=0.168 //l=0.115 //layer=ply \
 //thickness=0.18 //x=14.165 //y=1.585 //x2=14.28 //y2=1.585
r273 (  87 116 ) resistor r=5.52526 //w=0.168 //l=0.115 //layer=ply \
 //thickness=0.18 //x=13.945 //y=0.93 //x2=13.83 //y2=0.93
r274 (  86 118 ) resistor r=5.52526 //w=0.168 //l=0.115 //layer=ply \
 //thickness=0.18 //x=14.165 //y=0.93 //x2=14.28 //y2=0.93
r275 (  86 87 ) resistor r=112.809 //w=0.094 //l=0.22 //layer=ply \
 //thickness=0.18 //x=14.165 //y=0.93 //x2=13.945 //y2=0.93
r276 (  85 114 ) resistor r=16.5046 //w=0.27 //l=0.135 //layer=ply \
 //thickness=0.18 //x=13.92 //y=4.97 //x2=13.785 //y2=4.97
r277 (  84 91 ) resistor r=26.9307 //w=0.15 //l=0.106066 //layer=ply \
 //thickness=0.18 //x=14.16 //y=4.97 //x2=14.235 //y2=5.045
r278 (  84 85 ) resistor r=123.064 //w=0.094 //l=0.24 //layer=ply \
 //thickness=0.18 //x=14.16 //y=4.97 //x2=13.92 //y2=4.97
r279 (  79 117 ) resistor r=39.5823 //w=0.21 //l=0.173853 //layer=ply \
 //thickness=0.18 //x=13.79 //y=1.74 //x2=13.83 //y2=1.585
r280 (  79 109 ) resistor r=182.032 //w=0.094 //l=0.355 //layer=ply \
 //thickness=0.18 //x=13.79 //y=1.74 //x2=13.79 //y2=2.095
r281 (  78 117 ) resistor r=39.5823 //w=0.21 //l=0.173853 //layer=ply \
 //thickness=0.18 //x=13.79 //y=1.43 //x2=13.83 //y2=1.585
r282 (  77 116 ) resistor r=45.1352 //w=0.168 //l=0.173853 //layer=ply \
 //thickness=0.18 //x=13.79 //y=1.085 //x2=13.83 //y2=0.93
r283 (  77 78 ) resistor r=176.904 //w=0.094 //l=0.345 //layer=ply \
 //thickness=0.18 //x=13.79 //y=1.085 //x2=13.79 //y2=1.43
r284 (  73 101 ) resistor r=16.5046 //w=0.27 //l=0.135 //layer=ply \
 //thickness=0.18 //x=2.79 //y=4.97 //x2=2.655 //y2=4.97
r285 (  72 74 ) resistor r=26.9307 //w=0.15 //l=0.106066 //layer=ply \
 //thickness=0.18 //x=2.99 //y=4.97 //x2=3.065 //y2=5.045
r286 (  72 73 ) resistor r=102.553 //w=0.094 //l=0.2 //layer=ply \
 //thickness=0.18 //x=2.99 //y=4.97 //x2=2.79 //y2=4.97
r287 (  71 106 ) resistor r=38.6777 //w=0.284 //l=0.198997 //layer=ply \
 //thickness=0.18 //x=2.745 //y=2.095 //x2=2.67 //y2=2.26
r288 (  70 104 ) resistor r=21.2976 //w=0.217 //l=0.0928709 //layer=ply \
 //thickness=0.18 //x=2.745 //y=1.63 //x2=2.705 //y2=1.555
r289 (  70 71 ) resistor r=238.436 //w=0.094 //l=0.465 //layer=ply \
 //thickness=0.18 //x=2.745 //y=1.63 //x2=2.745 //y2=2.095
r290 (  69 104 ) resistor r=39.0671 //w=0.217 //l=0.173853 //layer=ply \
 //thickness=0.18 //x=2.745 //y=1.4 //x2=2.705 //y2=1.555
r291 (  68 103 ) resistor r=45.1352 //w=0.168 //l=0.173853 //layer=ply \
 //thickness=0.18 //x=2.745 //y=1.09 //x2=2.705 //y2=0.935
r292 (  68 69 ) resistor r=158.957 //w=0.094 //l=0.31 //layer=ply \
 //thickness=0.18 //x=2.745 //y=1.09 //x2=2.745 //y2=1.4
r293 (  63 97 ) resistor r=5.52526 //w=0.168 //l=0.115 //layer=ply \
 //thickness=0.18 //x=2.375 //y=1.555 //x2=2.26 //y2=1.555
r294 (  62 104 ) resistor r=11.4558 //w=0.217 //l=0.115 //layer=ply \
 //thickness=0.18 //x=2.59 //y=1.555 //x2=2.705 //y2=1.555
r295 (  61 96 ) resistor r=5.52526 //w=0.168 //l=0.115 //layer=ply \
 //thickness=0.18 //x=2.375 //y=0.935 //x2=2.26 //y2=0.935
r296 (  60 103 ) resistor r=5.52526 //w=0.168 //l=0.115 //layer=ply \
 //thickness=0.18 //x=2.59 //y=0.935 //x2=2.705 //y2=0.935
r297 (  60 61 ) resistor r=110.245 //w=0.094 //l=0.215 //layer=ply \
 //thickness=0.18 //x=2.59 //y=0.935 //x2=2.375 //y2=0.935
r298 (  59 97 ) resistor r=45.1352 //w=0.168 //l=0.173853 //layer=ply \
 //thickness=0.18 //x=2.22 //y=1.4 //x2=2.26 //y2=1.555
r299 (  58 96 ) resistor r=45.1352 //w=0.168 //l=0.173853 //layer=ply \
 //thickness=0.18 //x=2.22 //y=1.09 //x2=2.26 //y2=0.935
r300 (  58 59 ) resistor r=158.957 //w=0.094 //l=0.31 //layer=ply \
 //thickness=0.18 //x=2.22 //y=1.09 //x2=2.22 //y2=1.4
r301 (  57 91 ) resistor r=592.245 //w=0.094 //l=1.155 //layer=ply \
 //thickness=0.18 //x=14.235 //y=6.2 //x2=14.235 //y2=5.045
r302 (  56 115 ) resistor r=592.245 //w=0.094 //l=1.155 //layer=ply \
 //thickness=0.18 //x=13.795 //y=6.2 //x2=13.795 //y2=5.045
r303 (  55 74 ) resistor r=592.245 //w=0.094 //l=1.155 //layer=ply \
 //thickness=0.18 //x=3.065 //y=6.2 //x2=3.065 //y2=5.045
r304 (  54 102 ) resistor r=592.245 //w=0.094 //l=1.155 //layer=ply \
 //thickness=0.18 //x=2.625 //y=6.2 //x2=2.625 //y2=5.045
r305 (  53 88 ) resistor r=56.4043 //w=0.094 //l=0.11 //layer=ply \
 //thickness=0.18 //x=14.055 //y=1.585 //x2=14.165 //y2=1.585
r306 (  53 89 ) resistor r=56.4043 //w=0.094 //l=0.11 //layer=ply \
 //thickness=0.18 //x=14.055 //y=1.585 //x2=13.945 //y2=1.585
r307 (  52 62 ) resistor r=55.3787 //w=0.094 //l=0.108 //layer=ply \
 //thickness=0.18 //x=2.482 //y=1.555 //x2=2.59 //y2=1.555
r308 (  52 63 ) resistor r=54.866 //w=0.094 //l=0.107 //layer=ply \
 //thickness=0.18 //x=2.482 //y=1.555 //x2=2.375 //y2=1.555
r309 (  51 112 ) resistor r=152 //w=0.17 //l=0.17 //layer=licon //count=1 \
 //x=13.785 //y=4.88 //x2=13.785 //y2=4.88
r310 (  45 48 ) resistor r=39.016 //w=0.187 //l=0.57 //layer=li \
 //thickness=0.1 //x=2.655 //y=3.965 //x2=2.655 //y2=4.535
r311 (  42 44 ) resistor r=13.6898 //w=0.187 //l=0.2 //layer=li \
 //thickness=0.1 //x=2.655 //y=3.595 //x2=2.655 //y2=3.795
r312 (  39 41 ) resistor r=13.6898 //w=0.187 //l=0.2 //layer=li \
 //thickness=0.1 //x=2.655 //y=3.225 //x2=2.655 //y2=3.425
r313 (  36 38 ) resistor r=13.6898 //w=0.187 //l=0.2 //layer=li \
 //thickness=0.1 //x=2.655 //y=2.855 //x2=2.655 //y2=3.055
r314 (  30 108 ) resistor r=152 //w=0.17 //l=0.17 //layer=licon //count=1 \
 //x=13.755 //y=2.26 //x2=13.755 //y2=2.26
r315 (  30 33 ) resistor r=161.54 //w=0.187 //l=2.36 //layer=li \
 //thickness=0.1 //x=13.755 //y=2.26 //x2=13.755 //y2=4.62
r316 (  28 51 ) resistor r=11.4737 //w=0.186 //l=0.172337 //layer=li \
 //thickness=0.1 //x=13.755 //y=4.715 //x2=13.77 //y2=4.88
r317 (  28 33 ) resistor r=6.50267 //w=0.187 //l=0.095 //layer=li \
 //thickness=0.1 //x=13.755 //y=4.715 //x2=13.755 //y2=4.62
r318 (  26 99 ) resistor r=152 //w=0.17 //l=0.17 //layer=licon //count=1 \
 //x=2.655 //y=4.88 //x2=2.655 //y2=4.88
r319 (  26 49 ) resistor r=11.9786 //w=0.187 //l=0.175 //layer=li \
 //thickness=0.1 //x=2.655 //y=4.88 //x2=2.655 //y2=4.705
r320 (  14 106 ) resistor r=152 //w=0.17 //l=0.17 //layer=licon //count=1 \
 //x=2.655 //y=2.26 //x2=2.655 //y2=2.26
r321 (  14 35 ) resistor r=29.0909 //w=0.187 //l=0.425 //layer=li \
 //thickness=0.1 //x=2.655 //y=2.26 //x2=2.655 //y2=2.685
r322 (  11 49 ) resistor r=5.1957 //w=0.242 //l=0.085 //layer=li \
 //thickness=0.1 //x=2.682 //y=4.62 //x2=2.682 //y2=4.705
r323 (  11 48 ) resistor r=5.1957 //w=0.242 //l=0.085 //layer=li \
 //thickness=0.1 //x=2.682 //y=4.62 //x2=2.682 //y2=4.535
r324 (  10 45 ) resistor r=5.1957 //w=0.242 //l=0.085 //layer=li \
 //thickness=0.1 //x=2.682 //y=3.88 //x2=2.682 //y2=3.965
r325 (  10 44 ) resistor r=5.1957 //w=0.242 //l=0.085 //layer=li \
 //thickness=0.1 //x=2.682 //y=3.88 //x2=2.682 //y2=3.795
r326 (  9 42 ) resistor r=5.1957 //w=0.242 //l=0.085 //layer=li \
 //thickness=0.1 //x=2.682 //y=3.51 //x2=2.682 //y2=3.595
r327 (  9 41 ) resistor r=5.1957 //w=0.242 //l=0.085 //layer=li \
 //thickness=0.1 //x=2.682 //y=3.51 //x2=2.682 //y2=3.425
r328 (  8 39 ) resistor r=5.1957 //w=0.242 //l=0.085 //layer=li \
 //thickness=0.1 //x=2.682 //y=3.14 //x2=2.682 //y2=3.225
r329 (  8 38 ) resistor r=5.1957 //w=0.242 //l=0.085 //layer=li \
 //thickness=0.1 //x=2.682 //y=3.14 //x2=2.682 //y2=3.055
r330 (  7 36 ) resistor r=5.1957 //w=0.242 //l=0.085 //layer=li \
 //thickness=0.1 //x=2.682 //y=2.77 //x2=2.682 //y2=2.855
r331 (  7 35 ) resistor r=5.1957 //w=0.242 //l=0.085 //layer=li \
 //thickness=0.1 //x=2.682 //y=2.77 //x2=2.682 //y2=2.685
r332 (  6 33 ) resistor r=9.3 //w=0.17 //l=0.17 //layer=mcon //count=1 \
 //x=13.755 //y=4.62 //x2=13.755 //y2=4.62
r333 (  4 11 ) resistor r=9.3 //w=0.17 //l=0.17 //layer=mcon //count=1 \
 //x=2.655 //y=4.62 //x2=2.655 //y2=4.62
r334 (  2 4 ) resistor r=0.0717383 //w=0.224 //l=0.115 //layer=m1 \
 //thickness=0.36 //x=2.77 //y=4.62 //x2=2.655 //y2=4.62
r335 (  1 6 ) resistor r=0.0717383 //w=0.224 //l=0.115 //layer=m1 \
 //thickness=0.36 //x=13.64 //y=4.62 //x2=13.755 //y2=4.62
r336 (  1 2 ) resistor r=10.3721 //w=0.131 //l=10.87 //layer=m1 \
 //thickness=0.36 //x=13.64 //y=4.62 //x2=2.77 //y2=4.62
ends PM_DFFQX1\%CLK

subckt PM_DFFQX1\%noxref_6 ( 1 2 3 4 17 18 25 33 39 40 44 46 54 61 62 63 64 65 \
 66 67 68 69 70 71 72 76 78 81 82 86 87 88 89 93 95 98 99 109 118 121 123 124 \
 125 )
c258 ( 125 0 ) capacitor c=0.023087f //x=3.58 //y=5.2
c259 ( 124 0 ) capacitor c=0.023519f //x=2.7 //y=5.2
c260 ( 123 0 ) capacitor c=0.0224735f //x=1.82 //y=5.2
c261 ( 121 0 ) capacitor c=0.00872971f //x=3.83 //y=1.095
c262 ( 118 0 ) capacitor c=0.0593152f //x=16.345 //y=4.88
c263 ( 109 0 ) capacitor c=0.0588816f //x=6.355 //y=4.88
c264 ( 99 0 ) capacitor c=0.0318948f //x=16.68 //y=1.39
c265 ( 98 0 ) capacitor c=0.0187384f //x=16.68 //y=1.045
c266 ( 95 0 ) capacitor c=0.0141798f //x=16.525 //y=1.545
c267 ( 93 0 ) capacitor c=0.0149844f //x=16.525 //y=0.89
c268 ( 89 0 ) capacitor c=0.0860049f //x=16.15 //y=2.095
c269 ( 88 0 ) capacitor c=0.0229722f //x=16.15 //y=1.7
c270 ( 87 0 ) capacitor c=0.0234352f //x=16.15 //y=1.39
c271 ( 86 0 ) capacitor c=0.0199343f //x=16.15 //y=1.045
c272 ( 82 0 ) capacitor c=0.0318948f //x=6.69 //y=1.39
c273 ( 81 0 ) capacitor c=0.0187384f //x=6.69 //y=1.045
c274 ( 78 0 ) capacitor c=0.0141798f //x=6.535 //y=1.545
c275 ( 76 0 ) capacitor c=0.0149844f //x=6.535 //y=0.89
c276 ( 72 0 ) capacitor c=0.0860049f //x=6.16 //y=2.095
c277 ( 71 0 ) capacitor c=0.0229722f //x=6.16 //y=1.7
c278 ( 70 0 ) capacitor c=0.0234352f //x=6.16 //y=1.39
c279 ( 69 0 ) capacitor c=0.0199343f //x=6.16 //y=1.045
c280 ( 68 0 ) capacitor c=0.110275f //x=16.685 //y=6.2
c281 ( 67 0 ) capacitor c=0.154305f //x=16.245 //y=6.2
c282 ( 66 0 ) capacitor c=0.110275f //x=6.695 //y=6.2
c283 ( 65 0 ) capacitor c=0.154305f //x=6.255 //y=6.2
c284 ( 62 0 ) capacitor c=0.00106608f //x=3.725 //y=5.335
c285 ( 61 0 ) capacitor c=0.00179642f //x=2.845 //y=5.335
c286 ( 54 0 ) capacitor c=0.096094f //x=16.345 //y=2.26
c287 ( 46 0 ) capacitor c=0.0913801f //x=6.355 //y=2.26
c288 ( 44 0 ) capacitor c=0.11016f //x=4.505 //y=3.88
c289 ( 40 0 ) capacitor c=0.00493499f //x=4.105 //y=1.845
c290 ( 39 0 ) capacitor c=0.0154052f //x=4.42 //y=1.845
c291 ( 33 0 ) capacitor c=0.0284988f //x=4.42 //y=5.335
c292 ( 25 0 ) capacitor c=0.0176454f //x=3.64 //y=5.335
c293 ( 18 0 ) capacitor c=0.00351598f //x=2.05 //y=5.335
c294 ( 17 0 ) capacitor c=0.0154549f //x=2.76 //y=5.335
c295 ( 4 0 ) capacitor c=0.00424317f //x=6.47 //y=3.88
c296 ( 3 0 ) capacitor c=0.214861f //x=16.23 //y=3.88
c297 ( 2 0 ) capacitor c=0.0125346f //x=4.62 //y=3.88
c298 ( 1 0 ) capacitor c=0.0285004f //x=6.24 //y=3.88
r299 (  116 118 ) resistor r=20.6867 //w=0.233 //l=0.1 //layer=ply \
 //thickness=0.18 //x=16.245 //y=4.88 //x2=16.345 //y2=4.88
r300 (  107 109 ) resistor r=20.6867 //w=0.233 //l=0.1 //layer=ply \
 //thickness=0.18 //x=6.255 //y=4.88 //x2=6.355 //y2=4.88
r301 (  100 118 ) resistor r=70.3348 //w=0.233 //l=0.414367 //layer=ply \
 //thickness=0.18 //x=16.685 //y=5.045 //x2=16.345 //y2=4.88
r302 (  99 120 ) resistor r=45.1352 //w=0.168 //l=0.173853 //layer=ply \
 //thickness=0.18 //x=16.68 //y=1.39 //x2=16.64 //y2=1.545
r303 (  98 119 ) resistor r=45.1352 //w=0.168 //l=0.173853 //layer=ply \
 //thickness=0.18 //x=16.68 //y=1.045 //x2=16.64 //y2=0.89
r304 (  98 99 ) resistor r=176.904 //w=0.094 //l=0.345 //layer=ply \
 //thickness=0.18 //x=16.68 //y=1.045 //x2=16.68 //y2=1.39
r305 (  96 115 ) resistor r=10.701 //w=0.21 //l=0.115 //layer=ply \
 //thickness=0.18 //x=16.305 //y=1.545 //x2=16.19 //y2=1.545
r306 (  95 120 ) resistor r=5.52526 //w=0.168 //l=0.115 //layer=ply \
 //thickness=0.18 //x=16.525 //y=1.545 //x2=16.64 //y2=1.545
r307 (  94 114 ) resistor r=5.52526 //w=0.168 //l=0.115 //layer=ply \
 //thickness=0.18 //x=16.305 //y=0.89 //x2=16.19 //y2=0.89
r308 (  93 119 ) resistor r=5.52526 //w=0.168 //l=0.115 //layer=ply \
 //thickness=0.18 //x=16.525 //y=0.89 //x2=16.64 //y2=0.89
r309 (  93 94 ) resistor r=112.809 //w=0.094 //l=0.22 //layer=ply \
 //thickness=0.18 //x=16.525 //y=0.89 //x2=16.305 //y2=0.89
r310 (  90 116 ) resistor r=13.0941 //w=0.233 //l=0.165 //layer=ply \
 //thickness=0.18 //x=16.245 //y=5.045 //x2=16.245 //y2=4.88
r311 (  89 113 ) resistor r=34.8111 //w=0.27 //l=0.264953 //layer=ply \
 //thickness=0.18 //x=16.15 //y=2.095 //x2=16.345 //y2=2.26
r312 (  88 115 ) resistor r=39.5823 //w=0.21 //l=0.173853 //layer=ply \
 //thickness=0.18 //x=16.15 //y=1.7 //x2=16.19 //y2=1.545
r313 (  88 89 ) resistor r=202.543 //w=0.094 //l=0.395 //layer=ply \
 //thickness=0.18 //x=16.15 //y=1.7 //x2=16.15 //y2=2.095
r314 (  87 115 ) resistor r=39.5823 //w=0.21 //l=0.173853 //layer=ply \
 //thickness=0.18 //x=16.15 //y=1.39 //x2=16.19 //y2=1.545
r315 (  86 114 ) resistor r=45.1352 //w=0.168 //l=0.173853 //layer=ply \
 //thickness=0.18 //x=16.15 //y=1.045 //x2=16.19 //y2=0.89
r316 (  86 87 ) resistor r=176.904 //w=0.094 //l=0.345 //layer=ply \
 //thickness=0.18 //x=16.15 //y=1.045 //x2=16.15 //y2=1.39
r317 (  83 109 ) resistor r=70.3348 //w=0.233 //l=0.414367 //layer=ply \
 //thickness=0.18 //x=6.695 //y=5.045 //x2=6.355 //y2=4.88
r318 (  82 111 ) resistor r=45.1352 //w=0.168 //l=0.173853 //layer=ply \
 //thickness=0.18 //x=6.69 //y=1.39 //x2=6.65 //y2=1.545
r319 (  81 110 ) resistor r=45.1352 //w=0.168 //l=0.173853 //layer=ply \
 //thickness=0.18 //x=6.69 //y=1.045 //x2=6.65 //y2=0.89
r320 (  81 82 ) resistor r=176.904 //w=0.094 //l=0.345 //layer=ply \
 //thickness=0.18 //x=6.69 //y=1.045 //x2=6.69 //y2=1.39
r321 (  79 106 ) resistor r=10.701 //w=0.21 //l=0.115 //layer=ply \
 //thickness=0.18 //x=6.315 //y=1.545 //x2=6.2 //y2=1.545
r322 (  78 111 ) resistor r=5.52526 //w=0.168 //l=0.115 //layer=ply \
 //thickness=0.18 //x=6.535 //y=1.545 //x2=6.65 //y2=1.545
r323 (  77 105 ) resistor r=5.52526 //w=0.168 //l=0.115 //layer=ply \
 //thickness=0.18 //x=6.315 //y=0.89 //x2=6.2 //y2=0.89
r324 (  76 110 ) resistor r=5.52526 //w=0.168 //l=0.115 //layer=ply \
 //thickness=0.18 //x=6.535 //y=0.89 //x2=6.65 //y2=0.89
r325 (  76 77 ) resistor r=112.809 //w=0.094 //l=0.22 //layer=ply \
 //thickness=0.18 //x=6.535 //y=0.89 //x2=6.315 //y2=0.89
r326 (  73 107 ) resistor r=13.0941 //w=0.233 //l=0.165 //layer=ply \
 //thickness=0.18 //x=6.255 //y=5.045 //x2=6.255 //y2=4.88
r327 (  72 104 ) resistor r=34.8111 //w=0.27 //l=0.264953 //layer=ply \
 //thickness=0.18 //x=6.16 //y=2.095 //x2=6.355 //y2=2.26
r328 (  71 106 ) resistor r=39.5823 //w=0.21 //l=0.173853 //layer=ply \
 //thickness=0.18 //x=6.16 //y=1.7 //x2=6.2 //y2=1.545
r329 (  71 72 ) resistor r=202.543 //w=0.094 //l=0.395 //layer=ply \
 //thickness=0.18 //x=6.16 //y=1.7 //x2=6.16 //y2=2.095
r330 (  70 106 ) resistor r=39.5823 //w=0.21 //l=0.173853 //layer=ply \
 //thickness=0.18 //x=6.16 //y=1.39 //x2=6.2 //y2=1.545
r331 (  69 105 ) resistor r=45.1352 //w=0.168 //l=0.173853 //layer=ply \
 //thickness=0.18 //x=6.16 //y=1.045 //x2=6.2 //y2=0.89
r332 (  69 70 ) resistor r=176.904 //w=0.094 //l=0.345 //layer=ply \
 //thickness=0.18 //x=6.16 //y=1.045 //x2=6.16 //y2=1.39
r333 (  68 100 ) resistor r=592.245 //w=0.094 //l=1.155 //layer=ply \
 //thickness=0.18 //x=16.685 //y=6.2 //x2=16.685 //y2=5.045
r334 (  67 90 ) resistor r=592.245 //w=0.094 //l=1.155 //layer=ply \
 //thickness=0.18 //x=16.245 //y=6.2 //x2=16.245 //y2=5.045
r335 (  66 83 ) resistor r=592.245 //w=0.094 //l=1.155 //layer=ply \
 //thickness=0.18 //x=6.695 //y=6.2 //x2=6.695 //y2=5.045
r336 (  65 73 ) resistor r=592.245 //w=0.094 //l=1.155 //layer=ply \
 //thickness=0.18 //x=6.255 //y=6.2 //x2=6.255 //y2=5.045
r337 (  64 95 ) resistor r=56.4043 //w=0.094 //l=0.11 //layer=ply \
 //thickness=0.18 //x=16.415 //y=1.545 //x2=16.525 //y2=1.545
r338 (  64 96 ) resistor r=56.4043 //w=0.094 //l=0.11 //layer=ply \
 //thickness=0.18 //x=16.415 //y=1.545 //x2=16.305 //y2=1.545
r339 (  63 78 ) resistor r=56.4043 //w=0.094 //l=0.11 //layer=ply \
 //thickness=0.18 //x=6.425 //y=1.545 //x2=6.535 //y2=1.545
r340 (  63 79 ) resistor r=56.4043 //w=0.094 //l=0.11 //layer=ply \
 //thickness=0.18 //x=6.425 //y=1.545 //x2=6.315 //y2=1.545
r341 (  59 118 ) resistor r=152 //w=0.17 //l=0.17 //layer=licon //count=1 \
 //x=16.345 //y=4.88 //x2=16.345 //y2=4.88
r342 (  57 59 ) resistor r=68.4492 //w=0.187 //l=1 //layer=li //thickness=0.1 \
 //x=16.345 //y=3.88 //x2=16.345 //y2=4.88
r343 (  54 113 ) resistor r=152 //w=0.17 //l=0.17 //layer=licon //count=1 \
 //x=16.345 //y=2.26 //x2=16.345 //y2=2.26
r344 (  54 57 ) resistor r=110.888 //w=0.187 //l=1.62 //layer=li \
 //thickness=0.1 //x=16.345 //y=2.26 //x2=16.345 //y2=3.88
r345 (  51 109 ) resistor r=152 //w=0.17 //l=0.17 //layer=licon //count=1 \
 //x=6.355 //y=4.88 //x2=6.355 //y2=4.88
r346 (  49 51 ) resistor r=68.4492 //w=0.187 //l=1 //layer=li //thickness=0.1 \
 //x=6.355 //y=3.88 //x2=6.355 //y2=4.88
r347 (  46 104 ) resistor r=152 //w=0.17 //l=0.17 //layer=licon //count=1 \
 //x=6.355 //y=2.26 //x2=6.355 //y2=2.26
r348 (  46 49 ) resistor r=110.888 //w=0.187 //l=1.62 //layer=li \
 //thickness=0.1 //x=6.355 //y=2.26 //x2=6.355 //y2=3.88
r349 (  42 44 ) resistor r=93.7754 //w=0.187 //l=1.37 //layer=li \
 //thickness=0.1 //x=4.505 //y=5.25 //x2=4.505 //y2=3.88
r350 (  41 44 ) resistor r=133.476 //w=0.187 //l=1.95 //layer=li \
 //thickness=0.1 //x=4.505 //y=1.93 //x2=4.505 //y2=3.88
r351 (  39 41 ) resistor r=7.15173 //w=0.17 //l=0.120208 //layer=li \
 //thickness=0.1 //x=4.42 //y=1.845 //x2=4.505 //y2=1.93
r352 (  39 40 ) resistor r=21.5615 //w=0.187 //l=0.315 //layer=li \
 //thickness=0.1 //x=4.42 //y=1.845 //x2=4.105 //y2=1.845
r353 (  35 40 ) resistor r=7.15173 //w=0.17 //l=0.120208 //layer=li \
 //thickness=0.1 //x=4.02 //y=1.76 //x2=4.105 //y2=1.845
r354 (  35 121 ) resistor r=39.016 //w=0.187 //l=0.57 //layer=li \
 //thickness=0.1 //x=4.02 //y=1.76 //x2=4.02 //y2=1.19
r355 (  34 62 ) resistor r=5.4201 //w=0.17 //l=0.085 //layer=li \
 //thickness=0.1 //x=3.81 //y=5.335 //x2=3.725 //y2=5.335
r356 (  33 42 ) resistor r=7.15173 //w=0.17 //l=0.120208 //layer=li \
 //thickness=0.1 //x=4.42 //y=5.335 //x2=4.505 //y2=5.25
r357 (  33 34 ) resistor r=41.754 //w=0.187 //l=0.61 //layer=li \
 //thickness=0.1 //x=4.42 //y=5.335 //x2=3.81 //y2=5.335
r358 (  27 62 ) resistor r=1.40859 //w=0.34 //l=0.085 //layer=li \
 //thickness=0.1 //x=3.725 //y=5.42 //x2=3.725 //y2=5.335
r359 (  27 125 ) resistor r=33.1979 //w=0.187 //l=0.485 //layer=li \
 //thickness=0.1 //x=3.725 //y=5.42 //x2=3.725 //y2=5.905
r360 (  26 61 ) resistor r=5.4201 //w=0.17 //l=0.085 //layer=li \
 //thickness=0.1 //x=2.93 //y=5.335 //x2=2.845 //y2=5.335
r361 (  25 62 ) resistor r=5.4201 //w=0.17 //l=0.085 //layer=li \
 //thickness=0.1 //x=3.64 //y=5.335 //x2=3.725 //y2=5.335
r362 (  25 26 ) resistor r=48.5989 //w=0.187 //l=0.71 //layer=li \
 //thickness=0.1 //x=3.64 //y=5.335 //x2=2.93 //y2=5.335
r363 (  19 61 ) resistor r=1.40859 //w=0.34 //l=0.085 //layer=li \
 //thickness=0.1 //x=2.845 //y=5.42 //x2=2.845 //y2=5.335
r364 (  19 124 ) resistor r=33.1979 //w=0.187 //l=0.485 //layer=li \
 //thickness=0.1 //x=2.845 //y=5.42 //x2=2.845 //y2=5.905
r365 (  17 61 ) resistor r=5.4201 //w=0.17 //l=0.085 //layer=li \
 //thickness=0.1 //x=2.76 //y=5.335 //x2=2.845 //y2=5.335
r366 (  17 18 ) resistor r=48.5989 //w=0.187 //l=0.71 //layer=li \
 //thickness=0.1 //x=2.76 //y=5.335 //x2=2.05 //y2=5.335
r367 (  11 18 ) resistor r=7.15173 //w=0.17 //l=0.120208 //layer=li \
 //thickness=0.1 //x=1.965 //y=5.42 //x2=2.05 //y2=5.335
r368 (  11 123 ) resistor r=33.1979 //w=0.187 //l=0.485 //layer=li \
 //thickness=0.1 //x=1.965 //y=5.42 //x2=1.965 //y2=5.905
r369 (  10 57 ) resistor r=9.3 //w=0.17 //l=0.17 //layer=mcon //count=1 \
 //x=16.345 //y=3.88 //x2=16.345 //y2=3.88
r370 (  8 49 ) resistor r=9.3 //w=0.17 //l=0.17 //layer=mcon //count=1 \
 //x=6.355 //y=3.88 //x2=6.355 //y2=3.88
r371 (  6 44 ) resistor r=9.3 //w=0.17 //l=0.17 //layer=mcon //count=1 \
 //x=4.505 //y=3.88 //x2=4.505 //y2=3.88
r372 (  4 8 ) resistor r=0.0880901 //w=0.191 //l=0.115 //layer=m1 \
 //thickness=0.36 //x=6.47 //y=3.88 //x2=6.355 //y2=3.88
r373 (  3 10 ) resistor r=0.0717383 //w=0.224 //l=0.115 //layer=m1 \
 //thickness=0.36 //x=16.23 //y=3.88 //x2=16.345 //y2=3.88
r374 (  3 4 ) resistor r=9.31298 //w=0.131 //l=9.76 //layer=m1 \
 //thickness=0.36 //x=16.23 //y=3.88 //x2=6.47 //y2=3.88
r375 (  2 6 ) resistor r=0.0717383 //w=0.224 //l=0.115 //layer=m1 \
 //thickness=0.36 //x=4.62 //y=3.88 //x2=4.505 //y2=3.88
r376 (  1 8 ) resistor r=0.0880901 //w=0.191 //l=0.115 //layer=m1 \
 //thickness=0.36 //x=6.24 //y=3.88 //x2=6.355 //y2=3.88
r377 (  1 2 ) resistor r=1.5458 //w=0.131 //l=1.62 //layer=m1 //thickness=0.36 \
 //x=6.24 //y=3.88 //x2=4.62 //y2=3.88
ends PM_DFFQX1\%noxref_6

subckt PM_DFFQX1\%noxref_7 ( 3 5 8 11 12 13 14 15 16 21 23 25 31 32 34 35 38 )
c79 ( 38 0 ) capacitor c=0.0331552f //x=17.115 //y=4.88
c80 ( 35 0 ) capacitor c=0.0279499f //x=17.085 //y=2.095
c81 ( 34 0 ) capacitor c=0.0437302f //x=17.085 //y=2.26
c82 ( 32 0 ) capacitor c=0.0429696f //x=17.65 //y=1.43
c83 ( 31 0 ) capacitor c=0.0192208f //x=17.65 //y=1.085
c84 ( 25 0 ) capacitor c=0.0158629f //x=17.495 //y=1.585
c85 ( 23 0 ) capacitor c=0.0157803f //x=17.495 //y=0.93
c86 ( 21 0 ) capacitor c=0.0299681f //x=17.49 //y=4.97
c87 ( 16 0 ) capacitor c=0.0205163f //x=17.12 //y=1.74
c88 ( 15 0 ) capacitor c=0.0168481f //x=17.12 //y=1.43
c89 ( 14 0 ) capacitor c=0.0174783f //x=17.12 //y=1.085
c90 ( 13 0 ) capacitor c=0.15358f //x=17.565 //y=6.2
c91 ( 12 0 ) capacitor c=0.110281f //x=17.125 //y=6.2
c92 ( 8 0 ) capacitor c=0.0133912f //x=17.085 //y=3.88
c93 ( 5 0 ) capacitor c=0.0767547f //x=17.085 //y=2.26
c94 ( 3 0 ) capacitor c=0.00453889f //x=17.085 //y=4.715
r95 (  40 41 ) resistor r=32.4568 //w=0.214 //l=0.075 //layer=ply \
 //thickness=0.18 //x=17.115 //y=4.97 //x2=17.115 //y2=5.045
r96 (  38 40 ) resistor r=20.271 //w=0.214 //l=0.09 //layer=ply \
 //thickness=0.18 //x=17.115 //y=4.88 //x2=17.115 //y2=4.97
r97 (  34 35 ) resistor r=52.7279 //w=0.214 //l=0.165 //layer=ply \
 //thickness=0.18 //x=17.085 //y=2.26 //x2=17.085 //y2=2.095
r98 (  32 45 ) resistor r=45.1352 //w=0.168 //l=0.173853 //layer=ply \
 //thickness=0.18 //x=17.65 //y=1.43 //x2=17.61 //y2=1.585
r99 (  31 44 ) resistor r=45.1352 //w=0.168 //l=0.173853 //layer=ply \
 //thickness=0.18 //x=17.65 //y=1.085 //x2=17.61 //y2=0.93
r100 (  31 32 ) resistor r=176.904 //w=0.094 //l=0.345 //layer=ply \
 //thickness=0.18 //x=17.65 //y=1.085 //x2=17.65 //y2=1.43
r101 (  26 43 ) resistor r=10.701 //w=0.21 //l=0.115 //layer=ply \
 //thickness=0.18 //x=17.275 //y=1.585 //x2=17.16 //y2=1.585
r102 (  25 45 ) resistor r=5.52526 //w=0.168 //l=0.115 //layer=ply \
 //thickness=0.18 //x=17.495 //y=1.585 //x2=17.61 //y2=1.585
r103 (  24 42 ) resistor r=5.52526 //w=0.168 //l=0.115 //layer=ply \
 //thickness=0.18 //x=17.275 //y=0.93 //x2=17.16 //y2=0.93
r104 (  23 44 ) resistor r=5.52526 //w=0.168 //l=0.115 //layer=ply \
 //thickness=0.18 //x=17.495 //y=0.93 //x2=17.61 //y2=0.93
r105 (  23 24 ) resistor r=112.809 //w=0.094 //l=0.22 //layer=ply \
 //thickness=0.18 //x=17.495 //y=0.93 //x2=17.275 //y2=0.93
r106 (  22 40 ) resistor r=16.5046 //w=0.27 //l=0.135 //layer=ply \
 //thickness=0.18 //x=17.25 //y=4.97 //x2=17.115 //y2=4.97
r107 (  21 28 ) resistor r=26.9307 //w=0.15 //l=0.106066 //layer=ply \
 //thickness=0.18 //x=17.49 //y=4.97 //x2=17.565 //y2=5.045
r108 (  21 22 ) resistor r=123.064 //w=0.094 //l=0.24 //layer=ply \
 //thickness=0.18 //x=17.49 //y=4.97 //x2=17.25 //y2=4.97
r109 (  16 43 ) resistor r=39.5823 //w=0.21 //l=0.173853 //layer=ply \
 //thickness=0.18 //x=17.12 //y=1.74 //x2=17.16 //y2=1.585
r110 (  16 35 ) resistor r=182.032 //w=0.094 //l=0.355 //layer=ply \
 //thickness=0.18 //x=17.12 //y=1.74 //x2=17.12 //y2=2.095
r111 (  15 43 ) resistor r=39.5823 //w=0.21 //l=0.173853 //layer=ply \
 //thickness=0.18 //x=17.12 //y=1.43 //x2=17.16 //y2=1.585
r112 (  14 42 ) resistor r=45.1352 //w=0.168 //l=0.173853 //layer=ply \
 //thickness=0.18 //x=17.12 //y=1.085 //x2=17.16 //y2=0.93
r113 (  14 15 ) resistor r=176.904 //w=0.094 //l=0.345 //layer=ply \
 //thickness=0.18 //x=17.12 //y=1.085 //x2=17.12 //y2=1.43
r114 (  13 28 ) resistor r=592.245 //w=0.094 //l=1.155 //layer=ply \
 //thickness=0.18 //x=17.565 //y=6.2 //x2=17.565 //y2=5.045
r115 (  12 41 ) resistor r=592.245 //w=0.094 //l=1.155 //layer=ply \
 //thickness=0.18 //x=17.125 //y=6.2 //x2=17.125 //y2=5.045
r116 (  11 25 ) resistor r=56.4043 //w=0.094 //l=0.11 //layer=ply \
 //thickness=0.18 //x=17.385 //y=1.585 //x2=17.495 //y2=1.585
r117 (  11 26 ) resistor r=56.4043 //w=0.094 //l=0.11 //layer=ply \
 //thickness=0.18 //x=17.385 //y=1.585 //x2=17.275 //y2=1.585
r118 (  10 38 ) resistor r=152 //w=0.17 //l=0.17 //layer=licon //count=1 \
 //x=17.115 //y=4.88 //x2=17.115 //y2=4.88
r119 (  5 34 ) resistor r=152 //w=0.17 //l=0.17 //layer=licon //count=1 \
 //x=17.085 //y=2.26 //x2=17.085 //y2=2.26
r120 (  5 8 ) resistor r=110.888 //w=0.187 //l=1.62 //layer=li //thickness=0.1 \
 //x=17.085 //y=2.26 //x2=17.085 //y2=3.88
r121 (  3 10 ) resistor r=11.4737 //w=0.186 //l=0.172337 //layer=li \
 //thickness=0.1 //x=17.085 //y=4.715 //x2=17.1 //y2=4.88
r122 (  3 8 ) resistor r=57.1551 //w=0.187 //l=0.835 //layer=li \
 //thickness=0.1 //x=17.085 //y=4.715 //x2=17.085 //y2=3.88
ends PM_DFFQX1\%noxref_7

subckt PM_DFFQX1\%noxref_8 ( 9 10 21 23 24 28 29 30 32 33 )
c80 ( 33 0 ) capacitor c=0.0220291f //x=17.2 //y=5.2
c81 ( 32 0 ) capacitor c=0.0217503f //x=16.32 //y=5.2
c82 ( 30 0 ) capacitor c=0.00866655f //x=17.195 //y=1.085
c83 ( 29 0 ) capacitor c=0.0023043f //x=17.345 //y=5.38
c84 ( 28 0 ) capacitor c=0.129608f //x=17.825 //y=3.51
c85 ( 24 0 ) capacitor c=0.00533733f //x=17.47 //y=1.835
c86 ( 23 0 ) capacitor c=0.0139525f //x=17.74 //y=1.835
c87 ( 21 0 ) capacitor c=0.0140462f //x=17.74 //y=5.38
c88 ( 10 0 ) capacitor c=0.00265417f //x=16.55 //y=5.38
c89 ( 9 0 ) capacitor c=0.0149571f //x=17.26 //y=5.38
r90 (  26 28 ) resistor r=122.182 //w=0.187 //l=1.785 //layer=li \
 //thickness=0.1 //x=17.825 //y=5.295 //x2=17.825 //y2=3.51
r91 (  25 28 ) resistor r=108.834 //w=0.187 //l=1.59 //layer=li \
 //thickness=0.1 //x=17.825 //y=1.92 //x2=17.825 //y2=3.51
r92 (  23 25 ) resistor r=7.15173 //w=0.17 //l=0.120208 //layer=li \
 //thickness=0.1 //x=17.74 //y=1.835 //x2=17.825 //y2=1.92
r93 (  23 24 ) resistor r=18.4813 //w=0.187 //l=0.27 //layer=li \
 //thickness=0.1 //x=17.74 //y=1.835 //x2=17.47 //y2=1.835
r94 (  22 29 ) resistor r=5.4201 //w=0.17 //l=0.085 //layer=li //thickness=0.1 \
 //x=17.43 //y=5.38 //x2=17.345 //y2=5.38
r95 (  21 26 ) resistor r=7.15173 //w=0.17 //l=0.120208 //layer=li \
 //thickness=0.1 //x=17.74 //y=5.38 //x2=17.825 //y2=5.295
r96 (  21 22 ) resistor r=21.2193 //w=0.187 //l=0.31 //layer=li \
 //thickness=0.1 //x=17.74 //y=5.38 //x2=17.43 //y2=5.38
r97 (  17 24 ) resistor r=7.15173 //w=0.17 //l=0.120208 //layer=li \
 //thickness=0.1 //x=17.385 //y=1.75 //x2=17.47 //y2=1.835
r98 (  17 30 ) resistor r=39.016 //w=0.187 //l=0.57 //layer=li //thickness=0.1 \
 //x=17.385 //y=1.75 //x2=17.385 //y2=1.18
r99 (  11 29 ) resistor r=1.40859 //w=0.34 //l=0.085 //layer=li \
 //thickness=0.1 //x=17.345 //y=5.465 //x2=17.345 //y2=5.38
r100 (  11 33 ) resistor r=30.1176 //w=0.187 //l=0.44 //layer=li \
 //thickness=0.1 //x=17.345 //y=5.465 //x2=17.345 //y2=5.905
r101 (  9 29 ) resistor r=5.4201 //w=0.17 //l=0.085 //layer=li //thickness=0.1 \
 //x=17.26 //y=5.38 //x2=17.345 //y2=5.38
r102 (  9 10 ) resistor r=48.5989 //w=0.187 //l=0.71 //layer=li \
 //thickness=0.1 //x=17.26 //y=5.38 //x2=16.55 //y2=5.38
r103 (  3 10 ) resistor r=7.15173 //w=0.17 //l=0.120208 //layer=li \
 //thickness=0.1 //x=16.465 //y=5.465 //x2=16.55 //y2=5.38
r104 (  3 32 ) resistor r=30.1176 //w=0.187 //l=0.44 //layer=li \
 //thickness=0.1 //x=16.465 //y=5.465 //x2=16.465 //y2=5.905
ends PM_DFFQX1\%noxref_8

subckt PM_DFFQX1\%noxref_9 ( 6 9 13 14 15 16 17 18 19 23 25 28 29 39 )
c71 ( 39 0 ) capacitor c=0.0593152f //x=19.675 //y=4.88
c72 ( 29 0 ) capacitor c=0.0318948f //x=20.01 //y=1.39
c73 ( 28 0 ) capacitor c=0.0187384f //x=20.01 //y=1.045
c74 ( 25 0 ) capacitor c=0.0141798f //x=19.855 //y=1.545
c75 ( 23 0 ) capacitor c=0.0149844f //x=19.855 //y=0.89
c76 ( 19 0 ) capacitor c=0.0853292f //x=19.48 //y=2.095
c77 ( 18 0 ) capacitor c=0.0229722f //x=19.48 //y=1.7
c78 ( 17 0 ) capacitor c=0.0234352f //x=19.48 //y=1.39
c79 ( 16 0 ) capacitor c=0.0199343f //x=19.48 //y=1.045
c80 ( 15 0 ) capacitor c=0.110275f //x=20.015 //y=6.2
c81 ( 14 0 ) capacitor c=0.154305f //x=19.575 //y=6.2
c82 ( 9 0 ) capacitor c=0.0601101f //x=19.675 //y=3.51
c83 ( 6 0 ) capacitor c=0.0935079f //x=19.675 //y=2.26
r84 (  37 39 ) resistor r=20.6867 //w=0.233 //l=0.1 //layer=ply \
 //thickness=0.18 //x=19.575 //y=4.88 //x2=19.675 //y2=4.88
r85 (  30 39 ) resistor r=70.3348 //w=0.233 //l=0.414367 //layer=ply \
 //thickness=0.18 //x=20.015 //y=5.045 //x2=19.675 //y2=4.88
r86 (  29 41 ) resistor r=45.1352 //w=0.168 //l=0.173853 //layer=ply \
 //thickness=0.18 //x=20.01 //y=1.39 //x2=19.97 //y2=1.545
r87 (  28 40 ) resistor r=45.1352 //w=0.168 //l=0.173853 //layer=ply \
 //thickness=0.18 //x=20.01 //y=1.045 //x2=19.97 //y2=0.89
r88 (  28 29 ) resistor r=176.904 //w=0.094 //l=0.345 //layer=ply \
 //thickness=0.18 //x=20.01 //y=1.045 //x2=20.01 //y2=1.39
r89 (  26 36 ) resistor r=10.701 //w=0.21 //l=0.115 //layer=ply \
 //thickness=0.18 //x=19.635 //y=1.545 //x2=19.52 //y2=1.545
r90 (  25 41 ) resistor r=5.52526 //w=0.168 //l=0.115 //layer=ply \
 //thickness=0.18 //x=19.855 //y=1.545 //x2=19.97 //y2=1.545
r91 (  24 35 ) resistor r=5.52526 //w=0.168 //l=0.115 //layer=ply \
 //thickness=0.18 //x=19.635 //y=0.89 //x2=19.52 //y2=0.89
r92 (  23 40 ) resistor r=5.52526 //w=0.168 //l=0.115 //layer=ply \
 //thickness=0.18 //x=19.855 //y=0.89 //x2=19.97 //y2=0.89
r93 (  23 24 ) resistor r=112.809 //w=0.094 //l=0.22 //layer=ply \
 //thickness=0.18 //x=19.855 //y=0.89 //x2=19.635 //y2=0.89
r94 (  20 37 ) resistor r=13.0941 //w=0.233 //l=0.165 //layer=ply \
 //thickness=0.18 //x=19.575 //y=5.045 //x2=19.575 //y2=4.88
r95 (  19 34 ) resistor r=34.8111 //w=0.27 //l=0.264953 //layer=ply \
 //thickness=0.18 //x=19.48 //y=2.095 //x2=19.675 //y2=2.26
r96 (  18 36 ) resistor r=39.5823 //w=0.21 //l=0.173853 //layer=ply \
 //thickness=0.18 //x=19.48 //y=1.7 //x2=19.52 //y2=1.545
r97 (  18 19 ) resistor r=202.543 //w=0.094 //l=0.395 //layer=ply \
 //thickness=0.18 //x=19.48 //y=1.7 //x2=19.48 //y2=2.095
r98 (  17 36 ) resistor r=39.5823 //w=0.21 //l=0.173853 //layer=ply \
 //thickness=0.18 //x=19.48 //y=1.39 //x2=19.52 //y2=1.545
r99 (  16 35 ) resistor r=45.1352 //w=0.168 //l=0.173853 //layer=ply \
 //thickness=0.18 //x=19.48 //y=1.045 //x2=19.52 //y2=0.89
r100 (  16 17 ) resistor r=176.904 //w=0.094 //l=0.345 //layer=ply \
 //thickness=0.18 //x=19.48 //y=1.045 //x2=19.48 //y2=1.39
r101 (  15 30 ) resistor r=592.245 //w=0.094 //l=1.155 //layer=ply \
 //thickness=0.18 //x=20.015 //y=6.2 //x2=20.015 //y2=5.045
r102 (  14 20 ) resistor r=592.245 //w=0.094 //l=1.155 //layer=ply \
 //thickness=0.18 //x=19.575 //y=6.2 //x2=19.575 //y2=5.045
r103 (  13 25 ) resistor r=56.4043 //w=0.094 //l=0.11 //layer=ply \
 //thickness=0.18 //x=19.745 //y=1.545 //x2=19.855 //y2=1.545
r104 (  13 26 ) resistor r=56.4043 //w=0.094 //l=0.11 //layer=ply \
 //thickness=0.18 //x=19.745 //y=1.545 //x2=19.635 //y2=1.545
r105 (  11 39 ) resistor r=152 //w=0.17 //l=0.17 //layer=licon //count=1 \
 //x=19.675 //y=4.88 //x2=19.675 //y2=4.88
r106 (  9 11 ) resistor r=93.7754 //w=0.187 //l=1.37 //layer=li \
 //thickness=0.1 //x=19.675 //y=3.51 //x2=19.675 //y2=4.88
r107 (  6 34 ) resistor r=152 //w=0.17 //l=0.17 //layer=licon //count=1 \
 //x=19.675 //y=2.26 //x2=19.675 //y2=2.26
r108 (  6 9 ) resistor r=85.5615 //w=0.187 //l=1.25 //layer=li //thickness=0.1 \
 //x=19.675 //y=2.26 //x2=19.675 //y2=3.51
ends PM_DFFQX1\%noxref_9

subckt PM_DFFQX1\%noxref_10 ( 1 2 3 4 5 6 16 23 25 35 36 47 49 50 54 55 57 63 \
 66 67 68 69 70 71 72 73 74 75 76 77 78 79 81 87 88 89 90 94 95 96 101 103 105 \
 111 112 113 114 115 120 122 124 130 131 141 142 145 154 155 158 166 168 169 )
c366 ( 169 0 ) capacitor c=0.0220291f //x=13.87 //y=5.2
c367 ( 168 0 ) capacitor c=0.0217503f //x=12.99 //y=5.2
c368 ( 166 0 ) capacitor c=0.00866655f //x=13.865 //y=1.085
c369 ( 158 0 ) capacitor c=0.0331844f //x=20.445 //y=4.88
c370 ( 155 0 ) capacitor c=0.0279499f //x=20.415 //y=2.095
c371 ( 154 0 ) capacitor c=0.0437302f //x=20.415 //y=2.26
c372 ( 145 0 ) capacitor c=0.0331095f //x=10.455 //y=4.88
c373 ( 142 0 ) capacitor c=0.0279499f //x=10.425 //y=2.095
c374 ( 141 0 ) capacitor c=0.0437302f //x=10.425 //y=2.26
c375 ( 131 0 ) capacitor c=0.0429696f //x=20.98 //y=1.43
c376 ( 130 0 ) capacitor c=0.0192208f //x=20.98 //y=1.085
c377 ( 124 0 ) capacitor c=0.0158629f //x=20.825 //y=1.585
c378 ( 122 0 ) capacitor c=0.0157803f //x=20.825 //y=0.93
c379 ( 120 0 ) capacitor c=0.0306375f //x=20.82 //y=4.97
c380 ( 115 0 ) capacitor c=0.0205163f //x=20.45 //y=1.74
c381 ( 114 0 ) capacitor c=0.0168481f //x=20.45 //y=1.43
c382 ( 113 0 ) capacitor c=0.0174783f //x=20.45 //y=1.085
c383 ( 112 0 ) capacitor c=0.0429696f //x=10.99 //y=1.43
c384 ( 111 0 ) capacitor c=0.0192208f //x=10.99 //y=1.085
c385 ( 105 0 ) capacitor c=0.0158629f //x=10.835 //y=1.585
c386 ( 103 0 ) capacitor c=0.0157803f //x=10.835 //y=0.93
c387 ( 101 0 ) capacitor c=0.0295235f //x=10.83 //y=4.97
c388 ( 96 0 ) capacitor c=0.0205163f //x=10.46 //y=1.74
c389 ( 95 0 ) capacitor c=0.0168481f //x=10.46 //y=1.43
c390 ( 94 0 ) capacitor c=0.0174783f //x=10.46 //y=1.085
c391 ( 90 0 ) capacitor c=0.0559896f //x=1.82 //y=4.97
c392 ( 89 0 ) capacitor c=0.0298189f //x=2.11 //y=4.97
c393 ( 88 0 ) capacitor c=0.0347816f //x=1.775 //y=1.4
c394 ( 87 0 ) capacitor c=0.0187487f //x=1.775 //y=1.055
c395 ( 81 0 ) capacitor c=0.0137055f //x=1.62 //y=1.555
c396 ( 79 0 ) capacitor c=0.0149861f //x=1.62 //y=0.9
c397 ( 78 0 ) capacitor c=0.102158f //x=1.245 //y=2.095
c398 ( 77 0 ) capacitor c=0.0229444f //x=1.245 //y=1.71
c399 ( 76 0 ) capacitor c=0.0234352f //x=1.245 //y=1.4
c400 ( 75 0 ) capacitor c=0.0198724f //x=1.245 //y=1.055
c401 ( 74 0 ) capacitor c=0.15358f //x=20.895 //y=6.2
c402 ( 73 0 ) capacitor c=0.110281f //x=20.455 //y=6.2
c403 ( 72 0 ) capacitor c=0.15358f //x=10.905 //y=6.2
c404 ( 71 0 ) capacitor c=0.110281f //x=10.465 //y=6.2
c405 ( 70 0 ) capacitor c=0.110114f //x=2.185 //y=6.2
c406 ( 69 0 ) capacitor c=0.158956f //x=1.745 //y=6.2
c407 ( 63 0 ) capacitor c=0.0023043f //x=14.015 //y=5.38
c408 ( 57 0 ) capacitor c=0.0765697f //x=20.415 //y=2.26
c409 ( 55 0 ) capacitor c=0.00453889f //x=20.415 //y=4.715
c410 ( 54 0 ) capacitor c=0.111691f //x=14.495 //y=4.25
c411 ( 50 0 ) capacitor c=0.00525782f //x=14.14 //y=1.835
c412 ( 49 0 ) capacitor c=0.0140405f //x=14.41 //y=1.835
c413 ( 47 0 ) capacitor c=0.0140419f //x=14.41 //y=5.38
c414 ( 36 0 ) capacitor c=0.00251459f //x=13.22 //y=5.38
c415 ( 35 0 ) capacitor c=0.0143111f //x=13.93 //y=5.38
c416 ( 25 0 ) capacitor c=0.0739568f //x=10.425 //y=2.26
c417 ( 23 0 ) capacitor c=0.00453889f //x=10.425 //y=4.715
c418 ( 16 0 ) capacitor c=0.12442f //x=1.545 //y=2.26
c419 ( 6 0 ) capacitor c=0.00579155f //x=14.61 //y=4.25
c420 ( 5 0 ) capacitor c=0.173243f //x=20.3 //y=4.25
c421 ( 4 0 ) capacitor c=0.00412846f //x=10.54 //y=4.25
c422 ( 3 0 ) capacitor c=0.0575173f //x=14.38 //y=4.25
c423 ( 2 0 ) capacitor c=0.0160831f //x=1.66 //y=4.25
c424 ( 1 0 ) capacitor c=0.162077f //x=10.31 //y=4.25
r425 (  160 161 ) resistor r=32.4568 //w=0.214 //l=0.075 //layer=ply \
 //thickness=0.18 //x=20.445 //y=4.97 //x2=20.445 //y2=5.045
r426 (  158 160 ) resistor r=20.271 //w=0.214 //l=0.09 //layer=ply \
 //thickness=0.18 //x=20.445 //y=4.88 //x2=20.445 //y2=4.97
r427 (  154 155 ) resistor r=52.7279 //w=0.214 //l=0.165 //layer=ply \
 //thickness=0.18 //x=20.415 //y=2.26 //x2=20.415 //y2=2.095
r428 (  147 148 ) resistor r=32.4568 //w=0.214 //l=0.075 //layer=ply \
 //thickness=0.18 //x=10.455 //y=4.97 //x2=10.455 //y2=5.045
r429 (  145 147 ) resistor r=20.271 //w=0.214 //l=0.09 //layer=ply \
 //thickness=0.18 //x=10.455 //y=4.88 //x2=10.455 //y2=4.97
r430 (  141 142 ) resistor r=52.7279 //w=0.214 //l=0.165 //layer=ply \
 //thickness=0.18 //x=10.425 //y=2.26 //x2=10.425 //y2=2.095
r431 (  131 165 ) resistor r=45.1352 //w=0.168 //l=0.173853 //layer=ply \
 //thickness=0.18 //x=20.98 //y=1.43 //x2=20.94 //y2=1.585
r432 (  130 164 ) resistor r=45.1352 //w=0.168 //l=0.173853 //layer=ply \
 //thickness=0.18 //x=20.98 //y=1.085 //x2=20.94 //y2=0.93
r433 (  130 131 ) resistor r=176.904 //w=0.094 //l=0.345 //layer=ply \
 //thickness=0.18 //x=20.98 //y=1.085 //x2=20.98 //y2=1.43
r434 (  125 163 ) resistor r=10.701 //w=0.21 //l=0.115 //layer=ply \
 //thickness=0.18 //x=20.605 //y=1.585 //x2=20.49 //y2=1.585
r435 (  124 165 ) resistor r=5.52526 //w=0.168 //l=0.115 //layer=ply \
 //thickness=0.18 //x=20.825 //y=1.585 //x2=20.94 //y2=1.585
r436 (  123 162 ) resistor r=5.52526 //w=0.168 //l=0.115 //layer=ply \
 //thickness=0.18 //x=20.605 //y=0.93 //x2=20.49 //y2=0.93
r437 (  122 164 ) resistor r=5.52526 //w=0.168 //l=0.115 //layer=ply \
 //thickness=0.18 //x=20.825 //y=0.93 //x2=20.94 //y2=0.93
r438 (  122 123 ) resistor r=112.809 //w=0.094 //l=0.22 //layer=ply \
 //thickness=0.18 //x=20.825 //y=0.93 //x2=20.605 //y2=0.93
r439 (  121 160 ) resistor r=16.5046 //w=0.27 //l=0.135 //layer=ply \
 //thickness=0.18 //x=20.58 //y=4.97 //x2=20.445 //y2=4.97
r440 (  120 127 ) resistor r=26.9307 //w=0.15 //l=0.106066 //layer=ply \
 //thickness=0.18 //x=20.82 //y=4.97 //x2=20.895 //y2=5.045
r441 (  120 121 ) resistor r=123.064 //w=0.094 //l=0.24 //layer=ply \
 //thickness=0.18 //x=20.82 //y=4.97 //x2=20.58 //y2=4.97
r442 (  115 163 ) resistor r=39.5823 //w=0.21 //l=0.173853 //layer=ply \
 //thickness=0.18 //x=20.45 //y=1.74 //x2=20.49 //y2=1.585
r443 (  115 155 ) resistor r=182.032 //w=0.094 //l=0.355 //layer=ply \
 //thickness=0.18 //x=20.45 //y=1.74 //x2=20.45 //y2=2.095
r444 (  114 163 ) resistor r=39.5823 //w=0.21 //l=0.173853 //layer=ply \
 //thickness=0.18 //x=20.45 //y=1.43 //x2=20.49 //y2=1.585
r445 (  113 162 ) resistor r=45.1352 //w=0.168 //l=0.173853 //layer=ply \
 //thickness=0.18 //x=20.45 //y=1.085 //x2=20.49 //y2=0.93
r446 (  113 114 ) resistor r=176.904 //w=0.094 //l=0.345 //layer=ply \
 //thickness=0.18 //x=20.45 //y=1.085 //x2=20.45 //y2=1.43
r447 (  112 152 ) resistor r=45.1352 //w=0.168 //l=0.173853 //layer=ply \
 //thickness=0.18 //x=10.99 //y=1.43 //x2=10.95 //y2=1.585
r448 (  111 151 ) resistor r=45.1352 //w=0.168 //l=0.173853 //layer=ply \
 //thickness=0.18 //x=10.99 //y=1.085 //x2=10.95 //y2=0.93
r449 (  111 112 ) resistor r=176.904 //w=0.094 //l=0.345 //layer=ply \
 //thickness=0.18 //x=10.99 //y=1.085 //x2=10.99 //y2=1.43
r450 (  106 150 ) resistor r=10.701 //w=0.21 //l=0.115 //layer=ply \
 //thickness=0.18 //x=10.615 //y=1.585 //x2=10.5 //y2=1.585
r451 (  105 152 ) resistor r=5.52526 //w=0.168 //l=0.115 //layer=ply \
 //thickness=0.18 //x=10.835 //y=1.585 //x2=10.95 //y2=1.585
r452 (  104 149 ) resistor r=5.52526 //w=0.168 //l=0.115 //layer=ply \
 //thickness=0.18 //x=10.615 //y=0.93 //x2=10.5 //y2=0.93
r453 (  103 151 ) resistor r=5.52526 //w=0.168 //l=0.115 //layer=ply \
 //thickness=0.18 //x=10.835 //y=0.93 //x2=10.95 //y2=0.93
r454 (  103 104 ) resistor r=112.809 //w=0.094 //l=0.22 //layer=ply \
 //thickness=0.18 //x=10.835 //y=0.93 //x2=10.615 //y2=0.93
r455 (  102 147 ) resistor r=16.5046 //w=0.27 //l=0.135 //layer=ply \
 //thickness=0.18 //x=10.59 //y=4.97 //x2=10.455 //y2=4.97
r456 (  101 108 ) resistor r=26.9307 //w=0.15 //l=0.106066 //layer=ply \
 //thickness=0.18 //x=10.83 //y=4.97 //x2=10.905 //y2=5.045
r457 (  101 102 ) resistor r=123.064 //w=0.094 //l=0.24 //layer=ply \
 //thickness=0.18 //x=10.83 //y=4.97 //x2=10.59 //y2=4.97
r458 (  96 150 ) resistor r=39.5823 //w=0.21 //l=0.173853 //layer=ply \
 //thickness=0.18 //x=10.46 //y=1.74 //x2=10.5 //y2=1.585
r459 (  96 142 ) resistor r=182.032 //w=0.094 //l=0.355 //layer=ply \
 //thickness=0.18 //x=10.46 //y=1.74 //x2=10.46 //y2=2.095
r460 (  95 150 ) resistor r=39.5823 //w=0.21 //l=0.173853 //layer=ply \
 //thickness=0.18 //x=10.46 //y=1.43 //x2=10.5 //y2=1.585
r461 (  94 149 ) resistor r=45.1352 //w=0.168 //l=0.173853 //layer=ply \
 //thickness=0.18 //x=10.46 //y=1.085 //x2=10.5 //y2=0.93
r462 (  94 95 ) resistor r=176.904 //w=0.094 //l=0.345 //layer=ply \
 //thickness=0.18 //x=10.46 //y=1.085 //x2=10.46 //y2=1.43
r463 (  89 91 ) resistor r=26.9307 //w=0.15 //l=0.106066 //layer=ply \
 //thickness=0.18 //x=2.11 //y=4.97 //x2=2.185 //y2=5.045
r464 (  89 90 ) resistor r=148.702 //w=0.094 //l=0.29 //layer=ply \
 //thickness=0.18 //x=2.11 //y=4.97 //x2=1.82 //y2=4.97
r465 (  88 139 ) resistor r=45.1352 //w=0.168 //l=0.173853 //layer=ply \
 //thickness=0.18 //x=1.775 //y=1.4 //x2=1.735 //y2=1.555
r466 (  87 138 ) resistor r=45.1352 //w=0.168 //l=0.173853 //layer=ply \
 //thickness=0.18 //x=1.775 //y=1.055 //x2=1.735 //y2=0.9
r467 (  87 88 ) resistor r=176.904 //w=0.094 //l=0.345 //layer=ply \
 //thickness=0.18 //x=1.775 //y=1.055 //x2=1.775 //y2=1.4
r468 (  84 90 ) resistor r=22.7971 //w=0.269 //l=0.106066 //layer=ply \
 //thickness=0.18 //x=1.745 //y=5.045 //x2=1.82 //y2=4.97
r469 (  84 137 ) resistor r=35.8364 //w=0.269 //l=0.270185 //layer=ply \
 //thickness=0.18 //x=1.745 //y=5.045 //x2=1.545 //y2=4.88
r470 (  82 133 ) resistor r=10.701 //w=0.21 //l=0.115 //layer=ply \
 //thickness=0.18 //x=1.4 //y=1.555 //x2=1.285 //y2=1.555
r471 (  81 139 ) resistor r=5.52526 //w=0.168 //l=0.115 //layer=ply \
 //thickness=0.18 //x=1.62 //y=1.555 //x2=1.735 //y2=1.555
r472 (  80 132 ) resistor r=5.52526 //w=0.168 //l=0.115 //layer=ply \
 //thickness=0.18 //x=1.4 //y=0.9 //x2=1.285 //y2=0.9
r473 (  79 138 ) resistor r=5.52526 //w=0.168 //l=0.115 //layer=ply \
 //thickness=0.18 //x=1.62 //y=0.9 //x2=1.735 //y2=0.9
r474 (  79 80 ) resistor r=112.809 //w=0.094 //l=0.22 //layer=ply \
 //thickness=0.18 //x=1.62 //y=0.9 //x2=1.4 //y2=0.9
r475 (  78 135 ) resistor r=58.7805 //w=0.246 //l=0.373497 //layer=ply \
 //thickness=0.18 //x=1.245 //y=2.095 //x2=1.545 //y2=2.26
r476 (  77 133 ) resistor r=39.5823 //w=0.21 //l=0.173853 //layer=ply \
 //thickness=0.18 //x=1.245 //y=1.71 //x2=1.285 //y2=1.555
r477 (  77 78 ) resistor r=197.415 //w=0.094 //l=0.385 //layer=ply \
 //thickness=0.18 //x=1.245 //y=1.71 //x2=1.245 //y2=2.095
r478 (  76 133 ) resistor r=39.5823 //w=0.21 //l=0.173853 //layer=ply \
 //thickness=0.18 //x=1.245 //y=1.4 //x2=1.285 //y2=1.555
r479 (  75 132 ) resistor r=45.1352 //w=0.168 //l=0.173853 //layer=ply \
 //thickness=0.18 //x=1.245 //y=1.055 //x2=1.285 //y2=0.9
r480 (  75 76 ) resistor r=176.904 //w=0.094 //l=0.345 //layer=ply \
 //thickness=0.18 //x=1.245 //y=1.055 //x2=1.245 //y2=1.4
r481 (  74 127 ) resistor r=592.245 //w=0.094 //l=1.155 //layer=ply \
 //thickness=0.18 //x=20.895 //y=6.2 //x2=20.895 //y2=5.045
r482 (  73 161 ) resistor r=592.245 //w=0.094 //l=1.155 //layer=ply \
 //thickness=0.18 //x=20.455 //y=6.2 //x2=20.455 //y2=5.045
r483 (  72 108 ) resistor r=592.245 //w=0.094 //l=1.155 //layer=ply \
 //thickness=0.18 //x=10.905 //y=6.2 //x2=10.905 //y2=5.045
r484 (  71 148 ) resistor r=592.245 //w=0.094 //l=1.155 //layer=ply \
 //thickness=0.18 //x=10.465 //y=6.2 //x2=10.465 //y2=5.045
r485 (  70 91 ) resistor r=592.245 //w=0.094 //l=1.155 //layer=ply \
 //thickness=0.18 //x=2.185 //y=6.2 //x2=2.185 //y2=5.045
r486 (  69 84 ) resistor r=592.245 //w=0.094 //l=1.155 //layer=ply \
 //thickness=0.18 //x=1.745 //y=6.2 //x2=1.745 //y2=5.045
r487 (  68 124 ) resistor r=56.4043 //w=0.094 //l=0.11 //layer=ply \
 //thickness=0.18 //x=20.715 //y=1.585 //x2=20.825 //y2=1.585
r488 (  68 125 ) resistor r=56.4043 //w=0.094 //l=0.11 //layer=ply \
 //thickness=0.18 //x=20.715 //y=1.585 //x2=20.605 //y2=1.585
r489 (  67 105 ) resistor r=56.4043 //w=0.094 //l=0.11 //layer=ply \
 //thickness=0.18 //x=10.725 //y=1.585 //x2=10.835 //y2=1.585
r490 (  67 106 ) resistor r=56.4043 //w=0.094 //l=0.11 //layer=ply \
 //thickness=0.18 //x=10.725 //y=1.585 //x2=10.615 //y2=1.585
r491 (  66 81 ) resistor r=56.4043 //w=0.094 //l=0.11 //layer=ply \
 //thickness=0.18 //x=1.51 //y=1.555 //x2=1.62 //y2=1.555
r492 (  66 82 ) resistor r=56.4043 //w=0.094 //l=0.11 //layer=ply \
 //thickness=0.18 //x=1.51 //y=1.555 //x2=1.4 //y2=1.555
r493 (  65 158 ) resistor r=152 //w=0.17 //l=0.17 //layer=licon //count=1 \
 //x=20.445 //y=4.88 //x2=20.445 //y2=4.88
r494 (  62 145 ) resistor r=152 //w=0.17 //l=0.17 //layer=licon //count=1 \
 //x=10.455 //y=4.88 //x2=10.455 //y2=4.88
r495 (  57 154 ) resistor r=152 //w=0.17 //l=0.17 //layer=licon //count=1 \
 //x=20.415 //y=2.26 //x2=20.415 //y2=2.26
r496 (  57 60 ) resistor r=136.214 //w=0.187 //l=1.99 //layer=li \
 //thickness=0.1 //x=20.415 //y=2.26 //x2=20.415 //y2=4.25
r497 (  55 65 ) resistor r=11.4737 //w=0.186 //l=0.172337 //layer=li \
 //thickness=0.1 //x=20.415 //y=4.715 //x2=20.43 //y2=4.88
r498 (  55 60 ) resistor r=31.8289 //w=0.187 //l=0.465 //layer=li \
 //thickness=0.1 //x=20.415 //y=4.715 //x2=20.415 //y2=4.25
r499 (  52 54 ) resistor r=71.5294 //w=0.187 //l=1.045 //layer=li \
 //thickness=0.1 //x=14.495 //y=5.295 //x2=14.495 //y2=4.25
r500 (  51 54 ) resistor r=159.487 //w=0.187 //l=2.33 //layer=li \
 //thickness=0.1 //x=14.495 //y=1.92 //x2=14.495 //y2=4.25
r501 (  49 51 ) resistor r=7.15173 //w=0.17 //l=0.120208 //layer=li \
 //thickness=0.1 //x=14.41 //y=1.835 //x2=14.495 //y2=1.92
r502 (  49 50 ) resistor r=18.4813 //w=0.187 //l=0.27 //layer=li \
 //thickness=0.1 //x=14.41 //y=1.835 //x2=14.14 //y2=1.835
r503 (  48 63 ) resistor r=5.4201 //w=0.17 //l=0.085 //layer=li \
 //thickness=0.1 //x=14.1 //y=5.38 //x2=14.015 //y2=5.38
r504 (  47 52 ) resistor r=7.15173 //w=0.17 //l=0.120208 //layer=li \
 //thickness=0.1 //x=14.41 //y=5.38 //x2=14.495 //y2=5.295
r505 (  47 48 ) resistor r=21.2193 //w=0.187 //l=0.31 //layer=li \
 //thickness=0.1 //x=14.41 //y=5.38 //x2=14.1 //y2=5.38
r506 (  43 50 ) resistor r=7.15173 //w=0.17 //l=0.120208 //layer=li \
 //thickness=0.1 //x=14.055 //y=1.75 //x2=14.14 //y2=1.835
r507 (  43 166 ) resistor r=39.016 //w=0.187 //l=0.57 //layer=li \
 //thickness=0.1 //x=14.055 //y=1.75 //x2=14.055 //y2=1.18
r508 (  37 63 ) resistor r=1.40859 //w=0.34 //l=0.085 //layer=li \
 //thickness=0.1 //x=14.015 //y=5.465 //x2=14.015 //y2=5.38
r509 (  37 169 ) resistor r=30.1176 //w=0.187 //l=0.44 //layer=li \
 //thickness=0.1 //x=14.015 //y=5.465 //x2=14.015 //y2=5.905
r510 (  35 63 ) resistor r=5.4201 //w=0.17 //l=0.085 //layer=li \
 //thickness=0.1 //x=13.93 //y=5.38 //x2=14.015 //y2=5.38
r511 (  35 36 ) resistor r=48.5989 //w=0.187 //l=0.71 //layer=li \
 //thickness=0.1 //x=13.93 //y=5.38 //x2=13.22 //y2=5.38
r512 (  29 36 ) resistor r=7.15173 //w=0.17 //l=0.120208 //layer=li \
 //thickness=0.1 //x=13.135 //y=5.465 //x2=13.22 //y2=5.38
r513 (  29 168 ) resistor r=30.1176 //w=0.187 //l=0.44 //layer=li \
 //thickness=0.1 //x=13.135 //y=5.465 //x2=13.135 //y2=5.905
r514 (  25 141 ) resistor r=152 //w=0.17 //l=0.17 //layer=licon //count=1 \
 //x=10.425 //y=2.26 //x2=10.425 //y2=2.26
r515 (  25 28 ) resistor r=136.214 //w=0.187 //l=1.99 //layer=li \
 //thickness=0.1 //x=10.425 //y=2.26 //x2=10.425 //y2=4.25
r516 (  23 62 ) resistor r=11.4737 //w=0.186 //l=0.172337 //layer=li \
 //thickness=0.1 //x=10.425 //y=4.715 //x2=10.44 //y2=4.88
r517 (  23 28 ) resistor r=31.8289 //w=0.187 //l=0.465 //layer=li \
 //thickness=0.1 //x=10.425 //y=4.715 //x2=10.425 //y2=4.25
r518 (  21 137 ) resistor r=152 //w=0.17 //l=0.17 //layer=licon //count=1 \
 //x=1.545 //y=4.88 //x2=1.545 //y2=4.88
r519 (  19 21 ) resistor r=43.123 //w=0.187 //l=0.63 //layer=li \
 //thickness=0.1 //x=1.545 //y=4.25 //x2=1.545 //y2=4.88
r520 (  16 135 ) resistor r=152 //w=0.17 //l=0.17 //layer=licon //count=1 \
 //x=1.545 //y=2.26 //x2=1.545 //y2=2.26
r521 (  16 19 ) resistor r=136.214 //w=0.187 //l=1.99 //layer=li \
 //thickness=0.1 //x=1.545 //y=2.26 //x2=1.545 //y2=4.25
r522 (  14 60 ) resistor r=9.3 //w=0.17 //l=0.17 //layer=mcon //count=1 \
 //x=20.415 //y=4.25 //x2=20.415 //y2=4.25
r523 (  12 54 ) resistor r=9.3 //w=0.17 //l=0.17 //layer=mcon //count=1 \
 //x=14.495 //y=4.25 //x2=14.495 //y2=4.25
r524 (  10 28 ) resistor r=9.3 //w=0.17 //l=0.17 //layer=mcon //count=1 \
 //x=10.425 //y=4.25 //x2=10.425 //y2=4.25
r525 (  8 19 ) resistor r=9.3 //w=0.17 //l=0.17 //layer=mcon //count=1 \
 //x=1.545 //y=4.25 //x2=1.545 //y2=4.25
r526 (  6 12 ) resistor r=0.0880901 //w=0.191 //l=0.115 //layer=m1 \
 //thickness=0.36 //x=14.61 //y=4.25 //x2=14.495 //y2=4.25
r527 (  5 14 ) resistor r=0.0717383 //w=0.224 //l=0.115 //layer=m1 \
 //thickness=0.36 //x=20.3 //y=4.25 //x2=20.415 //y2=4.25
r528 (  5 6 ) resistor r=5.42939 //w=0.131 //l=5.69 //layer=m1 \
 //thickness=0.36 //x=20.3 //y=4.25 //x2=14.61 //y2=4.25
r529 (  4 10 ) resistor r=0.0880901 //w=0.191 //l=0.115 //layer=m1 \
 //thickness=0.36 //x=10.54 //y=4.25 //x2=10.425 //y2=4.25
r530 (  3 12 ) resistor r=0.0880901 //w=0.191 //l=0.115 //layer=m1 \
 //thickness=0.36 //x=14.38 //y=4.25 //x2=14.495 //y2=4.25
r531 (  3 4 ) resistor r=3.66412 //w=0.131 //l=3.84 //layer=m1 \
 //thickness=0.36 //x=14.38 //y=4.25 //x2=10.54 //y2=4.25
r532 (  2 8 ) resistor r=0.0717383 //w=0.224 //l=0.115 //layer=m1 \
 //thickness=0.36 //x=1.66 //y=4.25 //x2=1.545 //y2=4.25
r533 (  1 10 ) resistor r=0.0880901 //w=0.191 //l=0.115 //layer=m1 \
 //thickness=0.36 //x=10.31 //y=4.25 //x2=10.425 //y2=4.25
r534 (  1 2 ) resistor r=8.25382 //w=0.131 //l=8.65 //layer=m1 \
 //thickness=0.36 //x=10.31 //y=4.25 //x2=1.66 //y2=4.25
ends PM_DFFQX1\%noxref_10

subckt PM_DFFQX1\%Q ( 5 6 7 8 9 10 11 12 19 20 31 33 34 52 53 55 58 61 71 74 \
 77 79 81 82 )
c100 ( 82 0 ) capacitor c=0.0220291f //x=20.53 //y=5.2
c101 ( 81 0 ) capacitor c=0.0217503f //x=19.65 //y=5.2
c102 ( 79 0 ) capacitor c=0.0084702f //x=20.525 //y=1.085
c103 ( 77 0 ) capacitor c=0.00494433f //x=21.182 //y=4.905
c104 ( 74 0 ) capacitor c=0.00657732f //x=21.182 //y=4.535
c105 ( 71 0 ) capacitor c=0.0102418f //x=21.182 //y=4.165
c106 ( 68 0 ) capacitor c=0.0102899f //x=21.182 //y=3.795
c107 ( 64 0 ) capacitor c=0.0108345f //x=21.182 //y=3.425
c108 ( 61 0 ) capacitor c=0.00995733f //x=21.182 //y=3.055
c109 ( 58 0 ) capacitor c=0.00668362f //x=21.182 //y=2.685
c110 ( 55 0 ) capacitor c=0.0101945f //x=21.182 //y=2.315
c111 ( 53 0 ) capacitor c=0.0024826f //x=20.675 //y=5.38
c112 ( 52 0 ) capacitor c=0.005033f //x=21.155 //y=5.295
c113 ( 34 0 ) capacitor c=0.00525782f //x=20.8 //y=1.835
c114 ( 33 0 ) capacitor c=0.0140375f //x=21.07 //y=1.835
c115 ( 31 0 ) capacitor c=0.0142754f //x=21.07 //y=5.38
c116 ( 20 0 ) capacitor c=0.00265417f //x=19.88 //y=5.38
c117 ( 19 0 ) capacitor c=0.0150834f //x=20.59 //y=5.38
c118 ( 12 0 ) capacitor c=0.00610872f //x=21.21 //y=4.99
c119 ( 11 0 ) capacitor c=0.00667177f //x=21.21 //y=4.62
c120 ( 10 0 ) capacitor c=0.00888852f //x=21.21 //y=4.25
c121 ( 9 0 ) capacitor c=0.103594f //x=21.21 //y=3.88
c122 ( 8 0 ) capacitor c=0.0102049f //x=21.21 //y=3.51
c123 ( 7 0 ) capacitor c=0.0105558f //x=21.21 //y=3.14
c124 ( 6 0 ) capacitor c=0.00667177f //x=21.21 //y=2.77
c125 ( 5 0 ) capacitor c=0.00643997f //x=21.21 //y=2.4
r126 (  75 77 ) resistor r=13.6898 //w=0.187 //l=0.2 //layer=li \
 //thickness=0.1 //x=21.155 //y=4.705 //x2=21.155 //y2=4.905
r127 (  72 74 ) resistor r=13.6898 //w=0.187 //l=0.2 //layer=li \
 //thickness=0.1 //x=21.155 //y=4.335 //x2=21.155 //y2=4.535
r128 (  69 71 ) resistor r=13.6898 //w=0.187 //l=0.2 //layer=li \
 //thickness=0.1 //x=21.155 //y=3.965 //x2=21.155 //y2=4.165
r129 (  65 68 ) resistor r=13.6898 //w=0.187 //l=0.2 //layer=li \
 //thickness=0.1 //x=21.155 //y=3.595 //x2=21.155 //y2=3.795
r130 (  62 64 ) resistor r=13.6898 //w=0.187 //l=0.2 //layer=li \
 //thickness=0.1 //x=21.155 //y=3.225 //x2=21.155 //y2=3.425
r131 (  59 61 ) resistor r=13.6898 //w=0.187 //l=0.2 //layer=li \
 //thickness=0.1 //x=21.155 //y=2.855 //x2=21.155 //y2=3.055
r132 (  56 58 ) resistor r=13.6898 //w=0.187 //l=0.2 //layer=li \
 //thickness=0.1 //x=21.155 //y=2.485 //x2=21.155 //y2=2.685
r133 (  52 78 ) resistor r=15.0588 //w=0.187 //l=0.22 //layer=li \
 //thickness=0.1 //x=21.155 //y=5.295 //x2=21.155 //y2=5.075
r134 (  35 55 ) resistor r=27.0374 //w=0.187 //l=0.395 //layer=li \
 //thickness=0.1 //x=21.155 //y=1.92 //x2=21.155 //y2=2.315
r135 (  33 35 ) resistor r=7.15173 //w=0.17 //l=0.120208 //layer=li \
 //thickness=0.1 //x=21.07 //y=1.835 //x2=21.155 //y2=1.92
r136 (  33 34 ) resistor r=18.4813 //w=0.187 //l=0.27 //layer=li \
 //thickness=0.1 //x=21.07 //y=1.835 //x2=20.8 //y2=1.835
r137 (  32 53 ) resistor r=5.4201 //w=0.17 //l=0.085 //layer=li \
 //thickness=0.1 //x=20.76 //y=5.38 //x2=20.675 //y2=5.38
r138 (  31 52 ) resistor r=7.15173 //w=0.17 //l=0.120208 //layer=li \
 //thickness=0.1 //x=21.07 //y=5.38 //x2=21.155 //y2=5.295
r139 (  31 32 ) resistor r=21.2193 //w=0.187 //l=0.31 //layer=li \
 //thickness=0.1 //x=21.07 //y=5.38 //x2=20.76 //y2=5.38
r140 (  27 34 ) resistor r=7.15173 //w=0.17 //l=0.120208 //layer=li \
 //thickness=0.1 //x=20.715 //y=1.75 //x2=20.8 //y2=1.835
r141 (  27 79 ) resistor r=39.016 //w=0.187 //l=0.57 //layer=li \
 //thickness=0.1 //x=20.715 //y=1.75 //x2=20.715 //y2=1.18
r142 (  21 53 ) resistor r=1.40859 //w=0.34 //l=0.085 //layer=li \
 //thickness=0.1 //x=20.675 //y=5.465 //x2=20.675 //y2=5.38
r143 (  21 82 ) resistor r=30.1176 //w=0.187 //l=0.44 //layer=li \
 //thickness=0.1 //x=20.675 //y=5.465 //x2=20.675 //y2=5.905
r144 (  19 53 ) resistor r=5.4201 //w=0.17 //l=0.085 //layer=li \
 //thickness=0.1 //x=20.59 //y=5.38 //x2=20.675 //y2=5.38
r145 (  19 20 ) resistor r=48.5989 //w=0.187 //l=0.71 //layer=li \
 //thickness=0.1 //x=20.59 //y=5.38 //x2=19.88 //y2=5.38
r146 (  13 20 ) resistor r=7.15173 //w=0.17 //l=0.120208 //layer=li \
 //thickness=0.1 //x=19.795 //y=5.465 //x2=19.88 //y2=5.38
r147 (  13 81 ) resistor r=30.1176 //w=0.187 //l=0.44 //layer=li \
 //thickness=0.1 //x=19.795 //y=5.465 //x2=19.795 //y2=5.905
r148 (  12 78 ) resistor r=5.1957 //w=0.242 //l=0.085 //layer=li \
 //thickness=0.1 //x=21.182 //y=4.99 //x2=21.182 //y2=5.075
r149 (  12 77 ) resistor r=5.1957 //w=0.242 //l=0.085 //layer=li \
 //thickness=0.1 //x=21.182 //y=4.99 //x2=21.182 //y2=4.905
r150 (  11 75 ) resistor r=5.1957 //w=0.242 //l=0.085 //layer=li \
 //thickness=0.1 //x=21.182 //y=4.62 //x2=21.182 //y2=4.705
r151 (  11 74 ) resistor r=5.1957 //w=0.242 //l=0.085 //layer=li \
 //thickness=0.1 //x=21.182 //y=4.62 //x2=21.182 //y2=4.535
r152 (  10 72 ) resistor r=5.1957 //w=0.242 //l=0.085 //layer=li \
 //thickness=0.1 //x=21.182 //y=4.25 //x2=21.182 //y2=4.335
r153 (  10 71 ) resistor r=5.1957 //w=0.242 //l=0.085 //layer=li \
 //thickness=0.1 //x=21.182 //y=4.25 //x2=21.182 //y2=4.165
r154 (  9 69 ) resistor r=5.1957 //w=0.242 //l=0.085 //layer=li \
 //thickness=0.1 //x=21.182 //y=3.88 //x2=21.182 //y2=3.965
r155 (  9 68 ) resistor r=5.1957 //w=0.242 //l=0.085 //layer=li \
 //thickness=0.1 //x=21.182 //y=3.88 //x2=21.182 //y2=3.795
r156 (  8 65 ) resistor r=5.1957 //w=0.242 //l=0.085 //layer=li \
 //thickness=0.1 //x=21.182 //y=3.51 //x2=21.182 //y2=3.595
r157 (  8 64 ) resistor r=5.1957 //w=0.242 //l=0.085 //layer=li \
 //thickness=0.1 //x=21.182 //y=3.51 //x2=21.182 //y2=3.425
r158 (  7 62 ) resistor r=5.1957 //w=0.242 //l=0.085 //layer=li \
 //thickness=0.1 //x=21.182 //y=3.14 //x2=21.182 //y2=3.225
r159 (  7 61 ) resistor r=5.1957 //w=0.242 //l=0.085 //layer=li \
 //thickness=0.1 //x=21.182 //y=3.14 //x2=21.182 //y2=3.055
r160 (  6 59 ) resistor r=5.1957 //w=0.242 //l=0.085 //layer=li \
 //thickness=0.1 //x=21.182 //y=2.77 //x2=21.182 //y2=2.855
r161 (  6 58 ) resistor r=5.1957 //w=0.242 //l=0.085 //layer=li \
 //thickness=0.1 //x=21.182 //y=2.77 //x2=21.182 //y2=2.685
r162 (  5 56 ) resistor r=5.1957 //w=0.242 //l=0.085 //layer=li \
 //thickness=0.1 //x=21.182 //y=2.4 //x2=21.182 //y2=2.485
r163 (  5 55 ) resistor r=5.1957 //w=0.242 //l=0.085 //layer=li \
 //thickness=0.1 //x=21.182 //y=2.4 //x2=21.182 //y2=2.315
ends PM_DFFQX1\%Q

subckt PM_DFFQX1\%noxref_12 ( 1 5 9 13 17 35 )
c48 ( 35 0 ) capacitor c=0.0703709f //x=0.89 //y=0.555
c49 ( 17 0 ) capacitor c=0.0216756f //x=2.88 //y=1.77
c50 ( 13 0 ) capacitor c=0.0156939f //x=2.88 //y=0.72
c51 ( 9 0 ) capacitor c=0.00678203f //x=1.995 //y=0.805
c52 ( 5 0 ) capacitor c=0.0206412f //x=1.91 //y=1.77
c53 ( 1 0 ) capacitor c=0.0109947f //x=1.025 //y=1.685
r54 (  18 35 ) resistor r=5.4201 //w=0.17 //l=0.103078 //layer=li \
 //thickness=0.1 //x=2.08 //y=1.77 //x2=1.995 //y2=1.81
r55 (  18 35 ) resistor r=27.3797 //w=0.187 //l=0.4 //layer=li //thickness=0.1 \
 //x=2.08 //y=1.77 //x2=2.48 //y2=1.77
r56 (  17 35 ) resistor r=0.751729 //w=0.17 //l=0.085 //layer=li \
 //thickness=0.1 //x=2.88 //y=1.77 //x2=2.965 //y2=1.77
r57 (  17 35 ) resistor r=27.3797 //w=0.187 //l=0.4 //layer=li //thickness=0.1 \
 //x=2.88 //y=1.77 //x2=2.48 //y2=1.77
r58 (  14 35 ) resistor r=3.57586 //w=0.17 //l=0.103078 //layer=li \
 //thickness=0.1 //x=2.08 //y=0.72 //x2=1.995 //y2=0.68
r59 (  14 35 ) resistor r=27.3797 //w=0.187 //l=0.4 //layer=li //thickness=0.1 \
 //x=2.08 //y=0.72 //x2=2.48 //y2=0.72
r60 (  13 35 ) resistor r=0.751729 //w=0.17 //l=0.085 //layer=li \
 //thickness=0.1 //x=2.88 //y=0.72 //x2=2.965 //y2=0.72
r61 (  13 35 ) resistor r=27.3797 //w=0.187 //l=0.4 //layer=li //thickness=0.1 \
 //x=2.88 //y=0.72 //x2=2.48 //y2=0.72
r62 (  10 35 ) resistor r=1.40859 //w=0.34 //l=0.125 //layer=li \
 //thickness=0.1 //x=1.995 //y=1.685 //x2=1.995 //y2=1.81
r63 (  10 35 ) resistor r=42.0963 //w=0.187 //l=0.615 //layer=li \
 //thickness=0.1 //x=1.995 //y=1.685 //x2=1.995 //y2=1.07
r64 (  9 35 ) resistor r=3.57586 //w=0.17 //l=0.125 //layer=li //thickness=0.1 \
 //x=1.995 //y=0.805 //x2=1.995 //y2=0.68
r65 (  9 35 ) resistor r=18.139 //w=0.187 //l=0.265 //layer=li //thickness=0.1 \
 //x=1.995 //y=0.805 //x2=1.995 //y2=1.07
r66 (  6 35 ) resistor r=3.57586 //w=0.17 //l=0.103078 //layer=li \
 //thickness=0.1 //x=1.11 //y=1.77 //x2=1.025 //y2=1.81
r67 (  6 35 ) resistor r=27.3797 //w=0.187 //l=0.4 //layer=li //thickness=0.1 \
 //x=1.11 //y=1.77 //x2=1.51 //y2=1.77
r68 (  5 35 ) resistor r=5.4201 //w=0.17 //l=0.103078 //layer=li \
 //thickness=0.1 //x=1.91 //y=1.77 //x2=1.995 //y2=1.81
r69 (  5 35 ) resistor r=27.3797 //w=0.187 //l=0.4 //layer=li //thickness=0.1 \
 //x=1.91 //y=1.77 //x2=1.51 //y2=1.77
r70 (  1 35 ) resistor r=3.57586 //w=0.17 //l=0.125 //layer=li //thickness=0.1 \
 //x=1.025 //y=1.685 //x2=1.025 //y2=1.81
r71 (  1 35 ) resistor r=42.0963 //w=0.187 //l=0.615 //layer=li \
 //thickness=0.1 //x=1.025 //y=1.685 //x2=1.025 //y2=1.07
ends PM_DFFQX1\%noxref_12

subckt PM_DFFQX1\%noxref_13 ( 1 3 11 15 25 28 29 )
c53 ( 29 0 ) capacitor c=0.043074f //x=3.4 //y=0.555
c54 ( 28 0 ) capacitor c=0.00465142f //x=2.295 //y=1.09
c55 ( 25 0 ) capacitor c=0.00156479f //x=3.535 //y=1.175
c56 ( 15 0 ) capacitor c=0.00737666f //x=4.505 //y=0.805
c57 ( 11 0 ) capacitor c=0.0149771f //x=4.42 //y=0.72
c58 ( 3 0 ) capacitor c=0.00718386f //x=3.535 //y=0.805
c59 ( 1 0 ) capacitor c=0.0253322f //x=3.45 //y=1.175
r60 (  15 29 ) resistor r=3.57586 //w=0.17 //l=0.125 //layer=li \
 //thickness=0.1 //x=4.505 //y=0.805 //x2=4.505 //y2=0.68
r61 (  15 29 ) resistor r=18.139 //w=0.187 //l=0.265 //layer=li \
 //thickness=0.1 //x=4.505 //y=0.805 //x2=4.505 //y2=1.07
r62 (  12 29 ) resistor r=3.57586 //w=0.17 //l=0.103078 //layer=li \
 //thickness=0.1 //x=3.62 //y=0.72 //x2=3.535 //y2=0.68
r63 (  12 29 ) resistor r=27.3797 //w=0.187 //l=0.4 //layer=li //thickness=0.1 \
 //x=3.62 //y=0.72 //x2=4.02 //y2=0.72
r64 (  11 29 ) resistor r=3.57586 //w=0.17 //l=0.103078 //layer=li \
 //thickness=0.1 //x=4.42 //y=0.72 //x2=4.505 //y2=0.68
r65 (  11 29 ) resistor r=27.3797 //w=0.187 //l=0.4 //layer=li //thickness=0.1 \
 //x=4.42 //y=0.72 //x2=4.02 //y2=0.72
r66 (  7 25 ) resistor r=5.4201 //w=0.17 //l=0.085 //layer=li //thickness=0.1 \
 //x=3.535 //y=1.26 //x2=3.535 //y2=1.175
r67 (  7 29 ) resistor r=10.2674 //w=0.187 //l=0.15 //layer=li //thickness=0.1 \
 //x=3.535 //y=1.26 //x2=3.535 //y2=1.41
r68 (  4 25 ) resistor r=5.4201 //w=0.17 //l=0.085 //layer=li //thickness=0.1 \
 //x=3.535 //y=1.09 //x2=3.535 //y2=1.175
r69 (  4 29 ) resistor r=1.36898 //w=0.187 //l=0.02 //layer=li //thickness=0.1 \
 //x=3.535 //y=1.09 //x2=3.535 //y2=1.07
r70 (  3 29 ) resistor r=3.57586 //w=0.17 //l=0.125 //layer=li //thickness=0.1 \
 //x=3.535 //y=0.805 //x2=3.535 //y2=0.68
r71 (  3 29 ) resistor r=18.139 //w=0.187 //l=0.265 //layer=li //thickness=0.1 \
 //x=3.535 //y=0.805 //x2=3.535 //y2=1.07
r72 (  2 28 ) resistor r=0.751729 //w=0.17 //l=0.085 //layer=li \
 //thickness=0.1 //x=2.57 //y=1.175 //x2=2.485 //y2=1.175
r73 (  1 25 ) resistor r=1.40859 //w=0.34 //l=0.085 //layer=li //thickness=0.1 \
 //x=3.45 //y=1.175 //x2=3.535 //y2=1.175
r74 (  1 2 ) resistor r=60.2353 //w=0.187 //l=0.88 //layer=li //thickness=0.1 \
 //x=3.45 //y=1.175 //x2=2.57 //y2=1.175
ends PM_DFFQX1\%noxref_13

subckt PM_DFFQX1\%D ( 1 2 3 4 9 11 14 21 22 23 24 25 26 31 33 35 41 42 44 45 \
 48 )
c80 ( 48 0 ) capacitor c=0.0331095f //x=7.125 //y=4.88
c81 ( 45 0 ) capacitor c=0.0279499f //x=7.095 //y=2.095
c82 ( 44 0 ) capacitor c=0.04188f //x=7.095 //y=2.26
c83 ( 42 0 ) capacitor c=0.0429696f //x=7.66 //y=1.43
c84 ( 41 0 ) capacitor c=0.0192208f //x=7.66 //y=1.085
c85 ( 35 0 ) capacitor c=0.0158629f //x=7.505 //y=1.585
c86 ( 33 0 ) capacitor c=0.0157803f //x=7.505 //y=0.93
c87 ( 31 0 ) capacitor c=0.0295235f //x=7.5 //y=4.97
c88 ( 26 0 ) capacitor c=0.0202725f //x=7.13 //y=1.74
c89 ( 25 0 ) capacitor c=0.0168481f //x=7.13 //y=1.43
c90 ( 24 0 ) capacitor c=0.0174783f //x=7.13 //y=1.085
c91 ( 23 0 ) capacitor c=0.15358f //x=7.575 //y=6.2
c92 ( 22 0 ) capacitor c=0.110281f //x=7.135 //y=6.2
c93 ( 14 0 ) capacitor c=0.00707302f //x=7.122 //y=3.055
c94 ( 11 0 ) capacitor c=0.00615314f //x=7.122 //y=2.685
c95 ( 9 0 ) capacitor c=0.0464271f //x=7.095 //y=4.715
c96 ( 4 0 ) capacitor c=0.00716161f //x=7.095 //y=2.485
c97 ( 3 0 ) capacitor c=0.00754387f //x=7.15 //y=3.14
c98 ( 2 0 ) capacitor c=0.00678278f //x=7.15 //y=2.77
r99 (  50 51 ) resistor r=32.4568 //w=0.214 //l=0.075 //layer=ply \
 //thickness=0.18 //x=7.125 //y=4.97 //x2=7.125 //y2=5.045
r100 (  48 50 ) resistor r=20.271 //w=0.214 //l=0.09 //layer=ply \
 //thickness=0.18 //x=7.125 //y=4.88 //x2=7.125 //y2=4.97
r101 (  44 45 ) resistor r=52.7279 //w=0.214 //l=0.165 //layer=ply \
 //thickness=0.18 //x=7.095 //y=2.26 //x2=7.095 //y2=2.095
r102 (  42 55 ) resistor r=45.1352 //w=0.168 //l=0.173853 //layer=ply \
 //thickness=0.18 //x=7.66 //y=1.43 //x2=7.62 //y2=1.585
r103 (  41 54 ) resistor r=45.1352 //w=0.168 //l=0.173853 //layer=ply \
 //thickness=0.18 //x=7.66 //y=1.085 //x2=7.62 //y2=0.93
r104 (  41 42 ) resistor r=176.904 //w=0.094 //l=0.345 //layer=ply \
 //thickness=0.18 //x=7.66 //y=1.085 //x2=7.66 //y2=1.43
r105 (  36 53 ) resistor r=10.701 //w=0.21 //l=0.115 //layer=ply \
 //thickness=0.18 //x=7.285 //y=1.585 //x2=7.17 //y2=1.585
r106 (  35 55 ) resistor r=5.52526 //w=0.168 //l=0.115 //layer=ply \
 //thickness=0.18 //x=7.505 //y=1.585 //x2=7.62 //y2=1.585
r107 (  34 52 ) resistor r=5.52526 //w=0.168 //l=0.115 //layer=ply \
 //thickness=0.18 //x=7.285 //y=0.93 //x2=7.17 //y2=0.93
r108 (  33 54 ) resistor r=5.52526 //w=0.168 //l=0.115 //layer=ply \
 //thickness=0.18 //x=7.505 //y=0.93 //x2=7.62 //y2=0.93
r109 (  33 34 ) resistor r=112.809 //w=0.094 //l=0.22 //layer=ply \
 //thickness=0.18 //x=7.505 //y=0.93 //x2=7.285 //y2=0.93
r110 (  32 50 ) resistor r=16.5046 //w=0.27 //l=0.135 //layer=ply \
 //thickness=0.18 //x=7.26 //y=4.97 //x2=7.125 //y2=4.97
r111 (  31 38 ) resistor r=26.9307 //w=0.15 //l=0.106066 //layer=ply \
 //thickness=0.18 //x=7.5 //y=4.97 //x2=7.575 //y2=5.045
r112 (  31 32 ) resistor r=123.064 //w=0.094 //l=0.24 //layer=ply \
 //thickness=0.18 //x=7.5 //y=4.97 //x2=7.26 //y2=4.97
r113 (  26 53 ) resistor r=39.5823 //w=0.21 //l=0.173853 //layer=ply \
 //thickness=0.18 //x=7.13 //y=1.74 //x2=7.17 //y2=1.585
r114 (  26 45 ) resistor r=182.032 //w=0.094 //l=0.355 //layer=ply \
 //thickness=0.18 //x=7.13 //y=1.74 //x2=7.13 //y2=2.095
r115 (  25 53 ) resistor r=39.5823 //w=0.21 //l=0.173853 //layer=ply \
 //thickness=0.18 //x=7.13 //y=1.43 //x2=7.17 //y2=1.585
r116 (  24 52 ) resistor r=45.1352 //w=0.168 //l=0.173853 //layer=ply \
 //thickness=0.18 //x=7.13 //y=1.085 //x2=7.17 //y2=0.93
r117 (  24 25 ) resistor r=176.904 //w=0.094 //l=0.345 //layer=ply \
 //thickness=0.18 //x=7.13 //y=1.085 //x2=7.13 //y2=1.43
r118 (  23 38 ) resistor r=592.245 //w=0.094 //l=1.155 //layer=ply \
 //thickness=0.18 //x=7.575 //y=6.2 //x2=7.575 //y2=5.045
r119 (  22 51 ) resistor r=592.245 //w=0.094 //l=1.155 //layer=ply \
 //thickness=0.18 //x=7.135 //y=6.2 //x2=7.135 //y2=5.045
r120 (  21 35 ) resistor r=56.4043 //w=0.094 //l=0.11 //layer=ply \
 //thickness=0.18 //x=7.395 //y=1.585 //x2=7.505 //y2=1.585
r121 (  21 36 ) resistor r=56.4043 //w=0.094 //l=0.11 //layer=ply \
 //thickness=0.18 //x=7.395 //y=1.585 //x2=7.285 //y2=1.585
r122 (  19 44 ) resistor r=152 //w=0.17 //l=0.17 //layer=licon //count=1 \
 //x=7.095 //y=2.26 //x2=7.095 //y2=2.26
r123 (  17 48 ) resistor r=152 //w=0.17 //l=0.17 //layer=licon //count=1 \
 //x=7.125 //y=4.88 //x2=7.125 //y2=4.88
r124 (  12 14 ) resistor r=13.6898 //w=0.187 //l=0.2 //layer=li \
 //thickness=0.1 //x=7.095 //y=2.855 //x2=7.095 //y2=3.055
r125 (  9 17 ) resistor r=11.4737 //w=0.186 //l=0.172337 //layer=li \
 //thickness=0.1 //x=7.095 //y=4.715 //x2=7.11 //y2=4.88
r126 (  9 15 ) resistor r=101.989 //w=0.187 //l=1.49 //layer=li \
 //thickness=0.1 //x=7.095 //y=4.715 //x2=7.095 //y2=3.225
r127 (  4 11 ) resistor r=13.6898 //w=0.187 //l=0.2 //layer=li //thickness=0.1 \
 //x=7.095 //y=2.485 //x2=7.095 //y2=2.685
r128 (  3 15 ) resistor r=5.1957 //w=0.242 //l=0.085 //layer=li \
 //thickness=0.1 //x=7.122 //y=3.14 //x2=7.122 //y2=3.225
r129 (  3 14 ) resistor r=5.1957 //w=0.242 //l=0.085 //layer=li \
 //thickness=0.1 //x=7.122 //y=3.14 //x2=7.122 //y2=3.055
r130 (  2 12 ) resistor r=5.1957 //w=0.242 //l=0.085 //layer=li \
 //thickness=0.1 //x=7.122 //y=2.77 //x2=7.122 //y2=2.855
r131 (  2 11 ) resistor r=5.1957 //w=0.242 //l=0.085 //layer=li \
 //thickness=0.1 //x=7.122 //y=2.77 //x2=7.122 //y2=2.685
r132 (  1 4 ) resistor r=5.83724 //w=0.194 //l=0.0975705 //layer=li \
 //thickness=0.1 //x=7.122 //y=2.4 //x2=7.095 //y2=2.485
r133 (  1 19 ) resistor r=9.23711 //w=0.194 //l=0.14 //layer=li \
 //thickness=0.1 //x=7.122 //y=2.4 //x2=7.122 //y2=2.26
ends PM_DFFQX1\%D

subckt PM_DFFQX1\%noxref_15 ( 1 5 9 10 13 17 29 )
c53 ( 29 0 ) capacitor c=0.0638069f //x=5.805 //y=0.545
c54 ( 17 0 ) capacitor c=0.00722223f //x=7.88 //y=0.795
c55 ( 13 0 ) capacitor c=0.0146121f //x=7.795 //y=0.71
c56 ( 10 0 ) capacitor c=0.00664066f //x=6.91 //y=1.675
c57 ( 9 0 ) capacitor c=0.006761f //x=6.91 //y=0.795
c58 ( 5 0 ) capacitor c=0.0196287f //x=6.825 //y=1.76
c59 ( 1 0 ) capacitor c=0.00828748f //x=5.94 //y=1.675
r60 (  17 29 ) resistor r=3.57586 //w=0.17 //l=0.125 //layer=li \
 //thickness=0.1 //x=7.88 //y=0.795 //x2=7.88 //y2=0.67
r61 (  17 29 ) resistor r=18.139 //w=0.187 //l=0.265 //layer=li \
 //thickness=0.1 //x=7.88 //y=0.795 //x2=7.88 //y2=1.06
r62 (  14 29 ) resistor r=3.57586 //w=0.17 //l=0.103078 //layer=li \
 //thickness=0.1 //x=6.995 //y=0.71 //x2=6.91 //y2=0.67
r63 (  14 29 ) resistor r=27.3797 //w=0.187 //l=0.4 //layer=li //thickness=0.1 \
 //x=6.995 //y=0.71 //x2=7.395 //y2=0.71
r64 (  13 29 ) resistor r=3.57586 //w=0.17 //l=0.103078 //layer=li \
 //thickness=0.1 //x=7.795 //y=0.71 //x2=7.88 //y2=0.67
r65 (  13 29 ) resistor r=27.3797 //w=0.187 //l=0.4 //layer=li //thickness=0.1 \
 //x=7.795 //y=0.71 //x2=7.395 //y2=0.71
r66 (  10 29 ) resistor r=3.57586 //w=0.17 //l=0.125 //layer=li \
 //thickness=0.1 //x=6.91 //y=1.675 //x2=6.91 //y2=1.8
r67 (  10 29 ) resistor r=42.0963 //w=0.187 //l=0.615 //layer=li \
 //thickness=0.1 //x=6.91 //y=1.675 //x2=6.91 //y2=1.06
r68 (  9 29 ) resistor r=3.57586 //w=0.17 //l=0.125 //layer=li //thickness=0.1 \
 //x=6.91 //y=0.795 //x2=6.91 //y2=0.67
r69 (  9 29 ) resistor r=18.139 //w=0.187 //l=0.265 //layer=li //thickness=0.1 \
 //x=6.91 //y=0.795 //x2=6.91 //y2=1.06
r70 (  6 29 ) resistor r=3.57586 //w=0.17 //l=0.103078 //layer=li \
 //thickness=0.1 //x=6.025 //y=1.76 //x2=5.94 //y2=1.8
r71 (  6 29 ) resistor r=27.3797 //w=0.187 //l=0.4 //layer=li //thickness=0.1 \
 //x=6.025 //y=1.76 //x2=6.425 //y2=1.76
r72 (  5 29 ) resistor r=3.57586 //w=0.17 //l=0.103078 //layer=li \
 //thickness=0.1 //x=6.825 //y=1.76 //x2=6.91 //y2=1.8
r73 (  5 29 ) resistor r=27.3797 //w=0.187 //l=0.4 //layer=li //thickness=0.1 \
 //x=6.825 //y=1.76 //x2=6.425 //y2=1.76
r74 (  1 29 ) resistor r=3.57586 //w=0.17 //l=0.125 //layer=li //thickness=0.1 \
 //x=5.94 //y=1.675 //x2=5.94 //y2=1.8
r75 (  1 29 ) resistor r=42.0963 //w=0.187 //l=0.615 //layer=li \
 //thickness=0.1 //x=5.94 //y=1.675 //x2=5.94 //y2=1.06
ends PM_DFFQX1\%noxref_15

subckt PM_DFFQX1\%noxref_16 ( 1 5 9 10 13 17 29 )
c53 ( 29 0 ) capacitor c=0.0638071f //x=9.135 //y=0.545
c54 ( 17 0 ) capacitor c=0.00722223f //x=11.21 //y=0.795
c55 ( 13 0 ) capacitor c=0.0149613f //x=11.125 //y=0.71
c56 ( 10 0 ) capacitor c=0.00687696f //x=10.24 //y=1.675
c57 ( 9 0 ) capacitor c=0.006761f //x=10.24 //y=0.795
c58 ( 5 0 ) capacitor c=0.0201208f //x=10.155 //y=1.76
c59 ( 1 0 ) capacitor c=0.00828748f //x=9.27 //y=1.675
r60 (  17 29 ) resistor r=3.57586 //w=0.17 //l=0.125 //layer=li \
 //thickness=0.1 //x=11.21 //y=0.795 //x2=11.21 //y2=0.67
r61 (  17 29 ) resistor r=18.139 //w=0.187 //l=0.265 //layer=li \
 //thickness=0.1 //x=11.21 //y=0.795 //x2=11.21 //y2=1.06
r62 (  14 29 ) resistor r=3.57586 //w=0.17 //l=0.103078 //layer=li \
 //thickness=0.1 //x=10.325 //y=0.71 //x2=10.24 //y2=0.67
r63 (  14 29 ) resistor r=27.3797 //w=0.187 //l=0.4 //layer=li //thickness=0.1 \
 //x=10.325 //y=0.71 //x2=10.725 //y2=0.71
r64 (  13 29 ) resistor r=3.57586 //w=0.17 //l=0.103078 //layer=li \
 //thickness=0.1 //x=11.125 //y=0.71 //x2=11.21 //y2=0.67
r65 (  13 29 ) resistor r=27.3797 //w=0.187 //l=0.4 //layer=li //thickness=0.1 \
 //x=11.125 //y=0.71 //x2=10.725 //y2=0.71
r66 (  10 29 ) resistor r=3.57586 //w=0.17 //l=0.125 //layer=li \
 //thickness=0.1 //x=10.24 //y=1.675 //x2=10.24 //y2=1.8
r67 (  10 29 ) resistor r=42.0963 //w=0.187 //l=0.615 //layer=li \
 //thickness=0.1 //x=10.24 //y=1.675 //x2=10.24 //y2=1.06
r68 (  9 29 ) resistor r=3.57586 //w=0.17 //l=0.125 //layer=li //thickness=0.1 \
 //x=10.24 //y=0.795 //x2=10.24 //y2=0.67
r69 (  9 29 ) resistor r=18.139 //w=0.187 //l=0.265 //layer=li //thickness=0.1 \
 //x=10.24 //y=0.795 //x2=10.24 //y2=1.06
r70 (  6 29 ) resistor r=3.57586 //w=0.17 //l=0.103078 //layer=li \
 //thickness=0.1 //x=9.355 //y=1.76 //x2=9.27 //y2=1.8
r71 (  6 29 ) resistor r=27.3797 //w=0.187 //l=0.4 //layer=li //thickness=0.1 \
 //x=9.355 //y=1.76 //x2=9.755 //y2=1.76
r72 (  5 29 ) resistor r=3.57586 //w=0.17 //l=0.103078 //layer=li \
 //thickness=0.1 //x=10.155 //y=1.76 //x2=10.24 //y2=1.8
r73 (  5 29 ) resistor r=27.3797 //w=0.187 //l=0.4 //layer=li //thickness=0.1 \
 //x=10.155 //y=1.76 //x2=9.755 //y2=1.76
r74 (  1 29 ) resistor r=3.57586 //w=0.17 //l=0.125 //layer=li //thickness=0.1 \
 //x=9.27 //y=1.675 //x2=9.27 //y2=1.8
r75 (  1 29 ) resistor r=42.0963 //w=0.187 //l=0.615 //layer=li \
 //thickness=0.1 //x=9.27 //y=1.675 //x2=9.27 //y2=1.06
ends PM_DFFQX1\%noxref_16

subckt PM_DFFQX1\%noxref_17 ( 1 5 9 10 13 17 29 )
c53 ( 29 0 ) capacitor c=0.0637486f //x=12.465 //y=0.545
c54 ( 17 0 ) capacitor c=0.00722223f //x=14.54 //y=0.795
c55 ( 13 0 ) capacitor c=0.0149666f //x=14.455 //y=0.71
c56 ( 10 0 ) capacitor c=0.00687696f //x=13.57 //y=1.675
c57 ( 9 0 ) capacitor c=0.006761f //x=13.57 //y=0.795
c58 ( 5 0 ) capacitor c=0.0201208f //x=13.485 //y=1.76
c59 ( 1 0 ) capacitor c=0.00828748f //x=12.6 //y=1.675
r60 (  17 29 ) resistor r=3.57586 //w=0.17 //l=0.125 //layer=li \
 //thickness=0.1 //x=14.54 //y=0.795 //x2=14.54 //y2=0.67
r61 (  17 29 ) resistor r=18.139 //w=0.187 //l=0.265 //layer=li \
 //thickness=0.1 //x=14.54 //y=0.795 //x2=14.54 //y2=1.06
r62 (  14 29 ) resistor r=3.57586 //w=0.17 //l=0.103078 //layer=li \
 //thickness=0.1 //x=13.655 //y=0.71 //x2=13.57 //y2=0.67
r63 (  14 29 ) resistor r=27.3797 //w=0.187 //l=0.4 //layer=li //thickness=0.1 \
 //x=13.655 //y=0.71 //x2=14.055 //y2=0.71
r64 (  13 29 ) resistor r=3.57586 //w=0.17 //l=0.103078 //layer=li \
 //thickness=0.1 //x=14.455 //y=0.71 //x2=14.54 //y2=0.67
r65 (  13 29 ) resistor r=27.3797 //w=0.187 //l=0.4 //layer=li //thickness=0.1 \
 //x=14.455 //y=0.71 //x2=14.055 //y2=0.71
r66 (  10 29 ) resistor r=3.57586 //w=0.17 //l=0.125 //layer=li \
 //thickness=0.1 //x=13.57 //y=1.675 //x2=13.57 //y2=1.8
r67 (  10 29 ) resistor r=42.0963 //w=0.187 //l=0.615 //layer=li \
 //thickness=0.1 //x=13.57 //y=1.675 //x2=13.57 //y2=1.06
r68 (  9 29 ) resistor r=3.57586 //w=0.17 //l=0.125 //layer=li //thickness=0.1 \
 //x=13.57 //y=0.795 //x2=13.57 //y2=0.67
r69 (  9 29 ) resistor r=18.139 //w=0.187 //l=0.265 //layer=li //thickness=0.1 \
 //x=13.57 //y=0.795 //x2=13.57 //y2=1.06
r70 (  6 29 ) resistor r=3.57586 //w=0.17 //l=0.103078 //layer=li \
 //thickness=0.1 //x=12.685 //y=1.76 //x2=12.6 //y2=1.8
r71 (  6 29 ) resistor r=27.3797 //w=0.187 //l=0.4 //layer=li //thickness=0.1 \
 //x=12.685 //y=1.76 //x2=13.085 //y2=1.76
r72 (  5 29 ) resistor r=3.57586 //w=0.17 //l=0.103078 //layer=li \
 //thickness=0.1 //x=13.485 //y=1.76 //x2=13.57 //y2=1.8
r73 (  5 29 ) resistor r=27.3797 //w=0.187 //l=0.4 //layer=li //thickness=0.1 \
 //x=13.485 //y=1.76 //x2=13.085 //y2=1.76
r74 (  1 29 ) resistor r=3.57586 //w=0.17 //l=0.125 //layer=li //thickness=0.1 \
 //x=12.6 //y=1.675 //x2=12.6 //y2=1.8
r75 (  1 29 ) resistor r=42.0963 //w=0.187 //l=0.615 //layer=li \
 //thickness=0.1 //x=12.6 //y=1.675 //x2=12.6 //y2=1.06
ends PM_DFFQX1\%noxref_17

subckt PM_DFFQX1\%noxref_18 ( 1 5 9 10 13 17 29 )
c54 ( 29 0 ) capacitor c=0.0636503f //x=15.795 //y=0.545
c55 ( 17 0 ) capacitor c=0.00722223f //x=17.87 //y=0.795
c56 ( 13 0 ) capacitor c=0.014964f //x=17.785 //y=0.71
c57 ( 10 0 ) capacitor c=0.00705906f //x=16.9 //y=1.675
c58 ( 9 0 ) capacitor c=0.006761f //x=16.9 //y=0.795
c59 ( 5 0 ) capacitor c=0.0207245f //x=16.815 //y=1.76
c60 ( 1 0 ) capacitor c=0.00856252f //x=15.93 //y=1.675
r61 (  17 29 ) resistor r=3.57586 //w=0.17 //l=0.125 //layer=li \
 //thickness=0.1 //x=17.87 //y=0.795 //x2=17.87 //y2=0.67
r62 (  17 29 ) resistor r=18.139 //w=0.187 //l=0.265 //layer=li \
 //thickness=0.1 //x=17.87 //y=0.795 //x2=17.87 //y2=1.06
r63 (  14 29 ) resistor r=3.57586 //w=0.17 //l=0.103078 //layer=li \
 //thickness=0.1 //x=16.985 //y=0.71 //x2=16.9 //y2=0.67
r64 (  14 29 ) resistor r=27.3797 //w=0.187 //l=0.4 //layer=li //thickness=0.1 \
 //x=16.985 //y=0.71 //x2=17.385 //y2=0.71
r65 (  13 29 ) resistor r=3.57586 //w=0.17 //l=0.103078 //layer=li \
 //thickness=0.1 //x=17.785 //y=0.71 //x2=17.87 //y2=0.67
r66 (  13 29 ) resistor r=27.3797 //w=0.187 //l=0.4 //layer=li //thickness=0.1 \
 //x=17.785 //y=0.71 //x2=17.385 //y2=0.71
r67 (  10 29 ) resistor r=3.57586 //w=0.17 //l=0.125 //layer=li \
 //thickness=0.1 //x=16.9 //y=1.675 //x2=16.9 //y2=1.8
r68 (  10 29 ) resistor r=42.0963 //w=0.187 //l=0.615 //layer=li \
 //thickness=0.1 //x=16.9 //y=1.675 //x2=16.9 //y2=1.06
r69 (  9 29 ) resistor r=3.57586 //w=0.17 //l=0.125 //layer=li //thickness=0.1 \
 //x=16.9 //y=0.795 //x2=16.9 //y2=0.67
r70 (  9 29 ) resistor r=18.139 //w=0.187 //l=0.265 //layer=li //thickness=0.1 \
 //x=16.9 //y=0.795 //x2=16.9 //y2=1.06
r71 (  6 29 ) resistor r=3.57586 //w=0.17 //l=0.103078 //layer=li \
 //thickness=0.1 //x=16.015 //y=1.76 //x2=15.93 //y2=1.8
r72 (  6 29 ) resistor r=27.3797 //w=0.187 //l=0.4 //layer=li //thickness=0.1 \
 //x=16.015 //y=1.76 //x2=16.415 //y2=1.76
r73 (  5 29 ) resistor r=3.57586 //w=0.17 //l=0.103078 //layer=li \
 //thickness=0.1 //x=16.815 //y=1.76 //x2=16.9 //y2=1.8
r74 (  5 29 ) resistor r=27.3797 //w=0.187 //l=0.4 //layer=li //thickness=0.1 \
 //x=16.815 //y=1.76 //x2=16.415 //y2=1.76
r75 (  1 29 ) resistor r=3.57586 //w=0.17 //l=0.125 //layer=li //thickness=0.1 \
 //x=15.93 //y=1.675 //x2=15.93 //y2=1.8
r76 (  1 29 ) resistor r=42.0963 //w=0.187 //l=0.615 //layer=li \
 //thickness=0.1 //x=15.93 //y=1.675 //x2=15.93 //y2=1.06
ends PM_DFFQX1\%noxref_18

subckt PM_DFFQX1\%noxref_19 ( 1 5 9 10 13 17 29 )
c51 ( 29 0 ) capacitor c=0.0632623f //x=19.125 //y=0.545
c52 ( 17 0 ) capacitor c=0.00722223f //x=21.2 //y=0.795
c53 ( 13 0 ) capacitor c=0.0149664f //x=21.115 //y=0.71
c54 ( 10 0 ) capacitor c=0.00687696f //x=20.23 //y=1.675
c55 ( 9 0 ) capacitor c=0.006761f //x=20.23 //y=0.795
c56 ( 5 0 ) capacitor c=0.0201208f //x=20.145 //y=1.76
c57 ( 1 0 ) capacitor c=0.00828748f //x=19.26 //y=1.675
r58 (  17 29 ) resistor r=3.57586 //w=0.17 //l=0.125 //layer=li \
 //thickness=0.1 //x=21.2 //y=0.795 //x2=21.2 //y2=0.67
r59 (  17 29 ) resistor r=18.139 //w=0.187 //l=0.265 //layer=li \
 //thickness=0.1 //x=21.2 //y=0.795 //x2=21.2 //y2=1.06
r60 (  14 29 ) resistor r=3.57586 //w=0.17 //l=0.103078 //layer=li \
 //thickness=0.1 //x=20.315 //y=0.71 //x2=20.23 //y2=0.67
r61 (  14 29 ) resistor r=27.3797 //w=0.187 //l=0.4 //layer=li //thickness=0.1 \
 //x=20.315 //y=0.71 //x2=20.715 //y2=0.71
r62 (  13 29 ) resistor r=3.57586 //w=0.17 //l=0.103078 //layer=li \
 //thickness=0.1 //x=21.115 //y=0.71 //x2=21.2 //y2=0.67
r63 (  13 29 ) resistor r=27.3797 //w=0.187 //l=0.4 //layer=li //thickness=0.1 \
 //x=21.115 //y=0.71 //x2=20.715 //y2=0.71
r64 (  10 29 ) resistor r=3.57586 //w=0.17 //l=0.125 //layer=li \
 //thickness=0.1 //x=20.23 //y=1.675 //x2=20.23 //y2=1.8
r65 (  10 29 ) resistor r=42.0963 //w=0.187 //l=0.615 //layer=li \
 //thickness=0.1 //x=20.23 //y=1.675 //x2=20.23 //y2=1.06
r66 (  9 29 ) resistor r=3.57586 //w=0.17 //l=0.125 //layer=li //thickness=0.1 \
 //x=20.23 //y=0.795 //x2=20.23 //y2=0.67
r67 (  9 29 ) resistor r=18.139 //w=0.187 //l=0.265 //layer=li //thickness=0.1 \
 //x=20.23 //y=0.795 //x2=20.23 //y2=1.06
r68 (  6 29 ) resistor r=3.57586 //w=0.17 //l=0.103078 //layer=li \
 //thickness=0.1 //x=19.345 //y=1.76 //x2=19.26 //y2=1.8
r69 (  6 29 ) resistor r=27.3797 //w=0.187 //l=0.4 //layer=li //thickness=0.1 \
 //x=19.345 //y=1.76 //x2=19.745 //y2=1.76
r70 (  5 29 ) resistor r=3.57586 //w=0.17 //l=0.103078 //layer=li \
 //thickness=0.1 //x=20.145 //y=1.76 //x2=20.23 //y2=1.8
r71 (  5 29 ) resistor r=27.3797 //w=0.187 //l=0.4 //layer=li //thickness=0.1 \
 //x=20.145 //y=1.76 //x2=19.745 //y2=1.76
r72 (  1 29 ) resistor r=3.57586 //w=0.17 //l=0.125 //layer=li //thickness=0.1 \
 //x=19.26 //y=1.675 //x2=19.26 //y2=1.8
r73 (  1 29 ) resistor r=42.0963 //w=0.187 //l=0.615 //layer=li \
 //thickness=0.1 //x=19.26 //y=1.675 //x2=19.26 //y2=1.06
ends PM_DFFQX1\%noxref_19
