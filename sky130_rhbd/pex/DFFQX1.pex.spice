// File: DFFQX1.spi.pex
// Created: Thu Jan 22 07:03:24 2026
// Program "Calibre xRC"
// Version "v2023.2_27.15"
// Nominal Temperature: 30C
// Circuit Temperature: 30C
//
simulator lang=spectre
subckt PM_DFFQX1\%noxref_1 ( 1 2 3 4 7 12 13 15 16 18 19 20 22 23 30 34 35 38 \
 40 43 48 50 53 54 56 57 58 60 62 65 72 73 76 85 90 98 115 124 128 129 130 131 \
 132 133 137 138 139 144 146 149 150 151 152 153 154 158 160 163 164 169 170 \
 175 184 187 189 190 )
c428 ( 187 0 ) capacitor c=0.00878249f //x=7.205 //y=1.085
c429 ( 184 0 ) capacitor c=0.0682508f //x=9.685 //y=4.88
c430 ( 175 0 ) capacitor c=0.0710066f //x=3.765 //y=4.88
c431 ( 170 0 ) capacitor c=0.0278202f //x=3.765 //y=2.095
c432 ( 169 0 ) capacitor c=0.0479324f //x=3.765 //y=2.26
c433 ( 164 0 ) capacitor c=0.0318956f //x=10.02 //y=1.39
c434 ( 163 0 ) capacitor c=0.0186809f //x=10.02 //y=1.045
c435 ( 160 0 ) capacitor c=0.0141821f //x=9.865 //y=1.545
c436 ( 158 0 ) capacitor c=0.0158553f //x=9.865 //y=0.89
c437 ( 154 0 ) capacitor c=0.0854171f //x=9.49 //y=2.095
c438 ( 153 0 ) capacitor c=0.0229235f //x=9.49 //y=1.7
c439 ( 152 0 ) capacitor c=0.0234359f //x=9.49 //y=1.39
c440 ( 151 0 ) capacitor c=0.0198759f //x=9.49 //y=1.045
c441 ( 150 0 ) capacitor c=0.0443175f //x=4.285 //y=1.44
c442 ( 149 0 ) capacitor c=0.0199703f //x=4.285 //y=1.095
c443 ( 146 0 ) capacitor c=0.0162526f //x=4.13 //y=1.595
c444 ( 144 0 ) capacitor c=0.0157807f //x=4.13 //y=0.94
c445 ( 139 0 ) capacitor c=0.0220935f //x=3.755 //y=1.75
c446 ( 138 0 ) capacitor c=0.0207489f //x=3.755 //y=1.44
c447 ( 137 0 ) capacitor c=0.0194091f //x=3.755 //y=1.095
c448 ( 133 0 ) capacitor c=0.110369f //x=10.025 //y=6.2
c449 ( 132 0 ) capacitor c=0.154619f //x=9.585 //y=6.2
c450 ( 131 0 ) capacitor c=0.159671f //x=3.945 //y=6.2
c451 ( 130 0 ) capacitor c=0.110208f //x=3.505 //y=6.2
c452 ( 124 0 ) capacitor c=8.13425e-19 //x=9.685 //y=4.88
c453 ( 115 0 ) capacitor c=7.85889e-19 //x=9.685 //y=2.26
c454 ( 98 0 ) capacitor c=0.0322017f //x=7.355 //y=5.56
c455 ( 90 0 ) capacitor c=0.0290186f //x=6.475 //y=5.56
c456 ( 85 0 ) capacitor c=8.10944e-19 //x=3.765 //y=4.88
c457 ( 76 0 ) capacitor c=0.00101179f //x=3.765 //y=2.26
c458 ( 73 0 ) capacitor c=0.0504173f //x=9.52 //y=3.505
c459 ( 72 0 ) capacitor c=0.00163142f //x=9.68 //y=3.505
c460 ( 65 0 ) capacitor c=0.0253705f //x=7.99 //y=3.51
c461 ( 62 0 ) capacitor c=0.00684519f //x=6.565 //y=3.495
c462 ( 60 0 ) capacitor c=0.0382613f //x=5.965 //y=3.51
c463 ( 58 0 ) capacitor c=0.018822f //x=4.72 //y=3.495
c464 ( 57 0 ) capacitor c=0.00325528f //x=3.93 //y=3.51
c465 ( 56 0 ) capacitor c=0.00669908f //x=4.12 //y=3.51
c466 ( 54 0 ) capacitor c=0.0267314f //x=9.687 //y=4.74
c467 ( 53 0 ) capacitor c=0.00611287f //x=9.685 //y=4.88
c468 ( 50 0 ) capacitor c=0.0064096f //x=9.685 //y=2.26
c469 ( 48 0 ) capacitor c=0.0163473f //x=9.685 //y=3.51
c470 ( 43 0 ) capacitor c=0.0170489f //x=7.83 //y=3.51
c471 ( 40 0 ) capacitor c=0.0114531f //x=7.395 //y=1.18
c472 ( 38 0 ) capacitor c=5.78613e-19 //x=7.355 //y=5.56
c473 ( 35 0 ) capacitor c=0.0105334f //x=7.355 //y=5.38
c474 ( 34 0 ) capacitor c=0.00923791f //x=6.475 //y=5.56
c475 ( 30 0 ) capacitor c=0.0151939f //x=3.765 //y=3.51
c476 ( 23 0 ) capacitor c=0.0133022f //x=9.685 //y=3.665
c477 ( 22 0 ) capacitor c=0.0290122f //x=9.685 //y=3.345
c478 ( 20 0 ) capacitor c=0.0405859f //x=7.835 //y=5.295
c479 ( 19 0 ) capacitor c=0.0134936f //x=7.835 //y=3.67
c480 ( 18 0 ) capacitor c=0.0395231f //x=7.835 //y=3.35
c481 ( 16 0 ) capacitor c=0.00653562f //x=7.48 //y=1.835
c482 ( 15 0 ) capacitor c=0.013278f //x=7.75 //y=1.835
c483 ( 13 0 ) capacitor c=0.0108105f //x=7.75 //y=5.38
c484 ( 12 0 ) capacitor c=0.0102514f //x=7.395 //y=1.75
c485 ( 7 0 ) capacitor c=0.0151389f //x=7.24 //y=5.38
c486 ( 4 0 ) capacitor c=0.0286299f //x=3.765 //y=4.75
c487 ( 3 0 ) capacitor c=0.0126092f //x=3.765 //y=3.67
c488 ( 2 0 ) capacitor c=0.0274671f //x=3.765 //y=3.35
c489 ( 1 0 ) capacitor c=0.00685053f //x=3.765 //y=2.375
r490 (  182 184 ) resistor r=20.6867 //w=0.233 //l=0.1 //layer=ply \
 //thickness=0.18 //x=9.585 //y=4.88 //x2=9.685 //y2=4.88
r491 (  169 170 ) resistor r=52.7279 //w=0.214 //l=0.165 //layer=ply \
 //thickness=0.18 //x=3.765 //y=2.26 //x2=3.765 //y2=2.095
r492 (  165 184 ) resistor r=70.3348 //w=0.233 //l=0.414367 //layer=ply \
 //thickness=0.18 //x=10.025 //y=5.045 //x2=9.685 //y2=4.88
r493 (  164 186 ) resistor r=45.1352 //w=0.168 //l=0.173853 //layer=ply \
 //thickness=0.18 //x=10.02 //y=1.39 //x2=9.98 //y2=1.545
r494 (  163 185 ) resistor r=45.1352 //w=0.168 //l=0.173853 //layer=ply \
 //thickness=0.18 //x=10.02 //y=1.045 //x2=9.98 //y2=0.89
r495 (  163 164 ) resistor r=176.904 //w=0.094 //l=0.345 //layer=ply \
 //thickness=0.18 //x=10.02 //y=1.045 //x2=10.02 //y2=1.39
r496 (  161 181 ) resistor r=10.701 //w=0.21 //l=0.115 //layer=ply \
 //thickness=0.18 //x=9.645 //y=1.545 //x2=9.53 //y2=1.545
r497 (  160 186 ) resistor r=5.52526 //w=0.168 //l=0.115 //layer=ply \
 //thickness=0.18 //x=9.865 //y=1.545 //x2=9.98 //y2=1.545
r498 (  159 180 ) resistor r=5.52526 //w=0.168 //l=0.115 //layer=ply \
 //thickness=0.18 //x=9.645 //y=0.89 //x2=9.53 //y2=0.89
r499 (  158 185 ) resistor r=5.52526 //w=0.168 //l=0.115 //layer=ply \
 //thickness=0.18 //x=9.865 //y=0.89 //x2=9.98 //y2=0.89
r500 (  158 159 ) resistor r=112.809 //w=0.094 //l=0.22 //layer=ply \
 //thickness=0.18 //x=9.865 //y=0.89 //x2=9.645 //y2=0.89
r501 (  155 182 ) resistor r=13.0941 //w=0.233 //l=0.165 //layer=ply \
 //thickness=0.18 //x=9.585 //y=5.045 //x2=9.585 //y2=4.88
r502 (  154 179 ) resistor r=34.8111 //w=0.27 //l=0.264953 //layer=ply \
 //thickness=0.18 //x=9.49 //y=2.095 //x2=9.685 //y2=2.26
r503 (  153 181 ) resistor r=39.5823 //w=0.21 //l=0.173853 //layer=ply \
 //thickness=0.18 //x=9.49 //y=1.7 //x2=9.53 //y2=1.545
r504 (  153 154 ) resistor r=202.543 //w=0.094 //l=0.395 //layer=ply \
 //thickness=0.18 //x=9.49 //y=1.7 //x2=9.49 //y2=2.095
r505 (  152 181 ) resistor r=39.5823 //w=0.21 //l=0.173853 //layer=ply \
 //thickness=0.18 //x=9.49 //y=1.39 //x2=9.53 //y2=1.545
r506 (  151 180 ) resistor r=45.1352 //w=0.168 //l=0.173853 //layer=ply \
 //thickness=0.18 //x=9.49 //y=1.045 //x2=9.53 //y2=0.89
r507 (  151 152 ) resistor r=176.904 //w=0.094 //l=0.345 //layer=ply \
 //thickness=0.18 //x=9.49 //y=1.045 //x2=9.49 //y2=1.39
r508 (  150 177 ) resistor r=45.1352 //w=0.168 //l=0.173853 //layer=ply \
 //thickness=0.18 //x=4.285 //y=1.44 //x2=4.245 //y2=1.595
r509 (  149 176 ) resistor r=45.1352 //w=0.168 //l=0.173853 //layer=ply \
 //thickness=0.18 //x=4.285 //y=1.095 //x2=4.245 //y2=0.94
r510 (  149 150 ) resistor r=176.904 //w=0.094 //l=0.345 //layer=ply \
 //thickness=0.18 //x=4.285 //y=1.095 //x2=4.285 //y2=1.44
r511 (  147 173 ) resistor r=10.701 //w=0.21 //l=0.115 //layer=ply \
 //thickness=0.18 //x=3.91 //y=1.595 //x2=3.795 //y2=1.595
r512 (  146 177 ) resistor r=5.52526 //w=0.168 //l=0.115 //layer=ply \
 //thickness=0.18 //x=4.13 //y=1.595 //x2=4.245 //y2=1.595
r513 (  145 172 ) resistor r=5.52526 //w=0.168 //l=0.115 //layer=ply \
 //thickness=0.18 //x=3.91 //y=0.94 //x2=3.795 //y2=0.94
r514 (  144 176 ) resistor r=5.52526 //w=0.168 //l=0.115 //layer=ply \
 //thickness=0.18 //x=4.13 //y=0.94 //x2=4.245 //y2=0.94
r515 (  144 145 ) resistor r=112.809 //w=0.094 //l=0.22 //layer=ply \
 //thickness=0.18 //x=4.13 //y=0.94 //x2=3.91 //y2=0.94
r516 (  141 175 ) resistor r=37.236 //w=0.233 //l=0.249199 //layer=ply \
 //thickness=0.18 //x=3.945 //y=5.045 //x2=3.765 //y2=4.88
r517 (  139 173 ) resistor r=39.5823 //w=0.21 //l=0.173853 //layer=ply \
 //thickness=0.18 //x=3.755 //y=1.75 //x2=3.795 //y2=1.595
r518 (  139 170 ) resistor r=176.904 //w=0.094 //l=0.345 //layer=ply \
 //thickness=0.18 //x=3.755 //y=1.75 //x2=3.755 //y2=2.095
r519 (  138 173 ) resistor r=39.5823 //w=0.21 //l=0.173853 //layer=ply \
 //thickness=0.18 //x=3.755 //y=1.44 //x2=3.795 //y2=1.595
r520 (  137 172 ) resistor r=45.1352 //w=0.168 //l=0.173853 //layer=ply \
 //thickness=0.18 //x=3.755 //y=1.095 //x2=3.795 //y2=0.94
r521 (  137 138 ) resistor r=176.904 //w=0.094 //l=0.345 //layer=ply \
 //thickness=0.18 //x=3.755 //y=1.095 //x2=3.755 //y2=1.44
r522 (  134 175 ) resistor r=53.7854 //w=0.233 //l=0.332415 //layer=ply \
 //thickness=0.18 //x=3.505 //y=5.045 //x2=3.765 //y2=4.88
r523 (  133 165 ) resistor r=592.245 //w=0.094 //l=1.155 //layer=ply \
 //thickness=0.18 //x=10.025 //y=6.2 //x2=10.025 //y2=5.045
r524 (  132 155 ) resistor r=592.245 //w=0.094 //l=1.155 //layer=ply \
 //thickness=0.18 //x=9.585 //y=6.2 //x2=9.585 //y2=5.045
r525 (  131 141 ) resistor r=592.245 //w=0.094 //l=1.155 //layer=ply \
 //thickness=0.18 //x=3.945 //y=6.2 //x2=3.945 //y2=5.045
r526 (  130 134 ) resistor r=592.245 //w=0.094 //l=1.155 //layer=ply \
 //thickness=0.18 //x=3.505 //y=6.2 //x2=3.505 //y2=5.045
r527 (  129 160 ) resistor r=56.4043 //w=0.094 //l=0.11 //layer=ply \
 //thickness=0.18 //x=9.755 //y=1.545 //x2=9.865 //y2=1.545
r528 (  129 161 ) resistor r=56.4043 //w=0.094 //l=0.11 //layer=ply \
 //thickness=0.18 //x=9.755 //y=1.545 //x2=9.645 //y2=1.545
r529 (  128 146 ) resistor r=56.4043 //w=0.094 //l=0.11 //layer=ply \
 //thickness=0.18 //x=4.02 //y=1.595 //x2=4.13 //y2=1.595
r530 (  128 147 ) resistor r=56.4043 //w=0.094 //l=0.11 //layer=ply \
 //thickness=0.18 //x=4.02 //y=1.595 //x2=3.91 //y2=1.595
r531 (  124 184 ) resistor r=152 //w=0.17 //l=0.17 //layer=licon //count=1 \
 //x=9.685 //y=4.88 //x2=9.685 //y2=4.88
r532 (  115 179 ) resistor r=152 //w=0.17 //l=0.17 //layer=licon //count=1 \
 //x=9.685 //y=2.26 //x2=9.685 //y2=2.26
r533 (  98 190 ) resistor r=23.615 //w=0.187 //l=0.345 //layer=li \
 //thickness=0.1 //x=7.355 //y=5.56 //x2=7.355 //y2=5.905
r534 (  90 189 ) resistor r=23.615 //w=0.187 //l=0.345 //layer=li \
 //thickness=0.1 //x=6.475 //y=5.56 //x2=6.475 //y2=5.905
r535 (  85 175 ) resistor r=152 //w=0.17 //l=0.17 //layer=licon //count=1 \
 //x=3.765 //y=4.88 //x2=3.765 //y2=4.88
r536 (  76 169 ) resistor r=152 //w=0.17 //l=0.17 //layer=licon //count=1 \
 //x=3.765 //y=2.26 //x2=3.765 //y2=2.26
r537 (  72 73 ) resistor r=0.10734 //w=0.281 //l=0.16 //layer=m2 \
 //thickness=0.36 //x=9.68 //y=3.505 //x2=9.52 //y2=3.505
r538 (  65 70 ) resistor r=0.10188 //w=0.204 //l=0.16 //layer=m2 \
 //thickness=0.36 //x=7.99 //y=3.51 //x2=7.83 //y2=3.51
r539 (  65 73 ) resistor r=1.45992 //w=0.131 //l=1.53 //layer=m2 \
 //thickness=0.36 //x=7.99 //y=3.51 //x2=9.52 //y2=3.51
r540 (  62 70 ) resistor r=0.778963 //w=0.204 //l=1.27248 //layer=m2 \
 //thickness=0.36 //x=6.565 //y=3.495 //x2=7.83 //y2=3.51
r541 (  62 63 ) resistor r=0.410305 //w=0.131 //l=0.43 //layer=m2 \
 //thickness=0.36 //x=6.565 //y=3.495 //x2=6.135 //y2=3.495
r542 (  60 63 ) resistor r=0.125 //w=0.17 //l=0.177341 //layer=m2 \
 //thickness=0.36 //x=5.965 //y=3.51 //x2=6.135 //y2=3.495
r543 (  60 61 ) resistor r=0.944656 //w=0.131 //l=0.99 //layer=m2 \
 //thickness=0.36 //x=5.965 //y=3.51 //x2=4.975 //y2=3.51
r544 (  58 61 ) resistor r=0.1875 //w=0.17 //l=0.262393 //layer=m2 \
 //thickness=0.36 //x=4.72 //y=3.495 //x2=4.975 //y2=3.51
r545 (  58 59 ) resistor r=0.410305 //w=0.131 //l=0.43 //layer=m2 \
 //thickness=0.36 //x=4.72 //y=3.495 //x2=4.29 //y2=3.495
r546 (  57 67 ) resistor r=0.10734 //w=0.281 //l=0.16 //layer=m2 \
 //thickness=0.36 //x=3.93 //y=3.51 //x2=3.77 //y2=3.51
r547 (  56 59 ) resistor r=0.125 //w=0.17 //l=0.177341 //layer=m2 \
 //thickness=0.36 //x=4.12 //y=3.51 //x2=4.29 //y2=3.495
r548 (  56 57 ) resistor r=0.181298 //w=0.131 //l=0.19 //layer=m2 \
 //thickness=0.36 //x=4.12 //y=3.51 //x2=3.93 //y2=3.51
r549 (  53 124 ) resistor r=9.3 //w=0.17 //l=0.17 //layer=mcon //count=1 \
 //x=9.685 //y=4.88 //x2=9.685 //y2=4.88
r550 (  53 54 ) resistor r=0.103207 //w=0.196 //l=0.14 //layer=m1 \
 //thickness=0.36 //x=9.687 //y=4.88 //x2=9.687 //y2=4.74
r551 (  50 115 ) resistor r=9.3 //w=0.17 //l=0.17 //layer=mcon //count=1 \
 //x=9.685 //y=2.26 //x2=9.685 //y2=2.26
r552 (  46 72 ) resistor r=4.5 //w=0.15 //l=0.15 //layer=via1 //count=1 \
 //x=9.68 //y=3.505 //x2=9.68 //y2=3.505
r553 (  46 48 ) resistor r=0.00167112 //w=0.374 //l=0.005 //layer=m1 \
 //thickness=0.36 //x=9.63 //y=3.505 //x2=9.63 //y2=3.51
r554 (  43 70 ) resistor r=4.5 //w=0.15 //l=0.15 //layer=via1 //count=1 \
 //x=7.83 //y=3.51 //x2=7.83 //y2=3.51
r555 (  40 187 ) resistor r=9.3 //w=0.17 //l=0.17 //layer=mcon //count=1 \
 //x=7.395 //y=1.18 //x2=7.395 //y2=1.18
r556 (  38 98 ) resistor r=9.3 //w=0.17 //l=0.17 //layer=mcon //count=1 \
 //x=7.355 //y=5.56 //x2=7.355 //y2=5.56
r557 (  35 38 ) resistor r=0.117801 //w=0.191 //l=0.18 //layer=m1 \
 //thickness=0.36 //x=7.355 //y=5.38 //x2=7.355 //y2=5.56
r558 (  34 90 ) resistor r=9.3 //w=0.17 //l=0.17 //layer=mcon //count=1 \
 //x=6.475 //y=5.56 //x2=6.475 //y2=5.56
r559 (  32 34 ) resistor r=0.10274 //w=0.219 //l=0.18 //layer=m1 \
 //thickness=0.36 //x=6.475 //y=5.38 //x2=6.475 //y2=5.56
r560 (  30 67 ) resistor r=4.5 //w=0.15 //l=0.15 //layer=via1 //count=1 \
 //x=3.77 //y=3.51 //x2=3.77 //y2=3.51
r561 (  28 85 ) resistor r=9.3 //w=0.17 //l=0.17 //layer=mcon //count=1 \
 //x=3.765 //y=4.88 //x2=3.765 //y2=4.88
r562 (  26 76 ) resistor r=9.3 //w=0.17 //l=0.17 //layer=mcon //count=1 \
 //x=3.765 //y=2.26 //x2=3.765 //y2=2.26
r563 (  23 48 ) resistor r=0.089409 //w=0.374 //l=0.180416 //layer=m1 \
 //thickness=0.36 //x=9.685 //y=3.665 //x2=9.63 //y2=3.51
r564 (  23 54 ) resistor r=1.02576 //w=0.131 //l=1.075 //layer=m1 \
 //thickness=0.36 //x=9.685 //y=3.665 //x2=9.685 //y2=4.74
r565 (  22 46 ) resistor r=0.0910802 //w=0.374 //l=0.185472 //layer=m1 \
 //thickness=0.36 //x=9.685 //y=3.345 //x2=9.63 //y2=3.505
r566 (  21 50 ) resistor r=0.0933015 //w=0.201 //l=0.125 //layer=m1 \
 //thickness=0.36 //x=9.685 //y=2.385 //x2=9.685 //y2=2.26
r567 (  21 22 ) resistor r=0.916031 //w=0.131 //l=0.96 //layer=m1 \
 //thickness=0.36 //x=9.685 //y=2.385 //x2=9.685 //y2=3.345
r568 (  19 43 ) resistor r=0.0910802 //w=0.374 //l=0.185472 //layer=m1 \
 //thickness=0.36 //x=7.835 //y=3.67 //x2=7.78 //y2=3.51
r569 (  19 20 ) resistor r=1.55057 //w=0.131 //l=1.625 //layer=m1 \
 //thickness=0.36 //x=7.835 //y=3.67 //x2=7.835 //y2=5.295
r570 (  18 43 ) resistor r=0.0910802 //w=0.374 //l=0.185472 //layer=m1 \
 //thickness=0.36 //x=7.835 //y=3.35 //x2=7.78 //y2=3.51
r571 (  17 18 ) resistor r=1.3645 //w=0.131 //l=1.43 //layer=m1 \
 //thickness=0.36 //x=7.835 //y=1.92 //x2=7.835 //y2=3.35
r572 (  15 17 ) resistor r=0.0698411 //w=0.17 //l=0.120208 //layer=m1 \
 //thickness=0.36 //x=7.75 //y=1.835 //x2=7.835 //y2=1.92
r573 (  15 16 ) resistor r=0.257634 //w=0.131 //l=0.27 //layer=m1 \
 //thickness=0.36 //x=7.75 //y=1.835 //x2=7.48 //y2=1.835
r574 (  14 35 ) resistor r=0.0257089 //w=0.23 //l=0.115 //layer=m1 \
 //thickness=0.36 //x=7.47 //y=5.38 //x2=7.355 //y2=5.38
r575 (  13 20 ) resistor r=0.0698411 //w=0.17 //l=0.120208 //layer=m1 \
 //thickness=0.36 //x=7.75 //y=5.38 //x2=7.835 //y2=5.295
r576 (  13 14 ) resistor r=0.267176 //w=0.131 //l=0.28 //layer=m1 \
 //thickness=0.36 //x=7.75 //y=5.38 //x2=7.47 //y2=5.38
r577 (  12 16 ) resistor r=0.0698411 //w=0.17 //l=0.120208 //layer=m1 \
 //thickness=0.36 //x=7.395 //y=1.75 //x2=7.48 //y2=1.835
r578 (  11 40 ) resistor r=0.0913624 //w=0.191 //l=0.12 //layer=m1 \
 //thickness=0.36 //x=7.395 //y=1.3 //x2=7.395 //y2=1.18
r579 (  11 12 ) resistor r=0.429389 //w=0.131 //l=0.45 //layer=m1 \
 //thickness=0.36 //x=7.395 //y=1.3 //x2=7.395 //y2=1.75
r580 (  8 32 ) resistor r=0.0227762 //w=0.219 //l=0.115 //layer=m1 \
 //thickness=0.36 //x=6.59 //y=5.38 //x2=6.475 //y2=5.38
r581 (  7 35 ) resistor r=0.0257089 //w=0.23 //l=0.115 //layer=m1 \
 //thickness=0.36 //x=7.24 //y=5.38 //x2=7.355 //y2=5.38
r582 (  7 8 ) resistor r=0.620229 //w=0.131 //l=0.65 //layer=m1 \
 //thickness=0.36 //x=7.24 //y=5.38 //x2=6.59 //y2=5.38
r583 (  4 28 ) resistor r=0.0801089 //w=0.224 //l=0.13 //layer=m1 \
 //thickness=0.36 //x=3.765 //y=4.75 //x2=3.765 //y2=4.88
r584 (  3 30 ) resistor r=0.0910802 //w=0.374 //l=0.185472 //layer=m1 \
 //thickness=0.36 //x=3.765 //y=3.67 //x2=3.82 //y2=3.51
r585 (  3 4 ) resistor r=1.03053 //w=0.131 //l=1.08 //layer=m1 \
 //thickness=0.36 //x=3.765 //y=3.67 //x2=3.765 //y2=4.75
r586 (  2 30 ) resistor r=0.0910802 //w=0.374 //l=0.185472 //layer=m1 \
 //thickness=0.36 //x=3.765 //y=3.35 //x2=3.82 //y2=3.51
r587 (  1 26 ) resistor r=0.0719237 //w=0.222 //l=0.115 //layer=m1 \
 //thickness=0.36 //x=3.765 //y=2.375 //x2=3.765 //y2=2.26
r588 (  1 2 ) resistor r=0.930344 //w=0.131 //l=0.975 //layer=m1 \
 //thickness=0.36 //x=3.765 //y=2.375 //x2=3.765 //y2=3.35
ends PM_DFFQX1\%noxref_1

subckt PM_DFFQX1\%noxref_2 ( 3 8 9 11 12 14 15 16 18 19 23 24 27 29 32 35 38 \
 41 42 44 45 50 53 61 78 87 91 92 93 94 95 96 97 101 103 106 107 117 120 122 \
 123 )
c276 ( 120 0 ) capacitor c=0.00878249f //x=10.535 //y=1.085
c277 ( 117 0 ) capacitor c=0.0682508f //x=13.015 //y=4.88
c278 ( 107 0 ) capacitor c=0.0318956f //x=13.35 //y=1.39
c279 ( 106 0 ) capacitor c=0.0186809f //x=13.35 //y=1.045
c280 ( 103 0 ) capacitor c=0.0141821f //x=13.195 //y=1.545
c281 ( 101 0 ) capacitor c=0.0158553f //x=13.195 //y=0.89
c282 ( 97 0 ) capacitor c=0.0854195f //x=12.82 //y=2.095
c283 ( 96 0 ) capacitor c=0.0229235f //x=12.82 //y=1.7
c284 ( 95 0 ) capacitor c=0.0234359f //x=12.82 //y=1.39
c285 ( 94 0 ) capacitor c=0.0198759f //x=12.82 //y=1.045
c286 ( 93 0 ) capacitor c=0.110369f //x=13.355 //y=6.2
c287 ( 92 0 ) capacitor c=0.154619f //x=12.915 //y=6.2
c288 ( 87 0 ) capacitor c=8.13425e-19 //x=13.015 //y=4.88
c289 ( 78 0 ) capacitor c=7.85889e-19 //x=13.015 //y=2.26
c290 ( 61 0 ) capacitor c=0.0322017f //x=10.685 //y=5.56
c291 ( 53 0 ) capacitor c=0.0291714f //x=9.805 //y=5.56
c292 ( 50 0 ) capacitor c=0.00162839f //x=13.01 //y=3.51
c293 ( 45 0 ) capacitor c=0.00317997f //x=11.33 //y=3.51
c294 ( 44 0 ) capacitor c=0.0479792f //x=12.85 //y=3.51
c295 ( 42 0 ) capacitor c=0.0270867f //x=13.017 //y=4.74
c296 ( 41 0 ) capacitor c=0.0060492f //x=13.015 //y=4.88
c297 ( 38 0 ) capacitor c=0.00641145f //x=13.015 //y=2.26
c298 ( 35 0 ) capacitor c=0.0164425f //x=13.01 //y=3.51
c299 ( 32 0 ) capacitor c=0.0167895f //x=11.165 //y=3.51
c300 ( 29 0 ) capacitor c=0.0114498f //x=10.725 //y=1.18
c301 ( 27 0 ) capacitor c=5.78613e-19 //x=10.685 //y=5.56
c302 ( 24 0 ) capacitor c=0.0103127f //x=10.685 //y=5.38
c303 ( 23 0 ) capacitor c=0.00933334f //x=9.805 //y=5.56
c304 ( 19 0 ) capacitor c=0.0132504f //x=13.015 //y=3.67
c305 ( 18 0 ) capacitor c=0.0289239f //x=13.015 //y=3.35
c306 ( 16 0 ) capacitor c=0.0402153f //x=11.165 //y=5.295
c307 ( 15 0 ) capacitor c=0.0132747f //x=11.165 //y=3.67
c308 ( 14 0 ) capacitor c=0.0397593f //x=11.165 //y=3.35
c309 ( 12 0 ) capacitor c=0.00671763f //x=10.81 //y=1.835
c310 ( 11 0 ) capacitor c=0.0143344f //x=11.08 //y=1.835
c311 ( 9 0 ) capacitor c=0.0112475f //x=11.08 //y=5.38
c312 ( 8 0 ) capacitor c=0.0101547f //x=10.725 //y=1.75
c313 ( 3 0 ) capacitor c=0.0134484f //x=10.57 //y=5.38
r314 (  115 117 ) resistor r=20.6867 //w=0.233 //l=0.1 //layer=ply \
 //thickness=0.18 //x=12.915 //y=4.88 //x2=13.015 //y2=4.88
r315 (  108 117 ) resistor r=70.3348 //w=0.233 //l=0.414367 //layer=ply \
 //thickness=0.18 //x=13.355 //y=5.045 //x2=13.015 //y2=4.88
r316 (  107 119 ) resistor r=45.1352 //w=0.168 //l=0.173853 //layer=ply \
 //thickness=0.18 //x=13.35 //y=1.39 //x2=13.31 //y2=1.545
r317 (  106 118 ) resistor r=45.1352 //w=0.168 //l=0.173853 //layer=ply \
 //thickness=0.18 //x=13.35 //y=1.045 //x2=13.31 //y2=0.89
r318 (  106 107 ) resistor r=176.904 //w=0.094 //l=0.345 //layer=ply \
 //thickness=0.18 //x=13.35 //y=1.045 //x2=13.35 //y2=1.39
r319 (  104 114 ) resistor r=10.701 //w=0.21 //l=0.115 //layer=ply \
 //thickness=0.18 //x=12.975 //y=1.545 //x2=12.86 //y2=1.545
r320 (  103 119 ) resistor r=5.52526 //w=0.168 //l=0.115 //layer=ply \
 //thickness=0.18 //x=13.195 //y=1.545 //x2=13.31 //y2=1.545
r321 (  102 113 ) resistor r=5.52526 //w=0.168 //l=0.115 //layer=ply \
 //thickness=0.18 //x=12.975 //y=0.89 //x2=12.86 //y2=0.89
r322 (  101 118 ) resistor r=5.52526 //w=0.168 //l=0.115 //layer=ply \
 //thickness=0.18 //x=13.195 //y=0.89 //x2=13.31 //y2=0.89
r323 (  101 102 ) resistor r=112.809 //w=0.094 //l=0.22 //layer=ply \
 //thickness=0.18 //x=13.195 //y=0.89 //x2=12.975 //y2=0.89
r324 (  98 115 ) resistor r=13.0941 //w=0.233 //l=0.165 //layer=ply \
 //thickness=0.18 //x=12.915 //y=5.045 //x2=12.915 //y2=4.88
r325 (  97 112 ) resistor r=34.8111 //w=0.27 //l=0.264953 //layer=ply \
 //thickness=0.18 //x=12.82 //y=2.095 //x2=13.015 //y2=2.26
r326 (  96 114 ) resistor r=39.5823 //w=0.21 //l=0.173853 //layer=ply \
 //thickness=0.18 //x=12.82 //y=1.7 //x2=12.86 //y2=1.545
r327 (  96 97 ) resistor r=202.543 //w=0.094 //l=0.395 //layer=ply \
 //thickness=0.18 //x=12.82 //y=1.7 //x2=12.82 //y2=2.095
r328 (  95 114 ) resistor r=39.5823 //w=0.21 //l=0.173853 //layer=ply \
 //thickness=0.18 //x=12.82 //y=1.39 //x2=12.86 //y2=1.545
r329 (  94 113 ) resistor r=45.1352 //w=0.168 //l=0.173853 //layer=ply \
 //thickness=0.18 //x=12.82 //y=1.045 //x2=12.86 //y2=0.89
r330 (  94 95 ) resistor r=176.904 //w=0.094 //l=0.345 //layer=ply \
 //thickness=0.18 //x=12.82 //y=1.045 //x2=12.82 //y2=1.39
r331 (  93 108 ) resistor r=592.245 //w=0.094 //l=1.155 //layer=ply \
 //thickness=0.18 //x=13.355 //y=6.2 //x2=13.355 //y2=5.045
r332 (  92 98 ) resistor r=592.245 //w=0.094 //l=1.155 //layer=ply \
 //thickness=0.18 //x=12.915 //y=6.2 //x2=12.915 //y2=5.045
r333 (  91 103 ) resistor r=56.4043 //w=0.094 //l=0.11 //layer=ply \
 //thickness=0.18 //x=13.085 //y=1.545 //x2=13.195 //y2=1.545
r334 (  91 104 ) resistor r=56.4043 //w=0.094 //l=0.11 //layer=ply \
 //thickness=0.18 //x=13.085 //y=1.545 //x2=12.975 //y2=1.545
r335 (  87 117 ) resistor r=152 //w=0.17 //l=0.17 //layer=licon //count=1 \
 //x=13.015 //y=4.88 //x2=13.015 //y2=4.88
r336 (  78 112 ) resistor r=152 //w=0.17 //l=0.17 //layer=licon //count=1 \
 //x=13.015 //y=2.26 //x2=13.015 //y2=2.26
r337 (  61 123 ) resistor r=23.615 //w=0.187 //l=0.345 //layer=li \
 //thickness=0.1 //x=10.685 //y=5.56 //x2=10.685 //y2=5.905
r338 (  53 122 ) resistor r=23.615 //w=0.187 //l=0.345 //layer=li \
 //thickness=0.1 //x=9.805 //y=5.56 //x2=9.805 //y2=5.905
r339 (  45 47 ) resistor r=0.10734 //w=0.281 //l=0.16 //layer=m2 \
 //thickness=0.36 //x=11.33 //y=3.51 //x2=11.17 //y2=3.51
r340 (  44 50 ) resistor r=0.10734 //w=0.281 //l=0.16 //layer=m2 \
 //thickness=0.36 //x=12.85 //y=3.51 //x2=13.01 //y2=3.51
r341 (  44 45 ) resistor r=1.45038 //w=0.131 //l=1.52 //layer=m2 \
 //thickness=0.36 //x=12.85 //y=3.51 //x2=11.33 //y2=3.51
r342 (  41 87 ) resistor r=9.3 //w=0.17 //l=0.17 //layer=mcon //count=1 \
 //x=13.015 //y=4.88 //x2=13.015 //y2=4.88
r343 (  41 42 ) resistor r=0.103207 //w=0.196 //l=0.14 //layer=m1 \
 //thickness=0.36 //x=13.017 //y=4.88 //x2=13.017 //y2=4.74
r344 (  38 78 ) resistor r=9.3 //w=0.17 //l=0.17 //layer=mcon //count=1 \
 //x=13.015 //y=2.26 //x2=13.015 //y2=2.26
r345 (  35 50 ) resistor r=4.5 //w=0.15 //l=0.15 //layer=via1 //count=1 \
 //x=13.01 //y=3.51 //x2=13.01 //y2=3.51
r346 (  32 47 ) resistor r=4.5 //w=0.15 //l=0.15 //layer=via1 //count=1 \
 //x=11.17 //y=3.51 //x2=11.17 //y2=3.51
r347 (  29 120 ) resistor r=9.3 //w=0.17 //l=0.17 //layer=mcon //count=1 \
 //x=10.725 //y=1.18 //x2=10.725 //y2=1.18
r348 (  27 61 ) resistor r=9.3 //w=0.17 //l=0.17 //layer=mcon //count=1 \
 //x=10.685 //y=5.56 //x2=10.685 //y2=5.56
r349 (  24 27 ) resistor r=0.117801 //w=0.191 //l=0.18 //layer=m1 \
 //thickness=0.36 //x=10.685 //y=5.38 //x2=10.685 //y2=5.56
r350 (  23 53 ) resistor r=9.3 //w=0.17 //l=0.17 //layer=mcon //count=1 \
 //x=9.805 //y=5.56 //x2=9.805 //y2=5.56
r351 (  21 23 ) resistor r=0.10274 //w=0.219 //l=0.18 //layer=m1 \
 //thickness=0.36 //x=9.805 //y=5.38 //x2=9.805 //y2=5.56
r352 (  19 35 ) resistor r=0.0910802 //w=0.374 //l=0.185472 //layer=m1 \
 //thickness=0.36 //x=13.015 //y=3.67 //x2=12.96 //y2=3.51
r353 (  19 42 ) resistor r=1.02099 //w=0.131 //l=1.07 //layer=m1 \
 //thickness=0.36 //x=13.015 //y=3.67 //x2=13.015 //y2=4.74
r354 (  18 35 ) resistor r=0.0910802 //w=0.374 //l=0.185472 //layer=m1 \
 //thickness=0.36 //x=13.015 //y=3.35 //x2=12.96 //y2=3.51
r355 (  17 38 ) resistor r=0.0933015 //w=0.201 //l=0.125 //layer=m1 \
 //thickness=0.36 //x=13.015 //y=2.385 //x2=13.015 //y2=2.26
r356 (  17 18 ) resistor r=0.920802 //w=0.131 //l=0.965 //layer=m1 \
 //thickness=0.36 //x=13.015 //y=2.385 //x2=13.015 //y2=3.35
r357 (  15 32 ) resistor r=0.0910802 //w=0.374 //l=0.185472 //layer=m1 \
 //thickness=0.36 //x=11.165 //y=3.67 //x2=11.22 //y2=3.51
r358 (  15 16 ) resistor r=1.55057 //w=0.131 //l=1.625 //layer=m1 \
 //thickness=0.36 //x=11.165 //y=3.67 //x2=11.165 //y2=5.295
r359 (  14 32 ) resistor r=0.0910802 //w=0.374 //l=0.185472 //layer=m1 \
 //thickness=0.36 //x=11.165 //y=3.35 //x2=11.22 //y2=3.51
r360 (  13 14 ) resistor r=1.3645 //w=0.131 //l=1.43 //layer=m1 \
 //thickness=0.36 //x=11.165 //y=1.92 //x2=11.165 //y2=3.35
r361 (  11 13 ) resistor r=0.0698411 //w=0.17 //l=0.120208 //layer=m1 \
 //thickness=0.36 //x=11.08 //y=1.835 //x2=11.165 //y2=1.92
r362 (  11 12 ) resistor r=0.257634 //w=0.131 //l=0.27 //layer=m1 \
 //thickness=0.36 //x=11.08 //y=1.835 //x2=10.81 //y2=1.835
r363 (  10 24 ) resistor r=0.0257089 //w=0.23 //l=0.115 //layer=m1 \
 //thickness=0.36 //x=10.8 //y=5.38 //x2=10.685 //y2=5.38
r364 (  9 16 ) resistor r=0.0698411 //w=0.17 //l=0.120208 //layer=m1 \
 //thickness=0.36 //x=11.08 //y=5.38 //x2=11.165 //y2=5.295
r365 (  9 10 ) resistor r=0.267176 //w=0.131 //l=0.28 //layer=m1 \
 //thickness=0.36 //x=11.08 //y=5.38 //x2=10.8 //y2=5.38
r366 (  8 12 ) resistor r=0.0698411 //w=0.17 //l=0.120208 //layer=m1 \
 //thickness=0.36 //x=10.725 //y=1.75 //x2=10.81 //y2=1.835
r367 (  7 29 ) resistor r=0.0913624 //w=0.191 //l=0.12 //layer=m1 \
 //thickness=0.36 //x=10.725 //y=1.3 //x2=10.725 //y2=1.18
r368 (  7 8 ) resistor r=0.429389 //w=0.131 //l=0.45 //layer=m1 \
 //thickness=0.36 //x=10.725 //y=1.3 //x2=10.725 //y2=1.75
r369 (  4 21 ) resistor r=0.0227762 //w=0.219 //l=0.115 //layer=m1 \
 //thickness=0.36 //x=9.92 //y=5.38 //x2=9.805 //y2=5.38
r370 (  3 24 ) resistor r=0.0257089 //w=0.23 //l=0.115 //layer=m1 \
 //thickness=0.36 //x=10.57 //y=5.38 //x2=10.685 //y2=5.38
r371 (  3 4 ) resistor r=0.620229 //w=0.131 //l=0.65 //layer=m1 \
 //thickness=0.36 //x=10.57 //y=5.38 //x2=9.92 //y2=5.38
ends PM_DFFQX1\%noxref_2

subckt PM_DFFQX1\%CLK ( 1 2 3 4 5 6 20 24 27 30 33 38 39 44 47 49 51 57 62 67 \
 72 76 77 78 79 80 81 82 83 84 86 92 93 94 95 96 101 102 103 108 110 112 118 \
 119 123 132 133 136 )
c302 ( 136 0 ) capacitor c=0.0366322f //x=13.785 //y=4.88
c303 ( 133 0 ) capacitor c=0.0284095f //x=13.755 //y=2.095
c304 ( 132 0 ) capacitor c=0.0476356f //x=13.755 //y=2.26
c305 ( 123 0 ) capacitor c=0.0371837f //x=2.655 //y=4.88
c306 ( 119 0 ) capacitor c=0.0439708f //x=14.32 //y=1.43
c307 ( 118 0 ) capacitor c=0.0192582f //x=14.32 //y=1.085
c308 ( 112 0 ) capacitor c=0.0162526f //x=14.165 //y=1.585
c309 ( 110 0 ) capacitor c=0.0157807f //x=14.165 //y=0.93
c310 ( 108 0 ) capacitor c=0.0353784f //x=14.16 //y=4.97
c311 ( 103 0 ) capacitor c=0.0210762f //x=13.79 //y=1.74
c312 ( 102 0 ) capacitor c=0.0168511f //x=13.79 //y=1.43
c313 ( 101 0 ) capacitor c=0.0175485f //x=13.79 //y=1.085
c314 ( 96 0 ) capacitor c=0.0305913f //x=2.99 //y=4.97
c315 ( 95 0 ) capacitor c=0.0862588f //x=2.745 //y=2.095
c316 ( 94 0 ) capacitor c=0.0170266f //x=2.745 //y=1.63
c317 ( 93 0 ) capacitor c=0.018609f //x=2.745 //y=1.4
c318 ( 92 0 ) capacitor c=0.0186599f //x=2.745 //y=1.09
c319 ( 86 0 ) capacitor c=0.0146988f //x=2.59 //y=1.555
c320 ( 84 0 ) capacitor c=0.0148531f //x=2.59 //y=0.935
c321 ( 83 0 ) capacitor c=0.0334406f //x=2.22 //y=1.4
c322 ( 82 0 ) capacitor c=0.0173191f //x=2.22 //y=1.09
c323 ( 81 0 ) capacitor c=0.155269f //x=14.235 //y=6.2
c324 ( 80 0 ) capacitor c=0.110375f //x=13.795 //y=6.2
c325 ( 79 0 ) capacitor c=0.110208f //x=3.065 //y=6.2
c326 ( 78 0 ) capacitor c=0.110214f //x=2.625 //y=6.2
c327 ( 72 0 ) capacitor c=8.63406e-19 //x=13.785 //y=4.88
c328 ( 67 0 ) capacitor c=7.72439e-19 //x=13.755 //y=2.26
c329 ( 62 0 ) capacitor c=0.00143828f //x=2.655 //y=4.88
c330 ( 57 0 ) capacitor c=0.00121786f //x=2.655 //y=2.26
c331 ( 51 0 ) capacitor c=0.00181789f //x=2.655 //y=4.62
c332 ( 49 0 ) capacitor c=0.0886214f //x=10.645 //y=4.64
c333 ( 47 0 ) capacitor c=0.178731f //x=10.045 //y=4.62
c334 ( 44 0 ) capacitor c=0.00680024f //x=13.755 //y=2.26
c335 ( 39 0 ) capacitor c=0.0509274f //x=13.78 //y=4.705
c336 ( 38 0 ) capacitor c=0.00622154f //x=13.78 //y=4.865
c337 ( 33 0 ) capacitor c=0.00600692f //x=2.657 //y=3.795
c338 ( 30 0 ) capacitor c=0.00661856f //x=2.657 //y=3.425
c339 ( 27 0 ) capacitor c=0.00707416f //x=2.657 //y=3.055
c340 ( 24 0 ) capacitor c=0.00819168f //x=2.657 //y=2.685
c341 ( 20 0 ) capacitor c=0.00551512f //x=2.655 //y=4.88
c342 ( 6 0 ) capacitor c=0.00561142f //x=2.655 //y=2.375
c343 ( 5 0 ) capacitor c=0.00509564f //x=2.655 //y=3.88
c344 ( 4 0 ) capacitor c=0.00476233f //x=2.655 //y=3.51
c345 ( 3 0 ) capacitor c=0.00639296f //x=2.655 //y=3.14
c346 ( 2 0 ) capacitor c=0.00521398f //x=2.655 //y=2.77
c347 ( 1 0 ) capacitor c=0.0188395f //x=2.655 //y=4.62
r348 (  138 139 ) resistor r=32.4568 //w=0.214 //l=0.075 //layer=ply \
 //thickness=0.18 //x=13.785 //y=4.97 //x2=13.785 //y2=5.045
r349 (  136 138 ) resistor r=20.271 //w=0.214 //l=0.09 //layer=ply \
 //thickness=0.18 //x=13.785 //y=4.88 //x2=13.785 //y2=4.97
r350 (  132 133 ) resistor r=52.7279 //w=0.214 //l=0.165 //layer=ply \
 //thickness=0.18 //x=13.755 //y=2.26 //x2=13.755 //y2=2.095
r351 (  125 126 ) resistor r=32.4568 //w=0.214 //l=0.075 //layer=ply \
 //thickness=0.18 //x=2.655 //y=4.97 //x2=2.655 //y2=5.045
r352 (  123 125 ) resistor r=20.271 //w=0.214 //l=0.09 //layer=ply \
 //thickness=0.18 //x=2.655 //y=4.88 //x2=2.655 //y2=4.97
r353 (  119 143 ) resistor r=45.1352 //w=0.168 //l=0.173853 //layer=ply \
 //thickness=0.18 //x=14.32 //y=1.43 //x2=14.28 //y2=1.585
r354 (  118 142 ) resistor r=45.1352 //w=0.168 //l=0.173853 //layer=ply \
 //thickness=0.18 //x=14.32 //y=1.085 //x2=14.28 //y2=0.93
r355 (  118 119 ) resistor r=176.904 //w=0.094 //l=0.345 //layer=ply \
 //thickness=0.18 //x=14.32 //y=1.085 //x2=14.32 //y2=1.43
r356 (  113 141 ) resistor r=10.701 //w=0.21 //l=0.115 //layer=ply \
 //thickness=0.18 //x=13.945 //y=1.585 //x2=13.83 //y2=1.585
r357 (  112 143 ) resistor r=5.52526 //w=0.168 //l=0.115 //layer=ply \
 //thickness=0.18 //x=14.165 //y=1.585 //x2=14.28 //y2=1.585
r358 (  111 140 ) resistor r=5.52526 //w=0.168 //l=0.115 //layer=ply \
 //thickness=0.18 //x=13.945 //y=0.93 //x2=13.83 //y2=0.93
r359 (  110 142 ) resistor r=5.52526 //w=0.168 //l=0.115 //layer=ply \
 //thickness=0.18 //x=14.165 //y=0.93 //x2=14.28 //y2=0.93
r360 (  110 111 ) resistor r=112.809 //w=0.094 //l=0.22 //layer=ply \
 //thickness=0.18 //x=14.165 //y=0.93 //x2=13.945 //y2=0.93
r361 (  109 138 ) resistor r=16.5046 //w=0.27 //l=0.135 //layer=ply \
 //thickness=0.18 //x=13.92 //y=4.97 //x2=13.785 //y2=4.97
r362 (  108 115 ) resistor r=26.9307 //w=0.15 //l=0.106066 //layer=ply \
 //thickness=0.18 //x=14.16 //y=4.97 //x2=14.235 //y2=5.045
r363 (  108 109 ) resistor r=123.064 //w=0.094 //l=0.24 //layer=ply \
 //thickness=0.18 //x=14.16 //y=4.97 //x2=13.92 //y2=4.97
r364 (  103 141 ) resistor r=39.5823 //w=0.21 //l=0.173853 //layer=ply \
 //thickness=0.18 //x=13.79 //y=1.74 //x2=13.83 //y2=1.585
r365 (  103 133 ) resistor r=182.032 //w=0.094 //l=0.355 //layer=ply \
 //thickness=0.18 //x=13.79 //y=1.74 //x2=13.79 //y2=2.095
r366 (  102 141 ) resistor r=39.5823 //w=0.21 //l=0.173853 //layer=ply \
 //thickness=0.18 //x=13.79 //y=1.43 //x2=13.83 //y2=1.585
r367 (  101 140 ) resistor r=45.1352 //w=0.168 //l=0.173853 //layer=ply \
 //thickness=0.18 //x=13.79 //y=1.085 //x2=13.83 //y2=0.93
r368 (  101 102 ) resistor r=176.904 //w=0.094 //l=0.345 //layer=ply \
 //thickness=0.18 //x=13.79 //y=1.085 //x2=13.79 //y2=1.43
r369 (  97 125 ) resistor r=16.5046 //w=0.27 //l=0.135 //layer=ply \
 //thickness=0.18 //x=2.79 //y=4.97 //x2=2.655 //y2=4.97
r370 (  96 98 ) resistor r=26.9307 //w=0.15 //l=0.106066 //layer=ply \
 //thickness=0.18 //x=2.99 //y=4.97 //x2=3.065 //y2=5.045
r371 (  96 97 ) resistor r=102.553 //w=0.094 //l=0.2 //layer=ply \
 //thickness=0.18 //x=2.99 //y=4.97 //x2=2.79 //y2=4.97
r372 (  95 130 ) resistor r=38.6777 //w=0.284 //l=0.198997 //layer=ply \
 //thickness=0.18 //x=2.745 //y=2.095 //x2=2.67 //y2=2.26
r373 (  94 128 ) resistor r=21.2976 //w=0.217 //l=0.0928709 //layer=ply \
 //thickness=0.18 //x=2.745 //y=1.63 //x2=2.705 //y2=1.555
r374 (  94 95 ) resistor r=238.436 //w=0.094 //l=0.465 //layer=ply \
 //thickness=0.18 //x=2.745 //y=1.63 //x2=2.745 //y2=2.095
r375 (  93 128 ) resistor r=39.0671 //w=0.217 //l=0.173853 //layer=ply \
 //thickness=0.18 //x=2.745 //y=1.4 //x2=2.705 //y2=1.555
r376 (  92 127 ) resistor r=45.1352 //w=0.168 //l=0.173853 //layer=ply \
 //thickness=0.18 //x=2.745 //y=1.09 //x2=2.705 //y2=0.935
r377 (  92 93 ) resistor r=158.957 //w=0.094 //l=0.31 //layer=ply \
 //thickness=0.18 //x=2.745 //y=1.09 //x2=2.745 //y2=1.4
r378 (  87 121 ) resistor r=5.52526 //w=0.168 //l=0.115 //layer=ply \
 //thickness=0.18 //x=2.375 //y=1.555 //x2=2.26 //y2=1.555
r379 (  86 128 ) resistor r=11.4558 //w=0.217 //l=0.115 //layer=ply \
 //thickness=0.18 //x=2.59 //y=1.555 //x2=2.705 //y2=1.555
r380 (  85 120 ) resistor r=5.52526 //w=0.168 //l=0.115 //layer=ply \
 //thickness=0.18 //x=2.375 //y=0.935 //x2=2.26 //y2=0.935
r381 (  84 127 ) resistor r=5.52526 //w=0.168 //l=0.115 //layer=ply \
 //thickness=0.18 //x=2.59 //y=0.935 //x2=2.705 //y2=0.935
r382 (  84 85 ) resistor r=110.245 //w=0.094 //l=0.215 //layer=ply \
 //thickness=0.18 //x=2.59 //y=0.935 //x2=2.375 //y2=0.935
r383 (  83 121 ) resistor r=45.1352 //w=0.168 //l=0.173853 //layer=ply \
 //thickness=0.18 //x=2.22 //y=1.4 //x2=2.26 //y2=1.555
r384 (  82 120 ) resistor r=45.1352 //w=0.168 //l=0.173853 //layer=ply \
 //thickness=0.18 //x=2.22 //y=1.09 //x2=2.26 //y2=0.935
r385 (  82 83 ) resistor r=158.957 //w=0.094 //l=0.31 //layer=ply \
 //thickness=0.18 //x=2.22 //y=1.09 //x2=2.22 //y2=1.4
r386 (  81 115 ) resistor r=592.245 //w=0.094 //l=1.155 //layer=ply \
 //thickness=0.18 //x=14.235 //y=6.2 //x2=14.235 //y2=5.045
r387 (  80 139 ) resistor r=592.245 //w=0.094 //l=1.155 //layer=ply \
 //thickness=0.18 //x=13.795 //y=6.2 //x2=13.795 //y2=5.045
r388 (  79 98 ) resistor r=592.245 //w=0.094 //l=1.155 //layer=ply \
 //thickness=0.18 //x=3.065 //y=6.2 //x2=3.065 //y2=5.045
r389 (  78 126 ) resistor r=592.245 //w=0.094 //l=1.155 //layer=ply \
 //thickness=0.18 //x=2.625 //y=6.2 //x2=2.625 //y2=5.045
r390 (  77 112 ) resistor r=56.4043 //w=0.094 //l=0.11 //layer=ply \
 //thickness=0.18 //x=14.055 //y=1.585 //x2=14.165 //y2=1.585
r391 (  77 113 ) resistor r=56.4043 //w=0.094 //l=0.11 //layer=ply \
 //thickness=0.18 //x=14.055 //y=1.585 //x2=13.945 //y2=1.585
r392 (  76 86 ) resistor r=55.3787 //w=0.094 //l=0.108 //layer=ply \
 //thickness=0.18 //x=2.482 //y=1.555 //x2=2.59 //y2=1.555
r393 (  76 87 ) resistor r=54.866 //w=0.094 //l=0.107 //layer=ply \
 //thickness=0.18 //x=2.482 //y=1.555 //x2=2.375 //y2=1.555
r394 (  72 136 ) resistor r=152 //w=0.17 //l=0.17 //layer=licon //count=1 \
 //x=13.785 //y=4.88 //x2=13.785 //y2=4.88
r395 (  67 132 ) resistor r=152 //w=0.17 //l=0.17 //layer=licon //count=1 \
 //x=13.755 //y=2.26 //x2=13.755 //y2=2.26
r396 (  62 123 ) resistor r=152 //w=0.17 //l=0.17 //layer=licon //count=1 \
 //x=2.655 //y=4.88 //x2=2.655 //y2=4.88
r397 (  57 130 ) resistor r=152 //w=0.17 //l=0.17 //layer=licon //count=1 \
 //x=2.655 //y=2.26 //x2=2.655 //y2=2.26
r398 (  51 53 ) resistor r=0.110922 //w=0.293 //l=0.26 //layer=m2 \
 //thickness=0.36 //x=2.655 //y=4.62 //x2=2.655 //y2=4.88
r399 (  49 55 ) resistor r=1.99191 //w=0.197 //l=3.16733 //layer=m2 \
 //thickness=0.36 //x=10.645 //y=4.64 //x2=13.78 //y2=4.705
r400 (  49 50 ) resistor r=0.329198 //w=0.131 //l=0.345 //layer=m2 \
 //thickness=0.36 //x=10.645 //y=4.64 //x2=10.3 //y2=4.64
r401 (  48 51 ) resistor r=0.040188 //w=0.293 //l=0.16 //layer=m2 \
 //thickness=0.36 //x=2.815 //y=4.62 //x2=2.655 //y2=4.62
r402 (  47 50 ) resistor r=0.1875 //w=0.17 //l=0.264811 //layer=m2 \
 //thickness=0.36 //x=10.045 //y=4.62 //x2=10.3 //y2=4.64
r403 (  47 48 ) resistor r=6.89885 //w=0.131 //l=7.23 //layer=m2 \
 //thickness=0.36 //x=10.045 //y=4.62 //x2=2.815 //y2=4.62
r404 (  44 67 ) resistor r=9.3 //w=0.17 //l=0.17 //layer=mcon //count=1 \
 //x=13.755 //y=2.26 //x2=13.755 //y2=2.26
r405 (  44 46 ) resistor r=0.0936408 //w=0.196 //l=0.125 //layer=m1 \
 //thickness=0.36 //x=13.757 //y=2.26 //x2=13.757 //y2=2.385
r406 (  41 72 ) resistor r=9.3 //w=0.17 //l=0.17 //layer=mcon //count=1 \
 //x=13.785 //y=4.88 //x2=13.785 //y2=4.88
r407 (  39 46 ) resistor r=2.21374 //w=0.131 //l=2.32 //layer=m1 \
 //thickness=0.36 //x=13.755 //y=4.705 //x2=13.755 //y2=2.385
r408 (  38 55 ) resistor r=4.5 //w=0.15 //l=0.15 //layer=via1 //count=1 \
 //x=13.78 //y=4.865 //x2=13.78 //y2=4.865
r409 (  38 41 ) resistor r=0.0066726 //w=0.281 //l=0.015 //layer=m1 \
 //thickness=0.36 //x=13.78 //y=4.865 //x2=13.78 //y2=4.88
r410 (  38 39 ) resistor r=0.10734 //w=0.281 //l=0.16 //layer=m1 \
 //thickness=0.36 //x=13.78 //y=4.865 //x2=13.78 //y2=4.705
r411 (  36 57 ) resistor r=9.3 //w=0.17 //l=0.17 //layer=mcon //count=1 \
 //x=2.655 //y=2.26 //x2=2.655 //y2=2.26
r412 (  31 33 ) resistor r=0.19084 //w=0.131 //l=0.2 //layer=m1 \
 //thickness=0.36 //x=2.655 //y=3.595 //x2=2.655 //y2=3.795
r413 (  28 30 ) resistor r=0.19084 //w=0.131 //l=0.2 //layer=m1 \
 //thickness=0.36 //x=2.655 //y=3.225 //x2=2.655 //y2=3.425
r414 (  25 27 ) resistor r=0.19084 //w=0.131 //l=0.2 //layer=m1 \
 //thickness=0.36 //x=2.655 //y=2.855 //x2=2.655 //y2=3.055
r415 (  20 62 ) resistor r=9.3 //w=0.17 //l=0.17 //layer=mcon //count=1 \
 //x=2.655 //y=4.88 //x2=2.655 //y2=4.88
r416 (  20 53 ) resistor r=4.5 //w=0.15 //l=0.15 //layer=via1 //count=1 \
 //x=2.655 //y=4.88 //x2=2.655 //y2=4.88
r417 (  15 20 ) resistor r=0.10734 //w=0.281 //l=0.16 //layer=m1 \
 //thickness=0.36 //x=2.655 //y=4.72 //x2=2.655 //y2=4.88
r418 (  6 36 ) resistor r=0.0715665 //w=0.226 //l=0.115996 //layer=m1 \
 //thickness=0.36 //x=2.655 //y=2.375 //x2=2.657 //y2=2.26
r419 (  6 24 ) resistor r=0.295802 //w=0.131 //l=0.31 //layer=m1 \
 //thickness=0.36 //x=2.655 //y=2.375 //x2=2.655 //y2=2.685
r420 (  5 34 ) resistor r=0.078125 //w=0.136 //l=0.085 //layer=m1 \
 //thickness=0.36 //x=2.657 //y=3.88 //x2=2.657 //y2=3.965
r421 (  5 33 ) resistor r=0.078125 //w=0.136 //l=0.085 //layer=m1 \
 //thickness=0.36 //x=2.657 //y=3.88 //x2=2.657 //y2=3.795
r422 (  4 31 ) resistor r=0.078125 //w=0.136 //l=0.085 //layer=m1 \
 //thickness=0.36 //x=2.657 //y=3.51 //x2=2.657 //y2=3.595
r423 (  4 30 ) resistor r=0.078125 //w=0.136 //l=0.085 //layer=m1 \
 //thickness=0.36 //x=2.657 //y=3.51 //x2=2.657 //y2=3.425
r424 (  3 28 ) resistor r=0.078125 //w=0.136 //l=0.085 //layer=m1 \
 //thickness=0.36 //x=2.657 //y=3.14 //x2=2.657 //y2=3.225
r425 (  3 27 ) resistor r=0.078125 //w=0.136 //l=0.085 //layer=m1 \
 //thickness=0.36 //x=2.657 //y=3.14 //x2=2.657 //y2=3.055
r426 (  2 25 ) resistor r=0.078125 //w=0.136 //l=0.085 //layer=m1 \
 //thickness=0.36 //x=2.657 //y=2.77 //x2=2.657 //y2=2.855
r427 (  2 24 ) resistor r=0.078125 //w=0.136 //l=0.085 //layer=m1 \
 //thickness=0.36 //x=2.657 //y=2.77 //x2=2.657 //y2=2.685
r428 (  1 15 ) resistor r=0.0954198 //w=0.131 //l=0.1 //layer=m1 \
 //thickness=0.36 //x=2.655 //y=4.62 //x2=2.655 //y2=4.72
r429 (  1 34 ) resistor r=0.625 //w=0.131 //l=0.655 //layer=m1 \
 //thickness=0.36 //x=2.655 //y=4.62 //x2=2.655 //y2=3.965
ends PM_DFFQX1\%CLK

subckt PM_DFFQX1\%noxref_4 ( 1 3 6 7 9 10 11 12 14 15 16 18 19 22 23 25 28 31 \
 37 40 43 46 47 50 54 57 58 60 61 62 63 64 66 68 70 72 74 84 92 100 117 126 \
 131 140 144 145 146 147 148 149 150 151 152 153 157 159 162 163 167 168 169 \
 170 174 176 179 180 190 199 202 204 205 206 )
c478 ( 202 0 ) capacitor c=0.00885916f //x=3.83 //y=1.095
c479 ( 199 0 ) capacitor c=0.0645411f //x=16.345 //y=4.88
c480 ( 190 0 ) capacitor c=0.0645923f //x=6.355 //y=4.88
c481 ( 180 0 ) capacitor c=0.0318956f //x=16.68 //y=1.39
c482 ( 179 0 ) capacitor c=0.0186809f //x=16.68 //y=1.045
c483 ( 176 0 ) capacitor c=0.0141821f //x=16.525 //y=1.545
c484 ( 174 0 ) capacitor c=0.0158553f //x=16.525 //y=0.89
c485 ( 170 0 ) capacitor c=0.088055f //x=16.15 //y=2.095
c486 ( 169 0 ) capacitor c=0.0229235f //x=16.15 //y=1.7
c487 ( 168 0 ) capacitor c=0.0234359f //x=16.15 //y=1.39
c488 ( 167 0 ) capacitor c=0.0198759f //x=16.15 //y=1.045
c489 ( 163 0 ) capacitor c=0.0318956f //x=6.69 //y=1.39
c490 ( 162 0 ) capacitor c=0.0186809f //x=6.69 //y=1.045
c491 ( 159 0 ) capacitor c=0.0141821f //x=6.535 //y=1.545
c492 ( 157 0 ) capacitor c=0.0158553f //x=6.535 //y=0.89
c493 ( 153 0 ) capacitor c=0.088055f //x=6.16 //y=2.095
c494 ( 152 0 ) capacitor c=0.0229235f //x=6.16 //y=1.7
c495 ( 151 0 ) capacitor c=0.0234359f //x=6.16 //y=1.39
c496 ( 150 0 ) capacitor c=0.0198759f //x=6.16 //y=1.045
c497 ( 149 0 ) capacitor c=0.110369f //x=16.685 //y=6.2
c498 ( 148 0 ) capacitor c=0.154619f //x=16.245 //y=6.2
c499 ( 147 0 ) capacitor c=0.110369f //x=6.695 //y=6.2
c500 ( 146 0 ) capacitor c=0.154619f //x=6.255 //y=6.2
c501 ( 140 0 ) capacitor c=8.13425e-19 //x=16.345 //y=4.88
c502 ( 131 0 ) capacitor c=7.85889e-19 //x=16.345 //y=2.26
c503 ( 126 0 ) capacitor c=8.13425e-19 //x=6.355 //y=4.88
c504 ( 117 0 ) capacitor c=7.85889e-19 //x=6.355 //y=2.26
c505 ( 100 0 ) capacitor c=0.0293071f //x=3.725 //y=5.56
c506 ( 92 0 ) capacitor c=0.029137f //x=2.845 //y=5.56
c507 ( 84 0 ) capacitor c=0.0278099f //x=1.965 //y=5.56
c508 ( 74 0 ) capacitor c=0.0891228f //x=13.225 //y=3.895
c509 ( 72 0 ) capacitor c=0.0175525f //x=12.625 //y=3.88
c510 ( 70 0 ) capacitor c=0.00410953f //x=11.385 //y=3.895
c511 ( 68 0 ) capacitor c=0.0176014f //x=10.645 //y=3.87
c512 ( 66 0 ) capacitor c=0.0106365f //x=9.895 //y=3.89
c513 ( 64 0 ) capacitor c=0.0178779f //x=9.295 //y=3.88
c514 ( 63 0 ) capacitor c=0.0103681f //x=7.7 //y=3.895
c515 ( 62 0 ) capacitor c=0.00467954f //x=8.045 //y=3.895
c516 ( 61 0 ) capacitor c=7.05145e-19 //x=4.665 //y=3.88
c517 ( 60 0 ) capacitor c=0.0193144f //x=6.19 //y=3.88
c518 ( 58 0 ) capacitor c=0.0167537f //x=16.347 //y=4.74
c519 ( 57 0 ) capacitor c=0.00598189f //x=16.345 //y=4.88
c520 ( 54 0 ) capacitor c=0.00654828f //x=16.345 //y=2.26
c521 ( 50 0 ) capacitor c=0.0142994f //x=16.345 //y=3.88
c522 ( 47 0 ) capacitor c=0.0172769f //x=6.357 //y=4.74
c523 ( 46 0 ) capacitor c=0.00598357f //x=6.355 //y=4.88
c524 ( 43 0 ) capacitor c=0.00654649f //x=6.355 //y=2.26
c525 ( 40 0 ) capacitor c=0.0163193f //x=6.35 //y=3.88
c526 ( 37 0 ) capacitor c=0.0170864f //x=4.505 //y=3.88
c527 ( 31 0 ) capacitor c=9.55882e-19 //x=3.725 //y=5.335
c528 ( 28 0 ) capacitor c=0.00756506f //x=2.845 //y=5.335
c529 ( 25 0 ) capacitor c=0.0123281f //x=1.967 //y=5.335
c530 ( 23 0 ) capacitor c=0.0124767f //x=16.345 //y=4.045
c531 ( 22 0 ) capacitor c=0.0406685f //x=16.345 //y=3.725
c532 ( 19 0 ) capacitor c=0.0124834f //x=6.355 //y=4.04
c533 ( 18 0 ) capacitor c=0.0389536f //x=6.355 //y=3.72
c534 ( 16 0 ) capacitor c=0.0309857f //x=4.505 //y=5.25
c535 ( 15 0 ) capacitor c=0.0132732f //x=4.505 //y=4.04
c536 ( 14 0 ) capacitor c=0.0507527f //x=4.505 //y=3.72
c537 ( 12 0 ) capacitor c=0.00686157f //x=4.105 //y=1.845
c538 ( 11 0 ) capacitor c=0.0159771f //x=4.42 //y=1.845
c539 ( 10 0 ) capacitor c=0.0136149f //x=4.02 //y=1.76
c540 ( 9 0 ) capacitor c=0.0112344f //x=4.02 //y=1.305
c541 ( 7 0 ) capacitor c=0.0228253f //x=4.42 //y=5.335
c542 ( 6 0 ) capacitor c=0.00906713f //x=3.725 //y=5.56
c543 ( 3 0 ) capacitor c=0.019596f //x=3.61 //y=5.335
c544 ( 1 0 ) capacitor c=0.0150747f //x=2.725 //y=5.335
r545 (  197 199 ) resistor r=20.6867 //w=0.233 //l=0.1 //layer=ply \
 //thickness=0.18 //x=16.245 //y=4.88 //x2=16.345 //y2=4.88
r546 (  188 190 ) resistor r=20.6867 //w=0.233 //l=0.1 //layer=ply \
 //thickness=0.18 //x=6.255 //y=4.88 //x2=6.355 //y2=4.88
r547 (  181 199 ) resistor r=70.3348 //w=0.233 //l=0.414367 //layer=ply \
 //thickness=0.18 //x=16.685 //y=5.045 //x2=16.345 //y2=4.88
r548 (  180 201 ) resistor r=45.1352 //w=0.168 //l=0.173853 //layer=ply \
 //thickness=0.18 //x=16.68 //y=1.39 //x2=16.64 //y2=1.545
r549 (  179 200 ) resistor r=45.1352 //w=0.168 //l=0.173853 //layer=ply \
 //thickness=0.18 //x=16.68 //y=1.045 //x2=16.64 //y2=0.89
r550 (  179 180 ) resistor r=176.904 //w=0.094 //l=0.345 //layer=ply \
 //thickness=0.18 //x=16.68 //y=1.045 //x2=16.68 //y2=1.39
r551 (  177 196 ) resistor r=10.701 //w=0.21 //l=0.115 //layer=ply \
 //thickness=0.18 //x=16.305 //y=1.545 //x2=16.19 //y2=1.545
r552 (  176 201 ) resistor r=5.52526 //w=0.168 //l=0.115 //layer=ply \
 //thickness=0.18 //x=16.525 //y=1.545 //x2=16.64 //y2=1.545
r553 (  175 195 ) resistor r=5.52526 //w=0.168 //l=0.115 //layer=ply \
 //thickness=0.18 //x=16.305 //y=0.89 //x2=16.19 //y2=0.89
r554 (  174 200 ) resistor r=5.52526 //w=0.168 //l=0.115 //layer=ply \
 //thickness=0.18 //x=16.525 //y=0.89 //x2=16.64 //y2=0.89
r555 (  174 175 ) resistor r=112.809 //w=0.094 //l=0.22 //layer=ply \
 //thickness=0.18 //x=16.525 //y=0.89 //x2=16.305 //y2=0.89
r556 (  171 197 ) resistor r=13.0941 //w=0.233 //l=0.165 //layer=ply \
 //thickness=0.18 //x=16.245 //y=5.045 //x2=16.245 //y2=4.88
r557 (  170 194 ) resistor r=34.8111 //w=0.27 //l=0.264953 //layer=ply \
 //thickness=0.18 //x=16.15 //y=2.095 //x2=16.345 //y2=2.26
r558 (  169 196 ) resistor r=39.5823 //w=0.21 //l=0.173853 //layer=ply \
 //thickness=0.18 //x=16.15 //y=1.7 //x2=16.19 //y2=1.545
r559 (  169 170 ) resistor r=202.543 //w=0.094 //l=0.395 //layer=ply \
 //thickness=0.18 //x=16.15 //y=1.7 //x2=16.15 //y2=2.095
r560 (  168 196 ) resistor r=39.5823 //w=0.21 //l=0.173853 //layer=ply \
 //thickness=0.18 //x=16.15 //y=1.39 //x2=16.19 //y2=1.545
r561 (  167 195 ) resistor r=45.1352 //w=0.168 //l=0.173853 //layer=ply \
 //thickness=0.18 //x=16.15 //y=1.045 //x2=16.19 //y2=0.89
r562 (  167 168 ) resistor r=176.904 //w=0.094 //l=0.345 //layer=ply \
 //thickness=0.18 //x=16.15 //y=1.045 //x2=16.15 //y2=1.39
r563 (  164 190 ) resistor r=70.3348 //w=0.233 //l=0.414367 //layer=ply \
 //thickness=0.18 //x=6.695 //y=5.045 //x2=6.355 //y2=4.88
r564 (  163 192 ) resistor r=45.1352 //w=0.168 //l=0.173853 //layer=ply \
 //thickness=0.18 //x=6.69 //y=1.39 //x2=6.65 //y2=1.545
r565 (  162 191 ) resistor r=45.1352 //w=0.168 //l=0.173853 //layer=ply \
 //thickness=0.18 //x=6.69 //y=1.045 //x2=6.65 //y2=0.89
r566 (  162 163 ) resistor r=176.904 //w=0.094 //l=0.345 //layer=ply \
 //thickness=0.18 //x=6.69 //y=1.045 //x2=6.69 //y2=1.39
r567 (  160 187 ) resistor r=10.701 //w=0.21 //l=0.115 //layer=ply \
 //thickness=0.18 //x=6.315 //y=1.545 //x2=6.2 //y2=1.545
r568 (  159 192 ) resistor r=5.52526 //w=0.168 //l=0.115 //layer=ply \
 //thickness=0.18 //x=6.535 //y=1.545 //x2=6.65 //y2=1.545
r569 (  158 186 ) resistor r=5.52526 //w=0.168 //l=0.115 //layer=ply \
 //thickness=0.18 //x=6.315 //y=0.89 //x2=6.2 //y2=0.89
r570 (  157 191 ) resistor r=5.52526 //w=0.168 //l=0.115 //layer=ply \
 //thickness=0.18 //x=6.535 //y=0.89 //x2=6.65 //y2=0.89
r571 (  157 158 ) resistor r=112.809 //w=0.094 //l=0.22 //layer=ply \
 //thickness=0.18 //x=6.535 //y=0.89 //x2=6.315 //y2=0.89
r572 (  154 188 ) resistor r=13.0941 //w=0.233 //l=0.165 //layer=ply \
 //thickness=0.18 //x=6.255 //y=5.045 //x2=6.255 //y2=4.88
r573 (  153 185 ) resistor r=34.8111 //w=0.27 //l=0.264953 //layer=ply \
 //thickness=0.18 //x=6.16 //y=2.095 //x2=6.355 //y2=2.26
r574 (  152 187 ) resistor r=39.5823 //w=0.21 //l=0.173853 //layer=ply \
 //thickness=0.18 //x=6.16 //y=1.7 //x2=6.2 //y2=1.545
r575 (  152 153 ) resistor r=202.543 //w=0.094 //l=0.395 //layer=ply \
 //thickness=0.18 //x=6.16 //y=1.7 //x2=6.16 //y2=2.095
r576 (  151 187 ) resistor r=39.5823 //w=0.21 //l=0.173853 //layer=ply \
 //thickness=0.18 //x=6.16 //y=1.39 //x2=6.2 //y2=1.545
r577 (  150 186 ) resistor r=45.1352 //w=0.168 //l=0.173853 //layer=ply \
 //thickness=0.18 //x=6.16 //y=1.045 //x2=6.2 //y2=0.89
r578 (  150 151 ) resistor r=176.904 //w=0.094 //l=0.345 //layer=ply \
 //thickness=0.18 //x=6.16 //y=1.045 //x2=6.16 //y2=1.39
r579 (  149 181 ) resistor r=592.245 //w=0.094 //l=1.155 //layer=ply \
 //thickness=0.18 //x=16.685 //y=6.2 //x2=16.685 //y2=5.045
r580 (  148 171 ) resistor r=592.245 //w=0.094 //l=1.155 //layer=ply \
 //thickness=0.18 //x=16.245 //y=6.2 //x2=16.245 //y2=5.045
r581 (  147 164 ) resistor r=592.245 //w=0.094 //l=1.155 //layer=ply \
 //thickness=0.18 //x=6.695 //y=6.2 //x2=6.695 //y2=5.045
r582 (  146 154 ) resistor r=592.245 //w=0.094 //l=1.155 //layer=ply \
 //thickness=0.18 //x=6.255 //y=6.2 //x2=6.255 //y2=5.045
r583 (  145 176 ) resistor r=56.4043 //w=0.094 //l=0.11 //layer=ply \
 //thickness=0.18 //x=16.415 //y=1.545 //x2=16.525 //y2=1.545
r584 (  145 177 ) resistor r=56.4043 //w=0.094 //l=0.11 //layer=ply \
 //thickness=0.18 //x=16.415 //y=1.545 //x2=16.305 //y2=1.545
r585 (  144 159 ) resistor r=56.4043 //w=0.094 //l=0.11 //layer=ply \
 //thickness=0.18 //x=6.425 //y=1.545 //x2=6.535 //y2=1.545
r586 (  144 160 ) resistor r=56.4043 //w=0.094 //l=0.11 //layer=ply \
 //thickness=0.18 //x=6.425 //y=1.545 //x2=6.315 //y2=1.545
r587 (  140 199 ) resistor r=152 //w=0.17 //l=0.17 //layer=licon //count=1 \
 //x=16.345 //y=4.88 //x2=16.345 //y2=4.88
r588 (  131 194 ) resistor r=152 //w=0.17 //l=0.17 //layer=licon //count=1 \
 //x=16.345 //y=2.26 //x2=16.345 //y2=2.26
r589 (  126 190 ) resistor r=152 //w=0.17 //l=0.17 //layer=licon //count=1 \
 //x=6.355 //y=4.88 //x2=6.355 //y2=4.88
r590 (  117 185 ) resistor r=152 //w=0.17 //l=0.17 //layer=licon //count=1 \
 //x=6.355 //y=2.26 //x2=6.355 //y2=2.26
r591 (  100 206 ) resistor r=23.615 //w=0.187 //l=0.345 //layer=li \
 //thickness=0.1 //x=3.725 //y=5.56 //x2=3.725 //y2=5.905
r592 (  92 205 ) resistor r=23.615 //w=0.187 //l=0.345 //layer=li \
 //thickness=0.1 //x=2.845 //y=5.56 //x2=2.845 //y2=5.905
r593 (  84 204 ) resistor r=23.615 //w=0.187 //l=0.345 //layer=li \
 //thickness=0.1 //x=1.965 //y=5.56 //x2=1.965 //y2=5.905
r594 (  74 82 ) resistor r=2.10915 //w=0.185 //l=3.125 //layer=m2 \
 //thickness=0.36 //x=13.225 //y=3.895 //x2=16.345 //y2=3.885
r595 (  74 75 ) resistor r=0.329198 //w=0.131 //l=0.345 //layer=m2 \
 //thickness=0.36 //x=13.225 //y=3.895 //x2=12.88 //y2=3.895
r596 (  72 75 ) resistor r=0.1875 //w=0.17 //l=0.262393 //layer=m2 \
 //thickness=0.36 //x=12.625 //y=3.88 //x2=12.88 //y2=3.895
r597 (  72 73 ) resistor r=1.02099 //w=0.131 //l=1.07 //layer=m2 \
 //thickness=0.36 //x=12.625 //y=3.88 //x2=11.555 //y2=3.88
r598 (  70 73 ) resistor r=0.125 //w=0.17 //l=0.177341 //layer=m2 \
 //thickness=0.36 //x=11.385 //y=3.895 //x2=11.555 //y2=3.88
r599 (  70 71 ) resistor r=0.329198 //w=0.131 //l=0.345 //layer=m2 \
 //thickness=0.36 //x=11.385 //y=3.895 //x2=11.04 //y2=3.895
r600 (  68 71 ) resistor r=0.290441 //w=0.17 //l=0.407308 //layer=m2 \
 //thickness=0.36 //x=10.645 //y=3.87 //x2=11.04 //y2=3.895
r601 (  68 69 ) resistor r=0.410305 //w=0.131 //l=0.43 //layer=m2 \
 //thickness=0.36 //x=10.645 //y=3.87 //x2=10.215 //y2=3.87
r602 (  66 69 ) resistor r=0.235294 //w=0.17 //l=0.329848 //layer=m2 \
 //thickness=0.36 //x=9.895 //y=3.89 //x2=10.215 //y2=3.87
r603 (  66 67 ) resistor r=0.329198 //w=0.131 //l=0.345 //layer=m2 \
 //thickness=0.36 //x=9.895 //y=3.89 //x2=9.55 //y2=3.89
r604 (  64 67 ) resistor r=0.1875 //w=0.17 //l=0.259952 //layer=m2 \
 //thickness=0.36 //x=9.295 //y=3.88 //x2=9.55 //y2=3.89
r605 (  64 65 ) resistor r=1.03053 //w=0.131 //l=1.08 //layer=m2 \
 //thickness=0.36 //x=9.295 //y=3.88 //x2=8.215 //y2=3.88
r606 (  63 80 ) resistor r=0.838898 //w=0.202 //l=1.35748 //layer=m2 \
 //thickness=0.36 //x=7.7 //y=3.895 //x2=6.35 //y2=3.88
r607 (  62 65 ) resistor r=0.125 //w=0.17 //l=0.177341 //layer=m2 \
 //thickness=0.36 //x=8.045 //y=3.895 //x2=8.215 //y2=3.88
r608 (  62 63 ) resistor r=0.329198 //w=0.131 //l=0.345 //layer=m2 \
 //thickness=0.36 //x=8.045 //y=3.895 //x2=7.7 //y2=3.895
r609 (  61 77 ) resistor r=0.10734 //w=0.281 //l=0.16 //layer=m2 \
 //thickness=0.36 //x=4.665 //y=3.88 //x2=4.505 //y2=3.88
r610 (  60 80 ) resistor r=0.102512 //w=0.202 //l=0.16 //layer=m2 \
 //thickness=0.36 //x=6.19 //y=3.88 //x2=6.35 //y2=3.88
r611 (  60 61 ) resistor r=1.45515 //w=0.131 //l=1.525 //layer=m2 \
 //thickness=0.36 //x=6.19 //y=3.88 //x2=4.665 //y2=3.88
r612 (  57 140 ) resistor r=9.3 //w=0.17 //l=0.17 //layer=mcon //count=1 \
 //x=16.345 //y=4.88 //x2=16.345 //y2=4.88
r613 (  57 58 ) resistor r=0.103207 //w=0.196 //l=0.14 //layer=m1 \
 //thickness=0.36 //x=16.347 //y=4.88 //x2=16.347 //y2=4.74
r614 (  54 131 ) resistor r=9.3 //w=0.17 //l=0.17 //layer=mcon //count=1 \
 //x=16.345 //y=2.26 //x2=16.345 //y2=2.26
r615 (  52 82 ) resistor r=4.5 //w=0.15 //l=0.15 //layer=via1 //count=1 \
 //x=16.345 //y=3.885 //x2=16.345 //y2=3.885
r616 (  50 52 ) resistor r=0.00166223 //w=0.376 //l=0.005 //layer=m1 \
 //thickness=0.36 //x=16.292 //y=3.88 //x2=16.292 //y2=3.885
r617 (  46 126 ) resistor r=9.3 //w=0.17 //l=0.17 //layer=mcon //count=1 \
 //x=6.355 //y=4.88 //x2=6.355 //y2=4.88
r618 (  46 47 ) resistor r=0.103207 //w=0.196 //l=0.14 //layer=m1 \
 //thickness=0.36 //x=6.357 //y=4.88 //x2=6.357 //y2=4.74
r619 (  43 117 ) resistor r=9.3 //w=0.17 //l=0.17 //layer=mcon //count=1 \
 //x=6.355 //y=2.26 //x2=6.355 //y2=2.26
r620 (  40 80 ) resistor r=4.5 //w=0.15 //l=0.15 //layer=via1 //count=1 \
 //x=6.35 //y=3.88 //x2=6.35 //y2=3.88
r621 (  37 77 ) resistor r=4.5 //w=0.15 //l=0.15 //layer=via1 //count=1 \
 //x=4.505 //y=3.88 //x2=4.505 //y2=3.88
r622 (  35 202 ) resistor r=9.3 //w=0.17 //l=0.17 //layer=mcon //count=1 \
 //x=4.02 //y=1.19 //x2=4.02 //y2=1.19
r623 (  33 100 ) resistor r=9.3 //w=0.17 //l=0.17 //layer=mcon //count=1 \
 //x=3.725 //y=5.56 //x2=3.725 //y2=5.56
r624 (  30 92 ) resistor r=9.3 //w=0.17 //l=0.17 //layer=mcon //count=1 \
 //x=2.845 //y=5.56 //x2=2.845 //y2=5.56
r625 (  28 30 ) resistor r=0.121228 //w=0.232 //l=0.225 //layer=m1 \
 //thickness=0.36 //x=2.845 //y=5.335 //x2=2.845 //y2=5.56
r626 (  27 84 ) resistor r=9.3 //w=0.17 //l=0.17 //layer=mcon //count=1 \
 //x=1.965 //y=5.56 //x2=1.965 //y2=5.56
r627 (  25 27 ) resistor r=0.129608 //w=0.217 //l=0.225 //layer=m1 \
 //thickness=0.36 //x=1.967 //y=5.335 //x2=1.967 //y2=5.56
r628 (  23 52 ) resistor r=0.0911593 //w=0.376 //l=0.184608 //layer=m1 \
 //thickness=0.36 //x=16.345 //y=4.045 //x2=16.292 //y2=3.885
r629 (  23 58 ) resistor r=0.663168 //w=0.131 //l=0.695 //layer=m1 \
 //thickness=0.36 //x=16.345 //y=4.045 //x2=16.345 //y2=4.74
r630 (  22 50 ) resistor r=0.0894971 //w=0.376 //l=0.179555 //layer=m1 \
 //thickness=0.36 //x=16.345 //y=3.725 //x2=16.292 //y2=3.88
r631 (  21 54 ) resistor r=0.0933015 //w=0.201 //l=0.125 //layer=m1 \
 //thickness=0.36 //x=16.345 //y=2.385 //x2=16.345 //y2=2.26
r632 (  21 22 ) resistor r=1.27863 //w=0.131 //l=1.34 //layer=m1 \
 //thickness=0.36 //x=16.345 //y=2.385 //x2=16.345 //y2=3.725
r633 (  19 40 ) resistor r=0.0910802 //w=0.374 //l=0.185472 //layer=m1 \
 //thickness=0.36 //x=6.355 //y=4.04 //x2=6.3 //y2=3.88
r634 (  19 47 ) resistor r=0.667939 //w=0.131 //l=0.7 //layer=m1 \
 //thickness=0.36 //x=6.355 //y=4.04 //x2=6.355 //y2=4.74
r635 (  18 40 ) resistor r=0.0910802 //w=0.374 //l=0.185472 //layer=m1 \
 //thickness=0.36 //x=6.355 //y=3.72 //x2=6.3 //y2=3.88
r636 (  17 43 ) resistor r=0.0933015 //w=0.201 //l=0.125 //layer=m1 \
 //thickness=0.36 //x=6.355 //y=2.385 //x2=6.355 //y2=2.26
r637 (  17 18 ) resistor r=1.27385 //w=0.131 //l=1.335 //layer=m1 \
 //thickness=0.36 //x=6.355 //y=2.385 //x2=6.355 //y2=3.72
r638 (  15 37 ) resistor r=0.0911593 //w=0.376 //l=0.184174 //layer=m1 \
 //thickness=0.36 //x=4.505 //y=4.04 //x2=4.557 //y2=3.88
r639 (  15 16 ) resistor r=1.15458 //w=0.131 //l=1.21 //layer=m1 \
 //thickness=0.36 //x=4.505 //y=4.04 //x2=4.505 //y2=5.25
r640 (  14 37 ) resistor r=0.0911593 //w=0.376 //l=0.184174 //layer=m1 \
 //thickness=0.36 //x=4.505 //y=3.72 //x2=4.557 //y2=3.88
r641 (  13 14 ) resistor r=1.70802 //w=0.131 //l=1.79 //layer=m1 \
 //thickness=0.36 //x=4.505 //y=1.93 //x2=4.505 //y2=3.72
r642 (  11 13 ) resistor r=0.0698411 //w=0.17 //l=0.120208 //layer=m1 \
 //thickness=0.36 //x=4.42 //y=1.845 //x2=4.505 //y2=1.93
r643 (  11 12 ) resistor r=0.300573 //w=0.131 //l=0.315 //layer=m1 \
 //thickness=0.36 //x=4.42 //y=1.845 //x2=4.105 //y2=1.845
r644 (  10 12 ) resistor r=0.0698411 //w=0.17 //l=0.120208 //layer=m1 \
 //thickness=0.36 //x=4.02 //y=1.76 //x2=4.105 //y2=1.845
r645 (  9 35 ) resistor r=0.0717383 //w=0.224 //l=0.115 //layer=m1 \
 //thickness=0.36 //x=4.02 //y=1.305 //x2=4.02 //y2=1.19
r646 (  9 10 ) resistor r=0.43416 //w=0.131 //l=0.455 //layer=m1 \
 //thickness=0.36 //x=4.02 //y=1.305 //x2=4.02 //y2=1.76
r647 (  8 31 ) resistor r=0.0675342 //w=0.23 //l=0.115 //layer=m1 \
 //thickness=0.36 //x=3.84 //y=5.335 //x2=3.725 //y2=5.335
r648 (  7 16 ) resistor r=0.0698411 //w=0.17 //l=0.120208 //layer=m1 \
 //thickness=0.36 //x=4.42 //y=5.335 //x2=4.505 //y2=5.25
r649 (  7 8 ) resistor r=0.553435 //w=0.131 //l=0.58 //layer=m1 \
 //thickness=0.36 //x=4.42 //y=5.335 //x2=3.84 //y2=5.335
r650 (  6 33 ) resistor r=0.00118313 //w=0.23 //layer=m1 //thickness=0.36 \
 //x=3.725 //y=5.56 //x2=3.725 //y2=5.56
r651 (  5 31 ) resistor r=0.002872 //w=0.34 //l=0.085 //layer=m1 \
 //thickness=0.36 //x=3.725 //y=5.42 //x2=3.725 //y2=5.335
r652 (  5 6 ) resistor r=0.091623 //w=0.191 //l=0.14 //layer=m1 \
 //thickness=0.36 //x=3.725 //y=5.42 //x2=3.725 //y2=5.56
r653 (  4 28 ) resistor r=0.0262263 //w=0.232 //l=0.12 //layer=m1 \
 //thickness=0.36 //x=2.965 //y=5.335 //x2=2.845 //y2=5.335
r654 (  3 31 ) resistor r=0.0675342 //w=0.23 //l=0.115 //layer=m1 \
 //thickness=0.36 //x=3.61 //y=5.335 //x2=3.725 //y2=5.335
r655 (  3 4 ) resistor r=0.615458 //w=0.131 //l=0.645 //layer=m1 \
 //thickness=0.36 //x=3.61 //y=5.335 //x2=2.965 //y2=5.335
r656 (  2 25 ) resistor r=0.0222262 //w=0.217 //l=0.118 //layer=m1 \
 //thickness=0.36 //x=2.085 //y=5.335 //x2=1.967 //y2=5.335
r657 (  1 28 ) resistor r=0.0262263 //w=0.232 //l=0.12 //layer=m1 \
 //thickness=0.36 //x=2.725 //y=5.335 //x2=2.845 //y2=5.335
r658 (  1 2 ) resistor r=0.610687 //w=0.131 //l=0.64 //layer=m1 \
 //thickness=0.36 //x=2.725 //y=5.335 //x2=2.085 //y2=5.335
ends PM_DFFQX1\%noxref_4

subckt PM_DFFQX1\%noxref_5 ( 3 8 9 11 12 14 15 16 18 19 23 24 27 29 34 38 40 \
 43 44 51 53 54 57 65 82 91 95 96 97 98 99 100 101 105 107 110 111 121 124 126 \
 127 )
c273 ( 124 0 ) capacitor c=0.00878249f //x=17.195 //y=1.085
c274 ( 121 0 ) capacitor c=0.0682508f //x=19.675 //y=4.88
c275 ( 111 0 ) capacitor c=0.0318956f //x=20.01 //y=1.39
c276 ( 110 0 ) capacitor c=0.0186809f //x=20.01 //y=1.045
c277 ( 107 0 ) capacitor c=0.0141821f //x=19.855 //y=1.545
c278 ( 105 0 ) capacitor c=0.0158553f //x=19.855 //y=0.89
c279 ( 101 0 ) capacitor c=0.0854074f //x=19.48 //y=2.095
c280 ( 100 0 ) capacitor c=0.0229235f //x=19.48 //y=1.7
c281 ( 99 0 ) capacitor c=0.0234359f //x=19.48 //y=1.39
c282 ( 98 0 ) capacitor c=0.0198759f //x=19.48 //y=1.045
c283 ( 97 0 ) capacitor c=0.110369f //x=20.015 //y=6.2
c284 ( 96 0 ) capacitor c=0.154619f //x=19.575 //y=6.2
c285 ( 91 0 ) capacitor c=8.13425e-19 //x=19.675 //y=4.88
c286 ( 82 0 ) capacitor c=7.85889e-19 //x=19.675 //y=2.26
c287 ( 65 0 ) capacitor c=0.0322017f //x=17.345 //y=5.56
c288 ( 57 0 ) capacitor c=0.0290186f //x=16.465 //y=5.56
c289 ( 54 0 ) capacitor c=0.0480964f //x=19.515 //y=3.485
c290 ( 53 0 ) capacitor c=0.00163192f //x=19.675 //y=3.485
c291 ( 51 0 ) capacitor c=0.00306238f //x=17.985 //y=3.495
c292 ( 44 0 ) capacitor c=0.0269319f //x=19.677 //y=4.74
c293 ( 43 0 ) capacitor c=0.00611977f //x=19.675 //y=4.88
c294 ( 40 0 ) capacitor c=0.0064022f //x=19.675 //y=2.26
c295 ( 38 0 ) capacitor c=0.0167166f //x=19.675 //y=3.51
c296 ( 34 0 ) capacitor c=0.0173232f //x=17.825 //y=3.51
c297 ( 29 0 ) capacitor c=0.0113657f //x=17.385 //y=1.18
c298 ( 27 0 ) capacitor c=5.78613e-19 //x=17.345 //y=5.56
c299 ( 24 0 ) capacitor c=0.0112577f //x=17.345 //y=5.38
c300 ( 23 0 ) capacitor c=0.00921781f //x=16.465 //y=5.56
c301 ( 19 0 ) capacitor c=0.0135253f //x=19.675 //y=3.645
c302 ( 18 0 ) capacitor c=0.0282242f //x=19.675 //y=3.325
c303 ( 16 0 ) capacitor c=0.0402498f //x=17.825 //y=5.295
c304 ( 15 0 ) capacitor c=0.013502f //x=17.825 //y=3.655
c305 ( 14 0 ) capacitor c=0.039387f //x=17.825 //y=3.335
c306 ( 12 0 ) capacitor c=0.00622751f //x=17.47 //y=1.835
c307 ( 11 0 ) capacitor c=0.0142752f //x=17.74 //y=1.835
c308 ( 9 0 ) capacitor c=0.0116047f //x=17.74 //y=5.38
c309 ( 8 0 ) capacitor c=0.0101547f //x=17.385 //y=1.75
c310 ( 3 0 ) capacitor c=0.0148064f //x=17.23 //y=5.38
r311 (  119 121 ) resistor r=20.6867 //w=0.233 //l=0.1 //layer=ply \
 //thickness=0.18 //x=19.575 //y=4.88 //x2=19.675 //y2=4.88
r312 (  112 121 ) resistor r=70.3348 //w=0.233 //l=0.414367 //layer=ply \
 //thickness=0.18 //x=20.015 //y=5.045 //x2=19.675 //y2=4.88
r313 (  111 123 ) resistor r=45.1352 //w=0.168 //l=0.173853 //layer=ply \
 //thickness=0.18 //x=20.01 //y=1.39 //x2=19.97 //y2=1.545
r314 (  110 122 ) resistor r=45.1352 //w=0.168 //l=0.173853 //layer=ply \
 //thickness=0.18 //x=20.01 //y=1.045 //x2=19.97 //y2=0.89
r315 (  110 111 ) resistor r=176.904 //w=0.094 //l=0.345 //layer=ply \
 //thickness=0.18 //x=20.01 //y=1.045 //x2=20.01 //y2=1.39
r316 (  108 118 ) resistor r=10.701 //w=0.21 //l=0.115 //layer=ply \
 //thickness=0.18 //x=19.635 //y=1.545 //x2=19.52 //y2=1.545
r317 (  107 123 ) resistor r=5.52526 //w=0.168 //l=0.115 //layer=ply \
 //thickness=0.18 //x=19.855 //y=1.545 //x2=19.97 //y2=1.545
r318 (  106 117 ) resistor r=5.52526 //w=0.168 //l=0.115 //layer=ply \
 //thickness=0.18 //x=19.635 //y=0.89 //x2=19.52 //y2=0.89
r319 (  105 122 ) resistor r=5.52526 //w=0.168 //l=0.115 //layer=ply \
 //thickness=0.18 //x=19.855 //y=0.89 //x2=19.97 //y2=0.89
r320 (  105 106 ) resistor r=112.809 //w=0.094 //l=0.22 //layer=ply \
 //thickness=0.18 //x=19.855 //y=0.89 //x2=19.635 //y2=0.89
r321 (  102 119 ) resistor r=13.0941 //w=0.233 //l=0.165 //layer=ply \
 //thickness=0.18 //x=19.575 //y=5.045 //x2=19.575 //y2=4.88
r322 (  101 116 ) resistor r=34.8111 //w=0.27 //l=0.264953 //layer=ply \
 //thickness=0.18 //x=19.48 //y=2.095 //x2=19.675 //y2=2.26
r323 (  100 118 ) resistor r=39.5823 //w=0.21 //l=0.173853 //layer=ply \
 //thickness=0.18 //x=19.48 //y=1.7 //x2=19.52 //y2=1.545
r324 (  100 101 ) resistor r=202.543 //w=0.094 //l=0.395 //layer=ply \
 //thickness=0.18 //x=19.48 //y=1.7 //x2=19.48 //y2=2.095
r325 (  99 118 ) resistor r=39.5823 //w=0.21 //l=0.173853 //layer=ply \
 //thickness=0.18 //x=19.48 //y=1.39 //x2=19.52 //y2=1.545
r326 (  98 117 ) resistor r=45.1352 //w=0.168 //l=0.173853 //layer=ply \
 //thickness=0.18 //x=19.48 //y=1.045 //x2=19.52 //y2=0.89
r327 (  98 99 ) resistor r=176.904 //w=0.094 //l=0.345 //layer=ply \
 //thickness=0.18 //x=19.48 //y=1.045 //x2=19.48 //y2=1.39
r328 (  97 112 ) resistor r=592.245 //w=0.094 //l=1.155 //layer=ply \
 //thickness=0.18 //x=20.015 //y=6.2 //x2=20.015 //y2=5.045
r329 (  96 102 ) resistor r=592.245 //w=0.094 //l=1.155 //layer=ply \
 //thickness=0.18 //x=19.575 //y=6.2 //x2=19.575 //y2=5.045
r330 (  95 107 ) resistor r=56.4043 //w=0.094 //l=0.11 //layer=ply \
 //thickness=0.18 //x=19.745 //y=1.545 //x2=19.855 //y2=1.545
r331 (  95 108 ) resistor r=56.4043 //w=0.094 //l=0.11 //layer=ply \
 //thickness=0.18 //x=19.745 //y=1.545 //x2=19.635 //y2=1.545
r332 (  91 121 ) resistor r=152 //w=0.17 //l=0.17 //layer=licon //count=1 \
 //x=19.675 //y=4.88 //x2=19.675 //y2=4.88
r333 (  82 116 ) resistor r=152 //w=0.17 //l=0.17 //layer=licon //count=1 \
 //x=19.675 //y=2.26 //x2=19.675 //y2=2.26
r334 (  65 127 ) resistor r=23.615 //w=0.187 //l=0.345 //layer=li \
 //thickness=0.1 //x=17.345 //y=5.56 //x2=17.345 //y2=5.905
r335 (  57 126 ) resistor r=23.615 //w=0.187 //l=0.345 //layer=li \
 //thickness=0.1 //x=16.465 //y=5.56 //x2=16.465 //y2=5.905
r336 (  53 54 ) resistor r=0.10734 //w=0.281 //l=0.16 //layer=m2 \
 //thickness=0.36 //x=19.675 //y=3.485 //x2=19.515 //y2=3.485
r337 (  51 54 ) resistor r=1.45992 //w=0.131 //l=1.53 //layer=m2 \
 //thickness=0.36 //x=17.985 //y=3.51 //x2=19.515 //y2=3.51
r338 (  49 51 ) resistor r=0.10734 //w=0.281 //l=0.16 //layer=m2 \
 //thickness=0.36 //x=17.825 //y=3.495 //x2=17.985 //y2=3.495
r339 (  43 91 ) resistor r=9.3 //w=0.17 //l=0.17 //layer=mcon //count=1 \
 //x=19.675 //y=4.88 //x2=19.675 //y2=4.88
r340 (  43 44 ) resistor r=0.103207 //w=0.196 //l=0.14 //layer=m1 \
 //thickness=0.36 //x=19.677 //y=4.88 //x2=19.677 //y2=4.74
r341 (  40 82 ) resistor r=9.3 //w=0.17 //l=0.17 //layer=mcon //count=1 \
 //x=19.675 //y=2.26 //x2=19.675 //y2=2.26
r342 (  36 53 ) resistor r=4.5 //w=0.15 //l=0.15 //layer=via1 //count=1 \
 //x=19.675 //y=3.485 //x2=19.675 //y2=3.485
r343 (  36 38 ) resistor r=0.00831117 //w=0.376 //l=0.025 //layer=m1 \
 //thickness=0.36 //x=19.622 //y=3.485 //x2=19.622 //y2=3.51
r344 (  32 49 ) resistor r=4.5 //w=0.15 //l=0.15 //layer=via1 //count=1 \
 //x=17.825 //y=3.495 //x2=17.825 //y2=3.495
r345 (  32 34 ) resistor r=0.0049867 //w=0.376 //l=0.015 //layer=m1 \
 //thickness=0.36 //x=17.877 //y=3.495 //x2=17.877 //y2=3.51
r346 (  29 124 ) resistor r=9.3 //w=0.17 //l=0.17 //layer=mcon //count=1 \
 //x=17.385 //y=1.18 //x2=17.385 //y2=1.18
r347 (  27 65 ) resistor r=9.3 //w=0.17 //l=0.17 //layer=mcon //count=1 \
 //x=17.345 //y=5.56 //x2=17.345 //y2=5.56
r348 (  24 27 ) resistor r=0.117801 //w=0.191 //l=0.18 //layer=m1 \
 //thickness=0.36 //x=17.345 //y=5.38 //x2=17.345 //y2=5.56
r349 (  23 57 ) resistor r=9.3 //w=0.17 //l=0.17 //layer=mcon //count=1 \
 //x=16.465 //y=5.56 //x2=16.465 //y2=5.56
r350 (  21 23 ) resistor r=0.10274 //w=0.219 //l=0.18 //layer=m1 \
 //thickness=0.36 //x=16.465 //y=5.38 //x2=16.465 //y2=5.56
r351 (  19 38 ) resistor r=0.0828482 //w=0.376 //l=0.159311 //layer=m1 \
 //thickness=0.36 //x=19.675 //y=3.645 //x2=19.622 //y2=3.51
r352 (  19 44 ) resistor r=1.04485 //w=0.131 //l=1.095 //layer=m1 \
 //thickness=0.36 //x=19.675 //y=3.645 //x2=19.675 //y2=4.74
r353 (  18 36 ) resistor r=0.0911593 //w=0.376 //l=0.184608 //layer=m1 \
 //thickness=0.36 //x=19.675 //y=3.325 //x2=19.622 //y2=3.485
r354 (  17 40 ) resistor r=0.0933015 //w=0.201 //l=0.125 //layer=m1 \
 //thickness=0.36 //x=19.675 //y=2.385 //x2=19.675 //y2=2.26
r355 (  17 18 ) resistor r=0.896947 //w=0.131 //l=0.94 //layer=m1 \
 //thickness=0.36 //x=19.675 //y=2.385 //x2=19.675 //y2=3.325
r356 (  15 34 ) resistor r=0.0861726 //w=0.376 //l=0.169012 //layer=m1 \
 //thickness=0.36 //x=17.825 //y=3.655 //x2=17.877 //y2=3.51
r357 (  15 16 ) resistor r=1.56489 //w=0.131 //l=1.64 //layer=m1 \
 //thickness=0.36 //x=17.825 //y=3.655 //x2=17.825 //y2=5.295
r358 (  14 32 ) resistor r=0.0911593 //w=0.376 //l=0.184174 //layer=m1 \
 //thickness=0.36 //x=17.825 //y=3.335 //x2=17.877 //y2=3.495
r359 (  13 14 ) resistor r=1.35019 //w=0.131 //l=1.415 //layer=m1 \
 //thickness=0.36 //x=17.825 //y=1.92 //x2=17.825 //y2=3.335
r360 (  11 13 ) resistor r=0.0698411 //w=0.17 //l=0.120208 //layer=m1 \
 //thickness=0.36 //x=17.74 //y=1.835 //x2=17.825 //y2=1.92
r361 (  11 12 ) resistor r=0.257634 //w=0.131 //l=0.27 //layer=m1 \
 //thickness=0.36 //x=17.74 //y=1.835 //x2=17.47 //y2=1.835
r362 (  10 24 ) resistor r=0.0257089 //w=0.23 //l=0.115 //layer=m1 \
 //thickness=0.36 //x=17.46 //y=5.38 //x2=17.345 //y2=5.38
r363 (  9 16 ) resistor r=0.0698411 //w=0.17 //l=0.120208 //layer=m1 \
 //thickness=0.36 //x=17.74 //y=5.38 //x2=17.825 //y2=5.295
r364 (  9 10 ) resistor r=0.267176 //w=0.131 //l=0.28 //layer=m1 \
 //thickness=0.36 //x=17.74 //y=5.38 //x2=17.46 //y2=5.38
r365 (  8 12 ) resistor r=0.0698411 //w=0.17 //l=0.120208 //layer=m1 \
 //thickness=0.36 //x=17.385 //y=1.75 //x2=17.47 //y2=1.835
r366 (  7 29 ) resistor r=0.0913624 //w=0.191 //l=0.12 //layer=m1 \
 //thickness=0.36 //x=17.385 //y=1.3 //x2=17.385 //y2=1.18
r367 (  7 8 ) resistor r=0.429389 //w=0.131 //l=0.45 //layer=m1 \
 //thickness=0.36 //x=17.385 //y=1.3 //x2=17.385 //y2=1.75
r368 (  4 21 ) resistor r=0.0227762 //w=0.219 //l=0.115 //layer=m1 \
 //thickness=0.36 //x=16.58 //y=5.38 //x2=16.465 //y2=5.38
r369 (  3 24 ) resistor r=0.0257089 //w=0.23 //l=0.115 //layer=m1 \
 //thickness=0.36 //x=17.23 //y=5.38 //x2=17.345 //y2=5.38
r370 (  3 4 ) resistor r=0.620229 //w=0.131 //l=0.65 //layer=m1 \
 //thickness=0.36 //x=17.23 //y=5.38 //x2=16.58 //y2=5.38
ends PM_DFFQX1\%noxref_5

subckt PM_DFFQX1\%noxref_6 ( 1 2 3 4 6 7 8 11 16 17 19 20 22 23 24 26 27 28 34 \
 38 42 49 50 53 55 58 62 65 70 72 74 76 78 79 80 81 85 93 102 107 116 121 129 \
 146 155 159 160 161 162 163 164 165 166 167 168 169 170 171 172 174 180 181 \
 182 183 187 188 189 194 196 198 204 205 206 207 208 213 215 217 223 224 234 \
 235 238 247 248 251 259 261 262 )
c592 ( 259 0 ) capacitor c=0.00878249f //x=13.865 //y=1.085
c593 ( 251 0 ) capacitor c=0.0356006f //x=20.445 //y=4.88
c594 ( 248 0 ) capacitor c=0.0284095f //x=20.415 //y=2.095
c595 ( 247 0 ) capacitor c=0.0476356f //x=20.415 //y=2.26
c596 ( 238 0 ) capacitor c=0.0354915f //x=10.455 //y=4.88
c597 ( 235 0 ) capacitor c=0.0284095f //x=10.425 //y=2.095
c598 ( 234 0 ) capacitor c=0.0476356f //x=10.425 //y=2.26
c599 ( 224 0 ) capacitor c=0.0439708f //x=20.98 //y=1.43
c600 ( 223 0 ) capacitor c=0.0192582f //x=20.98 //y=1.085
c601 ( 217 0 ) capacitor c=0.0162526f //x=20.825 //y=1.585
c602 ( 215 0 ) capacitor c=0.0157807f //x=20.825 //y=0.93
c603 ( 213 0 ) capacitor c=0.035926f //x=20.82 //y=4.97
c604 ( 208 0 ) capacitor c=0.0210762f //x=20.45 //y=1.74
c605 ( 207 0 ) capacitor c=0.0168511f //x=20.45 //y=1.43
c606 ( 206 0 ) capacitor c=0.0175485f //x=20.45 //y=1.085
c607 ( 205 0 ) capacitor c=0.0439708f //x=10.99 //y=1.43
c608 ( 204 0 ) capacitor c=0.0192582f //x=10.99 //y=1.085
c609 ( 198 0 ) capacitor c=0.0162526f //x=10.835 //y=1.585
c610 ( 196 0 ) capacitor c=0.0157807f //x=10.835 //y=0.93
c611 ( 194 0 ) capacitor c=0.0372668f //x=10.83 //y=4.97
c612 ( 189 0 ) capacitor c=0.0210762f //x=10.46 //y=1.74
c613 ( 188 0 ) capacitor c=0.0168511f //x=10.46 //y=1.43
c614 ( 187 0 ) capacitor c=0.0175485f //x=10.46 //y=1.085
c615 ( 183 0 ) capacitor c=0.0551643f //x=1.82 //y=4.97
c616 ( 182 0 ) capacitor c=0.0376038f //x=2.11 //y=4.97
c617 ( 181 0 ) capacitor c=0.0346489f //x=1.775 //y=1.4
c618 ( 180 0 ) capacitor c=0.018692f //x=1.775 //y=1.055
c619 ( 174 0 ) capacitor c=0.0137077f //x=1.62 //y=1.555
c620 ( 172 0 ) capacitor c=0.0158585f //x=1.62 //y=0.9
c621 ( 171 0 ) capacitor c=0.103534f //x=1.245 //y=2.095
c622 ( 170 0 ) capacitor c=0.0229444f //x=1.245 //y=1.71
c623 ( 169 0 ) capacitor c=0.0234359f //x=1.245 //y=1.4
c624 ( 168 0 ) capacitor c=0.019815f //x=1.245 //y=1.055
c625 ( 167 0 ) capacitor c=0.155269f //x=20.895 //y=6.2
c626 ( 166 0 ) capacitor c=0.110375f //x=20.455 //y=6.2
c627 ( 165 0 ) capacitor c=0.155269f //x=10.905 //y=6.2
c628 ( 164 0 ) capacitor c=0.110375f //x=10.465 //y=6.2
c629 ( 163 0 ) capacitor c=0.110208f //x=2.185 //y=6.2
c630 ( 162 0 ) capacitor c=0.158957f //x=1.745 //y=6.2
c631 ( 155 0 ) capacitor c=5.80994e-19 //x=20.445 //y=4.88
c632 ( 146 0 ) capacitor c=5.78095e-19 //x=20.415 //y=2.26
c633 ( 129 0 ) capacitor c=0.0319332f //x=14.015 //y=5.56
c634 ( 121 0 ) capacitor c=0.0291719f //x=13.135 //y=5.56
c635 ( 116 0 ) capacitor c=5.80994e-19 //x=10.455 //y=4.88
c636 ( 107 0 ) capacitor c=5.78095e-19 //x=10.425 //y=2.26
c637 ( 102 0 ) capacitor c=0.0012433f //x=1.545 //y=4.88
c638 ( 93 0 ) capacitor c=0.0012618f //x=1.545 //y=2.26
c639 ( 85 0 ) capacitor c=0.0110688f //x=1.71 //y=4.255
c640 ( 81 0 ) capacitor c=0.0516669f //x=16.215 //y=4.27
c641 ( 80 0 ) capacitor c=0.107256f //x=16.56 //y=4.27
c642 ( 79 0 ) capacitor c=0.0370282f //x=10.59 //y=4.25
c643 ( 78 0 ) capacitor c=0.0401039f //x=14.325 //y=4.25
c644 ( 76 0 ) capacitor c=0.00148682f //x=6.565 //y=4.265
c645 ( 74 0 ) capacitor c=0.0158261f //x=5.965 //y=4.25
c646 ( 72 0 ) capacitor c=0.00410955f //x=4.72 //y=4.265
c647 ( 70 0 ) capacitor c=0.0804955f //x=4.12 //y=4.25
c648 ( 65 0 ) capacitor c=0.0066236f //x=20.415 //y=2.26
c649 ( 62 0 ) capacitor c=0.0141348f //x=20.415 //y=4.25
c650 ( 58 0 ) capacitor c=0.015184f //x=14.495 //y=4.25
c651 ( 55 0 ) capacitor c=0.0114498f //x=14.055 //y=1.18
c652 ( 53 0 ) capacitor c=5.78613e-19 //x=14.015 //y=5.56
c653 ( 50 0 ) capacitor c=0.0106343f //x=14.015 //y=5.38
c654 ( 49 0 ) capacitor c=0.00933207f //x=13.135 //y=5.56
c655 ( 42 0 ) capacitor c=0.00662515f //x=10.425 //y=2.26
c656 ( 38 0 ) capacitor c=0.0143744f //x=10.425 //y=4.25
c657 ( 34 0 ) capacitor c=0.0160407f //x=1.545 //y=4.25
c658 ( 28 0 ) capacitor c=0.00985447f //x=20.415 //y=4.735
c659 ( 27 0 ) capacitor c=0.0096151f //x=20.415 //y=4.41
c660 ( 26 0 ) capacitor c=0.0378361f //x=20.415 //y=4.09
c661 ( 24 0 ) capacitor c=0.0186555f //x=14.495 //y=5.295
c662 ( 23 0 ) capacitor c=0.0128691f //x=14.495 //y=4.425
c663 ( 22 0 ) capacitor c=0.0617041f //x=14.495 //y=4.105
c664 ( 20 0 ) capacitor c=0.00671966f //x=14.14 //y=1.835
c665 ( 19 0 ) capacitor c=0.0142356f //x=14.41 //y=1.835
c666 ( 17 0 ) capacitor c=0.0102685f //x=14.41 //y=5.38
c667 ( 16 0 ) capacitor c=0.0101547f //x=14.055 //y=1.75
c668 ( 11 0 ) capacitor c=0.0142466f //x=13.9 //y=5.38
c669 ( 8 0 ) capacitor c=0.00908133f //x=10.425 //y=4.735
c670 ( 7 0 ) capacitor c=0.00971944f //x=10.425 //y=4.415
c671 ( 6 0 ) capacitor c=0.0367292f //x=10.425 //y=4.095
c672 ( 4 0 ) capacitor c=0.0228118f //x=1.545 //y=4.755
c673 ( 3 0 ) capacitor c=0.0128906f //x=1.545 //y=4.415
c674 ( 2 0 ) capacitor c=0.0862595f //x=1.545 //y=4.095
c675 ( 1 0 ) capacitor c=0.0113406f //x=1.545 //y=2.375
r676 (  253 254 ) resistor r=32.4568 //w=0.214 //l=0.075 //layer=ply \
 //thickness=0.18 //x=20.445 //y=4.97 //x2=20.445 //y2=5.045
r677 (  251 253 ) resistor r=20.271 //w=0.214 //l=0.09 //layer=ply \
 //thickness=0.18 //x=20.445 //y=4.88 //x2=20.445 //y2=4.97
r678 (  247 248 ) resistor r=52.7279 //w=0.214 //l=0.165 //layer=ply \
 //thickness=0.18 //x=20.415 //y=2.26 //x2=20.415 //y2=2.095
r679 (  240 241 ) resistor r=32.4568 //w=0.214 //l=0.075 //layer=ply \
 //thickness=0.18 //x=10.455 //y=4.97 //x2=10.455 //y2=5.045
r680 (  238 240 ) resistor r=20.271 //w=0.214 //l=0.09 //layer=ply \
 //thickness=0.18 //x=10.455 //y=4.88 //x2=10.455 //y2=4.97
r681 (  234 235 ) resistor r=52.7279 //w=0.214 //l=0.165 //layer=ply \
 //thickness=0.18 //x=10.425 //y=2.26 //x2=10.425 //y2=2.095
r682 (  224 258 ) resistor r=45.1352 //w=0.168 //l=0.173853 //layer=ply \
 //thickness=0.18 //x=20.98 //y=1.43 //x2=20.94 //y2=1.585
r683 (  223 257 ) resistor r=45.1352 //w=0.168 //l=0.173853 //layer=ply \
 //thickness=0.18 //x=20.98 //y=1.085 //x2=20.94 //y2=0.93
r684 (  223 224 ) resistor r=176.904 //w=0.094 //l=0.345 //layer=ply \
 //thickness=0.18 //x=20.98 //y=1.085 //x2=20.98 //y2=1.43
r685 (  218 256 ) resistor r=10.701 //w=0.21 //l=0.115 //layer=ply \
 //thickness=0.18 //x=20.605 //y=1.585 //x2=20.49 //y2=1.585
r686 (  217 258 ) resistor r=5.52526 //w=0.168 //l=0.115 //layer=ply \
 //thickness=0.18 //x=20.825 //y=1.585 //x2=20.94 //y2=1.585
r687 (  216 255 ) resistor r=5.52526 //w=0.168 //l=0.115 //layer=ply \
 //thickness=0.18 //x=20.605 //y=0.93 //x2=20.49 //y2=0.93
r688 (  215 257 ) resistor r=5.52526 //w=0.168 //l=0.115 //layer=ply \
 //thickness=0.18 //x=20.825 //y=0.93 //x2=20.94 //y2=0.93
r689 (  215 216 ) resistor r=112.809 //w=0.094 //l=0.22 //layer=ply \
 //thickness=0.18 //x=20.825 //y=0.93 //x2=20.605 //y2=0.93
r690 (  214 253 ) resistor r=16.5046 //w=0.27 //l=0.135 //layer=ply \
 //thickness=0.18 //x=20.58 //y=4.97 //x2=20.445 //y2=4.97
r691 (  213 220 ) resistor r=26.9307 //w=0.15 //l=0.106066 //layer=ply \
 //thickness=0.18 //x=20.82 //y=4.97 //x2=20.895 //y2=5.045
r692 (  213 214 ) resistor r=123.064 //w=0.094 //l=0.24 //layer=ply \
 //thickness=0.18 //x=20.82 //y=4.97 //x2=20.58 //y2=4.97
r693 (  208 256 ) resistor r=39.5823 //w=0.21 //l=0.173853 //layer=ply \
 //thickness=0.18 //x=20.45 //y=1.74 //x2=20.49 //y2=1.585
r694 (  208 248 ) resistor r=182.032 //w=0.094 //l=0.355 //layer=ply \
 //thickness=0.18 //x=20.45 //y=1.74 //x2=20.45 //y2=2.095
r695 (  207 256 ) resistor r=39.5823 //w=0.21 //l=0.173853 //layer=ply \
 //thickness=0.18 //x=20.45 //y=1.43 //x2=20.49 //y2=1.585
r696 (  206 255 ) resistor r=45.1352 //w=0.168 //l=0.173853 //layer=ply \
 //thickness=0.18 //x=20.45 //y=1.085 //x2=20.49 //y2=0.93
r697 (  206 207 ) resistor r=176.904 //w=0.094 //l=0.345 //layer=ply \
 //thickness=0.18 //x=20.45 //y=1.085 //x2=20.45 //y2=1.43
r698 (  205 245 ) resistor r=45.1352 //w=0.168 //l=0.173853 //layer=ply \
 //thickness=0.18 //x=10.99 //y=1.43 //x2=10.95 //y2=1.585
r699 (  204 244 ) resistor r=45.1352 //w=0.168 //l=0.173853 //layer=ply \
 //thickness=0.18 //x=10.99 //y=1.085 //x2=10.95 //y2=0.93
r700 (  204 205 ) resistor r=176.904 //w=0.094 //l=0.345 //layer=ply \
 //thickness=0.18 //x=10.99 //y=1.085 //x2=10.99 //y2=1.43
r701 (  199 243 ) resistor r=10.701 //w=0.21 //l=0.115 //layer=ply \
 //thickness=0.18 //x=10.615 //y=1.585 //x2=10.5 //y2=1.585
r702 (  198 245 ) resistor r=5.52526 //w=0.168 //l=0.115 //layer=ply \
 //thickness=0.18 //x=10.835 //y=1.585 //x2=10.95 //y2=1.585
r703 (  197 242 ) resistor r=5.52526 //w=0.168 //l=0.115 //layer=ply \
 //thickness=0.18 //x=10.615 //y=0.93 //x2=10.5 //y2=0.93
r704 (  196 244 ) resistor r=5.52526 //w=0.168 //l=0.115 //layer=ply \
 //thickness=0.18 //x=10.835 //y=0.93 //x2=10.95 //y2=0.93
r705 (  196 197 ) resistor r=112.809 //w=0.094 //l=0.22 //layer=ply \
 //thickness=0.18 //x=10.835 //y=0.93 //x2=10.615 //y2=0.93
r706 (  195 240 ) resistor r=16.5046 //w=0.27 //l=0.135 //layer=ply \
 //thickness=0.18 //x=10.59 //y=4.97 //x2=10.455 //y2=4.97
r707 (  194 201 ) resistor r=26.9307 //w=0.15 //l=0.106066 //layer=ply \
 //thickness=0.18 //x=10.83 //y=4.97 //x2=10.905 //y2=5.045
r708 (  194 195 ) resistor r=123.064 //w=0.094 //l=0.24 //layer=ply \
 //thickness=0.18 //x=10.83 //y=4.97 //x2=10.59 //y2=4.97
r709 (  189 243 ) resistor r=39.5823 //w=0.21 //l=0.173853 //layer=ply \
 //thickness=0.18 //x=10.46 //y=1.74 //x2=10.5 //y2=1.585
r710 (  189 235 ) resistor r=182.032 //w=0.094 //l=0.355 //layer=ply \
 //thickness=0.18 //x=10.46 //y=1.74 //x2=10.46 //y2=2.095
r711 (  188 243 ) resistor r=39.5823 //w=0.21 //l=0.173853 //layer=ply \
 //thickness=0.18 //x=10.46 //y=1.43 //x2=10.5 //y2=1.585
r712 (  187 242 ) resistor r=45.1352 //w=0.168 //l=0.173853 //layer=ply \
 //thickness=0.18 //x=10.46 //y=1.085 //x2=10.5 //y2=0.93
r713 (  187 188 ) resistor r=176.904 //w=0.094 //l=0.345 //layer=ply \
 //thickness=0.18 //x=10.46 //y=1.085 //x2=10.46 //y2=1.43
r714 (  182 184 ) resistor r=26.9307 //w=0.15 //l=0.106066 //layer=ply \
 //thickness=0.18 //x=2.11 //y=4.97 //x2=2.185 //y2=5.045
r715 (  182 183 ) resistor r=148.702 //w=0.094 //l=0.29 //layer=ply \
 //thickness=0.18 //x=2.11 //y=4.97 //x2=1.82 //y2=4.97
r716 (  181 232 ) resistor r=45.1352 //w=0.168 //l=0.173853 //layer=ply \
 //thickness=0.18 //x=1.775 //y=1.4 //x2=1.735 //y2=1.555
r717 (  180 231 ) resistor r=45.1352 //w=0.168 //l=0.173853 //layer=ply \
 //thickness=0.18 //x=1.775 //y=1.055 //x2=1.735 //y2=0.9
r718 (  180 181 ) resistor r=176.904 //w=0.094 //l=0.345 //layer=ply \
 //thickness=0.18 //x=1.775 //y=1.055 //x2=1.775 //y2=1.4
r719 (  177 183 ) resistor r=22.7971 //w=0.269 //l=0.106066 //layer=ply \
 //thickness=0.18 //x=1.745 //y=5.045 //x2=1.82 //y2=4.97
r720 (  177 230 ) resistor r=35.8364 //w=0.269 //l=0.270185 //layer=ply \
 //thickness=0.18 //x=1.745 //y=5.045 //x2=1.545 //y2=4.88
r721 (  175 226 ) resistor r=10.701 //w=0.21 //l=0.115 //layer=ply \
 //thickness=0.18 //x=1.4 //y=1.555 //x2=1.285 //y2=1.555
r722 (  174 232 ) resistor r=5.52526 //w=0.168 //l=0.115 //layer=ply \
 //thickness=0.18 //x=1.62 //y=1.555 //x2=1.735 //y2=1.555
r723 (  173 225 ) resistor r=5.52526 //w=0.168 //l=0.115 //layer=ply \
 //thickness=0.18 //x=1.4 //y=0.9 //x2=1.285 //y2=0.9
r724 (  172 231 ) resistor r=5.52526 //w=0.168 //l=0.115 //layer=ply \
 //thickness=0.18 //x=1.62 //y=0.9 //x2=1.735 //y2=0.9
r725 (  172 173 ) resistor r=112.809 //w=0.094 //l=0.22 //layer=ply \
 //thickness=0.18 //x=1.62 //y=0.9 //x2=1.4 //y2=0.9
r726 (  171 228 ) resistor r=58.7805 //w=0.246 //l=0.373497 //layer=ply \
 //thickness=0.18 //x=1.245 //y=2.095 //x2=1.545 //y2=2.26
r727 (  170 226 ) resistor r=39.5823 //w=0.21 //l=0.173853 //layer=ply \
 //thickness=0.18 //x=1.245 //y=1.71 //x2=1.285 //y2=1.555
r728 (  170 171 ) resistor r=197.415 //w=0.094 //l=0.385 //layer=ply \
 //thickness=0.18 //x=1.245 //y=1.71 //x2=1.245 //y2=2.095
r729 (  169 226 ) resistor r=39.5823 //w=0.21 //l=0.173853 //layer=ply \
 //thickness=0.18 //x=1.245 //y=1.4 //x2=1.285 //y2=1.555
r730 (  168 225 ) resistor r=45.1352 //w=0.168 //l=0.173853 //layer=ply \
 //thickness=0.18 //x=1.245 //y=1.055 //x2=1.285 //y2=0.9
r731 (  168 169 ) resistor r=176.904 //w=0.094 //l=0.345 //layer=ply \
 //thickness=0.18 //x=1.245 //y=1.055 //x2=1.245 //y2=1.4
r732 (  167 220 ) resistor r=592.245 //w=0.094 //l=1.155 //layer=ply \
 //thickness=0.18 //x=20.895 //y=6.2 //x2=20.895 //y2=5.045
r733 (  166 254 ) resistor r=592.245 //w=0.094 //l=1.155 //layer=ply \
 //thickness=0.18 //x=20.455 //y=6.2 //x2=20.455 //y2=5.045
r734 (  165 201 ) resistor r=592.245 //w=0.094 //l=1.155 //layer=ply \
 //thickness=0.18 //x=10.905 //y=6.2 //x2=10.905 //y2=5.045
r735 (  164 241 ) resistor r=592.245 //w=0.094 //l=1.155 //layer=ply \
 //thickness=0.18 //x=10.465 //y=6.2 //x2=10.465 //y2=5.045
r736 (  163 184 ) resistor r=592.245 //w=0.094 //l=1.155 //layer=ply \
 //thickness=0.18 //x=2.185 //y=6.2 //x2=2.185 //y2=5.045
r737 (  162 177 ) resistor r=592.245 //w=0.094 //l=1.155 //layer=ply \
 //thickness=0.18 //x=1.745 //y=6.2 //x2=1.745 //y2=5.045
r738 (  161 217 ) resistor r=56.4043 //w=0.094 //l=0.11 //layer=ply \
 //thickness=0.18 //x=20.715 //y=1.585 //x2=20.825 //y2=1.585
r739 (  161 218 ) resistor r=56.4043 //w=0.094 //l=0.11 //layer=ply \
 //thickness=0.18 //x=20.715 //y=1.585 //x2=20.605 //y2=1.585
r740 (  160 198 ) resistor r=56.4043 //w=0.094 //l=0.11 //layer=ply \
 //thickness=0.18 //x=10.725 //y=1.585 //x2=10.835 //y2=1.585
r741 (  160 199 ) resistor r=56.4043 //w=0.094 //l=0.11 //layer=ply \
 //thickness=0.18 //x=10.725 //y=1.585 //x2=10.615 //y2=1.585
r742 (  159 174 ) resistor r=56.4043 //w=0.094 //l=0.11 //layer=ply \
 //thickness=0.18 //x=1.51 //y=1.555 //x2=1.62 //y2=1.555
r743 (  159 175 ) resistor r=56.4043 //w=0.094 //l=0.11 //layer=ply \
 //thickness=0.18 //x=1.51 //y=1.555 //x2=1.4 //y2=1.555
r744 (  155 251 ) resistor r=152 //w=0.17 //l=0.17 //layer=licon //count=1 \
 //x=20.445 //y=4.88 //x2=20.445 //y2=4.88
r745 (  146 247 ) resistor r=152 //w=0.17 //l=0.17 //layer=licon //count=1 \
 //x=20.415 //y=2.26 //x2=20.415 //y2=2.26
r746 (  129 262 ) resistor r=23.615 //w=0.187 //l=0.345 //layer=li \
 //thickness=0.1 //x=14.015 //y=5.56 //x2=14.015 //y2=5.905
r747 (  121 261 ) resistor r=23.615 //w=0.187 //l=0.345 //layer=li \
 //thickness=0.1 //x=13.135 //y=5.56 //x2=13.135 //y2=5.905
r748 (  116 238 ) resistor r=152 //w=0.17 //l=0.17 //layer=licon //count=1 \
 //x=10.455 //y=4.88 //x2=10.455 //y2=4.88
r749 (  107 234 ) resistor r=152 //w=0.17 //l=0.17 //layer=licon //count=1 \
 //x=10.425 //y=2.26 //x2=10.425 //y2=2.26
r750 (  102 230 ) resistor r=152 //w=0.17 //l=0.17 //layer=licon //count=1 \
 //x=1.545 //y=4.88 //x2=1.545 //y2=4.88
r751 (  93 228 ) resistor r=152 //w=0.17 //l=0.17 //layer=licon //count=1 \
 //x=1.545 //y=2.26 //x2=1.545 //y2=2.26
r752 (  83 85 ) resistor r=0.10734 //w=0.281 //l=0.16 //layer=m2 \
 //thickness=0.36 //x=1.55 //y=4.255 //x2=1.71 //y2=4.255
r753 (  81 89 ) resistor r=1.10585 //w=0.196 //l=1.7325 //layer=m2 \
 //thickness=0.36 //x=16.215 //y=4.27 //x2=14.485 //y2=4.265
r754 (  80 91 ) resistor r=2.64838 //w=0.182 //l=3.86499 //layer=m2 \
 //thickness=0.36 //x=16.56 //y=4.27 //x2=20.415 //y2=4.25
r755 (  80 81 ) resistor r=0.329198 //w=0.131 //l=0.345 //layer=m2 \
 //thickness=0.36 //x=16.56 //y=4.27 //x2=16.215 //y2=4.27
r756 (  79 87 ) resistor r=0.110608 //w=0.182 //l=0.162481 //layer=m2 \
 //thickness=0.36 //x=10.59 //y=4.25 //x2=10.43 //y2=4.255
r757 (  78 89 ) resistor r=0.104578 //w=0.196 //l=0.167332 //layer=m2 \
 //thickness=0.36 //x=14.325 //y=4.25 //x2=14.485 //y2=4.265
r758 (  78 79 ) resistor r=3.56393 //w=0.131 //l=3.735 //layer=m2 \
 //thickness=0.36 //x=14.325 //y=4.25 //x2=10.59 //y2=4.25
r759 (  76 87 ) resistor r=2.65525 //w=0.182 //l=3.87 //layer=m2 \
 //thickness=0.36 //x=6.565 //y=4.265 //x2=10.43 //y2=4.255
r760 (  76 77 ) resistor r=0.329198 //w=0.131 //l=0.345 //layer=m2 \
 //thickness=0.36 //x=6.565 //y=4.265 //x2=6.22 //y2=4.265
r761 (  74 77 ) resistor r=0.1875 //w=0.17 //l=0.262393 //layer=m2 \
 //thickness=0.36 //x=5.965 //y=4.25 //x2=6.22 //y2=4.265
r762 (  74 75 ) resistor r=1.02576 //w=0.131 //l=1.075 //layer=m2 \
 //thickness=0.36 //x=5.965 //y=4.25 //x2=4.89 //y2=4.25
r763 (  72 75 ) resistor r=0.125 //w=0.17 //l=0.177341 //layer=m2 \
 //thickness=0.36 //x=4.72 //y=4.265 //x2=4.89 //y2=4.25
r764 (  72 73 ) resistor r=0.329198 //w=0.131 //l=0.345 //layer=m2 \
 //thickness=0.36 //x=4.72 //y=4.265 //x2=4.375 //y2=4.265
r765 (  70 73 ) resistor r=0.1875 //w=0.17 //l=0.262393 //layer=m2 \
 //thickness=0.36 //x=4.12 //y=4.25 //x2=4.375 //y2=4.265
r766 (  70 85 ) resistor r=2.29962 //w=0.131 //l=2.41 //layer=m2 \
 //thickness=0.36 //x=4.12 //y=4.25 //x2=1.71 //y2=4.25
r767 (  69 155 ) resistor r=9.3 //w=0.17 //l=0.17 //layer=mcon //count=1 \
 //x=20.445 //y=4.88 //x2=20.445 //y2=4.88
r768 (  65 146 ) resistor r=9.3 //w=0.17 //l=0.17 //layer=mcon //count=1 \
 //x=20.415 //y=2.26 //x2=20.415 //y2=2.26
r769 (  65 67 ) resistor r=0.0936408 //w=0.196 //l=0.125 //layer=m1 \
 //thickness=0.36 //x=20.417 //y=2.26 //x2=20.417 //y2=2.385
r770 (  62 91 ) resistor r=4.5 //w=0.15 //l=0.15 //layer=via1 //count=1 \
 //x=20.415 //y=4.25 //x2=20.415 //y2=4.25
r771 (  60 89 ) resistor r=4.5 //w=0.15 //l=0.15 //layer=via1 //count=1 \
 //x=14.485 //y=4.265 //x2=14.485 //y2=4.265
r772 (  58 60 ) resistor r=0.00505391 //w=0.371 //l=0.015 //layer=m1 \
 //thickness=0.36 //x=14.437 //y=4.25 //x2=14.437 //y2=4.265
r773 (  55 259 ) resistor r=9.3 //w=0.17 //l=0.17 //layer=mcon //count=1 \
 //x=14.055 //y=1.18 //x2=14.055 //y2=1.18
r774 (  53 129 ) resistor r=9.3 //w=0.17 //l=0.17 //layer=mcon //count=1 \
 //x=14.015 //y=5.56 //x2=14.015 //y2=5.56
r775 (  50 53 ) resistor r=0.117801 //w=0.191 //l=0.18 //layer=m1 \
 //thickness=0.36 //x=14.015 //y=5.38 //x2=14.015 //y2=5.56
r776 (  49 121 ) resistor r=9.3 //w=0.17 //l=0.17 //layer=mcon //count=1 \
 //x=13.135 //y=5.56 //x2=13.135 //y2=5.56
r777 (  47 49 ) resistor r=0.10274 //w=0.219 //l=0.18 //layer=m1 \
 //thickness=0.36 //x=13.135 //y=5.38 //x2=13.135 //y2=5.56
r778 (  46 116 ) resistor r=9.3 //w=0.17 //l=0.17 //layer=mcon //count=1 \
 //x=10.455 //y=4.88 //x2=10.455 //y2=4.88
r779 (  42 107 ) resistor r=9.3 //w=0.17 //l=0.17 //layer=mcon //count=1 \
 //x=10.425 //y=2.26 //x2=10.425 //y2=2.26
r780 (  42 44 ) resistor r=0.0936408 //w=0.196 //l=0.125 //layer=m1 \
 //thickness=0.36 //x=10.427 //y=2.26 //x2=10.427 //y2=2.385
r781 (  40 87 ) resistor r=4.5 //w=0.15 //l=0.15 //layer=via1 //count=1 \
 //x=10.43 //y=4.255 //x2=10.43 //y2=4.255
r782 (  38 40 ) resistor r=0.00164908 //w=0.379 //l=0.005 //layer=m1 \
 //thickness=0.36 //x=10.375 //y=4.25 //x2=10.375 //y2=4.255
r783 (  36 83 ) resistor r=4.5 //w=0.15 //l=0.15 //layer=via1 //count=1 \
 //x=1.55 //y=4.255 //x2=1.55 //y2=4.255
r784 (  34 36 ) resistor r=0.00167112 //w=0.374 //l=0.005 //layer=m1 \
 //thickness=0.36 //x=1.6 //y=4.25 //x2=1.6 //y2=4.255
r785 (  32 102 ) resistor r=9.3 //w=0.17 //l=0.17 //layer=mcon //count=1 \
 //x=1.545 //y=4.88 //x2=1.545 //y2=4.88
r786 (  30 93 ) resistor r=9.3 //w=0.17 //l=0.17 //layer=mcon //count=1 \
 //x=1.545 //y=2.26 //x2=1.545 //y2=2.26
r787 (  28 69 ) resistor r=0.0878548 //w=0.228 //l=0.159295 //layer=m1 \
 //thickness=0.36 //x=20.415 //y=4.735 //x2=20.445 //y2=4.88
r788 (  27 62 ) resistor r=0.0911593 //w=0.376 //l=0.184608 //layer=m1 \
 //thickness=0.36 //x=20.415 //y=4.41 //x2=20.362 //y2=4.25
r789 (  27 28 ) resistor r=0.310115 //w=0.131 //l=0.325 //layer=m1 \
 //thickness=0.36 //x=20.415 //y=4.41 //x2=20.415 //y2=4.735
r790 (  26 62 ) resistor r=0.0911593 //w=0.376 //l=0.184608 //layer=m1 \
 //thickness=0.36 //x=20.415 //y=4.09 //x2=20.362 //y2=4.25
r791 (  26 67 ) resistor r=1.62691 //w=0.131 //l=1.705 //layer=m1 \
 //thickness=0.36 //x=20.415 //y=4.09 //x2=20.415 //y2=2.385
r792 (  23 60 ) resistor r=0.0909648 //w=0.371 //l=0.186762 //layer=m1 \
 //thickness=0.36 //x=14.495 //y=4.425 //x2=14.437 //y2=4.265
r793 (  23 24 ) resistor r=0.830153 //w=0.131 //l=0.87 //layer=m1 \
 //thickness=0.36 //x=14.495 //y=4.425 //x2=14.495 //y2=5.295
r794 (  22 58 ) resistor r=0.0859108 //w=0.371 //l=0.171566 //layer=m1 \
 //thickness=0.36 //x=14.495 //y=4.105 //x2=14.437 //y2=4.25
r795 (  21 22 ) resistor r=2.08492 //w=0.131 //l=2.185 //layer=m1 \
 //thickness=0.36 //x=14.495 //y=1.92 //x2=14.495 //y2=4.105
r796 (  19 21 ) resistor r=0.0698411 //w=0.17 //l=0.120208 //layer=m1 \
 //thickness=0.36 //x=14.41 //y=1.835 //x2=14.495 //y2=1.92
r797 (  19 20 ) resistor r=0.257634 //w=0.131 //l=0.27 //layer=m1 \
 //thickness=0.36 //x=14.41 //y=1.835 //x2=14.14 //y2=1.835
r798 (  18 50 ) resistor r=0.0257089 //w=0.23 //l=0.115 //layer=m1 \
 //thickness=0.36 //x=14.13 //y=5.38 //x2=14.015 //y2=5.38
r799 (  17 24 ) resistor r=0.0698411 //w=0.17 //l=0.120208 //layer=m1 \
 //thickness=0.36 //x=14.41 //y=5.38 //x2=14.495 //y2=5.295
r800 (  17 18 ) resistor r=0.267176 //w=0.131 //l=0.28 //layer=m1 \
 //thickness=0.36 //x=14.41 //y=5.38 //x2=14.13 //y2=5.38
r801 (  16 20 ) resistor r=0.0698411 //w=0.17 //l=0.120208 //layer=m1 \
 //thickness=0.36 //x=14.055 //y=1.75 //x2=14.14 //y2=1.835
r802 (  15 55 ) resistor r=0.0913624 //w=0.191 //l=0.12 //layer=m1 \
 //thickness=0.36 //x=14.055 //y=1.3 //x2=14.055 //y2=1.18
r803 (  15 16 ) resistor r=0.429389 //w=0.131 //l=0.45 //layer=m1 \
 //thickness=0.36 //x=14.055 //y=1.3 //x2=14.055 //y2=1.75
r804 (  12 47 ) resistor r=0.0227762 //w=0.219 //l=0.115 //layer=m1 \
 //thickness=0.36 //x=13.25 //y=5.38 //x2=13.135 //y2=5.38
r805 (  11 50 ) resistor r=0.0257089 //w=0.23 //l=0.115 //layer=m1 \
 //thickness=0.36 //x=13.9 //y=5.38 //x2=14.015 //y2=5.38
r806 (  11 12 ) resistor r=0.620229 //w=0.131 //l=0.65 //layer=m1 \
 //thickness=0.36 //x=13.9 //y=5.38 //x2=13.25 //y2=5.38
r807 (  8 46 ) resistor r=0.0878548 //w=0.228 //l=0.159295 //layer=m1 \
 //thickness=0.36 //x=10.425 //y=4.735 //x2=10.455 //y2=4.88
r808 (  7 40 ) resistor r=0.0912814 //w=0.379 //l=0.183303 //layer=m1 \
 //thickness=0.36 //x=10.425 //y=4.415 //x2=10.375 //y2=4.255
r809 (  7 8 ) resistor r=0.305344 //w=0.131 //l=0.32 //layer=m1 \
 //thickness=0.36 //x=10.425 //y=4.415 //x2=10.425 //y2=4.735
r810 (  6 38 ) resistor r=0.0896323 //w=0.379 //l=0.178255 //layer=m1 \
 //thickness=0.36 //x=10.425 //y=4.095 //x2=10.375 //y2=4.25
r811 (  6 44 ) resistor r=1.63168 //w=0.131 //l=1.71 //layer=m1 \
 //thickness=0.36 //x=10.425 //y=4.095 //x2=10.425 //y2=2.385
r812 (  4 32 ) resistor r=0.0760407 //w=0.238 //l=0.125 //layer=m1 \
 //thickness=0.36 //x=1.545 //y=4.755 //x2=1.545 //y2=4.88
r813 (  3 36 ) resistor r=0.0910802 //w=0.374 //l=0.185472 //layer=m1 \
 //thickness=0.36 //x=1.545 //y=4.415 //x2=1.6 //y2=4.255
r814 (  3 4 ) resistor r=0.324427 //w=0.131 //l=0.34 //layer=m1 \
 //thickness=0.36 //x=1.545 //y=4.415 //x2=1.545 //y2=4.755
r815 (  2 34 ) resistor r=0.089409 //w=0.374 //l=0.180416 //layer=m1 \
 //thickness=0.36 //x=1.545 //y=4.095 //x2=1.6 //y2=4.25
r816 (  1 30 ) resistor r=0.0719237 //w=0.222 //l=0.115 //layer=m1 \
 //thickness=0.36 //x=1.545 //y=2.375 //x2=1.545 //y2=2.26
r817 (  1 2 ) resistor r=1.64122 //w=0.131 //l=1.72 //layer=m1 \
 //thickness=0.36 //x=1.545 //y=2.375 //x2=1.545 //y2=4.095
ends PM_DFFQX1\%noxref_6

subckt PM_DFFQX1\%Q ( 1 2 3 4 5 6 7 9 10 11 14 19 20 22 23 30 36 44 47 48 51 \
 53 56 58 59 61 66 68 71 80 85 93 109 110 111 112 113 114 119 121 123 129 130 \
 132 133 136 144 146 147 )
c274 ( 144 0 ) capacitor c=0.00878249f //x=20.525 //y=1.085
c275 ( 136 0 ) capacitor c=0.036522f //x=17.115 //y=4.88
c276 ( 133 0 ) capacitor c=0.0284095f //x=17.085 //y=2.095
c277 ( 132 0 ) capacitor c=0.0476356f //x=17.085 //y=2.26
c278 ( 130 0 ) capacitor c=0.0439708f //x=17.65 //y=1.43
c279 ( 129 0 ) capacitor c=0.0192582f //x=17.65 //y=1.085
c280 ( 123 0 ) capacitor c=0.0162526f //x=17.495 //y=1.585
c281 ( 121 0 ) capacitor c=0.0157807f //x=17.495 //y=0.93
c282 ( 119 0 ) capacitor c=0.0359568f //x=17.49 //y=4.97
c283 ( 114 0 ) capacitor c=0.0210762f //x=17.12 //y=1.74
c284 ( 113 0 ) capacitor c=0.0168511f //x=17.12 //y=1.43
c285 ( 112 0 ) capacitor c=0.0175485f //x=17.12 //y=1.085
c286 ( 111 0 ) capacitor c=0.155269f //x=17.565 //y=6.2
c287 ( 110 0 ) capacitor c=0.110375f //x=17.125 //y=6.2
c288 ( 93 0 ) capacitor c=0.0322017f //x=20.675 //y=5.56
c289 ( 85 0 ) capacitor c=0.0290186f //x=19.795 //y=5.56
c290 ( 80 0 ) capacitor c=8.90417e-19 //x=17.115 //y=4.88
c291 ( 71 0 ) capacitor c=5.78095e-19 //x=17.085 //y=2.26
c292 ( 68 0 ) capacitor c=0.0231769f //x=21.15 //y=3.88
c293 ( 66 0 ) capacitor c=0.00315392f //x=17.245 //y=3.865
c294 ( 61 0 ) capacitor c=0.00895766f //x=20.63 //y=3.865
c295 ( 59 0 ) capacitor c=0.0410508f //x=20.03 //y=3.88
c296 ( 56 0 ) capacitor c=0.0181357f //x=21.15 //y=3.88
c297 ( 53 0 ) capacitor c=0.014893f //x=20.715 //y=1.18
c298 ( 51 0 ) capacitor c=5.78613e-19 //x=20.675 //y=5.56
c299 ( 48 0 ) capacitor c=0.014706f //x=20.675 //y=5.38
c300 ( 47 0 ) capacitor c=0.00914412f //x=19.795 //y=5.56
c301 ( 44 0 ) capacitor c=0.0139575f //x=17.085 //y=3.88
c302 ( 36 0 ) capacitor c=0.00650008f //x=17.085 //y=2.26
c303 ( 30 0 ) capacitor c=0.0127067f //x=21.155 //y=4.04
c304 ( 23 0 ) capacitor c=0.00671677f //x=20.8 //y=1.835
c305 ( 22 0 ) capacitor c=0.0151232f //x=21.07 //y=1.835
c306 ( 20 0 ) capacitor c=0.0125833f //x=21.07 //y=5.38
c307 ( 19 0 ) capacitor c=0.0133876f //x=20.715 //y=1.75
c308 ( 14 0 ) capacitor c=0.0136628f //x=20.56 //y=5.38
c309 ( 11 0 ) capacitor c=0.0182022f //x=17.085 //y=4.735
c310 ( 10 0 ) capacitor c=0.00981483f //x=17.085 //y=4.025
c311 ( 9 0 ) capacitor c=0.0307109f //x=17.085 //y=3.705
c312 ( 5 0 ) capacitor c=0.0431604f //x=21.155 //y=4.25
c313 ( 1 0 ) capacitor c=0.0739522f //x=21.155 //y=2.4
r314 (  138 139 ) resistor r=32.4568 //w=0.214 //l=0.075 //layer=ply \
 //thickness=0.18 //x=17.115 //y=4.97 //x2=17.115 //y2=5.045
r315 (  136 138 ) resistor r=20.271 //w=0.214 //l=0.09 //layer=ply \
 //thickness=0.18 //x=17.115 //y=4.88 //x2=17.115 //y2=4.97
r316 (  132 133 ) resistor r=52.7279 //w=0.214 //l=0.165 //layer=ply \
 //thickness=0.18 //x=17.085 //y=2.26 //x2=17.085 //y2=2.095
r317 (  130 143 ) resistor r=45.1352 //w=0.168 //l=0.173853 //layer=ply \
 //thickness=0.18 //x=17.65 //y=1.43 //x2=17.61 //y2=1.585
r318 (  129 142 ) resistor r=45.1352 //w=0.168 //l=0.173853 //layer=ply \
 //thickness=0.18 //x=17.65 //y=1.085 //x2=17.61 //y2=0.93
r319 (  129 130 ) resistor r=176.904 //w=0.094 //l=0.345 //layer=ply \
 //thickness=0.18 //x=17.65 //y=1.085 //x2=17.65 //y2=1.43
r320 (  124 141 ) resistor r=10.701 //w=0.21 //l=0.115 //layer=ply \
 //thickness=0.18 //x=17.275 //y=1.585 //x2=17.16 //y2=1.585
r321 (  123 143 ) resistor r=5.52526 //w=0.168 //l=0.115 //layer=ply \
 //thickness=0.18 //x=17.495 //y=1.585 //x2=17.61 //y2=1.585
r322 (  122 140 ) resistor r=5.52526 //w=0.168 //l=0.115 //layer=ply \
 //thickness=0.18 //x=17.275 //y=0.93 //x2=17.16 //y2=0.93
r323 (  121 142 ) resistor r=5.52526 //w=0.168 //l=0.115 //layer=ply \
 //thickness=0.18 //x=17.495 //y=0.93 //x2=17.61 //y2=0.93
r324 (  121 122 ) resistor r=112.809 //w=0.094 //l=0.22 //layer=ply \
 //thickness=0.18 //x=17.495 //y=0.93 //x2=17.275 //y2=0.93
r325 (  120 138 ) resistor r=16.5046 //w=0.27 //l=0.135 //layer=ply \
 //thickness=0.18 //x=17.25 //y=4.97 //x2=17.115 //y2=4.97
r326 (  119 126 ) resistor r=26.9307 //w=0.15 //l=0.106066 //layer=ply \
 //thickness=0.18 //x=17.49 //y=4.97 //x2=17.565 //y2=5.045
r327 (  119 120 ) resistor r=123.064 //w=0.094 //l=0.24 //layer=ply \
 //thickness=0.18 //x=17.49 //y=4.97 //x2=17.25 //y2=4.97
r328 (  114 141 ) resistor r=39.5823 //w=0.21 //l=0.173853 //layer=ply \
 //thickness=0.18 //x=17.12 //y=1.74 //x2=17.16 //y2=1.585
r329 (  114 133 ) resistor r=182.032 //w=0.094 //l=0.355 //layer=ply \
 //thickness=0.18 //x=17.12 //y=1.74 //x2=17.12 //y2=2.095
r330 (  113 141 ) resistor r=39.5823 //w=0.21 //l=0.173853 //layer=ply \
 //thickness=0.18 //x=17.12 //y=1.43 //x2=17.16 //y2=1.585
r331 (  112 140 ) resistor r=45.1352 //w=0.168 //l=0.173853 //layer=ply \
 //thickness=0.18 //x=17.12 //y=1.085 //x2=17.16 //y2=0.93
r332 (  112 113 ) resistor r=176.904 //w=0.094 //l=0.345 //layer=ply \
 //thickness=0.18 //x=17.12 //y=1.085 //x2=17.12 //y2=1.43
r333 (  111 126 ) resistor r=592.245 //w=0.094 //l=1.155 //layer=ply \
 //thickness=0.18 //x=17.565 //y=6.2 //x2=17.565 //y2=5.045
r334 (  110 139 ) resistor r=592.245 //w=0.094 //l=1.155 //layer=ply \
 //thickness=0.18 //x=17.125 //y=6.2 //x2=17.125 //y2=5.045
r335 (  109 123 ) resistor r=56.4043 //w=0.094 //l=0.11 //layer=ply \
 //thickness=0.18 //x=17.385 //y=1.585 //x2=17.495 //y2=1.585
r336 (  109 124 ) resistor r=56.4043 //w=0.094 //l=0.11 //layer=ply \
 //thickness=0.18 //x=17.385 //y=1.585 //x2=17.275 //y2=1.585
r337 (  93 147 ) resistor r=23.615 //w=0.187 //l=0.345 //layer=li \
 //thickness=0.1 //x=20.675 //y=5.56 //x2=20.675 //y2=5.905
r338 (  85 146 ) resistor r=23.615 //w=0.187 //l=0.345 //layer=li \
 //thickness=0.1 //x=19.795 //y=5.56 //x2=19.795 //y2=5.905
r339 (  80 136 ) resistor r=152 //w=0.17 //l=0.17 //layer=licon //count=1 \
 //x=17.115 //y=4.88 //x2=17.115 //y2=4.88
r340 (  71 132 ) resistor r=152 //w=0.17 //l=0.17 //layer=licon //count=1 \
 //x=17.085 //y=2.26 //x2=17.085 //y2=2.26
r341 (  64 66 ) resistor r=0.10734 //w=0.281 //l=0.16 //layer=m2 \
 //thickness=0.36 //x=17.085 //y=3.865 //x2=17.245 //y2=3.865
r342 (  61 68 ) resistor r=0.280717 //w=0.241 //l=0.527447 //layer=m2 \
 //thickness=0.36 //x=20.63 //y=3.865 //x2=21.15 //y2=3.88
r343 (  61 62 ) resistor r=0.410305 //w=0.131 //l=0.43 //layer=m2 \
 //thickness=0.36 //x=20.63 //y=3.865 //x2=20.2 //y2=3.865
r344 (  59 62 ) resistor r=0.125 //w=0.17 //l=0.177341 //layer=m2 \
 //thickness=0.36 //x=20.03 //y=3.88 //x2=20.2 //y2=3.865
r345 (  59 66 ) resistor r=2.65744 //w=0.131 //l=2.785 //layer=m2 \
 //thickness=0.36 //x=20.03 //y=3.88 //x2=17.245 //y2=3.88
r346 (  58 68 ) resistor r=0.00259336 //w=0.241 //l=0.005 //layer=m2 \
 //thickness=0.36 //x=21.155 //y=3.88 //x2=21.15 //y2=3.88
r347 (  56 68 ) resistor r=4.5 //w=0.15 //l=0.15 //layer=via1 //count=1 \
 //x=21.15 //y=3.88 //x2=21.15 //y2=3.88
r348 (  53 144 ) resistor r=9.3 //w=0.17 //l=0.17 //layer=mcon //count=1 \
 //x=20.715 //y=1.18 //x2=20.715 //y2=1.18
r349 (  51 93 ) resistor r=9.3 //w=0.17 //l=0.17 //layer=mcon //count=1 \
 //x=20.675 //y=5.56 //x2=20.675 //y2=5.56
r350 (  48 51 ) resistor r=0.117801 //w=0.191 //l=0.18 //layer=m1 \
 //thickness=0.36 //x=20.675 //y=5.38 //x2=20.675 //y2=5.56
r351 (  47 85 ) resistor r=9.3 //w=0.17 //l=0.17 //layer=mcon //count=1 \
 //x=19.795 //y=5.56 //x2=19.795 //y2=5.56
r352 (  45 47 ) resistor r=0.10274 //w=0.219 //l=0.18 //layer=m1 \
 //thickness=0.36 //x=19.795 //y=5.38 //x2=19.795 //y2=5.56
r353 (  42 64 ) resistor r=4.5 //w=0.15 //l=0.15 //layer=via1 //count=1 \
 //x=17.085 //y=3.865 //x2=17.085 //y2=3.865
r354 (  42 44 ) resistor r=0.0049867 //w=0.376 //l=0.015 //layer=m1 \
 //thickness=0.36 //x=17.137 //y=3.865 //x2=17.137 //y2=3.88
r355 (  40 80 ) resistor r=9.3 //w=0.17 //l=0.17 //layer=mcon //count=1 \
 //x=17.115 //y=4.88 //x2=17.115 //y2=4.88
r356 (  36 71 ) resistor r=9.3 //w=0.17 //l=0.17 //layer=mcon //count=1 \
 //x=17.085 //y=2.26 //x2=17.085 //y2=2.26
r357 (  36 38 ) resistor r=0.0936408 //w=0.196 //l=0.125 //layer=m1 \
 //thickness=0.36 //x=17.087 //y=2.26 //x2=17.087 //y2=2.385
r358 (  30 56 ) resistor r=0.0910802 //w=0.374 //l=0.185472 //layer=m1 \
 //thickness=0.36 //x=21.155 //y=4.04 //x2=21.1 //y2=3.88
r359 (  25 56 ) resistor r=0.0910802 //w=0.374 //l=0.185472 //layer=m1 \
 //thickness=0.36 //x=21.155 //y=3.72 //x2=21.1 //y2=3.88
r360 (  22 24 ) resistor r=0.0698411 //w=0.17 //l=0.120208 //layer=m1 \
 //thickness=0.36 //x=21.07 //y=1.835 //x2=21.155 //y2=1.92
r361 (  22 23 ) resistor r=0.257634 //w=0.131 //l=0.27 //layer=m1 \
 //thickness=0.36 //x=21.07 //y=1.835 //x2=20.8 //y2=1.835
r362 (  21 48 ) resistor r=0.0257089 //w=0.23 //l=0.115 //layer=m1 \
 //thickness=0.36 //x=20.79 //y=5.38 //x2=20.675 //y2=5.38
r363 (  20 31 ) resistor r=0.0698411 //w=0.17 //l=0.120208 //layer=m1 \
 //thickness=0.36 //x=21.07 //y=5.38 //x2=21.155 //y2=5.295
r364 (  20 21 ) resistor r=0.267176 //w=0.131 //l=0.28 //layer=m1 \
 //thickness=0.36 //x=21.07 //y=5.38 //x2=20.79 //y2=5.38
r365 (  19 23 ) resistor r=0.0698411 //w=0.17 //l=0.120208 //layer=m1 \
 //thickness=0.36 //x=20.715 //y=1.75 //x2=20.8 //y2=1.835
r366 (  18 53 ) resistor r=0.0913624 //w=0.191 //l=0.12 //layer=m1 \
 //thickness=0.36 //x=20.715 //y=1.3 //x2=20.715 //y2=1.18
r367 (  18 19 ) resistor r=0.429389 //w=0.131 //l=0.45 //layer=m1 \
 //thickness=0.36 //x=20.715 //y=1.3 //x2=20.715 //y2=1.75
r368 (  15 45 ) resistor r=0.0227762 //w=0.219 //l=0.115 //layer=m1 \
 //thickness=0.36 //x=19.91 //y=5.38 //x2=19.795 //y2=5.38
r369 (  14 48 ) resistor r=0.0257089 //w=0.23 //l=0.115 //layer=m1 \
 //thickness=0.36 //x=20.56 //y=5.38 //x2=20.675 //y2=5.38
r370 (  14 15 ) resistor r=0.620229 //w=0.131 //l=0.65 //layer=m1 \
 //thickness=0.36 //x=20.56 //y=5.38 //x2=19.91 //y2=5.38
r371 (  11 40 ) resistor r=0.0878548 //w=0.228 //l=0.159295 //layer=m1 \
 //thickness=0.36 //x=17.085 //y=4.735 //x2=17.115 //y2=4.88
r372 (  10 44 ) resistor r=0.0861726 //w=0.376 //l=0.169012 //layer=m1 \
 //thickness=0.36 //x=17.085 //y=4.025 //x2=17.137 //y2=3.88
r373 (  10 11 ) resistor r=0.677481 //w=0.131 //l=0.71 //layer=m1 \
 //thickness=0.36 //x=17.085 //y=4.025 //x2=17.085 //y2=4.735
r374 (  9 42 ) resistor r=0.0911593 //w=0.376 //l=0.184174 //layer=m1 \
 //thickness=0.36 //x=17.085 //y=3.705 //x2=17.137 //y2=3.865
r375 (  9 38 ) resistor r=1.25954 //w=0.131 //l=1.32 //layer=m1 \
 //thickness=0.36 //x=17.085 //y=3.705 //x2=17.085 //y2=2.385
r376 (  7 31 ) resistor r=0.291031 //w=0.131 //l=0.305 //layer=m1 \
 //thickness=0.36 //x=21.155 //y=4.99 //x2=21.155 //y2=5.295
r377 (  6 7 ) resistor r=0.353053 //w=0.131 //l=0.37 //layer=m1 \
 //thickness=0.36 //x=21.155 //y=4.62 //x2=21.155 //y2=4.99
r378 (  5 6 ) resistor r=0.353053 //w=0.131 //l=0.37 //layer=m1 \
 //thickness=0.36 //x=21.155 //y=4.25 //x2=21.155 //y2=4.62
r379 (  5 30 ) resistor r=0.200382 //w=0.131 //l=0.21 //layer=m1 \
 //thickness=0.36 //x=21.155 //y=4.25 //x2=21.155 //y2=4.04
r380 (  4 25 ) resistor r=0.200382 //w=0.131 //l=0.21 //layer=m1 \
 //thickness=0.36 //x=21.155 //y=3.51 //x2=21.155 //y2=3.72
r381 (  3 4 ) resistor r=0.353053 //w=0.131 //l=0.37 //layer=m1 \
 //thickness=0.36 //x=21.155 //y=3.14 //x2=21.155 //y2=3.51
r382 (  2 3 ) resistor r=0.353053 //w=0.131 //l=0.37 //layer=m1 \
 //thickness=0.36 //x=21.155 //y=2.77 //x2=21.155 //y2=3.14
r383 (  1 2 ) resistor r=0.353053 //w=0.131 //l=0.37 //layer=m1 \
 //thickness=0.36 //x=21.155 //y=2.4 //x2=21.155 //y2=2.77
r384 (  1 24 ) resistor r=0.458015 //w=0.131 //l=0.48 //layer=m1 \
 //thickness=0.36 //x=21.155 //y=2.4 //x2=21.155 //y2=1.92
ends PM_DFFQX1\%Q

subckt PM_DFFQX1\%VDD ( 1 39 58 67 77 85 95 111 119 145 155 181 191 213 221 \
 247 257 270 279 284 288 293 298 303 304 305 306 307 308 309 310 311 312 313 \
 314 315 316 317 318 319 320 321 )
c385 ( 321 0 ) capacitor c=0.0393089f //x=20.97 //y=5.2
c386 ( 320 0 ) capacitor c=0.0248174f //x=20.09 //y=5.2
c387 ( 319 0 ) capacitor c=0.0625788f //x=19.22 //y=5.2
c388 ( 318 0 ) capacitor c=0.039544f //x=17.64 //y=5.2
c389 ( 317 0 ) capacitor c=0.0248174f //x=16.76 //y=5.2
c390 ( 316 0 ) capacitor c=0.062487f //x=15.89 //y=5.2
c391 ( 315 0 ) capacitor c=0.0390282f //x=14.31 //y=5.2
c392 ( 314 0 ) capacitor c=0.0248174f //x=13.43 //y=5.2
c393 ( 313 0 ) capacitor c=0.0623361f //x=12.56 //y=5.2
c394 ( 312 0 ) capacitor c=0.039544f //x=10.98 //y=5.2
c395 ( 311 0 ) capacitor c=0.0248174f //x=10.1 //y=5.2
c396 ( 310 0 ) capacitor c=0.0623361f //x=9.23 //y=5.2
c397 ( 309 0 ) capacitor c=0.039544f //x=7.65 //y=5.2
c398 ( 308 0 ) capacitor c=0.0248174f //x=6.77 //y=5.2
c399 ( 307 0 ) capacitor c=0.0627254f //x=5.9 //y=5.2
c400 ( 306 0 ) capacitor c=0.0466891f //x=4.02 //y=5.2
c401 ( 305 0 ) capacitor c=0.0255836f //x=3.14 //y=5.2
c402 ( 304 0 ) capacitor c=0.0256114f //x=2.26 //y=5.2
c403 ( 303 0 ) capacitor c=0.0693239f //x=1.39 //y=5.2
c404 ( 301 0 ) capacitor c=0.00597439f //x=21.115 //y=7.585
c405 ( 300 0 ) capacitor c=0.00597439f //x=20.235 //y=7.585
c406 ( 299 0 ) capacitor c=0.00597439f //x=19.355 //y=7.585
c407 ( 298 0 ) capacitor c=0.127979f //x=18.565 //y=7.585
c408 ( 297 0 ) capacitor c=0.00597439f //x=17.785 //y=7.585
c409 ( 296 0 ) capacitor c=0.00597439f //x=16.905 //y=7.585
c410 ( 295 0 ) capacitor c=0.00597439f //x=15.975 //y=7.58
c411 ( 293 0 ) capacitor c=0.127181f //x=15.235 //y=7.585
c412 ( 292 0 ) capacitor c=0.00597439f //x=14.495 //y=7.58
c413 ( 290 0 ) capacitor c=0.00597439f //x=13.575 //y=7.585
c414 ( 289 0 ) capacitor c=0.00597439f //x=12.695 //y=7.585
c415 ( 288 0 ) capacitor c=0.126609f //x=11.905 //y=7.585
c416 ( 287 0 ) capacitor c=0.00597439f //x=11.125 //y=7.585
c417 ( 286 0 ) capacitor c=0.00597439f //x=10.245 //y=7.585
c418 ( 285 0 ) capacitor c=0.00597439f //x=9.365 //y=7.585
c419 ( 284 0 ) capacitor c=0.126767f //x=8.575 //y=7.585
c420 ( 283 0 ) capacitor c=0.00597439f //x=7.795 //y=7.585
c421 ( 282 0 ) capacitor c=0.00597439f //x=6.915 //y=7.585
c422 ( 281 0 ) capacitor c=0.00597439f //x=5.985 //y=7.58
c423 ( 279 0 ) capacitor c=0.145722f //x=5.245 //y=7.585
c424 ( 278 0 ) capacitor c=0.00597439f //x=4.165 //y=7.585
c425 ( 277 0 ) capacitor c=0.00597439f //x=3.285 //y=7.585
c426 ( 276 0 ) capacitor c=0.00597439f //x=2.405 //y=7.585
c427 ( 275 0 ) capacitor c=0.00597439f //x=1.525 //y=7.585
c428 ( 270 0 ) capacitor c=0.265027f //x=21.525 //y=7.58
c429 ( 257 0 ) capacitor c=0.0287376f //x=21.03 //y=7.585
c430 ( 247 0 ) capacitor c=0.0291078f //x=20.15 //y=7.585
c431 ( 237 0 ) capacitor c=0.0283511f //x=19.27 //y=7.585
c432 ( 231 0 ) capacitor c=0.0277785f //x=18.395 //y=7.585
c433 ( 221 0 ) capacitor c=0.0287375f //x=17.7 //y=7.585
c434 ( 213 0 ) capacitor c=0.0291078f //x=16.82 //y=7.585
c435 ( 203 0 ) capacitor c=0.0283511f //x=15.94 //y=7.585
c436 ( 199 0 ) capacitor c=0.0273918f //x=15.065 //y=7.585
c437 ( 191 0 ) capacitor c=0.0287377f //x=14.37 //y=7.585
c438 ( 181 0 ) capacitor c=0.0291078f //x=13.49 //y=7.585
c439 ( 169 0 ) capacitor c=0.0283511f //x=12.61 //y=7.585
c440 ( 165 0 ) capacitor c=0.0277785f //x=11.735 //y=7.585
c441 ( 155 0 ) capacitor c=0.0287376f //x=11.04 //y=7.585
c442 ( 145 0 ) capacitor c=0.0291078f //x=10.16 //y=7.585
c443 ( 135 0 ) capacitor c=0.0283511f //x=9.28 //y=7.585
c444 ( 129 0 ) capacitor c=0.0277785f //x=8.405 //y=7.585
c445 ( 119 0 ) capacitor c=0.0287375f //x=7.71 //y=7.585
c446 ( 111 0 ) capacitor c=0.0291078f //x=6.83 //y=7.585
c447 ( 101 0 ) capacitor c=0.0283511f //x=5.95 //y=7.585
c448 ( 95 0 ) capacitor c=0.042257f //x=5.075 //y=7.585
c449 ( 85 0 ) capacitor c=0.0288858f //x=4.08 //y=7.585
c450 ( 77 0 ) capacitor c=0.0288441f //x=3.2 //y=7.585
c451 ( 67 0 ) capacitor c=0.0289834f //x=2.32 //y=7.585
c452 ( 58 0 ) capacitor c=0.250322f //x=1.175 //y=7.58
c453 ( 55 0 ) capacitor c=0.0455283f //x=1.44 //y=7.585
c454 ( 39 0 ) capacitor c=0.824307f //x=21.525 //y=7.58
r455 (  268 301 ) resistor r=2.87058 //w=0.35 //l=0.085 //layer=li \
 //thickness=0.1 //x=21.2 //y=7.585 //x2=21.115 //y2=7.585
r456 (  268 270 ) resistor r=11.3351 //w=0.367 //l=0.325 //layer=li \
 //thickness=0.1 //x=21.2 //y=7.585 //x2=21.525 //y2=7.585
r457 (  261 301 ) resistor r=4.23183 //w=0.7 //l=0.175 //layer=li \
 //thickness=0.1 //x=21.115 //y=7.41 //x2=21.115 //y2=7.585
r458 (  261 321 ) resistor r=33.1979 //w=0.187 //l=0.485 //layer=li \
 //thickness=0.1 //x=21.115 //y=7.41 //x2=21.115 //y2=6.925
r459 (  258 300 ) resistor r=2.87058 //w=0.35 //l=0.085 //layer=li \
 //thickness=0.1 //x=20.32 //y=7.585 //x2=20.235 //y2=7.585
r460 (  258 260 ) resistor r=16.218 //w=0.367 //l=0.465 //layer=li \
 //thickness=0.1 //x=20.32 //y=7.585 //x2=20.785 //y2=7.585
r461 (  257 301 ) resistor r=2.87058 //w=0.35 //l=0.085 //layer=li \
 //thickness=0.1 //x=21.03 //y=7.585 //x2=21.115 //y2=7.585
r462 (  257 260 ) resistor r=8.54496 //w=0.367 //l=0.245 //layer=li \
 //thickness=0.1 //x=21.03 //y=7.585 //x2=20.785 //y2=7.585
r463 (  251 300 ) resistor r=4.23183 //w=0.7 //l=0.175 //layer=li \
 //thickness=0.1 //x=20.235 //y=7.41 //x2=20.235 //y2=7.585
r464 (  251 320 ) resistor r=33.1979 //w=0.187 //l=0.485 //layer=li \
 //thickness=0.1 //x=20.235 //y=7.41 //x2=20.235 //y2=6.925
r465 (  248 299 ) resistor r=2.87058 //w=0.35 //l=0.085 //layer=li \
 //thickness=0.1 //x=19.44 //y=7.585 //x2=19.355 //y2=7.585
r466 (  248 250 ) resistor r=8.19619 //w=0.367 //l=0.235 //layer=li \
 //thickness=0.1 //x=19.44 //y=7.585 //x2=19.675 //y2=7.585
r467 (  247 300 ) resistor r=2.87058 //w=0.35 //l=0.085 //layer=li \
 //thickness=0.1 //x=20.15 //y=7.585 //x2=20.235 //y2=7.585
r468 (  247 250 ) resistor r=16.5668 //w=0.367 //l=0.475 //layer=li \
 //thickness=0.1 //x=20.15 //y=7.585 //x2=19.675 //y2=7.585
r469 (  239 299 ) resistor r=4.23183 //w=0.7 //l=0.175 //layer=li \
 //thickness=0.1 //x=19.355 //y=7.41 //x2=19.355 //y2=7.585
r470 (  239 319 ) resistor r=56.4706 //w=0.187 //l=0.825 //layer=li \
 //thickness=0.1 //x=19.355 //y=7.41 //x2=19.355 //y2=6.585
r471 (  238 298 ) resistor r=5.29055 //w=0.35 //l=0.17 //layer=li \
 //thickness=0.1 //x=18.735 //y=7.585 //x2=18.565 //y2=7.585
r472 (  237 299 ) resistor r=2.87058 //w=0.35 //l=0.085 //layer=li \
 //thickness=0.1 //x=19.27 //y=7.585 //x2=19.355 //y2=7.585
r473 (  237 238 ) resistor r=18.6594 //w=0.367 //l=0.535 //layer=li \
 //thickness=0.1 //x=19.27 //y=7.585 //x2=18.735 //y2=7.585
r474 (  232 297 ) resistor r=2.87058 //w=0.35 //l=0.085 //layer=li \
 //thickness=0.1 //x=17.87 //y=7.585 //x2=17.785 //y2=7.585
r475 (  232 234 ) resistor r=11.3351 //w=0.367 //l=0.325 //layer=li \
 //thickness=0.1 //x=17.87 //y=7.585 //x2=18.195 //y2=7.585
r476 (  231 298 ) resistor r=5.29055 //w=0.35 //l=0.17 //layer=li \
 //thickness=0.1 //x=18.395 //y=7.585 //x2=18.565 //y2=7.585
r477 (  231 234 ) resistor r=6.97548 //w=0.367 //l=0.2 //layer=li \
 //thickness=0.1 //x=18.395 //y=7.585 //x2=18.195 //y2=7.585
r478 (  225 297 ) resistor r=4.23183 //w=0.7 //l=0.175 //layer=li \
 //thickness=0.1 //x=17.785 //y=7.41 //x2=17.785 //y2=7.585
r479 (  225 318 ) resistor r=33.1979 //w=0.187 //l=0.485 //layer=li \
 //thickness=0.1 //x=17.785 //y=7.41 //x2=17.785 //y2=6.925
r480 (  222 296 ) resistor r=2.87058 //w=0.35 //l=0.085 //layer=li \
 //thickness=0.1 //x=16.99 //y=7.585 //x2=16.905 //y2=7.585
r481 (  222 224 ) resistor r=3.31335 //w=0.367 //l=0.095 //layer=li \
 //thickness=0.1 //x=16.99 //y=7.585 //x2=17.085 //y2=7.585
r482 (  221 297 ) resistor r=2.87058 //w=0.35 //l=0.085 //layer=li \
 //thickness=0.1 //x=17.7 //y=7.585 //x2=17.785 //y2=7.585
r483 (  221 224 ) resistor r=21.4496 //w=0.367 //l=0.615 //layer=li \
 //thickness=0.1 //x=17.7 //y=7.585 //x2=17.085 //y2=7.585
r484 (  215 296 ) resistor r=4.23183 //w=0.7 //l=0.175 //layer=li \
 //thickness=0.1 //x=16.905 //y=7.41 //x2=16.905 //y2=7.585
r485 (  215 317 ) resistor r=33.1979 //w=0.187 //l=0.485 //layer=li \
 //thickness=0.1 //x=16.905 //y=7.41 //x2=16.905 //y2=6.925
r486 (  214 295 ) resistor r=2.87058 //w=0.35 //l=0.085 //layer=li \
 //thickness=0.1 //x=16.11 //y=7.585 //x2=16.025 //y2=7.585
r487 (  213 296 ) resistor r=2.87058 //w=0.35 //l=0.085 //layer=li \
 //thickness=0.1 //x=16.82 //y=7.585 //x2=16.905 //y2=7.585
r488 (  213 214 ) resistor r=24.7629 //w=0.367 //l=0.71 //layer=li \
 //thickness=0.1 //x=16.82 //y=7.585 //x2=16.11 //y2=7.585
r489 (  205 295 ) resistor r=4.23183 //w=0.7 //l=0.175 //layer=li \
 //thickness=0.1 //x=16.025 //y=7.41 //x2=16.025 //y2=7.585
r490 (  205 316 ) resistor r=56.4706 //w=0.187 //l=0.825 //layer=li \
 //thickness=0.1 //x=16.025 //y=7.41 //x2=16.025 //y2=6.585
r491 (  204 293 ) resistor r=5.29055 //w=0.35 //l=0.17 //layer=li \
 //thickness=0.1 //x=15.405 //y=7.585 //x2=15.235 //y2=7.585
r492 (  203 295 ) resistor r=2.87058 //w=0.35 //l=0.085 //layer=li \
 //thickness=0.1 //x=15.94 //y=7.585 //x2=16.025 //y2=7.585
r493 (  203 204 ) resistor r=18.6594 //w=0.367 //l=0.535 //layer=li \
 //thickness=0.1 //x=15.94 //y=7.585 //x2=15.405 //y2=7.585
r494 (  200 292 ) resistor r=2.87058 //w=0.35 //l=0.085 //layer=li \
 //thickness=0.1 //x=14.54 //y=7.585 //x2=14.455 //y2=7.585
r495 (  199 293 ) resistor r=5.29055 //w=0.35 //l=0.17 //layer=li \
 //thickness=0.1 //x=15.065 //y=7.585 //x2=15.235 //y2=7.585
r496 (  199 200 ) resistor r=18.3106 //w=0.367 //l=0.525 //layer=li \
 //thickness=0.1 //x=15.065 //y=7.585 //x2=14.54 //y2=7.585
r497 (  193 292 ) resistor r=4.23183 //w=0.7 //l=0.175 //layer=li \
 //thickness=0.1 //x=14.455 //y=7.41 //x2=14.455 //y2=7.585
r498 (  193 315 ) resistor r=33.1979 //w=0.187 //l=0.485 //layer=li \
 //thickness=0.1 //x=14.455 //y=7.41 //x2=14.455 //y2=6.925
r499 (  192 290 ) resistor r=2.87058 //w=0.35 //l=0.085 //layer=li \
 //thickness=0.1 //x=13.66 //y=7.585 //x2=13.575 //y2=7.585
r500 (  191 292 ) resistor r=2.87058 //w=0.35 //l=0.085 //layer=li \
 //thickness=0.1 //x=14.37 //y=7.585 //x2=14.455 //y2=7.585
r501 (  191 192 ) resistor r=24.7629 //w=0.367 //l=0.71 //layer=li \
 //thickness=0.1 //x=14.37 //y=7.585 //x2=13.66 //y2=7.585
r502 (  185 290 ) resistor r=4.23183 //w=0.7 //l=0.175 //layer=li \
 //thickness=0.1 //x=13.575 //y=7.41 //x2=13.575 //y2=7.585
r503 (  185 314 ) resistor r=33.1979 //w=0.187 //l=0.485 //layer=li \
 //thickness=0.1 //x=13.575 //y=7.41 //x2=13.575 //y2=6.925
r504 (  182 289 ) resistor r=2.87058 //w=0.35 //l=0.085 //layer=li \
 //thickness=0.1 //x=12.78 //y=7.585 //x2=12.695 //y2=7.585
r505 (  182 184 ) resistor r=21.1008 //w=0.367 //l=0.605 //layer=li \
 //thickness=0.1 //x=12.78 //y=7.585 //x2=13.385 //y2=7.585
r506 (  181 290 ) resistor r=2.87058 //w=0.35 //l=0.085 //layer=li \
 //thickness=0.1 //x=13.49 //y=7.585 //x2=13.575 //y2=7.585
r507 (  181 184 ) resistor r=3.66213 //w=0.367 //l=0.105 //layer=li \
 //thickness=0.1 //x=13.49 //y=7.585 //x2=13.385 //y2=7.585
r508 (  173 289 ) resistor r=4.23183 //w=0.7 //l=0.175 //layer=li \
 //thickness=0.1 //x=12.695 //y=7.41 //x2=12.695 //y2=7.585
r509 (  173 313 ) resistor r=56.4706 //w=0.187 //l=0.825 //layer=li \
 //thickness=0.1 //x=12.695 //y=7.41 //x2=12.695 //y2=6.585
r510 (  170 288 ) resistor r=5.29055 //w=0.35 //l=0.17 //layer=li \
 //thickness=0.1 //x=12.075 //y=7.585 //x2=11.905 //y2=7.585
r511 (  170 172 ) resistor r=6.97548 //w=0.367 //l=0.2 //layer=li \
 //thickness=0.1 //x=12.075 //y=7.585 //x2=12.275 //y2=7.585
r512 (  169 289 ) resistor r=2.87058 //w=0.35 //l=0.085 //layer=li \
 //thickness=0.1 //x=12.61 //y=7.585 //x2=12.695 //y2=7.585
r513 (  169 172 ) resistor r=11.6839 //w=0.367 //l=0.335 //layer=li \
 //thickness=0.1 //x=12.61 //y=7.585 //x2=12.275 //y2=7.585
r514 (  166 287 ) resistor r=2.87058 //w=0.35 //l=0.085 //layer=li \
 //thickness=0.1 //x=11.21 //y=7.585 //x2=11.125 //y2=7.585
r515 (  165 288 ) resistor r=5.29055 //w=0.35 //l=0.17 //layer=li \
 //thickness=0.1 //x=11.735 //y=7.585 //x2=11.905 //y2=7.585
r516 (  165 166 ) resistor r=18.3106 //w=0.367 //l=0.525 //layer=li \
 //thickness=0.1 //x=11.735 //y=7.585 //x2=11.21 //y2=7.585
r517 (  159 287 ) resistor r=4.23183 //w=0.7 //l=0.175 //layer=li \
 //thickness=0.1 //x=11.125 //y=7.41 //x2=11.125 //y2=7.585
r518 (  159 312 ) resistor r=33.1979 //w=0.187 //l=0.485 //layer=li \
 //thickness=0.1 //x=11.125 //y=7.41 //x2=11.125 //y2=6.925
r519 (  156 286 ) resistor r=2.87058 //w=0.35 //l=0.085 //layer=li \
 //thickness=0.1 //x=10.33 //y=7.585 //x2=10.245 //y2=7.585
r520 (  156 158 ) resistor r=16.218 //w=0.367 //l=0.465 //layer=li \
 //thickness=0.1 //x=10.33 //y=7.585 //x2=10.795 //y2=7.585
r521 (  155 287 ) resistor r=2.87058 //w=0.35 //l=0.085 //layer=li \
 //thickness=0.1 //x=11.04 //y=7.585 //x2=11.125 //y2=7.585
r522 (  155 158 ) resistor r=8.54496 //w=0.367 //l=0.245 //layer=li \
 //thickness=0.1 //x=11.04 //y=7.585 //x2=10.795 //y2=7.585
r523 (  149 286 ) resistor r=4.23183 //w=0.7 //l=0.175 //layer=li \
 //thickness=0.1 //x=10.245 //y=7.41 //x2=10.245 //y2=7.585
r524 (  149 311 ) resistor r=33.1979 //w=0.187 //l=0.485 //layer=li \
 //thickness=0.1 //x=10.245 //y=7.41 //x2=10.245 //y2=6.925
r525 (  146 285 ) resistor r=2.87058 //w=0.35 //l=0.085 //layer=li \
 //thickness=0.1 //x=9.45 //y=7.585 //x2=9.365 //y2=7.585
r526 (  146 148 ) resistor r=8.19619 //w=0.367 //l=0.235 //layer=li \
 //thickness=0.1 //x=9.45 //y=7.585 //x2=9.685 //y2=7.585
r527 (  145 286 ) resistor r=2.87058 //w=0.35 //l=0.085 //layer=li \
 //thickness=0.1 //x=10.16 //y=7.585 //x2=10.245 //y2=7.585
r528 (  145 148 ) resistor r=16.5668 //w=0.367 //l=0.475 //layer=li \
 //thickness=0.1 //x=10.16 //y=7.585 //x2=9.685 //y2=7.585
r529 (  137 285 ) resistor r=4.23183 //w=0.7 //l=0.175 //layer=li \
 //thickness=0.1 //x=9.365 //y=7.41 //x2=9.365 //y2=7.585
r530 (  137 310 ) resistor r=56.4706 //w=0.187 //l=0.825 //layer=li \
 //thickness=0.1 //x=9.365 //y=7.41 //x2=9.365 //y2=6.585
r531 (  136 284 ) resistor r=5.29055 //w=0.35 //l=0.17 //layer=li \
 //thickness=0.1 //x=8.745 //y=7.585 //x2=8.575 //y2=7.585
r532 (  135 285 ) resistor r=2.87058 //w=0.35 //l=0.085 //layer=li \
 //thickness=0.1 //x=9.28 //y=7.585 //x2=9.365 //y2=7.585
r533 (  135 136 ) resistor r=18.6594 //w=0.367 //l=0.535 //layer=li \
 //thickness=0.1 //x=9.28 //y=7.585 //x2=8.745 //y2=7.585
r534 (  130 283 ) resistor r=2.87058 //w=0.35 //l=0.085 //layer=li \
 //thickness=0.1 //x=7.88 //y=7.585 //x2=7.795 //y2=7.585
r535 (  130 132 ) resistor r=11.3351 //w=0.367 //l=0.325 //layer=li \
 //thickness=0.1 //x=7.88 //y=7.585 //x2=8.205 //y2=7.585
r536 (  129 284 ) resistor r=5.29055 //w=0.35 //l=0.17 //layer=li \
 //thickness=0.1 //x=8.405 //y=7.585 //x2=8.575 //y2=7.585
r537 (  129 132 ) resistor r=6.97548 //w=0.367 //l=0.2 //layer=li \
 //thickness=0.1 //x=8.405 //y=7.585 //x2=8.205 //y2=7.585
r538 (  123 283 ) resistor r=4.23183 //w=0.7 //l=0.175 //layer=li \
 //thickness=0.1 //x=7.795 //y=7.41 //x2=7.795 //y2=7.585
r539 (  123 309 ) resistor r=33.1979 //w=0.187 //l=0.485 //layer=li \
 //thickness=0.1 //x=7.795 //y=7.41 //x2=7.795 //y2=6.925
r540 (  120 282 ) resistor r=2.87058 //w=0.35 //l=0.085 //layer=li \
 //thickness=0.1 //x=7 //y=7.585 //x2=6.915 //y2=7.585
r541 (  120 122 ) resistor r=3.31335 //w=0.367 //l=0.095 //layer=li \
 //thickness=0.1 //x=7 //y=7.585 //x2=7.095 //y2=7.585
r542 (  119 283 ) resistor r=2.87058 //w=0.35 //l=0.085 //layer=li \
 //thickness=0.1 //x=7.71 //y=7.585 //x2=7.795 //y2=7.585
r543 (  119 122 ) resistor r=21.4496 //w=0.367 //l=0.615 //layer=li \
 //thickness=0.1 //x=7.71 //y=7.585 //x2=7.095 //y2=7.585
r544 (  113 282 ) resistor r=4.23183 //w=0.7 //l=0.175 //layer=li \
 //thickness=0.1 //x=6.915 //y=7.41 //x2=6.915 //y2=7.585
r545 (  113 308 ) resistor r=33.1979 //w=0.187 //l=0.485 //layer=li \
 //thickness=0.1 //x=6.915 //y=7.41 //x2=6.915 //y2=6.925
r546 (  112 281 ) resistor r=2.87058 //w=0.35 //l=0.085 //layer=li \
 //thickness=0.1 //x=6.12 //y=7.585 //x2=6.035 //y2=7.585
r547 (  111 282 ) resistor r=2.87058 //w=0.35 //l=0.085 //layer=li \
 //thickness=0.1 //x=6.83 //y=7.585 //x2=6.915 //y2=7.585
r548 (  111 112 ) resistor r=24.7629 //w=0.367 //l=0.71 //layer=li \
 //thickness=0.1 //x=6.83 //y=7.585 //x2=6.12 //y2=7.585
r549 (  103 281 ) resistor r=4.23183 //w=0.7 //l=0.175 //layer=li \
 //thickness=0.1 //x=6.035 //y=7.41 //x2=6.035 //y2=7.585
r550 (  103 307 ) resistor r=56.4706 //w=0.187 //l=0.825 //layer=li \
 //thickness=0.1 //x=6.035 //y=7.41 //x2=6.035 //y2=6.585
r551 (  102 279 ) resistor r=5.29055 //w=0.35 //l=0.17 //layer=li \
 //thickness=0.1 //x=5.415 //y=7.585 //x2=5.245 //y2=7.585
r552 (  101 281 ) resistor r=2.87058 //w=0.35 //l=0.085 //layer=li \
 //thickness=0.1 //x=5.95 //y=7.585 //x2=6.035 //y2=7.585
r553 (  101 102 ) resistor r=18.6594 //w=0.367 //l=0.535 //layer=li \
 //thickness=0.1 //x=5.95 //y=7.585 //x2=5.415 //y2=7.585
r554 (  96 278 ) resistor r=2.87058 //w=0.35 //l=0.085 //layer=li \
 //thickness=0.1 //x=4.25 //y=7.585 //x2=4.165 //y2=7.585
r555 (  96 98 ) resistor r=8.89373 //w=0.367 //l=0.255 //layer=li \
 //thickness=0.1 //x=4.25 //y=7.585 //x2=4.505 //y2=7.585
r556 (  95 279 ) resistor r=5.29055 //w=0.35 //l=0.17 //layer=li \
 //thickness=0.1 //x=5.075 //y=7.585 //x2=5.245 //y2=7.585
r557 (  95 98 ) resistor r=19.8801 //w=0.367 //l=0.57 //layer=li \
 //thickness=0.1 //x=5.075 //y=7.585 //x2=4.505 //y2=7.585
r558 (  89 278 ) resistor r=4.23183 //w=0.7 //l=0.175 //layer=li \
 //thickness=0.1 //x=4.165 //y=7.41 //x2=4.165 //y2=7.585
r559 (  89 306 ) resistor r=33.1979 //w=0.187 //l=0.485 //layer=li \
 //thickness=0.1 //x=4.165 //y=7.41 //x2=4.165 //y2=6.925
r560 (  86 277 ) resistor r=2.87058 //w=0.35 //l=0.085 //layer=li \
 //thickness=0.1 //x=3.37 //y=7.585 //x2=3.285 //y2=7.585
r561 (  86 88 ) resistor r=0.871935 //w=0.367 //l=0.025 //layer=li \
 //thickness=0.1 //x=3.37 //y=7.585 //x2=3.395 //y2=7.585
r562 (  85 278 ) resistor r=2.87058 //w=0.35 //l=0.085 //layer=li \
 //thickness=0.1 //x=4.08 //y=7.585 //x2=4.165 //y2=7.585
r563 (  85 88 ) resistor r=23.891 //w=0.367 //l=0.685 //layer=li \
 //thickness=0.1 //x=4.08 //y=7.585 //x2=3.395 //y2=7.585
r564 (  79 277 ) resistor r=4.23183 //w=0.7 //l=0.175 //layer=li \
 //thickness=0.1 //x=3.285 //y=7.41 //x2=3.285 //y2=7.585
r565 (  79 305 ) resistor r=33.1979 //w=0.187 //l=0.485 //layer=li \
 //thickness=0.1 //x=3.285 //y=7.41 //x2=3.285 //y2=6.925
r566 (  78 276 ) resistor r=2.87058 //w=0.35 //l=0.085 //layer=li \
 //thickness=0.1 //x=2.49 //y=7.585 //x2=2.405 //y2=7.585
r567 (  77 277 ) resistor r=2.87058 //w=0.35 //l=0.085 //layer=li \
 //thickness=0.1 //x=3.2 //y=7.585 //x2=3.285 //y2=7.585
r568 (  77 78 ) resistor r=24.7629 //w=0.367 //l=0.71 //layer=li \
 //thickness=0.1 //x=3.2 //y=7.585 //x2=2.49 //y2=7.585
r569 (  71 276 ) resistor r=4.23183 //w=0.7 //l=0.175 //layer=li \
 //thickness=0.1 //x=2.405 //y=7.41 //x2=2.405 //y2=7.585
r570 (  71 304 ) resistor r=33.1979 //w=0.187 //l=0.485 //layer=li \
 //thickness=0.1 //x=2.405 //y=7.41 //x2=2.405 //y2=6.925
r571 (  68 275 ) resistor r=2.87058 //w=0.35 //l=0.085 //layer=li \
 //thickness=0.1 //x=1.61 //y=7.585 //x2=1.525 //y2=7.585
r572 (  68 70 ) resistor r=23.5422 //w=0.367 //l=0.675 //layer=li \
 //thickness=0.1 //x=1.61 //y=7.585 //x2=2.285 //y2=7.585
r573 (  67 276 ) resistor r=2.87058 //w=0.35 //l=0.085 //layer=li \
 //thickness=0.1 //x=2.32 //y=7.585 //x2=2.405 //y2=7.585
r574 (  67 70 ) resistor r=1.22071 //w=0.367 //l=0.035 //layer=li \
 //thickness=0.1 //x=2.32 //y=7.585 //x2=2.285 //y2=7.585
r575 (  59 275 ) resistor r=4.23183 //w=0.7 //l=0.175 //layer=li \
 //thickness=0.1 //x=1.525 //y=7.41 //x2=1.525 //y2=7.585
r576 (  59 303 ) resistor r=56.4706 //w=0.187 //l=0.825 //layer=li \
 //thickness=0.1 //x=1.525 //y=7.41 //x2=1.525 //y2=6.585
r577 (  55 275 ) resistor r=2.87058 //w=0.35 //l=0.085 //layer=li \
 //thickness=0.1 //x=1.44 //y=7.585 //x2=1.525 //y2=7.585
r578 (  55 58 ) resistor r=9.24251 //w=0.367 //l=0.265 //layer=li \
 //thickness=0.1 //x=1.44 //y=7.585 //x2=1.175 //y2=7.585
r579 (  39 270 ) resistor r=9.3 //w=0.17 //l=0.17 //layer=mcon //count=1 \
 //x=21.525 //y=7.58 //x2=21.525 //y2=7.58
r580 (  37 260 ) resistor r=3.1 //w=0.17 //l=0.51 //layer=mcon //count=3 \
 //x=20.785 //y=7.58 //x2=20.785 //y2=7.58
r581 (  37 39 ) resistor r=0.297428 //w=0.311 //l=0.74 //layer=m1 \
 //thickness=0.36 //x=20.785 //y=7.585 //x2=21.525 //y2=7.585
r582 (  35 250 ) resistor r=3.1 //w=0.17 //l=0.51 //layer=mcon //count=3 \
 //x=19.675 //y=7.58 //x2=19.675 //y2=7.58
r583 (  35 37 ) resistor r=0.446141 //w=0.311 //l=1.11 //layer=m1 \
 //thickness=0.36 //x=19.675 //y=7.585 //x2=20.785 //y2=7.585
r584 (  33 234 ) resistor r=3.1 //w=0.17 //l=0.51 //layer=mcon //count=3 \
 //x=18.195 //y=7.58 //x2=18.195 //y2=7.58
r585 (  33 35 ) resistor r=0.594855 //w=0.311 //l=1.48 //layer=m1 \
 //thickness=0.36 //x=18.195 //y=7.585 //x2=19.675 //y2=7.585
r586 (  31 224 ) resistor r=3.1 //w=0.17 //l=0.51 //layer=mcon //count=3 \
 //x=17.085 //y=7.58 //x2=17.085 //y2=7.58
r587 (  31 33 ) resistor r=0.446141 //w=0.311 //l=1.11 //layer=m1 \
 //thickness=0.36 //x=17.085 //y=7.585 //x2=18.195 //y2=7.585
r588 (  29 295 ) resistor r=3.1 //w=0.17 //l=0.51 //layer=mcon //count=3 \
 //x=15.975 //y=7.58 //x2=15.975 //y2=7.58
r589 (  29 31 ) resistor r=0.446141 //w=0.311 //l=1.11 //layer=m1 \
 //thickness=0.36 //x=15.975 //y=7.585 //x2=17.085 //y2=7.585
r590 (  27 292 ) resistor r=3.1 //w=0.17 //l=0.51 //layer=mcon //count=3 \
 //x=14.495 //y=7.58 //x2=14.495 //y2=7.58
r591 (  27 29 ) resistor r=0.594855 //w=0.311 //l=1.48 //layer=m1 \
 //thickness=0.36 //x=14.495 //y=7.585 //x2=15.975 //y2=7.585
r592 (  25 184 ) resistor r=3.1 //w=0.17 //l=0.51 //layer=mcon //count=3 \
 //x=13.385 //y=7.58 //x2=13.385 //y2=7.58
r593 (  25 27 ) resistor r=0.446141 //w=0.311 //l=1.11 //layer=m1 \
 //thickness=0.36 //x=13.385 //y=7.585 //x2=14.495 //y2=7.585
r594 (  23 172 ) resistor r=3.1 //w=0.17 //l=0.51 //layer=mcon //count=3 \
 //x=12.275 //y=7.58 //x2=12.275 //y2=7.58
r595 (  23 25 ) resistor r=0.446141 //w=0.311 //l=1.11 //layer=m1 \
 //thickness=0.36 //x=12.275 //y=7.585 //x2=13.385 //y2=7.585
r596 (  20 158 ) resistor r=3.1 //w=0.17 //l=0.51 //layer=mcon //count=3 \
 //x=10.795 //y=7.58 //x2=10.795 //y2=7.58
r597 (  18 148 ) resistor r=3.1 //w=0.17 //l=0.51 //layer=mcon //count=3 \
 //x=9.685 //y=7.58 //x2=9.685 //y2=7.58
r598 (  18 20 ) resistor r=0.446141 //w=0.311 //l=1.11 //layer=m1 \
 //thickness=0.36 //x=9.685 //y=7.585 //x2=10.795 //y2=7.585
r599 (  16 132 ) resistor r=3.1 //w=0.17 //l=0.51 //layer=mcon //count=3 \
 //x=8.205 //y=7.58 //x2=8.205 //y2=7.58
r600 (  16 18 ) resistor r=0.594855 //w=0.311 //l=1.48 //layer=m1 \
 //thickness=0.36 //x=8.205 //y=7.585 //x2=9.685 //y2=7.585
r601 (  14 122 ) resistor r=3.1 //w=0.17 //l=0.51 //layer=mcon //count=3 \
 //x=7.095 //y=7.58 //x2=7.095 //y2=7.58
r602 (  14 16 ) resistor r=0.446141 //w=0.311 //l=1.11 //layer=m1 \
 //thickness=0.36 //x=7.095 //y=7.585 //x2=8.205 //y2=7.585
r603 (  12 281 ) resistor r=3.1 //w=0.17 //l=0.51 //layer=mcon //count=3 \
 //x=5.985 //y=7.58 //x2=5.985 //y2=7.58
r604 (  12 14 ) resistor r=0.446141 //w=0.311 //l=1.11 //layer=m1 \
 //thickness=0.36 //x=5.985 //y=7.585 //x2=7.095 //y2=7.585
r605 (  10 98 ) resistor r=3.1 //w=0.17 //l=0.51 //layer=mcon //count=3 \
 //x=4.505 //y=7.58 //x2=4.505 //y2=7.58
r606 (  10 12 ) resistor r=0.594855 //w=0.311 //l=1.48 //layer=m1 \
 //thickness=0.36 //x=4.505 //y=7.585 //x2=5.985 //y2=7.585
r607 (  8 88 ) resistor r=3.1 //w=0.17 //l=0.51 //layer=mcon //count=3 \
 //x=3.395 //y=7.58 //x2=3.395 //y2=7.58
r608 (  8 10 ) resistor r=0.446141 //w=0.311 //l=1.11 //layer=m1 \
 //thickness=0.36 //x=3.395 //y=7.585 //x2=4.505 //y2=7.585
r609 (  6 70 ) resistor r=3.1 //w=0.17 //l=0.51 //layer=mcon //count=3 \
 //x=2.285 //y=7.58 //x2=2.285 //y2=7.58
r610 (  6 8 ) resistor r=0.446141 //w=0.311 //l=1.11 //layer=m1 \
 //thickness=0.36 //x=2.285 //y=7.585 //x2=3.395 //y2=7.585
r611 (  3 58 ) resistor r=3.1 //w=0.17 //l=0.51 //layer=mcon //count=3 \
 //x=1.175 //y=7.58 //x2=1.175 //y2=7.58
r612 (  3 6 ) resistor r=0.446141 //w=0.311 //l=1.11 //layer=m1 \
 //thickness=0.36 //x=1.175 //y=7.585 //x2=2.285 //y2=7.585
r613 (  1 23 ) resistor r=0.424035 //w=0.311 //l=1.055 //layer=m1 \
 //thickness=0.36 //x=11.22 //y=7.585 //x2=12.275 //y2=7.585
r614 (  1 20 ) resistor r=0.17082 //w=0.311 //l=0.425 //layer=m1 \
 //thickness=0.36 //x=11.22 //y=7.585 //x2=10.795 //y2=7.585
ends PM_DFFQX1\%VDD

subckt PM_DFFQX1\%noxref_9 ( 5 7 15 19 30 33 34 )
c64 ( 34 0 ) capacitor c=0.0486635f //x=3.4 //y=0.555
c65 ( 33 0 ) capacitor c=0.0198746f //x=2.295 //y=1.09
c66 ( 30 0 ) capacitor c=0.00141302f //x=3.535 //y=1.175
c67 ( 19 0 ) capacitor c=0.00695768f //x=4.505 //y=0.805
c68 ( 15 0 ) capacitor c=0.0154966f //x=4.42 //y=0.72
c69 ( 7 0 ) capacitor c=0.00689476f //x=3.535 //y=0.805
c70 ( 5 0 ) capacitor c=0.0290436f //x=3.45 //y=1.175
r71 (  19 34 ) resistor r=3.57586 //w=0.17 //l=0.125 //layer=li \
 //thickness=0.1 //x=4.505 //y=0.805 //x2=4.505 //y2=0.68
r72 (  19 34 ) resistor r=18.139 //w=0.187 //l=0.265 //layer=li \
 //thickness=0.1 //x=4.505 //y=0.805 //x2=4.505 //y2=1.07
r73 (  16 34 ) resistor r=3.57586 //w=0.17 //l=0.103078 //layer=li \
 //thickness=0.1 //x=3.62 //y=0.72 //x2=3.535 //y2=0.68
r74 (  16 34 ) resistor r=27.3797 //w=0.187 //l=0.4 //layer=li //thickness=0.1 \
 //x=3.62 //y=0.72 //x2=4.02 //y2=0.72
r75 (  15 34 ) resistor r=3.57586 //w=0.17 //l=0.103078 //layer=li \
 //thickness=0.1 //x=4.42 //y=0.72 //x2=4.505 //y2=0.68
r76 (  15 34 ) resistor r=27.3797 //w=0.187 //l=0.4 //layer=li //thickness=0.1 \
 //x=4.42 //y=0.72 //x2=4.02 //y2=0.72
r77 (  11 30 ) resistor r=5.4201 //w=0.17 //l=0.085 //layer=li //thickness=0.1 \
 //x=3.535 //y=1.26 //x2=3.535 //y2=1.175
r78 (  11 34 ) resistor r=10.2674 //w=0.187 //l=0.15 //layer=li \
 //thickness=0.1 //x=3.535 //y=1.26 //x2=3.535 //y2=1.41
r79 (  8 30 ) resistor r=5.4201 //w=0.17 //l=0.085 //layer=li //thickness=0.1 \
 //x=3.535 //y=1.09 //x2=3.535 //y2=1.175
r80 (  8 34 ) resistor r=1.36898 //w=0.187 //l=0.02 //layer=li //thickness=0.1 \
 //x=3.535 //y=1.09 //x2=3.535 //y2=1.07
r81 (  7 34 ) resistor r=3.57586 //w=0.17 //l=0.125 //layer=li //thickness=0.1 \
 //x=3.535 //y=0.805 //x2=3.535 //y2=0.68
r82 (  7 34 ) resistor r=18.139 //w=0.187 //l=0.265 //layer=li //thickness=0.1 \
 //x=3.535 //y=0.805 //x2=3.535 //y2=1.07
r83 (  6 33 ) resistor r=0.751729 //w=0.17 //l=0.085 //layer=li \
 //thickness=0.1 //x=2.57 //y=1.175 //x2=2.485 //y2=1.175
r84 (  5 30 ) resistor r=1.40859 //w=0.34 //l=0.085 //layer=li //thickness=0.1 \
 //x=3.45 //y=1.175 //x2=3.535 //y2=1.175
r85 (  5 6 ) resistor r=60.2353 //w=0.187 //l=0.88 //layer=li //thickness=0.1 \
 //x=3.45 //y=1.175 //x2=2.57 //y2=1.175
ends PM_DFFQX1\%noxref_9

subckt PM_DFFQX1\%D ( 1 2 3 4 9 11 14 22 27 31 32 33 34 35 36 41 43 45 51 52 \
 54 55 58 )
c119 ( 58 0 ) capacitor c=0.0393541f //x=7.125 //y=4.88
c120 ( 55 0 ) capacitor c=0.0284095f //x=7.095 //y=2.095
c121 ( 54 0 ) capacitor c=0.0463911f //x=7.095 //y=2.26
c122 ( 52 0 ) capacitor c=0.0439708f //x=7.66 //y=1.43
c123 ( 51 0 ) capacitor c=0.0192582f //x=7.66 //y=1.085
c124 ( 45 0 ) capacitor c=0.0162526f //x=7.505 //y=1.585
c125 ( 43 0 ) capacitor c=0.0157807f //x=7.505 //y=0.93
c126 ( 41 0 ) capacitor c=0.0372668f //x=7.5 //y=4.97
c127 ( 36 0 ) capacitor c=0.020803f //x=7.13 //y=1.74
c128 ( 35 0 ) capacitor c=0.0168511f //x=7.13 //y=1.43
c129 ( 34 0 ) capacitor c=0.0175485f //x=7.13 //y=1.085
c130 ( 33 0 ) capacitor c=0.155269f //x=7.575 //y=6.2
c131 ( 32 0 ) capacitor c=0.110375f //x=7.135 //y=6.2
c132 ( 27 0 ) capacitor c=8.90417e-19 //x=7.125 //y=4.88
c133 ( 22 0 ) capacitor c=7.72439e-19 //x=7.095 //y=2.26
c134 ( 14 0 ) capacitor c=0.00559736f //x=7.122 //y=3.055
c135 ( 11 0 ) capacitor c=0.0040506f //x=7.122 //y=2.685
c136 ( 9 0 ) capacitor c=0.0353217f //x=7.095 //y=4.735
c137 ( 4 0 ) capacitor c=0.00764002f //x=7.095 //y=2.485
c138 ( 3 0 ) capacitor c=0.00623547f //x=7.147 //y=3.14
c139 ( 2 0 ) capacitor c=0.00422764f //x=7.147 //y=2.77
r140 (  60 61 ) resistor r=32.4568 //w=0.214 //l=0.075 //layer=ply \
 //thickness=0.18 //x=7.125 //y=4.97 //x2=7.125 //y2=5.045
r141 (  58 60 ) resistor r=20.271 //w=0.214 //l=0.09 //layer=ply \
 //thickness=0.18 //x=7.125 //y=4.88 //x2=7.125 //y2=4.97
r142 (  54 55 ) resistor r=52.7279 //w=0.214 //l=0.165 //layer=ply \
 //thickness=0.18 //x=7.095 //y=2.26 //x2=7.095 //y2=2.095
r143 (  52 65 ) resistor r=45.1352 //w=0.168 //l=0.173853 //layer=ply \
 //thickness=0.18 //x=7.66 //y=1.43 //x2=7.62 //y2=1.585
r144 (  51 64 ) resistor r=45.1352 //w=0.168 //l=0.173853 //layer=ply \
 //thickness=0.18 //x=7.66 //y=1.085 //x2=7.62 //y2=0.93
r145 (  51 52 ) resistor r=176.904 //w=0.094 //l=0.345 //layer=ply \
 //thickness=0.18 //x=7.66 //y=1.085 //x2=7.66 //y2=1.43
r146 (  46 63 ) resistor r=10.701 //w=0.21 //l=0.115 //layer=ply \
 //thickness=0.18 //x=7.285 //y=1.585 //x2=7.17 //y2=1.585
r147 (  45 65 ) resistor r=5.52526 //w=0.168 //l=0.115 //layer=ply \
 //thickness=0.18 //x=7.505 //y=1.585 //x2=7.62 //y2=1.585
r148 (  44 62 ) resistor r=5.52526 //w=0.168 //l=0.115 //layer=ply \
 //thickness=0.18 //x=7.285 //y=0.93 //x2=7.17 //y2=0.93
r149 (  43 64 ) resistor r=5.52526 //w=0.168 //l=0.115 //layer=ply \
 //thickness=0.18 //x=7.505 //y=0.93 //x2=7.62 //y2=0.93
r150 (  43 44 ) resistor r=112.809 //w=0.094 //l=0.22 //layer=ply \
 //thickness=0.18 //x=7.505 //y=0.93 //x2=7.285 //y2=0.93
r151 (  42 60 ) resistor r=16.5046 //w=0.27 //l=0.135 //layer=ply \
 //thickness=0.18 //x=7.26 //y=4.97 //x2=7.125 //y2=4.97
r152 (  41 48 ) resistor r=26.9307 //w=0.15 //l=0.106066 //layer=ply \
 //thickness=0.18 //x=7.5 //y=4.97 //x2=7.575 //y2=5.045
r153 (  41 42 ) resistor r=123.064 //w=0.094 //l=0.24 //layer=ply \
 //thickness=0.18 //x=7.5 //y=4.97 //x2=7.26 //y2=4.97
r154 (  36 63 ) resistor r=39.5823 //w=0.21 //l=0.173853 //layer=ply \
 //thickness=0.18 //x=7.13 //y=1.74 //x2=7.17 //y2=1.585
r155 (  36 55 ) resistor r=182.032 //w=0.094 //l=0.355 //layer=ply \
 //thickness=0.18 //x=7.13 //y=1.74 //x2=7.13 //y2=2.095
r156 (  35 63 ) resistor r=39.5823 //w=0.21 //l=0.173853 //layer=ply \
 //thickness=0.18 //x=7.13 //y=1.43 //x2=7.17 //y2=1.585
r157 (  34 62 ) resistor r=45.1352 //w=0.168 //l=0.173853 //layer=ply \
 //thickness=0.18 //x=7.13 //y=1.085 //x2=7.17 //y2=0.93
r158 (  34 35 ) resistor r=176.904 //w=0.094 //l=0.345 //layer=ply \
 //thickness=0.18 //x=7.13 //y=1.085 //x2=7.13 //y2=1.43
r159 (  33 48 ) resistor r=592.245 //w=0.094 //l=1.155 //layer=ply \
 //thickness=0.18 //x=7.575 //y=6.2 //x2=7.575 //y2=5.045
r160 (  32 61 ) resistor r=592.245 //w=0.094 //l=1.155 //layer=ply \
 //thickness=0.18 //x=7.135 //y=6.2 //x2=7.135 //y2=5.045
r161 (  31 45 ) resistor r=56.4043 //w=0.094 //l=0.11 //layer=ply \
 //thickness=0.18 //x=7.395 //y=1.585 //x2=7.505 //y2=1.585
r162 (  31 46 ) resistor r=56.4043 //w=0.094 //l=0.11 //layer=ply \
 //thickness=0.18 //x=7.395 //y=1.585 //x2=7.285 //y2=1.585
r163 (  27 58 ) resistor r=152 //w=0.17 //l=0.17 //layer=licon //count=1 \
 //x=7.125 //y=4.88 //x2=7.125 //y2=4.88
r164 (  22 54 ) resistor r=152 //w=0.17 //l=0.17 //layer=licon //count=1 \
 //x=7.095 //y=2.26 //x2=7.095 //y2=2.26
r165 (  20 27 ) resistor r=9.3 //w=0.17 //l=0.17 //layer=mcon //count=1 \
 //x=7.125 //y=4.88 //x2=7.125 //y2=4.88
r166 (  17 22 ) resistor r=9.3 //w=0.17 //l=0.17 //layer=mcon //count=1 \
 //x=7.095 //y=2.26 //x2=7.095 //y2=2.26
r167 (  12 14 ) resistor r=0.19084 //w=0.131 //l=0.2 //layer=m1 \
 //thickness=0.36 //x=7.095 //y=2.855 //x2=7.095 //y2=3.055
r168 (  9 20 ) resistor r=0.0878548 //w=0.228 //l=0.159295 //layer=m1 \
 //thickness=0.36 //x=7.095 //y=4.735 //x2=7.125 //y2=4.88
r169 (  9 15 ) resistor r=1.44084 //w=0.131 //l=1.51 //layer=m1 \
 //thickness=0.36 //x=7.095 //y=4.735 //x2=7.095 //y2=3.225
r170 (  4 11 ) resistor r=0.19084 //w=0.131 //l=0.2 //layer=m1 \
 //thickness=0.36 //x=7.095 //y=2.485 //x2=7.095 //y2=2.685
r171 (  3 15 ) resistor r=0.0685923 //w=0.186 //l=0.085 //layer=m1 \
 //thickness=0.36 //x=7.122 //y=3.14 //x2=7.122 //y2=3.225
r172 (  3 14 ) resistor r=0.0685923 //w=0.186 //l=0.085 //layer=m1 \
 //thickness=0.36 //x=7.122 //y=3.14 //x2=7.122 //y2=3.055
r173 (  2 12 ) resistor r=0.0685923 //w=0.186 //l=0.085 //layer=m1 \
 //thickness=0.36 //x=7.122 //y=2.77 //x2=7.122 //y2=2.855
r174 (  2 11 ) resistor r=0.0685923 //w=0.186 //l=0.085 //layer=m1 \
 //thickness=0.36 //x=7.122 //y=2.77 //x2=7.122 //y2=2.685
r175 (  1 4 ) resistor r=0.0550154 //w=0.237 //l=0.090802 //layer=m1 \
 //thickness=0.36 //x=7.107 //y=2.4 //x2=7.095 //y2=2.485
r176 (  1 17 ) resistor r=0.0738397 //w=0.237 //l=0.14 //layer=m1 \
 //thickness=0.36 //x=7.107 //y=2.4 //x2=7.107 //y2=2.26
ends PM_DFFQX1\%D

subckt PM_DFFQX1\%GND ( 1 2 6 7 19 27 36 46 58 61 65 66 70 71 76 77 81 82 86 \
 87 93 96 110 125 138 153 175 185 186 187 188 189 191 192 193 194 195 196 )
c424 ( 196 0 ) capacitor c=0.00843555f //x=19.555 //y=1.045
c425 ( 195 0 ) capacitor c=0.00843555f //x=16.225 //y=1.045
c426 ( 194 0 ) capacitor c=0.00843555f //x=12.895 //y=1.045
c427 ( 193 0 ) capacitor c=0.00843555f //x=9.565 //y=1.045
c428 ( 192 0 ) capacitor c=0.00843555f //x=6.235 //y=1.045
c429 ( 191 0 ) capacitor c=0.00840423f //x=1.32 //y=1.055
c430 ( 189 0 ) capacitor c=0.117691f //x=18.565 //y=0.175
c431 ( 188 0 ) capacitor c=0.11793f //x=15.235 //y=0.175
c432 ( 187 0 ) capacitor c=0.117691f //x=11.905 //y=0.175
c433 ( 186 0 ) capacitor c=0.117691f //x=8.575 //y=0.175
c434 ( 185 0 ) capacitor c=0.118861f //x=5.245 //y=0.175
c435 ( 175 0 ) capacitor c=0.338536f //x=21.525 //y=0.18
c436 ( 153 0 ) capacitor c=0.125256f //x=18.395 //y=0.175
c437 ( 138 0 ) capacitor c=0.126434f //x=15.065 //y=0.175
c438 ( 125 0 ) capacitor c=0.125256f //x=11.735 //y=0.175
c439 ( 110 0 ) capacitor c=0.126356f //x=8.405 //y=0.175
c440 ( 96 0 ) capacitor c=0.193915f //x=1.175 //y=0.18
c441 ( 93 0 ) capacitor c=0.181445f //x=5.075 //y=0.175
c442 ( 90 0 ) capacitor c=0.00509083f //x=19.675 //y=0.18
c443 ( 87 0 ) capacitor c=0.0232551f //x=19.742 //y=1.005
c444 ( 86 0 ) capacitor c=0.0129527f //x=19.745 //y=1.135
c445 ( 84 0 ) capacitor c=0.00509083f //x=16.415 //y=0.175
c446 ( 82 0 ) capacitor c=0.0188922f //x=16.412 //y=1.005
c447 ( 81 0 ) capacitor c=0.0127521f //x=16.415 //y=1.135
c448 ( 79 0 ) capacitor c=0.00509083f //x=13.085 //y=0.175
c449 ( 77 0 ) capacitor c=0.0188922f //x=13.082 //y=1.005
c450 ( 76 0 ) capacitor c=0.0127968f //x=13.085 //y=1.135
c451 ( 74 0 ) capacitor c=0.00509083f //x=9.685 //y=0.18
c452 ( 71 0 ) capacitor c=0.0188922f //x=9.752 //y=1.005
c453 ( 70 0 ) capacitor c=0.0127973f //x=9.755 //y=1.135
c454 ( 68 0 ) capacitor c=0.00509083f //x=6.425 //y=0.175
c455 ( 66 0 ) capacitor c=0.0235363f //x=6.422 //y=1.005
c456 ( 65 0 ) capacitor c=0.0138363f //x=6.425 //y=1.135
c457 ( 63 0 ) capacitor c=0.00509414f //x=1.51 //y=0.175
c458 ( 61 0 ) capacitor c=0.017081f //x=1.51 //y=1.145
c459 ( 58 0 ) capacitor c=0.105162f //x=21.525 //y=0.18
c460 ( 46 0 ) capacitor c=0.110954f //x=19.66 //y=0.175
c461 ( 36 0 ) capacitor c=0.112419f //x=16.33 //y=0.175
c462 ( 27 0 ) capacitor c=0.110896f //x=13 //y=0.175
c463 ( 19 0 ) capacitor c=0.112274f //x=9.67 //y=0.175
c464 ( 7 0 ) capacitor c=0.154867f //x=6.34 //y=0.175
c465 ( 6 0 ) capacitor c=0.0302305f //x=1.51 //y=1.015
c466 ( 2 0 ) capacitor c=0.0680864f //x=1.425 //y=0.175
r467 (  173 175 ) resistor r=25.8093 //w=0.367 //l=0.74 //layer=li \
 //thickness=0.1 //x=20.785 //y=0.175 //x2=21.525 //y2=0.175
r468 (  171 173 ) resistor r=38.7139 //w=0.367 //l=1.11 //layer=li \
 //thickness=0.1 //x=19.675 //y=0.175 //x2=20.785 //y2=0.175
r469 (  169 189 ) resistor r=5.29055 //w=0.35 //l=0.17 //layer=li \
 //thickness=0.1 //x=18.735 //y=0.175 //x2=18.565 //y2=0.175
r470 (  169 171 ) resistor r=32.7847 //w=0.367 //l=0.94 //layer=li \
 //thickness=0.1 //x=18.735 //y=0.175 //x2=19.675 //y2=0.175
r471 (  158 160 ) resistor r=38.7139 //w=0.367 //l=1.11 //layer=li \
 //thickness=0.1 //x=17.085 //y=0.175 //x2=18.195 //y2=0.175
r472 (  156 158 ) resistor r=38.7139 //w=0.367 //l=1.11 //layer=li \
 //thickness=0.1 //x=15.975 //y=0.175 //x2=17.085 //y2=0.175
r473 (  154 188 ) resistor r=5.29055 //w=0.35 //l=0.17 //layer=li \
 //thickness=0.1 //x=15.405 //y=0.175 //x2=15.235 //y2=0.175
r474 (  154 156 ) resistor r=19.8801 //w=0.367 //l=0.57 //layer=li \
 //thickness=0.1 //x=15.405 //y=0.175 //x2=15.975 //y2=0.175
r475 (  153 189 ) resistor r=5.29055 //w=0.35 //l=0.17 //layer=li \
 //thickness=0.1 //x=18.395 //y=0.175 //x2=18.565 //y2=0.175
r476 (  153 160 ) resistor r=6.97548 //w=0.367 //l=0.2 //layer=li \
 //thickness=0.1 //x=18.395 //y=0.175 //x2=18.195 //y2=0.175
r477 (  143 145 ) resistor r=38.7139 //w=0.367 //l=1.11 //layer=li \
 //thickness=0.1 //x=13.385 //y=0.175 //x2=14.495 //y2=0.175
r478 (  141 143 ) resistor r=38.7139 //w=0.367 //l=1.11 //layer=li \
 //thickness=0.1 //x=12.275 //y=0.175 //x2=13.385 //y2=0.175
r479 (  139 187 ) resistor r=5.29055 //w=0.35 //l=0.17 //layer=li \
 //thickness=0.1 //x=12.075 //y=0.175 //x2=11.905 //y2=0.175
r480 (  139 141 ) resistor r=6.97548 //w=0.367 //l=0.2 //layer=li \
 //thickness=0.1 //x=12.075 //y=0.175 //x2=12.275 //y2=0.175
r481 (  138 188 ) resistor r=5.29055 //w=0.35 //l=0.17 //layer=li \
 //thickness=0.1 //x=15.065 //y=0.175 //x2=15.235 //y2=0.175
r482 (  138 145 ) resistor r=19.8801 //w=0.367 //l=0.57 //layer=li \
 //thickness=0.1 //x=15.065 //y=0.175 //x2=14.495 //y2=0.175
r483 (  128 130 ) resistor r=38.7139 //w=0.367 //l=1.11 //layer=li \
 //thickness=0.1 //x=9.685 //y=0.175 //x2=10.795 //y2=0.175
r484 (  126 186 ) resistor r=5.29055 //w=0.35 //l=0.17 //layer=li \
 //thickness=0.1 //x=8.745 //y=0.175 //x2=8.575 //y2=0.175
r485 (  126 128 ) resistor r=32.7847 //w=0.367 //l=0.94 //layer=li \
 //thickness=0.1 //x=8.745 //y=0.175 //x2=9.685 //y2=0.175
r486 (  125 187 ) resistor r=5.29055 //w=0.35 //l=0.17 //layer=li \
 //thickness=0.1 //x=11.735 //y=0.175 //x2=11.905 //y2=0.175
r487 (  125 130 ) resistor r=32.7847 //w=0.367 //l=0.94 //layer=li \
 //thickness=0.1 //x=11.735 //y=0.175 //x2=10.795 //y2=0.175
r488 (  115 117 ) resistor r=38.7139 //w=0.367 //l=1.11 //layer=li \
 //thickness=0.1 //x=7.095 //y=0.175 //x2=8.205 //y2=0.175
r489 (  113 115 ) resistor r=38.7139 //w=0.367 //l=1.11 //layer=li \
 //thickness=0.1 //x=5.985 //y=0.175 //x2=7.095 //y2=0.175
r490 (  111 185 ) resistor r=5.29055 //w=0.35 //l=0.17 //layer=li \
 //thickness=0.1 //x=5.415 //y=0.175 //x2=5.245 //y2=0.175
r491 (  111 113 ) resistor r=19.8801 //w=0.367 //l=0.57 //layer=li \
 //thickness=0.1 //x=5.415 //y=0.175 //x2=5.985 //y2=0.175
r492 (  110 186 ) resistor r=5.29055 //w=0.35 //l=0.17 //layer=li \
 //thickness=0.1 //x=8.405 //y=0.175 //x2=8.575 //y2=0.175
r493 (  110 117 ) resistor r=6.97548 //w=0.367 //l=0.2 //layer=li \
 //thickness=0.1 //x=8.405 //y=0.175 //x2=8.205 //y2=0.175
r494 (  100 102 ) resistor r=38.7139 //w=0.367 //l=1.11 //layer=li \
 //thickness=0.1 //x=3.395 //y=0.175 //x2=4.505 //y2=0.175
r495 (  98 100 ) resistor r=38.7139 //w=0.367 //l=1.11 //layer=li \
 //thickness=0.1 //x=2.285 //y=0.175 //x2=3.395 //y2=0.175
r496 (  96 98 ) resistor r=38.7139 //w=0.367 //l=1.11 //layer=li \
 //thickness=0.1 //x=1.175 //y=0.175 //x2=2.285 //y2=0.175
r497 (  93 185 ) resistor r=5.29055 //w=0.35 //l=0.17 //layer=li \
 //thickness=0.1 //x=5.075 //y=0.175 //x2=5.245 //y2=0.175
r498 (  93 102 ) resistor r=19.8801 //w=0.367 //l=0.57 //layer=li \
 //thickness=0.1 //x=5.075 //y=0.175 //x2=4.505 //y2=0.175
r499 (  90 171 ) resistor r=3.1 //w=0.17 //l=0.51 //layer=mcon //count=3 \
 //x=19.675 //y=0.18 //x2=19.675 //y2=0.18
r500 (  86 196 ) resistor r=9.3 //w=0.17 //l=0.17 //layer=mcon //count=1 \
 //x=19.745 //y=1.135 //x2=19.745 //y2=1.135
r501 (  86 87 ) resistor r=0.0939994 //w=0.226 //l=0.13 //layer=m1 \
 //thickness=0.36 //x=19.742 //y=1.135 //x2=19.742 //y2=1.005
r502 (  81 195 ) resistor r=9.3 //w=0.17 //l=0.17 //layer=mcon //count=1 \
 //x=16.415 //y=1.135 //x2=16.415 //y2=1.135
r503 (  81 82 ) resistor r=0.0939994 //w=0.226 //l=0.13 //layer=m1 \
 //thickness=0.36 //x=16.412 //y=1.135 //x2=16.412 //y2=1.005
r504 (  76 194 ) resistor r=9.3 //w=0.17 //l=0.17 //layer=mcon //count=1 \
 //x=13.085 //y=1.135 //x2=13.085 //y2=1.135
r505 (  76 77 ) resistor r=0.0939994 //w=0.226 //l=0.13 //layer=m1 \
 //thickness=0.36 //x=13.082 //y=1.135 //x2=13.082 //y2=1.005
r506 (  74 128 ) resistor r=3.1 //w=0.17 //l=0.51 //layer=mcon //count=3 \
 //x=9.685 //y=0.18 //x2=9.685 //y2=0.18
r507 (  70 193 ) resistor r=9.3 //w=0.17 //l=0.17 //layer=mcon //count=1 \
 //x=9.755 //y=1.135 //x2=9.755 //y2=1.135
r508 (  70 71 ) resistor r=0.0939994 //w=0.226 //l=0.13 //layer=m1 \
 //thickness=0.36 //x=9.752 //y=1.135 //x2=9.752 //y2=1.005
r509 (  65 192 ) resistor r=9.3 //w=0.17 //l=0.17 //layer=mcon //count=1 \
 //x=6.425 //y=1.135 //x2=6.425 //y2=1.135
r510 (  65 66 ) resistor r=0.0939994 //w=0.226 //l=0.13 //layer=m1 \
 //thickness=0.36 //x=6.422 //y=1.135 //x2=6.422 //y2=1.005
r511 (  61 191 ) resistor r=9.3 //w=0.17 //l=0.17 //layer=mcon //count=1 \
 //x=1.51 //y=1.145 //x2=1.51 //y2=1.145
r512 (  58 175 ) resistor r=9.3 //w=0.17 //l=0.17 //layer=mcon //count=1 \
 //x=21.525 //y=0.18 //x2=21.525 //y2=0.18
r513 (  56 173 ) resistor r=3.1 //w=0.17 //l=0.51 //layer=mcon //count=3 \
 //x=20.785 //y=0.18 //x2=20.785 //y2=0.18
r514 (  56 58 ) resistor r=0.297428 //w=0.311 //l=0.74 //layer=m1 \
 //thickness=0.36 //x=20.785 //y=0.175 //x2=21.525 //y2=0.175
r515 (  54 90 ) resistor r=0.028033 //w=0.35 //l=0.085 //layer=m1 \
 //thickness=0.36 //x=19.83 //y=0.175 //x2=19.745 //y2=0.175
r516 (  54 56 ) resistor r=0.383842 //w=0.311 //l=0.955 //layer=m1 \
 //thickness=0.36 //x=19.83 //y=0.175 //x2=20.785 //y2=0.175
r517 (  52 90 ) resistor r=0.0413265 //w=0.7 //l=0.175 //layer=m1 \
 //thickness=0.36 //x=19.745 //y=0.35 //x2=19.745 //y2=0.175
r518 (  52 87 ) resistor r=0.625 //w=0.131 //l=0.655 //layer=m1 \
 //thickness=0.36 //x=19.745 //y=0.35 //x2=19.745 //y2=1.005
r519 (  51 160 ) resistor r=3.1 //w=0.17 //l=0.51 //layer=mcon //count=3 \
 //x=18.195 //y=0.18 //x2=18.195 //y2=0.18
r520 (  49 158 ) resistor r=3.1 //w=0.17 //l=0.51 //layer=mcon //count=3 \
 //x=17.085 //y=0.18 //x2=17.085 //y2=0.18
r521 (  49 51 ) resistor r=0.446141 //w=0.311 //l=1.11 //layer=m1 \
 //thickness=0.36 //x=17.085 //y=0.175 //x2=18.195 //y2=0.175
r522 (  47 84 ) resistor r=0.028033 //w=0.35 //l=0.085 //layer=m1 \
 //thickness=0.36 //x=16.5 //y=0.175 //x2=16.415 //y2=0.175
r523 (  47 49 ) resistor r=0.235129 //w=0.311 //l=0.585 //layer=m1 \
 //thickness=0.36 //x=16.5 //y=0.175 //x2=17.085 //y2=0.175
r524 (  46 90 ) resistor r=0.028033 //w=0.35 //l=0.085 //layer=m1 \
 //thickness=0.36 //x=19.66 //y=0.175 //x2=19.745 //y2=0.175
r525 (  46 51 ) resistor r=0.588826 //w=0.311 //l=1.465 //layer=m1 \
 //thickness=0.36 //x=19.66 //y=0.175 //x2=18.195 //y2=0.175
r526 (  44 84 ) resistor r=0.0413265 //w=0.7 //l=0.175 //layer=m1 \
 //thickness=0.36 //x=16.415 //y=0.35 //x2=16.415 //y2=0.175
r527 (  44 82 ) resistor r=0.625 //w=0.131 //l=0.655 //layer=m1 \
 //thickness=0.36 //x=16.415 //y=0.35 //x2=16.415 //y2=1.005
r528 (  43 156 ) resistor r=3.1 //w=0.17 //l=0.51 //layer=mcon //count=3 \
 //x=15.975 //y=0.18 //x2=15.975 //y2=0.18
r529 (  41 145 ) resistor r=3.1 //w=0.17 //l=0.51 //layer=mcon //count=3 \
 //x=14.495 //y=0.18 //x2=14.495 //y2=0.18
r530 (  41 43 ) resistor r=0.594855 //w=0.311 //l=1.48 //layer=m1 \
 //thickness=0.36 //x=14.495 //y=0.175 //x2=15.975 //y2=0.175
r531 (  39 143 ) resistor r=3.1 //w=0.17 //l=0.51 //layer=mcon //count=3 \
 //x=13.385 //y=0.18 //x2=13.385 //y2=0.18
r532 (  39 41 ) resistor r=0.446141 //w=0.311 //l=1.11 //layer=m1 \
 //thickness=0.36 //x=13.385 //y=0.175 //x2=14.495 //y2=0.175
r533 (  37 79 ) resistor r=0.028033 //w=0.35 //l=0.085 //layer=m1 \
 //thickness=0.36 //x=13.17 //y=0.175 //x2=13.085 //y2=0.175
r534 (  37 39 ) resistor r=0.0864148 //w=0.311 //l=0.215 //layer=m1 \
 //thickness=0.36 //x=13.17 //y=0.175 //x2=13.385 //y2=0.175
r535 (  36 84 ) resistor r=0.028033 //w=0.35 //l=0.085 //layer=m1 \
 //thickness=0.36 //x=16.33 //y=0.175 //x2=16.415 //y2=0.175
r536 (  36 43 ) resistor r=0.142685 //w=0.311 //l=0.355 //layer=m1 \
 //thickness=0.36 //x=16.33 //y=0.175 //x2=15.975 //y2=0.175
r537 (  34 79 ) resistor r=0.0413265 //w=0.7 //l=0.175 //layer=m1 \
 //thickness=0.36 //x=13.085 //y=0.35 //x2=13.085 //y2=0.175
r538 (  34 77 ) resistor r=0.625 //w=0.131 //l=0.655 //layer=m1 \
 //thickness=0.36 //x=13.085 //y=0.35 //x2=13.085 //y2=1.005
r539 (  33 141 ) resistor r=3.1 //w=0.17 //l=0.51 //layer=mcon //count=3 \
 //x=12.275 //y=0.18 //x2=12.275 //y2=0.18
r540 (  30 130 ) resistor r=3.1 //w=0.17 //l=0.51 //layer=mcon //count=3 \
 //x=10.795 //y=0.18 //x2=10.795 //y2=0.18
r541 (  28 74 ) resistor r=0.028033 //w=0.35 //l=0.085 //layer=m1 \
 //thickness=0.36 //x=9.84 //y=0.175 //x2=9.755 //y2=0.175
r542 (  28 30 ) resistor r=0.383842 //w=0.311 //l=0.955 //layer=m1 \
 //thickness=0.36 //x=9.84 //y=0.175 //x2=10.795 //y2=0.175
r543 (  27 79 ) resistor r=0.028033 //w=0.35 //l=0.085 //layer=m1 \
 //thickness=0.36 //x=13 //y=0.175 //x2=13.085 //y2=0.175
r544 (  27 33 ) resistor r=0.291399 //w=0.311 //l=0.725 //layer=m1 \
 //thickness=0.36 //x=13 //y=0.175 //x2=12.275 //y2=0.175
r545 (  25 74 ) resistor r=0.0413265 //w=0.7 //l=0.175 //layer=m1 \
 //thickness=0.36 //x=9.755 //y=0.35 //x2=9.755 //y2=0.175
r546 (  25 71 ) resistor r=0.625 //w=0.131 //l=0.655 //layer=m1 \
 //thickness=0.36 //x=9.755 //y=0.35 //x2=9.755 //y2=1.005
r547 (  24 117 ) resistor r=3.1 //w=0.17 //l=0.51 //layer=mcon //count=3 \
 //x=8.205 //y=0.18 //x2=8.205 //y2=0.18
r548 (  22 115 ) resistor r=3.1 //w=0.17 //l=0.51 //layer=mcon //count=3 \
 //x=7.095 //y=0.18 //x2=7.095 //y2=0.18
r549 (  22 24 ) resistor r=0.446141 //w=0.311 //l=1.11 //layer=m1 \
 //thickness=0.36 //x=7.095 //y=0.175 //x2=8.205 //y2=0.175
r550 (  20 68 ) resistor r=0.028033 //w=0.35 //l=0.085 //layer=m1 \
 //thickness=0.36 //x=6.51 //y=0.175 //x2=6.425 //y2=0.175
r551 (  20 22 ) resistor r=0.235129 //w=0.311 //l=0.585 //layer=m1 \
 //thickness=0.36 //x=6.51 //y=0.175 //x2=7.095 //y2=0.175
r552 (  19 74 ) resistor r=0.028033 //w=0.35 //l=0.085 //layer=m1 \
 //thickness=0.36 //x=9.67 //y=0.175 //x2=9.755 //y2=0.175
r553 (  19 24 ) resistor r=0.588826 //w=0.311 //l=1.465 //layer=m1 \
 //thickness=0.36 //x=9.67 //y=0.175 //x2=8.205 //y2=0.175
r554 (  17 68 ) resistor r=0.0413265 //w=0.7 //l=0.175 //layer=m1 \
 //thickness=0.36 //x=6.425 //y=0.35 //x2=6.425 //y2=0.175
r555 (  17 66 ) resistor r=0.625 //w=0.131 //l=0.655 //layer=m1 \
 //thickness=0.36 //x=6.425 //y=0.35 //x2=6.425 //y2=1.005
r556 (  16 113 ) resistor r=3.1 //w=0.17 //l=0.51 //layer=mcon //count=3 \
 //x=5.985 //y=0.18 //x2=5.985 //y2=0.18
r557 (  14 102 ) resistor r=3.1 //w=0.17 //l=0.51 //layer=mcon //count=3 \
 //x=4.505 //y=0.18 //x2=4.505 //y2=0.18
r558 (  14 16 ) resistor r=0.594855 //w=0.311 //l=1.48 //layer=m1 \
 //thickness=0.36 //x=4.505 //y=0.175 //x2=5.985 //y2=0.175
r559 (  12 100 ) resistor r=3.1 //w=0.17 //l=0.51 //layer=mcon //count=3 \
 //x=3.395 //y=0.18 //x2=3.395 //y2=0.18
r560 (  12 14 ) resistor r=0.446141 //w=0.311 //l=1.11 //layer=m1 \
 //thickness=0.36 //x=3.395 //y=0.175 //x2=4.505 //y2=0.175
r561 (  10 98 ) resistor r=3.1 //w=0.17 //l=0.51 //layer=mcon //count=3 \
 //x=2.285 //y=0.18 //x2=2.285 //y2=0.18
r562 (  10 12 ) resistor r=0.446141 //w=0.311 //l=1.11 //layer=m1 \
 //thickness=0.36 //x=2.285 //y=0.175 //x2=3.395 //y2=0.175
r563 (  8 63 ) resistor r=0.028033 //w=0.35 //l=0.085 //layer=m1 \
 //thickness=0.36 //x=1.595 //y=0.175 //x2=1.51 //y2=0.175
r564 (  8 10 ) resistor r=0.277331 //w=0.311 //l=0.69 //layer=m1 \
 //thickness=0.36 //x=1.595 //y=0.175 //x2=2.285 //y2=0.175
r565 (  7 68 ) resistor r=0.028033 //w=0.35 //l=0.085 //layer=m1 \
 //thickness=0.36 //x=6.34 //y=0.175 //x2=6.425 //y2=0.175
r566 (  7 16 ) resistor r=0.142685 //w=0.311 //l=0.355 //layer=m1 \
 //thickness=0.36 //x=6.34 //y=0.175 //x2=5.985 //y2=0.175
r567 (  6 61 ) resistor r=0.0942778 //w=0.221 //l=0.13 //layer=m1 \
 //thickness=0.36 //x=1.51 //y=1.015 //x2=1.51 //y2=1.145
r568 (  5 63 ) resistor r=0.0413265 //w=0.7 //l=0.175 //layer=m1 \
 //thickness=0.36 //x=1.51 //y=0.35 //x2=1.51 //y2=0.175
r569 (  5 6 ) resistor r=0.634542 //w=0.131 //l=0.665 //layer=m1 \
 //thickness=0.36 //x=1.51 //y=0.35 //x2=1.51 //y2=1.015
r570 (  4 96 ) resistor r=3.1 //w=0.17 //l=0.51 //layer=mcon //count=3 \
 //x=1.175 //y=0.18 //x2=1.175 //y2=0.18
r571 (  2 63 ) resistor r=0.028033 //w=0.35 //l=0.085 //layer=m1 \
 //thickness=0.36 //x=1.425 //y=0.175 //x2=1.51 //y2=0.175
r572 (  2 4 ) resistor r=0.0892857 //w=0.35 //l=0.25 //layer=m1 \
 //thickness=0.36 //x=1.425 //y=0.175 //x2=1.175 //y2=0.175
r573 (  1 33 ) resistor r=0.424035 //w=0.311 //l=1.055 //layer=m1 \
 //thickness=0.36 //x=11.22 //y=0.175 //x2=12.275 //y2=0.175
r574 (  1 30 ) resistor r=0.17082 //w=0.311 //l=0.425 //layer=m1 \
 //thickness=0.36 //x=11.22 //y=0.175 //x2=10.795 //y2=0.175
ends PM_DFFQX1\%GND

subckt PM_DFFQX1\%noxref_12 ( 1 5 9 13 17 35 )
c52 ( 35 0 ) capacitor c=0.076261f //x=0.89 //y=0.555
c53 ( 17 0 ) capacitor c=0.0259769f //x=2.88 //y=1.77
c54 ( 13 0 ) capacitor c=0.0153941f //x=2.88 //y=0.72
c55 ( 9 0 ) capacitor c=0.00772076f //x=1.995 //y=0.805
c56 ( 5 0 ) capacitor c=0.0211674f //x=1.91 //y=1.77
c57 ( 1 0 ) capacitor c=0.0109947f //x=1.025 //y=1.685
r58 (  18 35 ) resistor r=5.4201 //w=0.17 //l=0.103078 //layer=li \
 //thickness=0.1 //x=2.08 //y=1.77 //x2=1.995 //y2=1.81
r59 (  18 35 ) resistor r=27.3797 //w=0.187 //l=0.4 //layer=li //thickness=0.1 \
 //x=2.08 //y=1.77 //x2=2.48 //y2=1.77
r60 (  17 35 ) resistor r=0.751729 //w=0.17 //l=0.085 //layer=li \
 //thickness=0.1 //x=2.88 //y=1.77 //x2=2.965 //y2=1.77
r61 (  17 35 ) resistor r=27.3797 //w=0.187 //l=0.4 //layer=li //thickness=0.1 \
 //x=2.88 //y=1.77 //x2=2.48 //y2=1.77
r62 (  14 35 ) resistor r=3.57586 //w=0.17 //l=0.103078 //layer=li \
 //thickness=0.1 //x=2.08 //y=0.72 //x2=1.995 //y2=0.68
r63 (  14 35 ) resistor r=27.3797 //w=0.187 //l=0.4 //layer=li //thickness=0.1 \
 //x=2.08 //y=0.72 //x2=2.48 //y2=0.72
r64 (  13 35 ) resistor r=0.751729 //w=0.17 //l=0.085 //layer=li \
 //thickness=0.1 //x=2.88 //y=0.72 //x2=2.965 //y2=0.72
r65 (  13 35 ) resistor r=27.3797 //w=0.187 //l=0.4 //layer=li //thickness=0.1 \
 //x=2.88 //y=0.72 //x2=2.48 //y2=0.72
r66 (  10 35 ) resistor r=1.40859 //w=0.34 //l=0.125 //layer=li \
 //thickness=0.1 //x=1.995 //y=1.685 //x2=1.995 //y2=1.81
r67 (  10 35 ) resistor r=42.0963 //w=0.187 //l=0.615 //layer=li \
 //thickness=0.1 //x=1.995 //y=1.685 //x2=1.995 //y2=1.07
r68 (  9 35 ) resistor r=3.57586 //w=0.17 //l=0.125 //layer=li //thickness=0.1 \
 //x=1.995 //y=0.805 //x2=1.995 //y2=0.68
r69 (  9 35 ) resistor r=18.139 //w=0.187 //l=0.265 //layer=li //thickness=0.1 \
 //x=1.995 //y=0.805 //x2=1.995 //y2=1.07
r70 (  6 35 ) resistor r=3.57586 //w=0.17 //l=0.103078 //layer=li \
 //thickness=0.1 //x=1.11 //y=1.77 //x2=1.025 //y2=1.81
r71 (  6 35 ) resistor r=27.3797 //w=0.187 //l=0.4 //layer=li //thickness=0.1 \
 //x=1.11 //y=1.77 //x2=1.51 //y2=1.77
r72 (  5 35 ) resistor r=5.4201 //w=0.17 //l=0.103078 //layer=li \
 //thickness=0.1 //x=1.91 //y=1.77 //x2=1.995 //y2=1.81
r73 (  5 35 ) resistor r=27.3797 //w=0.187 //l=0.4 //layer=li //thickness=0.1 \
 //x=1.91 //y=1.77 //x2=1.51 //y2=1.77
r74 (  1 35 ) resistor r=3.57586 //w=0.17 //l=0.125 //layer=li //thickness=0.1 \
 //x=1.025 //y=1.685 //x2=1.025 //y2=1.81
r75 (  1 35 ) resistor r=42.0963 //w=0.187 //l=0.615 //layer=li \
 //thickness=0.1 //x=1.025 //y=1.685 //x2=1.025 //y2=1.07
ends PM_DFFQX1\%noxref_12

subckt PM_DFFQX1\%noxref_13 ( 1 5 9 10 13 17 29 )
c66 ( 29 0 ) capacitor c=0.0671084f //x=5.805 //y=0.545
c67 ( 17 0 ) capacitor c=0.0067865f //x=7.88 //y=0.795
c68 ( 13 0 ) capacitor c=0.0156925f //x=7.795 //y=0.71
c69 ( 10 0 ) capacitor c=0.00724577f //x=6.91 //y=1.675
c70 ( 9 0 ) capacitor c=0.00770028f //x=6.91 //y=0.795
c71 ( 5 0 ) capacitor c=0.0193892f //x=6.825 //y=1.76
c72 ( 1 0 ) capacitor c=0.00822695f //x=5.94 //y=1.675
r73 (  17 29 ) resistor r=3.57586 //w=0.17 //l=0.125 //layer=li \
 //thickness=0.1 //x=7.88 //y=0.795 //x2=7.88 //y2=0.67
r74 (  17 29 ) resistor r=18.139 //w=0.187 //l=0.265 //layer=li \
 //thickness=0.1 //x=7.88 //y=0.795 //x2=7.88 //y2=1.06
r75 (  14 29 ) resistor r=3.57586 //w=0.17 //l=0.103078 //layer=li \
 //thickness=0.1 //x=6.995 //y=0.71 //x2=6.91 //y2=0.67
r76 (  14 29 ) resistor r=27.3797 //w=0.187 //l=0.4 //layer=li //thickness=0.1 \
 //x=6.995 //y=0.71 //x2=7.395 //y2=0.71
r77 (  13 29 ) resistor r=3.57586 //w=0.17 //l=0.103078 //layer=li \
 //thickness=0.1 //x=7.795 //y=0.71 //x2=7.88 //y2=0.67
r78 (  13 29 ) resistor r=27.3797 //w=0.187 //l=0.4 //layer=li //thickness=0.1 \
 //x=7.795 //y=0.71 //x2=7.395 //y2=0.71
r79 (  10 29 ) resistor r=3.57586 //w=0.17 //l=0.125 //layer=li \
 //thickness=0.1 //x=6.91 //y=1.675 //x2=6.91 //y2=1.8
r80 (  10 29 ) resistor r=42.0963 //w=0.187 //l=0.615 //layer=li \
 //thickness=0.1 //x=6.91 //y=1.675 //x2=6.91 //y2=1.06
r81 (  9 29 ) resistor r=3.57586 //w=0.17 //l=0.125 //layer=li //thickness=0.1 \
 //x=6.91 //y=0.795 //x2=6.91 //y2=0.67
r82 (  9 29 ) resistor r=18.139 //w=0.187 //l=0.265 //layer=li //thickness=0.1 \
 //x=6.91 //y=0.795 //x2=6.91 //y2=1.06
r83 (  6 29 ) resistor r=3.57586 //w=0.17 //l=0.103078 //layer=li \
 //thickness=0.1 //x=6.025 //y=1.76 //x2=5.94 //y2=1.8
r84 (  6 29 ) resistor r=27.3797 //w=0.187 //l=0.4 //layer=li //thickness=0.1 \
 //x=6.025 //y=1.76 //x2=6.425 //y2=1.76
r85 (  5 29 ) resistor r=3.57586 //w=0.17 //l=0.103078 //layer=li \
 //thickness=0.1 //x=6.825 //y=1.76 //x2=6.91 //y2=1.8
r86 (  5 29 ) resistor r=27.3797 //w=0.187 //l=0.4 //layer=li //thickness=0.1 \
 //x=6.825 //y=1.76 //x2=6.425 //y2=1.76
r87 (  1 29 ) resistor r=3.57586 //w=0.17 //l=0.125 //layer=li //thickness=0.1 \
 //x=5.94 //y=1.675 //x2=5.94 //y2=1.8
r88 (  1 29 ) resistor r=42.0963 //w=0.187 //l=0.615 //layer=li \
 //thickness=0.1 //x=5.94 //y=1.675 //x2=5.94 //y2=1.06
ends PM_DFFQX1\%noxref_13

subckt PM_DFFQX1\%noxref_14 ( 1 5 9 10 13 17 29 )
c68 ( 29 0 ) capacitor c=0.0668051f //x=9.135 //y=0.545
c69 ( 17 0 ) capacitor c=0.0067865f //x=11.21 //y=0.795
c70 ( 13 0 ) capacitor c=0.0157426f //x=11.125 //y=0.71
c71 ( 10 0 ) capacitor c=0.00742952f //x=10.24 //y=1.675
c72 ( 9 0 ) capacitor c=0.00770028f //x=10.24 //y=0.795
c73 ( 5 0 ) capacitor c=0.0197708f //x=10.155 //y=1.76
c74 ( 1 0 ) capacitor c=0.00821716f //x=9.27 //y=1.675
r75 (  17 29 ) resistor r=3.57586 //w=0.17 //l=0.125 //layer=li \
 //thickness=0.1 //x=11.21 //y=0.795 //x2=11.21 //y2=0.67
r76 (  17 29 ) resistor r=18.139 //w=0.187 //l=0.265 //layer=li \
 //thickness=0.1 //x=11.21 //y=0.795 //x2=11.21 //y2=1.06
r77 (  14 29 ) resistor r=3.57586 //w=0.17 //l=0.103078 //layer=li \
 //thickness=0.1 //x=10.325 //y=0.71 //x2=10.24 //y2=0.67
r78 (  14 29 ) resistor r=27.3797 //w=0.187 //l=0.4 //layer=li //thickness=0.1 \
 //x=10.325 //y=0.71 //x2=10.725 //y2=0.71
r79 (  13 29 ) resistor r=3.57586 //w=0.17 //l=0.103078 //layer=li \
 //thickness=0.1 //x=11.125 //y=0.71 //x2=11.21 //y2=0.67
r80 (  13 29 ) resistor r=27.3797 //w=0.187 //l=0.4 //layer=li //thickness=0.1 \
 //x=11.125 //y=0.71 //x2=10.725 //y2=0.71
r81 (  10 29 ) resistor r=3.57586 //w=0.17 //l=0.125 //layer=li \
 //thickness=0.1 //x=10.24 //y=1.675 //x2=10.24 //y2=1.8
r82 (  10 29 ) resistor r=42.0963 //w=0.187 //l=0.615 //layer=li \
 //thickness=0.1 //x=10.24 //y=1.675 //x2=10.24 //y2=1.06
r83 (  9 29 ) resistor r=3.57586 //w=0.17 //l=0.125 //layer=li //thickness=0.1 \
 //x=10.24 //y=0.795 //x2=10.24 //y2=0.67
r84 (  9 29 ) resistor r=18.139 //w=0.187 //l=0.265 //layer=li //thickness=0.1 \
 //x=10.24 //y=0.795 //x2=10.24 //y2=1.06
r85 (  6 29 ) resistor r=3.57586 //w=0.17 //l=0.103078 //layer=li \
 //thickness=0.1 //x=9.355 //y=1.76 //x2=9.27 //y2=1.8
r86 (  6 29 ) resistor r=27.3797 //w=0.187 //l=0.4 //layer=li //thickness=0.1 \
 //x=9.355 //y=1.76 //x2=9.755 //y2=1.76
r87 (  5 29 ) resistor r=3.57586 //w=0.17 //l=0.103078 //layer=li \
 //thickness=0.1 //x=10.155 //y=1.76 //x2=10.24 //y2=1.8
r88 (  5 29 ) resistor r=27.3797 //w=0.187 //l=0.4 //layer=li //thickness=0.1 \
 //x=10.155 //y=1.76 //x2=9.755 //y2=1.76
r89 (  1 29 ) resistor r=3.57586 //w=0.17 //l=0.125 //layer=li //thickness=0.1 \
 //x=9.27 //y=1.675 //x2=9.27 //y2=1.8
r90 (  1 29 ) resistor r=42.0963 //w=0.187 //l=0.615 //layer=li \
 //thickness=0.1 //x=9.27 //y=1.675 //x2=9.27 //y2=1.06
ends PM_DFFQX1\%noxref_14

subckt PM_DFFQX1\%noxref_15 ( 1 5 9 10 13 17 29 )
c66 ( 29 0 ) capacitor c=0.0675014f //x=12.465 //y=0.545
c67 ( 17 0 ) capacitor c=0.0067865f //x=14.54 //y=0.795
c68 ( 13 0 ) capacitor c=0.0157877f //x=14.455 //y=0.71
c69 ( 10 0 ) capacitor c=0.00753446f //x=13.57 //y=1.675
c70 ( 9 0 ) capacitor c=0.00770028f //x=13.57 //y=0.795
c71 ( 5 0 ) capacitor c=0.0197745f //x=13.485 //y=1.76
c72 ( 1 0 ) capacitor c=0.00821716f //x=12.6 //y=1.675
r73 (  17 29 ) resistor r=3.57586 //w=0.17 //l=0.125 //layer=li \
 //thickness=0.1 //x=14.54 //y=0.795 //x2=14.54 //y2=0.67
r74 (  17 29 ) resistor r=18.139 //w=0.187 //l=0.265 //layer=li \
 //thickness=0.1 //x=14.54 //y=0.795 //x2=14.54 //y2=1.06
r75 (  14 29 ) resistor r=3.57586 //w=0.17 //l=0.103078 //layer=li \
 //thickness=0.1 //x=13.655 //y=0.71 //x2=13.57 //y2=0.67
r76 (  14 29 ) resistor r=27.3797 //w=0.187 //l=0.4 //layer=li //thickness=0.1 \
 //x=13.655 //y=0.71 //x2=14.055 //y2=0.71
r77 (  13 29 ) resistor r=3.57586 //w=0.17 //l=0.103078 //layer=li \
 //thickness=0.1 //x=14.455 //y=0.71 //x2=14.54 //y2=0.67
r78 (  13 29 ) resistor r=27.3797 //w=0.187 //l=0.4 //layer=li //thickness=0.1 \
 //x=14.455 //y=0.71 //x2=14.055 //y2=0.71
r79 (  10 29 ) resistor r=3.57586 //w=0.17 //l=0.125 //layer=li \
 //thickness=0.1 //x=13.57 //y=1.675 //x2=13.57 //y2=1.8
r80 (  10 29 ) resistor r=42.0963 //w=0.187 //l=0.615 //layer=li \
 //thickness=0.1 //x=13.57 //y=1.675 //x2=13.57 //y2=1.06
r81 (  9 29 ) resistor r=3.57586 //w=0.17 //l=0.125 //layer=li //thickness=0.1 \
 //x=13.57 //y=0.795 //x2=13.57 //y2=0.67
r82 (  9 29 ) resistor r=18.139 //w=0.187 //l=0.265 //layer=li //thickness=0.1 \
 //x=13.57 //y=0.795 //x2=13.57 //y2=1.06
r83 (  6 29 ) resistor r=3.57586 //w=0.17 //l=0.103078 //layer=li \
 //thickness=0.1 //x=12.685 //y=1.76 //x2=12.6 //y2=1.8
r84 (  6 29 ) resistor r=27.3797 //w=0.187 //l=0.4 //layer=li //thickness=0.1 \
 //x=12.685 //y=1.76 //x2=13.085 //y2=1.76
r85 (  5 29 ) resistor r=3.57586 //w=0.17 //l=0.103078 //layer=li \
 //thickness=0.1 //x=13.485 //y=1.76 //x2=13.57 //y2=1.8
r86 (  5 29 ) resistor r=27.3797 //w=0.187 //l=0.4 //layer=li //thickness=0.1 \
 //x=13.485 //y=1.76 //x2=13.085 //y2=1.76
r87 (  1 29 ) resistor r=3.57586 //w=0.17 //l=0.125 //layer=li //thickness=0.1 \
 //x=12.6 //y=1.675 //x2=12.6 //y2=1.8
r88 (  1 29 ) resistor r=42.0963 //w=0.187 //l=0.615 //layer=li \
 //thickness=0.1 //x=12.6 //y=1.675 //x2=12.6 //y2=1.06
ends PM_DFFQX1\%noxref_15

subckt PM_DFFQX1\%noxref_16 ( 1 5 9 10 13 17 29 )
c66 ( 29 0 ) capacitor c=0.0668023f //x=15.795 //y=0.545
c67 ( 17 0 ) capacitor c=0.0067865f //x=17.87 //y=0.795
c68 ( 13 0 ) capacitor c=0.0157377f //x=17.785 //y=0.71
c69 ( 10 0 ) capacitor c=0.00911004f //x=16.9 //y=1.675
c70 ( 9 0 ) capacitor c=0.00770028f //x=16.9 //y=0.795
c71 ( 5 0 ) capacitor c=0.0232545f //x=16.815 //y=1.76
c72 ( 1 0 ) capacitor c=0.00844422f //x=15.93 //y=1.675
r73 (  17 29 ) resistor r=3.57586 //w=0.17 //l=0.125 //layer=li \
 //thickness=0.1 //x=17.87 //y=0.795 //x2=17.87 //y2=0.67
r74 (  17 29 ) resistor r=18.139 //w=0.187 //l=0.265 //layer=li \
 //thickness=0.1 //x=17.87 //y=0.795 //x2=17.87 //y2=1.06
r75 (  14 29 ) resistor r=3.57586 //w=0.17 //l=0.103078 //layer=li \
 //thickness=0.1 //x=16.985 //y=0.71 //x2=16.9 //y2=0.67
r76 (  14 29 ) resistor r=27.3797 //w=0.187 //l=0.4 //layer=li //thickness=0.1 \
 //x=16.985 //y=0.71 //x2=17.385 //y2=0.71
r77 (  13 29 ) resistor r=3.57586 //w=0.17 //l=0.103078 //layer=li \
 //thickness=0.1 //x=17.785 //y=0.71 //x2=17.87 //y2=0.67
r78 (  13 29 ) resistor r=27.3797 //w=0.187 //l=0.4 //layer=li //thickness=0.1 \
 //x=17.785 //y=0.71 //x2=17.385 //y2=0.71
r79 (  10 29 ) resistor r=3.57586 //w=0.17 //l=0.125 //layer=li \
 //thickness=0.1 //x=16.9 //y=1.675 //x2=16.9 //y2=1.8
r80 (  10 29 ) resistor r=42.0963 //w=0.187 //l=0.615 //layer=li \
 //thickness=0.1 //x=16.9 //y=1.675 //x2=16.9 //y2=1.06
r81 (  9 29 ) resistor r=3.57586 //w=0.17 //l=0.125 //layer=li //thickness=0.1 \
 //x=16.9 //y=0.795 //x2=16.9 //y2=0.67
r82 (  9 29 ) resistor r=18.139 //w=0.187 //l=0.265 //layer=li //thickness=0.1 \
 //x=16.9 //y=0.795 //x2=16.9 //y2=1.06
r83 (  6 29 ) resistor r=3.57586 //w=0.17 //l=0.103078 //layer=li \
 //thickness=0.1 //x=16.015 //y=1.76 //x2=15.93 //y2=1.8
r84 (  6 29 ) resistor r=27.3797 //w=0.187 //l=0.4 //layer=li //thickness=0.1 \
 //x=16.015 //y=1.76 //x2=16.415 //y2=1.76
r85 (  5 29 ) resistor r=3.57586 //w=0.17 //l=0.103078 //layer=li \
 //thickness=0.1 //x=16.815 //y=1.76 //x2=16.9 //y2=1.8
r86 (  5 29 ) resistor r=27.3797 //w=0.187 //l=0.4 //layer=li //thickness=0.1 \
 //x=16.815 //y=1.76 //x2=16.415 //y2=1.76
r87 (  1 29 ) resistor r=3.57586 //w=0.17 //l=0.125 //layer=li //thickness=0.1 \
 //x=15.93 //y=1.675 //x2=15.93 //y2=1.8
r88 (  1 29 ) resistor r=42.0963 //w=0.187 //l=0.615 //layer=li \
 //thickness=0.1 //x=15.93 //y=1.675 //x2=15.93 //y2=1.06
ends PM_DFFQX1\%noxref_16

subckt PM_DFFQX1\%noxref_17 ( 1 5 9 10 13 17 29 )
c61 ( 29 0 ) capacitor c=0.067837f //x=19.125 //y=0.545
c62 ( 17 0 ) capacitor c=0.00709791f //x=21.2 //y=0.795
c63 ( 13 0 ) capacitor c=0.0157477f //x=21.115 //y=0.71
c64 ( 10 0 ) capacitor c=0.00742703f //x=20.23 //y=1.675
c65 ( 9 0 ) capacitor c=0.00770028f //x=20.23 //y=0.795
c66 ( 5 0 ) capacitor c=0.0196414f //x=20.145 //y=1.76
c67 ( 1 0 ) capacitor c=0.00821716f //x=19.26 //y=1.675
r68 (  17 29 ) resistor r=3.57586 //w=0.17 //l=0.125 //layer=li \
 //thickness=0.1 //x=21.2 //y=0.795 //x2=21.2 //y2=0.67
r69 (  17 29 ) resistor r=18.139 //w=0.187 //l=0.265 //layer=li \
 //thickness=0.1 //x=21.2 //y=0.795 //x2=21.2 //y2=1.06
r70 (  14 29 ) resistor r=3.57586 //w=0.17 //l=0.103078 //layer=li \
 //thickness=0.1 //x=20.315 //y=0.71 //x2=20.23 //y2=0.67
r71 (  14 29 ) resistor r=27.3797 //w=0.187 //l=0.4 //layer=li //thickness=0.1 \
 //x=20.315 //y=0.71 //x2=20.715 //y2=0.71
r72 (  13 29 ) resistor r=3.57586 //w=0.17 //l=0.103078 //layer=li \
 //thickness=0.1 //x=21.115 //y=0.71 //x2=21.2 //y2=0.67
r73 (  13 29 ) resistor r=27.3797 //w=0.187 //l=0.4 //layer=li //thickness=0.1 \
 //x=21.115 //y=0.71 //x2=20.715 //y2=0.71
r74 (  10 29 ) resistor r=3.57586 //w=0.17 //l=0.125 //layer=li \
 //thickness=0.1 //x=20.23 //y=1.675 //x2=20.23 //y2=1.8
r75 (  10 29 ) resistor r=42.0963 //w=0.187 //l=0.615 //layer=li \
 //thickness=0.1 //x=20.23 //y=1.675 //x2=20.23 //y2=1.06
r76 (  9 29 ) resistor r=3.57586 //w=0.17 //l=0.125 //layer=li //thickness=0.1 \
 //x=20.23 //y=0.795 //x2=20.23 //y2=0.67
r77 (  9 29 ) resistor r=18.139 //w=0.187 //l=0.265 //layer=li //thickness=0.1 \
 //x=20.23 //y=0.795 //x2=20.23 //y2=1.06
r78 (  6 29 ) resistor r=3.57586 //w=0.17 //l=0.103078 //layer=li \
 //thickness=0.1 //x=19.345 //y=1.76 //x2=19.26 //y2=1.8
r79 (  6 29 ) resistor r=27.3797 //w=0.187 //l=0.4 //layer=li //thickness=0.1 \
 //x=19.345 //y=1.76 //x2=19.745 //y2=1.76
r80 (  5 29 ) resistor r=3.57586 //w=0.17 //l=0.103078 //layer=li \
 //thickness=0.1 //x=20.145 //y=1.76 //x2=20.23 //y2=1.8
r81 (  5 29 ) resistor r=27.3797 //w=0.187 //l=0.4 //layer=li //thickness=0.1 \
 //x=20.145 //y=1.76 //x2=19.745 //y2=1.76
r82 (  1 29 ) resistor r=3.57586 //w=0.17 //l=0.125 //layer=li //thickness=0.1 \
 //x=19.26 //y=1.675 //x2=19.26 //y2=1.8
r83 (  1 29 ) resistor r=42.0963 //w=0.187 //l=0.615 //layer=li \
 //thickness=0.1 //x=19.26 //y=1.675 //x2=19.26 //y2=1.06
ends PM_DFFQX1\%noxref_17
