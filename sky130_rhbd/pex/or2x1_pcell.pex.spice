// File: or2x1_pcell.spi.pex
// Created: Thu Jan 22 07:16:06 2026
// Program "Calibre xRC"
// Version "v2023.2_27.15"
// Nominal Temperature: 30C
// Circuit Temperature: 30C
//
simulator lang=spectre
subckt PM_OR2X1_PCELL\%noxref_1 ( 1 2 3 4 5 6 7 9 12 13 14 16 17 18 22 28 32 \
 36 45 47 48 56 73 82 86 87 88 89 90 91 92 96 97 98 100 106 107 109 117 118 \
 121 )
c227 ( 118 0 ) capacitor c=0.00901091f //x=1.96 //y=0.905
c228 ( 117 0 ) capacitor c=0.00876479f //x=0.99 //y=0.905
c229 ( 109 0 ) capacitor c=0.0569816f //x=4.07 //y=2.085
c230 ( 107 0 ) capacitor c=0.0439576f //x=4.71 //y=1.255
c231 ( 106 0 ) capacitor c=0.0201087f //x=4.71 //y=0.91
c232 ( 100 0 ) capacitor c=0.0161986f //x=4.555 //y=1.41
c233 ( 98 0 ) capacitor c=0.0157807f //x=4.555 //y=0.755
c234 ( 97 0 ) capacitor c=0.0557689f //x=4.3 //y=4.79
c235 ( 96 0 ) capacitor c=0.0406047f //x=4.59 //y=4.79
c236 ( 92 0 ) capacitor c=0.0301471f //x=4.18 //y=1.92
c237 ( 91 0 ) capacitor c=0.0255349f //x=4.18 //y=1.565
c238 ( 90 0 ) capacitor c=0.0234346f //x=4.18 //y=1.255
c239 ( 89 0 ) capacitor c=0.02013f //x=4.18 //y=0.91
c240 ( 88 0 ) capacitor c=0.153839f //x=4.665 //y=6.02
c241 ( 87 0 ) capacitor c=0.15434f //x=4.225 //y=6.02
c242 ( 82 0 ) capacitor c=9.45276e-19 //x=4.07 //y=4.7
c243 ( 73 0 ) capacitor c=9.11699e-19 //x=4.07 //y=2.085
c244 ( 56 0 ) capacitor c=0.0246448f //x=2.11 //y=5.38
c245 ( 48 0 ) capacitor c=0.0605885f //x=3.91 //y=3.335
c246 ( 47 0 ) capacitor c=0.00395551f //x=4.07 //y=3.335
c247 ( 45 0 ) capacitor c=0.00534125f //x=2.75 //y=3.335
c248 ( 36 0 ) capacitor c=0.0113219f //x=4.07 //y=2.085
c249 ( 32 0 ) capacitor c=0.0162474f //x=4.07 //y=3.33
c250 ( 28 0 ) capacitor c=0.0168579f //x=2.59 //y=3.33
c251 ( 22 0 ) capacitor c=0.0134899f //x=2.105 //y=5.21
c252 ( 21 0 ) capacitor c=0.00513603f //x=2.15 //y=1.655
c253 ( 18 0 ) capacitor c=0.0346423f //x=4.07 //y=4.58
c254 ( 17 0 ) capacitor c=0.011581f //x=4.07 //y=3.495
c255 ( 16 0 ) capacitor c=0.0241673f //x=4.07 //y=3.175
c256 ( 14 0 ) capacitor c=0.0450244f //x=2.59 //y=5.125
c257 ( 13 0 ) capacitor c=0.011822f //x=2.59 //y=3.495
c258 ( 12 0 ) capacitor c=0.038167f //x=2.59 //y=3.175
c259 ( 9 0 ) capacitor c=0.014332f //x=2.505 //y=1.655
c260 ( 7 0 ) capacitor c=0.0108096f //x=2.505 //y=5.21
c261 ( 6 0 ) capacitor c=0.00690516f //x=2.15 //y=1.57
c262 ( 5 0 ) capacitor c=0.00824318f //x=2.15 //y=1.12
c263 ( 4 0 ) capacitor c=0.00472589f //x=1.265 //y=1.655
c264 ( 3 0 ) capacitor c=0.0217217f //x=2.065 //y=1.655
c265 ( 2 0 ) capacitor c=0.0106027f //x=1.18 //y=1.57
c266 ( 1 0 ) capacitor c=0.0116519f //x=1.18 //y=1.125
r267 (  109 110 ) resistor r=17.5563 //w=0.302 //l=0.11 //layer=ply \
 //thickness=0.18 //x=4.07 //y=2.085 //x2=4.18 //y2=2.085
r268 (  107 116 ) resistor r=45.1352 //w=0.168 //l=0.173853 //layer=ply \
 //thickness=0.18 //x=4.71 //y=1.255 //x2=4.67 //y2=1.41
r269 (  106 115 ) resistor r=45.1352 //w=0.168 //l=0.173853 //layer=ply \
 //thickness=0.18 //x=4.71 //y=0.91 //x2=4.67 //y2=0.755
r270 (  106 107 ) resistor r=176.904 //w=0.094 //l=0.345 //layer=ply \
 //thickness=0.18 //x=4.71 //y=0.91 //x2=4.71 //y2=1.255
r271 (  101 114 ) resistor r=10.701 //w=0.21 //l=0.115 //layer=ply \
 //thickness=0.18 //x=4.335 //y=1.41 //x2=4.22 //y2=1.41
r272 (  100 116 ) resistor r=5.52526 //w=0.168 //l=0.115 //layer=ply \
 //thickness=0.18 //x=4.555 //y=1.41 //x2=4.67 //y2=1.41
r273 (  99 113 ) resistor r=5.52526 //w=0.168 //l=0.115 //layer=ply \
 //thickness=0.18 //x=4.335 //y=0.755 //x2=4.22 //y2=0.755
r274 (  98 115 ) resistor r=5.52526 //w=0.168 //l=0.115 //layer=ply \
 //thickness=0.18 //x=4.555 //y=0.755 //x2=4.67 //y2=0.755
r275 (  98 99 ) resistor r=112.809 //w=0.094 //l=0.22 //layer=ply \
 //thickness=0.18 //x=4.555 //y=0.755 //x2=4.335 //y2=0.755
r276 (  96 103 ) resistor r=26.9307 //w=0.15 //l=0.106066 //layer=ply \
 //thickness=0.18 //x=4.59 //y=4.79 //x2=4.665 //y2=4.865
r277 (  96 97 ) resistor r=148.702 //w=0.094 //l=0.29 //layer=ply \
 //thickness=0.18 //x=4.59 //y=4.79 //x2=4.3 //y2=4.79
r278 (  93 97 ) resistor r=23.403 //w=0.284 //l=0.106066 //layer=ply \
 //thickness=0.18 //x=4.225 //y=4.865 //x2=4.3 //y2=4.79
r279 (  93 112 ) resistor r=26.3063 //w=0.284 //l=0.229783 //layer=ply \
 //thickness=0.18 //x=4.225 //y=4.865 //x2=4.07 //y2=4.7
r280 (  92 110 ) resistor r=19.1248 //w=0.302 //l=0.165 //layer=ply \
 //thickness=0.18 //x=4.18 //y=1.92 //x2=4.18 //y2=2.085
r281 (  91 114 ) resistor r=39.5823 //w=0.21 //l=0.173853 //layer=ply \
 //thickness=0.18 //x=4.18 //y=1.565 //x2=4.22 //y2=1.41
r282 (  91 92 ) resistor r=182.032 //w=0.094 //l=0.355 //layer=ply \
 //thickness=0.18 //x=4.18 //y=1.565 //x2=4.18 //y2=1.92
r283 (  90 114 ) resistor r=39.5823 //w=0.21 //l=0.173853 //layer=ply \
 //thickness=0.18 //x=4.18 //y=1.255 //x2=4.22 //y2=1.41
r284 (  89 113 ) resistor r=45.1352 //w=0.168 //l=0.173853 //layer=ply \
 //thickness=0.18 //x=4.18 //y=0.91 //x2=4.22 //y2=0.755
r285 (  89 90 ) resistor r=176.904 //w=0.094 //l=0.345 //layer=ply \
 //thickness=0.18 //x=4.18 //y=0.91 //x2=4.18 //y2=1.255
r286 (  88 103 ) resistor r=592.245 //w=0.094 //l=1.155 //layer=ply \
 //thickness=0.18 //x=4.665 //y=6.02 //x2=4.665 //y2=4.865
r287 (  87 93 ) resistor r=592.245 //w=0.094 //l=1.155 //layer=ply \
 //thickness=0.18 //x=4.225 //y=6.02 //x2=4.225 //y2=4.865
r288 (  86 100 ) resistor r=56.4043 //w=0.094 //l=0.11 //layer=ply \
 //thickness=0.18 //x=4.445 //y=1.41 //x2=4.555 //y2=1.41
r289 (  86 101 ) resistor r=56.4043 //w=0.094 //l=0.11 //layer=ply \
 //thickness=0.18 //x=4.445 //y=1.41 //x2=4.335 //y2=1.41
r290 (  82 112 ) resistor r=152 //w=0.17 //l=0.17 //layer=licon //count=1 \
 //x=4.07 //y=4.7 //x2=4.07 //y2=4.7
r291 (  73 109 ) resistor r=152 //w=0.17 //l=0.17 //layer=licon //count=1 \
 //x=4.07 //y=2.085 //x2=4.07 //y2=2.085
r292 (  56 121 ) resistor r=23.2727 //w=0.187 //l=0.34 //layer=li \
 //thickness=0.1 //x=2.11 //y=5.38 //x2=2.11 //y2=5.72
r293 (  47 48 ) resistor r=0.10734 //w=0.281 //l=0.16 //layer=m2 \
 //thickness=0.36 //x=4.07 //y=3.335 //x2=3.91 //y2=3.335
r294 (  45 48 ) resistor r=1.10687 //w=0.131 //l=1.16 //layer=m2 \
 //thickness=0.36 //x=2.75 //y=3.33 //x2=3.91 //y2=3.33
r295 (  43 45 ) resistor r=0.10734 //w=0.281 //l=0.16 //layer=m2 \
 //thickness=0.36 //x=2.59 //y=3.335 //x2=2.75 //y2=3.335
r296 (  39 82 ) resistor r=9.3 //w=0.17 //l=0.17 //layer=mcon //count=1 \
 //x=4.07 //y=4.7 //x2=4.07 //y2=4.7
r297 (  36 73 ) resistor r=9.3 //w=0.17 //l=0.17 //layer=mcon //count=1 \
 //x=4.07 //y=2.085 //x2=4.07 //y2=2.085
r298 (  34 47 ) resistor r=4.5 //w=0.15 //l=0.15 //layer=via1 //count=1 \
 //x=4.07 //y=3.335 //x2=4.07 //y2=3.335
r299 (  32 34 ) resistor r=0.00166223 //w=0.376 //l=0.005 //layer=m1 \
 //thickness=0.36 //x=4.017 //y=3.33 //x2=4.017 //y2=3.335
r300 (  30 43 ) resistor r=4.5 //w=0.15 //l=0.15 //layer=via1 //count=1 \
 //x=2.59 //y=3.335 //x2=2.59 //y2=3.335
r301 (  28 30 ) resistor r=0.00166223 //w=0.376 //l=0.005 //layer=m1 \
 //thickness=0.36 //x=2.642 //y=3.33 //x2=2.642 //y2=3.335
r302 (  26 118 ) resistor r=9.3 //w=0.17 //l=0.17 //layer=mcon //count=1 \
 //x=2.15 //y=1 //x2=2.15 //y2=1
r303 (  24 56 ) resistor r=9.3 //w=0.17 //l=0.17 //layer=mcon //count=1 \
 //x=2.11 //y=5.38 //x2=2.11 //y2=5.38
r304 (  22 24 ) resistor r=0.0974771 //w=0.218 //l=0.17 //layer=m1 \
 //thickness=0.36 //x=2.105 //y=5.21 //x2=2.105 //y2=5.38
r305 (  20 117 ) resistor r=9.3 //w=0.17 //l=0.17 //layer=mcon //count=1 \
 //x=1.18 //y=1 //x2=1.18 //y2=1
r306 (  18 39 ) resistor r=0.0732479 //w=0.241 //l=0.122474 //layer=m1 \
 //thickness=0.36 //x=4.07 //y=4.58 //x2=4.075 //y2=4.7
r307 (  17 34 ) resistor r=0.0911593 //w=0.376 //l=0.184608 //layer=m1 \
 //thickness=0.36 //x=4.07 //y=3.495 //x2=4.017 //y2=3.335
r308 (  17 18 ) resistor r=1.03531 //w=0.131 //l=1.085 //layer=m1 \
 //thickness=0.36 //x=4.07 //y=3.495 //x2=4.07 //y2=4.58
r309 (  16 32 ) resistor r=0.0894971 //w=0.376 //l=0.179555 //layer=m1 \
 //thickness=0.36 //x=4.07 //y=3.175 //x2=4.017 //y2=3.33
r310 (  15 36 ) resistor r=0.116051 //w=0.211 //l=0.165 //layer=m1 \
 //thickness=0.36 //x=4.07 //y=2.25 //x2=4.07 //y2=2.085
r311 (  15 16 ) resistor r=0.882634 //w=0.131 //l=0.925 //layer=m1 \
 //thickness=0.36 //x=4.07 //y=2.25 //x2=4.07 //y2=3.175
r312 (  13 30 ) resistor r=0.0911593 //w=0.376 //l=0.184174 //layer=m1 \
 //thickness=0.36 //x=2.59 //y=3.495 //x2=2.642 //y2=3.335
r313 (  13 14 ) resistor r=1.55534 //w=0.131 //l=1.63 //layer=m1 \
 //thickness=0.36 //x=2.59 //y=3.495 //x2=2.59 //y2=5.125
r314 (  12 28 ) resistor r=0.0894971 //w=0.376 //l=0.179123 //layer=m1 \
 //thickness=0.36 //x=2.59 //y=3.175 //x2=2.642 //y2=3.33
r315 (  11 12 ) resistor r=1.36927 //w=0.131 //l=1.435 //layer=m1 \
 //thickness=0.36 //x=2.59 //y=1.74 //x2=2.59 //y2=3.175
r316 (  10 21 ) resistor r=0.0529306 //w=0.17 //l=0.085 //layer=m1 \
 //thickness=0.36 //x=2.235 //y=1.655 //x2=2.15 //y2=1.655
r317 (  9 11 ) resistor r=0.0698411 //w=0.17 //l=0.120208 //layer=m1 \
 //thickness=0.36 //x=2.505 //y=1.655 //x2=2.59 //y2=1.74
r318 (  9 10 ) resistor r=0.257634 //w=0.131 //l=0.27 //layer=m1 \
 //thickness=0.36 //x=2.505 //y=1.655 //x2=2.235 //y2=1.655
r319 (  8 22 ) resistor r=0.0225019 //w=0.218 //l=0.12 //layer=m1 \
 //thickness=0.36 //x=2.225 //y=5.21 //x2=2.105 //y2=5.21
r320 (  7 14 ) resistor r=0.0698411 //w=0.17 //l=0.120208 //layer=m1 \
 //thickness=0.36 //x=2.505 //y=5.21 //x2=2.59 //y2=5.125
r321 (  7 8 ) resistor r=0.267176 //w=0.131 //l=0.28 //layer=m1 \
 //thickness=0.36 //x=2.505 //y=5.21 //x2=2.225 //y2=5.21
r322 (  6 21 ) resistor r=0.0137558 //w=0.34 //l=0.085 //layer=m1 \
 //thickness=0.36 //x=2.15 //y=1.57 //x2=2.15 //y2=1.655
r323 (  5 26 ) resistor r=0.0728765 //w=0.25 //l=0.121491 //layer=m1 \
 //thickness=0.36 //x=2.15 //y=1.12 //x2=2.147 //y2=1
r324 (  5 6 ) resistor r=0.429389 //w=0.131 //l=0.45 //layer=m1 \
 //thickness=0.36 //x=2.15 //y=1.12 //x2=2.15 //y2=1.57
r325 (  3 21 ) resistor r=0.0529306 //w=0.17 //l=0.085 //layer=m1 \
 //thickness=0.36 //x=2.065 //y=1.655 //x2=2.15 //y2=1.655
r326 (  3 4 ) resistor r=0.763359 //w=0.131 //l=0.8 //layer=m1 \
 //thickness=0.36 //x=2.065 //y=1.655 //x2=1.265 //y2=1.655
r327 (  2 4 ) resistor r=0.0698411 //w=0.17 //l=0.120208 //layer=m1 \
 //thickness=0.36 //x=1.18 //y=1.57 //x2=1.265 //y2=1.655
r328 (  1 20 ) resistor r=0.0764279 //w=0.233 //l=0.126491 //layer=m1 \
 //thickness=0.36 //x=1.18 //y=1.125 //x2=1.177 //y2=1
r329 (  1 2 ) resistor r=0.424618 //w=0.131 //l=0.445 //layer=m1 \
 //thickness=0.36 //x=1.18 //y=1.125 //x2=1.18 //y2=1.57
ends PM_OR2X1_PCELL\%noxref_1

subckt PM_OR2X1_PCELL\%noxref_2 ( 11 25 39 63 67 78 82 91 102 103 )
c98 ( 103 0 ) capacitor c=0.0652465f //x=3.825 //y=0.37
c99 ( 102 0 ) capacitor c=0.0777045f //x=0.56 //y=0.365
c100 ( 91 0 ) capacitor c=0.112821f //x=3.33 //y=0
c101 ( 88 0 ) capacitor c=0.00591168f //x=2.635 //y=0
c102 ( 85 0 ) capacitor c=0.00591168f //x=1.665 //y=0
c103 ( 82 0 ) capacitor c=0.212601f //x=0.74 //y=0
c104 ( 78 0 ) capacitor c=0.203119f //x=5.18 //y=0
c105 ( 76 0 ) capacitor c=0.0360826f //x=5.015 //y=0
c106 ( 70 0 ) capacitor c=0.00589014f //x=4.93 //y=0.45
c107 ( 67 0 ) capacitor c=0.00625302f //x=4.845 //y=0.535
c108 ( 66 0 ) capacitor c=0.00479851f //x=4.44 //y=0.45
c109 ( 63 0 ) capacitor c=0.00647662f //x=4.355 //y=0.535
c110 ( 58 0 ) capacitor c=0.00590583f //x=3.96 //y=0.45
c111 ( 55 0 ) capacitor c=0.0189058f //x=3.875 //y=0
c112 ( 49 0 ) capacitor c=0.0221419f //x=3.16 //y=0
c113 ( 44 0 ) capacitor c=0.00739123f //x=2.635 //y=0.445
c114 ( 39 0 ) capacitor c=0.0152893f //x=2.55 //y=0.53
c115 ( 35 0 ) capacitor c=0.0253251f //x=2.55 //y=0
c116 ( 30 0 ) capacitor c=0.00726869f //x=1.665 //y=0.445
c117 ( 25 0 ) capacitor c=0.0171409f //x=1.58 //y=0.53
c118 ( 23 0 ) capacitor c=0.025309f //x=1.58 //y=0
c119 ( 18 0 ) capacitor c=0.00739123f //x=0.695 //y=0.445
c120 ( 11 0 ) capacitor c=0.22176f //x=5.18 //y=0
r121 (  94 95 ) resistor r=17.5686 //w=0.357 //l=0.49 //layer=li \
 //thickness=0.1 //x=4.44 //y=0 //x2=4.93 //y2=0
r122 (  92 94 ) resistor r=17.2101 //w=0.357 //l=0.48 //layer=li \
 //thickness=0.1 //x=3.96 //y=0 //x2=4.44 //y2=0
r123 (  76 95 ) resistor r=3.04762 //w=0.357 //l=0.085 //layer=li \
 //thickness=0.1 //x=5.015 //y=0 //x2=4.93 //y2=0
r124 (  76 78 ) resistor r=5.91597 //w=0.357 //l=0.165 //layer=li \
 //thickness=0.1 //x=5.015 //y=0 //x2=5.18 //y2=0
r125 (  71 103 ) resistor r=5.4201 //w=0.17 //l=0.085 //layer=li \
 //thickness=0.1 //x=4.93 //y=0.62 //x2=4.93 //y2=0.535
r126 (  71 103 ) resistor r=41.4118 //w=0.187 //l=0.605 //layer=li \
 //thickness=0.1 //x=4.93 //y=0.62 //x2=4.93 //y2=1.225
r127 (  70 103 ) resistor r=5.4201 //w=0.17 //l=0.085 //layer=li \
 //thickness=0.1 //x=4.93 //y=0.45 //x2=4.93 //y2=0.535
r128 (  69 95 ) resistor r=5.03728 //w=0.34 //l=0.17 //layer=li \
 //thickness=0.1 //x=4.93 //y=0.17 //x2=4.93 //y2=0
r129 (  69 70 ) resistor r=19.1658 //w=0.187 //l=0.28 //layer=li \
 //thickness=0.1 //x=4.93 //y=0.17 //x2=4.93 //y2=0.45
r130 (  68 103 ) resistor r=5.4201 //w=0.17 //l=0.085 //layer=li \
 //thickness=0.1 //x=4.525 //y=0.535 //x2=4.44 //y2=0.535
r131 (  67 103 ) resistor r=1.40859 //w=0.34 //l=0.085 //layer=li \
 //thickness=0.1 //x=4.845 //y=0.535 //x2=4.93 //y2=0.535
r132 (  67 68 ) resistor r=21.9037 //w=0.187 //l=0.32 //layer=li \
 //thickness=0.1 //x=4.845 //y=0.535 //x2=4.525 //y2=0.535
r133 (  66 103 ) resistor r=1.40859 //w=0.34 //l=0.085 //layer=li \
 //thickness=0.1 //x=4.44 //y=0.45 //x2=4.44 //y2=0.535
r134 (  65 94 ) resistor r=5.03728 //w=0.34 //l=0.17 //layer=li \
 //thickness=0.1 //x=4.44 //y=0.17 //x2=4.44 //y2=0
r135 (  65 66 ) resistor r=19.1658 //w=0.187 //l=0.28 //layer=li \
 //thickness=0.1 //x=4.44 //y=0.17 //x2=4.44 //y2=0.45
r136 (  64 103 ) resistor r=1.40859 //w=0.34 //l=0.085 //layer=li \
 //thickness=0.1 //x=4.045 //y=0.535 //x2=3.96 //y2=0.535
r137 (  63 103 ) resistor r=5.4201 //w=0.17 //l=0.085 //layer=li \
 //thickness=0.1 //x=4.355 //y=0.535 //x2=4.44 //y2=0.535
r138 (  63 64 ) resistor r=21.2193 //w=0.187 //l=0.31 //layer=li \
 //thickness=0.1 //x=4.355 //y=0.535 //x2=4.045 //y2=0.535
r139 (  59 103 ) resistor r=5.4201 //w=0.17 //l=0.085 //layer=li \
 //thickness=0.1 //x=3.96 //y=0.62 //x2=3.96 //y2=0.535
r140 (  59 103 ) resistor r=41.4118 //w=0.187 //l=0.605 //layer=li \
 //thickness=0.1 //x=3.96 //y=0.62 //x2=3.96 //y2=1.225
r141 (  58 103 ) resistor r=5.4201 //w=0.17 //l=0.085 //layer=li \
 //thickness=0.1 //x=3.96 //y=0.45 //x2=3.96 //y2=0.535
r142 (  57 92 ) resistor r=5.03728 //w=0.34 //l=0.17 //layer=li \
 //thickness=0.1 //x=3.96 //y=0.17 //x2=3.96 //y2=0
r143 (  57 58 ) resistor r=19.1658 //w=0.187 //l=0.28 //layer=li \
 //thickness=0.1 //x=3.96 //y=0.17 //x2=3.96 //y2=0.45
r144 (  56 91 ) resistor r=5.4201 //w=0.34 //l=0.17 //layer=li //thickness=0.1 \
 //x=3.5 //y=0 //x2=3.33 //y2=0
r145 (  55 92 ) resistor r=3.04762 //w=0.357 //l=0.085 //layer=li \
 //thickness=0.1 //x=3.875 //y=0 //x2=3.96 //y2=0
r146 (  55 56 ) resistor r=13.4454 //w=0.357 //l=0.375 //layer=li \
 //thickness=0.1 //x=3.875 //y=0 //x2=3.5 //y2=0
r147 (  50 88 ) resistor r=2.94794 //w=0.34 //l=0.085 //layer=li \
 //thickness=0.1 //x=2.72 //y=0 //x2=2.635 //y2=0
r148 (  50 52 ) resistor r=8.60504 //w=0.357 //l=0.24 //layer=li \
 //thickness=0.1 //x=2.72 //y=0 //x2=2.96 //y2=0
r149 (  49 91 ) resistor r=5.4201 //w=0.34 //l=0.17 //layer=li //thickness=0.1 \
 //x=3.16 //y=0 //x2=3.33 //y2=0
r150 (  49 52 ) resistor r=7.17087 //w=0.357 //l=0.2 //layer=li \
 //thickness=0.1 //x=3.16 //y=0 //x2=2.96 //y2=0
r151 (  45 102 ) resistor r=5.4201 //w=0.17 //l=0.085 //layer=li \
 //thickness=0.1 //x=2.635 //y=0.615 //x2=2.635 //y2=0.53
r152 (  45 102 ) resistor r=18.139 //w=0.187 //l=0.265 //layer=li \
 //thickness=0.1 //x=2.635 //y=0.615 //x2=2.635 //y2=0.88
r153 (  44 102 ) resistor r=5.4201 //w=0.17 //l=0.085 //layer=li \
 //thickness=0.1 //x=2.635 //y=0.445 //x2=2.635 //y2=0.53
r154 (  43 88 ) resistor r=4.11603 //w=0.68 //l=0.17 //layer=li \
 //thickness=0.1 //x=2.635 //y=0.17 //x2=2.635 //y2=0
r155 (  43 44 ) resistor r=18.8235 //w=0.187 //l=0.275 //layer=li \
 //thickness=0.1 //x=2.635 //y=0.17 //x2=2.635 //y2=0.445
r156 (  40 102 ) resistor r=6.4 //w=0.17 //l=0.085 //layer=li //thickness=0.1 \
 //x=1.75 //y=0.53 //x2=1.665 //y2=0.53
r157 (  40 102 ) resistor r=27.3797 //w=0.187 //l=0.4 //layer=li \
 //thickness=0.1 //x=1.75 //y=0.53 //x2=2.15 //y2=0.53
r158 (  39 102 ) resistor r=1.40859 //w=0.34 //l=0.085 //layer=li \
 //thickness=0.1 //x=2.55 //y=0.53 //x2=2.635 //y2=0.53
r159 (  39 102 ) resistor r=27.3797 //w=0.187 //l=0.4 //layer=li \
 //thickness=0.1 //x=2.55 //y=0.53 //x2=2.15 //y2=0.53
r160 (  36 85 ) resistor r=2.94794 //w=0.34 //l=0.085 //layer=li \
 //thickness=0.1 //x=1.75 //y=0 //x2=1.665 //y2=0
r161 (  36 38 ) resistor r=3.58543 //w=0.357 //l=0.1 //layer=li \
 //thickness=0.1 //x=1.75 //y=0 //x2=1.85 //y2=0
r162 (  35 88 ) resistor r=2.94794 //w=0.34 //l=0.085 //layer=li \
 //thickness=0.1 //x=2.55 //y=0 //x2=2.635 //y2=0
r163 (  35 38 ) resistor r=25.098 //w=0.357 //l=0.7 //layer=li //thickness=0.1 \
 //x=2.55 //y=0 //x2=1.85 //y2=0
r164 (  31 102 ) resistor r=6.4 //w=0.17 //l=0.085 //layer=li //thickness=0.1 \
 //x=1.665 //y=0.615 //x2=1.665 //y2=0.53
r165 (  31 102 ) resistor r=18.139 //w=0.187 //l=0.265 //layer=li \
 //thickness=0.1 //x=1.665 //y=0.615 //x2=1.665 //y2=0.88
r166 (  30 102 ) resistor r=6.4 //w=0.17 //l=0.085 //layer=li //thickness=0.1 \
 //x=1.665 //y=0.445 //x2=1.665 //y2=0.53
r167 (  29 85 ) resistor r=4.11603 //w=0.68 //l=0.17 //layer=li \
 //thickness=0.1 //x=1.665 //y=0.17 //x2=1.665 //y2=0
r168 (  29 30 ) resistor r=18.8235 //w=0.187 //l=0.275 //layer=li \
 //thickness=0.1 //x=1.665 //y=0.17 //x2=1.665 //y2=0.445
r169 (  26 102 ) resistor r=1.40859 //w=0.34 //l=0.085 //layer=li \
 //thickness=0.1 //x=0.78 //y=0.53 //x2=0.695 //y2=0.53
r170 (  26 102 ) resistor r=27.3797 //w=0.187 //l=0.4 //layer=li \
 //thickness=0.1 //x=0.78 //y=0.53 //x2=1.18 //y2=0.53
r171 (  25 102 ) resistor r=6.4 //w=0.17 //l=0.085 //layer=li //thickness=0.1 \
 //x=1.58 //y=0.53 //x2=1.665 //y2=0.53
r172 (  25 102 ) resistor r=27.3797 //w=0.187 //l=0.4 //layer=li \
 //thickness=0.1 //x=1.58 //y=0.53 //x2=1.18 //y2=0.53
r173 (  24 82 ) resistor r=2.94794 //w=0.34 //l=0.085 //layer=li \
 //thickness=0.1 //x=0.78 //y=0 //x2=0.695 //y2=0
r174 (  23 85 ) resistor r=2.94794 //w=0.34 //l=0.085 //layer=li \
 //thickness=0.1 //x=1.58 //y=0 //x2=1.665 //y2=0
r175 (  23 24 ) resistor r=28.6835 //w=0.357 //l=0.8 //layer=li \
 //thickness=0.1 //x=1.58 //y=0 //x2=0.78 //y2=0
r176 (  19 102 ) resistor r=5.4201 //w=0.17 //l=0.085 //layer=li \
 //thickness=0.1 //x=0.695 //y=0.615 //x2=0.695 //y2=0.53
r177 (  19 102 ) resistor r=41.4118 //w=0.187 //l=0.605 //layer=li \
 //thickness=0.1 //x=0.695 //y=0.615 //x2=0.695 //y2=1.22
r178 (  18 102 ) resistor r=5.4201 //w=0.17 //l=0.085 //layer=li \
 //thickness=0.1 //x=0.695 //y=0.445 //x2=0.695 //y2=0.53
r179 (  17 82 ) resistor r=4.11603 //w=0.68 //l=0.17 //layer=li \
 //thickness=0.1 //x=0.695 //y=0.17 //x2=0.695 //y2=0
r180 (  17 18 ) resistor r=18.8235 //w=0.187 //l=0.275 //layer=li \
 //thickness=0.1 //x=0.695 //y=0.17 //x2=0.695 //y2=0.445
r181 (  11 78 ) resistor r=9.3 //w=0.17 //l=0.17 //layer=mcon //count=1 \
 //x=5.18 //y=0 //x2=5.18 //y2=0
r182 (  9 94 ) resistor r=3.1 //w=0.17 //l=0.51 //layer=mcon //count=3 \
 //x=4.44 //y=0 //x2=4.44 //y2=0
r183 (  9 11 ) resistor r=0.307309 //w=0.301 //l=0.74 //layer=m1 \
 //thickness=0.36 //x=4.44 //y=0 //x2=5.18 //y2=0
r184 (  7 52 ) resistor r=3.1 //w=0.17 //l=0.51 //layer=mcon //count=3 \
 //x=2.96 //y=0 //x2=2.96 //y2=0
r185 (  7 9 ) resistor r=0.614618 //w=0.301 //l=1.48 //layer=m1 \
 //thickness=0.36 //x=2.96 //y=0 //x2=4.44 //y2=0
r186 (  5 38 ) resistor r=3.1 //w=0.17 //l=0.51 //layer=mcon //count=3 \
 //x=1.85 //y=0 //x2=1.85 //y2=0
r187 (  5 7 ) resistor r=0.460963 //w=0.301 //l=1.11 //layer=m1 \
 //thickness=0.36 //x=1.85 //y=0 //x2=2.96 //y2=0
r188 (  2 82 ) resistor r=3.1 //w=0.17 //l=0.51 //layer=mcon //count=3 \
 //x=0.74 //y=0 //x2=0.74 //y2=0
r189 (  2 5 ) resistor r=0.460963 //w=0.301 //l=1.11 //layer=m1 \
 //thickness=0.36 //x=0.74 //y=0 //x2=1.85 //y2=0
ends PM_OR2X1_PCELL\%noxref_2

subckt PM_OR2X1_PCELL\%noxref_3 ( 1 3 5 10 14 17 20 30 46 47 48 )
c89 ( 48 0 ) capacitor c=0.0349726f //x=2.405 //y=5.025
c90 ( 46 0 ) capacitor c=0.0118024f //x=0.655 //y=5.025
c91 ( 30 0 ) capacitor c=0.0303466f //x=1.67 //y=5.38
c92 ( 20 0 ) capacitor c=0.0436664f //x=0.79 //y=5.38
c93 ( 17 0 ) capacitor c=0.0163612f //x=2.55 //y=6.74
c94 ( 14 0 ) capacitor c=0.00604334f //x=1.67 //y=6.74
c95 ( 10 0 ) capacitor c=0.0109996f //x=1.67 //y=5.21
c96 ( 5 0 ) capacitor c=0.0174235f //x=0.79 //y=5.21
c97 ( 3 0 ) capacitor c=0.00694548f //x=2.42 //y=6.91
c98 ( 1 0 ) capacitor c=0.0134808f //x=1.55 //y=5.21
r99 (  37 47 ) resistor r=23.2727 //w=0.187 //l=0.34 //layer=li \
 //thickness=0.1 //x=1.67 //y=6.74 //x2=1.67 //y2=6.4
r100 (  30 47 ) resistor r=23.2727 //w=0.187 //l=0.34 //layer=li \
 //thickness=0.1 //x=1.67 //y=5.38 //x2=1.67 //y2=5.72
r101 (  20 46 ) resistor r=23.2727 //w=0.187 //l=0.34 //layer=li \
 //thickness=0.1 //x=0.79 //y=5.38 //x2=0.79 //y2=5.72
r102 (  17 48 ) resistor r=9.3 //w=0.17 //l=0.17 //layer=mcon //count=1 \
 //x=2.55 //y=6.74 //x2=2.55 //y2=6.74
r103 (  17 18 ) resistor r=0.0932018 //w=0.228 //l=0.17 //layer=m1 \
 //thickness=0.36 //x=2.542 //y=6.74 //x2=2.542 //y2=6.91
r104 (  14 37 ) resistor r=9.3 //w=0.17 //l=0.17 //layer=mcon //count=1 \
 //x=1.67 //y=6.74 //x2=1.67 //y2=6.74
r105 (  14 15 ) resistor r=0.0992991 //w=0.214 //l=0.17 //layer=m1 \
 //thickness=0.36 //x=1.67 //y=6.74 //x2=1.67 //y2=6.91
r106 (  12 30 ) resistor r=9.3 //w=0.17 //l=0.17 //layer=mcon //count=1 \
 //x=1.67 //y=5.38 //x2=1.67 //y2=5.38
r107 (  10 12 ) resistor r=0.097032 //w=0.219 //l=0.17 //layer=m1 \
 //thickness=0.36 //x=1.67 //y=5.21 //x2=1.67 //y2=5.38
r108 (  7 20 ) resistor r=9.3 //w=0.17 //l=0.17 //layer=mcon //count=1 \
 //x=0.79 //y=5.38 //x2=0.79 //y2=5.38
r109 (  5 7 ) resistor r=0.0997653 //w=0.213 //l=0.17 //layer=m1 \
 //thickness=0.36 //x=0.79 //y=5.21 //x2=0.79 //y2=5.38
r110 (  4 15 ) resistor r=0.0213909 //w=0.214 //l=0.115 //layer=m1 \
 //thickness=0.36 //x=1.785 //y=6.91 //x2=1.67 //y2=6.91
r111 (  3 18 ) resistor r=0.0251868 //w=0.228 //l=0.122 //layer=m1 \
 //thickness=0.36 //x=2.42 //y=6.91 //x2=2.542 //y2=6.91
r112 (  3 4 ) resistor r=0.605916 //w=0.131 //l=0.635 //layer=m1 \
 //thickness=0.36 //x=2.42 //y=6.91 //x2=1.785 //y2=6.91
r113 (  2 5 ) resistor r=0.0211096 //w=0.213 //l=0.115 //layer=m1 \
 //thickness=0.36 //x=0.905 //y=5.21 //x2=0.79 //y2=5.21
r114 (  1 10 ) resistor r=0.0227762 //w=0.219 //l=0.12 //layer=m1 \
 //thickness=0.36 //x=1.55 //y=5.21 //x2=1.67 //y2=5.21
r115 (  1 2 ) resistor r=0.615458 //w=0.131 //l=0.645 //layer=m1 \
 //thickness=0.36 //x=1.55 //y=5.21 //x2=0.905 //y2=5.21
ends PM_OR2X1_PCELL\%noxref_3

subckt PM_OR2X1_PCELL\%noxref_4 ( 2 4 8 11 16 20 21 22 23 24 25 26 30 32 35 37 \
 38 43 )
c115 ( 43 0 ) capacitor c=0.0426341f //x=0.955 //y=4.705
c116 ( 38 0 ) capacitor c=0.0337825f //x=1.445 //y=1.25
c117 ( 37 0 ) capacitor c=0.0183823f //x=1.445 //y=0.905
c118 ( 35 0 ) capacitor c=0.0350928f //x=1.375 //y=4.795
c119 ( 32 0 ) capacitor c=0.013578f //x=1.29 //y=1.405
c120 ( 30 0 ) capacitor c=0.0157803f //x=1.29 //y=0.75
c121 ( 26 0 ) capacitor c=0.085272f //x=0.915 //y=1.915
c122 ( 25 0 ) capacitor c=0.0230165f //x=0.915 //y=1.56
c123 ( 24 0 ) capacitor c=0.0234348f //x=0.915 //y=1.25
c124 ( 23 0 ) capacitor c=0.019134f //x=0.915 //y=0.905
c125 ( 22 0 ) capacitor c=0.110994f //x=1.45 //y=6.025
c126 ( 21 0 ) capacitor c=0.154777f //x=1.01 //y=6.025
c127 ( 16 0 ) capacitor c=0.00174733f //x=1.11 //y=2.08
c128 ( 11 0 ) capacitor c=0.00705226f //x=0.955 //y=4.705
c129 ( 8 0 ) capacitor c=0.0166604f //x=0.955 //y=4.705
c130 ( 4 0 ) capacitor c=0.0119141f //x=1.11 //y=2.08
c131 ( 2 0 ) capacitor c=0.106096f //x=1.11 //y=4.585
r132 (  45 46 ) resistor r=32.4568 //w=0.214 //l=0.075 //layer=ply \
 //thickness=0.18 //x=0.955 //y=4.795 //x2=0.955 //y2=4.87
r133 (  43 45 ) resistor r=20.271 //w=0.214 //l=0.09 //layer=ply \
 //thickness=0.18 //x=0.955 //y=4.705 //x2=0.955 //y2=4.795
r134 (  38 52 ) resistor r=45.1352 //w=0.168 //l=0.173853 //layer=ply \
 //thickness=0.18 //x=1.445 //y=1.25 //x2=1.405 //y2=1.405
r135 (  37 51 ) resistor r=45.1352 //w=0.168 //l=0.173853 //layer=ply \
 //thickness=0.18 //x=1.445 //y=0.905 //x2=1.405 //y2=0.75
r136 (  37 38 ) resistor r=176.904 //w=0.094 //l=0.345 //layer=ply \
 //thickness=0.18 //x=1.445 //y=0.905 //x2=1.445 //y2=1.25
r137 (  36 45 ) resistor r=16.5046 //w=0.27 //l=0.135 //layer=ply \
 //thickness=0.18 //x=1.09 //y=4.795 //x2=0.955 //y2=4.795
r138 (  35 39 ) resistor r=26.9307 //w=0.15 //l=0.106066 //layer=ply \
 //thickness=0.18 //x=1.375 //y=4.795 //x2=1.45 //y2=4.87
r139 (  35 36 ) resistor r=146.138 //w=0.094 //l=0.285 //layer=ply \
 //thickness=0.18 //x=1.375 //y=4.795 //x2=1.09 //y2=4.795
r140 (  33 50 ) resistor r=10.701 //w=0.21 //l=0.115 //layer=ply \
 //thickness=0.18 //x=1.07 //y=1.405 //x2=0.955 //y2=1.405
r141 (  32 52 ) resistor r=5.52526 //w=0.168 //l=0.115 //layer=ply \
 //thickness=0.18 //x=1.29 //y=1.405 //x2=1.405 //y2=1.405
r142 (  31 49 ) resistor r=5.52526 //w=0.168 //l=0.115 //layer=ply \
 //thickness=0.18 //x=1.07 //y=0.75 //x2=0.955 //y2=0.75
r143 (  30 51 ) resistor r=5.52526 //w=0.168 //l=0.115 //layer=ply \
 //thickness=0.18 //x=1.29 //y=0.75 //x2=1.405 //y2=0.75
r144 (  30 31 ) resistor r=112.809 //w=0.094 //l=0.22 //layer=ply \
 //thickness=0.18 //x=1.29 //y=0.75 //x2=1.07 //y2=0.75
r145 (  26 48 ) resistor r=34.8111 //w=0.27 //l=0.264953 //layer=ply \
 //thickness=0.18 //x=0.915 //y=1.915 //x2=1.11 //y2=2.08
r146 (  25 50 ) resistor r=39.5823 //w=0.21 //l=0.173853 //layer=ply \
 //thickness=0.18 //x=0.915 //y=1.56 //x2=0.955 //y2=1.405
r147 (  25 26 ) resistor r=182.032 //w=0.094 //l=0.355 //layer=ply \
 //thickness=0.18 //x=0.915 //y=1.56 //x2=0.915 //y2=1.915
r148 (  24 50 ) resistor r=39.5823 //w=0.21 //l=0.173853 //layer=ply \
 //thickness=0.18 //x=0.915 //y=1.25 //x2=0.955 //y2=1.405
r149 (  23 49 ) resistor r=45.1352 //w=0.168 //l=0.173853 //layer=ply \
 //thickness=0.18 //x=0.915 //y=0.905 //x2=0.955 //y2=0.75
r150 (  23 24 ) resistor r=176.904 //w=0.094 //l=0.345 //layer=ply \
 //thickness=0.18 //x=0.915 //y=0.905 //x2=0.915 //y2=1.25
r151 (  22 39 ) resistor r=592.245 //w=0.094 //l=1.155 //layer=ply \
 //thickness=0.18 //x=1.45 //y=6.025 //x2=1.45 //y2=4.87
r152 (  21 46 ) resistor r=592.245 //w=0.094 //l=1.155 //layer=ply \
 //thickness=0.18 //x=1.01 //y=6.025 //x2=1.01 //y2=4.87
r153 (  20 32 ) resistor r=56.4043 //w=0.094 //l=0.11 //layer=ply \
 //thickness=0.18 //x=1.18 //y=1.405 //x2=1.29 //y2=1.405
r154 (  20 33 ) resistor r=56.4043 //w=0.094 //l=0.11 //layer=ply \
 //thickness=0.18 //x=1.18 //y=1.405 //x2=1.07 //y2=1.405
r155 (  16 48 ) resistor r=152 //w=0.17 //l=0.17 //layer=licon //count=1 \
 //x=1.11 //y=2.08 //x2=1.11 //y2=2.08
r156 (  11 43 ) resistor r=152 //w=0.17 //l=0.17 //layer=licon //count=1 \
 //x=0.955 //y=4.705 //x2=0.955 //y2=4.705
r157 (  8 11 ) resistor r=9.3 //w=0.17 //l=0.17 //layer=mcon //count=1 \
 //x=0.955 //y=4.705 //x2=0.955 //y2=4.705
r158 (  8 9 ) resistor r=0.0853524 //w=0.227 //l=0.155 //layer=m1 \
 //thickness=0.36 //x=0.955 //y=4.702 //x2=1.11 //y2=4.702
r159 (  4 16 ) resistor r=9.3 //w=0.17 //l=0.17 //layer=mcon //count=1 \
 //x=1.11 //y=2.08 //x2=1.11 //y2=2.08
r160 (  4 6 ) resistor r=0.0985786 //w=0.206 //l=0.135 //layer=m1 \
 //thickness=0.36 //x=1.107 //y=2.08 //x2=1.107 //y2=2.215
r161 (  2 9 ) resistor r=0.0249239 //w=0.227 //l=0.117 //layer=m1 \
 //thickness=0.36 //x=1.11 //y=4.585 //x2=1.11 //y2=4.702
r162 (  2 6 ) resistor r=2.26145 //w=0.131 //l=2.37 //layer=m1 \
 //thickness=0.36 //x=1.11 //y=4.585 //x2=1.11 //y2=2.215
ends PM_OR2X1_PCELL\%noxref_4

subckt PM_OR2X1_PCELL\%noxref_5 ( 1 5 6 15 26 29 53 68 71 74 75 76 )
c116 ( 76 0 ) capacitor c=0.0631391f //x=4.74 //y=5.02
c117 ( 75 0 ) capacitor c=0.057741f //x=3.87 //y=5.02
c118 ( 74 0 ) capacitor c=0.0229754f //x=1.085 //y=5.025
c119 ( 73 0 ) capacitor c=0.00591168f //x=4.885 //y=7.4
c120 ( 72 0 ) capacitor c=0.00591168f //x=4.005 //y=7.4
c121 ( 71 0 ) capacitor c=0.122394f //x=3.33 //y=7.4
c122 ( 68 0 ) capacitor c=0.23475f //x=5.18 //y=7.4
c123 ( 53 0 ) capacitor c=0.028723f //x=4.8 //y=7.4
c124 ( 43 0 ) capacitor c=0.0216067f //x=3.92 //y=7.4
c125 ( 29 0 ) capacitor c=0.214588f //x=0.74 //y=7.4
c126 ( 26 0 ) capacitor c=0.137893f //x=3.16 //y=7.4
c127 ( 17 0 ) capacitor c=0.00498911f //x=1.23 //y=7.4
c128 ( 15 0 ) capacitor c=0.162823f //x=5.18 //y=7.4
c129 ( 6 0 ) capacitor c=0.00916089f //x=1.23 //y=7.23
c130 ( 5 0 ) capacitor c=0.00572492f //x=1.23 //y=6.855
c131 ( 1 0 ) capacitor c=0.061321f //x=1.145 //y=7.4
r132 (  66 73 ) resistor r=2.94794 //w=0.34 //l=0.085 //layer=li \
 //thickness=0.1 //x=4.97 //y=7.4 //x2=4.885 //y2=7.4
r133 (  66 68 ) resistor r=7.52941 //w=0.357 //l=0.21 //layer=li \
 //thickness=0.1 //x=4.97 //y=7.4 //x2=5.18 //y2=7.4
r134 (  57 73 ) resistor r=4.11603 //w=0.68 //l=0.17 //layer=li \
 //thickness=0.1 //x=4.885 //y=7.23 //x2=4.885 //y2=7.4
r135 (  57 76 ) resistor r=56.4706 //w=0.187 //l=0.825 //layer=li \
 //thickness=0.1 //x=4.885 //y=7.23 //x2=4.885 //y2=6.405
r136 (  54 72 ) resistor r=2.94794 //w=0.34 //l=0.085 //layer=li \
 //thickness=0.1 //x=4.09 //y=7.4 //x2=4.005 //y2=7.4
r137 (  54 56 ) resistor r=12.549 //w=0.357 //l=0.35 //layer=li \
 //thickness=0.1 //x=4.09 //y=7.4 //x2=4.44 //y2=7.4
r138 (  53 73 ) resistor r=2.94794 //w=0.34 //l=0.085 //layer=li \
 //thickness=0.1 //x=4.8 //y=7.4 //x2=4.885 //y2=7.4
r139 (  53 56 ) resistor r=12.9076 //w=0.357 //l=0.36 //layer=li \
 //thickness=0.1 //x=4.8 //y=7.4 //x2=4.44 //y2=7.4
r140 (  45 72 ) resistor r=4.11603 //w=0.68 //l=0.17 //layer=li \
 //thickness=0.1 //x=4.005 //y=7.23 //x2=4.005 //y2=7.4
r141 (  45 75 ) resistor r=56.4706 //w=0.187 //l=0.825 //layer=li \
 //thickness=0.1 //x=4.005 //y=7.23 //x2=4.005 //y2=6.405
r142 (  44 71 ) resistor r=5.4201 //w=0.34 //l=0.17 //layer=li //thickness=0.1 \
 //x=3.5 //y=7.4 //x2=3.33 //y2=7.4
r143 (  43 72 ) resistor r=2.94794 //w=0.34 //l=0.085 //layer=li \
 //thickness=0.1 //x=3.92 //y=7.4 //x2=4.005 //y2=7.4
r144 (  43 44 ) resistor r=15.0588 //w=0.357 //l=0.42 //layer=li \
 //thickness=0.1 //x=3.92 //y=7.4 //x2=3.5 //y2=7.4
r145 (  31 33 ) resistor r=39.7983 //w=0.357 //l=1.11 //layer=li \
 //thickness=0.1 //x=1.85 //y=7.4 //x2=2.96 //y2=7.4
r146 (  29 31 ) resistor r=39.7983 //w=0.357 //l=1.11 //layer=li \
 //thickness=0.1 //x=0.74 //y=7.4 //x2=1.85 //y2=7.4
r147 (  26 71 ) resistor r=5.4201 //w=0.34 //l=0.17 //layer=li //thickness=0.1 \
 //x=3.16 //y=7.4 //x2=3.33 //y2=7.4
r148 (  26 33 ) resistor r=7.17087 //w=0.357 //l=0.2 //layer=li \
 //thickness=0.1 //x=3.16 //y=7.4 //x2=2.96 //y2=7.4
r149 (  19 74 ) resistor r=9.3 //w=0.17 //l=0.17 //layer=mcon //count=1 \
 //x=1.23 //y=6.74 //x2=1.23 //y2=6.74
r150 (  15 68 ) resistor r=9.3 //w=0.17 //l=0.17 //layer=mcon //count=1 \
 //x=5.18 //y=7.4 //x2=5.18 //y2=7.4
r151 (  13 56 ) resistor r=3.1 //w=0.17 //l=0.51 //layer=mcon //count=3 \
 //x=4.44 //y=7.4 //x2=4.44 //y2=7.4
r152 (  13 15 ) resistor r=0.307309 //w=0.301 //l=0.74 //layer=m1 \
 //thickness=0.36 //x=4.44 //y=7.4 //x2=5.18 //y2=7.4
r153 (  11 33 ) resistor r=3.1 //w=0.17 //l=0.51 //layer=mcon //count=3 \
 //x=2.96 //y=7.4 //x2=2.96 //y2=7.4
r154 (  11 13 ) resistor r=0.614618 //w=0.301 //l=1.48 //layer=m1 \
 //thickness=0.36 //x=2.96 //y=7.4 //x2=4.44 //y2=7.4
r155 (  9 31 ) resistor r=3.1 //w=0.17 //l=0.51 //layer=mcon //count=3 \
 //x=1.85 //y=7.4 //x2=1.85 //y2=7.4
r156 (  9 11 ) resistor r=0.460963 //w=0.301 //l=1.11 //layer=m1 \
 //thickness=0.36 //x=1.85 //y=7.4 //x2=2.96 //y2=7.4
r157 (  7 17 ) resistor r=0.0287885 //w=0.34 //l=0.085 //layer=m1 \
 //thickness=0.36 //x=1.315 //y=7.4 //x2=1.23 //y2=7.4
r158 (  7 9 ) resistor r=0.222176 //w=0.301 //l=0.535 //layer=m1 \
 //thickness=0.36 //x=1.315 //y=7.4 //x2=1.85 //y2=7.4
r159 (  6 17 ) resistor r=0.0401957 //w=0.68 //l=0.17 //layer=m1 \
 //thickness=0.36 //x=1.23 //y=7.23 //x2=1.23 //y2=7.4
r160 (  5 19 ) resistor r=0.0723371 //w=0.218 //l=0.115 //layer=m1 \
 //thickness=0.36 //x=1.23 //y=6.855 //x2=1.23 //y2=6.74
r161 (  5 6 ) resistor r=0.357824 //w=0.131 //l=0.375 //layer=m1 \
 //thickness=0.36 //x=1.23 //y=6.855 //x2=1.23 //y2=7.23
r162 (  3 29 ) resistor r=3.1 //w=0.17 //l=0.51 //layer=mcon //count=3 \
 //x=0.74 //y=7.4 //x2=0.74 //y2=7.4
r163 (  1 17 ) resistor r=0.0287885 //w=0.34 //l=0.085 //layer=m1 \
 //thickness=0.36 //x=1.145 //y=7.4 //x2=1.23 //y2=7.4
r164 (  1 3 ) resistor r=0.168189 //w=0.301 //l=0.405 //layer=m1 \
 //thickness=0.36 //x=1.145 //y=7.4 //x2=0.74 //y2=7.4
ends PM_OR2X1_PCELL\%noxref_5

subckt PM_OR2X1_PCELL\%noxref_6 ( 4 8 9 12 17 21 22 23 24 25 26 31 33 35 41 42 \
 44 45 48 )
c114 ( 48 0 ) capacitor c=0.0404287f //x=1.885 //y=4.705
c115 ( 45 0 ) capacitor c=0.0292709f //x=1.85 //y=1.915
c116 ( 44 0 ) capacitor c=0.0468503f //x=1.85 //y=2.08
c117 ( 42 0 ) capacitor c=0.0237765f //x=2.415 //y=1.255
c118 ( 41 0 ) capacitor c=0.0191782f //x=2.415 //y=0.905
c119 ( 35 0 ) capacitor c=0.035988f //x=2.26 //y=1.405
c120 ( 33 0 ) capacitor c=0.0157803f //x=2.26 //y=0.75
c121 ( 31 0 ) capacitor c=0.0367203f //x=2.255 //y=4.795
c122 ( 26 0 ) capacitor c=0.0206674f //x=1.885 //y=1.56
c123 ( 25 0 ) capacitor c=0.0169638f //x=1.885 //y=1.255
c124 ( 24 0 ) capacitor c=0.0185462f //x=1.885 //y=0.905
c125 ( 23 0 ) capacitor c=0.155887f //x=2.33 //y=6.025
c126 ( 22 0 ) capacitor c=0.110534f //x=1.89 //y=6.025
c127 ( 17 0 ) capacitor c=0.00113117f //x=1.885 //y=4.705
c128 ( 12 0 ) capacitor c=9.45497e-19 //x=1.85 //y=2.08
c129 ( 9 0 ) capacitor c=0.0576678f //x=1.885 //y=4.56
c130 ( 8 0 ) capacitor c=0.00668188f //x=1.885 //y=4.705
c131 ( 4 0 ) capacitor c=0.00573992f //x=1.85 //y=2.08
r132 (  50 51 ) resistor r=32.4568 //w=0.214 //l=0.075 //layer=ply \
 //thickness=0.18 //x=1.885 //y=4.795 //x2=1.885 //y2=4.87
r133 (  48 50 ) resistor r=20.271 //w=0.214 //l=0.09 //layer=ply \
 //thickness=0.18 //x=1.885 //y=4.705 //x2=1.885 //y2=4.795
r134 (  44 45 ) resistor r=52.7279 //w=0.214 //l=0.165 //layer=ply \
 //thickness=0.18 //x=1.85 //y=2.08 //x2=1.85 //y2=1.915
r135 (  42 55 ) resistor r=4.95774 //w=0.164 //l=0.112 //layer=ply \
 //thickness=0.18 //x=2.415 //y=1.255 //x2=2.415 //y2=1.367
r136 (  41 54 ) resistor r=45.1352 //w=0.168 //l=0.173853 //layer=ply \
 //thickness=0.18 //x=2.415 //y=0.905 //x2=2.375 //y2=0.75
r137 (  41 42 ) resistor r=179.468 //w=0.094 //l=0.35 //layer=ply \
 //thickness=0.18 //x=2.415 //y=0.905 //x2=2.415 //y2=1.255
r138 (  36 53 ) resistor r=10.8103 //w=0.211 //l=0.115 //layer=ply \
 //thickness=0.18 //x=2.04 //y=1.405 //x2=1.925 //y2=1.405
r139 (  35 55 ) resistor r=45.9962 //w=0.164 //l=0.17296 //layer=ply \
 //thickness=0.18 //x=2.26 //y=1.405 //x2=2.415 //y2=1.367
r140 (  34 52 ) resistor r=5.52526 //w=0.168 //l=0.115 //layer=ply \
 //thickness=0.18 //x=2.04 //y=0.75 //x2=1.925 //y2=0.75
r141 (  33 54 ) resistor r=5.52526 //w=0.168 //l=0.115 //layer=ply \
 //thickness=0.18 //x=2.26 //y=0.75 //x2=2.375 //y2=0.75
r142 (  33 34 ) resistor r=112.809 //w=0.094 //l=0.22 //layer=ply \
 //thickness=0.18 //x=2.26 //y=0.75 //x2=2.04 //y2=0.75
r143 (  32 50 ) resistor r=16.5046 //w=0.27 //l=0.135 //layer=ply \
 //thickness=0.18 //x=2.02 //y=4.795 //x2=1.885 //y2=4.795
r144 (  31 38 ) resistor r=26.9307 //w=0.15 //l=0.106066 //layer=ply \
 //thickness=0.18 //x=2.255 //y=4.795 //x2=2.33 //y2=4.87
r145 (  31 32 ) resistor r=120.5 //w=0.094 //l=0.235 //layer=ply \
 //thickness=0.18 //x=2.255 //y=4.795 //x2=2.02 //y2=4.795
r146 (  26 53 ) resistor r=39.5036 //w=0.211 //l=0.173853 //layer=ply \
 //thickness=0.18 //x=1.885 //y=1.56 //x2=1.925 //y2=1.405
r147 (  26 45 ) resistor r=182.032 //w=0.094 //l=0.355 //layer=ply \
 //thickness=0.18 //x=1.885 //y=1.56 //x2=1.885 //y2=1.915
r148 (  25 53 ) resistor r=38.3614 //w=0.211 //l=0.168819 //layer=ply \
 //thickness=0.18 //x=1.885 //y=1.255 //x2=1.925 //y2=1.405
r149 (  24 52 ) resistor r=45.1352 //w=0.168 //l=0.173853 //layer=ply \
 //thickness=0.18 //x=1.885 //y=0.905 //x2=1.925 //y2=0.75
r150 (  24 25 ) resistor r=179.468 //w=0.094 //l=0.35 //layer=ply \
 //thickness=0.18 //x=1.885 //y=0.905 //x2=1.885 //y2=1.255
r151 (  23 38 ) resistor r=592.245 //w=0.094 //l=1.155 //layer=ply \
 //thickness=0.18 //x=2.33 //y=6.025 //x2=2.33 //y2=4.87
r152 (  22 51 ) resistor r=592.245 //w=0.094 //l=1.155 //layer=ply \
 //thickness=0.18 //x=1.89 //y=6.025 //x2=1.89 //y2=4.87
r153 (  21 35 ) resistor r=56.4043 //w=0.094 //l=0.11 //layer=ply \
 //thickness=0.18 //x=2.15 //y=1.405 //x2=2.26 //y2=1.405
r154 (  21 36 ) resistor r=56.4043 //w=0.094 //l=0.11 //layer=ply \
 //thickness=0.18 //x=2.15 //y=1.405 //x2=2.04 //y2=1.405
r155 (  17 48 ) resistor r=152 //w=0.17 //l=0.17 //layer=licon //count=1 \
 //x=1.885 //y=4.705 //x2=1.885 //y2=4.705
r156 (  12 44 ) resistor r=152 //w=0.17 //l=0.17 //layer=licon //count=1 \
 //x=1.85 //y=2.08 //x2=1.85 //y2=2.08
r157 (  8 17 ) resistor r=9.3 //w=0.17 //l=0.17 //layer=mcon //count=1 \
 //x=1.885 //y=4.705 //x2=1.885 //y2=4.705
r158 (  8 9 ) resistor r=0.105739 //w=0.201 //l=0.145 //layer=m1 \
 //thickness=0.36 //x=1.885 //y=4.705 //x2=1.885 //y2=4.56
r159 (  6 9 ) resistor r=2.2376 //w=0.131 //l=2.345 //layer=m1 \
 //thickness=0.36 //x=1.85 //y=2.215 //x2=1.85 //y2=4.56
r160 (  4 12 ) resistor r=9.3 //w=0.17 //l=0.17 //layer=mcon //count=1 \
 //x=1.85 //y=2.08 //x2=1.85 //y2=2.08
r161 (  4 6 ) resistor r=0.0977888 //w=0.216 //l=0.135 //layer=m1 \
 //thickness=0.36 //x=1.847 //y=2.08 //x2=1.847 //y2=2.215
ends PM_OR2X1_PCELL\%noxref_6

subckt PM_OR2X1_PCELL\%noxref_7 ( 2 4 5 6 7 8 10 12 22 29 31 )
c81 ( 29 0 ) capacitor c=0.00869746f //x=4.255 //y=0.91
c82 ( 22 0 ) capacitor c=0.0261959f //x=4.445 //y=5.38
c83 ( 12 0 ) capacitor c=0.0191272f //x=4.44 //y=1.005
c84 ( 10 0 ) capacitor c=0.115689f //x=4.81 //y=4.875
c85 ( 8 0 ) capacitor c=0.00557311f //x=4.53 //y=4.96
c86 ( 7 0 ) capacitor c=0.00944012f //x=4.725 //y=4.96
c87 ( 6 0 ) capacitor c=0.00724565f //x=4.525 //y=1.84
c88 ( 5 0 ) capacitor c=0.0145753f //x=4.725 //y=1.84
c89 ( 4 0 ) capacitor c=0.0117594f //x=4.445 //y=5.24
c90 ( 2 0 ) capacitor c=0.0170096f //x=4.44 //y=1.755
r91 (  22 31 ) resistor r=23.615 //w=0.187 //l=0.345 //layer=li \
 //thickness=0.1 //x=4.445 //y=5.38 //x2=4.445 //y2=5.725
r92 (  15 22 ) resistor r=9.3 //w=0.17 //l=0.17 //layer=mcon //count=1 \
 //x=4.445 //y=5.38 //x2=4.445 //y2=5.38
r93 (  12 29 ) resistor r=9.3 //w=0.17 //l=0.17 //layer=mcon //count=1 \
 //x=4.44 //y=1.005 //x2=4.44 //y2=1.005
r94 (  9 10 ) resistor r=2.81489 //w=0.131 //l=2.95 //layer=m1 \
 //thickness=0.36 //x=4.81 //y=1.925 //x2=4.81 //y2=4.875
r95 (  7 10 ) resistor r=0.0698411 //w=0.17 //l=0.120208 //layer=m1 \
 //thickness=0.36 //x=4.725 //y=4.96 //x2=4.81 //y2=4.875
r96 (  7 8 ) resistor r=0.186069 //w=0.131 //l=0.195 //layer=m1 \
 //thickness=0.36 //x=4.725 //y=4.96 //x2=4.53 //y2=4.96
r97 (  5 9 ) resistor r=0.0698411 //w=0.17 //l=0.120208 //layer=m1 \
 //thickness=0.36 //x=4.725 //y=1.84 //x2=4.81 //y2=1.925
r98 (  5 6 ) resistor r=0.19084 //w=0.131 //l=0.2 //layer=m1 //thickness=0.36 \
 //x=4.725 //y=1.84 //x2=4.525 //y2=1.84
r99 (  4 15 ) resistor r=0.086672 //w=0.218 //l=0.14 //layer=m1 \
 //thickness=0.36 //x=4.445 //y=5.24 //x2=4.445 //y2=5.38
r100 (  3 8 ) resistor r=0.0698411 //w=0.17 //l=0.120208 //layer=m1 \
 //thickness=0.36 //x=4.445 //y=5.045 //x2=4.53 //y2=4.96
r101 (  3 4 ) resistor r=0.186069 //w=0.131 //l=0.195 //layer=m1 \
 //thickness=0.36 //x=4.445 //y=5.045 //x2=4.445 //y2=5.24
r102 (  2 6 ) resistor r=0.0698411 //w=0.17 //l=0.120208 //layer=m1 \
 //thickness=0.36 //x=4.44 //y=1.755 //x2=4.525 //y2=1.84
r103 (  1 12 ) resistor r=0.105739 //w=0.201 //l=0.145 //layer=m1 \
 //thickness=0.36 //x=4.44 //y=1.15 //x2=4.44 //y2=1.005
r104 (  1 2 ) resistor r=0.57729 //w=0.131 //l=0.605 //layer=m1 \
 //thickness=0.36 //x=4.44 //y=1.15 //x2=4.44 //y2=1.755
ends PM_OR2X1_PCELL\%noxref_7
