// File: dffsnx1_pcell.spi.DFFSNX1_PCELL.pxi
// Created: Sun Apr 12 08:40:20 2026
//
simulator lang=spectre
x_PM_DFFSNX1_PCELL\%noxref_1 ( N_noxref_1_c_61_p N_noxref_1_c_118_p \
 N_noxref_1_c_113_p N_noxref_1_c_71_p N_noxref_1_c_62_p N_noxref_1_c_13_p \
 N_noxref_1_c_55_p N_noxref_1_c_14_p N_noxref_1_c_9_p N_noxref_1_c_15_p \
 N_noxref_1_c_16_p N_noxref_1_c_17_p N_noxref_1_c_74_p N_noxref_1_c_75_p \
 N_noxref_1_c_76_p N_noxref_1_c_26_p N_noxref_1_c_201_p N_noxref_1_c_64_p \
 N_noxref_1_c_203_p N_noxref_1_c_116_p N_noxref_1_c_59_p N_noxref_1_c_18_p \
 N_noxref_1_c_5_p N_noxref_1_c_94_p N_noxref_1_c_60_p N_noxref_1_c_19_p \
 N_noxref_1_c_78_p N_noxref_1_c_10_p N_noxref_1_c_204_p N_noxref_1_c_65_p \
 N_noxref_1_c_11_p N_noxref_1_c_23_p N_noxref_1_c_144_p N_noxref_1_c_151_p \
 N_noxref_1_M2_noxref_g N_noxref_1_M5_noxref_g N_noxref_1_M19_noxref_g \
 N_noxref_1_M20_noxref_g N_noxref_1_M25_noxref_g N_noxref_1_M26_noxref_g \
 N_noxref_1_c_40_p N_noxref_1_c_41_p N_noxref_1_c_43_p N_noxref_1_c_12_p \
 N_noxref_1_c_282_p N_noxref_1_c_299_p N_noxref_1_c_42_p N_noxref_1_c_44_p \
 N_noxref_1_c_24_p N_noxref_1_c_25_p N_noxref_1_c_166_p N_noxref_1_c_167_p \
 N_noxref_1_c_169_p N_noxref_1_c_145_p N_noxref_1_c_285_p N_noxref_1_c_310_p \
 N_noxref_1_c_168_p N_noxref_1_c_170_p N_noxref_1_c_4_p N_noxref_1_c_153_p \
 N_noxref_1_M1_noxref_d N_noxref_1_M15_noxref_d N_noxref_1_M17_noxref_d )  \
 PM_DFFSNX1_PCELL\%noxref_1
x_PM_DFFSNX1_PCELL\%noxref_2 ( N_noxref_2_c_395_n N_noxref_2_c_478_p \
 N_noxref_2_c_509_p N_noxref_2_c_418_p N_noxref_2_c_462_p N_noxref_2_c_501_p \
 N_noxref_2_c_502_p N_noxref_2_c_452_p N_noxref_2_c_403_p N_noxref_2_c_465_p \
 N_noxref_2_c_404_p N_noxref_2_c_405_p N_noxref_2_c_406_p N_noxref_2_c_396_n \
 N_noxref_2_c_421_p N_noxref_2_c_497_p N_noxref_2_c_399_n N_noxref_2_c_407_p \
 N_noxref_2_c_411_p N_noxref_2_c_414_p N_noxref_2_c_408_p N_noxref_2_c_469_p \
 N_noxref_2_c_409_p N_noxref_2_c_455_p N_noxref_2_c_400_n N_noxref_2_c_461_p \
 N_noxref_2_c_499_p N_noxref_2_c_410_p N_noxref_2_c_416_p \
 N_noxref_2_M8_noxref_g N_noxref_2_M31_noxref_g N_noxref_2_M32_noxref_g \
 N_noxref_2_c_434_p N_noxref_2_c_435_p N_noxref_2_c_437_p N_noxref_2_c_413_p \
 N_noxref_2_c_639_p N_noxref_2_c_640_p N_noxref_2_c_436_p N_noxref_2_c_438_p \
 N_noxref_2_c_417_p N_noxref_2_M7_noxref_d N_noxref_2_M25_noxref_d \
 N_noxref_2_M27_noxref_d N_noxref_2_M29_noxref_d )  PM_DFFSNX1_PCELL\%noxref_2
x_PM_DFFSNX1_PCELL\%noxref_3 ( N_noxref_3_c_682_n N_noxref_3_c_686_n \
 N_noxref_3_c_727_n N_noxref_3_c_695_n N_noxref_3_c_735_n N_noxref_3_c_738_n \
 N_noxref_3_c_780_p N_noxref_3_c_699_n N_noxref_3_c_700_n N_noxref_3_c_702_n \
 N_noxref_3_c_706_n N_noxref_3_c_748_n N_noxref_3_c_752_n \
 N_noxref_3_M3_noxref_g N_noxref_3_M9_noxref_g N_noxref_3_M21_noxref_g \
 N_noxref_3_M22_noxref_g N_noxref_3_M33_noxref_g N_noxref_3_M34_noxref_g \
 N_noxref_3_c_713_n N_noxref_3_c_716_n N_noxref_3_c_923_p N_noxref_3_c_924_p \
 N_noxref_3_c_718_n N_noxref_3_c_719_n N_noxref_3_c_720_n N_noxref_3_c_721_n \
 N_noxref_3_c_794_p N_noxref_3_c_758_n N_noxref_3_c_761_n N_noxref_3_c_763_n \
 N_noxref_3_c_842_p N_noxref_3_c_857_p N_noxref_3_c_830_p N_noxref_3_c_766_n \
 N_noxref_3_c_767_n N_noxref_3_c_724_n N_noxref_3_c_768_n N_noxref_3_c_832_p \
 N_noxref_3_c_771_n )  PM_DFFSNX1_PCELL\%noxref_3
x_PM_DFFSNX1_PCELL\%noxref_4 ( N_noxref_4_c_958_n N_noxref_4_c_965_n \
 N_noxref_4_c_970_n N_noxref_4_c_973_n N_noxref_4_c_1057_n N_noxref_4_c_1046_n \
 N_noxref_4_c_1047_n N_noxref_4_c_974_n N_noxref_4_c_975_n N_noxref_4_c_1048_n \
 N_noxref_4_c_976_n N_noxref_4_c_978_n N_noxref_4_c_984_n N_noxref_4_c_985_n \
 N_noxref_4_c_1065_n N_noxref_4_c_1117_p N_noxref_4_c_986_n N_noxref_4_c_987_n \
 N_noxref_4_c_988_n N_noxref_4_c_1066_n N_noxref_4_c_1099_p \
 N_noxref_4_c_1106_p N_noxref_4_c_1224_p N_noxref_4_c_1090_p \
 N_noxref_4_c_1118_p N_noxref_4_c_1073_n N_noxref_4_c_993_n \
 N_noxref_4_c_1002_n N_noxref_4_c_1003_n N_noxref_4_c_1120_p \
 N_noxref_4_c_1006_n N_noxref_4_c_1008_n N_noxref_4_c_1009_n \
 N_noxref_4_c_1011_n N_noxref_4_c_1082_n N_noxref_4_c_1109_p \
 N_noxref_4_c_1092_p N_noxref_4_c_1189_p N_noxref_4_M1_noxref_g \
 N_noxref_4_M10_noxref_g N_noxref_4_M17_noxref_g N_noxref_4_M18_noxref_g \
 N_noxref_4_M35_noxref_g N_noxref_4_M36_noxref_g N_noxref_4_c_1020_n \
 N_noxref_4_c_1022_n N_noxref_4_c_1025_n N_noxref_4_c_1026_n \
 N_noxref_4_c_1029_n N_noxref_4_c_1031_n N_noxref_4_c_1035_n \
 N_noxref_4_c_1037_n N_noxref_4_c_1327_p N_noxref_4_c_1328_p \
 N_noxref_4_c_1330_p N_noxref_4_c_1316_p N_noxref_4_c_1370_p \
 N_noxref_4_c_1371_p N_noxref_4_c_1329_p N_noxref_4_c_1331_p \
 N_noxref_4_c_1041_n N_noxref_4_c_1042_n N_noxref_4_c_1044_n \
 N_noxref_4_c_1229_p N_noxref_4_M4_noxref_d N_noxref_4_M19_noxref_d \
 N_noxref_4_M21_noxref_d N_noxref_4_M23_noxref_d )  PM_DFFSNX1_PCELL\%noxref_4
x_PM_DFFSNX1_PCELL\%noxref_5 ( N_noxref_5_c_1422_n N_noxref_5_c_1426_n \
 N_noxref_5_c_1516_p N_noxref_5_c_1521_p N_noxref_5_c_1434_n \
 N_noxref_5_c_1517_p N_noxref_5_c_1467_n N_noxref_5_c_1436_n \
 N_noxref_5_c_1439_n N_noxref_5_c_1518_p N_noxref_5_c_1525_p \
 N_noxref_5_M6_noxref_g N_noxref_5_M13_noxref_g N_noxref_5_M27_noxref_g \
 N_noxref_5_M28_noxref_g N_noxref_5_M41_noxref_g N_noxref_5_M42_noxref_g \
 N_noxref_5_c_1446_n N_noxref_5_c_1449_n N_noxref_5_c_1599_p \
 N_noxref_5_c_1600_p N_noxref_5_c_1451_n N_noxref_5_c_1452_n \
 N_noxref_5_c_1453_n N_noxref_5_c_1454_n N_noxref_5_c_1486_n \
 N_noxref_5_c_1649_p N_noxref_5_c_1651_p N_noxref_5_c_1675_p \
 N_noxref_5_c_1676_p N_noxref_5_c_1562_p N_noxref_5_c_1563_p \
 N_noxref_5_c_1564_p N_noxref_5_c_1519_p N_noxref_5_c_1579_p \
 N_noxref_5_c_1457_n N_noxref_5_c_1526_p )  PM_DFFSNX1_PCELL\%noxref_5
x_PM_DFFSNX1_PCELL\%noxref_6 ( N_noxref_6_c_1734_n N_noxref_6_c_1735_n \
 N_noxref_6_c_1740_n N_noxref_6_c_1741_n N_noxref_6_c_1752_n \
 N_noxref_6_c_1743_n N_noxref_6_c_1760_n N_noxref_6_c_1745_n \
 N_noxref_6_c_1768_n N_noxref_6_c_1769_n N_noxref_6_c_1856_n \
 N_noxref_6_c_1857_n N_noxref_6_c_1770_n N_noxref_6_c_1771_n \
 N_noxref_6_c_1864_n N_noxref_6_c_1774_n N_noxref_6_c_2023_n \
 N_noxref_6_c_2027_n N_noxref_6_c_2030_n N_noxref_6_c_2031_n \
 N_noxref_6_c_1871_n N_noxref_6_c_1776_n N_noxref_6_c_1777_n \
 N_noxref_6_c_1873_n N_noxref_6_c_2093_p N_noxref_6_c_1785_n \
 N_noxref_6_c_1884_n N_noxref_6_c_2036_n N_noxref_6_c_1746_n \
 N_noxref_6_c_1886_n N_noxref_6_c_1747_n N_noxref_6_c_1751_n \
 N_noxref_6_c_1787_n N_noxref_6_c_1891_n N_noxref_6_c_2043_n \
 N_noxref_6_c_1967_n N_noxref_6_c_1892_n N_noxref_6_c_1896_n \
 N_noxref_6_c_1794_n N_noxref_6_c_1795_n N_noxref_6_c_1799_n \
 N_noxref_6_c_1899_n N_noxref_6_c_2054_n N_noxref_6_c_2057_n \
 N_noxref_6_M4_noxref_g N_noxref_6_M7_noxref_g N_noxref_6_M14_noxref_g \
 N_noxref_6_M23_noxref_g N_noxref_6_M24_noxref_g N_noxref_6_M29_noxref_g \
 N_noxref_6_M30_noxref_g N_noxref_6_M43_noxref_g N_noxref_6_M44_noxref_g \
 N_noxref_6_c_1906_n N_noxref_6_c_1907_n N_noxref_6_c_1908_n \
 N_noxref_6_c_1988_n N_noxref_6_c_1990_n N_noxref_6_c_1994_n \
 N_noxref_6_c_1996_n N_noxref_6_c_1810_n N_noxref_6_c_1812_n \
 N_noxref_6_c_1815_n N_noxref_6_c_1816_n N_noxref_6_c_1818_n \
 N_noxref_6_c_1822_n N_noxref_6_c_1824_n N_noxref_6_c_2069_n \
 N_noxref_6_c_2070_n N_noxref_6_c_2071_n N_noxref_6_c_2242_p \
 N_noxref_6_c_2243_p N_noxref_6_c_2220_p N_noxref_6_c_2197_p \
 N_noxref_6_c_1909_n N_noxref_6_c_1912_n N_noxref_6_c_1913_n \
 N_noxref_6_c_1828_n N_noxref_6_c_1829_n N_noxref_6_c_1831_n \
 N_noxref_6_c_2080_n N_noxref_6_c_2083_n N_noxref_6_c_2084_n \
 N_noxref_6_M9_noxref_d N_noxref_6_M31_noxref_d N_noxref_6_M33_noxref_d )  \
 PM_DFFSNX1_PCELL\%noxref_6
x_PM_DFFSNX1_PCELL\%noxref_7 ( N_noxref_7_c_2294_n N_noxref_7_c_2301_n \
 N_noxref_7_c_2304_n N_noxref_7_c_2309_n N_noxref_7_c_2405_n \
 N_noxref_7_c_2444_n N_noxref_7_c_2448_n N_noxref_7_c_2311_n \
 N_noxref_7_c_2368_n N_noxref_7_c_2372_n N_noxref_7_c_2376_n \
 N_noxref_7_c_2377_n N_noxref_7_c_2407_n N_noxref_7_c_2450_n \
 N_noxref_7_c_2577_p N_noxref_7_c_2632_p N_noxref_7_c_2501_n \
 N_noxref_7_c_2527_n N_noxref_7_c_2529_n N_noxref_7_c_2313_n \
 N_noxref_7_c_2316_n N_noxref_7_c_2324_n N_noxref_7_c_2382_n \
 N_noxref_7_c_2411_n N_noxref_7_c_2475_n N_noxref_7_M15_noxref_s \
 N_noxref_7_M16_noxref_d N_noxref_7_M18_noxref_d N_noxref_7_M19_noxref_s \
 N_noxref_7_M20_noxref_d N_noxref_7_M22_noxref_d N_noxref_7_M24_noxref_d \
 N_noxref_7_M25_noxref_s N_noxref_7_M26_noxref_d N_noxref_7_M28_noxref_d \
 N_noxref_7_M30_noxref_d N_noxref_7_M31_noxref_s N_noxref_7_M32_noxref_d \
 N_noxref_7_M34_noxref_d N_noxref_7_M35_noxref_s N_noxref_7_M36_noxref_d \
 N_noxref_7_M38_noxref_d N_noxref_7_M39_noxref_s N_noxref_7_M40_noxref_d \
 N_noxref_7_M42_noxref_d N_noxref_7_M44_noxref_d )  PM_DFFSNX1_PCELL\%noxref_7
x_PM_DFFSNX1_PCELL\%noxref_8 ( N_noxref_8_c_2689_n N_noxref_8_c_2676_n \
 N_noxref_8_c_2678_n N_noxref_8_c_2702_n N_noxref_8_c_2680_n \
 N_noxref_8_M0_noxref_g N_noxref_8_M15_noxref_g N_noxref_8_M16_noxref_g \
 N_noxref_8_c_2712_n N_noxref_8_c_2713_n N_noxref_8_c_2714_n \
 N_noxref_8_c_2716_n N_noxref_8_c_2745_p N_noxref_8_c_2746_p \
 N_noxref_8_c_2720_n N_noxref_8_c_2722_n N_noxref_8_c_2687_n )  \
 PM_DFFSNX1_PCELL\%noxref_8
x_PM_DFFSNX1_PCELL\%noxref_9 ( N_noxref_9_c_2776_n N_noxref_9_c_2818_p \
 N_noxref_9_c_2777_n N_noxref_9_c_2820_p N_noxref_9_c_2799_n \
 N_noxref_9_M3_noxref_d N_noxref_9_M4_noxref_s )  PM_DFFSNX1_PCELL\%noxref_9
x_PM_DFFSNX1_PCELL\%noxref_10 ( N_noxref_10_c_2857_n N_noxref_10_c_2888_p \
 N_noxref_10_c_2845_n N_noxref_10_c_2890_p N_noxref_10_c_2848_n \
 N_noxref_10_M6_noxref_d N_noxref_10_M7_noxref_s )  PM_DFFSNX1_PCELL\%noxref_10
x_PM_DFFSNX1_PCELL\%noxref_11 ( N_noxref_11_c_2915_n N_noxref_11_c_2924_n \
 N_noxref_11_c_2927_n N_noxref_11_c_2931_n N_noxref_11_M11_noxref_g \
 N_noxref_11_M37_noxref_g N_noxref_11_M38_noxref_g N_noxref_11_c_2937_n \
 N_noxref_11_c_2940_n N_noxref_11_c_2942_n N_noxref_11_c_2964_n \
 N_noxref_11_c_2991_p N_noxref_11_c_2973_p N_noxref_11_c_2945_n \
 N_noxref_11_c_2946_n N_noxref_11_c_2947_n N_noxref_11_c_2975_p \
 N_noxref_11_c_2950_n )  PM_DFFSNX1_PCELL\%noxref_11
x_PM_DFFSNX1_PCELL\%noxref_12 ( N_noxref_12_c_3020_n N_noxref_12_c_3040_n \
 N_noxref_12_c_3054_n N_noxref_12_c_3096_n N_noxref_12_c_3036_n \
 N_noxref_12_c_3021_n N_noxref_12_c_3023_n N_noxref_12_c_3048_n \
 N_noxref_12_c_3070_n N_noxref_12_c_3039_n N_noxref_12_c_3030_n \
 N_noxref_12_c_3081_n N_noxref_12_M11_noxref_d N_noxref_12_M35_noxref_d \
 N_noxref_12_M37_noxref_d )  PM_DFFSNX1_PCELL\%noxref_12
x_PM_DFFSNX1_PCELL\%noxref_13 ( N_noxref_13_c_3367_n N_noxref_13_c_3149_n \
 N_noxref_13_c_3153_n N_noxref_13_c_3268_n N_noxref_13_c_3156_n \
 N_noxref_13_c_3226_n N_noxref_13_c_3269_n N_noxref_13_c_3317_n \
 N_noxref_13_c_3446_p N_noxref_13_c_3318_n N_noxref_13_c_3159_n \
 N_noxref_13_c_3377_n N_noxref_13_c_3162_n N_noxref_13_c_3174_n \
 N_noxref_13_c_3230_n N_noxref_13_c_3241_n N_noxref_13_c_3280_n \
 N_noxref_13_c_3289_n N_noxref_13_c_3323_n N_noxref_13_c_3185_n \
 N_noxref_13_c_3187_n N_noxref_13_c_3189_n N_noxref_13_c_3190_n \
 N_noxref_13_c_3246_n N_noxref_13_c_3294_n N_noxref_13_c_3341_n \
 N_noxref_13_c_3191_n N_noxref_13_c_3203_n N_noxref_13_c_3247_n \
 N_noxref_13_c_3260_n N_noxref_13_c_3326_n N_noxref_13_M0_noxref_d \
 N_noxref_13_M2_noxref_d N_noxref_13_M5_noxref_d N_noxref_13_M8_noxref_d \
 N_noxref_13_M10_noxref_d N_noxref_13_M12_noxref_d )  \
 PM_DFFSNX1_PCELL\%noxref_13
x_PM_DFFSNX1_PCELL\%noxref_14 ( N_noxref_14_c_3614_n N_noxref_14_c_3619_n \
 N_noxref_14_c_3625_n N_noxref_14_c_3629_n N_noxref_14_M12_noxref_g \
 N_noxref_14_M39_noxref_g N_noxref_14_M40_noxref_g N_noxref_14_c_3635_n \
 N_noxref_14_c_3636_n N_noxref_14_c_3637_n N_noxref_14_c_3638_n \
 N_noxref_14_c_3684_n N_noxref_14_c_3687_n N_noxref_14_c_3641_n \
 N_noxref_14_c_3643_n N_noxref_14_c_3646_n N_noxref_14_c_3649_n )  \
 PM_DFFSNX1_PCELL\%noxref_14
x_PM_DFFSNX1_PCELL\%noxref_15 ( N_noxref_15_c_3713_n N_noxref_15_c_3745_n \
 N_noxref_15_c_3730_n N_noxref_15_c_3749_n N_noxref_15_c_3735_n \
 N_noxref_15_M13_noxref_d N_noxref_15_M14_noxref_s )  \
 PM_DFFSNX1_PCELL\%noxref_15
x_PM_DFFSNX1_PCELL\%noxref_16 ( N_noxref_16_c_3776_n N_noxref_16_c_3781_n \
 N_noxref_16_c_3797_n N_noxref_16_c_3799_n N_noxref_16_c_3804_n \
 N_noxref_16_c_3810_n N_noxref_16_c_3815_n N_noxref_16_c_3882_n \
 N_noxref_16_c_3782_n N_noxref_16_c_3827_n N_noxref_16_c_3783_n \
 N_noxref_16_c_3829_n N_noxref_16_c_3867_n N_noxref_16_c_3789_n \
 N_noxref_16_c_3832_n N_noxref_16_M14_noxref_d N_noxref_16_M39_noxref_d \
 N_noxref_16_M41_noxref_d N_noxref_16_M43_noxref_d )  \
 PM_DFFSNX1_PCELL\%noxref_16
x_PM_DFFSNX1_PCELL\%noxref_17 ( N_noxref_17_c_3929_n N_noxref_17_c_3930_n \
 N_noxref_17_c_3945_n N_noxref_17_c_3907_n N_noxref_17_c_3908_n \
 N_noxref_17_c_3954_n N_noxref_17_M0_noxref_s )  PM_DFFSNX1_PCELL\%noxref_17
x_PM_DFFSNX1_PCELL\%noxref_18 ( N_noxref_18_c_3967_n N_noxref_18_c_3969_n \
 N_noxref_18_c_3994_n N_noxref_18_c_3984_n N_noxref_18_c_3978_n \
 N_noxref_18_M2_noxref_s )  PM_DFFSNX1_PCELL\%noxref_18
x_PM_DFFSNX1_PCELL\%noxref_19 ( N_noxref_19_c_4027_n N_noxref_19_c_4029_n \
 N_noxref_19_c_4057_n N_noxref_19_c_4041_n N_noxref_19_c_4043_n \
 N_noxref_19_M5_noxref_s )  PM_DFFSNX1_PCELL\%noxref_19
x_PM_DFFSNX1_PCELL\%noxref_20 ( N_noxref_20_c_4087_n N_noxref_20_c_4088_n \
 N_noxref_20_c_4132_n N_noxref_20_c_4095_n N_noxref_20_c_4102_n \
 N_noxref_20_c_4141_n N_noxref_20_M8_noxref_s )  PM_DFFSNX1_PCELL\%noxref_20
x_PM_DFFSNX1_PCELL\%noxref_21 ( N_noxref_21_c_4154_n N_noxref_21_c_4155_n \
 N_noxref_21_c_4195_n N_noxref_21_c_4162_n N_noxref_21_c_4169_n \
 N_noxref_21_c_4204_n N_noxref_21_M10_noxref_s )  PM_DFFSNX1_PCELL\%noxref_21
x_PM_DFFSNX1_PCELL\%noxref_22 ( N_noxref_22_c_4220_n N_noxref_22_c_4221_n \
 N_noxref_22_c_4240_n N_noxref_22_c_4222_n N_noxref_22_c_4224_n \
 N_noxref_22_M12_noxref_s )  PM_DFFSNX1_PCELL\%noxref_22
cc_1 ( N_noxref_1_M26_noxref_g N_noxref_2_c_395_n ) capacitor c=0.00893512f \
 //x=9.89 //y=6.02 //x2=10.43 //y2=5.155
cc_2 ( N_noxref_1_M25_noxref_g N_noxref_2_c_396_n ) capacitor c=0.00461408f \
 //x=9.45 //y=6.02 //x2=9.672 //y2=5.155
cc_3 ( N_noxref_1_M26_noxref_g N_noxref_2_c_396_n ) capacitor c=0.00229208f \
 //x=9.89 //y=6.02 //x2=9.672 //y2=5.155
cc_4 ( N_noxref_1_c_4_p N_noxref_2_c_396_n ) capacitor c=0.00171885f //x=9.815 \
 //y=4.79 //x2=9.672 //y2=5.155
cc_5 ( N_noxref_1_c_5_p N_noxref_2_c_399_n ) capacitor c=4.26537e-19 //x=9.25 \
 //y=2.59 //x2=12.21 //y2=2.59
cc_6 ( N_noxref_1_M25_noxref_g N_noxref_2_c_400_n ) capacitor c=0.0162284f \
 //x=9.45 //y=6.02 //x2=9.67 //y2=5.38
cc_7 ( N_noxref_1_M26_noxref_g N_noxref_2_c_400_n ) capacitor c=0.0179041f \
 //x=9.89 //y=6.02 //x2=9.67 //y2=5.38
cc_8 ( N_noxref_1_c_4_p N_noxref_2_c_400_n ) capacitor c=0.00291477f //x=9.815 \
 //y=4.79 //x2=9.67 //y2=5.38
cc_9 ( N_noxref_1_c_9_p N_noxref_3_c_682_n ) capacitor c=0.0115546f //x=4.44 \
 //y=2.195 //x2=5.55 //y2=2.195
cc_10 ( N_noxref_1_c_10_p N_noxref_3_c_682_n ) capacitor c=0.00386237f \
 //x=9.09 //y=2.595 //x2=5.55 //y2=2.195
cc_11 ( N_noxref_1_c_11_p N_noxref_3_c_682_n ) capacitor c=5.40058e-19 \
 //x=4.44 //y=2.08 //x2=5.55 //y2=2.195
cc_12 ( N_noxref_1_c_12_p N_noxref_3_c_682_n ) capacitor c=0.00147006f \
 //x=4.14 //y=1.915 //x2=5.55 //y2=2.195
cc_13 ( N_noxref_1_c_13_p N_noxref_3_c_686_n ) capacitor c=5.24004e-19 \
 //x=2.59 //y=2.43 //x2=5.55 //y2=4.415
cc_14 ( N_noxref_1_c_14_p N_noxref_3_c_686_n ) capacitor c=0.00136634f \
 //x=2.59 //y=5.115 //x2=5.55 //y2=4.415
cc_15 ( N_noxref_1_c_15_p N_noxref_3_c_686_n ) capacitor c=0.00648708f \
 //x=4.44 //y=2.43 //x2=5.55 //y2=4.415
cc_16 ( N_noxref_1_c_16_p N_noxref_3_c_686_n ) capacitor c=0.00765388f \
 //x=4.44 //y=2.75 //x2=5.55 //y2=4.415
cc_17 ( N_noxref_1_c_17_p N_noxref_3_c_686_n ) capacitor c=0.048986f //x=4.44 \
 //y=4.575 //x2=5.55 //y2=4.415
cc_18 ( N_noxref_1_c_18_p N_noxref_3_c_686_n ) capacitor c=2.98349e-19 \
 //x=4.44 //y=2.585 //x2=5.55 //y2=4.415
cc_19 ( N_noxref_1_c_19_p N_noxref_3_c_686_n ) capacitor c=0.00242466f //x=4.6 \
 //y=2.59 //x2=5.55 //y2=4.415
cc_20 ( N_noxref_1_c_10_p N_noxref_3_c_686_n ) capacitor c=0.0320922f //x=9.09 \
 //y=2.595 //x2=5.55 //y2=4.415
cc_21 ( N_noxref_1_c_11_p N_noxref_3_c_686_n ) capacitor c=4.16726e-19 \
 //x=4.44 //y=2.08 //x2=5.55 //y2=4.415
cc_22 ( N_noxref_1_c_17_p N_noxref_3_c_695_n ) capacitor c=0.0119263f //x=4.44 \
 //y=4.575 //x2=5.55 //y2=4.575
cc_23 ( N_noxref_1_c_23_p N_noxref_3_c_695_n ) capacitor c=8.35331e-19 \
 //x=4.44 //y=4.7 //x2=5.55 //y2=4.575
cc_24 ( N_noxref_1_c_24_p N_noxref_3_c_695_n ) capacitor c=7.55789e-19 \
 //x=5.005 //y=4.79 //x2=5.55 //y2=4.575
cc_25 ( N_noxref_1_c_25_p N_noxref_3_c_695_n ) capacitor c=8.63332e-19 \
 //x=4.715 //y=4.79 //x2=5.55 //y2=4.575
cc_26 ( N_noxref_1_c_26_p N_noxref_3_c_699_n ) capacitor c=0.0332142f //x=9.25 \
 //y=4.575 //x2=7.61 //y2=4.455
cc_27 ( N_noxref_1_c_17_p N_noxref_3_c_700_n ) capacitor c=0.00733425f \
 //x=4.44 //y=4.575 //x2=5.55 //y2=4.44
cc_28 ( N_noxref_1_c_10_p N_noxref_3_c_700_n ) capacitor c=0.00243053f \
 //x=9.09 //y=2.595 //x2=5.55 //y2=4.44
cc_29 ( N_noxref_1_c_9_p N_noxref_3_c_702_n ) capacitor c=5.39999e-19 //x=4.44 \
 //y=2.195 //x2=5.55 //y2=2.08
cc_30 ( N_noxref_1_c_15_p N_noxref_3_c_702_n ) capacitor c=4.16726e-19 \
 //x=4.44 //y=2.43 //x2=5.55 //y2=2.08
cc_31 ( N_noxref_1_c_11_p N_noxref_3_c_702_n ) capacitor c=0.00125213f \
 //x=4.44 //y=2.08 //x2=5.55 //y2=2.08
cc_32 ( N_noxref_1_c_12_p N_noxref_3_c_702_n ) capacitor c=0.00214573f \
 //x=4.14 //y=1.915 //x2=5.55 //y2=2.08
cc_33 ( N_noxref_1_c_17_p N_noxref_3_c_706_n ) capacitor c=5.64453e-19 \
 //x=4.44 //y=4.575 //x2=5.55 //y2=4.7
cc_34 ( N_noxref_1_c_23_p N_noxref_3_c_706_n ) capacitor c=0.00113668f \
 //x=4.44 //y=4.7 //x2=5.55 //y2=4.7
cc_35 ( N_noxref_1_c_24_p N_noxref_3_c_706_n ) capacitor c=0.00116563f \
 //x=5.005 //y=4.79 //x2=5.55 //y2=4.7
cc_36 ( N_noxref_1_c_25_p N_noxref_3_c_706_n ) capacitor c=0.0012974f \
 //x=4.715 //y=4.79 //x2=5.55 //y2=4.7
cc_37 ( N_noxref_1_M19_noxref_g N_noxref_3_M21_noxref_g ) capacitor \
 c=0.0106276f //x=4.64 //y=6.02 //x2=5.52 //y2=6.02
cc_38 ( N_noxref_1_M20_noxref_g N_noxref_3_M21_noxref_g ) capacitor \
 c=0.107144f //x=5.08 //y=6.02 //x2=5.52 //y2=6.02
cc_39 ( N_noxref_1_M20_noxref_g N_noxref_3_M22_noxref_g ) capacitor \
 c=0.0101598f //x=5.08 //y=6.02 //x2=5.96 //y2=6.02
cc_40 ( N_noxref_1_c_40_p N_noxref_3_c_713_n ) capacitor c=5.72528e-19 \
 //x=4.14 //y=0.875 //x2=5.115 //y2=0.91
cc_41 ( N_noxref_1_c_41_p N_noxref_3_c_713_n ) capacitor c=0.00150277f \
 //x=4.14 //y=1.22 //x2=5.115 //y2=0.91
cc_42 ( N_noxref_1_c_42_p N_noxref_3_c_713_n ) capacitor c=0.0160123f //x=4.67 \
 //y=0.875 //x2=5.115 //y2=0.91
cc_43 ( N_noxref_1_c_43_p N_noxref_3_c_716_n ) capacitor c=0.00111227f \
 //x=4.14 //y=1.53 //x2=5.115 //y2=1.22
cc_44 ( N_noxref_1_c_44_p N_noxref_3_c_716_n ) capacitor c=0.0124075f //x=4.67 \
 //y=1.22 //x2=5.115 //y2=1.22
cc_45 ( N_noxref_1_c_42_p N_noxref_3_c_718_n ) capacitor c=9.19165e-19 \
 //x=4.67 //y=0.875 //x2=5.64 //y2=0.91
cc_46 ( N_noxref_1_c_44_p N_noxref_3_c_719_n ) capacitor c=0.0010154f //x=4.67 \
 //y=1.22 //x2=5.64 //y2=1.22
cc_47 ( N_noxref_1_c_44_p N_noxref_3_c_720_n ) capacitor c=9.23422e-19 \
 //x=4.67 //y=1.22 //x2=5.64 //y2=1.45
cc_48 ( N_noxref_1_c_9_p N_noxref_3_c_721_n ) capacitor c=0.00140534f //x=4.44 \
 //y=2.195 //x2=5.64 //y2=1.915
cc_49 ( N_noxref_1_c_11_p N_noxref_3_c_721_n ) capacitor c=0.0020754f //x=4.44 \
 //y=2.08 //x2=5.64 //y2=1.915
cc_50 ( N_noxref_1_c_12_p N_noxref_3_c_721_n ) capacitor c=0.00964411f \
 //x=4.14 //y=1.915 //x2=5.64 //y2=1.915
cc_51 ( N_noxref_1_c_23_p N_noxref_3_c_724_n ) capacitor c=0.00123917f \
 //x=4.44 //y=4.7 //x2=5.55 //y2=4.7
cc_52 ( N_noxref_1_c_24_p N_noxref_3_c_724_n ) capacitor c=0.0171228f \
 //x=5.005 //y=4.79 //x2=5.55 //y2=4.7
cc_53 ( N_noxref_1_c_25_p N_noxref_3_c_724_n ) capacitor c=0.00406071f \
 //x=4.715 //y=4.79 //x2=5.55 //y2=4.7
cc_54 ( N_noxref_1_c_13_p N_noxref_4_c_958_n ) capacitor c=0.0092434f //x=2.59 \
 //y=2.43 //x2=1.85 //y2=3.905
cc_55 ( N_noxref_1_c_55_p N_noxref_4_c_958_n ) capacitor c=0.0148501f //x=2.59 \
 //y=2.75 //x2=1.85 //y2=3.905
cc_56 ( N_noxref_1_c_14_p N_noxref_4_c_958_n ) capacitor c=0.0551358f //x=2.59 \
 //y=5.115 //x2=1.85 //y2=3.905
cc_57 ( N_noxref_1_c_15_p N_noxref_4_c_958_n ) capacitor c=6.31188e-19 \
 //x=4.44 //y=2.43 //x2=1.85 //y2=3.905
cc_58 ( N_noxref_1_c_17_p N_noxref_4_c_958_n ) capacitor c=0.00119034f \
 //x=4.44 //y=4.575 //x2=1.85 //y2=3.905
cc_59 ( N_noxref_1_c_59_p N_noxref_4_c_958_n ) capacitor c=6.20144e-19 \
 //x=2.59 //y=2.59 //x2=1.85 //y2=3.905
cc_60 ( N_noxref_1_c_60_p N_noxref_4_c_958_n ) capacitor c=0.00686847f \
 //x=2.75 //y=2.59 //x2=1.85 //y2=3.905
cc_61 ( N_noxref_1_c_61_p N_noxref_4_c_965_n ) capacitor c=0.00212208f \
 //x=1.995 //y=5.2 //x2=1.85 //y2=4.225
cc_62 ( N_noxref_1_c_62_p N_noxref_4_c_965_n ) capacitor c=4.53917e-19 \
 //x=2.235 //y=1.655 //x2=1.85 //y2=4.225
cc_63 ( N_noxref_1_c_14_p N_noxref_4_c_965_n ) capacitor c=0.0173413f //x=2.59 \
 //y=5.115 //x2=1.85 //y2=4.225
cc_64 ( N_noxref_1_c_64_p N_noxref_4_c_965_n ) capacitor c=0.00245839f \
 //x=2.11 //y=5.2 //x2=1.85 //y2=4.225
cc_65 ( N_noxref_1_c_65_p N_noxref_4_c_965_n ) capacitor c=8.00244e-19 \
 //x=2.11 //y=5.38 //x2=1.85 //y2=4.225
cc_66 ( N_noxref_1_c_61_p N_noxref_4_c_970_n ) capacitor c=0.0220622f \
 //x=1.995 //y=5.2 //x2=1.85 //y2=4.555
cc_67 ( N_noxref_1_c_14_p N_noxref_4_c_970_n ) capacitor c=0.0306018f //x=2.59 \
 //y=5.115 //x2=1.85 //y2=4.555
cc_68 ( N_noxref_1_c_17_p N_noxref_4_c_970_n ) capacitor c=0.00105013f \
 //x=4.44 //y=4.575 //x2=1.85 //y2=4.555
cc_69 ( N_noxref_1_M20_noxref_g N_noxref_4_c_973_n ) capacitor c=0.00973141f \
 //x=5.08 //y=6.02 //x2=5.62 //y2=5.155
cc_70 ( N_noxref_1_c_10_p N_noxref_4_c_974_n ) capacitor c=5.30005e-19 \
 //x=9.09 //y=2.595 //x2=6.915 //y2=1.125
cc_71 ( N_noxref_1_c_71_p N_noxref_4_c_975_n ) capacitor c=8.09327e-19 \
 //x=2.505 //y=1.655 //x2=6.915 //y2=1.58
cc_72 ( N_noxref_1_c_13_p N_noxref_4_c_976_n ) capacitor c=8.09327e-19 \
 //x=2.59 //y=2.43 //x2=7 //y2=1.665
cc_73 ( N_noxref_1_c_10_p N_noxref_4_c_976_n ) capacitor c=0.0143628f //x=9.09 \
 //y=2.595 //x2=7 //y2=1.665
cc_74 ( N_noxref_1_c_74_p N_noxref_4_c_978_n ) capacitor c=0.00458539f \
 //x=9.25 //y=2.195 //x2=7.4 //y2=3.91
cc_75 ( N_noxref_1_c_75_p N_noxref_4_c_978_n ) capacitor c=0.0035808f //x=9.25 \
 //y=2.435 //x2=7.4 //y2=3.91
cc_76 ( N_noxref_1_c_76_p N_noxref_4_c_978_n ) capacitor c=0.00248106f \
 //x=9.25 //y=2.755 //x2=7.4 //y2=3.91
cc_77 ( N_noxref_1_c_26_p N_noxref_4_c_978_n ) capacitor c=0.0200791f //x=9.25 \
 //y=4.575 //x2=7.4 //y2=3.91
cc_78 ( N_noxref_1_c_78_p N_noxref_4_c_978_n ) capacitor c=0.0015808f //x=9.25 \
 //y=2.595 //x2=7.4 //y2=3.91
cc_79 ( N_noxref_1_c_10_p N_noxref_4_c_978_n ) capacitor c=0.0324761f //x=9.09 \
 //y=2.595 //x2=7.4 //y2=3.91
cc_80 ( N_noxref_1_c_26_p N_noxref_4_c_984_n ) capacitor c=0.00251118f \
 //x=9.25 //y=4.575 //x2=7.4 //y2=4.23
cc_81 ( N_noxref_1_c_26_p N_noxref_4_c_985_n ) capacitor c=0.00765202f \
 //x=9.25 //y=4.575 //x2=7.4 //y2=5.07
cc_82 ( N_noxref_1_c_13_p N_noxref_4_c_986_n ) capacitor c=0.015397f //x=2.59 \
 //y=2.43 //x2=1.85 //y2=2.08
cc_83 ( N_noxref_1_c_14_p N_noxref_4_c_987_n ) capacitor c=5.56185e-19 \
 //x=2.59 //y=5.115 //x2=1.85 //y2=4.07
cc_84 ( N_noxref_1_c_14_p N_noxref_4_c_988_n ) capacitor c=0.00261914f \
 //x=2.59 //y=5.115 //x2=4.862 //y2=5.155
cc_85 ( N_noxref_1_c_64_p N_noxref_4_c_988_n ) capacitor c=5.0812e-19 //x=2.11 \
 //y=5.2 //x2=4.862 //y2=5.155
cc_86 ( N_noxref_1_M19_noxref_g N_noxref_4_c_988_n ) capacitor c=0.00461408f \
 //x=4.64 //y=6.02 //x2=4.862 //y2=5.155
cc_87 ( N_noxref_1_M20_noxref_g N_noxref_4_c_988_n ) capacitor c=0.00229208f \
 //x=5.08 //y=6.02 //x2=4.862 //y2=5.155
cc_88 ( N_noxref_1_c_24_p N_noxref_4_c_988_n ) capacitor c=0.00171885f \
 //x=5.005 //y=4.79 //x2=4.862 //y2=5.155
cc_89 ( N_noxref_1_c_55_p N_noxref_4_c_993_n ) capacitor c=0.00334974f \
 //x=2.59 //y=2.75 //x2=7.235 //y2=4.07
cc_90 ( N_noxref_1_c_14_p N_noxref_4_c_993_n ) capacitor c=0.0331543f //x=2.59 \
 //y=5.115 //x2=7.235 //y2=4.07
cc_91 ( N_noxref_1_c_16_p N_noxref_4_c_993_n ) capacitor c=0.00317239f \
 //x=4.44 //y=2.75 //x2=7.235 //y2=4.07
cc_92 ( N_noxref_1_c_17_p N_noxref_4_c_993_n ) capacitor c=0.0375646f //x=4.44 \
 //y=4.575 //x2=7.235 //y2=4.07
cc_93 ( N_noxref_1_c_64_p N_noxref_4_c_993_n ) capacitor c=0.014239f //x=2.11 \
 //y=5.2 //x2=7.235 //y2=4.07
cc_94 ( N_noxref_1_c_94_p N_noxref_4_c_993_n ) capacitor c=0.0386101f //x=4.28 \
 //y=2.59 //x2=7.235 //y2=4.07
cc_95 ( N_noxref_1_c_60_p N_noxref_4_c_993_n ) capacitor c=0.00523905f \
 //x=2.75 //y=2.59 //x2=7.235 //y2=4.07
cc_96 ( N_noxref_1_c_19_p N_noxref_4_c_993_n ) capacitor c=0.00523885f //x=4.6 \
 //y=2.59 //x2=7.235 //y2=4.07
cc_97 ( N_noxref_1_c_10_p N_noxref_4_c_993_n ) capacitor c=0.0496542f //x=9.09 \
 //y=2.595 //x2=7.235 //y2=4.07
cc_98 ( N_noxref_1_c_26_p N_noxref_4_c_1002_n ) capacitor c=0.00157696f \
 //x=9.25 //y=4.575 //x2=7.555 //y2=4.07
cc_99 ( N_noxref_1_c_61_p N_noxref_4_c_1003_n ) capacitor c=0.00119162f \
 //x=1.995 //y=5.2 //x2=2.01 //y2=4.065
cc_100 ( N_noxref_1_c_14_p N_noxref_4_c_1003_n ) capacitor c=0.0032735f \
 //x=2.59 //y=5.115 //x2=2.01 //y2=4.065
cc_101 ( N_noxref_1_c_64_p N_noxref_4_c_1003_n ) capacitor c=2.41886e-19 \
 //x=2.11 //y=5.2 //x2=2.01 //y2=4.065
cc_102 ( N_noxref_1_c_26_p N_noxref_4_c_1006_n ) capacitor c=0.0245637f \
 //x=9.25 //y=4.575 //x2=17.23 //y2=4.085
cc_103 ( N_noxref_1_c_10_p N_noxref_4_c_1006_n ) capacitor c=0.00532725f \
 //x=9.09 //y=2.595 //x2=17.23 //y2=4.085
cc_104 ( N_noxref_1_c_13_p N_noxref_4_c_1008_n ) capacitor c=9.90728e-19 \
 //x=2.59 //y=2.43 //x2=1.85 //y2=2.08
cc_105 ( N_noxref_1_c_61_p N_noxref_4_c_1009_n ) capacitor c=0.00469257f \
 //x=1.995 //y=5.2 //x2=1.88 //y2=4.7
cc_106 ( N_noxref_1_c_14_p N_noxref_4_c_1009_n ) capacitor c=7.76118e-19 \
 //x=2.59 //y=5.115 //x2=1.88 //y2=4.7
cc_107 ( N_noxref_1_M19_noxref_g N_noxref_4_c_1011_n ) capacitor c=0.0162284f \
 //x=4.64 //y=6.02 //x2=4.86 //y2=5.38
cc_108 ( N_noxref_1_M20_noxref_g N_noxref_4_c_1011_n ) capacitor c=0.0179041f \
 //x=5.08 //y=6.02 //x2=4.86 //y2=5.38
cc_109 ( N_noxref_1_c_24_p N_noxref_4_c_1011_n ) capacitor c=0.00291477f \
 //x=5.005 //y=4.79 //x2=4.86 //y2=5.38
cc_110 ( N_noxref_1_c_61_p N_noxref_4_M17_noxref_g ) capacitor c=0.00842859f \
 //x=1.995 //y=5.2 //x2=1.89 //y2=6.02
cc_111 ( N_noxref_1_c_64_p N_noxref_4_M17_noxref_g ) capacitor c=0.00192712f \
 //x=2.11 //y=5.2 //x2=1.89 //y2=6.02
cc_112 ( N_noxref_1_c_65_p N_noxref_4_M17_noxref_g ) capacitor c=0.0178987f \
 //x=2.11 //y=5.38 //x2=1.89 //y2=6.02
cc_113 ( N_noxref_1_c_113_p N_noxref_4_M18_noxref_g ) capacitor c=0.0110279f \
 //x=2.505 //y=5.2 //x2=2.33 //y2=6.02
cc_114 ( N_noxref_1_c_64_p N_noxref_4_M18_noxref_g ) capacitor c=0.00312463f \
 //x=2.11 //y=5.2 //x2=2.33 //y2=6.02
cc_115 ( N_noxref_1_c_65_p N_noxref_4_M18_noxref_g ) capacitor c=0.0178506f \
 //x=2.11 //y=5.38 //x2=2.33 //y2=6.02
cc_116 ( N_noxref_1_c_116_p N_noxref_4_c_1020_n ) capacitor c=0.00120406f \
 //x=2.15 //y=1 //x2=1.885 //y2=0.905
cc_117 ( N_noxref_1_M1_noxref_d N_noxref_4_c_1020_n ) capacitor c=0.00137165f \
 //x=1.96 //y=0.905 //x2=1.885 //y2=0.905
cc_118 ( N_noxref_1_c_118_p N_noxref_4_c_1022_n ) capacitor c=0.00127432f \
 //x=2.15 //y=1.57 //x2=1.885 //y2=1.25
cc_119 ( N_noxref_1_c_116_p N_noxref_4_c_1022_n ) capacitor c=0.00220847f \
 //x=2.15 //y=1 //x2=1.885 //y2=1.25
cc_120 ( N_noxref_1_M1_noxref_d N_noxref_4_c_1022_n ) capacitor c=0.00237422f \
 //x=1.96 //y=0.905 //x2=1.885 //y2=1.25
cc_121 ( N_noxref_1_c_118_p N_noxref_4_c_1025_n ) capacitor c=0.00454577f \
 //x=2.15 //y=1.57 //x2=1.885 //y2=1.56
cc_122 ( N_noxref_1_c_14_p N_noxref_4_c_1026_n ) capacitor c=0.00874009f \
 //x=2.59 //y=5.115 //x2=2.255 //y2=4.79
cc_123 ( N_noxref_1_c_64_p N_noxref_4_c_1026_n ) capacitor c=0.0020269f \
 //x=2.11 //y=5.2 //x2=2.255 //y2=4.79
cc_124 ( N_noxref_1_c_65_p N_noxref_4_c_1026_n ) capacitor c=0.00302834f \
 //x=2.11 //y=5.38 //x2=2.255 //y2=4.79
cc_125 ( N_noxref_1_c_116_p N_noxref_4_c_1029_n ) capacitor c=5.50523e-19 \
 //x=2.15 //y=1 //x2=2.26 //y2=0.75
cc_126 ( N_noxref_1_M1_noxref_d N_noxref_4_c_1029_n ) capacitor c=0.0020782f \
 //x=1.96 //y=0.905 //x2=2.26 //y2=0.75
cc_127 ( N_noxref_1_c_118_p N_noxref_4_c_1031_n ) capacitor c=0.00942306f \
 //x=2.15 //y=1.57 //x2=2.26 //y2=1.405
cc_128 ( N_noxref_1_c_71_p N_noxref_4_c_1031_n ) capacitor c=0.00194324f \
 //x=2.505 //y=1.655 //x2=2.26 //y2=1.405
cc_129 ( N_noxref_1_c_116_p N_noxref_4_c_1031_n ) capacitor c=5.43945e-19 \
 //x=2.15 //y=1 //x2=2.26 //y2=1.405
cc_130 ( N_noxref_1_M1_noxref_d N_noxref_4_c_1031_n ) capacitor c=0.00356097f \
 //x=1.96 //y=0.905 //x2=2.26 //y2=1.405
cc_131 ( N_noxref_1_c_116_p N_noxref_4_c_1035_n ) capacitor c=0.00108157f \
 //x=2.15 //y=1 //x2=2.415 //y2=0.905
cc_132 ( N_noxref_1_M1_noxref_d N_noxref_4_c_1035_n ) capacitor c=8.50095e-19 \
 //x=1.96 //y=0.905 //x2=2.415 //y2=0.905
cc_133 ( N_noxref_1_c_118_p N_noxref_4_c_1037_n ) capacitor c=0.00341295f \
 //x=2.15 //y=1.57 //x2=2.415 //y2=1.25
cc_134 ( N_noxref_1_c_71_p N_noxref_4_c_1037_n ) capacitor c=0.00323005f \
 //x=2.505 //y=1.655 //x2=2.415 //y2=1.25
cc_135 ( N_noxref_1_c_116_p N_noxref_4_c_1037_n ) capacitor c=0.00312028f \
 //x=2.15 //y=1 //x2=2.415 //y2=1.25
cc_136 ( N_noxref_1_M1_noxref_d N_noxref_4_c_1037_n ) capacitor c=0.00237422f \
 //x=1.96 //y=0.905 //x2=2.415 //y2=1.25
cc_137 ( N_noxref_1_c_13_p N_noxref_4_c_1041_n ) capacitor c=0.00285392f \
 //x=2.59 //y=2.43 //x2=1.85 //y2=2.08
cc_138 ( N_noxref_1_c_118_p N_noxref_4_c_1042_n ) capacitor c=0.00371023f \
 //x=2.15 //y=1.57 //x2=1.85 //y2=1.915
cc_139 ( N_noxref_1_c_13_p N_noxref_4_c_1042_n ) capacitor c=0.00341496f \
 //x=2.59 //y=2.43 //x2=1.85 //y2=1.915
cc_140 ( N_noxref_1_c_61_p N_noxref_4_c_1044_n ) capacitor c=8.43115e-19 \
 //x=1.995 //y=5.2 //x2=1.88 //y2=4.7
cc_141 ( N_noxref_1_c_14_p N_noxref_4_c_1044_n ) capacitor c=0.00142201f \
 //x=2.59 //y=5.115 //x2=1.88 //y2=4.7
cc_142 ( N_noxref_1_c_74_p N_noxref_5_c_1422_n ) capacitor c=0.00840403f \
 //x=9.25 //y=2.195 //x2=10.36 //y2=2.37
cc_143 ( N_noxref_1_c_75_p N_noxref_5_c_1422_n ) capacitor c=0.00398079f \
 //x=9.25 //y=2.435 //x2=10.36 //y2=2.37
cc_144 ( N_noxref_1_c_144_p N_noxref_5_c_1422_n ) capacitor c=0.00116411f \
 //x=9.25 //y=2.08 //x2=10.36 //y2=2.37
cc_145 ( N_noxref_1_c_145_p N_noxref_5_c_1422_n ) capacitor c=0.0015646f \
 //x=8.95 //y=1.915 //x2=10.36 //y2=2.37
cc_146 ( N_noxref_1_c_75_p N_noxref_5_c_1426_n ) capacitor c=0.00188309f \
 //x=9.25 //y=2.435 //x2=10.36 //y2=4.585
cc_147 ( N_noxref_1_c_76_p N_noxref_5_c_1426_n ) capacitor c=0.00775314f \
 //x=9.25 //y=2.755 //x2=10.36 //y2=4.585
cc_148 ( N_noxref_1_c_26_p N_noxref_5_c_1426_n ) capacitor c=0.0595781f \
 //x=9.25 //y=4.575 //x2=10.36 //y2=4.585
cc_149 ( N_noxref_1_c_5_p N_noxref_5_c_1426_n ) capacitor c=2.69051e-19 \
 //x=9.25 //y=2.59 //x2=10.36 //y2=4.585
cc_150 ( N_noxref_1_c_78_p N_noxref_5_c_1426_n ) capacitor c=0.00508119f \
 //x=9.25 //y=2.595 //x2=10.36 //y2=4.585
cc_151 ( N_noxref_1_c_151_p N_noxref_5_c_1426_n ) capacitor c=6.26008e-19 \
 //x=9.25 //y=4.7 //x2=10.36 //y2=4.585
cc_152 ( N_noxref_1_c_4_p N_noxref_5_c_1426_n ) capacitor c=7.66769e-19 \
 //x=9.815 //y=4.79 //x2=10.36 //y2=4.585
cc_153 ( N_noxref_1_c_153_p N_noxref_5_c_1426_n ) capacitor c=7.54501e-19 \
 //x=9.525 //y=4.79 //x2=10.36 //y2=4.585
cc_154 ( N_noxref_1_c_74_p N_noxref_5_c_1434_n ) capacitor c=0.00331546f \
 //x=9.25 //y=2.195 //x2=10.52 //y2=2.21
cc_155 ( N_noxref_1_c_75_p N_noxref_5_c_1434_n ) capacitor c=0.00308827f \
 //x=9.25 //y=2.435 //x2=10.52 //y2=2.21
cc_156 ( N_noxref_1_c_74_p N_noxref_5_c_1436_n ) capacitor c=5.39999e-19 \
 //x=9.25 //y=2.195 //x2=10.36 //y2=2.08
cc_157 ( N_noxref_1_c_144_p N_noxref_5_c_1436_n ) capacitor c=0.00124907f \
 //x=9.25 //y=2.08 //x2=10.36 //y2=2.08
cc_158 ( N_noxref_1_c_145_p N_noxref_5_c_1436_n ) capacitor c=0.00214501f \
 //x=8.95 //y=1.915 //x2=10.36 //y2=2.08
cc_159 ( N_noxref_1_c_26_p N_noxref_5_c_1439_n ) capacitor c=0.00103399f \
 //x=9.25 //y=4.575 //x2=10.36 //y2=4.7
cc_160 ( N_noxref_1_c_151_p N_noxref_5_c_1439_n ) capacitor c=0.00113984f \
 //x=9.25 //y=4.7 //x2=10.36 //y2=4.7
cc_161 ( N_noxref_1_c_4_p N_noxref_5_c_1439_n ) capacitor c=0.00116563f \
 //x=9.815 //y=4.79 //x2=10.36 //y2=4.7
cc_162 ( N_noxref_1_c_153_p N_noxref_5_c_1439_n ) capacitor c=0.00129812f \
 //x=9.525 //y=4.79 //x2=10.36 //y2=4.7
cc_163 ( N_noxref_1_M25_noxref_g N_noxref_5_M27_noxref_g ) capacitor \
 c=0.0106276f //x=9.45 //y=6.02 //x2=10.33 //y2=6.02
cc_164 ( N_noxref_1_M26_noxref_g N_noxref_5_M27_noxref_g ) capacitor \
 c=0.107144f //x=9.89 //y=6.02 //x2=10.33 //y2=6.02
cc_165 ( N_noxref_1_M26_noxref_g N_noxref_5_M28_noxref_g ) capacitor \
 c=0.0101598f //x=9.89 //y=6.02 //x2=10.77 //y2=6.02
cc_166 ( N_noxref_1_c_166_p N_noxref_5_c_1446_n ) capacitor c=5.72528e-19 \
 //x=8.95 //y=0.875 //x2=9.925 //y2=0.91
cc_167 ( N_noxref_1_c_167_p N_noxref_5_c_1446_n ) capacitor c=0.00150277f \
 //x=8.95 //y=1.22 //x2=9.925 //y2=0.91
cc_168 ( N_noxref_1_c_168_p N_noxref_5_c_1446_n ) capacitor c=0.0160123f \
 //x=9.48 //y=0.875 //x2=9.925 //y2=0.91
cc_169 ( N_noxref_1_c_169_p N_noxref_5_c_1449_n ) capacitor c=0.00111227f \
 //x=8.95 //y=1.53 //x2=9.925 //y2=1.22
cc_170 ( N_noxref_1_c_170_p N_noxref_5_c_1449_n ) capacitor c=0.0124075f \
 //x=9.48 //y=1.22 //x2=9.925 //y2=1.22
cc_171 ( N_noxref_1_c_168_p N_noxref_5_c_1451_n ) capacitor c=9.19165e-19 \
 //x=9.48 //y=0.875 //x2=10.45 //y2=0.91
cc_172 ( N_noxref_1_c_170_p N_noxref_5_c_1452_n ) capacitor c=0.0010154f \
 //x=9.48 //y=1.22 //x2=10.45 //y2=1.22
cc_173 ( N_noxref_1_c_170_p N_noxref_5_c_1453_n ) capacitor c=9.23422e-19 \
 //x=9.48 //y=1.22 //x2=10.45 //y2=1.45
cc_174 ( N_noxref_1_c_74_p N_noxref_5_c_1454_n ) capacitor c=5.616e-19 \
 //x=9.25 //y=2.195 //x2=10.45 //y2=1.915
cc_175 ( N_noxref_1_c_144_p N_noxref_5_c_1454_n ) capacitor c=0.0017273f \
 //x=9.25 //y=2.08 //x2=10.45 //y2=1.915
cc_176 ( N_noxref_1_c_145_p N_noxref_5_c_1454_n ) capacitor c=0.00880777f \
 //x=8.95 //y=1.915 //x2=10.45 //y2=1.915
cc_177 ( N_noxref_1_c_26_p N_noxref_5_c_1457_n ) capacitor c=0.00116212f \
 //x=9.25 //y=4.575 //x2=10.36 //y2=4.7
cc_178 ( N_noxref_1_c_151_p N_noxref_5_c_1457_n ) capacitor c=0.00155973f \
 //x=9.25 //y=4.7 //x2=10.36 //y2=4.7
cc_179 ( N_noxref_1_c_4_p N_noxref_5_c_1457_n ) capacitor c=0.0171374f \
 //x=9.815 //y=4.79 //x2=10.36 //y2=4.7
cc_180 ( N_noxref_1_c_153_p N_noxref_5_c_1457_n ) capacitor c=0.00484466f \
 //x=9.525 //y=4.79 //x2=10.36 //y2=4.7
cc_181 ( N_noxref_1_c_10_p N_noxref_6_c_1734_n ) capacitor c=0.00309026f \
 //x=9.09 //y=2.595 //x2=6.66 //y2=2.195
cc_182 ( N_noxref_1_c_15_p N_noxref_6_c_1735_n ) capacitor c=3.89313e-19 \
 //x=4.44 //y=2.43 //x2=6.66 //y2=3.525
cc_183 ( N_noxref_1_c_17_p N_noxref_6_c_1735_n ) capacitor c=7.01483e-19 \
 //x=4.44 //y=4.575 //x2=6.66 //y2=3.525
cc_184 ( N_noxref_1_c_75_p N_noxref_6_c_1735_n ) capacitor c=6.49065e-19 \
 //x=9.25 //y=2.435 //x2=6.66 //y2=3.525
cc_185 ( N_noxref_1_c_26_p N_noxref_6_c_1735_n ) capacitor c=7.8587e-19 \
 //x=9.25 //y=4.575 //x2=6.66 //y2=3.525
cc_186 ( N_noxref_1_c_10_p N_noxref_6_c_1735_n ) capacitor c=0.0299047f \
 //x=9.09 //y=2.595 //x2=6.66 //y2=3.525
cc_187 ( N_noxref_1_c_10_p N_noxref_6_c_1740_n ) capacitor c=0.00271462f \
 //x=9.09 //y=2.595 //x2=6.66 //y2=3.845
cc_188 ( N_noxref_1_c_17_p N_noxref_6_c_1741_n ) capacitor c=0.00107139f \
 //x=4.44 //y=4.575 //x2=6.66 //y2=4.57
cc_189 ( N_noxref_1_c_26_p N_noxref_6_c_1741_n ) capacitor c=0.00104627f \
 //x=9.25 //y=4.575 //x2=6.66 //y2=4.57
cc_190 ( N_noxref_1_c_75_p N_noxref_6_c_1743_n ) capacitor c=4.47631e-19 \
 //x=9.25 //y=2.435 //x2=11.47 //y2=3.525
cc_191 ( N_noxref_1_c_26_p N_noxref_6_c_1743_n ) capacitor c=6.96952e-19 \
 //x=9.25 //y=4.575 //x2=11.47 //y2=3.525
cc_192 ( N_noxref_1_c_26_p N_noxref_6_c_1745_n ) capacitor c=5.89264e-19 \
 //x=9.25 //y=4.575 //x2=11.47 //y2=4.57
cc_193 ( N_noxref_1_c_10_p N_noxref_6_c_1746_n ) capacitor c=0.0267006f \
 //x=9.09 //y=2.595 //x2=7.01 //y2=3.7
cc_194 ( N_noxref_1_c_76_p N_noxref_6_c_1747_n ) capacitor c=0.00350734f \
 //x=9.25 //y=2.755 //x2=11.63 //y2=3.7
cc_195 ( N_noxref_1_c_26_p N_noxref_6_c_1747_n ) capacitor c=0.0288892f \
 //x=9.25 //y=4.575 //x2=11.63 //y2=3.7
cc_196 ( N_noxref_1_c_78_p N_noxref_6_c_1747_n ) capacitor c=0.00843566f \
 //x=9.25 //y=2.595 //x2=11.63 //y2=3.7
cc_197 ( N_noxref_1_c_10_p N_noxref_6_c_1747_n ) capacitor c=0.0451914f \
 //x=9.09 //y=2.595 //x2=11.63 //y2=3.7
cc_198 ( N_noxref_1_c_10_p N_noxref_6_c_1751_n ) capacitor c=0.00831864f \
 //x=9.09 //y=2.595 //x2=6.825 //y2=3.685
cc_199 ( N_noxref_1_c_61_p N_noxref_7_c_2294_n ) capacitor c=0.00647552f \
 //x=1.995 //y=5.2 //x2=23.68 //y2=7.4
cc_200 ( N_noxref_1_c_113_p N_noxref_7_c_2294_n ) capacitor c=0.0048744f \
 //x=2.505 //y=5.2 //x2=23.68 //y2=7.4
cc_201 ( N_noxref_1_c_201_p N_noxref_7_c_2294_n ) capacitor c=0.00368144f \
 //x=1.23 //y=5.38 //x2=23.68 //y2=7.4
cc_202 ( N_noxref_1_c_64_p N_noxref_7_c_2294_n ) capacitor c=8.41034e-19 \
 //x=2.11 //y=5.2 //x2=23.68 //y2=7.4
cc_203 ( N_noxref_1_c_203_p N_noxref_7_c_2294_n ) capacitor c=0.00285294f \
 //x=2.11 //y=5.38 //x2=23.68 //y2=7.4
cc_204 ( N_noxref_1_c_204_p N_noxref_7_c_2294_n ) capacitor c=0.00224727f \
 //x=1.23 //y=5.38 //x2=23.68 //y2=7.4
cc_205 ( N_noxref_1_c_65_p N_noxref_7_c_2294_n ) capacitor c=0.00224727f \
 //x=2.11 //y=5.38 //x2=23.68 //y2=7.4
cc_206 ( N_noxref_1_c_61_p N_noxref_7_c_2301_n ) capacitor c=0.00213214f \
 //x=1.995 //y=5.2 //x2=1.585 //y2=7.4
cc_207 ( N_noxref_1_c_201_p N_noxref_7_c_2301_n ) capacitor c=9.98713e-19 \
 //x=1.23 //y=5.38 //x2=1.585 //y2=7.4
cc_208 ( N_noxref_1_c_204_p N_noxref_7_c_2301_n ) capacitor c=0.0136475f \
 //x=1.23 //y=5.38 //x2=1.585 //y2=7.4
cc_209 ( N_noxref_1_c_61_p N_noxref_7_c_2304_n ) capacitor c=0.00180744f \
 //x=1.995 //y=5.2 //x2=2.465 //y2=7.4
cc_210 ( N_noxref_1_c_113_p N_noxref_7_c_2304_n ) capacitor c=0.00208112f \
 //x=2.505 //y=5.2 //x2=2.465 //y2=7.4
cc_211 ( N_noxref_1_c_64_p N_noxref_7_c_2304_n ) capacitor c=4.23323e-19 \
 //x=2.11 //y=5.2 //x2=2.465 //y2=7.4
cc_212 ( N_noxref_1_c_203_p N_noxref_7_c_2304_n ) capacitor c=5.78261e-19 \
 //x=2.11 //y=5.38 //x2=2.465 //y2=7.4
cc_213 ( N_noxref_1_c_65_p N_noxref_7_c_2304_n ) capacitor c=0.0136475f \
 //x=2.11 //y=5.38 //x2=2.465 //y2=7.4
cc_214 ( N_noxref_1_M19_noxref_g N_noxref_7_c_2309_n ) capacitor c=0.00749687f \
 //x=4.64 //y=6.02 //x2=5.215 //y2=7.4
cc_215 ( N_noxref_1_M20_noxref_g N_noxref_7_c_2309_n ) capacitor c=0.00749619f \
 //x=5.08 //y=6.02 //x2=5.215 //y2=7.4
cc_216 ( N_noxref_1_M25_noxref_g N_noxref_7_c_2311_n ) capacitor c=0.00749687f \
 //x=9.45 //y=6.02 //x2=10.025 //y2=7.4
cc_217 ( N_noxref_1_M26_noxref_g N_noxref_7_c_2311_n ) capacitor c=0.00749619f \
 //x=9.89 //y=6.02 //x2=10.025 //y2=7.4
cc_218 ( N_noxref_1_c_14_p N_noxref_7_c_2313_n ) capacitor c=0.00197052f \
 //x=2.59 //y=5.115 //x2=0.74 //y2=7.4
cc_219 ( N_noxref_1_c_201_p N_noxref_7_c_2313_n ) capacitor c=6.39392e-19 \
 //x=1.23 //y=5.38 //x2=0.74 //y2=7.4
cc_220 ( N_noxref_1_c_204_p N_noxref_7_c_2313_n ) capacitor c=0.0064135f \
 //x=1.23 //y=5.38 //x2=0.74 //y2=7.4
cc_221 ( N_noxref_1_c_14_p N_noxref_7_c_2316_n ) capacitor c=0.0306839f \
 //x=2.59 //y=5.115 //x2=3.33 //y2=7.4
cc_222 ( N_noxref_1_c_17_p N_noxref_7_c_2316_n ) capacitor c=0.0135962f \
 //x=4.44 //y=4.575 //x2=3.33 //y2=7.4
cc_223 ( N_noxref_1_c_64_p N_noxref_7_c_2316_n ) capacitor c=0.0025639f \
 //x=2.11 //y=5.2 //x2=3.33 //y2=7.4
cc_224 ( N_noxref_1_c_203_p N_noxref_7_c_2316_n ) capacitor c=4.19141e-19 \
 //x=2.11 //y=5.38 //x2=3.33 //y2=7.4
cc_225 ( N_noxref_1_c_94_p N_noxref_7_c_2316_n ) capacitor c=0.00182447f \
 //x=4.28 //y=2.59 //x2=3.33 //y2=7.4
cc_226 ( N_noxref_1_c_65_p N_noxref_7_c_2316_n ) capacitor c=0.0101861f \
 //x=2.11 //y=5.38 //x2=3.33 //y2=7.4
cc_227 ( N_noxref_1_c_23_p N_noxref_7_c_2316_n ) capacitor c=0.00370784f \
 //x=4.44 //y=4.7 //x2=3.33 //y2=7.4
cc_228 ( N_noxref_1_c_25_p N_noxref_7_c_2316_n ) capacitor c=0.00590568f \
 //x=4.715 //y=4.79 //x2=3.33 //y2=7.4
cc_229 ( N_noxref_1_c_26_p N_noxref_7_c_2324_n ) capacitor c=0.0116769f \
 //x=9.25 //y=4.575 //x2=8.14 //y2=7.4
cc_230 ( N_noxref_1_c_151_p N_noxref_7_c_2324_n ) capacitor c=0.00370784f \
 //x=9.25 //y=4.7 //x2=8.14 //y2=7.4
cc_231 ( N_noxref_1_c_153_p N_noxref_7_c_2324_n ) capacitor c=0.00590568f \
 //x=9.525 //y=4.79 //x2=8.14 //y2=7.4
cc_232 ( N_noxref_1_c_201_p N_noxref_7_M15_noxref_s ) capacitor c=0.062494f \
 //x=1.23 //y=5.38 //x2=0.655 //y2=5.02
cc_233 ( N_noxref_1_c_64_p N_noxref_7_M15_noxref_s ) capacitor c=6.52457e-19 \
 //x=2.11 //y=5.2 //x2=0.655 //y2=5.02
cc_234 ( N_noxref_1_c_204_p N_noxref_7_M15_noxref_s ) capacitor c=0.0906717f \
 //x=1.23 //y=5.38 //x2=0.655 //y2=5.02
cc_235 ( N_noxref_1_c_61_p N_noxref_7_M16_noxref_d ) capacitor c=0.00784426f \
 //x=1.995 //y=5.2 //x2=1.525 //y2=5.02
cc_236 ( N_noxref_1_c_201_p N_noxref_7_M16_noxref_d ) capacitor c=0.0043528f \
 //x=1.23 //y=5.38 //x2=1.525 //y2=5.02
cc_237 ( N_noxref_1_c_203_p N_noxref_7_M16_noxref_d ) capacitor c=0.0043528f \
 //x=2.11 //y=5.38 //x2=1.525 //y2=5.02
cc_238 ( N_noxref_1_c_204_p N_noxref_7_M16_noxref_d ) capacitor c=0.065554f \
 //x=1.23 //y=5.38 //x2=1.525 //y2=5.02
cc_239 ( N_noxref_1_c_65_p N_noxref_7_M16_noxref_d ) capacitor c=0.065554f \
 //x=2.11 //y=5.38 //x2=1.525 //y2=5.02
cc_240 ( N_noxref_1_c_113_p N_noxref_7_M18_noxref_d ) capacitor c=0.00982929f \
 //x=2.505 //y=5.2 //x2=2.405 //y2=5.02
cc_241 ( N_noxref_1_c_203_p N_noxref_7_M18_noxref_d ) capacitor c=0.00955781f \
 //x=2.11 //y=5.38 //x2=2.405 //y2=5.02
cc_242 ( N_noxref_1_c_59_p N_noxref_7_M18_noxref_d ) capacitor c=6.87188e-19 \
 //x=2.59 //y=2.59 //x2=2.405 //y2=5.02
cc_243 ( N_noxref_1_c_65_p N_noxref_7_M18_noxref_d ) capacitor c=0.065554f \
 //x=2.11 //y=5.38 //x2=2.405 //y2=5.02
cc_244 ( N_noxref_1_c_113_p N_noxref_7_M19_noxref_s ) capacitor c=0.00220019f \
 //x=2.505 //y=5.2 //x2=4.285 //y2=5.02
cc_245 ( N_noxref_1_c_16_p N_noxref_7_M19_noxref_s ) capacitor c=4.52606e-19 \
 //x=4.44 //y=2.75 //x2=4.285 //y2=5.02
cc_246 ( N_noxref_1_c_17_p N_noxref_7_M19_noxref_s ) capacitor c=0.0224588f \
 //x=4.44 //y=4.575 //x2=4.285 //y2=5.02
cc_247 ( N_noxref_1_c_64_p N_noxref_7_M19_noxref_s ) capacitor c=0.00371125f \
 //x=2.11 //y=5.2 //x2=4.285 //y2=5.02
cc_248 ( N_noxref_1_c_203_p N_noxref_7_M19_noxref_s ) capacitor c=9.52042e-19 \
 //x=2.11 //y=5.38 //x2=4.285 //y2=5.02
cc_249 ( N_noxref_1_c_23_p N_noxref_7_M19_noxref_s ) capacitor c=0.00911304f \
 //x=4.44 //y=4.7 //x2=4.285 //y2=5.02
cc_250 ( N_noxref_1_M19_noxref_g N_noxref_7_M19_noxref_s ) capacitor \
 c=0.053419f //x=4.64 //y=6.02 //x2=4.285 //y2=5.02
cc_251 ( N_noxref_1_c_25_p N_noxref_7_M19_noxref_s ) capacitor c=0.00608894f \
 //x=4.715 //y=4.79 //x2=4.285 //y2=5.02
cc_252 ( N_noxref_1_M20_noxref_g N_noxref_7_M20_noxref_d ) capacitor \
 c=0.015318f //x=5.08 //y=6.02 //x2=5.155 //y2=5.02
cc_253 ( N_noxref_1_c_76_p N_noxref_7_M25_noxref_s ) capacitor c=4.37432e-19 \
 //x=9.25 //y=2.755 //x2=9.095 //y2=5.02
cc_254 ( N_noxref_1_c_26_p N_noxref_7_M25_noxref_s ) capacitor c=0.0217983f \
 //x=9.25 //y=4.575 //x2=9.095 //y2=5.02
cc_255 ( N_noxref_1_c_151_p N_noxref_7_M25_noxref_s ) capacitor c=0.00983393f \
 //x=9.25 //y=4.7 //x2=9.095 //y2=5.02
cc_256 ( N_noxref_1_M25_noxref_g N_noxref_7_M25_noxref_s ) capacitor \
 c=0.053419f //x=9.45 //y=6.02 //x2=9.095 //y2=5.02
cc_257 ( N_noxref_1_c_153_p N_noxref_7_M25_noxref_s ) capacitor c=0.0060888f \
 //x=9.525 //y=4.79 //x2=9.095 //y2=5.02
cc_258 ( N_noxref_1_M26_noxref_g N_noxref_7_M26_noxref_d ) capacitor \
 c=0.015318f //x=9.89 //y=6.02 //x2=9.965 //y2=5.02
cc_259 ( N_noxref_1_c_201_p N_noxref_8_c_2676_n ) capacitor c=0.0118546f \
 //x=1.23 //y=5.38 //x2=1.11 //y2=4.7
cc_260 ( N_noxref_1_c_204_p N_noxref_8_c_2676_n ) capacitor c=0.00165549f \
 //x=1.23 //y=5.38 //x2=1.11 //y2=4.7
cc_261 ( N_noxref_1_c_13_p N_noxref_8_c_2678_n ) capacitor c=0.00102483f \
 //x=2.59 //y=2.43 //x2=1.112 //y2=4.56
cc_262 ( N_noxref_1_c_14_p N_noxref_8_c_2678_n ) capacitor c=0.00469187f \
 //x=2.59 //y=5.115 //x2=1.112 //y2=4.56
cc_263 ( N_noxref_1_c_201_p N_noxref_8_c_2680_n ) capacitor c=0.00277154f \
 //x=1.23 //y=5.38 //x2=1.11 //y2=4.7
cc_264 ( N_noxref_1_c_204_p N_noxref_8_c_2680_n ) capacitor c=0.00377369f \
 //x=1.23 //y=5.38 //x2=1.11 //y2=4.7
cc_265 ( N_noxref_1_c_201_p N_noxref_8_M15_noxref_g ) capacitor c=0.0020878f \
 //x=1.23 //y=5.38 //x2=1.01 //y2=6.02
cc_266 ( N_noxref_1_c_204_p N_noxref_8_M15_noxref_g ) capacitor c=0.0158358f \
 //x=1.23 //y=5.38 //x2=1.01 //y2=6.02
cc_267 ( N_noxref_1_c_61_p N_noxref_8_M16_noxref_g ) capacitor c=0.0129249f \
 //x=1.995 //y=5.2 //x2=1.45 //y2=6.02
cc_268 ( N_noxref_1_c_201_p N_noxref_8_M16_noxref_g ) capacitor c=0.00192712f \
 //x=1.23 //y=5.38 //x2=1.45 //y2=6.02
cc_269 ( N_noxref_1_c_204_p N_noxref_8_M16_noxref_g ) capacitor c=0.0178987f \
 //x=1.23 //y=5.38 //x2=1.45 //y2=6.02
cc_270 ( N_noxref_1_c_201_p N_noxref_8_c_2687_n ) capacitor c=0.00207241f \
 //x=1.23 //y=5.38 //x2=1.11 //y2=4.7
cc_271 ( N_noxref_1_c_204_p N_noxref_8_c_2687_n ) capacitor c=0.0043218f \
 //x=1.23 //y=5.38 //x2=1.11 //y2=4.7
cc_272 ( N_noxref_1_c_10_p N_noxref_9_c_2776_n ) capacitor c=0.00528251f \
 //x=9.09 //y=2.595 //x2=6.345 //y2=0.995
cc_273 ( N_noxref_1_c_10_p N_noxref_9_c_2777_n ) capacitor c=2.88753e-19 \
 //x=9.09 //y=2.595 //x2=7.315 //y2=0.54
cc_274 ( N_noxref_1_c_116_p N_noxref_9_M3_noxref_d ) capacitor c=3.39394e-19 \
 //x=2.15 //y=1 //x2=5.19 //y2=0.91
cc_275 ( N_noxref_1_c_10_p N_noxref_9_M3_noxref_d ) capacitor c=0.00581656f \
 //x=9.09 //y=2.595 //x2=5.19 //y2=0.91
cc_276 ( N_noxref_1_c_10_p N_noxref_9_M4_noxref_s ) capacitor c=0.00354674f \
 //x=9.09 //y=2.595 //x2=6.295 //y2=0.375
cc_277 ( N_noxref_1_c_71_p N_noxref_13_c_3149_n ) capacitor c=0.00653239f \
 //x=2.505 //y=1.655 //x2=4.32 //y2=0
cc_278 ( N_noxref_1_c_55_p N_noxref_13_c_3149_n ) capacitor c=5.97638e-19 \
 //x=2.59 //y=2.75 //x2=4.32 //y2=0
cc_279 ( N_noxref_1_c_116_p N_noxref_13_c_3149_n ) capacitor c=0.00963092f \
 //x=2.15 //y=1 //x2=4.32 //y2=0
cc_280 ( N_noxref_1_M1_noxref_d N_noxref_13_c_3149_n ) capacitor c=3.01654e-19 \
 //x=1.96 //y=0.905 //x2=4.32 //y2=0
cc_281 ( N_noxref_1_c_40_p N_noxref_13_c_3153_n ) capacitor c=3.92414e-19 \
 //x=4.14 //y=0.875 //x2=4.405 //y2=0.835
cc_282 ( N_noxref_1_c_282_p N_noxref_13_c_3153_n ) capacitor c=0.00850983f \
 //x=4.515 //y=0.72 //x2=4.405 //y2=0.835
cc_283 ( N_noxref_1_c_42_p N_noxref_13_c_3153_n ) capacitor c=4.45447e-19 \
 //x=4.67 //y=0.875 //x2=4.405 //y2=0.835
cc_284 ( N_noxref_1_c_166_p N_noxref_13_c_3156_n ) capacitor c=3.97665e-19 \
 //x=8.95 //y=0.875 //x2=9.215 //y2=0.835
cc_285 ( N_noxref_1_c_285_p N_noxref_13_c_3156_n ) capacitor c=0.00864609f \
 //x=9.325 //y=0.72 //x2=9.215 //y2=0.835
cc_286 ( N_noxref_1_c_168_p N_noxref_13_c_3156_n ) capacitor c=4.45447e-19 \
 //x=9.48 //y=0.875 //x2=9.215 //y2=0.835
cc_287 ( N_noxref_1_c_201_p N_noxref_13_c_3159_n ) capacitor c=9.64329e-19 \
 //x=1.23 //y=5.38 //x2=1.18 //y2=0.955
cc_288 ( N_noxref_1_c_116_p N_noxref_13_c_3159_n ) capacitor c=0.0141894f \
 //x=2.15 //y=1 //x2=1.18 //y2=0.955
cc_289 ( N_noxref_1_M1_noxref_d N_noxref_13_c_3159_n ) capacitor c=2.93544e-19 \
 //x=1.96 //y=0.905 //x2=1.18 //y2=0.955
cc_290 ( N_noxref_1_c_9_p N_noxref_13_c_3162_n ) capacitor c=0.0079454f \
 //x=4.44 //y=2.195 //x2=4.405 //y2=0.965
cc_291 ( N_noxref_1_c_16_p N_noxref_13_c_3162_n ) capacitor c=0.00108886f \
 //x=4.44 //y=2.75 //x2=4.405 //y2=0.965
cc_292 ( N_noxref_1_c_116_p N_noxref_13_c_3162_n ) capacitor c=0.00606355f \
 //x=2.15 //y=1 //x2=4.405 //y2=0.965
cc_293 ( N_noxref_1_c_19_p N_noxref_13_c_3162_n ) capacitor c=0.00335863f \
 //x=4.6 //y=2.59 //x2=4.405 //y2=0.965
cc_294 ( N_noxref_1_c_11_p N_noxref_13_c_3162_n ) capacitor c=2.22861e-19 \
 //x=4.44 //y=2.08 //x2=4.405 //y2=0.965
cc_295 ( N_noxref_1_c_40_p N_noxref_13_c_3162_n ) capacitor c=0.0015128f \
 //x=4.14 //y=0.875 //x2=4.405 //y2=0.965
cc_296 ( N_noxref_1_c_41_p N_noxref_13_c_3162_n ) capacitor c=0.00350108f \
 //x=4.14 //y=1.22 //x2=4.405 //y2=0.965
cc_297 ( N_noxref_1_c_43_p N_noxref_13_c_3162_n ) capacitor c=4.09667e-19 \
 //x=4.14 //y=1.53 //x2=4.405 //y2=0.965
cc_298 ( N_noxref_1_c_282_p N_noxref_13_c_3162_n ) capacitor c=9.36995e-19 \
 //x=4.515 //y=0.72 //x2=4.405 //y2=0.965
cc_299 ( N_noxref_1_c_299_p N_noxref_13_c_3162_n ) capacitor c=5.27793e-19 \
 //x=4.515 //y=1.375 //x2=4.405 //y2=0.965
cc_300 ( N_noxref_1_c_42_p N_noxref_13_c_3162_n ) capacitor c=0.0017438f \
 //x=4.67 //y=0.875 //x2=4.405 //y2=0.965
cc_301 ( N_noxref_1_c_44_p N_noxref_13_c_3162_n ) capacitor c=0.00276804f \
 //x=4.67 //y=1.22 //x2=4.405 //y2=0.965
cc_302 ( N_noxref_1_c_74_p N_noxref_13_c_3174_n ) capacitor c=0.00794858f \
 //x=9.25 //y=2.195 //x2=9.215 //y2=0.965
cc_303 ( N_noxref_1_c_76_p N_noxref_13_c_3174_n ) capacitor c=0.00120974f \
 //x=9.25 //y=2.755 //x2=9.215 //y2=0.965
cc_304 ( N_noxref_1_c_78_p N_noxref_13_c_3174_n ) capacitor c=0.00334868f \
 //x=9.25 //y=2.595 //x2=9.215 //y2=0.965
cc_305 ( N_noxref_1_c_144_p N_noxref_13_c_3174_n ) capacitor c=2.22861e-19 \
 //x=9.25 //y=2.08 //x2=9.215 //y2=0.965
cc_306 ( N_noxref_1_c_166_p N_noxref_13_c_3174_n ) capacitor c=0.00156339f \
 //x=8.95 //y=0.875 //x2=9.215 //y2=0.965
cc_307 ( N_noxref_1_c_167_p N_noxref_13_c_3174_n ) capacitor c=0.00352472f \
 //x=8.95 //y=1.22 //x2=9.215 //y2=0.965
cc_308 ( N_noxref_1_c_169_p N_noxref_13_c_3174_n ) capacitor c=3.85805e-19 \
 //x=8.95 //y=1.53 //x2=9.215 //y2=0.965
cc_309 ( N_noxref_1_c_285_p N_noxref_13_c_3174_n ) capacitor c=9.36995e-19 \
 //x=9.325 //y=0.72 //x2=9.215 //y2=0.965
cc_310 ( N_noxref_1_c_310_p N_noxref_13_c_3174_n ) capacitor c=5.28241e-19 \
 //x=9.325 //y=1.375 //x2=9.215 //y2=0.965
cc_311 ( N_noxref_1_c_168_p N_noxref_13_c_3174_n ) capacitor c=0.0017438f \
 //x=9.48 //y=0.875 //x2=9.215 //y2=0.965
cc_312 ( N_noxref_1_c_170_p N_noxref_13_c_3174_n ) capacitor c=0.00276804f \
 //x=9.48 //y=1.22 //x2=9.215 //y2=0.965
cc_313 ( N_noxref_1_c_71_p N_noxref_13_c_3185_n ) capacitor c=7.76556e-19 \
 //x=2.505 //y=1.655 //x2=3.16 //y2=0
cc_314 ( N_noxref_1_c_55_p N_noxref_13_c_3185_n ) capacitor c=4.78557e-19 \
 //x=2.59 //y=2.75 //x2=3.16 //y2=0
cc_315 ( N_noxref_1_c_13_p N_noxref_13_c_3187_n ) capacitor c=0.00139243f \
 //x=2.59 //y=2.43 //x2=0.74 //y2=0
cc_316 ( N_noxref_1_c_59_p N_noxref_13_c_3187_n ) capacitor c=0.00133285f \
 //x=2.59 //y=2.59 //x2=0.74 //y2=0
cc_317 ( N_noxref_1_c_40_p N_noxref_13_c_3189_n ) capacitor c=0.00675021f \
 //x=4.14 //y=0.875 //x2=7.97 //y2=0
cc_318 ( N_noxref_1_c_166_p N_noxref_13_c_3190_n ) capacitor c=0.00675021f \
 //x=8.95 //y=0.875 //x2=12.78 //y2=0
cc_319 ( N_noxref_1_c_118_p N_noxref_13_c_3191_n ) capacitor c=0.00460657f \
 //x=2.15 //y=1.57 //x2=3.33 //y2=0
cc_320 ( N_noxref_1_c_71_p N_noxref_13_c_3191_n ) capacitor c=0.0229266f \
 //x=2.505 //y=1.655 //x2=3.33 //y2=0
cc_321 ( N_noxref_1_c_55_p N_noxref_13_c_3191_n ) capacitor c=0.00430881f \
 //x=2.59 //y=2.75 //x2=3.33 //y2=0
cc_322 ( N_noxref_1_c_9_p N_noxref_13_c_3191_n ) capacitor c=0.00407472f \
 //x=4.44 //y=2.195 //x2=3.33 //y2=0
cc_323 ( N_noxref_1_c_15_p N_noxref_13_c_3191_n ) capacitor c=0.00468396f \
 //x=4.44 //y=2.43 //x2=3.33 //y2=0
cc_324 ( N_noxref_1_c_16_p N_noxref_13_c_3191_n ) capacitor c=0.00272321f \
 //x=4.44 //y=2.75 //x2=3.33 //y2=0
cc_325 ( N_noxref_1_c_59_p N_noxref_13_c_3191_n ) capacitor c=0.0101608f \
 //x=2.59 //y=2.59 //x2=3.33 //y2=0
cc_326 ( N_noxref_1_c_18_p N_noxref_13_c_3191_n ) capacitor c=0.00539296f \
 //x=4.44 //y=2.585 //x2=3.33 //y2=0
cc_327 ( N_noxref_1_c_94_p N_noxref_13_c_3191_n ) capacitor c=0.0217368f \
 //x=4.28 //y=2.59 //x2=3.33 //y2=0
cc_328 ( N_noxref_1_c_11_p N_noxref_13_c_3191_n ) capacitor c=0.00394652f \
 //x=4.44 //y=2.08 //x2=3.33 //y2=0
cc_329 ( N_noxref_1_c_43_p N_noxref_13_c_3191_n ) capacitor c=0.00170145f \
 //x=4.14 //y=1.53 //x2=3.33 //y2=0
cc_330 ( N_noxref_1_c_12_p N_noxref_13_c_3191_n ) capacitor c=0.0103608f \
 //x=4.14 //y=1.915 //x2=3.33 //y2=0
cc_331 ( N_noxref_1_c_74_p N_noxref_13_c_3203_n ) capacitor c=0.00439019f \
 //x=9.25 //y=2.195 //x2=8.14 //y2=0
cc_332 ( N_noxref_1_c_75_p N_noxref_13_c_3203_n ) capacitor c=0.00436709f \
 //x=9.25 //y=2.435 //x2=8.14 //y2=0
cc_333 ( N_noxref_1_c_76_p N_noxref_13_c_3203_n ) capacitor c=0.00311095f \
 //x=9.25 //y=2.755 //x2=8.14 //y2=0
cc_334 ( N_noxref_1_c_5_p N_noxref_13_c_3203_n ) capacitor c=0.00528672f \
 //x=9.25 //y=2.59 //x2=8.14 //y2=0
cc_335 ( N_noxref_1_c_10_p N_noxref_13_c_3203_n ) capacitor c=0.0235189f \
 //x=9.09 //y=2.595 //x2=8.14 //y2=0
cc_336 ( N_noxref_1_c_144_p N_noxref_13_c_3203_n ) capacitor c=0.00394651f \
 //x=9.25 //y=2.08 //x2=8.14 //y2=0
cc_337 ( N_noxref_1_c_169_p N_noxref_13_c_3203_n ) capacitor c=0.00170145f \
 //x=8.95 //y=1.53 //x2=8.14 //y2=0
cc_338 ( N_noxref_1_c_145_p N_noxref_13_c_3203_n ) capacitor c=0.0103608f \
 //x=8.95 //y=1.915 //x2=8.14 //y2=0
cc_339 ( N_noxref_1_c_116_p N_noxref_13_M0_noxref_d ) capacitor c=2.82748e-19 \
 //x=2.15 //y=1 //x2=0.99 //y2=0.865
cc_340 ( N_noxref_1_c_9_p N_noxref_13_M2_noxref_d ) capacitor c=4.4417e-19 \
 //x=4.44 //y=2.195 //x2=4.215 //y2=0.875
cc_341 ( N_noxref_1_c_40_p N_noxref_13_M2_noxref_d ) capacitor c=0.00184354f \
 //x=4.14 //y=0.875 //x2=4.215 //y2=0.875
cc_342 ( N_noxref_1_c_41_p N_noxref_13_M2_noxref_d ) capacitor c=0.00210798f \
 //x=4.14 //y=1.22 //x2=4.215 //y2=0.875
cc_343 ( N_noxref_1_c_282_p N_noxref_13_M2_noxref_d ) capacitor c=0.00474029f \
 //x=4.515 //y=0.72 //x2=4.215 //y2=0.875
cc_344 ( N_noxref_1_c_299_p N_noxref_13_M2_noxref_d ) capacitor c=0.00166857f \
 //x=4.515 //y=1.375 //x2=4.215 //y2=0.875
cc_345 ( N_noxref_1_c_42_p N_noxref_13_M2_noxref_d ) capacitor c=0.00230174f \
 //x=4.67 //y=0.875 //x2=4.215 //y2=0.875
cc_346 ( N_noxref_1_c_44_p N_noxref_13_M2_noxref_d ) capacitor c=0.00210798f \
 //x=4.67 //y=1.22 //x2=4.215 //y2=0.875
cc_347 ( N_noxref_1_c_74_p N_noxref_13_M5_noxref_d ) capacitor c=4.4417e-19 \
 //x=9.25 //y=2.195 //x2=9.025 //y2=0.875
cc_348 ( N_noxref_1_c_166_p N_noxref_13_M5_noxref_d ) capacitor c=0.00184354f \
 //x=8.95 //y=0.875 //x2=9.025 //y2=0.875
cc_349 ( N_noxref_1_c_167_p N_noxref_13_M5_noxref_d ) capacitor c=0.00210798f \
 //x=8.95 //y=1.22 //x2=9.025 //y2=0.875
cc_350 ( N_noxref_1_c_285_p N_noxref_13_M5_noxref_d ) capacitor c=0.00474029f \
 //x=9.325 //y=0.72 //x2=9.025 //y2=0.875
cc_351 ( N_noxref_1_c_310_p N_noxref_13_M5_noxref_d ) capacitor c=0.00166857f \
 //x=9.325 //y=1.375 //x2=9.025 //y2=0.875
cc_352 ( N_noxref_1_c_168_p N_noxref_13_M5_noxref_d ) capacitor c=0.00230174f \
 //x=9.48 //y=0.875 //x2=9.025 //y2=0.875
cc_353 ( N_noxref_1_c_170_p N_noxref_13_M5_noxref_d ) capacitor c=0.00210798f \
 //x=9.48 //y=1.22 //x2=9.025 //y2=0.875
cc_354 ( N_noxref_1_c_62_p N_noxref_17_c_3907_n ) capacitor c=0.0103386f \
 //x=2.235 //y=1.655 //x2=1.665 //y2=1.495
cc_355 ( N_noxref_1_c_71_p N_noxref_17_c_3908_n ) capacitor c=0.00373013f \
 //x=2.505 //y=1.655 //x2=2.55 //y2=0.53
cc_356 ( N_noxref_1_c_116_p N_noxref_17_c_3908_n ) capacitor c=0.00367971f \
 //x=2.15 //y=1 //x2=2.55 //y2=0.53
cc_357 ( N_noxref_1_M1_noxref_d N_noxref_17_c_3908_n ) capacitor c=0.00910163f \
 //x=1.96 //y=0.905 //x2=2.55 //y2=0.53
cc_358 ( N_noxref_1_c_118_p N_noxref_17_M0_noxref_s ) capacitor c=0.0190756f \
 //x=2.15 //y=1.57 //x2=0.56 //y2=0.365
cc_359 ( N_noxref_1_c_71_p N_noxref_17_M0_noxref_s ) capacitor c=0.0055349f \
 //x=2.505 //y=1.655 //x2=0.56 //y2=0.365
cc_360 ( N_noxref_1_c_55_p N_noxref_17_M0_noxref_s ) capacitor c=7.86324e-19 \
 //x=2.59 //y=2.75 //x2=0.56 //y2=0.365
cc_361 ( N_noxref_1_c_116_p N_noxref_17_M0_noxref_s ) capacitor c=0.00900047f \
 //x=2.15 //y=1 //x2=0.56 //y2=0.365
cc_362 ( N_noxref_1_c_59_p N_noxref_17_M0_noxref_s ) capacitor c=0.00202552f \
 //x=2.59 //y=2.59 //x2=0.56 //y2=0.365
cc_363 ( N_noxref_1_M1_noxref_d N_noxref_17_M0_noxref_s ) capacitor \
 c=0.0275552f //x=1.96 //y=0.905 //x2=0.56 //y2=0.365
cc_364 ( N_noxref_1_c_94_p N_noxref_18_c_3967_n ) capacitor c=0.00355253f \
 //x=4.28 //y=2.59 //x2=3.92 //y2=1.505
cc_365 ( N_noxref_1_c_12_p N_noxref_18_c_3967_n ) capacitor c=0.00262672f \
 //x=4.14 //y=1.915 //x2=3.92 //y2=1.505
cc_366 ( N_noxref_1_c_9_p N_noxref_18_c_3969_n ) capacitor c=0.00428451f \
 //x=4.44 //y=2.195 //x2=4.805 //y2=1.59
cc_367 ( N_noxref_1_c_16_p N_noxref_18_c_3969_n ) capacitor c=0.00374191f \
 //x=4.44 //y=2.75 //x2=4.805 //y2=1.59
cc_368 ( N_noxref_1_c_94_p N_noxref_18_c_3969_n ) capacitor c=0.00626727f \
 //x=4.28 //y=2.59 //x2=4.805 //y2=1.59
cc_369 ( N_noxref_1_c_10_p N_noxref_18_c_3969_n ) capacitor c=0.00196699f \
 //x=9.09 //y=2.595 //x2=4.805 //y2=1.59
cc_370 ( N_noxref_1_c_11_p N_noxref_18_c_3969_n ) capacitor c=0.0104666f \
 //x=4.44 //y=2.08 //x2=4.805 //y2=1.59
cc_371 ( N_noxref_1_c_43_p N_noxref_18_c_3969_n ) capacitor c=0.00705077f \
 //x=4.14 //y=1.53 //x2=4.805 //y2=1.59
cc_372 ( N_noxref_1_c_12_p N_noxref_18_c_3969_n ) capacitor c=0.0209271f \
 //x=4.14 //y=1.915 //x2=4.805 //y2=1.59
cc_373 ( N_noxref_1_c_299_p N_noxref_18_c_3969_n ) capacitor c=0.00588627f \
 //x=4.515 //y=1.375 //x2=4.805 //y2=1.59
cc_374 ( N_noxref_1_c_44_p N_noxref_18_c_3969_n ) capacitor c=0.00698822f \
 //x=4.67 //y=1.22 //x2=4.805 //y2=1.59
cc_375 ( N_noxref_1_c_10_p N_noxref_18_c_3978_n ) capacitor c=0.00982891f \
 //x=9.09 //y=2.595 //x2=5.775 //y2=1.59
cc_376 ( N_noxref_1_c_10_p N_noxref_18_M2_noxref_s ) capacitor c=0.00659617f \
 //x=9.09 //y=2.595 //x2=3.785 //y2=0.375
cc_377 ( N_noxref_1_c_40_p N_noxref_18_M2_noxref_s ) capacitor c=0.0295256f \
 //x=4.14 //y=0.875 //x2=3.785 //y2=0.375
cc_378 ( N_noxref_1_c_43_p N_noxref_18_M2_noxref_s ) capacitor c=7.99997e-19 \
 //x=4.14 //y=1.53 //x2=3.785 //y2=0.375
cc_379 ( N_noxref_1_c_12_p N_noxref_18_M2_noxref_s ) capacitor c=0.00122123f \
 //x=4.14 //y=1.915 //x2=3.785 //y2=0.375
cc_380 ( N_noxref_1_c_42_p N_noxref_18_M2_noxref_s ) capacitor c=0.0125924f \
 //x=4.67 //y=0.875 //x2=3.785 //y2=0.375
cc_381 ( N_noxref_1_c_10_p N_noxref_19_c_4027_n ) capacitor c=0.00375801f \
 //x=9.09 //y=2.595 //x2=8.73 //y2=1.505
cc_382 ( N_noxref_1_c_145_p N_noxref_19_c_4027_n ) capacitor c=0.00262672f \
 //x=8.95 //y=1.915 //x2=8.73 //y2=1.505
cc_383 ( N_noxref_1_c_74_p N_noxref_19_c_4029_n ) capacitor c=0.00428451f \
 //x=9.25 //y=2.195 //x2=9.615 //y2=1.59
cc_384 ( N_noxref_1_c_76_p N_noxref_19_c_4029_n ) capacitor c=0.00449871f \
 //x=9.25 //y=2.755 //x2=9.615 //y2=1.59
cc_385 ( N_noxref_1_c_10_p N_noxref_19_c_4029_n ) capacitor c=0.00407827f \
 //x=9.09 //y=2.595 //x2=9.615 //y2=1.59
cc_386 ( N_noxref_1_c_144_p N_noxref_19_c_4029_n ) capacitor c=0.0104666f \
 //x=9.25 //y=2.08 //x2=9.615 //y2=1.59
cc_387 ( N_noxref_1_c_169_p N_noxref_19_c_4029_n ) capacitor c=0.00705077f \
 //x=8.95 //y=1.53 //x2=9.615 //y2=1.59
cc_388 ( N_noxref_1_c_145_p N_noxref_19_c_4029_n ) capacitor c=0.0201014f \
 //x=8.95 //y=1.915 //x2=9.615 //y2=1.59
cc_389 ( N_noxref_1_c_310_p N_noxref_19_c_4029_n ) capacitor c=0.00588627f \
 //x=9.325 //y=1.375 //x2=9.615 //y2=1.59
cc_390 ( N_noxref_1_c_170_p N_noxref_19_c_4029_n ) capacitor c=0.00754339f \
 //x=9.48 //y=1.22 //x2=9.615 //y2=1.59
cc_391 ( N_noxref_1_c_166_p N_noxref_19_M5_noxref_s ) capacitor c=0.0295256f \
 //x=8.95 //y=0.875 //x2=8.595 //y2=0.375
cc_392 ( N_noxref_1_c_169_p N_noxref_19_M5_noxref_s ) capacitor c=7.99997e-19 \
 //x=8.95 //y=1.53 //x2=8.595 //y2=0.375
cc_393 ( N_noxref_1_c_145_p N_noxref_19_M5_noxref_s ) capacitor c=0.00122123f \
 //x=8.95 //y=1.915 //x2=8.595 //y2=0.375
cc_394 ( N_noxref_1_c_168_p N_noxref_19_M5_noxref_s ) capacitor c=0.0125924f \
 //x=9.48 //y=0.875 //x2=8.595 //y2=0.375
cc_395 ( N_noxref_2_c_403_p N_noxref_3_c_727_n ) capacitor c=4.63397e-19 \
 //x=12.21 //y=2.445 //x2=14.8 //y2=4.41
cc_396 ( N_noxref_2_c_404_p N_noxref_3_c_727_n ) capacitor c=0.00217465f \
 //x=12.21 //y=5.07 //x2=14.8 //y2=4.41
cc_397 ( N_noxref_2_c_405_p N_noxref_3_c_727_n ) capacitor c=0.00839909f \
 //x=14.06 //y=2.445 //x2=14.8 //y2=4.41
cc_398 ( N_noxref_2_c_406_p N_noxref_3_c_727_n ) capacitor c=0.014957f \
 //x=14.06 //y=2.765 //x2=14.8 //y2=4.41
cc_399 ( N_noxref_2_c_407_p N_noxref_3_c_727_n ) capacitor c=6.6241e-19 \
 //x=14.06 //y=2.59 //x2=14.8 //y2=4.41
cc_400 ( N_noxref_2_c_408_p N_noxref_3_c_727_n ) capacitor c=0.0694743f \
 //x=14.062 //y=4.56 //x2=14.8 //y2=4.41
cc_401 ( N_noxref_2_c_409_p N_noxref_3_c_727_n ) capacitor c=0.00693435f \
 //x=14.055 //y=2.605 //x2=14.8 //y2=4.41
cc_402 ( N_noxref_2_c_410_p N_noxref_3_c_727_n ) capacitor c=3.30333e-19 \
 //x=14.06 //y=2.08 //x2=14.8 //y2=4.41
cc_403 ( N_noxref_2_c_411_p N_noxref_3_c_735_n ) capacitor c=0.0179797f \
 //x=14.06 //y=2.08 //x2=14.8 //y2=2.08
cc_404 ( N_noxref_2_c_410_p N_noxref_3_c_735_n ) capacitor c=5.16867e-19 \
 //x=14.06 //y=2.08 //x2=14.8 //y2=2.08
cc_405 ( N_noxref_2_c_413_p N_noxref_3_c_735_n ) capacitor c=0.00161745f \
 //x=13.865 //y=1.915 //x2=14.8 //y2=2.08
cc_406 ( N_noxref_2_c_414_p N_noxref_3_c_738_n ) capacitor c=0.0160977f \
 //x=14.06 //y=4.7 //x2=14.835 //y2=4.57
cc_407 ( N_noxref_2_c_408_p N_noxref_3_c_738_n ) capacitor c=0.00638948f \
 //x=14.062 //y=4.56 //x2=14.835 //y2=4.57
cc_408 ( N_noxref_2_c_416_p N_noxref_3_c_738_n ) capacitor c=0.00121956f \
 //x=14.06 //y=4.7 //x2=14.835 //y2=4.57
cc_409 ( N_noxref_2_c_417_p N_noxref_3_c_738_n ) capacitor c=0.00177782f \
 //x=14.06 //y=4.7 //x2=14.835 //y2=4.57
cc_410 ( N_noxref_2_c_418_p N_noxref_3_c_699_n ) capacitor c=0.0218207f \
 //x=12.125 //y=5.155 //x2=7.61 //y2=4.455
cc_411 ( N_noxref_2_c_404_p N_noxref_3_c_699_n ) capacitor c=0.0300365f \
 //x=12.21 //y=5.07 //x2=7.61 //y2=4.455
cc_412 ( N_noxref_2_c_396_n N_noxref_3_c_699_n ) capacitor c=0.0297372f \
 //x=9.672 //y=5.155 //x2=7.61 //y2=4.455
cc_413 ( N_noxref_2_c_421_p N_noxref_3_c_699_n ) capacitor c=0.0378349f \
 //x=10.55 //y=5.155 //x2=7.61 //y2=4.455
cc_414 ( N_noxref_2_c_414_p N_noxref_3_c_699_n ) capacitor c=0.00901811f \
 //x=14.06 //y=4.7 //x2=7.61 //y2=4.455
cc_415 ( N_noxref_2_c_408_p N_noxref_3_c_699_n ) capacitor c=0.0273494f \
 //x=14.062 //y=4.56 //x2=7.61 //y2=4.455
cc_416 ( N_noxref_2_c_405_p N_noxref_3_c_748_n ) capacitor c=3.30333e-19 \
 //x=14.06 //y=2.445 //x2=14.8 //y2=2.08
cc_417 ( N_noxref_2_c_411_p N_noxref_3_c_748_n ) capacitor c=5.24723e-19 \
 //x=14.06 //y=2.08 //x2=14.8 //y2=2.08
cc_418 ( N_noxref_2_c_410_p N_noxref_3_c_748_n ) capacitor c=0.00485709f \
 //x=14.06 //y=2.08 //x2=14.8 //y2=2.08
cc_419 ( N_noxref_2_c_413_p N_noxref_3_c_748_n ) capacitor c=0.00190888f \
 //x=13.865 //y=1.915 //x2=14.8 //y2=2.08
cc_420 ( N_noxref_2_c_414_p N_noxref_3_c_752_n ) capacitor c=4.80626e-19 \
 //x=14.06 //y=4.7 //x2=14.83 //y2=4.7
cc_421 ( N_noxref_2_c_416_p N_noxref_3_c_752_n ) capacitor c=0.0039678f \
 //x=14.06 //y=4.7 //x2=14.83 //y2=4.7
cc_422 ( N_noxref_2_c_417_p N_noxref_3_c_752_n ) capacitor c=0.0028411f \
 //x=14.06 //y=4.7 //x2=14.83 //y2=4.7
cc_423 ( N_noxref_2_M31_noxref_g N_noxref_3_M33_noxref_g ) capacitor \
 c=0.0104892f //x=13.96 //y=6.02 //x2=14.84 //y2=6.02
cc_424 ( N_noxref_2_M32_noxref_g N_noxref_3_M33_noxref_g ) capacitor \
 c=0.107636f //x=14.4 //y=6.02 //x2=14.84 //y2=6.02
cc_425 ( N_noxref_2_M32_noxref_g N_noxref_3_M34_noxref_g ) capacitor \
 c=0.0100341f //x=14.4 //y=6.02 //x2=15.28 //y2=6.02
cc_426 ( N_noxref_2_c_434_p N_noxref_3_c_758_n ) capacitor c=4.86545e-19 \
 //x=13.865 //y=0.865 //x2=14.835 //y2=0.905
cc_427 ( N_noxref_2_c_435_p N_noxref_3_c_758_n ) capacitor c=0.00152405f \
 //x=13.865 //y=1.21 //x2=14.835 //y2=0.905
cc_428 ( N_noxref_2_c_436_p N_noxref_3_c_758_n ) capacitor c=0.0151475f \
 //x=14.395 //y=0.865 //x2=14.835 //y2=0.905
cc_429 ( N_noxref_2_c_437_p N_noxref_3_c_761_n ) capacitor c=0.00109982f \
 //x=13.865 //y=1.52 //x2=14.835 //y2=1.25
cc_430 ( N_noxref_2_c_438_p N_noxref_3_c_761_n ) capacitor c=0.0111064f \
 //x=14.395 //y=1.21 //x2=14.835 //y2=1.25
cc_431 ( N_noxref_2_c_437_p N_noxref_3_c_763_n ) capacitor c=9.58243e-19 \
 //x=13.865 //y=1.52 //x2=14.835 //y2=1.56
cc_432 ( N_noxref_2_c_413_p N_noxref_3_c_763_n ) capacitor c=0.00662747f \
 //x=13.865 //y=1.915 //x2=14.835 //y2=1.56
cc_433 ( N_noxref_2_c_438_p N_noxref_3_c_763_n ) capacitor c=0.00862358f \
 //x=14.395 //y=1.21 //x2=14.835 //y2=1.56
cc_434 ( N_noxref_2_c_436_p N_noxref_3_c_766_n ) capacitor c=0.00127211f \
 //x=14.395 //y=0.865 //x2=15.365 //y2=0.905
cc_435 ( N_noxref_2_c_438_p N_noxref_3_c_767_n ) capacitor c=0.00204774f \
 //x=14.395 //y=1.21 //x2=15.365 //y2=1.25
cc_436 ( N_noxref_2_c_411_p N_noxref_3_c_768_n ) capacitor c=0.00161167f \
 //x=14.06 //y=2.08 //x2=14.8 //y2=2.08
cc_437 ( N_noxref_2_c_410_p N_noxref_3_c_768_n ) capacitor c=0.00266443f \
 //x=14.06 //y=2.08 //x2=14.8 //y2=2.08
cc_438 ( N_noxref_2_c_413_p N_noxref_3_c_768_n ) capacitor c=0.0181449f \
 //x=13.865 //y=1.915 //x2=14.8 //y2=2.08
cc_439 ( N_noxref_2_c_414_p N_noxref_3_c_771_n ) capacitor c=5.5856e-19 \
 //x=14.06 //y=4.7 //x2=14.83 //y2=4.7
cc_440 ( N_noxref_2_c_416_p N_noxref_3_c_771_n ) capacitor c=0.00211091f \
 //x=14.06 //y=4.7 //x2=14.83 //y2=4.7
cc_441 ( N_noxref_2_c_417_p N_noxref_3_c_771_n ) capacitor c=0.0291521f \
 //x=14.06 //y=4.7 //x2=14.83 //y2=4.7
cc_442 ( N_noxref_2_c_396_n N_noxref_4_c_1046_n ) capacitor c=6.09703e-19 \
 //x=9.672 //y=5.155 //x2=6.62 //y2=5.38
cc_443 ( N_noxref_2_c_396_n N_noxref_4_c_1047_n ) capacitor c=0.00306432f \
 //x=9.672 //y=5.155 //x2=7.315 //y2=5.155
cc_444 ( N_noxref_2_c_452_p N_noxref_4_c_1048_n ) capacitor c=0.00163399f \
 //x=11.81 //y=1.665 //x2=7.315 //y2=1.665
cc_445 ( N_noxref_2_c_404_p N_noxref_4_c_1006_n ) capacitor c=0.0233658f \
 //x=12.21 //y=5.07 //x2=17.23 //y2=4.085
cc_446 ( N_noxref_2_c_408_p N_noxref_4_c_1006_n ) capacitor c=0.0233519f \
 //x=14.062 //y=4.56 //x2=17.23 //y2=4.085
cc_447 ( N_noxref_2_c_455_p N_noxref_4_c_1006_n ) capacitor c=0.00564023f \
 //x=13.895 //y=2.605 //x2=17.23 //y2=4.085
cc_448 ( N_noxref_2_c_395_n N_noxref_5_c_1422_n ) capacitor c=3.45015e-19 \
 //x=10.43 //y=5.155 //x2=10.36 //y2=2.37
cc_449 ( N_noxref_2_c_421_p N_noxref_5_c_1422_n ) capacitor c=4.44961e-19 \
 //x=10.55 //y=5.155 //x2=10.36 //y2=2.37
cc_450 ( N_noxref_2_c_395_n N_noxref_5_c_1426_n ) capacitor c=0.0213631f \
 //x=10.43 //y=5.155 //x2=10.36 //y2=4.585
cc_451 ( N_noxref_2_c_404_p N_noxref_5_c_1426_n ) capacitor c=0.00246091f \
 //x=12.21 //y=5.07 //x2=10.36 //y2=4.585
cc_452 ( N_noxref_2_c_421_p N_noxref_5_c_1426_n ) capacitor c=0.00239361f \
 //x=10.55 //y=5.155 //x2=10.36 //y2=4.585
cc_453 ( N_noxref_2_c_461_p N_noxref_5_c_1426_n ) capacitor c=7.85344e-19 \
 //x=10.55 //y=5.38 //x2=10.36 //y2=4.585
cc_454 ( N_noxref_2_c_462_p N_noxref_5_c_1467_n ) capacitor c=7.08559e-19 \
 //x=11.725 //y=1.125 //x2=21.66 //y2=2.21
cc_455 ( N_noxref_2_c_452_p N_noxref_5_c_1467_n ) capacitor c=0.0210985f \
 //x=11.81 //y=1.665 //x2=21.66 //y2=2.21
cc_456 ( N_noxref_2_c_403_p N_noxref_5_c_1467_n ) capacitor c=0.0272596f \
 //x=12.21 //y=2.445 //x2=21.66 //y2=2.21
cc_457 ( N_noxref_2_c_465_p N_noxref_5_c_1467_n ) capacitor c=0.00838306f \
 //x=12.21 //y=2.765 //x2=21.66 //y2=2.21
cc_458 ( N_noxref_2_c_405_p N_noxref_5_c_1467_n ) capacitor c=0.0121034f \
 //x=14.06 //y=2.445 //x2=21.66 //y2=2.21
cc_459 ( N_noxref_2_c_406_p N_noxref_5_c_1467_n ) capacitor c=0.00673157f \
 //x=14.06 //y=2.765 //x2=21.66 //y2=2.21
cc_460 ( N_noxref_2_c_411_p N_noxref_5_c_1467_n ) capacitor c=0.0165635f \
 //x=14.06 //y=2.08 //x2=21.66 //y2=2.21
cc_461 ( N_noxref_2_c_469_p N_noxref_5_c_1467_n ) capacitor c=0.0365231f \
 //x=12.37 //y=2.605 //x2=21.66 //y2=2.21
cc_462 ( N_noxref_2_c_409_p N_noxref_5_c_1467_n ) capacitor c=0.0371276f \
 //x=14.055 //y=2.605 //x2=21.66 //y2=2.21
cc_463 ( N_noxref_2_c_455_p N_noxref_5_c_1467_n ) capacitor c=0.139504f \
 //x=13.895 //y=2.605 //x2=21.66 //y2=2.21
cc_464 ( N_noxref_2_c_410_p N_noxref_5_c_1467_n ) capacitor c=2.20453e-19 \
 //x=14.06 //y=2.08 //x2=21.66 //y2=2.21
cc_465 ( N_noxref_2_c_395_n N_noxref_5_c_1439_n ) capacitor c=0.00492634f \
 //x=10.43 //y=5.155 //x2=10.36 //y2=4.7
cc_466 ( N_noxref_2_c_421_p N_noxref_5_c_1439_n ) capacitor c=0.00132214f \
 //x=10.55 //y=5.155 //x2=10.36 //y2=4.7
cc_467 ( N_noxref_2_c_395_n N_noxref_5_M27_noxref_g ) capacitor c=0.00858241f \
 //x=10.43 //y=5.155 //x2=10.33 //y2=6.02
cc_468 ( N_noxref_2_c_421_p N_noxref_5_M27_noxref_g ) capacitor c=0.00229818f \
 //x=10.55 //y=5.155 //x2=10.33 //y2=6.02
cc_469 ( N_noxref_2_c_461_p N_noxref_5_M27_noxref_g ) capacitor c=0.0179041f \
 //x=10.55 //y=5.38 //x2=10.33 //y2=6.02
cc_470 ( N_noxref_2_c_478_p N_noxref_5_M28_noxref_g ) capacitor c=0.00955829f \
 //x=11.315 //y=5.155 //x2=10.77 //y2=6.02
cc_471 ( N_noxref_2_c_421_p N_noxref_5_M28_noxref_g ) capacitor c=0.00230699f \
 //x=10.55 //y=5.155 //x2=10.77 //y2=6.02
cc_472 ( N_noxref_2_c_461_p N_noxref_5_M28_noxref_g ) capacitor c=0.0179041f \
 //x=10.55 //y=5.38 //x2=10.77 //y2=6.02
cc_473 ( N_noxref_2_c_421_p N_noxref_5_c_1486_n ) capacitor c=0.00181015f \
 //x=10.55 //y=5.155 //x2=10.695 //y2=4.79
cc_474 ( N_noxref_2_c_461_p N_noxref_5_c_1486_n ) capacitor c=0.00290085f \
 //x=10.55 //y=5.38 //x2=10.695 //y2=4.79
cc_475 ( N_noxref_2_c_395_n N_noxref_5_c_1457_n ) capacitor c=6.14744e-19 \
 //x=10.43 //y=5.155 //x2=10.36 //y2=4.7
cc_476 ( N_noxref_2_c_403_p N_noxref_6_c_1752_n ) capacitor c=0.013943f \
 //x=12.21 //y=2.445 //x2=11.47 //y2=2.195
cc_477 ( N_noxref_2_c_403_p N_noxref_6_c_1743_n ) capacitor c=0.00898347f \
 //x=12.21 //y=2.445 //x2=11.47 //y2=3.525
cc_478 ( N_noxref_2_c_465_p N_noxref_6_c_1743_n ) capacitor c=0.0151188f \
 //x=12.21 //y=2.765 //x2=11.47 //y2=3.525
cc_479 ( N_noxref_2_c_404_p N_noxref_6_c_1743_n ) capacitor c=0.0362911f \
 //x=12.21 //y=5.07 //x2=11.47 //y2=3.525
cc_480 ( N_noxref_2_c_405_p N_noxref_6_c_1743_n ) capacitor c=4.63723e-19 \
 //x=14.06 //y=2.445 //x2=11.47 //y2=3.525
cc_481 ( N_noxref_2_c_399_n N_noxref_6_c_1743_n ) capacitor c=6.77171e-19 \
 //x=12.21 //y=2.59 //x2=11.47 //y2=3.525
cc_482 ( N_noxref_2_c_408_p N_noxref_6_c_1743_n ) capacitor c=7.7565e-19 \
 //x=14.062 //y=4.56 //x2=11.47 //y2=3.525
cc_483 ( N_noxref_2_c_469_p N_noxref_6_c_1743_n ) capacitor c=0.00696908f \
 //x=12.37 //y=2.605 //x2=11.47 //y2=3.525
cc_484 ( N_noxref_2_c_478_p N_noxref_6_c_1760_n ) capacitor c=0.00167286f \
 //x=11.315 //y=5.155 //x2=11.47 //y2=3.845
cc_485 ( N_noxref_2_c_418_p N_noxref_6_c_1760_n ) capacitor c=4.08809e-19 \
 //x=12.125 //y=5.155 //x2=11.47 //y2=3.845
cc_486 ( N_noxref_2_c_404_p N_noxref_6_c_1760_n ) capacitor c=0.0148932f \
 //x=12.21 //y=5.07 //x2=11.47 //y2=3.845
cc_487 ( N_noxref_2_c_418_p N_noxref_6_c_1745_n ) capacitor c=0.00228791f \
 //x=12.125 //y=5.155 //x2=11.47 //y2=4.57
cc_488 ( N_noxref_2_c_404_p N_noxref_6_c_1745_n ) capacitor c=0.042978f \
 //x=12.21 //y=5.07 //x2=11.47 //y2=4.57
cc_489 ( N_noxref_2_c_497_p N_noxref_6_c_1745_n ) capacitor c=0.0221235f \
 //x=11.43 //y=5.155 //x2=11.47 //y2=4.57
cc_490 ( N_noxref_2_c_408_p N_noxref_6_c_1745_n ) capacitor c=8.71319e-19 \
 //x=14.062 //y=4.56 //x2=11.47 //y2=4.57
cc_491 ( N_noxref_2_c_499_p N_noxref_6_c_1745_n ) capacitor c=0.00217653f \
 //x=11.43 //y=5.38 //x2=11.47 //y2=4.57
cc_492 ( N_noxref_2_M32_noxref_g N_noxref_6_c_1768_n ) capacitor c=0.00889217f \
 //x=14.4 //y=6.02 //x2=14.945 //y2=5.2
cc_493 ( N_noxref_2_c_501_p N_noxref_6_c_1769_n ) capacitor c=0.00326079f \
 //x=11.725 //y=1.58 //x2=15.1 //y2=1.57
cc_494 ( N_noxref_2_c_502_p N_noxref_6_c_1770_n ) capacitor c=0.00218808f \
 //x=12.125 //y=1.665 //x2=15.185 //y2=1.655
cc_495 ( N_noxref_2_c_502_p N_noxref_6_c_1771_n ) capacitor c=0.00203605f \
 //x=12.125 //y=1.665 //x2=15.54 //y2=3.525
cc_496 ( N_noxref_2_c_405_p N_noxref_6_c_1771_n ) capacitor c=6.61269e-19 \
 //x=14.06 //y=2.445 //x2=15.54 //y2=3.525
cc_497 ( N_noxref_2_c_408_p N_noxref_6_c_1771_n ) capacitor c=0.00127779f \
 //x=14.062 //y=4.56 //x2=15.54 //y2=3.525
cc_498 ( N_noxref_2_c_404_p N_noxref_6_c_1774_n ) capacitor c=0.00283621f \
 //x=12.21 //y=5.07 //x2=15.54 //y2=5.115
cc_499 ( N_noxref_2_c_408_p N_noxref_6_c_1774_n ) capacitor c=0.00195062f \
 //x=14.062 //y=4.56 //x2=15.54 //y2=5.115
cc_500 ( N_noxref_2_c_404_p N_noxref_6_c_1776_n ) capacitor c=9.19401e-19 \
 //x=12.21 //y=5.07 //x2=11.47 //y2=3.7
cc_501 ( N_noxref_2_c_509_p N_noxref_6_c_1777_n ) capacitor c=5.58535e-19 \
 //x=11.43 //y=5.38 //x2=14.18 //y2=5.38
cc_502 ( N_noxref_2_c_418_p N_noxref_6_c_1777_n ) capacitor c=0.00104762f \
 //x=12.125 //y=5.155 //x2=14.18 //y2=5.38
cc_503 ( N_noxref_2_c_406_p N_noxref_6_c_1777_n ) capacitor c=4.02865e-19 \
 //x=14.06 //y=2.765 //x2=14.18 //y2=5.38
cc_504 ( N_noxref_2_c_414_p N_noxref_6_c_1777_n ) capacitor c=0.0117744f \
 //x=14.06 //y=4.7 //x2=14.18 //y2=5.38
cc_505 ( N_noxref_2_c_416_p N_noxref_6_c_1777_n ) capacitor c=0.00277154f \
 //x=14.06 //y=4.7 //x2=14.18 //y2=5.38
cc_506 ( N_noxref_2_M31_noxref_g N_noxref_6_c_1777_n ) capacitor c=0.00201806f \
 //x=13.96 //y=6.02 //x2=14.18 //y2=5.38
cc_507 ( N_noxref_2_M32_noxref_g N_noxref_6_c_1777_n ) capacitor c=0.00192712f \
 //x=14.4 //y=6.02 //x2=14.18 //y2=5.38
cc_508 ( N_noxref_2_c_417_p N_noxref_6_c_1777_n ) capacitor c=0.00200677f \
 //x=14.06 //y=4.7 //x2=14.18 //y2=5.38
cc_509 ( N_noxref_2_c_462_p N_noxref_6_c_1785_n ) capacitor c=6.5615e-19 \
 //x=11.725 //y=1.125 //x2=15.1 //y2=1
cc_510 ( N_noxref_2_c_404_p N_noxref_6_c_1747_n ) capacitor c=0.00336755f \
 //x=12.21 //y=5.07 //x2=11.63 //y2=3.7
cc_511 ( N_noxref_2_c_465_p N_noxref_6_c_1787_n ) capacitor c=0.00454204f \
 //x=12.21 //y=2.765 //x2=15.375 //y2=3.685
cc_512 ( N_noxref_2_c_404_p N_noxref_6_c_1787_n ) capacitor c=0.0268865f \
 //x=12.21 //y=5.07 //x2=15.375 //y2=3.685
cc_513 ( N_noxref_2_c_406_p N_noxref_6_c_1787_n ) capacitor c=0.00308731f \
 //x=14.06 //y=2.765 //x2=15.375 //y2=3.685
cc_514 ( N_noxref_2_c_408_p N_noxref_6_c_1787_n ) capacitor c=0.0272967f \
 //x=14.062 //y=4.56 //x2=15.375 //y2=3.685
cc_515 ( N_noxref_2_c_469_p N_noxref_6_c_1787_n ) capacitor c=0.00829423f \
 //x=12.37 //y=2.605 //x2=15.375 //y2=3.685
cc_516 ( N_noxref_2_c_409_p N_noxref_6_c_1787_n ) capacitor c=0.00830817f \
 //x=14.055 //y=2.605 //x2=15.375 //y2=3.685
cc_517 ( N_noxref_2_c_455_p N_noxref_6_c_1787_n ) capacitor c=0.0472182f \
 //x=13.895 //y=2.605 //x2=15.375 //y2=3.685
cc_518 ( N_noxref_2_c_403_p N_noxref_6_c_1794_n ) capacitor c=0.0015536f \
 //x=12.21 //y=2.445 //x2=11.47 //y2=2.08
cc_519 ( N_noxref_2_c_418_p N_noxref_6_c_1795_n ) capacitor c=0.00130631f \
 //x=12.125 //y=5.155 //x2=11.47 //y2=4.7
cc_520 ( N_noxref_2_c_404_p N_noxref_6_c_1795_n ) capacitor c=0.00131258f \
 //x=12.21 //y=5.07 //x2=11.47 //y2=4.7
cc_521 ( N_noxref_2_c_497_p N_noxref_6_c_1795_n ) capacitor c=0.00346456f \
 //x=11.43 //y=5.155 //x2=11.47 //y2=4.7
cc_522 ( N_noxref_2_c_499_p N_noxref_6_c_1795_n ) capacitor c=0.00624059f \
 //x=11.43 //y=5.38 //x2=11.47 //y2=4.7
cc_523 ( N_noxref_2_c_414_p N_noxref_6_c_1799_n ) capacitor c=0.00104426f \
 //x=14.06 //y=4.7 //x2=14.18 //y2=5.38
cc_524 ( N_noxref_2_c_416_p N_noxref_6_c_1799_n ) capacitor c=0.00377369f \
 //x=14.06 //y=4.7 //x2=14.18 //y2=5.38
cc_525 ( N_noxref_2_M31_noxref_g N_noxref_6_c_1799_n ) capacitor c=0.0158358f \
 //x=13.96 //y=6.02 //x2=14.18 //y2=5.38
cc_526 ( N_noxref_2_M32_noxref_g N_noxref_6_c_1799_n ) capacitor c=0.0178987f \
 //x=14.4 //y=6.02 //x2=14.18 //y2=5.38
cc_527 ( N_noxref_2_c_417_p N_noxref_6_c_1799_n ) capacitor c=0.0043218f \
 //x=14.06 //y=4.7 //x2=14.18 //y2=5.38
cc_528 ( N_noxref_2_c_478_p N_noxref_6_M29_noxref_g ) capacitor c=0.00952006f \
 //x=11.315 //y=5.155 //x2=11.21 //y2=6.02
cc_529 ( N_noxref_2_c_509_p N_noxref_6_M29_noxref_g ) capacitor c=0.00226521f \
 //x=11.43 //y=5.38 //x2=11.21 //y2=6.02
cc_530 ( N_noxref_2_c_499_p N_noxref_6_M29_noxref_g ) capacitor c=0.0178885f \
 //x=11.43 //y=5.38 //x2=11.21 //y2=6.02
cc_531 ( N_noxref_2_c_509_p N_noxref_6_M30_noxref_g ) capacitor c=0.00368945f \
 //x=11.43 //y=5.38 //x2=11.65 //y2=6.02
cc_532 ( N_noxref_2_c_418_p N_noxref_6_M30_noxref_g ) capacitor c=0.010861f \
 //x=12.125 //y=5.155 //x2=11.65 //y2=6.02
cc_533 ( N_noxref_2_c_499_p N_noxref_6_M30_noxref_g ) capacitor c=0.0188608f \
 //x=11.43 //y=5.38 //x2=11.65 //y2=6.02
cc_534 ( N_noxref_2_c_462_p N_noxref_6_c_1810_n ) capacitor c=4.64015e-19 \
 //x=11.725 //y=1.125 //x2=11.46 //y2=0.915
cc_535 ( N_noxref_2_M7_noxref_d N_noxref_6_c_1810_n ) capacitor c=0.00137165f \
 //x=11.535 //y=0.915 //x2=11.46 //y2=0.915
cc_536 ( N_noxref_2_c_462_p N_noxref_6_c_1812_n ) capacitor c=0.0026012f \
 //x=11.725 //y=1.125 //x2=11.46 //y2=1.26
cc_537 ( N_noxref_2_c_501_p N_noxref_6_c_1812_n ) capacitor c=0.00127432f \
 //x=11.725 //y=1.58 //x2=11.46 //y2=1.26
cc_538 ( N_noxref_2_M7_noxref_d N_noxref_6_c_1812_n ) capacitor c=0.00237422f \
 //x=11.535 //y=0.915 //x2=11.46 //y2=1.26
cc_539 ( N_noxref_2_c_501_p N_noxref_6_c_1815_n ) capacitor c=0.00429966f \
 //x=11.725 //y=1.58 //x2=11.46 //y2=1.57
cc_540 ( N_noxref_2_c_462_p N_noxref_6_c_1816_n ) capacitor c=5.29969e-19 \
 //x=11.725 //y=1.125 //x2=11.835 //y2=0.76
cc_541 ( N_noxref_2_M7_noxref_d N_noxref_6_c_1816_n ) capacitor c=0.0020782f \
 //x=11.535 //y=0.915 //x2=11.835 //y2=0.76
cc_542 ( N_noxref_2_c_462_p N_noxref_6_c_1818_n ) capacitor c=5.31507e-19 \
 //x=11.725 //y=1.125 //x2=11.835 //y2=1.415
cc_543 ( N_noxref_2_c_501_p N_noxref_6_c_1818_n ) capacitor c=0.00930387f \
 //x=11.725 //y=1.58 //x2=11.835 //y2=1.415
cc_544 ( N_noxref_2_c_502_p N_noxref_6_c_1818_n ) capacitor c=0.00194716f \
 //x=12.125 //y=1.665 //x2=11.835 //y2=1.415
cc_545 ( N_noxref_2_M7_noxref_d N_noxref_6_c_1818_n ) capacitor c=0.00356097f \
 //x=11.535 //y=0.915 //x2=11.835 //y2=1.415
cc_546 ( N_noxref_2_c_462_p N_noxref_6_c_1822_n ) capacitor c=5.28622e-19 \
 //x=11.725 //y=1.125 //x2=11.99 //y2=0.915
cc_547 ( N_noxref_2_M7_noxref_d N_noxref_6_c_1822_n ) capacitor c=0.00139206f \
 //x=11.535 //y=0.915 //x2=11.99 //y2=0.915
cc_548 ( N_noxref_2_c_462_p N_noxref_6_c_1824_n ) capacitor c=0.00312156f \
 //x=11.725 //y=1.125 //x2=11.99 //y2=1.26
cc_549 ( N_noxref_2_c_501_p N_noxref_6_c_1824_n ) capacitor c=0.00347599f \
 //x=11.725 //y=1.58 //x2=11.99 //y2=1.26
cc_550 ( N_noxref_2_c_502_p N_noxref_6_c_1824_n ) capacitor c=0.00323576f \
 //x=12.125 //y=1.665 //x2=11.99 //y2=1.26
cc_551 ( N_noxref_2_M7_noxref_d N_noxref_6_c_1824_n ) capacitor c=0.00237422f \
 //x=11.535 //y=0.915 //x2=11.99 //y2=1.26
cc_552 ( N_noxref_2_c_403_p N_noxref_6_c_1828_n ) capacitor c=0.0024584f \
 //x=12.21 //y=2.445 //x2=11.47 //y2=2.08
cc_553 ( N_noxref_2_c_501_p N_noxref_6_c_1829_n ) capacitor c=0.0036273f \
 //x=11.725 //y=1.58 //x2=11.47 //y2=1.915
cc_554 ( N_noxref_2_c_403_p N_noxref_6_c_1829_n ) capacitor c=0.00282067f \
 //x=12.21 //y=2.445 //x2=11.47 //y2=1.915
cc_555 ( N_noxref_2_c_404_p N_noxref_6_c_1831_n ) capacitor c=0.00739875f \
 //x=12.21 //y=5.07 //x2=11.47 //y2=4.7
cc_556 ( N_noxref_2_c_497_p N_noxref_6_c_1831_n ) capacitor c=0.00203307f \
 //x=11.43 //y=5.155 //x2=11.47 //y2=4.7
cc_557 ( N_noxref_2_c_499_p N_noxref_6_c_1831_n ) capacitor c=0.00375636f \
 //x=11.43 //y=5.38 //x2=11.47 //y2=4.7
cc_558 ( N_noxref_2_c_395_n N_noxref_7_c_2294_n ) capacitor c=0.00620651f \
 //x=10.43 //y=5.155 //x2=23.68 //y2=7.4
cc_559 ( N_noxref_2_c_478_p N_noxref_7_c_2294_n ) capacitor c=0.00626467f \
 //x=11.315 //y=5.155 //x2=23.68 //y2=7.4
cc_560 ( N_noxref_2_c_509_p N_noxref_7_c_2294_n ) capacitor c=0.00255587f \
 //x=11.43 //y=5.38 //x2=23.68 //y2=7.4
cc_561 ( N_noxref_2_c_418_p N_noxref_7_c_2294_n ) capacitor c=0.00822764f \
 //x=12.125 //y=5.155 //x2=23.68 //y2=7.4
cc_562 ( N_noxref_2_c_396_n N_noxref_7_c_2294_n ) capacitor c=0.00261379f \
 //x=9.672 //y=5.155 //x2=23.68 //y2=7.4
cc_563 ( N_noxref_2_c_421_p N_noxref_7_c_2294_n ) capacitor c=0.0026965f \
 //x=10.55 //y=5.155 //x2=23.68 //y2=7.4
cc_564 ( N_noxref_2_c_414_p N_noxref_7_c_2294_n ) capacitor c=9.05427e-19 \
 //x=14.06 //y=4.7 //x2=23.68 //y2=7.4
cc_565 ( N_noxref_2_c_400_n N_noxref_7_c_2294_n ) capacitor c=0.00242194f \
 //x=9.67 //y=5.38 //x2=23.68 //y2=7.4
cc_566 ( N_noxref_2_c_461_p N_noxref_7_c_2294_n ) capacitor c=0.00242194f \
 //x=10.55 //y=5.38 //x2=23.68 //y2=7.4
cc_567 ( N_noxref_2_c_499_p N_noxref_7_c_2294_n ) capacitor c=0.00242194f \
 //x=11.43 //y=5.38 //x2=23.68 //y2=7.4
cc_568 ( N_noxref_2_c_416_p N_noxref_7_c_2294_n ) capacitor c=6.23118e-19 \
 //x=14.06 //y=4.7 //x2=23.68 //y2=7.4
cc_569 ( N_noxref_2_c_395_n N_noxref_7_c_2311_n ) capacitor c=0.00202948f \
 //x=10.43 //y=5.155 //x2=10.025 //y2=7.4
cc_570 ( N_noxref_2_c_396_n N_noxref_7_c_2311_n ) capacitor c=9.37357e-19 \
 //x=9.672 //y=5.155 //x2=10.025 //y2=7.4
cc_571 ( N_noxref_2_c_400_n N_noxref_7_c_2311_n ) capacitor c=0.0137846f \
 //x=9.67 //y=5.38 //x2=10.025 //y2=7.4
cc_572 ( N_noxref_2_c_395_n N_noxref_7_c_2368_n ) capacitor c=0.00177088f \
 //x=10.43 //y=5.155 //x2=10.905 //y2=7.4
cc_573 ( N_noxref_2_c_478_p N_noxref_7_c_2368_n ) capacitor c=0.00202948f \
 //x=11.315 //y=5.155 //x2=10.905 //y2=7.4
cc_574 ( N_noxref_2_c_421_p N_noxref_7_c_2368_n ) capacitor c=9.47876e-19 \
 //x=10.55 //y=5.155 //x2=10.905 //y2=7.4
cc_575 ( N_noxref_2_c_461_p N_noxref_7_c_2368_n ) capacitor c=0.0137846f \
 //x=10.55 //y=5.38 //x2=10.905 //y2=7.4
cc_576 ( N_noxref_2_c_478_p N_noxref_7_c_2372_n ) capacitor c=0.00205929f \
 //x=11.315 //y=5.155 //x2=11.785 //y2=7.4
cc_577 ( N_noxref_2_c_509_p N_noxref_7_c_2372_n ) capacitor c=8.49349e-19 \
 //x=11.43 //y=5.38 //x2=11.785 //y2=7.4
cc_578 ( N_noxref_2_c_418_p N_noxref_7_c_2372_n ) capacitor c=0.00204261f \
 //x=12.125 //y=5.155 //x2=11.785 //y2=7.4
cc_579 ( N_noxref_2_c_499_p N_noxref_7_c_2372_n ) capacitor c=0.0134886f \
 //x=11.43 //y=5.38 //x2=11.785 //y2=7.4
cc_580 ( N_noxref_2_c_418_p N_noxref_7_c_2376_n ) capacitor c=0.00183429f \
 //x=12.125 //y=5.155 //x2=12.78 //y2=7.4
cc_581 ( N_noxref_2_c_414_p N_noxref_7_c_2377_n ) capacitor c=6.28732e-19 \
 //x=14.06 //y=4.7 //x2=14.535 //y2=7.4
cc_582 ( N_noxref_2_M31_noxref_g N_noxref_7_c_2377_n ) capacitor c=0.0072715f \
 //x=13.96 //y=6.02 //x2=14.535 //y2=7.4
cc_583 ( N_noxref_2_M32_noxref_g N_noxref_7_c_2377_n ) capacitor c=0.00749619f \
 //x=14.4 //y=6.02 //x2=14.535 //y2=7.4
cc_584 ( N_noxref_2_c_396_n N_noxref_7_c_2324_n ) capacitor c=0.0022955f \
 //x=9.672 //y=5.155 //x2=8.14 //y2=7.4
cc_585 ( N_noxref_2_c_400_n N_noxref_7_c_2324_n ) capacitor c=0.00509469f \
 //x=9.67 //y=5.38 //x2=8.14 //y2=7.4
cc_586 ( N_noxref_2_c_509_p N_noxref_7_c_2382_n ) capacitor c=0.00269779f \
 //x=11.43 //y=5.38 //x2=12.95 //y2=7.4
cc_587 ( N_noxref_2_c_404_p N_noxref_7_c_2382_n ) capacitor c=0.0317189f \
 //x=12.21 //y=5.07 //x2=12.95 //y2=7.4
cc_588 ( N_noxref_2_c_414_p N_noxref_7_c_2382_n ) capacitor c=0.00483853f \
 //x=14.06 //y=4.7 //x2=12.95 //y2=7.4
cc_589 ( N_noxref_2_c_408_p N_noxref_7_c_2382_n ) capacitor c=0.00593318f \
 //x=14.062 //y=4.56 //x2=12.95 //y2=7.4
cc_590 ( N_noxref_2_c_499_p N_noxref_7_c_2382_n ) capacitor c=0.00776541f \
 //x=11.43 //y=5.38 //x2=12.95 //y2=7.4
cc_591 ( N_noxref_2_c_416_p N_noxref_7_c_2382_n ) capacitor c=0.00370494f \
 //x=14.06 //y=4.7 //x2=12.95 //y2=7.4
cc_592 ( N_noxref_2_c_417_p N_noxref_7_c_2382_n ) capacitor c=0.0129564f \
 //x=14.06 //y=4.7 //x2=12.95 //y2=7.4
cc_593 ( N_noxref_2_c_396_n N_noxref_7_M25_noxref_s ) capacitor c=0.0441176f \
 //x=9.672 //y=5.155 //x2=9.095 //y2=5.02
cc_594 ( N_noxref_2_c_421_p N_noxref_7_M25_noxref_s ) capacitor c=7.80122e-19 \
 //x=10.55 //y=5.155 //x2=9.095 //y2=5.02
cc_595 ( N_noxref_2_c_400_n N_noxref_7_M25_noxref_s ) capacitor c=0.09305f \
 //x=9.67 //y=5.38 //x2=9.095 //y2=5.02
cc_596 ( N_noxref_2_c_395_n N_noxref_7_M26_noxref_d ) capacitor c=0.00700078f \
 //x=10.43 //y=5.155 //x2=9.965 //y2=5.02
cc_597 ( N_noxref_2_c_400_n N_noxref_7_M26_noxref_d ) capacitor c=0.0674491f \
 //x=9.67 //y=5.38 //x2=9.965 //y2=5.02
cc_598 ( N_noxref_2_c_461_p N_noxref_7_M26_noxref_d ) capacitor c=0.0674762f \
 //x=10.55 //y=5.38 //x2=9.965 //y2=5.02
cc_599 ( N_noxref_2_c_478_p N_noxref_7_M28_noxref_d ) capacitor c=0.00700078f \
 //x=11.315 //y=5.155 //x2=10.845 //y2=5.02
cc_600 ( N_noxref_2_c_461_p N_noxref_7_M28_noxref_d ) capacitor c=0.067493f \
 //x=10.55 //y=5.38 //x2=10.845 //y2=5.02
cc_601 ( N_noxref_2_c_499_p N_noxref_7_M28_noxref_d ) capacitor c=0.0674288f \
 //x=11.43 //y=5.38 //x2=10.845 //y2=5.02
cc_602 ( N_noxref_2_c_418_p N_noxref_7_M30_noxref_d ) capacitor c=0.00700078f \
 //x=12.125 //y=5.155 //x2=11.725 //y2=5.02
cc_603 ( N_noxref_2_c_499_p N_noxref_7_M30_noxref_d ) capacitor c=0.0673824f \
 //x=11.43 //y=5.38 //x2=11.725 //y2=5.02
cc_604 ( N_noxref_2_c_509_p N_noxref_7_M31_noxref_s ) capacitor c=0.00536022f \
 //x=11.43 //y=5.38 //x2=13.605 //y2=5.02
cc_605 ( N_noxref_2_c_418_p N_noxref_7_M31_noxref_s ) capacitor c=0.00211796f \
 //x=12.125 //y=5.155 //x2=13.605 //y2=5.02
cc_606 ( N_noxref_2_c_406_p N_noxref_7_M31_noxref_s ) capacitor c=7.6965e-19 \
 //x=14.06 //y=2.765 //x2=13.605 //y2=5.02
cc_607 ( N_noxref_2_M31_noxref_g N_noxref_7_M31_noxref_s ) capacitor \
 c=0.0567929f //x=13.96 //y=6.02 //x2=13.605 //y2=5.02
cc_608 ( N_noxref_2_M32_noxref_g N_noxref_7_M32_noxref_d ) capacitor \
 c=0.015318f //x=14.4 //y=6.02 //x2=14.475 //y2=5.02
cc_609 ( N_noxref_2_c_462_p N_noxref_10_c_2845_n ) capacitor c=0.0036878f \
 //x=11.725 //y=1.125 //x2=12.125 //y2=0.54
cc_610 ( N_noxref_2_c_502_p N_noxref_10_c_2845_n ) capacitor c=0.00399931f \
 //x=12.125 //y=1.665 //x2=12.125 //y2=0.54
cc_611 ( N_noxref_2_M7_noxref_d N_noxref_10_c_2845_n ) capacitor c=0.00910163f \
 //x=11.535 //y=0.915 //x2=12.125 //y2=0.54
cc_612 ( N_noxref_2_M7_noxref_d N_noxref_10_c_2848_n ) capacitor c=0.00120711f \
 //x=11.535 //y=0.915 //x2=11.24 //y2=0.995
cc_613 ( N_noxref_2_c_395_n N_noxref_10_M6_noxref_d ) capacitor c=0.00140533f \
 //x=10.43 //y=5.155 //x2=10 //y2=0.91
cc_614 ( N_noxref_2_c_462_p N_noxref_10_M6_noxref_d ) capacitor c=0.00802836f \
 //x=11.725 //y=1.125 //x2=10 //y2=0.91
cc_615 ( N_noxref_2_c_462_p N_noxref_10_M7_noxref_s ) capacitor c=0.00993092f \
 //x=11.725 //y=1.125 //x2=11.105 //y2=0.375
cc_616 ( N_noxref_2_c_501_p N_noxref_10_M7_noxref_s ) capacitor c=0.0270624f \
 //x=11.725 //y=1.58 //x2=11.105 //y2=0.375
cc_617 ( N_noxref_2_c_502_p N_noxref_10_M7_noxref_s ) capacitor c=0.00752108f \
 //x=12.125 //y=1.665 //x2=11.105 //y2=0.375
cc_618 ( N_noxref_2_c_399_n N_noxref_10_M7_noxref_s ) capacitor c=0.00309975f \
 //x=12.21 //y=2.59 //x2=11.105 //y2=0.375
cc_619 ( N_noxref_2_M7_noxref_d N_noxref_10_M7_noxref_s ) capacitor \
 c=0.0279003f //x=11.535 //y=0.915 //x2=11.105 //y2=0.375
cc_620 ( N_noxref_2_c_462_p N_noxref_13_c_3226_n ) capacitor c=0.00877081f \
 //x=11.725 //y=1.125 //x2=14.045 //y2=0
cc_621 ( N_noxref_2_c_502_p N_noxref_13_c_3226_n ) capacitor c=0.00661744f \
 //x=12.125 //y=1.665 //x2=14.045 //y2=0
cc_622 ( N_noxref_2_c_465_p N_noxref_13_c_3226_n ) capacitor c=4.30081e-19 \
 //x=12.21 //y=2.765 //x2=14.045 //y2=0
cc_623 ( N_noxref_2_M7_noxref_d N_noxref_13_c_3226_n ) capacitor c=2.94508e-19 \
 //x=11.535 //y=0.915 //x2=14.045 //y2=0
cc_624 ( N_noxref_2_c_462_p N_noxref_13_c_3230_n ) capacitor c=0.00488628f \
 //x=11.725 //y=1.125 //x2=14.13 //y2=0.955
cc_625 ( N_noxref_2_c_406_p N_noxref_13_c_3230_n ) capacitor c=2.00349e-19 \
 //x=14.06 //y=2.765 //x2=14.13 //y2=0.955
cc_626 ( N_noxref_2_c_411_p N_noxref_13_c_3230_n ) capacitor c=0.00644901f \
 //x=14.06 //y=2.08 //x2=14.13 //y2=0.955
cc_627 ( N_noxref_2_c_410_p N_noxref_13_c_3230_n ) capacitor c=2.13705e-19 \
 //x=14.06 //y=2.08 //x2=14.13 //y2=0.955
cc_628 ( N_noxref_2_c_434_p N_noxref_13_c_3230_n ) capacitor c=0.00176535f \
 //x=13.865 //y=0.865 //x2=14.13 //y2=0.955
cc_629 ( N_noxref_2_c_435_p N_noxref_13_c_3230_n ) capacitor c=0.0036005f \
 //x=13.865 //y=1.21 //x2=14.13 //y2=0.955
cc_630 ( N_noxref_2_c_437_p N_noxref_13_c_3230_n ) capacitor c=4.2764e-19 \
 //x=13.865 //y=1.52 //x2=14.13 //y2=0.955
cc_631 ( N_noxref_2_c_639_p N_noxref_13_c_3230_n ) capacitor c=9.36995e-19 \
 //x=14.24 //y=0.71 //x2=14.13 //y2=0.955
cc_632 ( N_noxref_2_c_640_p N_noxref_13_c_3230_n ) capacitor c=6.38426e-19 \
 //x=14.24 //y=1.365 //x2=14.13 //y2=0.955
cc_633 ( N_noxref_2_c_436_p N_noxref_13_c_3230_n ) capacitor c=0.00171721f \
 //x=14.395 //y=0.865 //x2=14.13 //y2=0.955
cc_634 ( N_noxref_2_c_438_p N_noxref_13_c_3230_n ) capacitor c=0.00296337f \
 //x=14.395 //y=1.21 //x2=14.13 //y2=0.955
cc_635 ( N_noxref_2_c_434_p N_noxref_13_c_3241_n ) capacitor c=3.51399e-19 \
 //x=13.865 //y=0.865 //x2=14.127 //y2=0.825
cc_636 ( N_noxref_2_c_639_p N_noxref_13_c_3241_n ) capacitor c=0.00852028f \
 //x=14.24 //y=0.71 //x2=14.127 //y2=0.825
cc_637 ( N_noxref_2_c_436_p N_noxref_13_c_3241_n ) capacitor c=4.40641e-19 \
 //x=14.395 //y=0.865 //x2=14.127 //y2=0.825
cc_638 ( N_noxref_2_c_502_p N_noxref_13_c_3190_n ) capacitor c=6.86937e-19 \
 //x=12.125 //y=1.665 //x2=12.78 //y2=0
cc_639 ( N_noxref_2_c_465_p N_noxref_13_c_3190_n ) capacitor c=6.00616e-19 \
 //x=12.21 //y=2.765 //x2=12.78 //y2=0
cc_640 ( N_noxref_2_c_434_p N_noxref_13_c_3246_n ) capacitor c=0.00685132f \
 //x=13.865 //y=0.865 //x2=16.11 //y2=0
cc_641 ( N_noxref_2_c_501_p N_noxref_13_c_3247_n ) capacitor c=0.00285697f \
 //x=11.725 //y=1.58 //x2=12.95 //y2=0
cc_642 ( N_noxref_2_c_502_p N_noxref_13_c_3247_n ) capacitor c=0.022222f \
 //x=12.125 //y=1.665 //x2=12.95 //y2=0
cc_643 ( N_noxref_2_c_403_p N_noxref_13_c_3247_n ) capacitor c=2.00878e-19 \
 //x=12.21 //y=2.445 //x2=12.95 //y2=0
cc_644 ( N_noxref_2_c_465_p N_noxref_13_c_3247_n ) capacitor c=0.00401039f \
 //x=12.21 //y=2.765 //x2=12.95 //y2=0
cc_645 ( N_noxref_2_c_405_p N_noxref_13_c_3247_n ) capacitor c=0.00301679f \
 //x=14.06 //y=2.445 //x2=12.95 //y2=0
cc_646 ( N_noxref_2_c_406_p N_noxref_13_c_3247_n ) capacitor c=0.00293146f \
 //x=14.06 //y=2.765 //x2=12.95 //y2=0
cc_647 ( N_noxref_2_c_399_n N_noxref_13_c_3247_n ) capacitor c=0.0103966f \
 //x=12.21 //y=2.59 //x2=12.95 //y2=0
cc_648 ( N_noxref_2_c_407_p N_noxref_13_c_3247_n ) capacitor c=0.00512795f \
 //x=14.06 //y=2.59 //x2=12.95 //y2=0
cc_649 ( N_noxref_2_c_411_p N_noxref_13_c_3247_n ) capacitor c=0.00351582f \
 //x=14.06 //y=2.08 //x2=12.95 //y2=0
cc_650 ( N_noxref_2_c_455_p N_noxref_13_c_3247_n ) capacitor c=0.0102999f \
 //x=13.895 //y=2.605 //x2=12.95 //y2=0
cc_651 ( N_noxref_2_c_410_p N_noxref_13_c_3247_n ) capacitor c=0.00354425f \
 //x=14.06 //y=2.08 //x2=12.95 //y2=0
cc_652 ( N_noxref_2_c_437_p N_noxref_13_c_3247_n ) capacitor c=0.0015404f \
 //x=13.865 //y=1.52 //x2=12.95 //y2=0
cc_653 ( N_noxref_2_c_413_p N_noxref_13_c_3247_n ) capacitor c=0.0093907f \
 //x=13.865 //y=1.915 //x2=12.95 //y2=0
cc_654 ( N_noxref_2_c_407_p N_noxref_13_c_3260_n ) capacitor c=0.00159554f \
 //x=14.06 //y=2.59 //x2=16.28 //y2=0
cc_655 ( N_noxref_2_c_411_p N_noxref_13_M8_noxref_d ) capacitor c=2.20438e-19 \
 //x=14.06 //y=2.08 //x2=13.94 //y2=0.865
cc_656 ( N_noxref_2_c_434_p N_noxref_13_M8_noxref_d ) capacitor c=0.00192399f \
 //x=13.865 //y=0.865 //x2=13.94 //y2=0.865
cc_657 ( N_noxref_2_c_435_p N_noxref_13_M8_noxref_d ) capacitor c=0.00210798f \
 //x=13.865 //y=1.21 //x2=13.94 //y2=0.865
cc_658 ( N_noxref_2_c_639_p N_noxref_13_M8_noxref_d ) capacitor c=0.00472259f \
 //x=14.24 //y=0.71 //x2=13.94 //y2=0.865
cc_659 ( N_noxref_2_c_640_p N_noxref_13_M8_noxref_d ) capacitor c=0.00166857f \
 //x=14.24 //y=1.365 //x2=13.94 //y2=0.865
cc_660 ( N_noxref_2_c_436_p N_noxref_13_M8_noxref_d ) capacitor c=0.00230174f \
 //x=14.395 //y=0.865 //x2=13.94 //y2=0.865
cc_661 ( N_noxref_2_c_438_p N_noxref_13_M8_noxref_d ) capacitor c=0.00210798f \
 //x=14.395 //y=1.21 //x2=13.94 //y2=0.865
cc_662 ( N_noxref_2_c_413_p N_noxref_20_c_4087_n ) capacitor c=0.00262672f \
 //x=13.865 //y=1.915 //x2=13.645 //y2=1.495
cc_663 ( N_noxref_2_c_406_p N_noxref_20_c_4088_n ) capacitor c=0.00530082f \
 //x=14.06 //y=2.765 //x2=14.53 //y2=1.58
cc_664 ( N_noxref_2_c_411_p N_noxref_20_c_4088_n ) capacitor c=0.00509504f \
 //x=14.06 //y=2.08 //x2=14.53 //y2=1.58
cc_665 ( N_noxref_2_c_410_p N_noxref_20_c_4088_n ) capacitor c=0.00763108f \
 //x=14.06 //y=2.08 //x2=14.53 //y2=1.58
cc_666 ( N_noxref_2_c_437_p N_noxref_20_c_4088_n ) capacitor c=0.00697076f \
 //x=13.865 //y=1.52 //x2=14.53 //y2=1.58
cc_667 ( N_noxref_2_c_413_p N_noxref_20_c_4088_n ) capacitor c=0.0165799f \
 //x=13.865 //y=1.915 //x2=14.53 //y2=1.58
cc_668 ( N_noxref_2_c_640_p N_noxref_20_c_4088_n ) capacitor c=0.00723574f \
 //x=14.24 //y=1.365 //x2=14.53 //y2=1.58
cc_669 ( N_noxref_2_c_438_p N_noxref_20_c_4088_n ) capacitor c=0.00339872f \
 //x=14.395 //y=1.21 //x2=14.53 //y2=1.58
cc_670 ( N_noxref_2_c_413_p N_noxref_20_c_4095_n ) capacitor c=6.71402e-19 \
 //x=13.865 //y=1.915 //x2=14.615 //y2=1.495
cc_671 ( N_noxref_2_c_434_p N_noxref_20_M8_noxref_s ) capacitor c=0.0295366f \
 //x=13.865 //y=0.865 //x2=13.51 //y2=0.365
cc_672 ( N_noxref_2_c_437_p N_noxref_20_M8_noxref_s ) capacitor c=3.48408e-19 \
 //x=13.865 //y=1.52 //x2=13.51 //y2=0.365
cc_673 ( N_noxref_2_c_436_p N_noxref_20_M8_noxref_s ) capacitor c=0.0125442f \
 //x=14.395 //y=0.865 //x2=13.51 //y2=0.365
cc_674 ( N_noxref_3_c_695_n N_noxref_4_c_973_n ) capacitor c=0.023202f \
 //x=5.55 //y=4.575 //x2=5.62 //y2=5.155
cc_675 ( N_noxref_3_c_700_n N_noxref_4_c_973_n ) capacitor c=0.00118283f \
 //x=5.55 //y=4.44 //x2=5.62 //y2=5.155
cc_676 ( N_noxref_3_c_706_n N_noxref_4_c_973_n ) capacitor c=0.00492634f \
 //x=5.55 //y=4.7 //x2=5.62 //y2=5.155
cc_677 ( N_noxref_3_M21_noxref_g N_noxref_4_c_973_n ) capacitor c=0.00858236f \
 //x=5.52 //y=6.02 //x2=5.62 //y2=5.155
cc_678 ( N_noxref_3_c_724_n N_noxref_4_c_973_n ) capacitor c=3.67903e-19 \
 //x=5.55 //y=4.7 //x2=5.62 //y2=5.155
cc_679 ( N_noxref_3_M22_noxref_g N_noxref_4_c_1057_n ) capacitor c=0.00955829f \
 //x=5.96 //y=6.02 //x2=6.505 //y2=5.155
cc_680 ( N_noxref_3_c_780_p N_noxref_4_c_1047_n ) capacitor c=0.0194373f \
 //x=7.01 //y=4.44 //x2=7.315 //y2=5.155
cc_681 ( N_noxref_3_c_686_n N_noxref_4_c_978_n ) capacitor c=0.00321221f \
 //x=5.55 //y=4.415 //x2=7.4 //y2=3.91
cc_682 ( N_noxref_3_c_780_p N_noxref_4_c_984_n ) capacitor c=0.00124799f \
 //x=7.01 //y=4.44 //x2=7.4 //y2=4.23
cc_683 ( N_noxref_3_c_699_n N_noxref_4_c_984_n ) capacitor c=0.00726353f \
 //x=7.61 //y=4.455 //x2=7.4 //y2=4.23
cc_684 ( N_noxref_3_c_686_n N_noxref_4_c_985_n ) capacitor c=3.42225e-19 \
 //x=5.55 //y=4.415 //x2=7.4 //y2=5.07
cc_685 ( N_noxref_3_c_780_p N_noxref_4_c_985_n ) capacitor c=3.25767e-19 \
 //x=7.01 //y=4.44 //x2=7.4 //y2=5.07
cc_686 ( N_noxref_3_c_699_n N_noxref_4_c_985_n ) capacitor c=0.0293421f \
 //x=7.61 //y=4.455 //x2=7.4 //y2=5.07
cc_687 ( N_noxref_3_c_727_n N_noxref_4_c_1065_n ) capacitor c=0.00295973f \
 //x=14.8 //y=4.41 //x2=17.39 //y2=3.925
cc_688 ( N_noxref_3_c_695_n N_noxref_4_c_1066_n ) capacitor c=0.00519317f \
 //x=5.55 //y=4.575 //x2=5.74 //y2=5.155
cc_689 ( N_noxref_3_c_780_p N_noxref_4_c_1066_n ) capacitor c=0.0380295f \
 //x=7.01 //y=4.44 //x2=5.74 //y2=5.155
cc_690 ( N_noxref_3_c_700_n N_noxref_4_c_1066_n ) capacitor c=0.00118081f \
 //x=5.55 //y=4.44 //x2=5.74 //y2=5.155
cc_691 ( N_noxref_3_c_706_n N_noxref_4_c_1066_n ) capacitor c=0.00132214f \
 //x=5.55 //y=4.7 //x2=5.74 //y2=5.155
cc_692 ( N_noxref_3_M21_noxref_g N_noxref_4_c_1066_n ) capacitor c=0.00229818f \
 //x=5.52 //y=6.02 //x2=5.74 //y2=5.155
cc_693 ( N_noxref_3_M22_noxref_g N_noxref_4_c_1066_n ) capacitor c=0.00230699f \
 //x=5.96 //y=6.02 //x2=5.74 //y2=5.155
cc_694 ( N_noxref_3_c_794_p N_noxref_4_c_1066_n ) capacitor c=0.00172334f \
 //x=5.885 //y=4.79 //x2=5.74 //y2=5.155
cc_695 ( N_noxref_3_c_727_n N_noxref_4_c_1073_n ) capacitor c=4.34398e-19 \
 //x=14.8 //y=4.41 //x2=17.392 //y2=4.56
cc_696 ( N_noxref_3_c_686_n N_noxref_4_c_993_n ) capacitor c=0.0287619f \
 //x=5.55 //y=4.415 //x2=7.235 //y2=4.07
cc_697 ( N_noxref_3_c_695_n N_noxref_4_c_993_n ) capacitor c=0.00196208f \
 //x=5.55 //y=4.575 //x2=7.235 //y2=4.07
cc_698 ( N_noxref_3_c_780_p N_noxref_4_c_993_n ) capacitor c=0.0124008f \
 //x=7.01 //y=4.44 //x2=7.235 //y2=4.07
cc_699 ( N_noxref_3_c_700_n N_noxref_4_c_993_n ) capacitor c=0.155111f \
 //x=5.55 //y=4.44 //x2=7.235 //y2=4.07
cc_700 ( N_noxref_3_c_780_p N_noxref_4_c_1002_n ) capacitor c=0.0364871f \
 //x=7.01 //y=4.44 //x2=7.555 //y2=4.07
cc_701 ( N_noxref_3_c_727_n N_noxref_4_c_1006_n ) capacitor c=0.020623f \
 //x=14.8 //y=4.41 //x2=17.23 //y2=4.085
cc_702 ( N_noxref_3_c_738_n N_noxref_4_c_1006_n ) capacitor c=0.00235509f \
 //x=14.835 //y=4.57 //x2=17.23 //y2=4.085
cc_703 ( N_noxref_3_c_699_n N_noxref_4_c_1006_n ) capacitor c=0.676145f \
 //x=7.61 //y=4.455 //x2=17.23 //y2=4.085
cc_704 ( N_noxref_3_c_695_n N_noxref_4_c_1082_n ) capacitor c=0.00185675f \
 //x=5.55 //y=4.575 //x2=5.74 //y2=5.38
cc_705 ( N_noxref_3_M21_noxref_g N_noxref_4_c_1082_n ) capacitor c=0.0179041f \
 //x=5.52 //y=6.02 //x2=5.74 //y2=5.38
cc_706 ( N_noxref_3_M22_noxref_g N_noxref_4_c_1082_n ) capacitor c=0.0179041f \
 //x=5.96 //y=6.02 //x2=5.74 //y2=5.38
cc_707 ( N_noxref_3_c_794_p N_noxref_4_c_1082_n ) capacitor c=0.00294585f \
 //x=5.885 //y=4.79 //x2=5.74 //y2=5.38
cc_708 ( N_noxref_3_c_699_n N_noxref_5_c_1426_n ) capacitor c=0.0301257f \
 //x=7.61 //y=4.455 //x2=10.36 //y2=4.585
cc_709 ( N_noxref_3_c_727_n N_noxref_5_c_1467_n ) capacitor c=0.0166179f \
 //x=14.8 //y=4.41 //x2=21.66 //y2=2.21
cc_710 ( N_noxref_3_c_735_n N_noxref_5_c_1467_n ) capacitor c=0.0169481f \
 //x=14.8 //y=2.08 //x2=21.66 //y2=2.21
cc_711 ( N_noxref_3_c_682_n N_noxref_6_c_1734_n ) capacitor c=0.0116288f \
 //x=5.55 //y=2.195 //x2=6.66 //y2=2.195
cc_712 ( N_noxref_3_c_702_n N_noxref_6_c_1734_n ) capacitor c=5.39999e-19 \
 //x=5.55 //y=2.08 //x2=6.66 //y2=2.195
cc_713 ( N_noxref_3_c_721_n N_noxref_6_c_1734_n ) capacitor c=0.00141236f \
 //x=5.64 //y=1.915 //x2=6.66 //y2=2.195
cc_714 ( N_noxref_3_c_686_n N_noxref_6_c_1735_n ) capacitor c=0.038205f \
 //x=5.55 //y=4.415 //x2=6.66 //y2=3.525
cc_715 ( N_noxref_3_c_702_n N_noxref_6_c_1735_n ) capacitor c=4.16726e-19 \
 //x=5.55 //y=2.08 //x2=6.66 //y2=3.525
cc_716 ( N_noxref_3_c_686_n N_noxref_6_c_1740_n ) capacitor c=0.00776638f \
 //x=5.55 //y=4.415 //x2=6.66 //y2=3.845
cc_717 ( N_noxref_3_c_686_n N_noxref_6_c_1741_n ) capacitor c=0.0126059f \
 //x=5.55 //y=4.415 //x2=6.66 //y2=4.57
cc_718 ( N_noxref_3_c_695_n N_noxref_6_c_1741_n ) capacitor c=0.0109762f \
 //x=5.55 //y=4.575 //x2=6.66 //y2=4.57
cc_719 ( N_noxref_3_c_780_p N_noxref_6_c_1741_n ) capacitor c=0.0287277f \
 //x=7.01 //y=4.44 //x2=6.66 //y2=4.57
cc_720 ( N_noxref_3_c_700_n N_noxref_6_c_1741_n ) capacitor c=0.00462738f \
 //x=5.55 //y=4.44 //x2=6.66 //y2=4.57
cc_721 ( N_noxref_3_c_706_n N_noxref_6_c_1741_n ) capacitor c=4.56604e-19 \
 //x=5.55 //y=4.7 //x2=6.66 //y2=4.57
cc_722 ( N_noxref_3_c_699_n N_noxref_6_c_1745_n ) capacitor c=0.0287127f \
 //x=7.61 //y=4.455 //x2=11.47 //y2=4.57
cc_723 ( N_noxref_3_c_738_n N_noxref_6_c_1768_n ) capacitor c=0.0233476f \
 //x=14.835 //y=4.57 //x2=14.945 //y2=5.2
cc_724 ( N_noxref_3_c_699_n N_noxref_6_c_1768_n ) capacitor c=9.84751e-19 \
 //x=7.61 //y=4.455 //x2=14.945 //y2=5.2
cc_725 ( N_noxref_3_c_752_n N_noxref_6_c_1768_n ) capacitor c=0.00469232f \
 //x=14.83 //y=4.7 //x2=14.945 //y2=5.2
cc_726 ( N_noxref_3_M33_noxref_g N_noxref_6_c_1768_n ) capacitor c=0.00842852f \
 //x=14.84 //y=6.02 //x2=14.945 //y2=5.2
cc_727 ( N_noxref_3_c_771_n N_noxref_6_c_1768_n ) capacitor c=7.94507e-19 \
 //x=14.83 //y=4.7 //x2=14.945 //y2=5.2
cc_728 ( N_noxref_3_c_761_n N_noxref_6_c_1769_n ) capacitor c=0.00119302f \
 //x=14.835 //y=1.25 //x2=15.1 //y2=1.57
cc_729 ( N_noxref_3_c_763_n N_noxref_6_c_1769_n ) capacitor c=0.00439215f \
 //x=14.835 //y=1.56 //x2=15.1 //y2=1.57
cc_730 ( N_noxref_3_c_830_p N_noxref_6_c_1769_n ) capacitor c=0.00917366f \
 //x=15.21 //y=1.405 //x2=15.1 //y2=1.57
cc_731 ( N_noxref_3_c_767_n N_noxref_6_c_1769_n ) capacitor c=0.003249f \
 //x=15.365 //y=1.25 //x2=15.1 //y2=1.57
cc_732 ( N_noxref_3_c_832_p N_noxref_6_c_1769_n ) capacitor c=0.00341688f \
 //x=14.8 //y=1.915 //x2=15.1 //y2=1.57
cc_733 ( N_noxref_3_M34_noxref_g N_noxref_6_c_1856_n ) capacitor c=0.0109545f \
 //x=15.28 //y=6.02 //x2=15.455 //y2=5.2
cc_734 ( N_noxref_3_c_830_p N_noxref_6_c_1857_n ) capacitor c=0.00194324f \
 //x=15.21 //y=1.405 //x2=15.455 //y2=1.655
cc_735 ( N_noxref_3_c_767_n N_noxref_6_c_1857_n ) capacitor c=0.00323005f \
 //x=15.365 //y=1.25 //x2=15.455 //y2=1.655
cc_736 ( N_noxref_3_c_727_n N_noxref_6_c_1771_n ) capacitor c=0.0581058f \
 //x=14.8 //y=4.41 //x2=15.54 //y2=3.525
cc_737 ( N_noxref_3_c_735_n N_noxref_6_c_1771_n ) capacitor c=0.0138368f \
 //x=14.8 //y=2.08 //x2=15.54 //y2=3.525
cc_738 ( N_noxref_3_c_748_n N_noxref_6_c_1771_n ) capacitor c=9.26054e-19 \
 //x=14.8 //y=2.08 //x2=15.54 //y2=3.525
cc_739 ( N_noxref_3_c_768_n N_noxref_6_c_1771_n ) capacitor c=0.00268898f \
 //x=14.8 //y=2.08 //x2=15.54 //y2=3.525
cc_740 ( N_noxref_3_c_832_p N_noxref_6_c_1771_n ) capacitor c=0.00309058f \
 //x=14.8 //y=1.915 //x2=15.54 //y2=3.525
cc_741 ( N_noxref_3_c_727_n N_noxref_6_c_1864_n ) capacitor c=0.0176724f \
 //x=14.8 //y=4.41 //x2=15.54 //y2=3.845
cc_742 ( N_noxref_3_c_842_p N_noxref_6_c_1864_n ) capacitor c=0.00127572f \
 //x=15.205 //y=4.79 //x2=15.54 //y2=3.845
cc_743 ( N_noxref_3_c_727_n N_noxref_6_c_1774_n ) capacitor c=0.021778f \
 //x=14.8 //y=4.41 //x2=15.54 //y2=5.115
cc_744 ( N_noxref_3_c_738_n N_noxref_6_c_1774_n ) capacitor c=0.0218509f \
 //x=14.835 //y=4.57 //x2=15.54 //y2=5.115
cc_745 ( N_noxref_3_c_699_n N_noxref_6_c_1774_n ) capacitor c=0.00878819f \
 //x=7.61 //y=4.455 //x2=15.54 //y2=5.115
cc_746 ( N_noxref_3_c_752_n N_noxref_6_c_1774_n ) capacitor c=5.14671e-19 \
 //x=14.83 //y=4.7 //x2=15.54 //y2=5.115
cc_747 ( N_noxref_3_c_842_p N_noxref_6_c_1774_n ) capacitor c=0.00844995f \
 //x=15.205 //y=4.79 //x2=15.54 //y2=5.115
cc_748 ( N_noxref_3_c_686_n N_noxref_6_c_1871_n ) capacitor c=5.01652e-19 \
 //x=5.55 //y=4.415 //x2=6.66 //y2=3.7
cc_749 ( N_noxref_3_c_699_n N_noxref_6_c_1777_n ) capacitor c=0.0211459f \
 //x=7.61 //y=4.455 //x2=14.18 //y2=5.38
cc_750 ( N_noxref_3_c_738_n N_noxref_6_c_1873_n ) capacitor c=0.00285789f \
 //x=14.835 //y=4.57 //x2=15.06 //y2=5.2
cc_751 ( N_noxref_3_c_699_n N_noxref_6_c_1873_n ) capacitor c=0.00123315f \
 //x=7.61 //y=4.455 //x2=15.06 //y2=5.2
cc_752 ( N_noxref_3_M33_noxref_g N_noxref_6_c_1873_n ) capacitor c=0.00192712f \
 //x=14.84 //y=6.02 //x2=15.06 //y2=5.2
cc_753 ( N_noxref_3_M34_noxref_g N_noxref_6_c_1873_n ) capacitor c=0.00298276f \
 //x=15.28 //y=6.02 //x2=15.06 //y2=5.2
cc_754 ( N_noxref_3_c_842_p N_noxref_6_c_1873_n ) capacitor c=0.0020909f \
 //x=15.205 //y=4.79 //x2=15.06 //y2=5.2
cc_755 ( N_noxref_3_c_758_n N_noxref_6_c_1785_n ) capacitor c=0.00120406f \
 //x=14.835 //y=0.905 //x2=15.1 //y2=1
cc_756 ( N_noxref_3_c_761_n N_noxref_6_c_1785_n ) capacitor c=0.00218772f \
 //x=14.835 //y=1.25 //x2=15.1 //y2=1
cc_757 ( N_noxref_3_c_857_p N_noxref_6_c_1785_n ) capacitor c=5.50523e-19 \
 //x=15.21 //y=0.75 //x2=15.1 //y2=1
cc_758 ( N_noxref_3_c_830_p N_noxref_6_c_1785_n ) capacitor c=5.64626e-19 \
 //x=15.21 //y=1.405 //x2=15.1 //y2=1
cc_759 ( N_noxref_3_c_766_n N_noxref_6_c_1785_n ) capacitor c=0.00109205f \
 //x=15.365 //y=0.905 //x2=15.1 //y2=1
cc_760 ( N_noxref_3_c_767_n N_noxref_6_c_1785_n ) capacitor c=0.00317092f \
 //x=15.365 //y=1.25 //x2=15.1 //y2=1
cc_761 ( N_noxref_3_c_727_n N_noxref_6_c_1884_n ) capacitor c=9.19401e-19 \
 //x=14.8 //y=4.41 //x2=15.54 //y2=3.7
cc_762 ( N_noxref_3_c_780_p N_noxref_6_c_1746_n ) capacitor c=0.00355065f \
 //x=7.01 //y=4.44 //x2=7.01 //y2=3.7
cc_763 ( N_noxref_3_c_699_n N_noxref_6_c_1886_n ) capacitor c=0.00179696f \
 //x=7.61 //y=4.455 //x2=7.61 //y2=3.685
cc_764 ( N_noxref_3_c_699_n N_noxref_6_c_1747_n ) capacitor c=0.0213322f \
 //x=7.61 //y=4.455 //x2=11.63 //y2=3.7
cc_765 ( N_noxref_3_c_686_n N_noxref_6_c_1751_n ) capacitor c=0.00513046f \
 //x=5.55 //y=4.415 //x2=6.825 //y2=3.685
cc_766 ( N_noxref_3_c_727_n N_noxref_6_c_1787_n ) capacitor c=0.0247936f \
 //x=14.8 //y=4.41 //x2=15.375 //y2=3.685
cc_767 ( N_noxref_3_c_699_n N_noxref_6_c_1787_n ) capacitor c=0.0185064f \
 //x=7.61 //y=4.455 //x2=15.375 //y2=3.685
cc_768 ( N_noxref_3_c_727_n N_noxref_6_c_1891_n ) capacitor c=0.00338457f \
 //x=14.8 //y=4.41 //x2=15.695 //y2=3.685
cc_769 ( N_noxref_3_c_682_n N_noxref_6_c_1892_n ) capacitor c=5.42289e-19 \
 //x=5.55 //y=2.195 //x2=6.66 //y2=2.08
cc_770 ( N_noxref_3_c_686_n N_noxref_6_c_1892_n ) capacitor c=4.16726e-19 \
 //x=5.55 //y=4.415 //x2=6.66 //y2=2.08
cc_771 ( N_noxref_3_c_702_n N_noxref_6_c_1892_n ) capacitor c=0.00125213f \
 //x=5.55 //y=2.08 //x2=6.66 //y2=2.08
cc_772 ( N_noxref_3_c_721_n N_noxref_6_c_1892_n ) capacitor c=0.00209664f \
 //x=5.64 //y=1.915 //x2=6.66 //y2=2.08
cc_773 ( N_noxref_3_c_695_n N_noxref_6_c_1896_n ) capacitor c=9.62855e-19 \
 //x=5.55 //y=4.575 //x2=6.66 //y2=4.7
cc_774 ( N_noxref_3_c_706_n N_noxref_6_c_1896_n ) capacitor c=0.00113668f \
 //x=5.55 //y=4.7 //x2=6.66 //y2=4.7
cc_775 ( N_noxref_3_c_724_n N_noxref_6_c_1896_n ) capacitor c=9.77556e-19 \
 //x=5.55 //y=4.7 //x2=6.66 //y2=4.7
cc_776 ( N_noxref_3_c_738_n N_noxref_6_c_1899_n ) capacitor c=7.41644e-19 \
 //x=14.835 //y=4.57 //x2=15.06 //y2=5.38
cc_777 ( N_noxref_3_M33_noxref_g N_noxref_6_c_1899_n ) capacitor c=0.0178987f \
 //x=14.84 //y=6.02 //x2=15.06 //y2=5.38
cc_778 ( N_noxref_3_M34_noxref_g N_noxref_6_c_1899_n ) capacitor c=0.0178506f \
 //x=15.28 //y=6.02 //x2=15.06 //y2=5.38
cc_779 ( N_noxref_3_c_842_p N_noxref_6_c_1899_n ) capacitor c=0.00291714f \
 //x=15.205 //y=4.79 //x2=15.06 //y2=5.38
cc_780 ( N_noxref_3_M21_noxref_g N_noxref_6_M23_noxref_g ) capacitor \
 c=0.0101598f //x=5.52 //y=6.02 //x2=6.4 //y2=6.02
cc_781 ( N_noxref_3_M22_noxref_g N_noxref_6_M23_noxref_g ) capacitor \
 c=0.0607518f //x=5.96 //y=6.02 //x2=6.4 //y2=6.02
cc_782 ( N_noxref_3_M22_noxref_g N_noxref_6_M24_noxref_g ) capacitor \
 c=0.0101598f //x=5.96 //y=6.02 //x2=6.84 //y2=6.02
cc_783 ( N_noxref_3_c_718_n N_noxref_6_c_1906_n ) capacitor c=0.00456962f \
 //x=5.64 //y=0.91 //x2=6.65 //y2=0.915
cc_784 ( N_noxref_3_c_719_n N_noxref_6_c_1907_n ) capacitor c=0.00438372f \
 //x=5.64 //y=1.22 //x2=6.65 //y2=1.26
cc_785 ( N_noxref_3_c_720_n N_noxref_6_c_1908_n ) capacitor c=0.00438372f \
 //x=5.64 //y=1.45 //x2=6.65 //y2=1.57
cc_786 ( N_noxref_3_c_682_n N_noxref_6_c_1909_n ) capacitor c=0.00139071f \
 //x=5.55 //y=2.195 //x2=6.66 //y2=2.08
cc_787 ( N_noxref_3_c_702_n N_noxref_6_c_1909_n ) capacitor c=0.00204868f \
 //x=5.55 //y=2.08 //x2=6.66 //y2=2.08
cc_788 ( N_noxref_3_c_721_n N_noxref_6_c_1909_n ) capacitor c=0.00933826f \
 //x=5.64 //y=1.915 //x2=6.66 //y2=2.08
cc_789 ( N_noxref_3_c_721_n N_noxref_6_c_1912_n ) capacitor c=0.00438372f \
 //x=5.64 //y=1.915 //x2=6.66 //y2=1.915
cc_790 ( N_noxref_3_c_695_n N_noxref_6_c_1913_n ) capacitor c=0.00135081f \
 //x=5.55 //y=4.575 //x2=6.66 //y2=4.7
cc_791 ( N_noxref_3_c_706_n N_noxref_6_c_1913_n ) capacitor c=0.00186974f \
 //x=5.55 //y=4.7 //x2=6.66 //y2=4.7
cc_792 ( N_noxref_3_c_794_p N_noxref_6_c_1913_n ) capacitor c=0.0616777f \
 //x=5.885 //y=4.79 //x2=6.66 //y2=4.7
cc_793 ( N_noxref_3_c_724_n N_noxref_6_c_1913_n ) capacitor c=0.0042693f \
 //x=5.55 //y=4.7 //x2=6.66 //y2=4.7
cc_794 ( N_noxref_3_c_758_n N_noxref_6_M9_noxref_d ) capacitor c=0.00137165f \
 //x=14.835 //y=0.905 //x2=14.91 //y2=0.905
cc_795 ( N_noxref_3_c_761_n N_noxref_6_M9_noxref_d ) capacitor c=0.00237422f \
 //x=14.835 //y=1.25 //x2=14.91 //y2=0.905
cc_796 ( N_noxref_3_c_857_p N_noxref_6_M9_noxref_d ) capacitor c=0.0020782f \
 //x=15.21 //y=0.75 //x2=14.91 //y2=0.905
cc_797 ( N_noxref_3_c_830_p N_noxref_6_M9_noxref_d ) capacitor c=0.00356097f \
 //x=15.21 //y=1.405 //x2=14.91 //y2=0.905
cc_798 ( N_noxref_3_c_766_n N_noxref_6_M9_noxref_d ) capacitor c=8.50095e-19 \
 //x=15.365 //y=0.905 //x2=14.91 //y2=0.905
cc_799 ( N_noxref_3_c_767_n N_noxref_6_M9_noxref_d ) capacitor c=0.00237422f \
 //x=15.365 //y=1.25 //x2=14.91 //y2=0.905
cc_800 ( N_noxref_3_M21_noxref_g N_noxref_7_c_2405_n ) capacitor c=0.00700336f \
 //x=5.52 //y=6.02 //x2=6.095 //y2=7.4
cc_801 ( N_noxref_3_M22_noxref_g N_noxref_7_c_2405_n ) capacitor c=0.00749619f \
 //x=5.96 //y=6.02 //x2=6.095 //y2=7.4
cc_802 ( N_noxref_3_M33_noxref_g N_noxref_7_c_2407_n ) capacitor c=0.00692597f \
 //x=14.84 //y=6.02 //x2=15.415 //y2=7.4
cc_803 ( N_noxref_3_M34_noxref_g N_noxref_7_c_2407_n ) capacitor c=0.00749619f \
 //x=15.28 //y=6.02 //x2=15.415 //y2=7.4
cc_804 ( N_noxref_3_c_699_n N_noxref_7_c_2324_n ) capacitor c=0.0264761f \
 //x=7.61 //y=4.455 //x2=8.14 //y2=7.4
cc_805 ( N_noxref_3_c_699_n N_noxref_7_c_2382_n ) capacitor c=0.0263497f \
 //x=7.61 //y=4.455 //x2=12.95 //y2=7.4
cc_806 ( N_noxref_3_c_752_n N_noxref_7_c_2411_n ) capacitor c=0.00228191f \
 //x=14.83 //y=4.7 //x2=16.28 //y2=7.4
cc_807 ( N_noxref_3_c_842_p N_noxref_7_c_2411_n ) capacitor c=0.0129149f \
 //x=15.205 //y=4.79 //x2=16.28 //y2=7.4
cc_808 ( N_noxref_3_c_771_n N_noxref_7_c_2411_n ) capacitor c=2.73429e-19 \
 //x=14.83 //y=4.7 //x2=16.28 //y2=7.4
cc_809 ( N_noxref_3_M21_noxref_g N_noxref_7_M20_noxref_d ) capacitor \
 c=0.015318f //x=5.52 //y=6.02 //x2=5.155 //y2=5.02
cc_810 ( N_noxref_3_M22_noxref_g N_noxref_7_M22_noxref_d ) capacitor \
 c=0.015318f //x=5.96 //y=6.02 //x2=6.035 //y2=5.02
cc_811 ( N_noxref_3_c_699_n N_noxref_7_M25_noxref_s ) capacitor c=8.5753e-19 \
 //x=7.61 //y=4.455 //x2=9.095 //y2=5.02
cc_812 ( N_noxref_3_c_699_n N_noxref_7_M31_noxref_s ) capacitor c=0.00781443f \
 //x=7.61 //y=4.455 //x2=13.605 //y2=5.02
cc_813 ( N_noxref_3_M33_noxref_g N_noxref_7_M32_noxref_d ) capacitor \
 c=0.015318f //x=14.84 //y=6.02 //x2=14.475 //y2=5.02
cc_814 ( N_noxref_3_c_771_n N_noxref_7_M32_noxref_d ) capacitor c=3.50187e-19 \
 //x=14.83 //y=4.7 //x2=14.475 //y2=5.02
cc_815 ( N_noxref_3_M34_noxref_g N_noxref_7_M34_noxref_d ) capacitor \
 c=0.0430452f //x=15.28 //y=6.02 //x2=15.355 //y2=5.02
cc_816 ( N_noxref_3_c_718_n N_noxref_9_c_2776_n ) capacitor c=0.00123426f \
 //x=5.64 //y=0.91 //x2=6.345 //y2=0.995
cc_817 ( N_noxref_3_c_719_n N_noxref_9_c_2776_n ) capacitor c=0.0129288f \
 //x=5.64 //y=1.22 //x2=6.345 //y2=0.995
cc_818 ( N_noxref_3_c_720_n N_noxref_9_c_2776_n ) capacitor c=0.00132209f \
 //x=5.64 //y=1.45 //x2=6.345 //y2=0.995
cc_819 ( N_noxref_3_c_682_n N_noxref_9_M3_noxref_d ) capacitor c=0.00604066f \
 //x=5.55 //y=2.195 //x2=5.19 //y2=0.91
cc_820 ( N_noxref_3_c_702_n N_noxref_9_M3_noxref_d ) capacitor c=2.2052e-19 \
 //x=5.55 //y=2.08 //x2=5.19 //y2=0.91
cc_821 ( N_noxref_3_c_713_n N_noxref_9_M3_noxref_d ) capacitor c=0.00253592f \
 //x=5.115 //y=0.91 //x2=5.19 //y2=0.91
cc_822 ( N_noxref_3_c_716_n N_noxref_9_M3_noxref_d ) capacitor c=0.00604066f \
 //x=5.115 //y=1.22 //x2=5.19 //y2=0.91
cc_823 ( N_noxref_3_c_923_p N_noxref_9_M3_noxref_d ) capacitor c=0.002686f \
 //x=5.485 //y=0.755 //x2=5.19 //y2=0.91
cc_824 ( N_noxref_3_c_924_p N_noxref_9_M3_noxref_d ) capacitor c=0.00251995f \
 //x=5.485 //y=1.375 //x2=5.19 //y2=0.91
cc_825 ( N_noxref_3_c_718_n N_noxref_9_M3_noxref_d ) capacitor c=0.00314523f \
 //x=5.64 //y=0.91 //x2=5.19 //y2=0.91
cc_826 ( N_noxref_3_c_719_n N_noxref_9_M3_noxref_d ) capacitor c=0.00168289f \
 //x=5.64 //y=1.22 //x2=5.19 //y2=0.91
cc_827 ( N_noxref_3_c_720_n N_noxref_9_M3_noxref_d ) capacitor c=0.00111165f \
 //x=5.64 //y=1.45 //x2=5.19 //y2=0.91
cc_828 ( N_noxref_3_c_718_n N_noxref_9_M4_noxref_s ) capacitor c=7.21316e-19 \
 //x=5.64 //y=0.91 //x2=6.295 //y2=0.375
cc_829 ( N_noxref_3_c_719_n N_noxref_9_M4_noxref_s ) capacitor c=0.00365271f \
 //x=5.64 //y=1.22 //x2=6.295 //y2=0.375
cc_830 ( N_noxref_3_c_721_n N_noxref_9_M4_noxref_s ) capacitor c=9.86711e-19 \
 //x=5.64 //y=1.915 //x2=6.295 //y2=0.375
cc_831 ( N_noxref_3_c_682_n N_noxref_13_c_3268_n ) capacitor c=9.14667e-19 \
 //x=5.55 //y=2.195 //x2=9.13 //y2=0
cc_832 ( N_noxref_3_c_735_n N_noxref_13_c_3269_n ) capacitor c=0.00210539f \
 //x=14.8 //y=2.08 //x2=17.375 //y2=0
cc_833 ( N_noxref_3_c_735_n N_noxref_13_c_3246_n ) capacitor c=3.77673e-19 \
 //x=14.8 //y=2.08 //x2=16.11 //y2=0
cc_834 ( N_noxref_3_c_748_n N_noxref_13_c_3260_n ) capacitor c=0.00207214f \
 //x=14.8 //y=2.08 //x2=16.28 //y2=0
cc_835 ( N_noxref_3_c_767_n N_noxref_13_c_3260_n ) capacitor c=0.00275184f \
 //x=15.365 //y=1.25 //x2=16.28 //y2=0
cc_836 ( N_noxref_3_c_768_n N_noxref_13_c_3260_n ) capacitor c=2.63786e-19 \
 //x=14.8 //y=2.08 //x2=16.28 //y2=0
cc_837 ( N_noxref_3_c_713_n N_noxref_18_c_3984_n ) capacitor c=0.0167228f \
 //x=5.115 //y=0.91 //x2=5.775 //y2=0.54
cc_838 ( N_noxref_3_c_718_n N_noxref_18_c_3984_n ) capacitor c=0.00534519f \
 //x=5.64 //y=0.91 //x2=5.775 //y2=0.54
cc_839 ( N_noxref_3_c_682_n N_noxref_18_c_3978_n ) capacitor c=0.0048147f \
 //x=5.55 //y=2.195 //x2=5.775 //y2=1.59
cc_840 ( N_noxref_3_c_695_n N_noxref_18_c_3978_n ) capacitor c=9.66785e-19 \
 //x=5.55 //y=4.575 //x2=5.775 //y2=1.59
cc_841 ( N_noxref_3_c_702_n N_noxref_18_c_3978_n ) capacitor c=0.0105652f \
 //x=5.55 //y=2.08 //x2=5.775 //y2=1.59
cc_842 ( N_noxref_3_c_716_n N_noxref_18_c_3978_n ) capacitor c=0.0153476f \
 //x=5.115 //y=1.22 //x2=5.775 //y2=1.59
cc_843 ( N_noxref_3_c_721_n N_noxref_18_c_3978_n ) capacitor c=0.0200931f \
 //x=5.64 //y=1.915 //x2=5.775 //y2=1.59
cc_844 ( N_noxref_3_c_713_n N_noxref_18_M2_noxref_s ) capacitor c=0.00798959f \
 //x=5.115 //y=0.91 //x2=3.785 //y2=0.375
cc_845 ( N_noxref_3_c_720_n N_noxref_18_M2_noxref_s ) capacitor c=0.00212176f \
 //x=5.64 //y=1.45 //x2=3.785 //y2=0.375
cc_846 ( N_noxref_3_c_721_n N_noxref_18_M2_noxref_s ) capacitor c=0.00298115f \
 //x=5.64 //y=1.915 //x2=3.785 //y2=0.375
cc_847 ( N_noxref_3_c_735_n N_noxref_20_c_4095_n ) capacitor c=7.50092e-19 \
 //x=14.8 //y=2.08 //x2=14.615 //y2=1.495
cc_848 ( N_noxref_3_c_763_n N_noxref_20_c_4095_n ) capacitor c=0.00888238f \
 //x=14.835 //y=1.56 //x2=14.615 //y2=1.495
cc_849 ( N_noxref_3_c_768_n N_noxref_20_c_4095_n ) capacitor c=0.00175171f \
 //x=14.8 //y=2.08 //x2=14.615 //y2=1.495
cc_850 ( N_noxref_3_c_735_n N_noxref_20_c_4102_n ) capacitor c=0.001463f \
 //x=14.8 //y=2.08 //x2=15.5 //y2=0.53
cc_851 ( N_noxref_3_c_748_n N_noxref_20_c_4102_n ) capacitor c=8.82141e-19 \
 //x=14.8 //y=2.08 //x2=15.5 //y2=0.53
cc_852 ( N_noxref_3_c_758_n N_noxref_20_c_4102_n ) capacitor c=0.0200738f \
 //x=14.835 //y=0.905 //x2=15.5 //y2=0.53
cc_853 ( N_noxref_3_c_766_n N_noxref_20_c_4102_n ) capacitor c=0.00825432f \
 //x=15.365 //y=0.905 //x2=15.5 //y2=0.53
cc_854 ( N_noxref_3_c_768_n N_noxref_20_c_4102_n ) capacitor c=2.1838e-19 \
 //x=14.8 //y=2.08 //x2=15.5 //y2=0.53
cc_855 ( N_noxref_3_c_758_n N_noxref_20_M8_noxref_s ) capacitor c=0.00888238f \
 //x=14.835 //y=0.905 //x2=13.51 //y2=0.365
cc_856 ( N_noxref_3_c_766_n N_noxref_20_M8_noxref_s ) capacitor c=0.015333f \
 //x=15.365 //y=0.905 //x2=13.51 //y2=0.365
cc_857 ( N_noxref_3_c_767_n N_noxref_20_M8_noxref_s ) capacitor c=0.00248746f \
 //x=15.365 //y=1.25 //x2=13.51 //y2=0.365
cc_858 ( N_noxref_4_c_978_n N_noxref_5_c_1426_n ) capacitor c=0.00144926f \
 //x=7.4 //y=3.91 //x2=10.36 //y2=4.585
cc_859 ( N_noxref_4_c_985_n N_noxref_5_c_1426_n ) capacitor c=3.83887e-19 \
 //x=7.4 //y=5.07 //x2=10.36 //y2=4.585
cc_860 ( N_noxref_4_c_1006_n N_noxref_5_c_1426_n ) capacitor c=0.023508f \
 //x=17.23 //y=4.085 //x2=10.36 //y2=4.585
cc_861 ( N_noxref_4_c_1065_n N_noxref_5_c_1467_n ) capacitor c=0.0179022f \
 //x=17.39 //y=3.925 //x2=21.66 //y2=2.21
cc_862 ( N_noxref_4_c_1090_p N_noxref_5_c_1467_n ) capacitor c=0.0183918f \
 //x=17.39 //y=2.08 //x2=21.66 //y2=2.21
cc_863 ( N_noxref_4_c_1006_n N_noxref_5_c_1467_n ) capacitor c=0.0132793f \
 //x=17.23 //y=4.085 //x2=21.66 //y2=2.21
cc_864 ( N_noxref_4_c_1092_p N_noxref_5_c_1467_n ) capacitor c=2.20453e-19 \
 //x=17.39 //y=2.08 //x2=21.66 //y2=2.21
cc_865 ( N_noxref_4_c_978_n N_noxref_6_c_1734_n ) capacitor c=0.0154269f \
 //x=7.4 //y=3.91 //x2=6.66 //y2=2.195
cc_866 ( N_noxref_4_c_978_n N_noxref_6_c_1735_n ) capacitor c=0.0587286f \
 //x=7.4 //y=3.91 //x2=6.66 //y2=3.525
cc_867 ( N_noxref_4_c_1047_n N_noxref_6_c_1740_n ) capacitor c=0.00116878f \
 //x=7.315 //y=5.155 //x2=6.66 //y2=3.845
cc_868 ( N_noxref_4_c_974_n N_noxref_6_c_1740_n ) capacitor c=2.04829e-19 \
 //x=6.915 //y=1.125 //x2=6.66 //y2=3.845
cc_869 ( N_noxref_4_c_976_n N_noxref_6_c_1740_n ) capacitor c=8.43174e-19 \
 //x=7 //y=1.665 //x2=6.66 //y2=3.845
cc_870 ( N_noxref_4_c_978_n N_noxref_6_c_1740_n ) capacitor c=0.0176025f \
 //x=7.4 //y=3.91 //x2=6.66 //y2=3.845
cc_871 ( N_noxref_4_c_1099_p N_noxref_6_c_1740_n ) capacitor c=7.66594e-19 \
 //x=6.62 //y=5.155 //x2=6.66 //y2=3.845
cc_872 ( N_noxref_4_c_993_n N_noxref_6_c_1740_n ) capacitor c=0.00522697f \
 //x=7.235 //y=4.07 //x2=6.66 //y2=3.845
cc_873 ( N_noxref_4_c_1047_n N_noxref_6_c_1741_n ) capacitor c=0.00228791f \
 //x=7.315 //y=5.155 //x2=6.66 //y2=4.57
cc_874 ( N_noxref_4_c_978_n N_noxref_6_c_1741_n ) capacitor c=0.00283381f \
 //x=7.4 //y=3.91 //x2=6.66 //y2=4.57
cc_875 ( N_noxref_4_c_984_n N_noxref_6_c_1741_n ) capacitor c=0.0147947f \
 //x=7.4 //y=4.23 //x2=6.66 //y2=4.57
cc_876 ( N_noxref_4_c_985_n N_noxref_6_c_1741_n ) capacitor c=0.0275491f \
 //x=7.4 //y=5.07 //x2=6.66 //y2=4.57
cc_877 ( N_noxref_4_c_1099_p N_noxref_6_c_1741_n ) capacitor c=0.0221235f \
 //x=6.62 //y=5.155 //x2=6.66 //y2=4.57
cc_878 ( N_noxref_4_c_1106_p N_noxref_6_c_1741_n ) capacitor c=6.4807e-19 \
 //x=7.395 //y=4.07 //x2=6.66 //y2=4.57
cc_879 ( N_noxref_4_c_993_n N_noxref_6_c_1741_n ) capacitor c=0.0210332f \
 //x=7.235 //y=4.07 //x2=6.66 //y2=4.57
cc_880 ( N_noxref_4_c_1002_n N_noxref_6_c_1741_n ) capacitor c=0.00328982f \
 //x=7.555 //y=4.07 //x2=6.66 //y2=4.57
cc_881 ( N_noxref_4_c_1109_p N_noxref_6_c_1741_n ) capacitor c=0.00217653f \
 //x=6.62 //y=5.38 //x2=6.66 //y2=4.57
cc_882 ( N_noxref_4_c_1006_n N_noxref_6_c_1760_n ) capacitor c=0.00531452f \
 //x=17.23 //y=4.085 //x2=11.47 //y2=3.845
cc_883 ( N_noxref_4_c_1006_n N_noxref_6_c_1745_n ) capacitor c=0.0214777f \
 //x=17.23 //y=4.085 //x2=11.47 //y2=4.57
cc_884 ( N_noxref_4_c_1065_n N_noxref_6_c_1771_n ) capacitor c=0.0231307f \
 //x=17.39 //y=3.925 //x2=15.54 //y2=3.525
cc_885 ( N_noxref_4_c_1090_p N_noxref_6_c_1771_n ) capacitor c=0.00344372f \
 //x=17.39 //y=2.08 //x2=15.54 //y2=3.525
cc_886 ( N_noxref_4_c_1065_n N_noxref_6_c_1864_n ) capacitor c=0.00238733f \
 //x=17.39 //y=3.925 //x2=15.54 //y2=3.845
cc_887 ( N_noxref_4_c_1006_n N_noxref_6_c_1864_n ) capacitor c=0.00689641f \
 //x=17.23 //y=4.085 //x2=15.54 //y2=3.845
cc_888 ( N_noxref_4_c_1065_n N_noxref_6_c_1774_n ) capacitor c=0.00129137f \
 //x=17.39 //y=3.925 //x2=15.54 //y2=5.115
cc_889 ( N_noxref_4_c_1117_p N_noxref_6_c_1774_n ) capacitor c=0.00249513f \
 //x=17.39 //y=4.245 //x2=15.54 //y2=5.115
cc_890 ( N_noxref_4_c_1118_p N_noxref_6_c_1774_n ) capacitor c=0.00476843f \
 //x=17.39 //y=4.7 //x2=15.54 //y2=5.115
cc_891 ( N_noxref_4_c_1073_n N_noxref_6_c_1774_n ) capacitor c=0.00494097f \
 //x=17.392 //y=4.56 //x2=15.54 //y2=5.115
cc_892 ( N_noxref_4_c_1120_p N_noxref_6_c_1774_n ) capacitor c=0.0015808f \
 //x=17.39 //y=4.085 //x2=15.54 //y2=5.115
cc_893 ( N_noxref_4_c_1006_n N_noxref_6_c_1774_n ) capacitor c=0.028335f \
 //x=17.23 //y=4.085 //x2=15.54 //y2=5.115
cc_894 ( N_noxref_4_c_978_n N_noxref_6_c_1871_n ) capacitor c=9.19401e-19 \
 //x=7.4 //y=3.91 //x2=6.66 //y2=3.7
cc_895 ( N_noxref_4_c_1006_n N_noxref_6_c_1873_n ) capacitor c=0.012715f \
 //x=17.23 //y=4.085 //x2=15.06 //y2=5.2
cc_896 ( N_noxref_4_c_978_n N_noxref_6_c_1746_n ) capacitor c=2.73038e-19 \
 //x=7.4 //y=3.91 //x2=7.01 //y2=3.7
cc_897 ( N_noxref_4_c_993_n N_noxref_6_c_1746_n ) capacitor c=0.0345781f \
 //x=7.235 //y=4.07 //x2=7.01 //y2=3.7
cc_898 ( N_noxref_4_c_978_n N_noxref_6_c_1886_n ) capacitor c=0.0253905f \
 //x=7.4 //y=3.91 //x2=7.61 //y2=3.685
cc_899 ( N_noxref_4_c_984_n N_noxref_6_c_1886_n ) capacitor c=0.00912961f \
 //x=7.4 //y=4.23 //x2=7.61 //y2=3.685
cc_900 ( N_noxref_4_c_1002_n N_noxref_6_c_1886_n ) capacitor c=0.0358834f \
 //x=7.555 //y=4.07 //x2=7.61 //y2=3.685
cc_901 ( N_noxref_4_c_1006_n N_noxref_6_c_1886_n ) capacitor c=0.0109116f \
 //x=17.23 //y=4.085 //x2=7.61 //y2=3.685
cc_902 ( N_noxref_4_c_978_n N_noxref_6_c_1747_n ) capacitor c=4.72093e-19 \
 //x=7.4 //y=3.91 //x2=11.63 //y2=3.7
cc_903 ( N_noxref_4_c_1006_n N_noxref_6_c_1747_n ) capacitor c=0.355192f \
 //x=17.23 //y=4.085 //x2=11.63 //y2=3.7
cc_904 ( N_noxref_4_c_978_n N_noxref_6_c_1751_n ) capacitor c=0.00317812f \
 //x=7.4 //y=3.91 //x2=6.825 //y2=3.685
cc_905 ( N_noxref_4_c_993_n N_noxref_6_c_1751_n ) capacitor c=0.0358686f \
 //x=7.235 //y=4.07 //x2=6.825 //y2=3.685
cc_906 ( N_noxref_4_c_1006_n N_noxref_6_c_1787_n ) capacitor c=0.326716f \
 //x=17.23 //y=4.085 //x2=15.375 //y2=3.685
cc_907 ( N_noxref_4_c_1065_n N_noxref_6_c_1891_n ) capacitor c=0.00159442f \
 //x=17.39 //y=3.925 //x2=15.695 //y2=3.685
cc_908 ( N_noxref_4_c_1006_n N_noxref_6_c_1891_n ) capacitor c=0.0365231f \
 //x=17.23 //y=4.085 //x2=15.695 //y2=3.685
cc_909 ( N_noxref_4_c_1065_n N_noxref_6_c_1967_n ) capacitor c=0.027903f \
 //x=17.39 //y=3.925 //x2=22.78 //y2=3.705
cc_910 ( N_noxref_4_c_1117_p N_noxref_6_c_1967_n ) capacitor c=0.00890815f \
 //x=17.39 //y=4.245 //x2=22.78 //y2=3.705
cc_911 ( N_noxref_4_c_1120_p N_noxref_6_c_1967_n ) capacitor c=0.0368432f \
 //x=17.39 //y=4.085 //x2=22.78 //y2=3.705
cc_912 ( N_noxref_4_c_1006_n N_noxref_6_c_1967_n ) capacitor c=0.142205f \
 //x=17.23 //y=4.085 //x2=22.78 //y2=3.705
cc_913 ( N_noxref_4_c_978_n N_noxref_6_c_1892_n ) capacitor c=0.00163444f \
 //x=7.4 //y=3.91 //x2=6.66 //y2=2.08
cc_914 ( N_noxref_4_c_1047_n N_noxref_6_c_1896_n ) capacitor c=0.00130631f \
 //x=7.315 //y=5.155 //x2=6.66 //y2=4.7
cc_915 ( N_noxref_4_c_985_n N_noxref_6_c_1896_n ) capacitor c=0.0013045f \
 //x=7.4 //y=5.07 //x2=6.66 //y2=4.7
cc_916 ( N_noxref_4_c_1099_p N_noxref_6_c_1896_n ) capacitor c=0.00346456f \
 //x=6.62 //y=5.155 //x2=6.66 //y2=4.7
cc_917 ( N_noxref_4_c_1109_p N_noxref_6_c_1896_n ) capacitor c=0.00624059f \
 //x=6.62 //y=5.38 //x2=6.66 //y2=4.7
cc_918 ( N_noxref_4_c_1057_n N_noxref_6_M23_noxref_g ) capacitor c=0.00955829f \
 //x=6.505 //y=5.155 //x2=6.4 //y2=6.02
cc_919 ( N_noxref_4_c_1046_n N_noxref_6_M23_noxref_g ) capacitor c=0.00226521f \
 //x=6.62 //y=5.38 //x2=6.4 //y2=6.02
cc_920 ( N_noxref_4_c_1109_p N_noxref_6_M23_noxref_g ) capacitor c=0.0178885f \
 //x=6.62 //y=5.38 //x2=6.4 //y2=6.02
cc_921 ( N_noxref_4_c_1046_n N_noxref_6_M24_noxref_g ) capacitor c=0.00381703f \
 //x=6.62 //y=5.38 //x2=6.84 //y2=6.02
cc_922 ( N_noxref_4_c_1047_n N_noxref_6_M24_noxref_g ) capacitor c=0.0109667f \
 //x=7.315 //y=5.155 //x2=6.84 //y2=6.02
cc_923 ( N_noxref_4_c_1109_p N_noxref_6_M24_noxref_g ) capacitor c=0.0188608f \
 //x=6.62 //y=5.38 //x2=6.84 //y2=6.02
cc_924 ( N_noxref_4_c_974_n N_noxref_6_c_1906_n ) capacitor c=4.64015e-19 \
 //x=6.915 //y=1.125 //x2=6.65 //y2=0.915
cc_925 ( N_noxref_4_M4_noxref_d N_noxref_6_c_1906_n ) capacitor c=0.00137165f \
 //x=6.725 //y=0.915 //x2=6.65 //y2=0.915
cc_926 ( N_noxref_4_c_974_n N_noxref_6_c_1907_n ) capacitor c=0.0026012f \
 //x=6.915 //y=1.125 //x2=6.65 //y2=1.26
cc_927 ( N_noxref_4_c_975_n N_noxref_6_c_1907_n ) capacitor c=0.00127432f \
 //x=6.915 //y=1.58 //x2=6.65 //y2=1.26
cc_928 ( N_noxref_4_M4_noxref_d N_noxref_6_c_1907_n ) capacitor c=0.00237422f \
 //x=6.725 //y=0.915 //x2=6.65 //y2=1.26
cc_929 ( N_noxref_4_c_975_n N_noxref_6_c_1908_n ) capacitor c=0.00429966f \
 //x=6.915 //y=1.58 //x2=6.65 //y2=1.57
cc_930 ( N_noxref_4_c_974_n N_noxref_6_c_1988_n ) capacitor c=5.29969e-19 \
 //x=6.915 //y=1.125 //x2=7.025 //y2=0.76
cc_931 ( N_noxref_4_M4_noxref_d N_noxref_6_c_1988_n ) capacitor c=0.0020782f \
 //x=6.725 //y=0.915 //x2=7.025 //y2=0.76
cc_932 ( N_noxref_4_c_974_n N_noxref_6_c_1990_n ) capacitor c=5.16926e-19 \
 //x=6.915 //y=1.125 //x2=7.025 //y2=1.415
cc_933 ( N_noxref_4_c_975_n N_noxref_6_c_1990_n ) capacitor c=0.00942306f \
 //x=6.915 //y=1.58 //x2=7.025 //y2=1.415
cc_934 ( N_noxref_4_c_1048_n N_noxref_6_c_1990_n ) capacitor c=0.00194716f \
 //x=7.315 //y=1.665 //x2=7.025 //y2=1.415
cc_935 ( N_noxref_4_M4_noxref_d N_noxref_6_c_1990_n ) capacitor c=0.00356097f \
 //x=6.725 //y=0.915 //x2=7.025 //y2=1.415
cc_936 ( N_noxref_4_c_974_n N_noxref_6_c_1994_n ) capacitor c=5.24634e-19 \
 //x=6.915 //y=1.125 //x2=7.18 //y2=0.915
cc_937 ( N_noxref_4_M4_noxref_d N_noxref_6_c_1994_n ) capacitor c=0.00139206f \
 //x=6.725 //y=0.915 //x2=7.18 //y2=0.915
cc_938 ( N_noxref_4_c_974_n N_noxref_6_c_1996_n ) capacitor c=0.00307978f \
 //x=6.915 //y=1.125 //x2=7.18 //y2=1.26
cc_939 ( N_noxref_4_c_975_n N_noxref_6_c_1996_n ) capacitor c=0.00363411f \
 //x=6.915 //y=1.58 //x2=7.18 //y2=1.26
cc_940 ( N_noxref_4_c_1048_n N_noxref_6_c_1996_n ) capacitor c=0.00323576f \
 //x=7.315 //y=1.665 //x2=7.18 //y2=1.26
cc_941 ( N_noxref_4_M4_noxref_d N_noxref_6_c_1996_n ) capacitor c=0.00237422f \
 //x=6.725 //y=0.915 //x2=7.18 //y2=1.26
cc_942 ( N_noxref_4_c_978_n N_noxref_6_c_1909_n ) capacitor c=0.0025845f \
 //x=7.4 //y=3.91 //x2=6.66 //y2=2.08
cc_943 ( N_noxref_4_c_975_n N_noxref_6_c_1912_n ) capacitor c=0.00362297f \
 //x=6.915 //y=1.58 //x2=6.66 //y2=1.915
cc_944 ( N_noxref_4_c_978_n N_noxref_6_c_1912_n ) capacitor c=0.00282067f \
 //x=7.4 //y=3.91 //x2=6.66 //y2=1.915
cc_945 ( N_noxref_4_c_985_n N_noxref_6_c_1913_n ) capacitor c=0.00739287f \
 //x=7.4 //y=5.07 //x2=6.66 //y2=4.7
cc_946 ( N_noxref_4_c_1099_p N_noxref_6_c_1913_n ) capacitor c=0.00203307f \
 //x=6.62 //y=5.155 //x2=6.66 //y2=4.7
cc_947 ( N_noxref_4_c_1109_p N_noxref_6_c_1913_n ) capacitor c=0.00375636f \
 //x=6.62 //y=5.38 //x2=6.66 //y2=4.7
cc_948 ( N_noxref_4_c_973_n N_noxref_7_c_2294_n ) capacitor c=0.00620641f \
 //x=5.62 //y=5.155 //x2=23.68 //y2=7.4
cc_949 ( N_noxref_4_c_1057_n N_noxref_7_c_2294_n ) capacitor c=0.00626474f \
 //x=6.505 //y=5.155 //x2=23.68 //y2=7.4
cc_950 ( N_noxref_4_c_1046_n N_noxref_7_c_2294_n ) capacitor c=0.00255587f \
 //x=6.62 //y=5.38 //x2=23.68 //y2=7.4
cc_951 ( N_noxref_4_c_1047_n N_noxref_7_c_2294_n ) capacitor c=0.00827693f \
 //x=7.315 //y=5.155 //x2=23.68 //y2=7.4
cc_952 ( N_noxref_4_c_984_n N_noxref_7_c_2294_n ) capacitor c=4.84716e-19 \
 //x=7.4 //y=4.23 //x2=23.68 //y2=7.4
cc_953 ( N_noxref_4_c_1117_p N_noxref_7_c_2294_n ) capacitor c=2.25956e-19 \
 //x=17.39 //y=4.245 //x2=23.68 //y2=7.4
cc_954 ( N_noxref_4_c_988_n N_noxref_7_c_2294_n ) capacitor c=0.00261379f \
 //x=4.862 //y=5.155 //x2=23.68 //y2=7.4
cc_955 ( N_noxref_4_c_1066_n N_noxref_7_c_2294_n ) capacitor c=0.0026965f \
 //x=5.74 //y=5.155 //x2=23.68 //y2=7.4
cc_956 ( N_noxref_4_c_1106_p N_noxref_7_c_2294_n ) capacitor c=3.82861e-19 \
 //x=7.395 //y=4.07 //x2=23.68 //y2=7.4
cc_957 ( N_noxref_4_c_1118_p N_noxref_7_c_2294_n ) capacitor c=9.05427e-19 \
 //x=17.39 //y=4.7 //x2=23.68 //y2=7.4
cc_958 ( N_noxref_4_c_1011_n N_noxref_7_c_2294_n ) capacitor c=0.00242194f \
 //x=4.86 //y=5.38 //x2=23.68 //y2=7.4
cc_959 ( N_noxref_4_c_1082_n N_noxref_7_c_2294_n ) capacitor c=0.00242194f \
 //x=5.74 //y=5.38 //x2=23.68 //y2=7.4
cc_960 ( N_noxref_4_c_1109_p N_noxref_7_c_2294_n ) capacitor c=0.00242194f \
 //x=6.62 //y=5.38 //x2=23.68 //y2=7.4
cc_961 ( N_noxref_4_c_1189_p N_noxref_7_c_2294_n ) capacitor c=6.23118e-19 \
 //x=17.39 //y=4.7 //x2=23.68 //y2=7.4
cc_962 ( N_noxref_4_M17_noxref_g N_noxref_7_c_2304_n ) capacitor c=0.00692597f \
 //x=1.89 //y=6.02 //x2=2.465 //y2=7.4
cc_963 ( N_noxref_4_M18_noxref_g N_noxref_7_c_2304_n ) capacitor c=0.00749619f \
 //x=2.33 //y=6.02 //x2=2.465 //y2=7.4
cc_964 ( N_noxref_4_c_973_n N_noxref_7_c_2309_n ) capacitor c=0.00202948f \
 //x=5.62 //y=5.155 //x2=5.215 //y2=7.4
cc_965 ( N_noxref_4_c_988_n N_noxref_7_c_2309_n ) capacitor c=9.37357e-19 \
 //x=4.862 //y=5.155 //x2=5.215 //y2=7.4
cc_966 ( N_noxref_4_c_1011_n N_noxref_7_c_2309_n ) capacitor c=0.0137846f \
 //x=4.86 //y=5.38 //x2=5.215 //y2=7.4
cc_967 ( N_noxref_4_c_973_n N_noxref_7_c_2405_n ) capacitor c=0.00177088f \
 //x=5.62 //y=5.155 //x2=6.095 //y2=7.4
cc_968 ( N_noxref_4_c_1057_n N_noxref_7_c_2405_n ) capacitor c=0.00202948f \
 //x=6.505 //y=5.155 //x2=6.095 //y2=7.4
cc_969 ( N_noxref_4_c_1066_n N_noxref_7_c_2405_n ) capacitor c=9.47876e-19 \
 //x=5.74 //y=5.155 //x2=6.095 //y2=7.4
cc_970 ( N_noxref_4_c_1082_n N_noxref_7_c_2405_n ) capacitor c=0.0137846f \
 //x=5.74 //y=5.38 //x2=6.095 //y2=7.4
cc_971 ( N_noxref_4_c_1057_n N_noxref_7_c_2444_n ) capacitor c=0.00205929f \
 //x=6.505 //y=5.155 //x2=6.975 //y2=7.4
cc_972 ( N_noxref_4_c_1046_n N_noxref_7_c_2444_n ) capacitor c=8.49349e-19 \
 //x=6.62 //y=5.38 //x2=6.975 //y2=7.4
cc_973 ( N_noxref_4_c_1047_n N_noxref_7_c_2444_n ) capacitor c=0.00204261f \
 //x=7.315 //y=5.155 //x2=6.975 //y2=7.4
cc_974 ( N_noxref_4_c_1109_p N_noxref_7_c_2444_n ) capacitor c=0.0134886f \
 //x=6.62 //y=5.38 //x2=6.975 //y2=7.4
cc_975 ( N_noxref_4_c_1047_n N_noxref_7_c_2448_n ) capacitor c=0.00156832f \
 //x=7.315 //y=5.155 //x2=7.97 //y2=7.4
cc_976 ( N_noxref_4_c_984_n N_noxref_7_c_2448_n ) capacitor c=3.91676e-19 \
 //x=7.4 //y=4.23 //x2=7.97 //y2=7.4
cc_977 ( N_noxref_4_c_1118_p N_noxref_7_c_2450_n ) capacitor c=6.28732e-19 \
 //x=17.39 //y=4.7 //x2=17.865 //y2=7.4
cc_978 ( N_noxref_4_M35_noxref_g N_noxref_7_c_2450_n ) capacitor c=0.0072715f \
 //x=17.29 //y=6.02 //x2=17.865 //y2=7.4
cc_979 ( N_noxref_4_M36_noxref_g N_noxref_7_c_2450_n ) capacitor c=0.00749619f \
 //x=17.73 //y=6.02 //x2=17.865 //y2=7.4
cc_980 ( N_noxref_4_c_987_n N_noxref_7_c_2313_n ) capacitor c=9.76453e-19 \
 //x=1.85 //y=4.07 //x2=0.74 //y2=7.4
cc_981 ( N_noxref_4_c_987_n N_noxref_7_c_2316_n ) capacitor c=0.00133334f \
 //x=1.85 //y=4.07 //x2=3.33 //y2=7.4
cc_982 ( N_noxref_4_c_988_n N_noxref_7_c_2316_n ) capacitor c=0.0022955f \
 //x=4.862 //y=5.155 //x2=3.33 //y2=7.4
cc_983 ( N_noxref_4_c_993_n N_noxref_7_c_2316_n ) capacitor c=0.0195432f \
 //x=7.235 //y=4.07 //x2=3.33 //y2=7.4
cc_984 ( N_noxref_4_c_1009_n N_noxref_7_c_2316_n ) capacitor c=0.00226427f \
 //x=1.88 //y=4.7 //x2=3.33 //y2=7.4
cc_985 ( N_noxref_4_c_1011_n N_noxref_7_c_2316_n ) capacitor c=0.00508013f \
 //x=4.86 //y=5.38 //x2=3.33 //y2=7.4
cc_986 ( N_noxref_4_c_1026_n N_noxref_7_c_2316_n ) capacitor c=0.0129149f \
 //x=2.255 //y=4.79 //x2=3.33 //y2=7.4
cc_987 ( N_noxref_4_c_1044_n N_noxref_7_c_2316_n ) capacitor c=2.73429e-19 \
 //x=1.88 //y=4.7 //x2=3.33 //y2=7.4
cc_988 ( N_noxref_4_c_1046_n N_noxref_7_c_2324_n ) capacitor c=0.00282782f \
 //x=6.62 //y=5.38 //x2=8.14 //y2=7.4
cc_989 ( N_noxref_4_c_984_n N_noxref_7_c_2324_n ) capacitor c=0.00177813f \
 //x=7.4 //y=4.23 //x2=8.14 //y2=7.4
cc_990 ( N_noxref_4_c_985_n N_noxref_7_c_2324_n ) capacitor c=0.0293445f \
 //x=7.4 //y=5.07 //x2=8.14 //y2=7.4
cc_991 ( N_noxref_4_c_1106_p N_noxref_7_c_2324_n ) capacitor c=0.00499873f \
 //x=7.395 //y=4.07 //x2=8.14 //y2=7.4
cc_992 ( N_noxref_4_c_1006_n N_noxref_7_c_2324_n ) capacitor c=0.00826669f \
 //x=17.23 //y=4.085 //x2=8.14 //y2=7.4
cc_993 ( N_noxref_4_c_1109_p N_noxref_7_c_2324_n ) capacitor c=0.00777981f \
 //x=6.62 //y=5.38 //x2=8.14 //y2=7.4
cc_994 ( N_noxref_4_c_1006_n N_noxref_7_c_2382_n ) capacitor c=0.00885867f \
 //x=17.23 //y=4.085 //x2=12.95 //y2=7.4
cc_995 ( N_noxref_4_c_1117_p N_noxref_7_c_2411_n ) capacitor c=0.00144835f \
 //x=17.39 //y=4.245 //x2=16.28 //y2=7.4
cc_996 ( N_noxref_4_c_1224_p N_noxref_7_c_2411_n ) capacitor c=0.00247508f \
 //x=17.39 //y=4.07 //x2=16.28 //y2=7.4
cc_997 ( N_noxref_4_c_1118_p N_noxref_7_c_2411_n ) capacitor c=0.00447349f \
 //x=17.39 //y=4.7 //x2=16.28 //y2=7.4
cc_998 ( N_noxref_4_c_1073_n N_noxref_7_c_2411_n ) capacitor c=0.00506192f \
 //x=17.392 //y=4.56 //x2=16.28 //y2=7.4
cc_999 ( N_noxref_4_c_1006_n N_noxref_7_c_2411_n ) capacitor c=0.0193991f \
 //x=17.23 //y=4.085 //x2=16.28 //y2=7.4
cc_1000 ( N_noxref_4_c_1189_p N_noxref_7_c_2411_n ) capacitor c=0.00370494f \
 //x=17.39 //y=4.7 //x2=16.28 //y2=7.4
cc_1001 ( N_noxref_4_c_1229_p N_noxref_7_c_2411_n ) capacitor c=0.0129564f \
 //x=17.39 //y=4.7 //x2=16.28 //y2=7.4
cc_1002 ( N_noxref_4_c_1224_p N_noxref_7_c_2475_n ) capacitor c=7.01473e-19 \
 //x=17.39 //y=4.07 //x2=19.61 //y2=7.4
cc_1003 ( N_noxref_4_c_988_n N_noxref_7_M15_noxref_s ) capacitor c=4.22189e-19 \
 //x=4.862 //y=5.155 //x2=0.655 //y2=5.02
cc_1004 ( N_noxref_4_M17_noxref_g N_noxref_7_M16_noxref_d ) capacitor \
 c=0.015318f //x=1.89 //y=6.02 //x2=1.525 //y2=5.02
cc_1005 ( N_noxref_4_c_1044_n N_noxref_7_M16_noxref_d ) capacitor \
 c=3.50187e-19 //x=1.88 //y=4.7 //x2=1.525 //y2=5.02
cc_1006 ( N_noxref_4_M18_noxref_g N_noxref_7_M18_noxref_d ) capacitor \
 c=0.0430452f //x=2.33 //y=6.02 //x2=2.405 //y2=5.02
cc_1007 ( N_noxref_4_c_988_n N_noxref_7_M19_noxref_s ) capacitor c=0.0442713f \
 //x=4.862 //y=5.155 //x2=4.285 //y2=5.02
cc_1008 ( N_noxref_4_c_1066_n N_noxref_7_M19_noxref_s ) capacitor \
 c=7.80122e-19 //x=5.74 //y=5.155 //x2=4.285 //y2=5.02
cc_1009 ( N_noxref_4_c_993_n N_noxref_7_M19_noxref_s ) capacitor c=6.18859e-19 \
 //x=7.235 //y=4.07 //x2=4.285 //y2=5.02
cc_1010 ( N_noxref_4_c_1011_n N_noxref_7_M19_noxref_s ) capacitor c=0.0908457f \
 //x=4.86 //y=5.38 //x2=4.285 //y2=5.02
cc_1011 ( N_noxref_4_c_973_n N_noxref_7_M20_noxref_d ) capacitor c=0.00700078f \
 //x=5.62 //y=5.155 //x2=5.155 //y2=5.02
cc_1012 ( N_noxref_4_c_1011_n N_noxref_7_M20_noxref_d ) capacitor c=0.0673792f \
 //x=4.86 //y=5.38 //x2=5.155 //y2=5.02
cc_1013 ( N_noxref_4_c_1082_n N_noxref_7_M20_noxref_d ) capacitor c=0.0674762f \
 //x=5.74 //y=5.38 //x2=5.155 //y2=5.02
cc_1014 ( N_noxref_4_c_1057_n N_noxref_7_M22_noxref_d ) capacitor \
 c=0.00700078f //x=6.505 //y=5.155 //x2=6.035 //y2=5.02
cc_1015 ( N_noxref_4_c_1082_n N_noxref_7_M22_noxref_d ) capacitor c=0.067493f \
 //x=5.74 //y=5.38 //x2=6.035 //y2=5.02
cc_1016 ( N_noxref_4_c_1109_p N_noxref_7_M22_noxref_d ) capacitor c=0.0674979f \
 //x=6.62 //y=5.38 //x2=6.035 //y2=5.02
cc_1017 ( N_noxref_4_c_1047_n N_noxref_7_M24_noxref_d ) capacitor \
 c=0.00700078f //x=7.315 //y=5.155 //x2=6.915 //y2=5.02
cc_1018 ( N_noxref_4_c_1109_p N_noxref_7_M24_noxref_d ) capacitor c=0.0675002f \
 //x=6.62 //y=5.38 //x2=6.915 //y2=5.02
cc_1019 ( N_noxref_4_c_1046_n N_noxref_7_M25_noxref_s ) capacitor \
 c=0.00492616f //x=6.62 //y=5.38 //x2=9.095 //y2=5.02
cc_1020 ( N_noxref_4_c_1047_n N_noxref_7_M25_noxref_s ) capacitor \
 c=9.42705e-19 //x=7.315 //y=5.155 //x2=9.095 //y2=5.02
cc_1021 ( N_noxref_4_c_1066_n N_noxref_7_M25_noxref_s ) capacitor \
 c=2.11884e-19 //x=5.74 //y=5.155 //x2=9.095 //y2=5.02
cc_1022 ( N_noxref_4_c_1117_p N_noxref_7_M35_noxref_s ) capacitor \
 c=0.00222458f //x=17.39 //y=4.245 //x2=16.935 //y2=5.02
cc_1023 ( N_noxref_4_c_1006_n N_noxref_7_M35_noxref_s ) capacitor \
 c=0.00509704f //x=17.23 //y=4.085 //x2=16.935 //y2=5.02
cc_1024 ( N_noxref_4_M35_noxref_g N_noxref_7_M35_noxref_s ) capacitor \
 c=0.0567929f //x=17.29 //y=6.02 //x2=16.935 //y2=5.02
cc_1025 ( N_noxref_4_M36_noxref_g N_noxref_7_M36_noxref_d ) capacitor \
 c=0.015318f //x=17.73 //y=6.02 //x2=17.805 //y2=5.02
cc_1026 ( N_noxref_4_c_986_n N_noxref_8_c_2689_n ) capacitor c=0.0205342f \
 //x=1.85 //y=2.08 //x2=1.11 //y2=2.08
cc_1027 ( N_noxref_4_c_1008_n N_noxref_8_c_2689_n ) capacitor c=0.00370824f \
 //x=1.85 //y=2.08 //x2=1.11 //y2=2.08
cc_1028 ( N_noxref_4_c_1041_n N_noxref_8_c_2689_n ) capacitor c=0.00167305f \
 //x=1.85 //y=2.08 //x2=1.11 //y2=2.08
cc_1029 ( N_noxref_4_c_970_n N_noxref_8_c_2676_n ) capacitor c=0.0172863f \
 //x=1.85 //y=4.555 //x2=1.11 //y2=4.7
cc_1030 ( N_noxref_4_c_1009_n N_noxref_8_c_2676_n ) capacitor c=0.00389736f \
 //x=1.88 //y=4.7 //x2=1.11 //y2=4.7
cc_1031 ( N_noxref_4_c_1044_n N_noxref_8_c_2676_n ) capacitor c=0.00158715f \
 //x=1.88 //y=4.7 //x2=1.11 //y2=4.7
cc_1032 ( N_noxref_4_c_958_n N_noxref_8_c_2678_n ) capacitor c=0.0795217f \
 //x=1.85 //y=3.905 //x2=1.112 //y2=4.56
cc_1033 ( N_noxref_4_c_965_n N_noxref_8_c_2678_n ) capacitor c=0.0149195f \
 //x=1.85 //y=4.225 //x2=1.112 //y2=4.56
cc_1034 ( N_noxref_4_c_970_n N_noxref_8_c_2678_n ) capacitor c=0.0146931f \
 //x=1.85 //y=4.555 //x2=1.112 //y2=4.56
cc_1035 ( N_noxref_4_c_987_n N_noxref_8_c_2678_n ) capacitor c=0.00465739f \
 //x=1.85 //y=4.07 //x2=1.112 //y2=4.56
cc_1036 ( N_noxref_4_c_1003_n N_noxref_8_c_2678_n ) capacitor c=0.00686827f \
 //x=2.01 //y=4.065 //x2=1.112 //y2=4.56
cc_1037 ( N_noxref_4_c_1008_n N_noxref_8_c_2678_n ) capacitor c=3.49899e-19 \
 //x=1.85 //y=2.08 //x2=1.112 //y2=4.56
cc_1038 ( N_noxref_4_c_1009_n N_noxref_8_c_2678_n ) capacitor c=2.1563e-19 \
 //x=1.88 //y=4.7 //x2=1.112 //y2=4.56
cc_1039 ( N_noxref_4_c_958_n N_noxref_8_c_2702_n ) capacitor c=3.49899e-19 \
 //x=1.85 //y=3.905 //x2=1.11 //y2=2.08
cc_1040 ( N_noxref_4_c_986_n N_noxref_8_c_2702_n ) capacitor c=5.16867e-19 \
 //x=1.85 //y=2.08 //x2=1.11 //y2=2.08
cc_1041 ( N_noxref_4_c_1008_n N_noxref_8_c_2702_n ) capacitor c=0.00445529f \
 //x=1.85 //y=2.08 //x2=1.11 //y2=2.08
cc_1042 ( N_noxref_4_c_1041_n N_noxref_8_c_2702_n ) capacitor c=0.00266443f \
 //x=1.85 //y=2.08 //x2=1.11 //y2=2.08
cc_1043 ( N_noxref_4_c_970_n N_noxref_8_c_2680_n ) capacitor c=7.76143e-19 \
 //x=1.85 //y=4.555 //x2=1.11 //y2=4.7
cc_1044 ( N_noxref_4_c_1009_n N_noxref_8_c_2680_n ) capacitor c=0.00397338f \
 //x=1.88 //y=4.7 //x2=1.11 //y2=4.7
cc_1045 ( N_noxref_4_c_1044_n N_noxref_8_c_2680_n ) capacitor c=0.00237977f \
 //x=1.88 //y=4.7 //x2=1.11 //y2=4.7
cc_1046 ( N_noxref_4_M17_noxref_g N_noxref_8_M15_noxref_g ) capacitor \
 c=0.0104892f //x=1.89 //y=6.02 //x2=1.01 //y2=6.02
cc_1047 ( N_noxref_4_M17_noxref_g N_noxref_8_M16_noxref_g ) capacitor \
 c=0.107636f //x=1.89 //y=6.02 //x2=1.45 //y2=6.02
cc_1048 ( N_noxref_4_M18_noxref_g N_noxref_8_M16_noxref_g ) capacitor \
 c=0.0100341f //x=2.33 //y=6.02 //x2=1.45 //y2=6.02
cc_1049 ( N_noxref_4_c_1020_n N_noxref_8_c_2712_n ) capacitor c=4.86545e-19 \
 //x=1.885 //y=0.905 //x2=0.915 //y2=0.865
cc_1050 ( N_noxref_4_c_1020_n N_noxref_8_c_2713_n ) capacitor c=0.00152405f \
 //x=1.885 //y=0.905 //x2=0.915 //y2=1.21
cc_1051 ( N_noxref_4_c_1022_n N_noxref_8_c_2714_n ) capacitor c=0.00109982f \
 //x=1.885 //y=1.25 //x2=0.915 //y2=1.52
cc_1052 ( N_noxref_4_c_1025_n N_noxref_8_c_2714_n ) capacitor c=9.58243e-19 \
 //x=1.885 //y=1.56 //x2=0.915 //y2=1.52
cc_1053 ( N_noxref_4_c_986_n N_noxref_8_c_2716_n ) capacitor c=0.00167888f \
 //x=1.85 //y=2.08 //x2=0.915 //y2=1.915
cc_1054 ( N_noxref_4_c_1008_n N_noxref_8_c_2716_n ) capacitor c=0.00267961f \
 //x=1.85 //y=2.08 //x2=0.915 //y2=1.915
cc_1055 ( N_noxref_4_c_1025_n N_noxref_8_c_2716_n ) capacitor c=0.00662747f \
 //x=1.885 //y=1.56 //x2=0.915 //y2=1.915
cc_1056 ( N_noxref_4_c_1041_n N_noxref_8_c_2716_n ) capacitor c=0.0181449f \
 //x=1.85 //y=2.08 //x2=0.915 //y2=1.915
cc_1057 ( N_noxref_4_c_1020_n N_noxref_8_c_2720_n ) capacitor c=0.0151475f \
 //x=1.885 //y=0.905 //x2=1.445 //y2=0.865
cc_1058 ( N_noxref_4_c_1035_n N_noxref_8_c_2720_n ) capacitor c=0.00127211f \
 //x=2.415 //y=0.905 //x2=1.445 //y2=0.865
cc_1059 ( N_noxref_4_c_1022_n N_noxref_8_c_2722_n ) capacitor c=0.0111064f \
 //x=1.885 //y=1.25 //x2=1.445 //y2=1.21
cc_1060 ( N_noxref_4_c_1025_n N_noxref_8_c_2722_n ) capacitor c=0.00862358f \
 //x=1.885 //y=1.56 //x2=1.445 //y2=1.21
cc_1061 ( N_noxref_4_c_1037_n N_noxref_8_c_2722_n ) capacitor c=0.00204774f \
 //x=2.415 //y=1.25 //x2=1.445 //y2=1.21
cc_1062 ( N_noxref_4_c_970_n N_noxref_8_c_2687_n ) capacitor c=0.00201171f \
 //x=1.85 //y=4.555 //x2=1.11 //y2=4.7
cc_1063 ( N_noxref_4_c_1009_n N_noxref_8_c_2687_n ) capacitor c=0.00283894f \
 //x=1.88 //y=4.7 //x2=1.11 //y2=4.7
cc_1064 ( N_noxref_4_c_1044_n N_noxref_8_c_2687_n ) capacitor c=0.0297875f \
 //x=1.88 //y=4.7 //x2=1.11 //y2=4.7
cc_1065 ( N_noxref_4_c_974_n N_noxref_9_c_2777_n ) capacitor c=0.0036878f \
 //x=6.915 //y=1.125 //x2=7.315 //y2=0.54
cc_1066 ( N_noxref_4_c_1048_n N_noxref_9_c_2777_n ) capacitor c=0.00399931f \
 //x=7.315 //y=1.665 //x2=7.315 //y2=0.54
cc_1067 ( N_noxref_4_M4_noxref_d N_noxref_9_c_2777_n ) capacitor c=0.00910163f \
 //x=6.725 //y=0.915 //x2=7.315 //y2=0.54
cc_1068 ( N_noxref_4_M4_noxref_d N_noxref_9_c_2799_n ) capacitor c=0.00120711f \
 //x=6.725 //y=0.915 //x2=6.43 //y2=0.995
cc_1069 ( N_noxref_4_c_973_n N_noxref_9_M3_noxref_d ) capacitor c=0.00148661f \
 //x=5.62 //y=5.155 //x2=5.19 //y2=0.91
cc_1070 ( N_noxref_4_c_974_n N_noxref_9_M3_noxref_d ) capacitor c=0.00802417f \
 //x=6.915 //y=1.125 //x2=5.19 //y2=0.91
cc_1071 ( N_noxref_4_c_974_n N_noxref_9_M4_noxref_s ) capacitor c=0.0098487f \
 //x=6.915 //y=1.125 //x2=6.295 //y2=0.375
cc_1072 ( N_noxref_4_c_975_n N_noxref_9_M4_noxref_s ) capacitor c=0.0283111f \
 //x=6.915 //y=1.58 //x2=6.295 //y2=0.375
cc_1073 ( N_noxref_4_c_1048_n N_noxref_9_M4_noxref_s ) capacitor c=0.00946155f \
 //x=7.315 //y=1.665 //x2=6.295 //y2=0.375
cc_1074 ( N_noxref_4_c_1106_p N_noxref_9_M4_noxref_s ) capacitor c=0.00104339f \
 //x=7.395 //y=4.07 //x2=6.295 //y2=0.375
cc_1075 ( N_noxref_4_M4_noxref_d N_noxref_9_M4_noxref_s ) capacitor \
 c=0.0279003f //x=6.725 //y=0.915 //x2=6.295 //y2=0.375
cc_1076 ( N_noxref_4_c_974_n N_noxref_10_M6_noxref_d ) capacitor c=3.20746e-19 \
 //x=6.915 //y=1.125 //x2=10 //y2=0.91
cc_1077 ( N_noxref_4_c_1065_n N_noxref_11_c_2915_n ) capacitor c=0.0741723f \
 //x=17.39 //y=3.925 //x2=18.13 //y2=4.555
cc_1078 ( N_noxref_4_c_1117_p N_noxref_11_c_2915_n ) capacitor c=0.0151156f \
 //x=17.39 //y=4.245 //x2=18.13 //y2=4.555
cc_1079 ( N_noxref_4_c_1224_p N_noxref_11_c_2915_n ) capacitor c=9.19401e-19 \
 //x=17.39 //y=4.07 //x2=18.13 //y2=4.555
cc_1080 ( N_noxref_4_c_1118_p N_noxref_11_c_2915_n ) capacitor c=0.0172939f \
 //x=17.39 //y=4.7 //x2=18.13 //y2=4.555
cc_1081 ( N_noxref_4_c_1073_n N_noxref_11_c_2915_n ) capacitor c=0.0131851f \
 //x=17.392 //y=4.56 //x2=18.13 //y2=4.555
cc_1082 ( N_noxref_4_c_1120_p N_noxref_11_c_2915_n ) capacitor c=0.00686827f \
 //x=17.39 //y=4.085 //x2=18.13 //y2=4.555
cc_1083 ( N_noxref_4_c_1092_p N_noxref_11_c_2915_n ) capacitor c=3.30333e-19 \
 //x=17.39 //y=2.08 //x2=18.13 //y2=4.555
cc_1084 ( N_noxref_4_c_1189_p N_noxref_11_c_2915_n ) capacitor c=7.76143e-19 \
 //x=17.39 //y=4.7 //x2=18.13 //y2=4.555
cc_1085 ( N_noxref_4_c_1229_p N_noxref_11_c_2915_n ) capacitor c=0.00201171f \
 //x=17.39 //y=4.7 //x2=18.13 //y2=4.555
cc_1086 ( N_noxref_4_c_1090_p N_noxref_11_c_2924_n ) capacitor c=0.0179797f \
 //x=17.39 //y=2.08 //x2=18.13 //y2=2.08
cc_1087 ( N_noxref_4_c_1092_p N_noxref_11_c_2924_n ) capacitor c=5.16867e-19 \
 //x=17.39 //y=2.08 //x2=18.13 //y2=2.08
cc_1088 ( N_noxref_4_c_1316_p N_noxref_11_c_2924_n ) capacitor c=0.00161745f \
 //x=17.195 //y=1.915 //x2=18.13 //y2=2.08
cc_1089 ( N_noxref_4_c_1065_n N_noxref_11_c_2927_n ) capacitor c=3.30333e-19 \
 //x=17.39 //y=3.925 //x2=18.13 //y2=2.08
cc_1090 ( N_noxref_4_c_1090_p N_noxref_11_c_2927_n ) capacitor c=5.24723e-19 \
 //x=17.39 //y=2.08 //x2=18.13 //y2=2.08
cc_1091 ( N_noxref_4_c_1092_p N_noxref_11_c_2927_n ) capacitor c=0.00485709f \
 //x=17.39 //y=2.08 //x2=18.13 //y2=2.08
cc_1092 ( N_noxref_4_c_1316_p N_noxref_11_c_2927_n ) capacitor c=0.00267961f \
 //x=17.195 //y=1.915 //x2=18.13 //y2=2.08
cc_1093 ( N_noxref_4_c_1118_p N_noxref_11_c_2931_n ) capacitor c=4.80626e-19 \
 //x=17.39 //y=4.7 //x2=18.16 //y2=4.7
cc_1094 ( N_noxref_4_c_1189_p N_noxref_11_c_2931_n ) capacitor c=0.00397338f \
 //x=17.39 //y=4.7 //x2=18.16 //y2=4.7
cc_1095 ( N_noxref_4_c_1229_p N_noxref_11_c_2931_n ) capacitor c=0.00283894f \
 //x=17.39 //y=4.7 //x2=18.16 //y2=4.7
cc_1096 ( N_noxref_4_M35_noxref_g N_noxref_11_M37_noxref_g ) capacitor \
 c=0.0104892f //x=17.29 //y=6.02 //x2=18.17 //y2=6.02
cc_1097 ( N_noxref_4_M36_noxref_g N_noxref_11_M37_noxref_g ) capacitor \
 c=0.107636f //x=17.73 //y=6.02 //x2=18.17 //y2=6.02
cc_1098 ( N_noxref_4_M36_noxref_g N_noxref_11_M38_noxref_g ) capacitor \
 c=0.0100341f //x=17.73 //y=6.02 //x2=18.61 //y2=6.02
cc_1099 ( N_noxref_4_c_1327_p N_noxref_11_c_2937_n ) capacitor c=4.86545e-19 \
 //x=17.195 //y=0.865 //x2=18.165 //y2=0.905
cc_1100 ( N_noxref_4_c_1328_p N_noxref_11_c_2937_n ) capacitor c=0.00152405f \
 //x=17.195 //y=1.21 //x2=18.165 //y2=0.905
cc_1101 ( N_noxref_4_c_1329_p N_noxref_11_c_2937_n ) capacitor c=0.0151475f \
 //x=17.725 //y=0.865 //x2=18.165 //y2=0.905
cc_1102 ( N_noxref_4_c_1330_p N_noxref_11_c_2940_n ) capacitor c=0.00109982f \
 //x=17.195 //y=1.52 //x2=18.165 //y2=1.25
cc_1103 ( N_noxref_4_c_1331_p N_noxref_11_c_2940_n ) capacitor c=0.0111064f \
 //x=17.725 //y=1.21 //x2=18.165 //y2=1.25
cc_1104 ( N_noxref_4_c_1330_p N_noxref_11_c_2942_n ) capacitor c=9.58243e-19 \
 //x=17.195 //y=1.52 //x2=18.165 //y2=1.56
cc_1105 ( N_noxref_4_c_1316_p N_noxref_11_c_2942_n ) capacitor c=0.00662747f \
 //x=17.195 //y=1.915 //x2=18.165 //y2=1.56
cc_1106 ( N_noxref_4_c_1331_p N_noxref_11_c_2942_n ) capacitor c=0.00862358f \
 //x=17.725 //y=1.21 //x2=18.165 //y2=1.56
cc_1107 ( N_noxref_4_c_1329_p N_noxref_11_c_2945_n ) capacitor c=0.00127211f \
 //x=17.725 //y=0.865 //x2=18.695 //y2=0.905
cc_1108 ( N_noxref_4_c_1331_p N_noxref_11_c_2946_n ) capacitor c=0.00204774f \
 //x=17.725 //y=1.21 //x2=18.695 //y2=1.25
cc_1109 ( N_noxref_4_c_1090_p N_noxref_11_c_2947_n ) capacitor c=0.00161167f \
 //x=17.39 //y=2.08 //x2=18.13 //y2=2.08
cc_1110 ( N_noxref_4_c_1092_p N_noxref_11_c_2947_n ) capacitor c=0.0018937f \
 //x=17.39 //y=2.08 //x2=18.13 //y2=2.08
cc_1111 ( N_noxref_4_c_1316_p N_noxref_11_c_2947_n ) capacitor c=0.0181449f \
 //x=17.195 //y=1.915 //x2=18.13 //y2=2.08
cc_1112 ( N_noxref_4_c_1118_p N_noxref_11_c_2950_n ) capacitor c=0.00158715f \
 //x=17.39 //y=4.7 //x2=18.16 //y2=4.7
cc_1113 ( N_noxref_4_c_1189_p N_noxref_11_c_2950_n ) capacitor c=0.00237977f \
 //x=17.39 //y=4.7 //x2=18.16 //y2=4.7
cc_1114 ( N_noxref_4_c_1229_p N_noxref_11_c_2950_n ) capacitor c=0.0297875f \
 //x=17.39 //y=4.7 //x2=18.16 //y2=4.7
cc_1115 ( N_noxref_4_M36_noxref_g N_noxref_12_c_3020_n ) capacitor \
 c=0.0103227f //x=17.73 //y=6.02 //x2=18.275 //y2=5.2
cc_1116 ( N_noxref_4_c_1065_n N_noxref_12_c_3021_n ) capacitor c=0.00414746f \
 //x=17.39 //y=3.925 //x2=18.87 //y2=5.115
cc_1117 ( N_noxref_4_c_1073_n N_noxref_12_c_3021_n ) capacitor c=0.0015348f \
 //x=17.392 //y=4.56 //x2=18.87 //y2=5.115
cc_1118 ( N_noxref_4_c_1117_p N_noxref_12_c_3023_n ) capacitor c=0.00121594f \
 //x=17.39 //y=4.245 //x2=17.51 //y2=5.38
cc_1119 ( N_noxref_4_c_1118_p N_noxref_12_c_3023_n ) capacitor c=0.0117962f \
 //x=17.39 //y=4.7 //x2=17.51 //y2=5.38
cc_1120 ( N_noxref_4_c_1120_p N_noxref_12_c_3023_n ) capacitor c=6.61088e-19 \
 //x=17.39 //y=4.085 //x2=17.51 //y2=5.38
cc_1121 ( N_noxref_4_c_1189_p N_noxref_12_c_3023_n ) capacitor c=0.00277154f \
 //x=17.39 //y=4.7 //x2=17.51 //y2=5.38
cc_1122 ( N_noxref_4_M35_noxref_g N_noxref_12_c_3023_n ) capacitor \
 c=0.00201806f //x=17.29 //y=6.02 //x2=17.51 //y2=5.38
cc_1123 ( N_noxref_4_M36_noxref_g N_noxref_12_c_3023_n ) capacitor \
 c=0.00192712f //x=17.73 //y=6.02 //x2=17.51 //y2=5.38
cc_1124 ( N_noxref_4_c_1229_p N_noxref_12_c_3023_n ) capacitor c=0.00201193f \
 //x=17.39 //y=4.7 //x2=17.51 //y2=5.38
cc_1125 ( N_noxref_4_c_1117_p N_noxref_12_c_3030_n ) capacitor c=4.87998e-19 \
 //x=17.39 //y=4.245 //x2=17.51 //y2=5.38
cc_1126 ( N_noxref_4_c_1118_p N_noxref_12_c_3030_n ) capacitor c=0.00104426f \
 //x=17.39 //y=4.7 //x2=17.51 //y2=5.38
cc_1127 ( N_noxref_4_c_1189_p N_noxref_12_c_3030_n ) capacitor c=0.00377369f \
 //x=17.39 //y=4.7 //x2=17.51 //y2=5.38
cc_1128 ( N_noxref_4_M35_noxref_g N_noxref_12_c_3030_n ) capacitor \
 c=0.0158358f //x=17.29 //y=6.02 //x2=17.51 //y2=5.38
cc_1129 ( N_noxref_4_M36_noxref_g N_noxref_12_c_3030_n ) capacitor \
 c=0.0178987f //x=17.73 //y=6.02 //x2=17.51 //y2=5.38
cc_1130 ( N_noxref_4_c_1229_p N_noxref_12_c_3030_n ) capacitor c=0.00439888f \
 //x=17.39 //y=4.7 //x2=17.51 //y2=5.38
cc_1131 ( N_noxref_4_c_986_n N_noxref_13_c_3149_n ) capacitor c=0.00234099f \
 //x=1.85 //y=2.08 //x2=4.32 //y2=0
cc_1132 ( N_noxref_4_c_974_n N_noxref_13_c_3268_n ) capacitor c=0.00900212f \
 //x=6.915 //y=1.125 //x2=9.13 //y2=0
cc_1133 ( N_noxref_4_c_1048_n N_noxref_13_c_3268_n ) capacitor c=0.00712343f \
 //x=7.315 //y=1.665 //x2=9.13 //y2=0
cc_1134 ( N_noxref_4_c_984_n N_noxref_13_c_3268_n ) capacitor c=4.45012e-19 \
 //x=7.4 //y=4.23 //x2=9.13 //y2=0
cc_1135 ( N_noxref_4_M4_noxref_d N_noxref_13_c_3268_n ) capacitor \
 c=2.94508e-19 //x=6.725 //y=0.915 //x2=9.13 //y2=0
cc_1136 ( N_noxref_4_c_974_n N_noxref_13_c_3174_n ) capacitor c=0.00543195f \
 //x=6.915 //y=1.125 //x2=9.215 //y2=0.965
cc_1137 ( N_noxref_4_c_1090_p N_noxref_13_c_3280_n ) capacitor c=0.00644063f \
 //x=17.39 //y=2.08 //x2=17.46 //y2=0.955
cc_1138 ( N_noxref_4_c_1092_p N_noxref_13_c_3280_n ) capacitor c=2.13705e-19 \
 //x=17.39 //y=2.08 //x2=17.46 //y2=0.955
cc_1139 ( N_noxref_4_c_1327_p N_noxref_13_c_3280_n ) capacitor c=0.00171023f \
 //x=17.195 //y=0.865 //x2=17.46 //y2=0.955
cc_1140 ( N_noxref_4_c_1328_p N_noxref_13_c_3280_n ) capacitor c=0.00357815f \
 //x=17.195 //y=1.21 //x2=17.46 //y2=0.955
cc_1141 ( N_noxref_4_c_1330_p N_noxref_13_c_3280_n ) capacitor c=4.2764e-19 \
 //x=17.195 //y=1.52 //x2=17.46 //y2=0.955
cc_1142 ( N_noxref_4_c_1370_p N_noxref_13_c_3280_n ) capacitor c=9.36995e-19 \
 //x=17.57 //y=0.71 //x2=17.46 //y2=0.955
cc_1143 ( N_noxref_4_c_1371_p N_noxref_13_c_3280_n ) capacitor c=6.33567e-19 \
 //x=17.57 //y=1.365 //x2=17.46 //y2=0.955
cc_1144 ( N_noxref_4_c_1329_p N_noxref_13_c_3280_n ) capacitor c=0.00171483f \
 //x=17.725 //y=0.865 //x2=17.46 //y2=0.955
cc_1145 ( N_noxref_4_c_1331_p N_noxref_13_c_3280_n ) capacitor c=0.00296337f \
 //x=17.725 //y=1.21 //x2=17.46 //y2=0.955
cc_1146 ( N_noxref_4_c_1327_p N_noxref_13_c_3289_n ) capacitor c=3.46594e-19 \
 //x=17.195 //y=0.865 //x2=17.457 //y2=0.825
cc_1147 ( N_noxref_4_c_1370_p N_noxref_13_c_3289_n ) capacitor c=0.00838402f \
 //x=17.57 //y=0.71 //x2=17.457 //y2=0.825
cc_1148 ( N_noxref_4_c_1329_p N_noxref_13_c_3289_n ) capacitor c=4.40196e-19 \
 //x=17.725 //y=0.865 //x2=17.457 //y2=0.825
cc_1149 ( N_noxref_4_c_986_n N_noxref_13_c_3185_n ) capacitor c=3.77673e-19 \
 //x=1.85 //y=2.08 //x2=3.16 //y2=0
cc_1150 ( N_noxref_4_c_1048_n N_noxref_13_c_3189_n ) capacitor c=6.86937e-19 \
 //x=7.315 //y=1.665 //x2=7.97 //y2=0
cc_1151 ( N_noxref_4_c_1327_p N_noxref_13_c_3294_n ) capacitor c=0.00685132f \
 //x=17.195 //y=0.865 //x2=19.44 //y2=0
cc_1152 ( N_noxref_4_c_993_n N_noxref_13_c_3191_n ) capacitor c=0.0022439f \
 //x=7.235 //y=4.07 //x2=3.33 //y2=0
cc_1153 ( N_noxref_4_c_1008_n N_noxref_13_c_3191_n ) capacitor c=0.00224736f \
 //x=1.85 //y=2.08 //x2=3.33 //y2=0
cc_1154 ( N_noxref_4_c_1037_n N_noxref_13_c_3191_n ) capacitor c=0.00275184f \
 //x=2.415 //y=1.25 //x2=3.33 //y2=0
cc_1155 ( N_noxref_4_c_1041_n N_noxref_13_c_3191_n ) capacitor c=2.63786e-19 \
 //x=1.85 //y=2.08 //x2=3.33 //y2=0
cc_1156 ( N_noxref_4_c_975_n N_noxref_13_c_3203_n ) capacitor c=0.0045138f \
 //x=6.915 //y=1.58 //x2=8.14 //y2=0
cc_1157 ( N_noxref_4_c_1048_n N_noxref_13_c_3203_n ) capacitor c=0.0316807f \
 //x=7.315 //y=1.665 //x2=8.14 //y2=0
cc_1158 ( N_noxref_4_c_1065_n N_noxref_13_c_3260_n ) capacitor c=0.00781993f \
 //x=17.39 //y=3.925 //x2=16.28 //y2=0
cc_1159 ( N_noxref_4_c_1090_p N_noxref_13_c_3260_n ) capacitor c=0.00351582f \
 //x=17.39 //y=2.08 //x2=16.28 //y2=0
cc_1160 ( N_noxref_4_c_1092_p N_noxref_13_c_3260_n ) capacitor c=0.00371068f \
 //x=17.39 //y=2.08 //x2=16.28 //y2=0
cc_1161 ( N_noxref_4_c_1330_p N_noxref_13_c_3260_n ) capacitor c=0.0015404f \
 //x=17.195 //y=1.52 //x2=16.28 //y2=0
cc_1162 ( N_noxref_4_c_1316_p N_noxref_13_c_3260_n ) capacitor c=0.00938436f \
 //x=17.195 //y=1.915 //x2=16.28 //y2=0
cc_1163 ( N_noxref_4_c_1090_p N_noxref_13_M10_noxref_d ) capacitor \
 c=2.20438e-19 //x=17.39 //y=2.08 //x2=17.27 //y2=0.865
cc_1164 ( N_noxref_4_c_1327_p N_noxref_13_M10_noxref_d ) capacitor \
 c=0.00192399f //x=17.195 //y=0.865 //x2=17.27 //y2=0.865
cc_1165 ( N_noxref_4_c_1328_p N_noxref_13_M10_noxref_d ) capacitor \
 c=0.00210798f //x=17.195 //y=1.21 //x2=17.27 //y2=0.865
cc_1166 ( N_noxref_4_c_1370_p N_noxref_13_M10_noxref_d ) capacitor \
 c=0.00472259f //x=17.57 //y=0.71 //x2=17.27 //y2=0.865
cc_1167 ( N_noxref_4_c_1371_p N_noxref_13_M10_noxref_d ) capacitor \
 c=0.00166857f //x=17.57 //y=1.365 //x2=17.27 //y2=0.865
cc_1168 ( N_noxref_4_c_1329_p N_noxref_13_M10_noxref_d ) capacitor \
 c=0.00230174f //x=17.725 //y=0.865 //x2=17.27 //y2=0.865
cc_1169 ( N_noxref_4_c_1331_p N_noxref_13_M10_noxref_d ) capacitor \
 c=0.00210798f //x=17.725 //y=1.21 //x2=17.27 //y2=0.865
cc_1170 ( N_noxref_4_c_965_n N_noxref_17_c_3907_n ) capacitor c=2.69284e-19 \
 //x=1.85 //y=4.225 //x2=1.665 //y2=1.495
cc_1171 ( N_noxref_4_c_986_n N_noxref_17_c_3907_n ) capacitor c=7.50092e-19 \
 //x=1.85 //y=2.08 //x2=1.665 //y2=1.495
cc_1172 ( N_noxref_4_c_1025_n N_noxref_17_c_3907_n ) capacitor c=0.00888238f \
 //x=1.885 //y=1.56 //x2=1.665 //y2=1.495
cc_1173 ( N_noxref_4_c_1041_n N_noxref_17_c_3907_n ) capacitor c=0.00175171f \
 //x=1.85 //y=2.08 //x2=1.665 //y2=1.495
cc_1174 ( N_noxref_4_c_986_n N_noxref_17_c_3908_n ) capacitor c=0.001463f \
 //x=1.85 //y=2.08 //x2=2.55 //y2=0.53
cc_1175 ( N_noxref_4_c_1008_n N_noxref_17_c_3908_n ) capacitor c=8.82141e-19 \
 //x=1.85 //y=2.08 //x2=2.55 //y2=0.53
cc_1176 ( N_noxref_4_c_1020_n N_noxref_17_c_3908_n ) capacitor c=0.0200262f \
 //x=1.885 //y=0.905 //x2=2.55 //y2=0.53
cc_1177 ( N_noxref_4_c_1035_n N_noxref_17_c_3908_n ) capacitor c=0.00825432f \
 //x=2.415 //y=0.905 //x2=2.55 //y2=0.53
cc_1178 ( N_noxref_4_c_1041_n N_noxref_17_c_3908_n ) capacitor c=2.1838e-19 \
 //x=1.85 //y=2.08 //x2=2.55 //y2=0.53
cc_1179 ( N_noxref_4_c_1020_n N_noxref_17_M0_noxref_s ) capacitor \
 c=0.00888238f //x=1.885 //y=0.905 //x2=0.56 //y2=0.365
cc_1180 ( N_noxref_4_c_1035_n N_noxref_17_M0_noxref_s ) capacitor c=0.015333f \
 //x=2.415 //y=0.905 //x2=0.56 //y2=0.365
cc_1181 ( N_noxref_4_c_1037_n N_noxref_17_M0_noxref_s ) capacitor \
 c=0.00248746f //x=2.415 //y=1.25 //x2=0.56 //y2=0.365
cc_1182 ( N_noxref_4_c_1316_p N_noxref_21_c_4154_n ) capacitor c=0.00262672f \
 //x=17.195 //y=1.915 //x2=16.975 //y2=1.495
cc_1183 ( N_noxref_4_c_1117_p N_noxref_21_c_4155_n ) capacitor c=0.00330249f \
 //x=17.39 //y=4.245 //x2=17.86 //y2=1.58
cc_1184 ( N_noxref_4_c_1090_p N_noxref_21_c_4155_n ) capacitor c=0.00509504f \
 //x=17.39 //y=2.08 //x2=17.86 //y2=1.58
cc_1185 ( N_noxref_4_c_1092_p N_noxref_21_c_4155_n ) capacitor c=0.00763108f \
 //x=17.39 //y=2.08 //x2=17.86 //y2=1.58
cc_1186 ( N_noxref_4_c_1330_p N_noxref_21_c_4155_n ) capacitor c=0.00697076f \
 //x=17.195 //y=1.52 //x2=17.86 //y2=1.58
cc_1187 ( N_noxref_4_c_1316_p N_noxref_21_c_4155_n ) capacitor c=0.0170561f \
 //x=17.195 //y=1.915 //x2=17.86 //y2=1.58
cc_1188 ( N_noxref_4_c_1371_p N_noxref_21_c_4155_n ) capacitor c=0.00723574f \
 //x=17.57 //y=1.365 //x2=17.86 //y2=1.58
cc_1189 ( N_noxref_4_c_1331_p N_noxref_21_c_4155_n ) capacitor c=0.00339872f \
 //x=17.725 //y=1.21 //x2=17.86 //y2=1.58
cc_1190 ( N_noxref_4_c_1316_p N_noxref_21_c_4162_n ) capacitor c=6.71402e-19 \
 //x=17.195 //y=1.915 //x2=17.945 //y2=1.495
cc_1191 ( N_noxref_4_c_1327_p N_noxref_21_M10_noxref_s ) capacitor \
 c=0.0294925f //x=17.195 //y=0.865 //x2=16.84 //y2=0.365
cc_1192 ( N_noxref_4_c_1330_p N_noxref_21_M10_noxref_s ) capacitor \
 c=3.48408e-19 //x=17.195 //y=1.52 //x2=16.84 //y2=0.365
cc_1193 ( N_noxref_4_c_1329_p N_noxref_21_M10_noxref_s ) capacitor \
 c=0.0125442f //x=17.725 //y=0.865 //x2=16.84 //y2=0.365
cc_1194 ( N_noxref_5_c_1422_n N_noxref_6_c_1752_n ) capacitor c=0.00790562f \
 //x=10.36 //y=2.37 //x2=11.47 //y2=2.195
cc_1195 ( N_noxref_5_c_1434_n N_noxref_6_c_1752_n ) capacitor c=0.00195485f \
 //x=10.52 //y=2.21 //x2=11.47 //y2=2.195
cc_1196 ( N_noxref_5_c_1467_n N_noxref_6_c_1752_n ) capacitor c=0.0160193f \
 //x=21.66 //y=2.21 //x2=11.47 //y2=2.195
cc_1197 ( N_noxref_5_c_1436_n N_noxref_6_c_1752_n ) capacitor c=5.39999e-19 \
 //x=10.36 //y=2.08 //x2=11.47 //y2=2.195
cc_1198 ( N_noxref_5_c_1454_n N_noxref_6_c_1752_n ) capacitor c=6.5732e-19 \
 //x=10.45 //y=1.915 //x2=11.47 //y2=2.195
cc_1199 ( N_noxref_5_c_1422_n N_noxref_6_c_1743_n ) capacitor c=0.00339731f \
 //x=10.36 //y=2.37 //x2=11.47 //y2=3.525
cc_1200 ( N_noxref_5_c_1426_n N_noxref_6_c_1743_n ) capacitor c=0.0359663f \
 //x=10.36 //y=4.585 //x2=11.47 //y2=3.525
cc_1201 ( N_noxref_5_c_1434_n N_noxref_6_c_1743_n ) capacitor c=0.00105069f \
 //x=10.52 //y=2.21 //x2=11.47 //y2=3.525
cc_1202 ( N_noxref_5_c_1467_n N_noxref_6_c_1743_n ) capacitor c=0.0178948f \
 //x=21.66 //y=2.21 //x2=11.47 //y2=3.525
cc_1203 ( N_noxref_5_c_1426_n N_noxref_6_c_1760_n ) capacitor c=0.0078001f \
 //x=10.36 //y=4.585 //x2=11.47 //y2=3.845
cc_1204 ( N_noxref_5_c_1467_n N_noxref_6_c_1760_n ) capacitor c=0.00223608f \
 //x=21.66 //y=2.21 //x2=11.47 //y2=3.845
cc_1205 ( N_noxref_5_c_1426_n N_noxref_6_c_1745_n ) capacitor c=0.0266367f \
 //x=10.36 //y=4.585 //x2=11.47 //y2=4.57
cc_1206 ( N_noxref_5_c_1439_n N_noxref_6_c_1745_n ) capacitor c=9.52396e-19 \
 //x=10.36 //y=4.7 //x2=11.47 //y2=4.57
cc_1207 ( N_noxref_5_c_1457_n N_noxref_6_c_1745_n ) capacitor c=8.42568e-19 \
 //x=10.36 //y=4.7 //x2=11.47 //y2=4.57
cc_1208 ( N_noxref_5_c_1467_n N_noxref_6_c_1770_n ) capacitor c=0.0192658f \
 //x=21.66 //y=2.21 //x2=15.185 //y2=1.655
cc_1209 ( N_noxref_5_c_1467_n N_noxref_6_c_1771_n ) capacitor c=0.0331716f \
 //x=21.66 //y=2.21 //x2=15.54 //y2=3.525
cc_1210 ( N_noxref_5_c_1467_n N_noxref_6_c_1864_n ) capacitor c=0.00210759f \
 //x=21.66 //y=2.21 //x2=15.54 //y2=3.845
cc_1211 ( N_noxref_5_c_1516_p N_noxref_6_c_2023_n ) capacitor c=0.00829422f \
 //x=21.83 //y=2.37 //x2=22.94 //y2=2.195
cc_1212 ( N_noxref_5_c_1517_p N_noxref_6_c_2023_n ) capacitor c=0.00330689f \
 //x=21.82 //y=2.21 //x2=22.94 //y2=2.195
cc_1213 ( N_noxref_5_c_1518_p N_noxref_6_c_2023_n ) capacitor c=5.39999e-19 \
 //x=21.83 //y=2.08 //x2=22.94 //y2=2.195
cc_1214 ( N_noxref_5_c_1519_p N_noxref_6_c_2023_n ) capacitor c=6.57457e-19 \
 //x=21.92 //y=1.915 //x2=22.94 //y2=2.195
cc_1215 ( N_noxref_5_c_1516_p N_noxref_6_c_2027_n ) capacitor c=0.00391297f \
 //x=21.83 //y=2.37 //x2=22.94 //y2=3.545
cc_1216 ( N_noxref_5_c_1521_p N_noxref_6_c_2027_n ) capacitor c=0.037072f \
 //x=21.83 //y=4.585 //x2=22.94 //y2=3.545
cc_1217 ( N_noxref_5_c_1517_p N_noxref_6_c_2027_n ) capacitor c=0.00307154f \
 //x=21.82 //y=2.21 //x2=22.94 //y2=3.545
cc_1218 ( N_noxref_5_c_1521_p N_noxref_6_c_2030_n ) capacitor c=0.00772613f \
 //x=21.83 //y=4.585 //x2=22.94 //y2=3.865
cc_1219 ( N_noxref_5_c_1521_p N_noxref_6_c_2031_n ) capacitor c=0.0320186f \
 //x=21.83 //y=4.585 //x2=22.94 //y2=4.57
cc_1220 ( N_noxref_5_c_1525_p N_noxref_6_c_2031_n ) capacitor c=9.52396e-19 \
 //x=21.83 //y=4.7 //x2=22.94 //y2=4.57
cc_1221 ( N_noxref_5_c_1526_p N_noxref_6_c_2031_n ) capacitor c=8.42568e-19 \
 //x=21.83 //y=4.7 //x2=22.94 //y2=4.57
cc_1222 ( N_noxref_5_c_1426_n N_noxref_6_c_1776_n ) capacitor c=5.01652e-19 \
 //x=10.36 //y=4.585 //x2=11.47 //y2=3.7
cc_1223 ( N_noxref_5_c_1467_n N_noxref_6_c_1785_n ) capacitor c=6.99179e-19 \
 //x=21.66 //y=2.21 //x2=15.1 //y2=1
cc_1224 ( N_noxref_5_c_1521_p N_noxref_6_c_2036_n ) capacitor c=3.43503e-19 \
 //x=21.83 //y=4.585 //x2=22.94 //y2=3.7
cc_1225 ( N_noxref_5_c_1422_n N_noxref_6_c_1747_n ) capacitor c=0.00126615f \
 //x=10.36 //y=2.37 //x2=11.63 //y2=3.7
cc_1226 ( N_noxref_5_c_1426_n N_noxref_6_c_1747_n ) capacitor c=0.0305162f \
 //x=10.36 //y=4.585 //x2=11.63 //y2=3.7
cc_1227 ( N_noxref_5_c_1434_n N_noxref_6_c_1747_n ) capacitor c=0.00517956f \
 //x=10.52 //y=2.21 //x2=11.63 //y2=3.7
cc_1228 ( N_noxref_5_c_1467_n N_noxref_6_c_1747_n ) capacitor c=0.0250833f \
 //x=21.66 //y=2.21 //x2=11.63 //y2=3.7
cc_1229 ( N_noxref_5_c_1467_n N_noxref_6_c_1787_n ) capacitor c=0.0439305f \
 //x=21.66 //y=2.21 //x2=15.375 //y2=3.685
cc_1230 ( N_noxref_5_c_1467_n N_noxref_6_c_1891_n ) capacitor c=0.00512454f \
 //x=21.66 //y=2.21 //x2=15.695 //y2=3.685
cc_1231 ( N_noxref_5_c_1521_p N_noxref_6_c_2043_n ) capacitor c=0.00242466f \
 //x=21.83 //y=4.585 //x2=22.94 //y2=3.705
cc_1232 ( N_noxref_5_c_1516_p N_noxref_6_c_1967_n ) capacitor c=0.00126615f \
 //x=21.83 //y=2.37 //x2=22.78 //y2=3.705
cc_1233 ( N_noxref_5_c_1521_p N_noxref_6_c_1967_n ) capacitor c=0.0351282f \
 //x=21.83 //y=4.585 //x2=22.78 //y2=3.705
cc_1234 ( N_noxref_5_c_1517_p N_noxref_6_c_1967_n ) capacitor c=0.00518497f \
 //x=21.82 //y=2.21 //x2=22.78 //y2=3.705
cc_1235 ( N_noxref_5_c_1467_n N_noxref_6_c_1967_n ) capacitor c=0.142218f \
 //x=21.66 //y=2.21 //x2=22.78 //y2=3.705
cc_1236 ( N_noxref_5_c_1422_n N_noxref_6_c_1794_n ) capacitor c=0.00116634f \
 //x=10.36 //y=2.37 //x2=11.47 //y2=2.08
cc_1237 ( N_noxref_5_c_1436_n N_noxref_6_c_1794_n ) capacitor c=0.00124907f \
 //x=10.36 //y=2.08 //x2=11.47 //y2=2.08
cc_1238 ( N_noxref_5_c_1454_n N_noxref_6_c_1794_n ) capacitor c=0.00177608f \
 //x=10.45 //y=1.915 //x2=11.47 //y2=2.08
cc_1239 ( N_noxref_5_c_1426_n N_noxref_6_c_1795_n ) capacitor c=7.51101e-19 \
 //x=10.36 //y=4.585 //x2=11.47 //y2=4.7
cc_1240 ( N_noxref_5_c_1439_n N_noxref_6_c_1795_n ) capacitor c=0.00113985f \
 //x=10.36 //y=4.7 //x2=11.47 //y2=4.7
cc_1241 ( N_noxref_5_c_1457_n N_noxref_6_c_1795_n ) capacitor c=0.00129812f \
 //x=10.36 //y=4.7 //x2=11.47 //y2=4.7
cc_1242 ( N_noxref_5_c_1516_p N_noxref_6_c_2054_n ) capacitor c=0.00115817f \
 //x=21.83 //y=2.37 //x2=22.94 //y2=2.08
cc_1243 ( N_noxref_5_c_1518_p N_noxref_6_c_2054_n ) capacitor c=0.0012491f \
 //x=21.83 //y=2.08 //x2=22.94 //y2=2.08
cc_1244 ( N_noxref_5_c_1519_p N_noxref_6_c_2054_n ) capacitor c=0.00177608f \
 //x=21.92 //y=1.915 //x2=22.94 //y2=2.08
cc_1245 ( N_noxref_5_c_1521_p N_noxref_6_c_2057_n ) capacitor c=7.51101e-19 \
 //x=21.83 //y=4.585 //x2=22.94 //y2=4.7
cc_1246 ( N_noxref_5_c_1525_p N_noxref_6_c_2057_n ) capacitor c=0.00113985f \
 //x=21.83 //y=4.7 //x2=22.94 //y2=4.7
cc_1247 ( N_noxref_5_c_1526_p N_noxref_6_c_2057_n ) capacitor c=0.00129812f \
 //x=21.83 //y=4.7 //x2=22.94 //y2=4.7
cc_1248 ( N_noxref_5_M27_noxref_g N_noxref_6_M29_noxref_g ) capacitor \
 c=0.0101598f //x=10.33 //y=6.02 //x2=11.21 //y2=6.02
cc_1249 ( N_noxref_5_M28_noxref_g N_noxref_6_M29_noxref_g ) capacitor \
 c=0.0607518f //x=10.77 //y=6.02 //x2=11.21 //y2=6.02
cc_1250 ( N_noxref_5_M28_noxref_g N_noxref_6_M30_noxref_g ) capacitor \
 c=0.0101598f //x=10.77 //y=6.02 //x2=11.65 //y2=6.02
cc_1251 ( N_noxref_5_M41_noxref_g N_noxref_6_M43_noxref_g ) capacitor \
 c=0.0101598f //x=21.8 //y=6.02 //x2=22.68 //y2=6.02
cc_1252 ( N_noxref_5_M42_noxref_g N_noxref_6_M43_noxref_g ) capacitor \
 c=0.0607518f //x=22.24 //y=6.02 //x2=22.68 //y2=6.02
cc_1253 ( N_noxref_5_M42_noxref_g N_noxref_6_M44_noxref_g ) capacitor \
 c=0.0101598f //x=22.24 //y=6.02 //x2=23.12 //y2=6.02
cc_1254 ( N_noxref_5_c_1451_n N_noxref_6_c_1810_n ) capacitor c=0.00456962f \
 //x=10.45 //y=0.91 //x2=11.46 //y2=0.915
cc_1255 ( N_noxref_5_c_1452_n N_noxref_6_c_1812_n ) capacitor c=0.00438372f \
 //x=10.45 //y=1.22 //x2=11.46 //y2=1.26
cc_1256 ( N_noxref_5_c_1453_n N_noxref_6_c_1815_n ) capacitor c=0.00438372f \
 //x=10.45 //y=1.45 //x2=11.46 //y2=1.57
cc_1257 ( N_noxref_5_c_1562_p N_noxref_6_c_2069_n ) capacitor c=0.00456962f \
 //x=21.92 //y=0.91 //x2=22.93 //y2=0.915
cc_1258 ( N_noxref_5_c_1563_p N_noxref_6_c_2070_n ) capacitor c=0.00438372f \
 //x=21.92 //y=1.22 //x2=22.93 //y2=1.26
cc_1259 ( N_noxref_5_c_1564_p N_noxref_6_c_2071_n ) capacitor c=0.00438372f \
 //x=21.92 //y=1.45 //x2=22.93 //y2=1.57
cc_1260 ( N_noxref_5_c_1422_n N_noxref_6_c_1828_n ) capacitor c=0.00149114f \
 //x=10.36 //y=2.37 //x2=11.47 //y2=2.08
cc_1261 ( N_noxref_5_c_1436_n N_noxref_6_c_1828_n ) capacitor c=0.00204796f \
 //x=10.36 //y=2.08 //x2=11.47 //y2=2.08
cc_1262 ( N_noxref_5_c_1454_n N_noxref_6_c_1828_n ) capacitor c=0.00873247f \
 //x=10.45 //y=1.915 //x2=11.47 //y2=2.08
cc_1263 ( N_noxref_5_c_1454_n N_noxref_6_c_1829_n ) capacitor c=0.00438372f \
 //x=10.45 //y=1.915 //x2=11.47 //y2=1.915
cc_1264 ( N_noxref_5_c_1426_n N_noxref_6_c_1831_n ) capacitor c=0.00124604f \
 //x=10.36 //y=4.585 //x2=11.47 //y2=4.7
cc_1265 ( N_noxref_5_c_1439_n N_noxref_6_c_1831_n ) capacitor c=0.00187046f \
 //x=10.36 //y=4.7 //x2=11.47 //y2=4.7
cc_1266 ( N_noxref_5_c_1486_n N_noxref_6_c_1831_n ) capacitor c=0.0616777f \
 //x=10.695 //y=4.79 //x2=11.47 //y2=4.7
cc_1267 ( N_noxref_5_c_1457_n N_noxref_6_c_1831_n ) capacitor c=0.00487508f \
 //x=10.36 //y=4.7 //x2=11.47 //y2=4.7
cc_1268 ( N_noxref_5_c_1516_p N_noxref_6_c_2080_n ) capacitor c=0.00148267f \
 //x=21.83 //y=2.37 //x2=22.94 //y2=2.08
cc_1269 ( N_noxref_5_c_1518_p N_noxref_6_c_2080_n ) capacitor c=0.00204796f \
 //x=21.83 //y=2.08 //x2=22.94 //y2=2.08
cc_1270 ( N_noxref_5_c_1519_p N_noxref_6_c_2080_n ) capacitor c=0.00873247f \
 //x=21.92 //y=1.915 //x2=22.94 //y2=2.08
cc_1271 ( N_noxref_5_c_1519_p N_noxref_6_c_2083_n ) capacitor c=0.00438372f \
 //x=21.92 //y=1.915 //x2=22.94 //y2=1.915
cc_1272 ( N_noxref_5_c_1521_p N_noxref_6_c_2084_n ) capacitor c=0.00124604f \
 //x=21.83 //y=4.585 //x2=22.94 //y2=4.7
cc_1273 ( N_noxref_5_c_1525_p N_noxref_6_c_2084_n ) capacitor c=0.00187046f \
 //x=21.83 //y=4.7 //x2=22.94 //y2=4.7
cc_1274 ( N_noxref_5_c_1579_p N_noxref_6_c_2084_n ) capacitor c=0.0616777f \
 //x=22.165 //y=4.79 //x2=22.94 //y2=4.7
cc_1275 ( N_noxref_5_c_1526_p N_noxref_6_c_2084_n ) capacitor c=0.00487508f \
 //x=21.83 //y=4.7 //x2=22.94 //y2=4.7
cc_1276 ( N_noxref_5_M27_noxref_g N_noxref_7_c_2368_n ) capacitor \
 c=0.00700336f //x=10.33 //y=6.02 //x2=10.905 //y2=7.4
cc_1277 ( N_noxref_5_M28_noxref_g N_noxref_7_c_2368_n ) capacitor \
 c=0.00749619f //x=10.77 //y=6.02 //x2=10.905 //y2=7.4
cc_1278 ( N_noxref_5_M41_noxref_g N_noxref_7_c_2501_n ) capacitor \
 c=0.00700336f //x=21.8 //y=6.02 //x2=22.375 //y2=7.4
cc_1279 ( N_noxref_5_M42_noxref_g N_noxref_7_c_2501_n ) capacitor \
 c=0.00749619f //x=22.24 //y=6.02 //x2=22.375 //y2=7.4
cc_1280 ( N_noxref_5_M27_noxref_g N_noxref_7_M26_noxref_d ) capacitor \
 c=0.015318f //x=10.33 //y=6.02 //x2=9.965 //y2=5.02
cc_1281 ( N_noxref_5_M28_noxref_g N_noxref_7_M28_noxref_d ) capacitor \
 c=0.015318f //x=10.77 //y=6.02 //x2=10.845 //y2=5.02
cc_1282 ( N_noxref_5_M41_noxref_g N_noxref_7_M40_noxref_d ) capacitor \
 c=0.015318f //x=21.8 //y=6.02 //x2=21.435 //y2=5.02
cc_1283 ( N_noxref_5_M42_noxref_g N_noxref_7_M42_noxref_d ) capacitor \
 c=0.015318f //x=22.24 //y=6.02 //x2=22.315 //y2=5.02
cc_1284 ( N_noxref_5_c_1467_n N_noxref_10_c_2857_n ) capacitor c=0.00519491f \
 //x=21.66 //y=2.21 //x2=11.155 //y2=0.995
cc_1285 ( N_noxref_5_c_1451_n N_noxref_10_c_2857_n ) capacitor c=0.00123426f \
 //x=10.45 //y=0.91 //x2=11.155 //y2=0.995
cc_1286 ( N_noxref_5_c_1452_n N_noxref_10_c_2857_n ) capacitor c=0.0129287f \
 //x=10.45 //y=1.22 //x2=11.155 //y2=0.995
cc_1287 ( N_noxref_5_c_1453_n N_noxref_10_c_2857_n ) capacitor c=0.00132209f \
 //x=10.45 //y=1.45 //x2=11.155 //y2=0.995
cc_1288 ( N_noxref_5_c_1467_n N_noxref_10_c_2845_n ) capacitor c=3.59668e-19 \
 //x=21.66 //y=2.21 //x2=12.125 //y2=0.54
cc_1289 ( N_noxref_5_c_1422_n N_noxref_10_M6_noxref_d ) capacitor c=0.0067342f \
 //x=10.36 //y=2.37 //x2=10 //y2=0.91
cc_1290 ( N_noxref_5_c_1434_n N_noxref_10_M6_noxref_d ) capacitor \
 c=9.81665e-19 //x=10.52 //y=2.21 //x2=10 //y2=0.91
cc_1291 ( N_noxref_5_c_1436_n N_noxref_10_M6_noxref_d ) capacitor c=2.2052e-19 \
 //x=10.36 //y=2.08 //x2=10 //y2=0.91
cc_1292 ( N_noxref_5_c_1446_n N_noxref_10_M6_noxref_d ) capacitor \
 c=0.00253592f //x=9.925 //y=0.91 //x2=10 //y2=0.91
cc_1293 ( N_noxref_5_c_1449_n N_noxref_10_M6_noxref_d ) capacitor \
 c=0.00604087f //x=9.925 //y=1.22 //x2=10 //y2=0.91
cc_1294 ( N_noxref_5_c_1599_p N_noxref_10_M6_noxref_d ) capacitor c=0.002686f \
 //x=10.295 //y=0.755 //x2=10 //y2=0.91
cc_1295 ( N_noxref_5_c_1600_p N_noxref_10_M6_noxref_d ) capacitor \
 c=0.00251995f //x=10.295 //y=1.375 //x2=10 //y2=0.91
cc_1296 ( N_noxref_5_c_1451_n N_noxref_10_M6_noxref_d ) capacitor \
 c=0.00314523f //x=10.45 //y=0.91 //x2=10 //y2=0.91
cc_1297 ( N_noxref_5_c_1452_n N_noxref_10_M6_noxref_d ) capacitor \
 c=0.00168289f //x=10.45 //y=1.22 //x2=10 //y2=0.91
cc_1298 ( N_noxref_5_c_1453_n N_noxref_10_M6_noxref_d ) capacitor \
 c=0.00111165f //x=10.45 //y=1.45 //x2=10 //y2=0.91
cc_1299 ( N_noxref_5_c_1467_n N_noxref_10_M7_noxref_s ) capacitor \
 c=0.00471087f //x=21.66 //y=2.21 //x2=11.105 //y2=0.375
cc_1300 ( N_noxref_5_c_1451_n N_noxref_10_M7_noxref_s ) capacitor \
 c=7.21316e-19 //x=10.45 //y=0.91 //x2=11.105 //y2=0.375
cc_1301 ( N_noxref_5_c_1452_n N_noxref_10_M7_noxref_s ) capacitor \
 c=0.00365271f //x=10.45 //y=1.22 //x2=11.105 //y2=0.375
cc_1302 ( N_noxref_5_c_1454_n N_noxref_10_M7_noxref_s ) capacitor \
 c=9.86711e-19 //x=10.45 //y=1.915 //x2=11.105 //y2=0.375
cc_1303 ( N_noxref_5_c_1467_n N_noxref_11_c_2915_n ) capacitor c=0.0166179f \
 //x=21.66 //y=2.21 //x2=18.13 //y2=4.555
cc_1304 ( N_noxref_5_c_1467_n N_noxref_11_c_2924_n ) capacitor c=0.0170626f \
 //x=21.66 //y=2.21 //x2=18.13 //y2=2.08
cc_1305 ( N_noxref_5_c_1467_n N_noxref_12_c_3036_n ) capacitor c=0.0197568f \
 //x=21.66 //y=2.21 //x2=18.515 //y2=1.655
cc_1306 ( N_noxref_5_c_1521_p N_noxref_12_c_3021_n ) capacitor c=0.00283861f \
 //x=21.83 //y=4.585 //x2=18.87 //y2=5.115
cc_1307 ( N_noxref_5_c_1467_n N_noxref_12_c_3021_n ) capacitor c=0.0333831f \
 //x=21.66 //y=2.21 //x2=18.87 //y2=5.115
cc_1308 ( N_noxref_5_c_1467_n N_noxref_12_c_3039_n ) capacitor c=7.09092e-19 \
 //x=21.66 //y=2.21 //x2=18.43 //y2=1
cc_1309 ( N_noxref_5_c_1422_n N_noxref_13_c_3226_n ) capacitor c=8.86456e-19 \
 //x=10.36 //y=2.37 //x2=14.045 //y2=0
cc_1310 ( N_noxref_5_c_1434_n N_noxref_13_c_3226_n ) capacitor c=0.00334343f \
 //x=10.52 //y=2.21 //x2=14.045 //y2=0
cc_1311 ( N_noxref_5_c_1467_n N_noxref_13_c_3226_n ) capacitor c=0.100785f \
 //x=21.66 //y=2.21 //x2=14.045 //y2=0
cc_1312 ( N_noxref_5_c_1467_n N_noxref_13_c_3269_n ) capacitor c=0.0854967f \
 //x=21.66 //y=2.21 //x2=17.375 //y2=0
cc_1313 ( N_noxref_5_c_1467_n N_noxref_13_c_3317_n ) capacitor c=0.083514f \
 //x=21.66 //y=2.21 //x2=20.6 //y2=0
cc_1314 ( N_noxref_5_c_1516_p N_noxref_13_c_3318_n ) capacitor c=8.64665e-19 \
 //x=21.83 //y=2.37 //x2=23.68 //y2=0
cc_1315 ( N_noxref_5_c_1517_p N_noxref_13_c_3318_n ) capacitor c=0.00316384f \
 //x=21.82 //y=2.21 //x2=23.68 //y2=0
cc_1316 ( N_noxref_5_c_1467_n N_noxref_13_c_3318_n ) capacitor c=0.0248183f \
 //x=21.66 //y=2.21 //x2=23.68 //y2=0
cc_1317 ( N_noxref_5_c_1467_n N_noxref_13_c_3230_n ) capacitor c=0.00537176f \
 //x=21.66 //y=2.21 //x2=14.13 //y2=0.955
cc_1318 ( N_noxref_5_c_1467_n N_noxref_13_c_3280_n ) capacitor c=0.00570671f \
 //x=21.66 //y=2.21 //x2=17.46 //y2=0.955
cc_1319 ( N_noxref_5_c_1467_n N_noxref_13_c_3323_n ) capacitor c=0.00495607f \
 //x=21.66 //y=2.21 //x2=20.685 //y2=0.965
cc_1320 ( N_noxref_5_c_1467_n N_noxref_13_c_3247_n ) capacitor c=0.0219223f \
 //x=21.66 //y=2.21 //x2=12.95 //y2=0
cc_1321 ( N_noxref_5_c_1467_n N_noxref_13_c_3260_n ) capacitor c=0.0228073f \
 //x=21.66 //y=2.21 //x2=16.28 //y2=0
cc_1322 ( N_noxref_5_c_1467_n N_noxref_13_c_3326_n ) capacitor c=0.0227573f \
 //x=21.66 //y=2.21 //x2=19.61 //y2=0
cc_1323 ( N_noxref_5_c_1516_p N_noxref_14_c_3614_n ) capacitor c=0.00802132f \
 //x=21.83 //y=2.37 //x2=20.72 //y2=2.195
cc_1324 ( N_noxref_5_c_1517_p N_noxref_14_c_3614_n ) capacitor c=0.00196004f \
 //x=21.82 //y=2.21 //x2=20.72 //y2=2.195
cc_1325 ( N_noxref_5_c_1467_n N_noxref_14_c_3614_n ) capacitor c=0.0168015f \
 //x=21.66 //y=2.21 //x2=20.72 //y2=2.195
cc_1326 ( N_noxref_5_c_1518_p N_noxref_14_c_3614_n ) capacitor c=5.39999e-19 \
 //x=21.83 //y=2.08 //x2=20.72 //y2=2.195
cc_1327 ( N_noxref_5_c_1519_p N_noxref_14_c_3614_n ) capacitor c=5.616e-19 \
 //x=21.92 //y=1.915 //x2=20.72 //y2=2.195
cc_1328 ( N_noxref_5_c_1516_p N_noxref_14_c_3619_n ) capacitor c=0.00346868f \
 //x=21.83 //y=2.37 //x2=20.72 //y2=4.575
cc_1329 ( N_noxref_5_c_1521_p N_noxref_14_c_3619_n ) capacitor c=0.0780725f \
 //x=21.83 //y=4.585 //x2=20.72 //y2=4.575
cc_1330 ( N_noxref_5_c_1517_p N_noxref_14_c_3619_n ) capacitor c=0.00105803f \
 //x=21.82 //y=2.21 //x2=20.72 //y2=4.575
cc_1331 ( N_noxref_5_c_1467_n N_noxref_14_c_3619_n ) capacitor c=0.0194638f \
 //x=21.66 //y=2.21 //x2=20.72 //y2=4.575
cc_1332 ( N_noxref_5_c_1525_p N_noxref_14_c_3619_n ) capacitor c=0.00103399f \
 //x=21.83 //y=4.7 //x2=20.72 //y2=4.575
cc_1333 ( N_noxref_5_c_1526_p N_noxref_14_c_3619_n ) capacitor c=0.00116212f \
 //x=21.83 //y=4.7 //x2=20.72 //y2=4.575
cc_1334 ( N_noxref_5_c_1516_p N_noxref_14_c_3625_n ) capacitor c=0.00117245f \
 //x=21.83 //y=2.37 //x2=20.72 //y2=2.08
cc_1335 ( N_noxref_5_c_1467_n N_noxref_14_c_3625_n ) capacitor c=2.54369e-19 \
 //x=21.66 //y=2.21 //x2=20.72 //y2=2.08
cc_1336 ( N_noxref_5_c_1518_p N_noxref_14_c_3625_n ) capacitor c=0.00124905f \
 //x=21.83 //y=2.08 //x2=20.72 //y2=2.08
cc_1337 ( N_noxref_5_c_1519_p N_noxref_14_c_3625_n ) capacitor c=0.0017273f \
 //x=21.92 //y=1.915 //x2=20.72 //y2=2.08
cc_1338 ( N_noxref_5_c_1521_p N_noxref_14_c_3629_n ) capacitor c=6.26008e-19 \
 //x=21.83 //y=4.585 //x2=20.72 //y2=4.7
cc_1339 ( N_noxref_5_c_1525_p N_noxref_14_c_3629_n ) capacitor c=0.00113984f \
 //x=21.83 //y=4.7 //x2=20.72 //y2=4.7
cc_1340 ( N_noxref_5_c_1526_p N_noxref_14_c_3629_n ) capacitor c=0.00155973f \
 //x=21.83 //y=4.7 //x2=20.72 //y2=4.7
cc_1341 ( N_noxref_5_M41_noxref_g N_noxref_14_M39_noxref_g ) capacitor \
 c=0.0106276f //x=21.8 //y=6.02 //x2=20.92 //y2=6.02
cc_1342 ( N_noxref_5_M41_noxref_g N_noxref_14_M40_noxref_g ) capacitor \
 c=0.107144f //x=21.8 //y=6.02 //x2=21.36 //y2=6.02
cc_1343 ( N_noxref_5_M42_noxref_g N_noxref_14_M40_noxref_g ) capacitor \
 c=0.0101598f //x=22.24 //y=6.02 //x2=21.36 //y2=6.02
cc_1344 ( N_noxref_5_c_1649_p N_noxref_14_c_3635_n ) capacitor c=5.72528e-19 \
 //x=21.395 //y=0.91 //x2=20.42 //y2=0.875
cc_1345 ( N_noxref_5_c_1649_p N_noxref_14_c_3636_n ) capacitor c=0.00150277f \
 //x=21.395 //y=0.91 //x2=20.42 //y2=1.22
cc_1346 ( N_noxref_5_c_1651_p N_noxref_14_c_3637_n ) capacitor c=0.00111227f \
 //x=21.395 //y=1.22 //x2=20.42 //y2=1.53
cc_1347 ( N_noxref_5_c_1516_p N_noxref_14_c_3638_n ) capacitor c=0.00157323f \
 //x=21.83 //y=2.37 //x2=20.42 //y2=1.915
cc_1348 ( N_noxref_5_c_1518_p N_noxref_14_c_3638_n ) capacitor c=0.00214501f \
 //x=21.83 //y=2.08 //x2=20.42 //y2=1.915
cc_1349 ( N_noxref_5_c_1519_p N_noxref_14_c_3638_n ) capacitor c=0.00880777f \
 //x=21.92 //y=1.915 //x2=20.42 //y2=1.915
cc_1350 ( N_noxref_5_c_1649_p N_noxref_14_c_3641_n ) capacitor c=0.0160123f \
 //x=21.395 //y=0.91 //x2=20.95 //y2=0.875
cc_1351 ( N_noxref_5_c_1562_p N_noxref_14_c_3641_n ) capacitor c=9.19165e-19 \
 //x=21.92 //y=0.91 //x2=20.95 //y2=0.875
cc_1352 ( N_noxref_5_c_1651_p N_noxref_14_c_3643_n ) capacitor c=0.0124075f \
 //x=21.395 //y=1.22 //x2=20.95 //y2=1.22
cc_1353 ( N_noxref_5_c_1563_p N_noxref_14_c_3643_n ) capacitor c=0.0010154f \
 //x=21.92 //y=1.22 //x2=20.95 //y2=1.22
cc_1354 ( N_noxref_5_c_1564_p N_noxref_14_c_3643_n ) capacitor c=9.23422e-19 \
 //x=21.92 //y=1.45 //x2=20.95 //y2=1.22
cc_1355 ( N_noxref_5_c_1521_p N_noxref_14_c_3646_n ) capacitor c=7.66769e-19 \
 //x=21.83 //y=4.585 //x2=21.285 //y2=4.79
cc_1356 ( N_noxref_5_c_1525_p N_noxref_14_c_3646_n ) capacitor c=0.00116563f \
 //x=21.83 //y=4.7 //x2=21.285 //y2=4.79
cc_1357 ( N_noxref_5_c_1526_p N_noxref_14_c_3646_n ) capacitor c=0.0171374f \
 //x=21.83 //y=4.7 //x2=21.285 //y2=4.79
cc_1358 ( N_noxref_5_c_1521_p N_noxref_14_c_3649_n ) capacitor c=7.54501e-19 \
 //x=21.83 //y=4.585 //x2=20.995 //y2=4.79
cc_1359 ( N_noxref_5_c_1525_p N_noxref_14_c_3649_n ) capacitor c=0.00129812f \
 //x=21.83 //y=4.7 //x2=20.995 //y2=4.79
cc_1360 ( N_noxref_5_c_1526_p N_noxref_14_c_3649_n ) capacitor c=0.00484466f \
 //x=21.83 //y=4.7 //x2=20.995 //y2=4.79
cc_1361 ( N_noxref_5_c_1562_p N_noxref_15_c_3713_n ) capacitor c=0.00123426f \
 //x=21.92 //y=0.91 //x2=22.625 //y2=0.995
cc_1362 ( N_noxref_5_c_1563_p N_noxref_15_c_3713_n ) capacitor c=0.0129287f \
 //x=21.92 //y=1.22 //x2=22.625 //y2=0.995
cc_1363 ( N_noxref_5_c_1564_p N_noxref_15_c_3713_n ) capacitor c=0.00132209f \
 //x=21.92 //y=1.45 //x2=22.625 //y2=0.995
cc_1364 ( N_noxref_5_c_1516_p N_noxref_15_M13_noxref_d ) capacitor \
 c=0.00686082f //x=21.83 //y=2.37 //x2=21.47 //y2=0.91
cc_1365 ( N_noxref_5_c_1517_p N_noxref_15_M13_noxref_d ) capacitor \
 c=0.00119981f //x=21.82 //y=2.21 //x2=21.47 //y2=0.91
cc_1366 ( N_noxref_5_c_1467_n N_noxref_15_M13_noxref_d ) capacitor \
 c=0.00508822f //x=21.66 //y=2.21 //x2=21.47 //y2=0.91
cc_1367 ( N_noxref_5_c_1518_p N_noxref_15_M13_noxref_d ) capacitor \
 c=2.2052e-19 //x=21.83 //y=2.08 //x2=21.47 //y2=0.91
cc_1368 ( N_noxref_5_c_1649_p N_noxref_15_M13_noxref_d ) capacitor \
 c=0.00253592f //x=21.395 //y=0.91 //x2=21.47 //y2=0.91
cc_1369 ( N_noxref_5_c_1651_p N_noxref_15_M13_noxref_d ) capacitor \
 c=0.00604066f //x=21.395 //y=1.22 //x2=21.47 //y2=0.91
cc_1370 ( N_noxref_5_c_1675_p N_noxref_15_M13_noxref_d ) capacitor c=0.002686f \
 //x=21.765 //y=0.755 //x2=21.47 //y2=0.91
cc_1371 ( N_noxref_5_c_1676_p N_noxref_15_M13_noxref_d ) capacitor \
 c=0.00251995f //x=21.765 //y=1.375 //x2=21.47 //y2=0.91
cc_1372 ( N_noxref_5_c_1562_p N_noxref_15_M13_noxref_d ) capacitor \
 c=0.00314523f //x=21.92 //y=0.91 //x2=21.47 //y2=0.91
cc_1373 ( N_noxref_5_c_1563_p N_noxref_15_M13_noxref_d ) capacitor \
 c=0.00168289f //x=21.92 //y=1.22 //x2=21.47 //y2=0.91
cc_1374 ( N_noxref_5_c_1564_p N_noxref_15_M13_noxref_d ) capacitor \
 c=0.00111165f //x=21.92 //y=1.45 //x2=21.47 //y2=0.91
cc_1375 ( N_noxref_5_c_1562_p N_noxref_15_M14_noxref_s ) capacitor \
 c=7.21316e-19 //x=21.92 //y=0.91 //x2=22.575 //y2=0.375
cc_1376 ( N_noxref_5_c_1563_p N_noxref_15_M14_noxref_s ) capacitor \
 c=0.00365271f //x=21.92 //y=1.22 //x2=22.575 //y2=0.375
cc_1377 ( N_noxref_5_c_1519_p N_noxref_15_M14_noxref_s ) capacitor \
 c=9.86711e-19 //x=21.92 //y=1.915 //x2=22.575 //y2=0.375
cc_1378 ( N_noxref_5_c_1516_p N_noxref_16_c_3776_n ) capacitor c=4.33467e-19 \
 //x=21.83 //y=2.37 //x2=21.9 //y2=5.155
cc_1379 ( N_noxref_5_c_1521_p N_noxref_16_c_3776_n ) capacitor c=0.022014f \
 //x=21.83 //y=4.585 //x2=21.9 //y2=5.155
cc_1380 ( N_noxref_5_c_1525_p N_noxref_16_c_3776_n ) capacitor c=0.00492634f \
 //x=21.83 //y=4.7 //x2=21.9 //y2=5.155
cc_1381 ( N_noxref_5_M41_noxref_g N_noxref_16_c_3776_n ) capacitor \
 c=0.00858241f //x=21.8 //y=6.02 //x2=21.9 //y2=5.155
cc_1382 ( N_noxref_5_c_1526_p N_noxref_16_c_3776_n ) capacitor c=6.14744e-19 \
 //x=21.83 //y=4.7 //x2=21.9 //y2=5.155
cc_1383 ( N_noxref_5_M42_noxref_g N_noxref_16_c_3781_n ) capacitor \
 c=0.0110196f //x=22.24 //y=6.02 //x2=22.785 //y2=5.155
cc_1384 ( N_noxref_5_c_1521_p N_noxref_16_c_3782_n ) capacitor c=0.00447102f \
 //x=21.83 //y=4.585 //x2=23.68 //y2=5.07
cc_1385 ( N_noxref_5_c_1516_p N_noxref_16_c_3783_n ) capacitor c=4.04499e-19 \
 //x=21.83 //y=2.37 //x2=22.02 //y2=5.155
cc_1386 ( N_noxref_5_c_1521_p N_noxref_16_c_3783_n ) capacitor c=0.0024774f \
 //x=21.83 //y=4.585 //x2=22.02 //y2=5.155
cc_1387 ( N_noxref_5_c_1525_p N_noxref_16_c_3783_n ) capacitor c=0.00132214f \
 //x=21.83 //y=4.7 //x2=22.02 //y2=5.155
cc_1388 ( N_noxref_5_M41_noxref_g N_noxref_16_c_3783_n ) capacitor \
 c=0.00229818f //x=21.8 //y=6.02 //x2=22.02 //y2=5.155
cc_1389 ( N_noxref_5_M42_noxref_g N_noxref_16_c_3783_n ) capacitor \
 c=0.00230699f //x=22.24 //y=6.02 //x2=22.02 //y2=5.155
cc_1390 ( N_noxref_5_c_1579_p N_noxref_16_c_3783_n ) capacitor c=0.00177039f \
 //x=22.165 //y=4.79 //x2=22.02 //y2=5.155
cc_1391 ( N_noxref_5_c_1521_p N_noxref_16_c_3789_n ) capacitor c=7.85344e-19 \
 //x=21.83 //y=4.585 //x2=22.02 //y2=5.38
cc_1392 ( N_noxref_5_M41_noxref_g N_noxref_16_c_3789_n ) capacitor \
 c=0.0179041f //x=21.8 //y=6.02 //x2=22.02 //y2=5.38
cc_1393 ( N_noxref_5_M42_noxref_g N_noxref_16_c_3789_n ) capacitor \
 c=0.0179041f //x=22.24 //y=6.02 //x2=22.02 //y2=5.38
cc_1394 ( N_noxref_5_c_1579_p N_noxref_16_c_3789_n ) capacitor c=0.00290085f \
 //x=22.165 //y=4.79 //x2=22.02 //y2=5.38
cc_1395 ( N_noxref_5_c_1446_n N_noxref_19_c_4041_n ) capacitor c=0.0167228f \
 //x=9.925 //y=0.91 //x2=10.585 //y2=0.54
cc_1396 ( N_noxref_5_c_1451_n N_noxref_19_c_4041_n ) capacitor c=0.00534519f \
 //x=10.45 //y=0.91 //x2=10.585 //y2=0.54
cc_1397 ( N_noxref_5_c_1422_n N_noxref_19_c_4043_n ) capacitor c=0.00751795f \
 //x=10.36 //y=2.37 //x2=10.585 //y2=1.59
cc_1398 ( N_noxref_5_c_1467_n N_noxref_19_c_4043_n ) capacitor c=0.00129557f \
 //x=21.66 //y=2.21 //x2=10.585 //y2=1.59
cc_1399 ( N_noxref_5_c_1436_n N_noxref_19_c_4043_n ) capacitor c=0.0105652f \
 //x=10.36 //y=2.08 //x2=10.585 //y2=1.59
cc_1400 ( N_noxref_5_c_1449_n N_noxref_19_c_4043_n ) capacitor c=0.0154024f \
 //x=9.925 //y=1.22 //x2=10.585 //y2=1.59
cc_1401 ( N_noxref_5_c_1454_n N_noxref_19_c_4043_n ) capacitor c=0.0211955f \
 //x=10.45 //y=1.915 //x2=10.585 //y2=1.59
cc_1402 ( N_noxref_5_c_1467_n N_noxref_19_M5_noxref_s ) capacitor \
 c=0.00383739f //x=21.66 //y=2.21 //x2=8.595 //y2=0.375
cc_1403 ( N_noxref_5_c_1446_n N_noxref_19_M5_noxref_s ) capacitor \
 c=0.00798959f //x=9.925 //y=0.91 //x2=8.595 //y2=0.375
cc_1404 ( N_noxref_5_c_1453_n N_noxref_19_M5_noxref_s ) capacitor \
 c=0.00212176f //x=10.45 //y=1.45 //x2=8.595 //y2=0.375
cc_1405 ( N_noxref_5_c_1454_n N_noxref_19_M5_noxref_s ) capacitor \
 c=0.00298115f //x=10.45 //y=1.915 //x2=8.595 //y2=0.375
cc_1406 ( N_noxref_5_c_1467_n N_noxref_20_c_4087_n ) capacitor c=0.00442321f \
 //x=21.66 //y=2.21 //x2=13.645 //y2=1.495
cc_1407 ( N_noxref_5_c_1467_n N_noxref_20_c_4088_n ) capacitor c=0.0127693f \
 //x=21.66 //y=2.21 //x2=14.53 //y2=1.58
cc_1408 ( N_noxref_5_c_1467_n N_noxref_20_c_4095_n ) capacitor c=0.00403292f \
 //x=21.66 //y=2.21 //x2=14.615 //y2=1.495
cc_1409 ( N_noxref_5_c_1467_n N_noxref_20_c_4102_n ) capacitor c=5.61937e-19 \
 //x=21.66 //y=2.21 //x2=15.5 //y2=0.53
cc_1410 ( N_noxref_5_c_1467_n N_noxref_20_M8_noxref_s ) capacitor c=0.0010705f \
 //x=21.66 //y=2.21 //x2=13.51 //y2=0.365
cc_1411 ( N_noxref_5_c_1467_n N_noxref_21_c_4154_n ) capacitor c=0.00442321f \
 //x=21.66 //y=2.21 //x2=16.975 //y2=1.495
cc_1412 ( N_noxref_5_c_1467_n N_noxref_21_c_4155_n ) capacitor c=0.01279f \
 //x=21.66 //y=2.21 //x2=17.86 //y2=1.58
cc_1413 ( N_noxref_5_c_1467_n N_noxref_21_c_4162_n ) capacitor c=0.00403292f \
 //x=21.66 //y=2.21 //x2=17.945 //y2=1.495
cc_1414 ( N_noxref_5_c_1467_n N_noxref_21_c_4169_n ) capacitor c=5.61937e-19 \
 //x=21.66 //y=2.21 //x2=18.83 //y2=0.53
cc_1415 ( N_noxref_5_c_1467_n N_noxref_21_M10_noxref_s ) capacitor c=8.59e-19 \
 //x=21.66 //y=2.21 //x2=16.84 //y2=0.365
cc_1416 ( N_noxref_5_c_1467_n N_noxref_22_c_4220_n ) capacitor c=0.00444844f \
 //x=21.66 //y=2.21 //x2=20.2 //y2=1.505
cc_1417 ( N_noxref_5_c_1467_n N_noxref_22_c_4221_n ) capacitor c=0.0129011f \
 //x=21.66 //y=2.21 //x2=21.085 //y2=1.59
cc_1418 ( N_noxref_5_c_1649_p N_noxref_22_c_4222_n ) capacitor c=0.0167228f \
 //x=21.395 //y=0.91 //x2=22.055 //y2=0.54
cc_1419 ( N_noxref_5_c_1562_p N_noxref_22_c_4222_n ) capacitor c=0.00534519f \
 //x=21.92 //y=0.91 //x2=22.055 //y2=0.54
cc_1420 ( N_noxref_5_c_1516_p N_noxref_22_c_4224_n ) capacitor c=0.00743214f \
 //x=21.83 //y=2.37 //x2=22.055 //y2=1.59
cc_1421 ( N_noxref_5_c_1467_n N_noxref_22_c_4224_n ) capacitor c=0.00803439f \
 //x=21.66 //y=2.21 //x2=22.055 //y2=1.59
cc_1422 ( N_noxref_5_c_1518_p N_noxref_22_c_4224_n ) capacitor c=0.0105652f \
 //x=21.83 //y=2.08 //x2=22.055 //y2=1.59
cc_1423 ( N_noxref_5_c_1651_p N_noxref_22_c_4224_n ) capacitor c=0.0154243f \
 //x=21.395 //y=1.22 //x2=22.055 //y2=1.59
cc_1424 ( N_noxref_5_c_1519_p N_noxref_22_c_4224_n ) capacitor c=0.0214725f \
 //x=21.92 //y=1.915 //x2=22.055 //y2=1.59
cc_1425 ( N_noxref_5_c_1467_n N_noxref_22_M12_noxref_s ) capacitor \
 c=0.00444844f //x=21.66 //y=2.21 //x2=20.065 //y2=0.375
cc_1426 ( N_noxref_5_c_1649_p N_noxref_22_M12_noxref_s ) capacitor \
 c=0.00798959f //x=21.395 //y=0.91 //x2=20.065 //y2=0.375
cc_1427 ( N_noxref_5_c_1564_p N_noxref_22_M12_noxref_s ) capacitor \
 c=0.00212176f //x=21.92 //y=1.45 //x2=20.065 //y2=0.375
cc_1428 ( N_noxref_5_c_1519_p N_noxref_22_M12_noxref_s ) capacitor \
 c=0.00298115f //x=21.92 //y=1.915 //x2=20.065 //y2=0.375
cc_1429 ( N_noxref_6_c_1768_n N_noxref_7_c_2294_n ) capacitor c=0.00647555f \
 //x=14.945 //y=5.2 //x2=23.68 //y2=7.4
cc_1430 ( N_noxref_6_c_1856_n N_noxref_7_c_2294_n ) capacitor c=0.00491443f \
 //x=15.455 //y=5.2 //x2=23.68 //y2=7.4
cc_1431 ( N_noxref_6_c_1864_n N_noxref_7_c_2294_n ) capacitor c=2.03649e-19 \
 //x=15.54 //y=3.845 //x2=23.68 //y2=7.4
cc_1432 ( N_noxref_6_c_1777_n N_noxref_7_c_2294_n ) capacitor c=0.00368144f \
 //x=14.18 //y=5.38 //x2=23.68 //y2=7.4
cc_1433 ( N_noxref_6_c_1873_n N_noxref_7_c_2294_n ) capacitor c=8.41034e-19 \
 //x=15.06 //y=5.2 //x2=23.68 //y2=7.4
cc_1434 ( N_noxref_6_c_2093_p N_noxref_7_c_2294_n ) capacitor c=0.00285294f \
 //x=15.06 //y=5.38 //x2=23.68 //y2=7.4
cc_1435 ( N_noxref_6_c_1799_n N_noxref_7_c_2294_n ) capacitor c=0.00224727f \
 //x=14.18 //y=5.38 //x2=23.68 //y2=7.4
cc_1436 ( N_noxref_6_c_1899_n N_noxref_7_c_2294_n ) capacitor c=0.00224727f \
 //x=15.06 //y=5.38 //x2=23.68 //y2=7.4
cc_1437 ( N_noxref_6_M23_noxref_g N_noxref_7_c_2444_n ) capacitor \
 c=0.00749619f //x=6.4 //y=6.02 //x2=6.975 //y2=7.4
cc_1438 ( N_noxref_6_M24_noxref_g N_noxref_7_c_2444_n ) capacitor \
 c=0.00749823f //x=6.84 //y=6.02 //x2=6.975 //y2=7.4
cc_1439 ( N_noxref_6_M29_noxref_g N_noxref_7_c_2372_n ) capacitor \
 c=0.00749619f //x=11.21 //y=6.02 //x2=11.785 //y2=7.4
cc_1440 ( N_noxref_6_M30_noxref_g N_noxref_7_c_2372_n ) capacitor \
 c=0.00749823f //x=11.65 //y=6.02 //x2=11.785 //y2=7.4
cc_1441 ( N_noxref_6_c_1768_n N_noxref_7_c_2377_n ) capacitor c=0.00208112f \
 //x=14.945 //y=5.2 //x2=14.535 //y2=7.4
cc_1442 ( N_noxref_6_c_1777_n N_noxref_7_c_2377_n ) capacitor c=9.41091e-19 \
 //x=14.18 //y=5.38 //x2=14.535 //y2=7.4
cc_1443 ( N_noxref_6_c_1799_n N_noxref_7_c_2377_n ) capacitor c=0.0136475f \
 //x=14.18 //y=5.38 //x2=14.535 //y2=7.4
cc_1444 ( N_noxref_6_c_1768_n N_noxref_7_c_2407_n ) capacitor c=0.00180744f \
 //x=14.945 //y=5.2 //x2=15.415 //y2=7.4
cc_1445 ( N_noxref_6_c_1856_n N_noxref_7_c_2407_n ) capacitor c=0.00208112f \
 //x=15.455 //y=5.2 //x2=15.415 //y2=7.4
cc_1446 ( N_noxref_6_c_1873_n N_noxref_7_c_2407_n ) capacitor c=4.23323e-19 \
 //x=15.06 //y=5.2 //x2=15.415 //y2=7.4
cc_1447 ( N_noxref_6_c_2093_p N_noxref_7_c_2407_n ) capacitor c=5.78261e-19 \
 //x=15.06 //y=5.38 //x2=15.415 //y2=7.4
cc_1448 ( N_noxref_6_c_1899_n N_noxref_7_c_2407_n ) capacitor c=0.0136475f \
 //x=15.06 //y=5.38 //x2=15.415 //y2=7.4
cc_1449 ( N_noxref_6_M43_noxref_g N_noxref_7_c_2527_n ) capacitor \
 c=0.00749619f //x=22.68 //y=6.02 //x2=23.255 //y2=7.4
cc_1450 ( N_noxref_6_M44_noxref_g N_noxref_7_c_2527_n ) capacitor \
 c=0.00749823f //x=23.12 //y=6.02 //x2=23.255 //y2=7.4
cc_1451 ( N_noxref_6_c_2057_n N_noxref_7_c_2529_n ) capacitor c=0.00224736f \
 //x=22.94 //y=4.7 //x2=23.68 //y2=7.4
cc_1452 ( N_noxref_6_c_2084_n N_noxref_7_c_2529_n ) capacitor c=2.63786e-19 \
 //x=22.94 //y=4.7 //x2=23.68 //y2=7.4
cc_1453 ( N_noxref_6_c_1896_n N_noxref_7_c_2324_n ) capacitor c=0.00224736f \
 //x=6.66 //y=4.7 //x2=8.14 //y2=7.4
cc_1454 ( N_noxref_6_c_1913_n N_noxref_7_c_2324_n ) capacitor c=2.63786e-19 \
 //x=6.66 //y=4.7 //x2=8.14 //y2=7.4
cc_1455 ( N_noxref_6_c_1774_n N_noxref_7_c_2382_n ) capacitor c=0.0013228f \
 //x=15.54 //y=5.115 //x2=12.95 //y2=7.4
cc_1456 ( N_noxref_6_c_1777_n N_noxref_7_c_2382_n ) capacitor c=4.91377e-19 \
 //x=14.18 //y=5.38 //x2=12.95 //y2=7.4
cc_1457 ( N_noxref_6_c_1795_n N_noxref_7_c_2382_n ) capacitor c=0.00224736f \
 //x=11.47 //y=4.7 //x2=12.95 //y2=7.4
cc_1458 ( N_noxref_6_c_1799_n N_noxref_7_c_2382_n ) capacitor c=0.0064135f \
 //x=14.18 //y=5.38 //x2=12.95 //y2=7.4
cc_1459 ( N_noxref_6_c_1831_n N_noxref_7_c_2382_n ) capacitor c=2.63786e-19 \
 //x=11.47 //y=4.7 //x2=12.95 //y2=7.4
cc_1460 ( N_noxref_6_c_1774_n N_noxref_7_c_2411_n ) capacitor c=0.030815f \
 //x=15.54 //y=5.115 //x2=16.28 //y2=7.4
cc_1461 ( N_noxref_6_c_1873_n N_noxref_7_c_2411_n ) capacitor c=0.00240948f \
 //x=15.06 //y=5.2 //x2=16.28 //y2=7.4
cc_1462 ( N_noxref_6_c_2093_p N_noxref_7_c_2411_n ) capacitor c=4.09141e-19 \
 //x=15.06 //y=5.38 //x2=16.28 //y2=7.4
cc_1463 ( N_noxref_6_c_1899_n N_noxref_7_c_2411_n ) capacitor c=0.0101861f \
 //x=15.06 //y=5.38 //x2=16.28 //y2=7.4
cc_1464 ( N_noxref_6_c_1967_n N_noxref_7_c_2475_n ) capacitor c=0.00643435f \
 //x=22.78 //y=3.705 //x2=19.61 //y2=7.4
cc_1465 ( N_noxref_6_M23_noxref_g N_noxref_7_M22_noxref_d ) capacitor \
 c=0.015318f //x=6.4 //y=6.02 //x2=6.035 //y2=5.02
cc_1466 ( N_noxref_6_M24_noxref_g N_noxref_7_M24_noxref_d ) capacitor \
 c=0.0394719f //x=6.84 //y=6.02 //x2=6.915 //y2=5.02
cc_1467 ( N_noxref_6_M29_noxref_g N_noxref_7_M28_noxref_d ) capacitor \
 c=0.015318f //x=11.21 //y=6.02 //x2=10.845 //y2=5.02
cc_1468 ( N_noxref_6_M30_noxref_g N_noxref_7_M30_noxref_d ) capacitor \
 c=0.0394719f //x=11.65 //y=6.02 //x2=11.725 //y2=5.02
cc_1469 ( N_noxref_6_c_1777_n N_noxref_7_M31_noxref_s ) capacitor c=0.0611368f \
 //x=14.18 //y=5.38 //x2=13.605 //y2=5.02
cc_1470 ( N_noxref_6_c_1873_n N_noxref_7_M31_noxref_s ) capacitor \
 c=6.52457e-19 //x=15.06 //y=5.2 //x2=13.605 //y2=5.02
cc_1471 ( N_noxref_6_c_1799_n N_noxref_7_M31_noxref_s ) capacitor c=0.0887533f \
 //x=14.18 //y=5.38 //x2=13.605 //y2=5.02
cc_1472 ( N_noxref_6_c_1768_n N_noxref_7_M32_noxref_d ) capacitor \
 c=0.00734028f //x=14.945 //y=5.2 //x2=14.475 //y2=5.02
cc_1473 ( N_noxref_6_c_1777_n N_noxref_7_M32_noxref_d ) capacitor c=0.0043528f \
 //x=14.18 //y=5.38 //x2=14.475 //y2=5.02
cc_1474 ( N_noxref_6_c_2093_p N_noxref_7_M32_noxref_d ) capacitor c=0.0043528f \
 //x=15.06 //y=5.38 //x2=14.475 //y2=5.02
cc_1475 ( N_noxref_6_c_1799_n N_noxref_7_M32_noxref_d ) capacitor c=0.065554f \
 //x=14.18 //y=5.38 //x2=14.475 //y2=5.02
cc_1476 ( N_noxref_6_c_1899_n N_noxref_7_M32_noxref_d ) capacitor c=0.065554f \
 //x=15.06 //y=5.38 //x2=14.475 //y2=5.02
cc_1477 ( N_noxref_6_c_1856_n N_noxref_7_M34_noxref_d ) capacitor \
 c=0.00897657f //x=15.455 //y=5.2 //x2=15.355 //y2=5.02
cc_1478 ( N_noxref_6_c_2093_p N_noxref_7_M34_noxref_d ) capacitor \
 c=0.00587834f //x=15.06 //y=5.38 //x2=15.355 //y2=5.02
cc_1479 ( N_noxref_6_c_1884_n N_noxref_7_M34_noxref_d ) capacitor \
 c=0.00122227f //x=15.54 //y=3.7 //x2=15.355 //y2=5.02
cc_1480 ( N_noxref_6_c_1899_n N_noxref_7_M34_noxref_d ) capacitor c=0.065554f \
 //x=15.06 //y=5.38 //x2=15.355 //y2=5.02
cc_1481 ( N_noxref_6_c_1856_n N_noxref_7_M35_noxref_s ) capacitor \
 c=0.00326953f //x=15.455 //y=5.2 //x2=16.935 //y2=5.02
cc_1482 ( N_noxref_6_c_1873_n N_noxref_7_M35_noxref_s ) capacitor \
 c=0.00515461f //x=15.06 //y=5.2 //x2=16.935 //y2=5.02
cc_1483 ( N_noxref_6_c_2093_p N_noxref_7_M35_noxref_s ) capacitor \
 c=3.28075e-19 //x=15.06 //y=5.38 //x2=16.935 //y2=5.02
cc_1484 ( N_noxref_6_c_1967_n N_noxref_7_M39_noxref_s ) capacitor \
 c=4.77143e-19 //x=22.78 //y=3.705 //x2=20.565 //y2=5.02
cc_1485 ( N_noxref_6_M43_noxref_g N_noxref_7_M42_noxref_d ) capacitor \
 c=0.015318f //x=22.68 //y=6.02 //x2=22.315 //y2=5.02
cc_1486 ( N_noxref_6_M44_noxref_g N_noxref_7_M44_noxref_d ) capacitor \
 c=0.0394719f //x=23.12 //y=6.02 //x2=23.195 //y2=5.02
cc_1487 ( N_noxref_6_c_1734_n N_noxref_9_c_2777_n ) capacitor c=0.00177186f \
 //x=6.66 //y=2.195 //x2=7.315 //y2=0.54
cc_1488 ( N_noxref_6_c_1892_n N_noxref_9_c_2777_n ) capacitor c=0.00117306f \
 //x=6.66 //y=2.08 //x2=7.315 //y2=0.54
cc_1489 ( N_noxref_6_c_1906_n N_noxref_9_c_2777_n ) capacitor c=0.0206349f \
 //x=6.65 //y=0.915 //x2=7.315 //y2=0.54
cc_1490 ( N_noxref_6_c_1994_n N_noxref_9_c_2777_n ) capacitor c=0.00825432f \
 //x=7.18 //y=0.915 //x2=7.315 //y2=0.54
cc_1491 ( N_noxref_6_c_1909_n N_noxref_9_c_2777_n ) capacitor c=2.20712e-19 \
 //x=6.66 //y=2.08 //x2=7.315 //y2=0.54
cc_1492 ( N_noxref_6_c_1907_n N_noxref_9_c_2799_n ) capacitor c=0.0071177f \
 //x=6.65 //y=1.26 //x2=6.43 //y2=0.995
cc_1493 ( N_noxref_6_c_1906_n N_noxref_9_M4_noxref_s ) capacitor c=0.0071177f \
 //x=6.65 //y=0.915 //x2=6.295 //y2=0.375
cc_1494 ( N_noxref_6_c_1908_n N_noxref_9_M4_noxref_s ) capacitor c=0.0071177f \
 //x=6.65 //y=1.57 //x2=6.295 //y2=0.375
cc_1495 ( N_noxref_6_c_1994_n N_noxref_9_M4_noxref_s ) capacitor c=0.015333f \
 //x=7.18 //y=0.915 //x2=6.295 //y2=0.375
cc_1496 ( N_noxref_6_c_1996_n N_noxref_9_M4_noxref_s ) capacitor c=0.00248746f \
 //x=7.18 //y=1.26 //x2=6.295 //y2=0.375
cc_1497 ( N_noxref_6_c_1752_n N_noxref_10_c_2845_n ) capacitor c=0.00177186f \
 //x=11.47 //y=2.195 //x2=12.125 //y2=0.54
cc_1498 ( N_noxref_6_c_1794_n N_noxref_10_c_2845_n ) capacitor c=0.00117306f \
 //x=11.47 //y=2.08 //x2=12.125 //y2=0.54
cc_1499 ( N_noxref_6_c_1810_n N_noxref_10_c_2845_n ) capacitor c=0.0206349f \
 //x=11.46 //y=0.915 //x2=12.125 //y2=0.54
cc_1500 ( N_noxref_6_c_1822_n N_noxref_10_c_2845_n ) capacitor c=0.00825432f \
 //x=11.99 //y=0.915 //x2=12.125 //y2=0.54
cc_1501 ( N_noxref_6_c_1828_n N_noxref_10_c_2845_n ) capacitor c=2.20712e-19 \
 //x=11.47 //y=2.08 //x2=12.125 //y2=0.54
cc_1502 ( N_noxref_6_c_1812_n N_noxref_10_c_2848_n ) capacitor c=0.0071177f \
 //x=11.46 //y=1.26 //x2=11.24 //y2=0.995
cc_1503 ( N_noxref_6_c_1760_n N_noxref_10_M7_noxref_s ) capacitor \
 c=9.75621e-19 //x=11.47 //y=3.845 //x2=11.105 //y2=0.375
cc_1504 ( N_noxref_6_c_1810_n N_noxref_10_M7_noxref_s ) capacitor c=0.0071177f \
 //x=11.46 //y=0.915 //x2=11.105 //y2=0.375
cc_1505 ( N_noxref_6_c_1815_n N_noxref_10_M7_noxref_s ) capacitor c=0.0071177f \
 //x=11.46 //y=1.57 //x2=11.105 //y2=0.375
cc_1506 ( N_noxref_6_c_1822_n N_noxref_10_M7_noxref_s ) capacitor c=0.015333f \
 //x=11.99 //y=0.915 //x2=11.105 //y2=0.375
cc_1507 ( N_noxref_6_c_1824_n N_noxref_10_M7_noxref_s ) capacitor \
 c=0.00248746f //x=11.99 //y=1.26 //x2=11.105 //y2=0.375
cc_1508 ( N_noxref_6_c_1771_n N_noxref_11_c_2915_n ) capacitor c=0.00226046f \
 //x=15.54 //y=3.525 //x2=18.13 //y2=4.555
cc_1509 ( N_noxref_6_c_1774_n N_noxref_11_c_2915_n ) capacitor c=0.00236193f \
 //x=15.54 //y=5.115 //x2=18.13 //y2=4.555
cc_1510 ( N_noxref_6_c_1967_n N_noxref_11_c_2915_n ) capacitor c=0.0332279f \
 //x=22.78 //y=3.705 //x2=18.13 //y2=4.555
cc_1511 ( N_noxref_6_c_1967_n N_noxref_11_c_2924_n ) capacitor c=0.00102301f \
 //x=22.78 //y=3.705 //x2=18.13 //y2=2.08
cc_1512 ( N_noxref_6_c_1769_n N_noxref_12_c_3040_n ) capacitor c=0.00324213f \
 //x=15.1 //y=1.57 //x2=18.43 //y2=1.57
cc_1513 ( N_noxref_6_c_1857_n N_noxref_12_c_3036_n ) capacitor c=0.00231467f \
 //x=15.455 //y=1.655 //x2=18.515 //y2=1.655
cc_1514 ( N_noxref_6_c_1774_n N_noxref_12_c_3021_n ) capacitor c=9.42509e-19 \
 //x=15.54 //y=5.115 //x2=18.87 //y2=5.115
cc_1515 ( N_noxref_6_c_1967_n N_noxref_12_c_3021_n ) capacitor c=0.0346464f \
 //x=22.78 //y=3.705 //x2=18.87 //y2=5.115
cc_1516 ( N_noxref_6_c_1856_n N_noxref_12_c_3023_n ) capacitor c=0.00114153f \
 //x=15.455 //y=5.2 //x2=17.51 //y2=5.38
cc_1517 ( N_noxref_6_c_1873_n N_noxref_12_c_3023_n ) capacitor c=5.29822e-19 \
 //x=15.06 //y=5.2 //x2=17.51 //y2=5.38
cc_1518 ( N_noxref_6_c_2093_p N_noxref_12_c_3023_n ) capacitor c=0.00147119f \
 //x=15.06 //y=5.38 //x2=17.51 //y2=5.38
cc_1519 ( N_noxref_6_c_1967_n N_noxref_12_c_3023_n ) capacitor c=0.0144565f \
 //x=22.78 //y=3.705 //x2=17.51 //y2=5.38
cc_1520 ( N_noxref_6_c_1967_n N_noxref_12_c_3048_n ) capacitor c=0.0126498f \
 //x=22.78 //y=3.705 //x2=18.39 //y2=5.2
cc_1521 ( N_noxref_6_c_1785_n N_noxref_12_c_3039_n ) capacitor c=6.99317e-19 \
 //x=15.1 //y=1 //x2=18.43 //y2=1
cc_1522 ( N_noxref_6_c_1734_n N_noxref_13_c_3268_n ) capacitor c=0.00219445f \
 //x=6.66 //y=2.195 //x2=9.13 //y2=0
cc_1523 ( N_noxref_6_c_1752_n N_noxref_13_c_3226_n ) capacitor c=0.00196073f \
 //x=11.47 //y=2.195 //x2=14.045 //y2=0
cc_1524 ( N_noxref_6_c_1857_n N_noxref_13_c_3269_n ) capacitor c=0.00607337f \
 //x=15.455 //y=1.655 //x2=17.375 //y2=0
cc_1525 ( N_noxref_6_c_1785_n N_noxref_13_c_3269_n ) capacitor c=0.00913699f \
 //x=15.1 //y=1 //x2=17.375 //y2=0
cc_1526 ( N_noxref_6_M9_noxref_d N_noxref_13_c_3269_n ) capacitor \
 c=3.01654e-19 //x=14.91 //y=0.905 //x2=17.375 //y2=0
cc_1527 ( N_noxref_6_c_2023_n N_noxref_13_c_3318_n ) capacitor c=0.00219445f \
 //x=22.94 //y=2.195 //x2=23.68 //y2=0
cc_1528 ( N_noxref_6_c_2030_n N_noxref_13_c_3318_n ) capacitor c=2.73676e-19 \
 //x=22.94 //y=3.865 //x2=23.68 //y2=0
cc_1529 ( N_noxref_6_c_1777_n N_noxref_13_c_3230_n ) capacitor c=7.42819e-19 \
 //x=14.18 //y=5.38 //x2=14.13 //y2=0.955
cc_1530 ( N_noxref_6_c_1785_n N_noxref_13_c_3230_n ) capacitor c=0.0140211f \
 //x=15.1 //y=1 //x2=14.13 //y2=0.955
cc_1531 ( N_noxref_6_M9_noxref_d N_noxref_13_c_3230_n ) capacitor \
 c=2.93544e-19 //x=14.91 //y=0.905 //x2=14.13 //y2=0.955
cc_1532 ( N_noxref_6_c_1785_n N_noxref_13_c_3280_n ) capacitor c=0.00549186f \
 //x=15.1 //y=1 //x2=17.46 //y2=0.955
cc_1533 ( N_noxref_6_c_1734_n N_noxref_13_c_3189_n ) capacitor c=2.01623e-19 \
 //x=6.66 //y=2.195 //x2=7.97 //y2=0
cc_1534 ( N_noxref_6_c_1752_n N_noxref_13_c_3190_n ) capacitor c=2.01623e-19 \
 //x=11.47 //y=2.195 //x2=12.78 //y2=0
cc_1535 ( N_noxref_6_c_1857_n N_noxref_13_c_3246_n ) capacitor c=7.78078e-19 \
 //x=15.455 //y=1.655 //x2=16.11 //y2=0
cc_1536 ( N_noxref_6_c_2023_n N_noxref_13_c_3341_n ) capacitor c=2.01623e-19 \
 //x=22.94 //y=2.195 //x2=23.68 //y2=0
cc_1537 ( N_noxref_6_c_2054_n N_noxref_13_c_3341_n ) capacitor c=0.00239899f \
 //x=22.94 //y=2.08 //x2=23.68 //y2=0
cc_1538 ( N_noxref_6_c_2197_p N_noxref_13_c_3341_n ) capacitor c=0.00275764f \
 //x=23.46 //y=1.26 //x2=23.68 //y2=0
cc_1539 ( N_noxref_6_c_2080_n N_noxref_13_c_3341_n ) capacitor c=2.63786e-19 \
 //x=22.94 //y=2.08 //x2=23.68 //y2=0
cc_1540 ( N_noxref_6_c_1747_n N_noxref_13_c_3203_n ) capacitor c=0.00276642f \
 //x=11.63 //y=3.7 //x2=8.14 //y2=0
cc_1541 ( N_noxref_6_c_1892_n N_noxref_13_c_3203_n ) capacitor c=0.00239899f \
 //x=6.66 //y=2.08 //x2=8.14 //y2=0
cc_1542 ( N_noxref_6_c_1996_n N_noxref_13_c_3203_n ) capacitor c=0.00262688f \
 //x=7.18 //y=1.26 //x2=8.14 //y2=0
cc_1543 ( N_noxref_6_c_1909_n N_noxref_13_c_3203_n ) capacitor c=2.63786e-19 \
 //x=6.66 //y=2.08 //x2=8.14 //y2=0
cc_1544 ( N_noxref_6_c_1771_n N_noxref_13_c_3247_n ) capacitor c=9.32616e-19 \
 //x=15.54 //y=3.525 //x2=12.95 //y2=0
cc_1545 ( N_noxref_6_c_1787_n N_noxref_13_c_3247_n ) capacitor c=0.00276642f \
 //x=15.375 //y=3.685 //x2=12.95 //y2=0
cc_1546 ( N_noxref_6_c_1794_n N_noxref_13_c_3247_n ) capacitor c=0.00222376f \
 //x=11.47 //y=2.08 //x2=12.95 //y2=0
cc_1547 ( N_noxref_6_c_1824_n N_noxref_13_c_3247_n ) capacitor c=0.00262688f \
 //x=11.99 //y=1.26 //x2=12.95 //y2=0
cc_1548 ( N_noxref_6_c_1828_n N_noxref_13_c_3247_n ) capacitor c=2.63786e-19 \
 //x=11.47 //y=2.08 //x2=12.95 //y2=0
cc_1549 ( N_noxref_6_c_1769_n N_noxref_13_c_3260_n ) capacitor c=0.002973f \
 //x=15.1 //y=1.57 //x2=16.28 //y2=0
cc_1550 ( N_noxref_6_c_1857_n N_noxref_13_c_3260_n ) capacitor c=0.0292585f \
 //x=15.455 //y=1.655 //x2=16.28 //y2=0
cc_1551 ( N_noxref_6_c_1967_n N_noxref_13_c_3260_n ) capacitor c=0.00307714f \
 //x=22.78 //y=3.705 //x2=16.28 //y2=0
cc_1552 ( N_noxref_6_c_1967_n N_noxref_13_c_3326_n ) capacitor c=0.00307714f \
 //x=22.78 //y=3.705 //x2=19.61 //y2=0
cc_1553 ( N_noxref_6_c_1785_n N_noxref_13_M8_noxref_d ) capacitor \
 c=2.82748e-19 //x=15.1 //y=1 //x2=13.94 //y2=0.865
cc_1554 ( N_noxref_6_c_1967_n N_noxref_14_c_3614_n ) capacitor c=9.00668e-19 \
 //x=22.78 //y=3.705 //x2=20.72 //y2=2.195
cc_1555 ( N_noxref_6_c_2027_n N_noxref_14_c_3619_n ) capacitor c=0.00181347f \
 //x=22.94 //y=3.545 //x2=20.72 //y2=4.575
cc_1556 ( N_noxref_6_c_2031_n N_noxref_14_c_3619_n ) capacitor c=0.0011266f \
 //x=22.94 //y=4.57 //x2=20.72 //y2=4.575
cc_1557 ( N_noxref_6_c_1967_n N_noxref_14_c_3619_n ) capacitor c=0.0376819f \
 //x=22.78 //y=3.705 //x2=20.72 //y2=4.575
cc_1558 ( N_noxref_6_c_2023_n N_noxref_15_c_3730_n ) capacitor c=0.00177186f \
 //x=22.94 //y=2.195 //x2=23.595 //y2=0.54
cc_1559 ( N_noxref_6_c_2054_n N_noxref_15_c_3730_n ) capacitor c=0.00117306f \
 //x=22.94 //y=2.08 //x2=23.595 //y2=0.54
cc_1560 ( N_noxref_6_c_2069_n N_noxref_15_c_3730_n ) capacitor c=0.0206349f \
 //x=22.93 //y=0.915 //x2=23.595 //y2=0.54
cc_1561 ( N_noxref_6_c_2220_p N_noxref_15_c_3730_n ) capacitor c=0.00825432f \
 //x=23.46 //y=0.915 //x2=23.595 //y2=0.54
cc_1562 ( N_noxref_6_c_2080_n N_noxref_15_c_3730_n ) capacitor c=2.20712e-19 \
 //x=22.94 //y=2.08 //x2=23.595 //y2=0.54
cc_1563 ( N_noxref_6_c_2070_n N_noxref_15_c_3735_n ) capacitor c=0.0071177f \
 //x=22.93 //y=1.26 //x2=22.71 //y2=0.995
cc_1564 ( N_noxref_6_c_2030_n N_noxref_15_M14_noxref_s ) capacitor \
 c=9.72448e-19 //x=22.94 //y=3.865 //x2=22.575 //y2=0.375
cc_1565 ( N_noxref_6_c_1967_n N_noxref_15_M14_noxref_s ) capacitor \
 c=6.25077e-19 //x=22.78 //y=3.705 //x2=22.575 //y2=0.375
cc_1566 ( N_noxref_6_c_2069_n N_noxref_15_M14_noxref_s ) capacitor \
 c=0.0071177f //x=22.93 //y=0.915 //x2=22.575 //y2=0.375
cc_1567 ( N_noxref_6_c_2071_n N_noxref_15_M14_noxref_s ) capacitor \
 c=0.0071177f //x=22.93 //y=1.57 //x2=22.575 //y2=0.375
cc_1568 ( N_noxref_6_c_2220_p N_noxref_15_M14_noxref_s ) capacitor c=0.015333f \
 //x=23.46 //y=0.915 //x2=22.575 //y2=0.375
cc_1569 ( N_noxref_6_c_2197_p N_noxref_15_M14_noxref_s ) capacitor \
 c=0.00248746f //x=23.46 //y=1.26 //x2=22.575 //y2=0.375
cc_1570 ( N_noxref_6_c_2030_n N_noxref_16_c_3781_n ) capacitor c=0.00193736f \
 //x=22.94 //y=3.865 //x2=22.785 //y2=5.155
cc_1571 ( N_noxref_6_c_2043_n N_noxref_16_c_3781_n ) capacitor c=6.00078e-19 \
 //x=22.94 //y=3.705 //x2=22.785 //y2=5.155
cc_1572 ( N_noxref_6_c_1967_n N_noxref_16_c_3781_n ) capacitor c=0.00198232f \
 //x=22.78 //y=3.705 //x2=22.785 //y2=5.155
cc_1573 ( N_noxref_6_M43_noxref_g N_noxref_16_c_3781_n ) capacitor \
 c=0.0102805f //x=22.68 //y=6.02 //x2=22.785 //y2=5.155
cc_1574 ( N_noxref_6_M43_noxref_g N_noxref_16_c_3797_n ) capacitor \
 c=0.00226521f //x=22.68 //y=6.02 //x2=22.9 //y2=5.38
cc_1575 ( N_noxref_6_M44_noxref_g N_noxref_16_c_3797_n ) capacitor \
 c=0.00427254f //x=23.12 //y=6.02 //x2=22.9 //y2=5.38
cc_1576 ( N_noxref_6_c_2030_n N_noxref_16_c_3799_n ) capacitor c=5.37284e-19 \
 //x=22.94 //y=3.865 //x2=23.595 //y2=5.155
cc_1577 ( N_noxref_6_c_2031_n N_noxref_16_c_3799_n ) capacitor c=0.00237494f \
 //x=22.94 //y=4.57 //x2=23.595 //y2=5.155
cc_1578 ( N_noxref_6_c_2043_n N_noxref_16_c_3799_n ) capacitor c=9.55715e-19 \
 //x=22.94 //y=3.705 //x2=23.595 //y2=5.155
cc_1579 ( N_noxref_6_c_2057_n N_noxref_16_c_3799_n ) capacitor c=0.00130631f \
 //x=22.94 //y=4.7 //x2=23.595 //y2=5.155
cc_1580 ( N_noxref_6_M44_noxref_g N_noxref_16_c_3799_n ) capacitor c=0.011539f \
 //x=23.12 //y=6.02 //x2=23.595 //y2=5.155
cc_1581 ( N_noxref_6_c_2069_n N_noxref_16_c_3804_n ) capacitor c=4.64015e-19 \
 //x=22.93 //y=0.915 //x2=23.195 //y2=1.125
cc_1582 ( N_noxref_6_c_2070_n N_noxref_16_c_3804_n ) capacitor c=0.0026012f \
 //x=22.93 //y=1.26 //x2=23.195 //y2=1.125
cc_1583 ( N_noxref_6_c_2242_p N_noxref_16_c_3804_n ) capacitor c=5.29969e-19 \
 //x=23.305 //y=0.76 //x2=23.195 //y2=1.125
cc_1584 ( N_noxref_6_c_2243_p N_noxref_16_c_3804_n ) capacitor c=5.31989e-19 \
 //x=23.305 //y=1.415 //x2=23.195 //y2=1.125
cc_1585 ( N_noxref_6_c_2220_p N_noxref_16_c_3804_n ) capacitor c=5.7502e-19 \
 //x=23.46 //y=0.915 //x2=23.195 //y2=1.125
cc_1586 ( N_noxref_6_c_2197_p N_noxref_16_c_3804_n ) capacitor c=0.00357756f \
 //x=23.46 //y=1.26 //x2=23.195 //y2=1.125
cc_1587 ( N_noxref_6_c_2070_n N_noxref_16_c_3810_n ) capacitor c=0.00127432f \
 //x=22.93 //y=1.26 //x2=23.195 //y2=1.58
cc_1588 ( N_noxref_6_c_2071_n N_noxref_16_c_3810_n ) capacitor c=0.00429966f \
 //x=22.93 //y=1.57 //x2=23.195 //y2=1.58
cc_1589 ( N_noxref_6_c_2243_p N_noxref_16_c_3810_n ) capacitor c=0.00942306f \
 //x=23.305 //y=1.415 //x2=23.195 //y2=1.58
cc_1590 ( N_noxref_6_c_2197_p N_noxref_16_c_3810_n ) capacitor c=0.00363411f \
 //x=23.46 //y=1.26 //x2=23.195 //y2=1.58
cc_1591 ( N_noxref_6_c_2083_n N_noxref_16_c_3810_n ) capacitor c=0.00362297f \
 //x=22.94 //y=1.915 //x2=23.195 //y2=1.58
cc_1592 ( N_noxref_6_c_2243_p N_noxref_16_c_3815_n ) capacitor c=0.00194716f \
 //x=23.305 //y=1.415 //x2=23.595 //y2=1.665
cc_1593 ( N_noxref_6_c_2197_p N_noxref_16_c_3815_n ) capacitor c=0.00323576f \
 //x=23.46 //y=1.26 //x2=23.595 //y2=1.665
cc_1594 ( N_noxref_6_c_2023_n N_noxref_16_c_3782_n ) capacitor c=0.0147425f \
 //x=22.94 //y=2.195 //x2=23.68 //y2=5.07
cc_1595 ( N_noxref_6_c_2027_n N_noxref_16_c_3782_n ) capacitor c=0.0637023f \
 //x=22.94 //y=3.545 //x2=23.68 //y2=5.07
cc_1596 ( N_noxref_6_c_2030_n N_noxref_16_c_3782_n ) capacitor c=0.0149195f \
 //x=22.94 //y=3.865 //x2=23.68 //y2=5.07
cc_1597 ( N_noxref_6_c_2031_n N_noxref_16_c_3782_n ) capacitor c=0.0484264f \
 //x=22.94 //y=4.57 //x2=23.68 //y2=5.07
cc_1598 ( N_noxref_6_c_2036_n N_noxref_16_c_3782_n ) capacitor c=0.00548505f \
 //x=22.94 //y=3.7 //x2=23.68 //y2=5.07
cc_1599 ( N_noxref_6_c_2043_n N_noxref_16_c_3782_n ) capacitor c=0.00686827f \
 //x=22.94 //y=3.705 //x2=23.68 //y2=5.07
cc_1600 ( N_noxref_6_c_2054_n N_noxref_16_c_3782_n ) capacitor c=0.00448538f \
 //x=22.94 //y=2.08 //x2=23.68 //y2=5.07
cc_1601 ( N_noxref_6_c_2057_n N_noxref_16_c_3782_n ) capacitor c=0.00442006f \
 //x=22.94 //y=4.7 //x2=23.68 //y2=5.07
cc_1602 ( N_noxref_6_c_2080_n N_noxref_16_c_3782_n ) capacitor c=0.00246559f \
 //x=22.94 //y=2.08 //x2=23.68 //y2=5.07
cc_1603 ( N_noxref_6_c_2084_n N_noxref_16_c_3782_n ) capacitor c=0.0035458f \
 //x=22.94 //y=4.7 //x2=23.68 //y2=5.07
cc_1604 ( N_noxref_6_c_1967_n N_noxref_16_c_3827_n ) capacitor c=0.0188164f \
 //x=22.78 //y=3.705 //x2=21.142 //y2=5.155
cc_1605 ( N_noxref_6_c_1967_n N_noxref_16_c_3783_n ) capacitor c=0.0218171f \
 //x=22.78 //y=3.705 //x2=22.02 //y2=5.155
cc_1606 ( N_noxref_6_c_2031_n N_noxref_16_c_3829_n ) capacitor c=0.022673f \
 //x=22.94 //y=4.57 //x2=22.9 //y2=5.155
cc_1607 ( N_noxref_6_c_2057_n N_noxref_16_c_3829_n ) capacitor c=0.00346456f \
 //x=22.94 //y=4.7 //x2=22.9 //y2=5.155
cc_1608 ( N_noxref_6_c_2084_n N_noxref_16_c_3829_n ) capacitor c=0.00203307f \
 //x=22.94 //y=4.7 //x2=22.9 //y2=5.155
cc_1609 ( N_noxref_6_c_2031_n N_noxref_16_c_3832_n ) capacitor c=0.00217653f \
 //x=22.94 //y=4.57 //x2=22.9 //y2=5.38
cc_1610 ( N_noxref_6_c_2057_n N_noxref_16_c_3832_n ) capacitor c=0.00624059f \
 //x=22.94 //y=4.7 //x2=22.9 //y2=5.38
cc_1611 ( N_noxref_6_M43_noxref_g N_noxref_16_c_3832_n ) capacitor \
 c=0.0178885f //x=22.68 //y=6.02 //x2=22.9 //y2=5.38
cc_1612 ( N_noxref_6_M44_noxref_g N_noxref_16_c_3832_n ) capacitor \
 c=0.0188608f //x=23.12 //y=6.02 //x2=22.9 //y2=5.38
cc_1613 ( N_noxref_6_c_2084_n N_noxref_16_c_3832_n ) capacitor c=0.00255197f \
 //x=22.94 //y=4.7 //x2=22.9 //y2=5.38
cc_1614 ( N_noxref_6_c_2069_n N_noxref_16_M14_noxref_d ) capacitor \
 c=0.00137165f //x=22.93 //y=0.915 //x2=23.005 //y2=0.915
cc_1615 ( N_noxref_6_c_2070_n N_noxref_16_M14_noxref_d ) capacitor \
 c=0.00237422f //x=22.93 //y=1.26 //x2=23.005 //y2=0.915
cc_1616 ( N_noxref_6_c_2242_p N_noxref_16_M14_noxref_d ) capacitor \
 c=0.0020782f //x=23.305 //y=0.76 //x2=23.005 //y2=0.915
cc_1617 ( N_noxref_6_c_2243_p N_noxref_16_M14_noxref_d ) capacitor \
 c=0.00356097f //x=23.305 //y=1.415 //x2=23.005 //y2=0.915
cc_1618 ( N_noxref_6_c_2220_p N_noxref_16_M14_noxref_d ) capacitor \
 c=0.00139206f //x=23.46 //y=0.915 //x2=23.005 //y2=0.915
cc_1619 ( N_noxref_6_c_2197_p N_noxref_16_M14_noxref_d ) capacitor \
 c=0.00237422f //x=23.46 //y=1.26 //x2=23.005 //y2=0.915
cc_1620 ( N_noxref_6_c_1747_n N_noxref_19_c_4029_n ) capacitor c=0.00281558f \
 //x=11.63 //y=3.7 //x2=9.615 //y2=1.59
cc_1621 ( N_noxref_6_c_1747_n N_noxref_19_c_4043_n ) capacitor c=0.00475991f \
 //x=11.63 //y=3.7 //x2=10.585 //y2=1.59
cc_1622 ( N_noxref_6_c_1747_n N_noxref_19_M5_noxref_s ) capacitor \
 c=0.00212526f //x=11.63 //y=3.7 //x2=8.595 //y2=0.375
cc_1623 ( N_noxref_6_c_1770_n N_noxref_20_c_4095_n ) capacitor c=0.00911405f \
 //x=15.185 //y=1.655 //x2=14.615 //y2=1.495
cc_1624 ( N_noxref_6_c_1857_n N_noxref_20_c_4102_n ) capacitor c=0.00399245f \
 //x=15.455 //y=1.655 //x2=15.5 //y2=0.53
cc_1625 ( N_noxref_6_c_1785_n N_noxref_20_c_4102_n ) capacitor c=0.003751f \
 //x=15.1 //y=1 //x2=15.5 //y2=0.53
cc_1626 ( N_noxref_6_M9_noxref_d N_noxref_20_c_4102_n ) capacitor \
 c=0.00910163f //x=14.91 //y=0.905 //x2=15.5 //y2=0.53
cc_1627 ( N_noxref_6_c_1769_n N_noxref_20_M8_noxref_s ) capacitor c=0.01625f \
 //x=15.1 //y=1.57 //x2=13.51 //y2=0.365
cc_1628 ( N_noxref_6_c_1857_n N_noxref_20_M8_noxref_s ) capacitor \
 c=0.00670006f //x=15.455 //y=1.655 //x2=13.51 //y2=0.365
cc_1629 ( N_noxref_6_c_1864_n N_noxref_20_M8_noxref_s ) capacitor \
 c=3.24398e-19 //x=15.54 //y=3.845 //x2=13.51 //y2=0.365
cc_1630 ( N_noxref_6_c_1785_n N_noxref_20_M8_noxref_s ) capacitor \
 c=0.00905337f //x=15.1 //y=1 //x2=13.51 //y2=0.365
cc_1631 ( N_noxref_6_c_1884_n N_noxref_20_M8_noxref_s ) capacitor \
 c=8.42257e-19 //x=15.54 //y=3.7 //x2=13.51 //y2=0.365
cc_1632 ( N_noxref_6_M9_noxref_d N_noxref_20_M8_noxref_s ) capacitor \
 c=0.0275552f //x=14.91 //y=0.905 //x2=13.51 //y2=0.365
cc_1633 ( N_noxref_6_c_1967_n N_noxref_22_c_4224_n ) capacitor c=0.00163772f \
 //x=22.78 //y=3.705 //x2=22.055 //y2=1.59
cc_1634 ( N_noxref_6_c_1967_n N_noxref_22_M12_noxref_s ) capacitor \
 c=0.0020282f //x=22.78 //y=3.705 //x2=20.065 //y2=0.375
cc_1635 ( N_noxref_7_c_2294_n N_noxref_8_c_2676_n ) capacitor c=9.05427e-19 \
 //x=23.68 //y=7.4 //x2=1.11 //y2=4.7
cc_1636 ( N_noxref_7_c_2301_n N_noxref_8_c_2676_n ) capacitor c=6.28732e-19 \
 //x=1.585 //y=7.4 //x2=1.11 //y2=4.7
cc_1637 ( N_noxref_7_c_2313_n N_noxref_8_c_2676_n ) capacitor c=0.00867681f \
 //x=0.74 //y=7.4 //x2=1.11 //y2=4.7
cc_1638 ( N_noxref_7_c_2313_n N_noxref_8_c_2678_n ) capacitor c=0.00998287f \
 //x=0.74 //y=7.4 //x2=1.112 //y2=4.56
cc_1639 ( N_noxref_7_c_2294_n N_noxref_8_c_2680_n ) capacitor c=6.23118e-19 \
 //x=23.68 //y=7.4 //x2=1.11 //y2=4.7
cc_1640 ( N_noxref_7_c_2313_n N_noxref_8_c_2680_n ) capacitor c=0.00370735f \
 //x=0.74 //y=7.4 //x2=1.11 //y2=4.7
cc_1641 ( N_noxref_7_c_2301_n N_noxref_8_M15_noxref_g ) capacitor c=0.0072715f \
 //x=1.585 //y=7.4 //x2=1.01 //y2=6.02
cc_1642 ( N_noxref_7_M15_noxref_s N_noxref_8_M15_noxref_g ) capacitor \
 c=0.0567929f //x=0.655 //y=5.02 //x2=1.01 //y2=6.02
cc_1643 ( N_noxref_7_c_2301_n N_noxref_8_M16_noxref_g ) capacitor \
 c=0.00749619f //x=1.585 //y=7.4 //x2=1.45 //y2=6.02
cc_1644 ( N_noxref_7_M16_noxref_d N_noxref_8_M16_noxref_g ) capacitor \
 c=0.015318f //x=1.525 //y=5.02 //x2=1.45 //y2=6.02
cc_1645 ( N_noxref_7_c_2313_n N_noxref_8_c_2687_n ) capacitor c=0.0234764f \
 //x=0.74 //y=7.4 //x2=1.11 //y2=4.7
cc_1646 ( N_noxref_7_c_2475_n N_noxref_11_c_2931_n ) capacitor c=0.00226427f \
 //x=19.61 //y=7.4 //x2=18.16 //y2=4.7
cc_1647 ( N_noxref_7_c_2577_p N_noxref_11_M37_noxref_g ) capacitor \
 c=0.00692597f //x=18.745 //y=7.4 //x2=18.17 //y2=6.02
cc_1648 ( N_noxref_7_M36_noxref_d N_noxref_11_M37_noxref_g ) capacitor \
 c=0.015318f //x=17.805 //y=5.02 //x2=18.17 //y2=6.02
cc_1649 ( N_noxref_7_c_2577_p N_noxref_11_M38_noxref_g ) capacitor \
 c=0.00749619f //x=18.745 //y=7.4 //x2=18.61 //y2=6.02
cc_1650 ( N_noxref_7_M38_noxref_d N_noxref_11_M38_noxref_g ) capacitor \
 c=0.0430452f //x=18.685 //y=5.02 //x2=18.61 //y2=6.02
cc_1651 ( N_noxref_7_c_2475_n N_noxref_11_c_2964_n ) capacitor c=0.0131895f \
 //x=19.61 //y=7.4 //x2=18.535 //y2=4.79
cc_1652 ( N_noxref_7_c_2475_n N_noxref_11_c_2950_n ) capacitor c=2.73429e-19 \
 //x=19.61 //y=7.4 //x2=18.16 //y2=4.7
cc_1653 ( N_noxref_7_M36_noxref_d N_noxref_11_c_2950_n ) capacitor \
 c=3.32274e-19 //x=17.805 //y=5.02 //x2=18.16 //y2=4.7
cc_1654 ( N_noxref_7_c_2294_n N_noxref_12_c_3020_n ) capacitor c=0.00647565f \
 //x=23.68 //y=7.4 //x2=18.275 //y2=5.2
cc_1655 ( N_noxref_7_c_2450_n N_noxref_12_c_3020_n ) capacitor c=0.00208112f \
 //x=17.865 //y=7.4 //x2=18.275 //y2=5.2
cc_1656 ( N_noxref_7_c_2577_p N_noxref_12_c_3020_n ) capacitor c=0.00180744f \
 //x=18.745 //y=7.4 //x2=18.275 //y2=5.2
cc_1657 ( N_noxref_7_M36_noxref_d N_noxref_12_c_3020_n ) capacitor \
 c=0.00734028f //x=17.805 //y=5.02 //x2=18.275 //y2=5.2
cc_1658 ( N_noxref_7_c_2294_n N_noxref_12_c_3054_n ) capacitor c=0.0048744f \
 //x=23.68 //y=7.4 //x2=18.785 //y2=5.2
cc_1659 ( N_noxref_7_c_2577_p N_noxref_12_c_3054_n ) capacitor c=0.00208112f \
 //x=18.745 //y=7.4 //x2=18.785 //y2=5.2
cc_1660 ( N_noxref_7_M38_noxref_d N_noxref_12_c_3054_n ) capacitor c=0.010542f \
 //x=18.685 //y=5.02 //x2=18.785 //y2=5.2
cc_1661 ( N_noxref_7_M39_noxref_s N_noxref_12_c_3054_n ) capacitor \
 c=0.00273481f //x=20.565 //y=5.02 //x2=18.785 //y2=5.2
cc_1662 ( N_noxref_7_c_2411_n N_noxref_12_c_3021_n ) capacitor c=4.41765e-19 \
 //x=16.28 //y=7.4 //x2=18.87 //y2=5.115
cc_1663 ( N_noxref_7_c_2475_n N_noxref_12_c_3021_n ) capacitor c=0.0323312f \
 //x=19.61 //y=7.4 //x2=18.87 //y2=5.115
cc_1664 ( N_noxref_7_c_2294_n N_noxref_12_c_3023_n ) capacitor c=0.00368144f \
 //x=23.68 //y=7.4 //x2=17.51 //y2=5.38
cc_1665 ( N_noxref_7_c_2450_n N_noxref_12_c_3023_n ) capacitor c=9.41091e-19 \
 //x=17.865 //y=7.4 //x2=17.51 //y2=5.38
cc_1666 ( N_noxref_7_c_2411_n N_noxref_12_c_3023_n ) capacitor c=4.91377e-19 \
 //x=16.28 //y=7.4 //x2=17.51 //y2=5.38
cc_1667 ( N_noxref_7_M35_noxref_s N_noxref_12_c_3023_n ) capacitor \
 c=0.0572211f //x=16.935 //y=5.02 //x2=17.51 //y2=5.38
cc_1668 ( N_noxref_7_M36_noxref_d N_noxref_12_c_3023_n ) capacitor \
 c=0.0043528f //x=17.805 //y=5.02 //x2=17.51 //y2=5.38
cc_1669 ( N_noxref_7_c_2294_n N_noxref_12_c_3048_n ) capacitor c=8.41206e-19 \
 //x=23.68 //y=7.4 //x2=18.39 //y2=5.2
cc_1670 ( N_noxref_7_c_2577_p N_noxref_12_c_3048_n ) capacitor c=4.23323e-19 \
 //x=18.745 //y=7.4 //x2=18.39 //y2=5.2
cc_1671 ( N_noxref_7_c_2475_n N_noxref_12_c_3048_n ) capacitor c=0.0025639f \
 //x=19.61 //y=7.4 //x2=18.39 //y2=5.2
cc_1672 ( N_noxref_7_M35_noxref_s N_noxref_12_c_3048_n ) capacitor \
 c=6.52457e-19 //x=16.935 //y=5.02 //x2=18.39 //y2=5.2
cc_1673 ( N_noxref_7_M39_noxref_s N_noxref_12_c_3048_n ) capacitor \
 c=0.00371125f //x=20.565 //y=5.02 //x2=18.39 //y2=5.2
cc_1674 ( N_noxref_7_c_2294_n N_noxref_12_c_3070_n ) capacitor c=0.00285294f \
 //x=23.68 //y=7.4 //x2=18.39 //y2=5.38
cc_1675 ( N_noxref_7_c_2577_p N_noxref_12_c_3070_n ) capacitor c=5.78261e-19 \
 //x=18.745 //y=7.4 //x2=18.39 //y2=5.38
cc_1676 ( N_noxref_7_c_2475_n N_noxref_12_c_3070_n ) capacitor c=4.19141e-19 \
 //x=19.61 //y=7.4 //x2=18.39 //y2=5.38
cc_1677 ( N_noxref_7_M36_noxref_d N_noxref_12_c_3070_n ) capacitor \
 c=0.0043528f //x=17.805 //y=5.02 //x2=18.39 //y2=5.38
cc_1678 ( N_noxref_7_M38_noxref_d N_noxref_12_c_3070_n ) capacitor \
 c=0.00955781f //x=18.685 //y=5.02 //x2=18.39 //y2=5.38
cc_1679 ( N_noxref_7_M39_noxref_s N_noxref_12_c_3070_n ) capacitor \
 c=9.52042e-19 //x=20.565 //y=5.02 //x2=18.39 //y2=5.38
cc_1680 ( N_noxref_7_c_2294_n N_noxref_12_c_3030_n ) capacitor c=0.00224727f \
 //x=23.68 //y=7.4 //x2=17.51 //y2=5.38
cc_1681 ( N_noxref_7_c_2450_n N_noxref_12_c_3030_n ) capacitor c=0.0136475f \
 //x=17.865 //y=7.4 //x2=17.51 //y2=5.38
cc_1682 ( N_noxref_7_c_2411_n N_noxref_12_c_3030_n ) capacitor c=0.0064135f \
 //x=16.28 //y=7.4 //x2=17.51 //y2=5.38
cc_1683 ( N_noxref_7_M35_noxref_s N_noxref_12_c_3030_n ) capacitor \
 c=0.0887533f //x=16.935 //y=5.02 //x2=17.51 //y2=5.38
cc_1684 ( N_noxref_7_M36_noxref_d N_noxref_12_c_3030_n ) capacitor c=0.065554f \
 //x=17.805 //y=5.02 //x2=17.51 //y2=5.38
cc_1685 ( N_noxref_7_c_2294_n N_noxref_12_c_3081_n ) capacitor c=0.00224727f \
 //x=23.68 //y=7.4 //x2=18.39 //y2=5.38
cc_1686 ( N_noxref_7_c_2577_p N_noxref_12_c_3081_n ) capacitor c=0.0136475f \
 //x=18.745 //y=7.4 //x2=18.39 //y2=5.38
cc_1687 ( N_noxref_7_c_2475_n N_noxref_12_c_3081_n ) capacitor c=0.0101861f \
 //x=19.61 //y=7.4 //x2=18.39 //y2=5.38
cc_1688 ( N_noxref_7_M36_noxref_d N_noxref_12_c_3081_n ) capacitor c=0.065554f \
 //x=17.805 //y=5.02 //x2=18.39 //y2=5.38
cc_1689 ( N_noxref_7_M38_noxref_d N_noxref_12_c_3081_n ) capacitor c=0.065554f \
 //x=18.685 //y=5.02 //x2=18.39 //y2=5.38
cc_1690 ( N_noxref_7_M39_noxref_s N_noxref_13_c_3323_n ) capacitor \
 c=5.72362e-19 //x=20.565 //y=5.02 //x2=20.685 //y2=0.965
cc_1691 ( N_noxref_7_c_2313_n N_noxref_13_c_3187_n ) capacitor c=0.00989031f \
 //x=0.74 //y=7.4 //x2=0.74 //y2=0
cc_1692 ( N_noxref_7_c_2529_n N_noxref_13_c_3341_n ) capacitor c=0.00989031f \
 //x=23.68 //y=7.4 //x2=23.68 //y2=0
cc_1693 ( N_noxref_7_c_2316_n N_noxref_13_c_3191_n ) capacitor c=0.00680476f \
 //x=3.33 //y=7.4 //x2=3.33 //y2=0
cc_1694 ( N_noxref_7_c_2324_n N_noxref_13_c_3203_n ) capacitor c=0.00663522f \
 //x=8.14 //y=7.4 //x2=8.14 //y2=0
cc_1695 ( N_noxref_7_c_2382_n N_noxref_13_c_3247_n ) capacitor c=0.00663522f \
 //x=12.95 //y=7.4 //x2=12.95 //y2=0
cc_1696 ( N_noxref_7_c_2411_n N_noxref_13_c_3260_n ) capacitor c=0.00663522f \
 //x=16.28 //y=7.4 //x2=16.28 //y2=0
cc_1697 ( N_noxref_7_c_2475_n N_noxref_13_c_3326_n ) capacitor c=0.00912921f \
 //x=19.61 //y=7.4 //x2=19.61 //y2=0
cc_1698 ( N_noxref_7_c_2475_n N_noxref_14_c_3619_n ) capacitor c=0.0143075f \
 //x=19.61 //y=7.4 //x2=20.72 //y2=4.575
cc_1699 ( N_noxref_7_M39_noxref_s N_noxref_14_c_3619_n ) capacitor \
 c=0.0227567f //x=20.565 //y=5.02 //x2=20.72 //y2=4.575
cc_1700 ( N_noxref_7_c_2475_n N_noxref_14_c_3629_n ) capacitor c=0.00370784f \
 //x=19.61 //y=7.4 //x2=20.72 //y2=4.7
cc_1701 ( N_noxref_7_M39_noxref_s N_noxref_14_c_3629_n ) capacitor \
 c=0.00911304f //x=20.565 //y=5.02 //x2=20.72 //y2=4.7
cc_1702 ( N_noxref_7_c_2632_p N_noxref_14_M39_noxref_g ) capacitor \
 c=0.00749687f //x=21.495 //y=7.4 //x2=20.92 //y2=6.02
cc_1703 ( N_noxref_7_M39_noxref_s N_noxref_14_M39_noxref_g ) capacitor \
 c=0.053419f //x=20.565 //y=5.02 //x2=20.92 //y2=6.02
cc_1704 ( N_noxref_7_c_2632_p N_noxref_14_M40_noxref_g ) capacitor \
 c=0.00749619f //x=21.495 //y=7.4 //x2=21.36 //y2=6.02
cc_1705 ( N_noxref_7_M40_noxref_d N_noxref_14_M40_noxref_g ) capacitor \
 c=0.015318f //x=21.435 //y=5.02 //x2=21.36 //y2=6.02
cc_1706 ( N_noxref_7_c_2475_n N_noxref_14_c_3649_n ) capacitor c=0.00590568f \
 //x=19.61 //y=7.4 //x2=20.995 //y2=4.79
cc_1707 ( N_noxref_7_M39_noxref_s N_noxref_14_c_3649_n ) capacitor \
 c=0.00611794f //x=20.565 //y=5.02 //x2=20.995 //y2=4.79
cc_1708 ( N_noxref_7_c_2294_n N_noxref_16_c_3776_n ) capacitor c=0.00620651f \
 //x=23.68 //y=7.4 //x2=21.9 //y2=5.155
cc_1709 ( N_noxref_7_c_2632_p N_noxref_16_c_3776_n ) capacitor c=0.00202948f \
 //x=21.495 //y=7.4 //x2=21.9 //y2=5.155
cc_1710 ( N_noxref_7_c_2501_n N_noxref_16_c_3776_n ) capacitor c=0.00177088f \
 //x=22.375 //y=7.4 //x2=21.9 //y2=5.155
cc_1711 ( N_noxref_7_M40_noxref_d N_noxref_16_c_3776_n ) capacitor \
 c=0.00700078f //x=21.435 //y=5.02 //x2=21.9 //y2=5.155
cc_1712 ( N_noxref_7_c_2294_n N_noxref_16_c_3781_n ) capacitor c=0.00626467f \
 //x=23.68 //y=7.4 //x2=22.785 //y2=5.155
cc_1713 ( N_noxref_7_c_2501_n N_noxref_16_c_3781_n ) capacitor c=0.00202948f \
 //x=22.375 //y=7.4 //x2=22.785 //y2=5.155
cc_1714 ( N_noxref_7_c_2527_n N_noxref_16_c_3781_n ) capacitor c=0.00205929f \
 //x=23.255 //y=7.4 //x2=22.785 //y2=5.155
cc_1715 ( N_noxref_7_M42_noxref_d N_noxref_16_c_3781_n ) capacitor \
 c=0.00700078f //x=22.315 //y=5.02 //x2=22.785 //y2=5.155
cc_1716 ( N_noxref_7_c_2294_n N_noxref_16_c_3797_n ) capacitor c=0.00255587f \
 //x=23.68 //y=7.4 //x2=22.9 //y2=5.38
cc_1717 ( N_noxref_7_c_2527_n N_noxref_16_c_3797_n ) capacitor c=8.49349e-19 \
 //x=23.255 //y=7.4 //x2=22.9 //y2=5.38
cc_1718 ( N_noxref_7_c_2529_n N_noxref_16_c_3797_n ) capacitor c=0.00414616f \
 //x=23.68 //y=7.4 //x2=22.9 //y2=5.38
cc_1719 ( N_noxref_7_c_2294_n N_noxref_16_c_3799_n ) capacitor c=0.00822764f \
 //x=23.68 //y=7.4 //x2=23.595 //y2=5.155
cc_1720 ( N_noxref_7_c_2527_n N_noxref_16_c_3799_n ) capacitor c=0.00205506f \
 //x=23.255 //y=7.4 //x2=23.595 //y2=5.155
cc_1721 ( N_noxref_7_c_2529_n N_noxref_16_c_3799_n ) capacitor c=0.00226495f \
 //x=23.68 //y=7.4 //x2=23.595 //y2=5.155
cc_1722 ( N_noxref_7_M44_noxref_d N_noxref_16_c_3799_n ) capacitor \
 c=0.00775668f //x=23.195 //y=5.02 //x2=23.595 //y2=5.155
cc_1723 ( N_noxref_7_c_2529_n N_noxref_16_c_3782_n ) capacitor c=0.0398466f \
 //x=23.68 //y=7.4 //x2=23.68 //y2=5.07
cc_1724 ( N_noxref_7_c_2294_n N_noxref_16_c_3827_n ) capacitor c=0.00261379f \
 //x=23.68 //y=7.4 //x2=21.142 //y2=5.155
cc_1725 ( N_noxref_7_c_2632_p N_noxref_16_c_3827_n ) capacitor c=9.37357e-19 \
 //x=21.495 //y=7.4 //x2=21.142 //y2=5.155
cc_1726 ( N_noxref_7_c_2475_n N_noxref_16_c_3827_n ) capacitor c=0.0022955f \
 //x=19.61 //y=7.4 //x2=21.142 //y2=5.155
cc_1727 ( N_noxref_7_M35_noxref_s N_noxref_16_c_3827_n ) capacitor \
 c=4.22189e-19 //x=16.935 //y=5.02 //x2=21.142 //y2=5.155
cc_1728 ( N_noxref_7_M39_noxref_s N_noxref_16_c_3827_n ) capacitor \
 c=0.0442713f //x=20.565 //y=5.02 //x2=21.142 //y2=5.155
cc_1729 ( N_noxref_7_c_2294_n N_noxref_16_c_3783_n ) capacitor c=0.0026965f \
 //x=23.68 //y=7.4 //x2=22.02 //y2=5.155
cc_1730 ( N_noxref_7_c_2501_n N_noxref_16_c_3783_n ) capacitor c=9.47876e-19 \
 //x=22.375 //y=7.4 //x2=22.02 //y2=5.155
cc_1731 ( N_noxref_7_M39_noxref_s N_noxref_16_c_3783_n ) capacitor \
 c=7.80122e-19 //x=20.565 //y=5.02 //x2=22.02 //y2=5.155
cc_1732 ( N_noxref_7_c_2294_n N_noxref_16_c_3867_n ) capacitor c=0.00242194f \
 //x=23.68 //y=7.4 //x2=21.14 //y2=5.38
cc_1733 ( N_noxref_7_c_2632_p N_noxref_16_c_3867_n ) capacitor c=0.0137846f \
 //x=21.495 //y=7.4 //x2=21.14 //y2=5.38
cc_1734 ( N_noxref_7_c_2475_n N_noxref_16_c_3867_n ) capacitor c=0.00508013f \
 //x=19.61 //y=7.4 //x2=21.14 //y2=5.38
cc_1735 ( N_noxref_7_M39_noxref_s N_noxref_16_c_3867_n ) capacitor \
 c=0.0908457f //x=20.565 //y=5.02 //x2=21.14 //y2=5.38
cc_1736 ( N_noxref_7_M40_noxref_d N_noxref_16_c_3867_n ) capacitor \
 c=0.0673792f //x=21.435 //y=5.02 //x2=21.14 //y2=5.38
cc_1737 ( N_noxref_7_c_2294_n N_noxref_16_c_3789_n ) capacitor c=0.00242194f \
 //x=23.68 //y=7.4 //x2=22.02 //y2=5.38
cc_1738 ( N_noxref_7_c_2501_n N_noxref_16_c_3789_n ) capacitor c=0.0137846f \
 //x=22.375 //y=7.4 //x2=22.02 //y2=5.38
cc_1739 ( N_noxref_7_M40_noxref_d N_noxref_16_c_3789_n ) capacitor \
 c=0.0674762f //x=21.435 //y=5.02 //x2=22.02 //y2=5.38
cc_1740 ( N_noxref_7_M42_noxref_d N_noxref_16_c_3789_n ) capacitor c=0.067493f \
 //x=22.315 //y=5.02 //x2=22.02 //y2=5.38
cc_1741 ( N_noxref_7_c_2294_n N_noxref_16_c_3832_n ) capacitor c=0.00242194f \
 //x=23.68 //y=7.4 //x2=22.9 //y2=5.38
cc_1742 ( N_noxref_7_c_2527_n N_noxref_16_c_3832_n ) capacitor c=0.0134886f \
 //x=23.255 //y=7.4 //x2=22.9 //y2=5.38
cc_1743 ( N_noxref_7_c_2529_n N_noxref_16_c_3832_n ) capacitor c=0.00778106f \
 //x=23.68 //y=7.4 //x2=22.9 //y2=5.38
cc_1744 ( N_noxref_7_M42_noxref_d N_noxref_16_c_3832_n ) capacitor \
 c=0.0675031f //x=22.315 //y=5.02 //x2=22.9 //y2=5.38
cc_1745 ( N_noxref_7_M44_noxref_d N_noxref_16_c_3832_n ) capacitor \
 c=0.0675091f //x=23.195 //y=5.02 //x2=22.9 //y2=5.38
cc_1746 ( N_noxref_8_c_2689_n N_noxref_13_c_3367_n ) capacitor c=6.60635e-19 \
 //x=1.11 //y=2.08 //x2=1.095 //y2=0
cc_1747 ( N_noxref_8_c_2689_n N_noxref_13_c_3159_n ) capacitor c=0.00709452f \
 //x=1.11 //y=2.08 //x2=1.18 //y2=0.955
cc_1748 ( N_noxref_8_c_2702_n N_noxref_13_c_3159_n ) capacitor c=2.13705e-19 \
 //x=1.11 //y=2.08 //x2=1.18 //y2=0.955
cc_1749 ( N_noxref_8_c_2712_n N_noxref_13_c_3159_n ) capacitor c=0.00156094f \
 //x=0.915 //y=0.865 //x2=1.18 //y2=0.955
cc_1750 ( N_noxref_8_c_2713_n N_noxref_13_c_3159_n ) capacitor c=0.00413828f \
 //x=0.915 //y=1.21 //x2=1.18 //y2=0.955
cc_1751 ( N_noxref_8_c_2714_n N_noxref_13_c_3159_n ) capacitor c=4.2764e-19 \
 //x=0.915 //y=1.52 //x2=1.18 //y2=0.955
cc_1752 ( N_noxref_8_c_2745_p N_noxref_13_c_3159_n ) capacitor c=7.35788e-19 \
 //x=1.29 //y=0.71 //x2=1.18 //y2=0.955
cc_1753 ( N_noxref_8_c_2746_p N_noxref_13_c_3159_n ) capacitor c=6.38426e-19 \
 //x=1.29 //y=1.365 //x2=1.18 //y2=0.955
cc_1754 ( N_noxref_8_c_2720_n N_noxref_13_c_3159_n ) capacitor c=0.00171483f \
 //x=1.445 //y=0.865 //x2=1.18 //y2=0.955
cc_1755 ( N_noxref_8_c_2722_n N_noxref_13_c_3159_n ) capacitor c=0.00296337f \
 //x=1.445 //y=1.21 //x2=1.18 //y2=0.955
cc_1756 ( N_noxref_8_c_2712_n N_noxref_13_c_3377_n ) capacitor c=3.51399e-19 \
 //x=0.915 //y=0.865 //x2=1.177 //y2=0.825
cc_1757 ( N_noxref_8_c_2745_p N_noxref_13_c_3377_n ) capacitor c=0.00850809f \
 //x=1.29 //y=0.71 //x2=1.177 //y2=0.825
cc_1758 ( N_noxref_8_c_2720_n N_noxref_13_c_3377_n ) capacitor c=4.40196e-19 \
 //x=1.445 //y=0.865 //x2=1.177 //y2=0.825
cc_1759 ( N_noxref_8_c_2712_n N_noxref_13_c_3185_n ) capacitor c=0.00688065f \
 //x=0.915 //y=0.865 //x2=3.16 //y2=0
cc_1760 ( N_noxref_8_c_2689_n N_noxref_13_c_3187_n ) capacitor c=0.0082376f \
 //x=1.11 //y=2.08 //x2=0.74 //y2=0
cc_1761 ( N_noxref_8_c_2678_n N_noxref_13_c_3187_n ) capacitor c=0.0113215f \
 //x=1.112 //y=4.56 //x2=0.74 //y2=0
cc_1762 ( N_noxref_8_c_2702_n N_noxref_13_c_3187_n ) capacitor c=0.00369668f \
 //x=1.11 //y=2.08 //x2=0.74 //y2=0
cc_1763 ( N_noxref_8_c_2714_n N_noxref_13_c_3187_n ) capacitor c=0.0015404f \
 //x=0.915 //y=1.52 //x2=0.74 //y2=0
cc_1764 ( N_noxref_8_c_2716_n N_noxref_13_c_3187_n ) capacitor c=0.00950704f \
 //x=0.915 //y=1.915 //x2=0.74 //y2=0
cc_1765 ( N_noxref_8_c_2689_n N_noxref_13_M0_noxref_d ) capacitor \
 c=2.20438e-19 //x=1.11 //y=2.08 //x2=0.99 //y2=0.865
cc_1766 ( N_noxref_8_c_2712_n N_noxref_13_M0_noxref_d ) capacitor \
 c=0.00192399f //x=0.915 //y=0.865 //x2=0.99 //y2=0.865
cc_1767 ( N_noxref_8_c_2713_n N_noxref_13_M0_noxref_d ) capacitor \
 c=0.00210798f //x=0.915 //y=1.21 //x2=0.99 //y2=0.865
cc_1768 ( N_noxref_8_c_2745_p N_noxref_13_M0_noxref_d ) capacitor \
 c=0.00472259f //x=1.29 //y=0.71 //x2=0.99 //y2=0.865
cc_1769 ( N_noxref_8_c_2746_p N_noxref_13_M0_noxref_d ) capacitor \
 c=0.00166857f //x=1.29 //y=1.365 //x2=0.99 //y2=0.865
cc_1770 ( N_noxref_8_c_2720_n N_noxref_13_M0_noxref_d ) capacitor \
 c=0.00230174f //x=1.445 //y=0.865 //x2=0.99 //y2=0.865
cc_1771 ( N_noxref_8_c_2722_n N_noxref_13_M0_noxref_d ) capacitor \
 c=0.00210798f //x=1.445 //y=1.21 //x2=0.99 //y2=0.865
cc_1772 ( N_noxref_8_c_2716_n N_noxref_17_c_3929_n ) capacitor c=0.00262672f \
 //x=0.915 //y=1.915 //x2=0.695 //y2=1.495
cc_1773 ( N_noxref_8_c_2689_n N_noxref_17_c_3930_n ) capacitor c=0.00459552f \
 //x=1.11 //y=2.08 //x2=1.58 //y2=1.58
cc_1774 ( N_noxref_8_c_2702_n N_noxref_17_c_3930_n ) capacitor c=0.00763108f \
 //x=1.11 //y=2.08 //x2=1.58 //y2=1.58
cc_1775 ( N_noxref_8_c_2714_n N_noxref_17_c_3930_n ) capacitor c=0.00695869f \
 //x=0.915 //y=1.52 //x2=1.58 //y2=1.58
cc_1776 ( N_noxref_8_c_2716_n N_noxref_17_c_3930_n ) capacitor c=0.0194861f \
 //x=0.915 //y=1.915 //x2=1.58 //y2=1.58
cc_1777 ( N_noxref_8_c_2746_p N_noxref_17_c_3930_n ) capacitor c=0.00723574f \
 //x=1.29 //y=1.365 //x2=1.58 //y2=1.58
cc_1778 ( N_noxref_8_c_2722_n N_noxref_17_c_3930_n ) capacitor c=0.00399755f \
 //x=1.445 //y=1.21 //x2=1.58 //y2=1.58
cc_1779 ( N_noxref_8_c_2716_n N_noxref_17_c_3907_n ) capacitor c=6.71402e-19 \
 //x=0.915 //y=1.915 //x2=1.665 //y2=1.495
cc_1780 ( N_noxref_8_c_2712_n N_noxref_17_M0_noxref_s ) capacitor c=0.0294925f \
 //x=0.915 //y=0.865 //x2=0.56 //y2=0.365
cc_1781 ( N_noxref_8_c_2714_n N_noxref_17_M0_noxref_s ) capacitor \
 c=3.48408e-19 //x=0.915 //y=1.52 //x2=0.56 //y2=0.365
cc_1782 ( N_noxref_8_c_2720_n N_noxref_17_M0_noxref_s ) capacitor c=0.0125442f \
 //x=1.445 //y=0.865 //x2=0.56 //y2=0.365
cc_1783 ( N_noxref_9_c_2776_n N_noxref_13_c_3268_n ) capacitor c=0.00533525f \
 //x=6.345 //y=0.995 //x2=9.13 //y2=0
cc_1784 ( N_noxref_9_c_2818_p N_noxref_13_c_3268_n ) capacitor c=0.00685109f \
 //x=6.43 //y=0.625 //x2=9.13 //y2=0
cc_1785 ( N_noxref_9_c_2777_n N_noxref_13_c_3268_n ) capacitor c=0.00960258f \
 //x=7.315 //y=0.54 //x2=9.13 //y2=0
cc_1786 ( N_noxref_9_c_2820_p N_noxref_13_c_3268_n ) capacitor c=0.00232857f \
 //x=7.4 //y=0.625 //x2=9.13 //y2=0
cc_1787 ( N_noxref_9_M3_noxref_d N_noxref_13_c_3268_n ) capacitor c=0.013411f \
 //x=5.19 //y=0.91 //x2=9.13 //y2=0
cc_1788 ( N_noxref_9_M3_noxref_d N_noxref_13_c_3162_n ) capacitor c=0.0154456f \
 //x=5.19 //y=0.91 //x2=4.405 //y2=0.965
cc_1789 ( N_noxref_9_c_2776_n N_noxref_13_c_3189_n ) capacitor c=0.00807048f \
 //x=6.345 //y=0.995 //x2=7.97 //y2=0
cc_1790 ( N_noxref_9_c_2818_p N_noxref_13_c_3189_n ) capacitor c=0.0140218f \
 //x=6.43 //y=0.625 //x2=7.97 //y2=0
cc_1791 ( N_noxref_9_c_2777_n N_noxref_13_c_3189_n ) capacitor c=0.0364204f \
 //x=7.315 //y=0.54 //x2=7.97 //y2=0
cc_1792 ( N_noxref_9_c_2820_p N_noxref_13_c_3189_n ) capacitor c=0.0138658f \
 //x=7.4 //y=0.625 //x2=7.97 //y2=0
cc_1793 ( N_noxref_9_c_2777_n N_noxref_13_c_3341_n ) capacitor c=0.00189501f \
 //x=7.315 //y=0.54 //x2=23.68 //y2=0
cc_1794 ( N_noxref_9_M3_noxref_d N_noxref_13_c_3341_n ) capacitor c=2.7648e-19 \
 //x=5.19 //y=0.91 //x2=23.68 //y2=0
cc_1795 ( N_noxref_9_M4_noxref_s N_noxref_13_c_3191_n ) capacitor \
 c=8.16352e-19 //x=6.295 //y=0.375 //x2=3.33 //y2=0
cc_1796 ( N_noxref_9_c_2820_p N_noxref_13_c_3203_n ) capacitor c=0.037873f \
 //x=7.4 //y=0.625 //x2=8.14 //y2=0
cc_1797 ( N_noxref_9_M4_noxref_s N_noxref_13_c_3203_n ) capacitor c=0.0051897f \
 //x=6.295 //y=0.375 //x2=8.14 //y2=0
cc_1798 ( N_noxref_9_M3_noxref_d N_noxref_13_M2_noxref_d ) capacitor \
 c=3.12752e-19 //x=5.19 //y=0.91 //x2=4.215 //y2=0.875
cc_1799 ( N_noxref_9_c_2818_p N_noxref_18_c_3994_n ) capacitor c=2.15937e-19 \
 //x=6.43 //y=0.625 //x2=4.89 //y2=0.625
cc_1800 ( N_noxref_9_c_2776_n N_noxref_18_c_3984_n ) capacitor c=0.0131134f \
 //x=6.345 //y=0.995 //x2=5.775 //y2=0.54
cc_1801 ( N_noxref_9_M3_noxref_d N_noxref_18_c_3984_n ) capacitor c=0.0160925f \
 //x=5.19 //y=0.91 //x2=5.775 //y2=0.54
cc_1802 ( N_noxref_9_c_2776_n N_noxref_18_c_3978_n ) capacitor c=0.00947943f \
 //x=6.345 //y=0.995 //x2=5.775 //y2=1.59
cc_1803 ( N_noxref_9_M3_noxref_d N_noxref_18_c_3978_n ) capacitor c=0.0152665f \
 //x=5.19 //y=0.91 //x2=5.775 //y2=1.59
cc_1804 ( N_noxref_9_c_2776_n N_noxref_18_M2_noxref_s ) capacitor c=0.0225712f \
 //x=6.345 //y=0.995 //x2=3.785 //y2=0.375
cc_1805 ( N_noxref_9_c_2818_p N_noxref_18_M2_noxref_s ) capacitor c=0.0175461f \
 //x=6.43 //y=0.625 //x2=3.785 //y2=0.375
cc_1806 ( N_noxref_9_c_2820_p N_noxref_18_M2_noxref_s ) capacitor \
 c=2.98576e-19 //x=7.4 //y=0.625 //x2=3.785 //y2=0.375
cc_1807 ( N_noxref_9_M3_noxref_d N_noxref_18_M2_noxref_s ) capacitor \
 c=0.0187674f //x=5.19 //y=0.91 //x2=3.785 //y2=0.375
cc_1808 ( N_noxref_9_M4_noxref_s N_noxref_18_M2_noxref_s ) capacitor \
 c=0.0210819f //x=6.295 //y=0.375 //x2=3.785 //y2=0.375
cc_1809 ( N_noxref_9_c_2820_p N_noxref_19_M5_noxref_s ) capacitor \
 c=0.00368328f //x=7.4 //y=0.625 //x2=8.595 //y2=0.375
cc_1810 ( N_noxref_9_M4_noxref_s N_noxref_19_M5_noxref_s ) capacitor \
 c=0.00125282f //x=6.295 //y=0.375 //x2=8.595 //y2=0.375
cc_1811 ( N_noxref_10_c_2857_n N_noxref_13_c_3226_n ) capacitor c=0.00533525f \
 //x=11.155 //y=0.995 //x2=14.045 //y2=0
cc_1812 ( N_noxref_10_c_2888_p N_noxref_13_c_3226_n ) capacitor c=0.00338835f \
 //x=11.24 //y=0.625 //x2=14.045 //y2=0
cc_1813 ( N_noxref_10_c_2845_n N_noxref_13_c_3226_n ) capacitor c=0.00960258f \
 //x=12.125 //y=0.54 //x2=14.045 //y2=0
cc_1814 ( N_noxref_10_c_2890_p N_noxref_13_c_3226_n ) capacitor c=0.00232857f \
 //x=12.21 //y=0.625 //x2=14.045 //y2=0
cc_1815 ( N_noxref_10_M6_noxref_d N_noxref_13_c_3226_n ) capacitor \
 c=0.0132336f //x=10 //y=0.91 //x2=14.045 //y2=0
cc_1816 ( N_noxref_10_M6_noxref_d N_noxref_13_c_3174_n ) capacitor \
 c=0.0154456f //x=10 //y=0.91 //x2=9.215 //y2=0.965
cc_1817 ( N_noxref_10_c_2857_n N_noxref_13_c_3190_n ) capacitor c=0.00914678f \
 //x=11.155 //y=0.995 //x2=12.78 //y2=0
cc_1818 ( N_noxref_10_c_2888_p N_noxref_13_c_3190_n ) capacitor c=0.0141422f \
 //x=11.24 //y=0.625 //x2=12.78 //y2=0
cc_1819 ( N_noxref_10_c_2845_n N_noxref_13_c_3190_n ) capacitor c=0.036437f \
 //x=12.125 //y=0.54 //x2=12.78 //y2=0
cc_1820 ( N_noxref_10_c_2890_p N_noxref_13_c_3190_n ) capacitor c=0.0138658f \
 //x=12.21 //y=0.625 //x2=12.78 //y2=0
cc_1821 ( N_noxref_10_c_2845_n N_noxref_13_c_3341_n ) capacitor c=0.00189501f \
 //x=12.125 //y=0.54 //x2=23.68 //y2=0
cc_1822 ( N_noxref_10_M6_noxref_d N_noxref_13_c_3341_n ) capacitor \
 c=2.7648e-19 //x=10 //y=0.91 //x2=23.68 //y2=0
cc_1823 ( N_noxref_10_M7_noxref_s N_noxref_13_c_3203_n ) capacitor \
 c=8.16352e-19 //x=11.105 //y=0.375 //x2=8.14 //y2=0
cc_1824 ( N_noxref_10_c_2890_p N_noxref_13_c_3247_n ) capacitor c=0.0374312f \
 //x=12.21 //y=0.625 //x2=12.95 //y2=0
cc_1825 ( N_noxref_10_M7_noxref_s N_noxref_13_c_3247_n ) capacitor \
 c=0.00519576f //x=11.105 //y=0.375 //x2=12.95 //y2=0
cc_1826 ( N_noxref_10_M6_noxref_d N_noxref_13_M5_noxref_d ) capacitor \
 c=3.12752e-19 //x=10 //y=0.91 //x2=9.025 //y2=0.875
cc_1827 ( N_noxref_10_c_2888_p N_noxref_19_c_4057_n ) capacitor c=2.15937e-19 \
 //x=11.24 //y=0.625 //x2=9.7 //y2=0.625
cc_1828 ( N_noxref_10_c_2857_n N_noxref_19_c_4041_n ) capacitor c=0.0130703f \
 //x=11.155 //y=0.995 //x2=10.585 //y2=0.54
cc_1829 ( N_noxref_10_M6_noxref_d N_noxref_19_c_4041_n ) capacitor \
 c=0.0162022f //x=10 //y=0.91 //x2=10.585 //y2=0.54
cc_1830 ( N_noxref_10_c_2857_n N_noxref_19_c_4043_n ) capacitor c=0.00940787f \
 //x=11.155 //y=0.995 //x2=10.585 //y2=1.59
cc_1831 ( N_noxref_10_M6_noxref_d N_noxref_19_c_4043_n ) capacitor \
 c=0.0151189f //x=10 //y=0.91 //x2=10.585 //y2=1.59
cc_1832 ( N_noxref_10_c_2857_n N_noxref_19_M5_noxref_s ) capacitor \
 c=0.0223986f //x=11.155 //y=0.995 //x2=8.595 //y2=0.375
cc_1833 ( N_noxref_10_c_2888_p N_noxref_19_M5_noxref_s ) capacitor \
 c=0.0175532f //x=11.24 //y=0.625 //x2=8.595 //y2=0.375
cc_1834 ( N_noxref_10_c_2890_p N_noxref_19_M5_noxref_s ) capacitor \
 c=2.98721e-19 //x=12.21 //y=0.625 //x2=8.595 //y2=0.375
cc_1835 ( N_noxref_10_M6_noxref_d N_noxref_19_M5_noxref_s ) capacitor \
 c=0.0187685f //x=10 //y=0.91 //x2=8.595 //y2=0.375
cc_1836 ( N_noxref_10_M7_noxref_s N_noxref_19_M5_noxref_s ) capacitor \
 c=0.021082f //x=11.105 //y=0.375 //x2=8.595 //y2=0.375
cc_1837 ( N_noxref_10_c_2890_p N_noxref_20_M8_noxref_s ) capacitor \
 c=0.00370912f //x=12.21 //y=0.625 //x2=13.51 //y2=0.365
cc_1838 ( N_noxref_10_M7_noxref_s N_noxref_20_M8_noxref_s ) capacitor \
 c=0.00101401f //x=11.105 //y=0.375 //x2=13.51 //y2=0.365
cc_1839 ( N_noxref_11_c_2915_n N_noxref_12_c_3020_n ) capacitor c=0.0226381f \
 //x=18.13 //y=4.555 //x2=18.275 //y2=5.2
cc_1840 ( N_noxref_11_c_2931_n N_noxref_12_c_3020_n ) capacitor c=0.00469257f \
 //x=18.16 //y=4.7 //x2=18.275 //y2=5.2
cc_1841 ( N_noxref_11_M37_noxref_g N_noxref_12_c_3020_n ) capacitor \
 c=0.00842859f //x=18.17 //y=6.02 //x2=18.275 //y2=5.2
cc_1842 ( N_noxref_11_c_2950_n N_noxref_12_c_3020_n ) capacitor c=9.61466e-19 \
 //x=18.16 //y=4.7 //x2=18.275 //y2=5.2
cc_1843 ( N_noxref_11_c_2940_n N_noxref_12_c_3040_n ) capacitor c=0.00119008f \
 //x=18.165 //y=1.25 //x2=18.43 //y2=1.57
cc_1844 ( N_noxref_11_c_2942_n N_noxref_12_c_3040_n ) capacitor c=0.00438634f \
 //x=18.165 //y=1.56 //x2=18.43 //y2=1.57
cc_1845 ( N_noxref_11_c_2973_p N_noxref_12_c_3040_n ) capacitor c=0.00929259f \
 //x=18.54 //y=1.405 //x2=18.43 //y2=1.57
cc_1846 ( N_noxref_11_c_2946_n N_noxref_12_c_3040_n ) capacitor c=0.00341295f \
 //x=18.695 //y=1.25 //x2=18.43 //y2=1.57
cc_1847 ( N_noxref_11_c_2975_p N_noxref_12_c_3040_n ) capacitor c=0.00341114f \
 //x=18.13 //y=1.915 //x2=18.43 //y2=1.57
cc_1848 ( N_noxref_11_M38_noxref_g N_noxref_12_c_3054_n ) capacitor \
 c=0.0112745f //x=18.61 //y=6.02 //x2=18.785 //y2=5.2
cc_1849 ( N_noxref_11_c_2973_p N_noxref_12_c_3096_n ) capacitor c=0.00194324f \
 //x=18.54 //y=1.405 //x2=18.785 //y2=1.655
cc_1850 ( N_noxref_11_c_2946_n N_noxref_12_c_3096_n ) capacitor c=0.00323005f \
 //x=18.695 //y=1.25 //x2=18.785 //y2=1.655
cc_1851 ( N_noxref_11_c_2915_n N_noxref_12_c_3021_n ) capacitor c=0.117846f \
 //x=18.13 //y=4.555 //x2=18.87 //y2=5.115
cc_1852 ( N_noxref_11_c_2924_n N_noxref_12_c_3021_n ) capacitor c=0.0138368f \
 //x=18.13 //y=2.08 //x2=18.87 //y2=5.115
cc_1853 ( N_noxref_11_c_2927_n N_noxref_12_c_3021_n ) capacitor c=9.26054e-19 \
 //x=18.13 //y=2.08 //x2=18.87 //y2=5.115
cc_1854 ( N_noxref_11_c_2931_n N_noxref_12_c_3021_n ) capacitor c=7.76118e-19 \
 //x=18.16 //y=4.7 //x2=18.87 //y2=5.115
cc_1855 ( N_noxref_11_c_2964_n N_noxref_12_c_3021_n ) capacitor c=0.00461871f \
 //x=18.535 //y=4.79 //x2=18.87 //y2=5.115
cc_1856 ( N_noxref_11_c_2947_n N_noxref_12_c_3021_n ) capacitor c=0.00258952f \
 //x=18.13 //y=2.08 //x2=18.87 //y2=5.115
cc_1857 ( N_noxref_11_c_2950_n N_noxref_12_c_3021_n ) capacitor c=0.00142201f \
 //x=18.16 //y=4.7 //x2=18.87 //y2=5.115
cc_1858 ( N_noxref_11_M37_noxref_g N_noxref_12_c_3048_n ) capacitor \
 c=0.00192712f //x=18.17 //y=6.02 //x2=18.39 //y2=5.2
cc_1859 ( N_noxref_11_M38_noxref_g N_noxref_12_c_3048_n ) capacitor \
 c=0.00312463f //x=18.61 //y=6.02 //x2=18.39 //y2=5.2
cc_1860 ( N_noxref_11_c_2964_n N_noxref_12_c_3048_n ) capacitor c=0.0020909f \
 //x=18.535 //y=4.79 //x2=18.39 //y2=5.2
cc_1861 ( N_noxref_11_c_2937_n N_noxref_12_c_3039_n ) capacitor c=0.00120406f \
 //x=18.165 //y=0.905 //x2=18.43 //y2=1
cc_1862 ( N_noxref_11_c_2940_n N_noxref_12_c_3039_n ) capacitor c=0.00218694f \
 //x=18.165 //y=1.25 //x2=18.43 //y2=1
cc_1863 ( N_noxref_11_c_2991_p N_noxref_12_c_3039_n ) capacitor c=5.50523e-19 \
 //x=18.54 //y=0.75 //x2=18.43 //y2=1
cc_1864 ( N_noxref_11_c_2973_p N_noxref_12_c_3039_n ) capacitor c=5.67071e-19 \
 //x=18.54 //y=1.405 //x2=18.43 //y2=1
cc_1865 ( N_noxref_11_c_2945_n N_noxref_12_c_3039_n ) capacitor c=0.00108157f \
 //x=18.695 //y=0.905 //x2=18.43 //y2=1
cc_1866 ( N_noxref_11_c_2946_n N_noxref_12_c_3039_n ) capacitor c=0.00312028f \
 //x=18.695 //y=1.25 //x2=18.43 //y2=1
cc_1867 ( N_noxref_11_M37_noxref_g N_noxref_12_c_3081_n ) capacitor \
 c=0.0178987f //x=18.17 //y=6.02 //x2=18.39 //y2=5.38
cc_1868 ( N_noxref_11_M38_noxref_g N_noxref_12_c_3081_n ) capacitor \
 c=0.0178506f //x=18.61 //y=6.02 //x2=18.39 //y2=5.38
cc_1869 ( N_noxref_11_c_2964_n N_noxref_12_c_3081_n ) capacitor c=0.00291714f \
 //x=18.535 //y=4.79 //x2=18.39 //y2=5.38
cc_1870 ( N_noxref_11_c_2937_n N_noxref_12_M11_noxref_d ) capacitor \
 c=0.00137165f //x=18.165 //y=0.905 //x2=18.24 //y2=0.905
cc_1871 ( N_noxref_11_c_2940_n N_noxref_12_M11_noxref_d ) capacitor \
 c=0.00237422f //x=18.165 //y=1.25 //x2=18.24 //y2=0.905
cc_1872 ( N_noxref_11_c_2991_p N_noxref_12_M11_noxref_d ) capacitor \
 c=0.0020782f //x=18.54 //y=0.75 //x2=18.24 //y2=0.905
cc_1873 ( N_noxref_11_c_2973_p N_noxref_12_M11_noxref_d ) capacitor \
 c=0.00356097f //x=18.54 //y=1.405 //x2=18.24 //y2=0.905
cc_1874 ( N_noxref_11_c_2945_n N_noxref_12_M11_noxref_d ) capacitor \
 c=8.50095e-19 //x=18.695 //y=0.905 //x2=18.24 //y2=0.905
cc_1875 ( N_noxref_11_c_2946_n N_noxref_12_M11_noxref_d ) capacitor \
 c=0.00237422f //x=18.695 //y=1.25 //x2=18.24 //y2=0.905
cc_1876 ( N_noxref_11_c_2924_n N_noxref_13_c_3317_n ) capacitor c=0.00210539f \
 //x=18.13 //y=2.08 //x2=20.6 //y2=0
cc_1877 ( N_noxref_11_c_2924_n N_noxref_13_c_3294_n ) capacitor c=3.77673e-19 \
 //x=18.13 //y=2.08 //x2=19.44 //y2=0
cc_1878 ( N_noxref_11_c_2927_n N_noxref_13_c_3326_n ) capacitor c=0.00207214f \
 //x=18.13 //y=2.08 //x2=19.61 //y2=0
cc_1879 ( N_noxref_11_c_2946_n N_noxref_13_c_3326_n ) capacitor c=0.00275184f \
 //x=18.695 //y=1.25 //x2=19.61 //y2=0
cc_1880 ( N_noxref_11_c_2915_n N_noxref_14_c_3619_n ) capacitor c=0.00433224f \
 //x=18.13 //y=4.555 //x2=20.72 //y2=4.575
cc_1881 ( N_noxref_11_c_2924_n N_noxref_21_c_4162_n ) capacitor c=7.50092e-19 \
 //x=18.13 //y=2.08 //x2=17.945 //y2=1.495
cc_1882 ( N_noxref_11_c_2942_n N_noxref_21_c_4162_n ) capacitor c=0.00890678f \
 //x=18.165 //y=1.56 //x2=17.945 //y2=1.495
cc_1883 ( N_noxref_11_c_2947_n N_noxref_21_c_4162_n ) capacitor c=0.00175171f \
 //x=18.13 //y=2.08 //x2=17.945 //y2=1.495
cc_1884 ( N_noxref_11_c_2924_n N_noxref_21_c_4169_n ) capacitor c=0.001463f \
 //x=18.13 //y=2.08 //x2=18.83 //y2=0.53
cc_1885 ( N_noxref_11_c_2927_n N_noxref_21_c_4169_n ) capacitor c=8.82141e-19 \
 //x=18.13 //y=2.08 //x2=18.83 //y2=0.53
cc_1886 ( N_noxref_11_c_2937_n N_noxref_21_c_4169_n ) capacitor c=0.0200738f \
 //x=18.165 //y=0.905 //x2=18.83 //y2=0.53
cc_1887 ( N_noxref_11_c_2945_n N_noxref_21_c_4169_n ) capacitor c=0.00825432f \
 //x=18.695 //y=0.905 //x2=18.83 //y2=0.53
cc_1888 ( N_noxref_11_c_2947_n N_noxref_21_c_4169_n ) capacitor c=2.1838e-19 \
 //x=18.13 //y=2.08 //x2=18.83 //y2=0.53
cc_1889 ( N_noxref_11_c_2937_n N_noxref_21_M10_noxref_s ) capacitor \
 c=0.00890678f //x=18.165 //y=0.905 //x2=16.84 //y2=0.365
cc_1890 ( N_noxref_11_c_2945_n N_noxref_21_M10_noxref_s ) capacitor \
 c=0.015333f //x=18.695 //y=0.905 //x2=16.84 //y2=0.365
cc_1891 ( N_noxref_11_c_2946_n N_noxref_21_M10_noxref_s ) capacitor \
 c=0.00248746f //x=18.695 //y=1.25 //x2=16.84 //y2=0.365
cc_1892 ( N_noxref_12_c_3096_n N_noxref_13_c_3317_n ) capacitor c=0.00607337f \
 //x=18.785 //y=1.655 //x2=20.6 //y2=0
cc_1893 ( N_noxref_12_c_3039_n N_noxref_13_c_3317_n ) capacitor c=0.00927204f \
 //x=18.43 //y=1 //x2=20.6 //y2=0
cc_1894 ( N_noxref_12_M11_noxref_d N_noxref_13_c_3317_n ) capacitor \
 c=3.01654e-19 //x=18.24 //y=0.905 //x2=20.6 //y2=0
cc_1895 ( N_noxref_12_c_3023_n N_noxref_13_c_3280_n ) capacitor c=6.93965e-19 \
 //x=17.51 //y=5.38 //x2=17.46 //y2=0.955
cc_1896 ( N_noxref_12_c_3039_n N_noxref_13_c_3280_n ) capacitor c=0.0140087f \
 //x=18.43 //y=1 //x2=17.46 //y2=0.955
cc_1897 ( N_noxref_12_M11_noxref_d N_noxref_13_c_3280_n ) capacitor \
 c=2.93544e-19 //x=18.24 //y=0.905 //x2=17.46 //y2=0.955
cc_1898 ( N_noxref_12_c_3039_n N_noxref_13_c_3323_n ) capacitor c=0.00606355f \
 //x=18.43 //y=1 //x2=20.685 //y2=0.965
cc_1899 ( N_noxref_12_c_3096_n N_noxref_13_c_3294_n ) capacitor c=7.78078e-19 \
 //x=18.785 //y=1.655 //x2=19.44 //y2=0
cc_1900 ( N_noxref_12_c_3040_n N_noxref_13_c_3326_n ) capacitor c=0.00460657f \
 //x=18.43 //y=1.57 //x2=19.61 //y2=0
cc_1901 ( N_noxref_12_c_3096_n N_noxref_13_c_3326_n ) capacitor c=0.0313753f \
 //x=18.785 //y=1.655 //x2=19.61 //y2=0
cc_1902 ( N_noxref_12_c_3039_n N_noxref_13_M10_noxref_d ) capacitor \
 c=2.82748e-19 //x=18.43 //y=1 //x2=17.27 //y2=0.865
cc_1903 ( N_noxref_12_c_3021_n N_noxref_14_c_3614_n ) capacitor c=0.00358089f \
 //x=18.87 //y=5.115 //x2=20.72 //y2=2.195
cc_1904 ( N_noxref_12_c_3021_n N_noxref_14_c_3619_n ) capacitor c=0.0436519f \
 //x=18.87 //y=5.115 //x2=20.72 //y2=4.575
cc_1905 ( N_noxref_12_c_3039_n N_noxref_15_M13_noxref_d ) capacitor \
 c=3.39394e-19 //x=18.43 //y=1 //x2=21.47 //y2=0.91
cc_1906 ( N_noxref_12_c_3096_n N_noxref_16_c_3810_n ) capacitor c=9.69113e-19 \
 //x=18.785 //y=1.655 //x2=23.195 //y2=1.58
cc_1907 ( N_noxref_12_c_3021_n N_noxref_16_c_3882_n ) capacitor c=9.69113e-19 \
 //x=18.87 //y=5.115 //x2=23.28 //y2=1.665
cc_1908 ( N_noxref_12_c_3021_n N_noxref_16_c_3827_n ) capacitor c=0.00286942f \
 //x=18.87 //y=5.115 //x2=21.142 //y2=5.155
cc_1909 ( N_noxref_12_c_3048_n N_noxref_16_c_3827_n ) capacitor c=5.0812e-19 \
 //x=18.39 //y=5.2 //x2=21.142 //y2=5.155
cc_1910 ( N_noxref_12_c_3036_n N_noxref_21_c_4162_n ) capacitor c=0.00911498f \
 //x=18.515 //y=1.655 //x2=17.945 //y2=1.495
cc_1911 ( N_noxref_12_c_3096_n N_noxref_21_c_4169_n ) capacitor c=0.00399245f \
 //x=18.785 //y=1.655 //x2=18.83 //y2=0.53
cc_1912 ( N_noxref_12_c_3039_n N_noxref_21_c_4169_n ) capacitor c=0.003751f \
 //x=18.43 //y=1 //x2=18.83 //y2=0.53
cc_1913 ( N_noxref_12_M11_noxref_d N_noxref_21_c_4169_n ) capacitor \
 c=0.00910163f //x=18.24 //y=0.905 //x2=18.83 //y2=0.53
cc_1914 ( N_noxref_12_c_3040_n N_noxref_21_M10_noxref_s ) capacitor \
 c=0.0175047f //x=18.43 //y=1.57 //x2=16.84 //y2=0.365
cc_1915 ( N_noxref_12_c_3096_n N_noxref_21_M10_noxref_s ) capacitor \
 c=0.00764647f //x=18.785 //y=1.655 //x2=16.84 //y2=0.365
cc_1916 ( N_noxref_12_c_3039_n N_noxref_21_M10_noxref_s ) capacitor \
 c=0.00894261f //x=18.43 //y=1 //x2=16.84 //y2=0.365
cc_1917 ( N_noxref_12_M11_noxref_d N_noxref_21_M10_noxref_s ) capacitor \
 c=0.0275552f //x=18.24 //y=0.905 //x2=16.84 //y2=0.365
cc_1918 ( N_noxref_13_c_3323_n N_noxref_14_c_3614_n ) capacitor c=0.00772254f \
 //x=20.685 //y=0.965 //x2=20.72 //y2=2.195
cc_1919 ( N_noxref_13_c_3326_n N_noxref_14_c_3614_n ) capacitor c=0.00361632f \
 //x=19.61 //y=0 //x2=20.72 //y2=2.195
cc_1920 ( N_noxref_13_M12_noxref_d N_noxref_14_c_3614_n ) capacitor \
 c=4.4417e-19 //x=20.495 //y=0.875 //x2=20.72 //y2=2.195
cc_1921 ( N_noxref_13_c_3326_n N_noxref_14_c_3619_n ) capacitor c=0.0107391f \
 //x=19.61 //y=0 //x2=20.72 //y2=4.575
cc_1922 ( N_noxref_13_c_3323_n N_noxref_14_c_3625_n ) capacitor c=2.22861e-19 \
 //x=20.685 //y=0.965 //x2=20.72 //y2=2.08
cc_1923 ( N_noxref_13_c_3326_n N_noxref_14_c_3625_n ) capacitor c=0.00379568f \
 //x=19.61 //y=0 //x2=20.72 //y2=2.08
cc_1924 ( N_noxref_13_c_3446_p N_noxref_14_c_3635_n ) capacitor c=3.92414e-19 \
 //x=20.685 //y=0.835 //x2=20.42 //y2=0.875
cc_1925 ( N_noxref_13_c_3323_n N_noxref_14_c_3635_n ) capacitor c=0.0015128f \
 //x=20.685 //y=0.965 //x2=20.42 //y2=0.875
cc_1926 ( N_noxref_13_c_3341_n N_noxref_14_c_3635_n ) capacitor c=0.00679028f \
 //x=23.68 //y=0 //x2=20.42 //y2=0.875
cc_1927 ( N_noxref_13_M12_noxref_d N_noxref_14_c_3635_n ) capacitor \
 c=0.00184354f //x=20.495 //y=0.875 //x2=20.42 //y2=0.875
cc_1928 ( N_noxref_13_c_3323_n N_noxref_14_c_3636_n ) capacitor c=0.00350108f \
 //x=20.685 //y=0.965 //x2=20.42 //y2=1.22
cc_1929 ( N_noxref_13_M12_noxref_d N_noxref_14_c_3636_n ) capacitor \
 c=0.00210798f //x=20.495 //y=0.875 //x2=20.42 //y2=1.22
cc_1930 ( N_noxref_13_c_3323_n N_noxref_14_c_3637_n ) capacitor c=4.86145e-19 \
 //x=20.685 //y=0.965 //x2=20.42 //y2=1.53
cc_1931 ( N_noxref_13_c_3326_n N_noxref_14_c_3637_n ) capacitor c=0.00170145f \
 //x=19.61 //y=0 //x2=20.42 //y2=1.53
cc_1932 ( N_noxref_13_c_3326_n N_noxref_14_c_3638_n ) capacitor c=0.0102191f \
 //x=19.61 //y=0 //x2=20.42 //y2=1.915
cc_1933 ( N_noxref_13_c_3446_p N_noxref_14_c_3684_n ) capacitor c=0.00850983f \
 //x=20.685 //y=0.835 //x2=20.795 //y2=0.72
cc_1934 ( N_noxref_13_c_3323_n N_noxref_14_c_3684_n ) capacitor c=7.3749e-19 \
 //x=20.685 //y=0.965 //x2=20.795 //y2=0.72
cc_1935 ( N_noxref_13_M12_noxref_d N_noxref_14_c_3684_n ) capacitor \
 c=0.00474029f //x=20.495 //y=0.875 //x2=20.795 //y2=0.72
cc_1936 ( N_noxref_13_c_3323_n N_noxref_14_c_3687_n ) capacitor c=6.35695e-19 \
 //x=20.685 //y=0.965 //x2=20.795 //y2=1.375
cc_1937 ( N_noxref_13_M12_noxref_d N_noxref_14_c_3687_n ) capacitor \
 c=0.00166857f //x=20.495 //y=0.875 //x2=20.795 //y2=1.375
cc_1938 ( N_noxref_13_c_3446_p N_noxref_14_c_3641_n ) capacitor c=4.45447e-19 \
 //x=20.685 //y=0.835 //x2=20.95 //y2=0.875
cc_1939 ( N_noxref_13_c_3323_n N_noxref_14_c_3641_n ) capacitor c=0.00158223f \
 //x=20.685 //y=0.965 //x2=20.95 //y2=0.875
cc_1940 ( N_noxref_13_M12_noxref_d N_noxref_14_c_3641_n ) capacitor \
 c=0.00230174f //x=20.495 //y=0.875 //x2=20.95 //y2=0.875
cc_1941 ( N_noxref_13_c_3323_n N_noxref_14_c_3643_n ) capacitor c=0.00276804f \
 //x=20.685 //y=0.965 //x2=20.95 //y2=1.22
cc_1942 ( N_noxref_13_M12_noxref_d N_noxref_14_c_3643_n ) capacitor \
 c=0.00210798f //x=20.495 //y=0.875 //x2=20.95 //y2=1.22
cc_1943 ( N_noxref_13_c_3318_n N_noxref_15_c_3713_n ) capacitor c=0.00789826f \
 //x=23.68 //y=0 //x2=22.625 //y2=0.995
cc_1944 ( N_noxref_13_c_3341_n N_noxref_15_c_3713_n ) capacitor c=0.00824948f \
 //x=23.68 //y=0 //x2=22.625 //y2=0.995
cc_1945 ( N_noxref_13_c_3318_n N_noxref_15_c_3745_n ) capacitor c=0.00418147f \
 //x=23.68 //y=0 //x2=22.71 //y2=0.625
cc_1946 ( N_noxref_13_c_3341_n N_noxref_15_c_3745_n ) capacitor c=0.0140218f \
 //x=23.68 //y=0 //x2=22.71 //y2=0.625
cc_1947 ( N_noxref_13_c_3318_n N_noxref_15_c_3730_n ) capacitor c=0.00960391f \
 //x=23.68 //y=0 //x2=23.595 //y2=0.54
cc_1948 ( N_noxref_13_c_3341_n N_noxref_15_c_3730_n ) capacitor c=0.0383154f \
 //x=23.68 //y=0 //x2=23.595 //y2=0.54
cc_1949 ( N_noxref_13_c_3318_n N_noxref_15_c_3749_n ) capacitor c=0.00232857f \
 //x=23.68 //y=0 //x2=23.68 //y2=0.625
cc_1950 ( N_noxref_13_c_3341_n N_noxref_15_c_3749_n ) capacitor c=0.0541348f \
 //x=23.68 //y=0 //x2=23.68 //y2=0.625
cc_1951 ( N_noxref_13_c_3318_n N_noxref_15_M13_noxref_d ) capacitor \
 c=0.0130697f //x=23.68 //y=0 //x2=21.47 //y2=0.91
cc_1952 ( N_noxref_13_c_3323_n N_noxref_15_M13_noxref_d ) capacitor \
 c=0.0154456f //x=20.685 //y=0.965 //x2=21.47 //y2=0.91
cc_1953 ( N_noxref_13_c_3341_n N_noxref_15_M13_noxref_d ) capacitor \
 c=2.7648e-19 //x=23.68 //y=0 //x2=21.47 //y2=0.91
cc_1954 ( N_noxref_13_M12_noxref_d N_noxref_15_M13_noxref_d ) capacitor \
 c=3.12752e-19 //x=20.495 //y=0.875 //x2=21.47 //y2=0.91
cc_1955 ( N_noxref_13_c_3341_n N_noxref_15_M14_noxref_s ) capacitor \
 c=0.00533266f //x=23.68 //y=0 //x2=22.575 //y2=0.375
cc_1956 ( N_noxref_13_c_3326_n N_noxref_15_M14_noxref_s ) capacitor \
 c=8.16352e-19 //x=19.61 //y=0 //x2=22.575 //y2=0.375
cc_1957 ( N_noxref_13_c_3318_n N_noxref_16_c_3804_n ) capacitor c=0.00900212f \
 //x=23.68 //y=0 //x2=23.195 //y2=1.125
cc_1958 ( N_noxref_13_c_3341_n N_noxref_16_c_3810_n ) capacitor c=0.00518727f \
 //x=23.68 //y=0 //x2=23.195 //y2=1.58
cc_1959 ( N_noxref_13_c_3318_n N_noxref_16_c_3815_n ) capacitor c=0.00712383f \
 //x=23.68 //y=0 //x2=23.595 //y2=1.665
cc_1960 ( N_noxref_13_c_3341_n N_noxref_16_c_3815_n ) capacitor c=0.0408503f \
 //x=23.68 //y=0 //x2=23.595 //y2=1.665
cc_1961 ( N_noxref_13_c_3318_n N_noxref_16_M14_noxref_d ) capacitor \
 c=2.94508e-19 //x=23.68 //y=0 //x2=23.005 //y2=0.915
cc_1962 ( N_noxref_13_c_3367_n N_noxref_17_c_3930_n ) capacitor c=0.00275882f \
 //x=1.095 //y=0 //x2=1.58 //y2=1.58
cc_1963 ( N_noxref_13_c_3149_n N_noxref_17_c_3930_n ) capacitor c=7.73914e-19 \
 //x=4.32 //y=0 //x2=1.58 //y2=1.58
cc_1964 ( N_noxref_13_c_3159_n N_noxref_17_c_3930_n ) capacitor c=0.00407704f \
 //x=1.18 //y=0.955 //x2=1.58 //y2=1.58
cc_1965 ( N_noxref_13_c_3185_n N_noxref_17_c_3930_n ) capacitor c=0.00374872f \
 //x=3.16 //y=0 //x2=1.58 //y2=1.58
cc_1966 ( N_noxref_13_M0_noxref_d N_noxref_17_c_3930_n ) capacitor \
 c=0.00578453f //x=0.99 //y=0.865 //x2=1.58 //y2=1.58
cc_1967 ( N_noxref_13_c_3149_n N_noxref_17_c_3945_n ) capacitor c=0.00644655f \
 //x=4.32 //y=0 //x2=1.665 //y2=0.615
cc_1968 ( N_noxref_13_c_3377_n N_noxref_17_c_3945_n ) capacitor c=0.0119573f \
 //x=1.177 //y=0.825 //x2=1.665 //y2=0.615
cc_1969 ( N_noxref_13_c_3185_n N_noxref_17_c_3945_n ) capacitor c=0.0146219f \
 //x=3.16 //y=0 //x2=1.665 //y2=0.615
cc_1970 ( N_noxref_13_c_3187_n N_noxref_17_c_3945_n ) capacitor c=0.00283128f \
 //x=0.74 //y=0 //x2=1.665 //y2=0.615
cc_1971 ( N_noxref_13_c_3191_n N_noxref_17_c_3945_n ) capacitor c=2.99181e-19 \
 //x=3.33 //y=0 //x2=1.665 //y2=0.615
cc_1972 ( N_noxref_13_c_3187_n N_noxref_17_c_3907_n ) capacitor c=2.85935e-19 \
 //x=0.74 //y=0 //x2=1.665 //y2=1.495
cc_1973 ( N_noxref_13_c_3149_n N_noxref_17_c_3908_n ) capacitor c=0.00974193f \
 //x=4.32 //y=0 //x2=2.55 //y2=0.53
cc_1974 ( N_noxref_13_c_3185_n N_noxref_17_c_3908_n ) capacitor c=0.0374415f \
 //x=3.16 //y=0 //x2=2.55 //y2=0.53
cc_1975 ( N_noxref_13_c_3341_n N_noxref_17_c_3908_n ) capacitor c=0.00198522f \
 //x=23.68 //y=0 //x2=2.55 //y2=0.53
cc_1976 ( N_noxref_13_c_3149_n N_noxref_17_c_3954_n ) capacitor c=0.00244943f \
 //x=4.32 //y=0 //x2=2.635 //y2=0.615
cc_1977 ( N_noxref_13_c_3185_n N_noxref_17_c_3954_n ) capacitor c=0.0145161f \
 //x=3.16 //y=0 //x2=2.635 //y2=0.615
cc_1978 ( N_noxref_13_c_3191_n N_noxref_17_c_3954_n ) capacitor c=0.0396774f \
 //x=3.33 //y=0 //x2=2.635 //y2=0.615
cc_1979 ( N_noxref_13_c_3367_n N_noxref_17_M0_noxref_s ) capacitor \
 c=0.00723598f //x=1.095 //y=0 //x2=0.56 //y2=0.365
cc_1980 ( N_noxref_13_c_3159_n N_noxref_17_M0_noxref_s ) capacitor \
 c=0.0113621f //x=1.18 //y=0.955 //x2=0.56 //y2=0.365
cc_1981 ( N_noxref_13_c_3377_n N_noxref_17_M0_noxref_s ) capacitor \
 c=0.0170608f //x=1.177 //y=0.825 //x2=0.56 //y2=0.365
cc_1982 ( N_noxref_13_c_3185_n N_noxref_17_M0_noxref_s ) capacitor \
 c=0.0146208f //x=3.16 //y=0 //x2=0.56 //y2=0.365
cc_1983 ( N_noxref_13_c_3187_n N_noxref_17_M0_noxref_s ) capacitor \
 c=0.0559891f //x=0.74 //y=0 //x2=0.56 //y2=0.365
cc_1984 ( N_noxref_13_c_3191_n N_noxref_17_M0_noxref_s ) capacitor \
 c=0.00648062f //x=3.33 //y=0 //x2=0.56 //y2=0.365
cc_1985 ( N_noxref_13_M0_noxref_d N_noxref_17_M0_noxref_s ) capacitor \
 c=0.0271276f //x=0.99 //y=0.865 //x2=0.56 //y2=0.365
cc_1986 ( N_noxref_13_c_3149_n N_noxref_18_c_3969_n ) capacitor c=0.00113313f \
 //x=4.32 //y=0 //x2=4.805 //y2=1.59
cc_1987 ( N_noxref_13_c_3268_n N_noxref_18_c_3969_n ) capacitor c=6.52202e-19 \
 //x=9.13 //y=0 //x2=4.805 //y2=1.59
cc_1988 ( N_noxref_13_c_3162_n N_noxref_18_c_3969_n ) capacitor c=0.0035485f \
 //x=4.405 //y=0.965 //x2=4.805 //y2=1.59
cc_1989 ( N_noxref_13_c_3189_n N_noxref_18_c_3969_n ) capacitor c=0.00388837f \
 //x=7.97 //y=0 //x2=4.805 //y2=1.59
cc_1990 ( N_noxref_13_M2_noxref_d N_noxref_18_c_3969_n ) capacitor \
 c=0.00578031f //x=4.215 //y=0.875 //x2=4.805 //y2=1.59
cc_1991 ( N_noxref_13_c_3153_n N_noxref_18_c_3994_n ) capacitor c=0.0169052f \
 //x=4.405 //y=0.835 //x2=4.89 //y2=0.625
cc_1992 ( N_noxref_13_c_3268_n N_noxref_18_c_3994_n ) capacitor c=0.00709506f \
 //x=9.13 //y=0 //x2=4.89 //y2=0.625
cc_1993 ( N_noxref_13_c_3189_n N_noxref_18_c_3994_n ) capacitor c=0.0140218f \
 //x=7.97 //y=0 //x2=4.89 //y2=0.625
cc_1994 ( N_noxref_13_c_3191_n N_noxref_18_c_3994_n ) capacitor c=0.00322442f \
 //x=3.33 //y=0 //x2=4.89 //y2=0.625
cc_1995 ( N_noxref_13_c_3268_n N_noxref_18_c_3984_n ) capacitor c=0.0124067f \
 //x=9.13 //y=0 //x2=5.775 //y2=0.54
cc_1996 ( N_noxref_13_c_3189_n N_noxref_18_c_3984_n ) capacitor c=0.0356078f \
 //x=7.97 //y=0 //x2=5.775 //y2=0.54
cc_1997 ( N_noxref_13_c_3341_n N_noxref_18_c_3984_n ) capacitor c=0.00177401f \
 //x=23.68 //y=0 //x2=5.775 //y2=0.54
cc_1998 ( N_noxref_13_c_3149_n N_noxref_18_M2_noxref_s ) capacitor \
 c=0.00709506f //x=4.32 //y=0 //x2=3.785 //y2=0.375
cc_1999 ( N_noxref_13_c_3153_n N_noxref_18_M2_noxref_s ) capacitor \
 c=0.0125586f //x=4.405 //y=0.835 //x2=3.785 //y2=0.375
cc_2000 ( N_noxref_13_c_3268_n N_noxref_18_M2_noxref_s ) capacitor \
 c=0.00682701f //x=9.13 //y=0 //x2=3.785 //y2=0.375
cc_2001 ( N_noxref_13_c_3162_n N_noxref_18_M2_noxref_s ) capacitor \
 c=0.00972044f //x=4.405 //y=0.965 //x2=3.785 //y2=0.375
cc_2002 ( N_noxref_13_c_3189_n N_noxref_18_M2_noxref_s ) capacitor c=0.027164f \
 //x=7.97 //y=0 //x2=3.785 //y2=0.375
cc_2003 ( N_noxref_13_c_3191_n N_noxref_18_M2_noxref_s ) capacitor \
 c=0.0624873f //x=3.33 //y=0 //x2=3.785 //y2=0.375
cc_2004 ( N_noxref_13_c_3203_n N_noxref_18_M2_noxref_s ) capacitor \
 c=0.00166413f //x=8.14 //y=0 //x2=3.785 //y2=0.375
cc_2005 ( N_noxref_13_M2_noxref_d N_noxref_18_M2_noxref_s ) capacitor \
 c=0.0271316f //x=4.215 //y=0.875 //x2=3.785 //y2=0.375
cc_2006 ( N_noxref_13_c_3268_n N_noxref_19_c_4029_n ) capacitor c=0.00113313f \
 //x=9.13 //y=0 //x2=9.615 //y2=1.59
cc_2007 ( N_noxref_13_c_3226_n N_noxref_19_c_4029_n ) capacitor c=7.68788e-19 \
 //x=14.045 //y=0 //x2=9.615 //y2=1.59
cc_2008 ( N_noxref_13_c_3174_n N_noxref_19_c_4029_n ) capacitor c=0.00350555f \
 //x=9.215 //y=0.965 //x2=9.615 //y2=1.59
cc_2009 ( N_noxref_13_c_3190_n N_noxref_19_c_4029_n ) capacitor c=0.00388837f \
 //x=12.78 //y=0 //x2=9.615 //y2=1.59
cc_2010 ( N_noxref_13_M5_noxref_d N_noxref_19_c_4029_n ) capacitor \
 c=0.00578031f //x=9.025 //y=0.875 //x2=9.615 //y2=1.59
cc_2011 ( N_noxref_13_c_3156_n N_noxref_19_c_4057_n ) capacitor c=0.0169052f \
 //x=9.215 //y=0.835 //x2=9.7 //y2=0.625
cc_2012 ( N_noxref_13_c_3226_n N_noxref_19_c_4057_n ) capacitor c=0.00709506f \
 //x=14.045 //y=0 //x2=9.7 //y2=0.625
cc_2013 ( N_noxref_13_c_3190_n N_noxref_19_c_4057_n ) capacitor c=0.0140218f \
 //x=12.78 //y=0 //x2=9.7 //y2=0.625
cc_2014 ( N_noxref_13_c_3203_n N_noxref_19_c_4057_n ) capacitor c=0.00322478f \
 //x=8.14 //y=0 //x2=9.7 //y2=0.625
cc_2015 ( N_noxref_13_c_3226_n N_noxref_19_c_4041_n ) capacitor c=0.0130175f \
 //x=14.045 //y=0 //x2=10.585 //y2=0.54
cc_2016 ( N_noxref_13_c_3190_n N_noxref_19_c_4041_n ) capacitor c=0.0358446f \
 //x=12.78 //y=0 //x2=10.585 //y2=0.54
cc_2017 ( N_noxref_13_c_3341_n N_noxref_19_c_4041_n ) capacitor c=0.00177401f \
 //x=23.68 //y=0 //x2=10.585 //y2=0.54
cc_2018 ( N_noxref_13_c_3268_n N_noxref_19_M5_noxref_s ) capacitor \
 c=0.00709506f //x=9.13 //y=0 //x2=8.595 //y2=0.375
cc_2019 ( N_noxref_13_c_3156_n N_noxref_19_M5_noxref_s ) capacitor \
 c=0.0173062f //x=9.215 //y=0.835 //x2=8.595 //y2=0.375
cc_2020 ( N_noxref_13_c_3226_n N_noxref_19_M5_noxref_s ) capacitor \
 c=0.00444952f //x=14.045 //y=0 //x2=8.595 //y2=0.375
cc_2021 ( N_noxref_13_c_3174_n N_noxref_19_M5_noxref_s ) capacitor \
 c=0.00988958f //x=9.215 //y=0.965 //x2=8.595 //y2=0.375
cc_2022 ( N_noxref_13_c_3190_n N_noxref_19_M5_noxref_s ) capacitor \
 c=0.0272168f //x=12.78 //y=0 //x2=8.595 //y2=0.375
cc_2023 ( N_noxref_13_c_3203_n N_noxref_19_M5_noxref_s ) capacitor \
 c=0.0634633f //x=8.14 //y=0 //x2=8.595 //y2=0.375
cc_2024 ( N_noxref_13_c_3247_n N_noxref_19_M5_noxref_s ) capacitor \
 c=0.00166451f //x=12.95 //y=0 //x2=8.595 //y2=0.375
cc_2025 ( N_noxref_13_M5_noxref_d N_noxref_19_M5_noxref_s ) capacitor \
 c=0.0271316f //x=9.025 //y=0.875 //x2=8.595 //y2=0.375
cc_2026 ( N_noxref_13_c_3226_n N_noxref_20_c_4088_n ) capacitor c=9.58128e-19 \
 //x=14.045 //y=0 //x2=14.53 //y2=1.58
cc_2027 ( N_noxref_13_c_3269_n N_noxref_20_c_4088_n ) capacitor c=7.45312e-19 \
 //x=17.375 //y=0 //x2=14.53 //y2=1.58
cc_2028 ( N_noxref_13_c_3230_n N_noxref_20_c_4088_n ) capacitor c=0.00396929f \
 //x=14.13 //y=0.955 //x2=14.53 //y2=1.58
cc_2029 ( N_noxref_13_c_3246_n N_noxref_20_c_4088_n ) capacitor c=0.00395284f \
 //x=16.11 //y=0 //x2=14.53 //y2=1.58
cc_2030 ( N_noxref_13_M8_noxref_d N_noxref_20_c_4088_n ) capacitor \
 c=0.00578453f //x=13.94 //y=0.865 //x2=14.53 //y2=1.58
cc_2031 ( N_noxref_13_c_3269_n N_noxref_20_c_4132_n ) capacitor c=0.00425805f \
 //x=17.375 //y=0 //x2=14.615 //y2=0.615
cc_2032 ( N_noxref_13_c_3241_n N_noxref_20_c_4132_n ) capacitor c=0.0120153f \
 //x=14.127 //y=0.825 //x2=14.615 //y2=0.615
cc_2033 ( N_noxref_13_c_3246_n N_noxref_20_c_4132_n ) capacitor c=0.0147324f \
 //x=16.11 //y=0 //x2=14.615 //y2=0.615
cc_2034 ( N_noxref_13_c_3247_n N_noxref_20_c_4132_n ) capacitor c=0.00282583f \
 //x=12.95 //y=0 //x2=14.615 //y2=0.615
cc_2035 ( N_noxref_13_c_3260_n N_noxref_20_c_4132_n ) capacitor c=2.99356e-19 \
 //x=16.28 //y=0 //x2=14.615 //y2=0.615
cc_2036 ( N_noxref_13_c_3247_n N_noxref_20_c_4095_n ) capacitor c=2.8386e-19 \
 //x=12.95 //y=0 //x2=14.615 //y2=1.495
cc_2037 ( N_noxref_13_c_3269_n N_noxref_20_c_4102_n ) capacitor c=0.00979017f \
 //x=17.375 //y=0 //x2=15.5 //y2=0.53
cc_2038 ( N_noxref_13_c_3246_n N_noxref_20_c_4102_n ) capacitor c=0.037518f \
 //x=16.11 //y=0 //x2=15.5 //y2=0.53
cc_2039 ( N_noxref_13_c_3341_n N_noxref_20_c_4102_n ) capacitor c=0.00198522f \
 //x=23.68 //y=0 //x2=15.5 //y2=0.53
cc_2040 ( N_noxref_13_c_3269_n N_noxref_20_c_4141_n ) capacitor c=0.00253337f \
 //x=17.375 //y=0 //x2=15.585 //y2=0.615
cc_2041 ( N_noxref_13_c_3246_n N_noxref_20_c_4141_n ) capacitor c=0.0145099f \
 //x=16.11 //y=0 //x2=15.585 //y2=0.615
cc_2042 ( N_noxref_13_c_3260_n N_noxref_20_c_4141_n ) capacitor c=0.0392026f \
 //x=16.28 //y=0 //x2=15.585 //y2=0.615
cc_2043 ( N_noxref_13_c_3226_n N_noxref_20_M8_noxref_s ) capacitor \
 c=0.00451005f //x=14.045 //y=0 //x2=13.51 //y2=0.365
cc_2044 ( N_noxref_13_c_3230_n N_noxref_20_M8_noxref_s ) capacitor \
 c=0.0100997f //x=14.13 //y=0.955 //x2=13.51 //y2=0.365
cc_2045 ( N_noxref_13_c_3241_n N_noxref_20_M8_noxref_s ) capacitor \
 c=0.0170652f //x=14.127 //y=0.825 //x2=13.51 //y2=0.365
cc_2046 ( N_noxref_13_c_3246_n N_noxref_20_M8_noxref_s ) capacitor c=0.014742f \
 //x=16.11 //y=0 //x2=13.51 //y2=0.365
cc_2047 ( N_noxref_13_c_3247_n N_noxref_20_M8_noxref_s ) capacitor \
 c=0.0528206f //x=12.95 //y=0 //x2=13.51 //y2=0.365
cc_2048 ( N_noxref_13_c_3260_n N_noxref_20_M8_noxref_s ) capacitor \
 c=0.0064811f //x=16.28 //y=0 //x2=13.51 //y2=0.365
cc_2049 ( N_noxref_13_M8_noxref_d N_noxref_20_M8_noxref_s ) capacitor \
 c=0.0271276f //x=13.94 //y=0.865 //x2=13.51 //y2=0.365
cc_2050 ( N_noxref_13_c_3269_n N_noxref_21_c_4155_n ) capacitor c=9.98231e-19 \
 //x=17.375 //y=0 //x2=17.86 //y2=1.58
cc_2051 ( N_noxref_13_c_3317_n N_noxref_21_c_4155_n ) capacitor c=7.45312e-19 \
 //x=20.6 //y=0 //x2=17.86 //y2=1.58
cc_2052 ( N_noxref_13_c_3280_n N_noxref_21_c_4155_n ) capacitor c=0.00402802f \
 //x=17.46 //y=0.955 //x2=17.86 //y2=1.58
cc_2053 ( N_noxref_13_c_3294_n N_noxref_21_c_4155_n ) capacitor c=0.00395284f \
 //x=19.44 //y=0 //x2=17.86 //y2=1.58
cc_2054 ( N_noxref_13_M10_noxref_d N_noxref_21_c_4155_n ) capacitor \
 c=0.00578453f //x=17.27 //y=0.865 //x2=17.86 //y2=1.58
cc_2055 ( N_noxref_13_c_3317_n N_noxref_21_c_4195_n ) capacitor c=0.00433411f \
 //x=20.6 //y=0 //x2=17.945 //y2=0.615
cc_2056 ( N_noxref_13_c_3289_n N_noxref_21_c_4195_n ) capacitor c=0.0119573f \
 //x=17.457 //y=0.825 //x2=17.945 //y2=0.615
cc_2057 ( N_noxref_13_c_3294_n N_noxref_21_c_4195_n ) capacitor c=0.0147324f \
 //x=19.44 //y=0 //x2=17.945 //y2=0.615
cc_2058 ( N_noxref_13_c_3260_n N_noxref_21_c_4195_n ) capacitor c=0.00282552f \
 //x=16.28 //y=0 //x2=17.945 //y2=0.615
cc_2059 ( N_noxref_13_c_3326_n N_noxref_21_c_4195_n ) capacitor c=2.99181e-19 \
 //x=19.61 //y=0 //x2=17.945 //y2=0.615
cc_2060 ( N_noxref_13_c_3260_n N_noxref_21_c_4162_n ) capacitor c=2.84067e-19 \
 //x=16.28 //y=0 //x2=17.945 //y2=1.495
cc_2061 ( N_noxref_13_c_3317_n N_noxref_21_c_4169_n ) capacitor c=0.0100493f \
 //x=20.6 //y=0 //x2=18.83 //y2=0.53
cc_2062 ( N_noxref_13_c_3294_n N_noxref_21_c_4169_n ) capacitor c=0.037518f \
 //x=19.44 //y=0 //x2=18.83 //y2=0.53
cc_2063 ( N_noxref_13_c_3341_n N_noxref_21_c_4169_n ) capacitor c=0.00198522f \
 //x=23.68 //y=0 //x2=18.83 //y2=0.53
cc_2064 ( N_noxref_13_c_3317_n N_noxref_21_c_4204_n ) capacitor c=0.00293303f \
 //x=20.6 //y=0 //x2=18.915 //y2=0.615
cc_2065 ( N_noxref_13_c_3294_n N_noxref_21_c_4204_n ) capacitor c=0.0145099f \
 //x=19.44 //y=0 //x2=18.915 //y2=0.615
cc_2066 ( N_noxref_13_c_3326_n N_noxref_21_c_4204_n ) capacitor c=0.0396774f \
 //x=19.61 //y=0 //x2=18.915 //y2=0.615
cc_2067 ( N_noxref_13_c_3269_n N_noxref_21_M10_noxref_s ) capacitor \
 c=0.00451005f //x=17.375 //y=0 //x2=16.84 //y2=0.365
cc_2068 ( N_noxref_13_c_3280_n N_noxref_21_M10_noxref_s ) capacitor \
 c=0.00990843f //x=17.46 //y=0.955 //x2=16.84 //y2=0.365
cc_2069 ( N_noxref_13_c_3289_n N_noxref_21_M10_noxref_s ) capacitor \
 c=0.0123717f //x=17.457 //y=0.825 //x2=16.84 //y2=0.365
cc_2070 ( N_noxref_13_c_3294_n N_noxref_21_M10_noxref_s ) capacitor \
 c=0.014742f //x=19.44 //y=0 //x2=16.84 //y2=0.365
cc_2071 ( N_noxref_13_c_3260_n N_noxref_21_M10_noxref_s ) capacitor \
 c=0.0518734f //x=16.28 //y=0 //x2=16.84 //y2=0.365
cc_2072 ( N_noxref_13_c_3326_n N_noxref_21_M10_noxref_s ) capacitor \
 c=0.00648412f //x=19.61 //y=0 //x2=16.84 //y2=0.365
cc_2073 ( N_noxref_13_M10_noxref_d N_noxref_21_M10_noxref_s ) capacitor \
 c=0.0271276f //x=17.27 //y=0.865 //x2=16.84 //y2=0.365
cc_2074 ( N_noxref_13_c_3317_n N_noxref_22_c_4221_n ) capacitor c=0.00113313f \
 //x=20.6 //y=0 //x2=21.085 //y2=1.59
cc_2075 ( N_noxref_13_c_3318_n N_noxref_22_c_4221_n ) capacitor c=0.00193141f \
 //x=23.68 //y=0 //x2=21.085 //y2=1.59
cc_2076 ( N_noxref_13_c_3323_n N_noxref_22_c_4221_n ) capacitor c=0.00388641f \
 //x=20.685 //y=0.965 //x2=21.085 //y2=1.59
cc_2077 ( N_noxref_13_c_3341_n N_noxref_22_c_4221_n ) capacitor c=0.00416717f \
 //x=23.68 //y=0 //x2=21.085 //y2=1.59
cc_2078 ( N_noxref_13_M12_noxref_d N_noxref_22_c_4221_n ) capacitor \
 c=0.00578031f //x=20.495 //y=0.875 //x2=21.085 //y2=1.59
cc_2079 ( N_noxref_13_c_3446_p N_noxref_22_c_4240_n ) capacitor c=0.0169052f \
 //x=20.685 //y=0.835 //x2=21.17 //y2=0.625
cc_2080 ( N_noxref_13_c_3318_n N_noxref_22_c_4240_n ) capacitor c=0.00439992f \
 //x=23.68 //y=0 //x2=21.17 //y2=0.625
cc_2081 ( N_noxref_13_c_3341_n N_noxref_22_c_4240_n ) capacitor c=0.0141422f \
 //x=23.68 //y=0 //x2=21.17 //y2=0.625
cc_2082 ( N_noxref_13_c_3326_n N_noxref_22_c_4240_n ) capacitor c=0.00322442f \
 //x=19.61 //y=0 //x2=21.17 //y2=0.625
cc_2083 ( N_noxref_13_c_3318_n N_noxref_22_c_4222_n ) capacitor c=0.0130536f \
 //x=23.68 //y=0 //x2=22.055 //y2=0.54
cc_2084 ( N_noxref_13_c_3341_n N_noxref_22_c_4222_n ) capacitor c=0.0376383f \
 //x=23.68 //y=0 //x2=22.055 //y2=0.54
cc_2085 ( N_noxref_13_c_3317_n N_noxref_22_M12_noxref_s ) capacitor \
 c=0.00439992f //x=20.6 //y=0 //x2=20.065 //y2=0.375
cc_2086 ( N_noxref_13_c_3446_p N_noxref_22_M12_noxref_s ) capacitor \
 c=0.0125586f //x=20.685 //y=0.835 //x2=20.065 //y2=0.375
cc_2087 ( N_noxref_13_c_3318_n N_noxref_22_M12_noxref_s ) capacitor \
 c=0.00682701f //x=23.68 //y=0 //x2=20.065 //y2=0.375
cc_2088 ( N_noxref_13_c_3323_n N_noxref_22_M12_noxref_s ) capacitor \
 c=0.00972044f //x=20.685 //y=0.965 //x2=20.065 //y2=0.375
cc_2089 ( N_noxref_13_c_3341_n N_noxref_22_M12_noxref_s ) capacitor \
 c=0.0286464f //x=23.68 //y=0 //x2=20.065 //y2=0.375
cc_2090 ( N_noxref_13_c_3326_n N_noxref_22_M12_noxref_s ) capacitor \
 c=0.0624873f //x=19.61 //y=0 //x2=20.065 //y2=0.375
cc_2091 ( N_noxref_13_M12_noxref_d N_noxref_22_M12_noxref_s ) capacitor \
 c=0.0271316f //x=20.495 //y=0.875 //x2=20.065 //y2=0.375
cc_2092 ( N_noxref_14_M40_noxref_g N_noxref_16_c_3776_n ) capacitor \
 c=0.0103964f //x=21.36 //y=6.02 //x2=21.9 //y2=5.155
cc_2093 ( N_noxref_14_M39_noxref_g N_noxref_16_c_3827_n ) capacitor \
 c=0.00461408f //x=20.92 //y=6.02 //x2=21.142 //y2=5.155
cc_2094 ( N_noxref_14_M40_noxref_g N_noxref_16_c_3827_n ) capacitor \
 c=0.00229208f //x=21.36 //y=6.02 //x2=21.142 //y2=5.155
cc_2095 ( N_noxref_14_c_3646_n N_noxref_16_c_3827_n ) capacitor c=0.00171885f \
 //x=21.285 //y=4.79 //x2=21.142 //y2=5.155
cc_2096 ( N_noxref_14_M39_noxref_g N_noxref_16_c_3867_n ) capacitor \
 c=0.0162284f //x=20.92 //y=6.02 //x2=21.14 //y2=5.38
cc_2097 ( N_noxref_14_M40_noxref_g N_noxref_16_c_3867_n ) capacitor \
 c=0.0179041f //x=21.36 //y=6.02 //x2=21.14 //y2=5.38
cc_2098 ( N_noxref_14_c_3646_n N_noxref_16_c_3867_n ) capacitor c=0.00291477f \
 //x=21.285 //y=4.79 //x2=21.14 //y2=5.38
cc_2099 ( N_noxref_14_c_3638_n N_noxref_22_c_4220_n ) capacitor c=0.00262672f \
 //x=20.42 //y=1.915 //x2=20.2 //y2=1.505
cc_2100 ( N_noxref_14_c_3614_n N_noxref_22_c_4221_n ) capacitor c=0.00411069f \
 //x=20.72 //y=2.195 //x2=21.085 //y2=1.59
cc_2101 ( N_noxref_14_c_3619_n N_noxref_22_c_4221_n ) capacitor c=2.72044e-19 \
 //x=20.72 //y=4.575 //x2=21.085 //y2=1.59
cc_2102 ( N_noxref_14_c_3625_n N_noxref_22_c_4221_n ) capacitor c=0.0104666f \
 //x=20.72 //y=2.08 //x2=21.085 //y2=1.59
cc_2103 ( N_noxref_14_c_3637_n N_noxref_22_c_4221_n ) capacitor c=0.00705077f \
 //x=20.42 //y=1.53 //x2=21.085 //y2=1.59
cc_2104 ( N_noxref_14_c_3638_n N_noxref_22_c_4221_n ) capacitor c=0.0208759f \
 //x=20.42 //y=1.915 //x2=21.085 //y2=1.59
cc_2105 ( N_noxref_14_c_3687_n N_noxref_22_c_4221_n ) capacitor c=0.00588627f \
 //x=20.795 //y=1.375 //x2=21.085 //y2=1.59
cc_2106 ( N_noxref_14_c_3643_n N_noxref_22_c_4221_n ) capacitor c=0.00698822f \
 //x=20.95 //y=1.22 //x2=21.085 //y2=1.59
cc_2107 ( N_noxref_14_c_3635_n N_noxref_22_M12_noxref_s ) capacitor \
 c=0.0295256f //x=20.42 //y=0.875 //x2=20.065 //y2=0.375
cc_2108 ( N_noxref_14_c_3637_n N_noxref_22_M12_noxref_s ) capacitor \
 c=7.99997e-19 //x=20.42 //y=1.53 //x2=20.065 //y2=0.375
cc_2109 ( N_noxref_14_c_3638_n N_noxref_22_M12_noxref_s ) capacitor \
 c=0.00122123f //x=20.42 //y=1.915 //x2=20.065 //y2=0.375
cc_2110 ( N_noxref_14_c_3641_n N_noxref_22_M12_noxref_s ) capacitor \
 c=0.0125924f //x=20.95 //y=0.875 //x2=20.065 //y2=0.375
cc_2111 ( N_noxref_15_M13_noxref_d N_noxref_16_c_3776_n ) capacitor \
 c=0.00130696f //x=21.47 //y=0.91 //x2=21.9 //y2=5.155
cc_2112 ( N_noxref_15_c_3730_n N_noxref_16_c_3804_n ) capacitor c=0.00366459f \
 //x=23.595 //y=0.54 //x2=23.195 //y2=1.125
cc_2113 ( N_noxref_15_M13_noxref_d N_noxref_16_c_3804_n ) capacitor \
 c=0.00803465f //x=21.47 //y=0.91 //x2=23.195 //y2=1.125
cc_2114 ( N_noxref_15_M14_noxref_s N_noxref_16_c_3804_n ) capacitor \
 c=0.011355f //x=22.575 //y=0.375 //x2=23.195 //y2=1.125
cc_2115 ( N_noxref_15_M14_noxref_s N_noxref_16_c_3810_n ) capacitor \
 c=0.0283111f //x=22.575 //y=0.375 //x2=23.195 //y2=1.58
cc_2116 ( N_noxref_15_c_3730_n N_noxref_16_c_3815_n ) capacitor c=0.00362807f \
 //x=23.595 //y=0.54 //x2=23.595 //y2=1.665
cc_2117 ( N_noxref_15_M14_noxref_s N_noxref_16_c_3815_n ) capacitor \
 c=0.0106347f //x=22.575 //y=0.375 //x2=23.595 //y2=1.665
cc_2118 ( N_noxref_15_c_3730_n N_noxref_16_M14_noxref_d ) capacitor \
 c=0.00949319f //x=23.595 //y=0.54 //x2=23.005 //y2=0.915
cc_2119 ( N_noxref_15_c_3735_n N_noxref_16_M14_noxref_d ) capacitor \
 c=0.00120711f //x=22.71 //y=0.995 //x2=23.005 //y2=0.915
cc_2120 ( N_noxref_15_M14_noxref_s N_noxref_16_M14_noxref_d ) capacitor \
 c=0.0279003f //x=22.575 //y=0.375 //x2=23.005 //y2=0.915
cc_2121 ( N_noxref_15_c_3745_n N_noxref_22_c_4240_n ) capacitor c=2.15937e-19 \
 //x=22.71 //y=0.625 //x2=21.17 //y2=0.625
cc_2122 ( N_noxref_15_c_3713_n N_noxref_22_c_4222_n ) capacitor c=0.0132234f \
 //x=22.625 //y=0.995 //x2=22.055 //y2=0.54
cc_2123 ( N_noxref_15_M13_noxref_d N_noxref_22_c_4222_n ) capacitor \
 c=0.0160925f //x=21.47 //y=0.91 //x2=22.055 //y2=0.54
cc_2124 ( N_noxref_15_c_3713_n N_noxref_22_c_4224_n ) capacitor c=0.00949522f \
 //x=22.625 //y=0.995 //x2=22.055 //y2=1.59
cc_2125 ( N_noxref_15_M13_noxref_d N_noxref_22_c_4224_n ) capacitor c=0.01508f \
 //x=21.47 //y=0.91 //x2=22.055 //y2=1.59
cc_2126 ( N_noxref_15_c_3713_n N_noxref_22_M12_noxref_s ) capacitor \
 c=0.023368f //x=22.625 //y=0.995 //x2=20.065 //y2=0.375
cc_2127 ( N_noxref_15_c_3745_n N_noxref_22_M12_noxref_s ) capacitor \
 c=0.0182125f //x=22.71 //y=0.625 //x2=20.065 //y2=0.375
cc_2128 ( N_noxref_15_M13_noxref_d N_noxref_22_M12_noxref_s ) capacitor \
 c=0.0187674f //x=21.47 //y=0.91 //x2=20.065 //y2=0.375
cc_2129 ( N_noxref_15_M14_noxref_s N_noxref_22_M12_noxref_s ) capacitor \
 c=0.0210061f //x=22.575 //y=0.375 //x2=20.065 //y2=0.375
cc_2130 ( N_noxref_17_c_3907_n N_noxref_18_c_3967_n ) capacitor c=6.40432e-19 \
 //x=1.665 //y=1.495 //x2=3.92 //y2=1.505
cc_2131 ( N_noxref_17_c_3954_n N_noxref_18_M2_noxref_s ) capacitor \
 c=0.00453771f //x=2.635 //y=0.615 //x2=3.785 //y2=0.375
cc_2132 ( N_noxref_17_M0_noxref_s N_noxref_18_M2_noxref_s ) capacitor \
 c=6.40432e-19 //x=0.56 //y=0.365 //x2=3.785 //y2=0.375
cc_2133 ( N_noxref_20_c_4095_n N_noxref_21_c_4154_n ) capacitor c=5.34352e-19 \
 //x=14.615 //y=1.495 //x2=16.975 //y2=1.495
cc_2134 ( N_noxref_20_c_4141_n N_noxref_21_M10_noxref_s ) capacitor \
 c=0.0045327f //x=15.585 //y=0.615 //x2=16.84 //y2=0.365
cc_2135 ( N_noxref_20_M8_noxref_s N_noxref_21_M10_noxref_s ) capacitor \
 c=5.34352e-19 //x=13.51 //y=0.365 //x2=16.84 //y2=0.365
cc_2136 ( N_noxref_21_c_4162_n N_noxref_22_c_4220_n ) capacitor c=6.40634e-19 \
 //x=17.945 //y=1.495 //x2=20.2 //y2=1.505
cc_2137 ( N_noxref_21_c_4204_n N_noxref_22_M12_noxref_s ) capacitor \
 c=0.00453771f //x=18.915 //y=0.615 //x2=20.065 //y2=0.375
cc_2138 ( N_noxref_21_M10_noxref_s N_noxref_22_M12_noxref_s ) capacitor \
 c=6.40634e-19 //x=16.84 //y=0.365 //x2=20.065 //y2=0.375
