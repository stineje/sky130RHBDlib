// File: FA.spi
// Created: Thu Jan 22 07:06:06 2026
// Program "Calibre xRC"
// Version "v2023.2_27.15"
//
simulator lang=spectre
include "/import/yukari1/lrburle/sky130RHBDlib/sky130_rhbd/pex/FA.pex.spice"
subckt FA (  A B SUM CIN VDD GND COUT )
//
// COUT	COUT
// GND	GND
// VDD	VDD
// CIN	CIN
// SUM	SUM
// B	B
// A	A
M0_noxref ( N_noxref_2_M0_noxref_d N_A_M0_noxref_g N_GND_M0_noxref_s \
 noxref_423 ) NMOS l=0.163346 w=2.31104 m=1
M1_noxref ( N_GND_M1_noxref_d N_A_M1_noxref_g N_noxref_23_M1_noxref_s \
 noxref_423 ) NMOS l=0.163119 w=2.35104 m=1
M2_noxref ( N_noxref_5_M2_noxref_d N_B_M2_noxref_g N_noxref_23_M1_noxref_s \
 noxref_423 ) NMOS l=0.163346 w=2.31104 m=1
M3_noxref ( N_GND_M3_noxref_d N_noxref_3_M3_noxref_g N_noxref_24_M3_noxref_s \
 noxref_423 ) NMOS l=0.163119 w=2.35104 m=1
M4_noxref ( N_noxref_5_M4_noxref_d N_noxref_2_M4_noxref_g \
 N_noxref_24_M3_noxref_s noxref_423 ) NMOS l=0.163346 w=2.31104 m=1
M5_noxref ( N_noxref_3_M5_noxref_d N_B_M5_noxref_g N_GND_M5_noxref_s \
 noxref_423 ) NMOS l=0.163346 w=2.31104 m=1
M6_noxref ( N_noxref_6_M6_noxref_d N_noxref_5_M6_noxref_g N_GND_M6_noxref_s \
 noxref_423 ) NMOS l=0.163346 w=2.31104 m=1
M7_noxref ( N_GND_M7_noxref_d N_noxref_5_M7_noxref_g N_noxref_25_M7_noxref_s \
 noxref_423 ) NMOS l=0.163119 w=2.35104 m=1
M8_noxref ( N_SUM_M8_noxref_d N_CIN_M8_noxref_g N_noxref_25_M7_noxref_s \
 noxref_423 ) NMOS l=0.163346 w=2.31104 m=1
M9_noxref ( N_GND_M9_noxref_d N_noxref_8_M9_noxref_g N_noxref_26_M9_noxref_s \
 noxref_423 ) NMOS l=0.163119 w=2.35104 m=1
M10_noxref ( N_SUM_M10_noxref_d N_noxref_6_M10_noxref_g \
 N_noxref_26_M9_noxref_s noxref_423 ) NMOS l=0.163346 w=2.31104 m=1
M11_noxref ( N_noxref_8_M11_noxref_d N_CIN_M11_noxref_g N_GND_M11_noxref_s \
 noxref_423 ) NMOS l=0.163346 w=2.31104 m=1
M12_noxref ( N_GND_M12_noxref_d N_CIN_M12_noxref_g N_noxref_27_M12_noxref_s \
 noxref_423 ) NMOS l=0.163119 w=2.35104 m=1
M13_noxref ( N_noxref_10_M13_noxref_d N_noxref_5_M13_noxref_g \
 N_noxref_27_M12_noxref_s noxref_423 ) NMOS l=0.163346 w=2.31104 m=1
M14_noxref ( N_noxref_12_M14_noxref_d N_noxref_10_M14_noxref_g \
 N_GND_M14_noxref_s noxref_423 ) NMOS l=0.163346 w=2.31104 m=1
M15_noxref ( N_GND_M15_noxref_d N_B_M15_noxref_g N_noxref_28_M15_noxref_s \
 noxref_423 ) NMOS l=0.163119 w=2.35104 m=1
M16_noxref ( N_noxref_11_M16_noxref_d N_A_M16_noxref_g \
 N_noxref_28_M15_noxref_s noxref_423 ) NMOS l=0.163346 w=2.31104 m=1
M17_noxref ( N_noxref_13_M17_noxref_d N_noxref_11_M17_noxref_g \
 N_GND_M17_noxref_s noxref_423 ) NMOS l=0.163346 w=2.31104 m=1
M18_noxref ( N_noxref_14_M18_noxref_d N_noxref_12_M18_noxref_g \
 N_GND_M18_noxref_s noxref_423 ) NMOS l=0.163346 w=2.31104 m=1
M19_noxref ( N_noxref_14_M19_noxref_d N_noxref_13_M19_noxref_g \
 N_GND_M18_noxref_s noxref_423 ) NMOS l=0.163129 w=2.31397 m=1
M20_noxref ( N_COUT_M20_noxref_d N_noxref_14_M20_noxref_g N_GND_M20_noxref_s \
 noxref_423 ) NMOS l=0.163346 w=2.31104 m=1
M21_noxref ( N_noxref_2_M21_noxref_d N_A_M21_noxref_g N_VDD_M21_noxref_s \
 noxref_421 ) PMOS l=0.15 w=2 ad=0.57 as=0.57 pd=2.57 ps=2.57 nrd=0 nrs=0 m=1
M22_noxref ( N_VDD_M22_noxref_d N_A_M22_noxref_g N_noxref_2_M21_noxref_d \
 noxref_421 ) PMOS l=0.15 w=2 ad=0.56 as=0.56 pd=2.56 ps=2.56 nrd=0 nrs=0 m=1
M23_noxref ( N_VDD_M23_noxref_d N_A_M23_noxref_g N_noxref_16_M23_noxref_s \
 noxref_421 ) PMOS l=0.15 w=2 ad=0.57 as=0.57 pd=2.57 ps=2.57 nrd=0 nrs=0 m=1
M24_noxref ( N_noxref_16_M24_noxref_d N_A_M24_noxref_g N_VDD_M23_noxref_d \
 noxref_421 ) PMOS l=0.15 w=2 ad=0.58 as=0.58 pd=2.58 ps=2.58 nrd=0 nrs=0 m=1
M25_noxref ( N_noxref_5_M25_noxref_d N_noxref_3_M25_noxref_g \
 N_noxref_16_M24_noxref_d noxref_421 ) PMOS l=0.15 w=2 ad=0.58 as=0.58 pd=2.58 \
 ps=2.58 nrd=0 nrs=0 m=1
M26_noxref ( N_noxref_16_M26_noxref_d N_noxref_3_M26_noxref_g \
 N_noxref_5_M25_noxref_d noxref_421 ) PMOS l=0.15 w=2 ad=0.56 as=0.56 pd=2.56 \
 ps=2.56 nrd=0 nrs=0 m=1
M27_noxref ( N_VDD_M27_noxref_d N_B_M27_noxref_g N_noxref_17_M27_noxref_s \
 noxref_421 ) PMOS l=0.15 w=2 ad=0.57 as=0.57 pd=2.57 ps=2.57 nrd=0 nrs=0 m=1
M28_noxref ( N_noxref_17_M28_noxref_d N_B_M28_noxref_g N_VDD_M27_noxref_d \
 noxref_421 ) PMOS l=0.15 w=2 ad=0.58 as=0.58 pd=2.58 ps=2.58 nrd=0 nrs=0 m=1
M29_noxref ( N_noxref_5_M29_noxref_d N_noxref_2_M29_noxref_g \
 N_noxref_17_M28_noxref_d noxref_421 ) PMOS l=0.15 w=2 ad=0.58 as=0.58 pd=2.58 \
 ps=2.58 nrd=0 nrs=0 m=1
M30_noxref ( N_noxref_17_M30_noxref_d N_noxref_2_M30_noxref_g \
 N_noxref_5_M29_noxref_d noxref_421 ) PMOS l=0.15 w=2 ad=0.56 as=0.56 pd=2.56 \
 ps=2.56 nrd=0 nrs=0 m=1
M31_noxref ( N_noxref_3_M31_noxref_d N_B_M31_noxref_g N_VDD_M31_noxref_s \
 noxref_421 ) PMOS l=0.15 w=2 ad=0.56 as=0.56 pd=2.56 ps=2.56 nrd=0 nrs=0 m=1
M32_noxref ( N_VDD_M32_noxref_d N_B_M32_noxref_g N_noxref_3_M31_noxref_d \
 noxref_421 ) PMOS l=0.15 w=2 ad=0.57 as=0.57 pd=2.57 ps=2.57 nrd=0 nrs=0 m=1
M33_noxref ( N_noxref_6_M33_noxref_d N_noxref_5_M33_noxref_g \
 N_VDD_M33_noxref_s noxref_421 ) PMOS l=0.15 w=2 ad=0.57 as=0.57 pd=2.57 \
 ps=2.57 nrd=0 nrs=0 m=1
M34_noxref ( N_VDD_M34_noxref_d N_noxref_5_M34_noxref_g \
 N_noxref_6_M33_noxref_d noxref_421 ) PMOS l=0.15 w=2 ad=0.56 as=0.56 pd=2.56 \
 ps=2.56 nrd=0 nrs=0 m=1
M35_noxref ( N_VDD_M35_noxref_d N_noxref_5_M35_noxref_g \
 N_noxref_18_M35_noxref_s noxref_421 ) PMOS l=0.15 w=2 ad=0.57 as=0.57 pd=2.57 \
 ps=2.57 nrd=0 nrs=0 m=1
M36_noxref ( N_noxref_18_M36_noxref_d N_noxref_5_M36_noxref_g \
 N_VDD_M35_noxref_d noxref_421 ) PMOS l=0.15 w=2 ad=0.58 as=0.58 pd=2.58 \
 ps=2.58 nrd=0 nrs=0 m=1
M37_noxref ( N_SUM_M37_noxref_d N_noxref_8_M37_noxref_g \
 N_noxref_18_M36_noxref_d noxref_421 ) PMOS l=0.15 w=2 ad=0.58 as=0.58 pd=2.58 \
 ps=2.58 nrd=0 nrs=0 m=1
M38_noxref ( N_noxref_18_M38_noxref_d N_noxref_8_M38_noxref_g \
 N_SUM_M37_noxref_d noxref_421 ) PMOS l=0.15 w=2 ad=0.56 as=0.56 pd=2.56 \
 ps=2.56 nrd=0 nrs=0 m=1
M39_noxref ( N_VDD_M39_noxref_d N_CIN_M39_noxref_g N_noxref_19_M39_noxref_s \
 noxref_421 ) PMOS l=0.15 w=2 ad=0.57 as=0.57 pd=2.57 ps=2.57 nrd=0 nrs=0 m=1
M40_noxref ( N_noxref_19_M40_noxref_d N_CIN_M40_noxref_g N_VDD_M39_noxref_d \
 noxref_421 ) PMOS l=0.15 w=2 ad=0.58 as=0.58 pd=2.58 ps=2.58 nrd=0 nrs=0 m=1
M41_noxref ( N_SUM_M41_noxref_d N_noxref_6_M41_noxref_g \
 N_noxref_19_M40_noxref_d noxref_421 ) PMOS l=0.15 w=2 ad=0.58 as=0.58 pd=2.58 \
 ps=2.58 nrd=0 nrs=0 m=1
M42_noxref ( N_noxref_19_M42_noxref_d N_noxref_6_M42_noxref_g \
 N_SUM_M41_noxref_d noxref_421 ) PMOS l=0.15 w=2 ad=0.56 as=0.56 pd=2.56 \
 ps=2.56 nrd=0 nrs=0 m=1
M43_noxref ( N_noxref_8_M43_noxref_d N_CIN_M43_noxref_g N_VDD_M43_noxref_s \
 noxref_421 ) PMOS l=0.15 w=2 ad=0.56 as=0.56 pd=2.56 ps=2.56 nrd=0 nrs=0 m=1
M44_noxref ( N_VDD_M44_noxref_d N_CIN_M44_noxref_g N_noxref_8_M43_noxref_d \
 noxref_421 ) PMOS l=0.15 w=2 ad=0.57 as=0.57 pd=2.57 ps=2.57 nrd=0 nrs=0 m=1
M45_noxref ( N_noxref_10_M45_noxref_d N_CIN_M45_noxref_g N_VDD_M45_noxref_s \
 noxref_421 ) PMOS l=0.15 w=2 ad=0.57 as=0.57 pd=2.57 ps=2.57 nrd=0 nrs=0 m=1
M46_noxref ( N_VDD_M46_noxref_d N_CIN_M46_noxref_g N_noxref_10_M45_noxref_d \
 noxref_421 ) PMOS l=0.15 w=2 ad=0.58 as=0.58 pd=2.58 ps=2.58 nrd=0 nrs=0 m=1
M47_noxref ( N_noxref_10_M47_noxref_d N_noxref_5_M47_noxref_g \
 N_VDD_M46_noxref_d noxref_421 ) PMOS l=0.15 w=2 ad=0.58 as=0.58 pd=2.58 \
 ps=2.58 nrd=0 nrs=0 m=1
M48_noxref ( N_VDD_M48_noxref_d N_noxref_5_M48_noxref_g \
 N_noxref_10_M47_noxref_d noxref_421 ) PMOS l=0.15 w=2 ad=0.56 as=0.56 pd=2.56 \
 ps=2.56 nrd=0 nrs=0 m=1
M49_noxref ( N_noxref_12_M49_noxref_d N_noxref_10_M49_noxref_g \
 N_VDD_M49_noxref_s noxref_421 ) PMOS l=0.15 w=2 ad=0.57 as=0.57 pd=2.57 \
 ps=2.57 nrd=0 nrs=0 m=1
M50_noxref ( N_VDD_M50_noxref_d N_noxref_10_M50_noxref_g \
 N_noxref_12_M49_noxref_d noxref_421 ) PMOS l=0.15 w=2 ad=0.56 as=0.56 pd=2.56 \
 ps=2.56 nrd=0 nrs=0 m=1
M51_noxref ( N_noxref_11_M51_noxref_d N_B_M51_noxref_g N_VDD_M51_noxref_s \
 noxref_421 ) PMOS l=0.15 w=2 ad=0.57 as=0.57 pd=2.57 ps=2.57 nrd=0 nrs=0 m=1
M52_noxref ( N_VDD_M52_noxref_d N_B_M52_noxref_g N_noxref_11_M51_noxref_d \
 noxref_421 ) PMOS l=0.15 w=2 ad=0.58 as=0.58 pd=2.58 ps=2.58 nrd=0 nrs=0 m=1
M53_noxref ( N_noxref_11_M53_noxref_d N_A_M53_noxref_g N_VDD_M52_noxref_d \
 noxref_421 ) PMOS l=0.15 w=2 ad=0.58 as=0.58 pd=2.58 ps=2.58 nrd=0 nrs=0 m=1
M54_noxref ( N_VDD_M54_noxref_d N_A_M54_noxref_g N_noxref_11_M53_noxref_d \
 noxref_421 ) PMOS l=0.15 w=2 ad=0.56 as=0.56 pd=2.56 ps=2.56 nrd=0 nrs=0 m=1
M55_noxref ( N_noxref_13_M55_noxref_d N_noxref_11_M55_noxref_g \
 N_VDD_M55_noxref_s noxref_421 ) PMOS l=0.15 w=2 ad=0.57 as=0.57 pd=2.57 \
 ps=2.57 nrd=0 nrs=0 m=1
M56_noxref ( N_VDD_M56_noxref_d N_noxref_11_M56_noxref_g \
 N_noxref_13_M55_noxref_d noxref_421 ) PMOS l=0.15 w=2 ad=0.56 as=0.56 pd=2.56 \
 ps=2.56 nrd=0 nrs=0 m=1
M57_noxref ( N_VDD_M57_noxref_d N_noxref_12_M57_noxref_g \
 N_noxref_21_M57_noxref_s noxref_421 ) PMOS l=0.15 w=2 ad=0.57 as=0.57 pd=2.57 \
 ps=2.57 nrd=0 nrs=0 m=1
M58_noxref ( N_noxref_21_M58_noxref_d N_noxref_12_M58_noxref_g \
 N_VDD_M57_noxref_d noxref_421 ) PMOS l=0.15 w=2 ad=0.58 as=0.58 pd=2.58 \
 ps=2.58 nrd=0 nrs=0 m=1
M59_noxref ( N_noxref_14_M59_noxref_d N_noxref_13_M59_noxref_g \
 N_noxref_21_M58_noxref_d noxref_421 ) PMOS l=0.15 w=2 ad=0.58 as=0.58 pd=2.58 \
 ps=2.58 nrd=0 nrs=0 m=1
M60_noxref ( N_noxref_21_M60_noxref_d N_noxref_13_M60_noxref_g \
 N_noxref_14_M59_noxref_d noxref_421 ) PMOS l=0.15 w=2 ad=0.56 as=0.56 pd=2.56 \
 ps=2.56 nrd=0 nrs=0 m=1
M61_noxref ( N_COUT_M61_noxref_d N_noxref_14_M61_noxref_g N_VDD_M61_noxref_s \
 noxref_421 ) PMOS l=0.15 w=2 ad=0.57 as=0.57 pd=2.57 ps=2.57 nrd=0 nrs=0 m=1
M62_noxref ( N_VDD_M62_noxref_d N_noxref_14_M62_noxref_g N_COUT_M61_noxref_d \
 noxref_421 ) PMOS l=0.15 w=2 ad=0.56 as=0.56 pd=2.56 ps=2.56 nrd=0 nrs=0 m=1
//
include "/import/yukari1/lrburle/sky130RHBDlib/sky130_rhbd/pex/FA.pxi.spice"
//
ends FA
//
//
