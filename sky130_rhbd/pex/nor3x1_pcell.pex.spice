// File: nor3x1_pcell.spi.pex
// Created: Thu Jan 22 07:15:54 2026
// Program "Calibre xRC"
// Version "v2023.2_27.15"
// Nominal Temperature: 30C
// Circuit Temperature: 30C
//
simulator lang=spectre
subckt PM_NOR3X1_PCELL\%noxref_1 ( 9 23 37 51 64 68 80 )
c72 ( 80 0 ) capacitor c=0.102516f //x=0.56 //y=0.365
c73 ( 77 0 ) capacitor c=0.00591168f //x=3.605 //y=0
c74 ( 74 0 ) capacitor c=0.00591168f //x=2.635 //y=0
c75 ( 71 0 ) capacitor c=0.00591168f //x=1.665 //y=0
c76 ( 68 0 ) capacitor c=0.210231f //x=0.74 //y=0
c77 ( 64 0 ) capacitor c=0.253458f //x=4.07 //y=0
c78 ( 56 0 ) capacitor c=0.00932713f //x=3.605 //y=0.445
c79 ( 51 0 ) capacitor c=0.0149942f //x=3.52 //y=0.53
c80 ( 47 0 ) capacitor c=0.0253251f //x=3.52 //y=0
c81 ( 42 0 ) capacitor c=0.00726869f //x=2.635 //y=0.445
c82 ( 37 0 ) capacitor c=0.016156f //x=2.55 //y=0.53
c83 ( 33 0 ) capacitor c=0.0253251f //x=2.55 //y=0
c84 ( 28 0 ) capacitor c=0.00726869f //x=1.665 //y=0.445
c85 ( 23 0 ) capacitor c=0.0170849f //x=1.58 //y=0.53
c86 ( 21 0 ) capacitor c=0.025309f //x=1.58 //y=0
c87 ( 16 0 ) capacitor c=0.00739123f //x=0.695 //y=0.445
c88 ( 9 0 ) capacitor c=0.198045f //x=4.07 //y=0
r89 (  62 77 ) resistor r=2.94794 //w=0.34 //l=0.085 //layer=li \
 //thickness=0.1 //x=3.69 //y=0 //x2=3.605 //y2=0
r90 (  62 64 ) resistor r=13.6247 //w=0.357 //l=0.38 //layer=li \
 //thickness=0.1 //x=3.69 //y=0 //x2=4.07 //y2=0
r91 (  57 80 ) resistor r=5.4201 //w=0.17 //l=0.085 //layer=li //thickness=0.1 \
 //x=3.605 //y=0.615 //x2=3.605 //y2=0.53
r92 (  57 80 ) resistor r=18.139 //w=0.187 //l=0.265 //layer=li \
 //thickness=0.1 //x=3.605 //y=0.615 //x2=3.605 //y2=0.88
r93 (  56 80 ) resistor r=5.4201 //w=0.17 //l=0.085 //layer=li //thickness=0.1 \
 //x=3.605 //y=0.445 //x2=3.605 //y2=0.53
r94 (  55 77 ) resistor r=4.11603 //w=0.68 //l=0.17 //layer=li //thickness=0.1 \
 //x=3.605 //y=0.17 //x2=3.605 //y2=0
r95 (  55 56 ) resistor r=18.8235 //w=0.187 //l=0.275 //layer=li \
 //thickness=0.1 //x=3.605 //y=0.17 //x2=3.605 //y2=0.445
r96 (  52 80 ) resistor r=6.4 //w=0.17 //l=0.085 //layer=li //thickness=0.1 \
 //x=2.72 //y=0.53 //x2=2.635 //y2=0.53
r97 (  52 80 ) resistor r=27.3797 //w=0.187 //l=0.4 //layer=li //thickness=0.1 \
 //x=2.72 //y=0.53 //x2=3.12 //y2=0.53
r98 (  51 80 ) resistor r=1.40859 //w=0.34 //l=0.085 //layer=li \
 //thickness=0.1 //x=3.52 //y=0.53 //x2=3.605 //y2=0.53
r99 (  51 80 ) resistor r=27.3797 //w=0.187 //l=0.4 //layer=li //thickness=0.1 \
 //x=3.52 //y=0.53 //x2=3.12 //y2=0.53
r100 (  48 74 ) resistor r=2.94794 //w=0.34 //l=0.085 //layer=li \
 //thickness=0.1 //x=2.72 //y=0 //x2=2.635 //y2=0
r101 (  48 50 ) resistor r=8.60504 //w=0.357 //l=0.24 //layer=li \
 //thickness=0.1 //x=2.72 //y=0 //x2=2.96 //y2=0
r102 (  47 77 ) resistor r=2.94794 //w=0.34 //l=0.085 //layer=li \
 //thickness=0.1 //x=3.52 //y=0 //x2=3.605 //y2=0
r103 (  47 50 ) resistor r=20.0784 //w=0.357 //l=0.56 //layer=li \
 //thickness=0.1 //x=3.52 //y=0 //x2=2.96 //y2=0
r104 (  43 80 ) resistor r=6.4 //w=0.17 //l=0.085 //layer=li //thickness=0.1 \
 //x=2.635 //y=0.615 //x2=2.635 //y2=0.53
r105 (  43 80 ) resistor r=18.139 //w=0.187 //l=0.265 //layer=li \
 //thickness=0.1 //x=2.635 //y=0.615 //x2=2.635 //y2=0.88
r106 (  42 80 ) resistor r=6.4 //w=0.17 //l=0.085 //layer=li //thickness=0.1 \
 //x=2.635 //y=0.445 //x2=2.635 //y2=0.53
r107 (  41 74 ) resistor r=4.11603 //w=0.68 //l=0.17 //layer=li \
 //thickness=0.1 //x=2.635 //y=0.17 //x2=2.635 //y2=0
r108 (  41 42 ) resistor r=18.8235 //w=0.187 //l=0.275 //layer=li \
 //thickness=0.1 //x=2.635 //y=0.17 //x2=2.635 //y2=0.445
r109 (  38 80 ) resistor r=6.4 //w=0.17 //l=0.085 //layer=li //thickness=0.1 \
 //x=1.75 //y=0.53 //x2=1.665 //y2=0.53
r110 (  38 80 ) resistor r=27.3797 //w=0.187 //l=0.4 //layer=li \
 //thickness=0.1 //x=1.75 //y=0.53 //x2=2.15 //y2=0.53
r111 (  37 80 ) resistor r=6.4 //w=0.17 //l=0.085 //layer=li //thickness=0.1 \
 //x=2.55 //y=0.53 //x2=2.635 //y2=0.53
r112 (  37 80 ) resistor r=27.3797 //w=0.187 //l=0.4 //layer=li \
 //thickness=0.1 //x=2.55 //y=0.53 //x2=2.15 //y2=0.53
r113 (  34 71 ) resistor r=2.94794 //w=0.34 //l=0.085 //layer=li \
 //thickness=0.1 //x=1.75 //y=0 //x2=1.665 //y2=0
r114 (  34 36 ) resistor r=3.58543 //w=0.357 //l=0.1 //layer=li \
 //thickness=0.1 //x=1.75 //y=0 //x2=1.85 //y2=0
r115 (  33 74 ) resistor r=2.94794 //w=0.34 //l=0.085 //layer=li \
 //thickness=0.1 //x=2.55 //y=0 //x2=2.635 //y2=0
r116 (  33 36 ) resistor r=25.098 //w=0.357 //l=0.7 //layer=li //thickness=0.1 \
 //x=2.55 //y=0 //x2=1.85 //y2=0
r117 (  29 80 ) resistor r=6.4 //w=0.17 //l=0.085 //layer=li //thickness=0.1 \
 //x=1.665 //y=0.615 //x2=1.665 //y2=0.53
r118 (  29 80 ) resistor r=18.139 //w=0.187 //l=0.265 //layer=li \
 //thickness=0.1 //x=1.665 //y=0.615 //x2=1.665 //y2=0.88
r119 (  28 80 ) resistor r=6.4 //w=0.17 //l=0.085 //layer=li //thickness=0.1 \
 //x=1.665 //y=0.445 //x2=1.665 //y2=0.53
r120 (  27 71 ) resistor r=4.11603 //w=0.68 //l=0.17 //layer=li \
 //thickness=0.1 //x=1.665 //y=0.17 //x2=1.665 //y2=0
r121 (  27 28 ) resistor r=18.8235 //w=0.187 //l=0.275 //layer=li \
 //thickness=0.1 //x=1.665 //y=0.17 //x2=1.665 //y2=0.445
r122 (  24 80 ) resistor r=1.40859 //w=0.34 //l=0.085 //layer=li \
 //thickness=0.1 //x=0.78 //y=0.53 //x2=0.695 //y2=0.53
r123 (  24 80 ) resistor r=27.3797 //w=0.187 //l=0.4 //layer=li \
 //thickness=0.1 //x=0.78 //y=0.53 //x2=1.18 //y2=0.53
r124 (  23 80 ) resistor r=6.4 //w=0.17 //l=0.085 //layer=li //thickness=0.1 \
 //x=1.58 //y=0.53 //x2=1.665 //y2=0.53
r125 (  23 80 ) resistor r=27.3797 //w=0.187 //l=0.4 //layer=li \
 //thickness=0.1 //x=1.58 //y=0.53 //x2=1.18 //y2=0.53
r126 (  22 68 ) resistor r=2.94794 //w=0.34 //l=0.085 //layer=li \
 //thickness=0.1 //x=0.78 //y=0 //x2=0.695 //y2=0
r127 (  21 71 ) resistor r=2.94794 //w=0.34 //l=0.085 //layer=li \
 //thickness=0.1 //x=1.58 //y=0 //x2=1.665 //y2=0
r128 (  21 22 ) resistor r=28.6835 //w=0.357 //l=0.8 //layer=li \
 //thickness=0.1 //x=1.58 //y=0 //x2=0.78 //y2=0
r129 (  17 80 ) resistor r=5.4201 //w=0.17 //l=0.085 //layer=li \
 //thickness=0.1 //x=0.695 //y=0.615 //x2=0.695 //y2=0.53
r130 (  17 80 ) resistor r=41.4118 //w=0.187 //l=0.605 //layer=li \
 //thickness=0.1 //x=0.695 //y=0.615 //x2=0.695 //y2=1.22
r131 (  16 80 ) resistor r=5.4201 //w=0.17 //l=0.085 //layer=li \
 //thickness=0.1 //x=0.695 //y=0.445 //x2=0.695 //y2=0.53
r132 (  15 68 ) resistor r=4.11603 //w=0.68 //l=0.17 //layer=li \
 //thickness=0.1 //x=0.695 //y=0.17 //x2=0.695 //y2=0
r133 (  15 16 ) resistor r=18.8235 //w=0.187 //l=0.275 //layer=li \
 //thickness=0.1 //x=0.695 //y=0.17 //x2=0.695 //y2=0.445
r134 (  9 64 ) resistor r=3.1 //w=0.17 //l=0.51 //layer=mcon //count=3 \
 //x=4.07 //y=0 //x2=4.07 //y2=0
r135 (  7 50 ) resistor r=3.1 //w=0.17 //l=0.51 //layer=mcon //count=3 \
 //x=2.96 //y=0 //x2=2.96 //y2=0
r136 (  7 9 ) resistor r=0.460963 //w=0.301 //l=1.11 //layer=m1 \
 //thickness=0.36 //x=2.96 //y=0 //x2=4.07 //y2=0
r137 (  5 36 ) resistor r=3.1 //w=0.17 //l=0.51 //layer=mcon //count=3 \
 //x=1.85 //y=0 //x2=1.85 //y2=0
r138 (  5 7 ) resistor r=0.460963 //w=0.301 //l=1.11 //layer=m1 \
 //thickness=0.36 //x=1.85 //y=0 //x2=2.96 //y2=0
r139 (  2 68 ) resistor r=3.1 //w=0.17 //l=0.51 //layer=mcon //count=3 \
 //x=0.74 //y=0 //x2=0.74 //y2=0
r140 (  2 5 ) resistor r=0.460963 //w=0.301 //l=1.11 //layer=m1 \
 //thickness=0.36 //x=0.74 //y=0 //x2=1.85 //y2=0
ends PM_NOR3X1_PCELL\%noxref_1

subckt PM_NOR3X1_PCELL\%noxref_2 ( 1 3 5 10 14 17 20 30 46 47 48 )
c90 ( 48 0 ) capacitor c=0.0253852f //x=2.405 //y=5.025
c91 ( 46 0 ) capacitor c=0.0115693f //x=0.655 //y=5.025
c92 ( 30 0 ) capacitor c=0.0302586f //x=1.67 //y=5.38
c93 ( 20 0 ) capacitor c=0.0435973f //x=0.79 //y=5.38
c94 ( 17 0 ) capacitor c=0.00775965f //x=2.55 //y=6.74
c95 ( 14 0 ) capacitor c=0.00599877f //x=1.67 //y=6.74
c96 ( 10 0 ) capacitor c=0.0105983f //x=1.672 //y=5.21
c97 ( 5 0 ) capacitor c=0.0183603f //x=0.792 //y=5.21
c98 ( 3 0 ) capacitor c=0.00728543f //x=2.435 //y=6.91
c99 ( 1 0 ) capacitor c=0.0133332f //x=1.555 //y=5.21
r100 (  37 47 ) resistor r=23.2727 //w=0.187 //l=0.34 //layer=li \
 //thickness=0.1 //x=1.67 //y=6.74 //x2=1.67 //y2=6.4
r101 (  30 47 ) resistor r=23.2727 //w=0.187 //l=0.34 //layer=li \
 //thickness=0.1 //x=1.67 //y=5.38 //x2=1.67 //y2=5.72
r102 (  20 46 ) resistor r=23.2727 //w=0.187 //l=0.34 //layer=li \
 //thickness=0.1 //x=0.79 //y=5.38 //x2=0.79 //y2=5.72
r103 (  17 48 ) resistor r=9.3 //w=0.17 //l=0.17 //layer=mcon //count=1 \
 //x=2.55 //y=6.74 //x2=2.55 //y2=6.74
r104 (  17 18 ) resistor r=0.0983796 //w=0.216 //l=0.17 //layer=m1 \
 //thickness=0.36 //x=2.552 //y=6.74 //x2=2.552 //y2=6.91
r105 (  14 37 ) resistor r=9.3 //w=0.17 //l=0.17 //layer=mcon //count=1 \
 //x=1.67 //y=6.74 //x2=1.67 //y2=6.74
r106 (  14 15 ) resistor r=0.0979263 //w=0.217 //l=0.17 //layer=m1 \
 //thickness=0.36 //x=1.672 //y=6.74 //x2=1.672 //y2=6.91
r107 (  12 30 ) resistor r=9.3 //w=0.17 //l=0.17 //layer=mcon //count=1 \
 //x=1.67 //y=5.38 //x2=1.67 //y2=5.38
r108 (  10 12 ) resistor r=0.0983796 //w=0.216 //l=0.17 //layer=m1 \
 //thickness=0.36 //x=1.672 //y=5.21 //x2=1.672 //y2=5.38
r109 (  7 20 ) resistor r=9.3 //w=0.17 //l=0.17 //layer=mcon //count=1 \
 //x=0.79 //y=5.38 //x2=0.79 //y2=5.38
r110 (  5 7 ) resistor r=0.0940266 //w=0.226 //l=0.17 //layer=m1 \
 //thickness=0.36 //x=0.792 //y=5.21 //x2=0.792 //y2=5.38
r111 (  4 15 ) resistor r=0.0222262 //w=0.217 //l=0.118 //layer=m1 \
 //thickness=0.36 //x=1.79 //y=6.91 //x2=1.672 //y2=6.91
r112 (  3 18 ) resistor r=0.0219491 //w=0.216 //l=0.117 //layer=m1 \
 //thickness=0.36 //x=2.435 //y=6.91 //x2=2.552 //y2=6.91
r113 (  3 4 ) resistor r=0.615458 //w=0.131 //l=0.645 //layer=m1 \
 //thickness=0.36 //x=2.435 //y=6.91 //x2=1.79 //y2=6.91
r114 (  2 5 ) resistor r=0.0246599 //w=0.226 //l=0.123 //layer=m1 \
 //thickness=0.36 //x=0.915 //y=5.21 //x2=0.792 //y2=5.21
r115 (  1 10 ) resistor r=0.0219491 //w=0.216 //l=0.117 //layer=m1 \
 //thickness=0.36 //x=1.555 //y=5.21 //x2=1.672 //y2=5.21
r116 (  1 2 ) resistor r=0.610687 //w=0.131 //l=0.64 //layer=m1 \
 //thickness=0.36 //x=1.555 //y=5.21 //x2=0.915 //y2=5.21
ends PM_NOR3X1_PCELL\%noxref_2

subckt PM_NOR3X1_PCELL\%noxref_3 ( 1 2 4 9 14 18 19 20 21 22 23 24 28 30 33 35 \
 36 41 )
c112 ( 41 0 ) capacitor c=0.0426712f //x=0.955 //y=4.705
c113 ( 36 0 ) capacitor c=0.0337825f //x=1.445 //y=1.25
c114 ( 35 0 ) capacitor c=0.0185904f //x=1.445 //y=0.905
c115 ( 33 0 ) capacitor c=0.0351114f //x=1.375 //y=4.795
c116 ( 30 0 ) capacitor c=0.013578f //x=1.29 //y=1.405
c117 ( 28 0 ) capacitor c=0.0157807f //x=1.29 //y=0.75
c118 ( 24 0 ) capacitor c=0.0843978f //x=0.915 //y=1.915
c119 ( 23 0 ) capacitor c=0.0230165f //x=0.915 //y=1.56
c120 ( 22 0 ) capacitor c=0.0234348f //x=0.915 //y=1.25
c121 ( 21 0 ) capacitor c=0.0192379f //x=0.915 //y=0.905
c122 ( 20 0 ) capacitor c=0.110994f //x=1.45 //y=6.025
c123 ( 19 0 ) capacitor c=0.154777f //x=1.01 //y=6.025
c124 ( 14 0 ) capacitor c=0.00174733f //x=1.11 //y=2.08
c125 ( 9 0 ) capacitor c=0.00712197f //x=0.955 //y=4.705
c126 ( 4 0 ) capacitor c=0.0160301f //x=0.955 //y=4.705
c127 ( 2 0 ) capacitor c=0.110591f //x=1.11 //y=4.585
c128 ( 1 0 ) capacitor c=0.0130531f //x=1.11 //y=2.245
r129 (  43 44 ) resistor r=32.4568 //w=0.214 //l=0.075 //layer=ply \
 //thickness=0.18 //x=0.955 //y=4.795 //x2=0.955 //y2=4.87
r130 (  41 43 ) resistor r=20.271 //w=0.214 //l=0.09 //layer=ply \
 //thickness=0.18 //x=0.955 //y=4.705 //x2=0.955 //y2=4.795
r131 (  36 50 ) resistor r=45.1352 //w=0.168 //l=0.173853 //layer=ply \
 //thickness=0.18 //x=1.445 //y=1.25 //x2=1.405 //y2=1.405
r132 (  35 49 ) resistor r=45.1352 //w=0.168 //l=0.173853 //layer=ply \
 //thickness=0.18 //x=1.445 //y=0.905 //x2=1.405 //y2=0.75
r133 (  35 36 ) resistor r=176.904 //w=0.094 //l=0.345 //layer=ply \
 //thickness=0.18 //x=1.445 //y=0.905 //x2=1.445 //y2=1.25
r134 (  34 43 ) resistor r=16.5046 //w=0.27 //l=0.135 //layer=ply \
 //thickness=0.18 //x=1.09 //y=4.795 //x2=0.955 //y2=4.795
r135 (  33 37 ) resistor r=26.9307 //w=0.15 //l=0.106066 //layer=ply \
 //thickness=0.18 //x=1.375 //y=4.795 //x2=1.45 //y2=4.87
r136 (  33 34 ) resistor r=146.138 //w=0.094 //l=0.285 //layer=ply \
 //thickness=0.18 //x=1.375 //y=4.795 //x2=1.09 //y2=4.795
r137 (  31 48 ) resistor r=10.701 //w=0.21 //l=0.115 //layer=ply \
 //thickness=0.18 //x=1.07 //y=1.405 //x2=0.955 //y2=1.405
r138 (  30 50 ) resistor r=5.52526 //w=0.168 //l=0.115 //layer=ply \
 //thickness=0.18 //x=1.29 //y=1.405 //x2=1.405 //y2=1.405
r139 (  29 47 ) resistor r=5.52526 //w=0.168 //l=0.115 //layer=ply \
 //thickness=0.18 //x=1.07 //y=0.75 //x2=0.955 //y2=0.75
r140 (  28 49 ) resistor r=5.52526 //w=0.168 //l=0.115 //layer=ply \
 //thickness=0.18 //x=1.29 //y=0.75 //x2=1.405 //y2=0.75
r141 (  28 29 ) resistor r=112.809 //w=0.094 //l=0.22 //layer=ply \
 //thickness=0.18 //x=1.29 //y=0.75 //x2=1.07 //y2=0.75
r142 (  24 46 ) resistor r=34.8111 //w=0.27 //l=0.264953 //layer=ply \
 //thickness=0.18 //x=0.915 //y=1.915 //x2=1.11 //y2=2.08
r143 (  23 48 ) resistor r=39.5823 //w=0.21 //l=0.173853 //layer=ply \
 //thickness=0.18 //x=0.915 //y=1.56 //x2=0.955 //y2=1.405
r144 (  23 24 ) resistor r=182.032 //w=0.094 //l=0.355 //layer=ply \
 //thickness=0.18 //x=0.915 //y=1.56 //x2=0.915 //y2=1.915
r145 (  22 48 ) resistor r=39.5823 //w=0.21 //l=0.173853 //layer=ply \
 //thickness=0.18 //x=0.915 //y=1.25 //x2=0.955 //y2=1.405
r146 (  21 47 ) resistor r=45.1352 //w=0.168 //l=0.173853 //layer=ply \
 //thickness=0.18 //x=0.915 //y=0.905 //x2=0.955 //y2=0.75
r147 (  21 22 ) resistor r=176.904 //w=0.094 //l=0.345 //layer=ply \
 //thickness=0.18 //x=0.915 //y=0.905 //x2=0.915 //y2=1.25
r148 (  20 37 ) resistor r=592.245 //w=0.094 //l=1.155 //layer=ply \
 //thickness=0.18 //x=1.45 //y=6.025 //x2=1.45 //y2=4.87
r149 (  19 44 ) resistor r=592.245 //w=0.094 //l=1.155 //layer=ply \
 //thickness=0.18 //x=1.01 //y=6.025 //x2=1.01 //y2=4.87
r150 (  18 30 ) resistor r=56.4043 //w=0.094 //l=0.11 //layer=ply \
 //thickness=0.18 //x=1.18 //y=1.405 //x2=1.29 //y2=1.405
r151 (  18 31 ) resistor r=56.4043 //w=0.094 //l=0.11 //layer=ply \
 //thickness=0.18 //x=1.18 //y=1.405 //x2=1.07 //y2=1.405
r152 (  14 46 ) resistor r=152 //w=0.17 //l=0.17 //layer=licon //count=1 \
 //x=1.11 //y=2.08 //x2=1.11 //y2=2.08
r153 (  9 41 ) resistor r=152 //w=0.17 //l=0.17 //layer=licon //count=1 \
 //x=0.955 //y=4.705 //x2=0.955 //y2=4.705
r154 (  7 14 ) resistor r=9.3 //w=0.17 //l=0.17 //layer=mcon //count=1 \
 //x=1.11 //y=2.08 //x2=1.11 //y2=2.08
r155 (  4 9 ) resistor r=9.3 //w=0.17 //l=0.17 //layer=mcon //count=1 \
 //x=0.955 //y=4.705 //x2=0.955 //y2=4.705
r156 (  4 5 ) resistor r=0.0905374 //w=0.214 //l=0.155 //layer=m1 \
 //thickness=0.36 //x=0.955 //y=4.702 //x2=1.11 //y2=4.702
r157 (  2 5 ) resistor r=0.0213909 //w=0.214 //l=0.117 //layer=m1 \
 //thickness=0.36 //x=1.11 //y=4.585 //x2=1.11 //y2=4.702
r158 (  1 7 ) resistor r=0.0957534 //w=0.247 //l=0.165 //layer=m1 \
 //thickness=0.36 //x=1.11 //y=2.245 //x2=1.11 //y2=2.08
r159 (  1 2 ) resistor r=2.23282 //w=0.131 //l=2.34 //layer=m1 \
 //thickness=0.36 //x=1.11 //y=2.245 //x2=1.11 //y2=4.585
ends PM_NOR3X1_PCELL\%noxref_3

subckt PM_NOR3X1_PCELL\%noxref_4 ( 1 5 6 13 23 29 39 )
c74 ( 39 0 ) capacitor c=0.0229259f //x=1.085 //y=5.025
c75 ( 29 0 ) capacitor c=0.420724f //x=4.07 //y=7.4
c76 ( 23 0 ) capacitor c=0.211144f //x=0.74 //y=7.4
c77 ( 15 0 ) capacitor c=0.00498911f //x=1.23 //y=7.4
c78 ( 13 0 ) capacitor c=0.130872f //x=4.07 //y=7.4
c79 ( 6 0 ) capacitor c=0.00987753f //x=1.23 //y=7.23
c80 ( 5 0 ) capacitor c=0.00592383f //x=1.23 //y=6.855
c81 ( 1 0 ) capacitor c=0.061236f //x=1.145 //y=7.4
r82 (  27 29 ) resistor r=39.7983 //w=0.357 //l=1.11 //layer=li \
 //thickness=0.1 //x=2.96 //y=7.4 //x2=4.07 //y2=7.4
r83 (  25 27 ) resistor r=39.7983 //w=0.357 //l=1.11 //layer=li \
 //thickness=0.1 //x=1.85 //y=7.4 //x2=2.96 //y2=7.4
r84 (  23 25 ) resistor r=39.7983 //w=0.357 //l=1.11 //layer=li \
 //thickness=0.1 //x=0.74 //y=7.4 //x2=1.85 //y2=7.4
r85 (  17 39 ) resistor r=9.3 //w=0.17 //l=0.17 //layer=mcon //count=1 \
 //x=1.23 //y=6.74 //x2=1.23 //y2=6.74
r86 (  13 29 ) resistor r=3.1 //w=0.17 //l=0.51 //layer=mcon //count=3 \
 //x=4.07 //y=7.4 //x2=4.07 //y2=7.4
r87 (  11 27 ) resistor r=3.1 //w=0.17 //l=0.51 //layer=mcon //count=3 \
 //x=2.96 //y=7.4 //x2=2.96 //y2=7.4
r88 (  11 13 ) resistor r=0.460963 //w=0.301 //l=1.11 //layer=m1 \
 //thickness=0.36 //x=2.96 //y=7.4 //x2=4.07 //y2=7.4
r89 (  9 25 ) resistor r=3.1 //w=0.17 //l=0.51 //layer=mcon //count=3 //x=1.85 \
 //y=7.4 //x2=1.85 //y2=7.4
r90 (  9 11 ) resistor r=0.460963 //w=0.301 //l=1.11 //layer=m1 \
 //thickness=0.36 //x=1.85 //y=7.4 //x2=2.96 //y2=7.4
r91 (  7 15 ) resistor r=0.0287885 //w=0.34 //l=0.085 //layer=m1 \
 //thickness=0.36 //x=1.315 //y=7.4 //x2=1.23 //y2=7.4
r92 (  7 9 ) resistor r=0.222176 //w=0.301 //l=0.535 //layer=m1 \
 //thickness=0.36 //x=1.315 //y=7.4 //x2=1.85 //y2=7.4
r93 (  6 15 ) resistor r=0.0401957 //w=0.68 //l=0.17 //layer=m1 \
 //thickness=0.36 //x=1.23 //y=7.23 //x2=1.23 //y2=7.4
r94 (  5 17 ) resistor r=0.0722282 //w=0.219 //l=0.115 //layer=m1 \
 //thickness=0.36 //x=1.23 //y=6.855 //x2=1.23 //y2=6.74
r95 (  5 6 ) resistor r=0.357824 //w=0.131 //l=0.375 //layer=m1 \
 //thickness=0.36 //x=1.23 //y=6.855 //x2=1.23 //y2=7.23
r96 (  3 23 ) resistor r=3.1 //w=0.17 //l=0.51 //layer=mcon //count=3 //x=0.74 \
 //y=7.4 //x2=0.74 //y2=7.4
r97 (  1 15 ) resistor r=0.0287885 //w=0.34 //l=0.085 //layer=m1 \
 //thickness=0.36 //x=1.145 //y=7.4 //x2=1.23 //y2=7.4
r98 (  1 3 ) resistor r=0.168189 //w=0.301 //l=0.405 //layer=m1 \
 //thickness=0.36 //x=1.145 //y=7.4 //x2=0.74 //y2=7.4
ends PM_NOR3X1_PCELL\%noxref_4

subckt PM_NOR3X1_PCELL\%noxref_5 ( 1 2 8 13 17 18 19 20 21 22 27 29 31 37 38 \
 40 41 44 )
c128 ( 44 0 ) capacitor c=0.0385046f //x=1.885 //y=4.705
c129 ( 41 0 ) capacitor c=0.0266377f //x=1.85 //y=1.915
c130 ( 40 0 ) capacitor c=0.0431872f //x=1.85 //y=2.08
c131 ( 38 0 ) capacitor c=0.0170969f //x=2.415 //y=1.255
c132 ( 37 0 ) capacitor c=0.0176979f //x=2.415 //y=0.905
c133 ( 31 0 ) capacitor c=0.0323332f //x=2.26 //y=1.405
c134 ( 29 0 ) capacitor c=0.0157807f //x=2.26 //y=0.75
c135 ( 27 0 ) capacitor c=0.0338349f //x=2.255 //y=4.795
c136 ( 22 0 ) capacitor c=0.0194854f //x=1.885 //y=1.56
c137 ( 21 0 ) capacitor c=0.0169638f //x=1.885 //y=1.255
c138 ( 20 0 ) capacitor c=0.0177156f //x=1.885 //y=0.905
c139 ( 19 0 ) capacitor c=0.140843f //x=2.33 //y=6.025
c140 ( 18 0 ) capacitor c=0.110534f //x=1.89 //y=6.025
c141 ( 13 0 ) capacitor c=0.0016164f //x=1.885 //y=4.705
c142 ( 8 0 ) capacitor c=0.00179873f //x=1.85 //y=2.08
c143 ( 2 0 ) capacitor c=0.0775924f //x=1.85 //y=4.56
c144 ( 1 0 ) capacitor c=0.00671238f //x=1.85 //y=2.21
r145 (  46 47 ) resistor r=32.4568 //w=0.214 //l=0.075 //layer=ply \
 //thickness=0.18 //x=1.885 //y=4.795 //x2=1.885 //y2=4.87
r146 (  44 46 ) resistor r=20.271 //w=0.214 //l=0.09 //layer=ply \
 //thickness=0.18 //x=1.885 //y=4.705 //x2=1.885 //y2=4.795
r147 (  40 41 ) resistor r=52.7279 //w=0.214 //l=0.165 //layer=ply \
 //thickness=0.18 //x=1.85 //y=2.08 //x2=1.85 //y2=1.915
r148 (  38 51 ) resistor r=4.95774 //w=0.164 //l=0.112 //layer=ply \
 //thickness=0.18 //x=2.415 //y=1.255 //x2=2.415 //y2=1.367
r149 (  37 50 ) resistor r=45.1352 //w=0.168 //l=0.173853 //layer=ply \
 //thickness=0.18 //x=2.415 //y=0.905 //x2=2.375 //y2=0.75
r150 (  37 38 ) resistor r=179.468 //w=0.094 //l=0.35 //layer=ply \
 //thickness=0.18 //x=2.415 //y=0.905 //x2=2.415 //y2=1.255
r151 (  32 49 ) resistor r=10.8103 //w=0.211 //l=0.115 //layer=ply \
 //thickness=0.18 //x=2.04 //y=1.405 //x2=1.925 //y2=1.405
r152 (  31 51 ) resistor r=45.9962 //w=0.164 //l=0.17296 //layer=ply \
 //thickness=0.18 //x=2.26 //y=1.405 //x2=2.415 //y2=1.367
r153 (  30 48 ) resistor r=5.52526 //w=0.168 //l=0.115 //layer=ply \
 //thickness=0.18 //x=2.04 //y=0.75 //x2=1.925 //y2=0.75
r154 (  29 50 ) resistor r=5.52526 //w=0.168 //l=0.115 //layer=ply \
 //thickness=0.18 //x=2.26 //y=0.75 //x2=2.375 //y2=0.75
r155 (  29 30 ) resistor r=112.809 //w=0.094 //l=0.22 //layer=ply \
 //thickness=0.18 //x=2.26 //y=0.75 //x2=2.04 //y2=0.75
r156 (  28 46 ) resistor r=16.5046 //w=0.27 //l=0.135 //layer=ply \
 //thickness=0.18 //x=2.02 //y=4.795 //x2=1.885 //y2=4.795
r157 (  27 34 ) resistor r=26.9307 //w=0.15 //l=0.106066 //layer=ply \
 //thickness=0.18 //x=2.255 //y=4.795 //x2=2.33 //y2=4.87
r158 (  27 28 ) resistor r=120.5 //w=0.094 //l=0.235 //layer=ply \
 //thickness=0.18 //x=2.255 //y=4.795 //x2=2.02 //y2=4.795
r159 (  22 49 ) resistor r=39.5036 //w=0.211 //l=0.173853 //layer=ply \
 //thickness=0.18 //x=1.885 //y=1.56 //x2=1.925 //y2=1.405
r160 (  22 41 ) resistor r=182.032 //w=0.094 //l=0.355 //layer=ply \
 //thickness=0.18 //x=1.885 //y=1.56 //x2=1.885 //y2=1.915
r161 (  21 49 ) resistor r=38.3614 //w=0.211 //l=0.168819 //layer=ply \
 //thickness=0.18 //x=1.885 //y=1.255 //x2=1.925 //y2=1.405
r162 (  20 48 ) resistor r=45.1352 //w=0.168 //l=0.173853 //layer=ply \
 //thickness=0.18 //x=1.885 //y=0.905 //x2=1.925 //y2=0.75
r163 (  20 21 ) resistor r=179.468 //w=0.094 //l=0.35 //layer=ply \
 //thickness=0.18 //x=1.885 //y=0.905 //x2=1.885 //y2=1.255
r164 (  19 34 ) resistor r=592.245 //w=0.094 //l=1.155 //layer=ply \
 //thickness=0.18 //x=2.33 //y=6.025 //x2=2.33 //y2=4.87
r165 (  18 47 ) resistor r=592.245 //w=0.094 //l=1.155 //layer=ply \
 //thickness=0.18 //x=1.89 //y=6.025 //x2=1.89 //y2=4.87
r166 (  17 31 ) resistor r=56.4043 //w=0.094 //l=0.11 //layer=ply \
 //thickness=0.18 //x=2.15 //y=1.405 //x2=2.26 //y2=1.405
r167 (  17 32 ) resistor r=56.4043 //w=0.094 //l=0.11 //layer=ply \
 //thickness=0.18 //x=2.15 //y=1.405 //x2=2.04 //y2=1.405
r168 (  13 44 ) resistor r=152 //w=0.17 //l=0.17 //layer=licon //count=1 \
 //x=1.885 //y=4.705 //x2=1.885 //y2=4.705
r169 (  8 40 ) resistor r=152 //w=0.17 //l=0.17 //layer=licon //count=1 \
 //x=1.85 //y=2.08 //x2=1.85 //y2=2.08
r170 (  6 13 ) resistor r=9.3 //w=0.17 //l=0.17 //layer=mcon //count=1 \
 //x=1.885 //y=4.705 //x2=1.885 //y2=4.705
r171 (  4 8 ) resistor r=9.3 //w=0.17 //l=0.17 //layer=mcon //count=1 //x=1.85 \
 //y=2.08 //x2=1.85 //y2=2.08
r172 (  2 6 ) resistor r=0.0875652 //w=0.23 //l=0.161555 //layer=m1 \
 //thickness=0.36 //x=1.85 //y=4.56 //x2=1.885 //y2=4.705
r173 (  1 4 ) resistor r=0.078924 //w=0.235 //l=0.131491 //layer=m1 \
 //thickness=0.36 //x=1.85 //y=2.21 //x2=1.847 //y2=2.08
r174 (  1 2 ) resistor r=2.24237 //w=0.131 //l=2.35 //layer=m1 \
 //thickness=0.36 //x=1.85 //y=2.21 //x2=1.85 //y2=4.56
ends PM_NOR3X1_PCELL\%noxref_5

subckt PM_NOR3X1_PCELL\%noxref_6 ( 1 2 8 13 17 18 19 20 21 22 23 24 26 29 34 \
 35 36 41 45 )
c104 ( 51 0 ) capacitor c=0.011077f //x=3.37 //y=4.795
c105 ( 45 0 ) capacitor c=0.0475417f //x=2.96 //y=4.705
c106 ( 41 0 ) capacitor c=0.053123f //x=2.855 //y=2.08
c107 ( 36 0 ) capacitor c=0.0378324f //x=3.735 //y=4.795
c108 ( 35 0 ) capacitor c=0.0237765f //x=3.385 //y=1.255
c109 ( 34 0 ) capacitor c=0.0192157f //x=3.385 //y=0.905
c110 ( 29 0 ) capacitor c=0.0202474f //x=3.295 //y=4.795
c111 ( 26 0 ) capacitor c=0.0344387f //x=3.23 //y=1.405
c112 ( 24 0 ) capacitor c=0.0157807f //x=3.23 //y=0.75
c113 ( 23 0 ) capacitor c=0.0293304f //x=2.855 //y=1.915
c114 ( 22 0 ) capacitor c=0.0194031f //x=2.855 //y=1.56
c115 ( 21 0 ) capacitor c=0.0170969f //x=2.855 //y=1.255
c116 ( 20 0 ) capacitor c=0.0185784f //x=2.855 //y=0.905
c117 ( 19 0 ) capacitor c=0.155498f //x=3.81 //y=6.025
c118 ( 18 0 ) capacitor c=0.140775f //x=3.37 //y=6.025
c119 ( 13 0 ) capacitor c=9.4399e-19 //x=2.96 //y=4.705
c120 ( 8 0 ) capacitor c=9.1262e-19 //x=2.96 //y=2.08
c121 ( 2 0 ) capacitor c=0.0775717f //x=2.96 //y=4.585
c122 ( 1 0 ) capacitor c=0.00606585f //x=2.96 //y=2.225
r123 (  45 47 ) resistor r=20.271 //w=0.214 //l=0.09 //layer=ply \
 //thickness=0.18 //x=2.96 //y=4.705 //x2=2.96 //y2=4.795
r124 (  41 43 ) resistor r=16.5934 //w=0.305 //l=0.105 //layer=ply \
 //thickness=0.18 //x=2.855 //y=2.08 //x2=2.96 //y2=2.08
r125 (  37 51 ) resistor r=20.4101 //w=0.15 //l=0.075 //layer=ply \
 //thickness=0.18 //x=3.445 //y=4.795 //x2=3.37 //y2=4.795
r126 (  36 38 ) resistor r=26.9307 //w=0.15 //l=0.106066 //layer=ply \
 //thickness=0.18 //x=3.735 //y=4.795 //x2=3.81 //y2=4.87
r127 (  36 37 ) resistor r=148.702 //w=0.094 //l=0.29 //layer=ply \
 //thickness=0.18 //x=3.735 //y=4.795 //x2=3.445 //y2=4.795
r128 (  35 53 ) resistor r=4.95774 //w=0.164 //l=0.112 //layer=ply \
 //thickness=0.18 //x=3.385 //y=1.255 //x2=3.385 //y2=1.367
r129 (  34 52 ) resistor r=45.1352 //w=0.168 //l=0.173853 //layer=ply \
 //thickness=0.18 //x=3.385 //y=0.905 //x2=3.345 //y2=0.75
r130 (  34 35 ) resistor r=179.468 //w=0.094 //l=0.35 //layer=ply \
 //thickness=0.18 //x=3.385 //y=0.905 //x2=3.385 //y2=1.255
r131 (  31 51 ) resistor r=5.30422 //w=0.3 //l=0.075 //layer=ply \
 //thickness=0.18 //x=3.37 //y=4.87 //x2=3.37 //y2=4.795
r132 (  30 47 ) resistor r=16.5046 //w=0.27 //l=0.135 //layer=ply \
 //thickness=0.18 //x=3.095 //y=4.795 //x2=2.96 //y2=4.795
r133 (  29 51 ) resistor r=20.4101 //w=0.15 //l=0.075 //layer=ply \
 //thickness=0.18 //x=3.295 //y=4.795 //x2=3.37 //y2=4.795
r134 (  29 30 ) resistor r=102.553 //w=0.094 //l=0.2 //layer=ply \
 //thickness=0.18 //x=3.295 //y=4.795 //x2=3.095 //y2=4.795
r135 (  27 50 ) resistor r=10.8103 //w=0.211 //l=0.115 //layer=ply \
 //thickness=0.18 //x=3.01 //y=1.405 //x2=2.895 //y2=1.405
r136 (  26 53 ) resistor r=45.9962 //w=0.164 //l=0.17296 //layer=ply \
 //thickness=0.18 //x=3.23 //y=1.405 //x2=3.385 //y2=1.367
r137 (  25 49 ) resistor r=5.52526 //w=0.168 //l=0.115 //layer=ply \
 //thickness=0.18 //x=3.01 //y=0.75 //x2=2.895 //y2=0.75
r138 (  24 52 ) resistor r=5.52526 //w=0.168 //l=0.115 //layer=ply \
 //thickness=0.18 //x=3.23 //y=0.75 //x2=3.345 //y2=0.75
r139 (  24 25 ) resistor r=112.809 //w=0.094 //l=0.22 //layer=ply \
 //thickness=0.18 //x=3.23 //y=0.75 //x2=3.01 //y2=0.75
r140 (  23 41 ) resistor r=19.3576 //w=0.305 //l=0.165 //layer=ply \
 //thickness=0.18 //x=2.855 //y=1.915 //x2=2.855 //y2=2.08
r141 (  22 50 ) resistor r=39.5036 //w=0.211 //l=0.173853 //layer=ply \
 //thickness=0.18 //x=2.855 //y=1.56 //x2=2.895 //y2=1.405
r142 (  22 23 ) resistor r=182.032 //w=0.094 //l=0.355 //layer=ply \
 //thickness=0.18 //x=2.855 //y=1.56 //x2=2.855 //y2=1.915
r143 (  21 50 ) resistor r=38.3614 //w=0.211 //l=0.168819 //layer=ply \
 //thickness=0.18 //x=2.855 //y=1.255 //x2=2.895 //y2=1.405
r144 (  20 49 ) resistor r=45.1352 //w=0.168 //l=0.173853 //layer=ply \
 //thickness=0.18 //x=2.855 //y=0.905 //x2=2.895 //y2=0.75
r145 (  20 21 ) resistor r=179.468 //w=0.094 //l=0.35 //layer=ply \
 //thickness=0.18 //x=2.855 //y=0.905 //x2=2.855 //y2=1.255
r146 (  19 38 ) resistor r=592.245 //w=0.094 //l=1.155 //layer=ply \
 //thickness=0.18 //x=3.81 //y=6.025 //x2=3.81 //y2=4.87
r147 (  18 31 ) resistor r=592.245 //w=0.094 //l=1.155 //layer=ply \
 //thickness=0.18 //x=3.37 //y=6.025 //x2=3.37 //y2=4.87
r148 (  17 26 ) resistor r=56.4043 //w=0.094 //l=0.11 //layer=ply \
 //thickness=0.18 //x=3.12 //y=1.405 //x2=3.23 //y2=1.405
r149 (  17 27 ) resistor r=56.4043 //w=0.094 //l=0.11 //layer=ply \
 //thickness=0.18 //x=3.12 //y=1.405 //x2=3.01 //y2=1.405
r150 (  13 45 ) resistor r=152 //w=0.17 //l=0.17 //layer=licon //count=1 \
 //x=2.96 //y=4.705 //x2=2.96 //y2=4.705
r151 (  8 43 ) resistor r=152 //w=0.17 //l=0.17 //layer=licon //count=1 \
 //x=2.96 //y=2.08 //x2=2.96 //y2=2.08
r152 (  6 13 ) resistor r=9.3 //w=0.17 //l=0.17 //layer=mcon //count=1 \
 //x=2.96 //y=4.705 //x2=2.96 //y2=4.705
r153 (  4 8 ) resistor r=9.3 //w=0.17 //l=0.17 //layer=mcon //count=1 //x=2.96 \
 //y=2.08 //x2=2.96 //y2=2.08
r154 (  2 6 ) resistor r=0.0744285 //w=0.225 //l=0.12 //layer=m1 \
 //thickness=0.36 //x=2.96 //y=4.585 //x2=2.96 //y2=4.705
r155 (  1 4 ) resistor r=0.0864318 //w=0.239 //l=0.146492 //layer=m1 \
 //thickness=0.36 //x=2.96 //y=2.225 //x2=2.957 //y2=2.08
r156 (  1 2 ) resistor r=2.25191 //w=0.131 //l=2.36 //layer=m1 \
 //thickness=0.36 //x=2.96 //y=2.225 //x2=2.96 //y2=4.585
ends PM_NOR3X1_PCELL\%noxref_6

subckt PM_NOR3X1_PCELL\%noxref_7 ( 1 4 5 7 13 16 19 27 42 43 44 )
c76 ( 44 0 ) capacitor c=0.0383139f //x=3.885 //y=5.025
c77 ( 27 0 ) capacitor c=0.0270496f //x=3.15 //y=5.72
c78 ( 19 0 ) capacitor c=0.0250744f //x=2.11 //y=5.38
c79 ( 16 0 ) capacitor c=0.0178258f //x=4.03 //y=6.74
c80 ( 13 0 ) capacitor c=0.00671901f //x=3.15 //y=6.74
c81 ( 7 0 ) capacitor c=0.0124325f //x=2.11 //y=5.21
c82 ( 5 0 ) capacitor c=0.00970854f //x=3.915 //y=6.91
c83 ( 4 0 ) capacitor c=0.0176667f //x=3.15 //y=5.59
c84 ( 1 0 ) capacitor c=0.03242f //x=3.065 //y=5.21
r85 (  27 43 ) resistor r=23.2727 //w=0.187 //l=0.34 //layer=li \
 //thickness=0.1 //x=3.15 //y=5.72 //x2=3.15 //y2=6.06
r86 (  19 42 ) resistor r=23.2727 //w=0.187 //l=0.34 //layer=li \
 //thickness=0.1 //x=2.11 //y=5.38 //x2=2.11 //y2=5.72
r87 (  16 44 ) resistor r=9.3 //w=0.17 //l=0.17 //layer=mcon //count=1 \
 //x=4.03 //y=6.74 //x2=4.03 //y2=6.74
r88 (  16 17 ) resistor r=0.103155 //w=0.206 //l=0.17 //layer=m1 \
 //thickness=0.36 //x=4.03 //y=6.74 //x2=4.03 //y2=6.91
r89 (  13 43 ) resistor r=9.3 //w=0.17 //l=0.17 //layer=mcon //count=1 \
 //x=3.15 //y=6.74 //x2=3.15 //y2=6.74
r90 (  13 14 ) resistor r=0.103155 //w=0.206 //l=0.17 //layer=m1 \
 //thickness=0.36 //x=3.15 //y=6.74 //x2=3.15 //y2=6.91
r91 (  11 27 ) resistor r=9.3 //w=0.17 //l=0.17 //layer=mcon //count=1 \
 //x=3.15 //y=5.72 //x2=3.15 //y2=5.72
r92 (  9 19 ) resistor r=9.3 //w=0.17 //l=0.17 //layer=mcon //count=1 //x=2.11 \
 //y=5.38 //x2=2.11 //y2=5.38
r93 (  7 9 ) resistor r=0.0961538 //w=0.221 //l=0.17 //layer=m1 \
 //thickness=0.36 //x=2.11 //y=5.21 //x2=2.11 //y2=5.38
r94 (  6 14 ) resistor r=0.0190994 //w=0.206 //l=0.115 //layer=m1 \
 //thickness=0.36 //x=3.265 //y=6.91 //x2=3.15 //y2=6.91
r95 (  5 17 ) resistor r=0.0190994 //w=0.206 //l=0.115 //layer=m1 \
 //thickness=0.36 //x=3.915 //y=6.91 //x2=4.03 //y2=6.91
r96 (  5 6 ) resistor r=0.620229 //w=0.131 //l=0.65 //layer=m1 \
 //thickness=0.36 //x=3.915 //y=6.91 //x2=3.265 //y2=6.91
r97 (  4 11 ) resistor r=0.0784347 //w=0.241 //l=0.130996 //layer=m1 \
 //thickness=0.36 //x=3.15 //y=5.59 //x2=3.152 //y2=5.72
r98 (  3 4 ) resistor r=0.281489 //w=0.131 //l=0.295 //layer=m1 \
 //thickness=0.36 //x=3.15 //y=5.295 //x2=3.15 //y2=5.59
r99 (  2 7 ) resistor r=0.0233208 //w=0.221 //l=0.12 //layer=m1 \
 //thickness=0.36 //x=2.23 //y=5.21 //x2=2.11 //y2=5.21
r100 (  1 3 ) resistor r=0.0698411 //w=0.17 //l=0.120208 //layer=m1 \
 //thickness=0.36 //x=3.065 //y=5.21 //x2=3.15 //y2=5.295
r101 (  1 2 ) resistor r=0.796756 //w=0.131 //l=0.835 //layer=m1 \
 //thickness=0.36 //x=3.065 //y=5.21 //x2=2.23 //y2=5.21
ends PM_NOR3X1_PCELL\%noxref_7

subckt PM_NOR3X1_PCELL\%noxref_8 ( 1 2 3 4 5 6 7 9 10 11 14 16 22 27 47 52 53 \
 54 58 )
c162 ( 54 0 ) capacitor c=0.00873058f //x=2.93 //y=0.905
c163 ( 53 0 ) capacitor c=0.00875954f //x=1.96 //y=0.905
c164 ( 52 0 ) capacitor c=0.00846995f //x=0.99 //y=0.905
c165 ( 47 0 ) capacitor c=0.0175291f //x=3.59 //y=5.72
c166 ( 27 0 ) capacitor c=0.00871708f //x=3.7 //y=5.21
c167 ( 22 0 ) capacitor c=0.00396315f //x=3.12 //y=1.655
c168 ( 19 0 ) capacitor c=0.0053239f //x=2.15 //y=1.655
c169 ( 16 0 ) capacitor c=0.150495f //x=3.7 //y=5.125
c170 ( 14 0 ) capacitor c=0.0215729f //x=3.59 //y=5.59
c171 ( 11 0 ) capacitor c=0.025414f //x=3.615 //y=1.655
c172 ( 10 0 ) capacitor c=0.0114203f //x=3.12 //y=1.57
c173 ( 9 0 ) capacitor c=0.0124805f //x=3.12 //y=1.145
c174 ( 7 0 ) capacitor c=0.0226795f //x=3.035 //y=1.655
c175 ( 6 0 ) capacitor c=0.00495158f //x=2.15 //y=1.57
c176 ( 5 0 ) capacitor c=0.00403165f //x=2.15 //y=1.13
c177 ( 4 0 ) capacitor c=0.00466756f //x=1.265 //y=1.655
c178 ( 3 0 ) capacitor c=0.0219101f //x=2.065 //y=1.655
c179 ( 2 0 ) capacitor c=0.0106027f //x=1.18 //y=1.57
c180 ( 1 0 ) capacitor c=0.0119131f //x=1.18 //y=1.13
r181 (  47 58 ) resistor r=23.2727 //w=0.187 //l=0.34 //layer=li \
 //thickness=0.1 //x=3.59 //y=5.72 //x2=3.59 //y2=6.06
r182 (  30 47 ) resistor r=9.3 //w=0.17 //l=0.17 //layer=mcon //count=1 \
 //x=3.59 //y=5.72 //x2=3.59 //y2=5.72
r183 (  25 27 ) resistor r=0.104962 //w=0.131 //l=0.11 //layer=m1 \
 //thickness=0.36 //x=3.59 //y=5.21 //x2=3.7 //y2=5.21
r184 (  24 54 ) resistor r=9.3 //w=0.17 //l=0.17 //layer=mcon //count=1 \
 //x=3.12 //y=1 //x2=3.12 //y2=1
r185 (  21 53 ) resistor r=9.3 //w=0.17 //l=0.17 //layer=mcon //count=1 \
 //x=2.15 //y=1 //x2=2.15 //y2=1
r186 (  18 52 ) resistor r=9.3 //w=0.17 //l=0.17 //layer=mcon //count=1 \
 //x=1.18 //y=1 //x2=1.18 //y2=1
r187 (  16 27 ) resistor r=0.0073411 //w=0.17 //l=0.085 //layer=m1 \
 //thickness=0.36 //x=3.7 //y=5.125 //x2=3.7 //y2=5.21
r188 (  15 16 ) resistor r=3.22996 //w=0.131 //l=3.385 //layer=m1 \
 //thickness=0.36 //x=3.7 //y=1.74 //x2=3.7 //y2=5.125
r189 (  14 30 ) resistor r=0.0784347 //w=0.241 //l=0.130996 //layer=m1 \
 //thickness=0.36 //x=3.59 //y=5.59 //x2=3.592 //y2=5.72
r190 (  13 25 ) resistor r=0.0073411 //w=0.17 //l=0.085 //layer=m1 \
 //thickness=0.36 //x=3.59 //y=5.295 //x2=3.59 //y2=5.21
r191 (  13 14 ) resistor r=0.281489 //w=0.131 //l=0.295 //layer=m1 \
 //thickness=0.36 //x=3.59 //y=5.295 //x2=3.59 //y2=5.59
r192 (  12 22 ) resistor r=0.0529306 //w=0.17 //l=0.085 //layer=m1 \
 //thickness=0.36 //x=3.205 //y=1.655 //x2=3.12 //y2=1.655
r193 (  11 15 ) resistor r=0.0698411 //w=0.17 //l=0.120208 //layer=m1 \
 //thickness=0.36 //x=3.615 //y=1.655 //x2=3.7 //y2=1.74
r194 (  11 12 ) resistor r=0.391221 //w=0.131 //l=0.41 //layer=m1 \
 //thickness=0.36 //x=3.615 //y=1.655 //x2=3.205 //y2=1.655
r195 (  10 22 ) resistor r=0.0137558 //w=0.34 //l=0.085 //layer=m1 \
 //thickness=0.36 //x=3.12 //y=1.57 //x2=3.12 //y2=1.655
r196 (  9 24 ) resistor r=0.0857222 //w=0.246 //l=0.145 //layer=m1 \
 //thickness=0.36 //x=3.12 //y=1.145 //x2=3.12 //y2=1
r197 (  9 10 ) resistor r=0.405534 //w=0.131 //l=0.425 //layer=m1 \
 //thickness=0.36 //x=3.12 //y=1.145 //x2=3.12 //y2=1.57
r198 (  8 19 ) resistor r=0.0529306 //w=0.17 //l=0.085 //layer=m1 \
 //thickness=0.36 //x=2.235 //y=1.655 //x2=2.15 //y2=1.655
r199 (  7 22 ) resistor r=0.0529306 //w=0.17 //l=0.085 //layer=m1 \
 //thickness=0.36 //x=3.035 //y=1.655 //x2=3.12 //y2=1.655
r200 (  7 8 ) resistor r=0.763359 //w=0.131 //l=0.8 //layer=m1 \
 //thickness=0.36 //x=3.035 //y=1.655 //x2=2.235 //y2=1.655
r201 (  6 19 ) resistor r=0.0137558 //w=0.34 //l=0.085 //layer=m1 \
 //thickness=0.36 //x=2.15 //y=1.57 //x2=2.15 //y2=1.655
r202 (  5 21 ) resistor r=0.0778262 //w=0.251 //l=0.131491 //layer=m1 \
 //thickness=0.36 //x=2.15 //y=1.13 //x2=2.147 //y2=1
r203 (  5 6 ) resistor r=0.419847 //w=0.131 //l=0.44 //layer=m1 \
 //thickness=0.36 //x=2.15 //y=1.13 //x2=2.15 //y2=1.57
r204 (  3 19 ) resistor r=0.0529306 //w=0.17 //l=0.085 //layer=m1 \
 //thickness=0.36 //x=2.065 //y=1.655 //x2=2.15 //y2=1.655
r205 (  3 4 ) resistor r=0.763359 //w=0.131 //l=0.8 //layer=m1 \
 //thickness=0.36 //x=2.065 //y=1.655 //x2=1.265 //y2=1.655
r206 (  2 4 ) resistor r=0.0698411 //w=0.17 //l=0.120208 //layer=m1 \
 //thickness=0.36 //x=1.18 //y=1.57 //x2=1.265 //y2=1.655
r207 (  1 18 ) resistor r=0.0779837 //w=0.248 //l=0.130996 //layer=m1 \
 //thickness=0.36 //x=1.18 //y=1.13 //x2=1.182 //y2=1
r208 (  1 2 ) resistor r=0.419847 //w=0.131 //l=0.44 //layer=m1 \
 //thickness=0.36 //x=1.18 //y=1.13 //x2=1.18 //y2=1.57
ends PM_NOR3X1_PCELL\%noxref_8
