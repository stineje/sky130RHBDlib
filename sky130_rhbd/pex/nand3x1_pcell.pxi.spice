// File: nand3x1_pcell.spi.NAND3X1_PCELL.pxi
// Created: Sun Apr 12 08:41:29 2026
//
simulator lang=spectre
x_PM_NAND3X1_PCELL\%noxref_1 ( N_noxref_1_c_24_p N_noxref_1_c_1_p \
 N_noxref_1_c_8_p N_noxref_1_c_14_p N_noxref_1_c_19_p N_noxref_1_c_2_p \
 N_noxref_1_M3_noxref_s N_noxref_1_M4_noxref_d N_noxref_1_M6_noxref_d \
 N_noxref_1_M8_noxref_d )  PM_NAND3X1_PCELL\%noxref_1
x_PM_NAND3X1_PCELL\%noxref_3 ( N_noxref_3_c_106_n N_noxref_3_c_96_n \
 N_noxref_3_c_108_n N_noxref_3_c_98_n N_noxref_3_M0_noxref_g \
 N_noxref_3_M3_noxref_g N_noxref_3_M4_noxref_g N_noxref_3_c_109_n \
 N_noxref_3_c_110_n N_noxref_3_c_111_n N_noxref_3_c_112_n N_noxref_3_c_113_n \
 N_noxref_3_c_114_n N_noxref_3_c_115_n N_noxref_3_c_116_n N_noxref_3_c_123_p \
 N_noxref_3_c_104_n )  PM_NAND3X1_PCELL\%noxref_3
x_PM_NAND3X1_PCELL\%noxref_4 ( N_noxref_4_c_171_n N_noxref_4_c_172_n \
 N_noxref_4_c_173_n N_noxref_4_c_174_n N_noxref_4_c_196_p \
 N_noxref_4_M1_noxref_d N_noxref_4_M2_noxref_s )  PM_NAND3X1_PCELL\%noxref_4
x_PM_NAND3X1_PCELL\%noxref_5 ( N_noxref_5_c_225_n N_noxref_5_c_229_n \
 N_noxref_5_c_234_n N_noxref_5_c_238_n N_noxref_5_M1_noxref_g \
 N_noxref_5_M5_noxref_g N_noxref_5_M6_noxref_g N_noxref_5_c_245_n \
 N_noxref_5_c_248_n N_noxref_5_c_264_n N_noxref_5_c_265_n N_noxref_5_c_250_n \
 N_noxref_5_c_251_n N_noxref_5_c_252_n N_noxref_5_c_253_n N_noxref_5_c_301_p \
 N_noxref_5_c_256_n )  PM_NAND3X1_PCELL\%noxref_5
x_PM_NAND3X1_PCELL\%noxref_6 ( N_noxref_6_c_333_n N_noxref_6_c_336_n \
 N_noxref_6_c_334_n N_noxref_6_c_327_n N_noxref_6_M2_noxref_g \
 N_noxref_6_M7_noxref_g N_noxref_6_M8_noxref_g N_noxref_6_c_339_n \
 N_noxref_6_c_341_n N_noxref_6_c_342_n N_noxref_6_c_383_p N_noxref_6_c_384_p \
 N_noxref_6_c_343_n N_noxref_6_c_335_n N_noxref_6_c_346_n N_noxref_6_c_370_n \
 N_noxref_6_c_332_n )  PM_NAND3X1_PCELL\%noxref_6
x_PM_NAND3X1_PCELL\%noxref_7 ( N_noxref_7_c_414_n N_noxref_7_c_418_n \
 N_noxref_7_c_422_n N_noxref_7_c_425_n N_noxref_7_c_453_n N_noxref_7_c_454_n \
 N_noxref_7_c_455_n N_noxref_7_c_429_n N_noxref_7_c_430_n N_noxref_7_c_434_n \
 N_noxref_7_c_514_n N_noxref_7_c_437_n N_noxref_7_c_443_n N_noxref_7_c_448_n \
 N_noxref_7_M2_noxref_d N_noxref_7_M3_noxref_d N_noxref_7_M5_noxref_d \
 N_noxref_7_M7_noxref_d )  PM_NAND3X1_PCELL\%noxref_7
x_PM_NAND3X1_PCELL\%noxref_8 ( N_noxref_8_c_532_n N_noxref_8_c_528_n \
 N_noxref_8_c_529_n N_noxref_8_c_530_n N_noxref_8_c_547_n \
 N_noxref_8_M0_noxref_s )  PM_NAND3X1_PCELL\%noxref_8
cc_1 ( N_noxref_1_c_1_p noxref_2 ) capacitor c=0.00989031f //x=0.74 //y=7.4 \
 //x2=0.885 //y2=0.875
cc_2 ( N_noxref_1_c_2_p noxref_2 ) capacitor c=0.00989031f //x=4.07 //y=7.4 \
 //x2=0.885 //y2=0.875
cc_3 ( N_noxref_1_M3_noxref_s noxref_2 ) capacitor c=5.21561e-19 //x=0.955 \
 //y=5.02 //x2=0.885 //y2=0.875
cc_4 ( N_noxref_1_c_1_p N_noxref_3_c_96_n ) capacitor c=0.019298f //x=0.74 \
 //y=7.4 //x2=1.11 //y2=4.575
cc_5 ( N_noxref_1_M3_noxref_s N_noxref_3_c_96_n ) capacitor c=0.0230398f \
 //x=0.955 //y=5.02 //x2=1.11 //y2=4.575
cc_6 ( N_noxref_1_c_1_p N_noxref_3_c_98_n ) capacitor c=0.00371026f //x=0.74 \
 //y=7.4 //x2=1.11 //y2=4.7
cc_7 ( N_noxref_1_M3_noxref_s N_noxref_3_c_98_n ) capacitor c=0.00983393f \
 //x=0.955 //y=5.02 //x2=1.11 //y2=4.7
cc_8 ( N_noxref_1_c_8_p N_noxref_3_M3_noxref_g ) capacitor c=0.00749687f \
 //x=1.885 //y=7.4 //x2=1.31 //y2=6.02
cc_9 ( N_noxref_1_M3_noxref_s N_noxref_3_M3_noxref_g ) capacitor c=0.053419f \
 //x=0.955 //y=5.02 //x2=1.31 //y2=6.02
cc_10 ( N_noxref_1_c_8_p N_noxref_3_M4_noxref_g ) capacitor c=0.00749619f \
 //x=1.885 //y=7.4 //x2=1.75 //y2=6.02
cc_11 ( N_noxref_1_M4_noxref_d N_noxref_3_M4_noxref_g ) capacitor c=0.015318f \
 //x=1.825 //y=5.02 //x2=1.75 //y2=6.02
cc_12 ( N_noxref_1_c_1_p N_noxref_3_c_104_n ) capacitor c=0.00594885f //x=0.74 \
 //y=7.4 //x2=1.385 //y2=4.79
cc_13 ( N_noxref_1_M3_noxref_s N_noxref_3_c_104_n ) capacitor c=0.00633107f \
 //x=0.955 //y=5.02 //x2=1.385 //y2=4.79
cc_14 ( N_noxref_1_c_14_p N_noxref_5_M5_noxref_g ) capacitor c=0.00700336f \
 //x=2.765 //y=7.4 //x2=2.19 //y2=6.02
cc_15 ( N_noxref_1_M4_noxref_d N_noxref_5_M5_noxref_g ) capacitor c=0.015318f \
 //x=1.825 //y=5.02 //x2=2.19 //y2=6.02
cc_16 ( N_noxref_1_c_14_p N_noxref_5_M6_noxref_g ) capacitor c=0.00749619f \
 //x=2.765 //y=7.4 //x2=2.63 //y2=6.02
cc_17 ( N_noxref_1_M6_noxref_d N_noxref_5_M6_noxref_g ) capacitor c=0.015318f \
 //x=2.705 //y=5.02 //x2=2.63 //y2=6.02
cc_18 ( N_noxref_1_c_2_p N_noxref_6_c_327_n ) capacitor c=0.00224736f //x=4.07 \
 //y=7.4 //x2=3.33 //y2=4.7
cc_19 ( N_noxref_1_c_19_p N_noxref_6_M7_noxref_g ) capacitor c=0.00749619f \
 //x=3.645 //y=7.4 //x2=3.07 //y2=6.02
cc_20 ( N_noxref_1_M6_noxref_d N_noxref_6_M7_noxref_g ) capacitor c=0.015318f \
 //x=2.705 //y=5.02 //x2=3.07 //y2=6.02
cc_21 ( N_noxref_1_c_19_p N_noxref_6_M8_noxref_g ) capacitor c=0.00749823f \
 //x=3.645 //y=7.4 //x2=3.51 //y2=6.02
cc_22 ( N_noxref_1_M8_noxref_d N_noxref_6_M8_noxref_g ) capacitor c=0.0394719f \
 //x=3.585 //y=5.02 //x2=3.51 //y2=6.02
cc_23 ( N_noxref_1_c_2_p N_noxref_6_c_332_n ) capacitor c=2.63786e-19 //x=4.07 \
 //y=7.4 //x2=3.33 //y2=4.7
cc_24 ( N_noxref_1_c_24_p N_noxref_7_c_414_n ) capacitor c=0.00620651f \
 //x=4.07 //y=7.4 //x2=2.29 //y2=5.155
cc_25 ( N_noxref_1_c_8_p N_noxref_7_c_414_n ) capacitor c=0.0020718f //x=1.885 \
 //y=7.4 //x2=2.29 //y2=5.155
cc_26 ( N_noxref_1_c_14_p N_noxref_7_c_414_n ) capacitor c=0.00177088f \
 //x=2.765 //y=7.4 //x2=2.29 //y2=5.155
cc_27 ( N_noxref_1_M4_noxref_d N_noxref_7_c_414_n ) capacitor c=0.00775668f \
 //x=1.825 //y=5.02 //x2=2.29 //y2=5.155
cc_28 ( N_noxref_1_c_24_p N_noxref_7_c_418_n ) capacitor c=0.00626474f \
 //x=4.07 //y=7.4 //x2=3.175 //y2=5.155
cc_29 ( N_noxref_1_c_14_p N_noxref_7_c_418_n ) capacitor c=0.0020718f \
 //x=2.765 //y=7.4 //x2=3.175 //y2=5.155
cc_30 ( N_noxref_1_c_19_p N_noxref_7_c_418_n ) capacitor c=0.00210784f \
 //x=3.645 //y=7.4 //x2=3.175 //y2=5.155
cc_31 ( N_noxref_1_M6_noxref_d N_noxref_7_c_418_n ) capacitor c=0.00775668f \
 //x=2.705 //y=5.02 //x2=3.175 //y2=5.155
cc_32 ( N_noxref_1_c_24_p N_noxref_7_c_422_n ) capacitor c=0.00255604f \
 //x=4.07 //y=7.4 //x2=3.29 //y2=5.38
cc_33 ( N_noxref_1_c_19_p N_noxref_7_c_422_n ) capacitor c=9.07352e-19 \
 //x=3.645 //y=7.4 //x2=3.29 //y2=5.38
cc_34 ( N_noxref_1_c_2_p N_noxref_7_c_422_n ) capacitor c=0.00414616f //x=4.07 \
 //y=7.4 //x2=3.29 //y2=5.38
cc_35 ( N_noxref_1_c_24_p N_noxref_7_c_425_n ) capacitor c=0.00822764f \
 //x=4.07 //y=7.4 //x2=3.985 //y2=5.155
cc_36 ( N_noxref_1_c_19_p N_noxref_7_c_425_n ) capacitor c=0.00207995f \
 //x=3.645 //y=7.4 //x2=3.985 //y2=5.155
cc_37 ( N_noxref_1_c_2_p N_noxref_7_c_425_n ) capacitor c=0.00226495f //x=4.07 \
 //y=7.4 //x2=3.985 //y2=5.155
cc_38 ( N_noxref_1_M8_noxref_d N_noxref_7_c_425_n ) capacitor c=0.00775668f \
 //x=3.585 //y=5.02 //x2=3.985 //y2=5.155
cc_39 ( N_noxref_1_c_2_p N_noxref_7_c_429_n ) capacitor c=0.0398466f //x=4.07 \
 //y=7.4 //x2=4.07 //y2=5.07
cc_40 ( N_noxref_1_c_24_p N_noxref_7_c_430_n ) capacitor c=0.00261379f \
 //x=4.07 //y=7.4 //x2=1.532 //y2=5.155
cc_41 ( N_noxref_1_c_1_p N_noxref_7_c_430_n ) capacitor c=0.00331944f //x=0.74 \
 //y=7.4 //x2=1.532 //y2=5.155
cc_42 ( N_noxref_1_c_8_p N_noxref_7_c_430_n ) capacitor c=0.00105895f \
 //x=1.885 //y=7.4 //x2=1.532 //y2=5.155
cc_43 ( N_noxref_1_M3_noxref_s N_noxref_7_c_430_n ) capacitor c=0.0453361f \
 //x=0.955 //y=5.02 //x2=1.532 //y2=5.155
cc_44 ( N_noxref_1_c_24_p N_noxref_7_c_434_n ) capacitor c=0.0026965f //x=4.07 \
 //y=7.4 //x2=2.41 //y2=5.155
cc_45 ( N_noxref_1_c_14_p N_noxref_7_c_434_n ) capacitor c=0.00105421f \
 //x=2.765 //y=7.4 //x2=2.41 //y2=5.155
cc_46 ( N_noxref_1_M3_noxref_s N_noxref_7_c_434_n ) capacitor c=7.80122e-19 \
 //x=0.955 //y=5.02 //x2=2.41 //y2=5.155
cc_47 ( N_noxref_1_c_24_p N_noxref_7_c_437_n ) capacitor c=0.00242194f \
 //x=4.07 //y=7.4 //x2=1.53 //y2=5.38
cc_48 ( N_noxref_1_c_1_p N_noxref_7_c_437_n ) capacitor c=0.00509469f //x=0.74 \
 //y=7.4 //x2=1.53 //y2=5.38
cc_49 ( N_noxref_1_c_8_p N_noxref_7_c_437_n ) capacitor c=0.0137846f //x=1.885 \
 //y=7.4 //x2=1.53 //y2=5.38
cc_50 ( N_noxref_1_c_2_p N_noxref_7_c_437_n ) capacitor c=0.00135089f //x=4.07 \
 //y=7.4 //x2=1.53 //y2=5.38
cc_51 ( N_noxref_1_M3_noxref_s N_noxref_7_c_437_n ) capacitor c=0.09305f \
 //x=0.955 //y=5.02 //x2=1.53 //y2=5.38
cc_52 ( N_noxref_1_M4_noxref_d N_noxref_7_c_437_n ) capacitor c=0.0674491f \
 //x=1.825 //y=5.02 //x2=1.53 //y2=5.38
cc_53 ( N_noxref_1_c_24_p N_noxref_7_c_443_n ) capacitor c=0.00242194f \
 //x=4.07 //y=7.4 //x2=2.41 //y2=5.38
cc_54 ( N_noxref_1_c_14_p N_noxref_7_c_443_n ) capacitor c=0.0137846f \
 //x=2.765 //y=7.4 //x2=2.41 //y2=5.38
cc_55 ( N_noxref_1_c_2_p N_noxref_7_c_443_n ) capacitor c=0.00135089f //x=4.07 \
 //y=7.4 //x2=2.41 //y2=5.38
cc_56 ( N_noxref_1_M4_noxref_d N_noxref_7_c_443_n ) capacitor c=0.0674762f \
 //x=1.825 //y=5.02 //x2=2.41 //y2=5.38
cc_57 ( N_noxref_1_M6_noxref_d N_noxref_7_c_443_n ) capacitor c=0.067493f \
 //x=2.705 //y=5.02 //x2=2.41 //y2=5.38
cc_58 ( N_noxref_1_c_24_p N_noxref_7_c_448_n ) capacitor c=0.00242194f \
 //x=4.07 //y=7.4 //x2=3.29 //y2=5.38
cc_59 ( N_noxref_1_c_19_p N_noxref_7_c_448_n ) capacitor c=0.0137846f \
 //x=3.645 //y=7.4 //x2=3.29 //y2=5.38
cc_60 ( N_noxref_1_c_2_p N_noxref_7_c_448_n ) capacitor c=0.00913195f //x=4.07 \
 //y=7.4 //x2=3.29 //y2=5.38
cc_61 ( N_noxref_1_M6_noxref_d N_noxref_7_c_448_n ) capacitor c=0.0675031f \
 //x=2.705 //y=5.02 //x2=3.29 //y2=5.38
cc_62 ( N_noxref_1_M8_noxref_d N_noxref_7_c_448_n ) capacitor c=0.0675091f \
 //x=3.585 //y=5.02 //x2=3.29 //y2=5.38
cc_63 ( noxref_2 N_noxref_3_c_106_n ) capacitor c=0.0167295f //x=0.885 \
 //y=0.875 //x2=1.11 //y2=2.195
cc_64 ( noxref_2 N_noxref_3_c_96_n ) capacitor c=0.0126319f //x=0.885 \
 //y=0.875 //x2=1.11 //y2=4.575
cc_65 ( noxref_2 N_noxref_3_c_108_n ) capacitor c=0.00417062f //x=0.885 \
 //y=0.875 //x2=1.11 //y2=2.08
cc_66 ( noxref_2 N_noxref_3_c_109_n ) capacitor c=0.0104883f //x=0.885 \
 //y=0.875 //x2=0.81 //y2=0.875
cc_67 ( noxref_2 N_noxref_3_c_110_n ) capacitor c=0.00622084f //x=0.885 \
 //y=0.875 //x2=0.81 //y2=1.22
cc_68 ( noxref_2 N_noxref_3_c_111_n ) capacitor c=0.00344075f //x=0.885 \
 //y=0.875 //x2=0.81 //y2=1.53
cc_69 ( noxref_2 N_noxref_3_c_112_n ) capacitor c=0.0112432f //x=0.885 \
 //y=0.875 //x2=0.81 //y2=1.915
cc_70 ( noxref_2 N_noxref_3_c_113_n ) capacitor c=0.0139244f //x=0.885 \
 //y=0.875 //x2=1.185 //y2=0.72
cc_71 ( noxref_2 N_noxref_3_c_114_n ) capacitor c=0.00230427f //x=0.885 \
 //y=0.875 //x2=1.185 //y2=1.375
cc_72 ( noxref_2 N_noxref_3_c_115_n ) capacitor c=0.00432941f //x=0.885 \
 //y=0.875 //x2=1.34 //y2=0.875
cc_73 ( noxref_2 N_noxref_3_c_116_n ) capacitor c=0.00487602f //x=0.885 \
 //y=0.875 //x2=1.34 //y2=1.22
cc_74 ( noxref_2 N_noxref_4_c_171_n ) capacitor c=0.0163189f //x=0.885 \
 //y=0.875 //x2=3.015 //y2=0.995
cc_75 ( noxref_2 N_noxref_4_c_172_n ) capacitor c=0.0224975f //x=0.885 \
 //y=0.875 //x2=3.1 //y2=0.625
cc_76 ( noxref_2 N_noxref_4_c_173_n ) capacitor c=0.0496387f //x=0.885 \
 //y=0.875 //x2=3.985 //y2=0.54
cc_77 ( noxref_2 N_noxref_4_c_174_n ) capacitor c=0.0578358f //x=0.885 \
 //y=0.875 //x2=4.07 //y2=0.625
cc_78 ( noxref_2 N_noxref_4_M1_noxref_d ) capacitor c=0.0296369f //x=0.885 \
 //y=0.875 //x2=1.86 //y2=0.91
cc_79 ( noxref_2 N_noxref_4_M2_noxref_s ) capacitor c=0.00614902f //x=0.885 \
 //y=0.875 //x2=2.965 //y2=0.375
cc_80 ( noxref_2 N_noxref_5_c_225_n ) capacitor c=9.14667e-19 //x=0.885 \
 //y=0.875 //x2=2.22 //y2=2.195
cc_81 ( noxref_2 N_noxref_6_c_333_n ) capacitor c=0.00239607f //x=0.885 \
 //y=0.875 //x2=3.33 //y2=2.195
cc_82 ( noxref_2 N_noxref_6_c_334_n ) capacitor c=0.00246191f //x=0.885 \
 //y=0.875 //x2=3.33 //y2=2.08
cc_83 ( noxref_2 N_noxref_6_c_335_n ) capacitor c=0.00275764f //x=0.885 \
 //y=0.875 //x2=3.85 //y2=1.26
cc_84 ( noxref_2 N_noxref_7_c_453_n ) capacitor c=0.00933876f //x=0.885 \
 //y=0.875 //x2=3.585 //y2=1.125
cc_85 ( noxref_2 N_noxref_7_c_454_n ) capacitor c=0.00518727f //x=0.885 \
 //y=0.875 //x2=3.585 //y2=1.58
cc_86 ( noxref_2 N_noxref_7_c_455_n ) capacitor c=0.0478833f //x=0.885 \
 //y=0.875 //x2=3.985 //y2=1.665
cc_87 ( noxref_2 N_noxref_7_M2_noxref_d ) capacitor c=2.94508e-19 //x=0.885 \
 //y=0.875 //x2=3.395 //y2=0.915
cc_88 ( noxref_2 N_noxref_8_c_528_n ) capacitor c=0.0185298f //x=0.885 \
 //y=0.875 //x2=1.475 //y2=1.59
cc_89 ( noxref_2 N_noxref_8_c_529_n ) capacitor c=0.0426339f //x=0.885 \
 //y=0.875 //x2=1.56 //y2=0.625
cc_90 ( noxref_2 N_noxref_8_c_530_n ) capacitor c=0.05229f //x=0.885 //y=0.875 \
 //x2=2.445 //y2=0.54
cc_91 ( noxref_2 N_noxref_8_M0_noxref_s ) capacitor c=0.168462f //x=0.885 \
 //y=0.875 //x2=0.455 //y2=0.375
cc_92 ( N_noxref_3_c_106_n N_noxref_5_c_225_n ) capacitor c=0.0115546f \
 //x=1.11 //y=2.195 //x2=2.22 //y2=2.195
cc_93 ( N_noxref_3_c_108_n N_noxref_5_c_225_n ) capacitor c=5.40058e-19 \
 //x=1.11 //y=2.08 //x2=2.22 //y2=2.195
cc_94 ( N_noxref_3_c_112_n N_noxref_5_c_225_n ) capacitor c=0.00147006f \
 //x=0.81 //y=1.915 //x2=2.22 //y2=2.195
cc_95 ( N_noxref_3_c_96_n N_noxref_5_c_229_n ) capacitor c=0.088652f //x=1.11 \
 //y=4.575 //x2=2.22 //y2=4.585
cc_96 ( N_noxref_3_c_108_n N_noxref_5_c_229_n ) capacitor c=4.16726e-19 \
 //x=1.11 //y=2.08 //x2=2.22 //y2=4.585
cc_97 ( N_noxref_3_c_98_n N_noxref_5_c_229_n ) capacitor c=6.26008e-19 \
 //x=1.11 //y=4.7 //x2=2.22 //y2=4.585
cc_98 ( N_noxref_3_c_123_p N_noxref_5_c_229_n ) capacitor c=7.66769e-19 \
 //x=1.675 //y=4.79 //x2=2.22 //y2=4.585
cc_99 ( N_noxref_3_c_104_n N_noxref_5_c_229_n ) capacitor c=7.54501e-19 \
 //x=1.385 //y=4.79 //x2=2.22 //y2=4.585
cc_100 ( N_noxref_3_c_106_n N_noxref_5_c_234_n ) capacitor c=0.00375644f \
 //x=1.11 //y=2.195 //x2=2.22 //y2=2.08
cc_101 ( N_noxref_3_c_96_n N_noxref_5_c_234_n ) capacitor c=4.16726e-19 \
 //x=1.11 //y=4.575 //x2=2.22 //y2=2.08
cc_102 ( N_noxref_3_c_108_n N_noxref_5_c_234_n ) capacitor c=0.00125213f \
 //x=1.11 //y=2.08 //x2=2.22 //y2=2.08
cc_103 ( N_noxref_3_c_112_n N_noxref_5_c_234_n ) capacitor c=0.00214573f \
 //x=0.81 //y=1.915 //x2=2.22 //y2=2.08
cc_104 ( N_noxref_3_c_96_n N_noxref_5_c_238_n ) capacitor c=0.00411832f \
 //x=1.11 //y=4.575 //x2=2.22 //y2=4.7
cc_105 ( N_noxref_3_c_98_n N_noxref_5_c_238_n ) capacitor c=0.00113984f \
 //x=1.11 //y=4.7 //x2=2.22 //y2=4.7
cc_106 ( N_noxref_3_c_123_p N_noxref_5_c_238_n ) capacitor c=0.00116563f \
 //x=1.675 //y=4.79 //x2=2.22 //y2=4.7
cc_107 ( N_noxref_3_c_104_n N_noxref_5_c_238_n ) capacitor c=0.00129812f \
 //x=1.385 //y=4.79 //x2=2.22 //y2=4.7
cc_108 ( N_noxref_3_M3_noxref_g N_noxref_5_M5_noxref_g ) capacitor \
 c=0.0106276f //x=1.31 //y=6.02 //x2=2.19 //y2=6.02
cc_109 ( N_noxref_3_M4_noxref_g N_noxref_5_M5_noxref_g ) capacitor c=0.107144f \
 //x=1.75 //y=6.02 //x2=2.19 //y2=6.02
cc_110 ( N_noxref_3_M4_noxref_g N_noxref_5_M6_noxref_g ) capacitor \
 c=0.0101598f //x=1.75 //y=6.02 //x2=2.63 //y2=6.02
cc_111 ( N_noxref_3_c_109_n N_noxref_5_c_245_n ) capacitor c=5.72528e-19 \
 //x=0.81 //y=0.875 //x2=1.785 //y2=0.91
cc_112 ( N_noxref_3_c_110_n N_noxref_5_c_245_n ) capacitor c=0.00150277f \
 //x=0.81 //y=1.22 //x2=1.785 //y2=0.91
cc_113 ( N_noxref_3_c_115_n N_noxref_5_c_245_n ) capacitor c=0.0160123f \
 //x=1.34 //y=0.875 //x2=1.785 //y2=0.91
cc_114 ( N_noxref_3_c_111_n N_noxref_5_c_248_n ) capacitor c=0.00111227f \
 //x=0.81 //y=1.53 //x2=1.785 //y2=1.22
cc_115 ( N_noxref_3_c_116_n N_noxref_5_c_248_n ) capacitor c=0.0124075f \
 //x=1.34 //y=1.22 //x2=1.785 //y2=1.22
cc_116 ( N_noxref_3_c_115_n N_noxref_5_c_250_n ) capacitor c=9.19165e-19 \
 //x=1.34 //y=0.875 //x2=2.31 //y2=0.91
cc_117 ( N_noxref_3_c_116_n N_noxref_5_c_251_n ) capacitor c=0.0010154f \
 //x=1.34 //y=1.22 //x2=2.31 //y2=1.22
cc_118 ( N_noxref_3_c_116_n N_noxref_5_c_252_n ) capacitor c=9.23422e-19 \
 //x=1.34 //y=1.22 //x2=2.31 //y2=1.45
cc_119 ( N_noxref_3_c_106_n N_noxref_5_c_253_n ) capacitor c=0.00140534f \
 //x=1.11 //y=2.195 //x2=2.31 //y2=1.915
cc_120 ( N_noxref_3_c_108_n N_noxref_5_c_253_n ) capacitor c=0.0020754f \
 //x=1.11 //y=2.08 //x2=2.31 //y2=1.915
cc_121 ( N_noxref_3_c_112_n N_noxref_5_c_253_n ) capacitor c=0.00964411f \
 //x=0.81 //y=1.915 //x2=2.31 //y2=1.915
cc_122 ( N_noxref_3_c_96_n N_noxref_5_c_256_n ) capacitor c=0.00116212f \
 //x=1.11 //y=4.575 //x2=2.22 //y2=4.7
cc_123 ( N_noxref_3_c_98_n N_noxref_5_c_256_n ) capacitor c=0.00155973f \
 //x=1.11 //y=4.7 //x2=2.22 //y2=4.7
cc_124 ( N_noxref_3_c_123_p N_noxref_5_c_256_n ) capacitor c=0.0171374f \
 //x=1.675 //y=4.79 //x2=2.22 //y2=4.7
cc_125 ( N_noxref_3_c_104_n N_noxref_5_c_256_n ) capacitor c=0.00484466f \
 //x=1.385 //y=4.79 //x2=2.22 //y2=4.7
cc_126 ( N_noxref_3_c_96_n N_noxref_6_c_336_n ) capacitor c=0.00317625f \
 //x=1.11 //y=4.575 //x2=3.33 //y2=4.57
cc_127 ( N_noxref_3_M4_noxref_g N_noxref_7_c_414_n ) capacitor c=0.0130704f \
 //x=1.75 //y=6.02 //x2=2.29 //y2=5.155
cc_128 ( N_noxref_3_M3_noxref_g N_noxref_7_c_430_n ) capacitor c=0.00501342f \
 //x=1.31 //y=6.02 //x2=1.532 //y2=5.155
cc_129 ( N_noxref_3_M4_noxref_g N_noxref_7_c_430_n ) capacitor c=0.00229208f \
 //x=1.75 //y=6.02 //x2=1.532 //y2=5.155
cc_130 ( N_noxref_3_c_123_p N_noxref_7_c_430_n ) capacitor c=0.00171885f \
 //x=1.675 //y=4.79 //x2=1.532 //y2=5.155
cc_131 ( N_noxref_3_M3_noxref_g N_noxref_7_c_437_n ) capacitor c=0.0162284f \
 //x=1.31 //y=6.02 //x2=1.53 //y2=5.38
cc_132 ( N_noxref_3_M4_noxref_g N_noxref_7_c_437_n ) capacitor c=0.0179041f \
 //x=1.75 //y=6.02 //x2=1.53 //y2=5.38
cc_133 ( N_noxref_3_c_123_p N_noxref_7_c_437_n ) capacitor c=0.00291477f \
 //x=1.675 //y=4.79 //x2=1.53 //y2=5.38
cc_134 ( N_noxref_3_c_112_n N_noxref_8_c_532_n ) capacitor c=0.00267608f \
 //x=0.81 //y=1.915 //x2=0.59 //y2=1.505
cc_135 ( N_noxref_3_c_106_n N_noxref_8_c_528_n ) capacitor c=0.00411069f \
 //x=1.11 //y=2.195 //x2=1.475 //y2=1.59
cc_136 ( N_noxref_3_c_96_n N_noxref_8_c_528_n ) capacitor c=2.27025e-19 \
 //x=1.11 //y=4.575 //x2=1.475 //y2=1.59
cc_137 ( N_noxref_3_c_108_n N_noxref_8_c_528_n ) capacitor c=0.0104666f \
 //x=1.11 //y=2.08 //x2=1.475 //y2=1.59
cc_138 ( N_noxref_3_c_111_n N_noxref_8_c_528_n ) capacitor c=0.00703864f \
 //x=0.81 //y=1.53 //x2=1.475 //y2=1.59
cc_139 ( N_noxref_3_c_112_n N_noxref_8_c_528_n ) capacitor c=0.0234088f \
 //x=0.81 //y=1.915 //x2=1.475 //y2=1.59
cc_140 ( N_noxref_3_c_114_n N_noxref_8_c_528_n ) capacitor c=0.00588627f \
 //x=1.185 //y=1.375 //x2=1.475 //y2=1.59
cc_141 ( N_noxref_3_c_116_n N_noxref_8_c_528_n ) capacitor c=0.00698822f \
 //x=1.34 //y=1.22 //x2=1.475 //y2=1.59
cc_142 ( N_noxref_3_c_109_n N_noxref_8_M0_noxref_s ) capacitor c=0.0295256f \
 //x=0.81 //y=0.875 //x2=0.455 //y2=0.375
cc_143 ( N_noxref_3_c_111_n N_noxref_8_M0_noxref_s ) capacitor c=7.99997e-19 \
 //x=0.81 //y=1.53 //x2=0.455 //y2=0.375
cc_144 ( N_noxref_3_c_112_n N_noxref_8_M0_noxref_s ) capacitor c=0.00122123f \
 //x=0.81 //y=1.915 //x2=0.455 //y2=0.375
cc_145 ( N_noxref_3_c_115_n N_noxref_8_M0_noxref_s ) capacitor c=0.0125924f \
 //x=1.34 //y=0.875 //x2=0.455 //y2=0.375
cc_146 ( N_noxref_4_M1_noxref_d N_noxref_5_c_225_n ) capacitor c=0.00610736f \
 //x=1.86 //y=0.91 //x2=2.22 //y2=2.195
cc_147 ( N_noxref_4_M1_noxref_d N_noxref_5_c_234_n ) capacitor c=2.2052e-19 \
 //x=1.86 //y=0.91 //x2=2.22 //y2=2.08
cc_148 ( N_noxref_4_M1_noxref_d N_noxref_5_c_245_n ) capacitor c=0.00253592f \
 //x=1.86 //y=0.91 //x2=1.785 //y2=0.91
cc_149 ( N_noxref_4_M1_noxref_d N_noxref_5_c_248_n ) capacitor c=0.00604634f \
 //x=1.86 //y=0.91 //x2=1.785 //y2=1.22
cc_150 ( N_noxref_4_M1_noxref_d N_noxref_5_c_264_n ) capacitor c=0.002686f \
 //x=1.86 //y=0.91 //x2=2.155 //y2=0.755
cc_151 ( N_noxref_4_M1_noxref_d N_noxref_5_c_265_n ) capacitor c=0.00251995f \
 //x=1.86 //y=0.91 //x2=2.155 //y2=1.375
cc_152 ( N_noxref_4_c_171_n N_noxref_5_c_250_n ) capacitor c=0.00123426f \
 //x=3.015 //y=0.995 //x2=2.31 //y2=0.91
cc_153 ( N_noxref_4_M1_noxref_d N_noxref_5_c_250_n ) capacitor c=0.00314523f \
 //x=1.86 //y=0.91 //x2=2.31 //y2=0.91
cc_154 ( N_noxref_4_M2_noxref_s N_noxref_5_c_250_n ) capacitor c=7.21316e-19 \
 //x=2.965 //y=0.375 //x2=2.31 //y2=0.91
cc_155 ( N_noxref_4_c_171_n N_noxref_5_c_251_n ) capacitor c=0.0129288f \
 //x=3.015 //y=0.995 //x2=2.31 //y2=1.22
cc_156 ( N_noxref_4_M1_noxref_d N_noxref_5_c_251_n ) capacitor c=0.00168289f \
 //x=1.86 //y=0.91 //x2=2.31 //y2=1.22
cc_157 ( N_noxref_4_M2_noxref_s N_noxref_5_c_251_n ) capacitor c=0.00365271f \
 //x=2.965 //y=0.375 //x2=2.31 //y2=1.22
cc_158 ( N_noxref_4_c_171_n N_noxref_5_c_252_n ) capacitor c=0.00132209f \
 //x=3.015 //y=0.995 //x2=2.31 //y2=1.45
cc_159 ( N_noxref_4_M1_noxref_d N_noxref_5_c_252_n ) capacitor c=0.00111165f \
 //x=1.86 //y=0.91 //x2=2.31 //y2=1.45
cc_160 ( N_noxref_4_M2_noxref_s N_noxref_5_c_253_n ) capacitor c=9.86711e-19 \
 //x=2.965 //y=0.375 //x2=2.31 //y2=1.915
cc_161 ( N_noxref_4_c_173_n N_noxref_6_c_333_n ) capacitor c=0.00171317f \
 //x=3.985 //y=0.54 //x2=3.33 //y2=2.195
cc_162 ( N_noxref_4_c_173_n N_noxref_6_c_334_n ) capacitor c=0.00117306f \
 //x=3.985 //y=0.54 //x2=3.33 //y2=2.08
cc_163 ( N_noxref_4_c_173_n N_noxref_6_c_339_n ) capacitor c=0.0205874f \
 //x=3.985 //y=0.54 //x2=3.32 //y2=0.915
cc_164 ( N_noxref_4_M2_noxref_s N_noxref_6_c_339_n ) capacitor c=0.0071177f \
 //x=2.965 //y=0.375 //x2=3.32 //y2=0.915
cc_165 ( N_noxref_4_c_196_p N_noxref_6_c_341_n ) capacitor c=0.0071177f \
 //x=3.1 //y=0.995 //x2=3.32 //y2=1.26
cc_166 ( N_noxref_4_M2_noxref_s N_noxref_6_c_342_n ) capacitor c=0.0071177f \
 //x=2.965 //y=0.375 //x2=3.32 //y2=1.57
cc_167 ( N_noxref_4_c_173_n N_noxref_6_c_343_n ) capacitor c=0.00825432f \
 //x=3.985 //y=0.54 //x2=3.85 //y2=0.915
cc_168 ( N_noxref_4_M2_noxref_s N_noxref_6_c_343_n ) capacitor c=0.015333f \
 //x=2.965 //y=0.375 //x2=3.85 //y2=0.915
cc_169 ( N_noxref_4_M2_noxref_s N_noxref_6_c_335_n ) capacitor c=0.00248746f \
 //x=2.965 //y=0.375 //x2=3.85 //y2=1.26
cc_170 ( N_noxref_4_c_173_n N_noxref_6_c_346_n ) capacitor c=2.20712e-19 \
 //x=3.985 //y=0.54 //x2=3.33 //y2=2.08
cc_171 ( N_noxref_4_M1_noxref_d N_noxref_7_c_414_n ) capacitor c=0.00159056f \
 //x=1.86 //y=0.91 //x2=2.29 //y2=5.155
cc_172 ( N_noxref_4_c_173_n N_noxref_7_c_453_n ) capacitor c=0.00361816f \
 //x=3.985 //y=0.54 //x2=3.585 //y2=1.125
cc_173 ( N_noxref_4_M1_noxref_d N_noxref_7_c_453_n ) capacitor c=0.00803465f \
 //x=1.86 //y=0.91 //x2=3.585 //y2=1.125
cc_174 ( N_noxref_4_M2_noxref_s N_noxref_7_c_453_n ) capacitor c=0.011355f \
 //x=2.965 //y=0.375 //x2=3.585 //y2=1.125
cc_175 ( N_noxref_4_M2_noxref_s N_noxref_7_c_454_n ) capacitor c=0.028602f \
 //x=2.965 //y=0.375 //x2=3.585 //y2=1.58
cc_176 ( N_noxref_4_c_173_n N_noxref_7_c_455_n ) capacitor c=0.00362807f \
 //x=3.985 //y=0.54 //x2=3.985 //y2=1.665
cc_177 ( N_noxref_4_M2_noxref_s N_noxref_7_c_455_n ) capacitor c=0.0106347f \
 //x=2.965 //y=0.375 //x2=3.985 //y2=1.665
cc_178 ( N_noxref_4_c_173_n N_noxref_7_M2_noxref_d ) capacitor c=0.00910163f \
 //x=3.985 //y=0.54 //x2=3.395 //y2=0.915
cc_179 ( N_noxref_4_c_196_p N_noxref_7_M2_noxref_d ) capacitor c=0.00120711f \
 //x=3.1 //y=0.995 //x2=3.395 //y2=0.915
cc_180 ( N_noxref_4_M2_noxref_s N_noxref_7_M2_noxref_d ) capacitor \
 c=0.0279003f //x=2.965 //y=0.375 //x2=3.395 //y2=0.915
cc_181 ( N_noxref_4_c_172_n N_noxref_8_c_529_n ) capacitor c=2.15937e-19 \
 //x=3.1 //y=0.625 //x2=1.56 //y2=0.625
cc_182 ( N_noxref_4_c_171_n N_noxref_8_c_530_n ) capacitor c=0.0132582f \
 //x=3.015 //y=0.995 //x2=2.445 //y2=0.54
cc_183 ( N_noxref_4_M1_noxref_d N_noxref_8_c_530_n ) capacitor c=0.016458f \
 //x=1.86 //y=0.91 //x2=2.445 //y2=0.54
cc_184 ( N_noxref_4_c_171_n N_noxref_8_c_547_n ) capacitor c=0.00954209f \
 //x=3.015 //y=0.995 //x2=2.445 //y2=1.59
cc_185 ( N_noxref_4_M1_noxref_d N_noxref_8_c_547_n ) capacitor c=0.0152939f \
 //x=1.86 //y=0.91 //x2=2.445 //y2=1.59
cc_186 ( N_noxref_4_c_171_n N_noxref_8_M0_noxref_s ) capacitor c=0.023368f \
 //x=3.015 //y=0.995 //x2=0.455 //y2=0.375
cc_187 ( N_noxref_4_c_172_n N_noxref_8_M0_noxref_s ) capacitor c=0.0182125f \
 //x=3.1 //y=0.625 //x2=0.455 //y2=0.375
cc_188 ( N_noxref_4_M1_noxref_d N_noxref_8_M0_noxref_s ) capacitor \
 c=0.0187969f //x=1.86 //y=0.91 //x2=0.455 //y2=0.375
cc_189 ( N_noxref_4_M2_noxref_s N_noxref_8_M0_noxref_s ) capacitor \
 c=0.0210061f //x=2.965 //y=0.375 //x2=0.455 //y2=0.375
cc_190 ( N_noxref_5_c_225_n N_noxref_6_c_333_n ) capacitor c=0.0116288f \
 //x=2.22 //y=2.195 //x2=3.33 //y2=2.195
cc_191 ( N_noxref_5_c_234_n N_noxref_6_c_333_n ) capacitor c=5.39999e-19 \
 //x=2.22 //y=2.08 //x2=3.33 //y2=2.195
cc_192 ( N_noxref_5_c_253_n N_noxref_6_c_333_n ) capacitor c=0.00141236f \
 //x=2.31 //y=1.915 //x2=3.33 //y2=2.195
cc_193 ( N_noxref_5_c_229_n N_noxref_6_c_336_n ) capacitor c=0.0842952f \
 //x=2.22 //y=4.585 //x2=3.33 //y2=4.57
cc_194 ( N_noxref_5_c_234_n N_noxref_6_c_336_n ) capacitor c=4.16726e-19 \
 //x=2.22 //y=2.08 //x2=3.33 //y2=4.57
cc_195 ( N_noxref_5_c_238_n N_noxref_6_c_336_n ) capacitor c=9.52396e-19 \
 //x=2.22 //y=4.7 //x2=3.33 //y2=4.57
cc_196 ( N_noxref_5_c_256_n N_noxref_6_c_336_n ) capacitor c=8.42568e-19 \
 //x=2.22 //y=4.7 //x2=3.33 //y2=4.57
cc_197 ( N_noxref_5_c_225_n N_noxref_6_c_334_n ) capacitor c=5.42289e-19 \
 //x=2.22 //y=2.195 //x2=3.33 //y2=2.08
cc_198 ( N_noxref_5_c_229_n N_noxref_6_c_334_n ) capacitor c=4.16726e-19 \
 //x=2.22 //y=4.585 //x2=3.33 //y2=2.08
cc_199 ( N_noxref_5_c_234_n N_noxref_6_c_334_n ) capacitor c=0.00125213f \
 //x=2.22 //y=2.08 //x2=3.33 //y2=2.08
cc_200 ( N_noxref_5_c_253_n N_noxref_6_c_334_n ) capacitor c=0.00209664f \
 //x=2.31 //y=1.915 //x2=3.33 //y2=2.08
cc_201 ( N_noxref_5_c_229_n N_noxref_6_c_327_n ) capacitor c=7.51101e-19 \
 //x=2.22 //y=4.585 //x2=3.33 //y2=4.7
cc_202 ( N_noxref_5_c_238_n N_noxref_6_c_327_n ) capacitor c=0.00113985f \
 //x=2.22 //y=4.7 //x2=3.33 //y2=4.7
cc_203 ( N_noxref_5_c_256_n N_noxref_6_c_327_n ) capacitor c=0.00129812f \
 //x=2.22 //y=4.7 //x2=3.33 //y2=4.7
cc_204 ( N_noxref_5_M5_noxref_g N_noxref_6_M7_noxref_g ) capacitor \
 c=0.0101598f //x=2.19 //y=6.02 //x2=3.07 //y2=6.02
cc_205 ( N_noxref_5_M6_noxref_g N_noxref_6_M7_noxref_g ) capacitor \
 c=0.0607518f //x=2.63 //y=6.02 //x2=3.07 //y2=6.02
cc_206 ( N_noxref_5_M6_noxref_g N_noxref_6_M8_noxref_g ) capacitor \
 c=0.0101598f //x=2.63 //y=6.02 //x2=3.51 //y2=6.02
cc_207 ( N_noxref_5_c_250_n N_noxref_6_c_339_n ) capacitor c=0.00456962f \
 //x=2.31 //y=0.91 //x2=3.32 //y2=0.915
cc_208 ( N_noxref_5_c_251_n N_noxref_6_c_341_n ) capacitor c=0.00438372f \
 //x=2.31 //y=1.22 //x2=3.32 //y2=1.26
cc_209 ( N_noxref_5_c_252_n N_noxref_6_c_342_n ) capacitor c=0.00438372f \
 //x=2.31 //y=1.45 //x2=3.32 //y2=1.57
cc_210 ( N_noxref_5_c_225_n N_noxref_6_c_346_n ) capacitor c=0.00139071f \
 //x=2.22 //y=2.195 //x2=3.33 //y2=2.08
cc_211 ( N_noxref_5_c_234_n N_noxref_6_c_346_n ) capacitor c=0.00204868f \
 //x=2.22 //y=2.08 //x2=3.33 //y2=2.08
cc_212 ( N_noxref_5_c_253_n N_noxref_6_c_346_n ) capacitor c=0.00933826f \
 //x=2.31 //y=1.915 //x2=3.33 //y2=2.08
cc_213 ( N_noxref_5_c_253_n N_noxref_6_c_370_n ) capacitor c=0.00438372f \
 //x=2.31 //y=1.915 //x2=3.33 //y2=1.915
cc_214 ( N_noxref_5_c_229_n N_noxref_6_c_332_n ) capacitor c=0.00124604f \
 //x=2.22 //y=4.585 //x2=3.33 //y2=4.7
cc_215 ( N_noxref_5_c_238_n N_noxref_6_c_332_n ) capacitor c=0.00187046f \
 //x=2.22 //y=4.7 //x2=3.33 //y2=4.7
cc_216 ( N_noxref_5_c_301_p N_noxref_6_c_332_n ) capacitor c=0.0616777f \
 //x=2.555 //y=4.79 //x2=3.33 //y2=4.7
cc_217 ( N_noxref_5_c_256_n N_noxref_6_c_332_n ) capacitor c=0.00487508f \
 //x=2.22 //y=4.7 //x2=3.33 //y2=4.7
cc_218 ( N_noxref_5_c_229_n N_noxref_7_c_414_n ) capacitor c=0.0220212f \
 //x=2.22 //y=4.585 //x2=2.29 //y2=5.155
cc_219 ( N_noxref_5_c_238_n N_noxref_7_c_414_n ) capacitor c=0.00492634f \
 //x=2.22 //y=4.7 //x2=2.29 //y2=5.155
cc_220 ( N_noxref_5_M5_noxref_g N_noxref_7_c_414_n ) capacitor c=0.00858241f \
 //x=2.19 //y=6.02 //x2=2.29 //y2=5.155
cc_221 ( N_noxref_5_c_256_n N_noxref_7_c_414_n ) capacitor c=6.59853e-19 \
 //x=2.22 //y=4.7 //x2=2.29 //y2=5.155
cc_222 ( N_noxref_5_M6_noxref_g N_noxref_7_c_418_n ) capacitor c=0.0136936f \
 //x=2.63 //y=6.02 //x2=3.175 //y2=5.155
cc_223 ( N_noxref_5_c_229_n N_noxref_7_c_429_n ) capacitor c=0.00430203f \
 //x=2.22 //y=4.585 //x2=4.07 //y2=5.07
cc_224 ( N_noxref_5_c_229_n N_noxref_7_c_434_n ) capacitor c=0.00259321f \
 //x=2.22 //y=4.585 //x2=2.41 //y2=5.155
cc_225 ( N_noxref_5_c_238_n N_noxref_7_c_434_n ) capacitor c=0.00132214f \
 //x=2.22 //y=4.7 //x2=2.41 //y2=5.155
cc_226 ( N_noxref_5_M5_noxref_g N_noxref_7_c_434_n ) capacitor c=0.00229818f \
 //x=2.19 //y=6.02 //x2=2.41 //y2=5.155
cc_227 ( N_noxref_5_M6_noxref_g N_noxref_7_c_434_n ) capacitor c=0.00230699f \
 //x=2.63 //y=6.02 //x2=2.41 //y2=5.155
cc_228 ( N_noxref_5_c_301_p N_noxref_7_c_434_n ) capacitor c=0.00171075f \
 //x=2.555 //y=4.79 //x2=2.41 //y2=5.155
cc_229 ( N_noxref_5_c_229_n N_noxref_7_c_443_n ) capacitor c=7.85344e-19 \
 //x=2.22 //y=4.585 //x2=2.41 //y2=5.38
cc_230 ( N_noxref_5_M5_noxref_g N_noxref_7_c_443_n ) capacitor c=0.0179041f \
 //x=2.19 //y=6.02 //x2=2.41 //y2=5.38
cc_231 ( N_noxref_5_M6_noxref_g N_noxref_7_c_443_n ) capacitor c=0.0179041f \
 //x=2.63 //y=6.02 //x2=2.41 //y2=5.38
cc_232 ( N_noxref_5_c_301_p N_noxref_7_c_443_n ) capacitor c=0.00290085f \
 //x=2.555 //y=4.79 //x2=2.41 //y2=5.38
cc_233 ( N_noxref_5_c_245_n N_noxref_8_c_530_n ) capacitor c=0.0167228f \
 //x=1.785 //y=0.91 //x2=2.445 //y2=0.54
cc_234 ( N_noxref_5_c_250_n N_noxref_8_c_530_n ) capacitor c=0.00534519f \
 //x=2.31 //y=0.91 //x2=2.445 //y2=0.54
cc_235 ( N_noxref_5_c_225_n N_noxref_8_c_547_n ) capacitor c=0.0048147f \
 //x=2.22 //y=2.195 //x2=2.445 //y2=1.59
cc_236 ( N_noxref_5_c_234_n N_noxref_8_c_547_n ) capacitor c=0.0105652f \
 //x=2.22 //y=2.08 //x2=2.445 //y2=1.59
cc_237 ( N_noxref_5_c_248_n N_noxref_8_c_547_n ) capacitor c=0.0153476f \
 //x=1.785 //y=1.22 //x2=2.445 //y2=1.59
cc_238 ( N_noxref_5_c_253_n N_noxref_8_c_547_n ) capacitor c=0.0206484f \
 //x=2.31 //y=1.915 //x2=2.445 //y2=1.59
cc_239 ( N_noxref_5_c_245_n N_noxref_8_M0_noxref_s ) capacitor c=0.00798959f \
 //x=1.785 //y=0.91 //x2=0.455 //y2=0.375
cc_240 ( N_noxref_5_c_252_n N_noxref_8_M0_noxref_s ) capacitor c=0.00212176f \
 //x=2.31 //y=1.45 //x2=0.455 //y2=0.375
cc_241 ( N_noxref_5_c_253_n N_noxref_8_M0_noxref_s ) capacitor c=0.00298115f \
 //x=2.31 //y=1.915 //x2=0.455 //y2=0.375
cc_242 ( N_noxref_6_M7_noxref_g N_noxref_7_c_418_n ) capacitor c=0.0136936f \
 //x=3.07 //y=6.02 //x2=3.175 //y2=5.155
cc_243 ( N_noxref_6_M7_noxref_g N_noxref_7_c_422_n ) capacitor c=0.00226521f \
 //x=3.07 //y=6.02 //x2=3.29 //y2=5.38
cc_244 ( N_noxref_6_M8_noxref_g N_noxref_7_c_422_n ) capacitor c=0.00427254f \
 //x=3.51 //y=6.02 //x2=3.29 //y2=5.38
cc_245 ( N_noxref_6_c_336_n N_noxref_7_c_425_n ) capacitor c=0.00244389f \
 //x=3.33 //y=4.57 //x2=3.985 //y2=5.155
cc_246 ( N_noxref_6_c_327_n N_noxref_7_c_425_n ) capacitor c=0.00130631f \
 //x=3.33 //y=4.7 //x2=3.985 //y2=5.155
cc_247 ( N_noxref_6_M8_noxref_g N_noxref_7_c_425_n ) capacitor c=0.0122802f \
 //x=3.51 //y=6.02 //x2=3.985 //y2=5.155
cc_248 ( N_noxref_6_c_339_n N_noxref_7_c_453_n ) capacitor c=4.64015e-19 \
 //x=3.32 //y=0.915 //x2=3.585 //y2=1.125
cc_249 ( N_noxref_6_c_341_n N_noxref_7_c_453_n ) capacitor c=0.0026012f \
 //x=3.32 //y=1.26 //x2=3.585 //y2=1.125
cc_250 ( N_noxref_6_c_383_p N_noxref_7_c_453_n ) capacitor c=5.29969e-19 \
 //x=3.695 //y=0.76 //x2=3.585 //y2=1.125
cc_251 ( N_noxref_6_c_384_p N_noxref_7_c_453_n ) capacitor c=5.54437e-19 \
 //x=3.695 //y=1.415 //x2=3.585 //y2=1.125
cc_252 ( N_noxref_6_c_343_n N_noxref_7_c_453_n ) capacitor c=5.7502e-19 \
 //x=3.85 //y=0.915 //x2=3.585 //y2=1.125
cc_253 ( N_noxref_6_c_335_n N_noxref_7_c_453_n ) capacitor c=0.00357756f \
 //x=3.85 //y=1.26 //x2=3.585 //y2=1.125
cc_254 ( N_noxref_6_c_341_n N_noxref_7_c_454_n ) capacitor c=0.00127432f \
 //x=3.32 //y=1.26 //x2=3.585 //y2=1.58
cc_255 ( N_noxref_6_c_342_n N_noxref_7_c_454_n ) capacitor c=0.00429966f \
 //x=3.32 //y=1.57 //x2=3.585 //y2=1.58
cc_256 ( N_noxref_6_c_384_p N_noxref_7_c_454_n ) capacitor c=0.00942306f \
 //x=3.695 //y=1.415 //x2=3.585 //y2=1.58
cc_257 ( N_noxref_6_c_335_n N_noxref_7_c_454_n ) capacitor c=0.00363411f \
 //x=3.85 //y=1.26 //x2=3.585 //y2=1.58
cc_258 ( N_noxref_6_c_370_n N_noxref_7_c_454_n ) capacitor c=0.00372124f \
 //x=3.33 //y=1.915 //x2=3.585 //y2=1.58
cc_259 ( N_noxref_6_c_384_p N_noxref_7_c_455_n ) capacitor c=0.00194716f \
 //x=3.695 //y=1.415 //x2=3.985 //y2=1.665
cc_260 ( N_noxref_6_c_335_n N_noxref_7_c_455_n ) capacitor c=0.00323576f \
 //x=3.85 //y=1.26 //x2=3.985 //y2=1.665
cc_261 ( N_noxref_6_c_333_n N_noxref_7_c_429_n ) capacitor c=0.0148484f \
 //x=3.33 //y=2.195 //x2=4.07 //y2=5.07
cc_262 ( N_noxref_6_c_336_n N_noxref_7_c_429_n ) capacitor c=0.128266f \
 //x=3.33 //y=4.57 //x2=4.07 //y2=5.07
cc_263 ( N_noxref_6_c_334_n N_noxref_7_c_429_n ) capacitor c=0.00448538f \
 //x=3.33 //y=2.08 //x2=4.07 //y2=5.07
cc_264 ( N_noxref_6_c_327_n N_noxref_7_c_429_n ) capacitor c=0.00442006f \
 //x=3.33 //y=4.7 //x2=4.07 //y2=5.07
cc_265 ( N_noxref_6_c_346_n N_noxref_7_c_429_n ) capacitor c=0.00246559f \
 //x=3.33 //y=2.08 //x2=4.07 //y2=5.07
cc_266 ( N_noxref_6_c_332_n N_noxref_7_c_429_n ) capacitor c=0.0035458f \
 //x=3.33 //y=4.7 //x2=4.07 //y2=5.07
cc_267 ( N_noxref_6_c_336_n N_noxref_7_c_514_n ) capacitor c=0.024066f \
 //x=3.33 //y=4.57 //x2=3.29 //y2=5.155
cc_268 ( N_noxref_6_c_327_n N_noxref_7_c_514_n ) capacitor c=0.00346456f \
 //x=3.33 //y=4.7 //x2=3.29 //y2=5.155
cc_269 ( N_noxref_6_c_332_n N_noxref_7_c_514_n ) capacitor c=0.00203307f \
 //x=3.33 //y=4.7 //x2=3.29 //y2=5.155
cc_270 ( N_noxref_6_c_336_n N_noxref_7_c_448_n ) capacitor c=0.00266871f \
 //x=3.33 //y=4.57 //x2=3.29 //y2=5.38
cc_271 ( N_noxref_6_c_327_n N_noxref_7_c_448_n ) capacitor c=0.00624059f \
 //x=3.33 //y=4.7 //x2=3.29 //y2=5.38
cc_272 ( N_noxref_6_M7_noxref_g N_noxref_7_c_448_n ) capacitor c=0.0178885f \
 //x=3.07 //y=6.02 //x2=3.29 //y2=5.38
cc_273 ( N_noxref_6_M8_noxref_g N_noxref_7_c_448_n ) capacitor c=0.0188608f \
 //x=3.51 //y=6.02 //x2=3.29 //y2=5.38
cc_274 ( N_noxref_6_c_332_n N_noxref_7_c_448_n ) capacitor c=0.00375636f \
 //x=3.33 //y=4.7 //x2=3.29 //y2=5.38
cc_275 ( N_noxref_6_c_339_n N_noxref_7_M2_noxref_d ) capacitor c=0.00137165f \
 //x=3.32 //y=0.915 //x2=3.395 //y2=0.915
cc_276 ( N_noxref_6_c_341_n N_noxref_7_M2_noxref_d ) capacitor c=0.00237422f \
 //x=3.32 //y=1.26 //x2=3.395 //y2=0.915
cc_277 ( N_noxref_6_c_383_p N_noxref_7_M2_noxref_d ) capacitor c=0.0020782f \
 //x=3.695 //y=0.76 //x2=3.395 //y2=0.915
cc_278 ( N_noxref_6_c_384_p N_noxref_7_M2_noxref_d ) capacitor c=0.00356097f \
 //x=3.695 //y=1.415 //x2=3.395 //y2=0.915
cc_279 ( N_noxref_6_c_343_n N_noxref_7_M2_noxref_d ) capacitor c=0.00139206f \
 //x=3.85 //y=0.915 //x2=3.395 //y2=0.915
cc_280 ( N_noxref_6_c_335_n N_noxref_7_M2_noxref_d ) capacitor c=0.00237422f \
 //x=3.85 //y=1.26 //x2=3.395 //y2=0.915
