// File: AOA4X1.spi.pex
// Created: Sun Mar 15 12:39:00 2026
// Program "Calibre xRC"
// Version "v2023.2_27.15"
// Nominal Temperature: 30C
// Circuit Temperature: 30C
//
simulator lang=spectre
subckt PM_AOA4X1\%noxref_1 ( 3 8 9 11 12 14 15 16 18 19 20 23 24 27 29 34 38 \
 40 44 51 53 54 57 65 82 87 95 96 97 98 99 100 101 105 107 110 112 113 118 128 \
 130 131 )
c265 ( 128 0 ) capacitor c=0.00878249f //x=2.45 //y=1.085
c266 ( 118 0 ) capacitor c=0.0426341f //x=4.775 //y=4.885
c267 ( 113 0 ) capacitor c=0.0337825f //x=5.265 //y=1.43
c268 ( 112 0 ) capacitor c=0.0183823f //x=5.265 //y=1.085
c269 ( 110 0 ) capacitor c=0.0350928f //x=5.195 //y=4.975
c270 ( 107 0 ) capacitor c=0.013578f //x=5.11 //y=1.585
c271 ( 105 0 ) capacitor c=0.0157803f //x=5.11 //y=0.93
c272 ( 101 0 ) capacitor c=0.0787231f //x=4.735 //y=2.095
c273 ( 100 0 ) capacitor c=0.0230165f //x=4.735 //y=1.74
c274 ( 99 0 ) capacitor c=0.0234348f //x=4.735 //y=1.43
c275 ( 98 0 ) capacitor c=0.019134f //x=4.735 //y=1.085
c276 ( 97 0 ) capacitor c=0.110994f //x=5.27 //y=6.205
c277 ( 96 0 ) capacitor c=0.154777f //x=4.83 //y=6.205
c278 ( 87 0 ) capacitor c=4.74639e-19 //x=4.93 //y=2.26
c279 ( 82 0 ) capacitor c=0.0070524f //x=4.775 //y=4.885
c280 ( 65 0 ) capacitor c=0.0325392f //x=2.6 //y=5.56
c281 ( 57 0 ) capacitor c=0.0291911f //x=1.72 //y=5.56
c282 ( 54 0 ) capacitor c=0.0774598f //x=4.765 //y=2.765
c283 ( 53 0 ) capacitor c=0.00528707f //x=4.925 //y=2.765
c284 ( 51 0 ) capacitor c=0.00557932f //x=3.24 //y=2.765
c285 ( 44 0 ) capacitor c=0.00772734f //x=4.775 //y=4.885
c286 ( 40 0 ) capacitor c=0.0063606f //x=4.93 //y=2.26
c287 ( 38 0 ) capacitor c=0.0141822f //x=4.93 //y=2.77
c288 ( 34 0 ) capacitor c=0.0148986f //x=3.08 //y=2.77
c289 ( 29 0 ) capacitor c=0.011771f //x=2.64 //y=1.18
c290 ( 27 0 ) capacitor c=6.70882e-19 //x=2.6 //y=5.56
c291 ( 24 0 ) capacitor c=0.0129472f //x=2.6 //y=5.38
c292 ( 23 0 ) capacitor c=0.0106213f //x=1.72 //y=5.56
c293 ( 20 0 ) capacitor c=0.0626275f //x=4.93 //y=4.765
c294 ( 19 0 ) capacitor c=0.0110376f //x=4.93 //y=2.925
c295 ( 18 0 ) capacitor c=0.00428329f //x=4.93 //y=2.605
c296 ( 16 0 ) capacitor c=0.0762425f //x=3.08 //y=5.295
c297 ( 15 0 ) capacitor c=0.0117766f //x=3.08 //y=2.925
c298 ( 14 0 ) capacitor c=0.0169876f //x=3.08 //y=2.605
c299 ( 12 0 ) capacitor c=0.00837358f //x=2.725 //y=1.835
c300 ( 11 0 ) capacitor c=0.0136795f //x=2.995 //y=1.835
c301 ( 9 0 ) capacitor c=0.0123394f //x=2.995 //y=5.38
c302 ( 8 0 ) capacitor c=0.012699f //x=2.64 //y=1.75
c303 ( 3 0 ) capacitor c=0.019362f //x=2.485 //y=5.38
r304 (  120 121 ) resistor r=32.4568 //w=0.214 //l=0.075 //layer=ply \
 //thickness=0.18 //x=4.775 //y=4.975 //x2=4.775 //y2=5.05
r305 (  118 120 ) resistor r=20.271 //w=0.214 //l=0.09 //layer=ply \
 //thickness=0.18 //x=4.775 //y=4.885 //x2=4.775 //y2=4.975
r306 (  113 127 ) resistor r=45.1352 //w=0.168 //l=0.173853 //layer=ply \
 //thickness=0.18 //x=5.265 //y=1.43 //x2=5.225 //y2=1.585
r307 (  112 126 ) resistor r=45.1352 //w=0.168 //l=0.173853 //layer=ply \
 //thickness=0.18 //x=5.265 //y=1.085 //x2=5.225 //y2=0.93
r308 (  112 113 ) resistor r=176.904 //w=0.094 //l=0.345 //layer=ply \
 //thickness=0.18 //x=5.265 //y=1.085 //x2=5.265 //y2=1.43
r309 (  111 120 ) resistor r=16.5046 //w=0.27 //l=0.135 //layer=ply \
 //thickness=0.18 //x=4.91 //y=4.975 //x2=4.775 //y2=4.975
r310 (  110 114 ) resistor r=26.9307 //w=0.15 //l=0.106066 //layer=ply \
 //thickness=0.18 //x=5.195 //y=4.975 //x2=5.27 //y2=5.05
r311 (  110 111 ) resistor r=146.138 //w=0.094 //l=0.285 //layer=ply \
 //thickness=0.18 //x=5.195 //y=4.975 //x2=4.91 //y2=4.975
r312 (  108 125 ) resistor r=10.701 //w=0.21 //l=0.115 //layer=ply \
 //thickness=0.18 //x=4.89 //y=1.585 //x2=4.775 //y2=1.585
r313 (  107 127 ) resistor r=5.52526 //w=0.168 //l=0.115 //layer=ply \
 //thickness=0.18 //x=5.11 //y=1.585 //x2=5.225 //y2=1.585
r314 (  106 124 ) resistor r=5.52526 //w=0.168 //l=0.115 //layer=ply \
 //thickness=0.18 //x=4.89 //y=0.93 //x2=4.775 //y2=0.93
r315 (  105 126 ) resistor r=5.52526 //w=0.168 //l=0.115 //layer=ply \
 //thickness=0.18 //x=5.11 //y=0.93 //x2=5.225 //y2=0.93
r316 (  105 106 ) resistor r=112.809 //w=0.094 //l=0.22 //layer=ply \
 //thickness=0.18 //x=5.11 //y=0.93 //x2=4.89 //y2=0.93
r317 (  101 123 ) resistor r=34.8111 //w=0.27 //l=0.264953 //layer=ply \
 //thickness=0.18 //x=4.735 //y=2.095 //x2=4.93 //y2=2.26
r318 (  100 125 ) resistor r=39.5823 //w=0.21 //l=0.173853 //layer=ply \
 //thickness=0.18 //x=4.735 //y=1.74 //x2=4.775 //y2=1.585
r319 (  100 101 ) resistor r=182.032 //w=0.094 //l=0.355 //layer=ply \
 //thickness=0.18 //x=4.735 //y=1.74 //x2=4.735 //y2=2.095
r320 (  99 125 ) resistor r=39.5823 //w=0.21 //l=0.173853 //layer=ply \
 //thickness=0.18 //x=4.735 //y=1.43 //x2=4.775 //y2=1.585
r321 (  98 124 ) resistor r=45.1352 //w=0.168 //l=0.173853 //layer=ply \
 //thickness=0.18 //x=4.735 //y=1.085 //x2=4.775 //y2=0.93
r322 (  98 99 ) resistor r=176.904 //w=0.094 //l=0.345 //layer=ply \
 //thickness=0.18 //x=4.735 //y=1.085 //x2=4.735 //y2=1.43
r323 (  97 114 ) resistor r=592.245 //w=0.094 //l=1.155 //layer=ply \
 //thickness=0.18 //x=5.27 //y=6.205 //x2=5.27 //y2=5.05
r324 (  96 121 ) resistor r=592.245 //w=0.094 //l=1.155 //layer=ply \
 //thickness=0.18 //x=4.83 //y=6.205 //x2=4.83 //y2=5.05
r325 (  95 107 ) resistor r=56.4043 //w=0.094 //l=0.11 //layer=ply \
 //thickness=0.18 //x=5 //y=1.585 //x2=5.11 //y2=1.585
r326 (  95 108 ) resistor r=56.4043 //w=0.094 //l=0.11 //layer=ply \
 //thickness=0.18 //x=5 //y=1.585 //x2=4.89 //y2=1.585
r327 (  87 123 ) resistor r=152 //w=0.17 //l=0.17 //layer=licon //count=1 \
 //x=4.93 //y=2.26 //x2=4.93 //y2=2.26
r328 (  82 118 ) resistor r=152 //w=0.17 //l=0.17 //layer=licon //count=1 \
 //x=4.775 //y=4.885 //x2=4.775 //y2=4.885
r329 (  65 131 ) resistor r=23.615 //w=0.187 //l=0.345 //layer=li \
 //thickness=0.1 //x=2.6 //y=5.56 //x2=2.6 //y2=5.905
r330 (  57 130 ) resistor r=23.615 //w=0.187 //l=0.345 //layer=li \
 //thickness=0.1 //x=1.72 //y=5.56 //x2=1.72 //y2=5.905
r331 (  53 54 ) resistor r=0.10734 //w=0.281 //l=0.16 //layer=m2 \
 //thickness=0.36 //x=4.925 //y=2.765 //x2=4.765 //y2=2.765
r332 (  51 54 ) resistor r=1.45515 //w=0.131 //l=1.525 //layer=m2 \
 //thickness=0.36 //x=3.24 //y=2.77 //x2=4.765 //y2=2.77
r333 (  49 51 ) resistor r=0.10734 //w=0.281 //l=0.16 //layer=m2 \
 //thickness=0.36 //x=3.08 //y=2.765 //x2=3.24 //y2=2.765
r334 (  44 82 ) resistor r=9.3 //w=0.17 //l=0.17 //layer=mcon //count=1 \
 //x=4.775 //y=4.885 //x2=4.775 //y2=4.885
r335 (  44 45 ) resistor r=0.0853524 //w=0.227 //l=0.155 //layer=m1 \
 //thickness=0.36 //x=4.775 //y=4.882 //x2=4.93 //y2=4.882
r336 (  40 87 ) resistor r=9.3 //w=0.17 //l=0.17 //layer=mcon //count=1 \
 //x=4.93 //y=2.26 //x2=4.93 //y2=2.26
r337 (  40 42 ) resistor r=0.0985786 //w=0.206 //l=0.135 //layer=m1 \
 //thickness=0.36 //x=4.927 //y=2.26 //x2=4.927 //y2=2.395
r338 (  36 53 ) resistor r=4.5 //w=0.15 //l=0.15 //layer=via1 //count=1 \
 //x=4.925 //y=2.765 //x2=4.925 //y2=2.765
r339 (  36 38 ) resistor r=0.00167112 //w=0.374 //l=0.005 //layer=m1 \
 //thickness=0.36 //x=4.875 //y=2.765 //x2=4.875 //y2=2.77
r340 (  32 49 ) resistor r=4.5 //w=0.15 //l=0.15 //layer=via1 //count=1 \
 //x=3.08 //y=2.765 //x2=3.08 //y2=2.765
r341 (  32 34 ) resistor r=0.00166223 //w=0.376 //l=0.005 //layer=m1 \
 //thickness=0.36 //x=3.132 //y=2.765 //x2=3.132 //y2=2.77
r342 (  29 128 ) resistor r=9.3 //w=0.17 //l=0.17 //layer=mcon //count=1 \
 //x=2.64 //y=1.18 //x2=2.64 //y2=1.18
r343 (  27 65 ) resistor r=9.3 //w=0.17 //l=0.17 //layer=mcon //count=1 \
 //x=2.6 //y=5.56 //x2=2.6 //y2=5.56
r344 (  24 27 ) resistor r=0.117801 //w=0.191 //l=0.18 //layer=m1 \
 //thickness=0.36 //x=2.6 //y=5.38 //x2=2.6 //y2=5.56
r345 (  23 57 ) resistor r=9.3 //w=0.17 //l=0.17 //layer=mcon //count=1 \
 //x=1.72 //y=5.56 //x2=1.72 //y2=5.56
r346 (  21 23 ) resistor r=0.10274 //w=0.219 //l=0.18 //layer=m1 \
 //thickness=0.36 //x=1.72 //y=5.38 //x2=1.72 //y2=5.56
r347 (  20 45 ) resistor r=0.0249239 //w=0.227 //l=0.117 //layer=m1 \
 //thickness=0.36 //x=4.93 //y=4.765 //x2=4.93 //y2=4.882
r348 (  19 38 ) resistor r=0.089409 //w=0.374 //l=0.180416 //layer=m1 \
 //thickness=0.36 //x=4.93 //y=2.925 //x2=4.875 //y2=2.77
r349 (  19 20 ) resistor r=1.75573 //w=0.131 //l=1.84 //layer=m1 \
 //thickness=0.36 //x=4.93 //y=2.925 //x2=4.93 //y2=4.765
r350 (  18 36 ) resistor r=0.0910802 //w=0.374 //l=0.185472 //layer=m1 \
 //thickness=0.36 //x=4.93 //y=2.605 //x2=4.875 //y2=2.765
r351 (  18 42 ) resistor r=0.200382 //w=0.131 //l=0.21 //layer=m1 \
 //thickness=0.36 //x=4.93 //y=2.605 //x2=4.93 //y2=2.395
r352 (  15 34 ) resistor r=0.0894971 //w=0.376 //l=0.179123 //layer=m1 \
 //thickness=0.36 //x=3.08 //y=2.925 //x2=3.132 //y2=2.77
r353 (  15 16 ) resistor r=2.26145 //w=0.131 //l=2.37 //layer=m1 \
 //thickness=0.36 //x=3.08 //y=2.925 //x2=3.08 //y2=5.295
r354 (  14 32 ) resistor r=0.0911593 //w=0.376 //l=0.184174 //layer=m1 \
 //thickness=0.36 //x=3.08 //y=2.605 //x2=3.132 //y2=2.765
r355 (  13 14 ) resistor r=0.653626 //w=0.131 //l=0.685 //layer=m1 \
 //thickness=0.36 //x=3.08 //y=1.92 //x2=3.08 //y2=2.605
r356 (  11 13 ) resistor r=0.0698411 //w=0.17 //l=0.120208 //layer=m1 \
 //thickness=0.36 //x=2.995 //y=1.835 //x2=3.08 //y2=1.92
r357 (  11 12 ) resistor r=0.257634 //w=0.131 //l=0.27 //layer=m1 \
 //thickness=0.36 //x=2.995 //y=1.835 //x2=2.725 //y2=1.835
r358 (  10 24 ) resistor r=0.0257089 //w=0.23 //l=0.115 //layer=m1 \
 //thickness=0.36 //x=2.715 //y=5.38 //x2=2.6 //y2=5.38
r359 (  9 16 ) resistor r=0.0698411 //w=0.17 //l=0.120208 //layer=m1 \
 //thickness=0.36 //x=2.995 //y=5.38 //x2=3.08 //y2=5.295
r360 (  9 10 ) resistor r=0.267176 //w=0.131 //l=0.28 //layer=m1 \
 //thickness=0.36 //x=2.995 //y=5.38 //x2=2.715 //y2=5.38
r361 (  8 12 ) resistor r=0.0698411 //w=0.17 //l=0.120208 //layer=m1 \
 //thickness=0.36 //x=2.64 //y=1.75 //x2=2.725 //y2=1.835
r362 (  7 29 ) resistor r=0.0913624 //w=0.191 //l=0.12 //layer=m1 \
 //thickness=0.36 //x=2.64 //y=1.3 //x2=2.64 //y2=1.18
r363 (  7 8 ) resistor r=0.429389 //w=0.131 //l=0.45 //layer=m1 \
 //thickness=0.36 //x=2.64 //y=1.3 //x2=2.64 //y2=1.75
r364 (  4 21 ) resistor r=0.0227762 //w=0.219 //l=0.115 //layer=m1 \
 //thickness=0.36 //x=1.835 //y=5.38 //x2=1.72 //y2=5.38
r365 (  3 24 ) resistor r=0.0257089 //w=0.23 //l=0.115 //layer=m1 \
 //thickness=0.36 //x=2.485 //y=5.38 //x2=2.6 //y2=5.38
r366 (  3 4 ) resistor r=0.620229 //w=0.131 //l=0.65 //layer=m1 \
 //thickness=0.36 //x=2.485 //y=5.38 //x2=1.835 //y2=5.38
ends PM_AOA4X1\%noxref_1

subckt PM_AOA4X1\%noxref_2 ( 1 2 3 4 5 6 7 9 12 13 14 16 17 22 30 34 36 39 40 \
 47 49 50 58 75 84 88 89 90 91 92 93 94 98 100 103 104 114 117 118 121 )
c272 ( 118 0 ) capacitor c=0.00901091f //x=5.78 //y=1.085
c273 ( 117 0 ) capacitor c=0.00876479f //x=4.81 //y=1.085
c274 ( 114 0 ) capacitor c=0.0682508f //x=8.26 //y=4.88
c275 ( 104 0 ) capacitor c=0.0318956f //x=8.595 //y=1.39
c276 ( 103 0 ) capacitor c=0.0186809f //x=8.595 //y=1.045
c277 ( 100 0 ) capacitor c=0.0141821f //x=8.44 //y=1.545
c278 ( 98 0 ) capacitor c=0.0158553f //x=8.44 //y=0.89
c279 ( 94 0 ) capacitor c=0.0815046f //x=8.065 //y=2.095
c280 ( 93 0 ) capacitor c=0.0229235f //x=8.065 //y=1.7
c281 ( 92 0 ) capacitor c=0.0234359f //x=8.065 //y=1.39
c282 ( 91 0 ) capacitor c=0.0198759f //x=8.065 //y=1.045
c283 ( 90 0 ) capacitor c=0.110369f //x=8.6 //y=6.2
c284 ( 89 0 ) capacitor c=0.154619f //x=8.16 //y=6.2
c285 ( 84 0 ) capacitor c=8.13425e-19 //x=8.26 //y=4.88
c286 ( 75 0 ) capacitor c=5.17312e-19 //x=8.26 //y=2.26
c287 ( 58 0 ) capacitor c=0.0245539f //x=5.93 //y=5.56
c288 ( 50 0 ) capacitor c=0.0772176f //x=8.09 //y=2.765
c289 ( 49 0 ) capacitor c=0.00407557f //x=8.25 //y=2.765
c290 ( 47 0 ) capacitor c=0.00547085f //x=6.565 //y=2.765
c291 ( 40 0 ) capacitor c=0.061867f //x=8.262 //y=4.74
c292 ( 39 0 ) capacitor c=0.00635496f //x=8.26 //y=4.88
c293 ( 36 0 ) capacitor c=0.00617935f //x=8.26 //y=2.26
c294 ( 34 0 ) capacitor c=0.0141213f //x=8.26 //y=2.77
c295 ( 30 0 ) capacitor c=0.0143422f //x=6.41 //y=2.77
c296 ( 22 0 ) capacitor c=0.0136691f //x=5.925 //y=5.39
c297 ( 21 0 ) capacitor c=0.00513603f //x=5.97 //y=1.835
c298 ( 17 0 ) capacitor c=0.0114695f //x=8.26 //y=2.925
c299 ( 16 0 ) capacitor c=0.0044026f //x=8.26 //y=2.605
c300 ( 14 0 ) capacitor c=0.0748422f //x=6.41 //y=5.305
c301 ( 13 0 ) capacitor c=0.0124328f //x=6.41 //y=2.925
c302 ( 12 0 ) capacitor c=0.0158617f //x=6.41 //y=2.605
c303 ( 9 0 ) capacitor c=0.0141638f //x=6.325 //y=1.835
c304 ( 7 0 ) capacitor c=0.0112568f //x=6.325 //y=5.39
c305 ( 6 0 ) capacitor c=0.00792854f //x=5.97 //y=1.75
c306 ( 5 0 ) capacitor c=0.00855942f //x=5.97 //y=1.3
c307 ( 4 0 ) capacitor c=0.00230949f //x=5.085 //y=1.835
c308 ( 3 0 ) capacitor c=0.0217217f //x=5.885 //y=1.835
c309 ( 2 0 ) capacitor c=0.00638036f //x=5 //y=1.75
c310 ( 1 0 ) capacitor c=0.00825276f //x=5 //y=1.305
r311 (  112 114 ) resistor r=20.6867 //w=0.233 //l=0.1 //layer=ply \
 //thickness=0.18 //x=8.16 //y=4.88 //x2=8.26 //y2=4.88
r312 (  105 114 ) resistor r=70.3348 //w=0.233 //l=0.414367 //layer=ply \
 //thickness=0.18 //x=8.6 //y=5.045 //x2=8.26 //y2=4.88
r313 (  104 116 ) resistor r=45.1352 //w=0.168 //l=0.173853 //layer=ply \
 //thickness=0.18 //x=8.595 //y=1.39 //x2=8.555 //y2=1.545
r314 (  103 115 ) resistor r=45.1352 //w=0.168 //l=0.173853 //layer=ply \
 //thickness=0.18 //x=8.595 //y=1.045 //x2=8.555 //y2=0.89
r315 (  103 104 ) resistor r=176.904 //w=0.094 //l=0.345 //layer=ply \
 //thickness=0.18 //x=8.595 //y=1.045 //x2=8.595 //y2=1.39
r316 (  101 111 ) resistor r=10.701 //w=0.21 //l=0.115 //layer=ply \
 //thickness=0.18 //x=8.22 //y=1.545 //x2=8.105 //y2=1.545
r317 (  100 116 ) resistor r=5.52526 //w=0.168 //l=0.115 //layer=ply \
 //thickness=0.18 //x=8.44 //y=1.545 //x2=8.555 //y2=1.545
r318 (  99 110 ) resistor r=5.52526 //w=0.168 //l=0.115 //layer=ply \
 //thickness=0.18 //x=8.22 //y=0.89 //x2=8.105 //y2=0.89
r319 (  98 115 ) resistor r=5.52526 //w=0.168 //l=0.115 //layer=ply \
 //thickness=0.18 //x=8.44 //y=0.89 //x2=8.555 //y2=0.89
r320 (  98 99 ) resistor r=112.809 //w=0.094 //l=0.22 //layer=ply \
 //thickness=0.18 //x=8.44 //y=0.89 //x2=8.22 //y2=0.89
r321 (  95 112 ) resistor r=13.0941 //w=0.233 //l=0.165 //layer=ply \
 //thickness=0.18 //x=8.16 //y=5.045 //x2=8.16 //y2=4.88
r322 (  94 109 ) resistor r=34.8111 //w=0.27 //l=0.264953 //layer=ply \
 //thickness=0.18 //x=8.065 //y=2.095 //x2=8.26 //y2=2.26
r323 (  93 111 ) resistor r=39.5823 //w=0.21 //l=0.173853 //layer=ply \
 //thickness=0.18 //x=8.065 //y=1.7 //x2=8.105 //y2=1.545
r324 (  93 94 ) resistor r=202.543 //w=0.094 //l=0.395 //layer=ply \
 //thickness=0.18 //x=8.065 //y=1.7 //x2=8.065 //y2=2.095
r325 (  92 111 ) resistor r=39.5823 //w=0.21 //l=0.173853 //layer=ply \
 //thickness=0.18 //x=8.065 //y=1.39 //x2=8.105 //y2=1.545
r326 (  91 110 ) resistor r=45.1352 //w=0.168 //l=0.173853 //layer=ply \
 //thickness=0.18 //x=8.065 //y=1.045 //x2=8.105 //y2=0.89
r327 (  91 92 ) resistor r=176.904 //w=0.094 //l=0.345 //layer=ply \
 //thickness=0.18 //x=8.065 //y=1.045 //x2=8.065 //y2=1.39
r328 (  90 105 ) resistor r=592.245 //w=0.094 //l=1.155 //layer=ply \
 //thickness=0.18 //x=8.6 //y=6.2 //x2=8.6 //y2=5.045
r329 (  89 95 ) resistor r=592.245 //w=0.094 //l=1.155 //layer=ply \
 //thickness=0.18 //x=8.16 //y=6.2 //x2=8.16 //y2=5.045
r330 (  88 100 ) resistor r=56.4043 //w=0.094 //l=0.11 //layer=ply \
 //thickness=0.18 //x=8.33 //y=1.545 //x2=8.44 //y2=1.545
r331 (  88 101 ) resistor r=56.4043 //w=0.094 //l=0.11 //layer=ply \
 //thickness=0.18 //x=8.33 //y=1.545 //x2=8.22 //y2=1.545
r332 (  84 114 ) resistor r=152 //w=0.17 //l=0.17 //layer=licon //count=1 \
 //x=8.26 //y=4.88 //x2=8.26 //y2=4.88
r333 (  75 109 ) resistor r=152 //w=0.17 //l=0.17 //layer=licon //count=1 \
 //x=8.26 //y=2.26 //x2=8.26 //y2=2.26
r334 (  58 121 ) resistor r=23.2727 //w=0.187 //l=0.34 //layer=li \
 //thickness=0.1 //x=5.93 //y=5.56 //x2=5.93 //y2=5.9
r335 (  49 50 ) resistor r=0.104807 //w=0.281 //l=0.16 //layer=m2 \
 //thickness=0.36 //x=8.25 //y=2.765 //x2=8.09 //y2=2.765
r336 (  47 50 ) resistor r=1.40165 //w=0.136 //l=1.525 //layer=m2 \
 //thickness=0.36 //x=6.565 //y=2.767 //x2=8.09 //y2=2.767
r337 (  45 47 ) resistor r=0.104807 //w=0.281 //l=0.16 //layer=m2 \
 //thickness=0.36 //x=6.405 //y=2.765 //x2=6.565 //y2=2.765
r338 (  39 84 ) resistor r=9.3 //w=0.17 //l=0.17 //layer=mcon //count=1 \
 //x=8.26 //y=4.88 //x2=8.26 //y2=4.88
r339 (  39 40 ) resistor r=0.103207 //w=0.196 //l=0.14 //layer=m1 \
 //thickness=0.36 //x=8.262 //y=4.88 //x2=8.262 //y2=4.74
r340 (  36 75 ) resistor r=9.3 //w=0.17 //l=0.17 //layer=mcon //count=1 \
 //x=8.26 //y=2.26 //x2=8.26 //y2=2.26
r341 (  32 49 ) resistor r=4.5 //w=0.15 //l=0.15 //layer=via1 //count=1 \
 //x=8.25 //y=2.765 //x2=8.25 //y2=2.765
r342 (  32 34 ) resistor r=0.00168464 //w=0.371 //l=0.005 //layer=m1 \
 //thickness=0.36 //x=8.202 //y=2.765 //x2=8.202 //y2=2.77
r343 (  28 45 ) resistor r=4.5 //w=0.15 //l=0.15 //layer=via1 //count=1 \
 //x=6.405 //y=2.765 //x2=6.405 //y2=2.765
r344 (  28 30 ) resistor r=0.00164908 //w=0.379 //l=0.005 //layer=m1 \
 //thickness=0.36 //x=6.46 //y=2.765 //x2=6.46 //y2=2.77
r345 (  26 118 ) resistor r=9.3 //w=0.17 //l=0.17 //layer=mcon //count=1 \
 //x=5.97 //y=1.18 //x2=5.97 //y2=1.18
r346 (  24 58 ) resistor r=9.3 //w=0.17 //l=0.17 //layer=mcon //count=1 \
 //x=5.93 //y=5.56 //x2=5.93 //y2=5.56
r347 (  22 24 ) resistor r=0.0974771 //w=0.218 //l=0.17 //layer=m1 \
 //thickness=0.36 //x=5.925 //y=5.39 //x2=5.925 //y2=5.56
r348 (  20 117 ) resistor r=9.3 //w=0.17 //l=0.17 //layer=mcon //count=1 //x=5 \
 //y=1.18 //x2=5 //y2=1.18
r349 (  17 34 ) resistor r=0.0892801 //w=0.371 //l=0.1817 //layer=m1 \
 //thickness=0.36 //x=8.26 //y=2.925 //x2=8.202 //y2=2.77
r350 (  17 40 ) resistor r=1.73187 //w=0.131 //l=1.815 //layer=m1 \
 //thickness=0.36 //x=8.26 //y=2.925 //x2=8.26 //y2=4.74
r351 (  16 32 ) resistor r=0.0909648 //w=0.371 //l=0.186762 //layer=m1 \
 //thickness=0.36 //x=8.26 //y=2.605 //x2=8.202 //y2=2.765
r352 (  15 36 ) resistor r=0.0933015 //w=0.201 //l=0.125 //layer=m1 \
 //thickness=0.36 //x=8.26 //y=2.385 //x2=8.26 //y2=2.26
r353 (  15 16 ) resistor r=0.209924 //w=0.131 //l=0.22 //layer=m1 \
 //thickness=0.36 //x=8.26 //y=2.385 //x2=8.26 //y2=2.605
r354 (  13 30 ) resistor r=0.0896323 //w=0.379 //l=0.178255 //layer=m1 \
 //thickness=0.36 //x=6.41 //y=2.925 //x2=6.46 //y2=2.77
r355 (  13 14 ) resistor r=2.27099 //w=0.131 //l=2.38 //layer=m1 \
 //thickness=0.36 //x=6.41 //y=2.925 //x2=6.41 //y2=5.305
r356 (  12 28 ) resistor r=0.0912814 //w=0.379 //l=0.183303 //layer=m1 \
 //thickness=0.36 //x=6.41 //y=2.605 //x2=6.46 //y2=2.765
r357 (  11 12 ) resistor r=0.653626 //w=0.131 //l=0.685 //layer=m1 \
 //thickness=0.36 //x=6.41 //y=1.92 //x2=6.41 //y2=2.605
r358 (  10 21 ) resistor r=0.0529306 //w=0.17 //l=0.085 //layer=m1 \
 //thickness=0.36 //x=6.055 //y=1.835 //x2=5.97 //y2=1.835
r359 (  9 11 ) resistor r=0.0698411 //w=0.17 //l=0.120208 //layer=m1 \
 //thickness=0.36 //x=6.325 //y=1.835 //x2=6.41 //y2=1.92
r360 (  9 10 ) resistor r=0.257634 //w=0.131 //l=0.27 //layer=m1 \
 //thickness=0.36 //x=6.325 //y=1.835 //x2=6.055 //y2=1.835
r361 (  8 22 ) resistor r=0.0225019 //w=0.218 //l=0.12 //layer=m1 \
 //thickness=0.36 //x=6.045 //y=5.39 //x2=5.925 //y2=5.39
r362 (  7 14 ) resistor r=0.0698411 //w=0.17 //l=0.120208 //layer=m1 \
 //thickness=0.36 //x=6.325 //y=5.39 //x2=6.41 //y2=5.305
r363 (  7 8 ) resistor r=0.267176 //w=0.131 //l=0.28 //layer=m1 \
 //thickness=0.36 //x=6.325 //y=5.39 //x2=6.045 //y2=5.39
r364 (  6 21 ) resistor r=0.0137558 //w=0.34 //l=0.085 //layer=m1 \
 //thickness=0.36 //x=5.97 //y=1.75 //x2=5.97 //y2=1.835
r365 (  5 26 ) resistor r=0.0728765 //w=0.25 //l=0.121491 //layer=m1 \
 //thickness=0.36 //x=5.97 //y=1.3 //x2=5.967 //y2=1.18
r366 (  5 6 ) resistor r=0.429389 //w=0.131 //l=0.45 //layer=m1 \
 //thickness=0.36 //x=5.97 //y=1.3 //x2=5.97 //y2=1.75
r367 (  3 21 ) resistor r=0.0529306 //w=0.17 //l=0.085 //layer=m1 \
 //thickness=0.36 //x=5.885 //y=1.835 //x2=5.97 //y2=1.835
r368 (  3 4 ) resistor r=0.763359 //w=0.131 //l=0.8 //layer=m1 \
 //thickness=0.36 //x=5.885 //y=1.835 //x2=5.085 //y2=1.835
r369 (  2 4 ) resistor r=0.0698411 //w=0.17 //l=0.120208 //layer=m1 \
 //thickness=0.36 //x=5 //y=1.75 //x2=5.085 //y2=1.835
r370 (  1 20 ) resistor r=0.0764279 //w=0.233 //l=0.126491 //layer=m1 \
 //thickness=0.36 //x=5 //y=1.305 //x2=4.997 //y2=1.18
r371 (  1 2 ) resistor r=0.424618 //w=0.131 //l=0.445 //layer=m1 \
 //thickness=0.36 //x=5 //y=1.305 //x2=5 //y2=1.75
ends PM_AOA4X1\%noxref_2

subckt PM_AOA4X1\%noxref_3 ( 3 8 9 11 12 14 15 16 18 19 20 23 24 27 29 34 38 \
 40 49 51 52 55 63 80 89 93 94 95 96 97 98 99 103 104 105 107 113 114 116 124 \
 126 127 )
c231 ( 124 0 ) capacitor c=0.00878249f //x=9.11 //y=1.085
c232 ( 116 0 ) capacitor c=0.0555093f //x=11.22 //y=2.265
c233 ( 114 0 ) capacitor c=0.0439576f //x=11.86 //y=1.435
c234 ( 113 0 ) capacitor c=0.0201087f //x=11.86 //y=1.09
c235 ( 107 0 ) capacitor c=0.0161986f //x=11.705 //y=1.59
c236 ( 105 0 ) capacitor c=0.0157807f //x=11.705 //y=0.935
c237 ( 104 0 ) capacitor c=0.0557689f //x=11.45 //y=4.97
c238 ( 103 0 ) capacitor c=0.0406047f //x=11.74 //y=4.97
c239 ( 99 0 ) capacitor c=0.0301471f //x=11.33 //y=2.1
c240 ( 98 0 ) capacitor c=0.0255349f //x=11.33 //y=1.745
c241 ( 97 0 ) capacitor c=0.0234346f //x=11.33 //y=1.435
c242 ( 96 0 ) capacitor c=0.02013f //x=11.33 //y=1.09
c243 ( 95 0 ) capacitor c=0.153839f //x=11.815 //y=6.2
c244 ( 94 0 ) capacitor c=0.15434f //x=11.375 //y=6.2
c245 ( 89 0 ) capacitor c=9.4527e-19 //x=11.22 //y=4.88
c246 ( 80 0 ) capacitor c=6.43121e-19 //x=11.22 //y=2.265
c247 ( 63 0 ) capacitor c=0.0325184f //x=9.26 //y=5.56
c248 ( 55 0 ) capacitor c=0.0290792f //x=8.38 //y=5.56
c249 ( 52 0 ) capacitor c=0.056805f //x=11.06 //y=2.765
c250 ( 51 0 ) capacitor c=0.0045193f //x=11.22 //y=2.765
c251 ( 49 0 ) capacitor c=0.00557932f //x=9.9 //y=2.765
c252 ( 40 0 ) capacitor c=0.0110657f //x=11.22 //y=2.265
c253 ( 38 0 ) capacitor c=0.0123916f //x=11.22 //y=2.77
c254 ( 34 0 ) capacitor c=0.0142381f //x=9.74 //y=2.77
c255 ( 29 0 ) capacitor c=0.0114007f //x=9.3 //y=1.18
c256 ( 27 0 ) capacitor c=8.73568e-19 //x=9.26 //y=5.56
c257 ( 24 0 ) capacitor c=0.0125762f //x=9.26 //y=5.38
c258 ( 23 0 ) capacitor c=0.0104542f //x=8.38 //y=5.56
c259 ( 20 0 ) capacitor c=0.0607743f //x=11.22 //y=4.76
c260 ( 19 0 ) capacitor c=0.011625f //x=11.22 //y=2.925
c261 ( 18 0 ) capacitor c=0.00274252f //x=11.22 //y=2.605
c262 ( 16 0 ) capacitor c=0.0689735f //x=9.74 //y=5.295
c263 ( 15 0 ) capacitor c=0.011393f //x=9.74 //y=2.925
c264 ( 14 0 ) capacitor c=0.014907f //x=9.74 //y=2.605
c265 ( 12 0 ) capacitor c=0.0069619f //x=9.385 //y=1.835
c266 ( 11 0 ) capacitor c=0.0136462f //x=9.655 //y=1.835
c267 ( 9 0 ) capacitor c=0.0123258f //x=9.655 //y=5.38
c268 ( 8 0 ) capacitor c=0.00913132f //x=9.3 //y=1.75
c269 ( 3 0 ) capacitor c=0.019362f //x=9.145 //y=5.38
r270 (  116 117 ) resistor r=17.5563 //w=0.302 //l=0.11 //layer=ply \
 //thickness=0.18 //x=11.22 //y=2.265 //x2=11.33 //y2=2.265
r271 (  114 123 ) resistor r=45.1352 //w=0.168 //l=0.173853 //layer=ply \
 //thickness=0.18 //x=11.86 //y=1.435 //x2=11.82 //y2=1.59
r272 (  113 122 ) resistor r=45.1352 //w=0.168 //l=0.173853 //layer=ply \
 //thickness=0.18 //x=11.86 //y=1.09 //x2=11.82 //y2=0.935
r273 (  113 114 ) resistor r=176.904 //w=0.094 //l=0.345 //layer=ply \
 //thickness=0.18 //x=11.86 //y=1.09 //x2=11.86 //y2=1.435
r274 (  108 121 ) resistor r=10.701 //w=0.21 //l=0.115 //layer=ply \
 //thickness=0.18 //x=11.485 //y=1.59 //x2=11.37 //y2=1.59
r275 (  107 123 ) resistor r=5.52526 //w=0.168 //l=0.115 //layer=ply \
 //thickness=0.18 //x=11.705 //y=1.59 //x2=11.82 //y2=1.59
r276 (  106 120 ) resistor r=5.52526 //w=0.168 //l=0.115 //layer=ply \
 //thickness=0.18 //x=11.485 //y=0.935 //x2=11.37 //y2=0.935
r277 (  105 122 ) resistor r=5.52526 //w=0.168 //l=0.115 //layer=ply \
 //thickness=0.18 //x=11.705 //y=0.935 //x2=11.82 //y2=0.935
r278 (  105 106 ) resistor r=112.809 //w=0.094 //l=0.22 //layer=ply \
 //thickness=0.18 //x=11.705 //y=0.935 //x2=11.485 //y2=0.935
r279 (  103 110 ) resistor r=26.9307 //w=0.15 //l=0.106066 //layer=ply \
 //thickness=0.18 //x=11.74 //y=4.97 //x2=11.815 //y2=5.045
r280 (  103 104 ) resistor r=148.702 //w=0.094 //l=0.29 //layer=ply \
 //thickness=0.18 //x=11.74 //y=4.97 //x2=11.45 //y2=4.97
r281 (  100 104 ) resistor r=23.403 //w=0.284 //l=0.106066 //layer=ply \
 //thickness=0.18 //x=11.375 //y=5.045 //x2=11.45 //y2=4.97
r282 (  100 119 ) resistor r=26.3063 //w=0.284 //l=0.229783 //layer=ply \
 //thickness=0.18 //x=11.375 //y=5.045 //x2=11.22 //y2=4.88
r283 (  99 117 ) resistor r=19.1248 //w=0.302 //l=0.165 //layer=ply \
 //thickness=0.18 //x=11.33 //y=2.1 //x2=11.33 //y2=2.265
r284 (  98 121 ) resistor r=39.5823 //w=0.21 //l=0.173853 //layer=ply \
 //thickness=0.18 //x=11.33 //y=1.745 //x2=11.37 //y2=1.59
r285 (  98 99 ) resistor r=182.032 //w=0.094 //l=0.355 //layer=ply \
 //thickness=0.18 //x=11.33 //y=1.745 //x2=11.33 //y2=2.1
r286 (  97 121 ) resistor r=39.5823 //w=0.21 //l=0.173853 //layer=ply \
 //thickness=0.18 //x=11.33 //y=1.435 //x2=11.37 //y2=1.59
r287 (  96 120 ) resistor r=45.1352 //w=0.168 //l=0.173853 //layer=ply \
 //thickness=0.18 //x=11.33 //y=1.09 //x2=11.37 //y2=0.935
r288 (  96 97 ) resistor r=176.904 //w=0.094 //l=0.345 //layer=ply \
 //thickness=0.18 //x=11.33 //y=1.09 //x2=11.33 //y2=1.435
r289 (  95 110 ) resistor r=592.245 //w=0.094 //l=1.155 //layer=ply \
 //thickness=0.18 //x=11.815 //y=6.2 //x2=11.815 //y2=5.045
r290 (  94 100 ) resistor r=592.245 //w=0.094 //l=1.155 //layer=ply \
 //thickness=0.18 //x=11.375 //y=6.2 //x2=11.375 //y2=5.045
r291 (  93 107 ) resistor r=56.4043 //w=0.094 //l=0.11 //layer=ply \
 //thickness=0.18 //x=11.595 //y=1.59 //x2=11.705 //y2=1.59
r292 (  93 108 ) resistor r=56.4043 //w=0.094 //l=0.11 //layer=ply \
 //thickness=0.18 //x=11.595 //y=1.59 //x2=11.485 //y2=1.59
r293 (  89 119 ) resistor r=152 //w=0.17 //l=0.17 //layer=licon //count=1 \
 //x=11.22 //y=4.88 //x2=11.22 //y2=4.88
r294 (  80 116 ) resistor r=152 //w=0.17 //l=0.17 //layer=licon //count=1 \
 //x=11.22 //y=2.265 //x2=11.22 //y2=2.265
r295 (  63 127 ) resistor r=23.615 //w=0.187 //l=0.345 //layer=li \
 //thickness=0.1 //x=9.26 //y=5.56 //x2=9.26 //y2=5.905
r296 (  55 126 ) resistor r=23.615 //w=0.187 //l=0.345 //layer=li \
 //thickness=0.1 //x=8.38 //y=5.56 //x2=8.38 //y2=5.905
r297 (  51 52 ) resistor r=0.10734 //w=0.281 //l=0.16 //layer=m2 \
 //thickness=0.36 //x=11.22 //y=2.765 //x2=11.06 //y2=2.765
r298 (  49 52 ) resistor r=1.10687 //w=0.131 //l=1.16 //layer=m2 \
 //thickness=0.36 //x=9.9 //y=2.77 //x2=11.06 //y2=2.77
r299 (  47 49 ) resistor r=0.10734 //w=0.281 //l=0.16 //layer=m2 \
 //thickness=0.36 //x=9.74 //y=2.765 //x2=9.9 //y2=2.765
r300 (  43 89 ) resistor r=9.3 //w=0.17 //l=0.17 //layer=mcon //count=1 \
 //x=11.22 //y=4.88 //x2=11.22 //y2=4.88
r301 (  40 80 ) resistor r=9.3 //w=0.17 //l=0.17 //layer=mcon //count=1 \
 //x=11.22 //y=2.265 //x2=11.22 //y2=2.265
r302 (  36 51 ) resistor r=4.5 //w=0.15 //l=0.15 //layer=via1 //count=1 \
 //x=11.22 //y=2.765 //x2=11.22 //y2=2.765
r303 (  36 38 ) resistor r=0.00166223 //w=0.376 //l=0.005 //layer=m1 \
 //thickness=0.36 //x=11.167 //y=2.765 //x2=11.167 //y2=2.77
r304 (  32 47 ) resistor r=4.5 //w=0.15 //l=0.15 //layer=via1 //count=1 \
 //x=9.74 //y=2.765 //x2=9.74 //y2=2.765
r305 (  32 34 ) resistor r=0.00166223 //w=0.376 //l=0.005 //layer=m1 \
 //thickness=0.36 //x=9.792 //y=2.765 //x2=9.792 //y2=2.77
r306 (  29 124 ) resistor r=9.3 //w=0.17 //l=0.17 //layer=mcon //count=1 \
 //x=9.3 //y=1.18 //x2=9.3 //y2=1.18
r307 (  27 63 ) resistor r=9.3 //w=0.17 //l=0.17 //layer=mcon //count=1 \
 //x=9.26 //y=5.56 //x2=9.26 //y2=5.56
r308 (  24 27 ) resistor r=0.117801 //w=0.191 //l=0.18 //layer=m1 \
 //thickness=0.36 //x=9.26 //y=5.38 //x2=9.26 //y2=5.56
r309 (  23 55 ) resistor r=9.3 //w=0.17 //l=0.17 //layer=mcon //count=1 \
 //x=8.38 //y=5.56 //x2=8.38 //y2=5.56
r310 (  21 23 ) resistor r=0.10274 //w=0.219 //l=0.18 //layer=m1 \
 //thickness=0.36 //x=8.38 //y=5.38 //x2=8.38 //y2=5.56
r311 (  20 43 ) resistor r=0.0732479 //w=0.241 //l=0.122474 //layer=m1 \
 //thickness=0.36 //x=11.22 //y=4.76 //x2=11.225 //y2=4.88
r312 (  19 38 ) resistor r=0.0894971 //w=0.376 //l=0.179555 //layer=m1 \
 //thickness=0.36 //x=11.22 //y=2.925 //x2=11.167 //y2=2.77
r313 (  19 20 ) resistor r=1.75095 //w=0.131 //l=1.835 //layer=m1 \
 //thickness=0.36 //x=11.22 //y=2.925 //x2=11.22 //y2=4.76
r314 (  18 36 ) resistor r=0.0911593 //w=0.376 //l=0.184608 //layer=m1 \
 //thickness=0.36 //x=11.22 //y=2.605 //x2=11.167 //y2=2.765
r315 (  17 40 ) resistor r=0.116051 //w=0.211 //l=0.165 //layer=m1 \
 //thickness=0.36 //x=11.22 //y=2.43 //x2=11.22 //y2=2.265
r316 (  17 18 ) resistor r=0.166985 //w=0.131 //l=0.175 //layer=m1 \
 //thickness=0.36 //x=11.22 //y=2.43 //x2=11.22 //y2=2.605
r317 (  15 34 ) resistor r=0.0894971 //w=0.376 //l=0.179123 //layer=m1 \
 //thickness=0.36 //x=9.74 //y=2.925 //x2=9.792 //y2=2.77
r318 (  15 16 ) resistor r=2.26145 //w=0.131 //l=2.37 //layer=m1 \
 //thickness=0.36 //x=9.74 //y=2.925 //x2=9.74 //y2=5.295
r319 (  14 32 ) resistor r=0.0911593 //w=0.376 //l=0.184174 //layer=m1 \
 //thickness=0.36 //x=9.74 //y=2.605 //x2=9.792 //y2=2.765
r320 (  13 14 ) resistor r=0.653626 //w=0.131 //l=0.685 //layer=m1 \
 //thickness=0.36 //x=9.74 //y=1.92 //x2=9.74 //y2=2.605
r321 (  11 13 ) resistor r=0.0698411 //w=0.17 //l=0.120208 //layer=m1 \
 //thickness=0.36 //x=9.655 //y=1.835 //x2=9.74 //y2=1.92
r322 (  11 12 ) resistor r=0.257634 //w=0.131 //l=0.27 //layer=m1 \
 //thickness=0.36 //x=9.655 //y=1.835 //x2=9.385 //y2=1.835
r323 (  10 24 ) resistor r=0.0257089 //w=0.23 //l=0.115 //layer=m1 \
 //thickness=0.36 //x=9.375 //y=5.38 //x2=9.26 //y2=5.38
r324 (  9 16 ) resistor r=0.0698411 //w=0.17 //l=0.120208 //layer=m1 \
 //thickness=0.36 //x=9.655 //y=5.38 //x2=9.74 //y2=5.295
r325 (  9 10 ) resistor r=0.267176 //w=0.131 //l=0.28 //layer=m1 \
 //thickness=0.36 //x=9.655 //y=5.38 //x2=9.375 //y2=5.38
r326 (  8 12 ) resistor r=0.0698411 //w=0.17 //l=0.120208 //layer=m1 \
 //thickness=0.36 //x=9.3 //y=1.75 //x2=9.385 //y2=1.835
r327 (  7 29 ) resistor r=0.0913624 //w=0.191 //l=0.12 //layer=m1 \
 //thickness=0.36 //x=9.3 //y=1.3 //x2=9.3 //y2=1.18
r328 (  7 8 ) resistor r=0.429389 //w=0.131 //l=0.45 //layer=m1 \
 //thickness=0.36 //x=9.3 //y=1.3 //x2=9.3 //y2=1.75
r329 (  4 21 ) resistor r=0.0227762 //w=0.219 //l=0.115 //layer=m1 \
 //thickness=0.36 //x=8.495 //y=5.38 //x2=8.38 //y2=5.38
r330 (  3 24 ) resistor r=0.0257089 //w=0.23 //l=0.115 //layer=m1 \
 //thickness=0.36 //x=9.145 //y=5.38 //x2=9.26 //y2=5.38
r331 (  3 4 ) resistor r=0.620229 //w=0.131 //l=0.65 //layer=m1 \
 //thickness=0.36 //x=9.145 //y=5.38 //x2=8.495 //y2=5.38
ends PM_AOA4X1\%noxref_3

subckt PM_AOA4X1\%VDD ( 1 2 12 13 27 52 60 76 103 113 135 150 153 154 159 163 \
 164 165 166 167 168 169 170 171 172 )
c234 ( 172 0 ) capacitor c=0.0633007f //x=11.89 //y=5.2
c235 ( 171 0 ) capacitor c=0.0583563f //x=11.02 //y=5.2
c236 ( 170 0 ) capacitor c=0.0398743f //x=9.555 //y=5.2
c237 ( 169 0 ) capacitor c=0.0247473f //x=8.675 //y=5.2
c238 ( 168 0 ) capacitor c=0.0652534f //x=7.805 //y=5.2
c239 ( 167 0 ) capacitor c=0.0230094f //x=4.905 //y=5.205
c240 ( 166 0 ) capacitor c=0.0399069f //x=2.895 //y=5.2
c241 ( 165 0 ) capacitor c=0.0247434f //x=2.015 //y=5.2
c242 ( 164 0 ) capacitor c=0.0678024f //x=1.145 //y=5.2
c243 ( 163 0 ) capacitor c=0.259902f //x=11.96 //y=7.58
c244 ( 161 0 ) capacitor c=0.00597439f //x=11.22 //y=7.58
c245 ( 159 0 ) capacitor c=0.123433f //x=10.48 //y=7.585
c246 ( 158 0 ) capacitor c=0.00597439f //x=9.74 //y=7.58
c247 ( 156 0 ) capacitor c=0.00597439f //x=8.82 //y=7.585
c248 ( 155 0 ) capacitor c=0.00597439f //x=7.94 //y=7.585
c249 ( 154 0 ) capacitor c=0.130624f //x=7.15 //y=7.585
c250 ( 153 0 ) capacitor c=0.126563f //x=3.82 //y=7.585
c251 ( 152 0 ) capacitor c=0.00597439f //x=3.04 //y=7.585
c252 ( 151 0 ) capacitor c=0.00597439f //x=2.16 //y=7.585
c253 ( 150 0 ) capacitor c=0.271504f //x=1.23 //y=7.58
c254 ( 135 0 ) capacitor c=0.0289924f //x=11.95 //y=7.585
c255 ( 125 0 ) capacitor c=0.0217664f //x=11.07 //y=7.585
c256 ( 121 0 ) capacitor c=0.0277785f //x=10.31 //y=7.585
c257 ( 113 0 ) capacitor c=0.0287375f //x=9.615 //y=7.585
c258 ( 103 0 ) capacitor c=0.0291078f //x=8.735 //y=7.585
c259 ( 91 0 ) capacitor c=0.0283511f //x=7.855 //y=7.585
c260 ( 76 0 ) capacitor c=0.139031f //x=6.98 //y=7.585
c261 ( 70 0 ) capacitor c=0.0277785f //x=3.65 //y=7.585
c262 ( 60 0 ) capacitor c=0.0287375f //x=2.955 //y=7.585
c263 ( 52 0 ) capacitor c=0.0291078f //x=2.075 //y=7.585
c264 ( 31 0 ) capacitor c=0.00499323f //x=5.05 //y=7.585
c265 ( 27 0 ) capacitor c=0.30105f //x=11.96 //y=7.58
c266 ( 13 0 ) capacitor c=0.00916089f //x=5.05 //y=7.41
c267 ( 12 0 ) capacitor c=0.00572492f //x=5.05 //y=7.035
c268 ( 2 0 ) capacitor c=0.196513f //x=4.965 //y=7.585
r269 (  137 163 ) resistor r=4.23183 //w=0.7 //l=0.175 //layer=li \
 //thickness=0.1 //x=12.035 //y=7.41 //x2=12.035 //y2=7.585
r270 (  137 172 ) resistor r=56.4706 //w=0.187 //l=0.825 //layer=li \
 //thickness=0.1 //x=12.035 //y=7.41 //x2=12.035 //y2=6.585
r271 (  136 161 ) resistor r=2.87058 //w=0.35 //l=0.085 //layer=li \
 //thickness=0.1 //x=11.24 //y=7.585 //x2=11.155 //y2=7.585
r272 (  135 163 ) resistor r=2.87058 //w=0.35 //l=0.085 //layer=li \
 //thickness=0.1 //x=11.95 //y=7.585 //x2=12.035 //y2=7.585
r273 (  135 136 ) resistor r=24.7629 //w=0.367 //l=0.71 //layer=li \
 //thickness=0.1 //x=11.95 //y=7.585 //x2=11.24 //y2=7.585
r274 (  127 161 ) resistor r=4.23183 //w=0.7 //l=0.175 //layer=li \
 //thickness=0.1 //x=11.155 //y=7.41 //x2=11.155 //y2=7.585
r275 (  127 171 ) resistor r=56.4706 //w=0.187 //l=0.825 //layer=li \
 //thickness=0.1 //x=11.155 //y=7.41 //x2=11.155 //y2=6.585
r276 (  126 159 ) resistor r=5.29055 //w=0.35 //l=0.17 //layer=li \
 //thickness=0.1 //x=10.65 //y=7.585 //x2=10.48 //y2=7.585
r277 (  125 161 ) resistor r=2.87058 //w=0.35 //l=0.085 //layer=li \
 //thickness=0.1 //x=11.07 //y=7.585 //x2=11.155 //y2=7.585
r278 (  125 126 ) resistor r=14.6485 //w=0.367 //l=0.42 //layer=li \
 //thickness=0.1 //x=11.07 //y=7.585 //x2=10.65 //y2=7.585
r279 (  122 158 ) resistor r=2.87058 //w=0.35 //l=0.085 //layer=li \
 //thickness=0.1 //x=9.785 //y=7.585 //x2=9.7 //y2=7.585
r280 (  121 159 ) resistor r=5.29055 //w=0.35 //l=0.17 //layer=li \
 //thickness=0.1 //x=10.31 //y=7.585 //x2=10.48 //y2=7.585
r281 (  121 122 ) resistor r=18.3106 //w=0.367 //l=0.525 //layer=li \
 //thickness=0.1 //x=10.31 //y=7.585 //x2=9.785 //y2=7.585
r282 (  115 158 ) resistor r=4.23183 //w=0.7 //l=0.175 //layer=li \
 //thickness=0.1 //x=9.7 //y=7.41 //x2=9.7 //y2=7.585
r283 (  115 170 ) resistor r=33.1979 //w=0.187 //l=0.485 //layer=li \
 //thickness=0.1 //x=9.7 //y=7.41 //x2=9.7 //y2=6.925
r284 (  114 156 ) resistor r=2.87058 //w=0.35 //l=0.085 //layer=li \
 //thickness=0.1 //x=8.905 //y=7.585 //x2=8.82 //y2=7.585
r285 (  113 158 ) resistor r=2.87058 //w=0.35 //l=0.085 //layer=li \
 //thickness=0.1 //x=9.615 //y=7.585 //x2=9.7 //y2=7.585
r286 (  113 114 ) resistor r=24.7629 //w=0.367 //l=0.71 //layer=li \
 //thickness=0.1 //x=9.615 //y=7.585 //x2=8.905 //y2=7.585
r287 (  107 156 ) resistor r=4.23183 //w=0.7 //l=0.175 //layer=li \
 //thickness=0.1 //x=8.82 //y=7.41 //x2=8.82 //y2=7.585
r288 (  107 169 ) resistor r=33.1979 //w=0.187 //l=0.485 //layer=li \
 //thickness=0.1 //x=8.82 //y=7.41 //x2=8.82 //y2=6.925
r289 (  104 155 ) resistor r=2.87058 //w=0.35 //l=0.085 //layer=li \
 //thickness=0.1 //x=8.025 //y=7.585 //x2=7.94 //y2=7.585
r290 (  104 106 ) resistor r=21.1008 //w=0.367 //l=0.605 //layer=li \
 //thickness=0.1 //x=8.025 //y=7.585 //x2=8.63 //y2=7.585
r291 (  103 156 ) resistor r=2.87058 //w=0.35 //l=0.085 //layer=li \
 //thickness=0.1 //x=8.735 //y=7.585 //x2=8.82 //y2=7.585
r292 (  103 106 ) resistor r=3.66213 //w=0.367 //l=0.105 //layer=li \
 //thickness=0.1 //x=8.735 //y=7.585 //x2=8.63 //y2=7.585
r293 (  95 155 ) resistor r=4.23183 //w=0.7 //l=0.175 //layer=li \
 //thickness=0.1 //x=7.94 //y=7.41 //x2=7.94 //y2=7.585
r294 (  95 168 ) resistor r=56.4706 //w=0.187 //l=0.825 //layer=li \
 //thickness=0.1 //x=7.94 //y=7.41 //x2=7.94 //y2=6.585
r295 (  92 154 ) resistor r=5.29055 //w=0.35 //l=0.17 //layer=li \
 //thickness=0.1 //x=7.32 //y=7.585 //x2=7.15 //y2=7.585
r296 (  92 94 ) resistor r=6.97548 //w=0.367 //l=0.2 //layer=li \
 //thickness=0.1 //x=7.32 //y=7.585 //x2=7.52 //y2=7.585
r297 (  91 155 ) resistor r=2.87058 //w=0.35 //l=0.085 //layer=li \
 //thickness=0.1 //x=7.855 //y=7.585 //x2=7.94 //y2=7.585
r298 (  91 94 ) resistor r=11.6839 //w=0.367 //l=0.335 //layer=li \
 //thickness=0.1 //x=7.855 //y=7.585 //x2=7.52 //y2=7.585
r299 (  79 81 ) resistor r=38.7139 //w=0.367 //l=1.11 //layer=li \
 //thickness=0.1 //x=4.93 //y=7.585 //x2=6.04 //y2=7.585
r300 (  77 153 ) resistor r=5.29055 //w=0.35 //l=0.17 //layer=li \
 //thickness=0.1 //x=3.99 //y=7.585 //x2=3.82 //y2=7.585
r301 (  77 79 ) resistor r=32.7847 //w=0.367 //l=0.94 //layer=li \
 //thickness=0.1 //x=3.99 //y=7.585 //x2=4.93 //y2=7.585
r302 (  76 154 ) resistor r=5.29055 //w=0.35 //l=0.17 //layer=li \
 //thickness=0.1 //x=6.98 //y=7.585 //x2=7.15 //y2=7.585
r303 (  76 81 ) resistor r=32.7847 //w=0.367 //l=0.94 //layer=li \
 //thickness=0.1 //x=6.98 //y=7.585 //x2=6.04 //y2=7.585
r304 (  71 152 ) resistor r=2.87058 //w=0.35 //l=0.085 //layer=li \
 //thickness=0.1 //x=3.125 //y=7.585 //x2=3.04 //y2=7.585
r305 (  71 73 ) resistor r=11.3351 //w=0.367 //l=0.325 //layer=li \
 //thickness=0.1 //x=3.125 //y=7.585 //x2=3.45 //y2=7.585
r306 (  70 153 ) resistor r=5.29055 //w=0.35 //l=0.17 //layer=li \
 //thickness=0.1 //x=3.65 //y=7.585 //x2=3.82 //y2=7.585
r307 (  70 73 ) resistor r=6.97548 //w=0.367 //l=0.2 //layer=li \
 //thickness=0.1 //x=3.65 //y=7.585 //x2=3.45 //y2=7.585
r308 (  64 152 ) resistor r=4.23183 //w=0.7 //l=0.175 //layer=li \
 //thickness=0.1 //x=3.04 //y=7.41 //x2=3.04 //y2=7.585
r309 (  64 166 ) resistor r=33.1979 //w=0.187 //l=0.485 //layer=li \
 //thickness=0.1 //x=3.04 //y=7.41 //x2=3.04 //y2=6.925
r310 (  61 151 ) resistor r=2.87058 //w=0.35 //l=0.085 //layer=li \
 //thickness=0.1 //x=2.245 //y=7.585 //x2=2.16 //y2=7.585
r311 (  61 63 ) resistor r=3.31335 //w=0.367 //l=0.095 //layer=li \
 //thickness=0.1 //x=2.245 //y=7.585 //x2=2.34 //y2=7.585
r312 (  60 152 ) resistor r=2.87058 //w=0.35 //l=0.085 //layer=li \
 //thickness=0.1 //x=2.955 //y=7.585 //x2=3.04 //y2=7.585
r313 (  60 63 ) resistor r=21.4496 //w=0.367 //l=0.615 //layer=li \
 //thickness=0.1 //x=2.955 //y=7.585 //x2=2.34 //y2=7.585
r314 (  54 151 ) resistor r=4.23183 //w=0.7 //l=0.175 //layer=li \
 //thickness=0.1 //x=2.16 //y=7.41 //x2=2.16 //y2=7.585
r315 (  54 165 ) resistor r=33.1979 //w=0.187 //l=0.485 //layer=li \
 //thickness=0.1 //x=2.16 //y=7.41 //x2=2.16 //y2=6.925
r316 (  53 150 ) resistor r=2.87058 //w=0.35 //l=0.085 //layer=li \
 //thickness=0.1 //x=1.365 //y=7.585 //x2=1.28 //y2=7.585
r317 (  52 151 ) resistor r=2.87058 //w=0.35 //l=0.085 //layer=li \
 //thickness=0.1 //x=2.075 //y=7.585 //x2=2.16 //y2=7.585
r318 (  52 53 ) resistor r=24.7629 //w=0.367 //l=0.71 //layer=li \
 //thickness=0.1 //x=2.075 //y=7.585 //x2=1.365 //y2=7.585
r319 (  44 150 ) resistor r=4.23183 //w=0.7 //l=0.175 //layer=li \
 //thickness=0.1 //x=1.28 //y=7.41 //x2=1.28 //y2=7.585
r320 (  44 164 ) resistor r=56.4706 //w=0.187 //l=0.825 //layer=li \
 //thickness=0.1 //x=1.28 //y=7.41 //x2=1.28 //y2=6.585
r321 (  33 167 ) resistor r=9.3 //w=0.17 //l=0.17 //layer=mcon //count=1 \
 //x=5.05 //y=6.92 //x2=5.05 //y2=6.92
r322 (  27 163 ) resistor r=4.65 //w=0.17 //l=0.34 //layer=mcon //count=2 \
 //x=11.96 //y=7.58 //x2=11.96 //y2=7.58
r323 (  25 161 ) resistor r=3.1 //w=0.17 //l=0.51 //layer=mcon //count=3 \
 //x=11.22 //y=7.58 //x2=11.22 //y2=7.58
r324 (  25 27 ) resistor r=0.297428 //w=0.311 //l=0.74 //layer=m1 \
 //thickness=0.36 //x=11.22 //y=7.585 //x2=11.96 //y2=7.585
r325 (  23 158 ) resistor r=3.1 //w=0.17 //l=0.51 //layer=mcon //count=3 \
 //x=9.74 //y=7.58 //x2=9.74 //y2=7.58
r326 (  23 25 ) resistor r=0.594855 //w=0.311 //l=1.48 //layer=m1 \
 //thickness=0.36 //x=9.74 //y=7.585 //x2=11.22 //y2=7.585
r327 (  21 106 ) resistor r=3.1 //w=0.17 //l=0.51 //layer=mcon //count=3 \
 //x=8.63 //y=7.58 //x2=8.63 //y2=7.58
r328 (  21 23 ) resistor r=0.446141 //w=0.311 //l=1.11 //layer=m1 \
 //thickness=0.36 //x=8.63 //y=7.585 //x2=9.74 //y2=7.585
r329 (  19 94 ) resistor r=3.1 //w=0.17 //l=0.51 //layer=mcon //count=3 \
 //x=7.52 //y=7.58 //x2=7.52 //y2=7.58
r330 (  19 21 ) resistor r=0.446141 //w=0.311 //l=1.11 //layer=m1 \
 //thickness=0.36 //x=7.52 //y=7.585 //x2=8.63 //y2=7.585
r331 (  16 81 ) resistor r=3.1 //w=0.17 //l=0.51 //layer=mcon //count=3 \
 //x=6.04 //y=7.58 //x2=6.04 //y2=7.58
r332 (  14 31 ) resistor r=0.028033 //w=0.35 //l=0.085 //layer=m1 \
 //thickness=0.36 //x=5.135 //y=7.585 //x2=5.05 //y2=7.585
r333 (  14 16 ) resistor r=0.363746 //w=0.311 //l=0.905 //layer=m1 \
 //thickness=0.36 //x=5.135 //y=7.585 //x2=6.04 //y2=7.585
r334 (  13 31 ) resistor r=0.0413265 //w=0.7 //l=0.175 //layer=m1 \
 //thickness=0.36 //x=5.05 //y=7.41 //x2=5.05 //y2=7.585
r335 (  12 33 ) resistor r=0.0723371 //w=0.218 //l=0.115 //layer=m1 \
 //thickness=0.36 //x=5.05 //y=7.035 //x2=5.05 //y2=6.92
r336 (  12 13 ) resistor r=0.357824 //w=0.131 //l=0.375 //layer=m1 \
 //thickness=0.36 //x=5.05 //y=7.035 //x2=5.05 //y2=7.41
r337 (  11 79 ) resistor r=3.1 //w=0.17 //l=0.51 //layer=mcon //count=3 \
 //x=4.93 //y=7.58 //x2=4.93 //y2=7.58
r338 (  9 73 ) resistor r=3.1 //w=0.17 //l=0.51 //layer=mcon //count=3 \
 //x=3.45 //y=7.58 //x2=3.45 //y2=7.58
r339 (  9 11 ) resistor r=0.594855 //w=0.311 //l=1.48 //layer=m1 \
 //thickness=0.36 //x=3.45 //y=7.585 //x2=4.93 //y2=7.585
r340 (  7 63 ) resistor r=3.1 //w=0.17 //l=0.51 //layer=mcon //count=3 \
 //x=2.34 //y=7.58 //x2=2.34 //y2=7.58
r341 (  7 9 ) resistor r=0.446141 //w=0.311 //l=1.11 //layer=m1 \
 //thickness=0.36 //x=2.34 //y=7.585 //x2=3.45 //y2=7.585
r342 (  4 150 ) resistor r=3.1 //w=0.17 //l=0.51 //layer=mcon //count=3 \
 //x=1.23 //y=7.58 //x2=1.23 //y2=7.58
r343 (  4 7 ) resistor r=0.446141 //w=0.311 //l=1.11 //layer=m1 \
 //thickness=0.36 //x=1.23 //y=7.585 //x2=2.34 //y2=7.585
r344 (  2 31 ) resistor r=0.028033 //w=0.35 //l=0.085 //layer=m1 \
 //thickness=0.36 //x=4.965 //y=7.585 //x2=5.05 //y2=7.585
r345 (  2 11 ) resistor r=0.0140675 //w=0.311 //l=0.035 //layer=m1 \
 //thickness=0.36 //x=4.965 //y=7.585 //x2=4.93 //y2=7.585
r346 (  1 19 ) resistor r=0.371785 //w=0.311 //l=0.925 //layer=m1 \
 //thickness=0.36 //x=6.595 //y=7.585 //x2=7.52 //y2=7.585
r347 (  1 16 ) resistor r=0.223071 //w=0.311 //l=0.555 //layer=m1 \
 //thickness=0.36 //x=6.595 //y=7.585 //x2=6.04 //y2=7.585
ends PM_AOA4X1\%VDD

subckt PM_AOA4X1\%A ( 1 2 3 4 5 6 7 18 21 25 30 34 35 36 37 38 39 40 44 46 49 \
 50 60 )
c98 ( 60 0 ) capacitor c=0.0682508f //x=1.6 //y=4.88
c99 ( 50 0 ) capacitor c=0.0318956f //x=1.935 //y=1.39
c100 ( 49 0 ) capacitor c=0.0186809f //x=1.935 //y=1.045
c101 ( 46 0 ) capacitor c=0.0141821f //x=1.78 //y=1.545
c102 ( 44 0 ) capacitor c=0.0158553f //x=1.78 //y=0.89
c103 ( 40 0 ) capacitor c=0.088055f //x=1.405 //y=2.095
c104 ( 39 0 ) capacitor c=0.0229235f //x=1.405 //y=1.7
c105 ( 38 0 ) capacitor c=0.0234359f //x=1.405 //y=1.39
c106 ( 37 0 ) capacitor c=0.0198759f //x=1.405 //y=1.045
c107 ( 36 0 ) capacitor c=0.110369f //x=1.94 //y=6.2
c108 ( 35 0 ) capacitor c=0.154619f //x=1.5 //y=6.2
c109 ( 30 0 ) capacitor c=8.13425e-19 //x=1.6 //y=4.88
c110 ( 25 0 ) capacitor c=7.85889e-19 //x=1.6 //y=2.26
c111 ( 21 0 ) capacitor c=0.0113945f //x=1.6 //y=4.88
c112 ( 18 0 ) capacitor c=0.0108617f //x=1.6 //y=2.26
c113 ( 1 0 ) capacitor c=0.10646f //x=1.6 //y=2.4
r114 (  58 60 ) resistor r=20.6867 //w=0.233 //l=0.1 //layer=ply \
 //thickness=0.18 //x=1.5 //y=4.88 //x2=1.6 //y2=4.88
r115 (  51 60 ) resistor r=70.3348 //w=0.233 //l=0.414367 //layer=ply \
 //thickness=0.18 //x=1.94 //y=5.045 //x2=1.6 //y2=4.88
r116 (  50 62 ) resistor r=45.1352 //w=0.168 //l=0.173853 //layer=ply \
 //thickness=0.18 //x=1.935 //y=1.39 //x2=1.895 //y2=1.545
r117 (  49 61 ) resistor r=45.1352 //w=0.168 //l=0.173853 //layer=ply \
 //thickness=0.18 //x=1.935 //y=1.045 //x2=1.895 //y2=0.89
r118 (  49 50 ) resistor r=176.904 //w=0.094 //l=0.345 //layer=ply \
 //thickness=0.18 //x=1.935 //y=1.045 //x2=1.935 //y2=1.39
r119 (  47 57 ) resistor r=10.701 //w=0.21 //l=0.115 //layer=ply \
 //thickness=0.18 //x=1.56 //y=1.545 //x2=1.445 //y2=1.545
r120 (  46 62 ) resistor r=5.52526 //w=0.168 //l=0.115 //layer=ply \
 //thickness=0.18 //x=1.78 //y=1.545 //x2=1.895 //y2=1.545
r121 (  45 56 ) resistor r=5.52526 //w=0.168 //l=0.115 //layer=ply \
 //thickness=0.18 //x=1.56 //y=0.89 //x2=1.445 //y2=0.89
r122 (  44 61 ) resistor r=5.52526 //w=0.168 //l=0.115 //layer=ply \
 //thickness=0.18 //x=1.78 //y=0.89 //x2=1.895 //y2=0.89
r123 (  44 45 ) resistor r=112.809 //w=0.094 //l=0.22 //layer=ply \
 //thickness=0.18 //x=1.78 //y=0.89 //x2=1.56 //y2=0.89
r124 (  41 58 ) resistor r=13.0941 //w=0.233 //l=0.165 //layer=ply \
 //thickness=0.18 //x=1.5 //y=5.045 //x2=1.5 //y2=4.88
r125 (  40 55 ) resistor r=34.8111 //w=0.27 //l=0.264953 //layer=ply \
 //thickness=0.18 //x=1.405 //y=2.095 //x2=1.6 //y2=2.26
r126 (  39 57 ) resistor r=39.5823 //w=0.21 //l=0.173853 //layer=ply \
 //thickness=0.18 //x=1.405 //y=1.7 //x2=1.445 //y2=1.545
r127 (  39 40 ) resistor r=202.543 //w=0.094 //l=0.395 //layer=ply \
 //thickness=0.18 //x=1.405 //y=1.7 //x2=1.405 //y2=2.095
r128 (  38 57 ) resistor r=39.5823 //w=0.21 //l=0.173853 //layer=ply \
 //thickness=0.18 //x=1.405 //y=1.39 //x2=1.445 //y2=1.545
r129 (  37 56 ) resistor r=45.1352 //w=0.168 //l=0.173853 //layer=ply \
 //thickness=0.18 //x=1.405 //y=1.045 //x2=1.445 //y2=0.89
r130 (  37 38 ) resistor r=176.904 //w=0.094 //l=0.345 //layer=ply \
 //thickness=0.18 //x=1.405 //y=1.045 //x2=1.405 //y2=1.39
r131 (  36 51 ) resistor r=592.245 //w=0.094 //l=1.155 //layer=ply \
 //thickness=0.18 //x=1.94 //y=6.2 //x2=1.94 //y2=5.045
r132 (  35 41 ) resistor r=592.245 //w=0.094 //l=1.155 //layer=ply \
 //thickness=0.18 //x=1.5 //y=6.2 //x2=1.5 //y2=5.045
r133 (  34 46 ) resistor r=56.4043 //w=0.094 //l=0.11 //layer=ply \
 //thickness=0.18 //x=1.67 //y=1.545 //x2=1.78 //y2=1.545
r134 (  34 47 ) resistor r=56.4043 //w=0.094 //l=0.11 //layer=ply \
 //thickness=0.18 //x=1.67 //y=1.545 //x2=1.56 //y2=1.545
r135 (  30 60 ) resistor r=152 //w=0.17 //l=0.17 //layer=licon //count=1 \
 //x=1.6 //y=4.88 //x2=1.6 //y2=4.88
r136 (  25 55 ) resistor r=152 //w=0.17 //l=0.17 //layer=licon //count=1 \
 //x=1.6 //y=2.26 //x2=1.6 //y2=2.26
r137 (  21 30 ) resistor r=9.3 //w=0.17 //l=0.17 //layer=mcon //count=1 \
 //x=1.6 //y=4.88 //x2=1.6 //y2=4.88
r138 (  21 22 ) resistor r=0.103207 //w=0.196 //l=0.14 //layer=m1 \
 //thickness=0.36 //x=1.602 //y=4.88 //x2=1.602 //y2=4.74
r139 (  18 25 ) resistor r=9.3 //w=0.17 //l=0.17 //layer=mcon //count=1 \
 //x=1.6 //y=2.26 //x2=1.6 //y2=2.26
r140 (  8 18 ) resistor r=0.0933015 //w=0.201 //l=0.125 //layer=m1 \
 //thickness=0.36 //x=1.6 //y=2.385 //x2=1.6 //y2=2.26
r141 (  7 22 ) resistor r=0.114504 //w=0.131 //l=0.12 //layer=m1 \
 //thickness=0.36 //x=1.6 //y=4.62 //x2=1.6 //y2=4.74
r142 (  6 7 ) resistor r=0.353053 //w=0.131 //l=0.37 //layer=m1 \
 //thickness=0.36 //x=1.6 //y=4.25 //x2=1.6 //y2=4.62
r143 (  5 6 ) resistor r=0.353053 //w=0.131 //l=0.37 //layer=m1 \
 //thickness=0.36 //x=1.6 //y=3.88 //x2=1.6 //y2=4.25
r144 (  4 5 ) resistor r=0.353053 //w=0.131 //l=0.37 //layer=m1 \
 //thickness=0.36 //x=1.6 //y=3.51 //x2=1.6 //y2=3.88
r145 (  3 4 ) resistor r=0.353053 //w=0.131 //l=0.37 //layer=m1 \
 //thickness=0.36 //x=1.6 //y=3.14 //x2=1.6 //y2=3.51
r146 (  2 3 ) resistor r=0.353053 //w=0.131 //l=0.37 //layer=m1 \
 //thickness=0.36 //x=1.6 //y=2.77 //x2=1.6 //y2=3.14
r147 (  1 2 ) resistor r=0.353053 //w=0.131 //l=0.37 //layer=m1 \
 //thickness=0.36 //x=1.6 //y=2.4 //x2=1.6 //y2=2.77
r148 (  1 8 ) resistor r=0.014313 //w=0.131 //l=0.015 //layer=m1 \
 //thickness=0.36 //x=1.6 //y=2.4 //x2=1.6 //y2=2.385
ends PM_AOA4X1\%A

subckt PM_AOA4X1\%B ( 1 2 3 4 5 6 7 9 18 24 29 33 34 35 36 37 38 43 45 47 53 \
 54 56 57 60 )
c107 ( 60 0 ) capacitor c=0.0393541f //x=2.37 //y=4.88
c108 ( 57 0 ) capacitor c=0.0284095f //x=2.34 //y=2.095
c109 ( 56 0 ) capacitor c=0.0476356f //x=2.34 //y=2.26
c110 ( 54 0 ) capacitor c=0.0439708f //x=2.905 //y=1.43
c111 ( 53 0 ) capacitor c=0.0192582f //x=2.905 //y=1.085
c112 ( 47 0 ) capacitor c=0.0162526f //x=2.75 //y=1.585
c113 ( 45 0 ) capacitor c=0.0157807f //x=2.75 //y=0.93
c114 ( 43 0 ) capacitor c=0.0372668f //x=2.745 //y=4.97
c115 ( 38 0 ) capacitor c=0.0210762f //x=2.375 //y=1.74
c116 ( 37 0 ) capacitor c=0.0168511f //x=2.375 //y=1.43
c117 ( 36 0 ) capacitor c=0.0175485f //x=2.375 //y=1.085
c118 ( 35 0 ) capacitor c=0.155269f //x=2.82 //y=6.2
c119 ( 34 0 ) capacitor c=0.110375f //x=2.38 //y=6.2
c120 ( 29 0 ) capacitor c=8.90417e-19 //x=2.37 //y=4.88
c121 ( 24 0 ) capacitor c=7.72439e-19 //x=2.34 //y=2.26
c122 ( 18 0 ) capacitor c=0.00687137f //x=2.34 //y=2.26
c123 ( 9 0 ) capacitor c=0.00493417f //x=2.34 //y=4.735
c124 ( 1 0 ) capacitor c=0.0590889f //x=2.34 //y=2.4
r125 (  62 63 ) resistor r=32.4568 //w=0.214 //l=0.075 //layer=ply \
 //thickness=0.18 //x=2.37 //y=4.97 //x2=2.37 //y2=5.045
r126 (  60 62 ) resistor r=20.271 //w=0.214 //l=0.09 //layer=ply \
 //thickness=0.18 //x=2.37 //y=4.88 //x2=2.37 //y2=4.97
r127 (  56 57 ) resistor r=52.7279 //w=0.214 //l=0.165 //layer=ply \
 //thickness=0.18 //x=2.34 //y=2.26 //x2=2.34 //y2=2.095
r128 (  54 67 ) resistor r=45.1352 //w=0.168 //l=0.173853 //layer=ply \
 //thickness=0.18 //x=2.905 //y=1.43 //x2=2.865 //y2=1.585
r129 (  53 66 ) resistor r=45.1352 //w=0.168 //l=0.173853 //layer=ply \
 //thickness=0.18 //x=2.905 //y=1.085 //x2=2.865 //y2=0.93
r130 (  53 54 ) resistor r=176.904 //w=0.094 //l=0.345 //layer=ply \
 //thickness=0.18 //x=2.905 //y=1.085 //x2=2.905 //y2=1.43
r131 (  48 65 ) resistor r=10.701 //w=0.21 //l=0.115 //layer=ply \
 //thickness=0.18 //x=2.53 //y=1.585 //x2=2.415 //y2=1.585
r132 (  47 67 ) resistor r=5.52526 //w=0.168 //l=0.115 //layer=ply \
 //thickness=0.18 //x=2.75 //y=1.585 //x2=2.865 //y2=1.585
r133 (  46 64 ) resistor r=5.52526 //w=0.168 //l=0.115 //layer=ply \
 //thickness=0.18 //x=2.53 //y=0.93 //x2=2.415 //y2=0.93
r134 (  45 66 ) resistor r=5.52526 //w=0.168 //l=0.115 //layer=ply \
 //thickness=0.18 //x=2.75 //y=0.93 //x2=2.865 //y2=0.93
r135 (  45 46 ) resistor r=112.809 //w=0.094 //l=0.22 //layer=ply \
 //thickness=0.18 //x=2.75 //y=0.93 //x2=2.53 //y2=0.93
r136 (  44 62 ) resistor r=16.5046 //w=0.27 //l=0.135 //layer=ply \
 //thickness=0.18 //x=2.505 //y=4.97 //x2=2.37 //y2=4.97
r137 (  43 50 ) resistor r=26.9307 //w=0.15 //l=0.106066 //layer=ply \
 //thickness=0.18 //x=2.745 //y=4.97 //x2=2.82 //y2=5.045
r138 (  43 44 ) resistor r=123.064 //w=0.094 //l=0.24 //layer=ply \
 //thickness=0.18 //x=2.745 //y=4.97 //x2=2.505 //y2=4.97
r139 (  38 65 ) resistor r=39.5823 //w=0.21 //l=0.173853 //layer=ply \
 //thickness=0.18 //x=2.375 //y=1.74 //x2=2.415 //y2=1.585
r140 (  38 57 ) resistor r=182.032 //w=0.094 //l=0.355 //layer=ply \
 //thickness=0.18 //x=2.375 //y=1.74 //x2=2.375 //y2=2.095
r141 (  37 65 ) resistor r=39.5823 //w=0.21 //l=0.173853 //layer=ply \
 //thickness=0.18 //x=2.375 //y=1.43 //x2=2.415 //y2=1.585
r142 (  36 64 ) resistor r=45.1352 //w=0.168 //l=0.173853 //layer=ply \
 //thickness=0.18 //x=2.375 //y=1.085 //x2=2.415 //y2=0.93
r143 (  36 37 ) resistor r=176.904 //w=0.094 //l=0.345 //layer=ply \
 //thickness=0.18 //x=2.375 //y=1.085 //x2=2.375 //y2=1.43
r144 (  35 50 ) resistor r=592.245 //w=0.094 //l=1.155 //layer=ply \
 //thickness=0.18 //x=2.82 //y=6.2 //x2=2.82 //y2=5.045
r145 (  34 63 ) resistor r=592.245 //w=0.094 //l=1.155 //layer=ply \
 //thickness=0.18 //x=2.38 //y=6.2 //x2=2.38 //y2=5.045
r146 (  33 47 ) resistor r=56.4043 //w=0.094 //l=0.11 //layer=ply \
 //thickness=0.18 //x=2.64 //y=1.585 //x2=2.75 //y2=1.585
r147 (  33 48 ) resistor r=56.4043 //w=0.094 //l=0.11 //layer=ply \
 //thickness=0.18 //x=2.64 //y=1.585 //x2=2.53 //y2=1.585
r148 (  29 60 ) resistor r=152 //w=0.17 //l=0.17 //layer=licon //count=1 \
 //x=2.37 //y=4.88 //x2=2.37 //y2=4.88
r149 (  24 56 ) resistor r=152 //w=0.17 //l=0.17 //layer=licon //count=1 \
 //x=2.34 //y=2.26 //x2=2.34 //y2=2.26
r150 (  22 29 ) resistor r=9.3 //w=0.17 //l=0.17 //layer=mcon //count=1 \
 //x=2.37 //y=4.88 //x2=2.37 //y2=4.88
r151 (  18 24 ) resistor r=9.3 //w=0.17 //l=0.17 //layer=mcon //count=1 \
 //x=2.34 //y=2.26 //x2=2.34 //y2=2.26
r152 (  18 20 ) resistor r=0.0936408 //w=0.196 //l=0.125 //layer=m1 \
 //thickness=0.36 //x=2.342 //y=2.26 //x2=2.342 //y2=2.385
r153 (  9 22 ) resistor r=0.0878548 //w=0.228 //l=0.159295 //layer=m1 \
 //thickness=0.36 //x=2.34 //y=4.735 //x2=2.37 //y2=4.88
r154 (  7 9 ) resistor r=0.109733 //w=0.131 //l=0.115 //layer=m1 \
 //thickness=0.36 //x=2.34 //y=4.62 //x2=2.34 //y2=4.735
r155 (  6 7 ) resistor r=0.353053 //w=0.131 //l=0.37 //layer=m1 \
 //thickness=0.36 //x=2.34 //y=4.25 //x2=2.34 //y2=4.62
r156 (  5 6 ) resistor r=0.353053 //w=0.131 //l=0.37 //layer=m1 \
 //thickness=0.36 //x=2.34 //y=3.88 //x2=2.34 //y2=4.25
r157 (  4 5 ) resistor r=0.353053 //w=0.131 //l=0.37 //layer=m1 \
 //thickness=0.36 //x=2.34 //y=3.51 //x2=2.34 //y2=3.88
r158 (  3 4 ) resistor r=0.353053 //w=0.131 //l=0.37 //layer=m1 \
 //thickness=0.36 //x=2.34 //y=3.14 //x2=2.34 //y2=3.51
r159 (  2 3 ) resistor r=0.353053 //w=0.131 //l=0.37 //layer=m1 \
 //thickness=0.36 //x=2.34 //y=2.77 //x2=2.34 //y2=3.14
r160 (  1 2 ) resistor r=0.353053 //w=0.131 //l=0.37 //layer=m1 \
 //thickness=0.36 //x=2.34 //y=2.4 //x2=2.34 //y2=2.77
r161 (  1 20 ) resistor r=0.014313 //w=0.131 //l=0.015 //layer=m1 \
 //thickness=0.36 //x=2.34 //y=2.4 //x2=2.34 //y2=2.385
ends PM_AOA4X1\%B

subckt PM_AOA4X1\%noxref_7 ( 1 3 5 10 14 17 20 30 46 47 48 )
c94 ( 48 0 ) capacitor c=0.0348842f //x=6.225 //y=5.205
c95 ( 46 0 ) capacitor c=0.0118024f //x=4.475 //y=5.205
c96 ( 30 0 ) capacitor c=0.0302598f //x=5.49 //y=5.56
c97 ( 20 0 ) capacitor c=0.045655f //x=4.61 //y=5.56
c98 ( 17 0 ) capacitor c=0.0164155f //x=6.37 //y=6.92
c99 ( 14 0 ) capacitor c=0.00604334f //x=5.49 //y=6.92
c100 ( 10 0 ) capacitor c=0.0112444f //x=5.49 //y=5.39
c101 ( 5 0 ) capacitor c=0.012947f //x=4.61 //y=5.39
c102 ( 3 0 ) capacitor c=0.00694548f //x=6.24 //y=7.09
c103 ( 1 0 ) capacitor c=0.0131356f //x=5.37 //y=5.39
r104 (  37 47 ) resistor r=23.2727 //w=0.187 //l=0.34 //layer=li \
 //thickness=0.1 //x=5.49 //y=6.92 //x2=5.49 //y2=6.58
r105 (  30 47 ) resistor r=23.2727 //w=0.187 //l=0.34 //layer=li \
 //thickness=0.1 //x=5.49 //y=5.56 //x2=5.49 //y2=5.9
r106 (  20 46 ) resistor r=23.2727 //w=0.187 //l=0.34 //layer=li \
 //thickness=0.1 //x=4.61 //y=5.56 //x2=4.61 //y2=5.9
r107 (  17 48 ) resistor r=9.3 //w=0.17 //l=0.17 //layer=mcon //count=1 \
 //x=6.37 //y=6.92 //x2=6.37 //y2=6.92
r108 (  17 18 ) resistor r=0.0932018 //w=0.228 //l=0.17 //layer=m1 \
 //thickness=0.36 //x=6.362 //y=6.92 //x2=6.362 //y2=7.09
r109 (  14 37 ) resistor r=9.3 //w=0.17 //l=0.17 //layer=mcon //count=1 \
 //x=5.49 //y=6.92 //x2=5.49 //y2=6.92
r110 (  14 15 ) resistor r=0.0992991 //w=0.214 //l=0.17 //layer=m1 \
 //thickness=0.36 //x=5.49 //y=6.92 //x2=5.49 //y2=7.09
r111 (  12 30 ) resistor r=9.3 //w=0.17 //l=0.17 //layer=mcon //count=1 \
 //x=5.49 //y=5.56 //x2=5.49 //y2=5.56
r112 (  10 12 ) resistor r=0.097032 //w=0.219 //l=0.17 //layer=m1 \
 //thickness=0.36 //x=5.49 //y=5.39 //x2=5.49 //y2=5.56
r113 (  7 20 ) resistor r=9.3 //w=0.17 //l=0.17 //layer=mcon //count=1 \
 //x=4.61 //y=5.56 //x2=4.61 //y2=5.56
r114 (  5 7 ) resistor r=0.0997653 //w=0.213 //l=0.17 //layer=m1 \
 //thickness=0.36 //x=4.61 //y=5.39 //x2=4.61 //y2=5.56
r115 (  4 15 ) resistor r=0.0213909 //w=0.214 //l=0.115 //layer=m1 \
 //thickness=0.36 //x=5.605 //y=7.09 //x2=5.49 //y2=7.09
r116 (  3 18 ) resistor r=0.0251868 //w=0.228 //l=0.122 //layer=m1 \
 //thickness=0.36 //x=6.24 //y=7.09 //x2=6.362 //y2=7.09
r117 (  3 4 ) resistor r=0.605916 //w=0.131 //l=0.635 //layer=m1 \
 //thickness=0.36 //x=6.24 //y=7.09 //x2=5.605 //y2=7.09
r118 (  2 5 ) resistor r=0.0211096 //w=0.213 //l=0.115 //layer=m1 \
 //thickness=0.36 //x=4.725 //y=5.39 //x2=4.61 //y2=5.39
r119 (  1 10 ) resistor r=0.0227762 //w=0.219 //l=0.12 //layer=m1 \
 //thickness=0.36 //x=5.37 //y=5.39 //x2=5.49 //y2=5.39
r120 (  1 2 ) resistor r=0.615458 //w=0.131 //l=0.645 //layer=m1 \
 //thickness=0.36 //x=5.37 //y=5.39 //x2=4.725 //y2=5.39
ends PM_AOA4X1\%noxref_7

subckt PM_AOA4X1\%C ( 1 2 3 4 5 6 7 18 22 26 31 35 36 37 38 39 40 45 47 49 55 \
 56 58 59 62 )
c119 ( 62 0 ) capacitor c=0.0404287f //x=5.705 //y=4.885
c120 ( 59 0 ) capacitor c=0.0292709f //x=5.67 //y=2.095
c121 ( 58 0 ) capacitor c=0.0468503f //x=5.67 //y=2.26
c122 ( 56 0 ) capacitor c=0.0237765f //x=6.235 //y=1.435
c123 ( 55 0 ) capacitor c=0.0191782f //x=6.235 //y=1.085
c124 ( 49 0 ) capacitor c=0.035988f //x=6.08 //y=1.585
c125 ( 47 0 ) capacitor c=0.0157803f //x=6.08 //y=0.93
c126 ( 45 0 ) capacitor c=0.036638f //x=6.075 //y=4.975
c127 ( 40 0 ) capacitor c=0.0206674f //x=5.705 //y=1.74
c128 ( 39 0 ) capacitor c=0.0169638f //x=5.705 //y=1.435
c129 ( 38 0 ) capacitor c=0.0185462f //x=5.705 //y=1.085
c130 ( 37 0 ) capacitor c=0.155887f //x=6.15 //y=6.205
c131 ( 36 0 ) capacitor c=0.110534f //x=5.71 //y=6.205
c132 ( 31 0 ) capacitor c=0.0011312f //x=5.705 //y=4.885
c133 ( 26 0 ) capacitor c=9.45497e-19 //x=5.67 //y=2.26
c134 ( 22 0 ) capacitor c=0.0061903f //x=5.705 //y=4.885
c135 ( 18 0 ) capacitor c=0.00573992f //x=5.67 //y=2.26
c136 ( 1 0 ) capacitor c=0.0570424f //x=5.67 //y=2.4
r137 (  64 65 ) resistor r=32.4568 //w=0.214 //l=0.075 //layer=ply \
 //thickness=0.18 //x=5.705 //y=4.975 //x2=5.705 //y2=5.05
r138 (  62 64 ) resistor r=20.271 //w=0.214 //l=0.09 //layer=ply \
 //thickness=0.18 //x=5.705 //y=4.885 //x2=5.705 //y2=4.975
r139 (  58 59 ) resistor r=52.7279 //w=0.214 //l=0.165 //layer=ply \
 //thickness=0.18 //x=5.67 //y=2.26 //x2=5.67 //y2=2.095
r140 (  56 69 ) resistor r=4.95774 //w=0.164 //l=0.112 //layer=ply \
 //thickness=0.18 //x=6.235 //y=1.435 //x2=6.235 //y2=1.547
r141 (  55 68 ) resistor r=45.1352 //w=0.168 //l=0.173853 //layer=ply \
 //thickness=0.18 //x=6.235 //y=1.085 //x2=6.195 //y2=0.93
r142 (  55 56 ) resistor r=179.468 //w=0.094 //l=0.35 //layer=ply \
 //thickness=0.18 //x=6.235 //y=1.085 //x2=6.235 //y2=1.435
r143 (  50 67 ) resistor r=10.8103 //w=0.211 //l=0.115 //layer=ply \
 //thickness=0.18 //x=5.86 //y=1.585 //x2=5.745 //y2=1.585
r144 (  49 69 ) resistor r=45.9962 //w=0.164 //l=0.17296 //layer=ply \
 //thickness=0.18 //x=6.08 //y=1.585 //x2=6.235 //y2=1.547
r145 (  48 66 ) resistor r=5.52526 //w=0.168 //l=0.115 //layer=ply \
 //thickness=0.18 //x=5.86 //y=0.93 //x2=5.745 //y2=0.93
r146 (  47 68 ) resistor r=5.52526 //w=0.168 //l=0.115 //layer=ply \
 //thickness=0.18 //x=6.08 //y=0.93 //x2=6.195 //y2=0.93
r147 (  47 48 ) resistor r=112.809 //w=0.094 //l=0.22 //layer=ply \
 //thickness=0.18 //x=6.08 //y=0.93 //x2=5.86 //y2=0.93
r148 (  46 64 ) resistor r=16.5046 //w=0.27 //l=0.135 //layer=ply \
 //thickness=0.18 //x=5.84 //y=4.975 //x2=5.705 //y2=4.975
r149 (  45 52 ) resistor r=26.9307 //w=0.15 //l=0.106066 //layer=ply \
 //thickness=0.18 //x=6.075 //y=4.975 //x2=6.15 //y2=5.05
r150 (  45 46 ) resistor r=120.5 //w=0.094 //l=0.235 //layer=ply \
 //thickness=0.18 //x=6.075 //y=4.975 //x2=5.84 //y2=4.975
r151 (  40 67 ) resistor r=39.5036 //w=0.211 //l=0.173853 //layer=ply \
 //thickness=0.18 //x=5.705 //y=1.74 //x2=5.745 //y2=1.585
r152 (  40 59 ) resistor r=182.032 //w=0.094 //l=0.355 //layer=ply \
 //thickness=0.18 //x=5.705 //y=1.74 //x2=5.705 //y2=2.095
r153 (  39 67 ) resistor r=38.3614 //w=0.211 //l=0.168819 //layer=ply \
 //thickness=0.18 //x=5.705 //y=1.435 //x2=5.745 //y2=1.585
r154 (  38 66 ) resistor r=45.1352 //w=0.168 //l=0.173853 //layer=ply \
 //thickness=0.18 //x=5.705 //y=1.085 //x2=5.745 //y2=0.93
r155 (  38 39 ) resistor r=179.468 //w=0.094 //l=0.35 //layer=ply \
 //thickness=0.18 //x=5.705 //y=1.085 //x2=5.705 //y2=1.435
r156 (  37 52 ) resistor r=592.245 //w=0.094 //l=1.155 //layer=ply \
 //thickness=0.18 //x=6.15 //y=6.205 //x2=6.15 //y2=5.05
r157 (  36 65 ) resistor r=592.245 //w=0.094 //l=1.155 //layer=ply \
 //thickness=0.18 //x=5.71 //y=6.205 //x2=5.71 //y2=5.05
r158 (  35 49 ) resistor r=56.4043 //w=0.094 //l=0.11 //layer=ply \
 //thickness=0.18 //x=5.97 //y=1.585 //x2=6.08 //y2=1.585
r159 (  35 50 ) resistor r=56.4043 //w=0.094 //l=0.11 //layer=ply \
 //thickness=0.18 //x=5.97 //y=1.585 //x2=5.86 //y2=1.585
r160 (  31 62 ) resistor r=152 //w=0.17 //l=0.17 //layer=licon //count=1 \
 //x=5.705 //y=4.885 //x2=5.705 //y2=4.885
r161 (  26 58 ) resistor r=152 //w=0.17 //l=0.17 //layer=licon //count=1 \
 //x=5.67 //y=2.26 //x2=5.67 //y2=2.26
r162 (  22 31 ) resistor r=9.3 //w=0.17 //l=0.17 //layer=mcon //count=1 \
 //x=5.705 //y=4.885 //x2=5.705 //y2=4.885
r163 (  22 23 ) resistor r=0.105739 //w=0.201 //l=0.145 //layer=m1 \
 //thickness=0.36 //x=5.705 //y=4.885 //x2=5.705 //y2=4.74
r164 (  18 26 ) resistor r=9.3 //w=0.17 //l=0.17 //layer=mcon //count=1 \
 //x=5.67 //y=2.26 //x2=5.67 //y2=2.26
r165 (  18 20 ) resistor r=0.0977888 //w=0.216 //l=0.135 //layer=m1 \
 //thickness=0.36 //x=5.667 //y=2.26 //x2=5.667 //y2=2.395
r166 (  7 23 ) resistor r=0.114504 //w=0.131 //l=0.12 //layer=m1 \
 //thickness=0.36 //x=5.67 //y=4.62 //x2=5.67 //y2=4.74
r167 (  6 7 ) resistor r=0.353053 //w=0.131 //l=0.37 //layer=m1 \
 //thickness=0.36 //x=5.67 //y=4.25 //x2=5.67 //y2=4.62
r168 (  5 6 ) resistor r=0.353053 //w=0.131 //l=0.37 //layer=m1 \
 //thickness=0.36 //x=5.67 //y=3.88 //x2=5.67 //y2=4.25
r169 (  4 5 ) resistor r=0.353053 //w=0.131 //l=0.37 //layer=m1 \
 //thickness=0.36 //x=5.67 //y=3.51 //x2=5.67 //y2=3.88
r170 (  3 4 ) resistor r=0.353053 //w=0.131 //l=0.37 //layer=m1 \
 //thickness=0.36 //x=5.67 //y=3.14 //x2=5.67 //y2=3.51
r171 (  2 3 ) resistor r=0.353053 //w=0.131 //l=0.37 //layer=m1 \
 //thickness=0.36 //x=5.67 //y=2.77 //x2=5.67 //y2=3.14
r172 (  1 2 ) resistor r=0.353053 //w=0.131 //l=0.37 //layer=m1 \
 //thickness=0.36 //x=5.67 //y=2.4 //x2=5.67 //y2=2.77
r173 (  1 20 ) resistor r=0.00477099 //w=0.131 //l=0.005 //layer=m1 \
 //thickness=0.36 //x=5.67 //y=2.4 //x2=5.67 //y2=2.395
ends PM_AOA4X1\%C

subckt PM_AOA4X1\%GND ( 1 2 8 31 34 35 39 40 45 48 63 72 86 91 96 100 118 123 \
 127 139 149 150 157 164 165 166 167 )
c275 ( 167 0 ) capacitor c=0.0650111f //x=10.975 //y=0.55
c276 ( 166 0 ) capacitor c=0.00843555f //x=8.14 //y=1.045
c277 ( 165 0 ) capacitor c=0.0736857f //x=4.38 //y=0.545
c278 ( 164 0 ) capacitor c=0.00843555f //x=1.48 //y=1.045
c279 ( 157 0 ) capacitor c=0.257158f //x=12.08 //y=0.175
c280 ( 150 0 ) capacitor c=0.107475f //x=10.48 //y=0.175
c281 ( 149 0 ) capacitor c=0.112395f //x=7.15 //y=0.175
c282 ( 146 0 ) capacitor c=0.00597439f //x=6.455 //y=0.175
c283 ( 143 0 ) capacitor c=0.00597439f //x=5.485 //y=0.175
c284 ( 140 0 ) capacitor c=0.00597439f //x=4.515 //y=0.175
c285 ( 139 0 ) capacitor c=0.112772f //x=3.82 //y=0.175
c286 ( 130 0 ) capacitor c=0.00585268f //x=12.08 //y=0.63
c287 ( 127 0 ) capacitor c=0.00625302f //x=11.995 //y=0.715
c288 ( 126 0 ) capacitor c=0.00479851f //x=11.59 //y=0.63
c289 ( 123 0 ) capacitor c=0.00633238f //x=11.505 //y=0.715
c290 ( 118 0 ) capacitor c=0.00586769f //x=11.11 //y=0.63
c291 ( 115 0 ) capacitor c=0.0190699f //x=11.025 //y=0.175
c292 ( 100 0 ) capacitor c=0.12525f //x=10.31 //y=0.175
c293 ( 96 0 ) capacitor c=0.0221206f //x=6.98 //y=0.175
c294 ( 91 0 ) capacitor c=0.00739123f //x=6.455 //y=0.625
c295 ( 86 0 ) capacitor c=0.0152893f //x=6.37 //y=0.71
c296 ( 82 0 ) capacitor c=0.0258125f //x=6.37 //y=0.175
c297 ( 77 0 ) capacitor c=0.00726869f //x=5.485 //y=0.625
c298 ( 72 0 ) capacitor c=0.0165507f //x=5.4 //y=0.71
c299 ( 68 0 ) capacitor c=0.0257966f //x=5.4 //y=0.175
c300 ( 63 0 ) capacitor c=0.00739123f //x=4.515 //y=0.625
c301 ( 60 0 ) capacitor c=0.0229116f //x=4.43 //y=0.175
c302 ( 48 0 ) capacitor c=0.201723f //x=1.23 //y=0.18
c303 ( 45 0 ) capacitor c=0.12525f //x=3.65 //y=0.175
c304 ( 42 0 ) capacitor c=0.00509083f //x=8.33 //y=0.175
c305 ( 40 0 ) capacitor c=0.0278993f //x=8.327 //y=1.005
c306 ( 39 0 ) capacitor c=0.0139353f //x=8.33 //y=1.135
c307 ( 37 0 ) capacitor c=0.00509083f //x=1.67 //y=0.175
c308 ( 35 0 ) capacitor c=0.0278993f //x=1.667 //y=1.005
c309 ( 34 0 ) capacitor c=0.0168135f //x=1.67 //y=1.135
c310 ( 31 0 ) capacitor c=0.178489f //x=11.96 //y=0.18
c311 ( 8 0 ) capacitor c=0.221041f //x=8.245 //y=0.175
c312 ( 2 0 ) capacitor c=0.0764176f //x=1.585 //y=0.175
r313 (  156 157 ) resistor r=4.18529 //w=0.367 //l=0.12 //layer=li \
 //thickness=0.1 //x=11.96 //y=0.175 //x2=12.08 //y2=0.175
r314 (  154 156 ) resistor r=12.9046 //w=0.367 //l=0.37 //layer=li \
 //thickness=0.1 //x=11.59 //y=0.175 //x2=11.96 //y2=0.175
r315 (  153 154 ) resistor r=12.9046 //w=0.367 //l=0.37 //layer=li \
 //thickness=0.1 //x=11.22 //y=0.175 //x2=11.59 //y2=0.175
r316 (  151 153 ) resistor r=3.83651 //w=0.367 //l=0.11 //layer=li \
 //thickness=0.1 //x=11.11 //y=0.175 //x2=11.22 //y2=0.175
r317 (  131 167 ) resistor r=5.4201 //w=0.17 //l=0.085 //layer=li \
 //thickness=0.1 //x=12.08 //y=0.8 //x2=12.08 //y2=0.715
r318 (  131 167 ) resistor r=41.4118 //w=0.187 //l=0.605 //layer=li \
 //thickness=0.1 //x=12.08 //y=0.8 //x2=12.08 //y2=1.405
r319 (  130 167 ) resistor r=5.4201 //w=0.17 //l=0.085 //layer=li \
 //thickness=0.1 //x=12.08 //y=0.63 //x2=12.08 //y2=0.715
r320 (  129 157 ) resistor r=5.21862 //w=0.35 //l=0.175 //layer=li \
 //thickness=0.1 //x=12.08 //y=0.35 //x2=12.08 //y2=0.175
r321 (  129 130 ) resistor r=19.1658 //w=0.187 //l=0.28 //layer=li \
 //thickness=0.1 //x=12.08 //y=0.35 //x2=12.08 //y2=0.63
r322 (  128 167 ) resistor r=5.4201 //w=0.17 //l=0.085 //layer=li \
 //thickness=0.1 //x=11.675 //y=0.715 //x2=11.59 //y2=0.715
r323 (  127 167 ) resistor r=1.40859 //w=0.34 //l=0.085 //layer=li \
 //thickness=0.1 //x=11.995 //y=0.715 //x2=12.08 //y2=0.715
r324 (  127 128 ) resistor r=21.9037 //w=0.187 //l=0.32 //layer=li \
 //thickness=0.1 //x=11.995 //y=0.715 //x2=11.675 //y2=0.715
r325 (  126 167 ) resistor r=1.40859 //w=0.34 //l=0.085 //layer=li \
 //thickness=0.1 //x=11.59 //y=0.63 //x2=11.59 //y2=0.715
r326 (  125 154 ) resistor r=5.21862 //w=0.35 //l=0.175 //layer=li \
 //thickness=0.1 //x=11.59 //y=0.35 //x2=11.59 //y2=0.175
r327 (  125 126 ) resistor r=19.1658 //w=0.187 //l=0.28 //layer=li \
 //thickness=0.1 //x=11.59 //y=0.35 //x2=11.59 //y2=0.63
r328 (  124 167 ) resistor r=1.40859 //w=0.34 //l=0.085 //layer=li \
 //thickness=0.1 //x=11.195 //y=0.715 //x2=11.11 //y2=0.715
r329 (  123 167 ) resistor r=5.4201 //w=0.17 //l=0.085 //layer=li \
 //thickness=0.1 //x=11.505 //y=0.715 //x2=11.59 //y2=0.715
r330 (  123 124 ) resistor r=21.2193 //w=0.187 //l=0.31 //layer=li \
 //thickness=0.1 //x=11.505 //y=0.715 //x2=11.195 //y2=0.715
r331 (  119 167 ) resistor r=5.4201 //w=0.17 //l=0.085 //layer=li \
 //thickness=0.1 //x=11.11 //y=0.8 //x2=11.11 //y2=0.715
r332 (  119 167 ) resistor r=41.4118 //w=0.187 //l=0.605 //layer=li \
 //thickness=0.1 //x=11.11 //y=0.8 //x2=11.11 //y2=1.405
r333 (  118 167 ) resistor r=5.4201 //w=0.17 //l=0.085 //layer=li \
 //thickness=0.1 //x=11.11 //y=0.63 //x2=11.11 //y2=0.715
r334 (  117 151 ) resistor r=5.21862 //w=0.35 //l=0.175 //layer=li \
 //thickness=0.1 //x=11.11 //y=0.35 //x2=11.11 //y2=0.175
r335 (  117 118 ) resistor r=19.1658 //w=0.187 //l=0.28 //layer=li \
 //thickness=0.1 //x=11.11 //y=0.35 //x2=11.11 //y2=0.63
r336 (  116 150 ) resistor r=5.29055 //w=0.35 //l=0.17 //layer=li \
 //thickness=0.1 //x=10.65 //y=0.175 //x2=10.48 //y2=0.175
r337 (  115 151 ) resistor r=2.96458 //w=0.367 //l=0.085 //layer=li \
 //thickness=0.1 //x=11.025 //y=0.175 //x2=11.11 //y2=0.175
r338 (  115 116 ) resistor r=13.079 //w=0.367 //l=0.375 //layer=li \
 //thickness=0.1 //x=11.025 //y=0.175 //x2=10.65 //y2=0.175
r339 (  105 107 ) resistor r=38.7139 //w=0.367 //l=1.11 //layer=li \
 //thickness=0.1 //x=8.63 //y=0.175 //x2=9.74 //y2=0.175
r340 (  103 105 ) resistor r=38.7139 //w=0.367 //l=1.11 //layer=li \
 //thickness=0.1 //x=7.52 //y=0.175 //x2=8.63 //y2=0.175
r341 (  101 149 ) resistor r=5.29055 //w=0.35 //l=0.17 //layer=li \
 //thickness=0.1 //x=7.32 //y=0.175 //x2=7.15 //y2=0.175
r342 (  101 103 ) resistor r=6.97548 //w=0.367 //l=0.2 //layer=li \
 //thickness=0.1 //x=7.32 //y=0.175 //x2=7.52 //y2=0.175
r343 (  100 150 ) resistor r=5.29055 //w=0.35 //l=0.17 //layer=li \
 //thickness=0.1 //x=10.31 //y=0.175 //x2=10.48 //y2=0.175
r344 (  100 107 ) resistor r=19.8801 //w=0.367 //l=0.57 //layer=li \
 //thickness=0.1 //x=10.31 //y=0.175 //x2=9.74 //y2=0.175
r345 (  97 146 ) resistor r=2.87058 //w=0.35 //l=0.085 //layer=li \
 //thickness=0.1 //x=6.54 //y=0.175 //x2=6.455 //y2=0.175
r346 (  96 149 ) resistor r=5.29055 //w=0.35 //l=0.17 //layer=li \
 //thickness=0.1 //x=6.98 //y=0.175 //x2=7.15 //y2=0.175
r347 (  96 97 ) resistor r=15.346 //w=0.367 //l=0.44 //layer=li \
 //thickness=0.1 //x=6.98 //y=0.175 //x2=6.54 //y2=0.175
r348 (  92 165 ) resistor r=5.4201 //w=0.17 //l=0.085 //layer=li \
 //thickness=0.1 //x=6.455 //y=0.795 //x2=6.455 //y2=0.71
r349 (  92 165 ) resistor r=18.139 //w=0.187 //l=0.265 //layer=li \
 //thickness=0.1 //x=6.455 //y=0.795 //x2=6.455 //y2=1.06
r350 (  91 165 ) resistor r=5.4201 //w=0.17 //l=0.085 //layer=li \
 //thickness=0.1 //x=6.455 //y=0.625 //x2=6.455 //y2=0.71
r351 (  90 146 ) resistor r=4.23183 //w=0.7 //l=0.175 //layer=li \
 //thickness=0.1 //x=6.455 //y=0.35 //x2=6.455 //y2=0.175
r352 (  90 91 ) resistor r=18.8235 //w=0.187 //l=0.275 //layer=li \
 //thickness=0.1 //x=6.455 //y=0.35 //x2=6.455 //y2=0.625
r353 (  87 165 ) resistor r=6.4 //w=0.17 //l=0.085 //layer=li //thickness=0.1 \
 //x=5.57 //y=0.71 //x2=5.485 //y2=0.71
r354 (  87 165 ) resistor r=27.3797 //w=0.187 //l=0.4 //layer=li \
 //thickness=0.1 //x=5.57 //y=0.71 //x2=5.97 //y2=0.71
r355 (  86 165 ) resistor r=1.40859 //w=0.34 //l=0.085 //layer=li \
 //thickness=0.1 //x=6.37 //y=0.71 //x2=6.455 //y2=0.71
r356 (  86 165 ) resistor r=27.3797 //w=0.187 //l=0.4 //layer=li \
 //thickness=0.1 //x=6.37 //y=0.71 //x2=5.97 //y2=0.71
r357 (  83 143 ) resistor r=2.87058 //w=0.35 //l=0.085 //layer=li \
 //thickness=0.1 //x=5.57 //y=0.175 //x2=5.485 //y2=0.175
r358 (  83 85 ) resistor r=16.3924 //w=0.367 //l=0.47 //layer=li \
 //thickness=0.1 //x=5.57 //y=0.175 //x2=6.04 //y2=0.175
r359 (  82 146 ) resistor r=2.87058 //w=0.35 //l=0.085 //layer=li \
 //thickness=0.1 //x=6.37 //y=0.175 //x2=6.455 //y2=0.175
r360 (  82 85 ) resistor r=11.5095 //w=0.367 //l=0.33 //layer=li \
 //thickness=0.1 //x=6.37 //y=0.175 //x2=6.04 //y2=0.175
r361 (  78 165 ) resistor r=6.4 //w=0.17 //l=0.085 //layer=li //thickness=0.1 \
 //x=5.485 //y=0.795 //x2=5.485 //y2=0.71
r362 (  78 165 ) resistor r=18.139 //w=0.187 //l=0.265 //layer=li \
 //thickness=0.1 //x=5.485 //y=0.795 //x2=5.485 //y2=1.06
r363 (  77 165 ) resistor r=6.4 //w=0.17 //l=0.085 //layer=li //thickness=0.1 \
 //x=5.485 //y=0.625 //x2=5.485 //y2=0.71
r364 (  76 143 ) resistor r=4.23183 //w=0.7 //l=0.175 //layer=li \
 //thickness=0.1 //x=5.485 //y=0.35 //x2=5.485 //y2=0.175
r365 (  76 77 ) resistor r=18.8235 //w=0.187 //l=0.275 //layer=li \
 //thickness=0.1 //x=5.485 //y=0.35 //x2=5.485 //y2=0.625
r366 (  73 165 ) resistor r=1.40859 //w=0.34 //l=0.085 //layer=li \
 //thickness=0.1 //x=4.6 //y=0.71 //x2=4.515 //y2=0.71
r367 (  73 165 ) resistor r=27.3797 //w=0.187 //l=0.4 //layer=li \
 //thickness=0.1 //x=4.6 //y=0.71 //x2=5 //y2=0.71
r368 (  72 165 ) resistor r=6.4 //w=0.17 //l=0.085 //layer=li //thickness=0.1 \
 //x=5.4 //y=0.71 //x2=5.485 //y2=0.71
r369 (  72 165 ) resistor r=27.3797 //w=0.187 //l=0.4 //layer=li \
 //thickness=0.1 //x=5.4 //y=0.71 //x2=5 //y2=0.71
r370 (  69 140 ) resistor r=2.87058 //w=0.35 //l=0.085 //layer=li \
 //thickness=0.1 //x=4.6 //y=0.175 //x2=4.515 //y2=0.175
r371 (  69 71 ) resistor r=11.5095 //w=0.367 //l=0.33 //layer=li \
 //thickness=0.1 //x=4.6 //y=0.175 //x2=4.93 //y2=0.175
r372 (  68 143 ) resistor r=2.87058 //w=0.35 //l=0.085 //layer=li \
 //thickness=0.1 //x=5.4 //y=0.175 //x2=5.485 //y2=0.175
r373 (  68 71 ) resistor r=16.3924 //w=0.367 //l=0.47 //layer=li \
 //thickness=0.1 //x=5.4 //y=0.175 //x2=4.93 //y2=0.175
r374 (  64 165 ) resistor r=5.4201 //w=0.17 //l=0.085 //layer=li \
 //thickness=0.1 //x=4.515 //y=0.795 //x2=4.515 //y2=0.71
r375 (  64 165 ) resistor r=41.4118 //w=0.187 //l=0.605 //layer=li \
 //thickness=0.1 //x=4.515 //y=0.795 //x2=4.515 //y2=1.4
r376 (  63 165 ) resistor r=5.4201 //w=0.17 //l=0.085 //layer=li \
 //thickness=0.1 //x=4.515 //y=0.625 //x2=4.515 //y2=0.71
r377 (  62 140 ) resistor r=4.23183 //w=0.7 //l=0.175 //layer=li \
 //thickness=0.1 //x=4.515 //y=0.35 //x2=4.515 //y2=0.175
r378 (  62 63 ) resistor r=18.8235 //w=0.187 //l=0.275 //layer=li \
 //thickness=0.1 //x=4.515 //y=0.35 //x2=4.515 //y2=0.625
r379 (  61 139 ) resistor r=5.29055 //w=0.35 //l=0.17 //layer=li \
 //thickness=0.1 //x=3.99 //y=0.175 //x2=3.82 //y2=0.175
r380 (  60 140 ) resistor r=2.87058 //w=0.35 //l=0.085 //layer=li \
 //thickness=0.1 //x=4.43 //y=0.175 //x2=4.515 //y2=0.175
r381 (  60 61 ) resistor r=15.346 //w=0.367 //l=0.44 //layer=li \
 //thickness=0.1 //x=4.43 //y=0.175 //x2=3.99 //y2=0.175
r382 (  50 52 ) resistor r=38.7139 //w=0.367 //l=1.11 //layer=li \
 //thickness=0.1 //x=2.34 //y=0.175 //x2=3.45 //y2=0.175
r383 (  48 50 ) resistor r=38.7139 //w=0.367 //l=1.11 //layer=li \
 //thickness=0.1 //x=1.23 //y=0.175 //x2=2.34 //y2=0.175
r384 (  45 139 ) resistor r=5.29055 //w=0.35 //l=0.17 //layer=li \
 //thickness=0.1 //x=3.65 //y=0.175 //x2=3.82 //y2=0.175
r385 (  45 52 ) resistor r=6.97548 //w=0.367 //l=0.2 //layer=li \
 //thickness=0.1 //x=3.65 //y=0.175 //x2=3.45 //y2=0.175
r386 (  39 166 ) resistor r=9.3 //w=0.17 //l=0.17 //layer=mcon //count=1 \
 //x=8.33 //y=1.135 //x2=8.33 //y2=1.135
r387 (  39 40 ) resistor r=0.0939994 //w=0.226 //l=0.13 //layer=m1 \
 //thickness=0.36 //x=8.327 //y=1.135 //x2=8.327 //y2=1.005
r388 (  34 164 ) resistor r=9.3 //w=0.17 //l=0.17 //layer=mcon //count=1 \
 //x=1.67 //y=1.135 //x2=1.67 //y2=1.135
r389 (  34 35 ) resistor r=0.0939994 //w=0.226 //l=0.13 //layer=m1 \
 //thickness=0.36 //x=1.667 //y=1.135 //x2=1.667 //y2=1.005
r390 (  31 156 ) resistor r=4.65 //w=0.17 //l=0.34 //layer=mcon //count=2 \
 //x=11.96 //y=0.18 //x2=11.96 //y2=0.18
r391 (  29 153 ) resistor r=3.1 //w=0.17 //l=0.51 //layer=mcon //count=3 \
 //x=11.22 //y=0.18 //x2=11.22 //y2=0.18
r392 (  29 31 ) resistor r=0.297428 //w=0.311 //l=0.74 //layer=m1 \
 //thickness=0.36 //x=11.22 //y=0.175 //x2=11.96 //y2=0.175
r393 (  27 107 ) resistor r=3.1 //w=0.17 //l=0.51 //layer=mcon //count=3 \
 //x=9.74 //y=0.18 //x2=9.74 //y2=0.18
r394 (  27 29 ) resistor r=0.594855 //w=0.311 //l=1.48 //layer=m1 \
 //thickness=0.36 //x=9.74 //y=0.175 //x2=11.22 //y2=0.175
r395 (  25 105 ) resistor r=3.1 //w=0.17 //l=0.51 //layer=mcon //count=3 \
 //x=8.63 //y=0.18 //x2=8.63 //y2=0.18
r396 (  25 27 ) resistor r=0.446141 //w=0.311 //l=1.11 //layer=m1 \
 //thickness=0.36 //x=8.63 //y=0.175 //x2=9.74 //y2=0.175
r397 (  23 42 ) resistor r=0.028033 //w=0.35 //l=0.085 //layer=m1 \
 //thickness=0.36 //x=8.415 //y=0.175 //x2=8.33 //y2=0.175
r398 (  23 25 ) resistor r=0.0864148 //w=0.311 //l=0.215 //layer=m1 \
 //thickness=0.36 //x=8.415 //y=0.175 //x2=8.63 //y2=0.175
r399 (  21 42 ) resistor r=0.0413265 //w=0.7 //l=0.175 //layer=m1 \
 //thickness=0.36 //x=8.33 //y=0.35 //x2=8.33 //y2=0.175
r400 (  21 40 ) resistor r=0.625 //w=0.131 //l=0.655 //layer=m1 \
 //thickness=0.36 //x=8.33 //y=0.35 //x2=8.33 //y2=1.005
r401 (  20 103 ) resistor r=3.1 //w=0.17 //l=0.51 //layer=mcon //count=3 \
 //x=7.52 //y=0.18 //x2=7.52 //y2=0.18
r402 (  17 85 ) resistor r=3.1 //w=0.17 //l=0.51 //layer=mcon //count=3 \
 //x=6.04 //y=0.18 //x2=6.04 //y2=0.18
r403 (  15 71 ) resistor r=3.1 //w=0.17 //l=0.51 //layer=mcon //count=3 \
 //x=4.93 //y=0.18 //x2=4.93 //y2=0.18
r404 (  15 17 ) resistor r=0.446141 //w=0.311 //l=1.11 //layer=m1 \
 //thickness=0.36 //x=4.93 //y=0.175 //x2=6.04 //y2=0.175
r405 (  13 52 ) resistor r=3.1 //w=0.17 //l=0.51 //layer=mcon //count=3 \
 //x=3.45 //y=0.18 //x2=3.45 //y2=0.18
r406 (  13 15 ) resistor r=0.594855 //w=0.311 //l=1.48 //layer=m1 \
 //thickness=0.36 //x=3.45 //y=0.175 //x2=4.93 //y2=0.175
r407 (  11 50 ) resistor r=3.1 //w=0.17 //l=0.51 //layer=mcon //count=3 \
 //x=2.34 //y=0.18 //x2=2.34 //y2=0.18
r408 (  11 13 ) resistor r=0.446141 //w=0.311 //l=1.11 //layer=m1 \
 //thickness=0.36 //x=2.34 //y=0.175 //x2=3.45 //y2=0.175
r409 (  9 37 ) resistor r=0.028033 //w=0.35 //l=0.085 //layer=m1 \
 //thickness=0.36 //x=1.755 //y=0.175 //x2=1.67 //y2=0.175
r410 (  9 11 ) resistor r=0.235129 //w=0.311 //l=0.585 //layer=m1 \
 //thickness=0.36 //x=1.755 //y=0.175 //x2=2.34 //y2=0.175
r411 (  8 42 ) resistor r=0.028033 //w=0.35 //l=0.085 //layer=m1 \
 //thickness=0.36 //x=8.245 //y=0.175 //x2=8.33 //y2=0.175
r412 (  8 20 ) resistor r=0.291399 //w=0.311 //l=0.725 //layer=m1 \
 //thickness=0.36 //x=8.245 //y=0.175 //x2=7.52 //y2=0.175
r413 (  6 37 ) resistor r=0.0413265 //w=0.7 //l=0.175 //layer=m1 \
 //thickness=0.36 //x=1.67 //y=0.35 //x2=1.67 //y2=0.175
r414 (  6 35 ) resistor r=0.625 //w=0.131 //l=0.655 //layer=m1 \
 //thickness=0.36 //x=1.67 //y=0.35 //x2=1.67 //y2=1.005
r415 (  4 48 ) resistor r=3.1 //w=0.17 //l=0.51 //layer=mcon //count=3 \
 //x=1.23 //y=0.18 //x2=1.23 //y2=0.18
r416 (  2 37 ) resistor r=0.028033 //w=0.35 //l=0.085 //layer=m1 \
 //thickness=0.36 //x=1.585 //y=0.175 //x2=1.67 //y2=0.175
r417 (  2 4 ) resistor r=0.142685 //w=0.311 //l=0.355 //layer=m1 \
 //thickness=0.36 //x=1.585 //y=0.175 //x2=1.23 //y2=0.175
r418 (  1 20 ) resistor r=0.371785 //w=0.311 //l=0.925 //layer=m1 \
 //thickness=0.36 //x=6.595 //y=0.175 //x2=7.52 //y2=0.175
r419 (  1 17 ) resistor r=0.223071 //w=0.311 //l=0.555 //layer=m1 \
 //thickness=0.36 //x=6.595 //y=0.175 //x2=6.04 //y2=0.175
ends PM_AOA4X1\%GND

subckt PM_AOA4X1\%D ( 1 2 3 4 5 6 7 9 18 24 29 33 34 35 36 37 38 43 45 47 53 \
 54 56 57 60 )
c112 ( 60 0 ) capacitor c=0.0393541f //x=9.03 //y=4.88
c113 ( 57 0 ) capacitor c=0.0284095f //x=9 //y=2.095
c114 ( 56 0 ) capacitor c=0.0476356f //x=9 //y=2.26
c115 ( 54 0 ) capacitor c=0.0439708f //x=9.565 //y=1.43
c116 ( 53 0 ) capacitor c=0.0192582f //x=9.565 //y=1.085
c117 ( 47 0 ) capacitor c=0.0162526f //x=9.41 //y=1.585
c118 ( 45 0 ) capacitor c=0.0157807f //x=9.41 //y=0.93
c119 ( 43 0 ) capacitor c=0.0373491f //x=9.405 //y=4.97
c120 ( 38 0 ) capacitor c=0.0210762f //x=9.035 //y=1.74
c121 ( 37 0 ) capacitor c=0.0168511f //x=9.035 //y=1.43
c122 ( 36 0 ) capacitor c=0.0175485f //x=9.035 //y=1.085
c123 ( 35 0 ) capacitor c=0.155269f //x=9.48 //y=6.2
c124 ( 34 0 ) capacitor c=0.110375f //x=9.04 //y=6.2
c125 ( 29 0 ) capacitor c=8.90417e-19 //x=9.03 //y=4.88
c126 ( 24 0 ) capacitor c=7.72439e-19 //x=9 //y=2.26
c127 ( 18 0 ) capacitor c=0.00687137f //x=9 //y=2.26
c128 ( 9 0 ) capacitor c=0.00493417f //x=9 //y=4.735
c129 ( 1 0 ) capacitor c=0.0570558f //x=9 //y=2.4
r130 (  62 63 ) resistor r=32.4568 //w=0.214 //l=0.075 //layer=ply \
 //thickness=0.18 //x=9.03 //y=4.97 //x2=9.03 //y2=5.045
r131 (  60 62 ) resistor r=20.271 //w=0.214 //l=0.09 //layer=ply \
 //thickness=0.18 //x=9.03 //y=4.88 //x2=9.03 //y2=4.97
r132 (  56 57 ) resistor r=52.7279 //w=0.214 //l=0.165 //layer=ply \
 //thickness=0.18 //x=9 //y=2.26 //x2=9 //y2=2.095
r133 (  54 67 ) resistor r=45.1352 //w=0.168 //l=0.173853 //layer=ply \
 //thickness=0.18 //x=9.565 //y=1.43 //x2=9.525 //y2=1.585
r134 (  53 66 ) resistor r=45.1352 //w=0.168 //l=0.173853 //layer=ply \
 //thickness=0.18 //x=9.565 //y=1.085 //x2=9.525 //y2=0.93
r135 (  53 54 ) resistor r=176.904 //w=0.094 //l=0.345 //layer=ply \
 //thickness=0.18 //x=9.565 //y=1.085 //x2=9.565 //y2=1.43
r136 (  48 65 ) resistor r=10.701 //w=0.21 //l=0.115 //layer=ply \
 //thickness=0.18 //x=9.19 //y=1.585 //x2=9.075 //y2=1.585
r137 (  47 67 ) resistor r=5.52526 //w=0.168 //l=0.115 //layer=ply \
 //thickness=0.18 //x=9.41 //y=1.585 //x2=9.525 //y2=1.585
r138 (  46 64 ) resistor r=5.52526 //w=0.168 //l=0.115 //layer=ply \
 //thickness=0.18 //x=9.19 //y=0.93 //x2=9.075 //y2=0.93
r139 (  45 66 ) resistor r=5.52526 //w=0.168 //l=0.115 //layer=ply \
 //thickness=0.18 //x=9.41 //y=0.93 //x2=9.525 //y2=0.93
r140 (  45 46 ) resistor r=112.809 //w=0.094 //l=0.22 //layer=ply \
 //thickness=0.18 //x=9.41 //y=0.93 //x2=9.19 //y2=0.93
r141 (  44 62 ) resistor r=16.5046 //w=0.27 //l=0.135 //layer=ply \
 //thickness=0.18 //x=9.165 //y=4.97 //x2=9.03 //y2=4.97
r142 (  43 50 ) resistor r=26.9307 //w=0.15 //l=0.106066 //layer=ply \
 //thickness=0.18 //x=9.405 //y=4.97 //x2=9.48 //y2=5.045
r143 (  43 44 ) resistor r=123.064 //w=0.094 //l=0.24 //layer=ply \
 //thickness=0.18 //x=9.405 //y=4.97 //x2=9.165 //y2=4.97
r144 (  38 65 ) resistor r=39.5823 //w=0.21 //l=0.173853 //layer=ply \
 //thickness=0.18 //x=9.035 //y=1.74 //x2=9.075 //y2=1.585
r145 (  38 57 ) resistor r=182.032 //w=0.094 //l=0.355 //layer=ply \
 //thickness=0.18 //x=9.035 //y=1.74 //x2=9.035 //y2=2.095
r146 (  37 65 ) resistor r=39.5823 //w=0.21 //l=0.173853 //layer=ply \
 //thickness=0.18 //x=9.035 //y=1.43 //x2=9.075 //y2=1.585
r147 (  36 64 ) resistor r=45.1352 //w=0.168 //l=0.173853 //layer=ply \
 //thickness=0.18 //x=9.035 //y=1.085 //x2=9.075 //y2=0.93
r148 (  36 37 ) resistor r=176.904 //w=0.094 //l=0.345 //layer=ply \
 //thickness=0.18 //x=9.035 //y=1.085 //x2=9.035 //y2=1.43
r149 (  35 50 ) resistor r=592.245 //w=0.094 //l=1.155 //layer=ply \
 //thickness=0.18 //x=9.48 //y=6.2 //x2=9.48 //y2=5.045
r150 (  34 63 ) resistor r=592.245 //w=0.094 //l=1.155 //layer=ply \
 //thickness=0.18 //x=9.04 //y=6.2 //x2=9.04 //y2=5.045
r151 (  33 47 ) resistor r=56.4043 //w=0.094 //l=0.11 //layer=ply \
 //thickness=0.18 //x=9.3 //y=1.585 //x2=9.41 //y2=1.585
r152 (  33 48 ) resistor r=56.4043 //w=0.094 //l=0.11 //layer=ply \
 //thickness=0.18 //x=9.3 //y=1.585 //x2=9.19 //y2=1.585
r153 (  29 60 ) resistor r=152 //w=0.17 //l=0.17 //layer=licon //count=1 \
 //x=9.03 //y=4.88 //x2=9.03 //y2=4.88
r154 (  24 56 ) resistor r=152 //w=0.17 //l=0.17 //layer=licon //count=1 //x=9 \
 //y=2.26 //x2=9 //y2=2.26
r155 (  22 29 ) resistor r=9.3 //w=0.17 //l=0.17 //layer=mcon //count=1 \
 //x=9.03 //y=4.88 //x2=9.03 //y2=4.88
r156 (  18 24 ) resistor r=9.3 //w=0.17 //l=0.17 //layer=mcon //count=1 //x=9 \
 //y=2.26 //x2=9 //y2=2.26
r157 (  18 20 ) resistor r=0.0936408 //w=0.196 //l=0.125 //layer=m1 \
 //thickness=0.36 //x=9.002 //y=2.26 //x2=9.002 //y2=2.385
r158 (  9 22 ) resistor r=0.0878548 //w=0.228 //l=0.159295 //layer=m1 \
 //thickness=0.36 //x=9 //y=4.735 //x2=9.03 //y2=4.88
r159 (  7 9 ) resistor r=0.109733 //w=0.131 //l=0.115 //layer=m1 \
 //thickness=0.36 //x=9 //y=4.62 //x2=9 //y2=4.735
r160 (  6 7 ) resistor r=0.353053 //w=0.131 //l=0.37 //layer=m1 \
 //thickness=0.36 //x=9 //y=4.25 //x2=9 //y2=4.62
r161 (  5 6 ) resistor r=0.353053 //w=0.131 //l=0.37 //layer=m1 \
 //thickness=0.36 //x=9 //y=3.88 //x2=9 //y2=4.25
r162 (  4 5 ) resistor r=0.353053 //w=0.131 //l=0.37 //layer=m1 \
 //thickness=0.36 //x=9 //y=3.51 //x2=9 //y2=3.88
r163 (  3 4 ) resistor r=0.353053 //w=0.131 //l=0.37 //layer=m1 \
 //thickness=0.36 //x=9 //y=3.14 //x2=9 //y2=3.51
r164 (  2 3 ) resistor r=0.353053 //w=0.131 //l=0.37 //layer=m1 \
 //thickness=0.36 //x=9 //y=2.77 //x2=9 //y2=3.14
r165 (  1 2 ) resistor r=0.353053 //w=0.131 //l=0.37 //layer=m1 \
 //thickness=0.36 //x=9 //y=2.4 //x2=9 //y2=2.77
r166 (  1 20 ) resistor r=0.014313 //w=0.131 //l=0.015 //layer=m1 \
 //thickness=0.36 //x=9 //y=2.4 //x2=9 //y2=2.385
ends PM_AOA4X1\%D

subckt PM_AOA4X1\%Y ( 1 2 3 4 5 6 7 9 11 12 13 14 15 26 36 43 45 )
c80 ( 43 0 ) capacitor c=0.00869746f //x=11.405 //y=1.09
c81 ( 36 0 ) capacitor c=0.0262395f //x=11.595 //y=5.56
c82 ( 26 0 ) capacitor c=0.0191378f //x=11.59 //y=1.185
c83 ( 15 0 ) capacitor c=0.00557311f //x=11.68 //y=5.14
c84 ( 14 0 ) capacitor c=0.00944012f //x=11.875 //y=5.14
c85 ( 13 0 ) capacitor c=0.00724565f //x=11.675 //y=2.02
c86 ( 12 0 ) capacitor c=0.0145753f //x=11.875 //y=2.02
c87 ( 11 0 ) capacitor c=0.0118345f //x=11.595 //y=5.42
c88 ( 9 0 ) capacitor c=0.0170096f //x=11.59 //y=1.935
c89 ( 1 0 ) capacitor c=0.117157f //x=11.96 //y=2.4
r90 (  36 45 ) resistor r=23.615 //w=0.187 //l=0.345 //layer=li \
 //thickness=0.1 //x=11.595 //y=5.56 //x2=11.595 //y2=5.905
r91 (  29 36 ) resistor r=9.3 //w=0.17 //l=0.17 //layer=mcon //count=1 \
 //x=11.595 //y=5.56 //x2=11.595 //y2=5.56
r92 (  26 43 ) resistor r=9.3 //w=0.17 //l=0.17 //layer=mcon //count=1 \
 //x=11.59 //y=1.185 //x2=11.59 //y2=1.185
r93 (  14 17 ) resistor r=0.0698411 //w=0.17 //l=0.120208 //layer=m1 \
 //thickness=0.36 //x=11.875 //y=5.14 //x2=11.96 //y2=5.055
r94 (  14 15 ) resistor r=0.186069 //w=0.131 //l=0.195 //layer=m1 \
 //thickness=0.36 //x=11.875 //y=5.14 //x2=11.68 //y2=5.14
r95 (  12 16 ) resistor r=0.0698411 //w=0.17 //l=0.120208 //layer=m1 \
 //thickness=0.36 //x=11.875 //y=2.02 //x2=11.96 //y2=2.105
r96 (  12 13 ) resistor r=0.19084 //w=0.131 //l=0.2 //layer=m1 \
 //thickness=0.36 //x=11.875 //y=2.02 //x2=11.675 //y2=2.02
r97 (  11 29 ) resistor r=0.086672 //w=0.218 //l=0.14 //layer=m1 \
 //thickness=0.36 //x=11.595 //y=5.42 //x2=11.595 //y2=5.56
r98 (  10 15 ) resistor r=0.0698411 //w=0.17 //l=0.120208 //layer=m1 \
 //thickness=0.36 //x=11.595 //y=5.225 //x2=11.68 //y2=5.14
r99 (  10 11 ) resistor r=0.186069 //w=0.131 //l=0.195 //layer=m1 \
 //thickness=0.36 //x=11.595 //y=5.225 //x2=11.595 //y2=5.42
r100 (  9 13 ) resistor r=0.0698411 //w=0.17 //l=0.120208 //layer=m1 \
 //thickness=0.36 //x=11.59 //y=1.935 //x2=11.675 //y2=2.02
r101 (  8 26 ) resistor r=0.105739 //w=0.201 //l=0.145 //layer=m1 \
 //thickness=0.36 //x=11.59 //y=1.33 //x2=11.59 //y2=1.185
r102 (  8 9 ) resistor r=0.57729 //w=0.131 //l=0.605 //layer=m1 \
 //thickness=0.36 //x=11.59 //y=1.33 //x2=11.59 //y2=1.935
r103 (  7 17 ) resistor r=0.415076 //w=0.131 //l=0.435 //layer=m1 \
 //thickness=0.36 //x=11.96 //y=4.62 //x2=11.96 //y2=5.055
r104 (  6 7 ) resistor r=0.353053 //w=0.131 //l=0.37 //layer=m1 \
 //thickness=0.36 //x=11.96 //y=4.25 //x2=11.96 //y2=4.62
r105 (  5 6 ) resistor r=0.353053 //w=0.131 //l=0.37 //layer=m1 \
 //thickness=0.36 //x=11.96 //y=3.88 //x2=11.96 //y2=4.25
r106 (  4 5 ) resistor r=0.353053 //w=0.131 //l=0.37 //layer=m1 \
 //thickness=0.36 //x=11.96 //y=3.51 //x2=11.96 //y2=3.88
r107 (  3 4 ) resistor r=0.353053 //w=0.131 //l=0.37 //layer=m1 \
 //thickness=0.36 //x=11.96 //y=3.14 //x2=11.96 //y2=3.51
r108 (  2 3 ) resistor r=0.353053 //w=0.131 //l=0.37 //layer=m1 \
 //thickness=0.36 //x=11.96 //y=2.77 //x2=11.96 //y2=3.14
r109 (  1 2 ) resistor r=0.353053 //w=0.131 //l=0.37 //layer=m1 \
 //thickness=0.36 //x=11.96 //y=2.4 //x2=11.96 //y2=2.77
r110 (  1 16 ) resistor r=0.281489 //w=0.131 //l=0.295 //layer=m1 \
 //thickness=0.36 //x=11.96 //y=2.4 //x2=11.96 //y2=2.105
ends PM_AOA4X1\%Y

subckt PM_AOA4X1\%noxref_12 ( 1 5 9 10 13 17 29 )
c61 ( 29 0 ) capacitor c=0.0672366f //x=1.05 //y=0.545
c62 ( 17 0 ) capacitor c=0.00709791f //x=3.125 //y=0.795
c63 ( 13 0 ) capacitor c=0.0157877f //x=3.04 //y=0.71
c64 ( 10 0 ) capacitor c=0.00963509f //x=2.155 //y=1.675
c65 ( 9 0 ) capacitor c=0.00770028f //x=2.155 //y=0.795
c66 ( 5 0 ) capacitor c=0.0246013f //x=2.07 //y=1.76
c67 ( 1 0 ) capacitor c=0.0115037f //x=1.185 //y=1.675
r68 (  17 29 ) resistor r=3.57586 //w=0.17 //l=0.125 //layer=li \
 //thickness=0.1 //x=3.125 //y=0.795 //x2=3.125 //y2=0.67
r69 (  17 29 ) resistor r=18.139 //w=0.187 //l=0.265 //layer=li \
 //thickness=0.1 //x=3.125 //y=0.795 //x2=3.125 //y2=1.06
r70 (  14 29 ) resistor r=3.57586 //w=0.17 //l=0.103078 //layer=li \
 //thickness=0.1 //x=2.24 //y=0.71 //x2=2.155 //y2=0.67
r71 (  14 29 ) resistor r=27.3797 //w=0.187 //l=0.4 //layer=li //thickness=0.1 \
 //x=2.24 //y=0.71 //x2=2.64 //y2=0.71
r72 (  13 29 ) resistor r=3.57586 //w=0.17 //l=0.103078 //layer=li \
 //thickness=0.1 //x=3.04 //y=0.71 //x2=3.125 //y2=0.67
r73 (  13 29 ) resistor r=27.3797 //w=0.187 //l=0.4 //layer=li //thickness=0.1 \
 //x=3.04 //y=0.71 //x2=2.64 //y2=0.71
r74 (  10 29 ) resistor r=3.57586 //w=0.17 //l=0.125 //layer=li \
 //thickness=0.1 //x=2.155 //y=1.675 //x2=2.155 //y2=1.8
r75 (  10 29 ) resistor r=42.0963 //w=0.187 //l=0.615 //layer=li \
 //thickness=0.1 //x=2.155 //y=1.675 //x2=2.155 //y2=1.06
r76 (  9 29 ) resistor r=3.57586 //w=0.17 //l=0.125 //layer=li //thickness=0.1 \
 //x=2.155 //y=0.795 //x2=2.155 //y2=0.67
r77 (  9 29 ) resistor r=18.139 //w=0.187 //l=0.265 //layer=li //thickness=0.1 \
 //x=2.155 //y=0.795 //x2=2.155 //y2=1.06
r78 (  6 29 ) resistor r=3.57586 //w=0.17 //l=0.103078 //layer=li \
 //thickness=0.1 //x=1.27 //y=1.76 //x2=1.185 //y2=1.8
r79 (  6 29 ) resistor r=27.3797 //w=0.187 //l=0.4 //layer=li //thickness=0.1 \
 //x=1.27 //y=1.76 //x2=1.67 //y2=1.76
r80 (  5 29 ) resistor r=3.57586 //w=0.17 //l=0.103078 //layer=li \
 //thickness=0.1 //x=2.07 //y=1.76 //x2=2.155 //y2=1.8
r81 (  5 29 ) resistor r=27.3797 //w=0.187 //l=0.4 //layer=li //thickness=0.1 \
 //x=2.07 //y=1.76 //x2=1.67 //y2=1.76
r82 (  1 29 ) resistor r=3.57586 //w=0.17 //l=0.125 //layer=li //thickness=0.1 \
 //x=1.185 //y=1.675 //x2=1.185 //y2=1.8
r83 (  1 29 ) resistor r=42.0963 //w=0.187 //l=0.615 //layer=li \
 //thickness=0.1 //x=1.185 //y=1.675 //x2=1.185 //y2=1.06
ends PM_AOA4X1\%noxref_12

subckt PM_AOA4X1\%noxref_13 ( 1 5 9 10 13 17 29 )
c66 ( 29 0 ) capacitor c=0.0661664f //x=7.71 //y=0.545
c67 ( 17 0 ) capacitor c=0.00709791f //x=9.785 //y=0.795
c68 ( 13 0 ) capacitor c=0.0157877f //x=9.7 //y=0.71
c69 ( 10 0 ) capacitor c=0.00962197f //x=8.815 //y=1.675
c70 ( 9 0 ) capacitor c=0.00770028f //x=8.815 //y=0.795
c71 ( 5 0 ) capacitor c=0.0229059f //x=8.73 //y=1.76
c72 ( 1 0 ) capacitor c=0.00776684f //x=7.845 //y=1.675
r73 (  17 29 ) resistor r=3.57586 //w=0.17 //l=0.125 //layer=li \
 //thickness=0.1 //x=9.785 //y=0.795 //x2=9.785 //y2=0.67
r74 (  17 29 ) resistor r=18.139 //w=0.187 //l=0.265 //layer=li \
 //thickness=0.1 //x=9.785 //y=0.795 //x2=9.785 //y2=1.06
r75 (  14 29 ) resistor r=3.57586 //w=0.17 //l=0.103078 //layer=li \
 //thickness=0.1 //x=8.9 //y=0.71 //x2=8.815 //y2=0.67
r76 (  14 29 ) resistor r=27.3797 //w=0.187 //l=0.4 //layer=li //thickness=0.1 \
 //x=8.9 //y=0.71 //x2=9.3 //y2=0.71
r77 (  13 29 ) resistor r=3.57586 //w=0.17 //l=0.103078 //layer=li \
 //thickness=0.1 //x=9.7 //y=0.71 //x2=9.785 //y2=0.67
r78 (  13 29 ) resistor r=27.3797 //w=0.187 //l=0.4 //layer=li //thickness=0.1 \
 //x=9.7 //y=0.71 //x2=9.3 //y2=0.71
r79 (  10 29 ) resistor r=3.57586 //w=0.17 //l=0.125 //layer=li \
 //thickness=0.1 //x=8.815 //y=1.675 //x2=8.815 //y2=1.8
r80 (  10 29 ) resistor r=42.0963 //w=0.187 //l=0.615 //layer=li \
 //thickness=0.1 //x=8.815 //y=1.675 //x2=8.815 //y2=1.06
r81 (  9 29 ) resistor r=3.57586 //w=0.17 //l=0.125 //layer=li //thickness=0.1 \
 //x=8.815 //y=0.795 //x2=8.815 //y2=0.67
r82 (  9 29 ) resistor r=18.139 //w=0.187 //l=0.265 //layer=li //thickness=0.1 \
 //x=8.815 //y=0.795 //x2=8.815 //y2=1.06
r83 (  6 29 ) resistor r=3.57586 //w=0.17 //l=0.103078 //layer=li \
 //thickness=0.1 //x=7.93 //y=1.76 //x2=7.845 //y2=1.8
r84 (  6 29 ) resistor r=27.3797 //w=0.187 //l=0.4 //layer=li //thickness=0.1 \
 //x=7.93 //y=1.76 //x2=8.33 //y2=1.76
r85 (  5 29 ) resistor r=3.57586 //w=0.17 //l=0.103078 //layer=li \
 //thickness=0.1 //x=8.73 //y=1.76 //x2=8.815 //y2=1.8
r86 (  5 29 ) resistor r=27.3797 //w=0.187 //l=0.4 //layer=li //thickness=0.1 \
 //x=8.73 //y=1.76 //x2=8.33 //y2=1.76
r87 (  1 29 ) resistor r=3.57586 //w=0.17 //l=0.125 //layer=li //thickness=0.1 \
 //x=7.845 //y=1.675 //x2=7.845 //y2=1.8
r88 (  1 29 ) resistor r=42.0963 //w=0.187 //l=0.615 //layer=li \
 //thickness=0.1 //x=7.845 //y=1.675 //x2=7.845 //y2=1.06
ends PM_AOA4X1\%noxref_13
