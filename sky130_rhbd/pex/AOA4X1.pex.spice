// File: AOA4X1.spi.pex
// Created: Tue Apr 29 10:38:34 2025
// Program "Calibre xRC"
// Version "v2023.2_27.15"
// Nominal Temperature: 30C
// Circuit Temperature: 30C
//
simulator lang=spectre
subckt PM_AOA4X1\%GND ( 1 23 27 30 35 46 51 55 63 67 70 79 87 98 103 107 120 \
 140 142 149 156 157 158 159 )
c169 ( 159 0 ) capacitor c=0.0597376f //x=10.975 //y=0.55
c170 ( 158 0 ) capacitor c=0.0207704f //x=8.14 //y=1.045
c171 ( 157 0 ) capacitor c=0.069887f //x=4.38 //y=0.545
c172 ( 156 0 ) capacitor c=0.0208405f //x=1.48 //y=1.045
c173 ( 149 0 ) capacitor c=0.253193f //x=12.08 //y=0.175
c174 ( 142 0 ) capacitor c=0.101387f //x=10.48 //y=0.175
c175 ( 141 0 ) capacitor c=0.00446416f //x=8.33 //y=0.175
c176 ( 140 0 ) capacitor c=0.104406f //x=7.15 //y=0.175
c177 ( 120 0 ) capacitor c=0.107188f //x=3.82 //y=0.175
c178 ( 119 0 ) capacitor c=0.00446416f //x=1.67 //y=0.175
c179 ( 110 0 ) capacitor c=0.00583665f //x=12.08 //y=0.63
c180 ( 107 0 ) capacitor c=0.00542565f //x=11.995 //y=0.715
c181 ( 106 0 ) capacitor c=0.00479856f //x=11.595 //y=0.63
c182 ( 103 0 ) capacitor c=0.00690112f //x=11.51 //y=0.715
c183 ( 98 0 ) capacitor c=0.00588377f //x=11.11 //y=0.63
c184 ( 95 0 ) capacitor c=0.0191899f //x=11.025 //y=0.175
c185 ( 87 0 ) capacitor c=0.0760254f //x=10.31 //y=0.175
c186 ( 79 0 ) capacitor c=0.0430284f //x=8.245 //y=0.175
c187 ( 76 0 ) capacitor c=0.0670931f //x=6.54 //y=0.175
c188 ( 75 0 ) capacitor c=0.0229116f //x=6.98 //y=0.175
c189 ( 70 0 ) capacitor c=0.00609805f //x=6.455 //y=0.625
c190 ( 67 0 ) capacitor c=0.00508078f //x=6.37 //y=0.71
c191 ( 66 0 ) capacitor c=0.00468234f //x=5.97 //y=0.625
c192 ( 63 0 ) capacitor c=0.00556167f //x=5.885 //y=0.71
c193 ( 58 0 ) capacitor c=0.00468234f //x=5.485 //y=0.625
c194 ( 55 0 ) capacitor c=0.00556167f //x=5.4 //y=0.71
c195 ( 54 0 ) capacitor c=0.00468234f //x=5 //y=0.625
c196 ( 51 0 ) capacitor c=0.00692583f //x=4.915 //y=0.71
c197 ( 46 0 ) capacitor c=0.00609805f //x=4.515 //y=0.625
c198 ( 43 0 ) capacitor c=0.0229116f //x=4.43 //y=0.175
c199 ( 35 0 ) capacitor c=0.0760254f //x=3.65 //y=0.175
c200 ( 30 0 ) capacitor c=0.198174f //x=1.23 //y=0.18
c201 ( 27 0 ) capacitor c=0.0430284f //x=1.585 //y=0.175
c202 ( 23 0 ) capacitor c=0.494757f //x=11.96 //y=0.18
r203 (  148 149 ) resistor r=4.18529 //w=0.367 //l=0.12 //layer=li \
 //thickness=0.1 //x=11.96 //y=0.175 //x2=12.08 //y2=0.175
r204 (  146 148 ) resistor r=12.7302 //w=0.367 //l=0.365 //layer=li \
 //thickness=0.1 //x=11.595 //y=0.175 //x2=11.96 //y2=0.175
r205 (  145 146 ) resistor r=13.079 //w=0.367 //l=0.375 //layer=li \
 //thickness=0.1 //x=11.22 //y=0.175 //x2=11.595 //y2=0.175
r206 (  143 145 ) resistor r=3.83651 //w=0.367 //l=0.11 //layer=li \
 //thickness=0.1 //x=11.11 //y=0.175 //x2=11.22 //y2=0.175
r207 (  128 129 ) resistor r=14.4741 //w=0.367 //l=0.415 //layer=li \
 //thickness=0.1 //x=6.04 //y=0.175 //x2=6.455 //y2=0.175
r208 (  126 128 ) resistor r=2.44142 //w=0.367 //l=0.07 //layer=li \
 //thickness=0.1 //x=5.97 //y=0.175 //x2=6.04 //y2=0.175
r209 (  125 126 ) resistor r=16.9155 //w=0.367 //l=0.485 //layer=li \
 //thickness=0.1 //x=5.485 //y=0.175 //x2=5.97 //y2=0.175
r210 (  124 125 ) resistor r=16.9155 //w=0.367 //l=0.485 //layer=li \
 //thickness=0.1 //x=5 //y=0.175 //x2=5.485 //y2=0.175
r211 (  123 124 ) resistor r=2.44142 //w=0.367 //l=0.07 //layer=li \
 //thickness=0.1 //x=4.93 //y=0.175 //x2=5 //y2=0.175
r212 (  121 123 ) resistor r=14.4741 //w=0.367 //l=0.415 //layer=li \
 //thickness=0.1 //x=4.515 //y=0.175 //x2=4.93 //y2=0.175
r213 (  111 159 ) resistor r=5.4201 //w=0.17 //l=0.085 //layer=li \
 //thickness=0.1 //x=12.08 //y=0.8 //x2=12.08 //y2=0.715
r214 (  111 159 ) resistor r=41.4118 //w=0.187 //l=0.605 //layer=li \
 //thickness=0.1 //x=12.08 //y=0.8 //x2=12.08 //y2=1.405
r215 (  110 159 ) resistor r=5.4201 //w=0.17 //l=0.085 //layer=li \
 //thickness=0.1 //x=12.08 //y=0.63 //x2=12.08 //y2=0.715
r216 (  109 149 ) resistor r=5.21862 //w=0.35 //l=0.175 //layer=li \
 //thickness=0.1 //x=12.08 //y=0.35 //x2=12.08 //y2=0.175
r217 (  109 110 ) resistor r=19.1658 //w=0.187 //l=0.28 //layer=li \
 //thickness=0.1 //x=12.08 //y=0.35 //x2=12.08 //y2=0.63
r218 (  108 159 ) resistor r=5.4201 //w=0.17 //l=0.085 //layer=li \
 //thickness=0.1 //x=11.68 //y=0.715 //x2=11.595 //y2=0.715
r219 (  107 159 ) resistor r=1.40859 //w=0.34 //l=0.085 //layer=li \
 //thickness=0.1 //x=11.995 //y=0.715 //x2=12.08 //y2=0.715
r220 (  107 108 ) resistor r=21.5615 //w=0.187 //l=0.315 //layer=li \
 //thickness=0.1 //x=11.995 //y=0.715 //x2=11.68 //y2=0.715
r221 (  106 159 ) resistor r=1.40859 //w=0.34 //l=0.085 //layer=li \
 //thickness=0.1 //x=11.595 //y=0.63 //x2=11.595 //y2=0.715
r222 (  105 146 ) resistor r=5.21862 //w=0.35 //l=0.175 //layer=li \
 //thickness=0.1 //x=11.595 //y=0.35 //x2=11.595 //y2=0.175
r223 (  105 106 ) resistor r=19.1658 //w=0.187 //l=0.28 //layer=li \
 //thickness=0.1 //x=11.595 //y=0.35 //x2=11.595 //y2=0.63
r224 (  104 159 ) resistor r=1.40859 //w=0.34 //l=0.085 //layer=li \
 //thickness=0.1 //x=11.195 //y=0.715 //x2=11.11 //y2=0.715
r225 (  103 159 ) resistor r=5.4201 //w=0.17 //l=0.085 //layer=li \
 //thickness=0.1 //x=11.51 //y=0.715 //x2=11.595 //y2=0.715
r226 (  103 104 ) resistor r=21.5615 //w=0.187 //l=0.315 //layer=li \
 //thickness=0.1 //x=11.51 //y=0.715 //x2=11.195 //y2=0.715
r227 (  99 159 ) resistor r=5.4201 //w=0.17 //l=0.085 //layer=li \
 //thickness=0.1 //x=11.11 //y=0.8 //x2=11.11 //y2=0.715
r228 (  99 159 ) resistor r=41.4118 //w=0.187 //l=0.605 //layer=li \
 //thickness=0.1 //x=11.11 //y=0.8 //x2=11.11 //y2=1.405
r229 (  98 159 ) resistor r=5.4201 //w=0.17 //l=0.085 //layer=li \
 //thickness=0.1 //x=11.11 //y=0.63 //x2=11.11 //y2=0.715
r230 (  97 143 ) resistor r=5.21862 //w=0.35 //l=0.175 //layer=li \
 //thickness=0.1 //x=11.11 //y=0.35 //x2=11.11 //y2=0.175
r231 (  97 98 ) resistor r=19.1658 //w=0.187 //l=0.28 //layer=li \
 //thickness=0.1 //x=11.11 //y=0.35 //x2=11.11 //y2=0.63
r232 (  96 142 ) resistor r=5.29055 //w=0.35 //l=0.17 //layer=li \
 //thickness=0.1 //x=10.65 //y=0.175 //x2=10.48 //y2=0.175
r233 (  95 143 ) resistor r=2.96458 //w=0.367 //l=0.085 //layer=li \
 //thickness=0.1 //x=11.025 //y=0.175 //x2=11.11 //y2=0.175
r234 (  95 96 ) resistor r=13.079 //w=0.367 //l=0.375 //layer=li \
 //thickness=0.1 //x=11.025 //y=0.175 //x2=10.65 //y2=0.175
r235 (  90 92 ) resistor r=38.7139 //w=0.367 //l=1.11 //layer=li \
 //thickness=0.1 //x=8.63 //y=0.175 //x2=9.74 //y2=0.175
r236 (  88 141 ) resistor r=2.87058 //w=0.35 //l=0.085 //layer=li \
 //thickness=0.1 //x=8.415 //y=0.175 //x2=8.33 //y2=0.175
r237 (  88 90 ) resistor r=7.49864 //w=0.367 //l=0.215 //layer=li \
 //thickness=0.1 //x=8.415 //y=0.175 //x2=8.63 //y2=0.175
r238 (  87 142 ) resistor r=5.29055 //w=0.35 //l=0.17 //layer=li \
 //thickness=0.1 //x=10.31 //y=0.175 //x2=10.48 //y2=0.175
r239 (  87 92 ) resistor r=19.8801 //w=0.367 //l=0.57 //layer=li \
 //thickness=0.1 //x=10.31 //y=0.175 //x2=9.74 //y2=0.175
r240 (  83 141 ) resistor r=4.23183 //w=0.7 //l=0.175 //layer=li \
 //thickness=0.1 //x=8.33 //y=0.35 //x2=8.33 //y2=0.175
r241 (  83 158 ) resistor r=53.7326 //w=0.187 //l=0.785 //layer=li \
 //thickness=0.1 //x=8.33 //y=0.35 //x2=8.33 //y2=1.135
r242 (  80 140 ) resistor r=5.29055 //w=0.35 //l=0.17 //layer=li \
 //thickness=0.1 //x=7.32 //y=0.175 //x2=7.15 //y2=0.175
r243 (  80 82 ) resistor r=6.97548 //w=0.367 //l=0.2 //layer=li \
 //thickness=0.1 //x=7.32 //y=0.175 //x2=7.52 //y2=0.175
r244 (  79 141 ) resistor r=2.87058 //w=0.35 //l=0.085 //layer=li \
 //thickness=0.1 //x=8.245 //y=0.175 //x2=8.33 //y2=0.175
r245 (  79 82 ) resistor r=25.2861 //w=0.367 //l=0.725 //layer=li \
 //thickness=0.1 //x=8.245 //y=0.175 //x2=7.52 //y2=0.175
r246 (  76 129 ) resistor r=2.96458 //w=0.367 //l=0.085 //layer=li \
 //thickness=0.1 //x=6.54 //y=0.175 //x2=6.455 //y2=0.175
r247 (  75 140 ) resistor r=5.29055 //w=0.35 //l=0.17 //layer=li \
 //thickness=0.1 //x=6.98 //y=0.175 //x2=7.15 //y2=0.175
r248 (  75 76 ) resistor r=15.346 //w=0.367 //l=0.44 //layer=li \
 //thickness=0.1 //x=6.98 //y=0.175 //x2=6.54 //y2=0.175
r249 (  71 157 ) resistor r=5.4201 //w=0.17 //l=0.085 //layer=li \
 //thickness=0.1 //x=6.455 //y=0.795 //x2=6.455 //y2=0.71
r250 (  71 157 ) resistor r=18.139 //w=0.187 //l=0.265 //layer=li \
 //thickness=0.1 //x=6.455 //y=0.795 //x2=6.455 //y2=1.06
r251 (  70 157 ) resistor r=5.4201 //w=0.17 //l=0.085 //layer=li \
 //thickness=0.1 //x=6.455 //y=0.625 //x2=6.455 //y2=0.71
r252 (  69 129 ) resistor r=5.21862 //w=0.35 //l=0.175 //layer=li \
 //thickness=0.1 //x=6.455 //y=0.35 //x2=6.455 //y2=0.175
r253 (  69 70 ) resistor r=18.8235 //w=0.187 //l=0.275 //layer=li \
 //thickness=0.1 //x=6.455 //y=0.35 //x2=6.455 //y2=0.625
r254 (  68 157 ) resistor r=5.4201 //w=0.17 //l=0.085 //layer=li \
 //thickness=0.1 //x=6.055 //y=0.71 //x2=5.97 //y2=0.71
r255 (  67 157 ) resistor r=1.40859 //w=0.34 //l=0.085 //layer=li \
 //thickness=0.1 //x=6.37 //y=0.71 //x2=6.455 //y2=0.71
r256 (  67 68 ) resistor r=21.5615 //w=0.187 //l=0.315 //layer=li \
 //thickness=0.1 //x=6.37 //y=0.71 //x2=6.055 //y2=0.71
r257 (  66 157 ) resistor r=1.40859 //w=0.34 //l=0.085 //layer=li \
 //thickness=0.1 //x=5.97 //y=0.625 //x2=5.97 //y2=0.71
r258 (  65 126 ) resistor r=5.21862 //w=0.35 //l=0.175 //layer=li \
 //thickness=0.1 //x=5.97 //y=0.35 //x2=5.97 //y2=0.175
r259 (  65 66 ) resistor r=18.8235 //w=0.187 //l=0.275 //layer=li \
 //thickness=0.1 //x=5.97 //y=0.35 //x2=5.97 //y2=0.625
r260 (  64 157 ) resistor r=6.4 //w=0.17 //l=0.085 //layer=li //thickness=0.1 \
 //x=5.57 //y=0.71 //x2=5.485 //y2=0.71
r261 (  63 157 ) resistor r=5.4201 //w=0.17 //l=0.085 //layer=li \
 //thickness=0.1 //x=5.885 //y=0.71 //x2=5.97 //y2=0.71
r262 (  63 64 ) resistor r=21.5615 //w=0.187 //l=0.315 //layer=li \
 //thickness=0.1 //x=5.885 //y=0.71 //x2=5.57 //y2=0.71
r263 (  59 157 ) resistor r=6.4 //w=0.17 //l=0.085 //layer=li //thickness=0.1 \
 //x=5.485 //y=0.795 //x2=5.485 //y2=0.71
r264 (  59 157 ) resistor r=18.139 //w=0.187 //l=0.265 //layer=li \
 //thickness=0.1 //x=5.485 //y=0.795 //x2=5.485 //y2=1.06
r265 (  58 157 ) resistor r=6.4 //w=0.17 //l=0.085 //layer=li //thickness=0.1 \
 //x=5.485 //y=0.625 //x2=5.485 //y2=0.71
r266 (  57 125 ) resistor r=5.21862 //w=0.35 //l=0.175 //layer=li \
 //thickness=0.1 //x=5.485 //y=0.35 //x2=5.485 //y2=0.175
r267 (  57 58 ) resistor r=18.8235 //w=0.187 //l=0.275 //layer=li \
 //thickness=0.1 //x=5.485 //y=0.35 //x2=5.485 //y2=0.625
r268 (  56 157 ) resistor r=5.4201 //w=0.17 //l=0.085 //layer=li \
 //thickness=0.1 //x=5.085 //y=0.71 //x2=5 //y2=0.71
r269 (  55 157 ) resistor r=6.4 //w=0.17 //l=0.085 //layer=li //thickness=0.1 \
 //x=5.4 //y=0.71 //x2=5.485 //y2=0.71
r270 (  55 56 ) resistor r=21.5615 //w=0.187 //l=0.315 //layer=li \
 //thickness=0.1 //x=5.4 //y=0.71 //x2=5.085 //y2=0.71
r271 (  54 157 ) resistor r=1.40859 //w=0.34 //l=0.085 //layer=li \
 //thickness=0.1 //x=5 //y=0.625 //x2=5 //y2=0.71
r272 (  53 124 ) resistor r=5.21862 //w=0.35 //l=0.175 //layer=li \
 //thickness=0.1 //x=5 //y=0.35 //x2=5 //y2=0.175
r273 (  53 54 ) resistor r=18.8235 //w=0.187 //l=0.275 //layer=li \
 //thickness=0.1 //x=5 //y=0.35 //x2=5 //y2=0.625
r274 (  52 157 ) resistor r=1.40859 //w=0.34 //l=0.085 //layer=li \
 //thickness=0.1 //x=4.6 //y=0.71 //x2=4.515 //y2=0.71
r275 (  51 157 ) resistor r=5.4201 //w=0.17 //l=0.085 //layer=li \
 //thickness=0.1 //x=4.915 //y=0.71 //x2=5 //y2=0.71
r276 (  51 52 ) resistor r=21.5615 //w=0.187 //l=0.315 //layer=li \
 //thickness=0.1 //x=4.915 //y=0.71 //x2=4.6 //y2=0.71
r277 (  47 157 ) resistor r=5.4201 //w=0.17 //l=0.085 //layer=li \
 //thickness=0.1 //x=4.515 //y=0.795 //x2=4.515 //y2=0.71
r278 (  47 157 ) resistor r=41.4118 //w=0.187 //l=0.605 //layer=li \
 //thickness=0.1 //x=4.515 //y=0.795 //x2=4.515 //y2=1.4
r279 (  46 157 ) resistor r=5.4201 //w=0.17 //l=0.085 //layer=li \
 //thickness=0.1 //x=4.515 //y=0.625 //x2=4.515 //y2=0.71
r280 (  45 121 ) resistor r=5.21862 //w=0.35 //l=0.175 //layer=li \
 //thickness=0.1 //x=4.515 //y=0.35 //x2=4.515 //y2=0.175
r281 (  45 46 ) resistor r=18.8235 //w=0.187 //l=0.275 //layer=li \
 //thickness=0.1 //x=4.515 //y=0.35 //x2=4.515 //y2=0.625
r282 (  44 120 ) resistor r=5.29055 //w=0.35 //l=0.17 //layer=li \
 //thickness=0.1 //x=3.99 //y=0.175 //x2=3.82 //y2=0.175
r283 (  43 121 ) resistor r=2.96458 //w=0.367 //l=0.085 //layer=li \
 //thickness=0.1 //x=4.43 //y=0.175 //x2=4.515 //y2=0.175
r284 (  43 44 ) resistor r=15.346 //w=0.367 //l=0.44 //layer=li \
 //thickness=0.1 //x=4.43 //y=0.175 //x2=3.99 //y2=0.175
r285 (  38 40 ) resistor r=38.7139 //w=0.367 //l=1.11 //layer=li \
 //thickness=0.1 //x=2.34 //y=0.175 //x2=3.45 //y2=0.175
r286 (  36 119 ) resistor r=2.87058 //w=0.35 //l=0.085 //layer=li \
 //thickness=0.1 //x=1.755 //y=0.175 //x2=1.67 //y2=0.175
r287 (  36 38 ) resistor r=20.4033 //w=0.367 //l=0.585 //layer=li \
 //thickness=0.1 //x=1.755 //y=0.175 //x2=2.34 //y2=0.175
r288 (  35 120 ) resistor r=5.29055 //w=0.35 //l=0.17 //layer=li \
 //thickness=0.1 //x=3.65 //y=0.175 //x2=3.82 //y2=0.175
r289 (  35 40 ) resistor r=6.97548 //w=0.367 //l=0.2 //layer=li \
 //thickness=0.1 //x=3.65 //y=0.175 //x2=3.45 //y2=0.175
r290 (  31 119 ) resistor r=4.23183 //w=0.7 //l=0.175 //layer=li \
 //thickness=0.1 //x=1.67 //y=0.35 //x2=1.67 //y2=0.175
r291 (  31 156 ) resistor r=53.7326 //w=0.187 //l=0.785 //layer=li \
 //thickness=0.1 //x=1.67 //y=0.35 //x2=1.67 //y2=1.135
r292 (  27 119 ) resistor r=2.87058 //w=0.35 //l=0.085 //layer=li \
 //thickness=0.1 //x=1.585 //y=0.175 //x2=1.67 //y2=0.175
r293 (  27 30 ) resistor r=12.3815 //w=0.367 //l=0.355 //layer=li \
 //thickness=0.1 //x=1.585 //y=0.175 //x2=1.23 //y2=0.175
r294 (  23 148 ) resistor r=4.65 //w=0.17 //l=0.34 //layer=mcon //count=2 \
 //x=11.96 //y=0.18 //x2=11.96 //y2=0.18
r295 (  21 145 ) resistor r=3.1 //w=0.17 //l=0.51 //layer=mcon //count=3 \
 //x=11.22 //y=0.18 //x2=11.22 //y2=0.18
r296 (  21 23 ) resistor r=0.297428 //w=0.311 //l=0.74 //layer=m1 \
 //thickness=0.36 //x=11.22 //y=0.175 //x2=11.96 //y2=0.175
r297 (  19 92 ) resistor r=3.1 //w=0.17 //l=0.51 //layer=mcon //count=3 \
 //x=9.74 //y=0.18 //x2=9.74 //y2=0.18
r298 (  19 21 ) resistor r=0.594855 //w=0.311 //l=1.48 //layer=m1 \
 //thickness=0.36 //x=9.74 //y=0.175 //x2=11.22 //y2=0.175
r299 (  17 90 ) resistor r=3.1 //w=0.17 //l=0.51 //layer=mcon //count=3 \
 //x=8.63 //y=0.18 //x2=8.63 //y2=0.18
r300 (  17 19 ) resistor r=0.446141 //w=0.311 //l=1.11 //layer=m1 \
 //thickness=0.36 //x=8.63 //y=0.175 //x2=9.74 //y2=0.175
r301 (  15 82 ) resistor r=3.1 //w=0.17 //l=0.51 //layer=mcon //count=3 \
 //x=7.52 //y=0.18 //x2=7.52 //y2=0.18
r302 (  15 17 ) resistor r=0.446141 //w=0.311 //l=1.11 //layer=m1 \
 //thickness=0.36 //x=7.52 //y=0.175 //x2=8.63 //y2=0.175
r303 (  12 128 ) resistor r=3.1 //w=0.17 //l=0.51 //layer=mcon //count=3 \
 //x=6.04 //y=0.18 //x2=6.04 //y2=0.18
r304 (  10 123 ) resistor r=3.1 //w=0.17 //l=0.51 //layer=mcon //count=3 \
 //x=4.93 //y=0.18 //x2=4.93 //y2=0.18
r305 (  10 12 ) resistor r=0.446141 //w=0.311 //l=1.11 //layer=m1 \
 //thickness=0.36 //x=4.93 //y=0.175 //x2=6.04 //y2=0.175
r306 (  8 40 ) resistor r=3.1 //w=0.17 //l=0.51 //layer=mcon //count=3 \
 //x=3.45 //y=0.18 //x2=3.45 //y2=0.18
r307 (  8 10 ) resistor r=0.594855 //w=0.311 //l=1.48 //layer=m1 \
 //thickness=0.36 //x=3.45 //y=0.175 //x2=4.93 //y2=0.175
r308 (  6 38 ) resistor r=3.1 //w=0.17 //l=0.51 //layer=mcon //count=3 \
 //x=2.34 //y=0.18 //x2=2.34 //y2=0.18
r309 (  6 8 ) resistor r=0.446141 //w=0.311 //l=1.11 //layer=m1 \
 //thickness=0.36 //x=2.34 //y=0.175 //x2=3.45 //y2=0.175
r310 (  3 30 ) resistor r=3.1 //w=0.17 //l=0.51 //layer=mcon //count=3 \
 //x=1.23 //y=0.18 //x2=1.23 //y2=0.18
r311 (  3 6 ) resistor r=0.446141 //w=0.311 //l=1.11 //layer=m1 \
 //thickness=0.36 //x=1.23 //y=0.175 //x2=2.34 //y2=0.175
r312 (  1 15 ) resistor r=0.371785 //w=0.311 //l=0.925 //layer=m1 \
 //thickness=0.36 //x=6.595 //y=0.175 //x2=7.52 //y2=0.175
r313 (  1 12 ) resistor r=0.223071 //w=0.311 //l=0.555 //layer=m1 \
 //thickness=0.36 //x=6.595 //y=0.175 //x2=6.04 //y2=0.175
ends PM_AOA4X1\%GND

subckt PM_AOA4X1\%VDD ( 1 23 35 43 59 69 85 95 115 128 131 133 138 142 143 144 \
 145 146 147 148 149 150 151 )
c141 ( 151 0 ) capacitor c=0.0451938f //x=11.89 //y=5.2
c142 ( 150 0 ) capacitor c=0.0429272f //x=11.02 //y=5.2
c143 ( 149 0 ) capacitor c=0.0383754f //x=9.555 //y=5.2
c144 ( 148 0 ) capacitor c=0.0243053f //x=8.675 //y=5.2
c145 ( 147 0 ) capacitor c=0.0531988f //x=7.805 //y=5.2
c146 ( 146 0 ) capacitor c=0.0256797f //x=4.905 //y=5.205
c147 ( 145 0 ) capacitor c=0.0383754f //x=2.895 //y=5.2
c148 ( 144 0 ) capacitor c=0.0243053f //x=2.015 //y=5.2
c149 ( 143 0 ) capacitor c=0.0531988f //x=1.145 //y=5.2
c150 ( 142 0 ) capacitor c=0.253667f //x=11.96 //y=7.58
c151 ( 140 0 ) capacitor c=0.00597439f //x=11.22 //y=7.58
c152 ( 138 0 ) capacitor c=0.111767f //x=10.48 //y=7.585
c153 ( 137 0 ) capacitor c=0.00597439f //x=9.74 //y=7.58
c154 ( 135 0 ) capacitor c=0.00597439f //x=8.82 //y=7.585
c155 ( 134 0 ) capacitor c=0.00597439f //x=7.94 //y=7.585
c156 ( 133 0 ) capacitor c=0.11941f //x=7.15 //y=7.585
c157 ( 132 0 ) capacitor c=0.00597439f //x=5.05 //y=7.585
c158 ( 131 0 ) capacitor c=0.11613f //x=3.82 //y=7.585
c159 ( 130 0 ) capacitor c=0.00597439f //x=3.04 //y=7.585
c160 ( 129 0 ) capacitor c=0.00597439f //x=2.16 //y=7.585
c161 ( 128 0 ) capacitor c=0.266825f //x=1.23 //y=7.58
c162 ( 115 0 ) capacitor c=0.029016f //x=11.95 //y=7.585
c163 ( 107 0 ) capacitor c=0.0217664f //x=11.07 //y=7.585
c164 ( 103 0 ) capacitor c=0.0277785f //x=10.31 //y=7.585
c165 ( 95 0 ) capacitor c=0.0287734f //x=9.615 //y=7.585
c166 ( 85 0 ) capacitor c=0.0289072f //x=8.735 //y=7.585
c167 ( 75 0 ) capacitor c=0.0283511f //x=7.855 //y=7.585
c168 ( 69 0 ) capacitor c=0.0785214f //x=6.98 //y=7.585
c169 ( 59 0 ) capacitor c=0.046953f //x=4.965 //y=7.585
c170 ( 53 0 ) capacitor c=0.0277785f //x=3.65 //y=7.585
c171 ( 43 0 ) capacitor c=0.0287734f //x=2.955 //y=7.585
c172 ( 35 0 ) capacitor c=0.0289072f //x=2.075 //y=7.585
c173 ( 23 0 ) capacitor c=0.511775f //x=11.96 //y=7.58
r174 (  117 142 ) resistor r=4.23183 //w=0.7 //l=0.175 //layer=li \
 //thickness=0.1 //x=12.035 //y=7.41 //x2=12.035 //y2=7.585
r175 (  117 151 ) resistor r=56.4706 //w=0.187 //l=0.825 //layer=li \
 //thickness=0.1 //x=12.035 //y=7.41 //x2=12.035 //y2=6.585
r176 (  116 140 ) resistor r=2.87058 //w=0.35 //l=0.085 //layer=li \
 //thickness=0.1 //x=11.24 //y=7.585 //x2=11.155 //y2=7.585
r177 (  115 142 ) resistor r=2.87058 //w=0.35 //l=0.085 //layer=li \
 //thickness=0.1 //x=11.95 //y=7.585 //x2=12.035 //y2=7.585
r178 (  115 116 ) resistor r=24.7629 //w=0.367 //l=0.71 //layer=li \
 //thickness=0.1 //x=11.95 //y=7.585 //x2=11.24 //y2=7.585
r179 (  109 140 ) resistor r=4.23183 //w=0.7 //l=0.175 //layer=li \
 //thickness=0.1 //x=11.155 //y=7.41 //x2=11.155 //y2=7.585
r180 (  109 150 ) resistor r=56.4706 //w=0.187 //l=0.825 //layer=li \
 //thickness=0.1 //x=11.155 //y=7.41 //x2=11.155 //y2=6.585
r181 (  108 138 ) resistor r=5.29055 //w=0.35 //l=0.17 //layer=li \
 //thickness=0.1 //x=10.65 //y=7.585 //x2=10.48 //y2=7.585
r182 (  107 140 ) resistor r=2.87058 //w=0.35 //l=0.085 //layer=li \
 //thickness=0.1 //x=11.07 //y=7.585 //x2=11.155 //y2=7.585
r183 (  107 108 ) resistor r=14.6485 //w=0.367 //l=0.42 //layer=li \
 //thickness=0.1 //x=11.07 //y=7.585 //x2=10.65 //y2=7.585
r184 (  104 137 ) resistor r=2.87058 //w=0.35 //l=0.085 //layer=li \
 //thickness=0.1 //x=9.785 //y=7.585 //x2=9.7 //y2=7.585
r185 (  103 138 ) resistor r=5.29055 //w=0.35 //l=0.17 //layer=li \
 //thickness=0.1 //x=10.31 //y=7.585 //x2=10.48 //y2=7.585
r186 (  103 104 ) resistor r=18.3106 //w=0.367 //l=0.525 //layer=li \
 //thickness=0.1 //x=10.31 //y=7.585 //x2=9.785 //y2=7.585
r187 (  97 137 ) resistor r=4.23183 //w=0.7 //l=0.175 //layer=li \
 //thickness=0.1 //x=9.7 //y=7.41 //x2=9.7 //y2=7.585
r188 (  97 149 ) resistor r=33.1979 //w=0.187 //l=0.485 //layer=li \
 //thickness=0.1 //x=9.7 //y=7.41 //x2=9.7 //y2=6.925
r189 (  96 135 ) resistor r=2.87058 //w=0.35 //l=0.085 //layer=li \
 //thickness=0.1 //x=8.905 //y=7.585 //x2=8.82 //y2=7.585
r190 (  95 137 ) resistor r=2.87058 //w=0.35 //l=0.085 //layer=li \
 //thickness=0.1 //x=9.615 //y=7.585 //x2=9.7 //y2=7.585
r191 (  95 96 ) resistor r=24.7629 //w=0.367 //l=0.71 //layer=li \
 //thickness=0.1 //x=9.615 //y=7.585 //x2=8.905 //y2=7.585
r192 (  89 135 ) resistor r=4.23183 //w=0.7 //l=0.175 //layer=li \
 //thickness=0.1 //x=8.82 //y=7.41 //x2=8.82 //y2=7.585
r193 (  89 148 ) resistor r=33.1979 //w=0.187 //l=0.485 //layer=li \
 //thickness=0.1 //x=8.82 //y=7.41 //x2=8.82 //y2=6.925
r194 (  86 134 ) resistor r=2.87058 //w=0.35 //l=0.085 //layer=li \
 //thickness=0.1 //x=8.025 //y=7.585 //x2=7.94 //y2=7.585
r195 (  86 88 ) resistor r=21.1008 //w=0.367 //l=0.605 //layer=li \
 //thickness=0.1 //x=8.025 //y=7.585 //x2=8.63 //y2=7.585
r196 (  85 135 ) resistor r=2.87058 //w=0.35 //l=0.085 //layer=li \
 //thickness=0.1 //x=8.735 //y=7.585 //x2=8.82 //y2=7.585
r197 (  85 88 ) resistor r=3.66213 //w=0.367 //l=0.105 //layer=li \
 //thickness=0.1 //x=8.735 //y=7.585 //x2=8.63 //y2=7.585
r198 (  79 134 ) resistor r=4.23183 //w=0.7 //l=0.175 //layer=li \
 //thickness=0.1 //x=7.94 //y=7.41 //x2=7.94 //y2=7.585
r199 (  79 147 ) resistor r=56.4706 //w=0.187 //l=0.825 //layer=li \
 //thickness=0.1 //x=7.94 //y=7.41 //x2=7.94 //y2=6.585
r200 (  76 133 ) resistor r=5.29055 //w=0.35 //l=0.17 //layer=li \
 //thickness=0.1 //x=7.32 //y=7.585 //x2=7.15 //y2=7.585
r201 (  76 78 ) resistor r=6.97548 //w=0.367 //l=0.2 //layer=li \
 //thickness=0.1 //x=7.32 //y=7.585 //x2=7.52 //y2=7.585
r202 (  75 134 ) resistor r=2.87058 //w=0.35 //l=0.085 //layer=li \
 //thickness=0.1 //x=7.855 //y=7.585 //x2=7.94 //y2=7.585
r203 (  75 78 ) resistor r=11.6839 //w=0.367 //l=0.335 //layer=li \
 //thickness=0.1 //x=7.855 //y=7.585 //x2=7.52 //y2=7.585
r204 (  70 132 ) resistor r=2.87058 //w=0.35 //l=0.085 //layer=li \
 //thickness=0.1 //x=5.135 //y=7.585 //x2=5.05 //y2=7.585
r205 (  70 72 ) resistor r=31.564 //w=0.367 //l=0.905 //layer=li \
 //thickness=0.1 //x=5.135 //y=7.585 //x2=6.04 //y2=7.585
r206 (  69 133 ) resistor r=5.29055 //w=0.35 //l=0.17 //layer=li \
 //thickness=0.1 //x=6.98 //y=7.585 //x2=7.15 //y2=7.585
r207 (  69 72 ) resistor r=32.7847 //w=0.367 //l=0.94 //layer=li \
 //thickness=0.1 //x=6.98 //y=7.585 //x2=6.04 //y2=7.585
r208 (  63 132 ) resistor r=4.23183 //w=0.7 //l=0.175 //layer=li \
 //thickness=0.1 //x=5.05 //y=7.41 //x2=5.05 //y2=7.585
r209 (  63 146 ) resistor r=33.5401 //w=0.187 //l=0.49 //layer=li \
 //thickness=0.1 //x=5.05 //y=7.41 //x2=5.05 //y2=6.92
r210 (  60 131 ) resistor r=5.29055 //w=0.35 //l=0.17 //layer=li \
 //thickness=0.1 //x=3.99 //y=7.585 //x2=3.82 //y2=7.585
r211 (  60 62 ) resistor r=32.7847 //w=0.367 //l=0.94 //layer=li \
 //thickness=0.1 //x=3.99 //y=7.585 //x2=4.93 //y2=7.585
r212 (  59 132 ) resistor r=2.87058 //w=0.35 //l=0.085 //layer=li \
 //thickness=0.1 //x=4.965 //y=7.585 //x2=5.05 //y2=7.585
r213 (  59 62 ) resistor r=1.22071 //w=0.367 //l=0.035 //layer=li \
 //thickness=0.1 //x=4.965 //y=7.585 //x2=4.93 //y2=7.585
r214 (  54 130 ) resistor r=2.87058 //w=0.35 //l=0.085 //layer=li \
 //thickness=0.1 //x=3.125 //y=7.585 //x2=3.04 //y2=7.585
r215 (  54 56 ) resistor r=11.3351 //w=0.367 //l=0.325 //layer=li \
 //thickness=0.1 //x=3.125 //y=7.585 //x2=3.45 //y2=7.585
r216 (  53 131 ) resistor r=5.29055 //w=0.35 //l=0.17 //layer=li \
 //thickness=0.1 //x=3.65 //y=7.585 //x2=3.82 //y2=7.585
r217 (  53 56 ) resistor r=6.97548 //w=0.367 //l=0.2 //layer=li \
 //thickness=0.1 //x=3.65 //y=7.585 //x2=3.45 //y2=7.585
r218 (  47 130 ) resistor r=4.23183 //w=0.7 //l=0.175 //layer=li \
 //thickness=0.1 //x=3.04 //y=7.41 //x2=3.04 //y2=7.585
r219 (  47 145 ) resistor r=33.1979 //w=0.187 //l=0.485 //layer=li \
 //thickness=0.1 //x=3.04 //y=7.41 //x2=3.04 //y2=6.925
r220 (  44 129 ) resistor r=2.87058 //w=0.35 //l=0.085 //layer=li \
 //thickness=0.1 //x=2.245 //y=7.585 //x2=2.16 //y2=7.585
r221 (  44 46 ) resistor r=3.31335 //w=0.367 //l=0.095 //layer=li \
 //thickness=0.1 //x=2.245 //y=7.585 //x2=2.34 //y2=7.585
r222 (  43 130 ) resistor r=2.87058 //w=0.35 //l=0.085 //layer=li \
 //thickness=0.1 //x=2.955 //y=7.585 //x2=3.04 //y2=7.585
r223 (  43 46 ) resistor r=21.4496 //w=0.367 //l=0.615 //layer=li \
 //thickness=0.1 //x=2.955 //y=7.585 //x2=2.34 //y2=7.585
r224 (  37 129 ) resistor r=4.23183 //w=0.7 //l=0.175 //layer=li \
 //thickness=0.1 //x=2.16 //y=7.41 //x2=2.16 //y2=7.585
r225 (  37 144 ) resistor r=33.1979 //w=0.187 //l=0.485 //layer=li \
 //thickness=0.1 //x=2.16 //y=7.41 //x2=2.16 //y2=6.925
r226 (  36 128 ) resistor r=2.87058 //w=0.35 //l=0.085 //layer=li \
 //thickness=0.1 //x=1.365 //y=7.585 //x2=1.28 //y2=7.585
r227 (  35 129 ) resistor r=2.87058 //w=0.35 //l=0.085 //layer=li \
 //thickness=0.1 //x=2.075 //y=7.585 //x2=2.16 //y2=7.585
r228 (  35 36 ) resistor r=24.7629 //w=0.367 //l=0.71 //layer=li \
 //thickness=0.1 //x=2.075 //y=7.585 //x2=1.365 //y2=7.585
r229 (  29 128 ) resistor r=4.23183 //w=0.7 //l=0.175 //layer=li \
 //thickness=0.1 //x=1.28 //y=7.41 //x2=1.28 //y2=7.585
r230 (  29 143 ) resistor r=56.4706 //w=0.187 //l=0.825 //layer=li \
 //thickness=0.1 //x=1.28 //y=7.41 //x2=1.28 //y2=6.585
r231 (  23 142 ) resistor r=4.65 //w=0.17 //l=0.34 //layer=mcon //count=2 \
 //x=11.96 //y=7.58 //x2=11.96 //y2=7.58
r232 (  21 140 ) resistor r=3.1 //w=0.17 //l=0.51 //layer=mcon //count=3 \
 //x=11.22 //y=7.58 //x2=11.22 //y2=7.58
r233 (  21 23 ) resistor r=0.297428 //w=0.311 //l=0.74 //layer=m1 \
 //thickness=0.36 //x=11.22 //y=7.585 //x2=11.96 //y2=7.585
r234 (  19 137 ) resistor r=3.1 //w=0.17 //l=0.51 //layer=mcon //count=3 \
 //x=9.74 //y=7.58 //x2=9.74 //y2=7.58
r235 (  19 21 ) resistor r=0.594855 //w=0.311 //l=1.48 //layer=m1 \
 //thickness=0.36 //x=9.74 //y=7.585 //x2=11.22 //y2=7.585
r236 (  17 88 ) resistor r=3.1 //w=0.17 //l=0.51 //layer=mcon //count=3 \
 //x=8.63 //y=7.58 //x2=8.63 //y2=7.58
r237 (  17 19 ) resistor r=0.446141 //w=0.311 //l=1.11 //layer=m1 \
 //thickness=0.36 //x=8.63 //y=7.585 //x2=9.74 //y2=7.585
r238 (  15 78 ) resistor r=3.1 //w=0.17 //l=0.51 //layer=mcon //count=3 \
 //x=7.52 //y=7.58 //x2=7.52 //y2=7.58
r239 (  15 17 ) resistor r=0.446141 //w=0.311 //l=1.11 //layer=m1 \
 //thickness=0.36 //x=7.52 //y=7.585 //x2=8.63 //y2=7.585
r240 (  12 72 ) resistor r=3.1 //w=0.17 //l=0.51 //layer=mcon //count=3 \
 //x=6.04 //y=7.58 //x2=6.04 //y2=7.58
r241 (  10 62 ) resistor r=3.1 //w=0.17 //l=0.51 //layer=mcon //count=3 \
 //x=4.93 //y=7.58 //x2=4.93 //y2=7.58
r242 (  10 12 ) resistor r=0.446141 //w=0.311 //l=1.11 //layer=m1 \
 //thickness=0.36 //x=4.93 //y=7.585 //x2=6.04 //y2=7.585
r243 (  8 56 ) resistor r=3.1 //w=0.17 //l=0.51 //layer=mcon //count=3 \
 //x=3.45 //y=7.58 //x2=3.45 //y2=7.58
r244 (  8 10 ) resistor r=0.594855 //w=0.311 //l=1.48 //layer=m1 \
 //thickness=0.36 //x=3.45 //y=7.585 //x2=4.93 //y2=7.585
r245 (  6 46 ) resistor r=3.1 //w=0.17 //l=0.51 //layer=mcon //count=3 \
 //x=2.34 //y=7.58 //x2=2.34 //y2=7.58
r246 (  6 8 ) resistor r=0.446141 //w=0.311 //l=1.11 //layer=m1 \
 //thickness=0.36 //x=2.34 //y=7.585 //x2=3.45 //y2=7.585
r247 (  3 128 ) resistor r=3.1 //w=0.17 //l=0.51 //layer=mcon //count=3 \
 //x=1.23 //y=7.58 //x2=1.23 //y2=7.58
r248 (  3 6 ) resistor r=0.446141 //w=0.311 //l=1.11 //layer=m1 \
 //thickness=0.36 //x=1.23 //y=7.585 //x2=2.34 //y2=7.585
r249 (  1 15 ) resistor r=0.371785 //w=0.311 //l=0.925 //layer=m1 \
 //thickness=0.36 //x=6.595 //y=7.585 //x2=7.52 //y2=7.585
r250 (  1 12 ) resistor r=0.223071 //w=0.311 //l=0.555 //layer=m1 \
 //thickness=0.36 //x=6.595 //y=7.585 //x2=6.04 //y2=7.585
ends PM_AOA4X1\%VDD

subckt PM_AOA4X1\%noxref_3 ( 1 2 13 14 25 27 28 32 35 39 41 43 44 45 46 47 48 \
 49 53 55 58 60 61 66 76 78 79 )
c144 ( 79 0 ) capacitor c=0.0220291f //x=2.455 //y=5.2
c145 ( 78 0 ) capacitor c=0.0217503f //x=1.575 //y=5.2
c146 ( 76 0 ) capacitor c=0.00865153f //x=2.45 //y=1.085
c147 ( 66 0 ) capacitor c=0.04214f //x=4.775 //y=4.885
c148 ( 61 0 ) capacitor c=0.0321911f //x=5.265 //y=1.43
c149 ( 60 0 ) capacitor c=0.0185201f //x=5.265 //y=1.085
c150 ( 58 0 ) capacitor c=0.0344254f //x=5.195 //y=4.975
c151 ( 55 0 ) capacitor c=0.0133656f //x=5.11 //y=1.585
c152 ( 53 0 ) capacitor c=0.0157804f //x=5.11 //y=0.93
c153 ( 49 0 ) capacitor c=0.0785055f //x=4.735 //y=2.095
c154 ( 48 0 ) capacitor c=0.022867f //x=4.735 //y=1.74
c155 ( 47 0 ) capacitor c=0.0234318f //x=4.735 //y=1.43
c156 ( 46 0 ) capacitor c=0.0192004f //x=4.735 //y=1.085
c157 ( 45 0 ) capacitor c=0.110795f //x=5.27 //y=6.205
c158 ( 44 0 ) capacitor c=0.153847f //x=4.83 //y=6.205
c159 ( 41 0 ) capacitor c=0.00995068f //x=4.775 //y=4.885
c160 ( 39 0 ) capacitor c=0.00427536f //x=2.6 //y=5.38
c161 ( 35 0 ) capacitor c=0.0968481f //x=4.93 //y=2.26
c162 ( 32 0 ) capacitor c=0.117241f //x=3.08 //y=2.77
c163 ( 28 0 ) capacitor c=0.00781917f //x=2.725 //y=1.835
c164 ( 27 0 ) capacitor c=0.0159132f //x=2.995 //y=1.835
c165 ( 25 0 ) capacitor c=0.017841f //x=2.995 //y=5.38
c166 ( 14 0 ) capacitor c=0.00387264f //x=1.805 //y=5.38
c167 ( 13 0 ) capacitor c=0.0222171f //x=2.515 //y=5.38
c168 ( 2 0 ) capacitor c=0.0173935f //x=3.195 //y=2.77
c169 ( 1 0 ) capacitor c=0.111807f //x=4.815 //y=2.77
r170 (  68 69 ) resistor r=32.4568 //w=0.214 //l=0.075 //layer=ply \
 //thickness=0.18 //x=4.775 //y=4.975 //x2=4.775 //y2=5.05
r171 (  66 68 ) resistor r=20.271 //w=0.214 //l=0.09 //layer=ply \
 //thickness=0.18 //x=4.775 //y=4.885 //x2=4.775 //y2=4.975
r172 (  61 75 ) resistor r=45.1352 //w=0.168 //l=0.173853 //layer=ply \
 //thickness=0.18 //x=5.265 //y=1.43 //x2=5.225 //y2=1.585
r173 (  60 74 ) resistor r=45.1352 //w=0.168 //l=0.173853 //layer=ply \
 //thickness=0.18 //x=5.265 //y=1.085 //x2=5.225 //y2=0.93
r174 (  60 61 ) resistor r=176.904 //w=0.094 //l=0.345 //layer=ply \
 //thickness=0.18 //x=5.265 //y=1.085 //x2=5.265 //y2=1.43
r175 (  59 68 ) resistor r=16.5046 //w=0.27 //l=0.135 //layer=ply \
 //thickness=0.18 //x=4.91 //y=4.975 //x2=4.775 //y2=4.975
r176 (  58 62 ) resistor r=26.9307 //w=0.15 //l=0.106066 //layer=ply \
 //thickness=0.18 //x=5.195 //y=4.975 //x2=5.27 //y2=5.05
r177 (  58 59 ) resistor r=146.138 //w=0.094 //l=0.285 //layer=ply \
 //thickness=0.18 //x=5.195 //y=4.975 //x2=4.91 //y2=4.975
r178 (  56 73 ) resistor r=10.701 //w=0.21 //l=0.115 //layer=ply \
 //thickness=0.18 //x=4.89 //y=1.585 //x2=4.775 //y2=1.585
r179 (  55 75 ) resistor r=5.52526 //w=0.168 //l=0.115 //layer=ply \
 //thickness=0.18 //x=5.11 //y=1.585 //x2=5.225 //y2=1.585
r180 (  54 72 ) resistor r=5.52526 //w=0.168 //l=0.115 //layer=ply \
 //thickness=0.18 //x=4.89 //y=0.93 //x2=4.775 //y2=0.93
r181 (  53 74 ) resistor r=5.52526 //w=0.168 //l=0.115 //layer=ply \
 //thickness=0.18 //x=5.11 //y=0.93 //x2=5.225 //y2=0.93
r182 (  53 54 ) resistor r=112.809 //w=0.094 //l=0.22 //layer=ply \
 //thickness=0.18 //x=5.11 //y=0.93 //x2=4.89 //y2=0.93
r183 (  49 71 ) resistor r=34.8111 //w=0.27 //l=0.264953 //layer=ply \
 //thickness=0.18 //x=4.735 //y=2.095 //x2=4.93 //y2=2.26
r184 (  48 73 ) resistor r=39.5823 //w=0.21 //l=0.173853 //layer=ply \
 //thickness=0.18 //x=4.735 //y=1.74 //x2=4.775 //y2=1.585
r185 (  48 49 ) resistor r=182.032 //w=0.094 //l=0.355 //layer=ply \
 //thickness=0.18 //x=4.735 //y=1.74 //x2=4.735 //y2=2.095
r186 (  47 73 ) resistor r=39.5823 //w=0.21 //l=0.173853 //layer=ply \
 //thickness=0.18 //x=4.735 //y=1.43 //x2=4.775 //y2=1.585
r187 (  46 72 ) resistor r=45.1352 //w=0.168 //l=0.173853 //layer=ply \
 //thickness=0.18 //x=4.735 //y=1.085 //x2=4.775 //y2=0.93
r188 (  46 47 ) resistor r=176.904 //w=0.094 //l=0.345 //layer=ply \
 //thickness=0.18 //x=4.735 //y=1.085 //x2=4.735 //y2=1.43
r189 (  45 62 ) resistor r=592.245 //w=0.094 //l=1.155 //layer=ply \
 //thickness=0.18 //x=5.27 //y=6.205 //x2=5.27 //y2=5.05
r190 (  44 69 ) resistor r=592.245 //w=0.094 //l=1.155 //layer=ply \
 //thickness=0.18 //x=4.83 //y=6.205 //x2=4.83 //y2=5.05
r191 (  43 55 ) resistor r=56.4043 //w=0.094 //l=0.11 //layer=ply \
 //thickness=0.18 //x=5 //y=1.585 //x2=5.11 //y2=1.585
r192 (  43 56 ) resistor r=56.4043 //w=0.094 //l=0.11 //layer=ply \
 //thickness=0.18 //x=5 //y=1.585 //x2=4.89 //y2=1.585
r193 (  41 66 ) resistor r=152 //w=0.17 //l=0.17 //layer=licon //count=1 \
 //x=4.775 //y=4.885 //x2=4.775 //y2=4.885
r194 (  41 42 ) resistor r=7.81102 //w=0.254 //l=0.155 //layer=li \
 //thickness=0.1 //x=4.775 //y=4.885 //x2=4.93 //y2=4.885
r195 (  35 71 ) resistor r=152 //w=0.17 //l=0.17 //layer=licon //count=1 \
 //x=4.93 //y=2.26 //x2=4.93 //y2=2.26
r196 (  35 38 ) resistor r=34.9091 //w=0.187 //l=0.51 //layer=li \
 //thickness=0.1 //x=4.93 //y=2.26 //x2=4.93 //y2=2.77
r197 (  33 42 ) resistor r=3.23951 //w=0.254 //l=0.165 //layer=li \
 //thickness=0.1 //x=4.93 //y=4.72 //x2=4.93 //y2=4.885
r198 (  33 38 ) resistor r=133.476 //w=0.187 //l=1.95 //layer=li \
 //thickness=0.1 //x=4.93 //y=4.72 //x2=4.93 //y2=2.77
r199 (  30 32 ) resistor r=172.834 //w=0.187 //l=2.525 //layer=li \
 //thickness=0.1 //x=3.08 //y=5.295 //x2=3.08 //y2=2.77
r200 (  29 32 ) resistor r=58.1818 //w=0.187 //l=0.85 //layer=li \
 //thickness=0.1 //x=3.08 //y=1.92 //x2=3.08 //y2=2.77
r201 (  27 29 ) resistor r=7.15173 //w=0.17 //l=0.120208 //layer=li \
 //thickness=0.1 //x=2.995 //y=1.835 //x2=3.08 //y2=1.92
r202 (  27 28 ) resistor r=18.4813 //w=0.187 //l=0.27 //layer=li \
 //thickness=0.1 //x=2.995 //y=1.835 //x2=2.725 //y2=1.835
r203 (  26 39 ) resistor r=5.4201 //w=0.17 //l=0.085 //layer=li \
 //thickness=0.1 //x=2.685 //y=5.38 //x2=2.6 //y2=5.38
r204 (  25 30 ) resistor r=7.15173 //w=0.17 //l=0.120208 //layer=li \
 //thickness=0.1 //x=2.995 //y=5.38 //x2=3.08 //y2=5.295
r205 (  25 26 ) resistor r=21.2193 //w=0.187 //l=0.31 //layer=li \
 //thickness=0.1 //x=2.995 //y=5.38 //x2=2.685 //y2=5.38
r206 (  21 28 ) resistor r=7.15173 //w=0.17 //l=0.120208 //layer=li \
 //thickness=0.1 //x=2.64 //y=1.75 //x2=2.725 //y2=1.835
r207 (  21 76 ) resistor r=39.016 //w=0.187 //l=0.57 //layer=li \
 //thickness=0.1 //x=2.64 //y=1.75 //x2=2.64 //y2=1.18
r208 (  15 39 ) resistor r=1.40859 //w=0.34 //l=0.085 //layer=li \
 //thickness=0.1 //x=2.6 //y=5.465 //x2=2.6 //y2=5.38
r209 (  15 79 ) resistor r=30.1176 //w=0.187 //l=0.44 //layer=li \
 //thickness=0.1 //x=2.6 //y=5.465 //x2=2.6 //y2=5.905
r210 (  13 39 ) resistor r=5.4201 //w=0.17 //l=0.085 //layer=li \
 //thickness=0.1 //x=2.515 //y=5.38 //x2=2.6 //y2=5.38
r211 (  13 14 ) resistor r=48.5989 //w=0.187 //l=0.71 //layer=li \
 //thickness=0.1 //x=2.515 //y=5.38 //x2=1.805 //y2=5.38
r212 (  7 14 ) resistor r=7.15173 //w=0.17 //l=0.120208 //layer=li \
 //thickness=0.1 //x=1.72 //y=5.465 //x2=1.805 //y2=5.38
r213 (  7 78 ) resistor r=30.1176 //w=0.187 //l=0.44 //layer=li \
 //thickness=0.1 //x=1.72 //y=5.465 //x2=1.72 //y2=5.905
r214 (  6 38 ) resistor r=9.3 //w=0.17 //l=0.17 //layer=mcon //count=1 \
 //x=4.93 //y=2.77 //x2=4.93 //y2=2.77
r215 (  4 32 ) resistor r=9.3 //w=0.17 //l=0.17 //layer=mcon //count=1 \
 //x=3.08 //y=2.77 //x2=3.08 //y2=2.77
r216 (  2 4 ) resistor r=0.0717383 //w=0.224 //l=0.115 //layer=m1 \
 //thickness=0.36 //x=3.195 //y=2.77 //x2=3.08 //y2=2.77
r217 (  1 6 ) resistor r=0.0717383 //w=0.224 //l=0.115 //layer=m1 \
 //thickness=0.36 //x=4.815 //y=2.77 //x2=4.93 //y2=2.77
r218 (  1 2 ) resistor r=1.5458 //w=0.131 //l=1.62 //layer=m1 //thickness=0.36 \
 //x=4.815 //y=2.77 //x2=3.195 //y2=2.77
ends PM_AOA4X1\%noxref_3

subckt PM_AOA4X1\%noxref_4 ( 1 2 11 12 23 24 25 30 32 40 41 42 43 44 45 46 50 \
 52 55 56 66 69 70 73 )
c142 ( 73 0 ) capacitor c=0.0159573f //x=5.785 //y=5.205
c143 ( 70 0 ) capacitor c=0.00925154f //x=5.78 //y=1.085
c144 ( 69 0 ) capacitor c=0.007684f //x=4.81 //y=1.085
c145 ( 66 0 ) capacitor c=0.0667949f //x=8.26 //y=4.88
c146 ( 56 0 ) capacitor c=0.0318948f //x=8.595 //y=1.39
c147 ( 55 0 ) capacitor c=0.0187384f //x=8.595 //y=1.045
c148 ( 52 0 ) capacitor c=0.0141798f //x=8.44 //y=1.545
c149 ( 50 0 ) capacitor c=0.0149844f //x=8.44 //y=0.89
c150 ( 46 0 ) capacitor c=0.0816272f //x=8.065 //y=2.095
c151 ( 45 0 ) capacitor c=0.0229531f //x=8.065 //y=1.7
c152 ( 44 0 ) capacitor c=0.0234352f //x=8.065 //y=1.39
c153 ( 43 0 ) capacitor c=0.0199343f //x=8.065 //y=1.045
c154 ( 42 0 ) capacitor c=0.110275f //x=8.6 //y=6.2
c155 ( 41 0 ) capacitor c=0.154305f //x=8.16 //y=6.2
c156 ( 39 0 ) capacitor c=0.00710337f //x=5.97 //y=1.835
c157 ( 32 0 ) capacitor c=0.101048f //x=8.26 //y=2.26
c158 ( 30 0 ) capacitor c=0.117944f //x=6.41 //y=2.77
c159 ( 25 0 ) capacitor c=0.0160526f //x=6.325 //y=1.835
c160 ( 24 0 ) capacitor c=0.00499395f //x=6.015 //y=5.39
c161 ( 23 0 ) capacitor c=0.0164583f //x=6.325 //y=5.39
c162 ( 12 0 ) capacitor c=0.00220849f //x=5.085 //y=1.835
c163 ( 11 0 ) capacitor c=0.0280953f //x=5.885 //y=1.835
c164 ( 2 0 ) capacitor c=0.0120303f //x=6.525 //y=2.77
c165 ( 1 0 ) capacitor c=0.112452f //x=8.145 //y=2.77
r166 (  64 66 ) resistor r=20.6867 //w=0.233 //l=0.1 //layer=ply \
 //thickness=0.18 //x=8.16 //y=4.88 //x2=8.26 //y2=4.88
r167 (  57 66 ) resistor r=70.3348 //w=0.233 //l=0.414367 //layer=ply \
 //thickness=0.18 //x=8.6 //y=5.045 //x2=8.26 //y2=4.88
r168 (  56 68 ) resistor r=45.1352 //w=0.168 //l=0.173853 //layer=ply \
 //thickness=0.18 //x=8.595 //y=1.39 //x2=8.555 //y2=1.545
r169 (  55 67 ) resistor r=45.1352 //w=0.168 //l=0.173853 //layer=ply \
 //thickness=0.18 //x=8.595 //y=1.045 //x2=8.555 //y2=0.89
r170 (  55 56 ) resistor r=176.904 //w=0.094 //l=0.345 //layer=ply \
 //thickness=0.18 //x=8.595 //y=1.045 //x2=8.595 //y2=1.39
r171 (  53 63 ) resistor r=10.701 //w=0.21 //l=0.115 //layer=ply \
 //thickness=0.18 //x=8.22 //y=1.545 //x2=8.105 //y2=1.545
r172 (  52 68 ) resistor r=5.52526 //w=0.168 //l=0.115 //layer=ply \
 //thickness=0.18 //x=8.44 //y=1.545 //x2=8.555 //y2=1.545
r173 (  51 62 ) resistor r=5.52526 //w=0.168 //l=0.115 //layer=ply \
 //thickness=0.18 //x=8.22 //y=0.89 //x2=8.105 //y2=0.89
r174 (  50 67 ) resistor r=5.52526 //w=0.168 //l=0.115 //layer=ply \
 //thickness=0.18 //x=8.44 //y=0.89 //x2=8.555 //y2=0.89
r175 (  50 51 ) resistor r=112.809 //w=0.094 //l=0.22 //layer=ply \
 //thickness=0.18 //x=8.44 //y=0.89 //x2=8.22 //y2=0.89
r176 (  47 64 ) resistor r=13.0941 //w=0.233 //l=0.165 //layer=ply \
 //thickness=0.18 //x=8.16 //y=5.045 //x2=8.16 //y2=4.88
r177 (  46 61 ) resistor r=34.8111 //w=0.27 //l=0.264953 //layer=ply \
 //thickness=0.18 //x=8.065 //y=2.095 //x2=8.26 //y2=2.26
r178 (  45 63 ) resistor r=39.5823 //w=0.21 //l=0.173853 //layer=ply \
 //thickness=0.18 //x=8.065 //y=1.7 //x2=8.105 //y2=1.545
r179 (  45 46 ) resistor r=202.543 //w=0.094 //l=0.395 //layer=ply \
 //thickness=0.18 //x=8.065 //y=1.7 //x2=8.065 //y2=2.095
r180 (  44 63 ) resistor r=39.5823 //w=0.21 //l=0.173853 //layer=ply \
 //thickness=0.18 //x=8.065 //y=1.39 //x2=8.105 //y2=1.545
r181 (  43 62 ) resistor r=45.1352 //w=0.168 //l=0.173853 //layer=ply \
 //thickness=0.18 //x=8.065 //y=1.045 //x2=8.105 //y2=0.89
r182 (  43 44 ) resistor r=176.904 //w=0.094 //l=0.345 //layer=ply \
 //thickness=0.18 //x=8.065 //y=1.045 //x2=8.065 //y2=1.39
r183 (  42 57 ) resistor r=592.245 //w=0.094 //l=1.155 //layer=ply \
 //thickness=0.18 //x=8.6 //y=6.2 //x2=8.6 //y2=5.045
r184 (  41 47 ) resistor r=592.245 //w=0.094 //l=1.155 //layer=ply \
 //thickness=0.18 //x=8.16 //y=6.2 //x2=8.16 //y2=5.045
r185 (  40 52 ) resistor r=56.4043 //w=0.094 //l=0.11 //layer=ply \
 //thickness=0.18 //x=8.33 //y=1.545 //x2=8.44 //y2=1.545
r186 (  40 53 ) resistor r=56.4043 //w=0.094 //l=0.11 //layer=ply \
 //thickness=0.18 //x=8.33 //y=1.545 //x2=8.22 //y2=1.545
r187 (  37 66 ) resistor r=152 //w=0.17 //l=0.17 //layer=licon //count=1 \
 //x=8.26 //y=4.88 //x2=8.26 //y2=4.88
r188 (  35 37 ) resistor r=144.428 //w=0.187 //l=2.11 //layer=li \
 //thickness=0.1 //x=8.26 //y=2.77 //x2=8.26 //y2=4.88
r189 (  32 61 ) resistor r=152 //w=0.17 //l=0.17 //layer=licon //count=1 \
 //x=8.26 //y=2.26 //x2=8.26 //y2=2.26
r190 (  32 35 ) resistor r=34.9091 //w=0.187 //l=0.51 //layer=li \
 //thickness=0.1 //x=8.26 //y=2.26 //x2=8.26 //y2=2.77
r191 (  28 30 ) resistor r=173.519 //w=0.187 //l=2.535 //layer=li \
 //thickness=0.1 //x=6.41 //y=5.305 //x2=6.41 //y2=2.77
r192 (  27 30 ) resistor r=58.1818 //w=0.187 //l=0.85 //layer=li \
 //thickness=0.1 //x=6.41 //y=1.92 //x2=6.41 //y2=2.77
r193 (  26 39 ) resistor r=5.4201 //w=0.17 //l=0.085 //layer=li \
 //thickness=0.1 //x=6.055 //y=1.835 //x2=5.97 //y2=1.835
r194 (  25 27 ) resistor r=7.15173 //w=0.17 //l=0.120208 //layer=li \
 //thickness=0.1 //x=6.325 //y=1.835 //x2=6.41 //y2=1.92
r195 (  25 26 ) resistor r=18.4813 //w=0.187 //l=0.27 //layer=li \
 //thickness=0.1 //x=6.325 //y=1.835 //x2=6.055 //y2=1.835
r196 (  23 28 ) resistor r=7.15173 //w=0.17 //l=0.120208 //layer=li \
 //thickness=0.1 //x=6.325 //y=5.39 //x2=6.41 //y2=5.305
r197 (  23 24 ) resistor r=21.2193 //w=0.187 //l=0.31 //layer=li \
 //thickness=0.1 //x=6.325 //y=5.39 //x2=6.015 //y2=5.39
r198 (  19 39 ) resistor r=1.40859 //w=0.34 //l=0.085 //layer=li \
 //thickness=0.1 //x=5.97 //y=1.75 //x2=5.97 //y2=1.835
r199 (  19 70 ) resistor r=39.016 //w=0.187 //l=0.57 //layer=li \
 //thickness=0.1 //x=5.97 //y=1.75 //x2=5.97 //y2=1.18
r200 (  13 24 ) resistor r=7.15173 //w=0.17 //l=0.120208 //layer=li \
 //thickness=0.1 //x=5.93 //y=5.475 //x2=6.015 //y2=5.39
r201 (  13 73 ) resistor r=29.0909 //w=0.187 //l=0.425 //layer=li \
 //thickness=0.1 //x=5.93 //y=5.475 //x2=5.93 //y2=5.9
r202 (  11 39 ) resistor r=5.4201 //w=0.17 //l=0.085 //layer=li \
 //thickness=0.1 //x=5.885 //y=1.835 //x2=5.97 //y2=1.835
r203 (  11 12 ) resistor r=54.7594 //w=0.187 //l=0.8 //layer=li \
 //thickness=0.1 //x=5.885 //y=1.835 //x2=5.085 //y2=1.835
r204 (  7 12 ) resistor r=7.15173 //w=0.17 //l=0.120208 //layer=li \
 //thickness=0.1 //x=5 //y=1.75 //x2=5.085 //y2=1.835
r205 (  7 69 ) resistor r=39.016 //w=0.187 //l=0.57 //layer=li //thickness=0.1 \
 //x=5 //y=1.75 //x2=5 //y2=1.18
r206 (  6 35 ) resistor r=9.3 //w=0.17 //l=0.17 //layer=mcon //count=1 \
 //x=8.26 //y=2.77 //x2=8.26 //y2=2.77
r207 (  4 30 ) resistor r=9.3 //w=0.17 //l=0.17 //layer=mcon //count=1 \
 //x=6.41 //y=2.77 //x2=6.41 //y2=2.77
r208 (  2 4 ) resistor r=0.0717383 //w=0.224 //l=0.115 //layer=m1 \
 //thickness=0.36 //x=6.525 //y=2.77 //x2=6.41 //y2=2.77
r209 (  1 6 ) resistor r=0.0717383 //w=0.224 //l=0.115 //layer=m1 \
 //thickness=0.36 //x=8.145 //y=2.77 //x2=8.26 //y2=2.77
r210 (  1 2 ) resistor r=1.5458 //w=0.131 //l=1.62 //layer=m1 //thickness=0.36 \
 //x=8.145 //y=2.77 //x2=6.525 //y2=2.77
ends PM_AOA4X1\%noxref_4

subckt PM_AOA4X1\%noxref_5 ( 1 2 13 14 25 27 28 32 34 41 42 43 44 45 46 47 48 \
 52 53 54 56 62 63 65 73 75 76 )
c126 ( 76 0 ) capacitor c=0.0220291f //x=9.115 //y=5.2
c127 ( 75 0 ) capacitor c=0.0217503f //x=8.235 //y=5.2
c128 ( 73 0 ) capacitor c=0.0084702f //x=9.11 //y=1.085
c129 ( 65 0 ) capacitor c=0.0517753f //x=11.22 //y=2.265
c130 ( 63 0 ) capacitor c=0.0435629f //x=11.86 //y=1.435
c131 ( 62 0 ) capacitor c=0.0200386f //x=11.86 //y=1.09
c132 ( 56 0 ) capacitor c=0.0152946f //x=11.705 //y=1.59
c133 ( 54 0 ) capacitor c=0.0157804f //x=11.705 //y=0.935
c134 ( 53 0 ) capacitor c=0.0524991f //x=11.45 //y=4.97
c135 ( 52 0 ) capacitor c=0.0322983f //x=11.74 //y=4.97
c136 ( 48 0 ) capacitor c=0.0290017f //x=11.33 //y=2.1
c137 ( 47 0 ) capacitor c=0.0250027f //x=11.33 //y=1.745
c138 ( 46 0 ) capacitor c=0.0234316f //x=11.33 //y=1.435
c139 ( 45 0 ) capacitor c=0.0200596f //x=11.33 //y=1.09
c140 ( 44 0 ) capacitor c=0.154218f //x=11.815 //y=6.2
c141 ( 43 0 ) capacitor c=0.154243f //x=11.375 //y=6.2
c142 ( 41 0 ) capacitor c=0.00427536f //x=9.26 //y=5.38
c143 ( 34 0 ) capacitor c=0.0948756f //x=11.22 //y=2.265
c144 ( 32 0 ) capacitor c=0.113415f //x=9.74 //y=2.77
c145 ( 28 0 ) capacitor c=0.00781917f //x=9.385 //y=1.835
c146 ( 27 0 ) capacitor c=0.0159132f //x=9.655 //y=1.835
c147 ( 25 0 ) capacitor c=0.0180264f //x=9.655 //y=5.38
c148 ( 14 0 ) capacitor c=0.00391676f //x=8.465 //y=5.38
c149 ( 13 0 ) capacitor c=0.0222171f //x=9.175 //y=5.38
c150 ( 2 0 ) capacitor c=0.0119586f //x=9.855 //y=2.77
c151 ( 1 0 ) capacitor c=0.0934424f //x=11.105 //y=2.77
r152 (  65 66 ) resistor r=17.5563 //w=0.302 //l=0.11 //layer=ply \
 //thickness=0.18 //x=11.22 //y=2.265 //x2=11.33 //y2=2.265
r153 (  63 72 ) resistor r=45.1352 //w=0.168 //l=0.173853 //layer=ply \
 //thickness=0.18 //x=11.86 //y=1.435 //x2=11.82 //y2=1.59
r154 (  62 71 ) resistor r=45.1352 //w=0.168 //l=0.173853 //layer=ply \
 //thickness=0.18 //x=11.86 //y=1.09 //x2=11.82 //y2=0.935
r155 (  62 63 ) resistor r=176.904 //w=0.094 //l=0.345 //layer=ply \
 //thickness=0.18 //x=11.86 //y=1.09 //x2=11.86 //y2=1.435
r156 (  57 70 ) resistor r=10.701 //w=0.21 //l=0.115 //layer=ply \
 //thickness=0.18 //x=11.485 //y=1.59 //x2=11.37 //y2=1.59
r157 (  56 72 ) resistor r=5.52526 //w=0.168 //l=0.115 //layer=ply \
 //thickness=0.18 //x=11.705 //y=1.59 //x2=11.82 //y2=1.59
r158 (  55 69 ) resistor r=5.52526 //w=0.168 //l=0.115 //layer=ply \
 //thickness=0.18 //x=11.485 //y=0.935 //x2=11.37 //y2=0.935
r159 (  54 71 ) resistor r=5.52526 //w=0.168 //l=0.115 //layer=ply \
 //thickness=0.18 //x=11.705 //y=0.935 //x2=11.82 //y2=0.935
r160 (  54 55 ) resistor r=112.809 //w=0.094 //l=0.22 //layer=ply \
 //thickness=0.18 //x=11.705 //y=0.935 //x2=11.485 //y2=0.935
r161 (  52 59 ) resistor r=26.9307 //w=0.15 //l=0.106066 //layer=ply \
 //thickness=0.18 //x=11.74 //y=4.97 //x2=11.815 //y2=5.045
r162 (  52 53 ) resistor r=148.702 //w=0.094 //l=0.29 //layer=ply \
 //thickness=0.18 //x=11.74 //y=4.97 //x2=11.45 //y2=4.97
r163 (  49 53 ) resistor r=23.403 //w=0.284 //l=0.106066 //layer=ply \
 //thickness=0.18 //x=11.375 //y=5.045 //x2=11.45 //y2=4.97
r164 (  49 68 ) resistor r=26.3063 //w=0.284 //l=0.229783 //layer=ply \
 //thickness=0.18 //x=11.375 //y=5.045 //x2=11.22 //y2=4.88
r165 (  48 66 ) resistor r=19.1248 //w=0.302 //l=0.165 //layer=ply \
 //thickness=0.18 //x=11.33 //y=2.1 //x2=11.33 //y2=2.265
r166 (  47 70 ) resistor r=39.5823 //w=0.21 //l=0.173853 //layer=ply \
 //thickness=0.18 //x=11.33 //y=1.745 //x2=11.37 //y2=1.59
r167 (  47 48 ) resistor r=182.032 //w=0.094 //l=0.355 //layer=ply \
 //thickness=0.18 //x=11.33 //y=1.745 //x2=11.33 //y2=2.1
r168 (  46 70 ) resistor r=39.5823 //w=0.21 //l=0.173853 //layer=ply \
 //thickness=0.18 //x=11.33 //y=1.435 //x2=11.37 //y2=1.59
r169 (  45 69 ) resistor r=45.1352 //w=0.168 //l=0.173853 //layer=ply \
 //thickness=0.18 //x=11.33 //y=1.09 //x2=11.37 //y2=0.935
r170 (  45 46 ) resistor r=176.904 //w=0.094 //l=0.345 //layer=ply \
 //thickness=0.18 //x=11.33 //y=1.09 //x2=11.33 //y2=1.435
r171 (  44 59 ) resistor r=592.245 //w=0.094 //l=1.155 //layer=ply \
 //thickness=0.18 //x=11.815 //y=6.2 //x2=11.815 //y2=5.045
r172 (  43 49 ) resistor r=592.245 //w=0.094 //l=1.155 //layer=ply \
 //thickness=0.18 //x=11.375 //y=6.2 //x2=11.375 //y2=5.045
r173 (  42 56 ) resistor r=56.4043 //w=0.094 //l=0.11 //layer=ply \
 //thickness=0.18 //x=11.595 //y=1.59 //x2=11.705 //y2=1.59
r174 (  42 57 ) resistor r=56.4043 //w=0.094 //l=0.11 //layer=ply \
 //thickness=0.18 //x=11.595 //y=1.59 //x2=11.485 //y2=1.59
r175 (  39 68 ) resistor r=152 //w=0.17 //l=0.17 //layer=licon //count=1 \
 //x=11.22 //y=4.88 //x2=11.22 //y2=4.88
r176 (  37 39 ) resistor r=144.428 //w=0.187 //l=2.11 //layer=li \
 //thickness=0.1 //x=11.22 //y=2.77 //x2=11.22 //y2=4.88
r177 (  34 65 ) resistor r=152 //w=0.17 //l=0.17 //layer=licon //count=1 \
 //x=11.22 //y=2.265 //x2=11.22 //y2=2.265
r178 (  34 37 ) resistor r=34.5668 //w=0.187 //l=0.505 //layer=li \
 //thickness=0.1 //x=11.22 //y=2.265 //x2=11.22 //y2=2.77
r179 (  30 32 ) resistor r=172.834 //w=0.187 //l=2.525 //layer=li \
 //thickness=0.1 //x=9.74 //y=5.295 //x2=9.74 //y2=2.77
r180 (  29 32 ) resistor r=58.1818 //w=0.187 //l=0.85 //layer=li \
 //thickness=0.1 //x=9.74 //y=1.92 //x2=9.74 //y2=2.77
r181 (  27 29 ) resistor r=7.15173 //w=0.17 //l=0.120208 //layer=li \
 //thickness=0.1 //x=9.655 //y=1.835 //x2=9.74 //y2=1.92
r182 (  27 28 ) resistor r=18.4813 //w=0.187 //l=0.27 //layer=li \
 //thickness=0.1 //x=9.655 //y=1.835 //x2=9.385 //y2=1.835
r183 (  26 41 ) resistor r=5.4201 //w=0.17 //l=0.085 //layer=li \
 //thickness=0.1 //x=9.345 //y=5.38 //x2=9.26 //y2=5.38
r184 (  25 30 ) resistor r=7.15173 //w=0.17 //l=0.120208 //layer=li \
 //thickness=0.1 //x=9.655 //y=5.38 //x2=9.74 //y2=5.295
r185 (  25 26 ) resistor r=21.2193 //w=0.187 //l=0.31 //layer=li \
 //thickness=0.1 //x=9.655 //y=5.38 //x2=9.345 //y2=5.38
r186 (  21 28 ) resistor r=7.15173 //w=0.17 //l=0.120208 //layer=li \
 //thickness=0.1 //x=9.3 //y=1.75 //x2=9.385 //y2=1.835
r187 (  21 73 ) resistor r=39.016 //w=0.187 //l=0.57 //layer=li \
 //thickness=0.1 //x=9.3 //y=1.75 //x2=9.3 //y2=1.18
r188 (  15 41 ) resistor r=1.40859 //w=0.34 //l=0.085 //layer=li \
 //thickness=0.1 //x=9.26 //y=5.465 //x2=9.26 //y2=5.38
r189 (  15 76 ) resistor r=30.1176 //w=0.187 //l=0.44 //layer=li \
 //thickness=0.1 //x=9.26 //y=5.465 //x2=9.26 //y2=5.905
r190 (  13 41 ) resistor r=5.4201 //w=0.17 //l=0.085 //layer=li \
 //thickness=0.1 //x=9.175 //y=5.38 //x2=9.26 //y2=5.38
r191 (  13 14 ) resistor r=48.5989 //w=0.187 //l=0.71 //layer=li \
 //thickness=0.1 //x=9.175 //y=5.38 //x2=8.465 //y2=5.38
r192 (  7 14 ) resistor r=7.15173 //w=0.17 //l=0.120208 //layer=li \
 //thickness=0.1 //x=8.38 //y=5.465 //x2=8.465 //y2=5.38
r193 (  7 75 ) resistor r=30.1176 //w=0.187 //l=0.44 //layer=li \
 //thickness=0.1 //x=8.38 //y=5.465 //x2=8.38 //y2=5.905
r194 (  6 37 ) resistor r=9.3 //w=0.17 //l=0.17 //layer=mcon //count=1 \
 //x=11.22 //y=2.77 //x2=11.22 //y2=2.77
r195 (  4 32 ) resistor r=9.3 //w=0.17 //l=0.17 //layer=mcon //count=1 \
 //x=9.74 //y=2.77 //x2=9.74 //y2=2.77
r196 (  2 4 ) resistor r=0.0717383 //w=0.224 //l=0.115 //layer=m1 \
 //thickness=0.36 //x=9.855 //y=2.77 //x2=9.74 //y2=2.77
r197 (  1 6 ) resistor r=0.0717383 //w=0.224 //l=0.115 //layer=m1 \
 //thickness=0.36 //x=11.105 //y=2.77 //x2=11.22 //y2=2.77
r198 (  1 2 ) resistor r=1.19275 //w=0.131 //l=1.25 //layer=m1 \
 //thickness=0.36 //x=11.105 //y=2.77 //x2=9.855 //y2=2.77
ends PM_AOA4X1\%noxref_5

subckt PM_AOA4X1\%A ( 1 2 3 4 5 6 7 9 21 22 23 24 25 26 27 31 33 36 37 47 )
c55 ( 47 0 ) capacitor c=0.0667949f //x=1.6 //y=4.88
c56 ( 37 0 ) capacitor c=0.0318948f //x=1.935 //y=1.39
c57 ( 36 0 ) capacitor c=0.0187384f //x=1.935 //y=1.045
c58 ( 33 0 ) capacitor c=0.0141798f //x=1.78 //y=1.545
c59 ( 31 0 ) capacitor c=0.0149844f //x=1.78 //y=0.89
c60 ( 27 0 ) capacitor c=0.0860049f //x=1.405 //y=2.095
c61 ( 26 0 ) capacitor c=0.0229722f //x=1.405 //y=1.7
c62 ( 25 0 ) capacitor c=0.0234352f //x=1.405 //y=1.39
c63 ( 24 0 ) capacitor c=0.0199343f //x=1.405 //y=1.045
c64 ( 23 0 ) capacitor c=0.110275f //x=1.94 //y=6.2
c65 ( 22 0 ) capacitor c=0.154305f //x=1.5 //y=6.2
c66 ( 9 0 ) capacitor c=0.116498f //x=1.6 //y=2.26
r67 (  45 47 ) resistor r=20.6867 //w=0.233 //l=0.1 //layer=ply \
 //thickness=0.18 //x=1.5 //y=4.88 //x2=1.6 //y2=4.88
r68 (  38 47 ) resistor r=70.3348 //w=0.233 //l=0.414367 //layer=ply \
 //thickness=0.18 //x=1.94 //y=5.045 //x2=1.6 //y2=4.88
r69 (  37 49 ) resistor r=45.1352 //w=0.168 //l=0.173853 //layer=ply \
 //thickness=0.18 //x=1.935 //y=1.39 //x2=1.895 //y2=1.545
r70 (  36 48 ) resistor r=45.1352 //w=0.168 //l=0.173853 //layer=ply \
 //thickness=0.18 //x=1.935 //y=1.045 //x2=1.895 //y2=0.89
r71 (  36 37 ) resistor r=176.904 //w=0.094 //l=0.345 //layer=ply \
 //thickness=0.18 //x=1.935 //y=1.045 //x2=1.935 //y2=1.39
r72 (  34 44 ) resistor r=10.701 //w=0.21 //l=0.115 //layer=ply \
 //thickness=0.18 //x=1.56 //y=1.545 //x2=1.445 //y2=1.545
r73 (  33 49 ) resistor r=5.52526 //w=0.168 //l=0.115 //layer=ply \
 //thickness=0.18 //x=1.78 //y=1.545 //x2=1.895 //y2=1.545
r74 (  32 43 ) resistor r=5.52526 //w=0.168 //l=0.115 //layer=ply \
 //thickness=0.18 //x=1.56 //y=0.89 //x2=1.445 //y2=0.89
r75 (  31 48 ) resistor r=5.52526 //w=0.168 //l=0.115 //layer=ply \
 //thickness=0.18 //x=1.78 //y=0.89 //x2=1.895 //y2=0.89
r76 (  31 32 ) resistor r=112.809 //w=0.094 //l=0.22 //layer=ply \
 //thickness=0.18 //x=1.78 //y=0.89 //x2=1.56 //y2=0.89
r77 (  28 45 ) resistor r=13.0941 //w=0.233 //l=0.165 //layer=ply \
 //thickness=0.18 //x=1.5 //y=5.045 //x2=1.5 //y2=4.88
r78 (  27 42 ) resistor r=34.8111 //w=0.27 //l=0.264953 //layer=ply \
 //thickness=0.18 //x=1.405 //y=2.095 //x2=1.6 //y2=2.26
r79 (  26 44 ) resistor r=39.5823 //w=0.21 //l=0.173853 //layer=ply \
 //thickness=0.18 //x=1.405 //y=1.7 //x2=1.445 //y2=1.545
r80 (  26 27 ) resistor r=202.543 //w=0.094 //l=0.395 //layer=ply \
 //thickness=0.18 //x=1.405 //y=1.7 //x2=1.405 //y2=2.095
r81 (  25 44 ) resistor r=39.5823 //w=0.21 //l=0.173853 //layer=ply \
 //thickness=0.18 //x=1.405 //y=1.39 //x2=1.445 //y2=1.545
r82 (  24 43 ) resistor r=45.1352 //w=0.168 //l=0.173853 //layer=ply \
 //thickness=0.18 //x=1.405 //y=1.045 //x2=1.445 //y2=0.89
r83 (  24 25 ) resistor r=176.904 //w=0.094 //l=0.345 //layer=ply \
 //thickness=0.18 //x=1.405 //y=1.045 //x2=1.405 //y2=1.39
r84 (  23 38 ) resistor r=592.245 //w=0.094 //l=1.155 //layer=ply \
 //thickness=0.18 //x=1.94 //y=6.2 //x2=1.94 //y2=5.045
r85 (  22 28 ) resistor r=592.245 //w=0.094 //l=1.155 //layer=ply \
 //thickness=0.18 //x=1.5 //y=6.2 //x2=1.5 //y2=5.045
r86 (  21 33 ) resistor r=56.4043 //w=0.094 //l=0.11 //layer=ply \
 //thickness=0.18 //x=1.67 //y=1.545 //x2=1.78 //y2=1.545
r87 (  21 34 ) resistor r=56.4043 //w=0.094 //l=0.11 //layer=ply \
 //thickness=0.18 //x=1.67 //y=1.545 //x2=1.56 //y2=1.545
r88 (  19 47 ) resistor r=152 //w=0.17 //l=0.17 //layer=licon //count=1 \
 //x=1.6 //y=4.88 //x2=1.6 //y2=4.88
r89 (  9 42 ) resistor r=152 //w=0.17 //l=0.17 //layer=licon //count=1 //x=1.6 \
 //y=2.26 //x2=1.6 //y2=2.26
r90 (  7 19 ) resistor r=17.7968 //w=0.187 //l=0.26 //layer=li //thickness=0.1 \
 //x=1.6 //y=4.62 //x2=1.6 //y2=4.88
r91 (  6 7 ) resistor r=25.3262 //w=0.187 //l=0.37 //layer=li //thickness=0.1 \
 //x=1.6 //y=4.25 //x2=1.6 //y2=4.62
r92 (  5 6 ) resistor r=25.3262 //w=0.187 //l=0.37 //layer=li //thickness=0.1 \
 //x=1.6 //y=3.88 //x2=1.6 //y2=4.25
r93 (  4 5 ) resistor r=25.3262 //w=0.187 //l=0.37 //layer=li //thickness=0.1 \
 //x=1.6 //y=3.51 //x2=1.6 //y2=3.88
r94 (  3 4 ) resistor r=25.3262 //w=0.187 //l=0.37 //layer=li //thickness=0.1 \
 //x=1.6 //y=3.14 //x2=1.6 //y2=3.51
r95 (  2 3 ) resistor r=25.3262 //w=0.187 //l=0.37 //layer=li //thickness=0.1 \
 //x=1.6 //y=2.77 //x2=1.6 //y2=3.14
r96 (  1 2 ) resistor r=25.3262 //w=0.187 //l=0.37 //layer=li //thickness=0.1 \
 //x=1.6 //y=2.4 //x2=1.6 //y2=2.77
r97 (  1 9 ) resistor r=9.58289 //w=0.187 //l=0.14 //layer=li //thickness=0.1 \
 //x=1.6 //y=2.4 //x2=1.6 //y2=2.26
ends PM_AOA4X1\%A

subckt PM_AOA4X1\%B ( 1 2 3 4 5 6 7 8 10 21 22 23 24 25 26 31 33 35 41 42 44 \
 45 48 )
c64 ( 48 0 ) capacitor c=0.034715f //x=2.37 //y=4.88
c65 ( 45 0 ) capacitor c=0.0279499f //x=2.34 //y=2.095
c66 ( 44 0 ) capacitor c=0.0437302f //x=2.34 //y=2.26
c67 ( 42 0 ) capacitor c=0.0429696f //x=2.905 //y=1.43
c68 ( 41 0 ) capacitor c=0.0192208f //x=2.905 //y=1.085
c69 ( 35 0 ) capacitor c=0.0158629f //x=2.75 //y=1.585
c70 ( 33 0 ) capacitor c=0.0157803f //x=2.75 //y=0.93
c71 ( 31 0 ) capacitor c=0.0366192f //x=2.745 //y=4.97
c72 ( 26 0 ) capacitor c=0.0205163f //x=2.375 //y=1.74
c73 ( 25 0 ) capacitor c=0.0168481f //x=2.375 //y=1.43
c74 ( 24 0 ) capacitor c=0.0174783f //x=2.375 //y=1.085
c75 ( 23 0 ) capacitor c=0.15358f //x=2.82 //y=6.2
c76 ( 22 0 ) capacitor c=0.110281f //x=2.38 //y=6.2
c77 ( 10 0 ) capacitor c=0.0813556f //x=2.34 //y=2.26
c78 ( 8 0 ) capacitor c=0.00453889f //x=2.34 //y=4.715
r79 (  50 51 ) resistor r=32.4568 //w=0.214 //l=0.075 //layer=ply \
 //thickness=0.18 //x=2.37 //y=4.97 //x2=2.37 //y2=5.045
r80 (  48 50 ) resistor r=20.271 //w=0.214 //l=0.09 //layer=ply \
 //thickness=0.18 //x=2.37 //y=4.88 //x2=2.37 //y2=4.97
r81 (  44 45 ) resistor r=52.7279 //w=0.214 //l=0.165 //layer=ply \
 //thickness=0.18 //x=2.34 //y=2.26 //x2=2.34 //y2=2.095
r82 (  42 55 ) resistor r=45.1352 //w=0.168 //l=0.173853 //layer=ply \
 //thickness=0.18 //x=2.905 //y=1.43 //x2=2.865 //y2=1.585
r83 (  41 54 ) resistor r=45.1352 //w=0.168 //l=0.173853 //layer=ply \
 //thickness=0.18 //x=2.905 //y=1.085 //x2=2.865 //y2=0.93
r84 (  41 42 ) resistor r=176.904 //w=0.094 //l=0.345 //layer=ply \
 //thickness=0.18 //x=2.905 //y=1.085 //x2=2.905 //y2=1.43
r85 (  36 53 ) resistor r=10.701 //w=0.21 //l=0.115 //layer=ply \
 //thickness=0.18 //x=2.53 //y=1.585 //x2=2.415 //y2=1.585
r86 (  35 55 ) resistor r=5.52526 //w=0.168 //l=0.115 //layer=ply \
 //thickness=0.18 //x=2.75 //y=1.585 //x2=2.865 //y2=1.585
r87 (  34 52 ) resistor r=5.52526 //w=0.168 //l=0.115 //layer=ply \
 //thickness=0.18 //x=2.53 //y=0.93 //x2=2.415 //y2=0.93
r88 (  33 54 ) resistor r=5.52526 //w=0.168 //l=0.115 //layer=ply \
 //thickness=0.18 //x=2.75 //y=0.93 //x2=2.865 //y2=0.93
r89 (  33 34 ) resistor r=112.809 //w=0.094 //l=0.22 //layer=ply \
 //thickness=0.18 //x=2.75 //y=0.93 //x2=2.53 //y2=0.93
r90 (  32 50 ) resistor r=16.5046 //w=0.27 //l=0.135 //layer=ply \
 //thickness=0.18 //x=2.505 //y=4.97 //x2=2.37 //y2=4.97
r91 (  31 38 ) resistor r=26.9307 //w=0.15 //l=0.106066 //layer=ply \
 //thickness=0.18 //x=2.745 //y=4.97 //x2=2.82 //y2=5.045
r92 (  31 32 ) resistor r=123.064 //w=0.094 //l=0.24 //layer=ply \
 //thickness=0.18 //x=2.745 //y=4.97 //x2=2.505 //y2=4.97
r93 (  26 53 ) resistor r=39.5823 //w=0.21 //l=0.173853 //layer=ply \
 //thickness=0.18 //x=2.375 //y=1.74 //x2=2.415 //y2=1.585
r94 (  26 45 ) resistor r=182.032 //w=0.094 //l=0.355 //layer=ply \
 //thickness=0.18 //x=2.375 //y=1.74 //x2=2.375 //y2=2.095
r95 (  25 53 ) resistor r=39.5823 //w=0.21 //l=0.173853 //layer=ply \
 //thickness=0.18 //x=2.375 //y=1.43 //x2=2.415 //y2=1.585
r96 (  24 52 ) resistor r=45.1352 //w=0.168 //l=0.173853 //layer=ply \
 //thickness=0.18 //x=2.375 //y=1.085 //x2=2.415 //y2=0.93
r97 (  24 25 ) resistor r=176.904 //w=0.094 //l=0.345 //layer=ply \
 //thickness=0.18 //x=2.375 //y=1.085 //x2=2.375 //y2=1.43
r98 (  23 38 ) resistor r=592.245 //w=0.094 //l=1.155 //layer=ply \
 //thickness=0.18 //x=2.82 //y=6.2 //x2=2.82 //y2=5.045
r99 (  22 51 ) resistor r=592.245 //w=0.094 //l=1.155 //layer=ply \
 //thickness=0.18 //x=2.38 //y=6.2 //x2=2.38 //y2=5.045
r100 (  21 35 ) resistor r=56.4043 //w=0.094 //l=0.11 //layer=ply \
 //thickness=0.18 //x=2.64 //y=1.585 //x2=2.75 //y2=1.585
r101 (  21 36 ) resistor r=56.4043 //w=0.094 //l=0.11 //layer=ply \
 //thickness=0.18 //x=2.64 //y=1.585 //x2=2.53 //y2=1.585
r102 (  20 48 ) resistor r=152 //w=0.17 //l=0.17 //layer=licon //count=1 \
 //x=2.37 //y=4.88 //x2=2.37 //y2=4.88
r103 (  10 44 ) resistor r=152 //w=0.17 //l=0.17 //layer=licon //count=1 \
 //x=2.34 //y=2.26 //x2=2.34 //y2=2.26
r104 (  8 20 ) resistor r=11.4737 //w=0.186 //l=0.172337 //layer=li \
 //thickness=0.1 //x=2.34 //y=4.715 //x2=2.355 //y2=4.88
r105 (  7 8 ) resistor r=6.50267 //w=0.187 //l=0.095 //layer=li \
 //thickness=0.1 //x=2.34 //y=4.62 //x2=2.34 //y2=4.715
r106 (  6 7 ) resistor r=25.3262 //w=0.187 //l=0.37 //layer=li //thickness=0.1 \
 //x=2.34 //y=4.25 //x2=2.34 //y2=4.62
r107 (  5 6 ) resistor r=25.3262 //w=0.187 //l=0.37 //layer=li //thickness=0.1 \
 //x=2.34 //y=3.88 //x2=2.34 //y2=4.25
r108 (  4 5 ) resistor r=25.3262 //w=0.187 //l=0.37 //layer=li //thickness=0.1 \
 //x=2.34 //y=3.51 //x2=2.34 //y2=3.88
r109 (  3 4 ) resistor r=25.3262 //w=0.187 //l=0.37 //layer=li //thickness=0.1 \
 //x=2.34 //y=3.14 //x2=2.34 //y2=3.51
r110 (  2 3 ) resistor r=25.3262 //w=0.187 //l=0.37 //layer=li //thickness=0.1 \
 //x=2.34 //y=2.77 //x2=2.34 //y2=3.14
r111 (  1 2 ) resistor r=25.3262 //w=0.187 //l=0.37 //layer=li //thickness=0.1 \
 //x=2.34 //y=2.4 //x2=2.34 //y2=2.77
r112 (  1 10 ) resistor r=9.58289 //w=0.187 //l=0.14 //layer=li \
 //thickness=0.1 //x=2.34 //y=2.4 //x2=2.34 //y2=2.26
ends PM_AOA4X1\%B

subckt PM_AOA4X1\%noxref_8 ( 1 5 9 10 13 17 29 )
c51 ( 29 0 ) capacitor c=0.0632971f //x=1.05 //y=0.545
c52 ( 17 0 ) capacitor c=0.00722223f //x=3.125 //y=0.795
c53 ( 13 0 ) capacitor c=0.0154397f //x=3.04 //y=0.71
c54 ( 10 0 ) capacitor c=0.0092508f //x=2.155 //y=1.675
c55 ( 9 0 ) capacitor c=0.006761f //x=2.155 //y=0.795
c56 ( 5 0 ) capacitor c=0.0255599f //x=2.07 //y=1.76
c57 ( 1 0 ) capacitor c=0.0113547f //x=1.185 //y=1.675
r58 (  17 29 ) resistor r=3.57586 //w=0.17 //l=0.125 //layer=li \
 //thickness=0.1 //x=3.125 //y=0.795 //x2=3.125 //y2=0.67
r59 (  17 29 ) resistor r=18.139 //w=0.187 //l=0.265 //layer=li \
 //thickness=0.1 //x=3.125 //y=0.795 //x2=3.125 //y2=1.06
r60 (  14 29 ) resistor r=3.57586 //w=0.17 //l=0.103078 //layer=li \
 //thickness=0.1 //x=2.24 //y=0.71 //x2=2.155 //y2=0.67
r61 (  14 29 ) resistor r=27.3797 //w=0.187 //l=0.4 //layer=li //thickness=0.1 \
 //x=2.24 //y=0.71 //x2=2.64 //y2=0.71
r62 (  13 29 ) resistor r=3.57586 //w=0.17 //l=0.103078 //layer=li \
 //thickness=0.1 //x=3.04 //y=0.71 //x2=3.125 //y2=0.67
r63 (  13 29 ) resistor r=27.3797 //w=0.187 //l=0.4 //layer=li //thickness=0.1 \
 //x=3.04 //y=0.71 //x2=2.64 //y2=0.71
r64 (  10 29 ) resistor r=3.57586 //w=0.17 //l=0.125 //layer=li \
 //thickness=0.1 //x=2.155 //y=1.675 //x2=2.155 //y2=1.8
r65 (  10 29 ) resistor r=42.0963 //w=0.187 //l=0.615 //layer=li \
 //thickness=0.1 //x=2.155 //y=1.675 //x2=2.155 //y2=1.06
r66 (  9 29 ) resistor r=3.57586 //w=0.17 //l=0.125 //layer=li //thickness=0.1 \
 //x=2.155 //y=0.795 //x2=2.155 //y2=0.67
r67 (  9 29 ) resistor r=18.139 //w=0.187 //l=0.265 //layer=li //thickness=0.1 \
 //x=2.155 //y=0.795 //x2=2.155 //y2=1.06
r68 (  6 29 ) resistor r=3.57586 //w=0.17 //l=0.103078 //layer=li \
 //thickness=0.1 //x=1.27 //y=1.76 //x2=1.185 //y2=1.8
r69 (  6 29 ) resistor r=27.3797 //w=0.187 //l=0.4 //layer=li //thickness=0.1 \
 //x=1.27 //y=1.76 //x2=1.67 //y2=1.76
r70 (  5 29 ) resistor r=3.57586 //w=0.17 //l=0.103078 //layer=li \
 //thickness=0.1 //x=2.07 //y=1.76 //x2=2.155 //y2=1.8
r71 (  5 29 ) resistor r=27.3797 //w=0.187 //l=0.4 //layer=li //thickness=0.1 \
 //x=2.07 //y=1.76 //x2=1.67 //y2=1.76
r72 (  1 29 ) resistor r=3.57586 //w=0.17 //l=0.125 //layer=li //thickness=0.1 \
 //x=1.185 //y=1.675 //x2=1.185 //y2=1.8
r73 (  1 29 ) resistor r=42.0963 //w=0.187 //l=0.615 //layer=li \
 //thickness=0.1 //x=1.185 //y=1.675 //x2=1.185 //y2=1.06
ends PM_AOA4X1\%noxref_8

subckt PM_AOA4X1\%C ( 1 2 3 4 5 6 7 8 10 21 22 23 24 25 26 31 33 35 41 42 44 \
 45 48 )
c71 ( 48 0 ) capacitor c=0.0369822f //x=5.705 //y=4.885
c72 ( 45 0 ) capacitor c=0.0279572f //x=5.67 //y=2.095
c73 ( 44 0 ) capacitor c=0.0422144f //x=5.67 //y=2.26
c74 ( 42 0 ) capacitor c=0.0237734f //x=6.235 //y=1.435
c75 ( 41 0 ) capacitor c=0.0191782f //x=6.235 //y=1.085
c76 ( 35 0 ) capacitor c=0.0346941f //x=6.08 //y=1.585
c77 ( 33 0 ) capacitor c=0.0157803f //x=6.08 //y=0.93
c78 ( 31 0 ) capacitor c=0.0359964f //x=6.075 //y=4.975
c79 ( 26 0 ) capacitor c=0.0199921f //x=5.705 //y=1.74
c80 ( 25 0 ) capacitor c=0.0169608f //x=5.705 //y=1.435
c81 ( 24 0 ) capacitor c=0.0185462f //x=5.705 //y=1.085
c82 ( 23 0 ) capacitor c=0.15325f //x=6.15 //y=6.205
c83 ( 22 0 ) capacitor c=0.110232f //x=5.71 //y=6.205
c84 ( 10 0 ) capacitor c=0.0800125f //x=5.67 //y=2.26
c85 ( 8 0 ) capacitor c=0.00521267f //x=5.67 //y=4.72
r86 (  50 51 ) resistor r=32.4568 //w=0.214 //l=0.075 //layer=ply \
 //thickness=0.18 //x=5.705 //y=4.975 //x2=5.705 //y2=5.05
r87 (  48 50 ) resistor r=20.271 //w=0.214 //l=0.09 //layer=ply \
 //thickness=0.18 //x=5.705 //y=4.885 //x2=5.705 //y2=4.975
r88 (  44 45 ) resistor r=52.7279 //w=0.214 //l=0.165 //layer=ply \
 //thickness=0.18 //x=5.67 //y=2.26 //x2=5.67 //y2=2.095
r89 (  42 55 ) resistor r=4.95774 //w=0.164 //l=0.112 //layer=ply \
 //thickness=0.18 //x=6.235 //y=1.435 //x2=6.235 //y2=1.547
r90 (  41 54 ) resistor r=45.1352 //w=0.168 //l=0.173853 //layer=ply \
 //thickness=0.18 //x=6.235 //y=1.085 //x2=6.195 //y2=0.93
r91 (  41 42 ) resistor r=179.468 //w=0.094 //l=0.35 //layer=ply \
 //thickness=0.18 //x=6.235 //y=1.085 //x2=6.235 //y2=1.435
r92 (  36 53 ) resistor r=10.8103 //w=0.211 //l=0.115 //layer=ply \
 //thickness=0.18 //x=5.86 //y=1.585 //x2=5.745 //y2=1.585
r93 (  35 55 ) resistor r=45.9962 //w=0.164 //l=0.17296 //layer=ply \
 //thickness=0.18 //x=6.08 //y=1.585 //x2=6.235 //y2=1.547
r94 (  34 52 ) resistor r=5.52526 //w=0.168 //l=0.115 //layer=ply \
 //thickness=0.18 //x=5.86 //y=0.93 //x2=5.745 //y2=0.93
r95 (  33 54 ) resistor r=5.52526 //w=0.168 //l=0.115 //layer=ply \
 //thickness=0.18 //x=6.08 //y=0.93 //x2=6.195 //y2=0.93
r96 (  33 34 ) resistor r=112.809 //w=0.094 //l=0.22 //layer=ply \
 //thickness=0.18 //x=6.08 //y=0.93 //x2=5.86 //y2=0.93
r97 (  32 50 ) resistor r=16.5046 //w=0.27 //l=0.135 //layer=ply \
 //thickness=0.18 //x=5.84 //y=4.975 //x2=5.705 //y2=4.975
r98 (  31 38 ) resistor r=26.9307 //w=0.15 //l=0.106066 //layer=ply \
 //thickness=0.18 //x=6.075 //y=4.975 //x2=6.15 //y2=5.05
r99 (  31 32 ) resistor r=120.5 //w=0.094 //l=0.235 //layer=ply \
 //thickness=0.18 //x=6.075 //y=4.975 //x2=5.84 //y2=4.975
r100 (  26 53 ) resistor r=39.5036 //w=0.211 //l=0.173853 //layer=ply \
 //thickness=0.18 //x=5.705 //y=1.74 //x2=5.745 //y2=1.585
r101 (  26 45 ) resistor r=182.032 //w=0.094 //l=0.355 //layer=ply \
 //thickness=0.18 //x=5.705 //y=1.74 //x2=5.705 //y2=2.095
r102 (  25 53 ) resistor r=38.3614 //w=0.211 //l=0.168819 //layer=ply \
 //thickness=0.18 //x=5.705 //y=1.435 //x2=5.745 //y2=1.585
r103 (  24 52 ) resistor r=45.1352 //w=0.168 //l=0.173853 //layer=ply \
 //thickness=0.18 //x=5.705 //y=1.085 //x2=5.745 //y2=0.93
r104 (  24 25 ) resistor r=179.468 //w=0.094 //l=0.35 //layer=ply \
 //thickness=0.18 //x=5.705 //y=1.085 //x2=5.705 //y2=1.435
r105 (  23 38 ) resistor r=592.245 //w=0.094 //l=1.155 //layer=ply \
 //thickness=0.18 //x=6.15 //y=6.205 //x2=6.15 //y2=5.05
r106 (  22 51 ) resistor r=592.245 //w=0.094 //l=1.155 //layer=ply \
 //thickness=0.18 //x=5.71 //y=6.205 //x2=5.71 //y2=5.05
r107 (  21 35 ) resistor r=56.4043 //w=0.094 //l=0.11 //layer=ply \
 //thickness=0.18 //x=5.97 //y=1.585 //x2=6.08 //y2=1.585
r108 (  21 36 ) resistor r=56.4043 //w=0.094 //l=0.11 //layer=ply \
 //thickness=0.18 //x=5.97 //y=1.585 //x2=5.86 //y2=1.585
r109 (  20 48 ) resistor r=152 //w=0.17 //l=0.17 //layer=licon //count=1 \
 //x=5.705 //y=4.885 //x2=5.705 //y2=4.885
r110 (  10 44 ) resistor r=152 //w=0.17 //l=0.17 //layer=licon //count=1 \
 //x=5.67 //y=2.26 //x2=5.67 //y2=2.26
r111 (  8 20 ) resistor r=11.332 //w=0.189 //l=0.173292 //layer=li \
 //thickness=0.1 //x=5.67 //y=4.72 //x2=5.687 //y2=4.885
r112 (  7 8 ) resistor r=6.84492 //w=0.187 //l=0.1 //layer=li //thickness=0.1 \
 //x=5.67 //y=4.62 //x2=5.67 //y2=4.72
r113 (  6 7 ) resistor r=25.3262 //w=0.187 //l=0.37 //layer=li //thickness=0.1 \
 //x=5.67 //y=4.25 //x2=5.67 //y2=4.62
r114 (  5 6 ) resistor r=25.3262 //w=0.187 //l=0.37 //layer=li //thickness=0.1 \
 //x=5.67 //y=3.88 //x2=5.67 //y2=4.25
r115 (  4 5 ) resistor r=25.3262 //w=0.187 //l=0.37 //layer=li //thickness=0.1 \
 //x=5.67 //y=3.51 //x2=5.67 //y2=3.88
r116 (  3 4 ) resistor r=25.3262 //w=0.187 //l=0.37 //layer=li //thickness=0.1 \
 //x=5.67 //y=3.14 //x2=5.67 //y2=3.51
r117 (  2 3 ) resistor r=25.3262 //w=0.187 //l=0.37 //layer=li //thickness=0.1 \
 //x=5.67 //y=2.77 //x2=5.67 //y2=3.14
r118 (  1 2 ) resistor r=25.3262 //w=0.187 //l=0.37 //layer=li //thickness=0.1 \
 //x=5.67 //y=2.4 //x2=5.67 //y2=2.77
r119 (  1 10 ) resistor r=9.58289 //w=0.187 //l=0.14 //layer=li \
 //thickness=0.1 //x=5.67 //y=2.4 //x2=5.67 //y2=2.26
ends PM_AOA4X1\%C

subckt PM_AOA4X1\%noxref_10 ( 7 8 15 16 23 24 25 )
c43 ( 25 0 ) capacitor c=0.0308836f //x=6.225 //y=5.205
c44 ( 24 0 ) capacitor c=0.0185379f //x=5.345 //y=5.205
c45 ( 23 0 ) capacitor c=0.0409962f //x=4.475 //y=5.205
c46 ( 16 0 ) capacitor c=0.00193672f //x=5.575 //y=7.09
c47 ( 15 0 ) capacitor c=0.01354f //x=6.285 //y=7.09
c48 ( 8 0 ) capacitor c=0.00844339f //x=4.695 //y=5.39
c49 ( 7 0 ) capacitor c=0.0252644f //x=5.405 //y=5.39
r50 (  17 25 ) resistor r=5.81818 //w=0.187 //l=0.085 //layer=li \
 //thickness=0.1 //x=6.37 //y=7.005 //x2=6.37 //y2=6.92
r51 (  15 17 ) resistor r=7.15173 //w=0.17 //l=0.120208 //layer=li \
 //thickness=0.1 //x=6.285 //y=7.09 //x2=6.37 //y2=7.005
r52 (  15 16 ) resistor r=48.5989 //w=0.187 //l=0.71 //layer=li \
 //thickness=0.1 //x=6.285 //y=7.09 //x2=5.575 //y2=7.09
r53 (  10 16 ) resistor r=7.15173 //w=0.17 //l=0.120208 //layer=li \
 //thickness=0.1 //x=5.49 //y=7.005 //x2=5.575 //y2=7.09
r54 (  10 24 ) resistor r=29.0909 //w=0.187 //l=0.425 //layer=li \
 //thickness=0.1 //x=5.49 //y=7.005 //x2=5.49 //y2=6.58
r55 (  9 24 ) resistor r=29.0909 //w=0.187 //l=0.425 //layer=li \
 //thickness=0.1 //x=5.49 //y=5.475 //x2=5.49 //y2=5.9
r56 (  7 9 ) resistor r=7.15173 //w=0.17 //l=0.120208 //layer=li \
 //thickness=0.1 //x=5.405 //y=5.39 //x2=5.49 //y2=5.475
r57 (  7 8 ) resistor r=48.5989 //w=0.187 //l=0.71 //layer=li //thickness=0.1 \
 //x=5.405 //y=5.39 //x2=4.695 //y2=5.39
r58 (  1 8 ) resistor r=7.15173 //w=0.17 //l=0.120208 //layer=li \
 //thickness=0.1 //x=4.61 //y=5.475 //x2=4.695 //y2=5.39
r59 (  1 23 ) resistor r=29.0909 //w=0.187 //l=0.425 //layer=li \
 //thickness=0.1 //x=4.61 //y=5.475 //x2=4.61 //y2=5.9
ends PM_AOA4X1\%noxref_10

subckt PM_AOA4X1\%D ( 1 2 3 4 5 6 7 8 10 21 22 23 24 25 26 31 33 35 41 42 44 \
 45 48 )
c66 ( 48 0 ) capacitor c=0.034715f //x=9.03 //y=4.88
c67 ( 45 0 ) capacitor c=0.0279499f //x=9 //y=2.095
c68 ( 44 0 ) capacitor c=0.0437302f //x=9 //y=2.26
c69 ( 42 0 ) capacitor c=0.0429696f //x=9.565 //y=1.43
c70 ( 41 0 ) capacitor c=0.0192208f //x=9.565 //y=1.085
c71 ( 35 0 ) capacitor c=0.0158629f //x=9.41 //y=1.585
c72 ( 33 0 ) capacitor c=0.0157803f //x=9.41 //y=0.93
c73 ( 31 0 ) capacitor c=0.0367015f //x=9.405 //y=4.97
c74 ( 26 0 ) capacitor c=0.0205163f //x=9.035 //y=1.74
c75 ( 25 0 ) capacitor c=0.0168481f //x=9.035 //y=1.43
c76 ( 24 0 ) capacitor c=0.0174783f //x=9.035 //y=1.085
c77 ( 23 0 ) capacitor c=0.15358f //x=9.48 //y=6.2
c78 ( 22 0 ) capacitor c=0.110281f //x=9.04 //y=6.2
c79 ( 10 0 ) capacitor c=0.0804986f //x=9 //y=2.26
c80 ( 8 0 ) capacitor c=0.00453889f //x=9 //y=4.715
r81 (  50 51 ) resistor r=32.4568 //w=0.214 //l=0.075 //layer=ply \
 //thickness=0.18 //x=9.03 //y=4.97 //x2=9.03 //y2=5.045
r82 (  48 50 ) resistor r=20.271 //w=0.214 //l=0.09 //layer=ply \
 //thickness=0.18 //x=9.03 //y=4.88 //x2=9.03 //y2=4.97
r83 (  44 45 ) resistor r=52.7279 //w=0.214 //l=0.165 //layer=ply \
 //thickness=0.18 //x=9 //y=2.26 //x2=9 //y2=2.095
r84 (  42 55 ) resistor r=45.1352 //w=0.168 //l=0.173853 //layer=ply \
 //thickness=0.18 //x=9.565 //y=1.43 //x2=9.525 //y2=1.585
r85 (  41 54 ) resistor r=45.1352 //w=0.168 //l=0.173853 //layer=ply \
 //thickness=0.18 //x=9.565 //y=1.085 //x2=9.525 //y2=0.93
r86 (  41 42 ) resistor r=176.904 //w=0.094 //l=0.345 //layer=ply \
 //thickness=0.18 //x=9.565 //y=1.085 //x2=9.565 //y2=1.43
r87 (  36 53 ) resistor r=10.701 //w=0.21 //l=0.115 //layer=ply \
 //thickness=0.18 //x=9.19 //y=1.585 //x2=9.075 //y2=1.585
r88 (  35 55 ) resistor r=5.52526 //w=0.168 //l=0.115 //layer=ply \
 //thickness=0.18 //x=9.41 //y=1.585 //x2=9.525 //y2=1.585
r89 (  34 52 ) resistor r=5.52526 //w=0.168 //l=0.115 //layer=ply \
 //thickness=0.18 //x=9.19 //y=0.93 //x2=9.075 //y2=0.93
r90 (  33 54 ) resistor r=5.52526 //w=0.168 //l=0.115 //layer=ply \
 //thickness=0.18 //x=9.41 //y=0.93 //x2=9.525 //y2=0.93
r91 (  33 34 ) resistor r=112.809 //w=0.094 //l=0.22 //layer=ply \
 //thickness=0.18 //x=9.41 //y=0.93 //x2=9.19 //y2=0.93
r92 (  32 50 ) resistor r=16.5046 //w=0.27 //l=0.135 //layer=ply \
 //thickness=0.18 //x=9.165 //y=4.97 //x2=9.03 //y2=4.97
r93 (  31 38 ) resistor r=26.9307 //w=0.15 //l=0.106066 //layer=ply \
 //thickness=0.18 //x=9.405 //y=4.97 //x2=9.48 //y2=5.045
r94 (  31 32 ) resistor r=123.064 //w=0.094 //l=0.24 //layer=ply \
 //thickness=0.18 //x=9.405 //y=4.97 //x2=9.165 //y2=4.97
r95 (  26 53 ) resistor r=39.5823 //w=0.21 //l=0.173853 //layer=ply \
 //thickness=0.18 //x=9.035 //y=1.74 //x2=9.075 //y2=1.585
r96 (  26 45 ) resistor r=182.032 //w=0.094 //l=0.355 //layer=ply \
 //thickness=0.18 //x=9.035 //y=1.74 //x2=9.035 //y2=2.095
r97 (  25 53 ) resistor r=39.5823 //w=0.21 //l=0.173853 //layer=ply \
 //thickness=0.18 //x=9.035 //y=1.43 //x2=9.075 //y2=1.585
r98 (  24 52 ) resistor r=45.1352 //w=0.168 //l=0.173853 //layer=ply \
 //thickness=0.18 //x=9.035 //y=1.085 //x2=9.075 //y2=0.93
r99 (  24 25 ) resistor r=176.904 //w=0.094 //l=0.345 //layer=ply \
 //thickness=0.18 //x=9.035 //y=1.085 //x2=9.035 //y2=1.43
r100 (  23 38 ) resistor r=592.245 //w=0.094 //l=1.155 //layer=ply \
 //thickness=0.18 //x=9.48 //y=6.2 //x2=9.48 //y2=5.045
r101 (  22 51 ) resistor r=592.245 //w=0.094 //l=1.155 //layer=ply \
 //thickness=0.18 //x=9.04 //y=6.2 //x2=9.04 //y2=5.045
r102 (  21 35 ) resistor r=56.4043 //w=0.094 //l=0.11 //layer=ply \
 //thickness=0.18 //x=9.3 //y=1.585 //x2=9.41 //y2=1.585
r103 (  21 36 ) resistor r=56.4043 //w=0.094 //l=0.11 //layer=ply \
 //thickness=0.18 //x=9.3 //y=1.585 //x2=9.19 //y2=1.585
r104 (  20 48 ) resistor r=152 //w=0.17 //l=0.17 //layer=licon //count=1 \
 //x=9.03 //y=4.88 //x2=9.03 //y2=4.88
r105 (  10 44 ) resistor r=152 //w=0.17 //l=0.17 //layer=licon //count=1 //x=9 \
 //y=2.26 //x2=9 //y2=2.26
r106 (  8 20 ) resistor r=11.4737 //w=0.186 //l=0.172337 //layer=li \
 //thickness=0.1 //x=9 //y=4.715 //x2=9.015 //y2=4.88
r107 (  7 8 ) resistor r=6.50267 //w=0.187 //l=0.095 //layer=li \
 //thickness=0.1 //x=9 //y=4.62 //x2=9 //y2=4.715
r108 (  6 7 ) resistor r=25.3262 //w=0.187 //l=0.37 //layer=li //thickness=0.1 \
 //x=9 //y=4.25 //x2=9 //y2=4.62
r109 (  5 6 ) resistor r=25.3262 //w=0.187 //l=0.37 //layer=li //thickness=0.1 \
 //x=9 //y=3.88 //x2=9 //y2=4.25
r110 (  4 5 ) resistor r=25.3262 //w=0.187 //l=0.37 //layer=li //thickness=0.1 \
 //x=9 //y=3.51 //x2=9 //y2=3.88
r111 (  3 4 ) resistor r=25.3262 //w=0.187 //l=0.37 //layer=li //thickness=0.1 \
 //x=9 //y=3.14 //x2=9 //y2=3.51
r112 (  2 3 ) resistor r=25.3262 //w=0.187 //l=0.37 //layer=li //thickness=0.1 \
 //x=9 //y=2.77 //x2=9 //y2=3.14
r113 (  1 2 ) resistor r=25.3262 //w=0.187 //l=0.37 //layer=li //thickness=0.1 \
 //x=9 //y=2.4 //x2=9 //y2=2.77
r114 (  1 10 ) resistor r=9.58289 //w=0.187 //l=0.14 //layer=li \
 //thickness=0.1 //x=9 //y=2.4 //x2=9 //y2=2.26
ends PM_AOA4X1\%D

subckt PM_AOA4X1\%noxref_12 ( 1 5 9 10 13 17 29 )
c55 ( 29 0 ) capacitor c=0.0632684f //x=7.71 //y=0.545
c56 ( 17 0 ) capacitor c=0.00722223f //x=9.785 //y=0.795
c57 ( 13 0 ) capacitor c=0.0154397f //x=9.7 //y=0.71
c58 ( 10 0 ) capacitor c=0.0092508f //x=8.815 //y=1.675
c59 ( 9 0 ) capacitor c=0.006761f //x=8.815 //y=0.795
c60 ( 5 0 ) capacitor c=0.0235093f //x=8.73 //y=1.76
c61 ( 1 0 ) capacitor c=0.00765941f //x=7.845 //y=1.675
r62 (  17 29 ) resistor r=3.57586 //w=0.17 //l=0.125 //layer=li \
 //thickness=0.1 //x=9.785 //y=0.795 //x2=9.785 //y2=0.67
r63 (  17 29 ) resistor r=18.139 //w=0.187 //l=0.265 //layer=li \
 //thickness=0.1 //x=9.785 //y=0.795 //x2=9.785 //y2=1.06
r64 (  14 29 ) resistor r=3.57586 //w=0.17 //l=0.103078 //layer=li \
 //thickness=0.1 //x=8.9 //y=0.71 //x2=8.815 //y2=0.67
r65 (  14 29 ) resistor r=27.3797 //w=0.187 //l=0.4 //layer=li //thickness=0.1 \
 //x=8.9 //y=0.71 //x2=9.3 //y2=0.71
r66 (  13 29 ) resistor r=3.57586 //w=0.17 //l=0.103078 //layer=li \
 //thickness=0.1 //x=9.7 //y=0.71 //x2=9.785 //y2=0.67
r67 (  13 29 ) resistor r=27.3797 //w=0.187 //l=0.4 //layer=li //thickness=0.1 \
 //x=9.7 //y=0.71 //x2=9.3 //y2=0.71
r68 (  10 29 ) resistor r=3.57586 //w=0.17 //l=0.125 //layer=li \
 //thickness=0.1 //x=8.815 //y=1.675 //x2=8.815 //y2=1.8
r69 (  10 29 ) resistor r=42.0963 //w=0.187 //l=0.615 //layer=li \
 //thickness=0.1 //x=8.815 //y=1.675 //x2=8.815 //y2=1.06
r70 (  9 29 ) resistor r=3.57586 //w=0.17 //l=0.125 //layer=li //thickness=0.1 \
 //x=8.815 //y=0.795 //x2=8.815 //y2=0.67
r71 (  9 29 ) resistor r=18.139 //w=0.187 //l=0.265 //layer=li //thickness=0.1 \
 //x=8.815 //y=0.795 //x2=8.815 //y2=1.06
r72 (  6 29 ) resistor r=3.57586 //w=0.17 //l=0.103078 //layer=li \
 //thickness=0.1 //x=7.93 //y=1.76 //x2=7.845 //y2=1.8
r73 (  6 29 ) resistor r=27.3797 //w=0.187 //l=0.4 //layer=li //thickness=0.1 \
 //x=7.93 //y=1.76 //x2=8.33 //y2=1.76
r74 (  5 29 ) resistor r=3.57586 //w=0.17 //l=0.103078 //layer=li \
 //thickness=0.1 //x=8.73 //y=1.76 //x2=8.815 //y2=1.8
r75 (  5 29 ) resistor r=27.3797 //w=0.187 //l=0.4 //layer=li //thickness=0.1 \
 //x=8.73 //y=1.76 //x2=8.33 //y2=1.76
r76 (  1 29 ) resistor r=3.57586 //w=0.17 //l=0.125 //layer=li //thickness=0.1 \
 //x=7.845 //y=1.675 //x2=7.845 //y2=1.8
r77 (  1 29 ) resistor r=42.0963 //w=0.187 //l=0.615 //layer=li \
 //thickness=0.1 //x=7.845 //y=1.675 //x2=7.845 //y2=1.06
ends PM_AOA4X1\%noxref_12

subckt PM_AOA4X1\%Y ( 1 2 3 4 5 6 7 18 19 20 21 31 33 )
c43 ( 33 0 ) capacitor c=0.028734f //x=11.45 //y=5.2
c44 ( 31 0 ) capacitor c=0.0173218f //x=11.405 //y=1.09
c45 ( 21 0 ) capacitor c=0.00575887f //x=11.68 //y=4.76
c46 ( 20 0 ) capacitor c=0.0146395f //x=11.875 //y=4.76
c47 ( 19 0 ) capacitor c=0.00636159f //x=11.675 //y=2.26
c48 ( 18 0 ) capacitor c=0.0141837f //x=11.875 //y=2.26
c49 ( 1 0 ) capacitor c=0.105613f //x=11.96 //y=2.4
r50 (  20 23 ) resistor r=7.15173 //w=0.17 //l=0.120208 //layer=li \
 //thickness=0.1 //x=11.875 //y=4.76 //x2=11.96 //y2=4.675
r51 (  20 21 ) resistor r=13.3476 //w=0.187 //l=0.195 //layer=li \
 //thickness=0.1 //x=11.875 //y=4.76 //x2=11.68 //y2=4.76
r52 (  18 22 ) resistor r=7.15173 //w=0.17 //l=0.120208 //layer=li \
 //thickness=0.1 //x=11.875 //y=2.26 //x2=11.96 //y2=2.345
r53 (  18 19 ) resistor r=13.6898 //w=0.187 //l=0.2 //layer=li //thickness=0.1 \
 //x=11.875 //y=2.26 //x2=11.675 //y2=2.26
r54 (  12 21 ) resistor r=7.15173 //w=0.17 //l=0.120208 //layer=li \
 //thickness=0.1 //x=11.595 //y=4.845 //x2=11.68 //y2=4.76
r55 (  12 33 ) resistor r=72.5562 //w=0.187 //l=1.06 //layer=li \
 //thickness=0.1 //x=11.595 //y=4.845 //x2=11.595 //y2=5.905
r56 (  8 19 ) resistor r=7.15173 //w=0.17 //l=0.120208 //layer=li \
 //thickness=0.1 //x=11.59 //y=2.175 //x2=11.675 //y2=2.26
r57 (  8 31 ) resistor r=67.7647 //w=0.187 //l=0.99 //layer=li //thickness=0.1 \
 //x=11.59 //y=2.175 //x2=11.59 //y2=1.185
r58 (  7 23 ) resistor r=3.76471 //w=0.187 //l=0.055 //layer=li \
 //thickness=0.1 //x=11.96 //y=4.62 //x2=11.96 //y2=4.675
r59 (  6 7 ) resistor r=25.3262 //w=0.187 //l=0.37 //layer=li //thickness=0.1 \
 //x=11.96 //y=4.25 //x2=11.96 //y2=4.62
r60 (  5 6 ) resistor r=25.3262 //w=0.187 //l=0.37 //layer=li //thickness=0.1 \
 //x=11.96 //y=3.88 //x2=11.96 //y2=4.25
r61 (  4 5 ) resistor r=25.3262 //w=0.187 //l=0.37 //layer=li //thickness=0.1 \
 //x=11.96 //y=3.51 //x2=11.96 //y2=3.88
r62 (  3 4 ) resistor r=25.3262 //w=0.187 //l=0.37 //layer=li //thickness=0.1 \
 //x=11.96 //y=3.14 //x2=11.96 //y2=3.51
r63 (  2 3 ) resistor r=25.3262 //w=0.187 //l=0.37 //layer=li //thickness=0.1 \
 //x=11.96 //y=2.77 //x2=11.96 //y2=3.14
r64 (  1 2 ) resistor r=25.3262 //w=0.187 //l=0.37 //layer=li //thickness=0.1 \
 //x=11.96 //y=2.4 //x2=11.96 //y2=2.77
r65 (  1 22 ) resistor r=3.76471 //w=0.187 //l=0.055 //layer=li \
 //thickness=0.1 //x=11.96 //y=2.4 //x2=11.96 //y2=2.345
ends PM_AOA4X1\%Y
