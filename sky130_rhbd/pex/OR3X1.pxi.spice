// File: OR3X1.spi.OR3X1.pxi
// Created: Sun Mar 15 12:44:21 2026
//
simulator lang=spectre
x_PM_OR3X1\%noxref_1 ( N_noxref_1_c_1_p N_noxref_1_c_47_p N_noxref_1_c_2_p \
 N_noxref_1_c_70_p N_noxref_1_c_3_p N_noxref_1_c_50_p N_noxref_1_c_4_p \
 N_noxref_1_c_5_p N_noxref_1_c_33_p N_noxref_1_c_6_p N_noxref_1_c_108_p \
 N_noxref_1_c_130_p N_noxref_1_c_7_p N_noxref_1_c_109_p N_noxref_1_c_35_p \
 N_noxref_1_c_8_p N_noxref_1_c_102_p N_noxref_1_c_166_p N_noxref_1_c_72_p \
 N_noxref_1_c_9_p N_noxref_1_c_234_p N_noxref_1_c_10_p N_noxref_1_c_163_p \
 N_noxref_1_c_123_p N_noxref_1_c_37_p N_noxref_1_c_73_p N_noxref_1_c_11_p \
 N_noxref_1_c_103_p N_noxref_1_M3_noxref_g N_noxref_1_M10_noxref_g \
 N_noxref_1_M11_noxref_g N_noxref_1_c_30_p N_noxref_1_c_245_p \
 N_noxref_1_c_63_p N_noxref_1_c_39_p N_noxref_1_c_118_p N_noxref_1_c_115_p \
 N_noxref_1_c_65_p N_noxref_1_c_248_p N_noxref_1_c_32_p N_noxref_1_c_67_p \
 N_noxref_1_c_31_p N_noxref_1_M0_noxref_d N_noxref_1_M1_noxref_d \
 N_noxref_1_M2_noxref_d N_noxref_1_M8_noxref_d )  PM_OR3X1\%noxref_1
x_PM_OR3X1\%GND ( GND N_GND_c_277_n N_GND_c_291_n N_GND_c_294_n N_GND_c_298_n \
 N_GND_c_302_n N_GND_c_304_n N_GND_c_308_n N_GND_c_345_p N_GND_c_309_n \
 N_GND_c_317_n N_GND_M0_noxref_s N_GND_M3_noxref_s )  PM_OR3X1\%GND
x_PM_OR3X1\%noxref_3 ( N_noxref_3_c_396_n N_noxref_3_c_449_p \
 N_noxref_3_c_403_p N_noxref_3_c_398_n N_noxref_3_c_414_p N_noxref_3_c_425_p \
 N_noxref_3_c_404_p N_noxref_3_c_415_p N_noxref_3_M4_noxref_s \
 N_noxref_3_M5_noxref_d N_noxref_3_M7_noxref_d )  PM_OR3X1\%noxref_3
x_PM_OR3X1\%A ( A A A A A A A N_A_c_492_n N_A_c_533_n N_A_c_536_n N_A_c_495_n \
 N_A_M0_noxref_g N_A_M4_noxref_g N_A_M5_noxref_g N_A_c_498_n N_A_c_500_n \
 N_A_c_503_n N_A_c_504_n N_A_c_507_n N_A_c_509_n N_A_c_547_n N_A_c_512_n \
 N_A_c_514_n N_A_c_548_n )  PM_OR3X1\%A
x_PM_OR3X1\%VDD ( VDD N_VDD_c_636_n N_VDD_c_640_n N_VDD_c_646_n N_VDD_c_604_n \
 N_VDD_c_607_n N_VDD_c_633_n N_VDD_c_608_n N_VDD_c_611_n N_VDD_c_619_n \
 N_VDD_M4_noxref_d N_VDD_M10_noxref_s N_VDD_M11_noxref_d )  PM_OR3X1\%VDD
x_PM_OR3X1\%B ( B B B B B B B N_B_c_739_n N_B_c_741_n N_B_c_742_n N_B_c_778_n \
 N_B_M1_noxref_g N_B_M6_noxref_g N_B_M7_noxref_g N_B_c_743_n N_B_c_745_n \
 N_B_c_748_n N_B_c_857_p N_B_c_750_n N_B_c_752_n N_B_c_757_n N_B_c_759_n \
 N_B_c_762_n N_B_c_763_n N_B_c_786_n )  PM_OR3X1\%B
x_PM_OR3X1\%C ( C C C C C C C N_C_c_876_n N_C_c_880_n N_C_c_881_n N_C_c_886_n \
 N_C_M2_noxref_g N_C_M8_noxref_g N_C_M9_noxref_g N_C_c_895_n N_C_c_897_n \
 N_C_c_900_n N_C_c_902_n N_C_c_904_n N_C_c_906_n N_C_c_974_p N_C_c_910_n \
 N_C_c_912_n N_C_c_915_n N_C_c_918_n N_C_c_920_n )  PM_OR3X1\%C
x_PM_OR3X1\%noxref_8 ( N_noxref_8_c_983_n N_noxref_8_c_986_n \
 N_noxref_8_c_989_n N_noxref_8_c_993_n N_noxref_8_c_996_n N_noxref_8_c_997_n \
 N_noxref_8_c_1016_n N_noxref_8_c_999_n N_noxref_8_M6_noxref_d \
 N_noxref_8_M8_noxref_s N_noxref_8_M9_noxref_d )  PM_OR3X1\%noxref_8
x_PM_OR3X1\%Y ( Y Y Y Y Y Y Y N_Y_c_1084_n N_Y_c_1092_n N_Y_c_1096_n \
 N_Y_c_1097_n N_Y_c_1099_n N_Y_c_1100_n N_Y_c_1103_n N_Y_c_1110_n \
 N_Y_M3_noxref_d N_Y_M10_noxref_d )  PM_OR3X1\%Y
cc_1 ( N_noxref_1_c_1_p N_GND_c_277_n ) capacitor c=0.0100308f //x=1.67 \
 //y=1.31 //x2=6.78 //y2=0.18
cc_2 ( N_noxref_1_c_2_p N_GND_c_277_n ) capacitor c=0.00677967f //x=2.555 \
 //y=1.835 //x2=6.78 //y2=0.18
cc_3 ( N_noxref_1_c_3_p N_GND_c_277_n ) capacitor c=0.0100704f //x=2.64 \
 //y=1.31 //x2=6.78 //y2=0.18
cc_4 ( N_noxref_1_c_4_p N_GND_c_277_n ) capacitor c=0.00678034f //x=3.525 \
 //y=1.835 //x2=6.78 //y2=0.18
cc_5 ( N_noxref_1_c_5_p N_GND_c_277_n ) capacitor c=0.00984227f //x=3.61 \
 //y=1.325 //x2=6.78 //y2=0.18
cc_6 ( N_noxref_1_c_6_p N_GND_c_277_n ) capacitor c=0.00907904f //x=4.105 \
 //y=1.835 //x2=6.78 //y2=0.18
cc_7 ( N_noxref_1_c_7_p N_GND_c_277_n ) capacitor c=4.99521e-19 //x=4.19 \
 //y=3.67 //x2=6.78 //y2=0.18
cc_8 ( N_noxref_1_c_8_p N_GND_c_277_n ) capacitor c=4.49547e-19 //x=6.04 \
 //y=3.675 //x2=6.78 //y2=0.18
cc_9 ( N_noxref_1_c_9_p N_GND_c_277_n ) capacitor c=3.99312e-19 //x=4.19 \
 //y=3.51 //x2=6.78 //y2=0.18
cc_10 ( N_noxref_1_c_10_p N_GND_c_277_n ) capacitor c=0.00249122f //x=6.04 \
 //y=2.265 //x2=6.78 //y2=0.18
cc_11 ( N_noxref_1_c_11_p N_GND_c_277_n ) capacitor c=7.5371e-19 //x=6.04 \
 //y=2.265 //x2=6.78 //y2=0.18
cc_12 ( N_noxref_1_M0_noxref_d N_GND_c_277_n ) capacitor c=3.01769e-19 \
 //x=1.48 //y=1.085 //x2=6.78 //y2=0.18
cc_13 ( N_noxref_1_M1_noxref_d N_GND_c_277_n ) capacitor c=3.01769e-19 \
 //x=2.45 //y=1.085 //x2=6.78 //y2=0.18
cc_14 ( N_noxref_1_M2_noxref_d N_GND_c_277_n ) capacitor c=3.01769e-19 \
 //x=3.42 //y=1.085 //x2=6.78 //y2=0.18
cc_15 ( N_noxref_1_c_1_p N_GND_c_291_n ) capacitor c=0.00400023f //x=1.67 \
 //y=1.31 //x2=2.07 //y2=0.71
cc_16 ( N_noxref_1_c_2_p N_GND_c_291_n ) capacitor c=0.00128856f //x=2.555 \
 //y=1.835 //x2=2.07 //y2=0.71
cc_17 ( N_noxref_1_M0_noxref_d N_GND_c_291_n ) capacitor c=0.00910163f \
 //x=1.48 //y=1.085 //x2=2.07 //y2=0.71
cc_18 ( N_noxref_1_c_2_p N_GND_c_294_n ) capacitor c=0.0010475f //x=2.555 \
 //y=1.835 //x2=3.04 //y2=0.71
cc_19 ( N_noxref_1_c_3_p N_GND_c_294_n ) capacitor c=0.00431488f //x=2.64 \
 //y=1.31 //x2=3.04 //y2=0.71
cc_20 ( N_noxref_1_c_4_p N_GND_c_294_n ) capacitor c=0.00128856f //x=3.525 \
 //y=1.835 //x2=3.04 //y2=0.71
cc_21 ( N_noxref_1_M1_noxref_d N_GND_c_294_n ) capacitor c=0.00910163f \
 //x=2.45 //y=1.085 //x2=3.04 //y2=0.71
cc_22 ( N_noxref_1_c_4_p N_GND_c_298_n ) capacitor c=0.00176314f //x=3.525 \
 //y=1.835 //x2=4.01 //y2=0.71
cc_23 ( N_noxref_1_c_5_p N_GND_c_298_n ) capacitor c=0.00398909f //x=3.61 \
 //y=1.325 //x2=4.01 //y2=0.71
cc_24 ( N_noxref_1_c_6_p N_GND_c_298_n ) capacitor c=0.00348283f //x=4.105 \
 //y=1.835 //x2=4.01 //y2=0.71
cc_25 ( N_noxref_1_M2_noxref_d N_GND_c_298_n ) capacitor c=0.00910163f \
 //x=3.42 //y=1.085 //x2=4.01 //y2=0.71
cc_26 ( N_noxref_1_c_6_p N_GND_c_302_n ) capacitor c=3.15342e-19 //x=4.105 \
 //y=1.835 //x2=5.13 //y2=0.175
cc_27 ( N_noxref_1_c_7_p N_GND_c_302_n ) capacitor c=4.02528e-19 //x=4.19 \
 //y=3.67 //x2=5.13 //y2=0.175
cc_28 ( N_noxref_1_c_10_p N_GND_c_304_n ) capacitor c=0.00114179f //x=6.04 \
 //y=2.265 //x2=6.325 //y2=0.715
cc_29 ( N_noxref_1_c_11_p N_GND_c_304_n ) capacitor c=3.95714e-19 //x=6.04 \
 //y=2.265 //x2=6.325 //y2=0.715
cc_30 ( N_noxref_1_c_30_p N_GND_c_304_n ) capacitor c=0.0125549f //x=6.15 \
 //y=1.09 //x2=6.325 //y2=0.715
cc_31 ( N_noxref_1_c_31_p N_GND_c_304_n ) capacitor c=2.1838e-19 //x=6.04 \
 //y=2.265 //x2=6.325 //y2=0.715
cc_32 ( N_noxref_1_c_32_p N_GND_c_308_n ) capacitor c=0.0134289f //x=6.68 \
 //y=1.09 //x2=6.815 //y2=0.715
cc_33 ( N_noxref_1_c_33_p N_GND_c_309_n ) capacitor c=0.0025534f //x=3.61 \
 //y=1.75 //x2=5.3 //y2=0.175
cc_34 ( N_noxref_1_c_6_p N_GND_c_309_n ) capacitor c=0.0222089f //x=4.105 \
 //y=1.835 //x2=5.3 //y2=0.175
cc_35 ( N_noxref_1_c_35_p N_GND_c_309_n ) capacitor c=0.0111081f //x=6.04 \
 //y=3.355 //x2=5.3 //y2=0.175
cc_36 ( N_noxref_1_c_10_p N_GND_c_309_n ) capacitor c=0.00717107f //x=6.04 \
 //y=2.265 //x2=5.3 //y2=0.175
cc_37 ( N_noxref_1_c_37_p N_GND_c_309_n ) capacitor c=0.00560367f //x=5.88 \
 //y=3.515 //x2=5.3 //y2=0.175
cc_38 ( N_noxref_1_c_11_p N_GND_c_309_n ) capacitor c=0.00733236f //x=6.04 \
 //y=2.265 //x2=5.3 //y2=0.175
cc_39 ( N_noxref_1_c_39_p N_GND_c_309_n ) capacitor c=0.00570585f //x=6.15 \
 //y=2.1 //x2=5.3 //y2=0.175
cc_40 ( N_noxref_1_c_31_p N_GND_c_309_n ) capacitor c=0.00786308f //x=6.04 \
 //y=2.265 //x2=5.3 //y2=0.175
cc_41 ( N_noxref_1_c_1_p N_GND_c_317_n ) capacitor c=2.87802e-19 //x=1.67 \
 //y=1.31 //x2=6.9 //y2=0.175
cc_42 ( N_noxref_1_c_3_p N_GND_c_317_n ) capacitor c=2.87802e-19 //x=2.64 \
 //y=1.31 //x2=6.9 //y2=0.175
cc_43 ( N_noxref_1_c_5_p N_GND_c_317_n ) capacitor c=2.87802e-19 //x=3.61 \
 //y=1.325 //x2=6.9 //y2=0.175
cc_44 ( N_noxref_1_c_11_p N_GND_c_317_n ) capacitor c=0.0022444f //x=6.04 \
 //y=2.265 //x2=6.9 //y2=0.175
cc_45 ( N_noxref_1_c_31_p N_GND_c_317_n ) capacitor c=2.63786e-19 //x=6.04 \
 //y=2.265 //x2=6.9 //y2=0.175
cc_46 ( N_noxref_1_c_1_p N_GND_M0_noxref_s ) capacitor c=0.0106681f //x=1.67 \
 //y=1.31 //x2=1.05 //y2=0.545
cc_47 ( N_noxref_1_c_47_p N_GND_M0_noxref_s ) capacitor c=0.0281176f //x=1.67 \
 //y=1.75 //x2=1.05 //y2=0.545
cc_48 ( N_noxref_1_c_2_p N_GND_M0_noxref_s ) capacitor c=0.00857119f //x=2.555 \
 //y=1.835 //x2=1.05 //y2=0.545
cc_49 ( N_noxref_1_c_3_p N_GND_M0_noxref_s ) capacitor c=0.00695238f //x=2.64 \
 //y=1.31 //x2=1.05 //y2=0.545
cc_50 ( N_noxref_1_c_50_p N_GND_M0_noxref_s ) capacitor c=0.00901608f //x=2.64 \
 //y=1.75 //x2=1.05 //y2=0.545
cc_51 ( N_noxref_1_c_4_p N_GND_M0_noxref_s ) capacitor c=0.00884276f //x=3.525 \
 //y=1.835 //x2=1.05 //y2=0.545
cc_52 ( N_noxref_1_c_5_p N_GND_M0_noxref_s ) capacitor c=0.0101079f //x=3.61 \
 //y=1.325 //x2=1.05 //y2=0.545
cc_53 ( N_noxref_1_c_33_p N_GND_M0_noxref_s ) capacitor c=0.0103813f //x=3.61 \
 //y=1.75 //x2=1.05 //y2=0.545
cc_54 ( N_noxref_1_c_6_p N_GND_M0_noxref_s ) capacitor c=0.00860985f //x=4.105 \
 //y=1.835 //x2=1.05 //y2=0.545
cc_55 ( N_noxref_1_c_9_p N_GND_M0_noxref_s ) capacitor c=7.55526e-19 //x=4.19 \
 //y=3.51 //x2=1.05 //y2=0.545
cc_56 ( N_noxref_1_M0_noxref_d N_GND_M0_noxref_s ) capacitor c=0.0275007f \
 //x=1.48 //y=1.085 //x2=1.05 //y2=0.545
cc_57 ( N_noxref_1_M1_noxref_d N_GND_M0_noxref_s ) capacitor c=0.0274981f \
 //x=2.45 //y=1.085 //x2=1.05 //y2=0.545
cc_58 ( N_noxref_1_M2_noxref_d N_GND_M0_noxref_s ) capacitor c=0.0274983f \
 //x=3.42 //y=1.085 //x2=1.05 //y2=0.545
cc_59 ( N_noxref_1_c_8_p N_GND_M3_noxref_s ) capacitor c=8.07162e-19 //x=6.04 \
 //y=3.675 //x2=5.795 //y2=0.55
cc_60 ( N_noxref_1_c_10_p N_GND_M3_noxref_s ) capacitor c=0.00297876f //x=6.04 \
 //y=2.265 //x2=5.795 //y2=0.55
cc_61 ( N_noxref_1_c_11_p N_GND_M3_noxref_s ) capacitor c=0.00651326f //x=6.04 \
 //y=2.265 //x2=5.795 //y2=0.55
cc_62 ( N_noxref_1_c_30_p N_GND_M3_noxref_s ) capacitor c=0.030052f //x=6.15 \
 //y=1.09 //x2=5.795 //y2=0.55
cc_63 ( N_noxref_1_c_63_p N_GND_M3_noxref_s ) capacitor c=0.002132f //x=6.15 \
 //y=1.745 //x2=5.795 //y2=0.55
cc_64 ( N_noxref_1_c_39_p N_GND_M3_noxref_s ) capacitor c=0.00304786f //x=6.15 \
 //y=2.1 //x2=5.795 //y2=0.55
cc_65 ( N_noxref_1_c_65_p N_GND_M3_noxref_s ) capacitor c=0.00517463f \
 //x=6.525 //y=0.935 //x2=5.795 //y2=0.55
cc_66 ( N_noxref_1_c_32_p N_GND_M3_noxref_s ) capacitor c=0.0153553f //x=6.68 \
 //y=1.09 //x2=5.795 //y2=0.55
cc_67 ( N_noxref_1_c_67_p N_GND_M3_noxref_s ) capacitor c=0.00629878f //x=6.68 \
 //y=1.435 //x2=5.795 //y2=0.55
cc_68 ( N_noxref_1_c_31_p N_GND_M3_noxref_s ) capacitor c=0.00660555f //x=6.04 \
 //y=2.265 //x2=5.795 //y2=0.55
cc_69 ( N_noxref_1_c_1_p N_noxref_3_c_396_n ) capacitor c=2.38306e-19 //x=1.67 \
 //y=1.31 //x2=2.045 //y2=5.39
cc_70 ( N_noxref_1_c_70_p N_noxref_3_c_396_n ) capacitor c=0.00265006f \
 //x=1.755 //y=1.835 //x2=2.045 //y2=5.39
cc_71 ( N_noxref_1_c_2_p N_noxref_3_c_398_n ) capacitor c=0.00290517f \
 //x=2.555 //y=1.835 //x2=2.162 //y2=5.39
cc_72 ( N_noxref_1_c_72_p N_noxref_3_c_398_n ) capacitor c=0.00134451f \
 //x=4.19 //y=5.39 //x2=2.162 //y2=5.39
cc_73 ( N_noxref_1_c_73_p N_noxref_3_M7_noxref_d ) capacitor c=0.00395323f \
 //x=4.08 //y=5.9 //x2=2.895 //y2=5.205
cc_74 ( N_noxref_1_c_1_p N_A_c_492_n ) capacitor c=0.00147045f //x=1.67 \
 //y=1.31 //x2=1.6 //y2=2.425
cc_75 ( N_noxref_1_c_70_p N_A_c_492_n ) capacitor c=0.0171527f //x=1.755 \
 //y=1.835 //x2=1.6 //y2=2.425
cc_76 ( N_noxref_1_M0_noxref_d N_A_c_492_n ) capacitor c=0.00138074f //x=1.48 \
 //y=1.085 //x2=1.6 //y2=2.425
cc_77 ( N_noxref_1_c_1_p N_A_c_495_n ) capacitor c=7.07025e-19 //x=1.67 \
 //y=1.31 //x2=1.6 //y2=2.26
cc_78 ( N_noxref_1_c_70_p N_A_c_495_n ) capacitor c=0.00293491f //x=1.755 \
 //y=1.835 //x2=1.6 //y2=2.26
cc_79 ( N_noxref_1_M0_noxref_d N_A_c_495_n ) capacitor c=0.00150031f //x=1.48 \
 //y=1.085 //x2=1.6 //y2=2.26
cc_80 ( N_noxref_1_c_1_p N_A_c_498_n ) capacitor c=7.80351e-19 //x=1.67 \
 //y=1.31 //x2=1.405 //y2=1.085
cc_81 ( N_noxref_1_M0_noxref_d N_A_c_498_n ) capacitor c=8.46111e-19 //x=1.48 \
 //y=1.085 //x2=1.405 //y2=1.085
cc_82 ( N_noxref_1_c_1_p N_A_c_500_n ) capacitor c=0.00391325f //x=1.67 \
 //y=1.31 //x2=1.405 //y2=1.43
cc_83 ( N_noxref_1_c_47_p N_A_c_500_n ) capacitor c=0.00127432f //x=1.67 \
 //y=1.75 //x2=1.405 //y2=1.43
cc_84 ( N_noxref_1_M0_noxref_d N_A_c_500_n ) capacitor c=0.00237422f //x=1.48 \
 //y=1.085 //x2=1.405 //y2=1.43
cc_85 ( N_noxref_1_c_47_p N_A_c_503_n ) capacitor c=0.00350316f //x=1.67 \
 //y=1.75 //x2=1.405 //y2=1.74
cc_86 ( N_noxref_1_c_47_p N_A_c_504_n ) capacitor c=0.00379925f //x=1.67 \
 //y=1.75 //x2=1.405 //y2=2.095
cc_87 ( N_noxref_1_c_70_p N_A_c_504_n ) capacitor c=0.00113924f //x=1.755 \
 //y=1.835 //x2=1.405 //y2=2.095
cc_88 ( N_noxref_1_M0_noxref_d N_A_c_504_n ) capacitor c=4.64071e-19 //x=1.48 \
 //y=1.085 //x2=1.405 //y2=2.095
cc_89 ( N_noxref_1_c_1_p N_A_c_507_n ) capacitor c=5.34749e-19 //x=1.67 \
 //y=1.31 //x2=1.78 //y2=0.93
cc_90 ( N_noxref_1_M0_noxref_d N_A_c_507_n ) capacitor c=0.0020782f //x=1.48 \
 //y=1.085 //x2=1.78 //y2=0.93
cc_91 ( N_noxref_1_c_1_p N_A_c_509_n ) capacitor c=6.20502e-19 //x=1.67 \
 //y=1.31 //x2=1.78 //y2=1.585
cc_92 ( N_noxref_1_c_47_p N_A_c_509_n ) capacitor c=0.00702073f //x=1.67 \
 //y=1.75 //x2=1.78 //y2=1.585
cc_93 ( N_noxref_1_M0_noxref_d N_A_c_509_n ) capacitor c=0.00344131f //x=1.48 \
 //y=1.085 //x2=1.78 //y2=1.585
cc_94 ( N_noxref_1_c_1_p N_A_c_512_n ) capacitor c=9.60468e-19 //x=1.67 \
 //y=1.31 //x2=1.935 //y2=1.085
cc_95 ( N_noxref_1_M0_noxref_d N_A_c_512_n ) capacitor c=0.00139206f //x=1.48 \
 //y=1.085 //x2=1.935 //y2=1.085
cc_96 ( N_noxref_1_c_1_p N_A_c_514_n ) capacitor c=0.00221072f //x=1.67 \
 //y=1.31 //x2=1.935 //y2=1.43
cc_97 ( N_noxref_1_c_47_p N_A_c_514_n ) capacitor c=0.00253555f //x=1.67 \
 //y=1.75 //x2=1.935 //y2=1.43
cc_98 ( N_noxref_1_c_2_p N_A_c_514_n ) capacitor c=7.25274e-19 //x=2.555 \
 //y=1.835 //x2=1.935 //y2=1.43
cc_99 ( N_noxref_1_c_50_p N_A_c_514_n ) capacitor c=6.29838e-19 //x=2.64 \
 //y=1.75 //x2=1.935 //y2=1.43
cc_100 ( N_noxref_1_M0_noxref_d N_A_c_514_n ) capacitor c=0.00237422f //x=1.48 \
 //y=1.085 //x2=1.935 //y2=1.43
cc_101 ( N_noxref_1_c_8_p N_VDD_c_604_n ) capacitor c=2.57268e-19 //x=6.04 \
 //y=3.675 //x2=6.78 //y2=7.58
cc_102 ( N_noxref_1_c_102_p N_VDD_c_604_n ) capacitor c=5.73169e-19 //x=6.04 \
 //y=4.76 //x2=6.78 //y2=7.58
cc_103 ( N_noxref_1_c_103_p N_VDD_c_604_n ) capacitor c=3.40755e-19 //x=6.04 \
 //y=4.88 //x2=6.78 //y2=7.58
cc_104 ( N_noxref_1_c_73_p N_VDD_c_607_n ) capacitor c=0.00510208f //x=4.08 \
 //y=5.9 //x2=5.13 //y2=7.585
cc_105 ( N_noxref_1_c_102_p N_VDD_c_608_n ) capacitor c=5.48929e-19 //x=6.04 \
 //y=4.76 //x2=6.77 //y2=7.585
cc_106 ( N_noxref_1_M10_noxref_g N_VDD_c_608_n ) capacitor c=0.00753931f \
 //x=6.195 //y=6.2 //x2=6.77 //y2=7.585
cc_107 ( N_noxref_1_M11_noxref_g N_VDD_c_608_n ) capacitor c=0.00755544f \
 //x=6.635 //y=6.2 //x2=6.77 //y2=7.585
cc_108 ( N_noxref_1_c_108_p N_VDD_c_611_n ) capacitor c=0.00360403f //x=4.08 \
 //y=5.77 //x2=5.3 //y2=7.585
cc_109 ( N_noxref_1_c_109_p N_VDD_c_611_n ) capacitor c=0.0240178f //x=4.19 \
 //y=5.305 //x2=5.3 //y2=7.585
cc_110 ( N_noxref_1_c_102_p N_VDD_c_611_n ) capacitor c=0.0166244f //x=6.04 \
 //y=4.76 //x2=5.3 //y2=7.585
cc_111 ( N_noxref_1_c_37_p N_VDD_c_611_n ) capacitor c=0.00501359f //x=5.88 \
 //y=3.515 //x2=5.3 //y2=7.585
cc_112 ( N_noxref_1_c_73_p N_VDD_c_611_n ) capacitor c=0.0039206f //x=4.08 \
 //y=5.9 //x2=5.3 //y2=7.585
cc_113 ( N_noxref_1_c_103_p N_VDD_c_611_n ) capacitor c=0.00795384f //x=6.04 \
 //y=4.88 //x2=5.3 //y2=7.585
cc_114 ( N_noxref_1_M10_noxref_g N_VDD_c_611_n ) capacitor c=0.00873815f \
 //x=6.195 //y=6.2 //x2=5.3 //y2=7.585
cc_115 ( N_noxref_1_c_115_p N_VDD_c_611_n ) capacitor c=0.00799922f //x=6.27 \
 //y=4.97 //x2=5.3 //y2=7.585
cc_116 ( N_noxref_1_c_73_p N_VDD_c_619_n ) capacitor c=2.31538e-19 //x=4.08 \
 //y=5.9 //x2=6.78 //y2=7.58
cc_117 ( N_noxref_1_c_103_p N_VDD_c_619_n ) capacitor c=0.00241457f //x=6.04 \
 //y=4.88 //x2=6.78 //y2=7.58
cc_118 ( N_noxref_1_c_118_p N_VDD_c_619_n ) capacitor c=0.0174926f //x=6.56 \
 //y=4.97 //x2=6.78 //y2=7.58
cc_119 ( N_noxref_1_c_108_p N_VDD_M10_noxref_s ) capacitor c=0.00538961f \
 //x=4.08 //y=5.77 //x2=5.84 //y2=5.2
cc_120 ( N_noxref_1_c_8_p N_VDD_M10_noxref_s ) capacitor c=0.00120003f \
 //x=6.04 //y=3.675 //x2=5.84 //y2=5.2
cc_121 ( N_noxref_1_c_102_p N_VDD_M10_noxref_s ) capacitor c=0.0211603f \
 //x=6.04 //y=4.76 //x2=5.84 //y2=5.2
cc_122 ( N_noxref_1_c_72_p N_VDD_M10_noxref_s ) capacitor c=0.00235342f \
 //x=4.19 //y=5.39 //x2=5.84 //y2=5.2
cc_123 ( N_noxref_1_c_123_p N_VDD_M10_noxref_s ) capacitor c=4.26343e-19 \
 //x=6.04 //y=3.515 //x2=5.84 //y2=5.2
cc_124 ( N_noxref_1_c_37_p N_VDD_M10_noxref_s ) capacitor c=2.12313e-19 \
 //x=5.88 //y=3.515 //x2=5.84 //y2=5.2
cc_125 ( N_noxref_1_c_103_p N_VDD_M10_noxref_s ) capacitor c=0.00986169f \
 //x=6.04 //y=4.88 //x2=5.84 //y2=5.2
cc_126 ( N_noxref_1_M10_noxref_g N_VDD_M10_noxref_s ) capacitor c=0.0573441f \
 //x=6.195 //y=6.2 //x2=5.84 //y2=5.2
cc_127 ( N_noxref_1_c_115_p N_VDD_M10_noxref_s ) capacitor c=0.00524544f \
 //x=6.27 //y=4.97 //x2=5.84 //y2=5.2
cc_128 ( N_noxref_1_c_108_p N_VDD_M11_noxref_d ) capacitor c=5.58798e-19 \
 //x=4.08 //y=5.77 //x2=6.71 //y2=5.2
cc_129 ( N_noxref_1_M11_noxref_g N_VDD_M11_noxref_d ) capacitor c=0.0572684f \
 //x=6.635 //y=6.2 //x2=6.71 //y2=5.2
cc_130 ( N_noxref_1_c_130_p B ) capacitor c=0.00186546f //x=4.19 //y=3.35 \
 //x2=2.34 //y2=2.4
cc_131 ( N_noxref_1_c_109_p B ) capacitor c=0.00193455f //x=4.19 //y=5.305 \
 //x2=2.34 //y2=2.4
cc_132 ( N_noxref_1_c_2_p N_B_c_739_n ) capacitor c=0.030811f //x=2.555 \
 //y=1.835 //x2=2.34 //y2=2.39
cc_133 ( N_noxref_1_c_130_p N_B_c_739_n ) capacitor c=3.05675e-19 //x=4.19 \
 //y=3.35 //x2=2.34 //y2=2.39
cc_134 ( N_noxref_1_c_2_p N_B_c_741_n ) capacitor c=3.68612e-19 //x=2.555 \
 //y=1.835 //x2=2.34 //y2=4.74
cc_135 ( N_noxref_1_c_2_p N_B_c_742_n ) capacitor c=0.00494851f //x=2.555 \
 //y=1.835 //x2=2.34 //y2=2.26
cc_136 ( N_noxref_1_c_3_p N_B_c_743_n ) capacitor c=8.454e-19 //x=2.64 \
 //y=1.31 //x2=2.375 //y2=1.085
cc_137 ( N_noxref_1_M1_noxref_d N_B_c_743_n ) capacitor c=8.51904e-19 //x=2.45 \
 //y=1.085 //x2=2.375 //y2=1.085
cc_138 ( N_noxref_1_c_3_p N_B_c_745_n ) capacitor c=0.00221072f //x=2.64 \
 //y=1.31 //x2=2.375 //y2=1.435
cc_139 ( N_noxref_1_c_50_p N_B_c_745_n ) capacitor c=7.7986e-19 //x=2.64 \
 //y=1.75 //x2=2.375 //y2=1.435
cc_140 ( N_noxref_1_M1_noxref_d N_B_c_745_n ) capacitor c=0.00237422f //x=2.45 \
 //y=1.085 //x2=2.375 //y2=1.435
cc_141 ( N_noxref_1_c_47_p N_B_c_748_n ) capacitor c=6.83023e-19 //x=1.67 \
 //y=1.75 //x2=2.375 //y2=1.74
cc_142 ( N_noxref_1_c_50_p N_B_c_748_n ) capacitor c=0.00253868f //x=2.64 \
 //y=1.75 //x2=2.375 //y2=1.74
cc_143 ( N_noxref_1_c_3_p N_B_c_750_n ) capacitor c=5.42035e-19 //x=2.64 \
 //y=1.31 //x2=2.75 //y2=0.93
cc_144 ( N_noxref_1_M1_noxref_d N_B_c_750_n ) capacitor c=0.0020782f //x=2.45 \
 //y=1.085 //x2=2.75 //y2=0.93
cc_145 ( N_noxref_1_c_3_p N_B_c_752_n ) capacitor c=7.84428e-19 //x=2.64 \
 //y=1.31 //x2=2.75 //y2=1.585
cc_146 ( N_noxref_1_c_50_p N_B_c_752_n ) capacitor c=0.00845712f //x=2.64 \
 //y=1.75 //x2=2.75 //y2=1.585
cc_147 ( N_noxref_1_c_4_p N_B_c_752_n ) capacitor c=7.25274e-19 //x=3.525 \
 //y=1.835 //x2=2.75 //y2=1.585
cc_148 ( N_noxref_1_c_33_p N_B_c_752_n ) capacitor c=6.29838e-19 //x=3.61 \
 //y=1.75 //x2=2.75 //y2=1.585
cc_149 ( N_noxref_1_M1_noxref_d N_B_c_752_n ) capacitor c=0.00356097f //x=2.45 \
 //y=1.085 //x2=2.75 //y2=1.585
cc_150 ( N_noxref_1_c_3_p N_B_c_757_n ) capacitor c=7.61925e-19 //x=2.64 \
 //y=1.31 //x2=2.905 //y2=1.085
cc_151 ( N_noxref_1_M1_noxref_d N_B_c_757_n ) capacitor c=8.55887e-19 //x=2.45 \
 //y=1.085 //x2=2.905 //y2=1.085
cc_152 ( N_noxref_1_c_3_p N_B_c_759_n ) capacitor c=0.00220852f //x=2.64 \
 //y=1.31 //x2=2.905 //y2=1.435
cc_153 ( N_noxref_1_c_50_p N_B_c_759_n ) capacitor c=7.7986e-19 //x=2.64 \
 //y=1.75 //x2=2.905 //y2=1.435
cc_154 ( N_noxref_1_M1_noxref_d N_B_c_759_n ) capacitor c=0.00237422f //x=2.45 \
 //y=1.085 //x2=2.905 //y2=1.435
cc_155 ( N_noxref_1_c_2_p N_B_c_762_n ) capacitor c=0.00139093f //x=2.555 \
 //y=1.835 //x2=2.34 //y2=2.26
cc_156 ( N_noxref_1_c_2_p N_B_c_763_n ) capacitor c=0.00778097f //x=2.555 \
 //y=1.835 //x2=2.34 //y2=2.095
cc_157 ( N_noxref_1_c_130_p C ) capacitor c=0.0435221f //x=4.19 //y=3.35 \
 //x2=3.45 //y2=2.77
cc_158 ( N_noxref_1_c_7_p C ) capacitor c=0.0148501f //x=4.19 //y=3.67 \
 //x2=3.45 //y2=2.77
cc_159 ( N_noxref_1_c_109_p C ) capacitor c=0.0505949f //x=4.19 //y=5.305 \
 //x2=3.45 //y2=2.77
cc_160 ( N_noxref_1_c_35_p C ) capacitor c=0.00210601f //x=6.04 //y=3.355 \
 //x2=3.45 //y2=2.77
cc_161 ( N_noxref_1_c_102_p C ) capacitor c=0.00211352f //x=6.04 //y=4.76 \
 //x2=3.45 //y2=2.77
cc_162 ( N_noxref_1_c_9_p C ) capacitor c=6.03895e-19 //x=4.19 //y=3.51 \
 //x2=3.45 //y2=2.77
cc_163 ( N_noxref_1_c_163_p C ) capacitor c=0.006875f //x=4.35 //y=3.51 \
 //x2=3.45 //y2=2.77
cc_164 ( N_noxref_1_c_4_p N_C_c_876_n ) capacitor c=0.0286697f //x=3.525 \
 //y=1.835 //x2=3.45 //y2=2.405
cc_165 ( N_noxref_1_c_130_p N_C_c_876_n ) capacitor c=0.0161611f //x=4.19 \
 //y=3.35 //x2=3.45 //y2=2.405
cc_166 ( N_noxref_1_c_166_p N_C_c_876_n ) capacitor c=0.00327478f //x=3.61 \
 //y=1.835 //x2=3.45 //y2=2.405
cc_167 ( N_noxref_1_M2_noxref_d N_C_c_876_n ) capacitor c=8.91766e-19 //x=3.42 \
 //y=1.085 //x2=3.45 //y2=2.405
cc_168 ( N_noxref_1_c_109_p N_C_c_880_n ) capacitor c=0.0162663f //x=4.19 \
 //y=5.305 //x2=3.45 //y2=4.765
cc_169 ( N_noxref_1_c_4_p N_C_c_881_n ) capacitor c=0.00451545f //x=3.525 \
 //y=1.835 //x2=3.45 //y2=2.26
cc_170 ( N_noxref_1_c_5_p N_C_c_881_n ) capacitor c=2.35917e-19 //x=3.61 \
 //y=1.325 //x2=3.45 //y2=2.26
cc_171 ( N_noxref_1_c_130_p N_C_c_881_n ) capacitor c=0.00112301f //x=4.19 \
 //y=3.35 //x2=3.45 //y2=2.26
cc_172 ( N_noxref_1_c_166_p N_C_c_881_n ) capacitor c=0.00154812f //x=3.61 \
 //y=1.835 //x2=3.45 //y2=2.26
cc_173 ( N_noxref_1_M2_noxref_d N_C_c_881_n ) capacitor c=5.40451e-19 //x=3.42 \
 //y=1.085 //x2=3.45 //y2=2.26
cc_174 ( N_noxref_1_c_109_p N_C_c_886_n ) capacitor c=0.00154968f //x=4.19 \
 //y=5.305 //x2=3.45 //y2=4.885
cc_175 ( N_noxref_1_c_108_p N_C_M8_noxref_g ) capacitor c=0.00140876f //x=4.08 \
 //y=5.77 //x2=3.86 //y2=6.205
cc_176 ( N_noxref_1_c_109_p N_C_M8_noxref_g ) capacitor c=0.00478791f //x=4.19 \
 //y=5.305 //x2=3.86 //y2=6.205
cc_177 ( N_noxref_1_c_72_p N_C_M8_noxref_g ) capacitor c=0.00234737f //x=4.19 \
 //y=5.39 //x2=3.86 //y2=6.205
cc_178 ( N_noxref_1_c_73_p N_C_M8_noxref_g ) capacitor c=0.00896756f //x=4.08 \
 //y=5.9 //x2=3.86 //y2=6.205
cc_179 ( N_noxref_1_c_108_p N_C_M9_noxref_g ) capacitor c=0.00767663f //x=4.08 \
 //y=5.77 //x2=4.3 //y2=6.205
cc_180 ( N_noxref_1_c_109_p N_C_M9_noxref_g ) capacitor c=0.00397952f //x=4.19 \
 //y=5.305 //x2=4.3 //y2=6.205
cc_181 ( N_noxref_1_c_72_p N_C_M9_noxref_g ) capacitor c=0.00430799f //x=4.19 \
 //y=5.39 //x2=4.3 //y2=6.205
cc_182 ( N_noxref_1_c_73_p N_C_M9_noxref_g ) capacitor c=0.00896756f //x=4.08 \
 //y=5.9 //x2=4.3 //y2=6.205
cc_183 ( N_noxref_1_c_5_p N_C_c_895_n ) capacitor c=0.00114203f //x=3.61 \
 //y=1.325 //x2=3.345 //y2=1.085
cc_184 ( N_noxref_1_M2_noxref_d N_C_c_895_n ) capacitor c=0.00145956f //x=3.42 \
 //y=1.085 //x2=3.345 //y2=1.085
cc_185 ( N_noxref_1_c_5_p N_C_c_897_n ) capacitor c=0.00235402f //x=3.61 \
 //y=1.325 //x2=3.345 //y2=1.435
cc_186 ( N_noxref_1_c_33_p N_C_c_897_n ) capacitor c=7.7986e-19 //x=3.61 \
 //y=1.75 //x2=3.345 //y2=1.435
cc_187 ( N_noxref_1_M2_noxref_d N_C_c_897_n ) capacitor c=0.00237422f //x=3.42 \
 //y=1.085 //x2=3.345 //y2=1.435
cc_188 ( N_noxref_1_c_50_p N_C_c_900_n ) capacitor c=0.00120307f //x=2.64 \
 //y=1.75 //x2=3.345 //y2=1.74
cc_189 ( N_noxref_1_c_33_p N_C_c_900_n ) capacitor c=0.0030633f //x=3.61 \
 //y=1.75 //x2=3.345 //y2=1.74
cc_190 ( N_noxref_1_c_4_p N_C_c_902_n ) capacitor c=0.00915686f //x=3.525 \
 //y=1.835 //x2=3.345 //y2=2.095
cc_191 ( N_noxref_1_c_130_p N_C_c_902_n ) capacitor c=0.00300603f //x=4.19 \
 //y=3.35 //x2=3.345 //y2=2.095
cc_192 ( N_noxref_1_c_5_p N_C_c_904_n ) capacitor c=5.45609e-19 //x=3.61 \
 //y=1.325 //x2=3.72 //y2=0.93
cc_193 ( N_noxref_1_M2_noxref_d N_C_c_904_n ) capacitor c=0.0020782f //x=3.42 \
 //y=1.085 //x2=3.72 //y2=0.93
cc_194 ( N_noxref_1_c_5_p N_C_c_906_n ) capacitor c=4.1601e-19 //x=3.61 \
 //y=1.325 //x2=3.72 //y2=1.585
cc_195 ( N_noxref_1_c_33_p N_C_c_906_n ) capacitor c=0.00913324f //x=3.61 \
 //y=1.75 //x2=3.72 //y2=1.585
cc_196 ( N_noxref_1_c_6_p N_C_c_906_n ) capacitor c=0.0045388f //x=4.105 \
 //y=1.835 //x2=3.72 //y2=1.585
cc_197 ( N_noxref_1_M2_noxref_d N_C_c_906_n ) capacitor c=0.003549f //x=3.42 \
 //y=1.085 //x2=3.72 //y2=1.585
cc_198 ( N_noxref_1_c_5_p N_C_c_910_n ) capacitor c=9.74621e-19 //x=3.61 \
 //y=1.325 //x2=3.875 //y2=1.085
cc_199 ( N_noxref_1_M2_noxref_d N_C_c_910_n ) capacitor c=8.55887e-19 //x=3.42 \
 //y=1.085 //x2=3.875 //y2=1.085
cc_200 ( N_noxref_1_c_5_p N_C_c_912_n ) capacitor c=0.00376484f //x=3.61 \
 //y=1.325 //x2=3.875 //y2=1.435
cc_201 ( N_noxref_1_c_33_p N_C_c_912_n ) capacitor c=0.0012183f //x=3.61 \
 //y=1.75 //x2=3.875 //y2=1.435
cc_202 ( N_noxref_1_M2_noxref_d N_C_c_912_n ) capacitor c=0.00237422f //x=3.42 \
 //y=1.085 //x2=3.875 //y2=1.435
cc_203 ( N_noxref_1_c_109_p N_C_c_915_n ) capacitor c=0.00829075f //x=4.19 \
 //y=5.305 //x2=4.225 //y2=4.975
cc_204 ( N_noxref_1_c_72_p N_C_c_915_n ) capacitor c=0.00139519f //x=4.19 \
 //y=5.39 //x2=4.225 //y2=4.975
cc_205 ( N_noxref_1_c_73_p N_C_c_915_n ) capacitor c=0.00157916f //x=4.08 \
 //y=5.9 //x2=4.225 //y2=4.975
cc_206 ( N_noxref_1_c_4_p N_C_c_918_n ) capacitor c=0.00129562f //x=3.525 \
 //y=1.835 //x2=3.345 //y2=2.26
cc_207 ( N_noxref_1_c_130_p N_C_c_918_n ) capacitor c=0.00278769f //x=4.19 \
 //y=3.35 //x2=3.345 //y2=2.26
cc_208 ( N_noxref_1_c_109_p N_C_c_920_n ) capacitor c=0.00140919f //x=4.19 \
 //y=5.305 //x2=3.45 //y2=4.885
cc_209 ( N_noxref_1_c_3_p N_noxref_8_c_983_n ) capacitor c=2.03695e-19 \
 //x=2.64 //y=1.31 //x2=3.555 //y2=5.39
cc_210 ( N_noxref_1_c_4_p N_noxref_8_c_983_n ) capacitor c=0.00500529f \
 //x=3.525 //y=1.835 //x2=3.555 //y2=5.39
cc_211 ( N_noxref_1_c_72_p N_noxref_8_c_983_n ) capacitor c=0.0174982f \
 //x=4.19 //y=5.39 //x2=3.555 //y2=5.39
cc_212 ( N_noxref_1_c_6_p N_noxref_8_c_986_n ) capacitor c=3.49767e-19 \
 //x=4.105 //y=1.835 //x2=3.64 //y2=5.77
cc_213 ( N_noxref_1_c_108_p N_noxref_8_c_986_n ) capacitor c=0.0578031f \
 //x=4.08 //y=5.77 //x2=3.64 //y2=5.77
cc_214 ( N_noxref_1_c_73_p N_noxref_8_c_986_n ) capacitor c=0.00432732f \
 //x=4.08 //y=5.9 //x2=3.64 //y2=5.77
cc_215 ( N_noxref_1_c_108_p N_noxref_8_c_989_n ) capacitor c=0.00731192f \
 //x=4.08 //y=5.77 //x2=4.405 //y2=7.09
cc_216 ( N_noxref_1_c_7_p N_noxref_8_c_989_n ) capacitor c=5.02595e-19 \
 //x=4.19 //y=3.67 //x2=4.405 //y2=7.09
cc_217 ( N_noxref_1_c_72_p N_noxref_8_c_989_n ) capacitor c=0.00145412f \
 //x=4.19 //y=5.39 //x2=4.405 //y2=7.09
cc_218 ( N_noxref_1_c_73_p N_noxref_8_c_989_n ) capacitor c=0.00368853f \
 //x=4.08 //y=5.9 //x2=4.405 //y2=7.09
cc_219 ( N_noxref_1_c_2_p N_noxref_8_c_993_n ) capacitor c=0.00522451f \
 //x=2.555 //y=1.835 //x2=2.6 //y2=5.39
cc_220 ( N_noxref_1_c_3_p N_noxref_8_c_993_n ) capacitor c=2.29432e-19 \
 //x=2.64 //y=1.31 //x2=2.6 //y2=5.39
cc_221 ( N_noxref_1_c_108_p N_noxref_8_c_993_n ) capacitor c=0.00100155f \
 //x=4.08 //y=5.77 //x2=2.6 //y2=5.39
cc_222 ( N_noxref_1_c_73_p N_noxref_8_c_996_n ) capacitor c=8.19351e-19 \
 //x=4.08 //y=5.9 //x2=3.64 //y2=6.92
cc_223 ( N_noxref_1_c_7_p N_noxref_8_c_997_n ) capacitor c=2.85695e-19 \
 //x=4.19 //y=3.67 //x2=4.52 //y2=6.92
cc_224 ( N_noxref_1_c_73_p N_noxref_8_c_997_n ) capacitor c=8.19351e-19 \
 //x=4.08 //y=5.9 //x2=4.52 //y2=6.92
cc_225 ( N_noxref_1_c_108_p N_noxref_8_c_999_n ) capacitor c=0.00425215f \
 //x=4.08 //y=5.77 //x2=3.64 //y2=5.9
cc_226 ( N_noxref_1_c_73_p N_noxref_8_c_999_n ) capacitor c=0.0524362f \
 //x=4.08 //y=5.9 //x2=3.64 //y2=5.9
cc_227 ( N_noxref_1_c_108_p N_noxref_8_M9_noxref_d ) capacitor c=0.00783481f \
 //x=4.08 //y=5.77 //x2=4.375 //y2=5.205
cc_228 ( N_noxref_1_c_73_p N_noxref_8_M9_noxref_d ) capacitor c=0.0481518f \
 //x=4.08 //y=5.9 //x2=4.375 //y2=5.205
cc_229 ( N_noxref_1_c_130_p Y ) capacitor c=0.00260832f //x=4.19 //y=3.35 \
 //x2=6.78 //y2=2.4
cc_230 ( N_noxref_1_c_109_p Y ) capacitor c=0.00267317f //x=4.19 //y=5.305 \
 //x2=6.78 //y2=2.4
cc_231 ( N_noxref_1_c_35_p Y ) capacitor c=0.0425276f //x=6.04 //y=3.355 \
 //x2=6.78 //y2=2.4
cc_232 ( N_noxref_1_c_8_p Y ) capacitor c=0.0149195f //x=6.04 //y=3.675 \
 //x2=6.78 //y2=2.4
cc_233 ( N_noxref_1_c_102_p Y ) capacitor c=0.0570666f //x=6.04 //y=4.76 \
 //x2=6.78 //y2=2.4
cc_234 ( N_noxref_1_c_234_p Y ) capacitor c=0.00541027f //x=6.04 //y=3.51 \
 //x2=6.78 //y2=2.4
cc_235 ( N_noxref_1_c_10_p Y ) capacitor c=0.00825076f //x=6.04 //y=2.265 \
 //x2=6.78 //y2=2.4
cc_236 ( N_noxref_1_c_123_p Y ) capacitor c=0.006875f //x=6.04 //y=3.515 \
 //x2=6.78 //y2=2.4
cc_237 ( N_noxref_1_c_11_p Y ) capacitor c=0.0023016f //x=6.04 //y=2.265 \
 //x2=6.78 //y2=2.4
cc_238 ( N_noxref_1_c_103_p Y ) capacitor c=0.00250262f //x=6.04 //y=4.88 \
 //x2=6.78 //y2=2.4
cc_239 ( N_noxref_1_c_118_p Y ) capacitor c=4.08297e-19 //x=6.56 //y=4.97 \
 //x2=6.78 //y2=2.4
cc_240 ( N_noxref_1_c_115_p Y ) capacitor c=0.00124564f //x=6.27 //y=4.97 \
 //x2=6.78 //y2=2.4
cc_241 ( N_noxref_1_c_31_p Y ) capacitor c=0.00112403f //x=6.04 //y=2.265 \
 //x2=6.78 //y2=2.4
cc_242 ( N_noxref_1_c_50_p N_Y_c_1084_n ) capacitor c=5.90929e-19 //x=2.64 \
 //y=1.75 //x2=6.41 //y2=1.935
cc_243 ( N_noxref_1_c_33_p N_Y_c_1084_n ) capacitor c=0.00365555f //x=3.61 \
 //y=1.75 //x2=6.41 //y2=1.935
cc_244 ( N_noxref_1_c_6_p N_Y_c_1084_n ) capacitor c=0.00276776f //x=4.105 \
 //y=1.835 //x2=6.41 //y2=1.935
cc_245 ( N_noxref_1_c_245_p N_Y_c_1084_n ) capacitor c=0.00115244f //x=6.15 \
 //y=1.435 //x2=6.41 //y2=1.935
cc_246 ( N_noxref_1_c_63_p N_Y_c_1084_n ) capacitor c=0.00537549f //x=6.15 \
 //y=1.745 //x2=6.41 //y2=1.935
cc_247 ( N_noxref_1_c_39_p N_Y_c_1084_n ) capacitor c=0.00392604f //x=6.15 \
 //y=2.1 //x2=6.41 //y2=1.935
cc_248 ( N_noxref_1_c_248_p N_Y_c_1084_n ) capacitor c=0.00946302f //x=6.525 \
 //y=1.59 //x2=6.41 //y2=1.935
cc_249 ( N_noxref_1_c_67_p N_Y_c_1084_n ) capacitor c=0.00362207f //x=6.68 \
 //y=1.435 //x2=6.41 //y2=1.935
cc_250 ( N_noxref_1_c_108_p N_Y_c_1092_n ) capacitor c=8.16881e-19 //x=4.08 \
 //y=5.77 //x2=6.415 //y2=5.42
cc_251 ( N_noxref_1_c_72_p N_Y_c_1092_n ) capacitor c=0.00193209f //x=4.19 \
 //y=5.39 //x2=6.415 //y2=5.42
cc_252 ( N_noxref_1_M10_noxref_g N_Y_c_1092_n ) capacitor c=0.00141266f \
 //x=6.195 //y=6.2 //x2=6.415 //y2=5.42
cc_253 ( N_noxref_1_M11_noxref_g N_Y_c_1092_n ) capacitor c=0.00377331f \
 //x=6.635 //y=6.2 //x2=6.415 //y2=5.42
cc_254 ( N_noxref_1_c_248_p N_Y_c_1096_n ) capacitor c=0.00180253f //x=6.525 \
 //y=1.59 //x2=6.695 //y2=2.02
cc_255 ( N_noxref_1_c_130_p N_Y_c_1097_n ) capacitor c=0.00276776f //x=4.19 \
 //y=3.35 //x2=6.495 //y2=2.02
cc_256 ( N_noxref_1_c_31_p N_Y_c_1097_n ) capacitor c=0.00392604f //x=6.04 \
 //y=2.265 //x2=6.495 //y2=2.02
cc_257 ( N_noxref_1_M11_noxref_g N_Y_c_1099_n ) capacitor c=0.00966342f \
 //x=6.635 //y=6.2 //x2=6.695 //y2=5.14
cc_258 ( N_noxref_1_c_109_p N_Y_c_1100_n ) capacitor c=0.00193209f //x=4.19 \
 //y=5.305 //x2=6.5 //y2=5.14
cc_259 ( N_noxref_1_M10_noxref_g N_Y_c_1100_n ) capacitor c=0.0045573f \
 //x=6.195 //y=6.2 //x2=6.5 //y2=5.14
cc_260 ( N_noxref_1_c_118_p N_Y_c_1100_n ) capacitor c=0.00262283f //x=6.56 \
 //y=4.97 //x2=6.5 //y2=5.14
cc_261 ( N_noxref_1_c_5_p N_Y_c_1103_n ) capacitor c=0.00560743f //x=3.61 \
 //y=1.325 //x2=6.41 //y2=1.185
cc_262 ( N_noxref_1_c_30_p N_Y_c_1103_n ) capacitor c=0.00179658f //x=6.15 \
 //y=1.09 //x2=6.41 //y2=1.185
cc_263 ( N_noxref_1_c_245_p N_Y_c_1103_n ) capacitor c=0.00374613f //x=6.15 \
 //y=1.435 //x2=6.41 //y2=1.185
cc_264 ( N_noxref_1_c_65_p N_Y_c_1103_n ) capacitor c=5.57924e-19 //x=6.525 \
 //y=0.935 //x2=6.41 //y2=1.185
cc_265 ( N_noxref_1_c_248_p N_Y_c_1103_n ) capacitor c=5.75878e-19 //x=6.525 \
 //y=1.59 //x2=6.41 //y2=1.185
cc_266 ( N_noxref_1_c_32_p N_Y_c_1103_n ) capacitor c=0.00160969f //x=6.68 \
 //y=1.09 //x2=6.41 //y2=1.185
cc_267 ( N_noxref_1_c_67_p N_Y_c_1103_n ) capacitor c=0.00411132f //x=6.68 \
 //y=1.435 //x2=6.41 //y2=1.185
cc_268 ( N_noxref_1_M10_noxref_g N_Y_c_1110_n ) capacitor c=0.0162066f \
 //x=6.195 //y=6.2 //x2=6.415 //y2=5.56
cc_269 ( N_noxref_1_M11_noxref_g N_Y_c_1110_n ) capacitor c=0.0162066f \
 //x=6.635 //y=6.2 //x2=6.415 //y2=5.56
cc_270 ( N_noxref_1_c_118_p N_Y_c_1110_n ) capacitor c=0.00290963f //x=6.56 \
 //y=4.97 //x2=6.415 //y2=5.56
cc_271 ( N_noxref_1_c_30_p N_Y_M3_noxref_d ) capacitor c=0.00137914f //x=6.15 \
 //y=1.09 //x2=6.225 //y2=1.09
cc_272 ( N_noxref_1_c_245_p N_Y_M3_noxref_d ) capacitor c=0.0023891f //x=6.15 \
 //y=1.435 //x2=6.225 //y2=1.09
cc_273 ( N_noxref_1_c_65_p N_Y_M3_noxref_d ) capacitor c=0.0020782f //x=6.525 \
 //y=0.935 //x2=6.225 //y2=1.09
cc_274 ( N_noxref_1_c_248_p N_Y_M3_noxref_d ) capacitor c=0.00356097f \
 //x=6.525 //y=1.59 //x2=6.225 //y2=1.09
cc_275 ( N_noxref_1_c_32_p N_Y_M3_noxref_d ) capacitor c=0.00138452f //x=6.68 \
 //y=1.09 //x2=6.225 //y2=1.09
cc_276 ( N_noxref_1_c_67_p N_Y_M3_noxref_d ) capacitor c=0.00235934f //x=6.68 \
 //y=1.435 //x2=6.225 //y2=1.09
cc_277 ( N_GND_c_345_p A ) capacitor c=0.0119787f //x=1.23 //y=0.18 //x2=1.6 \
 //y2=2.77
cc_278 ( N_GND_c_277_n N_A_c_492_n ) capacitor c=7.00629e-19 //x=6.78 //y=0.18 \
 //x2=1.6 //y2=2.425
cc_279 ( N_GND_c_291_n N_A_c_492_n ) capacitor c=9.81943e-19 //x=2.07 //y=0.71 \
 //x2=1.6 //y2=2.425
cc_280 ( N_GND_c_345_p N_A_c_492_n ) capacitor c=0.00920582f //x=1.23 //y=0.18 \
 //x2=1.6 //y2=2.425
cc_281 ( N_GND_c_291_n N_A_c_495_n ) capacitor c=4.19546e-19 //x=2.07 //y=0.71 \
 //x2=1.6 //y2=2.26
cc_282 ( N_GND_c_345_p N_A_c_495_n ) capacitor c=0.00368165f //x=1.23 //y=0.18 \
 //x2=1.6 //y2=2.26
cc_283 ( N_GND_c_291_n N_A_c_498_n ) capacitor c=0.0209625f //x=2.07 //y=0.71 \
 //x2=1.405 //y2=1.085
cc_284 ( N_GND_M0_noxref_s N_A_c_498_n ) capacitor c=0.033078f //x=1.05 \
 //y=0.545 //x2=1.405 //y2=1.085
cc_285 ( N_GND_c_291_n N_A_c_504_n ) capacitor c=2.1838e-19 //x=2.07 //y=0.71 \
 //x2=1.405 //y2=2.095
cc_286 ( N_GND_c_345_p N_A_c_504_n ) capacitor c=0.0121558f //x=1.23 //y=0.18 \
 //x2=1.405 //y2=2.095
cc_287 ( N_GND_c_291_n N_A_c_512_n ) capacitor c=0.00805599f //x=2.07 //y=0.71 \
 //x2=1.935 //y2=1.085
cc_288 ( N_GND_M0_noxref_s N_A_c_512_n ) capacitor c=0.00617417f //x=1.05 \
 //y=0.545 //x2=1.935 //y2=1.085
cc_289 ( N_GND_M0_noxref_s N_A_c_514_n ) capacitor c=0.00120103f //x=1.05 \
 //y=0.545 //x2=1.935 //y2=1.43
cc_290 ( N_GND_c_345_p N_VDD_c_633_n ) capacitor c=0.00989514f //x=1.23 \
 //y=0.18 //x2=1.23 //y2=7.58
cc_291 ( N_GND_c_309_n N_VDD_c_611_n ) capacitor c=0.00912573f //x=5.3 \
 //y=0.175 //x2=5.3 //y2=7.585
cc_292 ( N_GND_c_317_n N_VDD_c_619_n ) capacitor c=0.00989514f //x=6.9 \
 //y=0.175 //x2=6.78 //y2=7.58
cc_293 ( N_GND_c_294_n N_B_c_739_n ) capacitor c=6.15173e-19 //x=3.04 //y=0.71 \
 //x2=2.34 //y2=2.39
cc_294 ( N_GND_c_294_n N_B_c_742_n ) capacitor c=9.05712e-19 //x=3.04 //y=0.71 \
 //x2=2.34 //y2=2.26
cc_295 ( N_GND_c_345_p N_B_c_742_n ) capacitor c=5.03552e-19 //x=1.23 //y=0.18 \
 //x2=2.34 //y2=2.26
cc_296 ( N_GND_c_309_n N_B_c_742_n ) capacitor c=2.74946e-19 //x=5.3 //y=0.175 \
 //x2=2.34 //y2=2.26
cc_297 ( N_GND_c_294_n N_B_c_743_n ) capacitor c=0.0207598f //x=3.04 //y=0.71 \
 //x2=2.375 //y2=1.085
cc_298 ( N_GND_M0_noxref_s N_B_c_743_n ) capacitor c=0.00732593f //x=1.05 \
 //y=0.545 //x2=2.375 //y2=1.085
cc_299 ( N_GND_M0_noxref_s N_B_c_752_n ) capacitor c=0.00120679f //x=1.05 \
 //y=0.545 //x2=2.75 //y2=1.585
cc_300 ( N_GND_c_294_n N_B_c_757_n ) capacitor c=0.00805599f //x=3.04 //y=0.71 \
 //x2=2.905 //y2=1.085
cc_301 ( N_GND_M0_noxref_s N_B_c_757_n ) capacitor c=0.00617003f //x=1.05 \
 //y=0.545 //x2=2.905 //y2=1.085
cc_302 ( N_GND_c_294_n N_B_c_762_n ) capacitor c=2.1838e-19 //x=3.04 //y=0.71 \
 //x2=2.34 //y2=2.26
cc_303 ( N_GND_M0_noxref_s N_B_c_762_n ) capacitor c=0.0011812f //x=1.05 \
 //y=0.545 //x2=2.34 //y2=2.26
cc_304 ( N_GND_c_298_n N_C_c_876_n ) capacitor c=7.66217e-19 //x=4.01 //y=0.71 \
 //x2=3.45 //y2=2.405
cc_305 ( N_GND_c_298_n N_C_c_881_n ) capacitor c=0.00100208f //x=4.01 //y=0.71 \
 //x2=3.45 //y2=2.26
cc_306 ( N_GND_c_309_n N_C_c_881_n ) capacitor c=0.00172597f //x=5.3 //y=0.175 \
 //x2=3.45 //y2=2.26
cc_307 ( N_GND_c_298_n N_C_c_895_n ) capacitor c=0.0208435f //x=4.01 //y=0.71 \
 //x2=3.345 //y2=1.085
cc_308 ( N_GND_M0_noxref_s N_C_c_895_n ) capacitor c=0.00732593f //x=1.05 \
 //y=0.545 //x2=3.345 //y2=1.085
cc_309 ( N_GND_M0_noxref_s N_C_c_906_n ) capacitor c=0.00271091f //x=1.05 \
 //y=0.545 //x2=3.72 //y2=1.585
cc_310 ( N_GND_c_298_n N_C_c_910_n ) capacitor c=0.00825432f //x=4.01 //y=0.71 \
 //x2=3.875 //y2=1.085
cc_311 ( N_GND_M0_noxref_s N_C_c_910_n ) capacitor c=0.0143707f //x=1.05 \
 //y=0.545 //x2=3.875 //y2=1.085
cc_312 ( N_GND_c_298_n N_C_c_918_n ) capacitor c=2.1838e-19 //x=4.01 //y=0.71 \
 //x2=3.345 //y2=2.26
cc_313 ( N_GND_c_309_n N_Y_c_1084_n ) capacitor c=0.00364638f //x=5.3 \
 //y=0.175 //x2=6.41 //y2=1.935
cc_314 ( N_GND_c_317_n N_Y_c_1084_n ) capacitor c=0.00174147f //x=6.9 \
 //y=0.175 //x2=6.41 //y2=1.935
cc_315 ( N_GND_M3_noxref_s N_Y_c_1084_n ) capacitor c=0.033207f //x=5.795 \
 //y=0.55 //x2=6.41 //y2=1.935
cc_316 ( N_GND_c_277_n N_Y_c_1096_n ) capacitor c=0.00497604f //x=6.78 \
 //y=0.18 //x2=6.695 //y2=2.02
cc_317 ( N_GND_c_308_n N_Y_c_1096_n ) capacitor c=0.00321695f //x=6.815 \
 //y=0.715 //x2=6.695 //y2=2.02
cc_318 ( N_GND_c_317_n N_Y_c_1096_n ) capacitor c=0.030726f //x=6.9 //y=0.175 \
 //x2=6.695 //y2=2.02
cc_319 ( N_GND_M3_noxref_s N_Y_c_1096_n ) capacitor c=0.00565821f //x=5.795 \
 //y=0.55 //x2=6.695 //y2=2.02
cc_320 ( N_GND_c_277_n N_Y_c_1103_n ) capacitor c=0.00998676f //x=6.78 \
 //y=0.18 //x2=6.41 //y2=1.185
cc_321 ( N_GND_c_304_n N_Y_c_1103_n ) capacitor c=0.00124813f //x=6.325 \
 //y=0.715 //x2=6.41 //y2=1.185
cc_322 ( N_GND_c_308_n N_Y_c_1103_n ) capacitor c=0.00130539f //x=6.815 \
 //y=0.715 //x2=6.41 //y2=1.185
cc_323 ( N_GND_c_317_n N_Y_c_1103_n ) capacitor c=2.8029e-19 //x=6.9 //y=0.175 \
 //x2=6.41 //y2=1.185
cc_324 ( N_GND_M3_noxref_s N_Y_c_1103_n ) capacitor c=0.0160891f //x=5.795 \
 //y=0.55 //x2=6.41 //y2=1.185
cc_325 ( N_GND_c_277_n N_Y_M3_noxref_d ) capacitor c=0.00119455f //x=6.78 \
 //y=0.18 //x2=6.225 //y2=1.09
cc_326 ( N_GND_c_317_n N_Y_M3_noxref_d ) capacitor c=2.70835e-19 //x=6.9 \
 //y=0.175 //x2=6.225 //y2=1.09
cc_327 ( N_GND_M3_noxref_s N_Y_M3_noxref_d ) capacitor c=0.0377642f //x=5.795 \
 //y=0.55 //x2=6.225 //y2=1.09
cc_328 ( N_noxref_3_c_396_n N_A_c_492_n ) capacitor c=3.49728e-19 //x=2.045 \
 //y=5.39 //x2=1.6 //y2=2.425
cc_329 ( N_noxref_3_c_396_n N_A_c_533_n ) capacitor c=0.00780885f //x=2.045 \
 //y=5.39 //x2=1.445 //y2=4.885
cc_330 ( N_noxref_3_c_403_p N_A_c_533_n ) capacitor c=0.0239345f //x=1.282 \
 //y=5.39 //x2=1.445 //y2=4.885
cc_331 ( N_noxref_3_c_404_p N_A_c_533_n ) capacitor c=0.0022154f //x=1.28 \
 //y=5.56 //x2=1.445 //y2=4.885
cc_332 ( N_noxref_3_c_396_n N_A_c_536_n ) capacitor c=0.00104675f //x=2.045 \
 //y=5.39 //x2=1.445 //y2=4.885
cc_333 ( N_noxref_3_c_403_p N_A_c_536_n ) capacitor c=0.00565893f //x=1.282 \
 //y=5.39 //x2=1.445 //y2=4.885
cc_334 ( N_noxref_3_c_404_p N_A_c_536_n ) capacitor c=0.00126834f //x=1.28 \
 //y=5.56 //x2=1.445 //y2=4.885
cc_335 ( N_noxref_3_c_396_n N_A_M4_noxref_g ) capacitor c=0.00997309f \
 //x=2.045 //y=5.39 //x2=1.5 //y2=6.205
cc_336 ( N_noxref_3_c_403_p N_A_M4_noxref_g ) capacitor c=0.00429908f \
 //x=1.282 //y=5.39 //x2=1.5 //y2=6.205
cc_337 ( N_noxref_3_c_404_p N_A_M4_noxref_g ) capacitor c=0.0483843f //x=1.28 \
 //y=5.56 //x2=1.5 //y2=6.205
cc_338 ( N_noxref_3_M4_noxref_s N_A_M4_noxref_g ) capacitor c=0.00370227f \
 //x=1.145 //y=5.205 //x2=1.5 //y2=6.205
cc_339 ( N_noxref_3_c_396_n N_A_M5_noxref_g ) capacitor c=0.00967464f \
 //x=2.045 //y=5.39 //x2=1.94 //y2=6.205
cc_340 ( N_noxref_3_c_398_n N_A_M5_noxref_g ) capacitor c=0.00182852f \
 //x=2.162 //y=5.39 //x2=1.94 //y2=6.205
cc_341 ( N_noxref_3_c_414_p N_A_M5_noxref_g ) capacitor c=0.00175452f //x=2.16 \
 //y=6.92 //x2=1.94 //y2=6.205
cc_342 ( N_noxref_3_c_415_p N_A_M5_noxref_g ) capacitor c=0.0170175f //x=2.16 \
 //y=5.56 //x2=1.94 //y2=6.205
cc_343 ( N_noxref_3_c_396_n N_A_c_547_n ) capacitor c=0.00196455f //x=2.045 \
 //y=5.39 //x2=1.865 //y2=4.975
cc_344 ( N_noxref_3_c_403_p N_A_c_548_n ) capacitor c=9.17057e-19 //x=1.282 \
 //y=5.39 //x2=1.445 //y2=4.885
cc_345 ( N_noxref_3_c_404_p N_A_c_548_n ) capacitor c=0.00297041f //x=1.28 \
 //y=5.56 //x2=1.445 //y2=4.885
cc_346 ( N_noxref_3_c_396_n N_VDD_c_636_n ) capacitor c=0.00186824f //x=2.045 \
 //y=5.39 //x2=1.635 //y2=7.585
cc_347 ( N_noxref_3_c_403_p N_VDD_c_636_n ) capacitor c=3.02242e-19 //x=1.282 \
 //y=5.39 //x2=1.635 //y2=7.585
cc_348 ( N_noxref_3_c_404_p N_VDD_c_636_n ) capacitor c=0.00240365f //x=1.28 \
 //y=5.56 //x2=1.635 //y2=7.585
cc_349 ( N_noxref_3_M4_noxref_s N_VDD_c_636_n ) capacitor c=0.0245525f \
 //x=1.145 //y=5.205 //x2=1.635 //y2=7.585
cc_350 ( N_noxref_3_c_396_n N_VDD_c_640_n ) capacitor c=0.00496034f //x=2.045 \
 //y=5.39 //x2=1.72 //y2=7.035
cc_351 ( N_noxref_3_c_414_p N_VDD_c_640_n ) capacitor c=0.0375632f //x=2.16 \
 //y=6.92 //x2=1.72 //y2=7.035
cc_352 ( N_noxref_3_c_425_p N_VDD_c_640_n ) capacitor c=6.22236e-19 //x=3.04 \
 //y=6.92 //x2=1.72 //y2=7.035
cc_353 ( N_noxref_3_c_404_p N_VDD_c_640_n ) capacitor c=0.00220362f //x=1.28 \
 //y=5.56 //x2=1.72 //y2=7.035
cc_354 ( N_noxref_3_c_415_p N_VDD_c_640_n ) capacitor c=0.00220362f //x=2.16 \
 //y=5.56 //x2=1.72 //y2=7.035
cc_355 ( N_noxref_3_M4_noxref_s N_VDD_c_640_n ) capacitor c=0.0381427f \
 //x=1.145 //y=5.205 //x2=1.72 //y2=7.035
cc_356 ( N_noxref_3_c_414_p N_VDD_c_646_n ) capacitor c=0.0104314f //x=2.16 \
 //y=6.92 //x2=1.72 //y2=7.41
cc_357 ( N_noxref_3_c_404_p N_VDD_c_646_n ) capacitor c=0.00158506f //x=1.28 \
 //y=5.56 //x2=1.72 //y2=7.41
cc_358 ( N_noxref_3_c_415_p N_VDD_c_646_n ) capacitor c=4.62894e-19 //x=2.16 \
 //y=5.56 //x2=1.72 //y2=7.41
cc_359 ( N_noxref_3_M4_noxref_s N_VDD_c_646_n ) capacitor c=0.0121524f \
 //x=1.145 //y=5.205 //x2=1.72 //y2=7.41
cc_360 ( N_noxref_3_c_396_n N_VDD_c_604_n ) capacitor c=0.00198782f //x=2.045 \
 //y=5.39 //x2=6.78 //y2=7.58
cc_361 ( N_noxref_3_c_414_p N_VDD_c_604_n ) capacitor c=0.0975061f //x=2.16 \
 //y=6.92 //x2=6.78 //y2=7.58
cc_362 ( N_noxref_3_c_425_p N_VDD_c_604_n ) capacitor c=0.00214997f //x=3.04 \
 //y=6.92 //x2=6.78 //y2=7.58
cc_363 ( N_noxref_3_c_415_p N_VDD_c_604_n ) capacitor c=0.00205411f //x=2.16 \
 //y=5.56 //x2=6.78 //y2=7.58
cc_364 ( N_noxref_3_M7_noxref_d N_VDD_c_604_n ) capacitor c=0.00206569f \
 //x=2.895 //y=5.205 //x2=6.78 //y2=7.58
cc_365 ( N_noxref_3_c_396_n N_VDD_c_607_n ) capacitor c=0.00432819f //x=2.045 \
 //y=5.39 //x2=5.13 //y2=7.585
cc_366 ( N_noxref_3_c_403_p N_VDD_c_607_n ) capacitor c=2.31341e-19 //x=1.282 \
 //y=5.39 //x2=5.13 //y2=7.585
cc_367 ( N_noxref_3_c_414_p N_VDD_c_607_n ) capacitor c=0.0204588f //x=2.16 \
 //y=6.92 //x2=5.13 //y2=7.585
cc_368 ( N_noxref_3_c_425_p N_VDD_c_607_n ) capacitor c=0.00106071f //x=3.04 \
 //y=6.92 //x2=5.13 //y2=7.585
cc_369 ( N_noxref_3_c_404_p N_VDD_c_607_n ) capacitor c=0.0126473f //x=1.28 \
 //y=5.56 //x2=5.13 //y2=7.585
cc_370 ( N_noxref_3_c_415_p N_VDD_c_607_n ) capacitor c=0.0085453f //x=2.16 \
 //y=5.56 //x2=5.13 //y2=7.585
cc_371 ( N_noxref_3_M4_noxref_s N_VDD_c_607_n ) capacitor c=0.00292136f \
 //x=1.145 //y=5.205 //x2=5.13 //y2=7.585
cc_372 ( N_noxref_3_M7_noxref_d N_VDD_c_607_n ) capacitor c=0.00856914f \
 //x=2.895 //y=5.205 //x2=5.13 //y2=7.585
cc_373 ( N_noxref_3_c_403_p N_VDD_c_633_n ) capacitor c=0.0100761f //x=1.282 \
 //y=5.39 //x2=1.23 //y2=7.58
cc_374 ( N_noxref_3_c_404_p N_VDD_c_633_n ) capacitor c=0.0554809f //x=1.28 \
 //y=5.56 //x2=1.23 //y2=7.58
cc_375 ( N_noxref_3_M4_noxref_s N_VDD_c_633_n ) capacitor c=0.00790985f \
 //x=1.145 //y=5.205 //x2=1.23 //y2=7.58
cc_376 ( N_noxref_3_c_449_p N_VDD_c_619_n ) capacitor c=0.00221878f //x=2.925 \
 //y=7.09 //x2=6.78 //y2=7.58
cc_377 ( N_noxref_3_c_414_p N_VDD_c_619_n ) capacitor c=0.00112916f //x=2.16 \
 //y=6.92 //x2=6.78 //y2=7.58
cc_378 ( N_noxref_3_c_425_p N_VDD_c_619_n ) capacitor c=0.00112713f //x=3.04 \
 //y=6.92 //x2=6.78 //y2=7.58
cc_379 ( N_noxref_3_c_404_p N_VDD_c_619_n ) capacitor c=0.00161681f //x=1.28 \
 //y=5.56 //x2=6.78 //y2=7.58
cc_380 ( N_noxref_3_c_415_p N_VDD_c_619_n ) capacitor c=0.00100828f //x=2.16 \
 //y=5.56 //x2=6.78 //y2=7.58
cc_381 ( N_noxref_3_M4_noxref_s N_VDD_c_619_n ) capacitor c=0.00129282f \
 //x=1.145 //y=5.205 //x2=6.78 //y2=7.58
cc_382 ( N_noxref_3_M7_noxref_d N_VDD_c_619_n ) capacitor c=0.00100487f \
 //x=2.895 //y=5.205 //x2=6.78 //y2=7.58
cc_383 ( N_noxref_3_c_396_n N_VDD_M4_noxref_d ) capacitor c=0.00667051f \
 //x=2.045 //y=5.39 //x2=1.575 //y2=5.205
cc_384 ( N_noxref_3_c_414_p N_VDD_M4_noxref_d ) capacitor c=0.00466156f \
 //x=2.16 //y=6.92 //x2=1.575 //y2=5.205
cc_385 ( N_noxref_3_c_404_p N_VDD_M4_noxref_d ) capacitor c=0.0736776f \
 //x=1.28 //y=5.56 //x2=1.575 //y2=5.205
cc_386 ( N_noxref_3_c_415_p N_VDD_M4_noxref_d ) capacitor c=0.0670838f \
 //x=2.16 //y=5.56 //x2=1.575 //y2=5.205
cc_387 ( N_noxref_3_M4_noxref_s N_VDD_M4_noxref_d ) capacitor c=0.00566948f \
 //x=1.145 //y=5.205 //x2=1.575 //y2=5.205
cc_388 ( N_noxref_3_c_398_n N_B_c_739_n ) capacitor c=6.32666e-19 //x=2.162 \
 //y=5.39 //x2=2.34 //y2=2.39
cc_389 ( N_noxref_3_c_449_p N_B_c_741_n ) capacitor c=0.00230547f //x=2.925 \
 //y=7.09 //x2=2.34 //y2=4.74
cc_390 ( N_noxref_3_c_398_n N_B_c_741_n ) capacitor c=0.00148837f //x=2.162 \
 //y=5.39 //x2=2.34 //y2=4.74
cc_391 ( N_noxref_3_c_449_p N_B_c_778_n ) capacitor c=0.00233465f //x=2.925 \
 //y=7.09 //x2=2.375 //y2=4.885
cc_392 ( N_noxref_3_c_449_p N_B_M6_noxref_g ) capacitor c=0.00778083f \
 //x=2.925 //y=7.09 //x2=2.38 //y2=6.205
cc_393 ( N_noxref_3_c_398_n N_B_M6_noxref_g ) capacitor c=0.0018192f //x=2.162 \
 //y=5.39 //x2=2.38 //y2=6.205
cc_394 ( N_noxref_3_c_414_p N_B_M6_noxref_g ) capacitor c=0.0018046f //x=2.16 \
 //y=6.92 //x2=2.38 //y2=6.205
cc_395 ( N_noxref_3_c_415_p N_B_M6_noxref_g ) capacitor c=0.0170175f //x=2.16 \
 //y=5.56 //x2=2.38 //y2=6.205
cc_396 ( N_noxref_3_c_449_p N_B_M7_noxref_g ) capacitor c=0.00843033f \
 //x=2.925 //y=7.09 //x2=2.82 //y2=6.205
cc_397 ( N_noxref_3_c_425_p N_B_M7_noxref_g ) capacitor c=0.00272866f //x=3.04 \
 //y=6.92 //x2=2.82 //y2=6.205
cc_398 ( N_noxref_3_M7_noxref_d N_B_M7_noxref_g ) capacitor c=0.0231499f \
 //x=2.895 //y=5.205 //x2=2.82 //y2=6.205
cc_399 ( N_noxref_3_c_398_n N_B_c_786_n ) capacitor c=6.56606e-19 //x=2.162 \
 //y=5.39 //x2=2.375 //y2=4.885
cc_400 ( N_noxref_3_c_449_p N_noxref_8_c_983_n ) capacitor c=0.00321697f \
 //x=2.925 //y=7.09 //x2=3.555 //y2=5.39
cc_401 ( N_noxref_3_c_425_p N_noxref_8_c_983_n ) capacitor c=0.00503384f \
 //x=3.04 //y=6.92 //x2=3.555 //y2=5.39
cc_402 ( N_noxref_3_M7_noxref_d N_noxref_8_c_983_n ) capacitor c=0.00659996f \
 //x=2.895 //y=5.205 //x2=3.555 //y2=5.39
cc_403 ( N_noxref_3_c_398_n N_noxref_8_c_986_n ) capacitor c=8.51609e-19 \
 //x=2.162 //y=5.39 //x2=3.64 //y2=5.77
cc_404 ( N_noxref_3_M7_noxref_d N_noxref_8_c_986_n ) capacitor c=0.00726094f \
 //x=2.895 //y=5.205 //x2=3.64 //y2=5.77
cc_405 ( N_noxref_3_c_449_p N_noxref_8_c_993_n ) capacitor c=0.00515028f \
 //x=2.925 //y=7.09 //x2=2.6 //y2=5.39
cc_406 ( N_noxref_3_c_403_p N_noxref_8_c_993_n ) capacitor c=6.44186e-19 \
 //x=1.282 //y=5.39 //x2=2.6 //y2=5.39
cc_407 ( N_noxref_3_c_398_n N_noxref_8_c_993_n ) capacitor c=0.0526233f \
 //x=2.162 //y=5.39 //x2=2.6 //y2=5.39
cc_408 ( N_noxref_3_c_415_p N_noxref_8_c_993_n ) capacitor c=0.00261162f \
 //x=2.16 //y=5.56 //x2=2.6 //y2=5.39
cc_409 ( N_noxref_3_c_414_p N_noxref_8_c_996_n ) capacitor c=4.26669e-19 \
 //x=2.16 //y=6.92 //x2=3.64 //y2=6.92
cc_410 ( N_noxref_3_c_425_p N_noxref_8_c_996_n ) capacitor c=0.036549f \
 //x=3.04 //y=6.92 //x2=3.64 //y2=6.92
cc_411 ( N_noxref_3_M7_noxref_d N_noxref_8_c_996_n ) capacitor c=0.00418103f \
 //x=2.895 //y=5.205 //x2=3.64 //y2=6.92
cc_412 ( N_noxref_3_c_425_p N_noxref_8_c_997_n ) capacitor c=4.2596e-19 \
 //x=3.04 //y=6.92 //x2=4.52 //y2=6.92
cc_413 ( N_noxref_3_c_449_p N_noxref_8_c_1016_n ) capacitor c=0.00406191f \
 //x=2.925 //y=7.09 //x2=2.6 //y2=5.56
cc_414 ( N_noxref_3_c_398_n N_noxref_8_c_1016_n ) capacitor c=0.00396335f \
 //x=2.162 //y=5.39 //x2=2.6 //y2=5.56
cc_415 ( N_noxref_3_c_415_p N_noxref_8_c_1016_n ) capacitor c=0.0679433f \
 //x=2.16 //y=5.56 //x2=2.6 //y2=5.56
cc_416 ( N_noxref_3_M7_noxref_d N_noxref_8_c_1016_n ) capacitor c=0.0468918f \
 //x=2.895 //y=5.205 //x2=2.6 //y2=5.56
cc_417 ( N_noxref_3_c_425_p N_noxref_8_c_999_n ) capacitor c=0.00161703f \
 //x=3.04 //y=6.92 //x2=3.64 //y2=5.9
cc_418 ( N_noxref_3_M7_noxref_d N_noxref_8_c_999_n ) capacitor c=0.0468546f \
 //x=2.895 //y=5.205 //x2=3.64 //y2=5.9
cc_419 ( N_A_M4_noxref_g N_VDD_c_640_n ) capacitor c=0.0012542f //x=1.5 \
 //y=6.205 //x2=1.72 //y2=7.035
cc_420 ( N_A_M5_noxref_g N_VDD_c_640_n ) capacitor c=0.0012542f //x=1.94 \
 //y=6.205 //x2=1.72 //y2=7.035
cc_421 ( N_A_M4_noxref_g N_VDD_c_646_n ) capacitor c=0.00205385f //x=1.5 \
 //y=6.205 //x2=1.72 //y2=7.41
cc_422 ( N_A_M5_noxref_g N_VDD_c_646_n ) capacitor c=0.00294739f //x=1.94 \
 //y=6.205 //x2=1.72 //y2=7.41
cc_423 ( N_A_M4_noxref_g N_VDD_c_607_n ) capacitor c=0.00720181f //x=1.5 \
 //y=6.205 //x2=5.13 //y2=7.585
cc_424 ( N_A_M5_noxref_g N_VDD_c_607_n ) capacitor c=0.00760847f //x=1.94 \
 //y=6.205 //x2=5.13 //y2=7.585
cc_425 ( A N_VDD_c_633_n ) capacitor c=0.0113632f //x=1.6 //y=2.77 //x2=1.23 \
 //y2=7.58
cc_426 ( N_A_c_533_n N_VDD_c_633_n ) capacitor c=0.00509436f //x=1.445 \
 //y=4.885 //x2=1.23 //y2=7.58
cc_427 ( N_A_c_536_n N_VDD_c_633_n ) capacitor c=0.00639333f //x=1.445 \
 //y=4.885 //x2=1.23 //y2=7.58
cc_428 ( N_A_M4_noxref_g N_VDD_c_633_n ) capacitor c=0.0165754f //x=1.5 \
 //y=6.205 //x2=1.23 //y2=7.58
cc_429 ( N_A_c_548_n N_VDD_c_633_n ) capacitor c=0.00542539f //x=1.445 \
 //y=4.885 //x2=1.23 //y2=7.58
cc_430 ( N_A_M4_noxref_g N_VDD_M4_noxref_d ) capacitor c=0.0130453f //x=1.5 \
 //y=6.205 //x2=1.575 //y2=5.205
cc_431 ( N_A_M5_noxref_g N_VDD_M4_noxref_d ) capacitor c=0.0146888f //x=1.94 \
 //y=6.205 //x2=1.575 //y2=5.205
cc_432 ( N_A_c_547_n N_VDD_M4_noxref_d ) capacitor c=0.00248632f //x=1.865 \
 //y=4.975 //x2=1.575 //y2=5.205
cc_433 ( A B ) capacitor c=0.0596757f //x=1.6 //y=2.77 //x2=2.34 //y2=2.4
cc_434 ( N_A_c_492_n B ) capacitor c=0.00271206f //x=1.6 //y=2.425 //x2=2.34 \
 //y2=2.4
cc_435 ( N_A_c_492_n N_B_c_739_n ) capacitor c=0.0198635f //x=1.6 //y=2.425 \
 //x2=2.34 //y2=2.39
cc_436 ( N_A_c_495_n N_B_c_739_n ) capacitor c=6.64673e-19 //x=1.6 //y=2.26 \
 //x2=2.34 //y2=2.39
cc_437 ( N_A_c_504_n N_B_c_739_n ) capacitor c=0.00160374f //x=1.405 //y=2.095 \
 //x2=2.34 //y2=2.39
cc_438 ( N_A_c_533_n N_B_c_741_n ) capacitor c=0.0621267f //x=1.445 //y=4.885 \
 //x2=2.34 //y2=4.74
cc_439 ( N_A_c_536_n N_B_c_741_n ) capacitor c=8.14108e-19 //x=1.445 //y=4.885 \
 //x2=2.34 //y2=4.74
cc_440 ( N_A_c_547_n N_B_c_741_n ) capacitor c=7.4344e-19 //x=1.865 //y=4.975 \
 //x2=2.34 //y2=4.74
cc_441 ( N_A_c_492_n N_B_c_742_n ) capacitor c=0.00412829f //x=1.6 //y=2.425 \
 //x2=2.34 //y2=2.26
cc_442 ( N_A_c_495_n N_B_c_742_n ) capacitor c=0.00444996f //x=1.6 //y=2.26 \
 //x2=2.34 //y2=2.26
cc_443 ( N_A_c_504_n N_B_c_742_n ) capacitor c=0.00284386f //x=1.405 //y=2.095 \
 //x2=2.34 //y2=2.26
cc_444 ( A N_B_c_778_n ) capacitor c=0.0023775f //x=1.6 //y=2.77 //x2=2.375 \
 //y2=4.885
cc_445 ( N_A_c_533_n N_B_c_778_n ) capacitor c=0.00153582f //x=1.445 //y=4.885 \
 //x2=2.375 //y2=4.885
cc_446 ( N_A_c_536_n N_B_c_778_n ) capacitor c=0.00234902f //x=1.445 //y=4.885 \
 //x2=2.375 //y2=4.885
cc_447 ( N_A_c_547_n N_B_c_778_n ) capacitor c=0.00112509f //x=1.865 //y=4.975 \
 //x2=2.375 //y2=4.885
cc_448 ( N_A_c_548_n N_B_c_778_n ) capacitor c=0.00121814f //x=1.445 //y=4.885 \
 //x2=2.375 //y2=4.885
cc_449 ( N_A_M4_noxref_g N_B_M6_noxref_g ) capacitor c=0.0101077f //x=1.5 \
 //y=6.205 //x2=2.38 //y2=6.205
cc_450 ( N_A_M5_noxref_g N_B_M6_noxref_g ) capacitor c=0.109254f //x=1.94 \
 //y=6.205 //x2=2.38 //y2=6.205
cc_451 ( N_A_M5_noxref_g N_B_M7_noxref_g ) capacitor c=0.00945018f //x=1.94 \
 //y=6.205 //x2=2.82 //y2=6.205
cc_452 ( N_A_c_498_n N_B_c_743_n ) capacitor c=0.00128177f //x=1.405 //y=1.085 \
 //x2=2.375 //y2=1.085
cc_453 ( N_A_c_512_n N_B_c_743_n ) capacitor c=0.0126654f //x=1.935 //y=1.085 \
 //x2=2.375 //y2=1.085
cc_454 ( N_A_c_500_n N_B_c_745_n ) capacitor c=0.00149727f //x=1.405 //y=1.43 \
 //x2=2.375 //y2=1.435
cc_455 ( N_A_c_503_n N_B_c_745_n ) capacitor c=0.00111802f //x=1.405 //y=1.74 \
 //x2=2.375 //y2=1.435
cc_456 ( N_A_c_514_n N_B_c_745_n ) capacitor c=0.0126654f //x=1.935 //y=1.43 \
 //x2=2.375 //y2=1.435
cc_457 ( N_A_c_503_n N_B_c_748_n ) capacitor c=0.00116305f //x=1.405 //y=1.74 \
 //x2=2.375 //y2=1.74
cc_458 ( N_A_c_514_n N_B_c_748_n ) capacitor c=0.00938322f //x=1.935 //y=1.43 \
 //x2=2.375 //y2=1.74
cc_459 ( N_A_c_514_n N_B_c_752_n ) capacitor c=0.00131492f //x=1.935 //y=1.43 \
 //x2=2.75 //y2=1.585
cc_460 ( N_A_c_512_n N_B_c_757_n ) capacitor c=0.00135327f //x=1.935 //y=1.085 \
 //x2=2.905 //y2=1.085
cc_461 ( N_A_c_514_n N_B_c_759_n ) capacitor c=0.00151998f //x=1.935 //y=1.43 \
 //x2=2.905 //y2=1.435
cc_462 ( N_A_c_492_n N_B_c_762_n ) capacitor c=0.00184232f //x=1.6 //y=2.425 \
 //x2=2.34 //y2=2.26
cc_463 ( N_A_c_495_n N_B_c_762_n ) capacitor c=0.00266357f //x=1.6 //y=2.26 \
 //x2=2.34 //y2=2.26
cc_464 ( N_A_c_504_n N_B_c_762_n ) capacitor c=0.0177224f //x=1.405 //y=2.095 \
 //x2=2.34 //y2=2.26
cc_465 ( N_A_c_504_n N_B_c_763_n ) capacitor c=0.00636965f //x=1.405 //y=2.095 \
 //x2=2.34 //y2=2.095
cc_466 ( A N_B_c_786_n ) capacitor c=0.00117002f //x=1.6 //y=2.77 //x2=2.375 \
 //y2=4.885
cc_467 ( N_A_c_533_n N_B_c_786_n ) capacitor c=4.66993e-19 //x=1.445 //y=4.885 \
 //x2=2.375 //y2=4.885
cc_468 ( N_A_c_536_n N_B_c_786_n ) capacitor c=0.0022472f //x=1.445 //y=4.885 \
 //x2=2.375 //y2=4.885
cc_469 ( N_A_c_547_n N_B_c_786_n ) capacitor c=0.019933f //x=1.865 //y=4.975 \
 //x2=2.375 //y2=4.885
cc_470 ( N_A_c_548_n N_B_c_786_n ) capacitor c=0.00590438f //x=1.445 //y=4.885 \
 //x2=2.375 //y2=4.885
cc_471 ( A C ) capacitor c=0.00474507f //x=1.6 //y=2.77 //x2=3.45 //y2=2.77
cc_472 ( N_A_c_536_n N_C_c_880_n ) capacitor c=2.52182e-19 //x=1.445 //y=4.885 \
 //x2=3.45 //y2=4.765
cc_473 ( N_VDD_c_607_n N_B_M6_noxref_g ) capacitor c=0.00724995f //x=5.13 \
 //y=7.585 //x2=2.38 //y2=6.205
cc_474 ( N_VDD_c_607_n N_B_M7_noxref_g ) capacitor c=0.00782837f //x=5.13 \
 //y=7.585 //x2=2.82 //y2=6.205
cc_475 ( N_VDD_c_611_n N_C_c_886_n ) capacitor c=0.0018189f //x=5.3 //y=7.585 \
 //x2=3.45 //y2=4.885
cc_476 ( N_VDD_c_607_n N_C_M8_noxref_g ) capacitor c=0.00782837f //x=5.13 \
 //y=7.585 //x2=3.86 //y2=6.205
cc_477 ( N_VDD_c_607_n N_C_M9_noxref_g ) capacitor c=0.00782837f //x=5.13 \
 //y=7.585 //x2=4.3 //y2=6.205
cc_478 ( N_VDD_c_611_n N_C_c_915_n ) capacitor c=0.0210247f //x=5.3 //y=7.585 \
 //x2=4.225 //y2=4.975
cc_479 ( N_VDD_c_604_n N_noxref_8_c_983_n ) capacitor c=0.00446119f //x=6.78 \
 //y=7.58 //x2=3.555 //y2=5.39
cc_480 ( N_VDD_c_607_n N_noxref_8_c_983_n ) capacitor c=0.00365626f //x=5.13 \
 //y=7.585 //x2=3.555 //y2=5.39
cc_481 ( N_VDD_M10_noxref_s N_noxref_8_c_983_n ) capacitor c=0.001796f \
 //x=5.84 //y=5.2 //x2=3.555 //y2=5.39
cc_482 ( N_VDD_c_619_n N_noxref_8_c_989_n ) capacitor c=0.00221878f //x=6.78 \
 //y=7.58 //x2=4.405 //y2=7.09
cc_483 ( N_VDD_c_604_n N_noxref_8_c_996_n ) capacitor c=0.0977224f //x=6.78 \
 //y=7.58 //x2=3.64 //y2=6.92
cc_484 ( N_VDD_c_607_n N_noxref_8_c_996_n ) capacitor c=0.0222237f //x=5.13 \
 //y=7.585 //x2=3.64 //y2=6.92
cc_485 ( N_VDD_c_619_n N_noxref_8_c_996_n ) capacitor c=0.00113169f //x=6.78 \
 //y=7.58 //x2=3.64 //y2=6.92
cc_486 ( N_VDD_c_604_n N_noxref_8_c_997_n ) capacitor c=0.00187896f //x=6.78 \
 //y=7.58 //x2=4.52 //y2=6.92
cc_487 ( N_VDD_c_607_n N_noxref_8_c_997_n ) capacitor c=9.15109e-19 //x=5.13 \
 //y=7.585 //x2=4.52 //y2=6.92
cc_488 ( N_VDD_c_611_n N_noxref_8_c_997_n ) capacitor c=0.0128867f //x=5.3 \
 //y=7.585 //x2=4.52 //y2=6.92
cc_489 ( N_VDD_c_619_n N_noxref_8_c_997_n ) capacitor c=0.00112693f //x=6.78 \
 //y=7.58 //x2=4.52 //y2=6.92
cc_490 ( N_VDD_c_607_n N_noxref_8_c_1016_n ) capacitor c=0.00513429f //x=5.13 \
 //y=7.585 //x2=2.6 //y2=5.56
cc_491 ( N_VDD_c_611_n N_noxref_8_c_1016_n ) capacitor c=0.00127839f //x=5.3 \
 //y=7.585 //x2=2.6 //y2=5.56
cc_492 ( N_VDD_c_619_n N_noxref_8_c_1016_n ) capacitor c=2.32853e-19 //x=6.78 \
 //y=7.58 //x2=2.6 //y2=5.56
cc_493 ( N_VDD_M4_noxref_d N_noxref_8_c_1016_n ) capacitor c=0.00557191f \
 //x=1.575 //y=5.205 //x2=2.6 //y2=5.56
cc_494 ( N_VDD_c_604_n N_noxref_8_c_999_n ) capacitor c=0.00206569f //x=6.78 \
 //y=7.58 //x2=3.64 //y2=5.9
cc_495 ( N_VDD_c_607_n N_noxref_8_c_999_n ) capacitor c=0.00856914f //x=5.13 \
 //y=7.585 //x2=3.64 //y2=5.9
cc_496 ( N_VDD_c_619_n N_noxref_8_c_999_n ) capacitor c=0.00100487f //x=6.78 \
 //y=7.58 //x2=3.64 //y2=5.9
cc_497 ( N_VDD_c_604_n N_noxref_8_M9_noxref_d ) capacitor c=0.00206569f \
 //x=6.78 //y=7.58 //x2=4.375 //y2=5.205
cc_498 ( N_VDD_c_607_n N_noxref_8_M9_noxref_d ) capacitor c=0.00856914f \
 //x=5.13 //y=7.585 //x2=4.375 //y2=5.205
cc_499 ( N_VDD_c_611_n N_noxref_8_M9_noxref_d ) capacitor c=0.0431966f //x=5.3 \
 //y=7.585 //x2=4.375 //y2=5.205
cc_500 ( N_VDD_c_619_n N_noxref_8_M9_noxref_d ) capacitor c=0.00100487f \
 //x=6.78 //y=7.58 //x2=4.375 //y2=5.205
cc_501 ( N_VDD_M10_noxref_s N_noxref_8_M9_noxref_d ) capacitor c=0.00285201f \
 //x=5.84 //y=5.2 //x2=4.375 //y2=5.205
cc_502 ( N_VDD_c_619_n Y ) capacitor c=0.0297606f //x=6.78 //y=7.58 //x2=6.78 \
 //y2=2.4
cc_503 ( N_VDD_c_604_n N_Y_c_1092_n ) capacitor c=0.00259721f //x=6.78 \
 //y=7.58 //x2=6.415 //y2=5.42
cc_504 ( N_VDD_c_608_n N_Y_c_1092_n ) capacitor c=0.00100699f //x=6.77 \
 //y=7.585 //x2=6.415 //y2=5.42
cc_505 ( N_VDD_c_619_n N_Y_c_1092_n ) capacitor c=0.00295945f //x=6.78 \
 //y=7.58 //x2=6.415 //y2=5.42
cc_506 ( N_VDD_M10_noxref_s N_Y_c_1092_n ) capacitor c=0.0465774f //x=5.84 \
 //y=5.2 //x2=6.415 //y2=5.42
cc_507 ( N_VDD_M11_noxref_d N_Y_c_1092_n ) capacitor c=0.0486749f //x=6.71 \
 //y=5.2 //x2=6.415 //y2=5.42
cc_508 ( N_VDD_c_604_n N_Y_c_1099_n ) capacitor c=0.00199795f //x=6.78 \
 //y=7.58 //x2=6.695 //y2=5.14
cc_509 ( N_VDD_c_608_n N_Y_c_1099_n ) capacitor c=0.00207379f //x=6.77 \
 //y=7.585 //x2=6.695 //y2=5.14
cc_510 ( N_VDD_M11_noxref_d N_Y_c_1099_n ) capacitor c=0.0235609f //x=6.71 \
 //y=5.2 //x2=6.695 //y2=5.14
cc_511 ( N_VDD_c_611_n N_Y_c_1100_n ) capacitor c=0.0049693f //x=5.3 //y=7.585 \
 //x2=6.5 //y2=5.14
cc_512 ( N_VDD_c_604_n N_Y_c_1110_n ) capacitor c=0.00241566f //x=6.78 \
 //y=7.58 //x2=6.415 //y2=5.56
cc_513 ( N_VDD_c_608_n N_Y_c_1110_n ) capacitor c=0.0138017f //x=6.77 \
 //y=7.585 //x2=6.415 //y2=5.56
cc_514 ( N_VDD_c_611_n N_Y_c_1110_n ) capacitor c=0.00817249f //x=5.3 \
 //y=7.585 //x2=6.415 //y2=5.56
cc_515 ( N_VDD_c_619_n N_Y_c_1110_n ) capacitor c=0.00960351f //x=6.78 \
 //y=7.58 //x2=6.415 //y2=5.56
cc_516 ( N_VDD_M10_noxref_s N_Y_c_1110_n ) capacitor c=0.0896047f //x=5.84 \
 //y=5.2 //x2=6.415 //y2=5.56
cc_517 ( N_VDD_M11_noxref_d N_Y_c_1110_n ) capacitor c=0.0928151f //x=6.71 \
 //y=5.2 //x2=6.415 //y2=5.56
cc_518 ( B C ) capacitor c=0.071118f //x=2.34 //y=2.4 //x2=3.45 //y2=2.77
cc_519 ( N_B_c_741_n C ) capacitor c=4.97833e-19 //x=2.34 //y=4.74 //x2=3.45 \
 //y2=2.77
cc_520 ( N_B_c_778_n C ) capacitor c=3.76054e-19 //x=2.375 //y=4.885 //x2=3.45 \
 //y2=2.77
cc_521 ( B N_C_c_876_n ) capacitor c=6.43877e-19 //x=2.34 //y=2.4 //x2=3.45 \
 //y2=2.405
cc_522 ( N_B_c_739_n N_C_c_876_n ) capacitor c=0.0115855f //x=2.34 //y=2.39 \
 //x2=3.45 //y2=2.405
cc_523 ( N_B_c_742_n N_C_c_876_n ) capacitor c=5.84901e-19 //x=2.34 //y=2.26 \
 //x2=3.45 //y2=2.405
cc_524 ( N_B_c_741_n N_C_c_880_n ) capacitor c=0.0119617f //x=2.34 //y=4.74 \
 //x2=3.45 //y2=4.765
cc_525 ( N_B_c_778_n N_C_c_880_n ) capacitor c=6.02667e-19 //x=2.375 //y=4.885 \
 //x2=3.45 //y2=4.765
cc_526 ( N_B_c_739_n N_C_c_881_n ) capacitor c=4.43682e-19 //x=2.34 //y=2.39 \
 //x2=3.45 //y2=2.26
cc_527 ( N_B_c_742_n N_C_c_881_n ) capacitor c=0.00114266f //x=2.34 //y=2.26 \
 //x2=3.45 //y2=2.26
cc_528 ( N_B_c_762_n N_C_c_881_n ) capacitor c=3.80079e-19 //x=2.34 //y=2.26 \
 //x2=3.45 //y2=2.26
cc_529 ( N_B_c_741_n N_C_c_886_n ) capacitor c=6.87335e-19 //x=2.34 //y=4.74 \
 //x2=3.45 //y2=4.885
cc_530 ( N_B_c_778_n N_C_c_886_n ) capacitor c=0.00124702f //x=2.375 //y=4.885 \
 //x2=3.45 //y2=4.885
cc_531 ( N_B_c_786_n N_C_c_886_n ) capacitor c=4.01223e-19 //x=2.375 //y=4.885 \
 //x2=3.45 //y2=4.885
cc_532 ( N_B_M7_noxref_g N_C_M8_noxref_g ) capacitor c=0.0359752f //x=2.82 \
 //y=6.205 //x2=3.86 //y2=6.205
cc_533 ( N_B_c_743_n N_C_c_895_n ) capacitor c=0.00133966f //x=2.375 //y=1.085 \
 //x2=3.345 //y2=1.085
cc_534 ( N_B_c_757_n N_C_c_895_n ) capacitor c=0.00886682f //x=2.905 //y=1.085 \
 //x2=3.345 //y2=1.085
cc_535 ( N_B_c_745_n N_C_c_897_n ) capacitor c=0.0015172f //x=2.375 //y=1.435 \
 //x2=3.345 //y2=1.435
cc_536 ( N_B_c_759_n N_C_c_897_n ) capacitor c=0.00886682f //x=2.905 //y=1.435 \
 //x2=3.345 //y2=1.435
cc_537 ( N_B_c_748_n N_C_c_900_n ) capacitor c=0.00296957f //x=2.375 //y=1.74 \
 //x2=3.345 //y2=1.74
cc_538 ( N_B_c_752_n N_C_c_900_n ) capacitor c=0.0182761f //x=2.75 //y=1.585 \
 //x2=3.345 //y2=1.74
cc_539 ( N_B_c_763_n N_C_c_902_n ) capacitor c=0.00581071f //x=2.34 //y=2.095 \
 //x2=3.345 //y2=2.095
cc_540 ( N_B_c_752_n N_C_c_906_n ) capacitor c=0.00131492f //x=2.75 //y=1.585 \
 //x2=3.72 //y2=1.585
cc_541 ( N_B_c_757_n N_C_c_910_n ) capacitor c=0.00135327f //x=2.905 //y=1.085 \
 //x2=3.875 //y2=1.085
cc_542 ( N_B_c_759_n N_C_c_912_n ) capacitor c=0.0015172f //x=2.905 //y=1.435 \
 //x2=3.875 //y2=1.435
cc_543 ( N_B_c_739_n N_C_c_918_n ) capacitor c=0.00151737f //x=2.34 //y=2.39 \
 //x2=3.345 //y2=2.26
cc_544 ( N_B_c_742_n N_C_c_918_n ) capacitor c=0.0021413f //x=2.34 //y=2.26 \
 //x2=3.345 //y2=2.26
cc_545 ( N_B_c_762_n N_C_c_918_n ) capacitor c=0.00926648f //x=2.34 //y=2.26 \
 //x2=3.345 //y2=2.26
cc_546 ( N_B_c_741_n N_C_c_920_n ) capacitor c=0.00135035f //x=2.34 //y=4.74 \
 //x2=3.45 //y2=4.885
cc_547 ( N_B_c_778_n N_C_c_920_n ) capacitor c=0.00193614f //x=2.375 //y=4.885 \
 //x2=3.45 //y2=4.885
cc_548 ( N_B_c_857_p N_C_c_920_n ) capacitor c=0.0107159f //x=2.745 //y=4.975 \
 //x2=3.45 //y2=4.885
cc_549 ( N_B_c_786_n N_C_c_920_n ) capacitor c=0.0051116f //x=2.375 //y=4.885 \
 //x2=3.45 //y2=4.885
cc_550 ( N_B_M7_noxref_g N_noxref_8_c_983_n ) capacitor c=0.0108199f //x=2.82 \
 //y=6.205 //x2=3.555 //y2=5.39
cc_551 ( N_B_M7_noxref_g N_noxref_8_c_986_n ) capacitor c=0.00165119f //x=2.82 \
 //y=6.205 //x2=3.64 //y2=5.77
cc_552 ( N_B_c_741_n N_noxref_8_c_993_n ) capacitor c=9.00765e-19 //x=2.34 \
 //y=4.74 //x2=2.6 //y2=5.39
cc_553 ( N_B_M6_noxref_g N_noxref_8_c_993_n ) capacitor c=0.00186001f //x=2.38 \
 //y=6.205 //x2=2.6 //y2=5.39
cc_554 ( N_B_M7_noxref_g N_noxref_8_c_993_n ) capacitor c=0.00210236f //x=2.82 \
 //y=6.205 //x2=2.6 //y2=5.39
cc_555 ( N_B_c_857_p N_noxref_8_c_993_n ) capacitor c=0.00213157f //x=2.745 \
 //y=4.975 //x2=2.6 //y2=5.39
cc_556 ( N_B_M7_noxref_g N_noxref_8_c_996_n ) capacitor c=4.79118e-19 //x=2.82 \
 //y=6.205 //x2=3.64 //y2=6.92
cc_557 ( N_B_M6_noxref_g N_noxref_8_c_1016_n ) capacitor c=0.0120591f //x=2.38 \
 //y=6.205 //x2=2.6 //y2=5.56
cc_558 ( N_B_M7_noxref_g N_noxref_8_c_1016_n ) capacitor c=0.0159649f //x=2.82 \
 //y=6.205 //x2=2.6 //y2=5.56
cc_559 ( N_B_c_857_p N_noxref_8_c_1016_n ) capacitor c=0.00293135f //x=2.745 \
 //y=4.975 //x2=2.6 //y2=5.56
cc_560 ( N_C_c_876_n N_noxref_8_c_983_n ) capacitor c=3.89231e-19 //x=3.45 \
 //y=2.405 //x2=3.555 //y2=5.39
cc_561 ( N_C_c_880_n N_noxref_8_c_983_n ) capacitor c=0.02207f //x=3.45 \
 //y=4.765 //x2=3.555 //y2=5.39
cc_562 ( N_C_c_886_n N_noxref_8_c_983_n ) capacitor c=0.00449448f //x=3.45 \
 //y=4.885 //x2=3.555 //y2=5.39
cc_563 ( N_C_M8_noxref_g N_noxref_8_c_983_n ) capacitor c=0.00412344f //x=3.86 \
 //y=6.205 //x2=3.555 //y2=5.39
cc_564 ( N_C_c_920_n N_noxref_8_c_983_n ) capacitor c=0.00462848f //x=3.45 \
 //y=4.885 //x2=3.555 //y2=5.39
cc_565 ( N_C_M8_noxref_g N_noxref_8_c_986_n ) capacitor c=0.0025714f //x=3.86 \
 //y=6.205 //x2=3.64 //y2=5.77
cc_566 ( N_C_c_974_p N_noxref_8_c_986_n ) capacitor c=6.67396e-19 //x=3.785 \
 //y=4.975 //x2=3.64 //y2=5.77
cc_567 ( N_C_M8_noxref_g N_noxref_8_c_989_n ) capacitor c=0.00998354f //x=3.86 \
 //y=6.205 //x2=4.405 //y2=7.09
cc_568 ( N_C_M9_noxref_g N_noxref_8_c_989_n ) capacitor c=0.00971865f //x=4.3 \
 //y=6.205 //x2=4.405 //y2=7.09
cc_569 ( N_C_M8_noxref_g N_noxref_8_c_996_n ) capacitor c=0.00266045f //x=3.86 \
 //y=6.205 //x2=3.64 //y2=6.92
cc_570 ( N_C_M9_noxref_g N_noxref_8_c_997_n ) capacitor c=0.00394587f //x=4.3 \
 //y=6.205 //x2=4.52 //y2=6.92
cc_571 ( N_C_c_880_n N_noxref_8_c_999_n ) capacitor c=3.85234e-19 //x=3.45 \
 //y=4.765 //x2=3.64 //y2=5.9
cc_572 ( N_C_M8_noxref_g N_noxref_8_c_999_n ) capacitor c=0.0227892f //x=3.86 \
 //y=6.205 //x2=3.64 //y2=5.9
cc_573 ( N_C_c_920_n N_noxref_8_c_999_n ) capacitor c=0.00281079f //x=3.45 \
 //y=4.885 //x2=3.64 //y2=5.9
cc_574 ( N_C_M9_noxref_g N_noxref_8_M9_noxref_d ) capacitor c=0.0365206f \
 //x=4.3 //y=6.205 //x2=4.375 //y2=5.205
cc_575 ( N_noxref_8_c_983_n N_Y_c_1092_n ) capacitor c=3.63983e-19 //x=3.555 \
 //y=5.39 //x2=6.415 //y2=5.42
