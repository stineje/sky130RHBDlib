// File: OR3X1.spi.OR3X1.pxi
// Created: Tue Apr 29 10:44:15 2025
//
simulator lang=spectre
x_PM_OR3X1\%GND ( GND N_GND_c_4_p N_GND_c_54_p N_GND_c_14_p N_GND_c_15_p \
 N_GND_c_18_p N_GND_c_19_p N_GND_c_22_p N_GND_c_5_p N_GND_c_6_p N_GND_c_7_p \
 N_GND_c_36_p N_GND_c_1_p N_GND_c_2_p N_GND_c_3_p N_GND_M0_noxref_s \
 N_GND_M3_noxref_s )  PM_OR3X1\%GND
x_PM_OR3X1\%VDD ( VDD N_VDD_c_92_p N_VDD_c_115_p N_VDD_c_89_n N_VDD_c_118_p \
 N_VDD_c_101_p N_VDD_c_90_n N_VDD_c_91_n N_VDD_M4_noxref_d N_VDD_M10_noxref_s \
 N_VDD_M11_noxref_d )  PM_OR3X1\%VDD
x_PM_OR3X1\%noxref_3 ( N_noxref_3_c_170_n N_noxref_3_c_176_n \
 N_noxref_3_c_179_n N_noxref_3_c_238_p N_noxref_3_c_183_n N_noxref_3_c_187_n \
 N_noxref_3_c_223_n N_noxref_3_c_193_n N_noxref_3_c_291_p N_noxref_3_c_263_p \
 N_noxref_3_M3_noxref_g N_noxref_3_M10_noxref_g N_noxref_3_M11_noxref_g \
 N_noxref_3_c_198_n N_noxref_3_c_312_p N_noxref_3_c_313_p N_noxref_3_c_200_n \
 N_noxref_3_c_233_n N_noxref_3_c_234_n N_noxref_3_c_201_n N_noxref_3_c_304_p \
 N_noxref_3_c_202_n N_noxref_3_c_204_n N_noxref_3_c_205_n \
 N_noxref_3_M0_noxref_d N_noxref_3_M1_noxref_d N_noxref_3_M2_noxref_d \
 N_noxref_3_M8_noxref_d )  PM_OR3X1\%noxref_3
x_PM_OR3X1\%A ( A A A A A A A N_A_c_323_n N_A_c_335_n N_A_M0_noxref_g \
 N_A_M4_noxref_g N_A_M5_noxref_g N_A_c_326_n N_A_c_346_n N_A_c_347_n \
 N_A_c_328_n N_A_c_330_n N_A_c_351_n N_A_c_356_p N_A_c_331_n N_A_c_333_n \
 N_A_c_343_n )  PM_OR3X1\%A
x_PM_OR3X1\%B ( B B B B B B B N_B_c_413_n N_B_c_389_n N_B_M1_noxref_g \
 N_B_M6_noxref_g N_B_M7_noxref_g N_B_c_390_n N_B_c_402_n N_B_c_403_n \
 N_B_c_461_p N_B_c_392_n N_B_c_393_n N_B_c_394_n N_B_c_410_n N_B_c_411_n \
 N_B_c_412_n N_B_c_434_n )  PM_OR3X1\%B
x_PM_OR3X1\%noxref_6 ( N_noxref_6_c_469_n N_noxref_6_c_473_n \
 N_noxref_6_c_474_n N_noxref_6_c_476_n N_noxref_6_M4_noxref_s \
 N_noxref_6_M5_noxref_d N_noxref_6_M7_noxref_d )  PM_OR3X1\%noxref_6
x_PM_OR3X1\%C ( C C C C C C C N_C_c_515_n N_C_M2_noxref_g N_C_M8_noxref_g \
 N_C_M9_noxref_g N_C_c_517_n N_C_c_540_n N_C_c_541_n N_C_c_544_n N_C_c_519_n \
 N_C_c_520_n N_C_c_521_n N_C_c_551_n N_C_c_529_n N_C_c_523_n N_C_c_557_n )  \
 PM_OR3X1\%C
x_PM_OR3X1\%noxref_8 ( N_noxref_8_c_586_n N_noxref_8_c_589_n \
 N_noxref_8_c_590_n N_noxref_8_c_591_n N_noxref_8_M6_noxref_d \
 N_noxref_8_M8_noxref_s N_noxref_8_M9_noxref_d )  PM_OR3X1\%noxref_8
x_PM_OR3X1\%Y ( Y Y Y Y Y Y Y N_Y_c_629_n N_Y_c_653_n N_Y_c_639_n N_Y_c_642_n \
 N_Y_M3_noxref_d N_Y_M10_noxref_d )  PM_OR3X1\%Y
cc_1 ( N_GND_c_1_p N_VDD_c_89_n ) capacitor c=0.00989514f //x=1.185 //y=0.175 \
 //x2=1.23 //y2=7.58
cc_2 ( N_GND_c_2_p N_VDD_c_90_n ) capacitor c=0.00856126f //x=5.3 //y=0.175 \
 //x2=5.3 //y2=7.585
cc_3 ( N_GND_c_3_p N_VDD_c_91_n ) capacitor c=0.00989514f //x=6.9 //y=0.175 \
 //x2=6.78 //y2=7.58
cc_4 ( N_GND_c_4_p N_noxref_3_c_170_n ) capacitor c=0.0146042f //x=6.78 \
 //y=0.18 //x2=5.925 //y2=3.51
cc_5 ( N_GND_c_5_p N_noxref_3_c_170_n ) capacitor c=0.00301826f //x=5.13 \
 //y=0.175 //x2=5.925 //y2=3.51
cc_6 ( N_GND_c_6_p N_noxref_3_c_170_n ) capacitor c=0.00110287f //x=5.845 \
 //y=0.175 //x2=5.925 //y2=3.51
cc_7 ( N_GND_c_7_p N_noxref_3_c_170_n ) capacitor c=2.76195e-19 //x=6.33 \
 //y=0.715 //x2=5.925 //y2=3.51
cc_8 ( N_GND_c_2_p N_noxref_3_c_170_n ) capacitor c=0.00820859f //x=5.3 \
 //y=0.175 //x2=5.925 //y2=3.51
cc_9 ( N_GND_M3_noxref_s N_noxref_3_c_170_n ) capacitor c=0.00164589f \
 //x=5.795 //y=0.55 //x2=5.925 //y2=3.51
cc_10 ( N_GND_c_4_p N_noxref_3_c_176_n ) capacitor c=0.00197355f //x=6.78 \
 //y=0.18 //x2=4.305 //y2=3.51
cc_11 ( N_GND_c_5_p N_noxref_3_c_176_n ) capacitor c=2.2422e-19 //x=5.13 \
 //y=0.175 //x2=4.305 //y2=3.51
cc_12 ( N_GND_M0_noxref_s N_noxref_3_c_176_n ) capacitor c=2.00242e-19 \
 //x=1.05 //y=0.545 //x2=4.305 //y2=3.51
cc_13 ( N_GND_c_4_p N_noxref_3_c_179_n ) capacitor c=0.00359332f //x=6.78 \
 //y=0.18 //x2=2.555 //y2=1.835
cc_14 ( N_GND_c_14_p N_noxref_3_c_179_n ) capacitor c=0.00381844f //x=2.07 \
 //y=0.71 //x2=2.555 //y2=1.835
cc_15 ( N_GND_c_15_p N_noxref_3_c_179_n ) capacitor c=0.00323369f //x=2.555 \
 //y=0.71 //x2=2.555 //y2=1.835
cc_16 ( N_GND_M0_noxref_s N_noxref_3_c_179_n ) capacitor c=0.0173696f //x=1.05 \
 //y=0.545 //x2=2.555 //y2=1.835
cc_17 ( N_GND_c_4_p N_noxref_3_c_183_n ) capacitor c=0.0041045f //x=6.78 \
 //y=0.18 //x2=3.525 //y2=1.835
cc_18 ( N_GND_c_18_p N_noxref_3_c_183_n ) capacitor c=0.00381844f //x=3.04 \
 //y=0.71 //x2=3.525 //y2=1.835
cc_19 ( N_GND_c_19_p N_noxref_3_c_183_n ) capacitor c=0.00324961f //x=3.525 \
 //y=0.71 //x2=3.525 //y2=1.835
cc_20 ( N_GND_M0_noxref_s N_noxref_3_c_183_n ) capacitor c=0.0175459f //x=1.05 \
 //y=0.545 //x2=3.525 //y2=1.835
cc_21 ( N_GND_c_4_p N_noxref_3_c_187_n ) capacitor c=0.00337849f //x=6.78 \
 //y=0.18 //x2=4.105 //y2=1.835
cc_22 ( N_GND_c_22_p N_noxref_3_c_187_n ) capacitor c=0.00479844f //x=4.01 \
 //y=0.71 //x2=4.105 //y2=1.835
cc_23 ( N_GND_c_5_p N_noxref_3_c_187_n ) capacitor c=4.96063e-19 //x=5.13 \
 //y=0.175 //x2=4.105 //y2=1.835
cc_24 ( N_GND_c_2_p N_noxref_3_c_187_n ) capacitor c=0.0293055f //x=5.3 \
 //y=0.175 //x2=4.105 //y2=1.835
cc_25 ( N_GND_M0_noxref_s N_noxref_3_c_187_n ) capacitor c=0.0200102f //x=1.05 \
 //y=0.545 //x2=4.105 //y2=1.835
cc_26 ( N_GND_M3_noxref_s N_noxref_3_c_187_n ) capacitor c=2.64584e-19 \
 //x=5.795 //y=0.55 //x2=4.105 //y2=1.835
cc_27 ( N_GND_c_4_p N_noxref_3_c_193_n ) capacitor c=0.00184912f //x=6.78 \
 //y=0.18 //x2=6.04 //y2=2.265
cc_28 ( N_GND_c_7_p N_noxref_3_c_193_n ) capacitor c=7.87839e-19 //x=6.33 \
 //y=0.715 //x2=6.04 //y2=2.265
cc_29 ( N_GND_c_2_p N_noxref_3_c_193_n ) capacitor c=0.029021f //x=5.3 \
 //y=0.175 //x2=6.04 //y2=2.265
cc_30 ( N_GND_c_3_p N_noxref_3_c_193_n ) capacitor c=0.00118981f //x=6.9 \
 //y=0.175 //x2=6.04 //y2=2.265
cc_31 ( N_GND_M3_noxref_s N_noxref_3_c_193_n ) capacitor c=0.0108553f \
 //x=5.795 //y=0.55 //x2=6.04 //y2=2.265
cc_32 ( N_GND_c_7_p N_noxref_3_c_198_n ) capacitor c=0.0121786f //x=6.33 \
 //y=0.715 //x2=6.15 //y2=1.09
cc_33 ( N_GND_M3_noxref_s N_noxref_3_c_198_n ) capacitor c=0.0317181f \
 //x=5.795 //y=0.55 //x2=6.15 //y2=1.09
cc_34 ( N_GND_c_2_p N_noxref_3_c_200_n ) capacitor c=0.0107331f //x=5.3 \
 //y=0.175 //x2=6.15 //y2=2.1
cc_35 ( N_GND_M3_noxref_s N_noxref_3_c_201_n ) capacitor c=0.00483567f \
 //x=5.795 //y=0.55 //x2=6.525 //y2=0.935
cc_36 ( N_GND_c_36_p N_noxref_3_c_202_n ) capacitor c=0.0118631f //x=6.815 \
 //y=0.715 //x2=6.68 //y2=1.09
cc_37 ( N_GND_M3_noxref_s N_noxref_3_c_202_n ) capacitor c=0.0143355f \
 //x=5.795 //y=0.55 //x2=6.68 //y2=1.09
cc_38 ( N_GND_M3_noxref_s N_noxref_3_c_204_n ) capacitor c=0.0074042f \
 //x=5.795 //y=0.55 //x2=6.68 //y2=1.435
cc_39 ( N_GND_c_7_p N_noxref_3_c_205_n ) capacitor c=2.1838e-19 //x=6.33 \
 //y=0.715 //x2=6.04 //y2=2.265
cc_40 ( N_GND_c_2_p N_noxref_3_c_205_n ) capacitor c=0.0108179f //x=5.3 \
 //y=0.175 //x2=6.04 //y2=2.265
cc_41 ( N_GND_M3_noxref_s N_noxref_3_c_205_n ) capacitor c=0.006558f //x=5.795 \
 //y=0.55 //x2=6.04 //y2=2.265
cc_42 ( N_GND_c_4_p N_noxref_3_M0_noxref_d ) capacitor c=0.00175671f //x=6.78 \
 //y=0.18 //x2=1.48 //y2=1.085
cc_43 ( N_GND_c_1_p N_noxref_3_M0_noxref_d ) capacitor c=0.00419389f //x=1.185 \
 //y=0.175 //x2=1.48 //y2=1.085
cc_44 ( N_GND_c_3_p N_noxref_3_M0_noxref_d ) capacitor c=2.31043e-19 //x=6.9 \
 //y=0.175 //x2=1.48 //y2=1.085
cc_45 ( N_GND_M0_noxref_s N_noxref_3_M0_noxref_d ) capacitor c=0.0775841f \
 //x=1.05 //y=0.545 //x2=1.48 //y2=1.085
cc_46 ( N_GND_c_4_p N_noxref_3_M1_noxref_d ) capacitor c=0.00195238f //x=6.78 \
 //y=0.18 //x2=2.45 //y2=1.085
cc_47 ( N_GND_c_3_p N_noxref_3_M1_noxref_d ) capacitor c=2.31043e-19 //x=6.9 \
 //y=0.175 //x2=2.45 //y2=1.085
cc_48 ( N_GND_M0_noxref_s N_noxref_3_M1_noxref_d ) capacitor c=0.0610599f \
 //x=1.05 //y=0.545 //x2=2.45 //y2=1.085
cc_49 ( N_GND_c_4_p N_noxref_3_M2_noxref_d ) capacitor c=0.00193281f //x=6.78 \
 //y=0.18 //x2=3.42 //y2=1.085
cc_50 ( N_GND_c_2_p N_noxref_3_M2_noxref_d ) capacitor c=0.00374104f //x=5.3 \
 //y=0.175 //x2=3.42 //y2=1.085
cc_51 ( N_GND_c_3_p N_noxref_3_M2_noxref_d ) capacitor c=2.31043e-19 //x=6.9 \
 //y=0.175 //x2=3.42 //y2=1.085
cc_52 ( N_GND_M0_noxref_s N_noxref_3_M2_noxref_d ) capacitor c=0.0604344f \
 //x=1.05 //y=0.545 //x2=3.42 //y2=1.085
cc_53 ( N_GND_c_4_p N_A_c_323_n ) capacitor c=6.77224e-19 //x=6.78 //y=0.18 \
 //x2=1.6 //y2=2.26
cc_54 ( N_GND_c_54_p N_A_c_323_n ) capacitor c=0.00136225f //x=1.585 //y=0.71 \
 //x2=1.6 //y2=2.26
cc_55 ( N_GND_c_1_p N_A_c_323_n ) capacitor c=0.0176887f //x=1.185 //y=0.175 \
 //x2=1.6 //y2=2.26
cc_56 ( N_GND_c_54_p N_A_c_326_n ) capacitor c=0.0122398f //x=1.585 //y=0.71 \
 //x2=1.405 //y2=1.085
cc_57 ( N_GND_M0_noxref_s N_A_c_326_n ) capacitor c=0.0318083f //x=1.05 \
 //y=0.545 //x2=1.405 //y2=1.085
cc_58 ( N_GND_c_54_p N_A_c_328_n ) capacitor c=2.1838e-19 //x=1.585 //y=0.71 \
 //x2=1.405 //y2=2.095
cc_59 ( N_GND_c_1_p N_A_c_328_n ) capacitor c=0.0198857f //x=1.185 //y=0.175 \
 //x2=1.405 //y2=2.095
cc_60 ( N_GND_M0_noxref_s N_A_c_330_n ) capacitor c=0.00474701f //x=1.05 \
 //y=0.545 //x2=1.78 //y2=0.93
cc_61 ( N_GND_c_14_p N_A_c_331_n ) capacitor c=0.0113116f //x=2.07 //y=0.71 \
 //x2=1.935 //y2=1.085
cc_62 ( N_GND_M0_noxref_s N_A_c_331_n ) capacitor c=0.00514143f //x=1.05 \
 //y=0.545 //x2=1.935 //y2=1.085
cc_63 ( N_GND_M0_noxref_s N_A_c_333_n ) capacitor c=8.33128e-19 //x=1.05 \
 //y=0.545 //x2=1.935 //y2=1.43
cc_64 ( N_GND_c_1_p N_B_c_389_n ) capacitor c=9.2064e-19 //x=1.185 //y=0.175 \
 //x2=2.34 //y2=2.26
cc_65 ( N_GND_c_15_p N_B_c_390_n ) capacitor c=0.0111331f //x=2.555 //y=0.71 \
 //x2=2.375 //y2=1.085
cc_66 ( N_GND_M0_noxref_s N_B_c_390_n ) capacitor c=0.00590563f //x=1.05 \
 //y=0.545 //x2=2.375 //y2=1.085
cc_67 ( N_GND_M0_noxref_s N_B_c_392_n ) capacitor c=0.00482035f //x=1.05 \
 //y=0.545 //x2=2.75 //y2=0.93
cc_68 ( N_GND_M0_noxref_s N_B_c_393_n ) capacitor c=8.38882e-19 //x=1.05 \
 //y=0.545 //x2=2.75 //y2=1.585
cc_69 ( N_GND_c_18_p N_B_c_394_n ) capacitor c=0.0113849f //x=3.04 //y=0.71 \
 //x2=2.905 //y2=1.085
cc_70 ( N_GND_M0_noxref_s N_B_c_394_n ) capacitor c=0.00513762f //x=1.05 \
 //y=0.545 //x2=2.905 //y2=1.085
cc_71 ( N_GND_c_4_p N_C_c_515_n ) capacitor c=3.71264e-19 //x=6.78 //y=0.18 \
 //x2=3.45 //y2=2.26
cc_72 ( N_GND_c_2_p N_C_c_515_n ) capacitor c=5.99091e-19 //x=5.3 //y=0.175 \
 //x2=3.45 //y2=2.26
cc_73 ( N_GND_c_19_p N_C_c_517_n ) capacitor c=0.0108383f //x=3.525 //y=0.71 \
 //x2=3.345 //y2=1.085
cc_74 ( N_GND_M0_noxref_s N_C_c_517_n ) capacitor c=0.00590563f //x=1.05 \
 //y=0.545 //x2=3.345 //y2=1.085
cc_75 ( N_GND_M0_noxref_s N_C_c_519_n ) capacitor c=0.00452558f //x=1.05 \
 //y=0.545 //x2=3.72 //y2=0.93
cc_76 ( N_GND_M0_noxref_s N_C_c_520_n ) capacitor c=0.00316186f //x=1.05 \
 //y=0.545 //x2=3.72 //y2=1.585
cc_77 ( N_GND_c_22_p N_C_c_521_n ) capacitor c=0.0110902f //x=4.01 //y=0.71 \
 //x2=3.875 //y2=1.085
cc_78 ( N_GND_M0_noxref_s N_C_c_521_n ) capacitor c=0.0132184f //x=1.05 \
 //y=0.545 //x2=3.875 //y2=1.085
cc_79 ( N_GND_c_19_p N_C_c_523_n ) capacitor c=2.26088e-19 //x=3.525 //y=0.71 \
 //x2=3.345 //y2=2.26
cc_80 ( N_GND_c_2_p Y ) capacitor c=8.10282e-19 //x=5.3 //y=0.175 //x2=6.78 \
 //y2=2.4
cc_81 ( N_GND_c_4_p N_Y_c_629_n ) capacitor c=0.00181107f //x=6.78 //y=0.18 \
 //x2=6.695 //y2=2.26
cc_82 ( N_GND_c_3_p N_Y_c_629_n ) capacitor c=0.0301661f //x=6.9 //y=0.175 \
 //x2=6.695 //y2=2.26
cc_83 ( N_GND_M3_noxref_s N_Y_c_629_n ) capacitor c=0.0099963f //x=5.795 \
 //y=0.55 //x2=6.695 //y2=2.26
cc_84 ( N_GND_c_4_p N_Y_M3_noxref_d ) capacitor c=0.00194747f //x=6.78 \
 //y=0.18 //x2=6.225 //y2=1.09
cc_85 ( N_GND_c_7_p N_Y_M3_noxref_d ) capacitor c=0.014622f //x=6.33 //y=0.715 \
 //x2=6.225 //y2=1.09
cc_86 ( N_GND_c_2_p N_Y_M3_noxref_d ) capacitor c=0.00924905f //x=5.3 \
 //y=0.175 //x2=6.225 //y2=1.09
cc_87 ( N_GND_c_3_p N_Y_M3_noxref_d ) capacitor c=0.00973758f //x=6.9 \
 //y=0.175 //x2=6.225 //y2=1.09
cc_88 ( N_GND_M3_noxref_s N_Y_M3_noxref_d ) capacitor c=0.076995f //x=5.795 \
 //y=0.55 //x2=6.225 //y2=1.09
cc_89 ( N_VDD_c_92_p N_noxref_3_c_170_n ) capacitor c=0.0112654f //x=6.78 \
 //y=7.58 //x2=5.925 //y2=3.51
cc_90 ( N_VDD_c_90_n N_noxref_3_c_170_n ) capacitor c=0.00694659f //x=5.3 \
 //y=7.585 //x2=5.925 //y2=3.51
cc_91 ( N_VDD_M10_noxref_s N_noxref_3_c_170_n ) capacitor c=0.0010609f \
 //x=5.84 //y=5.2 //x2=5.925 //y2=3.51
cc_92 ( N_VDD_c_92_p N_noxref_3_c_176_n ) capacitor c=0.00140169f //x=6.78 \
 //y=7.58 //x2=4.305 //y2=3.51
cc_93 ( N_VDD_c_90_n N_noxref_3_c_223_n ) capacitor c=0.0262421f //x=5.3 \
 //y=7.585 //x2=4.19 //y2=3.51
cc_94 ( N_VDD_c_92_p N_noxref_3_c_193_n ) capacitor c=0.00160062f //x=6.78 \
 //y=7.58 //x2=6.04 //y2=2.265
cc_95 ( N_VDD_c_90_n N_noxref_3_c_193_n ) capacitor c=0.0272885f //x=5.3 \
 //y=7.585 //x2=6.04 //y2=2.265
cc_96 ( N_VDD_c_91_n N_noxref_3_c_193_n ) capacitor c=0.00144809f //x=6.78 \
 //y=7.58 //x2=6.04 //y2=2.265
cc_97 ( N_VDD_M10_noxref_s N_noxref_3_c_193_n ) capacitor c=0.00971925f \
 //x=5.84 //y=5.2 //x2=6.04 //y2=2.265
cc_98 ( N_VDD_c_101_p N_noxref_3_M10_noxref_g ) capacitor c=0.00753931f \
 //x=6.77 //y=7.585 //x2=6.195 //y2=6.2
cc_99 ( N_VDD_c_90_n N_noxref_3_M10_noxref_g ) capacitor c=0.0102569f //x=5.3 \
 //y=7.585 //x2=6.195 //y2=6.2
cc_100 ( N_VDD_M10_noxref_s N_noxref_3_M10_noxref_g ) capacitor c=0.0528676f \
 //x=5.84 //y=5.2 //x2=6.195 //y2=6.2
cc_101 ( N_VDD_c_101_p N_noxref_3_M11_noxref_g ) capacitor c=0.00702238f \
 //x=6.77 //y=7.585 //x2=6.635 //y2=6.2
cc_102 ( N_VDD_M11_noxref_d N_noxref_3_M11_noxref_g ) capacitor c=0.0528676f \
 //x=6.71 //y=5.2 //x2=6.635 //y2=6.2
cc_103 ( N_VDD_c_91_n N_noxref_3_c_233_n ) capacitor c=0.0287802f //x=6.78 \
 //y=7.58 //x2=6.56 //y2=4.97
cc_104 ( N_VDD_c_90_n N_noxref_3_c_234_n ) capacitor c=0.011132f //x=5.3 \
 //y=7.585 //x2=6.27 //y2=4.97
cc_105 ( N_VDD_M10_noxref_s N_noxref_3_c_234_n ) capacitor c=0.0052728f \
 //x=5.84 //y=5.2 //x2=6.27 //y2=4.97
cc_106 ( N_VDD_c_90_n N_noxref_3_M8_noxref_d ) capacitor c=0.00966019f //x=5.3 \
 //y=7.585 //x2=3.935 //y2=5.205
cc_107 ( N_VDD_M10_noxref_s N_noxref_3_M8_noxref_d ) capacitor c=4.94992e-19 \
 //x=5.84 //y=5.2 //x2=3.935 //y2=5.205
cc_108 ( N_VDD_c_89_n N_A_c_323_n ) capacitor c=0.0104719f //x=1.23 //y=7.58 \
 //x2=1.6 //y2=2.26
cc_109 ( N_VDD_c_92_p N_A_c_335_n ) capacitor c=3.36051e-19 //x=6.78 //y=7.58 \
 //x2=1.445 //y2=4.885
cc_110 ( N_VDD_c_89_n N_A_c_335_n ) capacitor c=0.008636f //x=1.23 //y=7.58 \
 //x2=1.445 //y2=4.885
cc_111 ( N_VDD_M4_noxref_d N_A_c_335_n ) capacitor c=2.82994e-19 //x=1.575 \
 //y=5.205 //x2=1.445 //y2=4.885
cc_112 ( N_VDD_c_115_p N_A_M4_noxref_g ) capacitor c=0.00683851f //x=1.635 \
 //y=7.585 //x2=1.5 //y2=6.205
cc_113 ( N_VDD_c_89_n N_A_M4_noxref_g ) capacitor c=0.0241979f //x=1.23 \
 //y=7.58 //x2=1.5 //y2=6.205
cc_114 ( N_VDD_M4_noxref_d N_A_M4_noxref_g ) capacitor c=0.0156786f //x=1.575 \
 //y=5.205 //x2=1.5 //y2=6.205
cc_115 ( N_VDD_c_118_p N_A_M5_noxref_g ) capacitor c=0.0068279f //x=5.13 \
 //y=7.585 //x2=1.94 //y2=6.205
cc_116 ( N_VDD_M4_noxref_d N_A_M5_noxref_g ) capacitor c=0.019067f //x=1.575 \
 //y=5.205 //x2=1.94 //y2=6.205
cc_117 ( N_VDD_c_89_n N_A_c_343_n ) capacitor c=0.00890932f //x=1.23 //y=7.58 \
 //x2=1.445 //y2=4.885
cc_118 ( N_VDD_c_89_n N_B_c_389_n ) capacitor c=7.02327e-19 //x=1.23 //y=7.58 \
 //x2=2.34 //y2=2.26
cc_119 ( N_VDD_c_118_p N_B_M6_noxref_g ) capacitor c=0.00516984f //x=5.13 \
 //y=7.585 //x2=2.38 //y2=6.205
cc_120 ( N_VDD_c_118_p N_B_M7_noxref_g ) capacitor c=0.00515938f //x=5.13 \
 //y=7.585 //x2=2.82 //y2=6.205
cc_121 ( N_VDD_c_92_p N_noxref_6_c_469_n ) capacitor c=0.00568136f //x=6.78 \
 //y=7.58 //x2=2.075 //y2=5.39
cc_122 ( N_VDD_c_115_p N_noxref_6_c_469_n ) capacitor c=4.38114e-19 //x=1.635 \
 //y=7.585 //x2=2.075 //y2=5.39
cc_123 ( N_VDD_c_118_p N_noxref_6_c_469_n ) capacitor c=4.38114e-19 //x=5.13 \
 //y=7.585 //x2=2.075 //y2=5.39
cc_124 ( N_VDD_M4_noxref_d N_noxref_6_c_469_n ) capacitor c=0.0130902f \
 //x=1.575 //y=5.205 //x2=2.075 //y2=5.39
cc_125 ( N_VDD_c_89_n N_noxref_6_c_473_n ) capacitor c=0.0679103f //x=1.23 \
 //y=7.58 //x2=1.365 //y2=5.39
cc_126 ( N_VDD_c_90_n N_noxref_6_c_474_n ) capacitor c=7.99339e-19 //x=5.3 \
 //y=7.585 //x2=2.955 //y2=7.09
cc_127 ( N_VDD_c_91_n N_noxref_6_c_474_n ) capacitor c=0.00358655f //x=6.78 \
 //y=7.58 //x2=2.955 //y2=7.09
cc_128 ( N_VDD_c_92_p N_noxref_6_c_476_n ) capacitor c=0.0368228f //x=6.78 \
 //y=7.58 //x2=2.245 //y2=7.09
cc_129 ( N_VDD_c_118_p N_noxref_6_c_476_n ) capacitor c=0.0587941f //x=5.13 \
 //y=7.585 //x2=2.245 //y2=7.09
cc_130 ( N_VDD_c_91_n N_noxref_6_c_476_n ) capacitor c=0.00118659f //x=6.78 \
 //y=7.58 //x2=2.245 //y2=7.09
cc_131 ( N_VDD_c_92_p N_noxref_6_M4_noxref_s ) capacitor c=0.00714423f \
 //x=6.78 //y=7.58 //x2=1.145 //y2=5.205
cc_132 ( N_VDD_c_115_p N_noxref_6_M4_noxref_s ) capacitor c=0.0141529f \
 //x=1.635 //y=7.585 //x2=1.145 //y2=5.205
cc_133 ( N_VDD_c_91_n N_noxref_6_M4_noxref_s ) capacitor c=0.00138926f \
 //x=6.78 //y=7.58 //x2=1.145 //y2=5.205
cc_134 ( N_VDD_M4_noxref_d N_noxref_6_M4_noxref_s ) capacitor c=0.0667777f \
 //x=1.575 //y=5.205 //x2=1.145 //y2=5.205
cc_135 ( N_VDD_c_89_n N_noxref_6_M5_noxref_d ) capacitor c=8.88629e-19 \
 //x=1.23 //y=7.58 //x2=2.015 //y2=5.205
cc_136 ( N_VDD_M4_noxref_d N_noxref_6_M5_noxref_d ) capacitor c=0.0659925f \
 //x=1.575 //y=5.205 //x2=2.015 //y2=5.205
cc_137 ( N_VDD_M4_noxref_d N_noxref_6_M7_noxref_d ) capacitor c=0.00107819f \
 //x=1.575 //y=5.205 //x2=2.895 //y2=5.205
cc_138 ( N_VDD_c_92_p N_C_c_515_n ) capacitor c=2.78553e-19 //x=6.78 //y=7.58 \
 //x2=3.45 //y2=2.26
cc_139 ( N_VDD_c_90_n N_C_c_515_n ) capacitor c=7.00707e-19 //x=5.3 //y=7.585 \
 //x2=3.45 //y2=2.26
cc_140 ( N_VDD_c_118_p N_C_M8_noxref_g ) capacitor c=0.00515938f //x=5.13 \
 //y=7.585 //x2=3.86 //y2=6.205
cc_141 ( N_VDD_c_118_p N_C_M9_noxref_g ) capacitor c=0.00515938f //x=5.13 \
 //y=7.585 //x2=4.3 //y2=6.205
cc_142 ( N_VDD_c_90_n N_C_M9_noxref_g ) capacitor c=0.00342488f //x=5.3 \
 //y=7.585 //x2=4.3 //y2=6.205
cc_143 ( N_VDD_c_90_n N_C_c_529_n ) capacitor c=0.0155316f //x=5.3 //y=7.585 \
 //x2=4.225 //y2=4.975
cc_144 ( N_VDD_c_92_p N_noxref_8_c_586_n ) capacitor c=0.00437094f //x=6.78 \
 //y=7.58 //x2=3.555 //y2=5.39
cc_145 ( N_VDD_c_118_p N_noxref_8_c_586_n ) capacitor c=0.00311884f //x=5.13 \
 //y=7.585 //x2=3.555 //y2=5.39
cc_146 ( N_VDD_c_90_n N_noxref_8_c_586_n ) capacitor c=0.00275857f //x=5.3 \
 //y=7.585 //x2=3.555 //y2=5.39
cc_147 ( N_VDD_c_89_n N_noxref_8_c_589_n ) capacitor c=9.33216e-19 //x=1.23 \
 //y=7.58 //x2=2.685 //y2=5.39
cc_148 ( N_VDD_c_91_n N_noxref_8_c_590_n ) capacitor c=0.00358655f //x=6.78 \
 //y=7.58 //x2=4.435 //y2=7.09
cc_149 ( N_VDD_c_92_p N_noxref_8_c_591_n ) capacitor c=0.0327982f //x=6.78 \
 //y=7.58 //x2=3.725 //y2=7.09
cc_150 ( N_VDD_c_118_p N_noxref_8_c_591_n ) capacitor c=0.0586541f //x=5.13 \
 //y=7.585 //x2=3.725 //y2=7.09
cc_151 ( N_VDD_c_91_n N_noxref_8_c_591_n ) capacitor c=0.00118659f //x=6.78 \
 //y=7.58 //x2=3.725 //y2=7.09
cc_152 ( N_VDD_M4_noxref_d N_noxref_8_c_591_n ) capacitor c=9.25055e-19 \
 //x=1.575 //y=5.205 //x2=3.725 //y2=7.09
cc_153 ( N_VDD_M4_noxref_d N_noxref_8_M6_noxref_d ) capacitor c=0.00561178f \
 //x=1.575 //y=5.205 //x2=2.455 //y2=5.205
cc_154 ( N_VDD_c_90_n N_noxref_8_M9_noxref_d ) capacitor c=0.0520312f //x=5.3 \
 //y=7.585 //x2=4.375 //y2=5.205
cc_155 ( N_VDD_M10_noxref_s N_noxref_8_M9_noxref_d ) capacitor c=0.00226909f \
 //x=5.84 //y=5.2 //x2=4.375 //y2=5.205
cc_156 ( N_VDD_c_90_n Y ) capacitor c=4.80934e-19 //x=5.3 //y=7.585 //x2=6.78 \
 //y2=2.4
cc_157 ( N_VDD_c_91_n Y ) capacitor c=0.0232778f //x=6.78 //y=7.58 //x2=6.78 \
 //y2=2.4
cc_158 ( N_VDD_c_92_p N_Y_c_639_n ) capacitor c=0.00191195f //x=6.78 //y=7.58 \
 //x2=6.695 //y2=4.76
cc_159 ( N_VDD_c_101_p N_Y_c_639_n ) capacitor c=8.83313e-19 //x=6.77 \
 //y=7.585 //x2=6.695 //y2=4.76
cc_160 ( N_VDD_M11_noxref_d N_Y_c_639_n ) capacitor c=0.00641652f //x=6.71 \
 //y=5.2 //x2=6.695 //y2=4.76
cc_161 ( N_VDD_c_90_n N_Y_c_642_n ) capacitor c=0.017572f //x=5.3 //y=7.585 \
 //x2=6.5 //y2=4.76
cc_162 ( N_VDD_c_92_p N_Y_M10_noxref_d ) capacitor c=0.00710215f //x=6.78 \
 //y=7.58 //x2=6.27 //y2=5.2
cc_163 ( N_VDD_c_101_p N_Y_M10_noxref_d ) capacitor c=0.0139426f //x=6.77 \
 //y=7.585 //x2=6.27 //y2=5.2
cc_164 ( N_VDD_c_91_n N_Y_M10_noxref_d ) capacitor c=0.0219131f //x=6.78 \
 //y=7.58 //x2=6.27 //y2=5.2
cc_165 ( N_VDD_M10_noxref_s N_Y_M10_noxref_d ) capacitor c=0.0843065f //x=5.84 \
 //y=5.2 //x2=6.27 //y2=5.2
cc_166 ( N_VDD_M11_noxref_d N_Y_M10_noxref_d ) capacitor c=0.0832641f //x=6.71 \
 //y=5.2 //x2=6.27 //y2=5.2
cc_167 ( N_noxref_3_c_238_p N_A_c_323_n ) capacitor c=0.0112169f //x=1.755 \
 //y=1.835 //x2=1.6 //y2=2.26
cc_168 ( N_noxref_3_M0_noxref_d N_A_c_326_n ) capacitor c=0.0013184f //x=1.48 \
 //y=1.085 //x2=1.405 //y2=1.085
cc_169 ( N_noxref_3_M0_noxref_d N_A_c_346_n ) capacitor c=0.0034598f //x=1.48 \
 //y=1.085 //x2=1.405 //y2=1.43
cc_170 ( N_noxref_3_M0_noxref_d N_A_c_347_n ) capacitor c=0.00300148f //x=1.48 \
 //y=1.085 //x2=1.405 //y2=1.74
cc_171 ( N_noxref_3_c_238_p N_A_c_328_n ) capacitor c=0.00589082f //x=1.755 \
 //y=1.835 //x2=1.405 //y2=2.095
cc_172 ( N_noxref_3_M0_noxref_d N_A_c_328_n ) capacitor c=0.00274546f //x=1.48 \
 //y=1.085 //x2=1.405 //y2=2.095
cc_173 ( N_noxref_3_M0_noxref_d N_A_c_330_n ) capacitor c=0.00241102f //x=1.48 \
 //y=1.085 //x2=1.78 //y2=0.93
cc_174 ( N_noxref_3_M0_noxref_d N_A_c_351_n ) capacitor c=0.0123304f //x=1.48 \
 //y=1.085 //x2=1.78 //y2=1.585
cc_175 ( N_noxref_3_M0_noxref_d N_A_c_331_n ) capacitor c=0.00219619f //x=1.48 \
 //y=1.085 //x2=1.935 //y2=1.085
cc_176 ( N_noxref_3_c_179_n N_A_c_333_n ) capacitor c=0.00431513f //x=2.555 \
 //y=1.835 //x2=1.935 //y2=1.43
cc_177 ( N_noxref_3_M0_noxref_d N_A_c_333_n ) capacitor c=0.00603828f //x=1.48 \
 //y=1.085 //x2=1.935 //y2=1.43
cc_178 ( N_noxref_3_c_179_n N_B_c_389_n ) capacitor c=0.0162392f //x=2.555 \
 //y=1.835 //x2=2.34 //y2=2.26
cc_179 ( N_noxref_3_c_223_n N_B_c_389_n ) capacitor c=0.00270493f //x=4.19 \
 //y=3.51 //x2=2.34 //y2=2.26
cc_180 ( N_noxref_3_M1_noxref_d N_B_c_390_n ) capacitor c=0.00132426f //x=2.45 \
 //y=1.085 //x2=2.375 //y2=1.085
cc_181 ( N_noxref_3_M1_noxref_d N_B_c_402_n ) capacitor c=0.0035101f //x=2.45 \
 //y=1.085 //x2=2.375 //y2=1.435
cc_182 ( N_noxref_3_c_179_n N_B_c_403_n ) capacitor c=0.00158038f //x=2.555 \
 //y=1.835 //x2=2.375 //y2=1.74
cc_183 ( N_noxref_3_M0_noxref_d N_B_c_403_n ) capacitor c=8.74435e-19 //x=1.48 \
 //y=1.085 //x2=2.375 //y2=1.74
cc_184 ( N_noxref_3_M1_noxref_d N_B_c_403_n ) capacitor c=0.00297998f //x=2.45 \
 //y=1.085 //x2=2.375 //y2=1.74
cc_185 ( N_noxref_3_M1_noxref_d N_B_c_392_n ) capacitor c=0.00241102f //x=2.45 \
 //y=1.085 //x2=2.75 //y2=0.93
cc_186 ( N_noxref_3_c_183_n N_B_c_393_n ) capacitor c=0.00430135f //x=3.525 \
 //y=1.835 //x2=2.75 //y2=1.585
cc_187 ( N_noxref_3_M1_noxref_d N_B_c_393_n ) capacitor c=0.0154425f //x=2.45 \
 //y=1.085 //x2=2.75 //y2=1.585
cc_188 ( N_noxref_3_M1_noxref_d N_B_c_394_n ) capacitor c=0.00132831f //x=2.45 \
 //y=1.085 //x2=2.905 //y2=1.085
cc_189 ( N_noxref_3_M1_noxref_d N_B_c_410_n ) capacitor c=0.0035101f //x=2.45 \
 //y=1.085 //x2=2.905 //y2=1.435
cc_190 ( N_noxref_3_c_179_n N_B_c_411_n ) capacitor c=0.00633758f //x=2.555 \
 //y=1.835 //x2=2.34 //y2=2.26
cc_191 ( N_noxref_3_c_179_n N_B_c_412_n ) capacitor c=0.0185539f //x=2.555 \
 //y=1.835 //x2=2.34 //y2=2.095
cc_192 ( N_noxref_3_c_263_p N_noxref_6_c_469_n ) capacitor c=0.00108534f \
 //x=4.19 //y=5.39 //x2=2.075 //y2=5.39
cc_193 ( N_noxref_3_M8_noxref_d N_noxref_6_M7_noxref_d ) capacitor \
 c=0.0049951f //x=3.935 //y=5.205 //x2=2.895 //y2=5.205
cc_194 ( N_noxref_3_c_176_n N_C_c_515_n ) capacitor c=0.00720056f //x=4.305 \
 //y=3.51 //x2=3.45 //y2=2.26
cc_195 ( N_noxref_3_c_183_n N_C_c_515_n ) capacitor c=0.0182675f //x=3.525 \
 //y=1.835 //x2=3.45 //y2=2.26
cc_196 ( N_noxref_3_c_223_n N_C_c_515_n ) capacitor c=0.0909072f //x=4.19 \
 //y=3.51 //x2=3.45 //y2=2.26
cc_197 ( N_noxref_3_c_193_n N_C_c_515_n ) capacitor c=0.00118081f //x=6.04 \
 //y=2.265 //x2=3.45 //y2=2.26
cc_198 ( N_noxref_3_c_223_n N_C_M8_noxref_g ) capacitor c=0.0059988f //x=4.19 \
 //y=3.51 //x2=3.86 //y2=6.205
cc_199 ( N_noxref_3_c_263_p N_C_M8_noxref_g ) capacitor c=0.0132317f //x=4.19 \
 //y=5.39 //x2=3.86 //y2=6.205
cc_200 ( N_noxref_3_c_223_n N_C_M9_noxref_g ) capacitor c=0.0066533f //x=4.19 \
 //y=3.51 //x2=4.3 //y2=6.205
cc_201 ( N_noxref_3_c_263_p N_C_M9_noxref_g ) capacitor c=0.00775053f //x=4.19 \
 //y=5.39 //x2=4.3 //y2=6.205
cc_202 ( N_noxref_3_M8_noxref_d N_C_M9_noxref_g ) capacitor c=0.0136385f \
 //x=3.935 //y=5.205 //x2=4.3 //y2=6.205
cc_203 ( N_noxref_3_M2_noxref_d N_C_c_517_n ) capacitor c=0.00226395f //x=3.42 \
 //y=1.085 //x2=3.345 //y2=1.085
cc_204 ( N_noxref_3_M2_noxref_d N_C_c_540_n ) capacitor c=0.0035101f //x=3.42 \
 //y=1.085 //x2=3.345 //y2=1.435
cc_205 ( N_noxref_3_c_183_n N_C_c_541_n ) capacitor c=0.0013609f //x=3.525 \
 //y=1.835 //x2=3.345 //y2=1.74
cc_206 ( N_noxref_3_M1_noxref_d N_C_c_541_n ) capacitor c=0.00148728f //x=2.45 \
 //y=1.085 //x2=3.345 //y2=1.74
cc_207 ( N_noxref_3_M2_noxref_d N_C_c_541_n ) capacitor c=0.00484362f //x=3.42 \
 //y=1.085 //x2=3.345 //y2=1.74
cc_208 ( N_noxref_3_c_183_n N_C_c_544_n ) capacitor c=0.0216105f //x=3.525 \
 //y=1.835 //x2=3.345 //y2=2.095
cc_209 ( N_noxref_3_c_223_n N_C_c_544_n ) capacitor c=0.00278932f //x=4.19 \
 //y=3.51 //x2=3.345 //y2=2.095
cc_210 ( N_noxref_3_M2_noxref_d N_C_c_544_n ) capacitor c=3.4952e-19 //x=3.42 \
 //y=1.085 //x2=3.345 //y2=2.095
cc_211 ( N_noxref_3_M2_noxref_d N_C_c_519_n ) capacitor c=0.00241102f //x=3.42 \
 //y=1.085 //x2=3.72 //y2=0.93
cc_212 ( N_noxref_3_c_187_n N_C_c_520_n ) capacitor c=0.00777513f //x=4.105 \
 //y=1.835 //x2=3.72 //y2=1.585
cc_213 ( N_noxref_3_M2_noxref_d N_C_c_520_n ) capacitor c=0.0156879f //x=3.42 \
 //y=1.085 //x2=3.72 //y2=1.585
cc_214 ( N_noxref_3_M2_noxref_d N_C_c_521_n ) capacitor c=0.00132831f //x=3.42 \
 //y=1.085 //x2=3.875 //y2=1.085
cc_215 ( N_noxref_3_M2_noxref_d N_C_c_551_n ) capacitor c=0.0035101f //x=3.42 \
 //y=1.085 //x2=3.875 //y2=1.435
cc_216 ( N_noxref_3_c_223_n N_C_c_529_n ) capacitor c=0.0150293f //x=4.19 \
 //y=3.51 //x2=4.225 //y2=4.975
cc_217 ( N_noxref_3_c_263_p N_C_c_529_n ) capacitor c=0.00302595f //x=4.19 \
 //y=5.39 //x2=4.225 //y2=4.975
cc_218 ( N_noxref_3_c_183_n N_C_c_523_n ) capacitor c=0.003666f //x=3.525 \
 //y=1.835 //x2=3.345 //y2=2.26
cc_219 ( N_noxref_3_c_223_n N_C_c_523_n ) capacitor c=0.00882918f //x=4.19 \
 //y=3.51 //x2=3.345 //y2=2.26
cc_220 ( N_noxref_3_c_291_p N_C_c_523_n ) capacitor c=0.00470847f //x=3.61 \
 //y=1.835 //x2=3.345 //y2=2.26
cc_221 ( N_noxref_3_c_223_n N_C_c_557_n ) capacitor c=0.00513934f //x=4.19 \
 //y=3.51 //x2=3.45 //y2=4.885
cc_222 ( N_noxref_3_c_263_p N_noxref_8_c_586_n ) capacitor c=0.0344081f \
 //x=4.19 //y=5.39 //x2=3.555 //y2=5.39
cc_223 ( N_noxref_3_c_263_p N_noxref_8_c_590_n ) capacitor c=0.00113815f \
 //x=4.19 //y=5.39 //x2=4.435 //y2=7.09
cc_224 ( N_noxref_3_M8_noxref_d N_noxref_8_c_590_n ) capacitor c=0.011849f \
 //x=3.935 //y=5.205 //x2=4.435 //y2=7.09
cc_225 ( N_noxref_3_M8_noxref_d N_noxref_8_M6_noxref_d ) capacitor \
 c=0.00101354f //x=3.935 //y=5.205 //x2=2.455 //y2=5.205
cc_226 ( N_noxref_3_M8_noxref_d N_noxref_8_M8_noxref_s ) capacitor \
 c=0.0344081f //x=3.935 //y=5.205 //x2=3.505 //y2=5.205
cc_227 ( N_noxref_3_c_170_n N_noxref_8_M9_noxref_d ) capacitor c=0.00131309f \
 //x=5.925 //y=3.51 //x2=4.375 //y2=5.205
cc_228 ( N_noxref_3_M8_noxref_d N_noxref_8_M9_noxref_d ) capacitor \
 c=0.0458293f //x=3.935 //y=5.205 //x2=4.375 //y2=5.205
cc_229 ( N_noxref_3_c_170_n Y ) capacitor c=0.00584488f //x=5.925 //y=3.51 \
 //x2=6.78 //y2=2.4
cc_230 ( N_noxref_3_c_223_n Y ) capacitor c=0.00118081f //x=4.19 //y=3.51 \
 //x2=6.78 //y2=2.4
cc_231 ( N_noxref_3_c_193_n Y ) capacitor c=0.0711303f //x=6.04 //y=2.265 \
 //x2=6.78 //y2=2.4
cc_232 ( N_noxref_3_c_205_n Y ) capacitor c=8.49451e-19 //x=6.04 //y=2.265 \
 //x2=6.78 //y2=2.4
cc_233 ( N_noxref_3_c_304_p N_Y_c_629_n ) capacitor c=0.0023507f //x=6.525 \
 //y=1.59 //x2=6.695 //y2=2.26
cc_234 ( N_noxref_3_c_205_n N_Y_c_653_n ) capacitor c=0.0167852f //x=6.04 \
 //y=2.265 //x2=6.495 //y2=2.26
cc_235 ( N_noxref_3_c_233_n N_Y_c_639_n ) capacitor c=0.0101013f //x=6.56 \
 //y=4.97 //x2=6.695 //y2=4.76
cc_236 ( N_noxref_3_c_193_n N_Y_c_642_n ) capacitor c=0.0250789f //x=6.04 \
 //y=2.265 //x2=6.5 //y2=4.76
cc_237 ( N_noxref_3_c_234_n N_Y_c_642_n ) capacitor c=0.00962086f //x=6.27 \
 //y=4.97 //x2=6.5 //y2=4.76
cc_238 ( N_noxref_3_c_223_n N_Y_M3_noxref_d ) capacitor c=2.60259e-19 //x=4.19 \
 //y=3.51 //x2=6.225 //y2=1.09
cc_239 ( N_noxref_3_c_193_n N_Y_M3_noxref_d ) capacitor c=0.0175773f //x=6.04 \
 //y=2.265 //x2=6.225 //y2=1.09
cc_240 ( N_noxref_3_c_198_n N_Y_M3_noxref_d ) capacitor c=0.00218556f //x=6.15 \
 //y=1.09 //x2=6.225 //y2=1.09
cc_241 ( N_noxref_3_c_312_p N_Y_M3_noxref_d ) capacitor c=0.00347355f //x=6.15 \
 //y=1.435 //x2=6.225 //y2=1.09
cc_242 ( N_noxref_3_c_313_p N_Y_M3_noxref_d ) capacitor c=0.00742431f //x=6.15 \
 //y=1.745 //x2=6.225 //y2=1.09
cc_243 ( N_noxref_3_c_200_n N_Y_M3_noxref_d ) capacitor c=0.00957707f //x=6.15 \
 //y=2.1 //x2=6.225 //y2=1.09
cc_244 ( N_noxref_3_c_201_n N_Y_M3_noxref_d ) capacitor c=0.00220879f \
 //x=6.525 //y=0.935 //x2=6.225 //y2=1.09
cc_245 ( N_noxref_3_c_304_p N_Y_M3_noxref_d ) capacitor c=0.0138447f //x=6.525 \
 //y=1.59 //x2=6.225 //y2=1.09
cc_246 ( N_noxref_3_c_202_n N_Y_M3_noxref_d ) capacitor c=0.00218624f //x=6.68 \
 //y=1.09 //x2=6.225 //y2=1.09
cc_247 ( N_noxref_3_c_204_n N_Y_M3_noxref_d ) capacitor c=0.00601286f //x=6.68 \
 //y=1.435 //x2=6.225 //y2=1.09
cc_248 ( N_noxref_3_M10_noxref_g N_Y_M10_noxref_d ) capacitor c=0.0219309f \
 //x=6.195 //y=6.2 //x2=6.27 //y2=5.2
cc_249 ( N_noxref_3_M11_noxref_g N_Y_M10_noxref_d ) capacitor c=0.021902f \
 //x=6.635 //y=6.2 //x2=6.27 //y2=5.2
cc_250 ( N_noxref_3_c_233_n N_Y_M10_noxref_d ) capacitor c=0.0148755f //x=6.56 \
 //y=4.97 //x2=6.27 //y2=5.2
cc_251 ( N_noxref_3_c_234_n N_Y_M10_noxref_d ) capacitor c=0.00307344f \
 //x=6.27 //y=4.97 //x2=6.27 //y2=5.2
cc_252 ( N_A_c_335_n N_B_c_413_n ) capacitor c=0.0481157f //x=1.445 //y=4.885 \
 //x2=2.34 //y2=4.72
cc_253 ( N_A_c_356_p N_B_c_413_n ) capacitor c=0.00146509f //x=1.865 //y=4.975 \
 //x2=2.34 //y2=4.72
cc_254 ( N_A_c_343_n N_B_c_413_n ) capacitor c=0.00112871f //x=1.445 //y=4.885 \
 //x2=2.34 //y2=4.72
cc_255 ( N_A_c_323_n N_B_c_389_n ) capacitor c=0.0453706f //x=1.6 //y=2.26 \
 //x2=2.34 //y2=2.26
cc_256 ( N_A_c_328_n N_B_c_389_n ) capacitor c=0.00308814f //x=1.405 //y=2.095 \
 //x2=2.34 //y2=2.26
cc_257 ( N_A_M4_noxref_g N_B_M6_noxref_g ) capacitor c=0.0100243f //x=1.5 \
 //y=6.205 //x2=2.38 //y2=6.205
cc_258 ( N_A_M5_noxref_g N_B_M6_noxref_g ) capacitor c=0.107798f //x=1.94 \
 //y=6.205 //x2=2.38 //y2=6.205
cc_259 ( N_A_M5_noxref_g N_B_M7_noxref_g ) capacitor c=0.0094155f //x=1.94 \
 //y=6.205 //x2=2.82 //y2=6.205
cc_260 ( N_A_c_326_n N_B_c_390_n ) capacitor c=0.00125788f //x=1.405 //y=1.085 \
 //x2=2.375 //y2=1.085
cc_261 ( N_A_c_331_n N_B_c_390_n ) capacitor c=0.0126654f //x=1.935 //y=1.085 \
 //x2=2.375 //y2=1.085
cc_262 ( N_A_c_346_n N_B_c_402_n ) capacitor c=0.00148539f //x=1.405 //y=1.43 \
 //x2=2.375 //y2=1.435
cc_263 ( N_A_c_347_n N_B_c_402_n ) capacitor c=0.00105591f //x=1.405 //y=1.74 \
 //x2=2.375 //y2=1.435
cc_264 ( N_A_c_333_n N_B_c_402_n ) capacitor c=0.0126654f //x=1.935 //y=1.43 \
 //x2=2.375 //y2=1.435
cc_265 ( N_A_c_347_n N_B_c_403_n ) capacitor c=0.00109549f //x=1.405 //y=1.74 \
 //x2=2.375 //y2=1.74
cc_266 ( N_A_c_333_n N_B_c_403_n ) capacitor c=0.00886999f //x=1.935 //y=1.43 \
 //x2=2.375 //y2=1.74
cc_267 ( N_A_c_333_n N_B_c_393_n ) capacitor c=0.00123863f //x=1.935 //y=1.43 \
 //x2=2.75 //y2=1.585
cc_268 ( N_A_c_331_n N_B_c_394_n ) capacitor c=0.00132934f //x=1.935 //y=1.085 \
 //x2=2.905 //y2=1.085
cc_269 ( N_A_c_333_n N_B_c_410_n ) capacitor c=0.00150734f //x=1.935 //y=1.43 \
 //x2=2.905 //y2=1.435
cc_270 ( N_A_c_323_n N_B_c_411_n ) capacitor c=0.00307062f //x=1.6 //y=2.26 \
 //x2=2.34 //y2=2.26
cc_271 ( N_A_c_328_n N_B_c_411_n ) capacitor c=0.0176046f //x=1.405 //y=2.095 \
 //x2=2.34 //y2=2.26
cc_272 ( N_A_c_328_n N_B_c_412_n ) capacitor c=0.00577193f //x=1.405 //y=2.095 \
 //x2=2.34 //y2=2.095
cc_273 ( N_A_c_335_n N_B_c_434_n ) capacitor c=0.00336963f //x=1.445 //y=4.885 \
 //x2=2.375 //y2=4.885
cc_274 ( N_A_c_356_p N_B_c_434_n ) capacitor c=0.0197705f //x=1.865 //y=4.975 \
 //x2=2.375 //y2=4.885
cc_275 ( N_A_c_343_n N_B_c_434_n ) capacitor c=0.00546725f //x=1.445 //y=4.885 \
 //x2=2.375 //y2=4.885
cc_276 ( N_A_c_335_n N_noxref_6_c_469_n ) capacitor c=0.00628365f //x=1.445 \
 //y=4.885 //x2=2.075 //y2=5.39
cc_277 ( N_A_M4_noxref_g N_noxref_6_c_469_n ) capacitor c=0.0182391f //x=1.5 \
 //y=6.205 //x2=2.075 //y2=5.39
cc_278 ( N_A_M5_noxref_g N_noxref_6_c_469_n ) capacitor c=0.0203804f //x=1.94 \
 //y=6.205 //x2=2.075 //y2=5.39
cc_279 ( N_A_c_356_p N_noxref_6_c_469_n ) capacitor c=0.00343485f //x=1.865 \
 //y=4.975 //x2=2.075 //y2=5.39
cc_280 ( N_A_c_343_n N_noxref_6_c_469_n ) capacitor c=0.0017421f //x=1.445 \
 //y=4.885 //x2=2.075 //y2=5.39
cc_281 ( N_A_c_335_n N_noxref_6_c_473_n ) capacitor c=0.0120346f //x=1.445 \
 //y=4.885 //x2=1.365 //y2=5.39
cc_282 ( N_A_c_343_n N_noxref_6_c_473_n ) capacitor c=0.00518332f //x=1.445 \
 //y=4.885 //x2=1.365 //y2=5.39
cc_283 ( N_A_M4_noxref_g N_noxref_6_M4_noxref_s ) capacitor c=0.0473218f \
 //x=1.5 //y=6.205 //x2=1.145 //y2=5.205
cc_284 ( N_A_M5_noxref_g N_noxref_6_M5_noxref_d ) capacitor c=0.0170604f \
 //x=1.94 //y=6.205 //x2=2.015 //y2=5.205
cc_285 ( N_A_c_323_n N_C_c_515_n ) capacitor c=0.00247242f //x=1.6 //y=2.26 \
 //x2=3.45 //y2=2.26
cc_286 ( N_B_M6_noxref_g N_noxref_6_c_469_n ) capacitor c=0.0170604f //x=2.38 \
 //y=6.205 //x2=2.075 //y2=5.39
cc_287 ( N_B_c_434_n N_noxref_6_c_469_n ) capacitor c=2.24869e-19 //x=2.375 \
 //y=4.885 //x2=2.075 //y2=5.39
cc_288 ( N_B_c_413_n N_noxref_6_c_474_n ) capacitor c=8.92402e-19 //x=2.34 \
 //y=4.72 //x2=2.955 //y2=7.09
cc_289 ( N_B_M6_noxref_g N_noxref_6_c_474_n ) capacitor c=0.0148484f //x=2.38 \
 //y=6.205 //x2=2.955 //y2=7.09
cc_290 ( N_B_M7_noxref_g N_noxref_6_c_474_n ) capacitor c=0.0160244f //x=2.82 \
 //y=6.205 //x2=2.955 //y2=7.09
cc_291 ( N_B_M7_noxref_g N_noxref_6_M7_noxref_d ) capacitor c=0.0216879f \
 //x=2.82 //y=6.205 //x2=2.895 //y2=5.205
cc_292 ( N_B_c_413_n N_C_c_515_n ) capacitor c=0.00562297f //x=2.34 //y=4.72 \
 //x2=3.45 //y2=2.26
cc_293 ( N_B_c_389_n N_C_c_515_n ) capacitor c=0.0530421f //x=2.34 //y=2.26 \
 //x2=3.45 //y2=2.26
cc_294 ( N_B_c_411_n N_C_c_515_n ) capacitor c=3.80079e-19 //x=2.34 //y=2.26 \
 //x2=3.45 //y2=2.26
cc_295 ( N_B_c_434_n N_C_c_515_n ) capacitor c=4.01223e-19 //x=2.375 //y=4.885 \
 //x2=3.45 //y2=2.26
cc_296 ( N_B_M7_noxref_g N_C_M8_noxref_g ) capacitor c=0.0343614f //x=2.82 \
 //y=6.205 //x2=3.86 //y2=6.205
cc_297 ( N_B_c_390_n N_C_c_517_n ) capacitor c=0.00131574f //x=2.375 //y=1.085 \
 //x2=3.345 //y2=1.085
cc_298 ( N_B_c_394_n N_C_c_517_n ) capacitor c=0.00886682f //x=2.905 //y=1.085 \
 //x2=3.345 //y2=1.085
cc_299 ( N_B_c_402_n N_C_c_540_n ) capacitor c=0.00150456f //x=2.375 //y=1.435 \
 //x2=3.345 //y2=1.435
cc_300 ( N_B_c_410_n N_C_c_540_n ) capacitor c=0.00886682f //x=2.905 //y=1.435 \
 //x2=3.345 //y2=1.435
cc_301 ( N_B_c_403_n N_C_c_541_n ) capacitor c=0.00276257f //x=2.375 //y=1.74 \
 //x2=3.345 //y2=1.74
cc_302 ( N_B_c_393_n N_C_c_541_n ) capacitor c=0.0177628f //x=2.75 //y=1.585 \
 //x2=3.345 //y2=1.74
cc_303 ( N_B_c_412_n N_C_c_544_n ) capacitor c=0.00494016f //x=2.34 //y=2.095 \
 //x2=3.345 //y2=2.095
cc_304 ( N_B_c_393_n N_C_c_520_n ) capacitor c=0.00123863f //x=2.75 //y=1.585 \
 //x2=3.72 //y2=1.585
cc_305 ( N_B_c_394_n N_C_c_521_n ) capacitor c=0.00132934f //x=2.905 //y=1.085 \
 //x2=3.875 //y2=1.085
cc_306 ( N_B_c_410_n N_C_c_551_n ) capacitor c=0.00150456f //x=2.905 //y=1.435 \
 //x2=3.875 //y2=1.435
cc_307 ( N_B_c_389_n N_C_c_523_n ) capacitor c=0.00235136f //x=2.34 //y=2.26 \
 //x2=3.345 //y2=2.26
cc_308 ( N_B_c_411_n N_C_c_523_n ) capacitor c=0.00922588f //x=2.34 //y=2.26 \
 //x2=3.345 //y2=2.26
cc_309 ( N_B_c_413_n N_C_c_557_n ) capacitor c=0.00227279f //x=2.34 //y=4.72 \
 //x2=3.45 //y2=4.885
cc_310 ( N_B_c_461_p N_C_c_557_n ) capacitor c=0.0106154f //x=2.745 //y=4.975 \
 //x2=3.45 //y2=4.885
cc_311 ( N_B_c_434_n N_C_c_557_n ) capacitor c=0.00510965f //x=2.375 //y=4.885 \
 //x2=3.45 //y2=4.885
cc_312 ( N_B_M7_noxref_g N_noxref_8_c_586_n ) capacitor c=0.0222373f //x=2.82 \
 //y=6.205 //x2=3.555 //y2=5.39
cc_313 ( N_B_M6_noxref_g N_noxref_8_c_589_n ) capacitor c=0.0132989f //x=2.38 \
 //y=6.205 //x2=2.685 //y2=5.39
cc_314 ( N_B_c_461_p N_noxref_8_c_589_n ) capacitor c=0.00410596f //x=2.745 \
 //y=4.975 //x2=2.685 //y2=5.39
cc_315 ( N_B_M7_noxref_g N_noxref_8_c_591_n ) capacitor c=0.00102459f //x=2.82 \
 //y=6.205 //x2=3.725 //y2=7.09
cc_316 ( N_B_M7_noxref_g N_noxref_8_M6_noxref_d ) capacitor c=0.0134276f \
 //x=2.82 //y=6.205 //x2=2.455 //y2=5.205
cc_317 ( N_B_M7_noxref_g N_noxref_8_M8_noxref_s ) capacitor c=0.00207713f \
 //x=2.82 //y=6.205 //x2=3.505 //y2=5.205
cc_318 ( N_noxref_6_c_474_n N_C_M8_noxref_g ) capacitor c=0.00102459f \
 //x=2.955 //y=7.09 //x2=3.86 //y2=6.205
cc_319 ( N_noxref_6_c_474_n N_noxref_8_c_586_n ) capacitor c=0.00112299f \
 //x=2.955 //y=7.09 //x2=3.555 //y2=5.39
cc_320 ( N_noxref_6_M7_noxref_d N_noxref_8_c_586_n ) capacitor c=0.0129087f \
 //x=2.895 //y=5.205 //x2=3.555 //y2=5.39
cc_321 ( N_noxref_6_c_469_n N_noxref_8_c_589_n ) capacitor c=0.0351721f \
 //x=2.075 //y=5.39 //x2=2.685 //y2=5.39
cc_322 ( N_noxref_6_c_474_n N_noxref_8_c_591_n ) capacitor c=0.027433f \
 //x=2.955 //y=7.09 //x2=3.725 //y2=7.09
cc_323 ( N_noxref_6_c_474_n N_noxref_8_M6_noxref_d ) capacitor c=0.0118172f \
 //x=2.955 //y=7.09 //x2=2.455 //y2=5.205
cc_324 ( N_noxref_6_M4_noxref_s N_noxref_8_M6_noxref_d ) capacitor \
 c=0.00107541f //x=1.145 //y=5.205 //x2=2.455 //y2=5.205
cc_325 ( N_noxref_6_M5_noxref_d N_noxref_8_M6_noxref_d ) capacitor \
 c=0.0351721f //x=2.015 //y=5.205 //x2=2.455 //y2=5.205
cc_326 ( N_noxref_6_M7_noxref_d N_noxref_8_M6_noxref_d ) capacitor \
 c=0.0458293f //x=2.895 //y=5.205 //x2=2.455 //y2=5.205
cc_327 ( N_noxref_6_M5_noxref_d N_noxref_8_M8_noxref_s ) capacitor \
 c=0.00194853f //x=2.015 //y=5.205 //x2=3.505 //y2=5.205
cc_328 ( N_noxref_6_M7_noxref_d N_noxref_8_M8_noxref_s ) capacitor c=0.027433f \
 //x=2.895 //y=5.205 //x2=3.505 //y2=5.205
cc_329 ( N_noxref_6_M7_noxref_d N_noxref_8_M9_noxref_d ) capacitor \
 c=9.17547e-19 //x=2.895 //y=5.205 //x2=4.375 //y2=5.205
cc_330 ( N_C_c_515_n N_noxref_8_c_586_n ) capacitor c=0.012085f //x=3.45 \
 //y=2.26 //x2=3.555 //y2=5.39
cc_331 ( N_C_M8_noxref_g N_noxref_8_c_586_n ) capacitor c=0.0286624f //x=3.86 \
 //y=6.205 //x2=3.555 //y2=5.39
cc_332 ( N_C_c_557_n N_noxref_8_c_586_n ) capacitor c=0.0140071f //x=3.45 \
 //y=4.885 //x2=3.555 //y2=5.39
cc_333 ( N_C_M8_noxref_g N_noxref_8_c_590_n ) capacitor c=0.016576f //x=3.86 \
 //y=6.205 //x2=4.435 //y2=7.09
cc_334 ( N_C_M9_noxref_g N_noxref_8_c_590_n ) capacitor c=0.0166873f //x=4.3 \
 //y=6.205 //x2=4.435 //y2=7.09
cc_335 ( N_C_M9_noxref_g N_noxref_8_M9_noxref_d ) capacitor c=0.0351101f \
 //x=4.3 //y=6.205 //x2=4.375 //y2=5.205
