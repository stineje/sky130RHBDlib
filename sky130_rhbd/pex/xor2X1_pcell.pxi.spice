// File: xor2X1_pcell.spi.XOR2X1_PCELL.pxi
// Created: Sun Mar 15 12:53:31 2026
//
simulator lang=spectre
x_PM_XOR2X1_PCELL\%noxref_1 ( N_noxref_1_c_15_p N_noxref_1_c_25_p \
 N_noxref_1_c_26_p N_noxref_1_c_16_p N_noxref_1_c_17_p N_noxref_1_c_28_p \
 N_noxref_1_c_29_p N_noxref_1_c_18_p N_noxref_1_c_30_p N_noxref_1_c_71_p \
 N_noxref_1_c_31_p N_noxref_1_c_32_p N_noxref_1_c_6_p N_noxref_1_c_19_p \
 N_noxref_1_c_34_p N_noxref_1_c_91_p N_noxref_1_c_74_p N_noxref_1_M0_noxref_g \
 N_noxref_1_M1_noxref_g N_noxref_1_M6_noxref_g N_noxref_1_M7_noxref_g \
 N_noxref_1_M8_noxref_g N_noxref_1_M9_noxref_g N_noxref_1_c_38_p \
 N_noxref_1_c_1_p N_noxref_1_c_2_p N_noxref_1_c_3_p N_noxref_1_c_14_p \
 N_noxref_1_c_36_p N_noxref_1_c_40_p N_noxref_1_c_4_p N_noxref_1_c_42_p \
 N_noxref_1_c_5_p N_noxref_1_c_100_p N_noxref_1_c_101_p N_noxref_1_c_103_p \
 N_noxref_1_c_92_p N_noxref_1_c_179_p N_noxref_1_c_180_p N_noxref_1_c_102_p \
 N_noxref_1_c_104_p N_noxref_1_c_10_p N_noxref_1_c_75_p )  \
 PM_XOR2X1_PCELL\%noxref_1
x_PM_XOR2X1_PCELL\%noxref_2 ( N_noxref_2_c_230_n N_noxref_2_c_235_n \
 N_noxref_2_c_238_n N_noxref_2_c_239_n N_noxref_2_c_240_n N_noxref_2_c_241_n \
 N_noxref_2_c_244_n N_noxref_2_c_250_n N_noxref_2_c_253_n N_noxref_2_c_298_p \
 N_noxref_2_c_266_n N_noxref_2_c_322_p N_noxref_2_c_299_p N_noxref_2_c_267_n \
 N_noxref_2_c_273_n N_noxref_2_c_336_p N_noxref_2_c_318_p N_noxref_2_c_274_n \
 N_noxref_2_c_306_p N_noxref_2_c_277_n N_noxref_2_c_282_n N_noxref_2_c_324_p \
 N_noxref_2_c_319_p N_noxref_2_M4_noxref_g N_noxref_2_M14_noxref_g \
 N_noxref_2_M15_noxref_g N_noxref_2_c_307_p N_noxref_2_c_308_p \
 N_noxref_2_c_314_p N_noxref_2_c_315_p N_noxref_2_c_309_p N_noxref_2_c_310_p \
 N_noxref_2_c_311_p N_noxref_2_c_312_p N_noxref_2_c_343_p \
 N_noxref_2_M0_noxref_d N_noxref_2_M6_noxref_d )  PM_XOR2X1_PCELL\%noxref_2
x_PM_XOR2X1_PCELL\%noxref_3 ( N_noxref_3_c_524_n N_noxref_3_c_526_n \
 N_noxref_3_c_606_p N_noxref_3_c_528_n N_noxref_3_c_529_n N_noxref_3_c_517_n \
 N_noxref_3_c_518_n N_noxref_3_c_519_n N_noxref_3_c_538_n N_noxref_3_c_546_n \
 N_noxref_3_c_551_n N_noxref_3_c_554_n N_noxref_3_c_560_n N_noxref_3_c_565_n \
 N_noxref_3_c_573_n N_noxref_3_c_577_n N_noxref_3_c_581_n N_noxref_3_c_799_p \
 N_noxref_3_c_582_n N_noxref_3_c_587_n N_noxref_3_c_523_n N_noxref_3_c_589_n \
 N_noxref_3_c_590_n N_noxref_3_c_613_p N_noxref_3_c_592_n \
 N_noxref_3_M2_noxref_d N_noxref_3_M4_noxref_d N_noxref_3_M10_noxref_d \
 N_noxref_3_M14_noxref_d )  PM_XOR2X1_PCELL\%noxref_3
x_PM_XOR2X1_PCELL\%noxref_4 ( N_noxref_4_c_811_n N_noxref_4_c_815_n \
 N_noxref_4_c_833_n N_noxref_4_c_837_n N_noxref_4_c_842_n N_noxref_4_c_880_n \
 N_noxref_4_c_844_n N_noxref_4_c_886_n N_noxref_4_c_845_n N_noxref_4_c_959_p \
 N_noxref_4_c_888_n N_noxref_4_c_966_p N_noxref_4_c_982_p N_noxref_4_c_889_n \
 N_noxref_4_c_891_n N_noxref_4_c_818_n N_noxref_4_c_846_n N_noxref_4_c_896_n \
 N_noxref_4_c_897_n N_noxref_4_c_898_n N_noxref_4_c_820_n N_noxref_4_c_847_n \
 N_noxref_4_c_904_n N_noxref_4_c_849_n N_noxref_4_c_913_n N_noxref_4_c_851_n \
 N_noxref_4_c_823_n N_noxref_4_c_853_n N_noxref_4_c_984_p \
 N_noxref_4_M3_noxref_g N_noxref_4_M10_noxref_g N_noxref_4_M11_noxref_g \
 N_noxref_4_c_856_n N_noxref_4_c_857_n N_noxref_4_c_858_n N_noxref_4_c_860_n \
 N_noxref_4_c_1056_p N_noxref_4_c_1057_p N_noxref_4_c_864_n N_noxref_4_c_866_n \
 N_noxref_4_c_829_n N_noxref_4_M5_noxref_d N_noxref_4_M16_noxref_d )  \
 PM_XOR2X1_PCELL\%noxref_4
x_PM_XOR2X1_PCELL\%noxref_5 ( N_noxref_5_c_1104_n N_noxref_5_c_1107_n \
 N_noxref_5_c_1155_n N_noxref_5_c_1206_n N_noxref_5_c_1109_n \
 N_noxref_5_c_1131_n N_noxref_5_c_1211_n N_noxref_5_c_1212_n \
 N_noxref_5_c_1161_n N_noxref_5_c_1222_n N_noxref_5_c_1133_n \
 N_noxref_5_c_1231_n N_noxref_5_c_1237_n N_noxref_5_c_1137_n \
 N_noxref_5_c_1110_n N_noxref_5_c_1111_n N_noxref_5_c_1140_n \
 N_noxref_5_c_1253_n N_noxref_5_c_1254_n N_noxref_5_M2_noxref_g \
 N_noxref_5_M5_noxref_g N_noxref_5_M12_noxref_g N_noxref_5_M13_noxref_g \
 N_noxref_5_M16_noxref_g N_noxref_5_M17_noxref_g N_noxref_5_c_1114_n \
 N_noxref_5_c_1117_n N_noxref_5_c_1119_n N_noxref_5_c_1122_n \
 N_noxref_5_c_1192_n N_noxref_5_c_1194_n N_noxref_5_c_1125_n \
 N_noxref_5_c_1126_n N_noxref_5_c_1262_n N_noxref_5_c_1264_n \
 N_noxref_5_c_1268_n N_noxref_5_c_1270_n N_noxref_5_c_1273_n \
 N_noxref_5_c_1275_n N_noxref_5_c_1306_p N_noxref_5_c_1278_n \
 N_noxref_5_c_1280_n N_noxref_5_c_1283_n N_noxref_5_c_1284_n \
 N_noxref_5_c_1147_n N_noxref_5_c_1285_n )  PM_XOR2X1_PCELL\%noxref_5
x_PM_XOR2X1_PCELL\%noxref_6 ( N_noxref_6_c_1377_n N_noxref_6_c_1380_n \
 N_noxref_6_c_1382_n N_noxref_6_c_1443_n N_noxref_6_c_1494_n \
 N_noxref_6_c_1496_n N_noxref_6_c_1445_n N_noxref_6_c_1384_n \
 N_noxref_6_c_1388_n N_noxref_6_c_1424_n N_noxref_6_c_1470_n \
 N_noxref_6_c_1390_n N_noxref_6_c_1396_n N_noxref_6_c_1433_n \
 N_noxref_6_c_1434_n N_noxref_6_c_1436_n N_noxref_6_M6_noxref_s \
 N_noxref_6_M7_noxref_d N_noxref_6_M8_noxref_d N_noxref_6_M12_noxref_d \
 N_noxref_6_M16_noxref_s N_noxref_6_M17_noxref_d )  PM_XOR2X1_PCELL\%noxref_6
x_PM_XOR2X1_PCELL\%noxref_7 ( N_noxref_7_c_1619_n N_noxref_7_c_1636_n \
 N_noxref_7_c_1626_n N_noxref_7_c_1629_n N_noxref_7_c_1630_n \
 N_noxref_7_c_1642_n N_noxref_7_c_1631_n N_noxref_7_c_1633_n \
 N_noxref_7_M8_noxref_s N_noxref_7_M9_noxref_d N_noxref_7_M11_noxref_d )  \
 PM_XOR2X1_PCELL\%noxref_7
x_PM_XOR2X1_PCELL\%noxref_8 ( N_noxref_8_c_1725_n N_noxref_8_c_1702_n \
 N_noxref_8_c_1712_n N_noxref_8_c_1704_n N_noxref_8_c_1705_n \
 N_noxref_8_c_1706_n N_noxref_8_c_1735_n N_noxref_8_c_1707_n \
 N_noxref_8_M12_noxref_s N_noxref_8_M13_noxref_d N_noxref_8_M15_noxref_d )  \
 PM_XOR2X1_PCELL\%noxref_8
x_PM_XOR2X1_PCELL\%noxref_9 ( N_noxref_9_c_1783_n N_noxref_9_c_1788_n \
 N_noxref_9_c_1867_n N_noxref_9_c_1838_n N_noxref_9_c_1839_n \
 N_noxref_9_c_1796_n N_noxref_9_c_1800_n N_noxref_9_c_1990_p \
 N_noxref_9_c_1801_n N_noxref_9_c_1878_n N_noxref_9_c_2013_p \
 N_noxref_9_c_1903_n N_noxref_9_c_1906_n N_noxref_9_c_1802_n \
 N_noxref_9_c_1807_n N_noxref_9_c_1851_n N_noxref_9_c_1853_n \
 N_noxref_9_c_1857_n N_noxref_9_M0_noxref_s N_noxref_9_M1_noxref_d \
 N_noxref_9_M3_noxref_d N_noxref_9_M5_noxref_s )  PM_XOR2X1_PCELL\%noxref_9
x_PM_XOR2X1_PCELL\%noxref_10 ( N_noxref_10_c_2024_n N_noxref_10_c_2025_n \
 N_noxref_10_c_2063_n N_noxref_10_c_2032_n N_noxref_10_c_2039_n \
 N_noxref_10_c_2073_n N_noxref_10_M1_noxref_s )  PM_XOR2X1_PCELL\%noxref_10
x_PM_XOR2X1_PCELL\%noxref_11 ( N_noxref_11_c_2088_n N_noxref_11_c_2089_n \
 N_noxref_11_c_2129_n N_noxref_11_c_2090_n N_noxref_11_c_2092_n \
 N_noxref_11_c_2139_n N_noxref_11_M3_noxref_s )  PM_XOR2X1_PCELL\%noxref_11
cc_1 ( N_noxref_1_c_1_p N_noxref_2_c_230_n ) capacitor c=0.0012792f //x=0.85 \
 //y=1.255 //x2=1.11 //y2=1.755
cc_2 ( N_noxref_1_c_2_p N_noxref_2_c_230_n ) capacitor c=0.00561986f //x=0.85 \
 //y=1.565 //x2=1.11 //y2=1.755
cc_3 ( N_noxref_1_c_3_p N_noxref_2_c_230_n ) capacitor c=0.00440271f //x=0.85 \
 //y=1.92 //x2=1.11 //y2=1.755
cc_4 ( N_noxref_1_c_4_p N_noxref_2_c_230_n ) capacitor c=0.00953922f //x=1.225 \
 //y=1.41 //x2=1.11 //y2=1.755
cc_5 ( N_noxref_1_c_5_p N_noxref_2_c_230_n ) capacitor c=0.00344663f //x=1.38 \
 //y=1.255 //x2=1.11 //y2=1.755
cc_6 ( N_noxref_1_c_6_p N_noxref_2_c_235_n ) capacitor c=6.95554e-19 //x=3.165 \
 //y=4.075 //x2=1.115 //y2=5.24
cc_7 ( N_noxref_1_M6_noxref_g N_noxref_2_c_235_n ) capacitor c=0.00141266f \
 //x=0.895 //y=6.02 //x2=1.115 //y2=5.24
cc_8 ( N_noxref_1_M7_noxref_g N_noxref_2_c_235_n ) capacitor c=0.00352414f \
 //x=1.335 //y=6.02 //x2=1.115 //y2=5.24
cc_9 ( N_noxref_1_c_4_p N_noxref_2_c_238_n ) capacitor c=0.00180253f //x=1.225 \
 //y=1.41 //x2=1.395 //y2=1.84
cc_10 ( N_noxref_1_c_10_p N_noxref_2_c_239_n ) capacitor c=0.00440271f \
 //x=0.74 //y=2.085 //x2=1.195 //y2=1.84
cc_11 ( N_noxref_1_M7_noxref_g N_noxref_2_c_240_n ) capacitor c=0.00958461f \
 //x=1.335 //y=6.02 //x2=1.395 //y2=4.96
cc_12 ( N_noxref_1_c_6_p N_noxref_2_c_241_n ) capacitor c=0.0134401f //x=3.165 \
 //y=4.075 //x2=1.2 //y2=4.96
cc_13 ( N_noxref_1_M6_noxref_g N_noxref_2_c_241_n ) capacitor c=0.00534267f \
 //x=0.895 //y=6.02 //x2=1.2 //y2=4.96
cc_14 ( N_noxref_1_c_14_p N_noxref_2_c_241_n ) capacitor c=0.00262283f \
 //x=1.26 //y=4.79 //x2=1.2 //y2=4.96
cc_15 ( N_noxref_1_c_15_p N_noxref_2_c_244_n ) capacitor c=0.0078132f //x=0.74 \
 //y=3.91 //x2=1.48 //y2=2.43
cc_16 ( N_noxref_1_c_16_p N_noxref_2_c_244_n ) capacitor c=0.00495348f \
 //x=3.33 //y=2.24 //x2=1.48 //y2=2.43
cc_17 ( N_noxref_1_c_17_p N_noxref_2_c_244_n ) capacitor c=0.00298036f \
 //x=3.33 //y=3.915 //x2=1.48 //y2=2.43
cc_18 ( N_noxref_1_c_18_p N_noxref_2_c_244_n ) capacitor c=0.0181783f //x=0.74 \
 //y=2.085 //x2=1.48 //y2=2.43
cc_19 ( N_noxref_1_c_19_p N_noxref_2_c_244_n ) capacitor c=4.71798e-19 \
 //x=0.74 //y=2.085 //x2=1.48 //y2=2.43
cc_20 ( N_noxref_1_c_10_p N_noxref_2_c_244_n ) capacitor c=0.00275704f \
 //x=0.74 //y=2.085 //x2=1.48 //y2=2.43
cc_21 ( N_noxref_1_c_15_p N_noxref_2_c_250_n ) capacitor c=0.0149195f //x=0.74 \
 //y=3.91 //x2=1.48 //y2=2.75
cc_22 ( N_noxref_1_c_17_p N_noxref_2_c_250_n ) capacitor c=0.00251111f \
 //x=3.33 //y=3.915 //x2=1.48 //y2=2.75
cc_23 ( N_noxref_1_c_6_p N_noxref_2_c_250_n ) capacitor c=0.00255477f \
 //x=3.165 //y=4.075 //x2=1.48 //y2=2.75
cc_24 ( N_noxref_1_c_15_p N_noxref_2_c_253_n ) capacitor c=0.0562085f //x=0.74 \
 //y=3.91 //x2=1.48 //y2=4.875
cc_25 ( N_noxref_1_c_25_p N_noxref_2_c_253_n ) capacitor c=0.0176785f //x=0.74 \
 //y=4.23 //x2=1.48 //y2=4.875
cc_26 ( N_noxref_1_c_26_p N_noxref_2_c_253_n ) capacitor c=0.0321108f //x=0.74 \
 //y=4.58 //x2=1.48 //y2=4.875
cc_27 ( N_noxref_1_c_17_p N_noxref_2_c_253_n ) capacitor c=0.0228969f //x=3.33 \
 //y=3.915 //x2=1.48 //y2=4.875
cc_28 ( N_noxref_1_c_28_p N_noxref_2_c_253_n ) capacitor c=0.00250563f \
 //x=3.33 //y=4.235 //x2=1.48 //y2=4.875
cc_29 ( N_noxref_1_c_29_p N_noxref_2_c_253_n ) capacitor c=0.00971824f \
 //x=3.33 //y=4.585 //x2=1.48 //y2=4.875
cc_30 ( N_noxref_1_c_30_p N_noxref_2_c_253_n ) capacitor c=5.56854e-19 \
 //x=0.74 //y=4.07 //x2=1.48 //y2=4.875
cc_31 ( N_noxref_1_c_31_p N_noxref_2_c_253_n ) capacitor c=0.0032735f //x=0.9 \
 //y=4.07 //x2=1.48 //y2=4.875
cc_32 ( N_noxref_1_c_32_p N_noxref_2_c_253_n ) capacitor c=0.00158465f \
 //x=3.325 //y=4.075 //x2=1.48 //y2=4.875
cc_33 ( N_noxref_1_c_6_p N_noxref_2_c_253_n ) capacitor c=0.0318589f //x=3.165 \
 //y=4.075 //x2=1.48 //y2=4.875
cc_34 ( N_noxref_1_c_34_p N_noxref_2_c_253_n ) capacitor c=0.00152249f \
 //x=0.74 //y=4.7 //x2=1.48 //y2=4.875
cc_35 ( N_noxref_1_c_14_p N_noxref_2_c_253_n ) capacitor c=0.00208693f \
 //x=1.26 //y=4.79 //x2=1.48 //y2=4.875
cc_36 ( N_noxref_1_c_36_p N_noxref_2_c_253_n ) capacitor c=0.00140024f \
 //x=0.97 //y=4.79 //x2=1.48 //y2=4.875
cc_37 ( N_noxref_1_c_17_p N_noxref_2_c_266_n ) capacitor c=5.03125e-19 \
 //x=3.33 //y=3.915 //x2=7.65 //y2=4.55
cc_38 ( N_noxref_1_c_38_p N_noxref_2_c_267_n ) capacitor c=0.00187726f \
 //x=0.85 //y=0.91 //x2=1.11 //y2=1.005
cc_39 ( N_noxref_1_c_1_p N_noxref_2_c_267_n ) capacitor c=0.00414335f //x=0.85 \
 //y=1.255 //x2=1.11 //y2=1.005
cc_40 ( N_noxref_1_c_40_p N_noxref_2_c_267_n ) capacitor c=5.57924e-19 \
 //x=1.225 //y=0.755 //x2=1.11 //y2=1.005
cc_41 ( N_noxref_1_c_4_p N_noxref_2_c_267_n ) capacitor c=5.75878e-19 \
 //x=1.225 //y=1.41 //x2=1.11 //y2=1.005
cc_42 ( N_noxref_1_c_42_p N_noxref_2_c_267_n ) capacitor c=0.00148359f \
 //x=1.38 //y=0.91 //x2=1.11 //y2=1.005
cc_43 ( N_noxref_1_c_5_p N_noxref_2_c_267_n ) capacitor c=0.00356717f //x=1.38 \
 //y=1.255 //x2=1.11 //y2=1.005
cc_44 ( N_noxref_1_c_15_p N_noxref_2_c_273_n ) capacitor c=0.00350918f \
 //x=0.74 //y=3.91 //x2=1.48 //y2=2.59
cc_45 ( N_noxref_1_c_15_p N_noxref_2_c_274_n ) capacitor c=0.00686827f \
 //x=0.74 //y=3.91 //x2=1.64 //y2=2.59
cc_46 ( N_noxref_1_c_17_p N_noxref_2_c_274_n ) capacitor c=0.0015808f //x=3.33 \
 //y=3.915 //x2=1.64 //y2=2.59
cc_47 ( N_noxref_1_c_6_p N_noxref_2_c_274_n ) capacitor c=0.00523905f \
 //x=3.165 //y=4.075 //x2=1.64 //y2=2.59
cc_48 ( N_noxref_1_c_16_p N_noxref_2_c_277_n ) capacitor c=0.00431408f \
 //x=3.33 //y=2.24 //x2=7.595 //y2=2.575
cc_49 ( N_noxref_1_c_17_p N_noxref_2_c_277_n ) capacitor c=0.0335466f //x=3.33 \
 //y=3.915 //x2=7.595 //y2=2.575
cc_50 ( N_noxref_1_c_28_p N_noxref_2_c_277_n ) capacitor c=0.0021083f //x=3.33 \
 //y=4.235 //x2=7.595 //y2=2.575
cc_51 ( N_noxref_1_c_32_p N_noxref_2_c_277_n ) capacitor c=0.00521129f \
 //x=3.325 //y=4.075 //x2=7.595 //y2=2.575
cc_52 ( N_noxref_1_c_6_p N_noxref_2_c_277_n ) capacitor c=0.0374485f //x=3.165 \
 //y=4.075 //x2=7.595 //y2=2.575
cc_53 ( N_noxref_1_M6_noxref_g N_noxref_2_c_282_n ) capacitor c=0.0162066f \
 //x=0.895 //y=6.02 //x2=1.115 //y2=5.38
cc_54 ( N_noxref_1_M7_noxref_g N_noxref_2_c_282_n ) capacitor c=0.0162066f \
 //x=1.335 //y=6.02 //x2=1.115 //y2=5.38
cc_55 ( N_noxref_1_c_14_p N_noxref_2_c_282_n ) capacitor c=0.00290963f \
 //x=1.26 //y=4.79 //x2=1.115 //y2=5.38
cc_56 ( N_noxref_1_c_38_p N_noxref_2_M0_noxref_d ) capacitor c=0.00137914f \
 //x=0.85 //y=0.91 //x2=0.925 //y2=0.91
cc_57 ( N_noxref_1_c_1_p N_noxref_2_M0_noxref_d ) capacitor c=0.0023891f \
 //x=0.85 //y=1.255 //x2=0.925 //y2=0.91
cc_58 ( N_noxref_1_c_40_p N_noxref_2_M0_noxref_d ) capacitor c=0.0020782f \
 //x=1.225 //y=0.755 //x2=0.925 //y2=0.91
cc_59 ( N_noxref_1_c_4_p N_noxref_2_M0_noxref_d ) capacitor c=0.00356097f \
 //x=1.225 //y=1.41 //x2=0.925 //y2=0.91
cc_60 ( N_noxref_1_c_42_p N_noxref_2_M0_noxref_d ) capacitor c=0.00138452f \
 //x=1.38 //y=0.91 //x2=0.925 //y2=0.91
cc_61 ( N_noxref_1_c_5_p N_noxref_2_M0_noxref_d ) capacitor c=0.00235934f \
 //x=1.38 //y=1.255 //x2=0.925 //y2=0.91
cc_62 ( N_noxref_1_c_17_p N_noxref_3_c_517_n ) capacitor c=0.0126897f //x=3.33 \
 //y=3.915 //x2=4.93 //y2=3.555
cc_63 ( N_noxref_1_c_17_p N_noxref_3_c_518_n ) capacitor c=0.00382991f \
 //x=3.33 //y=3.915 //x2=4.93 //y2=3.875
cc_64 ( N_noxref_1_c_17_p N_noxref_3_c_519_n ) capacitor c=8.27091e-19 \
 //x=3.33 //y=3.915 //x2=4.93 //y2=5.12
cc_65 ( N_noxref_1_c_28_p N_noxref_3_c_519_n ) capacitor c=0.00100476f \
 //x=3.33 //y=4.235 //x2=4.93 //y2=5.12
cc_66 ( N_noxref_1_c_29_p N_noxref_3_c_519_n ) capacitor c=0.00194983f \
 //x=3.33 //y=4.585 //x2=4.93 //y2=5.12
cc_67 ( N_noxref_1_c_32_p N_noxref_3_c_519_n ) capacitor c=4.77997e-19 \
 //x=3.325 //y=4.075 //x2=4.93 //y2=5.12
cc_68 ( N_noxref_1_c_17_p N_noxref_3_c_523_n ) capacitor c=0.00373937f \
 //x=3.33 //y=3.915 //x2=5.135 //y2=3.715
cc_69 ( N_noxref_1_c_28_p N_noxref_4_c_811_n ) capacitor c=0.0104777f //x=3.33 \
 //y=4.235 //x2=4.44 //y2=4.395
cc_70 ( N_noxref_1_c_29_p N_noxref_4_c_811_n ) capacitor c=0.00332107f \
 //x=3.33 //y=4.585 //x2=4.44 //y2=4.395
cc_71 ( N_noxref_1_c_71_p N_noxref_4_c_811_n ) capacitor c=2.20462e-19 \
 //x=3.33 //y=4.07 //x2=4.44 //y2=4.395
cc_72 ( N_noxref_1_c_32_p N_noxref_4_c_811_n ) capacitor c=0.00277624f \
 //x=3.325 //y=4.075 //x2=4.44 //y2=4.395
cc_73 ( N_noxref_1_c_29_p N_noxref_4_c_815_n ) capacitor c=0.0161091f //x=3.33 \
 //y=4.585 //x2=4.44 //y2=4.585
cc_74 ( N_noxref_1_c_74_p N_noxref_4_c_815_n ) capacitor c=9.57294e-19 \
 //x=3.33 //y=4.7 //x2=4.44 //y2=4.585
cc_75 ( N_noxref_1_c_75_p N_noxref_4_c_815_n ) capacitor c=0.00138908f \
 //x=3.33 //y=4.7 //x2=4.44 //y2=4.585
cc_76 ( N_noxref_1_c_28_p N_noxref_4_c_818_n ) capacitor c=5.21732e-19 \
 //x=3.33 //y=4.235 //x2=4.485 //y2=4.235
cc_77 ( N_noxref_1_c_71_p N_noxref_4_c_818_n ) capacitor c=0.00540988f \
 //x=3.33 //y=4.07 //x2=4.485 //y2=4.235
cc_78 ( N_noxref_1_c_28_p N_noxref_4_c_820_n ) capacitor c=6.43301e-19 \
 //x=3.33 //y=4.235 //x2=4.485 //y2=4.1
cc_79 ( N_noxref_1_c_29_p N_noxref_4_c_820_n ) capacitor c=0.00250264f \
 //x=3.33 //y=4.585 //x2=4.485 //y2=4.1
cc_80 ( N_noxref_1_c_32_p N_noxref_4_c_820_n ) capacitor c=0.00709734f \
 //x=3.325 //y=4.075 //x2=4.485 //y2=4.1
cc_81 ( N_noxref_1_c_29_p N_noxref_4_c_823_n ) capacitor c=7.48237e-19 \
 //x=3.33 //y=4.585 //x2=4.44 //y2=4.7
cc_82 ( N_noxref_1_c_74_p N_noxref_4_c_823_n ) capacitor c=0.00113699f \
 //x=3.33 //y=4.7 //x2=4.44 //y2=4.7
cc_83 ( N_noxref_1_c_75_p N_noxref_4_c_823_n ) capacitor c=0.00195576f \
 //x=3.33 //y=4.7 //x2=4.44 //y2=4.7
cc_84 ( N_noxref_1_M8_noxref_g N_noxref_4_M10_noxref_g ) capacitor \
 c=0.0102032f //x=3.23 //y=6.02 //x2=4.11 //y2=6.02
cc_85 ( N_noxref_1_M9_noxref_g N_noxref_4_M10_noxref_g ) capacitor \
 c=0.0618855f //x=3.67 //y=6.02 //x2=4.11 //y2=6.02
cc_86 ( N_noxref_1_M9_noxref_g N_noxref_4_M11_noxref_g ) capacitor \
 c=0.00945236f //x=3.67 //y=6.02 //x2=4.55 //y2=6.02
cc_87 ( N_noxref_1_c_29_p N_noxref_4_c_829_n ) capacitor c=0.0012806f //x=3.33 \
 //y=4.585 //x2=4.44 //y2=4.7
cc_88 ( N_noxref_1_c_74_p N_noxref_4_c_829_n ) capacitor c=0.0019442f //x=3.33 \
 //y=4.7 //x2=4.44 //y2=4.7
cc_89 ( N_noxref_1_c_75_p N_noxref_4_c_829_n ) capacitor c=0.067621f //x=3.33 \
 //y=4.7 //x2=4.44 //y2=4.7
cc_90 ( N_noxref_1_c_16_p N_noxref_5_c_1104_n ) capacitor c=0.012348f //x=3.33 \
 //y=2.24 //x2=4.44 //y2=2.235
cc_91 ( N_noxref_1_c_91_p N_noxref_5_c_1104_n ) capacitor c=4.19574e-19 \
 //x=3.33 //y=2.085 //x2=4.44 //y2=2.235
cc_92 ( N_noxref_1_c_92_p N_noxref_5_c_1104_n ) capacitor c=0.00149735f \
 //x=3.135 //y=1.92 //x2=4.44 //y2=2.235
cc_93 ( N_noxref_1_c_16_p N_noxref_5_c_1107_n ) capacitor c=2.06286e-19 \
 //x=3.33 //y=2.24 //x2=4.44 //y2=2.815
cc_94 ( N_noxref_1_c_17_p N_noxref_5_c_1107_n ) capacitor c=0.0134937f \
 //x=3.33 //y=3.915 //x2=4.44 //y2=2.815
cc_95 ( N_noxref_1_c_17_p N_noxref_5_c_1109_n ) capacitor c=0.00832877f \
 //x=3.33 //y=3.915 //x2=4.44 //y2=2.96
cc_96 ( N_noxref_1_c_17_p N_noxref_5_c_1110_n ) capacitor c=0.00513442f \
 //x=3.33 //y=3.915 //x2=4.6 //y2=2.975
cc_97 ( N_noxref_1_c_16_p N_noxref_5_c_1111_n ) capacitor c=5.56121e-19 \
 //x=3.33 //y=2.24 //x2=4.44 //y2=2.085
cc_98 ( N_noxref_1_c_91_p N_noxref_5_c_1111_n ) capacitor c=0.00114269f \
 //x=3.33 //y=2.085 //x2=4.44 //y2=2.085
cc_99 ( N_noxref_1_c_92_p N_noxref_5_c_1111_n ) capacitor c=0.00187625f \
 //x=3.135 //y=1.92 //x2=4.44 //y2=2.085
cc_100 ( N_noxref_1_c_100_p N_noxref_5_c_1114_n ) capacitor c=4.86545e-19 \
 //x=3.135 //y=0.87 //x2=4.105 //y2=0.91
cc_101 ( N_noxref_1_c_101_p N_noxref_5_c_1114_n ) capacitor c=0.00152405f \
 //x=3.135 //y=1.215 //x2=4.105 //y2=0.91
cc_102 ( N_noxref_1_c_102_p N_noxref_5_c_1114_n ) capacitor c=0.0157772f \
 //x=3.665 //y=0.87 //x2=4.105 //y2=0.91
cc_103 ( N_noxref_1_c_103_p N_noxref_5_c_1117_n ) capacitor c=0.00109982f \
 //x=3.135 //y=1.525 //x2=4.105 //y2=1.255
cc_104 ( N_noxref_1_c_104_p N_noxref_5_c_1117_n ) capacitor c=0.0117362f \
 //x=3.665 //y=1.215 //x2=4.105 //y2=1.255
cc_105 ( N_noxref_1_c_103_p N_noxref_5_c_1119_n ) capacitor c=9.58243e-19 \
 //x=3.135 //y=1.525 //x2=4.105 //y2=1.565
cc_106 ( N_noxref_1_c_92_p N_noxref_5_c_1119_n ) capacitor c=0.00662747f \
 //x=3.135 //y=1.92 //x2=4.105 //y2=1.565
cc_107 ( N_noxref_1_c_104_p N_noxref_5_c_1119_n ) capacitor c=0.00862358f \
 //x=3.665 //y=1.215 //x2=4.105 //y2=1.565
cc_108 ( N_noxref_1_c_16_p N_noxref_5_c_1122_n ) capacitor c=0.00170155f \
 //x=3.33 //y=2.24 //x2=4.105 //y2=1.92
cc_109 ( N_noxref_1_c_91_p N_noxref_5_c_1122_n ) capacitor c=0.00214703f \
 //x=3.33 //y=2.085 //x2=4.105 //y2=1.92
cc_110 ( N_noxref_1_c_92_p N_noxref_5_c_1122_n ) capacitor c=0.012184f \
 //x=3.135 //y=1.92 //x2=4.105 //y2=1.92
cc_111 ( N_noxref_1_c_102_p N_noxref_5_c_1125_n ) capacitor c=0.00127211f \
 //x=3.665 //y=0.87 //x2=4.635 //y2=0.91
cc_112 ( N_noxref_1_c_104_p N_noxref_5_c_1126_n ) capacitor c=0.00204774f \
 //x=3.665 //y=1.215 //x2=4.635 //y2=1.255
cc_113 ( N_noxref_1_c_25_p N_noxref_6_c_1377_n ) capacitor c=3.15482e-19 \
 //x=0.74 //y=4.23 //x2=3.365 //y2=7.4
cc_114 ( N_noxref_1_c_26_p N_noxref_6_c_1377_n ) capacitor c=5.72932e-19 \
 //x=0.74 //y=4.58 //x2=3.365 //y2=7.4
cc_115 ( N_noxref_1_c_34_p N_noxref_6_c_1377_n ) capacitor c=3.40875e-19 \
 //x=0.74 //y=4.7 //x2=3.365 //y2=7.4
cc_116 ( N_noxref_1_M8_noxref_g N_noxref_6_c_1380_n ) capacitor c=0.00404722f \
 //x=3.23 //y=6.02 //x2=3.45 //y2=6.52
cc_117 ( N_noxref_1_M9_noxref_g N_noxref_6_c_1380_n ) capacitor c=0.00381678f \
 //x=3.67 //y=6.02 //x2=3.45 //y2=6.52
cc_118 ( N_noxref_1_M8_noxref_g N_noxref_6_c_1382_n ) capacitor c=0.00543844f \
 //x=3.23 //y=6.02 //x2=3.45 //y2=7.23
cc_119 ( N_noxref_1_M9_noxref_g N_noxref_6_c_1382_n ) capacitor c=0.00573531f \
 //x=3.67 //y=6.02 //x2=3.45 //y2=7.23
cc_120 ( N_noxref_1_c_25_p N_noxref_6_c_1384_n ) capacitor c=2.90373e-19 \
 //x=0.74 //y=4.23 //x2=1.47 //y2=7.4
cc_121 ( N_noxref_1_c_26_p N_noxref_6_c_1384_n ) capacitor c=5.49403e-19 \
 //x=0.74 //y=4.58 //x2=1.47 //y2=7.4
cc_122 ( N_noxref_1_M6_noxref_g N_noxref_6_c_1384_n ) capacitor c=0.00748034f \
 //x=0.895 //y=6.02 //x2=1.47 //y2=7.4
cc_123 ( N_noxref_1_M7_noxref_g N_noxref_6_c_1384_n ) capacitor c=0.00749619f \
 //x=1.335 //y=6.02 //x2=1.47 //y2=7.4
cc_124 ( N_noxref_1_M8_noxref_g N_noxref_6_c_1388_n ) capacitor c=0.0072715f \
 //x=3.23 //y=6.02 //x2=5.38 //y2=7.4
cc_125 ( N_noxref_1_M9_noxref_g N_noxref_6_c_1388_n ) capacitor c=0.00767575f \
 //x=3.67 //y=6.02 //x2=5.38 //y2=7.4
cc_126 ( N_noxref_1_c_25_p N_noxref_6_c_1390_n ) capacitor c=0.002608f \
 //x=0.74 //y=4.23 //x2=0.74 //y2=7.4
cc_127 ( N_noxref_1_c_26_p N_noxref_6_c_1390_n ) capacitor c=0.0189675f \
 //x=0.74 //y=4.58 //x2=0.74 //y2=7.4
cc_128 ( N_noxref_1_c_30_p N_noxref_6_c_1390_n ) capacitor c=0.00438735f \
 //x=0.74 //y=4.07 //x2=0.74 //y2=7.4
cc_129 ( N_noxref_1_c_34_p N_noxref_6_c_1390_n ) capacitor c=0.00795776f \
 //x=0.74 //y=4.7 //x2=0.74 //y2=7.4
cc_130 ( N_noxref_1_M6_noxref_g N_noxref_6_c_1390_n ) capacitor c=0.0150194f \
 //x=0.895 //y=6.02 //x2=0.74 //y2=7.4
cc_131 ( N_noxref_1_c_36_p N_noxref_6_c_1390_n ) capacitor c=0.00799922f \
 //x=0.97 //y=4.79 //x2=0.74 //y2=7.4
cc_132 ( N_noxref_1_c_28_p N_noxref_6_c_1396_n ) capacitor c=0.00129292f \
 //x=3.33 //y=4.235 //x2=2.22 //y2=7.4
cc_133 ( N_noxref_1_c_29_p N_noxref_6_c_1396_n ) capacitor c=0.00926729f \
 //x=3.33 //y=4.585 //x2=2.22 //y2=7.4
cc_134 ( N_noxref_1_c_30_p N_noxref_6_c_1396_n ) capacitor c=0.00133334f \
 //x=0.74 //y=4.07 //x2=2.22 //y2=7.4
cc_135 ( N_noxref_1_c_71_p N_noxref_6_c_1396_n ) capacitor c=0.00247452f \
 //x=3.33 //y=4.07 //x2=2.22 //y2=7.4
cc_136 ( N_noxref_1_c_6_p N_noxref_6_c_1396_n ) capacitor c=0.0192133f \
 //x=3.165 //y=4.075 //x2=2.22 //y2=7.4
cc_137 ( N_noxref_1_c_34_p N_noxref_6_c_1396_n ) capacitor c=0.00235165f \
 //x=0.74 //y=4.7 //x2=2.22 //y2=7.4
cc_138 ( N_noxref_1_c_74_p N_noxref_6_c_1396_n ) capacitor c=0.00370212f \
 //x=3.33 //y=4.7 //x2=2.22 //y2=7.4
cc_139 ( N_noxref_1_c_14_p N_noxref_6_c_1396_n ) capacitor c=0.00838585f \
 //x=1.26 //y=4.79 //x2=2.22 //y2=7.4
cc_140 ( N_noxref_1_c_36_p N_noxref_6_c_1396_n ) capacitor c=2.63786e-19 \
 //x=0.97 //y=4.79 //x2=2.22 //y2=7.4
cc_141 ( N_noxref_1_c_75_p N_noxref_6_c_1396_n ) capacitor c=0.0160934f \
 //x=3.33 //y=4.7 //x2=2.22 //y2=7.4
cc_142 ( N_noxref_1_c_25_p N_noxref_6_M6_noxref_s ) capacitor c=0.00210985f \
 //x=0.74 //y=4.23 //x2=0.54 //y2=5.02
cc_143 ( N_noxref_1_c_26_p N_noxref_6_M6_noxref_s ) capacitor c=0.020913f \
 //x=0.74 //y=4.58 //x2=0.54 //y2=5.02
cc_144 ( N_noxref_1_c_31_p N_noxref_6_M6_noxref_s ) capacitor c=6.57934e-19 \
 //x=0.9 //y=4.07 //x2=0.54 //y2=5.02
cc_145 ( N_noxref_1_c_34_p N_noxref_6_M6_noxref_s ) capacitor c=0.00986151f \
 //x=0.74 //y=4.7 //x2=0.54 //y2=5.02
cc_146 ( N_noxref_1_M6_noxref_g N_noxref_6_M6_noxref_s ) capacitor \
 c=0.0573441f //x=0.895 //y=6.02 //x2=0.54 //y2=5.02
cc_147 ( N_noxref_1_c_36_p N_noxref_6_M6_noxref_s ) capacitor c=0.00531619f \
 //x=0.97 //y=4.79 //x2=0.54 //y2=5.02
cc_148 ( N_noxref_1_c_6_p N_noxref_6_M7_noxref_d ) capacitor c=0.00270385f \
 //x=3.165 //y=4.075 //x2=1.41 //y2=5.02
cc_149 ( N_noxref_1_M7_noxref_g N_noxref_6_M7_noxref_d ) capacitor \
 c=0.0572684f //x=1.335 //y=6.02 //x2=1.41 //y2=5.02
cc_150 ( N_noxref_1_c_74_p N_noxref_6_M8_noxref_d ) capacitor c=0.00152867f \
 //x=3.33 //y=4.7 //x2=3.305 //y2=5.02
cc_151 ( N_noxref_1_M8_noxref_g N_noxref_6_M8_noxref_d ) capacitor \
 c=0.00896756f //x=3.23 //y=6.02 //x2=3.305 //y2=5.02
cc_152 ( N_noxref_1_M9_noxref_g N_noxref_6_M8_noxref_d ) capacitor \
 c=0.00896756f //x=3.67 //y=6.02 //x2=3.305 //y2=5.02
cc_153 ( N_noxref_1_c_75_p N_noxref_6_M8_noxref_d ) capacitor c=0.00329802f \
 //x=3.33 //y=4.7 //x2=3.305 //y2=5.02
cc_154 ( N_noxref_1_c_28_p N_noxref_7_c_1619_n ) capacitor c=0.00177848f \
 //x=3.33 //y=4.235 //x2=3.77 //y2=5.205
cc_155 ( N_noxref_1_c_29_p N_noxref_7_c_1619_n ) capacitor c=0.0209582f \
 //x=3.33 //y=4.585 //x2=3.77 //y2=5.205
cc_156 ( N_noxref_1_c_32_p N_noxref_7_c_1619_n ) capacitor c=0.00177887f \
 //x=3.325 //y=4.075 //x2=3.77 //y2=5.205
cc_157 ( N_noxref_1_c_74_p N_noxref_7_c_1619_n ) capacitor c=0.00412201f \
 //x=3.33 //y=4.7 //x2=3.77 //y2=5.205
cc_158 ( N_noxref_1_M8_noxref_g N_noxref_7_c_1619_n ) capacitor c=0.0102378f \
 //x=3.23 //y=6.02 //x2=3.77 //y2=5.205
cc_159 ( N_noxref_1_M9_noxref_g N_noxref_7_c_1619_n ) capacitor c=0.0136385f \
 //x=3.67 //y=6.02 //x2=3.77 //y2=5.205
cc_160 ( N_noxref_1_c_75_p N_noxref_7_c_1619_n ) capacitor c=0.00186066f \
 //x=3.33 //y=4.7 //x2=3.77 //y2=5.205
cc_161 ( N_noxref_1_c_28_p N_noxref_7_c_1626_n ) capacitor c=0.00206409f \
 //x=3.33 //y=4.235 //x2=3.017 //y2=5.205
cc_162 ( N_noxref_1_c_6_p N_noxref_7_c_1626_n ) capacitor c=0.00635846f \
 //x=3.165 //y=4.075 //x2=3.017 //y2=5.205
cc_163 ( N_noxref_1_M8_noxref_g N_noxref_7_c_1626_n ) capacitor c=0.00402951f \
 //x=3.23 //y=6.02 //x2=3.017 //y2=5.205
cc_164 ( N_noxref_1_M9_noxref_g N_noxref_7_c_1629_n ) capacitor c=0.00178158f \
 //x=3.67 //y=6.02 //x2=3.89 //y2=5.205
cc_165 ( N_noxref_1_M9_noxref_g N_noxref_7_c_1630_n ) capacitor c=0.00182026f \
 //x=3.67 //y=6.02 //x2=3.89 //y2=6.735
cc_166 ( N_noxref_1_c_28_p N_noxref_7_c_1631_n ) capacitor c=3.5629e-19 \
 //x=3.33 //y=4.235 //x2=3.01 //y2=5.375
cc_167 ( N_noxref_1_M8_noxref_g N_noxref_7_c_1631_n ) capacitor c=0.0467484f \
 //x=3.23 //y=6.02 //x2=3.01 //y2=5.375
cc_168 ( N_noxref_1_M9_noxref_g N_noxref_7_c_1633_n ) capacitor c=0.0184757f \
 //x=3.67 //y=6.02 //x2=3.89 //y2=5.375
cc_169 ( N_noxref_1_M8_noxref_g N_noxref_7_M8_noxref_s ) capacitor \
 c=0.0057176f //x=3.23 //y=6.02 //x2=2.875 //y2=5.02
cc_170 ( N_noxref_1_c_25_p N_noxref_9_c_1783_n ) capacitor c=2.71938e-19 \
 //x=0.74 //y=4.23 //x2=3.315 //y2=0
cc_171 ( N_noxref_1_c_16_p N_noxref_9_c_1783_n ) capacitor c=7.4552e-19 \
 //x=3.33 //y=2.24 //x2=3.315 //y2=0
cc_172 ( N_noxref_1_c_28_p N_noxref_9_c_1783_n ) capacitor c=2.76774e-19 \
 //x=3.33 //y=4.235 //x2=3.315 //y2=0
cc_173 ( N_noxref_1_c_18_p N_noxref_9_c_1783_n ) capacitor c=0.00248634f \
 //x=0.74 //y=2.085 //x2=3.315 //y2=0
cc_174 ( N_noxref_1_c_19_p N_noxref_9_c_1783_n ) capacitor c=7.53892e-19 \
 //x=0.74 //y=2.085 //x2=3.315 //y2=0
cc_175 ( N_noxref_1_c_16_p N_noxref_9_c_1788_n ) capacitor c=0.00568696f \
 //x=3.33 //y=2.24 //x2=3.4 //y2=0.845
cc_176 ( N_noxref_1_c_91_p N_noxref_9_c_1788_n ) capacitor c=4.20163e-19 \
 //x=3.33 //y=2.085 //x2=3.4 //y2=0.845
cc_177 ( N_noxref_1_c_100_p N_noxref_9_c_1788_n ) capacitor c=0.00146326f \
 //x=3.135 //y=0.87 //x2=3.4 //y2=0.845
cc_178 ( N_noxref_1_c_101_p N_noxref_9_c_1788_n ) capacitor c=0.00305617f \
 //x=3.135 //y=1.215 //x2=3.4 //y2=0.845
cc_179 ( N_noxref_1_c_179_p N_noxref_9_c_1788_n ) capacitor c=0.00923503f \
 //x=3.51 //y=0.715 //x2=3.4 //y2=0.845
cc_180 ( N_noxref_1_c_180_p N_noxref_9_c_1788_n ) capacitor c=6.13264e-19 \
 //x=3.51 //y=1.37 //x2=3.4 //y2=0.845
cc_181 ( N_noxref_1_c_102_p N_noxref_9_c_1788_n ) capacitor c=0.00176231f \
 //x=3.665 //y=0.87 //x2=3.4 //y2=0.845
cc_182 ( N_noxref_1_c_104_p N_noxref_9_c_1788_n ) capacitor c=0.00234543f \
 //x=3.665 //y=1.215 //x2=3.4 //y2=0.845
cc_183 ( N_noxref_1_c_18_p N_noxref_9_c_1796_n ) capacitor c=0.00114179f \
 //x=0.74 //y=2.085 //x2=1.025 //y2=0.535
cc_184 ( N_noxref_1_c_19_p N_noxref_9_c_1796_n ) capacitor c=3.95714e-19 \
 //x=0.74 //y=2.085 //x2=1.025 //y2=0.535
cc_185 ( N_noxref_1_c_38_p N_noxref_9_c_1796_n ) capacitor c=0.0125519f \
 //x=0.85 //y=0.91 //x2=1.025 //y2=0.535
cc_186 ( N_noxref_1_c_10_p N_noxref_9_c_1796_n ) capacitor c=2.1838e-19 \
 //x=0.74 //y=2.085 //x2=1.025 //y2=0.535
cc_187 ( N_noxref_1_c_42_p N_noxref_9_c_1800_n ) capacitor c=0.0130723f \
 //x=1.38 //y=0.91 //x2=1.515 //y2=0.535
cc_188 ( N_noxref_1_c_100_p N_noxref_9_c_1801_n ) capacitor c=0.00683923f \
 //x=3.135 //y=0.87 //x2=5.38 //y2=0
cc_189 ( N_noxref_1_c_15_p N_noxref_9_c_1802_n ) capacitor c=0.0137647f \
 //x=0.74 //y=3.91 //x2=0.63 //y2=0
cc_190 ( N_noxref_1_c_18_p N_noxref_9_c_1802_n ) capacitor c=0.0100674f \
 //x=0.74 //y=2.085 //x2=0.63 //y2=0
cc_191 ( N_noxref_1_c_19_p N_noxref_9_c_1802_n ) capacitor c=0.00733542f \
 //x=0.74 //y=2.085 //x2=0.63 //y2=0
cc_192 ( N_noxref_1_c_3_p N_noxref_9_c_1802_n ) capacitor c=0.00552086f \
 //x=0.85 //y=1.92 //x2=0.63 //y2=0
cc_193 ( N_noxref_1_c_10_p N_noxref_9_c_1802_n ) capacitor c=0.00785621f \
 //x=0.74 //y=2.085 //x2=0.63 //y2=0
cc_194 ( N_noxref_1_c_16_p N_noxref_9_c_1807_n ) capacitor c=0.00458673f \
 //x=3.33 //y=2.24 //x2=2.22 //y2=0
cc_195 ( N_noxref_1_c_17_p N_noxref_9_c_1807_n ) capacitor c=0.00679229f \
 //x=3.33 //y=3.915 //x2=2.22 //y2=0
cc_196 ( N_noxref_1_c_6_p N_noxref_9_c_1807_n ) capacitor c=0.0022439f \
 //x=3.165 //y=4.075 //x2=2.22 //y2=0
cc_197 ( N_noxref_1_c_19_p N_noxref_9_c_1807_n ) capacitor c=0.0022444f \
 //x=0.74 //y=2.085 //x2=2.22 //y2=0
cc_198 ( N_noxref_1_c_91_p N_noxref_9_c_1807_n ) capacitor c=0.00369227f \
 //x=3.33 //y=2.085 //x2=2.22 //y2=0
cc_199 ( N_noxref_1_c_92_p N_noxref_9_c_1807_n ) capacitor c=0.00932032f \
 //x=3.135 //y=1.92 //x2=2.22 //y2=0
cc_200 ( N_noxref_1_c_10_p N_noxref_9_c_1807_n ) capacitor c=2.63786e-19 \
 //x=0.74 //y=2.085 //x2=2.22 //y2=0
cc_201 ( N_noxref_1_c_25_p N_noxref_9_M0_noxref_s ) capacitor c=2.12506e-19 \
 //x=0.74 //y=4.23 //x2=0.495 //y2=0.37
cc_202 ( N_noxref_1_c_18_p N_noxref_9_M0_noxref_s ) capacitor c=0.00297844f \
 //x=0.74 //y=2.085 //x2=0.495 //y2=0.37
cc_203 ( N_noxref_1_c_19_p N_noxref_9_M0_noxref_s ) capacitor c=0.00651272f \
 //x=0.74 //y=2.085 //x2=0.495 //y2=0.37
cc_204 ( N_noxref_1_c_38_p N_noxref_9_M0_noxref_s ) capacitor c=0.0300238f \
 //x=0.85 //y=0.91 //x2=0.495 //y2=0.37
cc_205 ( N_noxref_1_c_2_p N_noxref_9_M0_noxref_s ) capacitor c=0.002132f \
 //x=0.85 //y=1.565 //x2=0.495 //y2=0.37
cc_206 ( N_noxref_1_c_3_p N_noxref_9_M0_noxref_s ) capacitor c=0.00304786f \
 //x=0.85 //y=1.92 //x2=0.495 //y2=0.37
cc_207 ( N_noxref_1_c_40_p N_noxref_9_M0_noxref_s ) capacitor c=0.00517157f \
 //x=1.225 //y=0.755 //x2=0.495 //y2=0.37
cc_208 ( N_noxref_1_c_42_p N_noxref_9_M0_noxref_s ) capacitor c=0.0153553f \
 //x=1.38 //y=0.91 //x2=0.495 //y2=0.37
cc_209 ( N_noxref_1_c_5_p N_noxref_9_M0_noxref_s ) capacitor c=0.00629878f \
 //x=1.38 //y=1.255 //x2=0.495 //y2=0.37
cc_210 ( N_noxref_1_c_10_p N_noxref_9_M0_noxref_s ) capacitor c=0.00660494f \
 //x=0.74 //y=2.085 //x2=0.495 //y2=0.37
cc_211 ( N_noxref_1_c_16_p N_noxref_9_M1_noxref_d ) capacitor c=4.22955e-19 \
 //x=3.33 //y=2.24 //x2=3.21 //y2=0.87
cc_212 ( N_noxref_1_c_100_p N_noxref_9_M1_noxref_d ) capacitor c=0.00192399f \
 //x=3.135 //y=0.87 //x2=3.21 //y2=0.87
cc_213 ( N_noxref_1_c_101_p N_noxref_9_M1_noxref_d ) capacitor c=0.00210798f \
 //x=3.135 //y=1.215 //x2=3.21 //y2=0.87
cc_214 ( N_noxref_1_c_179_p N_noxref_9_M1_noxref_d ) capacitor c=0.00473146f \
 //x=3.51 //y=0.715 //x2=3.21 //y2=0.87
cc_215 ( N_noxref_1_c_180_p N_noxref_9_M1_noxref_d ) capacitor c=0.00166857f \
 //x=3.51 //y=1.37 //x2=3.21 //y2=0.87
cc_216 ( N_noxref_1_c_102_p N_noxref_9_M1_noxref_d ) capacitor c=0.00230174f \
 //x=3.665 //y=0.87 //x2=3.21 //y2=0.87
cc_217 ( N_noxref_1_c_104_p N_noxref_9_M1_noxref_d ) capacitor c=0.00210798f \
 //x=3.665 //y=1.215 //x2=3.21 //y2=0.87
cc_218 ( N_noxref_1_c_92_p N_noxref_10_c_2024_n ) capacitor c=0.00262672f \
 //x=3.135 //y=1.92 //x2=2.915 //y2=1.5
cc_219 ( N_noxref_1_c_16_p N_noxref_10_c_2025_n ) capacitor c=0.00483835f \
 //x=3.33 //y=2.24 //x2=3.8 //y2=1.585
cc_220 ( N_noxref_1_c_28_p N_noxref_10_c_2025_n ) capacitor c=0.00314242f \
 //x=3.33 //y=4.235 //x2=3.8 //y2=1.585
cc_221 ( N_noxref_1_c_91_p N_noxref_10_c_2025_n ) capacitor c=0.00763108f \
 //x=3.33 //y=2.085 //x2=3.8 //y2=1.585
cc_222 ( N_noxref_1_c_103_p N_noxref_10_c_2025_n ) capacitor c=0.00696372f \
 //x=3.135 //y=1.525 //x2=3.8 //y2=1.585
cc_223 ( N_noxref_1_c_92_p N_noxref_10_c_2025_n ) capacitor c=0.0175576f \
 //x=3.135 //y=1.92 //x2=3.8 //y2=1.585
cc_224 ( N_noxref_1_c_180_p N_noxref_10_c_2025_n ) capacitor c=0.00725092f \
 //x=3.51 //y=1.37 //x2=3.8 //y2=1.585
cc_225 ( N_noxref_1_c_104_p N_noxref_10_c_2025_n ) capacitor c=0.0034036f \
 //x=3.665 //y=1.215 //x2=3.8 //y2=1.585
cc_226 ( N_noxref_1_c_92_p N_noxref_10_c_2032_n ) capacitor c=6.71402e-19 \
 //x=3.135 //y=1.92 //x2=3.885 //y2=1.5
cc_227 ( N_noxref_1_c_100_p N_noxref_10_M1_noxref_s ) capacitor c=0.0294925f \
 //x=3.135 //y=0.87 //x2=2.78 //y2=0.37
cc_228 ( N_noxref_1_c_103_p N_noxref_10_M1_noxref_s ) capacitor c=3.48408e-19 \
 //x=3.135 //y=1.525 //x2=2.78 //y2=0.37
cc_229 ( N_noxref_1_c_102_p N_noxref_10_M1_noxref_s ) capacitor c=0.0125442f \
 //x=3.665 //y=0.87 //x2=2.78 //y2=0.37
cc_230 ( N_noxref_2_c_267_n N_noxref_3_c_524_n ) capacitor c=7.0089e-19 \
 //x=1.11 //y=1.005 //x2=4.37 //y2=1.125
cc_231 ( N_noxref_2_c_277_n N_noxref_3_c_524_n ) capacitor c=4.93684e-19 \
 //x=7.595 //y=2.575 //x2=4.37 //y2=1.125
cc_232 ( N_noxref_2_c_230_n N_noxref_3_c_526_n ) capacitor c=0.00493745f \
 //x=1.11 //y=1.755 //x2=4.37 //y2=1.57
cc_233 ( N_noxref_2_c_267_n N_noxref_3_c_526_n ) capacitor c=3.46581e-19 \
 //x=1.11 //y=1.005 //x2=4.37 //y2=1.57
cc_234 ( N_noxref_2_c_277_n N_noxref_3_c_528_n ) capacitor c=0.00757486f \
 //x=7.595 //y=2.575 //x2=4.845 //y2=1.655
cc_235 ( N_noxref_2_c_277_n N_noxref_3_c_529_n ) capacitor c=8.06158e-19 \
 //x=7.595 //y=2.575 //x2=4.455 //y2=1.655
cc_236 ( N_noxref_2_c_238_n N_noxref_3_c_517_n ) capacitor c=0.00197799f \
 //x=1.395 //y=1.84 //x2=4.93 //y2=3.555
cc_237 ( N_noxref_2_c_298_p N_noxref_3_c_517_n ) capacitor c=0.00174515f \
 //x=7.65 //y=2.735 //x2=4.93 //y2=3.555
cc_238 ( N_noxref_2_c_299_p N_noxref_3_c_517_n ) capacitor c=4.56327e-19 \
 //x=7.77 //y=2.415 //x2=4.93 //y2=3.555
cc_239 ( N_noxref_2_c_277_n N_noxref_3_c_517_n ) capacitor c=0.0274064f \
 //x=7.595 //y=2.575 //x2=4.93 //y2=3.555
cc_240 ( N_noxref_2_c_266_n N_noxref_3_c_518_n ) capacitor c=0.00197512f \
 //x=7.65 //y=4.55 //x2=4.93 //y2=3.875
cc_241 ( N_noxref_2_c_235_n N_noxref_3_c_519_n ) capacitor c=6.97655e-19 \
 //x=1.115 //y=5.24 //x2=4.93 //y2=5.12
cc_242 ( N_noxref_2_c_253_n N_noxref_3_c_519_n ) capacitor c=0.00217756f \
 //x=1.48 //y=4.875 //x2=4.93 //y2=5.12
cc_243 ( N_noxref_2_c_266_n N_noxref_3_c_519_n ) capacitor c=0.00526544f \
 //x=7.65 //y=4.55 //x2=4.93 //y2=5.12
cc_244 ( N_noxref_2_c_298_p N_noxref_3_c_538_n ) capacitor c=4.06021e-19 \
 //x=7.65 //y=2.735 //x2=7.7 //y2=1.12
cc_245 ( N_noxref_2_c_306_p N_noxref_3_c_538_n ) capacitor c=2.49465e-19 \
 //x=7.755 //y=2.575 //x2=7.7 //y2=1.12
cc_246 ( N_noxref_2_c_307_p N_noxref_3_c_538_n ) capacitor c=4.13109e-19 \
 //x=7.435 //y=0.91 //x2=7.7 //y2=1.12
cc_247 ( N_noxref_2_c_308_p N_noxref_3_c_538_n ) capacitor c=0.00213f \
 //x=7.435 //y=1.255 //x2=7.7 //y2=1.12
cc_248 ( N_noxref_2_c_309_p N_noxref_3_c_538_n ) capacitor c=5.28423e-19 \
 //x=7.81 //y=0.755 //x2=7.7 //y2=1.12
cc_249 ( N_noxref_2_c_310_p N_noxref_3_c_538_n ) capacitor c=4.49341e-19 \
 //x=7.81 //y=1.41 //x2=7.7 //y2=1.12
cc_250 ( N_noxref_2_c_311_p N_noxref_3_c_538_n ) capacitor c=4.42805e-19 \
 //x=7.965 //y=0.91 //x2=7.7 //y2=1.12
cc_251 ( N_noxref_2_c_312_p N_noxref_3_c_538_n ) capacitor c=0.00304778f \
 //x=7.965 //y=1.255 //x2=7.7 //y2=1.12
cc_252 ( N_noxref_2_c_308_p N_noxref_3_c_546_n ) capacitor c=0.00119008f \
 //x=7.435 //y=1.255 //x2=7.7 //y2=1.57
cc_253 ( N_noxref_2_c_314_p N_noxref_3_c_546_n ) capacitor c=0.00410123f \
 //x=7.435 //y=1.565 //x2=7.7 //y2=1.57
cc_254 ( N_noxref_2_c_315_p N_noxref_3_c_546_n ) capacitor c=0.00329274f \
 //x=7.435 //y=1.92 //x2=7.7 //y2=1.57
cc_255 ( N_noxref_2_c_310_p N_noxref_3_c_546_n ) capacitor c=0.00740116f \
 //x=7.81 //y=1.41 //x2=7.7 //y2=1.57
cc_256 ( N_noxref_2_c_312_p N_noxref_3_c_546_n ) capacitor c=0.00303393f \
 //x=7.965 //y=1.255 //x2=7.7 //y2=1.57
cc_257 ( N_noxref_2_c_318_p N_noxref_3_c_551_n ) capacitor c=0.00245563f \
 //x=7.65 //y=4.697 //x2=8.055 //y2=5.205
cc_258 ( N_noxref_2_c_319_p N_noxref_3_c_551_n ) capacitor c=0.00104675f \
 //x=7.77 //y=4.7 //x2=8.055 //y2=5.205
cc_259 ( N_noxref_2_M15_noxref_g N_noxref_3_c_551_n ) capacitor c=0.00983704f \
 //x=7.88 //y=6.02 //x2=8.055 //y2=5.205
cc_260 ( N_noxref_2_c_298_p N_noxref_3_c_554_n ) capacitor c=7.52676e-19 \
 //x=7.65 //y=2.735 //x2=8.055 //y2=1.655
cc_261 ( N_noxref_2_c_322_p N_noxref_3_c_554_n ) capacitor c=0.00329057f \
 //x=7.77 //y=2.23 //x2=8.055 //y2=1.655
cc_262 ( N_noxref_2_c_306_p N_noxref_3_c_554_n ) capacitor c=3.72305e-19 \
 //x=7.755 //y=2.575 //x2=8.055 //y2=1.655
cc_263 ( N_noxref_2_c_324_p N_noxref_3_c_554_n ) capacitor c=0.00147657f \
 //x=7.77 //y=2.085 //x2=8.055 //y2=1.655
cc_264 ( N_noxref_2_c_310_p N_noxref_3_c_554_n ) capacitor c=0.00124662f \
 //x=7.81 //y=1.41 //x2=8.055 //y2=1.655
cc_265 ( N_noxref_2_c_312_p N_noxref_3_c_554_n ) capacitor c=0.00300547f \
 //x=7.965 //y=1.255 //x2=8.055 //y2=1.655
cc_266 ( N_noxref_2_c_298_p N_noxref_3_c_560_n ) capacitor c=0.00108723f \
 //x=7.65 //y=2.735 //x2=7.785 //y2=1.655
cc_267 ( N_noxref_2_c_322_p N_noxref_3_c_560_n ) capacitor c=0.0245822f \
 //x=7.77 //y=2.23 //x2=7.785 //y2=1.655
cc_268 ( N_noxref_2_c_306_p N_noxref_3_c_560_n ) capacitor c=4.74754e-19 \
 //x=7.755 //y=2.575 //x2=7.785 //y2=1.655
cc_269 ( N_noxref_2_c_324_p N_noxref_3_c_560_n ) capacitor c=0.00408056f \
 //x=7.77 //y=2.085 //x2=7.785 //y2=1.655
cc_270 ( N_noxref_2_c_315_p N_noxref_3_c_560_n ) capacitor c=0.00189997f \
 //x=7.435 //y=1.92 //x2=7.785 //y2=1.655
cc_271 ( N_noxref_2_c_298_p N_noxref_3_c_565_n ) capacitor c=0.0345487f \
 //x=7.65 //y=2.735 //x2=8.14 //y2=3.555
cc_272 ( N_noxref_2_c_266_n N_noxref_3_c_565_n ) capacitor c=0.0520611f \
 //x=7.65 //y=4.55 //x2=8.14 //y2=3.555
cc_273 ( N_noxref_2_c_322_p N_noxref_3_c_565_n ) capacitor c=0.0335163f \
 //x=7.77 //y=2.23 //x2=8.14 //y2=3.555
cc_274 ( N_noxref_2_c_299_p N_noxref_3_c_565_n ) capacitor c=0.015798f \
 //x=7.77 //y=2.415 //x2=8.14 //y2=3.555
cc_275 ( N_noxref_2_c_336_p N_noxref_3_c_565_n ) capacitor c=0.00268185f \
 //x=7.77 //y=2.59 //x2=8.14 //y2=3.555
cc_276 ( N_noxref_2_c_306_p N_noxref_3_c_565_n ) capacitor c=0.0127171f \
 //x=7.755 //y=2.575 //x2=8.14 //y2=3.555
cc_277 ( N_noxref_2_c_324_p N_noxref_3_c_565_n ) capacitor c=0.00263396f \
 //x=7.77 //y=2.085 //x2=8.14 //y2=3.555
cc_278 ( N_noxref_2_c_315_p N_noxref_3_c_565_n ) capacitor c=0.00855577f \
 //x=7.435 //y=1.92 //x2=8.14 //y2=3.555
cc_279 ( N_noxref_2_c_298_p N_noxref_3_c_573_n ) capacitor c=0.0011496f \
 //x=7.65 //y=2.735 //x2=8.14 //y2=3.875
cc_280 ( N_noxref_2_c_266_n N_noxref_3_c_573_n ) capacitor c=0.0328751f \
 //x=7.65 //y=4.55 //x2=8.14 //y2=3.875
cc_281 ( N_noxref_2_c_318_p N_noxref_3_c_573_n ) capacitor c=2.21717e-19 \
 //x=7.65 //y=4.697 //x2=8.14 //y2=3.875
cc_282 ( N_noxref_2_c_343_p N_noxref_3_c_573_n ) capacitor c=0.00109921f \
 //x=7.77 //y=4.7 //x2=8.14 //y2=3.875
cc_283 ( N_noxref_2_c_266_n N_noxref_3_c_577_n ) capacitor c=0.0421585f \
 //x=7.65 //y=4.55 //x2=8.14 //y2=5.12
cc_284 ( N_noxref_2_c_318_p N_noxref_3_c_577_n ) capacitor c=0.033569f \
 //x=7.65 //y=4.697 //x2=8.14 //y2=5.12
cc_285 ( N_noxref_2_c_319_p N_noxref_3_c_577_n ) capacitor c=0.00262905f \
 //x=7.77 //y=4.7 //x2=8.14 //y2=5.12
cc_286 ( N_noxref_2_c_343_p N_noxref_3_c_577_n ) capacitor c=0.0109587f \
 //x=7.77 //y=4.7 //x2=8.14 //y2=5.12
cc_287 ( N_noxref_2_c_235_n N_noxref_3_c_581_n ) capacitor c=3.86497e-19 \
 //x=1.115 //y=5.24 //x2=4.33 //y2=5.205
cc_288 ( N_noxref_2_c_318_p N_noxref_3_c_582_n ) capacitor c=0.0275415f \
 //x=7.65 //y=4.697 //x2=7.66 //y2=5.205
cc_289 ( N_noxref_2_c_319_p N_noxref_3_c_582_n ) capacitor c=0.0039033f \
 //x=7.77 //y=4.7 //x2=7.66 //y2=5.205
cc_290 ( N_noxref_2_M14_noxref_g N_noxref_3_c_582_n ) capacitor c=0.00179079f \
 //x=7.44 //y=6.02 //x2=7.66 //y2=5.205
cc_291 ( N_noxref_2_M15_noxref_g N_noxref_3_c_582_n ) capacitor c=0.00270394f \
 //x=7.88 //y=6.02 //x2=7.66 //y2=5.205
cc_292 ( N_noxref_2_c_343_p N_noxref_3_c_582_n ) capacitor c=0.00190838f \
 //x=7.77 //y=4.7 //x2=7.66 //y2=5.205
cc_293 ( N_noxref_2_c_266_n N_noxref_3_c_587_n ) capacitor c=0.00518857f \
 //x=7.65 //y=4.55 //x2=8.14 //y2=3.7
cc_294 ( N_noxref_2_c_277_n N_noxref_3_c_523_n ) capacitor c=7.7387e-19 \
 //x=7.595 //y=2.575 //x2=5.135 //y2=3.715
cc_295 ( N_noxref_2_c_266_n N_noxref_3_c_589_n ) capacitor c=0.00368778f \
 //x=7.65 //y=4.55 //x2=8.155 //y2=3.715
cc_296 ( N_noxref_2_c_266_n N_noxref_3_c_590_n ) capacitor c=0.0208701f \
 //x=7.65 //y=4.55 //x2=7.995 //y2=3.715
cc_297 ( N_noxref_2_c_277_n N_noxref_3_c_590_n ) capacitor c=0.0049308f \
 //x=7.595 //y=2.575 //x2=7.995 //y2=3.715
cc_298 ( N_noxref_2_c_318_p N_noxref_3_c_592_n ) capacitor c=0.00369516f \
 //x=7.65 //y=4.697 //x2=7.66 //y2=5.375
cc_299 ( N_noxref_2_c_319_p N_noxref_3_c_592_n ) capacitor c=0.00414273f \
 //x=7.77 //y=4.7 //x2=7.66 //y2=5.375
cc_300 ( N_noxref_2_M14_noxref_g N_noxref_3_c_592_n ) capacitor c=0.0120591f \
 //x=7.44 //y=6.02 //x2=7.66 //y2=5.375
cc_301 ( N_noxref_2_M15_noxref_g N_noxref_3_c_592_n ) capacitor c=0.0140704f \
 //x=7.88 //y=6.02 //x2=7.66 //y2=5.375
cc_302 ( N_noxref_2_c_343_p N_noxref_3_c_592_n ) capacitor c=0.0044017f \
 //x=7.77 //y=4.7 //x2=7.66 //y2=5.375
cc_303 ( N_noxref_2_c_298_p N_noxref_3_M4_noxref_d ) capacitor c=2.74358e-19 \
 //x=7.65 //y=2.735 //x2=7.51 //y2=0.91
cc_304 ( N_noxref_2_c_322_p N_noxref_3_M4_noxref_d ) capacitor c=9.49603e-19 \
 //x=7.77 //y=2.23 //x2=7.51 //y2=0.91
cc_305 ( N_noxref_2_c_324_p N_noxref_3_M4_noxref_d ) capacitor c=0.00150031f \
 //x=7.77 //y=2.085 //x2=7.51 //y2=0.91
cc_306 ( N_noxref_2_c_307_p N_noxref_3_M4_noxref_d ) capacitor c=0.00137165f \
 //x=7.435 //y=0.91 //x2=7.51 //y2=0.91
cc_307 ( N_noxref_2_c_308_p N_noxref_3_M4_noxref_d ) capacitor c=0.00237422f \
 //x=7.435 //y=1.255 //x2=7.51 //y2=0.91
cc_308 ( N_noxref_2_c_309_p N_noxref_3_M4_noxref_d ) capacitor c=0.0020782f \
 //x=7.81 //y=0.755 //x2=7.51 //y2=0.91
cc_309 ( N_noxref_2_c_310_p N_noxref_3_M4_noxref_d ) capacitor c=0.00344131f \
 //x=7.81 //y=1.41 //x2=7.51 //y2=0.91
cc_310 ( N_noxref_2_c_311_p N_noxref_3_M4_noxref_d ) capacitor c=8.50094e-19 \
 //x=7.965 //y=0.91 //x2=7.51 //y2=0.91
cc_311 ( N_noxref_2_c_312_p N_noxref_3_M4_noxref_d ) capacitor c=0.00237422f \
 //x=7.965 //y=1.255 //x2=7.51 //y2=0.91
cc_312 ( N_noxref_2_c_253_n N_noxref_4_c_815_n ) capacitor c=4.10384e-19 \
 //x=1.48 //y=4.875 //x2=4.44 //y2=4.585
cc_313 ( N_noxref_2_c_322_p N_noxref_4_c_833_n ) capacitor c=0.0111982f \
 //x=7.77 //y=2.23 //x2=6.66 //y2=2.205
cc_314 ( N_noxref_2_c_277_n N_noxref_4_c_833_n ) capacitor c=0.00333983f \
 //x=7.595 //y=2.575 //x2=6.66 //y2=2.205
cc_315 ( N_noxref_2_c_324_p N_noxref_4_c_833_n ) capacitor c=3.75556e-19 \
 //x=7.77 //y=2.085 //x2=6.66 //y2=2.205
cc_316 ( N_noxref_2_c_315_p N_noxref_4_c_833_n ) capacitor c=0.00152667f \
 //x=7.435 //y=1.92 //x2=6.66 //y2=2.205
cc_317 ( N_noxref_2_c_298_p N_noxref_4_c_837_n ) capacitor c=0.0214146f \
 //x=7.65 //y=2.735 //x2=6.66 //y2=3.205
cc_318 ( N_noxref_2_c_322_p N_noxref_4_c_837_n ) capacitor c=0.00108959f \
 //x=7.77 //y=2.23 //x2=6.66 //y2=3.205
cc_319 ( N_noxref_2_c_299_p N_noxref_4_c_837_n ) capacitor c=0.00492906f \
 //x=7.77 //y=2.415 //x2=6.66 //y2=3.205
cc_320 ( N_noxref_2_c_306_p N_noxref_4_c_837_n ) capacitor c=0.00147011f \
 //x=7.755 //y=2.575 //x2=6.66 //y2=3.205
cc_321 ( N_noxref_2_c_277_n N_noxref_4_c_837_n ) capacitor c=0.0279132f \
 //x=7.595 //y=2.575 //x2=6.66 //y2=3.205
cc_322 ( N_noxref_2_c_266_n N_noxref_4_c_842_n ) capacitor c=8.64336e-19 \
 //x=7.65 //y=4.55 //x2=9.62 //y2=3.155
cc_323 ( N_noxref_2_c_299_p N_noxref_4_c_842_n ) capacitor c=0.00105161f \
 //x=7.77 //y=2.415 //x2=9.62 //y2=3.155
cc_324 ( N_noxref_2_c_266_n N_noxref_4_c_844_n ) capacitor c=0.00112373f \
 //x=7.65 //y=4.55 //x2=9.62 //y2=3.955
cc_325 ( N_noxref_2_c_266_n N_noxref_4_c_845_n ) capacitor c=6.04659e-19 \
 //x=7.65 //y=4.55 //x2=9.62 //y2=4.875
cc_326 ( N_noxref_2_c_266_n N_noxref_4_c_846_n ) capacitor c=0.0100855f \
 //x=7.65 //y=4.55 //x2=6.66 //y2=3.33
cc_327 ( N_noxref_2_c_266_n N_noxref_4_c_847_n ) capacitor c=0.00284758f \
 //x=7.65 //y=4.55 //x2=6.82 //y2=3.345
cc_328 ( N_noxref_2_c_277_n N_noxref_4_c_847_n ) capacitor c=0.0011786f \
 //x=7.595 //y=2.575 //x2=6.82 //y2=3.345
cc_329 ( N_noxref_2_c_266_n N_noxref_4_c_849_n ) capacitor c=0.0217961f \
 //x=7.65 //y=4.55 //x2=9.465 //y2=4.09
cc_330 ( N_noxref_2_c_277_n N_noxref_4_c_849_n ) capacitor c=0.00109024f \
 //x=7.595 //y=2.575 //x2=9.465 //y2=4.09
cc_331 ( N_noxref_2_c_266_n N_noxref_4_c_851_n ) capacitor c=0.0196397f \
 //x=7.65 //y=4.55 //x2=9.495 //y2=3.315
cc_332 ( N_noxref_2_c_277_n N_noxref_4_c_851_n ) capacitor c=0.0046655f \
 //x=7.595 //y=2.575 //x2=9.495 //y2=3.315
cc_333 ( N_noxref_2_c_322_p N_noxref_4_c_853_n ) capacitor c=7.23736e-19 \
 //x=7.77 //y=2.23 //x2=6.66 //y2=2.085
cc_334 ( N_noxref_2_c_324_p N_noxref_4_c_853_n ) capacitor c=0.00114264f \
 //x=7.77 //y=2.085 //x2=6.66 //y2=2.085
cc_335 ( N_noxref_2_c_315_p N_noxref_4_c_853_n ) capacitor c=0.00214703f \
 //x=7.435 //y=1.92 //x2=6.66 //y2=2.085
cc_336 ( N_noxref_2_c_307_p N_noxref_4_c_856_n ) capacitor c=4.86545e-19 \
 //x=7.435 //y=0.91 //x2=6.465 //y2=0.87
cc_337 ( N_noxref_2_c_307_p N_noxref_4_c_857_n ) capacitor c=0.00152405f \
 //x=7.435 //y=0.91 //x2=6.465 //y2=1.215
cc_338 ( N_noxref_2_c_308_p N_noxref_4_c_858_n ) capacitor c=0.00109982f \
 //x=7.435 //y=1.255 //x2=6.465 //y2=1.525
cc_339 ( N_noxref_2_c_314_p N_noxref_4_c_858_n ) capacitor c=9.58243e-19 \
 //x=7.435 //y=1.565 //x2=6.465 //y2=1.525
cc_340 ( N_noxref_2_c_322_p N_noxref_4_c_860_n ) capacitor c=0.00153002f \
 //x=7.77 //y=2.23 //x2=6.465 //y2=1.92
cc_341 ( N_noxref_2_c_324_p N_noxref_4_c_860_n ) capacitor c=0.00187625f \
 //x=7.77 //y=2.085 //x2=6.465 //y2=1.92
cc_342 ( N_noxref_2_c_314_p N_noxref_4_c_860_n ) capacitor c=0.00662747f \
 //x=7.435 //y=1.565 //x2=6.465 //y2=1.92
cc_343 ( N_noxref_2_c_315_p N_noxref_4_c_860_n ) capacitor c=0.012184f \
 //x=7.435 //y=1.92 //x2=6.465 //y2=1.92
cc_344 ( N_noxref_2_c_307_p N_noxref_4_c_864_n ) capacitor c=0.0157772f \
 //x=7.435 //y=0.91 //x2=6.995 //y2=0.87
cc_345 ( N_noxref_2_c_311_p N_noxref_4_c_864_n ) capacitor c=0.00127211f \
 //x=7.965 //y=0.91 //x2=6.995 //y2=0.87
cc_346 ( N_noxref_2_c_308_p N_noxref_4_c_866_n ) capacitor c=0.0117362f \
 //x=7.435 //y=1.255 //x2=6.995 //y2=1.215
cc_347 ( N_noxref_2_c_314_p N_noxref_4_c_866_n ) capacitor c=0.00862358f \
 //x=7.435 //y=1.565 //x2=6.995 //y2=1.215
cc_348 ( N_noxref_2_c_312_p N_noxref_4_c_866_n ) capacitor c=0.00204774f \
 //x=7.965 //y=1.255 //x2=6.995 //y2=1.215
cc_349 ( N_noxref_2_c_277_n N_noxref_5_c_1104_n ) capacitor c=0.00315782f \
 //x=7.595 //y=2.575 //x2=4.44 //y2=2.235
cc_350 ( N_noxref_2_c_244_n N_noxref_5_c_1107_n ) capacitor c=4.78474e-19 \
 //x=1.48 //y=2.43 //x2=4.44 //y2=2.815
cc_351 ( N_noxref_2_c_277_n N_noxref_5_c_1107_n ) capacitor c=0.0230148f \
 //x=7.595 //y=2.575 //x2=4.44 //y2=2.815
cc_352 ( N_noxref_2_c_277_n N_noxref_5_c_1109_n ) capacitor c=0.00512176f \
 //x=7.595 //y=2.575 //x2=4.44 //y2=2.96
cc_353 ( N_noxref_2_c_266_n N_noxref_5_c_1131_n ) capacitor c=0.0128176f \
 //x=7.65 //y=4.55 //x2=6.66 //y2=4.44
cc_354 ( N_noxref_2_c_319_p N_noxref_5_c_1131_n ) capacitor c=2.2865e-19 \
 //x=7.77 //y=4.7 //x2=6.66 //y2=4.44
cc_355 ( N_noxref_2_c_298_p N_noxref_5_c_1133_n ) capacitor c=0.00753295f \
 //x=7.65 //y=2.735 //x2=9.27 //y2=2.96
cc_356 ( N_noxref_2_c_266_n N_noxref_5_c_1133_n ) capacitor c=0.0196093f \
 //x=7.65 //y=4.55 //x2=9.27 //y2=2.96
cc_357 ( N_noxref_2_c_306_p N_noxref_5_c_1133_n ) capacitor c=0.0367867f \
 //x=7.755 //y=2.575 //x2=9.27 //y2=2.96
cc_358 ( N_noxref_2_c_277_n N_noxref_5_c_1133_n ) capacitor c=0.270373f \
 //x=7.595 //y=2.575 //x2=9.27 //y2=2.96
cc_359 ( N_noxref_2_c_266_n N_noxref_5_c_1137_n ) capacitor c=0.0248503f \
 //x=7.65 //y=4.55 //x2=9.495 //y2=4.475
cc_360 ( N_noxref_2_c_318_p N_noxref_5_c_1137_n ) capacitor c=0.0107356f \
 //x=7.65 //y=4.697 //x2=9.495 //y2=4.475
cc_361 ( N_noxref_2_c_277_n N_noxref_5_c_1110_n ) capacitor c=0.0367391f \
 //x=7.595 //y=2.575 //x2=4.6 //y2=2.975
cc_362 ( N_noxref_2_c_266_n N_noxref_5_c_1140_n ) capacitor c=9.46427e-19 \
 //x=7.65 //y=4.55 //x2=6.66 //y2=4.44
cc_363 ( N_noxref_2_c_318_p N_noxref_5_c_1140_n ) capacitor c=0.00297256f \
 //x=7.65 //y=4.697 //x2=6.66 //y2=4.44
cc_364 ( N_noxref_2_c_319_p N_noxref_5_c_1140_n ) capacitor c=0.00150017f \
 //x=7.77 //y=4.7 //x2=6.66 //y2=4.44
cc_365 ( N_noxref_2_c_343_p N_noxref_5_c_1140_n ) capacitor c=0.00186624f \
 //x=7.77 //y=4.7 //x2=6.66 //y2=4.44
cc_366 ( N_noxref_2_M14_noxref_g N_noxref_5_M12_noxref_g ) capacitor \
 c=0.0102032f //x=7.44 //y=6.02 //x2=6.56 //y2=6.02
cc_367 ( N_noxref_2_M14_noxref_g N_noxref_5_M13_noxref_g ) capacitor \
 c=0.0618439f //x=7.44 //y=6.02 //x2=7 //y2=6.02
cc_368 ( N_noxref_2_M15_noxref_g N_noxref_5_M13_noxref_g ) capacitor \
 c=0.00945236f //x=7.88 //y=6.02 //x2=7 //y2=6.02
cc_369 ( N_noxref_2_c_318_p N_noxref_5_c_1147_n ) capacitor c=0.00105639f \
 //x=7.65 //y=4.697 //x2=6.66 //y2=4.7
cc_370 ( N_noxref_2_c_319_p N_noxref_5_c_1147_n ) capacitor c=0.00166675f \
 //x=7.77 //y=4.7 //x2=6.66 //y2=4.7
cc_371 ( N_noxref_2_c_343_p N_noxref_5_c_1147_n ) capacitor c=0.0664454f \
 //x=7.77 //y=4.7 //x2=6.66 //y2=4.7
cc_372 ( N_noxref_2_c_235_n N_noxref_6_c_1377_n ) capacitor c=0.00259272f \
 //x=1.115 //y=5.24 //x2=3.365 //y2=7.4
cc_373 ( N_noxref_2_c_240_n N_noxref_6_c_1377_n ) capacitor c=0.00199455f \
 //x=1.395 //y=4.96 //x2=3.365 //y2=7.4
cc_374 ( N_noxref_2_c_282_n N_noxref_6_c_1377_n ) capacitor c=0.0024144f \
 //x=1.115 //y=5.38 //x2=3.365 //y2=7.4
cc_375 ( N_noxref_2_c_235_n N_noxref_6_c_1384_n ) capacitor c=8.9666e-19 \
 //x=1.115 //y=5.24 //x2=1.47 //y2=7.4
cc_376 ( N_noxref_2_c_240_n N_noxref_6_c_1384_n ) capacitor c=0.00197518f \
 //x=1.395 //y=4.96 //x2=1.47 //y2=7.4
cc_377 ( N_noxref_2_c_282_n N_noxref_6_c_1384_n ) capacitor c=0.0137788f \
 //x=1.115 //y=5.38 //x2=1.47 //y2=7.4
cc_378 ( N_noxref_2_M14_noxref_g N_noxref_6_c_1424_n ) capacitor c=0.00772064f \
 //x=7.44 //y=6.02 //x2=8.71 //y2=7.4
cc_379 ( N_noxref_2_M15_noxref_g N_noxref_6_c_1424_n ) capacitor c=0.00753389f \
 //x=7.88 //y=6.02 //x2=8.71 //y2=7.4
cc_380 ( N_noxref_2_c_241_n N_noxref_6_c_1390_n ) capacitor c=0.00685597f \
 //x=1.2 //y=4.96 //x2=0.74 //y2=7.4
cc_381 ( N_noxref_2_c_253_n N_noxref_6_c_1390_n ) capacitor c=2.43252e-19 \
 //x=1.48 //y=4.875 //x2=0.74 //y2=7.4
cc_382 ( N_noxref_2_c_282_n N_noxref_6_c_1390_n ) capacitor c=0.00822762f \
 //x=1.115 //y=5.38 //x2=0.74 //y2=7.4
cc_383 ( N_noxref_2_c_235_n N_noxref_6_c_1396_n ) capacitor c=0.00232499f \
 //x=1.115 //y=5.24 //x2=2.22 //y2=7.4
cc_384 ( N_noxref_2_c_253_n N_noxref_6_c_1396_n ) capacitor c=0.021852f \
 //x=1.48 //y=4.875 //x2=2.22 //y2=7.4
cc_385 ( N_noxref_2_c_277_n N_noxref_6_c_1396_n ) capacitor c=0.00182447f \
 //x=7.595 //y=2.575 //x2=2.22 //y2=7.4
cc_386 ( N_noxref_2_c_282_n N_noxref_6_c_1396_n ) capacitor c=0.00820601f \
 //x=1.115 //y=5.38 //x2=2.22 //y2=7.4
cc_387 ( N_noxref_2_c_266_n N_noxref_6_c_1433_n ) capacitor c=8.19548e-19 \
 //x=7.65 //y=4.55 //x2=5.55 //y2=7.4
cc_388 ( N_noxref_2_c_319_p N_noxref_6_c_1434_n ) capacitor c=0.00347772f \
 //x=7.77 //y=4.7 //x2=8.88 //y2=7.4
cc_389 ( N_noxref_2_c_343_p N_noxref_6_c_1434_n ) capacitor c=0.0199669f \
 //x=7.77 //y=4.7 //x2=8.88 //y2=7.4
cc_390 ( N_noxref_2_c_282_n N_noxref_6_c_1436_n ) capacitor c=0.00135089f \
 //x=1.115 //y=5.38 //x2=10.36 //y2=7.4
cc_391 ( N_noxref_2_c_235_n N_noxref_6_M6_noxref_s ) capacitor c=0.0480012f \
 //x=1.115 //y=5.24 //x2=0.54 //y2=5.02
cc_392 ( N_noxref_2_c_282_n N_noxref_6_M6_noxref_s ) capacitor c=0.0920695f \
 //x=1.115 //y=5.38 //x2=0.54 //y2=5.02
cc_393 ( N_noxref_2_c_235_n N_noxref_6_M7_noxref_d ) capacitor c=0.0474638f \
 //x=1.115 //y=5.24 //x2=1.41 //y2=5.02
cc_394 ( N_noxref_2_c_240_n N_noxref_6_M7_noxref_d ) capacitor c=0.021356f \
 //x=1.395 //y=4.96 //x2=1.41 //y2=5.02
cc_395 ( N_noxref_2_c_250_n N_noxref_6_M7_noxref_d ) capacitor c=0.00162332f \
 //x=1.48 //y=2.75 //x2=1.41 //y2=5.02
cc_396 ( N_noxref_2_c_282_n N_noxref_6_M7_noxref_d ) capacitor c=0.0908242f \
 //x=1.115 //y=5.38 //x2=1.41 //y2=5.02
cc_397 ( N_noxref_2_c_235_n N_noxref_7_c_1626_n ) capacitor c=0.001884f \
 //x=1.115 //y=5.24 //x2=3.017 //y2=5.205
cc_398 ( N_noxref_2_M14_noxref_g N_noxref_8_c_1702_n ) capacitor c=0.00901373f \
 //x=7.44 //y=6.02 //x2=7.98 //y2=6.905
cc_399 ( N_noxref_2_M15_noxref_g N_noxref_8_c_1702_n ) capacitor c=0.00932531f \
 //x=7.88 //y=6.02 //x2=7.98 //y2=6.905
cc_400 ( N_noxref_2_M14_noxref_g N_noxref_8_c_1704_n ) capacitor c=0.00175157f \
 //x=7.44 //y=6.02 //x2=7.22 //y2=5.205
cc_401 ( N_noxref_2_M14_noxref_g N_noxref_8_c_1705_n ) capacitor c=0.00178586f \
 //x=7.44 //y=6.02 //x2=7.22 //y2=6.735
cc_402 ( N_noxref_2_M15_noxref_g N_noxref_8_c_1706_n ) capacitor c=0.00406674f \
 //x=7.88 //y=6.02 //x2=8.1 //y2=6.735
cc_403 ( N_noxref_2_M14_noxref_g N_noxref_8_c_1707_n ) capacitor c=0.0170175f \
 //x=7.44 //y=6.02 //x2=7.22 //y2=5.375
cc_404 ( N_noxref_2_M15_noxref_g N_noxref_8_M15_noxref_d ) capacitor \
 c=0.0365939f //x=7.88 //y=6.02 //x2=7.955 //y2=5.02
cc_405 ( N_noxref_2_c_238_n N_noxref_9_c_1783_n ) capacitor c=0.00498313f \
 //x=1.395 //y=1.84 //x2=3.315 //y2=0
cc_406 ( N_noxref_2_c_250_n N_noxref_9_c_1783_n ) capacitor c=6.42604e-19 \
 //x=1.48 //y=2.75 //x2=3.315 //y2=0
cc_407 ( N_noxref_2_c_267_n N_noxref_9_c_1783_n ) capacitor c=0.00996824f \
 //x=1.11 //y=1.005 //x2=3.315 //y2=0
cc_408 ( N_noxref_2_c_273_n N_noxref_9_c_1783_n ) capacitor c=4.4656e-19 \
 //x=1.48 //y=2.59 //x2=3.315 //y2=0
cc_409 ( N_noxref_2_M0_noxref_d N_noxref_9_c_1783_n ) capacitor c=0.00119583f \
 //x=0.925 //y=0.91 //x2=3.315 //y2=0
cc_410 ( N_noxref_2_c_267_n N_noxref_9_c_1788_n ) capacitor c=0.0052977f \
 //x=1.11 //y=1.005 //x2=3.4 //y2=0.845
cc_411 ( N_noxref_2_c_277_n N_noxref_9_c_1788_n ) capacitor c=0.00348866f \
 //x=7.595 //y=2.575 //x2=3.4 //y2=0.845
cc_412 ( N_noxref_2_c_277_n N_noxref_9_c_1838_n ) capacitor c=0.00361852f \
 //x=7.595 //y=2.575 //x2=6.73 //y2=0.845
cc_413 ( N_noxref_2_c_298_p N_noxref_9_c_1839_n ) capacitor c=2.07499e-19 \
 //x=7.65 //y=2.735 //x2=10.36 //y2=0
cc_414 ( N_noxref_2_c_267_n N_noxref_9_c_1796_n ) capacitor c=0.00124697f \
 //x=1.11 //y=1.005 //x2=1.025 //y2=0.535
cc_415 ( N_noxref_2_c_238_n N_noxref_9_c_1800_n ) capacitor c=0.00307212f \
 //x=1.395 //y=1.84 //x2=1.515 //y2=0.535
cc_416 ( N_noxref_2_c_267_n N_noxref_9_c_1800_n ) capacitor c=0.00130436f \
 //x=1.11 //y=1.005 //x2=1.515 //y2=0.535
cc_417 ( N_noxref_2_c_273_n N_noxref_9_c_1800_n ) capacitor c=4.2833e-19 \
 //x=1.48 //y=2.59 //x2=1.515 //y2=0.535
cc_418 ( N_noxref_2_c_230_n N_noxref_9_c_1802_n ) capacitor c=0.00520602f \
 //x=1.11 //y=1.755 //x2=0.63 //y2=0
cc_419 ( N_noxref_2_c_244_n N_noxref_9_c_1802_n ) capacitor c=2.14154e-19 \
 //x=1.48 //y=2.43 //x2=0.63 //y2=0
cc_420 ( N_noxref_2_c_273_n N_noxref_9_c_1802_n ) capacitor c=0.00313158f \
 //x=1.48 //y=2.59 //x2=0.63 //y2=0
cc_421 ( N_noxref_2_c_238_n N_noxref_9_c_1807_n ) capacitor c=0.0161089f \
 //x=1.395 //y=1.84 //x2=2.22 //y2=0
cc_422 ( N_noxref_2_c_250_n N_noxref_9_c_1807_n ) capacitor c=0.00439621f \
 //x=1.48 //y=2.75 //x2=2.22 //y2=0
cc_423 ( N_noxref_2_c_273_n N_noxref_9_c_1807_n ) capacitor c=0.0101813f \
 //x=1.48 //y=2.59 //x2=2.22 //y2=0
cc_424 ( N_noxref_2_c_277_n N_noxref_9_c_1807_n ) capacitor c=0.0241204f \
 //x=7.595 //y=2.575 //x2=2.22 //y2=0
cc_425 ( N_noxref_2_c_336_p N_noxref_9_c_1851_n ) capacitor c=0.00118906f \
 //x=7.77 //y=2.59 //x2=5.55 //y2=0
cc_426 ( N_noxref_2_c_277_n N_noxref_9_c_1851_n ) capacitor c=0.0236769f \
 //x=7.595 //y=2.575 //x2=5.55 //y2=0
cc_427 ( N_noxref_2_c_336_p N_noxref_9_c_1853_n ) capacitor c=0.00499198f \
 //x=7.77 //y=2.59 //x2=8.88 //y2=0
cc_428 ( N_noxref_2_c_324_p N_noxref_9_c_1853_n ) capacitor c=0.00371073f \
 //x=7.77 //y=2.085 //x2=8.88 //y2=0
cc_429 ( N_noxref_2_c_315_p N_noxref_9_c_1853_n ) capacitor c=0.00539594f \
 //x=7.435 //y=1.92 //x2=8.88 //y2=0
cc_430 ( N_noxref_2_c_312_p N_noxref_9_c_1853_n ) capacitor c=0.00230557f \
 //x=7.965 //y=1.255 //x2=8.88 //y2=0
cc_431 ( N_noxref_2_c_267_n N_noxref_9_c_1857_n ) capacitor c=2.8029e-19 \
 //x=1.11 //y=1.005 //x2=10.47 //y2=0
cc_432 ( N_noxref_2_M0_noxref_d N_noxref_9_c_1857_n ) capacitor c=2.70835e-19 \
 //x=0.925 //y=0.91 //x2=10.47 //y2=0
cc_433 ( N_noxref_2_c_230_n N_noxref_9_M0_noxref_s ) capacitor c=0.0339444f \
 //x=1.11 //y=1.755 //x2=0.495 //y2=0.37
cc_434 ( N_noxref_2_c_238_n N_noxref_9_M0_noxref_s ) capacitor c=0.00316664f \
 //x=1.395 //y=1.84 //x2=0.495 //y2=0.37
cc_435 ( N_noxref_2_c_250_n N_noxref_9_M0_noxref_s ) capacitor c=0.00297038f \
 //x=1.48 //y=2.75 //x2=0.495 //y2=0.37
cc_436 ( N_noxref_2_c_267_n N_noxref_9_M0_noxref_s ) capacitor c=0.0157385f \
 //x=1.11 //y=1.005 //x2=0.495 //y2=0.37
cc_437 ( N_noxref_2_c_273_n N_noxref_9_M0_noxref_s ) capacitor c=0.00227181f \
 //x=1.48 //y=2.59 //x2=0.495 //y2=0.37
cc_438 ( N_noxref_2_M0_noxref_d N_noxref_9_M0_noxref_s ) capacitor \
 c=0.0377604f //x=0.925 //y=0.91 //x2=0.495 //y2=0.37
cc_439 ( N_noxref_2_c_277_n N_noxref_10_c_2024_n ) capacitor c=0.00354349f \
 //x=7.595 //y=2.575 //x2=2.915 //y2=1.5
cc_440 ( N_noxref_2_c_277_n N_noxref_10_c_2025_n ) capacitor c=0.0113349f \
 //x=7.595 //y=2.575 //x2=3.8 //y2=1.585
cc_441 ( N_noxref_2_c_277_n N_noxref_10_c_2032_n ) capacitor c=0.00354349f \
 //x=7.595 //y=2.575 //x2=3.885 //y2=1.5
cc_442 ( N_noxref_2_c_277_n N_noxref_10_c_2039_n ) capacitor c=0.00226051f \
 //x=7.595 //y=2.575 //x2=4.77 //y2=0.535
cc_443 ( N_noxref_2_c_277_n N_noxref_11_c_2088_n ) capacitor c=0.0037497f \
 //x=7.595 //y=2.575 //x2=6.245 //y2=1.5
cc_444 ( N_noxref_2_c_277_n N_noxref_11_c_2089_n ) capacitor c=0.0117017f \
 //x=7.595 //y=2.575 //x2=7.13 //y2=1.585
cc_445 ( N_noxref_2_c_277_n N_noxref_11_c_2090_n ) capacitor c=0.0037497f \
 //x=7.595 //y=2.575 //x2=7.215 //y2=1.5
cc_446 ( N_noxref_2_c_314_p N_noxref_11_c_2090_n ) capacitor c=0.00888238f \
 //x=7.435 //y=1.565 //x2=7.215 //y2=1.5
cc_447 ( N_noxref_2_c_298_p N_noxref_11_c_2092_n ) capacitor c=5.34835e-19 \
 //x=7.65 //y=2.735 //x2=8.1 //y2=0.535
cc_448 ( N_noxref_2_c_277_n N_noxref_11_c_2092_n ) capacitor c=0.00149097f \
 //x=7.595 //y=2.575 //x2=8.1 //y2=0.535
cc_449 ( N_noxref_2_c_324_p N_noxref_11_c_2092_n ) capacitor c=4.1952e-19 \
 //x=7.77 //y=2.085 //x2=8.1 //y2=0.535
cc_450 ( N_noxref_2_c_307_p N_noxref_11_c_2092_n ) capacitor c=0.0204604f \
 //x=7.435 //y=0.91 //x2=8.1 //y2=0.535
cc_451 ( N_noxref_2_c_315_p N_noxref_11_c_2092_n ) capacitor c=2.1838e-19 \
 //x=7.435 //y=1.92 //x2=8.1 //y2=0.535
cc_452 ( N_noxref_2_c_311_p N_noxref_11_c_2092_n ) capacitor c=0.00825432f \
 //x=7.965 //y=0.91 //x2=8.1 //y2=0.535
cc_453 ( N_noxref_2_c_307_p N_noxref_11_M3_noxref_s ) capacitor c=0.00888238f \
 //x=7.435 //y=0.91 //x2=6.11 //y2=0.37
cc_454 ( N_noxref_2_c_311_p N_noxref_11_M3_noxref_s ) capacitor c=0.015333f \
 //x=7.965 //y=0.91 //x2=6.11 //y2=0.37
cc_455 ( N_noxref_2_c_312_p N_noxref_11_M3_noxref_s ) capacitor c=0.00248746f \
 //x=7.965 //y=1.255 //x2=6.11 //y2=0.37
cc_456 ( N_noxref_3_c_606_p N_noxref_4_c_811_n ) capacitor c=0.00303165f \
 //x=4.845 //y=5.205 //x2=4.44 //y2=4.395
cc_457 ( N_noxref_3_c_528_n N_noxref_4_c_811_n ) capacitor c=2.64348e-19 \
 //x=4.845 //y=1.655 //x2=4.44 //y2=4.395
cc_458 ( N_noxref_3_c_519_n N_noxref_4_c_811_n ) capacitor c=0.0458811f \
 //x=4.93 //y=5.12 //x2=4.44 //y2=4.395
cc_459 ( N_noxref_3_c_581_n N_noxref_4_c_811_n ) capacitor c=6.66577e-19 \
 //x=4.33 //y=5.205 //x2=4.44 //y2=4.395
cc_460 ( N_noxref_3_c_606_p N_noxref_4_c_815_n ) capacitor c=0.00292208f \
 //x=4.845 //y=5.205 //x2=4.44 //y2=4.585
cc_461 ( N_noxref_3_c_519_n N_noxref_4_c_815_n ) capacitor c=0.0358146f \
 //x=4.93 //y=5.12 //x2=4.44 //y2=4.585
cc_462 ( N_noxref_3_c_581_n N_noxref_4_c_815_n ) capacitor c=0.0207548f \
 //x=4.33 //y=5.205 //x2=4.44 //y2=4.585
cc_463 ( N_noxref_3_c_613_p N_noxref_4_c_815_n ) capacitor c=0.00137304f \
 //x=4.33 //y=5.375 //x2=4.44 //y2=4.585
cc_464 ( N_noxref_3_c_517_n N_noxref_4_c_833_n ) capacitor c=0.00484003f \
 //x=4.93 //y=3.555 //x2=6.66 //y2=2.205
cc_465 ( N_noxref_3_c_517_n N_noxref_4_c_837_n ) capacitor c=0.0129604f \
 //x=4.93 //y=3.555 //x2=6.66 //y2=3.205
cc_466 ( N_noxref_3_c_565_n N_noxref_4_c_837_n ) capacitor c=0.00378988f \
 //x=8.14 //y=3.555 //x2=6.66 //y2=3.205
cc_467 ( N_noxref_3_c_565_n N_noxref_4_c_880_n ) capacitor c=0.00398704f \
 //x=8.14 //y=3.555 //x2=9.62 //y2=3.475
cc_468 ( N_noxref_3_c_565_n N_noxref_4_c_844_n ) capacitor c=0.0016325f \
 //x=8.14 //y=3.555 //x2=9.62 //y2=3.955
cc_469 ( N_noxref_3_c_573_n N_noxref_4_c_844_n ) capacitor c=0.00493311f \
 //x=8.14 //y=3.875 //x2=9.62 //y2=3.955
cc_470 ( N_noxref_3_c_577_n N_noxref_4_c_844_n ) capacitor c=0.00139895f \
 //x=8.14 //y=5.12 //x2=9.62 //y2=3.955
cc_471 ( N_noxref_3_c_587_n N_noxref_4_c_844_n ) capacitor c=3.17649e-19 \
 //x=8.14 //y=3.7 //x2=9.62 //y2=3.955
cc_472 ( N_noxref_3_c_589_n N_noxref_4_c_844_n ) capacitor c=0.005854f \
 //x=8.155 //y=3.715 //x2=9.62 //y2=3.955
cc_473 ( N_noxref_3_c_577_n N_noxref_4_c_886_n ) capacitor c=0.00436509f \
 //x=8.14 //y=5.12 //x2=9.62 //y2=4.25
cc_474 ( N_noxref_3_c_577_n N_noxref_4_c_845_n ) capacitor c=0.0135229f \
 //x=8.14 //y=5.12 //x2=9.62 //y2=4.875
cc_475 ( N_noxref_3_c_565_n N_noxref_4_c_888_n ) capacitor c=0.0263739f \
 //x=8.14 //y=3.555 //x2=9.705 //y2=1.84
cc_476 ( N_noxref_3_c_577_n N_noxref_4_c_889_n ) capacitor c=0.00270091f \
 //x=8.14 //y=5.12 //x2=9.985 //y2=5.24
cc_477 ( N_noxref_3_c_582_n N_noxref_4_c_889_n ) capacitor c=4.99083e-19 \
 //x=7.66 //y=5.205 //x2=9.985 //y2=5.24
cc_478 ( N_noxref_3_c_546_n N_noxref_4_c_891_n ) capacitor c=0.00464508f \
 //x=7.7 //y=1.57 //x2=9.99 //y2=1.755
cc_479 ( N_noxref_3_c_554_n N_noxref_4_c_891_n ) capacitor c=0.00329276f \
 //x=8.055 //y=1.655 //x2=9.99 //y2=1.755
cc_480 ( N_noxref_3_c_519_n N_noxref_4_c_818_n ) capacitor c=0.00654928f \
 //x=4.93 //y=5.12 //x2=4.485 //y2=4.235
cc_481 ( N_noxref_3_c_517_n N_noxref_4_c_846_n ) capacitor c=0.00403661f \
 //x=4.93 //y=3.555 //x2=6.66 //y2=3.33
cc_482 ( N_noxref_3_c_590_n N_noxref_4_c_846_n ) capacitor c=0.00760299f \
 //x=7.995 //y=3.715 //x2=6.66 //y2=3.33
cc_483 ( N_noxref_3_c_565_n N_noxref_4_c_896_n ) capacitor c=2.17715e-19 \
 //x=8.14 //y=3.555 //x2=9.62 //y2=3.33
cc_484 ( N_noxref_3_c_577_n N_noxref_4_c_897_n ) capacitor c=5.93415e-19 \
 //x=8.14 //y=5.12 //x2=9.62 //y2=4.07
cc_485 ( N_noxref_3_c_538_n N_noxref_4_c_898_n ) capacitor c=0.00582787f \
 //x=7.7 //y=1.12 //x2=9.99 //y2=1.005
cc_486 ( N_noxref_3_c_546_n N_noxref_4_c_898_n ) capacitor c=6.23317e-19 \
 //x=7.7 //y=1.57 //x2=9.99 //y2=1.005
cc_487 ( N_noxref_3_c_606_p N_noxref_4_c_820_n ) capacitor c=0.00178776f \
 //x=4.845 //y=5.205 //x2=4.485 //y2=4.1
cc_488 ( N_noxref_3_c_519_n N_noxref_4_c_820_n ) capacitor c=0.00664189f \
 //x=4.93 //y=5.12 //x2=4.485 //y2=4.1
cc_489 ( N_noxref_3_c_517_n N_noxref_4_c_847_n ) capacitor c=0.00354109f \
 //x=4.93 //y=3.555 //x2=6.82 //y2=3.345
cc_490 ( N_noxref_3_c_590_n N_noxref_4_c_847_n ) capacitor c=0.0349865f \
 //x=7.995 //y=3.715 //x2=6.82 //y2=3.345
cc_491 ( N_noxref_3_c_577_n N_noxref_4_c_904_n ) capacitor c=0.0016766f \
 //x=8.14 //y=5.12 //x2=9.625 //y2=4.09
cc_492 ( N_noxref_3_c_606_p N_noxref_4_c_849_n ) capacitor c=0.00420305f \
 //x=4.845 //y=5.205 //x2=9.465 //y2=4.09
cc_493 ( N_noxref_3_c_518_n N_noxref_4_c_849_n ) capacitor c=0.00907117f \
 //x=4.93 //y=3.875 //x2=9.465 //y2=4.09
cc_494 ( N_noxref_3_c_519_n N_noxref_4_c_849_n ) capacitor c=0.0265986f \
 //x=4.93 //y=5.12 //x2=9.465 //y2=4.09
cc_495 ( N_noxref_3_c_573_n N_noxref_4_c_849_n ) capacitor c=0.00540116f \
 //x=8.14 //y=3.875 //x2=9.465 //y2=4.09
cc_496 ( N_noxref_3_c_577_n N_noxref_4_c_849_n ) capacitor c=0.0201136f \
 //x=8.14 //y=5.12 //x2=9.465 //y2=4.09
cc_497 ( N_noxref_3_c_523_n N_noxref_4_c_849_n ) capacitor c=0.0365231f \
 //x=5.135 //y=3.715 //x2=9.465 //y2=4.09
cc_498 ( N_noxref_3_c_589_n N_noxref_4_c_849_n ) capacitor c=0.0360345f \
 //x=8.155 //y=3.715 //x2=9.465 //y2=4.09
cc_499 ( N_noxref_3_c_590_n N_noxref_4_c_849_n ) capacitor c=0.252326f \
 //x=7.995 //y=3.715 //x2=9.465 //y2=4.09
cc_500 ( N_noxref_3_c_565_n N_noxref_4_c_913_n ) capacitor c=0.00191229f \
 //x=8.14 //y=3.555 //x2=9.655 //y2=3.315
cc_501 ( N_noxref_3_c_565_n N_noxref_4_c_851_n ) capacitor c=0.0203568f \
 //x=8.14 //y=3.555 //x2=9.495 //y2=3.315
cc_502 ( N_noxref_3_c_573_n N_noxref_4_c_851_n ) capacitor c=0.0076014f \
 //x=8.14 //y=3.875 //x2=9.495 //y2=3.315
cc_503 ( N_noxref_3_c_589_n N_noxref_4_c_851_n ) capacitor c=0.0360345f \
 //x=8.155 //y=3.715 //x2=9.495 //y2=3.315
cc_504 ( N_noxref_3_c_590_n N_noxref_4_c_851_n ) capacitor c=0.0922798f \
 //x=7.995 //y=3.715 //x2=9.495 //y2=3.315
cc_505 ( N_noxref_3_c_606_p N_noxref_4_c_823_n ) capacitor c=0.00104675f \
 //x=4.845 //y=5.205 //x2=4.44 //y2=4.7
cc_506 ( N_noxref_3_c_519_n N_noxref_4_c_823_n ) capacitor c=0.00463729f \
 //x=4.93 //y=5.12 //x2=4.44 //y2=4.7
cc_507 ( N_noxref_3_c_581_n N_noxref_4_c_823_n ) capacitor c=0.00390413f \
 //x=4.33 //y=5.205 //x2=4.44 //y2=4.7
cc_508 ( N_noxref_3_c_613_p N_noxref_4_c_823_n ) capacitor c=0.00414188f \
 //x=4.33 //y=5.375 //x2=4.44 //y2=4.7
cc_509 ( N_noxref_3_c_581_n N_noxref_4_M10_noxref_g ) capacitor c=0.00179689f \
 //x=4.33 //y=5.205 //x2=4.11 //y2=6.02
cc_510 ( N_noxref_3_c_613_p N_noxref_4_M10_noxref_g ) capacitor c=0.0120591f \
 //x=4.33 //y=5.375 //x2=4.11 //y2=6.02
cc_511 ( N_noxref_3_c_606_p N_noxref_4_M11_noxref_g ) capacitor c=0.00982401f \
 //x=4.845 //y=5.205 //x2=4.55 //y2=6.02
cc_512 ( N_noxref_3_c_581_n N_noxref_4_M11_noxref_g ) capacitor c=0.00277466f \
 //x=4.33 //y=5.205 //x2=4.55 //y2=6.02
cc_513 ( N_noxref_3_c_613_p N_noxref_4_M11_noxref_g ) capacitor c=0.0140704f \
 //x=4.33 //y=5.375 //x2=4.55 //y2=6.02
cc_514 ( N_noxref_3_c_519_n N_noxref_4_c_829_n ) capacitor c=0.0102862f \
 //x=4.93 //y=5.12 //x2=4.44 //y2=4.7
cc_515 ( N_noxref_3_c_581_n N_noxref_4_c_829_n ) capacitor c=0.00203067f \
 //x=4.33 //y=5.205 //x2=4.44 //y2=4.7
cc_516 ( N_noxref_3_c_613_p N_noxref_4_c_829_n ) capacitor c=0.00435839f \
 //x=4.33 //y=5.375 //x2=4.44 //y2=4.7
cc_517 ( N_noxref_3_c_528_n N_noxref_5_c_1104_n ) capacitor c=0.00282714f \
 //x=4.845 //y=1.655 //x2=4.44 //y2=2.235
cc_518 ( N_noxref_3_c_529_n N_noxref_5_c_1104_n ) capacitor c=0.0240673f \
 //x=4.455 //y=1.655 //x2=4.44 //y2=2.235
cc_519 ( N_noxref_3_c_517_n N_noxref_5_c_1104_n ) capacitor c=0.0257645f \
 //x=4.93 //y=3.555 //x2=4.44 //y2=2.235
cc_520 ( N_noxref_3_M2_noxref_d N_noxref_5_c_1104_n ) capacitor c=4.61207e-19 \
 //x=4.18 //y=0.91 //x2=4.44 //y2=2.235
cc_521 ( N_noxref_3_c_517_n N_noxref_5_c_1107_n ) capacitor c=0.0370664f \
 //x=4.93 //y=3.555 //x2=4.44 //y2=2.815
cc_522 ( N_noxref_3_c_565_n N_noxref_5_c_1155_n ) capacitor c=0.00186903f \
 //x=8.14 //y=3.555 //x2=10.36 //y2=2.8
cc_523 ( N_noxref_3_c_528_n N_noxref_5_c_1109_n ) capacitor c=0.00236659f \
 //x=4.845 //y=1.655 //x2=4.44 //y2=2.96
cc_524 ( N_noxref_3_c_529_n N_noxref_5_c_1109_n ) capacitor c=7.25731e-19 \
 //x=4.455 //y=1.655 //x2=4.44 //y2=2.96
cc_525 ( N_noxref_3_c_517_n N_noxref_5_c_1109_n ) capacitor c=0.0348988f \
 //x=4.93 //y=3.555 //x2=4.44 //y2=2.96
cc_526 ( N_noxref_3_c_581_n N_noxref_5_c_1109_n ) capacitor c=2.9596e-19 \
 //x=4.33 //y=5.205 //x2=4.44 //y2=2.96
cc_527 ( N_noxref_3_c_519_n N_noxref_5_c_1131_n ) capacitor c=0.00459954f \
 //x=4.93 //y=5.12 //x2=6.66 //y2=4.44
cc_528 ( N_noxref_3_c_565_n N_noxref_5_c_1161_n ) capacitor c=0.00118611f \
 //x=8.14 //y=3.555 //x2=10.37 //y2=4.545
cc_529 ( N_noxref_3_c_577_n N_noxref_5_c_1161_n ) capacitor c=0.00142372f \
 //x=8.14 //y=5.12 //x2=10.37 //y2=4.545
cc_530 ( N_noxref_3_c_517_n N_noxref_5_c_1133_n ) capacitor c=0.0222476f \
 //x=4.93 //y=3.555 //x2=9.27 //y2=2.96
cc_531 ( N_noxref_3_c_518_n N_noxref_5_c_1133_n ) capacitor c=0.00652184f \
 //x=4.93 //y=3.875 //x2=9.27 //y2=2.96
cc_532 ( N_noxref_3_c_554_n N_noxref_5_c_1133_n ) capacitor c=0.00271047f \
 //x=8.055 //y=1.655 //x2=9.27 //y2=2.96
cc_533 ( N_noxref_3_c_565_n N_noxref_5_c_1133_n ) capacitor c=0.0277835f \
 //x=8.14 //y=3.555 //x2=9.27 //y2=2.96
cc_534 ( N_noxref_3_c_523_n N_noxref_5_c_1133_n ) capacitor c=0.0157015f \
 //x=5.135 //y=3.715 //x2=9.27 //y2=2.96
cc_535 ( N_noxref_3_c_589_n N_noxref_5_c_1133_n ) capacitor c=7.21807e-19 \
 //x=8.155 //y=3.715 //x2=9.27 //y2=2.96
cc_536 ( N_noxref_3_c_590_n N_noxref_5_c_1133_n ) capacitor c=0.0680498f \
 //x=7.995 //y=3.715 //x2=9.27 //y2=2.96
cc_537 ( N_noxref_3_c_519_n N_noxref_5_c_1137_n ) capacitor c=0.00345096f \
 //x=4.93 //y=5.12 //x2=9.495 //y2=4.475
cc_538 ( N_noxref_3_c_551_n N_noxref_5_c_1137_n ) capacitor c=0.00552068f \
 //x=8.055 //y=5.205 //x2=9.495 //y2=4.475
cc_539 ( N_noxref_3_c_577_n N_noxref_5_c_1137_n ) capacitor c=0.0271386f \
 //x=8.14 //y=5.12 //x2=9.495 //y2=4.475
cc_540 ( N_noxref_3_c_582_n N_noxref_5_c_1137_n ) capacitor c=6.46296e-19 \
 //x=7.66 //y=5.205 //x2=9.495 //y2=4.475
cc_541 ( N_noxref_3_c_589_n N_noxref_5_c_1137_n ) capacitor c=7.60969e-19 \
 //x=8.155 //y=3.715 //x2=9.495 //y2=4.475
cc_542 ( N_noxref_3_c_590_n N_noxref_5_c_1137_n ) capacitor c=0.00744882f \
 //x=7.995 //y=3.715 //x2=9.495 //y2=4.475
cc_543 ( N_noxref_3_c_517_n N_noxref_5_c_1110_n ) capacitor c=0.00470736f \
 //x=4.93 //y=3.555 //x2=4.6 //y2=2.975
cc_544 ( N_noxref_3_c_528_n N_noxref_5_c_1111_n ) capacitor c=0.00147657f \
 //x=4.845 //y=1.655 //x2=4.44 //y2=2.085
cc_545 ( N_noxref_3_c_529_n N_noxref_5_c_1111_n ) capacitor c=0.00408056f \
 //x=4.455 //y=1.655 //x2=4.44 //y2=2.085
cc_546 ( N_noxref_3_c_517_n N_noxref_5_c_1111_n ) capacitor c=0.00169572f \
 //x=4.93 //y=3.555 //x2=4.44 //y2=2.085
cc_547 ( N_noxref_3_M2_noxref_d N_noxref_5_c_1111_n ) capacitor c=0.00150031f \
 //x=4.18 //y=0.91 //x2=4.44 //y2=2.085
cc_548 ( N_noxref_3_c_577_n N_noxref_5_c_1140_n ) capacitor c=3.44947e-19 \
 //x=8.14 //y=5.12 //x2=6.66 //y2=4.44
cc_549 ( N_noxref_3_c_524_n N_noxref_5_c_1114_n ) capacitor c=5.45132e-19 \
 //x=4.37 //y=1.125 //x2=4.105 //y2=0.91
cc_550 ( N_noxref_3_M2_noxref_d N_noxref_5_c_1114_n ) capacitor c=0.00137165f \
 //x=4.18 //y=0.91 //x2=4.105 //y2=0.91
cc_551 ( N_noxref_3_c_524_n N_noxref_5_c_1117_n ) capacitor c=0.00220865f \
 //x=4.37 //y=1.125 //x2=4.105 //y2=1.255
cc_552 ( N_noxref_3_c_526_n N_noxref_5_c_1117_n ) capacitor c=0.00118531f \
 //x=4.37 //y=1.57 //x2=4.105 //y2=1.255
cc_553 ( N_noxref_3_M2_noxref_d N_noxref_5_c_1117_n ) capacitor c=0.00237422f \
 //x=4.18 //y=0.91 //x2=4.105 //y2=1.255
cc_554 ( N_noxref_3_c_526_n N_noxref_5_c_1119_n ) capacitor c=0.00409175f \
 //x=4.37 //y=1.57 //x2=4.105 //y2=1.565
cc_555 ( N_noxref_3_c_526_n N_noxref_5_c_1122_n ) capacitor c=0.00341876f \
 //x=4.37 //y=1.57 //x2=4.105 //y2=1.92
cc_556 ( N_noxref_3_c_529_n N_noxref_5_c_1122_n ) capacitor c=0.00203544f \
 //x=4.455 //y=1.655 //x2=4.105 //y2=1.92
cc_557 ( N_noxref_3_c_517_n N_noxref_5_c_1122_n ) capacitor c=0.00810353f \
 //x=4.93 //y=3.555 //x2=4.105 //y2=1.92
cc_558 ( N_noxref_3_M2_noxref_d N_noxref_5_c_1122_n ) capacitor c=4.64071e-19 \
 //x=4.18 //y=0.91 //x2=4.105 //y2=1.92
cc_559 ( N_noxref_3_c_524_n N_noxref_5_c_1192_n ) capacitor c=5.33629e-19 \
 //x=4.37 //y=1.125 //x2=4.48 //y2=0.755
cc_560 ( N_noxref_3_M2_noxref_d N_noxref_5_c_1192_n ) capacitor c=0.0020782f \
 //x=4.18 //y=0.91 //x2=4.48 //y2=0.755
cc_561 ( N_noxref_3_c_524_n N_noxref_5_c_1194_n ) capacitor c=5.44173e-19 \
 //x=4.37 //y=1.125 //x2=4.48 //y2=1.41
cc_562 ( N_noxref_3_c_526_n N_noxref_5_c_1194_n ) capacitor c=0.00758256f \
 //x=4.37 //y=1.57 //x2=4.48 //y2=1.41
cc_563 ( N_noxref_3_c_528_n N_noxref_5_c_1194_n ) capacitor c=0.00122055f \
 //x=4.845 //y=1.655 //x2=4.48 //y2=1.41
cc_564 ( N_noxref_3_M2_noxref_d N_noxref_5_c_1194_n ) capacitor c=0.00344131f \
 //x=4.18 //y=0.91 //x2=4.48 //y2=1.41
cc_565 ( N_noxref_3_c_524_n N_noxref_5_c_1125_n ) capacitor c=6.34991e-19 \
 //x=4.37 //y=1.125 //x2=4.635 //y2=0.91
cc_566 ( N_noxref_3_M2_noxref_d N_noxref_5_c_1125_n ) capacitor c=8.50094e-19 \
 //x=4.18 //y=0.91 //x2=4.635 //y2=0.91
cc_567 ( N_noxref_3_c_524_n N_noxref_5_c_1126_n ) capacitor c=0.00320504f \
 //x=4.37 //y=1.125 //x2=4.635 //y2=1.255
cc_568 ( N_noxref_3_c_526_n N_noxref_5_c_1126_n ) capacitor c=0.003249f \
 //x=4.37 //y=1.57 //x2=4.635 //y2=1.255
cc_569 ( N_noxref_3_c_528_n N_noxref_5_c_1126_n ) capacitor c=0.00300547f \
 //x=4.845 //y=1.655 //x2=4.635 //y2=1.255
cc_570 ( N_noxref_3_M2_noxref_d N_noxref_5_c_1126_n ) capacitor c=0.00237422f \
 //x=4.18 //y=0.91 //x2=4.635 //y2=1.255
cc_571 ( N_noxref_3_c_606_p N_noxref_6_c_1443_n ) capacitor c=0.00189305f \
 //x=4.845 //y=5.205 //x2=6.695 //y2=7.4
cc_572 ( N_noxref_3_c_518_n N_noxref_6_c_1443_n ) capacitor c=6.59872e-19 \
 //x=4.93 //y=3.875 //x2=6.695 //y2=7.4
cc_573 ( N_noxref_3_c_551_n N_noxref_6_c_1445_n ) capacitor c=2.87983e-19 \
 //x=8.055 //y=5.205 //x2=10.36 //y2=7.4
cc_574 ( N_noxref_3_c_573_n N_noxref_6_c_1445_n ) capacitor c=2.35119e-19 \
 //x=8.14 //y=3.875 //x2=10.36 //y2=7.4
cc_575 ( N_noxref_3_c_606_p N_noxref_6_c_1388_n ) capacitor c=9.35369e-19 \
 //x=4.845 //y=5.205 //x2=5.38 //y2=7.4
cc_576 ( N_noxref_3_c_613_p N_noxref_6_c_1388_n ) capacitor c=0.00508598f \
 //x=4.33 //y=5.375 //x2=5.38 //y2=7.4
cc_577 ( N_noxref_3_c_592_n N_noxref_6_c_1424_n ) capacitor c=0.00471239f \
 //x=7.66 //y=5.375 //x2=8.71 //y2=7.4
cc_578 ( N_noxref_3_c_519_n N_noxref_6_c_1396_n ) capacitor c=0.00127493f \
 //x=4.93 //y=5.12 //x2=2.22 //y2=7.4
cc_579 ( N_noxref_3_c_519_n N_noxref_6_c_1433_n ) capacitor c=0.0340468f \
 //x=4.93 //y=5.12 //x2=5.55 //y2=7.4
cc_580 ( N_noxref_3_c_577_n N_noxref_6_c_1433_n ) capacitor c=0.00124961f \
 //x=8.14 //y=5.12 //x2=5.55 //y2=7.4
cc_581 ( N_noxref_3_c_581_n N_noxref_6_c_1433_n ) capacitor c=0.00269155f \
 //x=4.33 //y=5.205 //x2=5.55 //y2=7.4
cc_582 ( N_noxref_3_c_613_p N_noxref_6_c_1433_n ) capacitor c=0.0091804f \
 //x=4.33 //y=5.375 //x2=5.55 //y2=7.4
cc_583 ( N_noxref_3_c_577_n N_noxref_6_c_1434_n ) capacitor c=0.0251234f \
 //x=8.14 //y=5.12 //x2=8.88 //y2=7.4
cc_584 ( N_noxref_3_c_582_n N_noxref_6_c_1434_n ) capacitor c=0.00261447f \
 //x=7.66 //y=5.205 //x2=8.88 //y2=7.4
cc_585 ( N_noxref_3_c_592_n N_noxref_6_c_1434_n ) capacitor c=0.00920443f \
 //x=7.66 //y=5.375 //x2=8.88 //y2=7.4
cc_586 ( N_noxref_3_c_613_p N_noxref_6_c_1436_n ) capacitor c=2.29347e-19 \
 //x=4.33 //y=5.375 //x2=10.36 //y2=7.4
cc_587 ( N_noxref_3_c_592_n N_noxref_6_c_1436_n ) capacitor c=2.29347e-19 \
 //x=7.66 //y=5.375 //x2=10.36 //y2=7.4
cc_588 ( N_noxref_3_c_581_n N_noxref_6_M7_noxref_d ) capacitor c=2.46246e-19 \
 //x=4.33 //y=5.205 //x2=1.41 //y2=5.02
cc_589 ( N_noxref_3_c_613_p N_noxref_6_M8_noxref_d ) capacitor c=0.00464138f \
 //x=4.33 //y=5.375 //x2=3.305 //y2=5.02
cc_590 ( N_noxref_3_c_592_n N_noxref_6_M12_noxref_d ) capacitor c=0.00464146f \
 //x=7.66 //y=5.375 //x2=6.635 //y2=5.02
cc_591 ( N_noxref_3_c_551_n N_noxref_6_M16_noxref_s ) capacitor c=0.0032599f \
 //x=8.055 //y=5.205 //x2=9.42 //y2=5.02
cc_592 ( N_noxref_3_c_582_n N_noxref_6_M16_noxref_s ) capacitor c=0.0057075f \
 //x=7.66 //y=5.205 //x2=9.42 //y2=5.02
cc_593 ( N_noxref_3_c_606_p N_noxref_7_c_1636_n ) capacitor c=0.00325084f \
 //x=4.845 //y=5.205 //x2=4.655 //y2=6.905
cc_594 ( N_noxref_3_c_581_n N_noxref_7_c_1636_n ) capacitor c=0.00483367f \
 //x=4.33 //y=5.205 //x2=4.655 //y2=6.905
cc_595 ( N_noxref_3_c_613_p N_noxref_7_c_1636_n ) capacitor c=0.00407104f \
 //x=4.33 //y=5.375 //x2=4.655 //y2=6.905
cc_596 ( N_noxref_3_c_581_n N_noxref_7_c_1626_n ) capacitor c=6.22227e-19 \
 //x=4.33 //y=5.205 //x2=3.017 //y2=5.205
cc_597 ( N_noxref_3_c_581_n N_noxref_7_c_1629_n ) capacitor c=0.0507834f \
 //x=4.33 //y=5.205 //x2=3.89 //y2=5.205
cc_598 ( N_noxref_3_c_613_p N_noxref_7_c_1629_n ) capacitor c=0.00270385f \
 //x=4.33 //y=5.375 //x2=3.89 //y2=5.205
cc_599 ( N_noxref_3_c_606_p N_noxref_7_c_1642_n ) capacitor c=0.00501306f \
 //x=4.845 //y=5.205 //x2=4.77 //y2=6.735
cc_600 ( N_noxref_3_c_581_n N_noxref_7_c_1633_n ) capacitor c=0.00261471f \
 //x=4.33 //y=5.205 //x2=3.89 //y2=5.375
cc_601 ( N_noxref_3_c_613_p N_noxref_7_c_1633_n ) capacitor c=0.0673924f \
 //x=4.33 //y=5.375 //x2=3.89 //y2=5.375
cc_602 ( N_noxref_3_c_606_p N_noxref_7_M11_noxref_d ) capacitor c=0.00704645f \
 //x=4.845 //y=5.205 //x2=4.625 //y2=5.02
cc_603 ( N_noxref_3_c_613_p N_noxref_7_M11_noxref_d ) capacitor c=0.0472015f \
 //x=4.33 //y=5.375 //x2=4.625 //y2=5.02
cc_604 ( N_noxref_3_c_551_n N_noxref_8_c_1702_n ) capacitor c=0.00314935f \
 //x=8.055 //y=5.205 //x2=7.98 //y2=6.905
cc_605 ( N_noxref_3_c_582_n N_noxref_8_c_1702_n ) capacitor c=0.00482905f \
 //x=7.66 //y=5.205 //x2=7.98 //y2=6.905
cc_606 ( N_noxref_3_c_592_n N_noxref_8_c_1702_n ) capacitor c=0.00407104f \
 //x=7.66 //y=5.375 //x2=7.98 //y2=6.905
cc_607 ( N_noxref_3_c_606_p N_noxref_8_c_1712_n ) capacitor c=0.00476373f \
 //x=4.845 //y=5.205 //x2=6.34 //y2=5.205
cc_608 ( N_noxref_3_c_581_n N_noxref_8_c_1712_n ) capacitor c=0.00509041f \
 //x=4.33 //y=5.205 //x2=6.34 //y2=5.205
cc_609 ( N_noxref_3_c_582_n N_noxref_8_c_1712_n ) capacitor c=6.06937e-19 \
 //x=7.66 //y=5.205 //x2=6.34 //y2=5.205
cc_610 ( N_noxref_3_c_582_n N_noxref_8_c_1704_n ) capacitor c=0.0501053f \
 //x=7.66 //y=5.205 //x2=7.22 //y2=5.205
cc_611 ( N_noxref_3_c_592_n N_noxref_8_c_1704_n ) capacitor c=0.0026584f \
 //x=7.66 //y=5.375 //x2=7.22 //y2=5.205
cc_612 ( N_noxref_3_c_551_n N_noxref_8_c_1706_n ) capacitor c=0.00500806f \
 //x=8.055 //y=5.205 //x2=8.1 //y2=6.735
cc_613 ( N_noxref_3_c_582_n N_noxref_8_c_1707_n ) capacitor c=0.00266093f \
 //x=7.66 //y=5.205 //x2=7.22 //y2=5.375
cc_614 ( N_noxref_3_c_592_n N_noxref_8_c_1707_n ) capacitor c=0.0674619f \
 //x=7.66 //y=5.375 //x2=7.22 //y2=5.375
cc_615 ( N_noxref_3_c_551_n N_noxref_8_M15_noxref_d ) capacitor c=0.00776833f \
 //x=8.055 //y=5.205 //x2=7.955 //y2=5.02
cc_616 ( N_noxref_3_c_587_n N_noxref_8_M15_noxref_d ) capacitor c=0.0012136f \
 //x=8.14 //y=3.7 //x2=7.955 //y2=5.02
cc_617 ( N_noxref_3_c_592_n N_noxref_8_M15_noxref_d ) capacitor c=0.0473277f \
 //x=7.66 //y=5.375 //x2=7.955 //y2=5.02
cc_618 ( N_noxref_3_c_524_n N_noxref_9_c_1788_n ) capacitor c=0.0136681f \
 //x=4.37 //y=1.125 //x2=3.4 //y2=0.845
cc_619 ( N_noxref_3_M2_noxref_d N_noxref_9_c_1788_n ) capacitor c=5.48773e-19 \
 //x=4.18 //y=0.91 //x2=3.4 //y2=0.845
cc_620 ( N_noxref_3_c_524_n N_noxref_9_c_1867_n ) capacitor c=0.00927078f \
 //x=4.37 //y=1.125 //x2=6.645 //y2=0
cc_621 ( N_noxref_3_c_528_n N_noxref_9_c_1867_n ) capacitor c=0.00836938f \
 //x=4.845 //y=1.655 //x2=6.645 //y2=0
cc_622 ( N_noxref_3_c_518_n N_noxref_9_c_1867_n ) capacitor c=0.00102194f \
 //x=4.93 //y=3.875 //x2=6.645 //y2=0
cc_623 ( N_noxref_3_M2_noxref_d N_noxref_9_c_1867_n ) capacitor c=2.98052e-19 \
 //x=4.18 //y=0.91 //x2=6.645 //y2=0
cc_624 ( N_noxref_3_c_524_n N_noxref_9_c_1838_n ) capacitor c=0.00519351f \
 //x=4.37 //y=1.125 //x2=6.73 //y2=0.845
cc_625 ( N_noxref_3_c_538_n N_noxref_9_c_1838_n ) capacitor c=0.0136059f \
 //x=7.7 //y=1.12 //x2=6.73 //y2=0.845
cc_626 ( N_noxref_3_M4_noxref_d N_noxref_9_c_1838_n ) capacitor c=5.45329e-19 \
 //x=7.51 //y=0.91 //x2=6.73 //y2=0.845
cc_627 ( N_noxref_3_c_538_n N_noxref_9_c_1839_n ) capacitor c=0.00908607f \
 //x=7.7 //y=1.12 //x2=10.36 //y2=0
cc_628 ( N_noxref_3_c_554_n N_noxref_9_c_1839_n ) capacitor c=0.00653639f \
 //x=8.055 //y=1.655 //x2=10.36 //y2=0
cc_629 ( N_noxref_3_M4_noxref_d N_noxref_9_c_1839_n ) capacitor c=2.98052e-19 \
 //x=7.51 //y=0.91 //x2=10.36 //y2=0
cc_630 ( N_noxref_3_c_528_n N_noxref_9_c_1801_n ) capacitor c=0.00137019f \
 //x=4.845 //y=1.655 //x2=5.38 //y2=0
cc_631 ( N_noxref_3_c_554_n N_noxref_9_c_1878_n ) capacitor c=7.81782e-19 \
 //x=8.055 //y=1.655 //x2=8.71 //y2=0
cc_632 ( N_noxref_3_c_517_n N_noxref_9_c_1807_n ) capacitor c=8.64413e-19 \
 //x=4.93 //y=3.555 //x2=2.22 //y2=0
cc_633 ( N_noxref_3_c_526_n N_noxref_9_c_1851_n ) capacitor c=0.00289817f \
 //x=4.37 //y=1.57 //x2=5.55 //y2=0
cc_634 ( N_noxref_3_c_528_n N_noxref_9_c_1851_n ) capacitor c=0.032706f \
 //x=4.845 //y=1.655 //x2=5.55 //y2=0
cc_635 ( N_noxref_3_c_565_n N_noxref_9_c_1851_n ) capacitor c=9.20071e-19 \
 //x=8.14 //y=3.555 //x2=5.55 //y2=0
cc_636 ( N_noxref_3_c_546_n N_noxref_9_c_1853_n ) capacitor c=0.00262965f \
 //x=7.7 //y=1.57 //x2=8.88 //y2=0
cc_637 ( N_noxref_3_c_554_n N_noxref_9_c_1853_n ) capacitor c=0.0237295f \
 //x=8.055 //y=1.655 //x2=8.88 //y2=0
cc_638 ( N_noxref_3_c_524_n N_noxref_9_c_1857_n ) capacitor c=2.8441e-19 \
 //x=4.37 //y=1.125 //x2=10.47 //y2=0
cc_639 ( N_noxref_3_c_538_n N_noxref_9_c_1857_n ) capacitor c=2.8441e-19 \
 //x=7.7 //y=1.12 //x2=10.47 //y2=0
cc_640 ( N_noxref_3_c_524_n N_noxref_9_M1_noxref_d ) capacitor c=5.45409e-19 \
 //x=4.37 //y=1.125 //x2=3.21 //y2=0.87
cc_641 ( N_noxref_3_c_538_n N_noxref_9_M3_noxref_d ) capacitor c=5.45329e-19 \
 //x=7.7 //y=1.12 //x2=6.54 //y2=0.87
cc_642 ( N_noxref_3_c_529_n N_noxref_10_c_2032_n ) capacitor c=0.00898362f \
 //x=4.455 //y=1.655 //x2=3.885 //y2=1.5
cc_643 ( N_noxref_3_c_524_n N_noxref_10_c_2039_n ) capacitor c=0.00352617f \
 //x=4.37 //y=1.125 //x2=4.77 //y2=0.535
cc_644 ( N_noxref_3_c_528_n N_noxref_10_c_2039_n ) capacitor c=0.00362992f \
 //x=4.845 //y=1.655 //x2=4.77 //y2=0.535
cc_645 ( N_noxref_3_M2_noxref_d N_noxref_10_c_2039_n ) capacitor c=0.00910163f \
 //x=4.18 //y=0.91 //x2=4.77 //y2=0.535
cc_646 ( N_noxref_3_c_524_n N_noxref_10_M1_noxref_s ) capacitor c=0.00888619f \
 //x=4.37 //y=1.125 //x2=2.78 //y2=0.37
cc_647 ( N_noxref_3_c_526_n N_noxref_10_M1_noxref_s ) capacitor c=0.0161119f \
 //x=4.37 //y=1.57 //x2=2.78 //y2=0.37
cc_648 ( N_noxref_3_c_528_n N_noxref_10_M1_noxref_s ) capacitor c=0.00879038f \
 //x=4.845 //y=1.655 //x2=2.78 //y2=0.37
cc_649 ( N_noxref_3_c_799_p N_noxref_10_M1_noxref_s ) capacitor c=4.48997e-19 \
 //x=4.98 //y=3.7 //x2=2.78 //y2=0.37
cc_650 ( N_noxref_3_M2_noxref_d N_noxref_10_M1_noxref_s ) capacitor \
 c=0.0275562f //x=4.18 //y=0.91 //x2=2.78 //y2=0.37
cc_651 ( N_noxref_3_c_560_n N_noxref_11_c_2090_n ) capacitor c=0.00902033f \
 //x=7.785 //y=1.655 //x2=7.215 //y2=1.5
cc_652 ( N_noxref_3_c_538_n N_noxref_11_c_2092_n ) capacitor c=0.00340242f \
 //x=7.7 //y=1.12 //x2=8.1 //y2=0.535
cc_653 ( N_noxref_3_c_554_n N_noxref_11_c_2092_n ) capacitor c=0.00367965f \
 //x=8.055 //y=1.655 //x2=8.1 //y2=0.535
cc_654 ( N_noxref_3_M4_noxref_d N_noxref_11_c_2092_n ) capacitor c=0.00910163f \
 //x=7.51 //y=0.91 //x2=8.1 //y2=0.535
cc_655 ( N_noxref_3_c_538_n N_noxref_11_M3_noxref_s ) capacitor c=0.00845391f \
 //x=7.7 //y=1.12 //x2=6.11 //y2=0.37
cc_656 ( N_noxref_3_c_546_n N_noxref_11_M3_noxref_s ) capacitor c=0.0157899f \
 //x=7.7 //y=1.57 //x2=6.11 //y2=0.37
cc_657 ( N_noxref_3_c_554_n N_noxref_11_M3_noxref_s ) capacitor c=0.00674704f \
 //x=8.055 //y=1.655 //x2=6.11 //y2=0.37
cc_658 ( N_noxref_3_c_573_n N_noxref_11_M3_noxref_s ) capacitor c=3.19116e-19 \
 //x=8.14 //y=3.875 //x2=6.11 //y2=0.37
cc_659 ( N_noxref_3_c_587_n N_noxref_11_M3_noxref_s ) capacitor c=8.43954e-19 \
 //x=8.14 //y=3.7 //x2=6.11 //y2=0.37
cc_660 ( N_noxref_3_M4_noxref_d N_noxref_11_M3_noxref_s ) capacitor \
 c=0.0275615f //x=7.51 //y=0.91 //x2=6.11 //y2=0.37
cc_661 ( N_noxref_4_c_837_n N_noxref_5_c_1107_n ) capacitor c=0.00171814f \
 //x=6.66 //y=3.205 //x2=4.44 //y2=2.815
cc_662 ( N_noxref_4_c_842_n N_noxref_5_c_1155_n ) capacitor c=0.0242837f \
 //x=9.62 //y=3.155 //x2=10.36 //y2=2.8
cc_663 ( N_noxref_4_c_842_n N_noxref_5_c_1206_n ) capacitor c=0.0175711f \
 //x=9.62 //y=3.155 //x2=10.36 //y2=3.12
cc_664 ( N_noxref_4_c_811_n N_noxref_5_c_1109_n ) capacitor c=0.0132081f \
 //x=4.44 //y=4.395 //x2=4.44 //y2=2.96
cc_665 ( N_noxref_4_c_818_n N_noxref_5_c_1109_n ) capacitor c=0.0075172f \
 //x=4.485 //y=4.235 //x2=4.44 //y2=2.96
cc_666 ( N_noxref_4_c_846_n N_noxref_5_c_1131_n ) capacitor c=0.00927997f \
 //x=6.66 //y=3.33 //x2=6.66 //y2=4.44
cc_667 ( N_noxref_4_c_849_n N_noxref_5_c_1131_n ) capacitor c=0.00931051f \
 //x=9.465 //y=4.09 //x2=6.66 //y2=4.44
cc_668 ( N_noxref_4_c_842_n N_noxref_5_c_1211_n ) capacitor c=6.78671e-19 \
 //x=9.62 //y=3.155 //x2=10.355 //y2=2.96
cc_669 ( N_noxref_4_c_845_n N_noxref_5_c_1212_n ) capacitor c=0.0140261f \
 //x=9.62 //y=4.875 //x2=10.36 //y2=4.7
cc_670 ( N_noxref_4_c_842_n N_noxref_5_c_1161_n ) capacitor c=0.00161653f \
 //x=9.62 //y=3.155 //x2=10.37 //y2=4.545
cc_671 ( N_noxref_4_c_880_n N_noxref_5_c_1161_n ) capacitor c=0.0164061f \
 //x=9.62 //y=3.475 //x2=10.37 //y2=4.545
cc_672 ( N_noxref_4_c_844_n N_noxref_5_c_1161_n ) capacitor c=0.0211948f \
 //x=9.62 //y=3.955 //x2=10.37 //y2=4.545
cc_673 ( N_noxref_4_c_886_n N_noxref_5_c_1161_n ) capacitor c=0.0143392f \
 //x=9.62 //y=4.25 //x2=10.37 //y2=4.545
cc_674 ( N_noxref_4_c_845_n N_noxref_5_c_1161_n ) capacitor c=0.0105049f \
 //x=9.62 //y=4.875 //x2=10.37 //y2=4.545
cc_675 ( N_noxref_4_c_896_n N_noxref_5_c_1161_n ) capacitor c=0.00549287f \
 //x=9.62 //y=3.33 //x2=10.37 //y2=4.545
cc_676 ( N_noxref_4_c_897_n N_noxref_5_c_1161_n ) capacitor c=0.00478955f \
 //x=9.62 //y=4.07 //x2=10.37 //y2=4.545
cc_677 ( N_noxref_4_c_904_n N_noxref_5_c_1161_n ) capacitor c=0.00688969f \
 //x=9.625 //y=4.09 //x2=10.37 //y2=4.545
cc_678 ( N_noxref_4_c_913_n N_noxref_5_c_1161_n ) capacitor c=0.00722096f \
 //x=9.655 //y=3.315 //x2=10.37 //y2=4.545
cc_679 ( N_noxref_4_c_842_n N_noxref_5_c_1222_n ) capacitor c=0.0181783f \
 //x=9.62 //y=3.155 //x2=10.36 //y2=2.085
cc_680 ( N_noxref_4_c_811_n N_noxref_5_c_1133_n ) capacitor c=8.94562e-19 \
 //x=4.44 //y=4.395 //x2=9.27 //y2=2.96
cc_681 ( N_noxref_4_c_837_n N_noxref_5_c_1133_n ) capacitor c=0.0236671f \
 //x=6.66 //y=3.205 //x2=9.27 //y2=2.96
cc_682 ( N_noxref_4_c_842_n N_noxref_5_c_1133_n ) capacitor c=9.10138e-19 \
 //x=9.62 //y=3.155 //x2=9.27 //y2=2.96
cc_683 ( N_noxref_4_c_880_n N_noxref_5_c_1133_n ) capacitor c=0.00252824f \
 //x=9.62 //y=3.475 //x2=9.27 //y2=2.96
cc_684 ( N_noxref_4_c_846_n N_noxref_5_c_1133_n ) capacitor c=0.00324894f \
 //x=6.66 //y=3.33 //x2=9.27 //y2=2.96
cc_685 ( N_noxref_4_c_820_n N_noxref_5_c_1133_n ) capacitor c=0.0176977f \
 //x=4.485 //y=4.1 //x2=9.27 //y2=2.96
cc_686 ( N_noxref_4_c_847_n N_noxref_5_c_1133_n ) capacitor c=0.0368037f \
 //x=6.82 //y=3.345 //x2=9.27 //y2=2.96
cc_687 ( N_noxref_4_c_851_n N_noxref_5_c_1133_n ) capacitor c=0.234687f \
 //x=9.495 //y=3.315 //x2=9.27 //y2=2.96
cc_688 ( N_noxref_4_c_842_n N_noxref_5_c_1231_n ) capacitor c=0.0299619f \
 //x=9.62 //y=3.155 //x2=9.87 //y2=2.93
cc_689 ( N_noxref_4_c_880_n N_noxref_5_c_1231_n ) capacitor c=0.00405043f \
 //x=9.62 //y=3.475 //x2=9.87 //y2=2.93
cc_690 ( N_noxref_4_c_959_p N_noxref_5_c_1231_n ) capacitor c=0.00929464f \
 //x=9.905 //y=1.84 //x2=9.87 //y2=2.93
cc_691 ( N_noxref_4_c_898_n N_noxref_5_c_1231_n ) capacitor c=4.71823e-19 \
 //x=9.99 //y=1.005 //x2=9.87 //y2=2.93
cc_692 ( N_noxref_4_c_904_n N_noxref_5_c_1231_n ) capacitor c=9.16478e-19 \
 //x=9.625 //y=4.09 //x2=9.87 //y2=2.93
cc_693 ( N_noxref_4_c_913_n N_noxref_5_c_1231_n ) capacitor c=0.0365231f \
 //x=9.655 //y=3.315 //x2=9.87 //y2=2.93
cc_694 ( N_noxref_4_c_880_n N_noxref_5_c_1237_n ) capacitor c=2.76741e-19 \
 //x=9.62 //y=3.475 //x2=9.84 //y2=4.475
cc_695 ( N_noxref_4_c_886_n N_noxref_5_c_1237_n ) capacitor c=0.00242768f \
 //x=9.62 //y=4.25 //x2=9.84 //y2=4.475
cc_696 ( N_noxref_4_c_845_n N_noxref_5_c_1237_n ) capacitor c=0.0330232f \
 //x=9.62 //y=4.875 //x2=9.84 //y2=4.475
cc_697 ( N_noxref_4_c_966_p N_noxref_5_c_1237_n ) capacitor c=0.0170287f \
 //x=9.9 //y=4.96 //x2=9.84 //y2=4.475
cc_698 ( N_noxref_4_c_889_n N_noxref_5_c_1237_n ) capacitor c=0.00103017f \
 //x=9.985 //y=5.24 //x2=9.84 //y2=4.475
cc_699 ( N_noxref_4_c_913_n N_noxref_5_c_1237_n ) capacitor c=0.00164053f \
 //x=9.655 //y=3.315 //x2=9.84 //y2=4.475
cc_700 ( N_noxref_4_c_886_n N_noxref_5_c_1137_n ) capacitor c=0.00285949f \
 //x=9.62 //y=4.25 //x2=9.495 //y2=4.475
cc_701 ( N_noxref_4_c_845_n N_noxref_5_c_1137_n ) capacitor c=0.00100708f \
 //x=9.62 //y=4.875 //x2=9.495 //y2=4.475
cc_702 ( N_noxref_4_c_820_n N_noxref_5_c_1137_n ) capacitor c=2.60705e-19 \
 //x=4.485 //y=4.1 //x2=9.495 //y2=4.475
cc_703 ( N_noxref_4_c_904_n N_noxref_5_c_1137_n ) capacitor c=0.0364799f \
 //x=9.625 //y=4.09 //x2=9.495 //y2=4.475
cc_704 ( N_noxref_4_c_849_n N_noxref_5_c_1137_n ) capacitor c=0.285501f \
 //x=9.465 //y=4.09 //x2=9.495 //y2=4.475
cc_705 ( N_noxref_4_c_851_n N_noxref_5_c_1137_n ) capacitor c=0.00392621f \
 //x=9.495 //y=3.315 //x2=9.495 //y2=4.475
cc_706 ( N_noxref_4_c_811_n N_noxref_5_c_1110_n ) capacitor c=0.00406614f \
 //x=4.44 //y=4.395 //x2=4.6 //y2=2.975
cc_707 ( N_noxref_4_c_820_n N_noxref_5_c_1110_n ) capacitor c=0.00735888f \
 //x=4.485 //y=4.1 //x2=4.6 //y2=2.975
cc_708 ( N_noxref_4_c_846_n N_noxref_5_c_1140_n ) capacitor c=0.00778656f \
 //x=6.66 //y=3.33 //x2=6.66 //y2=4.44
cc_709 ( N_noxref_4_c_849_n N_noxref_5_c_1140_n ) capacitor c=0.00158244f \
 //x=9.465 //y=4.09 //x2=6.66 //y2=4.44
cc_710 ( N_noxref_4_c_842_n N_noxref_5_c_1253_n ) capacitor c=4.71798e-19 \
 //x=9.62 //y=3.155 //x2=10.36 //y2=2.085
cc_711 ( N_noxref_4_c_845_n N_noxref_5_c_1254_n ) capacitor c=5.88334e-19 \
 //x=9.62 //y=4.875 //x2=10.36 //y2=4.7
cc_712 ( N_noxref_4_c_966_p N_noxref_5_M16_noxref_g ) capacitor c=0.00681176f \
 //x=9.9 //y=4.96 //x2=9.765 //y2=6.02
cc_713 ( N_noxref_4_c_982_p N_noxref_5_M16_noxref_g ) capacitor c=0.00222545f \
 //x=9.705 //y=4.96 //x2=9.765 //y2=6.02
cc_714 ( N_noxref_4_c_889_n N_noxref_5_M16_noxref_g ) capacitor c=0.00332234f \
 //x=9.985 //y=5.24 //x2=9.765 //y2=6.02
cc_715 ( N_noxref_4_c_984_p N_noxref_5_M16_noxref_g ) capacitor c=0.0162066f \
 //x=9.985 //y=5.38 //x2=9.765 //y2=6.02
cc_716 ( N_noxref_4_c_966_p N_noxref_5_M17_noxref_g ) capacitor c=0.00534267f \
 //x=9.9 //y=4.96 //x2=10.205 //y2=6.02
cc_717 ( N_noxref_4_c_889_n N_noxref_5_M17_noxref_g ) capacitor c=0.00141266f \
 //x=9.985 //y=5.24 //x2=10.205 //y2=6.02
cc_718 ( N_noxref_4_c_984_p N_noxref_5_M17_noxref_g ) capacitor c=0.0162066f \
 //x=9.985 //y=5.38 //x2=10.205 //y2=6.02
cc_719 ( N_noxref_4_c_898_n N_noxref_5_c_1262_n ) capacitor c=0.00147264f \
 //x=9.99 //y=1.005 //x2=9.72 //y2=0.91
cc_720 ( N_noxref_4_M5_noxref_d N_noxref_5_c_1262_n ) capacitor c=0.00136418f \
 //x=9.795 //y=0.91 //x2=9.72 //y2=0.91
cc_721 ( N_noxref_4_c_959_p N_noxref_5_c_1264_n ) capacitor c=0.00180253f \
 //x=9.905 //y=1.84 //x2=9.72 //y2=1.255
cc_722 ( N_noxref_4_c_891_n N_noxref_5_c_1264_n ) capacitor c=0.00322824f \
 //x=9.99 //y=1.755 //x2=9.72 //y2=1.255
cc_723 ( N_noxref_4_c_898_n N_noxref_5_c_1264_n ) capacitor c=0.00350441f \
 //x=9.99 //y=1.005 //x2=9.72 //y2=1.255
cc_724 ( N_noxref_4_M5_noxref_d N_noxref_5_c_1264_n ) capacitor c=0.00235934f \
 //x=9.795 //y=0.91 //x2=9.72 //y2=1.255
cc_725 ( N_noxref_4_c_966_p N_noxref_5_c_1268_n ) capacitor c=0.00262283f \
 //x=9.9 //y=4.96 //x2=10.13 //y2=4.79
cc_726 ( N_noxref_4_c_984_p N_noxref_5_c_1268_n ) capacitor c=0.00290963f \
 //x=9.985 //y=5.38 //x2=10.13 //y2=4.79
cc_727 ( N_noxref_4_c_886_n N_noxref_5_c_1270_n ) capacitor c=0.00105397f \
 //x=9.62 //y=4.25 //x2=9.84 //y2=4.79
cc_728 ( N_noxref_4_c_845_n N_noxref_5_c_1270_n ) capacitor c=0.00203237f \
 //x=9.62 //y=4.875 //x2=9.84 //y2=4.79
cc_729 ( N_noxref_4_c_897_n N_noxref_5_c_1270_n ) capacitor c=2.84121e-19 \
 //x=9.62 //y=4.07 //x2=9.84 //y2=4.79
cc_730 ( N_noxref_4_c_898_n N_noxref_5_c_1273_n ) capacitor c=5.57924e-19 \
 //x=9.99 //y=1.005 //x2=10.095 //y2=0.755
cc_731 ( N_noxref_4_M5_noxref_d N_noxref_5_c_1273_n ) capacitor c=0.0020782f \
 //x=9.795 //y=0.91 //x2=10.095 //y2=0.755
cc_732 ( N_noxref_4_c_891_n N_noxref_5_c_1275_n ) capacitor c=0.00935661f \
 //x=9.99 //y=1.755 //x2=10.095 //y2=1.41
cc_733 ( N_noxref_4_c_898_n N_noxref_5_c_1275_n ) capacitor c=5.75878e-19 \
 //x=9.99 //y=1.005 //x2=10.095 //y2=1.41
cc_734 ( N_noxref_4_M5_noxref_d N_noxref_5_c_1275_n ) capacitor c=0.00356097f \
 //x=9.795 //y=0.91 //x2=10.095 //y2=1.41
cc_735 ( N_noxref_4_c_898_n N_noxref_5_c_1278_n ) capacitor c=0.0018901f \
 //x=9.99 //y=1.005 //x2=10.25 //y2=0.91
cc_736 ( N_noxref_4_M5_noxref_d N_noxref_5_c_1278_n ) capacitor c=0.00139961f \
 //x=9.795 //y=0.91 //x2=10.25 //y2=0.91
cc_737 ( N_noxref_4_c_891_n N_noxref_5_c_1280_n ) capacitor c=0.0012792f \
 //x=9.99 //y=1.755 //x2=10.25 //y2=1.255
cc_738 ( N_noxref_4_c_898_n N_noxref_5_c_1280_n ) capacitor c=0.00414335f \
 //x=9.99 //y=1.005 //x2=10.25 //y2=1.255
cc_739 ( N_noxref_4_M5_noxref_d N_noxref_5_c_1280_n ) capacitor c=0.0023891f \
 //x=9.795 //y=0.91 //x2=10.25 //y2=1.255
cc_740 ( N_noxref_4_c_891_n N_noxref_5_c_1283_n ) capacitor c=0.0056351f \
 //x=9.99 //y=1.755 //x2=10.25 //y2=1.565
cc_741 ( N_noxref_4_c_891_n N_noxref_5_c_1284_n ) capacitor c=0.00440271f \
 //x=9.99 //y=1.755 //x2=10.25 //y2=1.92
cc_742 ( N_noxref_4_c_842_n N_noxref_5_c_1285_n ) capacitor c=0.00275704f \
 //x=9.62 //y=3.155 //x2=10.25 //y2=2.085
cc_743 ( N_noxref_4_c_959_p N_noxref_5_c_1285_n ) capacitor c=0.00440271f \
 //x=9.905 //y=1.84 //x2=10.25 //y2=2.085
cc_744 ( N_noxref_4_c_982_p N_noxref_6_c_1445_n ) capacitor c=0.0019981f \
 //x=9.705 //y=4.96 //x2=10.36 //y2=7.4
cc_745 ( N_noxref_4_c_889_n N_noxref_6_c_1445_n ) capacitor c=0.00259272f \
 //x=9.985 //y=5.24 //x2=10.36 //y2=7.4
cc_746 ( N_noxref_4_c_984_p N_noxref_6_c_1445_n ) capacitor c=0.0024144f \
 //x=9.985 //y=5.38 //x2=10.36 //y2=7.4
cc_747 ( N_noxref_4_M10_noxref_g N_noxref_6_c_1388_n ) capacitor c=0.00772064f \
 //x=4.11 //y=6.02 //x2=5.38 //y2=7.4
cc_748 ( N_noxref_4_M11_noxref_g N_noxref_6_c_1388_n ) capacitor c=0.00753389f \
 //x=4.55 //y=6.02 //x2=5.38 //y2=7.4
cc_749 ( N_noxref_4_c_982_p N_noxref_6_c_1470_n ) capacitor c=0.00194101f \
 //x=9.705 //y=4.96 //x2=10.34 //y2=7.4
cc_750 ( N_noxref_4_c_889_n N_noxref_6_c_1470_n ) capacitor c=8.9666e-19 \
 //x=9.985 //y=5.24 //x2=10.34 //y2=7.4
cc_751 ( N_noxref_4_c_984_p N_noxref_6_c_1470_n ) capacitor c=0.0137788f \
 //x=9.985 //y=5.38 //x2=10.34 //y2=7.4
cc_752 ( N_noxref_4_c_818_n N_noxref_6_c_1433_n ) capacitor c=0.00225757f \
 //x=4.485 //y=4.235 //x2=5.55 //y2=7.4
cc_753 ( N_noxref_4_c_849_n N_noxref_6_c_1433_n ) capacitor c=0.020338f \
 //x=9.465 //y=4.09 //x2=5.55 //y2=7.4
cc_754 ( N_noxref_4_c_823_n N_noxref_6_c_1433_n ) capacitor c=0.00347829f \
 //x=4.44 //y=4.7 //x2=5.55 //y2=7.4
cc_755 ( N_noxref_4_c_829_n N_noxref_6_c_1433_n ) capacitor c=0.0200066f \
 //x=4.44 //y=4.7 //x2=5.55 //y2=7.4
cc_756 ( N_noxref_4_c_886_n N_noxref_6_c_1434_n ) capacitor c=0.00193791f \
 //x=9.62 //y=4.25 //x2=8.88 //y2=7.4
cc_757 ( N_noxref_4_c_845_n N_noxref_6_c_1434_n ) capacitor c=0.0160087f \
 //x=9.62 //y=4.875 //x2=8.88 //y2=7.4
cc_758 ( N_noxref_4_c_889_n N_noxref_6_c_1434_n ) capacitor c=0.00203464f \
 //x=9.985 //y=5.24 //x2=8.88 //y2=7.4
cc_759 ( N_noxref_4_c_897_n N_noxref_6_c_1434_n ) capacitor c=0.00491566f \
 //x=9.62 //y=4.07 //x2=8.88 //y2=7.4
cc_760 ( N_noxref_4_c_849_n N_noxref_6_c_1434_n ) capacitor c=0.00929033f \
 //x=9.465 //y=4.09 //x2=8.88 //y2=7.4
cc_761 ( N_noxref_4_c_984_p N_noxref_6_c_1434_n ) capacitor c=0.00821754f \
 //x=9.985 //y=5.38 //x2=8.88 //y2=7.4
cc_762 ( N_noxref_4_c_845_n N_noxref_6_c_1436_n ) capacitor c=2.43252e-19 \
 //x=9.62 //y=4.875 //x2=10.36 //y2=7.4
cc_763 ( N_noxref_4_c_966_p N_noxref_6_c_1436_n ) capacitor c=0.00685597f \
 //x=9.9 //y=4.96 //x2=10.36 //y2=7.4
cc_764 ( N_noxref_4_c_897_n N_noxref_6_c_1436_n ) capacitor c=0.00143727f \
 //x=9.62 //y=4.07 //x2=10.36 //y2=7.4
cc_765 ( N_noxref_4_c_984_p N_noxref_6_c_1436_n ) capacitor c=0.00958323f \
 //x=9.985 //y=5.38 //x2=10.36 //y2=7.4
cc_766 ( N_noxref_4_c_886_n N_noxref_6_M16_noxref_s ) capacitor c=0.00402344f \
 //x=9.62 //y=4.25 //x2=9.42 //y2=5.02
cc_767 ( N_noxref_4_c_982_p N_noxref_6_M16_noxref_s ) capacitor c=0.0201084f \
 //x=9.705 //y=4.96 //x2=9.42 //y2=5.02
cc_768 ( N_noxref_4_c_889_n N_noxref_6_M16_noxref_s ) capacitor c=0.0474638f \
 //x=9.985 //y=5.24 //x2=9.42 //y2=5.02
cc_769 ( N_noxref_4_c_897_n N_noxref_6_M16_noxref_s ) capacitor c=0.00133029f \
 //x=9.62 //y=4.07 //x2=9.42 //y2=5.02
cc_770 ( N_noxref_4_c_984_p N_noxref_6_M16_noxref_s ) capacitor c=0.0909229f \
 //x=9.985 //y=5.38 //x2=9.42 //y2=5.02
cc_771 ( N_noxref_4_c_889_n N_noxref_6_M17_noxref_d ) capacitor c=0.0480012f \
 //x=9.985 //y=5.24 //x2=10.28 //y2=5.02
cc_772 ( N_noxref_4_c_984_p N_noxref_6_M17_noxref_d ) capacitor c=0.09216f \
 //x=9.985 //y=5.38 //x2=10.28 //y2=5.02
cc_773 ( N_noxref_4_M10_noxref_g N_noxref_7_c_1636_n ) capacitor c=0.0090785f \
 //x=4.11 //y=6.02 //x2=4.655 //y2=6.905
cc_774 ( N_noxref_4_M11_noxref_g N_noxref_7_c_1636_n ) capacitor c=0.00931972f \
 //x=4.55 //y=6.02 //x2=4.655 //y2=6.905
cc_775 ( N_noxref_4_M10_noxref_g N_noxref_7_c_1629_n ) capacitor c=0.00179653f \
 //x=4.11 //y=6.02 //x2=3.89 //y2=5.205
cc_776 ( N_noxref_4_M10_noxref_g N_noxref_7_c_1630_n ) capacitor c=0.00179267f \
 //x=4.11 //y=6.02 //x2=3.89 //y2=6.735
cc_777 ( N_noxref_4_M11_noxref_g N_noxref_7_c_1642_n ) capacitor c=0.00394587f \
 //x=4.55 //y=6.02 //x2=4.77 //y2=6.735
cc_778 ( N_noxref_4_M10_noxref_g N_noxref_7_c_1633_n ) capacitor c=0.0170175f \
 //x=4.11 //y=6.02 //x2=3.89 //y2=5.375
cc_779 ( N_noxref_4_M11_noxref_g N_noxref_7_M11_noxref_d ) capacitor \
 c=0.0365939f //x=4.55 //y=6.02 //x2=4.625 //y2=5.02
cc_780 ( N_noxref_4_c_849_n N_noxref_8_c_1712_n ) capacitor c=0.00758358f \
 //x=9.465 //y=4.09 //x2=6.34 //y2=5.205
cc_781 ( N_noxref_4_c_889_n N_noxref_8_c_1704_n ) capacitor c=4.00761e-19 \
 //x=9.985 //y=5.24 //x2=7.22 //y2=5.205
cc_782 ( N_noxref_4_c_833_n N_noxref_9_c_1838_n ) capacitor c=0.0055888f \
 //x=6.66 //y=2.205 //x2=6.73 //y2=0.845
cc_783 ( N_noxref_4_c_846_n N_noxref_9_c_1838_n ) capacitor c=3.43532e-19 \
 //x=6.66 //y=3.33 //x2=6.73 //y2=0.845
cc_784 ( N_noxref_4_c_853_n N_noxref_9_c_1838_n ) capacitor c=4.17965e-19 \
 //x=6.66 //y=2.085 //x2=6.73 //y2=0.845
cc_785 ( N_noxref_4_c_856_n N_noxref_9_c_1838_n ) capacitor c=0.00144305f \
 //x=6.465 //y=0.87 //x2=6.73 //y2=0.845
cc_786 ( N_noxref_4_c_857_n N_noxref_9_c_1838_n ) capacitor c=0.00300481f \
 //x=6.465 //y=1.215 //x2=6.73 //y2=0.845
cc_787 ( N_noxref_4_c_1056_p N_noxref_9_c_1838_n ) capacitor c=0.00923307f \
 //x=6.84 //y=0.715 //x2=6.73 //y2=0.845
cc_788 ( N_noxref_4_c_1057_p N_noxref_9_c_1838_n ) capacitor c=5.58852e-19 \
 //x=6.84 //y=1.37 //x2=6.73 //y2=0.845
cc_789 ( N_noxref_4_c_864_n N_noxref_9_c_1838_n ) capacitor c=0.00167052f \
 //x=6.995 //y=0.87 //x2=6.73 //y2=0.845
cc_790 ( N_noxref_4_c_866_n N_noxref_9_c_1838_n ) capacitor c=0.00212338f \
 //x=6.995 //y=1.215 //x2=6.73 //y2=0.845
cc_791 ( N_noxref_4_c_880_n N_noxref_9_c_1839_n ) capacitor c=5.16834e-19 \
 //x=9.62 //y=3.475 //x2=10.36 //y2=0
cc_792 ( N_noxref_4_c_888_n N_noxref_9_c_1839_n ) capacitor c=0.00498327f \
 //x=9.705 //y=1.84 //x2=10.36 //y2=0
cc_793 ( N_noxref_4_c_898_n N_noxref_9_c_1839_n ) capacitor c=0.00981066f \
 //x=9.99 //y=1.005 //x2=10.36 //y2=0
cc_794 ( N_noxref_4_M5_noxref_d N_noxref_9_c_1839_n ) capacitor c=0.00119583f \
 //x=9.795 //y=0.91 //x2=10.36 //y2=0
cc_795 ( N_noxref_4_c_856_n N_noxref_9_c_1878_n ) capacitor c=0.00685249f \
 //x=6.465 //y=0.87 //x2=8.71 //y2=0
cc_796 ( N_noxref_4_c_888_n N_noxref_9_c_1903_n ) capacitor c=0.00321227f \
 //x=9.705 //y=1.84 //x2=9.905 //y2=0.535
cc_797 ( N_noxref_4_c_896_n N_noxref_9_c_1903_n ) capacitor c=2.56765e-19 \
 //x=9.62 //y=3.33 //x2=9.905 //y2=0.535
cc_798 ( N_noxref_4_c_898_n N_noxref_9_c_1903_n ) capacitor c=0.00130436f \
 //x=9.99 //y=1.005 //x2=9.905 //y2=0.535
cc_799 ( N_noxref_4_c_898_n N_noxref_9_c_1906_n ) capacitor c=0.00127229f \
 //x=9.99 //y=1.005 //x2=10.385 //y2=0.535
cc_800 ( N_noxref_4_c_833_n N_noxref_9_c_1851_n ) capacitor c=0.00394736f \
 //x=6.66 //y=2.205 //x2=5.55 //y2=0
cc_801 ( N_noxref_4_c_837_n N_noxref_9_c_1851_n ) capacitor c=0.00664422f \
 //x=6.66 //y=3.205 //x2=5.55 //y2=0
cc_802 ( N_noxref_4_c_853_n N_noxref_9_c_1851_n ) capacitor c=0.00369503f \
 //x=6.66 //y=2.085 //x2=5.55 //y2=0
cc_803 ( N_noxref_4_c_858_n N_noxref_9_c_1851_n ) capacitor c=0.0015404f \
 //x=6.465 //y=1.525 //x2=5.55 //y2=0
cc_804 ( N_noxref_4_c_860_n N_noxref_9_c_1851_n ) capacitor c=0.00950704f \
 //x=6.465 //y=1.92 //x2=5.55 //y2=0
cc_805 ( N_noxref_4_c_888_n N_noxref_9_c_1853_n ) capacitor c=0.0205341f \
 //x=9.705 //y=1.84 //x2=8.88 //y2=0
cc_806 ( N_noxref_4_c_842_n N_noxref_9_c_1857_n ) capacitor c=2.14154e-19 \
 //x=9.62 //y=3.155 //x2=10.47 //y2=0
cc_807 ( N_noxref_4_c_891_n N_noxref_9_c_1857_n ) capacitor c=0.00520602f \
 //x=9.99 //y=1.755 //x2=10.47 //y2=0
cc_808 ( N_noxref_4_c_898_n N_noxref_9_c_1857_n ) capacitor c=2.8029e-19 \
 //x=9.99 //y=1.005 //x2=10.47 //y2=0
cc_809 ( N_noxref_4_M5_noxref_d N_noxref_9_c_1857_n ) capacitor c=2.70835e-19 \
 //x=9.795 //y=0.91 //x2=10.47 //y2=0
cc_810 ( N_noxref_4_c_833_n N_noxref_9_M3_noxref_d ) capacitor c=4.23034e-19 \
 //x=6.66 //y=2.205 //x2=6.54 //y2=0.87
cc_811 ( N_noxref_4_c_856_n N_noxref_9_M3_noxref_d ) capacitor c=0.00192399f \
 //x=6.465 //y=0.87 //x2=6.54 //y2=0.87
cc_812 ( N_noxref_4_c_857_n N_noxref_9_M3_noxref_d ) capacitor c=0.00210798f \
 //x=6.465 //y=1.215 //x2=6.54 //y2=0.87
cc_813 ( N_noxref_4_c_1056_p N_noxref_9_M3_noxref_d ) capacitor c=0.00473146f \
 //x=6.84 //y=0.715 //x2=6.54 //y2=0.87
cc_814 ( N_noxref_4_c_1057_p N_noxref_9_M3_noxref_d ) capacitor c=0.00166857f \
 //x=6.84 //y=1.37 //x2=6.54 //y2=0.87
cc_815 ( N_noxref_4_c_864_n N_noxref_9_M3_noxref_d ) capacitor c=0.00230174f \
 //x=6.995 //y=0.87 //x2=6.54 //y2=0.87
cc_816 ( N_noxref_4_c_866_n N_noxref_9_M3_noxref_d ) capacitor c=0.00210798f \
 //x=6.995 //y=1.215 //x2=6.54 //y2=0.87
cc_817 ( N_noxref_4_c_880_n N_noxref_9_M5_noxref_s ) capacitor c=0.00134937f \
 //x=9.62 //y=3.475 //x2=9.375 //y2=0.37
cc_818 ( N_noxref_4_c_888_n N_noxref_9_M5_noxref_s ) capacitor c=0.00386149f \
 //x=9.705 //y=1.84 //x2=9.375 //y2=0.37
cc_819 ( N_noxref_4_c_891_n N_noxref_9_M5_noxref_s ) capacitor c=0.032512f \
 //x=9.99 //y=1.755 //x2=9.375 //y2=0.37
cc_820 ( N_noxref_4_c_896_n N_noxref_9_M5_noxref_s ) capacitor c=7.24828e-19 \
 //x=9.62 //y=3.33 //x2=9.375 //y2=0.37
cc_821 ( N_noxref_4_c_898_n N_noxref_9_M5_noxref_s ) capacitor c=0.0156189f \
 //x=9.99 //y=1.005 //x2=9.375 //y2=0.37
cc_822 ( N_noxref_4_M5_noxref_d N_noxref_9_M5_noxref_s ) capacitor \
 c=0.0377604f //x=9.795 //y=0.91 //x2=9.375 //y2=0.37
cc_823 ( N_noxref_4_c_860_n N_noxref_11_c_2088_n ) capacitor c=0.00262672f \
 //x=6.465 //y=1.92 //x2=6.245 //y2=1.5
cc_824 ( N_noxref_4_c_833_n N_noxref_11_c_2089_n ) capacitor c=0.00528521f \
 //x=6.66 //y=2.205 //x2=7.13 //y2=1.585
cc_825 ( N_noxref_4_c_846_n N_noxref_11_c_2089_n ) capacitor c=0.00232678f \
 //x=6.66 //y=3.33 //x2=7.13 //y2=1.585
cc_826 ( N_noxref_4_c_853_n N_noxref_11_c_2089_n ) capacitor c=0.00763108f \
 //x=6.66 //y=2.085 //x2=7.13 //y2=1.585
cc_827 ( N_noxref_4_c_858_n N_noxref_11_c_2089_n ) capacitor c=0.00697569f \
 //x=6.465 //y=1.525 //x2=7.13 //y2=1.585
cc_828 ( N_noxref_4_c_860_n N_noxref_11_c_2089_n ) capacitor c=0.0174857f \
 //x=6.465 //y=1.92 //x2=7.13 //y2=1.585
cc_829 ( N_noxref_4_c_1057_p N_noxref_11_c_2089_n ) capacitor c=0.00725634f \
 //x=6.84 //y=1.37 //x2=7.13 //y2=1.585
cc_830 ( N_noxref_4_c_866_n N_noxref_11_c_2089_n ) capacitor c=0.0034036f \
 //x=6.995 //y=1.215 //x2=7.13 //y2=1.585
cc_831 ( N_noxref_4_c_860_n N_noxref_11_c_2090_n ) capacitor c=6.71402e-19 \
 //x=6.465 //y=1.92 //x2=7.215 //y2=1.5
cc_832 ( N_noxref_4_c_856_n N_noxref_11_M3_noxref_s ) capacitor c=0.0294925f \
 //x=6.465 //y=0.87 //x2=6.11 //y2=0.37
cc_833 ( N_noxref_4_c_858_n N_noxref_11_M3_noxref_s ) capacitor c=3.48408e-19 \
 //x=6.465 //y=1.525 //x2=6.11 //y2=0.37
cc_834 ( N_noxref_4_c_864_n N_noxref_11_M3_noxref_s ) capacitor c=0.0125442f \
 //x=6.995 //y=0.87 //x2=6.11 //y2=0.37
cc_835 ( N_noxref_5_M12_noxref_g N_noxref_6_c_1494_n ) capacitor c=0.00365752f \
 //x=6.56 //y=6.02 //x2=6.78 //y2=6.51
cc_836 ( N_noxref_5_M13_noxref_g N_noxref_6_c_1494_n ) capacitor c=0.00387858f \
 //x=7 //y=6.02 //x2=6.78 //y2=6.51
cc_837 ( N_noxref_5_M12_noxref_g N_noxref_6_c_1496_n ) capacitor c=0.00522062f \
 //x=6.56 //y=6.02 //x2=6.78 //y2=7.23
cc_838 ( N_noxref_5_M13_noxref_g N_noxref_6_c_1496_n ) capacitor c=0.00588679f \
 //x=7 //y=6.02 //x2=6.78 //y2=7.23
cc_839 ( N_noxref_5_c_1206_n N_noxref_6_c_1445_n ) capacitor c=2.19282e-19 \
 //x=10.36 //y=3.12 //x2=10.36 //y2=7.4
cc_840 ( N_noxref_5_c_1212_n N_noxref_6_c_1445_n ) capacitor c=2.8019e-19 \
 //x=10.36 //y=4.7 //x2=10.36 //y2=7.4
cc_841 ( N_noxref_5_c_1254_n N_noxref_6_c_1445_n ) capacitor c=3.40875e-19 \
 //x=10.36 //y=4.7 //x2=10.36 //y2=7.4
cc_842 ( N_noxref_5_M12_noxref_g N_noxref_6_c_1424_n ) capacitor c=0.00744813f \
 //x=6.56 //y=6.02 //x2=8.71 //y2=7.4
cc_843 ( N_noxref_5_M13_noxref_g N_noxref_6_c_1424_n ) capacitor c=0.00749619f \
 //x=7 //y=6.02 //x2=8.71 //y2=7.4
cc_844 ( N_noxref_5_c_1212_n N_noxref_6_c_1470_n ) capacitor c=2.31887e-19 \
 //x=10.36 //y=4.7 //x2=10.34 //y2=7.4
cc_845 ( N_noxref_5_M16_noxref_g N_noxref_6_c_1470_n ) capacitor c=0.0074551f \
 //x=9.765 //y=6.02 //x2=10.34 //y2=7.4
cc_846 ( N_noxref_5_M17_noxref_g N_noxref_6_c_1470_n ) capacitor c=0.00748034f \
 //x=10.205 //y=6.02 //x2=10.34 //y2=7.4
cc_847 ( N_noxref_5_c_1131_n N_noxref_6_c_1433_n ) capacitor c=0.00343839f \
 //x=6.66 //y=4.44 //x2=5.55 //y2=7.4
cc_848 ( N_noxref_5_c_1140_n N_noxref_6_c_1433_n ) capacitor c=0.0101962f \
 //x=6.66 //y=4.44 //x2=5.55 //y2=7.4
cc_849 ( N_noxref_5_c_1147_n N_noxref_6_c_1433_n ) capacitor c=0.016029f \
 //x=6.66 //y=4.7 //x2=5.55 //y2=7.4
cc_850 ( N_noxref_5_c_1137_n N_noxref_6_c_1434_n ) capacitor c=0.0259477f \
 //x=9.495 //y=4.475 //x2=8.88 //y2=7.4
cc_851 ( N_noxref_5_c_1140_n N_noxref_6_c_1434_n ) capacitor c=0.00169109f \
 //x=6.66 //y=4.44 //x2=8.88 //y2=7.4
cc_852 ( N_noxref_5_c_1254_n N_noxref_6_c_1434_n ) capacitor c=0.00235165f \
 //x=10.36 //y=4.7 //x2=8.88 //y2=7.4
cc_853 ( N_noxref_5_c_1270_n N_noxref_6_c_1434_n ) capacitor c=0.00915756f \
 //x=9.84 //y=4.79 //x2=8.88 //y2=7.4
cc_854 ( N_noxref_5_c_1306_p N_noxref_6_c_1434_n ) capacitor c=2.63786e-19 \
 //x=10.205 //y=4.865 //x2=8.88 //y2=7.4
cc_855 ( N_noxref_5_c_1212_n N_noxref_6_c_1436_n ) capacitor c=0.00699438f \
 //x=10.36 //y=4.7 //x2=10.36 //y2=7.4
cc_856 ( N_noxref_5_c_1161_n N_noxref_6_c_1436_n ) capacitor c=0.0117359f \
 //x=10.37 //y=4.545 //x2=10.36 //y2=7.4
cc_857 ( N_noxref_5_c_1254_n N_noxref_6_c_1436_n ) capacitor c=0.00803468f \
 //x=10.36 //y=4.7 //x2=10.36 //y2=7.4
cc_858 ( N_noxref_5_M17_noxref_g N_noxref_6_c_1436_n ) capacitor c=0.0181495f \
 //x=10.205 //y=6.02 //x2=10.36 //y2=7.4
cc_859 ( N_noxref_5_c_1306_p N_noxref_6_c_1436_n ) capacitor c=0.0061994f \
 //x=10.205 //y=4.865 //x2=10.36 //y2=7.4
cc_860 ( N_noxref_5_c_1140_n N_noxref_6_M12_noxref_d ) capacitor c=0.00176891f \
 //x=6.66 //y=4.44 //x2=6.635 //y2=5.02
cc_861 ( N_noxref_5_M12_noxref_g N_noxref_6_M12_noxref_d ) capacitor \
 c=0.00896756f //x=6.56 //y=6.02 //x2=6.635 //y2=5.02
cc_862 ( N_noxref_5_M13_noxref_g N_noxref_6_M12_noxref_d ) capacitor \
 c=0.00896756f //x=7 //y=6.02 //x2=6.635 //y2=5.02
cc_863 ( N_noxref_5_c_1147_n N_noxref_6_M12_noxref_d ) capacitor c=0.00318882f \
 //x=6.66 //y=4.7 //x2=6.635 //y2=5.02
cc_864 ( N_noxref_5_c_1137_n N_noxref_6_M16_noxref_s ) capacitor c=0.00303281f \
 //x=9.495 //y=4.475 //x2=9.42 //y2=5.02
cc_865 ( N_noxref_5_M16_noxref_g N_noxref_6_M16_noxref_s ) capacitor \
 c=0.0572684f //x=9.765 //y=6.02 //x2=9.42 //y2=5.02
cc_866 ( N_noxref_5_c_1212_n N_noxref_6_M17_noxref_d ) capacitor c=0.0220603f \
 //x=10.36 //y=4.7 //x2=10.28 //y2=5.02
cc_867 ( N_noxref_5_c_1237_n N_noxref_6_M17_noxref_d ) capacitor c=0.00616847f \
 //x=9.84 //y=4.475 //x2=10.28 //y2=5.02
cc_868 ( N_noxref_5_c_1254_n N_noxref_6_M17_noxref_d ) capacitor c=0.00986151f \
 //x=10.36 //y=4.7 //x2=10.28 //y2=5.02
cc_869 ( N_noxref_5_M17_noxref_g N_noxref_6_M17_noxref_d ) capacitor \
 c=0.0573441f //x=10.205 //y=6.02 //x2=10.28 //y2=5.02
cc_870 ( N_noxref_5_c_1306_p N_noxref_6_M17_noxref_d ) capacitor c=0.00463874f \
 //x=10.205 //y=4.865 //x2=10.28 //y2=5.02
cc_871 ( N_noxref_5_c_1131_n N_noxref_8_c_1725_n ) capacitor c=0.0192022f \
 //x=6.66 //y=4.44 //x2=7.105 //y2=5.205
cc_872 ( N_noxref_5_c_1137_n N_noxref_8_c_1725_n ) capacitor c=0.0271887f \
 //x=9.495 //y=4.475 //x2=7.105 //y2=5.205
cc_873 ( N_noxref_5_c_1140_n N_noxref_8_c_1725_n ) capacitor c=0.00477026f \
 //x=6.66 //y=4.44 //x2=7.105 //y2=5.205
cc_874 ( N_noxref_5_M12_noxref_g N_noxref_8_c_1725_n ) capacitor c=0.0111298f \
 //x=6.56 //y=6.02 //x2=7.105 //y2=5.205
cc_875 ( N_noxref_5_M13_noxref_g N_noxref_8_c_1725_n ) capacitor c=0.00889995f \
 //x=7 //y=6.02 //x2=7.105 //y2=5.205
cc_876 ( N_noxref_5_c_1147_n N_noxref_8_c_1725_n ) capacitor c=0.00140744f \
 //x=6.66 //y=4.7 //x2=7.105 //y2=5.205
cc_877 ( N_noxref_5_M12_noxref_g N_noxref_8_c_1712_n ) capacitor c=0.00394587f \
 //x=6.56 //y=6.02 //x2=6.34 //y2=5.205
cc_878 ( N_noxref_5_c_1137_n N_noxref_8_c_1704_n ) capacitor c=9.55296e-19 \
 //x=9.495 //y=4.475 //x2=7.22 //y2=5.205
cc_879 ( N_noxref_5_M13_noxref_g N_noxref_8_c_1704_n ) capacitor c=0.00179267f \
 //x=7 //y=6.02 //x2=7.22 //y2=5.205
cc_880 ( N_noxref_5_M13_noxref_g N_noxref_8_c_1705_n ) capacitor c=0.00182026f \
 //x=7 //y=6.02 //x2=7.22 //y2=6.735
cc_881 ( N_noxref_5_M12_noxref_g N_noxref_8_c_1735_n ) capacitor c=0.046753f \
 //x=6.56 //y=6.02 //x2=6.34 //y2=5.375
cc_882 ( N_noxref_5_M13_noxref_g N_noxref_8_c_1707_n ) capacitor c=0.0184757f \
 //x=7 //y=6.02 //x2=7.22 //y2=5.375
cc_883 ( N_noxref_5_M12_noxref_g N_noxref_8_M12_noxref_s ) capacitor \
 c=0.00526487f //x=6.56 //y=6.02 //x2=6.205 //y2=5.02
cc_884 ( N_noxref_5_c_1206_n N_noxref_9_c_1839_n ) capacitor c=3.74292e-19 \
 //x=10.36 //y=3.12 //x2=10.36 //y2=0
cc_885 ( N_noxref_5_c_1222_n N_noxref_9_c_1839_n ) capacitor c=0.0024861f \
 //x=10.36 //y=2.085 //x2=10.36 //y2=0
cc_886 ( N_noxref_5_c_1253_n N_noxref_9_c_1839_n ) capacitor c=7.53892e-19 \
 //x=10.36 //y=2.085 //x2=10.36 //y2=0
cc_887 ( N_noxref_5_c_1262_n N_noxref_9_c_1903_n ) capacitor c=0.0132638f \
 //x=9.72 //y=0.91 //x2=9.905 //y2=0.535
cc_888 ( N_noxref_5_c_1206_n N_noxref_9_c_1906_n ) capacitor c=5.06314e-19 \
 //x=10.36 //y=3.12 //x2=10.385 //y2=0.535
cc_889 ( N_noxref_5_c_1222_n N_noxref_9_c_1906_n ) capacitor c=0.00114179f \
 //x=10.36 //y=2.085 //x2=10.385 //y2=0.535
cc_890 ( N_noxref_5_c_1253_n N_noxref_9_c_1906_n ) capacitor c=3.95714e-19 \
 //x=10.36 //y=2.085 //x2=10.385 //y2=0.535
cc_891 ( N_noxref_5_c_1278_n N_noxref_9_c_1906_n ) capacitor c=0.0126436f \
 //x=10.25 //y=0.91 //x2=10.385 //y2=0.535
cc_892 ( N_noxref_5_c_1285_n N_noxref_9_c_1906_n ) capacitor c=2.1838e-19 \
 //x=10.25 //y=2.085 //x2=10.385 //y2=0.535
cc_893 ( N_noxref_5_c_1133_n N_noxref_9_c_1851_n ) capacitor c=0.00411791f \
 //x=9.27 //y=2.96 //x2=5.55 //y2=0
cc_894 ( N_noxref_5_c_1111_n N_noxref_9_c_1851_n ) capacitor c=0.00348382f \
 //x=4.44 //y=2.085 //x2=5.55 //y2=0
cc_895 ( N_noxref_5_c_1122_n N_noxref_9_c_1851_n ) capacitor c=0.00583872f \
 //x=4.105 //y=1.92 //x2=5.55 //y2=0
cc_896 ( N_noxref_5_c_1126_n N_noxref_9_c_1851_n ) capacitor c=0.00230557f \
 //x=4.635 //y=1.255 //x2=5.55 //y2=0
cc_897 ( N_noxref_5_c_1133_n N_noxref_9_c_1853_n ) capacitor c=0.00725422f \
 //x=9.27 //y=2.96 //x2=8.88 //y2=0
cc_898 ( N_noxref_5_c_1253_n N_noxref_9_c_1853_n ) capacitor c=0.0022444f \
 //x=10.36 //y=2.085 //x2=8.88 //y2=0
cc_899 ( N_noxref_5_c_1285_n N_noxref_9_c_1853_n ) capacitor c=2.63786e-19 \
 //x=10.25 //y=2.085 //x2=8.88 //y2=0
cc_900 ( N_noxref_5_c_1155_n N_noxref_9_c_1857_n ) capacitor c=0.0146622f \
 //x=10.36 //y=2.8 //x2=10.47 //y2=0
cc_901 ( N_noxref_5_c_1222_n N_noxref_9_c_1857_n ) capacitor c=0.0100674f \
 //x=10.36 //y=2.085 //x2=10.47 //y2=0
cc_902 ( N_noxref_5_c_1253_n N_noxref_9_c_1857_n ) capacitor c=0.00733542f \
 //x=10.36 //y=2.085 //x2=10.47 //y2=0
cc_903 ( N_noxref_5_c_1284_n N_noxref_9_c_1857_n ) capacitor c=0.00574455f \
 //x=10.25 //y=1.92 //x2=10.47 //y2=0
cc_904 ( N_noxref_5_c_1285_n N_noxref_9_c_1857_n ) capacitor c=0.00785621f \
 //x=10.25 //y=2.085 //x2=10.47 //y2=0
cc_905 ( N_noxref_5_c_1206_n N_noxref_9_M5_noxref_s ) capacitor c=5.46408e-19 \
 //x=10.36 //y=3.12 //x2=9.375 //y2=0.37
cc_906 ( N_noxref_5_c_1222_n N_noxref_9_M5_noxref_s ) capacitor c=0.00297747f \
 //x=10.36 //y=2.085 //x2=9.375 //y2=0.37
cc_907 ( N_noxref_5_c_1133_n N_noxref_9_M5_noxref_s ) capacitor c=0.00188668f \
 //x=9.27 //y=2.96 //x2=9.375 //y2=0.37
cc_908 ( N_noxref_5_c_1253_n N_noxref_9_M5_noxref_s ) capacitor c=0.00651272f \
 //x=10.36 //y=2.085 //x2=9.375 //y2=0.37
cc_909 ( N_noxref_5_c_1262_n N_noxref_9_M5_noxref_s ) capacitor c=0.0153553f \
 //x=9.72 //y=0.91 //x2=9.375 //y2=0.37
cc_910 ( N_noxref_5_c_1264_n N_noxref_9_M5_noxref_s ) capacitor c=0.00629878f \
 //x=9.72 //y=1.255 //x2=9.375 //y2=0.37
cc_911 ( N_noxref_5_c_1273_n N_noxref_9_M5_noxref_s ) capacitor c=0.0052107f \
 //x=10.095 //y=0.755 //x2=9.375 //y2=0.37
cc_912 ( N_noxref_5_c_1278_n N_noxref_9_M5_noxref_s ) capacitor c=0.030052f \
 //x=10.25 //y=0.91 //x2=9.375 //y2=0.37
cc_913 ( N_noxref_5_c_1283_n N_noxref_9_M5_noxref_s ) capacitor c=0.002132f \
 //x=10.25 //y=1.565 //x2=9.375 //y2=0.37
cc_914 ( N_noxref_5_c_1284_n N_noxref_9_M5_noxref_s ) capacitor c=0.00304786f \
 //x=10.25 //y=1.92 //x2=9.375 //y2=0.37
cc_915 ( N_noxref_5_c_1285_n N_noxref_9_M5_noxref_s ) capacitor c=0.00659899f \
 //x=10.25 //y=2.085 //x2=9.375 //y2=0.37
cc_916 ( N_noxref_5_c_1119_n N_noxref_10_c_2032_n ) capacitor c=0.00888238f \
 //x=4.105 //y=1.565 //x2=3.885 //y2=1.5
cc_917 ( N_noxref_5_c_1111_n N_noxref_10_c_2039_n ) capacitor c=4.16328e-19 \
 //x=4.44 //y=2.085 //x2=4.77 //y2=0.535
cc_918 ( N_noxref_5_c_1114_n N_noxref_10_c_2039_n ) capacitor c=0.0204604f \
 //x=4.105 //y=0.91 //x2=4.77 //y2=0.535
cc_919 ( N_noxref_5_c_1122_n N_noxref_10_c_2039_n ) capacitor c=2.1838e-19 \
 //x=4.105 //y=1.92 //x2=4.77 //y2=0.535
cc_920 ( N_noxref_5_c_1125_n N_noxref_10_c_2039_n ) capacitor c=0.00825432f \
 //x=4.635 //y=0.91 //x2=4.77 //y2=0.535
cc_921 ( N_noxref_5_c_1114_n N_noxref_10_M1_noxref_s ) capacitor c=0.00888238f \
 //x=4.105 //y=0.91 //x2=2.78 //y2=0.37
cc_922 ( N_noxref_5_c_1125_n N_noxref_10_M1_noxref_s ) capacitor c=0.015333f \
 //x=4.635 //y=0.91 //x2=2.78 //y2=0.37
cc_923 ( N_noxref_5_c_1126_n N_noxref_10_M1_noxref_s ) capacitor c=0.00248746f \
 //x=4.635 //y=1.255 //x2=2.78 //y2=0.37
cc_924 ( N_noxref_5_c_1133_n N_noxref_11_M3_noxref_s ) capacitor c=6.41629e-19 \
 //x=9.27 //y=2.96 //x2=6.11 //y2=0.37
cc_925 ( N_noxref_6_c_1377_n N_noxref_7_c_1619_n ) capacitor c=0.0017521f \
 //x=3.365 //y=7.4 //x2=3.77 //y2=5.205
cc_926 ( N_noxref_6_c_1380_n N_noxref_7_c_1619_n ) capacitor c=0.00657392f \
 //x=3.45 //y=6.52 //x2=3.77 //y2=5.205
cc_927 ( N_noxref_6_c_1443_n N_noxref_7_c_1619_n ) capacitor c=5.36284e-19 \
 //x=6.695 //y=7.4 //x2=3.77 //y2=5.205
cc_928 ( N_noxref_6_c_1388_n N_noxref_7_c_1619_n ) capacitor c=0.00593768f \
 //x=5.38 //y=7.4 //x2=3.77 //y2=5.205
cc_929 ( N_noxref_6_M8_noxref_d N_noxref_7_c_1619_n ) capacitor c=0.00553895f \
 //x=3.305 //y=5.02 //x2=3.77 //y2=5.205
cc_930 ( N_noxref_6_c_1436_n N_noxref_7_c_1636_n ) capacitor c=0.00218824f \
 //x=10.36 //y=7.4 //x2=4.655 //y2=6.905
cc_931 ( N_noxref_6_c_1377_n N_noxref_7_c_1626_n ) capacitor c=4.40913e-19 \
 //x=3.365 //y=7.4 //x2=3.017 //y2=5.205
cc_932 ( N_noxref_6_c_1388_n N_noxref_7_c_1626_n ) capacitor c=2.3145e-19 \
 //x=5.38 //y=7.4 //x2=3.017 //y2=5.205
cc_933 ( N_noxref_6_c_1396_n N_noxref_7_c_1626_n ) capacitor c=0.00721415f \
 //x=2.22 //y=7.4 //x2=3.017 //y2=5.205
cc_934 ( N_noxref_6_M7_noxref_d N_noxref_7_c_1626_n ) capacitor c=0.0122414f \
 //x=1.41 //y=5.02 //x2=3.017 //y2=5.205
cc_935 ( N_noxref_6_c_1382_n N_noxref_7_c_1630_n ) capacitor c=0.0389154f \
 //x=3.45 //y=7.23 //x2=3.89 //y2=6.735
cc_936 ( N_noxref_6_c_1443_n N_noxref_7_c_1630_n ) capacitor c=0.0962448f \
 //x=6.695 //y=7.4 //x2=3.89 //y2=6.735
cc_937 ( N_noxref_6_c_1388_n N_noxref_7_c_1630_n ) capacitor c=0.0204097f \
 //x=5.38 //y=7.4 //x2=3.89 //y2=6.735
cc_938 ( N_noxref_6_c_1436_n N_noxref_7_c_1630_n ) capacitor c=0.0011052f \
 //x=10.36 //y=7.4 //x2=3.89 //y2=6.735
cc_939 ( N_noxref_6_c_1382_n N_noxref_7_c_1642_n ) capacitor c=0.00102965f \
 //x=3.45 //y=7.23 //x2=4.77 //y2=6.735
cc_940 ( N_noxref_6_c_1443_n N_noxref_7_c_1642_n ) capacitor c=0.00184044f \
 //x=6.695 //y=7.4 //x2=4.77 //y2=6.735
cc_941 ( N_noxref_6_c_1496_n N_noxref_7_c_1642_n ) capacitor c=0.002629f \
 //x=6.78 //y=7.23 //x2=4.77 //y2=6.735
cc_942 ( N_noxref_6_c_1388_n N_noxref_7_c_1642_n ) capacitor c=9.08172e-19 \
 //x=5.38 //y=7.4 //x2=4.77 //y2=6.735
cc_943 ( N_noxref_6_c_1433_n N_noxref_7_c_1642_n ) capacitor c=0.00746969f \
 //x=5.55 //y=7.4 //x2=4.77 //y2=6.735
cc_944 ( N_noxref_6_c_1436_n N_noxref_7_c_1642_n ) capacitor c=0.00110302f \
 //x=10.36 //y=7.4 //x2=4.77 //y2=6.735
cc_945 ( N_noxref_6_c_1377_n N_noxref_7_c_1631_n ) capacitor c=0.00209141f \
 //x=3.365 //y=7.4 //x2=3.01 //y2=5.375
cc_946 ( N_noxref_6_c_1380_n N_noxref_7_c_1631_n ) capacitor c=0.00716177f \
 //x=3.45 //y=6.52 //x2=3.01 //y2=5.375
cc_947 ( N_noxref_6_c_1382_n N_noxref_7_c_1631_n ) capacitor c=0.00218649f \
 //x=3.45 //y=7.23 //x2=3.01 //y2=5.375
cc_948 ( N_noxref_6_c_1388_n N_noxref_7_c_1631_n ) capacitor c=0.00845886f \
 //x=5.38 //y=7.4 //x2=3.01 //y2=5.375
cc_949 ( N_noxref_6_c_1396_n N_noxref_7_c_1631_n ) capacitor c=0.0523125f \
 //x=2.22 //y=7.4 //x2=3.01 //y2=5.375
cc_950 ( N_noxref_6_c_1436_n N_noxref_7_c_1631_n ) capacitor c=9.85326e-19 \
 //x=10.36 //y=7.4 //x2=3.01 //y2=5.375
cc_951 ( N_noxref_6_M7_noxref_d N_noxref_7_c_1631_n ) capacitor c=0.00276503f \
 //x=1.41 //y=5.02 //x2=3.01 //y2=5.375
cc_952 ( N_noxref_6_M8_noxref_d N_noxref_7_c_1631_n ) capacitor c=0.0478566f \
 //x=3.305 //y=5.02 //x2=3.01 //y2=5.375
cc_953 ( N_noxref_6_c_1380_n N_noxref_7_c_1633_n ) capacitor c=0.00626175f \
 //x=3.45 //y=6.52 //x2=3.89 //y2=5.375
cc_954 ( N_noxref_6_c_1382_n N_noxref_7_c_1633_n ) capacitor c=0.00311588f \
 //x=3.45 //y=7.23 //x2=3.89 //y2=5.375
cc_955 ( N_noxref_6_c_1443_n N_noxref_7_c_1633_n ) capacitor c=0.00203518f \
 //x=6.695 //y=7.4 //x2=3.89 //y2=5.375
cc_956 ( N_noxref_6_c_1388_n N_noxref_7_c_1633_n ) capacitor c=0.00843215f \
 //x=5.38 //y=7.4 //x2=3.89 //y2=5.375
cc_957 ( N_noxref_6_c_1436_n N_noxref_7_c_1633_n ) capacitor c=9.85326e-19 \
 //x=10.36 //y=7.4 //x2=3.89 //y2=5.375
cc_958 ( N_noxref_6_M8_noxref_d N_noxref_7_c_1633_n ) capacitor c=0.047843f \
 //x=3.305 //y=5.02 //x2=3.89 //y2=5.375
cc_959 ( N_noxref_6_c_1377_n N_noxref_7_M8_noxref_s ) capacitor c=0.0218047f \
 //x=3.365 //y=7.4 //x2=2.875 //y2=5.02
cc_960 ( N_noxref_6_c_1382_n N_noxref_7_M8_noxref_s ) capacitor c=0.0369805f \
 //x=3.45 //y=7.23 //x2=2.875 //y2=5.02
cc_961 ( N_noxref_6_c_1388_n N_noxref_7_M8_noxref_s ) capacitor c=0.00342594f \
 //x=5.38 //y=7.4 //x2=2.875 //y2=5.02
cc_962 ( N_noxref_6_c_1396_n N_noxref_7_M8_noxref_s ) capacitor c=0.00927581f \
 //x=2.22 //y=7.4 //x2=2.875 //y2=5.02
cc_963 ( N_noxref_6_c_1436_n N_noxref_7_M8_noxref_s ) capacitor c=8.52457e-19 \
 //x=10.36 //y=7.4 //x2=2.875 //y2=5.02
cc_964 ( N_noxref_6_c_1443_n N_noxref_7_M11_noxref_d ) capacitor c=0.00204666f \
 //x=6.695 //y=7.4 //x2=4.625 //y2=5.02
cc_965 ( N_noxref_6_c_1388_n N_noxref_7_M11_noxref_d ) capacitor c=0.00845514f \
 //x=5.38 //y=7.4 //x2=4.625 //y2=5.02
cc_966 ( N_noxref_6_c_1433_n N_noxref_7_M11_noxref_d ) capacitor c=0.0449172f \
 //x=5.55 //y=7.4 //x2=4.625 //y2=5.02
cc_967 ( N_noxref_6_c_1436_n N_noxref_7_M11_noxref_d ) capacitor c=9.81989e-19 \
 //x=10.36 //y=7.4 //x2=4.625 //y2=5.02
cc_968 ( N_noxref_6_c_1443_n N_noxref_8_c_1725_n ) capacitor c=5.95793e-19 \
 //x=6.695 //y=7.4 //x2=7.105 //y2=5.205
cc_969 ( N_noxref_6_c_1494_n N_noxref_8_c_1725_n ) capacitor c=0.00615258f \
 //x=6.78 //y=6.51 //x2=7.105 //y2=5.205
cc_970 ( N_noxref_6_c_1445_n N_noxref_8_c_1725_n ) capacitor c=0.00199018f \
 //x=10.36 //y=7.4 //x2=7.105 //y2=5.205
cc_971 ( N_noxref_6_c_1424_n N_noxref_8_c_1725_n ) capacitor c=0.00595347f \
 //x=8.71 //y=7.4 //x2=7.105 //y2=5.205
cc_972 ( N_noxref_6_M12_noxref_d N_noxref_8_c_1725_n ) capacitor c=0.00560574f \
 //x=6.635 //y=5.02 //x2=7.105 //y2=5.205
cc_973 ( N_noxref_6_c_1436_n N_noxref_8_c_1702_n ) capacitor c=0.00218824f \
 //x=10.36 //y=7.4 //x2=7.98 //y2=6.905
cc_974 ( N_noxref_6_c_1433_n N_noxref_8_c_1712_n ) capacitor c=0.00751288f \
 //x=5.55 //y=7.4 //x2=6.34 //y2=5.205
cc_975 ( N_noxref_6_M16_noxref_s N_noxref_8_c_1704_n ) capacitor c=7.50235e-19 \
 //x=9.42 //y=5.02 //x2=7.22 //y2=5.205
cc_976 ( N_noxref_6_c_1496_n N_noxref_8_c_1705_n ) capacitor c=0.0393574f \
 //x=6.78 //y=7.23 //x2=7.22 //y2=6.735
cc_977 ( N_noxref_6_c_1445_n N_noxref_8_c_1705_n ) capacitor c=0.0963472f \
 //x=10.36 //y=7.4 //x2=7.22 //y2=6.735
cc_978 ( N_noxref_6_c_1424_n N_noxref_8_c_1705_n ) capacitor c=0.0204015f \
 //x=8.71 //y=7.4 //x2=7.22 //y2=6.735
cc_979 ( N_noxref_6_c_1436_n N_noxref_8_c_1705_n ) capacitor c=0.0011052f \
 //x=10.36 //y=7.4 //x2=7.22 //y2=6.735
cc_980 ( N_noxref_6_c_1496_n N_noxref_8_c_1706_n ) capacitor c=0.00105525f \
 //x=6.78 //y=7.23 //x2=8.1 //y2=6.735
cc_981 ( N_noxref_6_c_1445_n N_noxref_8_c_1706_n ) capacitor c=0.00190896f \
 //x=10.36 //y=7.4 //x2=8.1 //y2=6.735
cc_982 ( N_noxref_6_c_1424_n N_noxref_8_c_1706_n ) capacitor c=5.93285e-19 \
 //x=8.71 //y=7.4 //x2=8.1 //y2=6.735
cc_983 ( N_noxref_6_c_1434_n N_noxref_8_c_1706_n ) capacitor c=0.0114198f \
 //x=8.88 //y=7.4 //x2=8.1 //y2=6.735
cc_984 ( N_noxref_6_c_1436_n N_noxref_8_c_1706_n ) capacitor c=0.00110321f \
 //x=10.36 //y=7.4 //x2=8.1 //y2=6.735
cc_985 ( N_noxref_6_c_1443_n N_noxref_8_c_1735_n ) capacitor c=0.00210328f \
 //x=6.695 //y=7.4 //x2=6.34 //y2=5.375
cc_986 ( N_noxref_6_c_1494_n N_noxref_8_c_1735_n ) capacitor c=0.00601924f \
 //x=6.78 //y=6.51 //x2=6.34 //y2=5.375
cc_987 ( N_noxref_6_c_1496_n N_noxref_8_c_1735_n ) capacitor c=0.00237006f \
 //x=6.78 //y=7.23 //x2=6.34 //y2=5.375
cc_988 ( N_noxref_6_c_1424_n N_noxref_8_c_1735_n ) capacitor c=0.00846521f \
 //x=8.71 //y=7.4 //x2=6.34 //y2=5.375
cc_989 ( N_noxref_6_c_1433_n N_noxref_8_c_1735_n ) capacitor c=0.0532223f \
 //x=5.55 //y=7.4 //x2=6.34 //y2=5.375
cc_990 ( N_noxref_6_c_1436_n N_noxref_8_c_1735_n ) capacitor c=9.85326e-19 \
 //x=10.36 //y=7.4 //x2=6.34 //y2=5.375
cc_991 ( N_noxref_6_M12_noxref_d N_noxref_8_c_1735_n ) capacitor c=0.0479465f \
 //x=6.635 //y=5.02 //x2=6.34 //y2=5.375
cc_992 ( N_noxref_6_c_1494_n N_noxref_8_c_1707_n ) capacitor c=0.00689217f \
 //x=6.78 //y=6.51 //x2=7.22 //y2=5.375
cc_993 ( N_noxref_6_c_1496_n N_noxref_8_c_1707_n ) capacitor c=0.00366379f \
 //x=6.78 //y=7.23 //x2=7.22 //y2=5.375
cc_994 ( N_noxref_6_c_1445_n N_noxref_8_c_1707_n ) capacitor c=0.00203518f \
 //x=10.36 //y=7.4 //x2=7.22 //y2=5.375
cc_995 ( N_noxref_6_c_1424_n N_noxref_8_c_1707_n ) capacitor c=0.00843215f \
 //x=8.71 //y=7.4 //x2=7.22 //y2=5.375
cc_996 ( N_noxref_6_c_1436_n N_noxref_8_c_1707_n ) capacitor c=9.85326e-19 \
 //x=10.36 //y=7.4 //x2=7.22 //y2=5.375
cc_997 ( N_noxref_6_M12_noxref_d N_noxref_8_c_1707_n ) capacitor c=0.0478672f \
 //x=6.635 //y=5.02 //x2=7.22 //y2=5.375
cc_998 ( N_noxref_6_c_1382_n N_noxref_8_M12_noxref_s ) capacitor c=4.52323e-19 \
 //x=3.45 //y=7.23 //x2=6.205 //y2=5.02
cc_999 ( N_noxref_6_c_1443_n N_noxref_8_M12_noxref_s ) capacitor c=0.0216206f \
 //x=6.695 //y=7.4 //x2=6.205 //y2=5.02
cc_1000 ( N_noxref_6_c_1496_n N_noxref_8_M12_noxref_s ) capacitor c=0.0339466f \
 //x=6.78 //y=7.23 //x2=6.205 //y2=5.02
cc_1001 ( N_noxref_6_c_1424_n N_noxref_8_M12_noxref_s ) capacitor \
 c=0.00371051f //x=8.71 //y=7.4 //x2=6.205 //y2=5.02
cc_1002 ( N_noxref_6_c_1433_n N_noxref_8_M12_noxref_s ) capacitor \
 c=0.00541973f //x=5.55 //y=7.4 //x2=6.205 //y2=5.02
cc_1003 ( N_noxref_6_c_1436_n N_noxref_8_M12_noxref_s ) capacitor \
 c=8.06314e-19 //x=10.36 //y=7.4 //x2=6.205 //y2=5.02
cc_1004 ( N_noxref_6_c_1445_n N_noxref_8_M15_noxref_d ) capacitor \
 c=0.00204666f //x=10.36 //y=7.4 //x2=7.955 //y2=5.02
cc_1005 ( N_noxref_6_c_1424_n N_noxref_8_M15_noxref_d ) capacitor \
 c=0.00845514f //x=8.71 //y=7.4 //x2=7.955 //y2=5.02
cc_1006 ( N_noxref_6_c_1434_n N_noxref_8_M15_noxref_d ) capacitor c=0.0442402f \
 //x=8.88 //y=7.4 //x2=7.955 //y2=5.02
cc_1007 ( N_noxref_6_c_1436_n N_noxref_8_M15_noxref_d ) capacitor \
 c=9.81989e-19 //x=10.36 //y=7.4 //x2=7.955 //y2=5.02
cc_1008 ( N_noxref_6_M16_noxref_s N_noxref_8_M15_noxref_d ) capacitor \
 c=0.00279822f //x=9.42 //y=5.02 //x2=7.955 //y2=5.02
cc_1009 ( N_noxref_6_c_1390_n N_noxref_9_c_1802_n ) capacitor c=0.00989031f \
 //x=0.74 //y=7.4 //x2=0.63 //y2=0
cc_1010 ( N_noxref_6_c_1396_n N_noxref_9_c_1807_n ) capacitor c=0.00680476f \
 //x=2.22 //y=7.4 //x2=2.22 //y2=0
cc_1011 ( N_noxref_6_c_1433_n N_noxref_9_c_1851_n ) capacitor c=0.00647703f \
 //x=5.55 //y=7.4 //x2=5.55 //y2=0
cc_1012 ( N_noxref_6_c_1434_n N_noxref_9_c_1853_n ) capacitor c=0.00650206f \
 //x=8.88 //y=7.4 //x2=8.88 //y2=0
cc_1013 ( N_noxref_6_c_1436_n N_noxref_9_c_1857_n ) capacitor c=0.00989031f \
 //x=10.36 //y=7.4 //x2=10.47 //y2=0
cc_1014 ( N_noxref_7_c_1629_n N_noxref_8_c_1712_n ) capacitor c=0.00119247f \
 //x=3.89 //y=5.205 //x2=6.34 //y2=5.205
cc_1015 ( N_noxref_7_c_1642_n N_noxref_8_c_1705_n ) capacitor c=5.03119e-19 \
 //x=4.77 //y=6.735 //x2=7.22 //y2=6.735
cc_1016 ( N_noxref_7_M11_noxref_d N_noxref_8_c_1735_n ) capacitor \
 c=0.00208849f //x=4.625 //y=5.02 //x2=6.34 //y2=5.375
cc_1017 ( N_noxref_7_c_1642_n N_noxref_8_M12_noxref_s ) capacitor c=0.0112164f \
 //x=4.77 //y=6.735 //x2=6.205 //y2=5.02
cc_1018 ( N_noxref_7_c_1619_n N_noxref_9_c_1788_n ) capacitor c=2.88015e-19 \
 //x=3.77 //y=5.205 //x2=3.4 //y2=0.845
cc_1019 ( N_noxref_9_M0_noxref_s N_noxref_10_c_2024_n ) capacitor \
 c=0.00297957f //x=0.495 //y=0.37 //x2=2.915 //y2=1.5
cc_1020 ( N_noxref_9_c_1783_n N_noxref_10_c_2025_n ) capacitor c=0.00252046f \
 //x=3.315 //y=0 //x2=3.8 //y2=1.585
cc_1021 ( N_noxref_9_c_1788_n N_noxref_10_c_2025_n ) capacitor c=0.00329816f \
 //x=3.4 //y=0.845 //x2=3.8 //y2=1.585
cc_1022 ( N_noxref_9_c_1867_n N_noxref_10_c_2025_n ) capacitor c=7.42937e-19 \
 //x=6.645 //y=0 //x2=3.8 //y2=1.585
cc_1023 ( N_noxref_9_c_1801_n N_noxref_10_c_2025_n ) capacitor c=0.00375915f \
 //x=5.38 //y=0 //x2=3.8 //y2=1.585
cc_1024 ( N_noxref_9_M1_noxref_d N_noxref_10_c_2025_n ) capacitor \
 c=0.00578453f //x=3.21 //y=0.87 //x2=3.8 //y2=1.585
cc_1025 ( N_noxref_9_c_1788_n N_noxref_10_c_2063_n ) capacitor c=0.0120153f \
 //x=3.4 //y=0.845 //x2=3.885 //y2=0.62
cc_1026 ( N_noxref_9_c_1867_n N_noxref_10_c_2063_n ) capacitor c=0.00716432f \
 //x=6.645 //y=0 //x2=3.885 //y2=0.62
cc_1027 ( N_noxref_9_c_1801_n N_noxref_10_c_2063_n ) capacitor c=0.0143129f \
 //x=5.38 //y=0 //x2=3.885 //y2=0.62
cc_1028 ( N_noxref_9_c_1807_n N_noxref_10_c_2063_n ) capacitor c=0.00282499f \
 //x=2.22 //y=0 //x2=3.885 //y2=0.62
cc_1029 ( N_noxref_9_c_1851_n N_noxref_10_c_2063_n ) capacitor c=2.99356e-19 \
 //x=5.55 //y=0 //x2=3.885 //y2=0.62
cc_1030 ( N_noxref_9_c_1857_n N_noxref_10_c_2063_n ) capacitor c=0.00141889f \
 //x=10.47 //y=0 //x2=3.885 //y2=0.62
cc_1031 ( N_noxref_9_c_1807_n N_noxref_10_c_2032_n ) capacitor c=2.8481e-19 \
 //x=2.22 //y=0 //x2=3.885 //y2=1.5
cc_1032 ( N_noxref_9_c_1867_n N_noxref_10_c_2039_n ) capacitor c=0.0122844f \
 //x=6.645 //y=0 //x2=4.77 //y2=0.535
cc_1033 ( N_noxref_9_c_1801_n N_noxref_10_c_2039_n ) capacitor c=0.0368282f \
 //x=5.38 //y=0 //x2=4.77 //y2=0.535
cc_1034 ( N_noxref_9_c_1857_n N_noxref_10_c_2039_n ) capacitor c=0.00194827f \
 //x=10.47 //y=0 //x2=4.77 //y2=0.535
cc_1035 ( N_noxref_9_c_1867_n N_noxref_10_c_2073_n ) capacitor c=0.00234309f \
 //x=6.645 //y=0 //x2=4.855 //y2=0.62
cc_1036 ( N_noxref_9_c_1801_n N_noxref_10_c_2073_n ) capacitor c=0.0141474f \
 //x=5.38 //y=0 //x2=4.855 //y2=0.62
cc_1037 ( N_noxref_9_c_1851_n N_noxref_10_c_2073_n ) capacitor c=0.0392084f \
 //x=5.55 //y=0 //x2=4.855 //y2=0.62
cc_1038 ( N_noxref_9_c_1857_n N_noxref_10_c_2073_n ) capacitor c=0.00141054f \
 //x=10.47 //y=0 //x2=4.855 //y2=0.62
cc_1039 ( N_noxref_9_c_1783_n N_noxref_10_M1_noxref_s ) capacitor \
 c=0.00716432f //x=3.315 //y=0 //x2=2.78 //y2=0.37
cc_1040 ( N_noxref_9_c_1788_n N_noxref_10_M1_noxref_s ) capacitor c=0.0262211f \
 //x=3.4 //y=0.845 //x2=2.78 //y2=0.37
cc_1041 ( N_noxref_9_c_1990_p N_noxref_10_M1_noxref_s ) capacitor \
 c=0.00297957f //x=1.6 //y=0.45 //x2=2.78 //y2=0.37
cc_1042 ( N_noxref_9_c_1801_n N_noxref_10_M1_noxref_s ) capacitor c=0.0143129f \
 //x=5.38 //y=0 //x2=2.78 //y2=0.37
cc_1043 ( N_noxref_9_c_1807_n N_noxref_10_M1_noxref_s ) capacitor c=0.0528189f \
 //x=2.22 //y=0 //x2=2.78 //y2=0.37
cc_1044 ( N_noxref_9_c_1851_n N_noxref_10_M1_noxref_s ) capacitor \
 c=0.00645748f //x=5.55 //y=0 //x2=2.78 //y2=0.37
cc_1045 ( N_noxref_9_c_1857_n N_noxref_10_M1_noxref_s ) capacitor \
 c=0.00141889f //x=10.47 //y=0 //x2=2.78 //y2=0.37
cc_1046 ( N_noxref_9_M1_noxref_d N_noxref_10_M1_noxref_s ) capacitor \
 c=0.0271984f //x=3.21 //y=0.87 //x2=2.78 //y2=0.37
cc_1047 ( N_noxref_9_c_1867_n N_noxref_11_c_2089_n ) capacitor c=0.00113462f \
 //x=6.645 //y=0 //x2=7.13 //y2=1.585
cc_1048 ( N_noxref_9_c_1838_n N_noxref_11_c_2089_n ) capacitor c=0.00300732f \
 //x=6.73 //y=0.845 //x2=7.13 //y2=1.585
cc_1049 ( N_noxref_9_c_1839_n N_noxref_11_c_2089_n ) capacitor c=0.00192868f \
 //x=10.36 //y=0 //x2=7.13 //y2=1.585
cc_1050 ( N_noxref_9_c_1878_n N_noxref_11_c_2089_n ) capacitor c=0.00388445f \
 //x=8.71 //y=0 //x2=7.13 //y2=1.585
cc_1051 ( N_noxref_9_M3_noxref_d N_noxref_11_c_2089_n ) capacitor \
 c=0.00578453f //x=6.54 //y=0.87 //x2=7.13 //y2=1.585
cc_1052 ( N_noxref_9_c_1838_n N_noxref_11_c_2129_n ) capacitor c=0.0167642f \
 //x=6.73 //y=0.845 //x2=7.215 //y2=0.62
cc_1053 ( N_noxref_9_c_1839_n N_noxref_11_c_2129_n ) capacitor c=0.00716432f \
 //x=10.36 //y=0 //x2=7.215 //y2=0.62
cc_1054 ( N_noxref_9_c_1878_n N_noxref_11_c_2129_n ) capacitor c=0.0143129f \
 //x=8.71 //y=0 //x2=7.215 //y2=0.62
cc_1055 ( N_noxref_9_c_1851_n N_noxref_11_c_2129_n ) capacitor c=0.00282553f \
 //x=5.55 //y=0 //x2=7.215 //y2=0.62
cc_1056 ( N_noxref_9_c_1853_n N_noxref_11_c_2129_n ) capacitor c=2.21767e-19 \
 //x=8.88 //y=0 //x2=7.215 //y2=0.62
cc_1057 ( N_noxref_9_c_1857_n N_noxref_11_c_2129_n ) capacitor c=0.00141889f \
 //x=10.47 //y=0 //x2=7.215 //y2=0.62
cc_1058 ( N_noxref_9_c_1851_n N_noxref_11_c_2090_n ) capacitor c=2.83682e-19 \
 //x=5.55 //y=0 //x2=7.215 //y2=1.5
cc_1059 ( N_noxref_9_c_1839_n N_noxref_11_c_2092_n ) capacitor c=0.0115867f \
 //x=10.36 //y=0 //x2=8.1 //y2=0.535
cc_1060 ( N_noxref_9_c_1878_n N_noxref_11_c_2092_n ) capacitor c=0.0368282f \
 //x=8.71 //y=0 //x2=8.1 //y2=0.535
cc_1061 ( N_noxref_9_c_1857_n N_noxref_11_c_2092_n ) capacitor c=0.00194827f \
 //x=10.47 //y=0 //x2=8.1 //y2=0.535
cc_1062 ( N_noxref_9_c_1839_n N_noxref_11_c_2139_n ) capacitor c=0.00251273f \
 //x=10.36 //y=0 //x2=8.185 //y2=0.62
cc_1063 ( N_noxref_9_c_1878_n N_noxref_11_c_2139_n ) capacitor c=0.0141611f \
 //x=8.71 //y=0 //x2=8.185 //y2=0.62
cc_1064 ( N_noxref_9_c_2013_p N_noxref_11_c_2139_n ) capacitor c=0.00212205f \
 //x=9.5 //y=0.45 //x2=8.185 //y2=0.62
cc_1065 ( N_noxref_9_c_1853_n N_noxref_11_c_2139_n ) capacitor c=0.0402f \
 //x=8.88 //y=0 //x2=8.185 //y2=0.62
cc_1066 ( N_noxref_9_c_1857_n N_noxref_11_c_2139_n ) capacitor c=0.00141054f \
 //x=10.47 //y=0 //x2=8.185 //y2=0.62
cc_1067 ( N_noxref_9_c_1867_n N_noxref_11_M3_noxref_s ) capacitor \
 c=0.00716432f //x=6.645 //y=0 //x2=6.11 //y2=0.37
cc_1068 ( N_noxref_9_c_1838_n N_noxref_11_M3_noxref_s ) capacitor c=0.02175f \
 //x=6.73 //y=0.845 //x2=6.11 //y2=0.37
cc_1069 ( N_noxref_9_c_1878_n N_noxref_11_M3_noxref_s ) capacitor c=0.0143129f \
 //x=8.71 //y=0 //x2=6.11 //y2=0.37
cc_1070 ( N_noxref_9_c_1851_n N_noxref_11_M3_noxref_s ) capacitor c=0.0518398f \
 //x=5.55 //y=0 //x2=6.11 //y2=0.37
cc_1071 ( N_noxref_9_c_1853_n N_noxref_11_M3_noxref_s ) capacitor \
 c=0.00642631f //x=8.88 //y=0 //x2=6.11 //y2=0.37
cc_1072 ( N_noxref_9_c_1857_n N_noxref_11_M3_noxref_s ) capacitor \
 c=0.00141889f //x=10.47 //y=0 //x2=6.11 //y2=0.37
cc_1073 ( N_noxref_9_M3_noxref_d N_noxref_11_M3_noxref_s ) capacitor \
 c=0.0272028f //x=6.54 //y=0.87 //x2=6.11 //y2=0.37
cc_1074 ( N_noxref_9_M5_noxref_s N_noxref_11_M3_noxref_s ) capacitor \
 c=0.0032083f //x=9.375 //y=0.37 //x2=6.11 //y2=0.37
cc_1075 ( N_noxref_10_c_2032_n N_noxref_11_c_2088_n ) capacitor c=5.32163e-19 \
 //x=3.885 //y=1.5 //x2=6.245 //y2=1.5
cc_1076 ( N_noxref_10_c_2073_n N_noxref_11_M3_noxref_s ) capacitor \
 c=0.00453341f //x=4.855 //y=0.62 //x2=6.11 //y2=0.37
cc_1077 ( N_noxref_10_M1_noxref_s N_noxref_11_M3_noxref_s ) capacitor \
 c=5.32163e-19 //x=2.78 //y=0.37 //x2=6.11 //y2=0.37
