// File: DFFRNQX1.spi.pex
// Created: Tue Apr 29 10:40:01 2025
// Program "Calibre xRC"
// Version "v2023.2_27.15"
// Nominal Temperature: 30C
// Circuit Temperature: 30C
//
simulator lang=spectre
subckt PM_DFFRNQX1\%VDD ( 1 47 54 61 71 79 89 95 105 115 123 133 139 147 155 \
 165 171 179 187 197 207 213 221 229 239 249 255 263 273 286 295 300 305 311 \
 317 322 323 324 325 326 327 328 329 330 331 332 333 334 335 336 337 338 339 \
 340 341 342 343 )
c331 ( 343 0 ) capacitor c=0.0382077f //x=25.41 //y=5.2
c332 ( 342 0 ) capacitor c=0.0240874f //x=24.53 //y=5.2
c333 ( 341 0 ) capacitor c=0.0495447f //x=23.66 //y=5.2
c334 ( 340 0 ) capacitor c=0.045306f //x=21.78 //y=5.2
c335 ( 339 0 ) capacitor c=0.0242401f //x=20.9 //y=5.2
c336 ( 338 0 ) capacitor c=0.0242401f //x=20.02 //y=5.2
c337 ( 337 0 ) capacitor c=0.0531794f //x=19.15 //y=5.2
c338 ( 336 0 ) capacitor c=0.045306f //x=16.97 //y=5.2
c339 ( 335 0 ) capacitor c=0.0242401f //x=16.09 //y=5.2
c340 ( 334 0 ) capacitor c=0.0241521f //x=15.21 //y=5.2
c341 ( 333 0 ) capacitor c=0.0531894f //x=14.34 //y=5.2
c342 ( 332 0 ) capacitor c=0.038068f //x=12.46 //y=5.2
c343 ( 331 0 ) capacitor c=0.0240081f //x=11.58 //y=5.2
c344 ( 330 0 ) capacitor c=0.0492093f //x=10.71 //y=5.2
c345 ( 329 0 ) capacitor c=0.045218f //x=8.83 //y=5.2
c346 ( 328 0 ) capacitor c=0.0241521f //x=7.95 //y=5.2
c347 ( 327 0 ) capacitor c=0.0241521f //x=7.07 //y=5.2
c348 ( 326 0 ) capacitor c=0.053132f //x=6.2 //y=5.2
c349 ( 325 0 ) capacitor c=0.045218f //x=4.02 //y=5.2
c350 ( 324 0 ) capacitor c=0.0241521f //x=3.14 //y=5.2
c351 ( 323 0 ) capacitor c=0.0242401f //x=2.26 //y=5.2
c352 ( 322 0 ) capacitor c=0.0531407f //x=1.39 //y=5.2
c353 ( 320 0 ) capacitor c=0.00597439f //x=25.555 //y=7.585
c354 ( 319 0 ) capacitor c=0.00597439f //x=24.675 //y=7.585
c355 ( 318 0 ) capacitor c=0.00597439f //x=23.795 //y=7.585
c356 ( 317 0 ) capacitor c=0.136875f //x=23.005 //y=7.585
c357 ( 316 0 ) capacitor c=0.00597439f //x=21.925 //y=7.585
c358 ( 315 0 ) capacitor c=0.00597439f //x=21.045 //y=7.585
c359 ( 314 0 ) capacitor c=0.00597439f //x=20.165 //y=7.585
c360 ( 313 0 ) capacitor c=0.00597439f //x=19.305 //y=7.58
c361 ( 311 0 ) capacitor c=0.157264f //x=18.195 //y=7.585
c362 ( 310 0 ) capacitor c=0.00597439f //x=17.115 //y=7.585
c363 ( 309 0 ) capacitor c=0.00597439f //x=16.235 //y=7.585
c364 ( 308 0 ) capacitor c=0.00597439f //x=15.355 //y=7.585
c365 ( 307 0 ) capacitor c=0.00597439f //x=14.495 //y=7.58
c366 ( 305 0 ) capacitor c=0.135162f //x=13.385 //y=7.585
c367 ( 304 0 ) capacitor c=0.00597439f //x=12.605 //y=7.585
c368 ( 303 0 ) capacitor c=0.00597439f //x=11.725 //y=7.585
c369 ( 302 0 ) capacitor c=0.00597439f //x=10.795 //y=7.58
c370 ( 300 0 ) capacitor c=0.134682f //x=10.055 //y=7.585
c371 ( 299 0 ) capacitor c=0.00597439f //x=8.975 //y=7.585
c372 ( 298 0 ) capacitor c=0.00597439f //x=8.095 //y=7.585
c373 ( 297 0 ) capacitor c=0.00597439f //x=7.215 //y=7.585
c374 ( 296 0 ) capacitor c=0.00597439f //x=6.335 //y=7.585
c375 ( 295 0 ) capacitor c=0.155314f //x=5.245 //y=7.585
c376 ( 294 0 ) capacitor c=0.00597439f //x=4.165 //y=7.585
c377 ( 293 0 ) capacitor c=0.00597439f //x=3.285 //y=7.585
c378 ( 292 0 ) capacitor c=0.00597439f //x=2.405 //y=7.585
c379 ( 291 0 ) capacitor c=0.00597439f //x=1.525 //y=7.585
c380 ( 286 0 ) capacitor c=0.259038f //x=25.965 //y=7.58
c381 ( 273 0 ) capacitor c=0.028702f //x=25.47 //y=7.585
c382 ( 263 0 ) capacitor c=0.0291291f //x=24.59 //y=7.585
c383 ( 255 0 ) capacitor c=0.024303f //x=23.71 //y=7.585
c384 ( 249 0 ) capacitor c=0.0398302f //x=22.835 //y=7.585
c385 ( 239 0 ) capacitor c=0.0291418f //x=21.84 //y=7.585
c386 ( 229 0 ) capacitor c=0.0292658f //x=20.96 //y=7.585
c387 ( 221 0 ) capacitor c=0.0287792f //x=20.08 //y=7.585
c388 ( 213 0 ) capacitor c=0.0386886f //x=19.2 //y=7.585
c389 ( 207 0 ) capacitor c=0.0398272f //x=18.025 //y=7.585
c390 ( 197 0 ) capacitor c=0.0291418f //x=17.03 //y=7.585
c391 ( 187 0 ) capacitor c=0.029147f //x=16.15 //y=7.585
c392 ( 179 0 ) capacitor c=0.0287649f //x=15.27 //y=7.585
c393 ( 171 0 ) capacitor c=0.0386886f //x=14.39 //y=7.585
c394 ( 165 0 ) capacitor c=0.0238235f //x=13.215 //y=7.585
c395 ( 155 0 ) capacitor c=0.0291008f //x=12.52 //y=7.585
c396 ( 147 0 ) capacitor c=0.0291028f //x=11.64 //y=7.585
c397 ( 139 0 ) capacitor c=0.024303f //x=10.76 //y=7.585
c398 ( 133 0 ) capacitor c=0.0397734f //x=9.885 //y=7.585
c399 ( 123 0 ) capacitor c=0.0291138f //x=8.89 //y=7.585
c400 ( 115 0 ) capacitor c=0.0290172f //x=8.01 //y=7.585
c401 ( 105 0 ) capacitor c=0.0287649f //x=7.13 //y=7.585
c402 ( 95 0 ) capacitor c=0.0386886f //x=6.25 //y=7.585
c403 ( 89 0 ) capacitor c=0.0397734f //x=5.075 //y=7.585
c404 ( 79 0 ) capacitor c=0.0291138f //x=4.08 //y=7.585
c405 ( 71 0 ) capacitor c=0.0291349f //x=3.2 //y=7.585
c406 ( 61 0 ) capacitor c=0.0287792f //x=2.32 //y=7.585
c407 ( 54 0 ) capacitor c=0.249947f //x=1.175 //y=7.58
c408 ( 51 0 ) capacitor c=0.0455283f //x=1.44 //y=7.585
c409 ( 47 0 ) capacitor c=0.936789f //x=25.965 //y=7.58
r410 (  284 320 ) resistor r=2.87058 //w=0.35 //l=0.085 //layer=li \
 //thickness=0.1 //x=25.64 //y=7.585 //x2=25.555 //y2=7.585
r411 (  284 286 ) resistor r=11.3351 //w=0.367 //l=0.325 //layer=li \
 //thickness=0.1 //x=25.64 //y=7.585 //x2=25.965 //y2=7.585
r412 (  277 320 ) resistor r=4.23183 //w=0.7 //l=0.175 //layer=li \
 //thickness=0.1 //x=25.555 //y=7.41 //x2=25.555 //y2=7.585
r413 (  277 343 ) resistor r=33.1979 //w=0.187 //l=0.485 //layer=li \
 //thickness=0.1 //x=25.555 //y=7.41 //x2=25.555 //y2=6.925
r414 (  274 319 ) resistor r=2.87058 //w=0.35 //l=0.085 //layer=li \
 //thickness=0.1 //x=24.76 //y=7.585 //x2=24.675 //y2=7.585
r415 (  274 276 ) resistor r=16.218 //w=0.367 //l=0.465 //layer=li \
 //thickness=0.1 //x=24.76 //y=7.585 //x2=25.225 //y2=7.585
r416 (  273 320 ) resistor r=2.87058 //w=0.35 //l=0.085 //layer=li \
 //thickness=0.1 //x=25.47 //y=7.585 //x2=25.555 //y2=7.585
r417 (  273 276 ) resistor r=8.54496 //w=0.367 //l=0.245 //layer=li \
 //thickness=0.1 //x=25.47 //y=7.585 //x2=25.225 //y2=7.585
r418 (  267 319 ) resistor r=4.23183 //w=0.7 //l=0.175 //layer=li \
 //thickness=0.1 //x=24.675 //y=7.41 //x2=24.675 //y2=7.585
r419 (  267 342 ) resistor r=33.1979 //w=0.187 //l=0.485 //layer=li \
 //thickness=0.1 //x=24.675 //y=7.41 //x2=24.675 //y2=6.925
r420 (  264 318 ) resistor r=2.87058 //w=0.35 //l=0.085 //layer=li \
 //thickness=0.1 //x=23.88 //y=7.585 //x2=23.795 //y2=7.585
r421 (  264 266 ) resistor r=8.19619 //w=0.367 //l=0.235 //layer=li \
 //thickness=0.1 //x=23.88 //y=7.585 //x2=24.115 //y2=7.585
r422 (  263 319 ) resistor r=2.87058 //w=0.35 //l=0.085 //layer=li \
 //thickness=0.1 //x=24.59 //y=7.585 //x2=24.675 //y2=7.585
r423 (  263 266 ) resistor r=16.5668 //w=0.367 //l=0.475 //layer=li \
 //thickness=0.1 //x=24.59 //y=7.585 //x2=24.115 //y2=7.585
r424 (  257 318 ) resistor r=4.23183 //w=0.7 //l=0.175 //layer=li \
 //thickness=0.1 //x=23.795 //y=7.41 //x2=23.795 //y2=7.585
r425 (  257 341 ) resistor r=56.4706 //w=0.187 //l=0.825 //layer=li \
 //thickness=0.1 //x=23.795 //y=7.41 //x2=23.795 //y2=6.585
r426 (  256 317 ) resistor r=5.29055 //w=0.35 //l=0.17 //layer=li \
 //thickness=0.1 //x=23.175 //y=7.585 //x2=23.005 //y2=7.585
r427 (  255 318 ) resistor r=2.87058 //w=0.35 //l=0.085 //layer=li \
 //thickness=0.1 //x=23.71 //y=7.585 //x2=23.795 //y2=7.585
r428 (  255 256 ) resistor r=18.6594 //w=0.367 //l=0.535 //layer=li \
 //thickness=0.1 //x=23.71 //y=7.585 //x2=23.175 //y2=7.585
r429 (  250 316 ) resistor r=2.87058 //w=0.35 //l=0.085 //layer=li \
 //thickness=0.1 //x=22.01 //y=7.585 //x2=21.925 //y2=7.585
r430 (  250 252 ) resistor r=21.7984 //w=0.367 //l=0.625 //layer=li \
 //thickness=0.1 //x=22.01 //y=7.585 //x2=22.635 //y2=7.585
r431 (  249 317 ) resistor r=5.29055 //w=0.35 //l=0.17 //layer=li \
 //thickness=0.1 //x=22.835 //y=7.585 //x2=23.005 //y2=7.585
r432 (  249 252 ) resistor r=6.97548 //w=0.367 //l=0.2 //layer=li \
 //thickness=0.1 //x=22.835 //y=7.585 //x2=22.635 //y2=7.585
r433 (  243 316 ) resistor r=4.23183 //w=0.7 //l=0.175 //layer=li \
 //thickness=0.1 //x=21.925 //y=7.41 //x2=21.925 //y2=7.585
r434 (  243 340 ) resistor r=33.1979 //w=0.187 //l=0.485 //layer=li \
 //thickness=0.1 //x=21.925 //y=7.41 //x2=21.925 //y2=6.925
r435 (  240 315 ) resistor r=2.87058 //w=0.35 //l=0.085 //layer=li \
 //thickness=0.1 //x=21.13 //y=7.585 //x2=21.045 //y2=7.585
r436 (  240 242 ) resistor r=13.7766 //w=0.367 //l=0.395 //layer=li \
 //thickness=0.1 //x=21.13 //y=7.585 //x2=21.525 //y2=7.585
r437 (  239 316 ) resistor r=2.87058 //w=0.35 //l=0.085 //layer=li \
 //thickness=0.1 //x=21.84 //y=7.585 //x2=21.925 //y2=7.585
r438 (  239 242 ) resistor r=10.9864 //w=0.367 //l=0.315 //layer=li \
 //thickness=0.1 //x=21.84 //y=7.585 //x2=21.525 //y2=7.585
r439 (  233 315 ) resistor r=4.23183 //w=0.7 //l=0.175 //layer=li \
 //thickness=0.1 //x=21.045 //y=7.41 //x2=21.045 //y2=7.585
r440 (  233 339 ) resistor r=33.1979 //w=0.187 //l=0.485 //layer=li \
 //thickness=0.1 //x=21.045 //y=7.41 //x2=21.045 //y2=6.925
r441 (  230 314 ) resistor r=2.87058 //w=0.35 //l=0.085 //layer=li \
 //thickness=0.1 //x=20.25 //y=7.585 //x2=20.165 //y2=7.585
r442 (  230 232 ) resistor r=5.75477 //w=0.367 //l=0.165 //layer=li \
 //thickness=0.1 //x=20.25 //y=7.585 //x2=20.415 //y2=7.585
r443 (  229 315 ) resistor r=2.87058 //w=0.35 //l=0.085 //layer=li \
 //thickness=0.1 //x=20.96 //y=7.585 //x2=21.045 //y2=7.585
r444 (  229 232 ) resistor r=19.0082 //w=0.367 //l=0.545 //layer=li \
 //thickness=0.1 //x=20.96 //y=7.585 //x2=20.415 //y2=7.585
r445 (  223 314 ) resistor r=4.23183 //w=0.7 //l=0.175 //layer=li \
 //thickness=0.1 //x=20.165 //y=7.41 //x2=20.165 //y2=7.585
r446 (  223 338 ) resistor r=33.1979 //w=0.187 //l=0.485 //layer=li \
 //thickness=0.1 //x=20.165 //y=7.41 //x2=20.165 //y2=6.925
r447 (  222 313 ) resistor r=2.87058 //w=0.35 //l=0.085 //layer=li \
 //thickness=0.1 //x=19.37 //y=7.585 //x2=19.285 //y2=7.585
r448 (  221 314 ) resistor r=2.87058 //w=0.35 //l=0.085 //layer=li \
 //thickness=0.1 //x=20.08 //y=7.585 //x2=20.165 //y2=7.585
r449 (  221 222 ) resistor r=24.7629 //w=0.367 //l=0.71 //layer=li \
 //thickness=0.1 //x=20.08 //y=7.585 //x2=19.37 //y2=7.585
r450 (  215 313 ) resistor r=4.23183 //w=0.7 //l=0.175 //layer=li \
 //thickness=0.1 //x=19.285 //y=7.41 //x2=19.285 //y2=7.585
r451 (  215 337 ) resistor r=56.4706 //w=0.187 //l=0.825 //layer=li \
 //thickness=0.1 //x=19.285 //y=7.41 //x2=19.285 //y2=6.585
r452 (  214 311 ) resistor r=5.29055 //w=0.35 //l=0.17 //layer=li \
 //thickness=0.1 //x=18.365 //y=7.585 //x2=18.195 //y2=7.585
r453 (  213 313 ) resistor r=2.87058 //w=0.35 //l=0.085 //layer=li \
 //thickness=0.1 //x=19.2 //y=7.585 //x2=19.285 //y2=7.585
r454 (  213 214 ) resistor r=29.1226 //w=0.367 //l=0.835 //layer=li \
 //thickness=0.1 //x=19.2 //y=7.585 //x2=18.365 //y2=7.585
r455 (  208 310 ) resistor r=2.87058 //w=0.35 //l=0.085 //layer=li \
 //thickness=0.1 //x=17.2 //y=7.585 //x2=17.115 //y2=7.585
r456 (  208 210 ) resistor r=21.7984 //w=0.367 //l=0.625 //layer=li \
 //thickness=0.1 //x=17.2 //y=7.585 //x2=17.825 //y2=7.585
r457 (  207 311 ) resistor r=5.29055 //w=0.35 //l=0.17 //layer=li \
 //thickness=0.1 //x=18.025 //y=7.585 //x2=18.195 //y2=7.585
r458 (  207 210 ) resistor r=6.97548 //w=0.367 //l=0.2 //layer=li \
 //thickness=0.1 //x=18.025 //y=7.585 //x2=17.825 //y2=7.585
r459 (  201 310 ) resistor r=4.23183 //w=0.7 //l=0.175 //layer=li \
 //thickness=0.1 //x=17.115 //y=7.41 //x2=17.115 //y2=7.585
r460 (  201 336 ) resistor r=33.1979 //w=0.187 //l=0.485 //layer=li \
 //thickness=0.1 //x=17.115 //y=7.41 //x2=17.115 //y2=6.925
r461 (  198 309 ) resistor r=2.87058 //w=0.35 //l=0.085 //layer=li \
 //thickness=0.1 //x=16.32 //y=7.585 //x2=16.235 //y2=7.585
r462 (  198 200 ) resistor r=13.7766 //w=0.367 //l=0.395 //layer=li \
 //thickness=0.1 //x=16.32 //y=7.585 //x2=16.715 //y2=7.585
r463 (  197 310 ) resistor r=2.87058 //w=0.35 //l=0.085 //layer=li \
 //thickness=0.1 //x=17.03 //y=7.585 //x2=17.115 //y2=7.585
r464 (  197 200 ) resistor r=10.9864 //w=0.367 //l=0.315 //layer=li \
 //thickness=0.1 //x=17.03 //y=7.585 //x2=16.715 //y2=7.585
r465 (  191 309 ) resistor r=4.23183 //w=0.7 //l=0.175 //layer=li \
 //thickness=0.1 //x=16.235 //y=7.41 //x2=16.235 //y2=7.585
r466 (  191 335 ) resistor r=33.1979 //w=0.187 //l=0.485 //layer=li \
 //thickness=0.1 //x=16.235 //y=7.41 //x2=16.235 //y2=6.925
r467 (  188 308 ) resistor r=2.87058 //w=0.35 //l=0.085 //layer=li \
 //thickness=0.1 //x=15.44 //y=7.585 //x2=15.355 //y2=7.585
r468 (  188 190 ) resistor r=5.75477 //w=0.367 //l=0.165 //layer=li \
 //thickness=0.1 //x=15.44 //y=7.585 //x2=15.605 //y2=7.585
r469 (  187 309 ) resistor r=2.87058 //w=0.35 //l=0.085 //layer=li \
 //thickness=0.1 //x=16.15 //y=7.585 //x2=16.235 //y2=7.585
r470 (  187 190 ) resistor r=19.0082 //w=0.367 //l=0.545 //layer=li \
 //thickness=0.1 //x=16.15 //y=7.585 //x2=15.605 //y2=7.585
r471 (  181 308 ) resistor r=4.23183 //w=0.7 //l=0.175 //layer=li \
 //thickness=0.1 //x=15.355 //y=7.41 //x2=15.355 //y2=7.585
r472 (  181 334 ) resistor r=33.1979 //w=0.187 //l=0.485 //layer=li \
 //thickness=0.1 //x=15.355 //y=7.41 //x2=15.355 //y2=6.925
r473 (  180 307 ) resistor r=2.87058 //w=0.35 //l=0.085 //layer=li \
 //thickness=0.1 //x=14.56 //y=7.585 //x2=14.475 //y2=7.585
r474 (  179 308 ) resistor r=2.87058 //w=0.35 //l=0.085 //layer=li \
 //thickness=0.1 //x=15.27 //y=7.585 //x2=15.355 //y2=7.585
r475 (  179 180 ) resistor r=24.7629 //w=0.367 //l=0.71 //layer=li \
 //thickness=0.1 //x=15.27 //y=7.585 //x2=14.56 //y2=7.585
r476 (  173 307 ) resistor r=4.23183 //w=0.7 //l=0.175 //layer=li \
 //thickness=0.1 //x=14.475 //y=7.41 //x2=14.475 //y2=7.585
r477 (  173 333 ) resistor r=56.4706 //w=0.187 //l=0.825 //layer=li \
 //thickness=0.1 //x=14.475 //y=7.41 //x2=14.475 //y2=6.585
r478 (  172 305 ) resistor r=5.29055 //w=0.35 //l=0.17 //layer=li \
 //thickness=0.1 //x=13.555 //y=7.585 //x2=13.385 //y2=7.585
r479 (  171 307 ) resistor r=2.87058 //w=0.35 //l=0.085 //layer=li \
 //thickness=0.1 //x=14.39 //y=7.585 //x2=14.475 //y2=7.585
r480 (  171 172 ) resistor r=29.1226 //w=0.367 //l=0.835 //layer=li \
 //thickness=0.1 //x=14.39 //y=7.585 //x2=13.555 //y2=7.585
r481 (  166 304 ) resistor r=2.87058 //w=0.35 //l=0.085 //layer=li \
 //thickness=0.1 //x=12.69 //y=7.585 //x2=12.605 //y2=7.585
r482 (  166 168 ) resistor r=11.3351 //w=0.367 //l=0.325 //layer=li \
 //thickness=0.1 //x=12.69 //y=7.585 //x2=13.015 //y2=7.585
r483 (  165 305 ) resistor r=5.29055 //w=0.35 //l=0.17 //layer=li \
 //thickness=0.1 //x=13.215 //y=7.585 //x2=13.385 //y2=7.585
r484 (  165 168 ) resistor r=6.97548 //w=0.367 //l=0.2 //layer=li \
 //thickness=0.1 //x=13.215 //y=7.585 //x2=13.015 //y2=7.585
r485 (  159 304 ) resistor r=4.23183 //w=0.7 //l=0.175 //layer=li \
 //thickness=0.1 //x=12.605 //y=7.41 //x2=12.605 //y2=7.585
r486 (  159 332 ) resistor r=33.1979 //w=0.187 //l=0.485 //layer=li \
 //thickness=0.1 //x=12.605 //y=7.41 //x2=12.605 //y2=6.925
r487 (  156 303 ) resistor r=2.87058 //w=0.35 //l=0.085 //layer=li \
 //thickness=0.1 //x=11.81 //y=7.585 //x2=11.725 //y2=7.585
r488 (  156 158 ) resistor r=3.31335 //w=0.367 //l=0.095 //layer=li \
 //thickness=0.1 //x=11.81 //y=7.585 //x2=11.905 //y2=7.585
r489 (  155 304 ) resistor r=2.87058 //w=0.35 //l=0.085 //layer=li \
 //thickness=0.1 //x=12.52 //y=7.585 //x2=12.605 //y2=7.585
r490 (  155 158 ) resistor r=21.4496 //w=0.367 //l=0.615 //layer=li \
 //thickness=0.1 //x=12.52 //y=7.585 //x2=11.905 //y2=7.585
r491 (  149 303 ) resistor r=4.23183 //w=0.7 //l=0.175 //layer=li \
 //thickness=0.1 //x=11.725 //y=7.41 //x2=11.725 //y2=7.585
r492 (  149 331 ) resistor r=33.1979 //w=0.187 //l=0.485 //layer=li \
 //thickness=0.1 //x=11.725 //y=7.41 //x2=11.725 //y2=6.925
r493 (  148 302 ) resistor r=2.87058 //w=0.35 //l=0.085 //layer=li \
 //thickness=0.1 //x=10.93 //y=7.585 //x2=10.845 //y2=7.585
r494 (  147 303 ) resistor r=2.87058 //w=0.35 //l=0.085 //layer=li \
 //thickness=0.1 //x=11.64 //y=7.585 //x2=11.725 //y2=7.585
r495 (  147 148 ) resistor r=24.7629 //w=0.367 //l=0.71 //layer=li \
 //thickness=0.1 //x=11.64 //y=7.585 //x2=10.93 //y2=7.585
r496 (  141 302 ) resistor r=4.23183 //w=0.7 //l=0.175 //layer=li \
 //thickness=0.1 //x=10.845 //y=7.41 //x2=10.845 //y2=7.585
r497 (  141 330 ) resistor r=56.4706 //w=0.187 //l=0.825 //layer=li \
 //thickness=0.1 //x=10.845 //y=7.41 //x2=10.845 //y2=6.585
r498 (  140 300 ) resistor r=5.29055 //w=0.35 //l=0.17 //layer=li \
 //thickness=0.1 //x=10.225 //y=7.585 //x2=10.055 //y2=7.585
r499 (  139 302 ) resistor r=2.87058 //w=0.35 //l=0.085 //layer=li \
 //thickness=0.1 //x=10.76 //y=7.585 //x2=10.845 //y2=7.585
r500 (  139 140 ) resistor r=18.6594 //w=0.367 //l=0.535 //layer=li \
 //thickness=0.1 //x=10.76 //y=7.585 //x2=10.225 //y2=7.585
r501 (  134 299 ) resistor r=2.87058 //w=0.35 //l=0.085 //layer=li \
 //thickness=0.1 //x=9.06 //y=7.585 //x2=8.975 //y2=7.585
r502 (  134 136 ) resistor r=8.89373 //w=0.367 //l=0.255 //layer=li \
 //thickness=0.1 //x=9.06 //y=7.585 //x2=9.315 //y2=7.585
r503 (  133 300 ) resistor r=5.29055 //w=0.35 //l=0.17 //layer=li \
 //thickness=0.1 //x=9.885 //y=7.585 //x2=10.055 //y2=7.585
r504 (  133 136 ) resistor r=19.8801 //w=0.367 //l=0.57 //layer=li \
 //thickness=0.1 //x=9.885 //y=7.585 //x2=9.315 //y2=7.585
r505 (  127 299 ) resistor r=4.23183 //w=0.7 //l=0.175 //layer=li \
 //thickness=0.1 //x=8.975 //y=7.41 //x2=8.975 //y2=7.585
r506 (  127 329 ) resistor r=33.1979 //w=0.187 //l=0.485 //layer=li \
 //thickness=0.1 //x=8.975 //y=7.41 //x2=8.975 //y2=6.925
r507 (  124 298 ) resistor r=2.87058 //w=0.35 //l=0.085 //layer=li \
 //thickness=0.1 //x=8.18 //y=7.585 //x2=8.095 //y2=7.585
r508 (  124 126 ) resistor r=0.871935 //w=0.367 //l=0.025 //layer=li \
 //thickness=0.1 //x=8.18 //y=7.585 //x2=8.205 //y2=7.585
r509 (  123 299 ) resistor r=2.87058 //w=0.35 //l=0.085 //layer=li \
 //thickness=0.1 //x=8.89 //y=7.585 //x2=8.975 //y2=7.585
r510 (  123 126 ) resistor r=23.891 //w=0.367 //l=0.685 //layer=li \
 //thickness=0.1 //x=8.89 //y=7.585 //x2=8.205 //y2=7.585
r511 (  117 298 ) resistor r=4.23183 //w=0.7 //l=0.175 //layer=li \
 //thickness=0.1 //x=8.095 //y=7.41 //x2=8.095 //y2=7.585
r512 (  117 328 ) resistor r=33.1979 //w=0.187 //l=0.485 //layer=li \
 //thickness=0.1 //x=8.095 //y=7.41 //x2=8.095 //y2=6.925
r513 (  116 297 ) resistor r=2.87058 //w=0.35 //l=0.085 //layer=li \
 //thickness=0.1 //x=7.3 //y=7.585 //x2=7.215 //y2=7.585
r514 (  115 298 ) resistor r=2.87058 //w=0.35 //l=0.085 //layer=li \
 //thickness=0.1 //x=8.01 //y=7.585 //x2=8.095 //y2=7.585
r515 (  115 116 ) resistor r=24.7629 //w=0.367 //l=0.71 //layer=li \
 //thickness=0.1 //x=8.01 //y=7.585 //x2=7.3 //y2=7.585
r516 (  109 297 ) resistor r=4.23183 //w=0.7 //l=0.175 //layer=li \
 //thickness=0.1 //x=7.215 //y=7.41 //x2=7.215 //y2=7.585
r517 (  109 327 ) resistor r=33.1979 //w=0.187 //l=0.485 //layer=li \
 //thickness=0.1 //x=7.215 //y=7.41 //x2=7.215 //y2=6.925
r518 (  106 296 ) resistor r=2.87058 //w=0.35 //l=0.085 //layer=li \
 //thickness=0.1 //x=6.42 //y=7.585 //x2=6.335 //y2=7.585
r519 (  106 108 ) resistor r=23.5422 //w=0.367 //l=0.675 //layer=li \
 //thickness=0.1 //x=6.42 //y=7.585 //x2=7.095 //y2=7.585
r520 (  105 297 ) resistor r=2.87058 //w=0.35 //l=0.085 //layer=li \
 //thickness=0.1 //x=7.13 //y=7.585 //x2=7.215 //y2=7.585
r521 (  105 108 ) resistor r=1.22071 //w=0.367 //l=0.035 //layer=li \
 //thickness=0.1 //x=7.13 //y=7.585 //x2=7.095 //y2=7.585
r522 (  99 296 ) resistor r=4.23183 //w=0.7 //l=0.175 //layer=li \
 //thickness=0.1 //x=6.335 //y=7.41 //x2=6.335 //y2=7.585
r523 (  99 326 ) resistor r=56.4706 //w=0.187 //l=0.825 //layer=li \
 //thickness=0.1 //x=6.335 //y=7.41 //x2=6.335 //y2=6.585
r524 (  96 295 ) resistor r=5.29055 //w=0.35 //l=0.17 //layer=li \
 //thickness=0.1 //x=5.415 //y=7.585 //x2=5.245 //y2=7.585
r525 (  96 98 ) resistor r=19.8801 //w=0.367 //l=0.57 //layer=li \
 //thickness=0.1 //x=5.415 //y=7.585 //x2=5.985 //y2=7.585
r526 (  95 296 ) resistor r=2.87058 //w=0.35 //l=0.085 //layer=li \
 //thickness=0.1 //x=6.25 //y=7.585 //x2=6.335 //y2=7.585
r527 (  95 98 ) resistor r=9.24251 //w=0.367 //l=0.265 //layer=li \
 //thickness=0.1 //x=6.25 //y=7.585 //x2=5.985 //y2=7.585
r528 (  90 294 ) resistor r=2.87058 //w=0.35 //l=0.085 //layer=li \
 //thickness=0.1 //x=4.25 //y=7.585 //x2=4.165 //y2=7.585
r529 (  90 92 ) resistor r=8.89373 //w=0.367 //l=0.255 //layer=li \
 //thickness=0.1 //x=4.25 //y=7.585 //x2=4.505 //y2=7.585
r530 (  89 295 ) resistor r=5.29055 //w=0.35 //l=0.17 //layer=li \
 //thickness=0.1 //x=5.075 //y=7.585 //x2=5.245 //y2=7.585
r531 (  89 92 ) resistor r=19.8801 //w=0.367 //l=0.57 //layer=li \
 //thickness=0.1 //x=5.075 //y=7.585 //x2=4.505 //y2=7.585
r532 (  83 294 ) resistor r=4.23183 //w=0.7 //l=0.175 //layer=li \
 //thickness=0.1 //x=4.165 //y=7.41 //x2=4.165 //y2=7.585
r533 (  83 325 ) resistor r=33.1979 //w=0.187 //l=0.485 //layer=li \
 //thickness=0.1 //x=4.165 //y=7.41 //x2=4.165 //y2=6.925
r534 (  80 293 ) resistor r=2.87058 //w=0.35 //l=0.085 //layer=li \
 //thickness=0.1 //x=3.37 //y=7.585 //x2=3.285 //y2=7.585
r535 (  80 82 ) resistor r=0.871935 //w=0.367 //l=0.025 //layer=li \
 //thickness=0.1 //x=3.37 //y=7.585 //x2=3.395 //y2=7.585
r536 (  79 294 ) resistor r=2.87058 //w=0.35 //l=0.085 //layer=li \
 //thickness=0.1 //x=4.08 //y=7.585 //x2=4.165 //y2=7.585
r537 (  79 82 ) resistor r=23.891 //w=0.367 //l=0.685 //layer=li \
 //thickness=0.1 //x=4.08 //y=7.585 //x2=3.395 //y2=7.585
r538 (  73 293 ) resistor r=4.23183 //w=0.7 //l=0.175 //layer=li \
 //thickness=0.1 //x=3.285 //y=7.41 //x2=3.285 //y2=7.585
r539 (  73 324 ) resistor r=33.1979 //w=0.187 //l=0.485 //layer=li \
 //thickness=0.1 //x=3.285 //y=7.41 //x2=3.285 //y2=6.925
r540 (  72 292 ) resistor r=2.87058 //w=0.35 //l=0.085 //layer=li \
 //thickness=0.1 //x=2.49 //y=7.585 //x2=2.405 //y2=7.585
r541 (  71 293 ) resistor r=2.87058 //w=0.35 //l=0.085 //layer=li \
 //thickness=0.1 //x=3.2 //y=7.585 //x2=3.285 //y2=7.585
r542 (  71 72 ) resistor r=24.7629 //w=0.367 //l=0.71 //layer=li \
 //thickness=0.1 //x=3.2 //y=7.585 //x2=2.49 //y2=7.585
r543 (  65 292 ) resistor r=4.23183 //w=0.7 //l=0.175 //layer=li \
 //thickness=0.1 //x=2.405 //y=7.41 //x2=2.405 //y2=7.585
r544 (  65 323 ) resistor r=33.1979 //w=0.187 //l=0.485 //layer=li \
 //thickness=0.1 //x=2.405 //y=7.41 //x2=2.405 //y2=6.925
r545 (  62 291 ) resistor r=2.87058 //w=0.35 //l=0.085 //layer=li \
 //thickness=0.1 //x=1.61 //y=7.585 //x2=1.525 //y2=7.585
r546 (  62 64 ) resistor r=23.5422 //w=0.367 //l=0.675 //layer=li \
 //thickness=0.1 //x=1.61 //y=7.585 //x2=2.285 //y2=7.585
r547 (  61 292 ) resistor r=2.87058 //w=0.35 //l=0.085 //layer=li \
 //thickness=0.1 //x=2.32 //y=7.585 //x2=2.405 //y2=7.585
r548 (  61 64 ) resistor r=1.22071 //w=0.367 //l=0.035 //layer=li \
 //thickness=0.1 //x=2.32 //y=7.585 //x2=2.285 //y2=7.585
r549 (  55 291 ) resistor r=4.23183 //w=0.7 //l=0.175 //layer=li \
 //thickness=0.1 //x=1.525 //y=7.41 //x2=1.525 //y2=7.585
r550 (  55 322 ) resistor r=56.4706 //w=0.187 //l=0.825 //layer=li \
 //thickness=0.1 //x=1.525 //y=7.41 //x2=1.525 //y2=6.585
r551 (  51 291 ) resistor r=2.87058 //w=0.35 //l=0.085 //layer=li \
 //thickness=0.1 //x=1.44 //y=7.585 //x2=1.525 //y2=7.585
r552 (  51 54 ) resistor r=9.24251 //w=0.367 //l=0.265 //layer=li \
 //thickness=0.1 //x=1.44 //y=7.585 //x2=1.175 //y2=7.585
r553 (  47 286 ) resistor r=9.3 //w=0.17 //l=0.17 //layer=mcon //count=1 \
 //x=25.965 //y=7.58 //x2=25.965 //y2=7.58
r554 (  45 276 ) resistor r=3.1 //w=0.17 //l=0.51 //layer=mcon //count=3 \
 //x=25.225 //y=7.58 //x2=25.225 //y2=7.58
r555 (  45 47 ) resistor r=0.297428 //w=0.311 //l=0.74 //layer=m1 \
 //thickness=0.36 //x=25.225 //y=7.585 //x2=25.965 //y2=7.585
r556 (  43 266 ) resistor r=3.1 //w=0.17 //l=0.51 //layer=mcon //count=3 \
 //x=24.115 //y=7.58 //x2=24.115 //y2=7.58
r557 (  43 45 ) resistor r=0.446141 //w=0.311 //l=1.11 //layer=m1 \
 //thickness=0.36 //x=24.115 //y=7.585 //x2=25.225 //y2=7.585
r558 (  41 252 ) resistor r=3.1 //w=0.17 //l=0.51 //layer=mcon //count=3 \
 //x=22.635 //y=7.58 //x2=22.635 //y2=7.58
r559 (  41 43 ) resistor r=0.594855 //w=0.311 //l=1.48 //layer=m1 \
 //thickness=0.36 //x=22.635 //y=7.585 //x2=24.115 //y2=7.585
r560 (  39 242 ) resistor r=3.1 //w=0.17 //l=0.51 //layer=mcon //count=3 \
 //x=21.525 //y=7.58 //x2=21.525 //y2=7.58
r561 (  39 41 ) resistor r=0.446141 //w=0.311 //l=1.11 //layer=m1 \
 //thickness=0.36 //x=21.525 //y=7.585 //x2=22.635 //y2=7.585
r562 (  37 232 ) resistor r=3.1 //w=0.17 //l=0.51 //layer=mcon //count=3 \
 //x=20.415 //y=7.58 //x2=20.415 //y2=7.58
r563 (  37 39 ) resistor r=0.446141 //w=0.311 //l=1.11 //layer=m1 \
 //thickness=0.36 //x=20.415 //y=7.585 //x2=21.525 //y2=7.585
r564 (  35 313 ) resistor r=3.1 //w=0.17 //l=0.51 //layer=mcon //count=3 \
 //x=19.305 //y=7.58 //x2=19.305 //y2=7.58
r565 (  35 37 ) resistor r=0.446141 //w=0.311 //l=1.11 //layer=m1 \
 //thickness=0.36 //x=19.305 //y=7.585 //x2=20.415 //y2=7.585
r566 (  33 210 ) resistor r=3.1 //w=0.17 //l=0.51 //layer=mcon //count=3 \
 //x=17.825 //y=7.58 //x2=17.825 //y2=7.58
r567 (  33 35 ) resistor r=0.594855 //w=0.311 //l=1.48 //layer=m1 \
 //thickness=0.36 //x=17.825 //y=7.585 //x2=19.305 //y2=7.585
r568 (  31 200 ) resistor r=3.1 //w=0.17 //l=0.51 //layer=mcon //count=3 \
 //x=16.715 //y=7.58 //x2=16.715 //y2=7.58
r569 (  31 33 ) resistor r=0.446141 //w=0.311 //l=1.11 //layer=m1 \
 //thickness=0.36 //x=16.715 //y=7.585 //x2=17.825 //y2=7.585
r570 (  29 190 ) resistor r=3.1 //w=0.17 //l=0.51 //layer=mcon //count=3 \
 //x=15.605 //y=7.58 //x2=15.605 //y2=7.58
r571 (  29 31 ) resistor r=0.446141 //w=0.311 //l=1.11 //layer=m1 \
 //thickness=0.36 //x=15.605 //y=7.585 //x2=16.715 //y2=7.585
r572 (  27 307 ) resistor r=3.1 //w=0.17 //l=0.51 //layer=mcon //count=3 \
 //x=14.495 //y=7.58 //x2=14.495 //y2=7.58
r573 (  27 29 ) resistor r=0.446141 //w=0.311 //l=1.11 //layer=m1 \
 //thickness=0.36 //x=14.495 //y=7.585 //x2=15.605 //y2=7.585
r574 (  24 168 ) resistor r=3.1 //w=0.17 //l=0.51 //layer=mcon //count=3 \
 //x=13.015 //y=7.58 //x2=13.015 //y2=7.58
r575 (  22 158 ) resistor r=3.1 //w=0.17 //l=0.51 //layer=mcon //count=3 \
 //x=11.905 //y=7.58 //x2=11.905 //y2=7.58
r576 (  22 24 ) resistor r=0.446141 //w=0.311 //l=1.11 //layer=m1 \
 //thickness=0.36 //x=11.905 //y=7.585 //x2=13.015 //y2=7.585
r577 (  20 302 ) resistor r=3.1 //w=0.17 //l=0.51 //layer=mcon //count=3 \
 //x=10.795 //y=7.58 //x2=10.795 //y2=7.58
r578 (  20 22 ) resistor r=0.446141 //w=0.311 //l=1.11 //layer=m1 \
 //thickness=0.36 //x=10.795 //y=7.585 //x2=11.905 //y2=7.585
r579 (  18 136 ) resistor r=3.1 //w=0.17 //l=0.51 //layer=mcon //count=3 \
 //x=9.315 //y=7.58 //x2=9.315 //y2=7.58
r580 (  18 20 ) resistor r=0.594855 //w=0.311 //l=1.48 //layer=m1 \
 //thickness=0.36 //x=9.315 //y=7.585 //x2=10.795 //y2=7.585
r581 (  16 126 ) resistor r=3.1 //w=0.17 //l=0.51 //layer=mcon //count=3 \
 //x=8.205 //y=7.58 //x2=8.205 //y2=7.58
r582 (  16 18 ) resistor r=0.446141 //w=0.311 //l=1.11 //layer=m1 \
 //thickness=0.36 //x=8.205 //y=7.585 //x2=9.315 //y2=7.585
r583 (  14 108 ) resistor r=3.1 //w=0.17 //l=0.51 //layer=mcon //count=3 \
 //x=7.095 //y=7.58 //x2=7.095 //y2=7.58
r584 (  14 16 ) resistor r=0.446141 //w=0.311 //l=1.11 //layer=m1 \
 //thickness=0.36 //x=7.095 //y=7.585 //x2=8.205 //y2=7.585
r585 (  12 98 ) resistor r=3.1 //w=0.17 //l=0.51 //layer=mcon //count=3 \
 //x=5.985 //y=7.58 //x2=5.985 //y2=7.58
r586 (  12 14 ) resistor r=0.446141 //w=0.311 //l=1.11 //layer=m1 \
 //thickness=0.36 //x=5.985 //y=7.585 //x2=7.095 //y2=7.585
r587 (  10 92 ) resistor r=3.1 //w=0.17 //l=0.51 //layer=mcon //count=3 \
 //x=4.505 //y=7.58 //x2=4.505 //y2=7.58
r588 (  10 12 ) resistor r=0.594855 //w=0.311 //l=1.48 //layer=m1 \
 //thickness=0.36 //x=4.505 //y=7.585 //x2=5.985 //y2=7.585
r589 (  8 82 ) resistor r=3.1 //w=0.17 //l=0.51 //layer=mcon //count=3 \
 //x=3.395 //y=7.58 //x2=3.395 //y2=7.58
r590 (  8 10 ) resistor r=0.446141 //w=0.311 //l=1.11 //layer=m1 \
 //thickness=0.36 //x=3.395 //y=7.585 //x2=4.505 //y2=7.585
r591 (  6 64 ) resistor r=3.1 //w=0.17 //l=0.51 //layer=mcon //count=3 \
 //x=2.285 //y=7.58 //x2=2.285 //y2=7.58
r592 (  6 8 ) resistor r=0.446141 //w=0.311 //l=1.11 //layer=m1 \
 //thickness=0.36 //x=2.285 //y=7.585 //x2=3.395 //y2=7.585
r593 (  3 54 ) resistor r=3.1 //w=0.17 //l=0.51 //layer=mcon //count=3 \
 //x=1.175 //y=7.58 //x2=1.175 //y2=7.58
r594 (  3 6 ) resistor r=0.446141 //w=0.311 //l=1.11 //layer=m1 \
 //thickness=0.36 //x=1.175 //y=7.585 //x2=2.285 //y2=7.585
r595 (  1 27 ) resistor r=0.424035 //w=0.311 //l=1.055 //layer=m1 \
 //thickness=0.36 //x=13.44 //y=7.585 //x2=14.495 //y2=7.585
r596 (  1 24 ) resistor r=0.17082 //w=0.311 //l=0.425 //layer=m1 \
 //thickness=0.36 //x=13.44 //y=7.585 //x2=13.015 //y2=7.585
ends PM_DFFRNQX1\%VDD

subckt PM_DFFRNQX1\%GND ( 1 47 51 54 59 69 77 87 95 103 109 119 125 135 146 \
 152 154 156 159 162 166 167 168 169 170 171 )
c300 ( 171 0 ) capacitor c=0.0208018f //x=23.995 //y=1.045
c301 ( 170 0 ) capacitor c=0.0225954f //x=19.08 //y=1.055
c302 ( 169 0 ) capacitor c=0.0226075f //x=14.27 //y=1.055
c303 ( 168 0 ) capacitor c=0.0207408f //x=11.045 //y=1.045
c304 ( 167 0 ) capacitor c=0.0226571f //x=6.13 //y=1.055
c305 ( 166 0 ) capacitor c=0.022675f //x=1.32 //y=1.055
c306 ( 164 0 ) capacitor c=0.00446416f //x=24.115 //y=0.18
c307 ( 162 0 ) capacitor c=0.110005f //x=23.005 //y=0.175
c308 ( 161 0 ) capacitor c=0.00446464f //x=19.305 //y=0.18
c309 ( 159 0 ) capacitor c=0.108144f //x=18.195 //y=0.175
c310 ( 158 0 ) capacitor c=0.00446464f //x=14.495 //y=0.18
c311 ( 156 0 ) capacitor c=0.104775f //x=13.385 //y=0.175
c312 ( 155 0 ) capacitor c=0.00446416f //x=11.235 //y=0.175
c313 ( 154 0 ) capacitor c=0.108895f //x=10.055 //y=0.175
c314 ( 153 0 ) capacitor c=0.00446464f //x=6.32 //y=0.175
c315 ( 152 0 ) capacitor c=0.108816f //x=5.245 //y=0.175
c316 ( 151 0 ) capacitor c=0.00446464f //x=1.51 //y=0.175
c317 ( 146 0 ) capacitor c=0.282305f //x=25.965 //y=0.18
c318 ( 135 0 ) capacitor c=0.0392803f //x=24.1 //y=0.175
c319 ( 125 0 ) capacitor c=0.133714f //x=22.835 //y=0.175
c320 ( 119 0 ) capacitor c=0.0342713f //x=19.185 //y=0.175
c321 ( 109 0 ) capacitor c=0.135264f //x=18.025 //y=0.175
c322 ( 103 0 ) capacitor c=0.0342713f //x=14.375 //y=0.175
c323 ( 95 0 ) capacitor c=0.0727058f //x=13.215 //y=0.175
c324 ( 87 0 ) capacitor c=0.0392405f //x=11.15 //y=0.175
c325 ( 77 0 ) capacitor c=0.135402f //x=9.885 //y=0.175
c326 ( 69 0 ) capacitor c=0.0343125f //x=6.235 //y=0.175
c327 ( 59 0 ) capacitor c=0.133468f //x=5.075 //y=0.175
c328 ( 54 0 ) capacitor c=0.1835f //x=1.175 //y=0.18
c329 ( 51 0 ) capacitor c=0.0370791f //x=1.425 //y=0.175
c330 ( 47 0 ) capacitor c=0.843877f //x=25.965 //y=0.18
r331 (  144 146 ) resistor r=25.8093 //w=0.367 //l=0.74 //layer=li \
 //thickness=0.1 //x=25.225 //y=0.175 //x2=25.965 //y2=0.175
r332 (  142 164 ) resistor r=2.87058 //w=0.35 //l=0.085 //layer=li \
 //thickness=0.1 //x=24.27 //y=0.175 //x2=24.185 //y2=0.175
r333 (  142 144 ) resistor r=33.3079 //w=0.367 //l=0.955 //layer=li \
 //thickness=0.1 //x=24.27 //y=0.175 //x2=25.225 //y2=0.175
r334 (  137 164 ) resistor r=4.23183 //w=0.7 //l=0.175 //layer=li \
 //thickness=0.1 //x=24.185 //y=0.35 //x2=24.185 //y2=0.175
r335 (  137 171 ) resistor r=53.7326 //w=0.187 //l=0.785 //layer=li \
 //thickness=0.1 //x=24.185 //y=0.35 //x2=24.185 //y2=1.135
r336 (  136 162 ) resistor r=5.29055 //w=0.35 //l=0.17 //layer=li \
 //thickness=0.1 //x=23.175 //y=0.175 //x2=23.005 //y2=0.175
r337 (  135 164 ) resistor r=2.87058 //w=0.35 //l=0.085 //layer=li \
 //thickness=0.1 //x=24.1 //y=0.175 //x2=24.185 //y2=0.175
r338 (  135 136 ) resistor r=32.2616 //w=0.367 //l=0.925 //layer=li \
 //thickness=0.1 //x=24.1 //y=0.175 //x2=23.175 //y2=0.175
r339 (  130 132 ) resistor r=38.7139 //w=0.367 //l=1.11 //layer=li \
 //thickness=0.1 //x=21.525 //y=0.175 //x2=22.635 //y2=0.175
r340 (  128 130 ) resistor r=38.7139 //w=0.367 //l=1.11 //layer=li \
 //thickness=0.1 //x=20.415 //y=0.175 //x2=21.525 //y2=0.175
r341 (  126 161 ) resistor r=2.87058 //w=0.35 //l=0.085 //layer=li \
 //thickness=0.1 //x=19.355 //y=0.175 //x2=19.27 //y2=0.175
r342 (  126 128 ) resistor r=36.97 //w=0.367 //l=1.06 //layer=li \
 //thickness=0.1 //x=19.355 //y=0.175 //x2=20.415 //y2=0.175
r343 (  125 162 ) resistor r=5.29055 //w=0.35 //l=0.17 //layer=li \
 //thickness=0.1 //x=22.835 //y=0.175 //x2=23.005 //y2=0.175
r344 (  125 132 ) resistor r=6.97548 //w=0.367 //l=0.2 //layer=li \
 //thickness=0.1 //x=22.835 //y=0.175 //x2=22.635 //y2=0.175
r345 (  121 161 ) resistor r=4.23183 //w=0.7 //l=0.175 //layer=li \
 //thickness=0.1 //x=19.27 //y=0.35 //x2=19.27 //y2=0.175
r346 (  121 170 ) resistor r=54.4171 //w=0.187 //l=0.795 //layer=li \
 //thickness=0.1 //x=19.27 //y=0.35 //x2=19.27 //y2=1.145
r347 (  120 159 ) resistor r=5.29055 //w=0.35 //l=0.17 //layer=li \
 //thickness=0.1 //x=18.365 //y=0.175 //x2=18.195 //y2=0.175
r348 (  119 161 ) resistor r=2.87058 //w=0.35 //l=0.085 //layer=li \
 //thickness=0.1 //x=19.185 //y=0.175 //x2=19.27 //y2=0.175
r349 (  119 120 ) resistor r=28.5995 //w=0.367 //l=0.82 //layer=li \
 //thickness=0.1 //x=19.185 //y=0.175 //x2=18.365 //y2=0.175
r350 (  114 116 ) resistor r=38.7139 //w=0.367 //l=1.11 //layer=li \
 //thickness=0.1 //x=16.715 //y=0.175 //x2=17.825 //y2=0.175
r351 (  112 114 ) resistor r=38.7139 //w=0.367 //l=1.11 //layer=li \
 //thickness=0.1 //x=15.605 //y=0.175 //x2=16.715 //y2=0.175
r352 (  110 158 ) resistor r=2.87058 //w=0.35 //l=0.085 //layer=li \
 //thickness=0.1 //x=14.545 //y=0.175 //x2=14.46 //y2=0.175
r353 (  110 112 ) resistor r=36.97 //w=0.367 //l=1.06 //layer=li \
 //thickness=0.1 //x=14.545 //y=0.175 //x2=15.605 //y2=0.175
r354 (  109 159 ) resistor r=5.29055 //w=0.35 //l=0.17 //layer=li \
 //thickness=0.1 //x=18.025 //y=0.175 //x2=18.195 //y2=0.175
r355 (  109 116 ) resistor r=6.97548 //w=0.367 //l=0.2 //layer=li \
 //thickness=0.1 //x=18.025 //y=0.175 //x2=17.825 //y2=0.175
r356 (  105 158 ) resistor r=4.23183 //w=0.7 //l=0.175 //layer=li \
 //thickness=0.1 //x=14.46 //y=0.35 //x2=14.46 //y2=0.175
r357 (  105 169 ) resistor r=54.4171 //w=0.187 //l=0.795 //layer=li \
 //thickness=0.1 //x=14.46 //y=0.35 //x2=14.46 //y2=1.145
r358 (  104 156 ) resistor r=5.29055 //w=0.35 //l=0.17 //layer=li \
 //thickness=0.1 //x=13.555 //y=0.175 //x2=13.385 //y2=0.175
r359 (  103 158 ) resistor r=2.87058 //w=0.35 //l=0.085 //layer=li \
 //thickness=0.1 //x=14.375 //y=0.175 //x2=14.46 //y2=0.175
r360 (  103 104 ) resistor r=28.5995 //w=0.367 //l=0.82 //layer=li \
 //thickness=0.1 //x=14.375 //y=0.175 //x2=13.555 //y2=0.175
r361 (  98 100 ) resistor r=38.7139 //w=0.367 //l=1.11 //layer=li \
 //thickness=0.1 //x=11.905 //y=0.175 //x2=13.015 //y2=0.175
r362 (  96 155 ) resistor r=2.87058 //w=0.35 //l=0.085 //layer=li \
 //thickness=0.1 //x=11.32 //y=0.175 //x2=11.235 //y2=0.175
r363 (  96 98 ) resistor r=20.4033 //w=0.367 //l=0.585 //layer=li \
 //thickness=0.1 //x=11.32 //y=0.175 //x2=11.905 //y2=0.175
r364 (  95 156 ) resistor r=5.29055 //w=0.35 //l=0.17 //layer=li \
 //thickness=0.1 //x=13.215 //y=0.175 //x2=13.385 //y2=0.175
r365 (  95 100 ) resistor r=6.97548 //w=0.367 //l=0.2 //layer=li \
 //thickness=0.1 //x=13.215 //y=0.175 //x2=13.015 //y2=0.175
r366 (  91 155 ) resistor r=4.23183 //w=0.7 //l=0.175 //layer=li \
 //thickness=0.1 //x=11.235 //y=0.35 //x2=11.235 //y2=0.175
r367 (  91 168 ) resistor r=53.7326 //w=0.187 //l=0.785 //layer=li \
 //thickness=0.1 //x=11.235 //y=0.35 //x2=11.235 //y2=1.135
r368 (  88 154 ) resistor r=5.29055 //w=0.35 //l=0.17 //layer=li \
 //thickness=0.1 //x=10.225 //y=0.175 //x2=10.055 //y2=0.175
r369 (  88 90 ) resistor r=19.8801 //w=0.367 //l=0.57 //layer=li \
 //thickness=0.1 //x=10.225 //y=0.175 //x2=10.795 //y2=0.175
r370 (  87 155 ) resistor r=2.87058 //w=0.35 //l=0.085 //layer=li \
 //thickness=0.1 //x=11.15 //y=0.175 //x2=11.235 //y2=0.175
r371 (  87 90 ) resistor r=12.3815 //w=0.367 //l=0.355 //layer=li \
 //thickness=0.1 //x=11.15 //y=0.175 //x2=10.795 //y2=0.175
r372 (  82 84 ) resistor r=38.7139 //w=0.367 //l=1.11 //layer=li \
 //thickness=0.1 //x=8.205 //y=0.175 //x2=9.315 //y2=0.175
r373 (  80 82 ) resistor r=38.7139 //w=0.367 //l=1.11 //layer=li \
 //thickness=0.1 //x=7.095 //y=0.175 //x2=8.205 //y2=0.175
r374 (  78 153 ) resistor r=2.87058 //w=0.35 //l=0.085 //layer=li \
 //thickness=0.1 //x=6.405 //y=0.175 //x2=6.32 //y2=0.175
r375 (  78 80 ) resistor r=24.0654 //w=0.367 //l=0.69 //layer=li \
 //thickness=0.1 //x=6.405 //y=0.175 //x2=7.095 //y2=0.175
r376 (  77 154 ) resistor r=5.29055 //w=0.35 //l=0.17 //layer=li \
 //thickness=0.1 //x=9.885 //y=0.175 //x2=10.055 //y2=0.175
r377 (  77 84 ) resistor r=19.8801 //w=0.367 //l=0.57 //layer=li \
 //thickness=0.1 //x=9.885 //y=0.175 //x2=9.315 //y2=0.175
r378 (  73 153 ) resistor r=4.23183 //w=0.7 //l=0.175 //layer=li \
 //thickness=0.1 //x=6.32 //y=0.35 //x2=6.32 //y2=0.175
r379 (  73 167 ) resistor r=54.4171 //w=0.187 //l=0.795 //layer=li \
 //thickness=0.1 //x=6.32 //y=0.35 //x2=6.32 //y2=1.145
r380 (  70 152 ) resistor r=5.29055 //w=0.35 //l=0.17 //layer=li \
 //thickness=0.1 //x=5.415 //y=0.175 //x2=5.245 //y2=0.175
r381 (  70 72 ) resistor r=19.8801 //w=0.367 //l=0.57 //layer=li \
 //thickness=0.1 //x=5.415 //y=0.175 //x2=5.985 //y2=0.175
r382 (  69 153 ) resistor r=2.87058 //w=0.35 //l=0.085 //layer=li \
 //thickness=0.1 //x=6.235 //y=0.175 //x2=6.32 //y2=0.175
r383 (  69 72 ) resistor r=8.71935 //w=0.367 //l=0.25 //layer=li \
 //thickness=0.1 //x=6.235 //y=0.175 //x2=5.985 //y2=0.175
r384 (  64 66 ) resistor r=38.7139 //w=0.367 //l=1.11 //layer=li \
 //thickness=0.1 //x=3.395 //y=0.175 //x2=4.505 //y2=0.175
r385 (  62 64 ) resistor r=38.7139 //w=0.367 //l=1.11 //layer=li \
 //thickness=0.1 //x=2.285 //y=0.175 //x2=3.395 //y2=0.175
r386 (  60 151 ) resistor r=2.87058 //w=0.35 //l=0.085 //layer=li \
 //thickness=0.1 //x=1.595 //y=0.175 //x2=1.51 //y2=0.175
r387 (  60 62 ) resistor r=24.0654 //w=0.367 //l=0.69 //layer=li \
 //thickness=0.1 //x=1.595 //y=0.175 //x2=2.285 //y2=0.175
r388 (  59 152 ) resistor r=5.29055 //w=0.35 //l=0.17 //layer=li \
 //thickness=0.1 //x=5.075 //y=0.175 //x2=5.245 //y2=0.175
r389 (  59 66 ) resistor r=19.8801 //w=0.367 //l=0.57 //layer=li \
 //thickness=0.1 //x=5.075 //y=0.175 //x2=4.505 //y2=0.175
r390 (  55 151 ) resistor r=4.23183 //w=0.7 //l=0.175 //layer=li \
 //thickness=0.1 //x=1.51 //y=0.35 //x2=1.51 //y2=0.175
r391 (  55 166 ) resistor r=54.4171 //w=0.187 //l=0.795 //layer=li \
 //thickness=0.1 //x=1.51 //y=0.35 //x2=1.51 //y2=1.145
r392 (  51 151 ) resistor r=2.87058 //w=0.35 //l=0.085 //layer=li \
 //thickness=0.1 //x=1.425 //y=0.175 //x2=1.51 //y2=0.175
r393 (  51 54 ) resistor r=8.71935 //w=0.367 //l=0.25 //layer=li \
 //thickness=0.1 //x=1.425 //y=0.175 //x2=1.175 //y2=0.175
r394 (  47 146 ) resistor r=9.3 //w=0.17 //l=0.17 //layer=mcon //count=1 \
 //x=25.965 //y=0.18 //x2=25.965 //y2=0.18
r395 (  45 144 ) resistor r=3.1 //w=0.17 //l=0.51 //layer=mcon //count=3 \
 //x=25.225 //y=0.18 //x2=25.225 //y2=0.18
r396 (  45 47 ) resistor r=0.297428 //w=0.311 //l=0.74 //layer=m1 \
 //thickness=0.36 //x=25.225 //y=0.175 //x2=25.965 //y2=0.175
r397 (  43 164 ) resistor r=3.1 //w=0.17 //l=0.51 //layer=mcon //count=3 \
 //x=24.115 //y=0.18 //x2=24.115 //y2=0.18
r398 (  43 45 ) resistor r=0.446141 //w=0.311 //l=1.11 //layer=m1 \
 //thickness=0.36 //x=24.115 //y=0.175 //x2=25.225 //y2=0.175
r399 (  41 132 ) resistor r=3.1 //w=0.17 //l=0.51 //layer=mcon //count=3 \
 //x=22.635 //y=0.18 //x2=22.635 //y2=0.18
r400 (  41 43 ) resistor r=0.594855 //w=0.311 //l=1.48 //layer=m1 \
 //thickness=0.36 //x=22.635 //y=0.175 //x2=24.115 //y2=0.175
r401 (  39 130 ) resistor r=3.1 //w=0.17 //l=0.51 //layer=mcon //count=3 \
 //x=21.525 //y=0.18 //x2=21.525 //y2=0.18
r402 (  39 41 ) resistor r=0.446141 //w=0.311 //l=1.11 //layer=m1 \
 //thickness=0.36 //x=21.525 //y=0.175 //x2=22.635 //y2=0.175
r403 (  37 128 ) resistor r=3.1 //w=0.17 //l=0.51 //layer=mcon //count=3 \
 //x=20.415 //y=0.18 //x2=20.415 //y2=0.18
r404 (  37 39 ) resistor r=0.446141 //w=0.311 //l=1.11 //layer=m1 \
 //thickness=0.36 //x=20.415 //y=0.175 //x2=21.525 //y2=0.175
r405 (  35 161 ) resistor r=3.1 //w=0.17 //l=0.51 //layer=mcon //count=3 \
 //x=19.305 //y=0.18 //x2=19.305 //y2=0.18
r406 (  35 37 ) resistor r=0.446141 //w=0.311 //l=1.11 //layer=m1 \
 //thickness=0.36 //x=19.305 //y=0.175 //x2=20.415 //y2=0.175
r407 (  33 116 ) resistor r=3.1 //w=0.17 //l=0.51 //layer=mcon //count=3 \
 //x=17.825 //y=0.18 //x2=17.825 //y2=0.18
r408 (  33 35 ) resistor r=0.594855 //w=0.311 //l=1.48 //layer=m1 \
 //thickness=0.36 //x=17.825 //y=0.175 //x2=19.305 //y2=0.175
r409 (  31 114 ) resistor r=3.1 //w=0.17 //l=0.51 //layer=mcon //count=3 \
 //x=16.715 //y=0.18 //x2=16.715 //y2=0.18
r410 (  31 33 ) resistor r=0.446141 //w=0.311 //l=1.11 //layer=m1 \
 //thickness=0.36 //x=16.715 //y=0.175 //x2=17.825 //y2=0.175
r411 (  29 112 ) resistor r=3.1 //w=0.17 //l=0.51 //layer=mcon //count=3 \
 //x=15.605 //y=0.18 //x2=15.605 //y2=0.18
r412 (  29 31 ) resistor r=0.446141 //w=0.311 //l=1.11 //layer=m1 \
 //thickness=0.36 //x=15.605 //y=0.175 //x2=16.715 //y2=0.175
r413 (  27 158 ) resistor r=3.1 //w=0.17 //l=0.51 //layer=mcon //count=3 \
 //x=14.495 //y=0.18 //x2=14.495 //y2=0.18
r414 (  27 29 ) resistor r=0.446141 //w=0.311 //l=1.11 //layer=m1 \
 //thickness=0.36 //x=14.495 //y=0.175 //x2=15.605 //y2=0.175
r415 (  24 100 ) resistor r=3.1 //w=0.17 //l=0.51 //layer=mcon //count=3 \
 //x=13.015 //y=0.18 //x2=13.015 //y2=0.18
r416 (  22 98 ) resistor r=3.1 //w=0.17 //l=0.51 //layer=mcon //count=3 \
 //x=11.905 //y=0.18 //x2=11.905 //y2=0.18
r417 (  22 24 ) resistor r=0.446141 //w=0.311 //l=1.11 //layer=m1 \
 //thickness=0.36 //x=11.905 //y=0.175 //x2=13.015 //y2=0.175
r418 (  20 90 ) resistor r=3.1 //w=0.17 //l=0.51 //layer=mcon //count=3 \
 //x=10.795 //y=0.18 //x2=10.795 //y2=0.18
r419 (  20 22 ) resistor r=0.446141 //w=0.311 //l=1.11 //layer=m1 \
 //thickness=0.36 //x=10.795 //y=0.175 //x2=11.905 //y2=0.175
r420 (  18 84 ) resistor r=3.1 //w=0.17 //l=0.51 //layer=mcon //count=3 \
 //x=9.315 //y=0.18 //x2=9.315 //y2=0.18
r421 (  18 20 ) resistor r=0.594855 //w=0.311 //l=1.48 //layer=m1 \
 //thickness=0.36 //x=9.315 //y=0.175 //x2=10.795 //y2=0.175
r422 (  16 82 ) resistor r=3.1 //w=0.17 //l=0.51 //layer=mcon //count=3 \
 //x=8.205 //y=0.18 //x2=8.205 //y2=0.18
r423 (  16 18 ) resistor r=0.446141 //w=0.311 //l=1.11 //layer=m1 \
 //thickness=0.36 //x=8.205 //y=0.175 //x2=9.315 //y2=0.175
r424 (  14 80 ) resistor r=3.1 //w=0.17 //l=0.51 //layer=mcon //count=3 \
 //x=7.095 //y=0.18 //x2=7.095 //y2=0.18
r425 (  14 16 ) resistor r=0.446141 //w=0.311 //l=1.11 //layer=m1 \
 //thickness=0.36 //x=7.095 //y=0.175 //x2=8.205 //y2=0.175
r426 (  12 72 ) resistor r=3.1 //w=0.17 //l=0.51 //layer=mcon //count=3 \
 //x=5.985 //y=0.18 //x2=5.985 //y2=0.18
r427 (  12 14 ) resistor r=0.446141 //w=0.311 //l=1.11 //layer=m1 \
 //thickness=0.36 //x=5.985 //y=0.175 //x2=7.095 //y2=0.175
r428 (  10 66 ) resistor r=3.1 //w=0.17 //l=0.51 //layer=mcon //count=3 \
 //x=4.505 //y=0.18 //x2=4.505 //y2=0.18
r429 (  10 12 ) resistor r=0.594855 //w=0.311 //l=1.48 //layer=m1 \
 //thickness=0.36 //x=4.505 //y=0.175 //x2=5.985 //y2=0.175
r430 (  8 64 ) resistor r=3.1 //w=0.17 //l=0.51 //layer=mcon //count=3 \
 //x=3.395 //y=0.18 //x2=3.395 //y2=0.18
r431 (  8 10 ) resistor r=0.446141 //w=0.311 //l=1.11 //layer=m1 \
 //thickness=0.36 //x=3.395 //y=0.175 //x2=4.505 //y2=0.175
r432 (  6 62 ) resistor r=3.1 //w=0.17 //l=0.51 //layer=mcon //count=3 \
 //x=2.285 //y=0.18 //x2=2.285 //y2=0.18
r433 (  6 8 ) resistor r=0.446141 //w=0.311 //l=1.11 //layer=m1 \
 //thickness=0.36 //x=2.285 //y=0.175 //x2=3.395 //y2=0.175
r434 (  3 54 ) resistor r=3.1 //w=0.17 //l=0.51 //layer=mcon //count=3 \
 //x=1.175 //y=0.18 //x2=1.175 //y2=0.18
r435 (  3 6 ) resistor r=0.446141 //w=0.311 //l=1.11 //layer=m1 \
 //thickness=0.36 //x=1.175 //y=0.175 //x2=2.285 //y2=0.175
r436 (  1 27 ) resistor r=0.424035 //w=0.311 //l=1.055 //layer=m1 \
 //thickness=0.36 //x=13.44 //y=0.175 //x2=14.495 //y2=0.175
r437 (  1 24 ) resistor r=0.17082 //w=0.311 //l=0.425 //layer=m1 \
 //thickness=0.36 //x=13.44 //y=0.175 //x2=13.015 //y2=0.175
ends PM_DFFRNQX1\%GND

subckt PM_DFFRNQX1\%noxref_3 ( 1 2 3 4 12 25 26 33 41 47 48 52 54 61 62 63 64 \
 65 66 67 68 72 73 74 79 81 84 85 86 87 88 89 93 95 98 99 104 105 110 119 122 \
 124 125 126 )
c269 ( 126 0 ) capacitor c=0.023087f //x=8.39 //y=5.2
c270 ( 125 0 ) capacitor c=0.023519f //x=7.51 //y=5.2
c271 ( 124 0 ) capacitor c=0.0224735f //x=6.63 //y=5.2
c272 ( 122 0 ) capacitor c=0.00872971f //x=8.64 //y=1.095
c273 ( 119 0 ) capacitor c=0.0588816f //x=11.165 //y=4.88
c274 ( 110 0 ) capacitor c=0.058931f //x=3.765 //y=4.88
c275 ( 105 0 ) capacitor c=0.0273931f //x=3.765 //y=2.095
c276 ( 104 0 ) capacitor c=0.0464411f //x=3.765 //y=2.26
c277 ( 99 0 ) capacitor c=0.0318948f //x=11.5 //y=1.39
c278 ( 98 0 ) capacitor c=0.0187384f //x=11.5 //y=1.045
c279 ( 95 0 ) capacitor c=0.0141798f //x=11.345 //y=1.545
c280 ( 93 0 ) capacitor c=0.0149844f //x=11.345 //y=0.89
c281 ( 89 0 ) capacitor c=0.0813322f //x=10.97 //y=2.095
c282 ( 88 0 ) capacitor c=0.0229267f //x=10.97 //y=1.7
c283 ( 87 0 ) capacitor c=0.0234352f //x=10.97 //y=1.39
c284 ( 86 0 ) capacitor c=0.0199343f //x=10.97 //y=1.045
c285 ( 85 0 ) capacitor c=0.0432517f //x=4.285 //y=1.44
c286 ( 84 0 ) capacitor c=0.0200379f //x=4.285 //y=1.095
c287 ( 81 0 ) capacitor c=0.0158629f //x=4.13 //y=1.595
c288 ( 79 0 ) capacitor c=0.0157803f //x=4.13 //y=0.94
c289 ( 74 0 ) capacitor c=0.0218028f //x=3.755 //y=1.75
c290 ( 73 0 ) capacitor c=0.0207459f //x=3.755 //y=1.44
c291 ( 72 0 ) capacitor c=0.0194308f //x=3.755 //y=1.095
c292 ( 68 0 ) capacitor c=0.110275f //x=11.505 //y=6.2
c293 ( 67 0 ) capacitor c=0.154305f //x=11.065 //y=6.2
c294 ( 66 0 ) capacitor c=0.158794f //x=3.945 //y=6.2
c295 ( 65 0 ) capacitor c=0.110114f //x=3.505 //y=6.2
c296 ( 62 0 ) capacitor c=0.00106608f //x=8.535 //y=5.335
c297 ( 61 0 ) capacitor c=0.00212756f //x=7.655 //y=5.335
c298 ( 54 0 ) capacitor c=0.0897272f //x=11.165 //y=2.26
c299 ( 52 0 ) capacitor c=0.109027f //x=9.315 //y=3.51
c300 ( 48 0 ) capacitor c=0.00398962f //x=8.915 //y=1.845
c301 ( 47 0 ) capacitor c=0.0137288f //x=9.23 //y=1.845
c302 ( 41 0 ) capacitor c=0.0285553f //x=9.23 //y=5.335
c303 ( 33 0 ) capacitor c=0.0176454f //x=8.45 //y=5.335
c304 ( 26 0 ) capacitor c=0.00332903f //x=6.86 //y=5.335
c305 ( 25 0 ) capacitor c=0.0148863f //x=7.57 //y=5.335
c306 ( 12 0 ) capacitor c=0.0879612f //x=3.765 //y=2.26
c307 ( 4 0 ) capacitor c=0.00479603f //x=9.43 //y=3.51
c308 ( 3 0 ) capacitor c=0.0449509f //x=11.05 //y=3.51
c309 ( 2 0 ) capacitor c=0.0164246f //x=3.88 //y=3.51
c310 ( 1 0 ) capacitor c=0.14326f //x=9.2 //y=3.51
r311 (  117 119 ) resistor r=20.6867 //w=0.233 //l=0.1 //layer=ply \
 //thickness=0.18 //x=11.065 //y=4.88 //x2=11.165 //y2=4.88
r312 (  104 105 ) resistor r=52.7279 //w=0.214 //l=0.165 //layer=ply \
 //thickness=0.18 //x=3.765 //y=2.26 //x2=3.765 //y2=2.095
r313 (  100 119 ) resistor r=70.3348 //w=0.233 //l=0.414367 //layer=ply \
 //thickness=0.18 //x=11.505 //y=5.045 //x2=11.165 //y2=4.88
r314 (  99 121 ) resistor r=45.1352 //w=0.168 //l=0.173853 //layer=ply \
 //thickness=0.18 //x=11.5 //y=1.39 //x2=11.46 //y2=1.545
r315 (  98 120 ) resistor r=45.1352 //w=0.168 //l=0.173853 //layer=ply \
 //thickness=0.18 //x=11.5 //y=1.045 //x2=11.46 //y2=0.89
r316 (  98 99 ) resistor r=176.904 //w=0.094 //l=0.345 //layer=ply \
 //thickness=0.18 //x=11.5 //y=1.045 //x2=11.5 //y2=1.39
r317 (  96 116 ) resistor r=10.701 //w=0.21 //l=0.115 //layer=ply \
 //thickness=0.18 //x=11.125 //y=1.545 //x2=11.01 //y2=1.545
r318 (  95 121 ) resistor r=5.52526 //w=0.168 //l=0.115 //layer=ply \
 //thickness=0.18 //x=11.345 //y=1.545 //x2=11.46 //y2=1.545
r319 (  94 115 ) resistor r=5.52526 //w=0.168 //l=0.115 //layer=ply \
 //thickness=0.18 //x=11.125 //y=0.89 //x2=11.01 //y2=0.89
r320 (  93 120 ) resistor r=5.52526 //w=0.168 //l=0.115 //layer=ply \
 //thickness=0.18 //x=11.345 //y=0.89 //x2=11.46 //y2=0.89
r321 (  93 94 ) resistor r=112.809 //w=0.094 //l=0.22 //layer=ply \
 //thickness=0.18 //x=11.345 //y=0.89 //x2=11.125 //y2=0.89
r322 (  90 117 ) resistor r=13.0941 //w=0.233 //l=0.165 //layer=ply \
 //thickness=0.18 //x=11.065 //y=5.045 //x2=11.065 //y2=4.88
r323 (  89 114 ) resistor r=34.8111 //w=0.27 //l=0.264953 //layer=ply \
 //thickness=0.18 //x=10.97 //y=2.095 //x2=11.165 //y2=2.26
r324 (  88 116 ) resistor r=39.5823 //w=0.21 //l=0.173853 //layer=ply \
 //thickness=0.18 //x=10.97 //y=1.7 //x2=11.01 //y2=1.545
r325 (  88 89 ) resistor r=202.543 //w=0.094 //l=0.395 //layer=ply \
 //thickness=0.18 //x=10.97 //y=1.7 //x2=10.97 //y2=2.095
r326 (  87 116 ) resistor r=39.5823 //w=0.21 //l=0.173853 //layer=ply \
 //thickness=0.18 //x=10.97 //y=1.39 //x2=11.01 //y2=1.545
r327 (  86 115 ) resistor r=45.1352 //w=0.168 //l=0.173853 //layer=ply \
 //thickness=0.18 //x=10.97 //y=1.045 //x2=11.01 //y2=0.89
r328 (  86 87 ) resistor r=176.904 //w=0.094 //l=0.345 //layer=ply \
 //thickness=0.18 //x=10.97 //y=1.045 //x2=10.97 //y2=1.39
r329 (  85 112 ) resistor r=45.1352 //w=0.168 //l=0.173853 //layer=ply \
 //thickness=0.18 //x=4.285 //y=1.44 //x2=4.245 //y2=1.595
r330 (  84 111 ) resistor r=45.1352 //w=0.168 //l=0.173853 //layer=ply \
 //thickness=0.18 //x=4.285 //y=1.095 //x2=4.245 //y2=0.94
r331 (  84 85 ) resistor r=176.904 //w=0.094 //l=0.345 //layer=ply \
 //thickness=0.18 //x=4.285 //y=1.095 //x2=4.285 //y2=1.44
r332 (  82 108 ) resistor r=10.701 //w=0.21 //l=0.115 //layer=ply \
 //thickness=0.18 //x=3.91 //y=1.595 //x2=3.795 //y2=1.595
r333 (  81 112 ) resistor r=5.52526 //w=0.168 //l=0.115 //layer=ply \
 //thickness=0.18 //x=4.13 //y=1.595 //x2=4.245 //y2=1.595
r334 (  80 107 ) resistor r=5.52526 //w=0.168 //l=0.115 //layer=ply \
 //thickness=0.18 //x=3.91 //y=0.94 //x2=3.795 //y2=0.94
r335 (  79 111 ) resistor r=5.52526 //w=0.168 //l=0.115 //layer=ply \
 //thickness=0.18 //x=4.13 //y=0.94 //x2=4.245 //y2=0.94
r336 (  79 80 ) resistor r=112.809 //w=0.094 //l=0.22 //layer=ply \
 //thickness=0.18 //x=4.13 //y=0.94 //x2=3.91 //y2=0.94
r337 (  76 110 ) resistor r=37.236 //w=0.233 //l=0.249199 //layer=ply \
 //thickness=0.18 //x=3.945 //y=5.045 //x2=3.765 //y2=4.88
r338 (  74 108 ) resistor r=39.5823 //w=0.21 //l=0.173853 //layer=ply \
 //thickness=0.18 //x=3.755 //y=1.75 //x2=3.795 //y2=1.595
r339 (  74 105 ) resistor r=176.904 //w=0.094 //l=0.345 //layer=ply \
 //thickness=0.18 //x=3.755 //y=1.75 //x2=3.755 //y2=2.095
r340 (  73 108 ) resistor r=39.5823 //w=0.21 //l=0.173853 //layer=ply \
 //thickness=0.18 //x=3.755 //y=1.44 //x2=3.795 //y2=1.595
r341 (  72 107 ) resistor r=45.1352 //w=0.168 //l=0.173853 //layer=ply \
 //thickness=0.18 //x=3.755 //y=1.095 //x2=3.795 //y2=0.94
r342 (  72 73 ) resistor r=176.904 //w=0.094 //l=0.345 //layer=ply \
 //thickness=0.18 //x=3.755 //y=1.095 //x2=3.755 //y2=1.44
r343 (  69 110 ) resistor r=53.7854 //w=0.233 //l=0.332415 //layer=ply \
 //thickness=0.18 //x=3.505 //y=5.045 //x2=3.765 //y2=4.88
r344 (  68 100 ) resistor r=592.245 //w=0.094 //l=1.155 //layer=ply \
 //thickness=0.18 //x=11.505 //y=6.2 //x2=11.505 //y2=5.045
r345 (  67 90 ) resistor r=592.245 //w=0.094 //l=1.155 //layer=ply \
 //thickness=0.18 //x=11.065 //y=6.2 //x2=11.065 //y2=5.045
r346 (  66 76 ) resistor r=592.245 //w=0.094 //l=1.155 //layer=ply \
 //thickness=0.18 //x=3.945 //y=6.2 //x2=3.945 //y2=5.045
r347 (  65 69 ) resistor r=592.245 //w=0.094 //l=1.155 //layer=ply \
 //thickness=0.18 //x=3.505 //y=6.2 //x2=3.505 //y2=5.045
r348 (  64 95 ) resistor r=56.4043 //w=0.094 //l=0.11 //layer=ply \
 //thickness=0.18 //x=11.235 //y=1.545 //x2=11.345 //y2=1.545
r349 (  64 96 ) resistor r=56.4043 //w=0.094 //l=0.11 //layer=ply \
 //thickness=0.18 //x=11.235 //y=1.545 //x2=11.125 //y2=1.545
r350 (  63 81 ) resistor r=56.4043 //w=0.094 //l=0.11 //layer=ply \
 //thickness=0.18 //x=4.02 //y=1.595 //x2=4.13 //y2=1.595
r351 (  63 82 ) resistor r=56.4043 //w=0.094 //l=0.11 //layer=ply \
 //thickness=0.18 //x=4.02 //y=1.595 //x2=3.91 //y2=1.595
r352 (  59 119 ) resistor r=152 //w=0.17 //l=0.17 //layer=licon //count=1 \
 //x=11.165 //y=4.88 //x2=11.165 //y2=4.88
r353 (  57 59 ) resistor r=93.7754 //w=0.187 //l=1.37 //layer=li \
 //thickness=0.1 //x=11.165 //y=3.51 //x2=11.165 //y2=4.88
r354 (  54 114 ) resistor r=152 //w=0.17 //l=0.17 //layer=licon //count=1 \
 //x=11.165 //y=2.26 //x2=11.165 //y2=2.26
r355 (  54 57 ) resistor r=85.5615 //w=0.187 //l=1.25 //layer=li \
 //thickness=0.1 //x=11.165 //y=2.26 //x2=11.165 //y2=3.51
r356 (  50 52 ) resistor r=119.102 //w=0.187 //l=1.74 //layer=li \
 //thickness=0.1 //x=9.315 //y=5.25 //x2=9.315 //y2=3.51
r357 (  49 52 ) resistor r=108.15 //w=0.187 //l=1.58 //layer=li \
 //thickness=0.1 //x=9.315 //y=1.93 //x2=9.315 //y2=3.51
r358 (  47 49 ) resistor r=7.15173 //w=0.17 //l=0.120208 //layer=li \
 //thickness=0.1 //x=9.23 //y=1.845 //x2=9.315 //y2=1.93
r359 (  47 48 ) resistor r=21.5615 //w=0.187 //l=0.315 //layer=li \
 //thickness=0.1 //x=9.23 //y=1.845 //x2=8.915 //y2=1.845
r360 (  43 48 ) resistor r=7.15173 //w=0.17 //l=0.120208 //layer=li \
 //thickness=0.1 //x=8.83 //y=1.76 //x2=8.915 //y2=1.845
r361 (  43 122 ) resistor r=39.016 //w=0.187 //l=0.57 //layer=li \
 //thickness=0.1 //x=8.83 //y=1.76 //x2=8.83 //y2=1.19
r362 (  42 62 ) resistor r=5.4201 //w=0.17 //l=0.085 //layer=li \
 //thickness=0.1 //x=8.62 //y=5.335 //x2=8.535 //y2=5.335
r363 (  41 50 ) resistor r=7.15173 //w=0.17 //l=0.120208 //layer=li \
 //thickness=0.1 //x=9.23 //y=5.335 //x2=9.315 //y2=5.25
r364 (  41 42 ) resistor r=41.754 //w=0.187 //l=0.61 //layer=li \
 //thickness=0.1 //x=9.23 //y=5.335 //x2=8.62 //y2=5.335
r365 (  35 62 ) resistor r=1.40859 //w=0.34 //l=0.085 //layer=li \
 //thickness=0.1 //x=8.535 //y=5.42 //x2=8.535 //y2=5.335
r366 (  35 126 ) resistor r=33.1979 //w=0.187 //l=0.485 //layer=li \
 //thickness=0.1 //x=8.535 //y=5.42 //x2=8.535 //y2=5.905
r367 (  34 61 ) resistor r=5.4201 //w=0.17 //l=0.085 //layer=li \
 //thickness=0.1 //x=7.74 //y=5.335 //x2=7.655 //y2=5.335
r368 (  33 62 ) resistor r=5.4201 //w=0.17 //l=0.085 //layer=li \
 //thickness=0.1 //x=8.45 //y=5.335 //x2=8.535 //y2=5.335
r369 (  33 34 ) resistor r=48.5989 //w=0.187 //l=0.71 //layer=li \
 //thickness=0.1 //x=8.45 //y=5.335 //x2=7.74 //y2=5.335
r370 (  27 61 ) resistor r=1.40859 //w=0.34 //l=0.085 //layer=li \
 //thickness=0.1 //x=7.655 //y=5.42 //x2=7.655 //y2=5.335
r371 (  27 125 ) resistor r=33.1979 //w=0.187 //l=0.485 //layer=li \
 //thickness=0.1 //x=7.655 //y=5.42 //x2=7.655 //y2=5.905
r372 (  25 61 ) resistor r=5.4201 //w=0.17 //l=0.085 //layer=li \
 //thickness=0.1 //x=7.57 //y=5.335 //x2=7.655 //y2=5.335
r373 (  25 26 ) resistor r=48.5989 //w=0.187 //l=0.71 //layer=li \
 //thickness=0.1 //x=7.57 //y=5.335 //x2=6.86 //y2=5.335
r374 (  19 26 ) resistor r=7.15173 //w=0.17 //l=0.120208 //layer=li \
 //thickness=0.1 //x=6.775 //y=5.42 //x2=6.86 //y2=5.335
r375 (  19 124 ) resistor r=33.1979 //w=0.187 //l=0.485 //layer=li \
 //thickness=0.1 //x=6.775 //y=5.42 //x2=6.775 //y2=5.905
r376 (  17 110 ) resistor r=152 //w=0.17 //l=0.17 //layer=licon //count=1 \
 //x=3.765 //y=4.88 //x2=3.765 //y2=4.88
r377 (  15 17 ) resistor r=93.7754 //w=0.187 //l=1.37 //layer=li \
 //thickness=0.1 //x=3.765 //y=3.51 //x2=3.765 //y2=4.88
r378 (  12 104 ) resistor r=152 //w=0.17 //l=0.17 //layer=licon //count=1 \
 //x=3.765 //y=2.26 //x2=3.765 //y2=2.26
r379 (  12 15 ) resistor r=85.5615 //w=0.187 //l=1.25 //layer=li \
 //thickness=0.1 //x=3.765 //y=2.26 //x2=3.765 //y2=3.51
r380 (  10 57 ) resistor r=9.3 //w=0.17 //l=0.17 //layer=mcon //count=1 \
 //x=11.165 //y=3.51 //x2=11.165 //y2=3.51
r381 (  8 52 ) resistor r=9.3 //w=0.17 //l=0.17 //layer=mcon //count=1 \
 //x=9.315 //y=3.51 //x2=9.315 //y2=3.51
r382 (  6 15 ) resistor r=9.3 //w=0.17 //l=0.17 //layer=mcon //count=1 \
 //x=3.765 //y=3.51 //x2=3.765 //y2=3.51
r383 (  4 8 ) resistor r=0.0880901 //w=0.191 //l=0.115 //layer=m1 \
 //thickness=0.36 //x=9.43 //y=3.51 //x2=9.315 //y2=3.51
r384 (  3 10 ) resistor r=0.0717383 //w=0.224 //l=0.115 //layer=m1 \
 //thickness=0.36 //x=11.05 //y=3.51 //x2=11.165 //y2=3.51
r385 (  3 4 ) resistor r=1.5458 //w=0.131 //l=1.62 //layer=m1 //thickness=0.36 \
 //x=11.05 //y=3.51 //x2=9.43 //y2=3.51
r386 (  2 6 ) resistor r=0.0717383 //w=0.224 //l=0.115 //layer=m1 \
 //thickness=0.36 //x=3.88 //y=3.51 //x2=3.765 //y2=3.51
r387 (  1 8 ) resistor r=0.0880901 //w=0.191 //l=0.115 //layer=m1 \
 //thickness=0.36 //x=9.2 //y=3.51 //x2=9.315 //y2=3.51
r388 (  1 2 ) resistor r=5.07634 //w=0.131 //l=5.32 //layer=m1 \
 //thickness=0.36 //x=9.2 //y=3.51 //x2=3.88 //y2=3.51
ends PM_DFFRNQX1\%noxref_3

subckt PM_DFFRNQX1\%noxref_4 ( 1 2 13 14 25 27 28 32 34 41 42 43 44 45 46 47 \
 48 49 51 57 58 59 60 72 74 75 )
c149 ( 75 0 ) capacitor c=0.0220291f //x=12.02 //y=5.2
c150 ( 74 0 ) capacitor c=0.0217503f //x=11.14 //y=5.2
c151 ( 72 0 ) capacitor c=0.0084702f //x=12.015 //y=1.085
c152 ( 60 0 ) capacitor c=0.0556143f //x=14.77 //y=4.97
c153 ( 59 0 ) capacitor c=0.0293157f //x=15.06 //y=4.97
c154 ( 58 0 ) capacitor c=0.0347816f //x=14.725 //y=1.4
c155 ( 57 0 ) capacitor c=0.0187487f //x=14.725 //y=1.055
c156 ( 51 0 ) capacitor c=0.0137055f //x=14.57 //y=1.555
c157 ( 49 0 ) capacitor c=0.0149861f //x=14.57 //y=0.9
c158 ( 48 0 ) capacitor c=0.096037f //x=14.195 //y=2.095
c159 ( 47 0 ) capacitor c=0.0228993f //x=14.195 //y=1.71
c160 ( 46 0 ) capacitor c=0.0234352f //x=14.195 //y=1.4
c161 ( 45 0 ) capacitor c=0.0198724f //x=14.195 //y=1.055
c162 ( 44 0 ) capacitor c=0.110114f //x=15.135 //y=6.2
c163 ( 43 0 ) capacitor c=0.158956f //x=14.695 //y=6.2
c164 ( 41 0 ) capacitor c=0.00211606f //x=12.165 //y=5.38
c165 ( 34 0 ) capacitor c=0.0998491f //x=14.495 //y=2.26
c166 ( 32 0 ) capacitor c=0.10775f //x=12.645 //y=3.51
c167 ( 28 0 ) capacitor c=0.00404073f //x=12.29 //y=1.835
c168 ( 27 0 ) capacitor c=0.0122201f //x=12.56 //y=1.835
c169 ( 25 0 ) capacitor c=0.0137995f //x=12.56 //y=5.38
c170 ( 14 0 ) capacitor c=0.00251635f //x=11.37 //y=5.38
c171 ( 13 0 ) capacitor c=0.0143649f //x=12.08 //y=5.38
c172 ( 2 0 ) capacitor c=0.00733653f //x=12.76 //y=3.51
c173 ( 1 0 ) capacitor c=0.0503252f //x=14.38 //y=3.51
r174 (  59 61 ) resistor r=26.9307 //w=0.15 //l=0.106066 //layer=ply \
 //thickness=0.18 //x=15.06 //y=4.97 //x2=15.135 //y2=5.045
r175 (  59 60 ) resistor r=148.702 //w=0.094 //l=0.29 //layer=ply \
 //thickness=0.18 //x=15.06 //y=4.97 //x2=14.77 //y2=4.97
r176 (  58 71 ) resistor r=45.1352 //w=0.168 //l=0.173853 //layer=ply \
 //thickness=0.18 //x=14.725 //y=1.4 //x2=14.685 //y2=1.555
r177 (  57 70 ) resistor r=45.1352 //w=0.168 //l=0.173853 //layer=ply \
 //thickness=0.18 //x=14.725 //y=1.055 //x2=14.685 //y2=0.9
r178 (  57 58 ) resistor r=176.904 //w=0.094 //l=0.345 //layer=ply \
 //thickness=0.18 //x=14.725 //y=1.055 //x2=14.725 //y2=1.4
r179 (  54 60 ) resistor r=22.7971 //w=0.269 //l=0.106066 //layer=ply \
 //thickness=0.18 //x=14.695 //y=5.045 //x2=14.77 //y2=4.97
r180 (  54 69 ) resistor r=35.8364 //w=0.269 //l=0.270185 //layer=ply \
 //thickness=0.18 //x=14.695 //y=5.045 //x2=14.495 //y2=4.88
r181 (  52 65 ) resistor r=10.701 //w=0.21 //l=0.115 //layer=ply \
 //thickness=0.18 //x=14.35 //y=1.555 //x2=14.235 //y2=1.555
r182 (  51 71 ) resistor r=5.52526 //w=0.168 //l=0.115 //layer=ply \
 //thickness=0.18 //x=14.57 //y=1.555 //x2=14.685 //y2=1.555
r183 (  50 64 ) resistor r=5.52526 //w=0.168 //l=0.115 //layer=ply \
 //thickness=0.18 //x=14.35 //y=0.9 //x2=14.235 //y2=0.9
r184 (  49 70 ) resistor r=5.52526 //w=0.168 //l=0.115 //layer=ply \
 //thickness=0.18 //x=14.57 //y=0.9 //x2=14.685 //y2=0.9
r185 (  49 50 ) resistor r=112.809 //w=0.094 //l=0.22 //layer=ply \
 //thickness=0.18 //x=14.57 //y=0.9 //x2=14.35 //y2=0.9
r186 (  48 67 ) resistor r=58.7805 //w=0.246 //l=0.373497 //layer=ply \
 //thickness=0.18 //x=14.195 //y=2.095 //x2=14.495 //y2=2.26
r187 (  47 65 ) resistor r=39.5823 //w=0.21 //l=0.173853 //layer=ply \
 //thickness=0.18 //x=14.195 //y=1.71 //x2=14.235 //y2=1.555
r188 (  47 48 ) resistor r=197.415 //w=0.094 //l=0.385 //layer=ply \
 //thickness=0.18 //x=14.195 //y=1.71 //x2=14.195 //y2=2.095
r189 (  46 65 ) resistor r=39.5823 //w=0.21 //l=0.173853 //layer=ply \
 //thickness=0.18 //x=14.195 //y=1.4 //x2=14.235 //y2=1.555
r190 (  45 64 ) resistor r=45.1352 //w=0.168 //l=0.173853 //layer=ply \
 //thickness=0.18 //x=14.195 //y=1.055 //x2=14.235 //y2=0.9
r191 (  45 46 ) resistor r=176.904 //w=0.094 //l=0.345 //layer=ply \
 //thickness=0.18 //x=14.195 //y=1.055 //x2=14.195 //y2=1.4
r192 (  44 61 ) resistor r=592.245 //w=0.094 //l=1.155 //layer=ply \
 //thickness=0.18 //x=15.135 //y=6.2 //x2=15.135 //y2=5.045
r193 (  43 54 ) resistor r=592.245 //w=0.094 //l=1.155 //layer=ply \
 //thickness=0.18 //x=14.695 //y=6.2 //x2=14.695 //y2=5.045
r194 (  42 51 ) resistor r=56.4043 //w=0.094 //l=0.11 //layer=ply \
 //thickness=0.18 //x=14.46 //y=1.555 //x2=14.57 //y2=1.555
r195 (  42 52 ) resistor r=56.4043 //w=0.094 //l=0.11 //layer=ply \
 //thickness=0.18 //x=14.46 //y=1.555 //x2=14.35 //y2=1.555
r196 (  39 69 ) resistor r=152 //w=0.17 //l=0.17 //layer=licon //count=1 \
 //x=14.495 //y=4.88 //x2=14.495 //y2=4.88
r197 (  37 39 ) resistor r=93.7754 //w=0.187 //l=1.37 //layer=li \
 //thickness=0.1 //x=14.495 //y=3.51 //x2=14.495 //y2=4.88
r198 (  34 67 ) resistor r=152 //w=0.17 //l=0.17 //layer=licon //count=1 \
 //x=14.495 //y=2.26 //x2=14.495 //y2=2.26
r199 (  34 37 ) resistor r=85.5615 //w=0.187 //l=1.25 //layer=li \
 //thickness=0.1 //x=14.495 //y=2.26 //x2=14.495 //y2=3.51
r200 (  30 32 ) resistor r=122.182 //w=0.187 //l=1.785 //layer=li \
 //thickness=0.1 //x=12.645 //y=5.295 //x2=12.645 //y2=3.51
r201 (  29 32 ) resistor r=108.834 //w=0.187 //l=1.59 //layer=li \
 //thickness=0.1 //x=12.645 //y=1.92 //x2=12.645 //y2=3.51
r202 (  27 29 ) resistor r=7.15173 //w=0.17 //l=0.120208 //layer=li \
 //thickness=0.1 //x=12.56 //y=1.835 //x2=12.645 //y2=1.92
r203 (  27 28 ) resistor r=18.4813 //w=0.187 //l=0.27 //layer=li \
 //thickness=0.1 //x=12.56 //y=1.835 //x2=12.29 //y2=1.835
r204 (  26 41 ) resistor r=5.4201 //w=0.17 //l=0.085 //layer=li \
 //thickness=0.1 //x=12.25 //y=5.38 //x2=12.165 //y2=5.38
r205 (  25 30 ) resistor r=7.15173 //w=0.17 //l=0.120208 //layer=li \
 //thickness=0.1 //x=12.56 //y=5.38 //x2=12.645 //y2=5.295
r206 (  25 26 ) resistor r=21.2193 //w=0.187 //l=0.31 //layer=li \
 //thickness=0.1 //x=12.56 //y=5.38 //x2=12.25 //y2=5.38
r207 (  21 28 ) resistor r=7.15173 //w=0.17 //l=0.120208 //layer=li \
 //thickness=0.1 //x=12.205 //y=1.75 //x2=12.29 //y2=1.835
r208 (  21 72 ) resistor r=39.016 //w=0.187 //l=0.57 //layer=li \
 //thickness=0.1 //x=12.205 //y=1.75 //x2=12.205 //y2=1.18
r209 (  15 41 ) resistor r=1.40859 //w=0.34 //l=0.085 //layer=li \
 //thickness=0.1 //x=12.165 //y=5.465 //x2=12.165 //y2=5.38
r210 (  15 75 ) resistor r=30.1176 //w=0.187 //l=0.44 //layer=li \
 //thickness=0.1 //x=12.165 //y=5.465 //x2=12.165 //y2=5.905
r211 (  13 41 ) resistor r=5.4201 //w=0.17 //l=0.085 //layer=li \
 //thickness=0.1 //x=12.08 //y=5.38 //x2=12.165 //y2=5.38
r212 (  13 14 ) resistor r=48.5989 //w=0.187 //l=0.71 //layer=li \
 //thickness=0.1 //x=12.08 //y=5.38 //x2=11.37 //y2=5.38
r213 (  7 14 ) resistor r=7.15173 //w=0.17 //l=0.120208 //layer=li \
 //thickness=0.1 //x=11.285 //y=5.465 //x2=11.37 //y2=5.38
r214 (  7 74 ) resistor r=30.1176 //w=0.187 //l=0.44 //layer=li \
 //thickness=0.1 //x=11.285 //y=5.465 //x2=11.285 //y2=5.905
r215 (  6 37 ) resistor r=9.3 //w=0.17 //l=0.17 //layer=mcon //count=1 \
 //x=14.495 //y=3.51 //x2=14.495 //y2=3.51
r216 (  4 32 ) resistor r=9.3 //w=0.17 //l=0.17 //layer=mcon //count=1 \
 //x=12.645 //y=3.51 //x2=12.645 //y2=3.51
r217 (  2 4 ) resistor r=0.0717383 //w=0.224 //l=0.115 //layer=m1 \
 //thickness=0.36 //x=12.76 //y=3.51 //x2=12.645 //y2=3.51
r218 (  1 6 ) resistor r=0.0717383 //w=0.224 //l=0.115 //layer=m1 \
 //thickness=0.36 //x=14.38 //y=3.51 //x2=14.495 //y2=3.51
r219 (  1 2 ) resistor r=1.5458 //w=0.131 //l=1.62 //layer=m1 //thickness=0.36 \
 //x=14.38 //y=3.51 //x2=12.76 //y2=3.51
ends PM_DFFRNQX1\%noxref_4

subckt PM_DFFRNQX1\%CLK ( 1 2 7 8 9 10 11 12 13 14 15 18 30 34 44 50 53 56 60 \
 66 69 73 75 76 77 78 79 80 81 82 83 85 91 92 93 94 95 100 101 102 104 110 111 \
 112 113 114 122 133 )
c252 ( 133 0 ) capacitor c=0.0334004f //x=15.605 //y=4.88
c253 ( 122 0 ) capacitor c=0.0334004f //x=2.655 //y=4.88
c254 ( 114 0 ) capacitor c=0.0246513f //x=15.94 //y=4.97
c255 ( 113 0 ) capacitor c=0.0825646f //x=15.695 //y=2.095
c256 ( 112 0 ) capacitor c=0.0170266f //x=15.695 //y=1.63
c257 ( 111 0 ) capacitor c=0.018609f //x=15.695 //y=1.4
c258 ( 110 0 ) capacitor c=0.0187309f //x=15.695 //y=1.09
c259 ( 104 0 ) capacitor c=0.014725f //x=15.54 //y=1.555
c260 ( 102 0 ) capacitor c=0.0146567f //x=15.54 //y=0.935
c261 ( 101 0 ) capacitor c=0.0335408f //x=15.17 //y=1.4
c262 ( 100 0 ) capacitor c=0.0173761f //x=15.17 //y=1.09
c263 ( 95 0 ) capacitor c=0.0242579f //x=2.99 //y=4.97
c264 ( 94 0 ) capacitor c=0.0836699f //x=2.745 //y=2.095
c265 ( 93 0 ) capacitor c=0.0170266f //x=2.745 //y=1.63
c266 ( 92 0 ) capacitor c=0.018609f //x=2.745 //y=1.4
c267 ( 91 0 ) capacitor c=0.0187309f //x=2.745 //y=1.09
c268 ( 85 0 ) capacitor c=0.014725f //x=2.59 //y=1.555
c269 ( 83 0 ) capacitor c=0.0146567f //x=2.59 //y=0.935
c270 ( 82 0 ) capacitor c=0.0335408f //x=2.22 //y=1.4
c271 ( 81 0 ) capacitor c=0.0173761f //x=2.22 //y=1.09
c272 ( 80 0 ) capacitor c=0.110114f //x=16.015 //y=6.2
c273 ( 79 0 ) capacitor c=0.11012f //x=15.575 //y=6.2
c274 ( 78 0 ) capacitor c=0.110114f //x=3.065 //y=6.2
c275 ( 77 0 ) capacitor c=0.11012f //x=2.625 //y=6.2
c276 ( 73 0 ) capacitor c=0.0346129f //x=15.632 //y=4.535
c277 ( 69 0 ) capacitor c=0.00846054f //x=15.632 //y=3.425
c278 ( 66 0 ) capacitor c=0.00874422f //x=15.632 //y=3.055
c279 ( 60 0 ) capacitor c=0.021333f //x=2.682 //y=4.535
c280 ( 56 0 ) capacitor c=0.00840571f //x=2.682 //y=3.795
c281 ( 53 0 ) capacitor c=0.00846054f //x=2.682 //y=3.425
c282 ( 50 0 ) capacitor c=0.00874422f //x=2.682 //y=3.055
c283 ( 44 0 ) capacitor c=0.00474631f //x=15.605 //y=4.88
c284 ( 34 0 ) capacitor c=0.0125579f //x=15.605 //y=2.26
c285 ( 30 0 ) capacitor c=0.00474631f //x=2.655 //y=4.88
c286 ( 18 0 ) capacitor c=0.0153402f //x=2.655 //y=2.26
c287 ( 15 0 ) capacitor c=0.00589586f //x=15.66 //y=4.62
c288 ( 14 0 ) capacitor c=0.00852122f //x=15.66 //y=3.51
c289 ( 13 0 ) capacitor c=0.00839732f //x=15.66 //y=3.14
c290 ( 12 0 ) capacitor c=0.00834842f //x=15.66 //y=2.77
c291 ( 11 0 ) capacitor c=0.00579039f //x=2.71 //y=4.62
c292 ( 10 0 ) capacitor c=0.00833816f //x=2.71 //y=3.88
c293 ( 9 0 ) capacitor c=0.00769643f //x=2.71 //y=3.51
c294 ( 8 0 ) capacitor c=0.00838372f //x=2.71 //y=3.14
c295 ( 7 0 ) capacitor c=0.00841072f //x=2.71 //y=2.77
c296 ( 2 0 ) capacitor c=0.0154682f //x=2.77 //y=4.62
c297 ( 1 0 ) capacitor c=0.292284f //x=15.49 //y=4.62
r298 (  135 136 ) resistor r=32.4568 //w=0.214 //l=0.075 //layer=ply \
 //thickness=0.18 //x=15.605 //y=4.97 //x2=15.605 //y2=5.045
r299 (  133 135 ) resistor r=20.271 //w=0.214 //l=0.09 //layer=ply \
 //thickness=0.18 //x=15.605 //y=4.88 //x2=15.605 //y2=4.97
r300 (  124 125 ) resistor r=32.4568 //w=0.214 //l=0.075 //layer=ply \
 //thickness=0.18 //x=2.655 //y=4.97 //x2=2.655 //y2=5.045
r301 (  122 124 ) resistor r=20.271 //w=0.214 //l=0.09 //layer=ply \
 //thickness=0.18 //x=2.655 //y=4.88 //x2=2.655 //y2=4.97
r302 (  115 135 ) resistor r=16.5046 //w=0.27 //l=0.135 //layer=ply \
 //thickness=0.18 //x=15.74 //y=4.97 //x2=15.605 //y2=4.97
r303 (  114 116 ) resistor r=26.9307 //w=0.15 //l=0.106066 //layer=ply \
 //thickness=0.18 //x=15.94 //y=4.97 //x2=16.015 //y2=5.045
r304 (  114 115 ) resistor r=102.553 //w=0.094 //l=0.2 //layer=ply \
 //thickness=0.18 //x=15.94 //y=4.97 //x2=15.74 //y2=4.97
r305 (  113 140 ) resistor r=38.6777 //w=0.284 //l=0.198997 //layer=ply \
 //thickness=0.18 //x=15.695 //y=2.095 //x2=15.62 //y2=2.26
r306 (  112 138 ) resistor r=21.2976 //w=0.217 //l=0.0928709 //layer=ply \
 //thickness=0.18 //x=15.695 //y=1.63 //x2=15.655 //y2=1.555
r307 (  112 113 ) resistor r=238.436 //w=0.094 //l=0.465 //layer=ply \
 //thickness=0.18 //x=15.695 //y=1.63 //x2=15.695 //y2=2.095
r308 (  111 138 ) resistor r=39.0671 //w=0.217 //l=0.173853 //layer=ply \
 //thickness=0.18 //x=15.695 //y=1.4 //x2=15.655 //y2=1.555
r309 (  110 137 ) resistor r=45.1352 //w=0.168 //l=0.173853 //layer=ply \
 //thickness=0.18 //x=15.695 //y=1.09 //x2=15.655 //y2=0.935
r310 (  110 111 ) resistor r=158.957 //w=0.094 //l=0.31 //layer=ply \
 //thickness=0.18 //x=15.695 //y=1.09 //x2=15.695 //y2=1.4
r311 (  105 131 ) resistor r=5.52526 //w=0.168 //l=0.115 //layer=ply \
 //thickness=0.18 //x=15.325 //y=1.555 //x2=15.21 //y2=1.555
r312 (  104 138 ) resistor r=11.4558 //w=0.217 //l=0.115 //layer=ply \
 //thickness=0.18 //x=15.54 //y=1.555 //x2=15.655 //y2=1.555
r313 (  103 130 ) resistor r=5.52526 //w=0.168 //l=0.115 //layer=ply \
 //thickness=0.18 //x=15.325 //y=0.935 //x2=15.21 //y2=0.935
r314 (  102 137 ) resistor r=5.52526 //w=0.168 //l=0.115 //layer=ply \
 //thickness=0.18 //x=15.54 //y=0.935 //x2=15.655 //y2=0.935
r315 (  102 103 ) resistor r=110.245 //w=0.094 //l=0.215 //layer=ply \
 //thickness=0.18 //x=15.54 //y=0.935 //x2=15.325 //y2=0.935
r316 (  101 131 ) resistor r=45.1352 //w=0.168 //l=0.173853 //layer=ply \
 //thickness=0.18 //x=15.17 //y=1.4 //x2=15.21 //y2=1.555
r317 (  100 130 ) resistor r=45.1352 //w=0.168 //l=0.173853 //layer=ply \
 //thickness=0.18 //x=15.17 //y=1.09 //x2=15.21 //y2=0.935
r318 (  100 101 ) resistor r=158.957 //w=0.094 //l=0.31 //layer=ply \
 //thickness=0.18 //x=15.17 //y=1.09 //x2=15.17 //y2=1.4
r319 (  96 124 ) resistor r=16.5046 //w=0.27 //l=0.135 //layer=ply \
 //thickness=0.18 //x=2.79 //y=4.97 //x2=2.655 //y2=4.97
r320 (  95 97 ) resistor r=26.9307 //w=0.15 //l=0.106066 //layer=ply \
 //thickness=0.18 //x=2.99 //y=4.97 //x2=3.065 //y2=5.045
r321 (  95 96 ) resistor r=102.553 //w=0.094 //l=0.2 //layer=ply \
 //thickness=0.18 //x=2.99 //y=4.97 //x2=2.79 //y2=4.97
r322 (  94 129 ) resistor r=38.6777 //w=0.284 //l=0.198997 //layer=ply \
 //thickness=0.18 //x=2.745 //y=2.095 //x2=2.67 //y2=2.26
r323 (  93 127 ) resistor r=21.2976 //w=0.217 //l=0.0928709 //layer=ply \
 //thickness=0.18 //x=2.745 //y=1.63 //x2=2.705 //y2=1.555
r324 (  93 94 ) resistor r=238.436 //w=0.094 //l=0.465 //layer=ply \
 //thickness=0.18 //x=2.745 //y=1.63 //x2=2.745 //y2=2.095
r325 (  92 127 ) resistor r=39.0671 //w=0.217 //l=0.173853 //layer=ply \
 //thickness=0.18 //x=2.745 //y=1.4 //x2=2.705 //y2=1.555
r326 (  91 126 ) resistor r=45.1352 //w=0.168 //l=0.173853 //layer=ply \
 //thickness=0.18 //x=2.745 //y=1.09 //x2=2.705 //y2=0.935
r327 (  91 92 ) resistor r=158.957 //w=0.094 //l=0.31 //layer=ply \
 //thickness=0.18 //x=2.745 //y=1.09 //x2=2.745 //y2=1.4
r328 (  86 120 ) resistor r=5.52526 //w=0.168 //l=0.115 //layer=ply \
 //thickness=0.18 //x=2.375 //y=1.555 //x2=2.26 //y2=1.555
r329 (  85 127 ) resistor r=11.4558 //w=0.217 //l=0.115 //layer=ply \
 //thickness=0.18 //x=2.59 //y=1.555 //x2=2.705 //y2=1.555
r330 (  84 119 ) resistor r=5.52526 //w=0.168 //l=0.115 //layer=ply \
 //thickness=0.18 //x=2.375 //y=0.935 //x2=2.26 //y2=0.935
r331 (  83 126 ) resistor r=5.52526 //w=0.168 //l=0.115 //layer=ply \
 //thickness=0.18 //x=2.59 //y=0.935 //x2=2.705 //y2=0.935
r332 (  83 84 ) resistor r=110.245 //w=0.094 //l=0.215 //layer=ply \
 //thickness=0.18 //x=2.59 //y=0.935 //x2=2.375 //y2=0.935
r333 (  82 120 ) resistor r=45.1352 //w=0.168 //l=0.173853 //layer=ply \
 //thickness=0.18 //x=2.22 //y=1.4 //x2=2.26 //y2=1.555
r334 (  81 119 ) resistor r=45.1352 //w=0.168 //l=0.173853 //layer=ply \
 //thickness=0.18 //x=2.22 //y=1.09 //x2=2.26 //y2=0.935
r335 (  81 82 ) resistor r=158.957 //w=0.094 //l=0.31 //layer=ply \
 //thickness=0.18 //x=2.22 //y=1.09 //x2=2.22 //y2=1.4
r336 (  80 116 ) resistor r=592.245 //w=0.094 //l=1.155 //layer=ply \
 //thickness=0.18 //x=16.015 //y=6.2 //x2=16.015 //y2=5.045
r337 (  79 136 ) resistor r=592.245 //w=0.094 //l=1.155 //layer=ply \
 //thickness=0.18 //x=15.575 //y=6.2 //x2=15.575 //y2=5.045
r338 (  78 97 ) resistor r=592.245 //w=0.094 //l=1.155 //layer=ply \
 //thickness=0.18 //x=3.065 //y=6.2 //x2=3.065 //y2=5.045
r339 (  77 125 ) resistor r=592.245 //w=0.094 //l=1.155 //layer=ply \
 //thickness=0.18 //x=2.625 //y=6.2 //x2=2.625 //y2=5.045
r340 (  76 104 ) resistor r=55.3787 //w=0.094 //l=0.108 //layer=ply \
 //thickness=0.18 //x=15.432 //y=1.555 //x2=15.54 //y2=1.555
r341 (  76 105 ) resistor r=54.866 //w=0.094 //l=0.107 //layer=ply \
 //thickness=0.18 //x=15.432 //y=1.555 //x2=15.325 //y2=1.555
r342 (  75 85 ) resistor r=55.3787 //w=0.094 //l=0.108 //layer=ply \
 //thickness=0.18 //x=2.482 //y=1.555 //x2=2.59 //y2=1.555
r343 (  75 86 ) resistor r=54.866 //w=0.094 //l=0.107 //layer=ply \
 //thickness=0.18 //x=2.482 //y=1.555 //x2=2.375 //y2=1.555
r344 (  70 73 ) resistor r=64.3422 //w=0.187 //l=0.94 //layer=li \
 //thickness=0.1 //x=15.605 //y=3.595 //x2=15.605 //y2=4.535
r345 (  67 69 ) resistor r=13.6898 //w=0.187 //l=0.2 //layer=li \
 //thickness=0.1 //x=15.605 //y=3.225 //x2=15.605 //y2=3.425
r346 (  64 66 ) resistor r=13.6898 //w=0.187 //l=0.2 //layer=li \
 //thickness=0.1 //x=15.605 //y=2.855 //x2=15.605 //y2=3.055
r347 (  57 60 ) resistor r=39.016 //w=0.187 //l=0.57 //layer=li \
 //thickness=0.1 //x=2.655 //y=3.965 //x2=2.655 //y2=4.535
r348 (  54 56 ) resistor r=13.6898 //w=0.187 //l=0.2 //layer=li \
 //thickness=0.1 //x=2.655 //y=3.595 //x2=2.655 //y2=3.795
r349 (  51 53 ) resistor r=13.6898 //w=0.187 //l=0.2 //layer=li \
 //thickness=0.1 //x=2.655 //y=3.225 //x2=2.655 //y2=3.425
r350 (  48 50 ) resistor r=13.6898 //w=0.187 //l=0.2 //layer=li \
 //thickness=0.1 //x=2.655 //y=2.855 //x2=2.655 //y2=3.055
r351 (  44 133 ) resistor r=152 //w=0.17 //l=0.17 //layer=licon //count=1 \
 //x=15.605 //y=4.88 //x2=15.605 //y2=4.88
r352 (  44 74 ) resistor r=11.9786 //w=0.187 //l=0.175 //layer=li \
 //thickness=0.1 //x=15.605 //y=4.88 //x2=15.605 //y2=4.705
r353 (  34 140 ) resistor r=152 //w=0.17 //l=0.17 //layer=licon //count=1 \
 //x=15.605 //y=2.26 //x2=15.605 //y2=2.26
r354 (  34 63 ) resistor r=29.0909 //w=0.187 //l=0.425 //layer=li \
 //thickness=0.1 //x=15.605 //y=2.26 //x2=15.605 //y2=2.685
r355 (  30 122 ) resistor r=152 //w=0.17 //l=0.17 //layer=licon //count=1 \
 //x=2.655 //y=4.88 //x2=2.655 //y2=4.88
r356 (  30 61 ) resistor r=11.9786 //w=0.187 //l=0.175 //layer=li \
 //thickness=0.1 //x=2.655 //y=4.88 //x2=2.655 //y2=4.705
r357 (  18 129 ) resistor r=152 //w=0.17 //l=0.17 //layer=licon //count=1 \
 //x=2.655 //y=2.26 //x2=2.655 //y2=2.26
r358 (  18 47 ) resistor r=29.0909 //w=0.187 //l=0.425 //layer=li \
 //thickness=0.1 //x=2.655 //y=2.26 //x2=2.655 //y2=2.685
r359 (  15 74 ) resistor r=5.1957 //w=0.242 //l=0.085 //layer=li \
 //thickness=0.1 //x=15.632 //y=4.62 //x2=15.632 //y2=4.705
r360 (  15 73 ) resistor r=5.1957 //w=0.242 //l=0.085 //layer=li \
 //thickness=0.1 //x=15.632 //y=4.62 //x2=15.632 //y2=4.535
r361 (  14 70 ) resistor r=5.1957 //w=0.242 //l=0.085 //layer=li \
 //thickness=0.1 //x=15.632 //y=3.51 //x2=15.632 //y2=3.595
r362 (  14 69 ) resistor r=5.1957 //w=0.242 //l=0.085 //layer=li \
 //thickness=0.1 //x=15.632 //y=3.51 //x2=15.632 //y2=3.425
r363 (  13 67 ) resistor r=5.1957 //w=0.242 //l=0.085 //layer=li \
 //thickness=0.1 //x=15.632 //y=3.14 //x2=15.632 //y2=3.225
r364 (  13 66 ) resistor r=5.1957 //w=0.242 //l=0.085 //layer=li \
 //thickness=0.1 //x=15.632 //y=3.14 //x2=15.632 //y2=3.055
r365 (  12 64 ) resistor r=5.1957 //w=0.242 //l=0.085 //layer=li \
 //thickness=0.1 //x=15.632 //y=2.77 //x2=15.632 //y2=2.855
r366 (  12 63 ) resistor r=5.1957 //w=0.242 //l=0.085 //layer=li \
 //thickness=0.1 //x=15.632 //y=2.77 //x2=15.632 //y2=2.685
r367 (  11 61 ) resistor r=5.1957 //w=0.242 //l=0.085 //layer=li \
 //thickness=0.1 //x=2.682 //y=4.62 //x2=2.682 //y2=4.705
r368 (  11 60 ) resistor r=5.1957 //w=0.242 //l=0.085 //layer=li \
 //thickness=0.1 //x=2.682 //y=4.62 //x2=2.682 //y2=4.535
r369 (  10 57 ) resistor r=5.1957 //w=0.242 //l=0.085 //layer=li \
 //thickness=0.1 //x=2.682 //y=3.88 //x2=2.682 //y2=3.965
r370 (  10 56 ) resistor r=5.1957 //w=0.242 //l=0.085 //layer=li \
 //thickness=0.1 //x=2.682 //y=3.88 //x2=2.682 //y2=3.795
r371 (  9 54 ) resistor r=5.1957 //w=0.242 //l=0.085 //layer=li \
 //thickness=0.1 //x=2.682 //y=3.51 //x2=2.682 //y2=3.595
r372 (  9 53 ) resistor r=5.1957 //w=0.242 //l=0.085 //layer=li \
 //thickness=0.1 //x=2.682 //y=3.51 //x2=2.682 //y2=3.425
r373 (  8 51 ) resistor r=5.1957 //w=0.242 //l=0.085 //layer=li \
 //thickness=0.1 //x=2.682 //y=3.14 //x2=2.682 //y2=3.225
r374 (  8 50 ) resistor r=5.1957 //w=0.242 //l=0.085 //layer=li \
 //thickness=0.1 //x=2.682 //y=3.14 //x2=2.682 //y2=3.055
r375 (  7 48 ) resistor r=5.1957 //w=0.242 //l=0.085 //layer=li \
 //thickness=0.1 //x=2.682 //y=2.77 //x2=2.682 //y2=2.855
r376 (  7 47 ) resistor r=5.1957 //w=0.242 //l=0.085 //layer=li \
 //thickness=0.1 //x=2.682 //y=2.77 //x2=2.682 //y2=2.685
r377 (  6 15 ) resistor r=9.3 //w=0.17 //l=0.17 //layer=mcon //count=1 \
 //x=15.605 //y=4.62 //x2=15.605 //y2=4.62
r378 (  4 11 ) resistor r=9.3 //w=0.17 //l=0.17 //layer=mcon //count=1 \
 //x=2.655 //y=4.62 //x2=2.655 //y2=4.62
r379 (  2 4 ) resistor r=0.0717383 //w=0.224 //l=0.115 //layer=m1 \
 //thickness=0.36 //x=2.77 //y=4.62 //x2=2.655 //y2=4.62
r380 (  1 6 ) resistor r=0.0717383 //w=0.224 //l=0.115 //layer=m1 \
 //thickness=0.36 //x=15.49 //y=4.62 //x2=15.605 //y2=4.62
r381 (  1 2 ) resistor r=12.1374 //w=0.131 //l=12.72 //layer=m1 \
 //thickness=0.36 //x=15.49 //y=4.62 //x2=2.77 //y2=4.62
ends PM_DFFRNQX1\%CLK

subckt PM_DFFRNQX1\%noxref_6 ( 1 2 3 4 17 18 25 33 39 40 44 46 54 61 62 63 64 \
 65 66 67 68 69 70 71 72 73 75 81 82 83 84 88 89 90 91 92 94 100 101 102 103 \
 123 125 126 127 )
c255 ( 127 0 ) capacitor c=0.023087f //x=3.58 //y=5.2
c256 ( 126 0 ) capacitor c=0.023519f //x=2.7 //y=5.2
c257 ( 125 0 ) capacitor c=0.0224735f //x=1.82 //y=5.2
c258 ( 123 0 ) capacitor c=0.00853354f //x=3.83 //y=1.095
c259 ( 103 0 ) capacitor c=0.0558396f //x=19.58 //y=4.97
c260 ( 102 0 ) capacitor c=0.0298189f //x=19.87 //y=4.97
c261 ( 101 0 ) capacitor c=0.0347816f //x=19.535 //y=1.4
c262 ( 100 0 ) capacitor c=0.0187487f //x=19.535 //y=1.055
c263 ( 94 0 ) capacitor c=0.0137055f //x=19.38 //y=1.555
c264 ( 92 0 ) capacitor c=0.0149861f //x=19.38 //y=0.9
c265 ( 91 0 ) capacitor c=0.096037f //x=19.005 //y=2.095
c266 ( 90 0 ) capacitor c=0.0228993f //x=19.005 //y=1.71
c267 ( 89 0 ) capacitor c=0.0234352f //x=19.005 //y=1.4
c268 ( 88 0 ) capacitor c=0.0198724f //x=19.005 //y=1.055
c269 ( 84 0 ) capacitor c=0.0556143f //x=6.63 //y=4.97
c270 ( 83 0 ) capacitor c=0.0293157f //x=6.92 //y=4.97
c271 ( 82 0 ) capacitor c=0.0347816f //x=6.585 //y=1.4
c272 ( 81 0 ) capacitor c=0.0187487f //x=6.585 //y=1.055
c273 ( 75 0 ) capacitor c=0.0137055f //x=6.43 //y=1.555
c274 ( 73 0 ) capacitor c=0.0149861f //x=6.43 //y=0.9
c275 ( 72 0 ) capacitor c=0.102158f //x=6.055 //y=2.095
c276 ( 71 0 ) capacitor c=0.0229444f //x=6.055 //y=1.71
c277 ( 70 0 ) capacitor c=0.0234352f //x=6.055 //y=1.4
c278 ( 69 0 ) capacitor c=0.0198724f //x=6.055 //y=1.055
c279 ( 68 0 ) capacitor c=0.110114f //x=19.945 //y=6.2
c280 ( 67 0 ) capacitor c=0.158956f //x=19.505 //y=6.2
c281 ( 66 0 ) capacitor c=0.110114f //x=6.995 //y=6.2
c282 ( 65 0 ) capacitor c=0.158956f //x=6.555 //y=6.2
c283 ( 62 0 ) capacitor c=0.00106608f //x=3.725 //y=5.335
c284 ( 61 0 ) capacitor c=0.00179642f //x=2.845 //y=5.335
c285 ( 54 0 ) capacitor c=0.106682f //x=19.305 //y=2.26
c286 ( 46 0 ) capacitor c=0.102391f //x=6.355 //y=2.26
c287 ( 44 0 ) capacitor c=0.110215f //x=4.505 //y=3.88
c288 ( 40 0 ) capacitor c=0.00493499f //x=4.105 //y=1.845
c289 ( 39 0 ) capacitor c=0.0154052f //x=4.42 //y=1.845
c290 ( 33 0 ) capacitor c=0.0283082f //x=4.42 //y=5.335
c291 ( 25 0 ) capacitor c=0.0176454f //x=3.64 //y=5.335
c292 ( 18 0 ) capacitor c=0.00351598f //x=2.05 //y=5.335
c293 ( 17 0 ) capacitor c=0.0154549f //x=2.76 //y=5.335
c294 ( 4 0 ) capacitor c=0.00424246f //x=6.47 //y=3.88
c295 ( 3 0 ) capacitor c=0.236173f //x=19.19 //y=3.88
c296 ( 2 0 ) capacitor c=0.0125346f //x=4.62 //y=3.88
c297 ( 1 0 ) capacitor c=0.0288301f //x=6.24 //y=3.88
r298 (  102 104 ) resistor r=26.9307 //w=0.15 //l=0.106066 //layer=ply \
 //thickness=0.18 //x=19.87 //y=4.97 //x2=19.945 //y2=5.045
r299 (  102 103 ) resistor r=148.702 //w=0.094 //l=0.29 //layer=ply \
 //thickness=0.18 //x=19.87 //y=4.97 //x2=19.58 //y2=4.97
r300 (  101 122 ) resistor r=45.1352 //w=0.168 //l=0.173853 //layer=ply \
 //thickness=0.18 //x=19.535 //y=1.4 //x2=19.495 //y2=1.555
r301 (  100 121 ) resistor r=45.1352 //w=0.168 //l=0.173853 //layer=ply \
 //thickness=0.18 //x=19.535 //y=1.055 //x2=19.495 //y2=0.9
r302 (  100 101 ) resistor r=176.904 //w=0.094 //l=0.345 //layer=ply \
 //thickness=0.18 //x=19.535 //y=1.055 //x2=19.535 //y2=1.4
r303 (  97 103 ) resistor r=22.7971 //w=0.269 //l=0.106066 //layer=ply \
 //thickness=0.18 //x=19.505 //y=5.045 //x2=19.58 //y2=4.97
r304 (  97 120 ) resistor r=35.8364 //w=0.269 //l=0.270185 //layer=ply \
 //thickness=0.18 //x=19.505 //y=5.045 //x2=19.305 //y2=4.88
r305 (  95 116 ) resistor r=10.701 //w=0.21 //l=0.115 //layer=ply \
 //thickness=0.18 //x=19.16 //y=1.555 //x2=19.045 //y2=1.555
r306 (  94 122 ) resistor r=5.52526 //w=0.168 //l=0.115 //layer=ply \
 //thickness=0.18 //x=19.38 //y=1.555 //x2=19.495 //y2=1.555
r307 (  93 115 ) resistor r=5.52526 //w=0.168 //l=0.115 //layer=ply \
 //thickness=0.18 //x=19.16 //y=0.9 //x2=19.045 //y2=0.9
r308 (  92 121 ) resistor r=5.52526 //w=0.168 //l=0.115 //layer=ply \
 //thickness=0.18 //x=19.38 //y=0.9 //x2=19.495 //y2=0.9
r309 (  92 93 ) resistor r=112.809 //w=0.094 //l=0.22 //layer=ply \
 //thickness=0.18 //x=19.38 //y=0.9 //x2=19.16 //y2=0.9
r310 (  91 118 ) resistor r=58.7805 //w=0.246 //l=0.373497 //layer=ply \
 //thickness=0.18 //x=19.005 //y=2.095 //x2=19.305 //y2=2.26
r311 (  90 116 ) resistor r=39.5823 //w=0.21 //l=0.173853 //layer=ply \
 //thickness=0.18 //x=19.005 //y=1.71 //x2=19.045 //y2=1.555
r312 (  90 91 ) resistor r=197.415 //w=0.094 //l=0.385 //layer=ply \
 //thickness=0.18 //x=19.005 //y=1.71 //x2=19.005 //y2=2.095
r313 (  89 116 ) resistor r=39.5823 //w=0.21 //l=0.173853 //layer=ply \
 //thickness=0.18 //x=19.005 //y=1.4 //x2=19.045 //y2=1.555
r314 (  88 115 ) resistor r=45.1352 //w=0.168 //l=0.173853 //layer=ply \
 //thickness=0.18 //x=19.005 //y=1.055 //x2=19.045 //y2=0.9
r315 (  88 89 ) resistor r=176.904 //w=0.094 //l=0.345 //layer=ply \
 //thickness=0.18 //x=19.005 //y=1.055 //x2=19.005 //y2=1.4
r316 (  83 85 ) resistor r=26.9307 //w=0.15 //l=0.106066 //layer=ply \
 //thickness=0.18 //x=6.92 //y=4.97 //x2=6.995 //y2=5.045
r317 (  83 84 ) resistor r=148.702 //w=0.094 //l=0.29 //layer=ply \
 //thickness=0.18 //x=6.92 //y=4.97 //x2=6.63 //y2=4.97
r318 (  82 114 ) resistor r=45.1352 //w=0.168 //l=0.173853 //layer=ply \
 //thickness=0.18 //x=6.585 //y=1.4 //x2=6.545 //y2=1.555
r319 (  81 113 ) resistor r=45.1352 //w=0.168 //l=0.173853 //layer=ply \
 //thickness=0.18 //x=6.585 //y=1.055 //x2=6.545 //y2=0.9
r320 (  81 82 ) resistor r=176.904 //w=0.094 //l=0.345 //layer=ply \
 //thickness=0.18 //x=6.585 //y=1.055 //x2=6.585 //y2=1.4
r321 (  78 84 ) resistor r=22.7971 //w=0.269 //l=0.106066 //layer=ply \
 //thickness=0.18 //x=6.555 //y=5.045 //x2=6.63 //y2=4.97
r322 (  78 112 ) resistor r=35.8364 //w=0.269 //l=0.270185 //layer=ply \
 //thickness=0.18 //x=6.555 //y=5.045 //x2=6.355 //y2=4.88
r323 (  76 108 ) resistor r=10.701 //w=0.21 //l=0.115 //layer=ply \
 //thickness=0.18 //x=6.21 //y=1.555 //x2=6.095 //y2=1.555
r324 (  75 114 ) resistor r=5.52526 //w=0.168 //l=0.115 //layer=ply \
 //thickness=0.18 //x=6.43 //y=1.555 //x2=6.545 //y2=1.555
r325 (  74 107 ) resistor r=5.52526 //w=0.168 //l=0.115 //layer=ply \
 //thickness=0.18 //x=6.21 //y=0.9 //x2=6.095 //y2=0.9
r326 (  73 113 ) resistor r=5.52526 //w=0.168 //l=0.115 //layer=ply \
 //thickness=0.18 //x=6.43 //y=0.9 //x2=6.545 //y2=0.9
r327 (  73 74 ) resistor r=112.809 //w=0.094 //l=0.22 //layer=ply \
 //thickness=0.18 //x=6.43 //y=0.9 //x2=6.21 //y2=0.9
r328 (  72 110 ) resistor r=58.7805 //w=0.246 //l=0.373497 //layer=ply \
 //thickness=0.18 //x=6.055 //y=2.095 //x2=6.355 //y2=2.26
r329 (  71 108 ) resistor r=39.5823 //w=0.21 //l=0.173853 //layer=ply \
 //thickness=0.18 //x=6.055 //y=1.71 //x2=6.095 //y2=1.555
r330 (  71 72 ) resistor r=197.415 //w=0.094 //l=0.385 //layer=ply \
 //thickness=0.18 //x=6.055 //y=1.71 //x2=6.055 //y2=2.095
r331 (  70 108 ) resistor r=39.5823 //w=0.21 //l=0.173853 //layer=ply \
 //thickness=0.18 //x=6.055 //y=1.4 //x2=6.095 //y2=1.555
r332 (  69 107 ) resistor r=45.1352 //w=0.168 //l=0.173853 //layer=ply \
 //thickness=0.18 //x=6.055 //y=1.055 //x2=6.095 //y2=0.9
r333 (  69 70 ) resistor r=176.904 //w=0.094 //l=0.345 //layer=ply \
 //thickness=0.18 //x=6.055 //y=1.055 //x2=6.055 //y2=1.4
r334 (  68 104 ) resistor r=592.245 //w=0.094 //l=1.155 //layer=ply \
 //thickness=0.18 //x=19.945 //y=6.2 //x2=19.945 //y2=5.045
r335 (  67 97 ) resistor r=592.245 //w=0.094 //l=1.155 //layer=ply \
 //thickness=0.18 //x=19.505 //y=6.2 //x2=19.505 //y2=5.045
r336 (  66 85 ) resistor r=592.245 //w=0.094 //l=1.155 //layer=ply \
 //thickness=0.18 //x=6.995 //y=6.2 //x2=6.995 //y2=5.045
r337 (  65 78 ) resistor r=592.245 //w=0.094 //l=1.155 //layer=ply \
 //thickness=0.18 //x=6.555 //y=6.2 //x2=6.555 //y2=5.045
r338 (  64 94 ) resistor r=56.4043 //w=0.094 //l=0.11 //layer=ply \
 //thickness=0.18 //x=19.27 //y=1.555 //x2=19.38 //y2=1.555
r339 (  64 95 ) resistor r=56.4043 //w=0.094 //l=0.11 //layer=ply \
 //thickness=0.18 //x=19.27 //y=1.555 //x2=19.16 //y2=1.555
r340 (  63 75 ) resistor r=56.4043 //w=0.094 //l=0.11 //layer=ply \
 //thickness=0.18 //x=6.32 //y=1.555 //x2=6.43 //y2=1.555
r341 (  63 76 ) resistor r=56.4043 //w=0.094 //l=0.11 //layer=ply \
 //thickness=0.18 //x=6.32 //y=1.555 //x2=6.21 //y2=1.555
r342 (  59 120 ) resistor r=152 //w=0.17 //l=0.17 //layer=licon //count=1 \
 //x=19.305 //y=4.88 //x2=19.305 //y2=4.88
r343 (  57 59 ) resistor r=68.4492 //w=0.187 //l=1 //layer=li //thickness=0.1 \
 //x=19.305 //y=3.88 //x2=19.305 //y2=4.88
r344 (  54 118 ) resistor r=152 //w=0.17 //l=0.17 //layer=licon //count=1 \
 //x=19.305 //y=2.26 //x2=19.305 //y2=2.26
r345 (  54 57 ) resistor r=110.888 //w=0.187 //l=1.62 //layer=li \
 //thickness=0.1 //x=19.305 //y=2.26 //x2=19.305 //y2=3.88
r346 (  51 112 ) resistor r=152 //w=0.17 //l=0.17 //layer=licon //count=1 \
 //x=6.355 //y=4.88 //x2=6.355 //y2=4.88
r347 (  49 51 ) resistor r=68.4492 //w=0.187 //l=1 //layer=li //thickness=0.1 \
 //x=6.355 //y=3.88 //x2=6.355 //y2=4.88
r348 (  46 110 ) resistor r=152 //w=0.17 //l=0.17 //layer=licon //count=1 \
 //x=6.355 //y=2.26 //x2=6.355 //y2=2.26
r349 (  46 49 ) resistor r=110.888 //w=0.187 //l=1.62 //layer=li \
 //thickness=0.1 //x=6.355 //y=2.26 //x2=6.355 //y2=3.88
r350 (  42 44 ) resistor r=93.7754 //w=0.187 //l=1.37 //layer=li \
 //thickness=0.1 //x=4.505 //y=5.25 //x2=4.505 //y2=3.88
r351 (  41 44 ) resistor r=133.476 //w=0.187 //l=1.95 //layer=li \
 //thickness=0.1 //x=4.505 //y=1.93 //x2=4.505 //y2=3.88
r352 (  39 41 ) resistor r=7.15173 //w=0.17 //l=0.120208 //layer=li \
 //thickness=0.1 //x=4.42 //y=1.845 //x2=4.505 //y2=1.93
r353 (  39 40 ) resistor r=21.5615 //w=0.187 //l=0.315 //layer=li \
 //thickness=0.1 //x=4.42 //y=1.845 //x2=4.105 //y2=1.845
r354 (  35 40 ) resistor r=7.15173 //w=0.17 //l=0.120208 //layer=li \
 //thickness=0.1 //x=4.02 //y=1.76 //x2=4.105 //y2=1.845
r355 (  35 123 ) resistor r=39.016 //w=0.187 //l=0.57 //layer=li \
 //thickness=0.1 //x=4.02 //y=1.76 //x2=4.02 //y2=1.19
r356 (  34 62 ) resistor r=5.4201 //w=0.17 //l=0.085 //layer=li \
 //thickness=0.1 //x=3.81 //y=5.335 //x2=3.725 //y2=5.335
r357 (  33 42 ) resistor r=7.15173 //w=0.17 //l=0.120208 //layer=li \
 //thickness=0.1 //x=4.42 //y=5.335 //x2=4.505 //y2=5.25
r358 (  33 34 ) resistor r=41.754 //w=0.187 //l=0.61 //layer=li \
 //thickness=0.1 //x=4.42 //y=5.335 //x2=3.81 //y2=5.335
r359 (  27 62 ) resistor r=1.40859 //w=0.34 //l=0.085 //layer=li \
 //thickness=0.1 //x=3.725 //y=5.42 //x2=3.725 //y2=5.335
r360 (  27 127 ) resistor r=33.1979 //w=0.187 //l=0.485 //layer=li \
 //thickness=0.1 //x=3.725 //y=5.42 //x2=3.725 //y2=5.905
r361 (  26 61 ) resistor r=5.4201 //w=0.17 //l=0.085 //layer=li \
 //thickness=0.1 //x=2.93 //y=5.335 //x2=2.845 //y2=5.335
r362 (  25 62 ) resistor r=5.4201 //w=0.17 //l=0.085 //layer=li \
 //thickness=0.1 //x=3.64 //y=5.335 //x2=3.725 //y2=5.335
r363 (  25 26 ) resistor r=48.5989 //w=0.187 //l=0.71 //layer=li \
 //thickness=0.1 //x=3.64 //y=5.335 //x2=2.93 //y2=5.335
r364 (  19 61 ) resistor r=1.40859 //w=0.34 //l=0.085 //layer=li \
 //thickness=0.1 //x=2.845 //y=5.42 //x2=2.845 //y2=5.335
r365 (  19 126 ) resistor r=33.1979 //w=0.187 //l=0.485 //layer=li \
 //thickness=0.1 //x=2.845 //y=5.42 //x2=2.845 //y2=5.905
r366 (  17 61 ) resistor r=5.4201 //w=0.17 //l=0.085 //layer=li \
 //thickness=0.1 //x=2.76 //y=5.335 //x2=2.845 //y2=5.335
r367 (  17 18 ) resistor r=48.5989 //w=0.187 //l=0.71 //layer=li \
 //thickness=0.1 //x=2.76 //y=5.335 //x2=2.05 //y2=5.335
r368 (  11 18 ) resistor r=7.15173 //w=0.17 //l=0.120208 //layer=li \
 //thickness=0.1 //x=1.965 //y=5.42 //x2=2.05 //y2=5.335
r369 (  11 125 ) resistor r=33.1979 //w=0.187 //l=0.485 //layer=li \
 //thickness=0.1 //x=1.965 //y=5.42 //x2=1.965 //y2=5.905
r370 (  10 57 ) resistor r=9.3 //w=0.17 //l=0.17 //layer=mcon //count=1 \
 //x=19.305 //y=3.88 //x2=19.305 //y2=3.88
r371 (  8 49 ) resistor r=9.3 //w=0.17 //l=0.17 //layer=mcon //count=1 \
 //x=6.355 //y=3.88 //x2=6.355 //y2=3.88
r372 (  6 44 ) resistor r=9.3 //w=0.17 //l=0.17 //layer=mcon //count=1 \
 //x=4.505 //y=3.88 //x2=4.505 //y2=3.88
r373 (  4 8 ) resistor r=0.0880901 //w=0.191 //l=0.115 //layer=m1 \
 //thickness=0.36 //x=6.47 //y=3.88 //x2=6.355 //y2=3.88
r374 (  3 10 ) resistor r=0.0717383 //w=0.224 //l=0.115 //layer=m1 \
 //thickness=0.36 //x=19.19 //y=3.88 //x2=19.305 //y2=3.88
r375 (  3 4 ) resistor r=12.1374 //w=0.131 //l=12.72 //layer=m1 \
 //thickness=0.36 //x=19.19 //y=3.88 //x2=6.47 //y2=3.88
r376 (  2 6 ) resistor r=0.0717383 //w=0.224 //l=0.115 //layer=m1 \
 //thickness=0.36 //x=4.62 //y=3.88 //x2=4.505 //y2=3.88
r377 (  1 8 ) resistor r=0.0880901 //w=0.191 //l=0.115 //layer=m1 \
 //thickness=0.36 //x=6.24 //y=3.88 //x2=6.355 //y2=3.88
r378 (  1 2 ) resistor r=1.5458 //w=0.131 //l=1.62 //layer=m1 //thickness=0.36 \
 //x=6.24 //y=3.88 //x2=4.62 //y2=3.88
ends PM_DFFRNQX1\%noxref_6

subckt PM_DFFRNQX1\%RN ( 1 2 3 4 11 12 13 14 15 16 17 18 19 20 21 22 23 24 30 \
 32 40 42 54 57 60 67 70 73 80 83 86 89 92 98 99 100 101 102 103 104 105 106 \
 110 111 112 117 119 122 123 127 128 129 134 136 139 140 141 142 143 145 151 \
 152 153 154 155 161 162 167 171 172 177 183 )
c321 ( 183 0 ) capacitor c=0.0333776f //x=20.415 //y=4.88
c322 ( 177 0 ) capacitor c=0.0593675f //x=16.715 //y=4.88
c323 ( 172 0 ) capacitor c=0.0273931f //x=16.715 //y=2.095
c324 ( 171 0 ) capacitor c=0.045007f //x=16.715 //y=2.26
c325 ( 167 0 ) capacitor c=0.0587755f //x=8.575 //y=4.88
c326 ( 162 0 ) capacitor c=0.0273931f //x=8.575 //y=2.095
c327 ( 161 0 ) capacitor c=0.0451854f //x=8.575 //y=2.26
c328 ( 155 0 ) capacitor c=0.0246513f //x=20.75 //y=4.97
c329 ( 154 0 ) capacitor c=0.0826449f //x=20.505 //y=2.095
c330 ( 153 0 ) capacitor c=0.0170266f //x=20.505 //y=1.63
c331 ( 152 0 ) capacitor c=0.018609f //x=20.505 //y=1.4
c332 ( 151 0 ) capacitor c=0.0187309f //x=20.505 //y=1.09
c333 ( 145 0 ) capacitor c=0.014725f //x=20.35 //y=1.555
c334 ( 143 0 ) capacitor c=0.0146567f //x=20.35 //y=0.935
c335 ( 142 0 ) capacitor c=0.0335408f //x=19.98 //y=1.4
c336 ( 141 0 ) capacitor c=0.0173761f //x=19.98 //y=1.09
c337 ( 140 0 ) capacitor c=0.0432517f //x=17.235 //y=1.44
c338 ( 139 0 ) capacitor c=0.0200379f //x=17.235 //y=1.095
c339 ( 136 0 ) capacitor c=0.0148873f //x=17.08 //y=1.595
c340 ( 134 0 ) capacitor c=0.0157803f //x=17.08 //y=0.94
c341 ( 129 0 ) capacitor c=0.0218028f //x=16.705 //y=1.75
c342 ( 128 0 ) capacitor c=0.0207459f //x=16.705 //y=1.44
c343 ( 127 0 ) capacitor c=0.0194308f //x=16.705 //y=1.095
c344 ( 123 0 ) capacitor c=0.0432517f //x=9.095 //y=1.44
c345 ( 122 0 ) capacitor c=0.0200379f //x=9.095 //y=1.095
c346 ( 119 0 ) capacitor c=0.0148873f //x=8.94 //y=1.595
c347 ( 117 0 ) capacitor c=0.0157803f //x=8.94 //y=0.94
c348 ( 112 0 ) capacitor c=0.0218028f //x=8.565 //y=1.75
c349 ( 111 0 ) capacitor c=0.0207459f //x=8.565 //y=1.44
c350 ( 110 0 ) capacitor c=0.0194308f //x=8.565 //y=1.095
c351 ( 106 0 ) capacitor c=0.110114f //x=20.825 //y=6.2
c352 ( 105 0 ) capacitor c=0.11012f //x=20.385 //y=6.2
c353 ( 104 0 ) capacitor c=0.158794f //x=16.895 //y=6.2
c354 ( 103 0 ) capacitor c=0.110114f //x=16.455 //y=6.2
c355 ( 102 0 ) capacitor c=0.158794f //x=8.755 //y=6.2
c356 ( 101 0 ) capacitor c=0.110114f //x=8.315 //y=6.2
c357 ( 92 0 ) capacitor c=0.021673f //x=20.442 //y=4.535
c358 ( 89 0 ) capacitor c=0.00830308f //x=20.442 //y=3.795
c359 ( 86 0 ) capacitor c=0.00869519f //x=20.442 //y=3.425
c360 ( 83 0 ) capacitor c=0.00874422f //x=20.442 //y=3.055
c361 ( 80 0 ) capacitor c=0.00736593f //x=20.442 //y=2.685
c362 ( 73 0 ) capacitor c=0.00783245f //x=16.742 //y=3.425
c363 ( 70 0 ) capacitor c=0.00790488f //x=16.742 //y=3.055
c364 ( 67 0 ) capacitor c=0.0065904f //x=16.742 //y=2.685
c365 ( 60 0 ) capacitor c=0.00790488f //x=8.602 //y=3.055
c366 ( 57 0 ) capacitor c=0.0065904f //x=8.602 //y=2.685
c367 ( 54 0 ) capacitor c=0.00520319f //x=20.415 //y=4.88
c368 ( 42 0 ) capacitor c=0.00589947f //x=20.415 //y=2.485
c369 ( 40 0 ) capacitor c=0.0414107f //x=16.715 //y=4.88
c370 ( 32 0 ) capacitor c=0.00556841f //x=16.715 //y=2.485
c371 ( 30 0 ) capacitor c=0.052045f //x=8.575 //y=4.88
c372 ( 24 0 ) capacitor c=0.00565956f //x=8.575 //y=2.485
c373 ( 23 0 ) capacitor c=0.00736617f //x=20.47 //y=4.62
c374 ( 22 0 ) capacitor c=0.00736127f //x=20.47 //y=3.88
c375 ( 21 0 ) capacitor c=0.00798743f //x=20.47 //y=3.51
c376 ( 20 0 ) capacitor c=0.00839732f //x=20.47 //y=3.14
c377 ( 19 0 ) capacitor c=0.00834432f //x=20.47 //y=2.77
c378 ( 17 0 ) capacitor c=0.00796213f //x=16.77 //y=3.51
c379 ( 16 0 ) capacitor c=0.00772022f //x=16.77 //y=3.14
c380 ( 15 0 ) capacitor c=0.00753048f //x=16.77 //y=2.77
c381 ( 13 0 ) capacitor c=0.00818692f //x=8.63 //y=3.14
c382 ( 12 0 ) capacitor c=0.0077179f //x=8.63 //y=2.77
c383 ( 4 0 ) capacitor c=0.00675464f //x=16.83 //y=2.4
c384 ( 3 0 ) capacitor c=0.111786f //x=20.3 //y=2.4
c385 ( 2 0 ) capacitor c=0.0161417f //x=8.69 //y=2.4
c386 ( 1 0 ) capacitor c=0.208691f //x=16.6 //y=2.4
r387 (  185 186 ) resistor r=32.4568 //w=0.214 //l=0.075 //layer=ply \
 //thickness=0.18 //x=20.415 //y=4.97 //x2=20.415 //y2=5.045
r388 (  183 185 ) resistor r=20.271 //w=0.214 //l=0.09 //layer=ply \
 //thickness=0.18 //x=20.415 //y=4.88 //x2=20.415 //y2=4.97
r389 (  171 172 ) resistor r=52.7279 //w=0.214 //l=0.165 //layer=ply \
 //thickness=0.18 //x=16.715 //y=2.26 //x2=16.715 //y2=2.095
r390 (  161 162 ) resistor r=52.7279 //w=0.214 //l=0.165 //layer=ply \
 //thickness=0.18 //x=8.575 //y=2.26 //x2=8.575 //y2=2.095
r391 (  156 185 ) resistor r=16.5046 //w=0.27 //l=0.135 //layer=ply \
 //thickness=0.18 //x=20.55 //y=4.97 //x2=20.415 //y2=4.97
r392 (  155 157 ) resistor r=26.9307 //w=0.15 //l=0.106066 //layer=ply \
 //thickness=0.18 //x=20.75 //y=4.97 //x2=20.825 //y2=5.045
r393 (  155 156 ) resistor r=102.553 //w=0.094 //l=0.2 //layer=ply \
 //thickness=0.18 //x=20.75 //y=4.97 //x2=20.55 //y2=4.97
r394 (  154 190 ) resistor r=38.6777 //w=0.284 //l=0.198997 //layer=ply \
 //thickness=0.18 //x=20.505 //y=2.095 //x2=20.43 //y2=2.26
r395 (  153 188 ) resistor r=21.2976 //w=0.217 //l=0.0928709 //layer=ply \
 //thickness=0.18 //x=20.505 //y=1.63 //x2=20.465 //y2=1.555
r396 (  153 154 ) resistor r=238.436 //w=0.094 //l=0.465 //layer=ply \
 //thickness=0.18 //x=20.505 //y=1.63 //x2=20.505 //y2=2.095
r397 (  152 188 ) resistor r=39.0671 //w=0.217 //l=0.173853 //layer=ply \
 //thickness=0.18 //x=20.505 //y=1.4 //x2=20.465 //y2=1.555
r398 (  151 187 ) resistor r=45.1352 //w=0.168 //l=0.173853 //layer=ply \
 //thickness=0.18 //x=20.505 //y=1.09 //x2=20.465 //y2=0.935
r399 (  151 152 ) resistor r=158.957 //w=0.094 //l=0.31 //layer=ply \
 //thickness=0.18 //x=20.505 //y=1.09 //x2=20.505 //y2=1.4
r400 (  146 181 ) resistor r=5.52526 //w=0.168 //l=0.115 //layer=ply \
 //thickness=0.18 //x=20.135 //y=1.555 //x2=20.02 //y2=1.555
r401 (  145 188 ) resistor r=11.4558 //w=0.217 //l=0.115 //layer=ply \
 //thickness=0.18 //x=20.35 //y=1.555 //x2=20.465 //y2=1.555
r402 (  144 180 ) resistor r=5.52526 //w=0.168 //l=0.115 //layer=ply \
 //thickness=0.18 //x=20.135 //y=0.935 //x2=20.02 //y2=0.935
r403 (  143 187 ) resistor r=5.52526 //w=0.168 //l=0.115 //layer=ply \
 //thickness=0.18 //x=20.35 //y=0.935 //x2=20.465 //y2=0.935
r404 (  143 144 ) resistor r=110.245 //w=0.094 //l=0.215 //layer=ply \
 //thickness=0.18 //x=20.35 //y=0.935 //x2=20.135 //y2=0.935
r405 (  142 181 ) resistor r=45.1352 //w=0.168 //l=0.173853 //layer=ply \
 //thickness=0.18 //x=19.98 //y=1.4 //x2=20.02 //y2=1.555
r406 (  141 180 ) resistor r=45.1352 //w=0.168 //l=0.173853 //layer=ply \
 //thickness=0.18 //x=19.98 //y=1.09 //x2=20.02 //y2=0.935
r407 (  141 142 ) resistor r=158.957 //w=0.094 //l=0.31 //layer=ply \
 //thickness=0.18 //x=19.98 //y=1.09 //x2=19.98 //y2=1.4
r408 (  140 179 ) resistor r=45.1352 //w=0.168 //l=0.173853 //layer=ply \
 //thickness=0.18 //x=17.235 //y=1.44 //x2=17.195 //y2=1.595
r409 (  139 178 ) resistor r=45.1352 //w=0.168 //l=0.173853 //layer=ply \
 //thickness=0.18 //x=17.235 //y=1.095 //x2=17.195 //y2=0.94
r410 (  139 140 ) resistor r=176.904 //w=0.094 //l=0.345 //layer=ply \
 //thickness=0.18 //x=17.235 //y=1.095 //x2=17.235 //y2=1.44
r411 (  137 175 ) resistor r=10.701 //w=0.21 //l=0.115 //layer=ply \
 //thickness=0.18 //x=16.86 //y=1.595 //x2=16.745 //y2=1.595
r412 (  136 179 ) resistor r=5.52526 //w=0.168 //l=0.115 //layer=ply \
 //thickness=0.18 //x=17.08 //y=1.595 //x2=17.195 //y2=1.595
r413 (  135 174 ) resistor r=5.52526 //w=0.168 //l=0.115 //layer=ply \
 //thickness=0.18 //x=16.86 //y=0.94 //x2=16.745 //y2=0.94
r414 (  134 178 ) resistor r=5.52526 //w=0.168 //l=0.115 //layer=ply \
 //thickness=0.18 //x=17.08 //y=0.94 //x2=17.195 //y2=0.94
r415 (  134 135 ) resistor r=112.809 //w=0.094 //l=0.22 //layer=ply \
 //thickness=0.18 //x=17.08 //y=0.94 //x2=16.86 //y2=0.94
r416 (  131 177 ) resistor r=37.236 //w=0.233 //l=0.249199 //layer=ply \
 //thickness=0.18 //x=16.895 //y=5.045 //x2=16.715 //y2=4.88
r417 (  129 175 ) resistor r=39.5823 //w=0.21 //l=0.173853 //layer=ply \
 //thickness=0.18 //x=16.705 //y=1.75 //x2=16.745 //y2=1.595
r418 (  129 172 ) resistor r=176.904 //w=0.094 //l=0.345 //layer=ply \
 //thickness=0.18 //x=16.705 //y=1.75 //x2=16.705 //y2=2.095
r419 (  128 175 ) resistor r=39.5823 //w=0.21 //l=0.173853 //layer=ply \
 //thickness=0.18 //x=16.705 //y=1.44 //x2=16.745 //y2=1.595
r420 (  127 174 ) resistor r=45.1352 //w=0.168 //l=0.173853 //layer=ply \
 //thickness=0.18 //x=16.705 //y=1.095 //x2=16.745 //y2=0.94
r421 (  127 128 ) resistor r=176.904 //w=0.094 //l=0.345 //layer=ply \
 //thickness=0.18 //x=16.705 //y=1.095 //x2=16.705 //y2=1.44
r422 (  124 177 ) resistor r=53.7854 //w=0.233 //l=0.332415 //layer=ply \
 //thickness=0.18 //x=16.455 //y=5.045 //x2=16.715 //y2=4.88
r423 (  123 169 ) resistor r=45.1352 //w=0.168 //l=0.173853 //layer=ply \
 //thickness=0.18 //x=9.095 //y=1.44 //x2=9.055 //y2=1.595
r424 (  122 168 ) resistor r=45.1352 //w=0.168 //l=0.173853 //layer=ply \
 //thickness=0.18 //x=9.095 //y=1.095 //x2=9.055 //y2=0.94
r425 (  122 123 ) resistor r=176.904 //w=0.094 //l=0.345 //layer=ply \
 //thickness=0.18 //x=9.095 //y=1.095 //x2=9.095 //y2=1.44
r426 (  120 165 ) resistor r=10.701 //w=0.21 //l=0.115 //layer=ply \
 //thickness=0.18 //x=8.72 //y=1.595 //x2=8.605 //y2=1.595
r427 (  119 169 ) resistor r=5.52526 //w=0.168 //l=0.115 //layer=ply \
 //thickness=0.18 //x=8.94 //y=1.595 //x2=9.055 //y2=1.595
r428 (  118 164 ) resistor r=5.52526 //w=0.168 //l=0.115 //layer=ply \
 //thickness=0.18 //x=8.72 //y=0.94 //x2=8.605 //y2=0.94
r429 (  117 168 ) resistor r=5.52526 //w=0.168 //l=0.115 //layer=ply \
 //thickness=0.18 //x=8.94 //y=0.94 //x2=9.055 //y2=0.94
r430 (  117 118 ) resistor r=112.809 //w=0.094 //l=0.22 //layer=ply \
 //thickness=0.18 //x=8.94 //y=0.94 //x2=8.72 //y2=0.94
r431 (  114 167 ) resistor r=37.236 //w=0.233 //l=0.249199 //layer=ply \
 //thickness=0.18 //x=8.755 //y=5.045 //x2=8.575 //y2=4.88
r432 (  112 165 ) resistor r=39.5823 //w=0.21 //l=0.173853 //layer=ply \
 //thickness=0.18 //x=8.565 //y=1.75 //x2=8.605 //y2=1.595
r433 (  112 162 ) resistor r=176.904 //w=0.094 //l=0.345 //layer=ply \
 //thickness=0.18 //x=8.565 //y=1.75 //x2=8.565 //y2=2.095
r434 (  111 165 ) resistor r=39.5823 //w=0.21 //l=0.173853 //layer=ply \
 //thickness=0.18 //x=8.565 //y=1.44 //x2=8.605 //y2=1.595
r435 (  110 164 ) resistor r=45.1352 //w=0.168 //l=0.173853 //layer=ply \
 //thickness=0.18 //x=8.565 //y=1.095 //x2=8.605 //y2=0.94
r436 (  110 111 ) resistor r=176.904 //w=0.094 //l=0.345 //layer=ply \
 //thickness=0.18 //x=8.565 //y=1.095 //x2=8.565 //y2=1.44
r437 (  107 167 ) resistor r=53.7854 //w=0.233 //l=0.332415 //layer=ply \
 //thickness=0.18 //x=8.315 //y=5.045 //x2=8.575 //y2=4.88
r438 (  106 157 ) resistor r=592.245 //w=0.094 //l=1.155 //layer=ply \
 //thickness=0.18 //x=20.825 //y=6.2 //x2=20.825 //y2=5.045
r439 (  105 186 ) resistor r=592.245 //w=0.094 //l=1.155 //layer=ply \
 //thickness=0.18 //x=20.385 //y=6.2 //x2=20.385 //y2=5.045
r440 (  104 131 ) resistor r=592.245 //w=0.094 //l=1.155 //layer=ply \
 //thickness=0.18 //x=16.895 //y=6.2 //x2=16.895 //y2=5.045
r441 (  103 124 ) resistor r=592.245 //w=0.094 //l=1.155 //layer=ply \
 //thickness=0.18 //x=16.455 //y=6.2 //x2=16.455 //y2=5.045
r442 (  102 114 ) resistor r=592.245 //w=0.094 //l=1.155 //layer=ply \
 //thickness=0.18 //x=8.755 //y=6.2 //x2=8.755 //y2=5.045
r443 (  101 107 ) resistor r=592.245 //w=0.094 //l=1.155 //layer=ply \
 //thickness=0.18 //x=8.315 //y=6.2 //x2=8.315 //y2=5.045
r444 (  100 145 ) resistor r=55.3787 //w=0.094 //l=0.108 //layer=ply \
 //thickness=0.18 //x=20.242 //y=1.555 //x2=20.35 //y2=1.555
r445 (  100 146 ) resistor r=54.866 //w=0.094 //l=0.107 //layer=ply \
 //thickness=0.18 //x=20.242 //y=1.555 //x2=20.135 //y2=1.555
r446 (  99 136 ) resistor r=56.4043 //w=0.094 //l=0.11 //layer=ply \
 //thickness=0.18 //x=16.97 //y=1.595 //x2=17.08 //y2=1.595
r447 (  99 137 ) resistor r=56.4043 //w=0.094 //l=0.11 //layer=ply \
 //thickness=0.18 //x=16.97 //y=1.595 //x2=16.86 //y2=1.595
r448 (  98 119 ) resistor r=56.4043 //w=0.094 //l=0.11 //layer=ply \
 //thickness=0.18 //x=8.83 //y=1.595 //x2=8.94 //y2=1.595
r449 (  98 120 ) resistor r=56.4043 //w=0.094 //l=0.11 //layer=ply \
 //thickness=0.18 //x=8.83 //y=1.595 //x2=8.72 //y2=1.595
r450 (  95 190 ) resistor r=152 //w=0.17 //l=0.17 //layer=licon //count=1 \
 //x=20.415 //y=2.26 //x2=20.415 //y2=2.26
r451 (  90 92 ) resistor r=39.016 //w=0.187 //l=0.57 //layer=li \
 //thickness=0.1 //x=20.415 //y=3.965 //x2=20.415 //y2=4.535
r452 (  87 89 ) resistor r=13.6898 //w=0.187 //l=0.2 //layer=li \
 //thickness=0.1 //x=20.415 //y=3.595 //x2=20.415 //y2=3.795
r453 (  84 86 ) resistor r=13.6898 //w=0.187 //l=0.2 //layer=li \
 //thickness=0.1 //x=20.415 //y=3.225 //x2=20.415 //y2=3.425
r454 (  81 83 ) resistor r=13.6898 //w=0.187 //l=0.2 //layer=li \
 //thickness=0.1 //x=20.415 //y=2.855 //x2=20.415 //y2=3.055
r455 (  76 171 ) resistor r=152 //w=0.17 //l=0.17 //layer=licon //count=1 \
 //x=16.715 //y=2.26 //x2=16.715 //y2=2.26
r456 (  71 73 ) resistor r=13.6898 //w=0.187 //l=0.2 //layer=li \
 //thickness=0.1 //x=16.715 //y=3.225 //x2=16.715 //y2=3.425
r457 (  68 70 ) resistor r=13.6898 //w=0.187 //l=0.2 //layer=li \
 //thickness=0.1 //x=16.715 //y=2.855 //x2=16.715 //y2=3.055
r458 (  63 161 ) resistor r=152 //w=0.17 //l=0.17 //layer=licon //count=1 \
 //x=8.575 //y=2.26 //x2=8.575 //y2=2.26
r459 (  58 60 ) resistor r=13.6898 //w=0.187 //l=0.2 //layer=li \
 //thickness=0.1 //x=8.575 //y=2.855 //x2=8.575 //y2=3.055
r460 (  54 183 ) resistor r=152 //w=0.17 //l=0.17 //layer=licon //count=1 \
 //x=20.415 //y=4.88 //x2=20.415 //y2=4.88
r461 (  54 93 ) resistor r=11.9786 //w=0.187 //l=0.175 //layer=li \
 //thickness=0.1 //x=20.415 //y=4.88 //x2=20.415 //y2=4.705
r462 (  42 80 ) resistor r=13.6898 //w=0.187 //l=0.2 //layer=li \
 //thickness=0.1 //x=20.415 //y=2.485 //x2=20.415 //y2=2.685
r463 (  40 177 ) resistor r=152 //w=0.17 //l=0.17 //layer=licon //count=1 \
 //x=16.715 //y=4.88 //x2=16.715 //y2=4.88
r464 (  40 74 ) resistor r=87.9572 //w=0.187 //l=1.285 //layer=li \
 //thickness=0.1 //x=16.715 //y=4.88 //x2=16.715 //y2=3.595
r465 (  32 67 ) resistor r=13.6898 //w=0.187 //l=0.2 //layer=li \
 //thickness=0.1 //x=16.715 //y=2.485 //x2=16.715 //y2=2.685
r466 (  30 167 ) resistor r=152 //w=0.17 //l=0.17 //layer=licon //count=1 \
 //x=8.575 //y=4.88 //x2=8.575 //y2=4.88
r467 (  30 61 ) resistor r=113.283 //w=0.187 //l=1.655 //layer=li \
 //thickness=0.1 //x=8.575 //y=4.88 //x2=8.575 //y2=3.225
r468 (  24 57 ) resistor r=13.6898 //w=0.187 //l=0.2 //layer=li \
 //thickness=0.1 //x=8.575 //y=2.485 //x2=8.575 //y2=2.685
r469 (  23 93 ) resistor r=5.1957 //w=0.242 //l=0.085 //layer=li \
 //thickness=0.1 //x=20.442 //y=4.62 //x2=20.442 //y2=4.705
r470 (  23 92 ) resistor r=5.1957 //w=0.242 //l=0.085 //layer=li \
 //thickness=0.1 //x=20.442 //y=4.62 //x2=20.442 //y2=4.535
r471 (  22 90 ) resistor r=5.1957 //w=0.242 //l=0.085 //layer=li \
 //thickness=0.1 //x=20.442 //y=3.88 //x2=20.442 //y2=3.965
r472 (  22 89 ) resistor r=5.1957 //w=0.242 //l=0.085 //layer=li \
 //thickness=0.1 //x=20.442 //y=3.88 //x2=20.442 //y2=3.795
r473 (  21 87 ) resistor r=5.1957 //w=0.242 //l=0.085 //layer=li \
 //thickness=0.1 //x=20.442 //y=3.51 //x2=20.442 //y2=3.595
r474 (  21 86 ) resistor r=5.1957 //w=0.242 //l=0.085 //layer=li \
 //thickness=0.1 //x=20.442 //y=3.51 //x2=20.442 //y2=3.425
r475 (  20 84 ) resistor r=5.1957 //w=0.242 //l=0.085 //layer=li \
 //thickness=0.1 //x=20.442 //y=3.14 //x2=20.442 //y2=3.225
r476 (  20 83 ) resistor r=5.1957 //w=0.242 //l=0.085 //layer=li \
 //thickness=0.1 //x=20.442 //y=3.14 //x2=20.442 //y2=3.055
r477 (  19 81 ) resistor r=5.1957 //w=0.242 //l=0.085 //layer=li \
 //thickness=0.1 //x=20.442 //y=2.77 //x2=20.442 //y2=2.855
r478 (  19 80 ) resistor r=5.1957 //w=0.242 //l=0.085 //layer=li \
 //thickness=0.1 //x=20.442 //y=2.77 //x2=20.442 //y2=2.685
r479 (  18 42 ) resistor r=5.83724 //w=0.194 //l=0.0975705 //layer=li \
 //thickness=0.1 //x=20.442 //y=2.4 //x2=20.415 //y2=2.485
r480 (  18 95 ) resistor r=9.23711 //w=0.194 //l=0.14 //layer=li \
 //thickness=0.1 //x=20.442 //y=2.4 //x2=20.442 //y2=2.26
r481 (  17 74 ) resistor r=5.1957 //w=0.242 //l=0.085 //layer=li \
 //thickness=0.1 //x=16.742 //y=3.51 //x2=16.742 //y2=3.595
r482 (  17 73 ) resistor r=5.1957 //w=0.242 //l=0.085 //layer=li \
 //thickness=0.1 //x=16.742 //y=3.51 //x2=16.742 //y2=3.425
r483 (  16 71 ) resistor r=5.1957 //w=0.242 //l=0.085 //layer=li \
 //thickness=0.1 //x=16.742 //y=3.14 //x2=16.742 //y2=3.225
r484 (  16 70 ) resistor r=5.1957 //w=0.242 //l=0.085 //layer=li \
 //thickness=0.1 //x=16.742 //y=3.14 //x2=16.742 //y2=3.055
r485 (  15 68 ) resistor r=5.1957 //w=0.242 //l=0.085 //layer=li \
 //thickness=0.1 //x=16.742 //y=2.77 //x2=16.742 //y2=2.855
r486 (  15 67 ) resistor r=5.1957 //w=0.242 //l=0.085 //layer=li \
 //thickness=0.1 //x=16.742 //y=2.77 //x2=16.742 //y2=2.685
r487 (  14 32 ) resistor r=5.83724 //w=0.194 //l=0.0975705 //layer=li \
 //thickness=0.1 //x=16.742 //y=2.4 //x2=16.715 //y2=2.485
r488 (  14 76 ) resistor r=9.23711 //w=0.194 //l=0.14 //layer=li \
 //thickness=0.1 //x=16.742 //y=2.4 //x2=16.742 //y2=2.26
r489 (  13 61 ) resistor r=5.1957 //w=0.242 //l=0.085 //layer=li \
 //thickness=0.1 //x=8.602 //y=3.14 //x2=8.602 //y2=3.225
r490 (  13 60 ) resistor r=5.1957 //w=0.242 //l=0.085 //layer=li \
 //thickness=0.1 //x=8.602 //y=3.14 //x2=8.602 //y2=3.055
r491 (  12 58 ) resistor r=5.1957 //w=0.242 //l=0.085 //layer=li \
 //thickness=0.1 //x=8.602 //y=2.77 //x2=8.602 //y2=2.855
r492 (  12 57 ) resistor r=5.1957 //w=0.242 //l=0.085 //layer=li \
 //thickness=0.1 //x=8.602 //y=2.77 //x2=8.602 //y2=2.685
r493 (  11 24 ) resistor r=5.83724 //w=0.194 //l=0.0975705 //layer=li \
 //thickness=0.1 //x=8.602 //y=2.4 //x2=8.575 //y2=2.485
r494 (  11 63 ) resistor r=9.23711 //w=0.194 //l=0.14 //layer=li \
 //thickness=0.1 //x=8.602 //y=2.4 //x2=8.602 //y2=2.26
r495 (  10 18 ) resistor r=9.3 //w=0.17 //l=0.17 //layer=mcon //count=1 \
 //x=20.415 //y=2.4 //x2=20.415 //y2=2.4
r496 (  8 14 ) resistor r=9.3 //w=0.17 //l=0.17 //layer=mcon //count=1 \
 //x=16.715 //y=2.4 //x2=16.715 //y2=2.4
r497 (  6 11 ) resistor r=9.3 //w=0.17 //l=0.17 //layer=mcon //count=1 \
 //x=8.575 //y=2.4 //x2=8.575 //y2=2.4
r498 (  4 8 ) resistor r=0.0880901 //w=0.191 //l=0.115 //layer=m1 \
 //thickness=0.36 //x=16.83 //y=2.4 //x2=16.715 //y2=2.4
r499 (  3 10 ) resistor r=0.0717383 //w=0.224 //l=0.115 //layer=m1 \
 //thickness=0.36 //x=20.3 //y=2.4 //x2=20.415 //y2=2.4
r500 (  3 4 ) resistor r=3.31107 //w=0.131 //l=3.47 //layer=m1 \
 //thickness=0.36 //x=20.3 //y=2.4 //x2=16.83 //y2=2.4
r501 (  2 6 ) resistor r=0.0717383 //w=0.224 //l=0.115 //layer=m1 \
 //thickness=0.36 //x=8.69 //y=2.4 //x2=8.575 //y2=2.4
r502 (  1 8 ) resistor r=0.0880901 //w=0.191 //l=0.115 //layer=m1 \
 //thickness=0.36 //x=16.6 //y=2.4 //x2=16.715 //y2=2.4
r503 (  1 2 ) resistor r=7.54771 //w=0.131 //l=7.91 //layer=m1 \
 //thickness=0.36 //x=16.6 //y=2.4 //x2=8.69 //y2=2.4
ends PM_DFFRNQX1\%RN

subckt PM_DFFRNQX1\%Q ( 7 8 9 10 11 12 13 14 15 16 17 18 19 22 34 42 43 54 56 \
 57 75 80 83 87 90 92 94 97 100 110 113 116 118 119 120 124 125 126 131 133 \
 136 137 139 140 145 148 150 151 )
c188 ( 151 0 ) capacitor c=0.0220291f //x=24.97 //y=5.2
c189 ( 150 0 ) capacitor c=0.0217503f //x=24.09 //y=5.2
c190 ( 148 0 ) capacitor c=0.0084702f //x=24.965 //y=1.085
c191 ( 145 0 ) capacitor c=0.0589458f //x=21.525 //y=4.88
c192 ( 140 0 ) capacitor c=0.0273931f //x=21.525 //y=2.095
c193 ( 139 0 ) capacitor c=0.0462125f //x=21.525 //y=2.26
c194 ( 137 0 ) capacitor c=0.0432517f //x=22.045 //y=1.44
c195 ( 136 0 ) capacitor c=0.0200379f //x=22.045 //y=1.095
c196 ( 133 0 ) capacitor c=0.0158629f //x=21.89 //y=1.595
c197 ( 131 0 ) capacitor c=0.0157803f //x=21.89 //y=0.94
c198 ( 126 0 ) capacitor c=0.0218028f //x=21.515 //y=1.75
c199 ( 125 0 ) capacitor c=0.0207459f //x=21.515 //y=1.44
c200 ( 124 0 ) capacitor c=0.0194308f //x=21.515 //y=1.095
c201 ( 120 0 ) capacitor c=0.158794f //x=21.705 //y=6.2
c202 ( 119 0 ) capacitor c=0.110114f //x=21.265 //y=6.2
c203 ( 116 0 ) capacitor c=0.00494433f //x=25.622 //y=4.905
c204 ( 113 0 ) capacitor c=0.00657732f //x=25.622 //y=4.535
c205 ( 110 0 ) capacitor c=0.0102418f //x=25.622 //y=4.165
c206 ( 107 0 ) capacitor c=0.0102899f //x=25.622 //y=3.795
c207 ( 103 0 ) capacitor c=0.0108345f //x=25.622 //y=3.425
c208 ( 100 0 ) capacitor c=0.00995733f //x=25.622 //y=3.055
c209 ( 97 0 ) capacitor c=0.00668362f //x=25.622 //y=2.685
c210 ( 94 0 ) capacitor c=0.0101945f //x=25.622 //y=2.315
c211 ( 92 0 ) capacitor c=0.0024826f //x=25.115 //y=5.38
c212 ( 90 0 ) capacitor c=0.0196863f //x=21.552 //y=4.535
c213 ( 87 0 ) capacitor c=0.00745776f //x=21.552 //y=3.795
c214 ( 83 0 ) capacitor c=0.00779034f //x=21.552 //y=3.425
c215 ( 80 0 ) capacitor c=0.00790488f //x=21.552 //y=3.055
c216 ( 75 0 ) capacitor c=0.005033f //x=25.595 //y=5.295
c217 ( 57 0 ) capacitor c=0.00525782f //x=25.24 //y=1.835
c218 ( 56 0 ) capacitor c=0.0140375f //x=25.51 //y=1.835
c219 ( 54 0 ) capacitor c=0.0142754f //x=25.51 //y=5.38
c220 ( 43 0 ) capacitor c=0.00265593f //x=24.32 //y=5.38
c221 ( 42 0 ) capacitor c=0.0150834f //x=25.03 //y=5.38
c222 ( 34 0 ) capacitor c=0.00490727f //x=21.525 //y=4.88
c223 ( 22 0 ) capacitor c=0.013523f //x=21.525 //y=2.26
c224 ( 19 0 ) capacitor c=0.00610872f //x=25.65 //y=4.99
c225 ( 18 0 ) capacitor c=0.00667177f //x=25.65 //y=4.62
c226 ( 17 0 ) capacitor c=0.00888852f //x=25.65 //y=4.25
c227 ( 16 0 ) capacitor c=0.102447f //x=25.65 //y=3.88
c228 ( 15 0 ) capacitor c=0.0102049f //x=25.65 //y=3.51
c229 ( 14 0 ) capacitor c=0.0105558f //x=25.65 //y=3.14
c230 ( 13 0 ) capacitor c=0.00667177f //x=25.65 //y=2.77
c231 ( 12 0 ) capacitor c=0.00643997f //x=25.65 //y=2.4
c232 ( 11 0 ) capacitor c=0.00625f //x=21.58 //y=4.62
c233 ( 10 0 ) capacitor c=0.0203727f //x=21.58 //y=3.88
c234 ( 9 0 ) capacitor c=0.00685268f //x=21.58 //y=3.51
c235 ( 8 0 ) capacitor c=0.0075287f //x=21.58 //y=3.14
c236 ( 7 0 ) capacitor c=0.00762619f //x=21.58 //y=2.77
r237 (  139 140 ) resistor r=52.7279 //w=0.214 //l=0.165 //layer=ply \
 //thickness=0.18 //x=21.525 //y=2.26 //x2=21.525 //y2=2.095
r238 (  137 147 ) resistor r=45.1352 //w=0.168 //l=0.173853 //layer=ply \
 //thickness=0.18 //x=22.045 //y=1.44 //x2=22.005 //y2=1.595
r239 (  136 146 ) resistor r=45.1352 //w=0.168 //l=0.173853 //layer=ply \
 //thickness=0.18 //x=22.045 //y=1.095 //x2=22.005 //y2=0.94
r240 (  136 137 ) resistor r=176.904 //w=0.094 //l=0.345 //layer=ply \
 //thickness=0.18 //x=22.045 //y=1.095 //x2=22.045 //y2=1.44
r241 (  134 143 ) resistor r=10.701 //w=0.21 //l=0.115 //layer=ply \
 //thickness=0.18 //x=21.67 //y=1.595 //x2=21.555 //y2=1.595
r242 (  133 147 ) resistor r=5.52526 //w=0.168 //l=0.115 //layer=ply \
 //thickness=0.18 //x=21.89 //y=1.595 //x2=22.005 //y2=1.595
r243 (  132 142 ) resistor r=5.52526 //w=0.168 //l=0.115 //layer=ply \
 //thickness=0.18 //x=21.67 //y=0.94 //x2=21.555 //y2=0.94
r244 (  131 146 ) resistor r=5.52526 //w=0.168 //l=0.115 //layer=ply \
 //thickness=0.18 //x=21.89 //y=0.94 //x2=22.005 //y2=0.94
r245 (  131 132 ) resistor r=112.809 //w=0.094 //l=0.22 //layer=ply \
 //thickness=0.18 //x=21.89 //y=0.94 //x2=21.67 //y2=0.94
r246 (  128 145 ) resistor r=37.236 //w=0.233 //l=0.249199 //layer=ply \
 //thickness=0.18 //x=21.705 //y=5.045 //x2=21.525 //y2=4.88
r247 (  126 143 ) resistor r=39.5823 //w=0.21 //l=0.173853 //layer=ply \
 //thickness=0.18 //x=21.515 //y=1.75 //x2=21.555 //y2=1.595
r248 (  126 140 ) resistor r=176.904 //w=0.094 //l=0.345 //layer=ply \
 //thickness=0.18 //x=21.515 //y=1.75 //x2=21.515 //y2=2.095
r249 (  125 143 ) resistor r=39.5823 //w=0.21 //l=0.173853 //layer=ply \
 //thickness=0.18 //x=21.515 //y=1.44 //x2=21.555 //y2=1.595
r250 (  124 142 ) resistor r=45.1352 //w=0.168 //l=0.173853 //layer=ply \
 //thickness=0.18 //x=21.515 //y=1.095 //x2=21.555 //y2=0.94
r251 (  124 125 ) resistor r=176.904 //w=0.094 //l=0.345 //layer=ply \
 //thickness=0.18 //x=21.515 //y=1.095 //x2=21.515 //y2=1.44
r252 (  121 145 ) resistor r=53.7854 //w=0.233 //l=0.332415 //layer=ply \
 //thickness=0.18 //x=21.265 //y=5.045 //x2=21.525 //y2=4.88
r253 (  120 128 ) resistor r=592.245 //w=0.094 //l=1.155 //layer=ply \
 //thickness=0.18 //x=21.705 //y=6.2 //x2=21.705 //y2=5.045
r254 (  119 121 ) resistor r=592.245 //w=0.094 //l=1.155 //layer=ply \
 //thickness=0.18 //x=21.265 //y=6.2 //x2=21.265 //y2=5.045
r255 (  118 133 ) resistor r=56.4043 //w=0.094 //l=0.11 //layer=ply \
 //thickness=0.18 //x=21.78 //y=1.595 //x2=21.89 //y2=1.595
r256 (  118 134 ) resistor r=56.4043 //w=0.094 //l=0.11 //layer=ply \
 //thickness=0.18 //x=21.78 //y=1.595 //x2=21.67 //y2=1.595
r257 (  114 116 ) resistor r=13.6898 //w=0.187 //l=0.2 //layer=li \
 //thickness=0.1 //x=25.595 //y=4.705 //x2=25.595 //y2=4.905
r258 (  111 113 ) resistor r=13.6898 //w=0.187 //l=0.2 //layer=li \
 //thickness=0.1 //x=25.595 //y=4.335 //x2=25.595 //y2=4.535
r259 (  108 110 ) resistor r=13.6898 //w=0.187 //l=0.2 //layer=li \
 //thickness=0.1 //x=25.595 //y=3.965 //x2=25.595 //y2=4.165
r260 (  104 107 ) resistor r=13.6898 //w=0.187 //l=0.2 //layer=li \
 //thickness=0.1 //x=25.595 //y=3.595 //x2=25.595 //y2=3.795
r261 (  101 103 ) resistor r=13.6898 //w=0.187 //l=0.2 //layer=li \
 //thickness=0.1 //x=25.595 //y=3.225 //x2=25.595 //y2=3.425
r262 (  98 100 ) resistor r=13.6898 //w=0.187 //l=0.2 //layer=li \
 //thickness=0.1 //x=25.595 //y=2.855 //x2=25.595 //y2=3.055
r263 (  95 97 ) resistor r=13.6898 //w=0.187 //l=0.2 //layer=li \
 //thickness=0.1 //x=25.595 //y=2.485 //x2=25.595 //y2=2.685
r264 (  88 90 ) resistor r=39.016 //w=0.187 //l=0.57 //layer=li \
 //thickness=0.1 //x=21.525 //y=3.965 //x2=21.525 //y2=4.535
r265 (  84 87 ) resistor r=13.6898 //w=0.187 //l=0.2 //layer=li \
 //thickness=0.1 //x=21.525 //y=3.595 //x2=21.525 //y2=3.795
r266 (  81 83 ) resistor r=13.6898 //w=0.187 //l=0.2 //layer=li \
 //thickness=0.1 //x=21.525 //y=3.225 //x2=21.525 //y2=3.425
r267 (  78 80 ) resistor r=13.6898 //w=0.187 //l=0.2 //layer=li \
 //thickness=0.1 //x=21.525 //y=2.855 //x2=21.525 //y2=3.055
r268 (  75 117 ) resistor r=15.0588 //w=0.187 //l=0.22 //layer=li \
 //thickness=0.1 //x=25.595 //y=5.295 //x2=25.595 //y2=5.075
r269 (  58 94 ) resistor r=27.0374 //w=0.187 //l=0.395 //layer=li \
 //thickness=0.1 //x=25.595 //y=1.92 //x2=25.595 //y2=2.315
r270 (  56 58 ) resistor r=7.15173 //w=0.17 //l=0.120208 //layer=li \
 //thickness=0.1 //x=25.51 //y=1.835 //x2=25.595 //y2=1.92
r271 (  56 57 ) resistor r=18.4813 //w=0.187 //l=0.27 //layer=li \
 //thickness=0.1 //x=25.51 //y=1.835 //x2=25.24 //y2=1.835
r272 (  55 92 ) resistor r=5.4201 //w=0.17 //l=0.085 //layer=li \
 //thickness=0.1 //x=25.2 //y=5.38 //x2=25.115 //y2=5.38
r273 (  54 75 ) resistor r=7.15173 //w=0.17 //l=0.120208 //layer=li \
 //thickness=0.1 //x=25.51 //y=5.38 //x2=25.595 //y2=5.295
r274 (  54 55 ) resistor r=21.2193 //w=0.187 //l=0.31 //layer=li \
 //thickness=0.1 //x=25.51 //y=5.38 //x2=25.2 //y2=5.38
r275 (  50 57 ) resistor r=7.15173 //w=0.17 //l=0.120208 //layer=li \
 //thickness=0.1 //x=25.155 //y=1.75 //x2=25.24 //y2=1.835
r276 (  50 148 ) resistor r=39.016 //w=0.187 //l=0.57 //layer=li \
 //thickness=0.1 //x=25.155 //y=1.75 //x2=25.155 //y2=1.18
r277 (  44 92 ) resistor r=1.40859 //w=0.34 //l=0.085 //layer=li \
 //thickness=0.1 //x=25.115 //y=5.465 //x2=25.115 //y2=5.38
r278 (  44 151 ) resistor r=30.1176 //w=0.187 //l=0.44 //layer=li \
 //thickness=0.1 //x=25.115 //y=5.465 //x2=25.115 //y2=5.905
r279 (  42 92 ) resistor r=5.4201 //w=0.17 //l=0.085 //layer=li \
 //thickness=0.1 //x=25.03 //y=5.38 //x2=25.115 //y2=5.38
r280 (  42 43 ) resistor r=48.5989 //w=0.187 //l=0.71 //layer=li \
 //thickness=0.1 //x=25.03 //y=5.38 //x2=24.32 //y2=5.38
r281 (  36 43 ) resistor r=7.15173 //w=0.17 //l=0.120208 //layer=li \
 //thickness=0.1 //x=24.235 //y=5.465 //x2=24.32 //y2=5.38
r282 (  36 150 ) resistor r=30.1176 //w=0.187 //l=0.44 //layer=li \
 //thickness=0.1 //x=24.235 //y=5.465 //x2=24.235 //y2=5.905
r283 (  34 145 ) resistor r=152 //w=0.17 //l=0.17 //layer=licon //count=1 \
 //x=21.525 //y=4.88 //x2=21.525 //y2=4.88
r284 (  34 91 ) resistor r=11.9786 //w=0.187 //l=0.175 //layer=li \
 //thickness=0.1 //x=21.525 //y=4.88 //x2=21.525 //y2=4.705
r285 (  22 139 ) resistor r=152 //w=0.17 //l=0.17 //layer=licon //count=1 \
 //x=21.525 //y=2.26 //x2=21.525 //y2=2.26
r286 (  22 77 ) resistor r=29.0909 //w=0.187 //l=0.425 //layer=li \
 //thickness=0.1 //x=21.525 //y=2.26 //x2=21.525 //y2=2.685
r287 (  19 117 ) resistor r=5.1957 //w=0.242 //l=0.085 //layer=li \
 //thickness=0.1 //x=25.622 //y=4.99 //x2=25.622 //y2=5.075
r288 (  19 116 ) resistor r=5.1957 //w=0.242 //l=0.085 //layer=li \
 //thickness=0.1 //x=25.622 //y=4.99 //x2=25.622 //y2=4.905
r289 (  18 114 ) resistor r=5.1957 //w=0.242 //l=0.085 //layer=li \
 //thickness=0.1 //x=25.622 //y=4.62 //x2=25.622 //y2=4.705
r290 (  18 113 ) resistor r=5.1957 //w=0.242 //l=0.085 //layer=li \
 //thickness=0.1 //x=25.622 //y=4.62 //x2=25.622 //y2=4.535
r291 (  17 111 ) resistor r=5.1957 //w=0.242 //l=0.085 //layer=li \
 //thickness=0.1 //x=25.622 //y=4.25 //x2=25.622 //y2=4.335
r292 (  17 110 ) resistor r=5.1957 //w=0.242 //l=0.085 //layer=li \
 //thickness=0.1 //x=25.622 //y=4.25 //x2=25.622 //y2=4.165
r293 (  16 108 ) resistor r=5.1957 //w=0.242 //l=0.085 //layer=li \
 //thickness=0.1 //x=25.622 //y=3.88 //x2=25.622 //y2=3.965
r294 (  16 107 ) resistor r=5.1957 //w=0.242 //l=0.085 //layer=li \
 //thickness=0.1 //x=25.622 //y=3.88 //x2=25.622 //y2=3.795
r295 (  15 104 ) resistor r=5.1957 //w=0.242 //l=0.085 //layer=li \
 //thickness=0.1 //x=25.622 //y=3.51 //x2=25.622 //y2=3.595
r296 (  15 103 ) resistor r=5.1957 //w=0.242 //l=0.085 //layer=li \
 //thickness=0.1 //x=25.622 //y=3.51 //x2=25.622 //y2=3.425
r297 (  14 101 ) resistor r=5.1957 //w=0.242 //l=0.085 //layer=li \
 //thickness=0.1 //x=25.622 //y=3.14 //x2=25.622 //y2=3.225
r298 (  14 100 ) resistor r=5.1957 //w=0.242 //l=0.085 //layer=li \
 //thickness=0.1 //x=25.622 //y=3.14 //x2=25.622 //y2=3.055
r299 (  13 98 ) resistor r=5.1957 //w=0.242 //l=0.085 //layer=li \
 //thickness=0.1 //x=25.622 //y=2.77 //x2=25.622 //y2=2.855
r300 (  13 97 ) resistor r=5.1957 //w=0.242 //l=0.085 //layer=li \
 //thickness=0.1 //x=25.622 //y=2.77 //x2=25.622 //y2=2.685
r301 (  12 95 ) resistor r=5.1957 //w=0.242 //l=0.085 //layer=li \
 //thickness=0.1 //x=25.622 //y=2.4 //x2=25.622 //y2=2.485
r302 (  12 94 ) resistor r=5.1957 //w=0.242 //l=0.085 //layer=li \
 //thickness=0.1 //x=25.622 //y=2.4 //x2=25.622 //y2=2.315
r303 (  11 91 ) resistor r=5.1957 //w=0.242 //l=0.085 //layer=li \
 //thickness=0.1 //x=21.552 //y=4.62 //x2=21.552 //y2=4.705
r304 (  11 90 ) resistor r=5.1957 //w=0.242 //l=0.085 //layer=li \
 //thickness=0.1 //x=21.552 //y=4.62 //x2=21.552 //y2=4.535
r305 (  10 88 ) resistor r=5.1957 //w=0.242 //l=0.085 //layer=li \
 //thickness=0.1 //x=21.552 //y=3.88 //x2=21.552 //y2=3.965
r306 (  10 87 ) resistor r=5.1957 //w=0.242 //l=0.085 //layer=li \
 //thickness=0.1 //x=21.552 //y=3.88 //x2=21.552 //y2=3.795
r307 (  9 84 ) resistor r=5.1957 //w=0.242 //l=0.085 //layer=li \
 //thickness=0.1 //x=21.552 //y=3.51 //x2=21.552 //y2=3.595
r308 (  9 83 ) resistor r=5.1957 //w=0.242 //l=0.085 //layer=li \
 //thickness=0.1 //x=21.552 //y=3.51 //x2=21.552 //y2=3.425
r309 (  8 81 ) resistor r=5.1957 //w=0.242 //l=0.085 //layer=li \
 //thickness=0.1 //x=21.552 //y=3.14 //x2=21.552 //y2=3.225
r310 (  8 80 ) resistor r=5.1957 //w=0.242 //l=0.085 //layer=li \
 //thickness=0.1 //x=21.552 //y=3.14 //x2=21.552 //y2=3.055
r311 (  7 78 ) resistor r=5.1957 //w=0.242 //l=0.085 //layer=li \
 //thickness=0.1 //x=21.552 //y=2.77 //x2=21.552 //y2=2.855
r312 (  7 77 ) resistor r=5.1957 //w=0.242 //l=0.085 //layer=li \
 //thickness=0.1 //x=21.552 //y=2.77 //x2=21.552 //y2=2.685
ends PM_DFFRNQX1\%Q

subckt PM_DFFRNQX1\%noxref_9 ( 9 10 17 25 31 32 36 37 38 39 41 42 43 )
c104 ( 43 0 ) capacitor c=0.023087f //x=21.34 //y=5.2
c105 ( 42 0 ) capacitor c=0.023519f //x=20.46 //y=5.2
c106 ( 41 0 ) capacitor c=0.0224735f //x=19.58 //y=5.2
c107 ( 39 0 ) capacitor c=0.00872971f //x=21.59 //y=1.095
c108 ( 38 0 ) capacitor c=0.00116729f //x=21.485 //y=5.335
c109 ( 37 0 ) capacitor c=0.00195139f //x=20.605 //y=5.335
c110 ( 36 0 ) capacitor c=0.131426f //x=22.265 //y=3.51
c111 ( 32 0 ) capacitor c=0.00528754f //x=21.865 //y=1.845
c112 ( 31 0 ) capacitor c=0.015794f //x=22.18 //y=1.845
c113 ( 25 0 ) capacitor c=0.028799f //x=22.18 //y=5.335
c114 ( 17 0 ) capacitor c=0.0184197f //x=21.4 //y=5.335
c115 ( 10 0 ) capacitor c=0.00351598f //x=19.81 //y=5.335
c116 ( 9 0 ) capacitor c=0.0153421f //x=20.52 //y=5.335
r117 (  34 36 ) resistor r=119.102 //w=0.187 //l=1.74 //layer=li \
 //thickness=0.1 //x=22.265 //y=5.25 //x2=22.265 //y2=3.51
r118 (  33 36 ) resistor r=108.15 //w=0.187 //l=1.58 //layer=li \
 //thickness=0.1 //x=22.265 //y=1.93 //x2=22.265 //y2=3.51
r119 (  31 33 ) resistor r=7.15173 //w=0.17 //l=0.120208 //layer=li \
 //thickness=0.1 //x=22.18 //y=1.845 //x2=22.265 //y2=1.93
r120 (  31 32 ) resistor r=21.5615 //w=0.187 //l=0.315 //layer=li \
 //thickness=0.1 //x=22.18 //y=1.845 //x2=21.865 //y2=1.845
r121 (  27 32 ) resistor r=7.15173 //w=0.17 //l=0.120208 //layer=li \
 //thickness=0.1 //x=21.78 //y=1.76 //x2=21.865 //y2=1.845
r122 (  27 39 ) resistor r=39.016 //w=0.187 //l=0.57 //layer=li \
 //thickness=0.1 //x=21.78 //y=1.76 //x2=21.78 //y2=1.19
r123 (  26 38 ) resistor r=5.4201 //w=0.17 //l=0.085 //layer=li \
 //thickness=0.1 //x=21.57 //y=5.335 //x2=21.485 //y2=5.335
r124 (  25 34 ) resistor r=7.15173 //w=0.17 //l=0.120208 //layer=li \
 //thickness=0.1 //x=22.18 //y=5.335 //x2=22.265 //y2=5.25
r125 (  25 26 ) resistor r=41.754 //w=0.187 //l=0.61 //layer=li \
 //thickness=0.1 //x=22.18 //y=5.335 //x2=21.57 //y2=5.335
r126 (  19 38 ) resistor r=1.40859 //w=0.34 //l=0.085 //layer=li \
 //thickness=0.1 //x=21.485 //y=5.42 //x2=21.485 //y2=5.335
r127 (  19 43 ) resistor r=33.1979 //w=0.187 //l=0.485 //layer=li \
 //thickness=0.1 //x=21.485 //y=5.42 //x2=21.485 //y2=5.905
r128 (  18 37 ) resistor r=5.4201 //w=0.17 //l=0.085 //layer=li \
 //thickness=0.1 //x=20.69 //y=5.335 //x2=20.605 //y2=5.335
r129 (  17 38 ) resistor r=5.4201 //w=0.17 //l=0.085 //layer=li \
 //thickness=0.1 //x=21.4 //y=5.335 //x2=21.485 //y2=5.335
r130 (  17 18 ) resistor r=48.5989 //w=0.187 //l=0.71 //layer=li \
 //thickness=0.1 //x=21.4 //y=5.335 //x2=20.69 //y2=5.335
r131 (  11 37 ) resistor r=1.40859 //w=0.34 //l=0.085 //layer=li \
 //thickness=0.1 //x=20.605 //y=5.42 //x2=20.605 //y2=5.335
r132 (  11 42 ) resistor r=33.1979 //w=0.187 //l=0.485 //layer=li \
 //thickness=0.1 //x=20.605 //y=5.42 //x2=20.605 //y2=5.905
r133 (  9 37 ) resistor r=5.4201 //w=0.17 //l=0.085 //layer=li //thickness=0.1 \
 //x=20.52 //y=5.335 //x2=20.605 //y2=5.335
r134 (  9 10 ) resistor r=48.5989 //w=0.187 //l=0.71 //layer=li \
 //thickness=0.1 //x=20.52 //y=5.335 //x2=19.81 //y2=5.335
r135 (  3 10 ) resistor r=7.15173 //w=0.17 //l=0.120208 //layer=li \
 //thickness=0.1 //x=19.725 //y=5.42 //x2=19.81 //y2=5.335
r136 (  3 41 ) resistor r=33.1979 //w=0.187 //l=0.485 //layer=li \
 //thickness=0.1 //x=19.725 //y=5.42 //x2=19.725 //y2=5.905
ends PM_DFFRNQX1\%noxref_9

subckt PM_DFFRNQX1\%noxref_10 ( 6 9 13 14 15 16 17 18 19 23 25 28 29 39 )
c70 ( 39 0 ) capacitor c=0.0593152f //x=24.115 //y=4.88
c71 ( 29 0 ) capacitor c=0.0318948f //x=24.45 //y=1.39
c72 ( 28 0 ) capacitor c=0.0187384f //x=24.45 //y=1.045
c73 ( 25 0 ) capacitor c=0.0141798f //x=24.295 //y=1.545
c74 ( 23 0 ) capacitor c=0.0149844f //x=24.295 //y=0.89
c75 ( 19 0 ) capacitor c=0.0853292f //x=23.92 //y=2.095
c76 ( 18 0 ) capacitor c=0.0229722f //x=23.92 //y=1.7
c77 ( 17 0 ) capacitor c=0.0234352f //x=23.92 //y=1.39
c78 ( 16 0 ) capacitor c=0.0199343f //x=23.92 //y=1.045
c79 ( 15 0 ) capacitor c=0.110275f //x=24.455 //y=6.2
c80 ( 14 0 ) capacitor c=0.154305f //x=24.015 //y=6.2
c81 ( 9 0 ) capacitor c=0.0601101f //x=24.115 //y=3.51
c82 ( 6 0 ) capacitor c=0.0942616f //x=24.115 //y=2.26
r83 (  37 39 ) resistor r=20.6867 //w=0.233 //l=0.1 //layer=ply \
 //thickness=0.18 //x=24.015 //y=4.88 //x2=24.115 //y2=4.88
r84 (  30 39 ) resistor r=70.3348 //w=0.233 //l=0.414367 //layer=ply \
 //thickness=0.18 //x=24.455 //y=5.045 //x2=24.115 //y2=4.88
r85 (  29 41 ) resistor r=45.1352 //w=0.168 //l=0.173853 //layer=ply \
 //thickness=0.18 //x=24.45 //y=1.39 //x2=24.41 //y2=1.545
r86 (  28 40 ) resistor r=45.1352 //w=0.168 //l=0.173853 //layer=ply \
 //thickness=0.18 //x=24.45 //y=1.045 //x2=24.41 //y2=0.89
r87 (  28 29 ) resistor r=176.904 //w=0.094 //l=0.345 //layer=ply \
 //thickness=0.18 //x=24.45 //y=1.045 //x2=24.45 //y2=1.39
r88 (  26 36 ) resistor r=10.701 //w=0.21 //l=0.115 //layer=ply \
 //thickness=0.18 //x=24.075 //y=1.545 //x2=23.96 //y2=1.545
r89 (  25 41 ) resistor r=5.52526 //w=0.168 //l=0.115 //layer=ply \
 //thickness=0.18 //x=24.295 //y=1.545 //x2=24.41 //y2=1.545
r90 (  24 35 ) resistor r=5.52526 //w=0.168 //l=0.115 //layer=ply \
 //thickness=0.18 //x=24.075 //y=0.89 //x2=23.96 //y2=0.89
r91 (  23 40 ) resistor r=5.52526 //w=0.168 //l=0.115 //layer=ply \
 //thickness=0.18 //x=24.295 //y=0.89 //x2=24.41 //y2=0.89
r92 (  23 24 ) resistor r=112.809 //w=0.094 //l=0.22 //layer=ply \
 //thickness=0.18 //x=24.295 //y=0.89 //x2=24.075 //y2=0.89
r93 (  20 37 ) resistor r=13.0941 //w=0.233 //l=0.165 //layer=ply \
 //thickness=0.18 //x=24.015 //y=5.045 //x2=24.015 //y2=4.88
r94 (  19 34 ) resistor r=34.8111 //w=0.27 //l=0.264953 //layer=ply \
 //thickness=0.18 //x=23.92 //y=2.095 //x2=24.115 //y2=2.26
r95 (  18 36 ) resistor r=39.5823 //w=0.21 //l=0.173853 //layer=ply \
 //thickness=0.18 //x=23.92 //y=1.7 //x2=23.96 //y2=1.545
r96 (  18 19 ) resistor r=202.543 //w=0.094 //l=0.395 //layer=ply \
 //thickness=0.18 //x=23.92 //y=1.7 //x2=23.92 //y2=2.095
r97 (  17 36 ) resistor r=39.5823 //w=0.21 //l=0.173853 //layer=ply \
 //thickness=0.18 //x=23.92 //y=1.39 //x2=23.96 //y2=1.545
r98 (  16 35 ) resistor r=45.1352 //w=0.168 //l=0.173853 //layer=ply \
 //thickness=0.18 //x=23.92 //y=1.045 //x2=23.96 //y2=0.89
r99 (  16 17 ) resistor r=176.904 //w=0.094 //l=0.345 //layer=ply \
 //thickness=0.18 //x=23.92 //y=1.045 //x2=23.92 //y2=1.39
r100 (  15 30 ) resistor r=592.245 //w=0.094 //l=1.155 //layer=ply \
 //thickness=0.18 //x=24.455 //y=6.2 //x2=24.455 //y2=5.045
r101 (  14 20 ) resistor r=592.245 //w=0.094 //l=1.155 //layer=ply \
 //thickness=0.18 //x=24.015 //y=6.2 //x2=24.015 //y2=5.045
r102 (  13 25 ) resistor r=56.4043 //w=0.094 //l=0.11 //layer=ply \
 //thickness=0.18 //x=24.185 //y=1.545 //x2=24.295 //y2=1.545
r103 (  13 26 ) resistor r=56.4043 //w=0.094 //l=0.11 //layer=ply \
 //thickness=0.18 //x=24.185 //y=1.545 //x2=24.075 //y2=1.545
r104 (  11 39 ) resistor r=152 //w=0.17 //l=0.17 //layer=licon //count=1 \
 //x=24.115 //y=4.88 //x2=24.115 //y2=4.88
r105 (  9 11 ) resistor r=93.7754 //w=0.187 //l=1.37 //layer=li \
 //thickness=0.1 //x=24.115 //y=3.51 //x2=24.115 //y2=4.88
r106 (  6 34 ) resistor r=152 //w=0.17 //l=0.17 //layer=licon //count=1 \
 //x=24.115 //y=2.26 //x2=24.115 //y2=2.26
r107 (  6 9 ) resistor r=85.5615 //w=0.187 //l=1.25 //layer=li //thickness=0.1 \
 //x=24.115 //y=2.26 //x2=24.115 //y2=3.51
ends PM_DFFRNQX1\%noxref_10

subckt PM_DFFRNQX1\%noxref_11 ( 1 2 3 4 5 6 16 23 25 35 36 43 51 57 58 62 63 \
 65 71 72 75 76 77 78 79 80 81 82 83 84 85 86 87 88 90 96 97 98 99 103 104 105 \
 110 112 114 120 121 122 123 124 129 131 133 139 140 150 151 154 163 164 167 \
 175 177 178 179 )
c408 ( 179 0 ) capacitor c=0.023087f //x=16.53 //y=5.2
c409 ( 178 0 ) capacitor c=0.023519f //x=15.65 //y=5.2
c410 ( 177 0 ) capacitor c=0.0224735f //x=14.77 //y=5.2
c411 ( 175 0 ) capacitor c=0.00853354f //x=16.78 //y=1.095
c412 ( 167 0 ) capacitor c=0.0331844f //x=24.885 //y=4.88
c413 ( 164 0 ) capacitor c=0.0279499f //x=24.855 //y=2.095
c414 ( 163 0 ) capacitor c=0.0437302f //x=24.855 //y=2.26
c415 ( 154 0 ) capacitor c=0.0331095f //x=11.935 //y=4.88
c416 ( 151 0 ) capacitor c=0.0279499f //x=11.905 //y=2.095
c417 ( 150 0 ) capacitor c=0.0425269f //x=11.905 //y=2.26
c418 ( 140 0 ) capacitor c=0.0429696f //x=25.42 //y=1.43
c419 ( 139 0 ) capacitor c=0.0192208f //x=25.42 //y=1.085
c420 ( 133 0 ) capacitor c=0.0158629f //x=25.265 //y=1.585
c421 ( 131 0 ) capacitor c=0.0157803f //x=25.265 //y=0.93
c422 ( 129 0 ) capacitor c=0.0306375f //x=25.26 //y=4.97
c423 ( 124 0 ) capacitor c=0.0205163f //x=24.89 //y=1.74
c424 ( 123 0 ) capacitor c=0.0168481f //x=24.89 //y=1.43
c425 ( 122 0 ) capacitor c=0.0174783f //x=24.89 //y=1.085
c426 ( 121 0 ) capacitor c=0.0429696f //x=12.47 //y=1.43
c427 ( 120 0 ) capacitor c=0.0192208f //x=12.47 //y=1.085
c428 ( 114 0 ) capacitor c=0.0148884f //x=12.315 //y=1.585
c429 ( 112 0 ) capacitor c=0.0157803f //x=12.315 //y=0.93
c430 ( 110 0 ) capacitor c=0.0295235f //x=12.31 //y=4.97
c431 ( 105 0 ) capacitor c=0.0205163f //x=11.94 //y=1.74
c432 ( 104 0 ) capacitor c=0.0168481f //x=11.94 //y=1.43
c433 ( 103 0 ) capacitor c=0.0174783f //x=11.94 //y=1.085
c434 ( 99 0 ) capacitor c=0.0559896f //x=1.82 //y=4.97
c435 ( 98 0 ) capacitor c=0.0298189f //x=2.11 //y=4.97
c436 ( 97 0 ) capacitor c=0.0347816f //x=1.775 //y=1.4
c437 ( 96 0 ) capacitor c=0.0187487f //x=1.775 //y=1.055
c438 ( 90 0 ) capacitor c=0.0137055f //x=1.62 //y=1.555
c439 ( 88 0 ) capacitor c=0.0149861f //x=1.62 //y=0.9
c440 ( 87 0 ) capacitor c=0.102158f //x=1.245 //y=2.095
c441 ( 86 0 ) capacitor c=0.0229444f //x=1.245 //y=1.71
c442 ( 85 0 ) capacitor c=0.0234352f //x=1.245 //y=1.4
c443 ( 84 0 ) capacitor c=0.0198724f //x=1.245 //y=1.055
c444 ( 83 0 ) capacitor c=0.15358f //x=25.335 //y=6.2
c445 ( 82 0 ) capacitor c=0.110281f //x=24.895 //y=6.2
c446 ( 81 0 ) capacitor c=0.15358f //x=12.385 //y=6.2
c447 ( 80 0 ) capacitor c=0.110281f //x=11.945 //y=6.2
c448 ( 79 0 ) capacitor c=0.110114f //x=2.185 //y=6.2
c449 ( 78 0 ) capacitor c=0.158956f //x=1.745 //y=6.2
c450 ( 72 0 ) capacitor c=0.00116729f //x=16.675 //y=5.335
c451 ( 71 0 ) capacitor c=0.00192123f //x=15.795 //y=5.335
c452 ( 65 0 ) capacitor c=0.0765697f //x=24.855 //y=2.26
c453 ( 63 0 ) capacitor c=0.00453889f //x=24.855 //y=4.715
c454 ( 62 0 ) capacitor c=0.113171f //x=17.455 //y=4.25
c455 ( 58 0 ) capacitor c=0.00398962f //x=17.055 //y=1.845
c456 ( 57 0 ) capacitor c=0.0137288f //x=17.37 //y=1.845
c457 ( 51 0 ) capacitor c=0.029094f //x=17.37 //y=5.335
c458 ( 43 0 ) capacitor c=0.0184197f //x=16.59 //y=5.335
c459 ( 36 0 ) capacitor c=0.00332903f //x=15 //y=5.335
c460 ( 35 0 ) capacitor c=0.0148447f //x=15.71 //y=5.335
c461 ( 25 0 ) capacitor c=0.0719943f //x=11.905 //y=2.26
c462 ( 23 0 ) capacitor c=0.00453889f //x=11.905 //y=4.715
c463 ( 16 0 ) capacitor c=0.12442f //x=1.545 //y=2.26
c464 ( 6 0 ) capacitor c=0.00720076f //x=17.57 //y=4.25
c465 ( 5 0 ) capacitor c=0.22758f //x=24.74 //y=4.25
c466 ( 4 0 ) capacitor c=0.00557292f //x=12.02 //y=4.25
c467 ( 3 0 ) capacitor c=0.0892321f //x=17.34 //y=4.25
c468 ( 2 0 ) capacitor c=0.0160831f //x=1.66 //y=4.25
c469 ( 1 0 ) capacitor c=0.182607f //x=11.79 //y=4.25
r470 (  169 170 ) resistor r=32.4568 //w=0.214 //l=0.075 //layer=ply \
 //thickness=0.18 //x=24.885 //y=4.97 //x2=24.885 //y2=5.045
r471 (  167 169 ) resistor r=20.271 //w=0.214 //l=0.09 //layer=ply \
 //thickness=0.18 //x=24.885 //y=4.88 //x2=24.885 //y2=4.97
r472 (  163 164 ) resistor r=52.7279 //w=0.214 //l=0.165 //layer=ply \
 //thickness=0.18 //x=24.855 //y=2.26 //x2=24.855 //y2=2.095
r473 (  156 157 ) resistor r=32.4568 //w=0.214 //l=0.075 //layer=ply \
 //thickness=0.18 //x=11.935 //y=4.97 //x2=11.935 //y2=5.045
r474 (  154 156 ) resistor r=20.271 //w=0.214 //l=0.09 //layer=ply \
 //thickness=0.18 //x=11.935 //y=4.88 //x2=11.935 //y2=4.97
r475 (  150 151 ) resistor r=52.7279 //w=0.214 //l=0.165 //layer=ply \
 //thickness=0.18 //x=11.905 //y=2.26 //x2=11.905 //y2=2.095
r476 (  140 174 ) resistor r=45.1352 //w=0.168 //l=0.173853 //layer=ply \
 //thickness=0.18 //x=25.42 //y=1.43 //x2=25.38 //y2=1.585
r477 (  139 173 ) resistor r=45.1352 //w=0.168 //l=0.173853 //layer=ply \
 //thickness=0.18 //x=25.42 //y=1.085 //x2=25.38 //y2=0.93
r478 (  139 140 ) resistor r=176.904 //w=0.094 //l=0.345 //layer=ply \
 //thickness=0.18 //x=25.42 //y=1.085 //x2=25.42 //y2=1.43
r479 (  134 172 ) resistor r=10.701 //w=0.21 //l=0.115 //layer=ply \
 //thickness=0.18 //x=25.045 //y=1.585 //x2=24.93 //y2=1.585
r480 (  133 174 ) resistor r=5.52526 //w=0.168 //l=0.115 //layer=ply \
 //thickness=0.18 //x=25.265 //y=1.585 //x2=25.38 //y2=1.585
r481 (  132 171 ) resistor r=5.52526 //w=0.168 //l=0.115 //layer=ply \
 //thickness=0.18 //x=25.045 //y=0.93 //x2=24.93 //y2=0.93
r482 (  131 173 ) resistor r=5.52526 //w=0.168 //l=0.115 //layer=ply \
 //thickness=0.18 //x=25.265 //y=0.93 //x2=25.38 //y2=0.93
r483 (  131 132 ) resistor r=112.809 //w=0.094 //l=0.22 //layer=ply \
 //thickness=0.18 //x=25.265 //y=0.93 //x2=25.045 //y2=0.93
r484 (  130 169 ) resistor r=16.5046 //w=0.27 //l=0.135 //layer=ply \
 //thickness=0.18 //x=25.02 //y=4.97 //x2=24.885 //y2=4.97
r485 (  129 136 ) resistor r=26.9307 //w=0.15 //l=0.106066 //layer=ply \
 //thickness=0.18 //x=25.26 //y=4.97 //x2=25.335 //y2=5.045
r486 (  129 130 ) resistor r=123.064 //w=0.094 //l=0.24 //layer=ply \
 //thickness=0.18 //x=25.26 //y=4.97 //x2=25.02 //y2=4.97
r487 (  124 172 ) resistor r=39.5823 //w=0.21 //l=0.173853 //layer=ply \
 //thickness=0.18 //x=24.89 //y=1.74 //x2=24.93 //y2=1.585
r488 (  124 164 ) resistor r=182.032 //w=0.094 //l=0.355 //layer=ply \
 //thickness=0.18 //x=24.89 //y=1.74 //x2=24.89 //y2=2.095
r489 (  123 172 ) resistor r=39.5823 //w=0.21 //l=0.173853 //layer=ply \
 //thickness=0.18 //x=24.89 //y=1.43 //x2=24.93 //y2=1.585
r490 (  122 171 ) resistor r=45.1352 //w=0.168 //l=0.173853 //layer=ply \
 //thickness=0.18 //x=24.89 //y=1.085 //x2=24.93 //y2=0.93
r491 (  122 123 ) resistor r=176.904 //w=0.094 //l=0.345 //layer=ply \
 //thickness=0.18 //x=24.89 //y=1.085 //x2=24.89 //y2=1.43
r492 (  121 161 ) resistor r=45.1352 //w=0.168 //l=0.173853 //layer=ply \
 //thickness=0.18 //x=12.47 //y=1.43 //x2=12.43 //y2=1.585
r493 (  120 160 ) resistor r=45.1352 //w=0.168 //l=0.173853 //layer=ply \
 //thickness=0.18 //x=12.47 //y=1.085 //x2=12.43 //y2=0.93
r494 (  120 121 ) resistor r=176.904 //w=0.094 //l=0.345 //layer=ply \
 //thickness=0.18 //x=12.47 //y=1.085 //x2=12.47 //y2=1.43
r495 (  115 159 ) resistor r=10.701 //w=0.21 //l=0.115 //layer=ply \
 //thickness=0.18 //x=12.095 //y=1.585 //x2=11.98 //y2=1.585
r496 (  114 161 ) resistor r=5.52526 //w=0.168 //l=0.115 //layer=ply \
 //thickness=0.18 //x=12.315 //y=1.585 //x2=12.43 //y2=1.585
r497 (  113 158 ) resistor r=5.52526 //w=0.168 //l=0.115 //layer=ply \
 //thickness=0.18 //x=12.095 //y=0.93 //x2=11.98 //y2=0.93
r498 (  112 160 ) resistor r=5.52526 //w=0.168 //l=0.115 //layer=ply \
 //thickness=0.18 //x=12.315 //y=0.93 //x2=12.43 //y2=0.93
r499 (  112 113 ) resistor r=112.809 //w=0.094 //l=0.22 //layer=ply \
 //thickness=0.18 //x=12.315 //y=0.93 //x2=12.095 //y2=0.93
r500 (  111 156 ) resistor r=16.5046 //w=0.27 //l=0.135 //layer=ply \
 //thickness=0.18 //x=12.07 //y=4.97 //x2=11.935 //y2=4.97
r501 (  110 117 ) resistor r=26.9307 //w=0.15 //l=0.106066 //layer=ply \
 //thickness=0.18 //x=12.31 //y=4.97 //x2=12.385 //y2=5.045
r502 (  110 111 ) resistor r=123.064 //w=0.094 //l=0.24 //layer=ply \
 //thickness=0.18 //x=12.31 //y=4.97 //x2=12.07 //y2=4.97
r503 (  105 159 ) resistor r=39.5823 //w=0.21 //l=0.173853 //layer=ply \
 //thickness=0.18 //x=11.94 //y=1.74 //x2=11.98 //y2=1.585
r504 (  105 151 ) resistor r=182.032 //w=0.094 //l=0.355 //layer=ply \
 //thickness=0.18 //x=11.94 //y=1.74 //x2=11.94 //y2=2.095
r505 (  104 159 ) resistor r=39.5823 //w=0.21 //l=0.173853 //layer=ply \
 //thickness=0.18 //x=11.94 //y=1.43 //x2=11.98 //y2=1.585
r506 (  103 158 ) resistor r=45.1352 //w=0.168 //l=0.173853 //layer=ply \
 //thickness=0.18 //x=11.94 //y=1.085 //x2=11.98 //y2=0.93
r507 (  103 104 ) resistor r=176.904 //w=0.094 //l=0.345 //layer=ply \
 //thickness=0.18 //x=11.94 //y=1.085 //x2=11.94 //y2=1.43
r508 (  98 100 ) resistor r=26.9307 //w=0.15 //l=0.106066 //layer=ply \
 //thickness=0.18 //x=2.11 //y=4.97 //x2=2.185 //y2=5.045
r509 (  98 99 ) resistor r=148.702 //w=0.094 //l=0.29 //layer=ply \
 //thickness=0.18 //x=2.11 //y=4.97 //x2=1.82 //y2=4.97
r510 (  97 148 ) resistor r=45.1352 //w=0.168 //l=0.173853 //layer=ply \
 //thickness=0.18 //x=1.775 //y=1.4 //x2=1.735 //y2=1.555
r511 (  96 147 ) resistor r=45.1352 //w=0.168 //l=0.173853 //layer=ply \
 //thickness=0.18 //x=1.775 //y=1.055 //x2=1.735 //y2=0.9
r512 (  96 97 ) resistor r=176.904 //w=0.094 //l=0.345 //layer=ply \
 //thickness=0.18 //x=1.775 //y=1.055 //x2=1.775 //y2=1.4
r513 (  93 99 ) resistor r=22.7971 //w=0.269 //l=0.106066 //layer=ply \
 //thickness=0.18 //x=1.745 //y=5.045 //x2=1.82 //y2=4.97
r514 (  93 146 ) resistor r=35.8364 //w=0.269 //l=0.270185 //layer=ply \
 //thickness=0.18 //x=1.745 //y=5.045 //x2=1.545 //y2=4.88
r515 (  91 142 ) resistor r=10.701 //w=0.21 //l=0.115 //layer=ply \
 //thickness=0.18 //x=1.4 //y=1.555 //x2=1.285 //y2=1.555
r516 (  90 148 ) resistor r=5.52526 //w=0.168 //l=0.115 //layer=ply \
 //thickness=0.18 //x=1.62 //y=1.555 //x2=1.735 //y2=1.555
r517 (  89 141 ) resistor r=5.52526 //w=0.168 //l=0.115 //layer=ply \
 //thickness=0.18 //x=1.4 //y=0.9 //x2=1.285 //y2=0.9
r518 (  88 147 ) resistor r=5.52526 //w=0.168 //l=0.115 //layer=ply \
 //thickness=0.18 //x=1.62 //y=0.9 //x2=1.735 //y2=0.9
r519 (  88 89 ) resistor r=112.809 //w=0.094 //l=0.22 //layer=ply \
 //thickness=0.18 //x=1.62 //y=0.9 //x2=1.4 //y2=0.9
r520 (  87 144 ) resistor r=58.7805 //w=0.246 //l=0.373497 //layer=ply \
 //thickness=0.18 //x=1.245 //y=2.095 //x2=1.545 //y2=2.26
r521 (  86 142 ) resistor r=39.5823 //w=0.21 //l=0.173853 //layer=ply \
 //thickness=0.18 //x=1.245 //y=1.71 //x2=1.285 //y2=1.555
r522 (  86 87 ) resistor r=197.415 //w=0.094 //l=0.385 //layer=ply \
 //thickness=0.18 //x=1.245 //y=1.71 //x2=1.245 //y2=2.095
r523 (  85 142 ) resistor r=39.5823 //w=0.21 //l=0.173853 //layer=ply \
 //thickness=0.18 //x=1.245 //y=1.4 //x2=1.285 //y2=1.555
r524 (  84 141 ) resistor r=45.1352 //w=0.168 //l=0.173853 //layer=ply \
 //thickness=0.18 //x=1.245 //y=1.055 //x2=1.285 //y2=0.9
r525 (  84 85 ) resistor r=176.904 //w=0.094 //l=0.345 //layer=ply \
 //thickness=0.18 //x=1.245 //y=1.055 //x2=1.245 //y2=1.4
r526 (  83 136 ) resistor r=592.245 //w=0.094 //l=1.155 //layer=ply \
 //thickness=0.18 //x=25.335 //y=6.2 //x2=25.335 //y2=5.045
r527 (  82 170 ) resistor r=592.245 //w=0.094 //l=1.155 //layer=ply \
 //thickness=0.18 //x=24.895 //y=6.2 //x2=24.895 //y2=5.045
r528 (  81 117 ) resistor r=592.245 //w=0.094 //l=1.155 //layer=ply \
 //thickness=0.18 //x=12.385 //y=6.2 //x2=12.385 //y2=5.045
r529 (  80 157 ) resistor r=592.245 //w=0.094 //l=1.155 //layer=ply \
 //thickness=0.18 //x=11.945 //y=6.2 //x2=11.945 //y2=5.045
r530 (  79 100 ) resistor r=592.245 //w=0.094 //l=1.155 //layer=ply \
 //thickness=0.18 //x=2.185 //y=6.2 //x2=2.185 //y2=5.045
r531 (  78 93 ) resistor r=592.245 //w=0.094 //l=1.155 //layer=ply \
 //thickness=0.18 //x=1.745 //y=6.2 //x2=1.745 //y2=5.045
r532 (  77 133 ) resistor r=56.4043 //w=0.094 //l=0.11 //layer=ply \
 //thickness=0.18 //x=25.155 //y=1.585 //x2=25.265 //y2=1.585
r533 (  77 134 ) resistor r=56.4043 //w=0.094 //l=0.11 //layer=ply \
 //thickness=0.18 //x=25.155 //y=1.585 //x2=25.045 //y2=1.585
r534 (  76 114 ) resistor r=56.4043 //w=0.094 //l=0.11 //layer=ply \
 //thickness=0.18 //x=12.205 //y=1.585 //x2=12.315 //y2=1.585
r535 (  76 115 ) resistor r=56.4043 //w=0.094 //l=0.11 //layer=ply \
 //thickness=0.18 //x=12.205 //y=1.585 //x2=12.095 //y2=1.585
r536 (  75 90 ) resistor r=56.4043 //w=0.094 //l=0.11 //layer=ply \
 //thickness=0.18 //x=1.51 //y=1.555 //x2=1.62 //y2=1.555
r537 (  75 91 ) resistor r=56.4043 //w=0.094 //l=0.11 //layer=ply \
 //thickness=0.18 //x=1.51 //y=1.555 //x2=1.4 //y2=1.555
r538 (  74 167 ) resistor r=152 //w=0.17 //l=0.17 //layer=licon //count=1 \
 //x=24.885 //y=4.88 //x2=24.885 //y2=4.88
r539 (  70 154 ) resistor r=152 //w=0.17 //l=0.17 //layer=licon //count=1 \
 //x=11.935 //y=4.88 //x2=11.935 //y2=4.88
r540 (  65 163 ) resistor r=152 //w=0.17 //l=0.17 //layer=licon //count=1 \
 //x=24.855 //y=2.26 //x2=24.855 //y2=2.26
r541 (  65 68 ) resistor r=136.214 //w=0.187 //l=1.99 //layer=li \
 //thickness=0.1 //x=24.855 //y=2.26 //x2=24.855 //y2=4.25
r542 (  63 74 ) resistor r=11.4737 //w=0.186 //l=0.172337 //layer=li \
 //thickness=0.1 //x=24.855 //y=4.715 //x2=24.87 //y2=4.88
r543 (  63 68 ) resistor r=31.8289 //w=0.187 //l=0.465 //layer=li \
 //thickness=0.1 //x=24.855 //y=4.715 //x2=24.855 //y2=4.25
r544 (  60 62 ) resistor r=68.4492 //w=0.187 //l=1 //layer=li //thickness=0.1 \
 //x=17.455 //y=5.25 //x2=17.455 //y2=4.25
r545 (  59 62 ) resistor r=158.802 //w=0.187 //l=2.32 //layer=li \
 //thickness=0.1 //x=17.455 //y=1.93 //x2=17.455 //y2=4.25
r546 (  57 59 ) resistor r=7.15173 //w=0.17 //l=0.120208 //layer=li \
 //thickness=0.1 //x=17.37 //y=1.845 //x2=17.455 //y2=1.93
r547 (  57 58 ) resistor r=21.5615 //w=0.187 //l=0.315 //layer=li \
 //thickness=0.1 //x=17.37 //y=1.845 //x2=17.055 //y2=1.845
r548 (  53 58 ) resistor r=7.15173 //w=0.17 //l=0.120208 //layer=li \
 //thickness=0.1 //x=16.97 //y=1.76 //x2=17.055 //y2=1.845
r549 (  53 175 ) resistor r=39.016 //w=0.187 //l=0.57 //layer=li \
 //thickness=0.1 //x=16.97 //y=1.76 //x2=16.97 //y2=1.19
r550 (  52 72 ) resistor r=5.4201 //w=0.17 //l=0.085 //layer=li \
 //thickness=0.1 //x=16.76 //y=5.335 //x2=16.675 //y2=5.335
r551 (  51 60 ) resistor r=7.15173 //w=0.17 //l=0.120208 //layer=li \
 //thickness=0.1 //x=17.37 //y=5.335 //x2=17.455 //y2=5.25
r552 (  51 52 ) resistor r=41.754 //w=0.187 //l=0.61 //layer=li \
 //thickness=0.1 //x=17.37 //y=5.335 //x2=16.76 //y2=5.335
r553 (  45 72 ) resistor r=1.40859 //w=0.34 //l=0.085 //layer=li \
 //thickness=0.1 //x=16.675 //y=5.42 //x2=16.675 //y2=5.335
r554 (  45 179 ) resistor r=33.1979 //w=0.187 //l=0.485 //layer=li \
 //thickness=0.1 //x=16.675 //y=5.42 //x2=16.675 //y2=5.905
r555 (  44 71 ) resistor r=5.4201 //w=0.17 //l=0.085 //layer=li \
 //thickness=0.1 //x=15.88 //y=5.335 //x2=15.795 //y2=5.335
r556 (  43 72 ) resistor r=5.4201 //w=0.17 //l=0.085 //layer=li \
 //thickness=0.1 //x=16.59 //y=5.335 //x2=16.675 //y2=5.335
r557 (  43 44 ) resistor r=48.5989 //w=0.187 //l=0.71 //layer=li \
 //thickness=0.1 //x=16.59 //y=5.335 //x2=15.88 //y2=5.335
r558 (  37 71 ) resistor r=1.40859 //w=0.34 //l=0.085 //layer=li \
 //thickness=0.1 //x=15.795 //y=5.42 //x2=15.795 //y2=5.335
r559 (  37 178 ) resistor r=33.1979 //w=0.187 //l=0.485 //layer=li \
 //thickness=0.1 //x=15.795 //y=5.42 //x2=15.795 //y2=5.905
r560 (  35 71 ) resistor r=5.4201 //w=0.17 //l=0.085 //layer=li \
 //thickness=0.1 //x=15.71 //y=5.335 //x2=15.795 //y2=5.335
r561 (  35 36 ) resistor r=48.5989 //w=0.187 //l=0.71 //layer=li \
 //thickness=0.1 //x=15.71 //y=5.335 //x2=15 //y2=5.335
r562 (  29 36 ) resistor r=7.15173 //w=0.17 //l=0.120208 //layer=li \
 //thickness=0.1 //x=14.915 //y=5.42 //x2=15 //y2=5.335
r563 (  29 177 ) resistor r=33.1979 //w=0.187 //l=0.485 //layer=li \
 //thickness=0.1 //x=14.915 //y=5.42 //x2=14.915 //y2=5.905
r564 (  25 150 ) resistor r=152 //w=0.17 //l=0.17 //layer=licon //count=1 \
 //x=11.905 //y=2.26 //x2=11.905 //y2=2.26
r565 (  25 28 ) resistor r=136.214 //w=0.187 //l=1.99 //layer=li \
 //thickness=0.1 //x=11.905 //y=2.26 //x2=11.905 //y2=4.25
r566 (  23 70 ) resistor r=11.4737 //w=0.186 //l=0.172337 //layer=li \
 //thickness=0.1 //x=11.905 //y=4.715 //x2=11.92 //y2=4.88
r567 (  23 28 ) resistor r=31.8289 //w=0.187 //l=0.465 //layer=li \
 //thickness=0.1 //x=11.905 //y=4.715 //x2=11.905 //y2=4.25
r568 (  21 146 ) resistor r=152 //w=0.17 //l=0.17 //layer=licon //count=1 \
 //x=1.545 //y=4.88 //x2=1.545 //y2=4.88
r569 (  19 21 ) resistor r=43.123 //w=0.187 //l=0.63 //layer=li \
 //thickness=0.1 //x=1.545 //y=4.25 //x2=1.545 //y2=4.88
r570 (  16 144 ) resistor r=152 //w=0.17 //l=0.17 //layer=licon //count=1 \
 //x=1.545 //y=2.26 //x2=1.545 //y2=2.26
r571 (  16 19 ) resistor r=136.214 //w=0.187 //l=1.99 //layer=li \
 //thickness=0.1 //x=1.545 //y=2.26 //x2=1.545 //y2=4.25
r572 (  14 68 ) resistor r=9.3 //w=0.17 //l=0.17 //layer=mcon //count=1 \
 //x=24.855 //y=4.25 //x2=24.855 //y2=4.25
r573 (  12 62 ) resistor r=9.3 //w=0.17 //l=0.17 //layer=mcon //count=1 \
 //x=17.455 //y=4.25 //x2=17.455 //y2=4.25
r574 (  10 28 ) resistor r=9.3 //w=0.17 //l=0.17 //layer=mcon //count=1 \
 //x=11.905 //y=4.25 //x2=11.905 //y2=4.25
r575 (  8 19 ) resistor r=9.3 //w=0.17 //l=0.17 //layer=mcon //count=1 \
 //x=1.545 //y=4.25 //x2=1.545 //y2=4.25
r576 (  6 12 ) resistor r=0.0880901 //w=0.191 //l=0.115 //layer=m1 \
 //thickness=0.36 //x=17.57 //y=4.25 //x2=17.455 //y2=4.25
r577 (  5 14 ) resistor r=0.0717383 //w=0.224 //l=0.115 //layer=m1 \
 //thickness=0.36 //x=24.74 //y=4.25 //x2=24.855 //y2=4.25
r578 (  5 6 ) resistor r=6.8416 //w=0.131 //l=7.17 //layer=m1 //thickness=0.36 \
 //x=24.74 //y=4.25 //x2=17.57 //y2=4.25
r579 (  4 10 ) resistor r=0.0880901 //w=0.191 //l=0.115 //layer=m1 \
 //thickness=0.36 //x=12.02 //y=4.25 //x2=11.905 //y2=4.25
r580 (  3 12 ) resistor r=0.0880901 //w=0.191 //l=0.115 //layer=m1 \
 //thickness=0.36 //x=17.34 //y=4.25 //x2=17.455 //y2=4.25
r581 (  3 4 ) resistor r=5.07634 //w=0.131 //l=5.32 //layer=m1 \
 //thickness=0.36 //x=17.34 //y=4.25 //x2=12.02 //y2=4.25
r582 (  2 8 ) resistor r=0.0717383 //w=0.224 //l=0.115 //layer=m1 \
 //thickness=0.36 //x=1.66 //y=4.25 //x2=1.545 //y2=4.25
r583 (  1 10 ) resistor r=0.0880901 //w=0.191 //l=0.115 //layer=m1 \
 //thickness=0.36 //x=11.79 //y=4.25 //x2=11.905 //y2=4.25
r584 (  1 2 ) resistor r=9.66603 //w=0.131 //l=10.13 //layer=m1 \
 //thickness=0.36 //x=11.79 //y=4.25 //x2=1.66 //y2=4.25
ends PM_DFFRNQX1\%noxref_11

subckt PM_DFFRNQX1\%noxref_12 ( 1 5 9 13 17 35 )
c48 ( 35 0 ) capacitor c=0.0703709f //x=0.89 //y=0.555
c49 ( 17 0 ) capacitor c=0.0216756f //x=2.88 //y=1.77
c50 ( 13 0 ) capacitor c=0.0156939f //x=2.88 //y=0.72
c51 ( 9 0 ) capacitor c=0.00678203f //x=1.995 //y=0.805
c52 ( 5 0 ) capacitor c=0.0206412f //x=1.91 //y=1.77
c53 ( 1 0 ) capacitor c=0.0109947f //x=1.025 //y=1.685
r54 (  18 35 ) resistor r=5.4201 //w=0.17 //l=0.103078 //layer=li \
 //thickness=0.1 //x=2.08 //y=1.77 //x2=1.995 //y2=1.81
r55 (  18 35 ) resistor r=27.3797 //w=0.187 //l=0.4 //layer=li //thickness=0.1 \
 //x=2.08 //y=1.77 //x2=2.48 //y2=1.77
r56 (  17 35 ) resistor r=0.751729 //w=0.17 //l=0.085 //layer=li \
 //thickness=0.1 //x=2.88 //y=1.77 //x2=2.965 //y2=1.77
r57 (  17 35 ) resistor r=27.3797 //w=0.187 //l=0.4 //layer=li //thickness=0.1 \
 //x=2.88 //y=1.77 //x2=2.48 //y2=1.77
r58 (  14 35 ) resistor r=3.57586 //w=0.17 //l=0.103078 //layer=li \
 //thickness=0.1 //x=2.08 //y=0.72 //x2=1.995 //y2=0.68
r59 (  14 35 ) resistor r=27.3797 //w=0.187 //l=0.4 //layer=li //thickness=0.1 \
 //x=2.08 //y=0.72 //x2=2.48 //y2=0.72
r60 (  13 35 ) resistor r=0.751729 //w=0.17 //l=0.085 //layer=li \
 //thickness=0.1 //x=2.88 //y=0.72 //x2=2.965 //y2=0.72
r61 (  13 35 ) resistor r=27.3797 //w=0.187 //l=0.4 //layer=li //thickness=0.1 \
 //x=2.88 //y=0.72 //x2=2.48 //y2=0.72
r62 (  10 35 ) resistor r=1.40859 //w=0.34 //l=0.125 //layer=li \
 //thickness=0.1 //x=1.995 //y=1.685 //x2=1.995 //y2=1.81
r63 (  10 35 ) resistor r=42.0963 //w=0.187 //l=0.615 //layer=li \
 //thickness=0.1 //x=1.995 //y=1.685 //x2=1.995 //y2=1.07
r64 (  9 35 ) resistor r=3.57586 //w=0.17 //l=0.125 //layer=li //thickness=0.1 \
 //x=1.995 //y=0.805 //x2=1.995 //y2=0.68
r65 (  9 35 ) resistor r=18.139 //w=0.187 //l=0.265 //layer=li //thickness=0.1 \
 //x=1.995 //y=0.805 //x2=1.995 //y2=1.07
r66 (  6 35 ) resistor r=3.57586 //w=0.17 //l=0.103078 //layer=li \
 //thickness=0.1 //x=1.11 //y=1.77 //x2=1.025 //y2=1.81
r67 (  6 35 ) resistor r=27.3797 //w=0.187 //l=0.4 //layer=li //thickness=0.1 \
 //x=1.11 //y=1.77 //x2=1.51 //y2=1.77
r68 (  5 35 ) resistor r=5.4201 //w=0.17 //l=0.103078 //layer=li \
 //thickness=0.1 //x=1.91 //y=1.77 //x2=1.995 //y2=1.81
r69 (  5 35 ) resistor r=27.3797 //w=0.187 //l=0.4 //layer=li //thickness=0.1 \
 //x=1.91 //y=1.77 //x2=1.51 //y2=1.77
r70 (  1 35 ) resistor r=3.57586 //w=0.17 //l=0.125 //layer=li //thickness=0.1 \
 //x=1.025 //y=1.685 //x2=1.025 //y2=1.81
r71 (  1 35 ) resistor r=42.0963 //w=0.187 //l=0.615 //layer=li \
 //thickness=0.1 //x=1.025 //y=1.685 //x2=1.025 //y2=1.07
ends PM_DFFRNQX1\%noxref_12

subckt PM_DFFRNQX1\%noxref_13 ( 1 3 11 15 25 28 29 )
c53 ( 29 0 ) capacitor c=0.043074f //x=3.4 //y=0.555
c54 ( 28 0 ) capacitor c=0.00465142f //x=2.295 //y=1.09
c55 ( 25 0 ) capacitor c=0.00156479f //x=3.535 //y=1.175
c56 ( 15 0 ) capacitor c=0.00737666f //x=4.505 //y=0.805
c57 ( 11 0 ) capacitor c=0.0149771f //x=4.42 //y=0.72
c58 ( 3 0 ) capacitor c=0.00718386f //x=3.535 //y=0.805
c59 ( 1 0 ) capacitor c=0.0253322f //x=3.45 //y=1.175
r60 (  15 29 ) resistor r=3.57586 //w=0.17 //l=0.125 //layer=li \
 //thickness=0.1 //x=4.505 //y=0.805 //x2=4.505 //y2=0.68
r61 (  15 29 ) resistor r=18.139 //w=0.187 //l=0.265 //layer=li \
 //thickness=0.1 //x=4.505 //y=0.805 //x2=4.505 //y2=1.07
r62 (  12 29 ) resistor r=3.57586 //w=0.17 //l=0.103078 //layer=li \
 //thickness=0.1 //x=3.62 //y=0.72 //x2=3.535 //y2=0.68
r63 (  12 29 ) resistor r=27.3797 //w=0.187 //l=0.4 //layer=li //thickness=0.1 \
 //x=3.62 //y=0.72 //x2=4.02 //y2=0.72
r64 (  11 29 ) resistor r=3.57586 //w=0.17 //l=0.103078 //layer=li \
 //thickness=0.1 //x=4.42 //y=0.72 //x2=4.505 //y2=0.68
r65 (  11 29 ) resistor r=27.3797 //w=0.187 //l=0.4 //layer=li //thickness=0.1 \
 //x=4.42 //y=0.72 //x2=4.02 //y2=0.72
r66 (  7 25 ) resistor r=5.4201 //w=0.17 //l=0.085 //layer=li //thickness=0.1 \
 //x=3.535 //y=1.26 //x2=3.535 //y2=1.175
r67 (  7 29 ) resistor r=10.2674 //w=0.187 //l=0.15 //layer=li //thickness=0.1 \
 //x=3.535 //y=1.26 //x2=3.535 //y2=1.41
r68 (  4 25 ) resistor r=5.4201 //w=0.17 //l=0.085 //layer=li //thickness=0.1 \
 //x=3.535 //y=1.09 //x2=3.535 //y2=1.175
r69 (  4 29 ) resistor r=1.36898 //w=0.187 //l=0.02 //layer=li //thickness=0.1 \
 //x=3.535 //y=1.09 //x2=3.535 //y2=1.07
r70 (  3 29 ) resistor r=3.57586 //w=0.17 //l=0.125 //layer=li //thickness=0.1 \
 //x=3.535 //y=0.805 //x2=3.535 //y2=0.68
r71 (  3 29 ) resistor r=18.139 //w=0.187 //l=0.265 //layer=li //thickness=0.1 \
 //x=3.535 //y=0.805 //x2=3.535 //y2=1.07
r72 (  2 28 ) resistor r=0.751729 //w=0.17 //l=0.085 //layer=li \
 //thickness=0.1 //x=2.57 //y=1.175 //x2=2.485 //y2=1.175
r73 (  1 25 ) resistor r=1.40859 //w=0.34 //l=0.085 //layer=li //thickness=0.1 \
 //x=3.45 //y=1.175 //x2=3.535 //y2=1.175
r74 (  1 2 ) resistor r=60.2353 //w=0.187 //l=0.88 //layer=li //thickness=0.1 \
 //x=3.45 //y=1.175 //x2=2.57 //y2=1.175
ends PM_DFFRNQX1\%noxref_13

subckt PM_DFFRNQX1\%D ( 1 2 5 11 17 19 20 21 22 23 24 26 32 33 34 35 36 44 )
c89 ( 44 0 ) capacitor c=0.0335551f //x=7.465 //y=4.88
c90 ( 36 0 ) capacitor c=0.0245352f //x=7.8 //y=4.97
c91 ( 35 0 ) capacitor c=0.0836699f //x=7.555 //y=2.095
c92 ( 34 0 ) capacitor c=0.0170266f //x=7.555 //y=1.63
c93 ( 33 0 ) capacitor c=0.018609f //x=7.555 //y=1.4
c94 ( 32 0 ) capacitor c=0.0187309f //x=7.555 //y=1.09
c95 ( 26 0 ) capacitor c=0.014725f //x=7.4 //y=1.555
c96 ( 24 0 ) capacitor c=0.0146567f //x=7.4 //y=0.935
c97 ( 23 0 ) capacitor c=0.0335408f //x=7.03 //y=1.4
c98 ( 22 0 ) capacitor c=0.0173761f //x=7.03 //y=1.09
c99 ( 21 0 ) capacitor c=0.110114f //x=7.875 //y=6.2
c100 ( 20 0 ) capacitor c=0.11012f //x=7.435 //y=6.2
c101 ( 17 0 ) capacitor c=0.00874422f //x=7.492 //y=3.055
c102 ( 11 0 ) capacitor c=0.0573681f //x=7.465 //y=4.88
c103 ( 5 0 ) capacitor c=0.0150164f //x=7.465 //y=2.26
c104 ( 2 0 ) capacitor c=0.00905554f //x=7.52 //y=3.14
c105 ( 1 0 ) capacitor c=0.00842433f //x=7.52 //y=2.77
r106 (  46 47 ) resistor r=32.4568 //w=0.214 //l=0.075 //layer=ply \
 //thickness=0.18 //x=7.465 //y=4.97 //x2=7.465 //y2=5.045
r107 (  44 46 ) resistor r=20.271 //w=0.214 //l=0.09 //layer=ply \
 //thickness=0.18 //x=7.465 //y=4.88 //x2=7.465 //y2=4.97
r108 (  37 46 ) resistor r=16.5046 //w=0.27 //l=0.135 //layer=ply \
 //thickness=0.18 //x=7.6 //y=4.97 //x2=7.465 //y2=4.97
r109 (  36 38 ) resistor r=26.9307 //w=0.15 //l=0.106066 //layer=ply \
 //thickness=0.18 //x=7.8 //y=4.97 //x2=7.875 //y2=5.045
r110 (  36 37 ) resistor r=102.553 //w=0.094 //l=0.2 //layer=ply \
 //thickness=0.18 //x=7.8 //y=4.97 //x2=7.6 //y2=4.97
r111 (  35 51 ) resistor r=38.6777 //w=0.284 //l=0.198997 //layer=ply \
 //thickness=0.18 //x=7.555 //y=2.095 //x2=7.48 //y2=2.26
r112 (  34 49 ) resistor r=21.2976 //w=0.217 //l=0.0928709 //layer=ply \
 //thickness=0.18 //x=7.555 //y=1.63 //x2=7.515 //y2=1.555
r113 (  34 35 ) resistor r=238.436 //w=0.094 //l=0.465 //layer=ply \
 //thickness=0.18 //x=7.555 //y=1.63 //x2=7.555 //y2=2.095
r114 (  33 49 ) resistor r=39.0671 //w=0.217 //l=0.173853 //layer=ply \
 //thickness=0.18 //x=7.555 //y=1.4 //x2=7.515 //y2=1.555
r115 (  32 48 ) resistor r=45.1352 //w=0.168 //l=0.173853 //layer=ply \
 //thickness=0.18 //x=7.555 //y=1.09 //x2=7.515 //y2=0.935
r116 (  32 33 ) resistor r=158.957 //w=0.094 //l=0.31 //layer=ply \
 //thickness=0.18 //x=7.555 //y=1.09 //x2=7.555 //y2=1.4
r117 (  27 42 ) resistor r=5.52526 //w=0.168 //l=0.115 //layer=ply \
 //thickness=0.18 //x=7.185 //y=1.555 //x2=7.07 //y2=1.555
r118 (  26 49 ) resistor r=11.4558 //w=0.217 //l=0.115 //layer=ply \
 //thickness=0.18 //x=7.4 //y=1.555 //x2=7.515 //y2=1.555
r119 (  25 41 ) resistor r=5.52526 //w=0.168 //l=0.115 //layer=ply \
 //thickness=0.18 //x=7.185 //y=0.935 //x2=7.07 //y2=0.935
r120 (  24 48 ) resistor r=5.52526 //w=0.168 //l=0.115 //layer=ply \
 //thickness=0.18 //x=7.4 //y=0.935 //x2=7.515 //y2=0.935
r121 (  24 25 ) resistor r=110.245 //w=0.094 //l=0.215 //layer=ply \
 //thickness=0.18 //x=7.4 //y=0.935 //x2=7.185 //y2=0.935
r122 (  23 42 ) resistor r=45.1352 //w=0.168 //l=0.173853 //layer=ply \
 //thickness=0.18 //x=7.03 //y=1.4 //x2=7.07 //y2=1.555
r123 (  22 41 ) resistor r=45.1352 //w=0.168 //l=0.173853 //layer=ply \
 //thickness=0.18 //x=7.03 //y=1.09 //x2=7.07 //y2=0.935
r124 (  22 23 ) resistor r=158.957 //w=0.094 //l=0.31 //layer=ply \
 //thickness=0.18 //x=7.03 //y=1.09 //x2=7.03 //y2=1.4
r125 (  21 38 ) resistor r=592.245 //w=0.094 //l=1.155 //layer=ply \
 //thickness=0.18 //x=7.875 //y=6.2 //x2=7.875 //y2=5.045
r126 (  20 47 ) resistor r=592.245 //w=0.094 //l=1.155 //layer=ply \
 //thickness=0.18 //x=7.435 //y=6.2 //x2=7.435 //y2=5.045
r127 (  19 26 ) resistor r=55.3787 //w=0.094 //l=0.108 //layer=ply \
 //thickness=0.18 //x=7.292 //y=1.555 //x2=7.4 //y2=1.555
r128 (  19 27 ) resistor r=54.866 //w=0.094 //l=0.107 //layer=ply \
 //thickness=0.18 //x=7.292 //y=1.555 //x2=7.185 //y2=1.555
r129 (  15 17 ) resistor r=13.6898 //w=0.187 //l=0.2 //layer=li \
 //thickness=0.1 //x=7.465 //y=2.855 //x2=7.465 //y2=3.055
r130 (  11 44 ) resistor r=152 //w=0.17 //l=0.17 //layer=licon //count=1 \
 //x=7.465 //y=4.88 //x2=7.465 //y2=4.88
r131 (  11 18 ) resistor r=113.283 //w=0.187 //l=1.655 //layer=li \
 //thickness=0.1 //x=7.465 //y=4.88 //x2=7.465 //y2=3.225
r132 (  5 51 ) resistor r=152 //w=0.17 //l=0.17 //layer=licon //count=1 \
 //x=7.465 //y=2.26 //x2=7.465 //y2=2.26
r133 (  5 14 ) resistor r=29.0909 //w=0.187 //l=0.425 //layer=li \
 //thickness=0.1 //x=7.465 //y=2.26 //x2=7.465 //y2=2.685
r134 (  2 18 ) resistor r=5.1957 //w=0.242 //l=0.085 //layer=li \
 //thickness=0.1 //x=7.492 //y=3.14 //x2=7.492 //y2=3.225
r135 (  2 17 ) resistor r=5.1957 //w=0.242 //l=0.085 //layer=li \
 //thickness=0.1 //x=7.492 //y=3.14 //x2=7.492 //y2=3.055
r136 (  1 15 ) resistor r=5.1957 //w=0.242 //l=0.085 //layer=li \
 //thickness=0.1 //x=7.492 //y=2.77 //x2=7.492 //y2=2.855
r137 (  1 14 ) resistor r=5.1957 //w=0.242 //l=0.085 //layer=li \
 //thickness=0.1 //x=7.492 //y=2.77 //x2=7.492 //y2=2.685
ends PM_DFFRNQX1\%D

subckt PM_DFFRNQX1\%noxref_15 ( 1 5 9 13 17 35 )
c51 ( 35 0 ) capacitor c=0.0693021f //x=5.7 //y=0.555
c52 ( 17 0 ) capacitor c=0.0201762f //x=7.69 //y=1.77
c53 ( 13 0 ) capacitor c=0.0156174f //x=7.69 //y=0.72
c54 ( 9 0 ) capacitor c=0.00678203f //x=6.805 //y=0.805
c55 ( 5 0 ) capacitor c=0.0183576f //x=6.72 //y=1.77
c56 ( 1 0 ) capacitor c=0.00791969f //x=5.835 //y=1.685
r57 (  18 35 ) resistor r=5.4201 //w=0.17 //l=0.103078 //layer=li \
 //thickness=0.1 //x=6.89 //y=1.77 //x2=6.805 //y2=1.81
r58 (  18 35 ) resistor r=27.3797 //w=0.187 //l=0.4 //layer=li //thickness=0.1 \
 //x=6.89 //y=1.77 //x2=7.29 //y2=1.77
r59 (  17 35 ) resistor r=0.751729 //w=0.17 //l=0.085 //layer=li \
 //thickness=0.1 //x=7.69 //y=1.77 //x2=7.775 //y2=1.77
r60 (  17 35 ) resistor r=27.3797 //w=0.187 //l=0.4 //layer=li //thickness=0.1 \
 //x=7.69 //y=1.77 //x2=7.29 //y2=1.77
r61 (  14 35 ) resistor r=3.57586 //w=0.17 //l=0.103078 //layer=li \
 //thickness=0.1 //x=6.89 //y=0.72 //x2=6.805 //y2=0.68
r62 (  14 35 ) resistor r=27.3797 //w=0.187 //l=0.4 //layer=li //thickness=0.1 \
 //x=6.89 //y=0.72 //x2=7.29 //y2=0.72
r63 (  13 35 ) resistor r=0.751729 //w=0.17 //l=0.085 //layer=li \
 //thickness=0.1 //x=7.69 //y=0.72 //x2=7.775 //y2=0.72
r64 (  13 35 ) resistor r=27.3797 //w=0.187 //l=0.4 //layer=li //thickness=0.1 \
 //x=7.69 //y=0.72 //x2=7.29 //y2=0.72
r65 (  10 35 ) resistor r=1.40859 //w=0.34 //l=0.125 //layer=li \
 //thickness=0.1 //x=6.805 //y=1.685 //x2=6.805 //y2=1.81
r66 (  10 35 ) resistor r=42.0963 //w=0.187 //l=0.615 //layer=li \
 //thickness=0.1 //x=6.805 //y=1.685 //x2=6.805 //y2=1.07
r67 (  9 35 ) resistor r=3.57586 //w=0.17 //l=0.125 //layer=li //thickness=0.1 \
 //x=6.805 //y=0.805 //x2=6.805 //y2=0.68
r68 (  9 35 ) resistor r=18.139 //w=0.187 //l=0.265 //layer=li //thickness=0.1 \
 //x=6.805 //y=0.805 //x2=6.805 //y2=1.07
r69 (  6 35 ) resistor r=3.57586 //w=0.17 //l=0.103078 //layer=li \
 //thickness=0.1 //x=5.92 //y=1.77 //x2=5.835 //y2=1.81
r70 (  6 35 ) resistor r=27.3797 //w=0.187 //l=0.4 //layer=li //thickness=0.1 \
 //x=5.92 //y=1.77 //x2=6.32 //y2=1.77
r71 (  5 35 ) resistor r=5.4201 //w=0.17 //l=0.103078 //layer=li \
 //thickness=0.1 //x=6.72 //y=1.77 //x2=6.805 //y2=1.81
r72 (  5 35 ) resistor r=27.3797 //w=0.187 //l=0.4 //layer=li //thickness=0.1 \
 //x=6.72 //y=1.77 //x2=6.32 //y2=1.77
r73 (  1 35 ) resistor r=3.57586 //w=0.17 //l=0.125 //layer=li //thickness=0.1 \
 //x=5.835 //y=1.685 //x2=5.835 //y2=1.81
r74 (  1 35 ) resistor r=42.0963 //w=0.187 //l=0.615 //layer=li \
 //thickness=0.1 //x=5.835 //y=1.685 //x2=5.835 //y2=1.07
ends PM_DFFRNQX1\%noxref_15

subckt PM_DFFRNQX1\%noxref_16 ( 1 3 11 15 25 28 29 )
c54 ( 29 0 ) capacitor c=0.0423432f //x=8.21 //y=0.555
c55 ( 28 0 ) capacitor c=0.00463374f //x=7.105 //y=1.09
c56 ( 25 0 ) capacitor c=0.00156479f //x=8.345 //y=1.175
c57 ( 15 0 ) capacitor c=0.00737666f //x=9.315 //y=0.805
c58 ( 11 0 ) capacitor c=0.0143878f //x=9.23 //y=0.72
c59 ( 3 0 ) capacitor c=0.00718386f //x=8.345 //y=0.805
c60 ( 1 0 ) capacitor c=0.0242666f //x=8.26 //y=1.175
r61 (  15 29 ) resistor r=3.57586 //w=0.17 //l=0.125 //layer=li \
 //thickness=0.1 //x=9.315 //y=0.805 //x2=9.315 //y2=0.68
r62 (  15 29 ) resistor r=18.139 //w=0.187 //l=0.265 //layer=li \
 //thickness=0.1 //x=9.315 //y=0.805 //x2=9.315 //y2=1.07
r63 (  12 29 ) resistor r=3.57586 //w=0.17 //l=0.103078 //layer=li \
 //thickness=0.1 //x=8.43 //y=0.72 //x2=8.345 //y2=0.68
r64 (  12 29 ) resistor r=27.3797 //w=0.187 //l=0.4 //layer=li //thickness=0.1 \
 //x=8.43 //y=0.72 //x2=8.83 //y2=0.72
r65 (  11 29 ) resistor r=3.57586 //w=0.17 //l=0.103078 //layer=li \
 //thickness=0.1 //x=9.23 //y=0.72 //x2=9.315 //y2=0.68
r66 (  11 29 ) resistor r=27.3797 //w=0.187 //l=0.4 //layer=li //thickness=0.1 \
 //x=9.23 //y=0.72 //x2=8.83 //y2=0.72
r67 (  7 25 ) resistor r=5.4201 //w=0.17 //l=0.085 //layer=li //thickness=0.1 \
 //x=8.345 //y=1.26 //x2=8.345 //y2=1.175
r68 (  7 29 ) resistor r=10.2674 //w=0.187 //l=0.15 //layer=li //thickness=0.1 \
 //x=8.345 //y=1.26 //x2=8.345 //y2=1.41
r69 (  4 25 ) resistor r=5.4201 //w=0.17 //l=0.085 //layer=li //thickness=0.1 \
 //x=8.345 //y=1.09 //x2=8.345 //y2=1.175
r70 (  4 29 ) resistor r=1.36898 //w=0.187 //l=0.02 //layer=li //thickness=0.1 \
 //x=8.345 //y=1.09 //x2=8.345 //y2=1.07
r71 (  3 29 ) resistor r=3.57586 //w=0.17 //l=0.125 //layer=li //thickness=0.1 \
 //x=8.345 //y=0.805 //x2=8.345 //y2=0.68
r72 (  3 29 ) resistor r=18.139 //w=0.187 //l=0.265 //layer=li //thickness=0.1 \
 //x=8.345 //y=0.805 //x2=8.345 //y2=1.07
r73 (  2 28 ) resistor r=0.751729 //w=0.17 //l=0.085 //layer=li \
 //thickness=0.1 //x=7.38 //y=1.175 //x2=7.295 //y2=1.175
r74 (  1 25 ) resistor r=1.40859 //w=0.34 //l=0.085 //layer=li //thickness=0.1 \
 //x=8.26 //y=1.175 //x2=8.345 //y2=1.175
r75 (  1 2 ) resistor r=60.2353 //w=0.187 //l=0.88 //layer=li //thickness=0.1 \
 //x=8.26 //y=1.175 //x2=7.38 //y2=1.175
ends PM_DFFRNQX1\%noxref_16

subckt PM_DFFRNQX1\%noxref_17 ( 1 5 9 10 13 17 29 )
c52 ( 29 0 ) capacitor c=0.0632682f //x=10.615 //y=0.545
c53 ( 17 0 ) capacitor c=0.0072343f //x=12.69 //y=0.795
c54 ( 13 0 ) capacitor c=0.0145084f //x=12.605 //y=0.71
c55 ( 10 0 ) capacitor c=0.00582081f //x=11.72 //y=1.675
c56 ( 9 0 ) capacitor c=0.006761f //x=11.72 //y=0.795
c57 ( 5 0 ) capacitor c=0.0173046f //x=11.635 //y=1.76
c58 ( 1 0 ) capacitor c=0.00733328f //x=10.75 //y=1.675
r59 (  17 29 ) resistor r=3.57586 //w=0.17 //l=0.125 //layer=li \
 //thickness=0.1 //x=12.69 //y=0.795 //x2=12.69 //y2=0.67
r60 (  17 29 ) resistor r=18.139 //w=0.187 //l=0.265 //layer=li \
 //thickness=0.1 //x=12.69 //y=0.795 //x2=12.69 //y2=1.06
r61 (  14 29 ) resistor r=3.57586 //w=0.17 //l=0.103078 //layer=li \
 //thickness=0.1 //x=11.805 //y=0.71 //x2=11.72 //y2=0.67
r62 (  14 29 ) resistor r=27.3797 //w=0.187 //l=0.4 //layer=li //thickness=0.1 \
 //x=11.805 //y=0.71 //x2=12.205 //y2=0.71
r63 (  13 29 ) resistor r=3.57586 //w=0.17 //l=0.103078 //layer=li \
 //thickness=0.1 //x=12.605 //y=0.71 //x2=12.69 //y2=0.67
r64 (  13 29 ) resistor r=27.3797 //w=0.187 //l=0.4 //layer=li //thickness=0.1 \
 //x=12.605 //y=0.71 //x2=12.205 //y2=0.71
r65 (  10 29 ) resistor r=3.57586 //w=0.17 //l=0.125 //layer=li \
 //thickness=0.1 //x=11.72 //y=1.675 //x2=11.72 //y2=1.8
r66 (  10 29 ) resistor r=42.0963 //w=0.187 //l=0.615 //layer=li \
 //thickness=0.1 //x=11.72 //y=1.675 //x2=11.72 //y2=1.06
r67 (  9 29 ) resistor r=3.57586 //w=0.17 //l=0.125 //layer=li //thickness=0.1 \
 //x=11.72 //y=0.795 //x2=11.72 //y2=0.67
r68 (  9 29 ) resistor r=18.139 //w=0.187 //l=0.265 //layer=li //thickness=0.1 \
 //x=11.72 //y=0.795 //x2=11.72 //y2=1.06
r69 (  6 29 ) resistor r=3.57586 //w=0.17 //l=0.103078 //layer=li \
 //thickness=0.1 //x=10.835 //y=1.76 //x2=10.75 //y2=1.8
r70 (  6 29 ) resistor r=27.3797 //w=0.187 //l=0.4 //layer=li //thickness=0.1 \
 //x=10.835 //y=1.76 //x2=11.235 //y2=1.76
r71 (  5 29 ) resistor r=3.57586 //w=0.17 //l=0.103078 //layer=li \
 //thickness=0.1 //x=11.635 //y=1.76 //x2=11.72 //y2=1.8
r72 (  5 29 ) resistor r=27.3797 //w=0.187 //l=0.4 //layer=li //thickness=0.1 \
 //x=11.635 //y=1.76 //x2=11.235 //y2=1.76
r73 (  1 29 ) resistor r=3.57586 //w=0.17 //l=0.125 //layer=li //thickness=0.1 \
 //x=10.75 //y=1.675 //x2=10.75 //y2=1.8
r74 (  1 29 ) resistor r=42.0963 //w=0.187 //l=0.615 //layer=li \
 //thickness=0.1 //x=10.75 //y=1.675 //x2=10.75 //y2=1.06
ends PM_DFFRNQX1\%noxref_17

subckt PM_DFFRNQX1\%noxref_18 ( 1 5 9 13 17 35 )
c51 ( 35 0 ) capacitor c=0.0673029f //x=13.84 //y=0.555
c52 ( 17 0 ) capacitor c=0.0173844f //x=15.83 //y=1.77
c53 ( 13 0 ) capacitor c=0.0154936f //x=15.83 //y=0.72
c54 ( 9 0 ) capacitor c=0.00678203f //x=14.945 //y=0.805
c55 ( 5 0 ) capacitor c=0.0164013f //x=14.86 //y=1.77
c56 ( 1 0 ) capacitor c=0.00696517f //x=13.975 //y=1.685
r57 (  18 35 ) resistor r=5.4201 //w=0.17 //l=0.103078 //layer=li \
 //thickness=0.1 //x=15.03 //y=1.77 //x2=14.945 //y2=1.81
r58 (  18 35 ) resistor r=27.3797 //w=0.187 //l=0.4 //layer=li //thickness=0.1 \
 //x=15.03 //y=1.77 //x2=15.43 //y2=1.77
r59 (  17 35 ) resistor r=0.751729 //w=0.17 //l=0.085 //layer=li \
 //thickness=0.1 //x=15.83 //y=1.77 //x2=15.915 //y2=1.77
r60 (  17 35 ) resistor r=27.3797 //w=0.187 //l=0.4 //layer=li //thickness=0.1 \
 //x=15.83 //y=1.77 //x2=15.43 //y2=1.77
r61 (  14 35 ) resistor r=3.57586 //w=0.17 //l=0.103078 //layer=li \
 //thickness=0.1 //x=15.03 //y=0.72 //x2=14.945 //y2=0.68
r62 (  14 35 ) resistor r=27.3797 //w=0.187 //l=0.4 //layer=li //thickness=0.1 \
 //x=15.03 //y=0.72 //x2=15.43 //y2=0.72
r63 (  13 35 ) resistor r=0.751729 //w=0.17 //l=0.085 //layer=li \
 //thickness=0.1 //x=15.83 //y=0.72 //x2=15.915 //y2=0.72
r64 (  13 35 ) resistor r=27.3797 //w=0.187 //l=0.4 //layer=li //thickness=0.1 \
 //x=15.83 //y=0.72 //x2=15.43 //y2=0.72
r65 (  10 35 ) resistor r=1.40859 //w=0.34 //l=0.125 //layer=li \
 //thickness=0.1 //x=14.945 //y=1.685 //x2=14.945 //y2=1.81
r66 (  10 35 ) resistor r=42.0963 //w=0.187 //l=0.615 //layer=li \
 //thickness=0.1 //x=14.945 //y=1.685 //x2=14.945 //y2=1.07
r67 (  9 35 ) resistor r=3.57586 //w=0.17 //l=0.125 //layer=li //thickness=0.1 \
 //x=14.945 //y=0.805 //x2=14.945 //y2=0.68
r68 (  9 35 ) resistor r=18.139 //w=0.187 //l=0.265 //layer=li //thickness=0.1 \
 //x=14.945 //y=0.805 //x2=14.945 //y2=1.07
r69 (  6 35 ) resistor r=3.57586 //w=0.17 //l=0.103078 //layer=li \
 //thickness=0.1 //x=14.06 //y=1.77 //x2=13.975 //y2=1.81
r70 (  6 35 ) resistor r=27.3797 //w=0.187 //l=0.4 //layer=li //thickness=0.1 \
 //x=14.06 //y=1.77 //x2=14.46 //y2=1.77
r71 (  5 35 ) resistor r=5.4201 //w=0.17 //l=0.103078 //layer=li \
 //thickness=0.1 //x=14.86 //y=1.77 //x2=14.945 //y2=1.81
r72 (  5 35 ) resistor r=27.3797 //w=0.187 //l=0.4 //layer=li //thickness=0.1 \
 //x=14.86 //y=1.77 //x2=14.46 //y2=1.77
r73 (  1 35 ) resistor r=3.57586 //w=0.17 //l=0.125 //layer=li //thickness=0.1 \
 //x=13.975 //y=1.685 //x2=13.975 //y2=1.81
r74 (  1 35 ) resistor r=42.0963 //w=0.187 //l=0.615 //layer=li \
 //thickness=0.1 //x=13.975 //y=1.685 //x2=13.975 //y2=1.07
ends PM_DFFRNQX1\%noxref_18

subckt PM_DFFRNQX1\%noxref_19 ( 1 3 11 15 25 28 29 )
c54 ( 29 0 ) capacitor c=0.0413887f //x=16.35 //y=0.555
c55 ( 28 0 ) capacitor c=0.0045748f //x=15.245 //y=1.09
c56 ( 25 0 ) capacitor c=0.00156479f //x=16.485 //y=1.175
c57 ( 15 0 ) capacitor c=0.00737666f //x=17.455 //y=0.805
c58 ( 11 0 ) capacitor c=0.0143878f //x=17.37 //y=0.72
c59 ( 3 0 ) capacitor c=0.00718386f //x=16.485 //y=0.805
c60 ( 1 0 ) capacitor c=0.0220678f //x=16.4 //y=1.175
r61 (  15 29 ) resistor r=3.57586 //w=0.17 //l=0.125 //layer=li \
 //thickness=0.1 //x=17.455 //y=0.805 //x2=17.455 //y2=0.68
r62 (  15 29 ) resistor r=18.139 //w=0.187 //l=0.265 //layer=li \
 //thickness=0.1 //x=17.455 //y=0.805 //x2=17.455 //y2=1.07
r63 (  12 29 ) resistor r=3.57586 //w=0.17 //l=0.103078 //layer=li \
 //thickness=0.1 //x=16.57 //y=0.72 //x2=16.485 //y2=0.68
r64 (  12 29 ) resistor r=27.3797 //w=0.187 //l=0.4 //layer=li //thickness=0.1 \
 //x=16.57 //y=0.72 //x2=16.97 //y2=0.72
r65 (  11 29 ) resistor r=3.57586 //w=0.17 //l=0.103078 //layer=li \
 //thickness=0.1 //x=17.37 //y=0.72 //x2=17.455 //y2=0.68
r66 (  11 29 ) resistor r=27.3797 //w=0.187 //l=0.4 //layer=li //thickness=0.1 \
 //x=17.37 //y=0.72 //x2=16.97 //y2=0.72
r67 (  7 25 ) resistor r=5.4201 //w=0.17 //l=0.085 //layer=li //thickness=0.1 \
 //x=16.485 //y=1.26 //x2=16.485 //y2=1.175
r68 (  7 29 ) resistor r=10.2674 //w=0.187 //l=0.15 //layer=li //thickness=0.1 \
 //x=16.485 //y=1.26 //x2=16.485 //y2=1.41
r69 (  4 25 ) resistor r=5.4201 //w=0.17 //l=0.085 //layer=li //thickness=0.1 \
 //x=16.485 //y=1.09 //x2=16.485 //y2=1.175
r70 (  4 29 ) resistor r=1.36898 //w=0.187 //l=0.02 //layer=li //thickness=0.1 \
 //x=16.485 //y=1.09 //x2=16.485 //y2=1.07
r71 (  3 29 ) resistor r=3.57586 //w=0.17 //l=0.125 //layer=li //thickness=0.1 \
 //x=16.485 //y=0.805 //x2=16.485 //y2=0.68
r72 (  3 29 ) resistor r=18.139 //w=0.187 //l=0.265 //layer=li //thickness=0.1 \
 //x=16.485 //y=0.805 //x2=16.485 //y2=1.07
r73 (  2 28 ) resistor r=0.751729 //w=0.17 //l=0.085 //layer=li \
 //thickness=0.1 //x=15.52 //y=1.175 //x2=15.435 //y2=1.175
r74 (  1 25 ) resistor r=1.40859 //w=0.34 //l=0.085 //layer=li //thickness=0.1 \
 //x=16.4 //y=1.175 //x2=16.485 //y2=1.175
r75 (  1 2 ) resistor r=60.2353 //w=0.187 //l=0.88 //layer=li //thickness=0.1 \
 //x=16.4 //y=1.175 //x2=15.52 //y2=1.175
ends PM_DFFRNQX1\%noxref_19

subckt PM_DFFRNQX1\%noxref_20 ( 1 5 9 13 17 35 )
c52 ( 35 0 ) capacitor c=0.0688914f //x=18.65 //y=0.555
c53 ( 17 0 ) capacitor c=0.017663f //x=20.64 //y=1.77
c54 ( 13 0 ) capacitor c=0.0155709f //x=20.64 //y=0.72
c55 ( 9 0 ) capacitor c=0.00678203f //x=19.755 //y=0.805
c56 ( 5 0 ) capacitor c=0.0164013f //x=19.67 //y=1.77
c57 ( 1 0 ) capacitor c=0.00696517f //x=18.785 //y=1.685
r58 (  18 35 ) resistor r=5.4201 //w=0.17 //l=0.103078 //layer=li \
 //thickness=0.1 //x=19.84 //y=1.77 //x2=19.755 //y2=1.81
r59 (  18 35 ) resistor r=27.3797 //w=0.187 //l=0.4 //layer=li //thickness=0.1 \
 //x=19.84 //y=1.77 //x2=20.24 //y2=1.77
r60 (  17 35 ) resistor r=0.751729 //w=0.17 //l=0.085 //layer=li \
 //thickness=0.1 //x=20.64 //y=1.77 //x2=20.725 //y2=1.77
r61 (  17 35 ) resistor r=27.3797 //w=0.187 //l=0.4 //layer=li //thickness=0.1 \
 //x=20.64 //y=1.77 //x2=20.24 //y2=1.77
r62 (  14 35 ) resistor r=3.57586 //w=0.17 //l=0.103078 //layer=li \
 //thickness=0.1 //x=19.84 //y=0.72 //x2=19.755 //y2=0.68
r63 (  14 35 ) resistor r=27.3797 //w=0.187 //l=0.4 //layer=li //thickness=0.1 \
 //x=19.84 //y=0.72 //x2=20.24 //y2=0.72
r64 (  13 35 ) resistor r=0.751729 //w=0.17 //l=0.085 //layer=li \
 //thickness=0.1 //x=20.64 //y=0.72 //x2=20.725 //y2=0.72
r65 (  13 35 ) resistor r=27.3797 //w=0.187 //l=0.4 //layer=li //thickness=0.1 \
 //x=20.64 //y=0.72 //x2=20.24 //y2=0.72
r66 (  10 35 ) resistor r=1.40859 //w=0.34 //l=0.125 //layer=li \
 //thickness=0.1 //x=19.755 //y=1.685 //x2=19.755 //y2=1.81
r67 (  10 35 ) resistor r=42.0963 //w=0.187 //l=0.615 //layer=li \
 //thickness=0.1 //x=19.755 //y=1.685 //x2=19.755 //y2=1.07
r68 (  9 35 ) resistor r=3.57586 //w=0.17 //l=0.125 //layer=li //thickness=0.1 \
 //x=19.755 //y=0.805 //x2=19.755 //y2=0.68
r69 (  9 35 ) resistor r=18.139 //w=0.187 //l=0.265 //layer=li //thickness=0.1 \
 //x=19.755 //y=0.805 //x2=19.755 //y2=1.07
r70 (  6 35 ) resistor r=3.57586 //w=0.17 //l=0.103078 //layer=li \
 //thickness=0.1 //x=18.87 //y=1.77 //x2=18.785 //y2=1.81
r71 (  6 35 ) resistor r=27.3797 //w=0.187 //l=0.4 //layer=li //thickness=0.1 \
 //x=18.87 //y=1.77 //x2=19.27 //y2=1.77
r72 (  5 35 ) resistor r=5.4201 //w=0.17 //l=0.103078 //layer=li \
 //thickness=0.1 //x=19.67 //y=1.77 //x2=19.755 //y2=1.81
r73 (  5 35 ) resistor r=27.3797 //w=0.187 //l=0.4 //layer=li //thickness=0.1 \
 //x=19.67 //y=1.77 //x2=19.27 //y2=1.77
r74 (  1 35 ) resistor r=3.57586 //w=0.17 //l=0.125 //layer=li //thickness=0.1 \
 //x=18.785 //y=1.685 //x2=18.785 //y2=1.81
r75 (  1 35 ) resistor r=42.0963 //w=0.187 //l=0.615 //layer=li \
 //thickness=0.1 //x=18.785 //y=1.685 //x2=18.785 //y2=1.07
ends PM_DFFRNQX1\%noxref_20

subckt PM_DFFRNQX1\%noxref_21 ( 1 3 11 15 25 28 29 )
c54 ( 29 0 ) capacitor c=0.0430705f //x=21.16 //y=0.555
c55 ( 28 0 ) capacitor c=0.00457437f //x=20.055 //y=1.09
c56 ( 25 0 ) capacitor c=0.00156479f //x=21.295 //y=1.175
c57 ( 15 0 ) capacitor c=0.00737666f //x=22.265 //y=0.805
c58 ( 11 0 ) capacitor c=0.0147617f //x=22.18 //y=0.72
c59 ( 3 0 ) capacitor c=0.00718386f //x=21.295 //y=0.805
c60 ( 1 0 ) capacitor c=0.0252161f //x=21.21 //y=1.175
r61 (  15 29 ) resistor r=3.57586 //w=0.17 //l=0.125 //layer=li \
 //thickness=0.1 //x=22.265 //y=0.805 //x2=22.265 //y2=0.68
r62 (  15 29 ) resistor r=18.139 //w=0.187 //l=0.265 //layer=li \
 //thickness=0.1 //x=22.265 //y=0.805 //x2=22.265 //y2=1.07
r63 (  12 29 ) resistor r=3.57586 //w=0.17 //l=0.103078 //layer=li \
 //thickness=0.1 //x=21.38 //y=0.72 //x2=21.295 //y2=0.68
r64 (  12 29 ) resistor r=27.3797 //w=0.187 //l=0.4 //layer=li //thickness=0.1 \
 //x=21.38 //y=0.72 //x2=21.78 //y2=0.72
r65 (  11 29 ) resistor r=3.57586 //w=0.17 //l=0.103078 //layer=li \
 //thickness=0.1 //x=22.18 //y=0.72 //x2=22.265 //y2=0.68
r66 (  11 29 ) resistor r=27.3797 //w=0.187 //l=0.4 //layer=li //thickness=0.1 \
 //x=22.18 //y=0.72 //x2=21.78 //y2=0.72
r67 (  7 25 ) resistor r=5.4201 //w=0.17 //l=0.085 //layer=li //thickness=0.1 \
 //x=21.295 //y=1.26 //x2=21.295 //y2=1.175
r68 (  7 29 ) resistor r=10.2674 //w=0.187 //l=0.15 //layer=li //thickness=0.1 \
 //x=21.295 //y=1.26 //x2=21.295 //y2=1.41
r69 (  4 25 ) resistor r=5.4201 //w=0.17 //l=0.085 //layer=li //thickness=0.1 \
 //x=21.295 //y=1.09 //x2=21.295 //y2=1.175
r70 (  4 29 ) resistor r=1.36898 //w=0.187 //l=0.02 //layer=li //thickness=0.1 \
 //x=21.295 //y=1.09 //x2=21.295 //y2=1.07
r71 (  3 29 ) resistor r=3.57586 //w=0.17 //l=0.125 //layer=li //thickness=0.1 \
 //x=21.295 //y=0.805 //x2=21.295 //y2=0.68
r72 (  3 29 ) resistor r=18.139 //w=0.187 //l=0.265 //layer=li //thickness=0.1 \
 //x=21.295 //y=0.805 //x2=21.295 //y2=1.07
r73 (  2 28 ) resistor r=0.751729 //w=0.17 //l=0.085 //layer=li \
 //thickness=0.1 //x=20.33 //y=1.175 //x2=20.245 //y2=1.175
r74 (  1 25 ) resistor r=1.40859 //w=0.34 //l=0.085 //layer=li //thickness=0.1 \
 //x=21.21 //y=1.175 //x2=21.295 //y2=1.175
r75 (  1 2 ) resistor r=60.2353 //w=0.187 //l=0.88 //layer=li //thickness=0.1 \
 //x=21.21 //y=1.175 //x2=20.33 //y2=1.175
ends PM_DFFRNQX1\%noxref_21

subckt PM_DFFRNQX1\%noxref_22 ( 1 5 9 10 13 17 29 )
c51 ( 29 0 ) capacitor c=0.0632621f //x=23.565 //y=0.545
c52 ( 17 0 ) capacitor c=0.00722223f //x=25.64 //y=0.795
c53 ( 13 0 ) capacitor c=0.0149664f //x=25.555 //y=0.71
c54 ( 10 0 ) capacitor c=0.00687696f //x=24.67 //y=1.675
c55 ( 9 0 ) capacitor c=0.006761f //x=24.67 //y=0.795
c56 ( 5 0 ) capacitor c=0.0201208f //x=24.585 //y=1.76
c57 ( 1 0 ) capacitor c=0.00828748f //x=23.7 //y=1.675
r58 (  17 29 ) resistor r=3.57586 //w=0.17 //l=0.125 //layer=li \
 //thickness=0.1 //x=25.64 //y=0.795 //x2=25.64 //y2=0.67
r59 (  17 29 ) resistor r=18.139 //w=0.187 //l=0.265 //layer=li \
 //thickness=0.1 //x=25.64 //y=0.795 //x2=25.64 //y2=1.06
r60 (  14 29 ) resistor r=3.57586 //w=0.17 //l=0.103078 //layer=li \
 //thickness=0.1 //x=24.755 //y=0.71 //x2=24.67 //y2=0.67
r61 (  14 29 ) resistor r=27.3797 //w=0.187 //l=0.4 //layer=li //thickness=0.1 \
 //x=24.755 //y=0.71 //x2=25.155 //y2=0.71
r62 (  13 29 ) resistor r=3.57586 //w=0.17 //l=0.103078 //layer=li \
 //thickness=0.1 //x=25.555 //y=0.71 //x2=25.64 //y2=0.67
r63 (  13 29 ) resistor r=27.3797 //w=0.187 //l=0.4 //layer=li //thickness=0.1 \
 //x=25.555 //y=0.71 //x2=25.155 //y2=0.71
r64 (  10 29 ) resistor r=3.57586 //w=0.17 //l=0.125 //layer=li \
 //thickness=0.1 //x=24.67 //y=1.675 //x2=24.67 //y2=1.8
r65 (  10 29 ) resistor r=42.0963 //w=0.187 //l=0.615 //layer=li \
 //thickness=0.1 //x=24.67 //y=1.675 //x2=24.67 //y2=1.06
r66 (  9 29 ) resistor r=3.57586 //w=0.17 //l=0.125 //layer=li //thickness=0.1 \
 //x=24.67 //y=0.795 //x2=24.67 //y2=0.67
r67 (  9 29 ) resistor r=18.139 //w=0.187 //l=0.265 //layer=li //thickness=0.1 \
 //x=24.67 //y=0.795 //x2=24.67 //y2=1.06
r68 (  6 29 ) resistor r=3.57586 //w=0.17 //l=0.103078 //layer=li \
 //thickness=0.1 //x=23.785 //y=1.76 //x2=23.7 //y2=1.8
r69 (  6 29 ) resistor r=27.3797 //w=0.187 //l=0.4 //layer=li //thickness=0.1 \
 //x=23.785 //y=1.76 //x2=24.185 //y2=1.76
r70 (  5 29 ) resistor r=3.57586 //w=0.17 //l=0.103078 //layer=li \
 //thickness=0.1 //x=24.585 //y=1.76 //x2=24.67 //y2=1.8
r71 (  5 29 ) resistor r=27.3797 //w=0.187 //l=0.4 //layer=li //thickness=0.1 \
 //x=24.585 //y=1.76 //x2=24.185 //y2=1.76
r72 (  1 29 ) resistor r=3.57586 //w=0.17 //l=0.125 //layer=li //thickness=0.1 \
 //x=23.7 //y=1.675 //x2=23.7 //y2=1.8
r73 (  1 29 ) resistor r=42.0963 //w=0.187 //l=0.615 //layer=li \
 //thickness=0.1 //x=23.7 //y=1.675 //x2=23.7 //y2=1.06
ends PM_DFFRNQX1\%noxref_22
