// File: DFFRNQX1.spi.pex
// Created: Sun Mar 15 12:40:22 2026
// Program "Calibre xRC"
// Version "v2023.2_27.15"
// Nominal Temperature: 30C
// Circuit Temperature: 30C
//
simulator lang=spectre
subckt PM_DFFRNQX1\%noxref_1 ( 1 2 3 4 5 7 10 11 13 14 15 16 18 19 20 22 23 30 \
 32 35 38 44 47 50 53 54 56 57 58 60 62 64 65 72 75 84 89 97 105 122 131 135 \
 136 137 138 139 140 144 145 146 151 153 156 157 158 159 160 161 165 167 170 \
 171 176 177 182 191 194 196 197 198 )
c431 ( 194 0 ) capacitor c=0.00885916f //x=8.64 //y=1.095
c432 ( 191 0 ) capacitor c=0.0682508f //x=11.165 //y=4.88
c433 ( 182 0 ) capacitor c=0.0710579f //x=3.765 //y=4.88
c434 ( 177 0 ) capacitor c=0.0278202f //x=3.765 //y=2.095
c435 ( 176 0 ) capacitor c=0.0479324f //x=3.765 //y=2.26
c436 ( 171 0 ) capacitor c=0.0318956f //x=11.5 //y=1.39
c437 ( 170 0 ) capacitor c=0.0186809f //x=11.5 //y=1.045
c438 ( 167 0 ) capacitor c=0.0141821f //x=11.345 //y=1.545
c439 ( 165 0 ) capacitor c=0.0158553f //x=11.345 //y=0.89
c440 ( 161 0 ) capacitor c=0.0854195f //x=10.97 //y=2.095
c441 ( 160 0 ) capacitor c=0.0229235f //x=10.97 //y=1.7
c442 ( 159 0 ) capacitor c=0.0234359f //x=10.97 //y=1.39
c443 ( 158 0 ) capacitor c=0.0198759f //x=10.97 //y=1.045
c444 ( 157 0 ) capacitor c=0.0443175f //x=4.285 //y=1.44
c445 ( 156 0 ) capacitor c=0.0199703f //x=4.285 //y=1.095
c446 ( 153 0 ) capacitor c=0.0162526f //x=4.13 //y=1.595
c447 ( 151 0 ) capacitor c=0.0157807f //x=4.13 //y=0.94
c448 ( 146 0 ) capacitor c=0.0220935f //x=3.755 //y=1.75
c449 ( 145 0 ) capacitor c=0.0207489f //x=3.755 //y=1.44
c450 ( 144 0 ) capacitor c=0.0194091f //x=3.755 //y=1.095
c451 ( 140 0 ) capacitor c=0.110369f //x=11.505 //y=6.2
c452 ( 139 0 ) capacitor c=0.154619f //x=11.065 //y=6.2
c453 ( 138 0 ) capacitor c=0.159671f //x=3.945 //y=6.2
c454 ( 137 0 ) capacitor c=0.110208f //x=3.505 //y=6.2
c455 ( 131 0 ) capacitor c=8.13425e-19 //x=11.165 //y=4.88
c456 ( 122 0 ) capacitor c=7.85889e-19 //x=11.165 //y=2.26
c457 ( 105 0 ) capacitor c=0.0292634f //x=8.535 //y=5.56
c458 ( 97 0 ) capacitor c=0.029137f //x=7.655 //y=5.56
c459 ( 89 0 ) capacitor c=0.0278099f //x=6.775 //y=5.56
c460 ( 84 0 ) capacitor c=7.7417e-19 //x=3.765 //y=4.88
c461 ( 75 0 ) capacitor c=0.00101179f //x=3.765 //y=2.26
c462 ( 72 0 ) capacitor c=5.96651e-19 //x=11.165 //y=3.51
c463 ( 65 0 ) capacitor c=0.0575743f //x=9.48 //y=3.51
c464 ( 64 0 ) capacitor c=0.0258251f //x=11.005 //y=3.51
c465 ( 62 0 ) capacitor c=0.00710937f //x=6.575 //y=3.495
c466 ( 60 0 ) capacitor c=0.0381622f //x=5.975 //y=3.51
c467 ( 58 0 ) capacitor c=0.0188644f //x=4.725 //y=3.5
c468 ( 57 0 ) capacitor c=0.00331832f //x=3.925 //y=3.51
c469 ( 56 0 ) capacitor c=0.00718343f //x=4.125 //y=3.51
c470 ( 54 0 ) capacitor c=0.0268056f //x=11.167 //y=4.74
c471 ( 53 0 ) capacitor c=0.00611114f //x=11.165 //y=4.88
c472 ( 50 0 ) capacitor c=0.00463527f //x=11.165 //y=2.26
c473 ( 47 0 ) capacitor c=0.0161834f //x=11.165 //y=3.51
c474 ( 44 0 ) capacitor c=0.0170515f //x=9.315 //y=3.51
c475 ( 38 0 ) capacitor c=0.00112339f //x=8.535 //y=5.335
c476 ( 35 0 ) capacitor c=0.00824259f //x=7.655 //y=5.335
c477 ( 32 0 ) capacitor c=0.0111234f //x=6.777 //y=5.335
c478 ( 30 0 ) capacitor c=0.0148558f //x=3.765 //y=3.51
c479 ( 23 0 ) capacitor c=0.0133355f //x=11.165 //y=3.67
c480 ( 22 0 ) capacitor c=0.0282347f //x=11.165 //y=3.35
c481 ( 20 0 ) capacitor c=0.0423878f //x=9.315 //y=5.25
c482 ( 19 0 ) capacitor c=0.0130115f //x=9.315 //y=3.67
c483 ( 18 0 ) capacitor c=0.0411304f //x=9.315 //y=3.35
c484 ( 16 0 ) capacitor c=0.00493487f //x=8.915 //y=1.845
c485 ( 15 0 ) capacitor c=0.012936f //x=9.23 //y=1.845
c486 ( 14 0 ) capacitor c=0.0136149f //x=8.83 //y=1.76
c487 ( 13 0 ) capacitor c=0.0112307f //x=8.83 //y=1.305
c488 ( 11 0 ) capacitor c=0.0238835f //x=9.23 //y=5.335
c489 ( 10 0 ) capacitor c=0.00906713f //x=8.535 //y=5.56
c490 ( 7 0 ) capacitor c=0.019596f //x=8.42 //y=5.335
c491 ( 5 0 ) capacitor c=0.0153086f //x=7.535 //y=5.335
c492 ( 4 0 ) capacitor c=0.0286297f //x=3.765 //y=4.75
c493 ( 3 0 ) capacitor c=0.0128763f //x=3.765 //y=3.67
c494 ( 2 0 ) capacitor c=0.0274817f //x=3.765 //y=3.35
c495 ( 1 0 ) capacitor c=0.00685053f //x=3.765 //y=2.375
r496 (  189 191 ) resistor r=20.6867 //w=0.233 //l=0.1 //layer=ply \
 //thickness=0.18 //x=11.065 //y=4.88 //x2=11.165 //y2=4.88
r497 (  176 177 ) resistor r=52.7279 //w=0.214 //l=0.165 //layer=ply \
 //thickness=0.18 //x=3.765 //y=2.26 //x2=3.765 //y2=2.095
r498 (  172 191 ) resistor r=70.3348 //w=0.233 //l=0.414367 //layer=ply \
 //thickness=0.18 //x=11.505 //y=5.045 //x2=11.165 //y2=4.88
r499 (  171 193 ) resistor r=45.1352 //w=0.168 //l=0.173853 //layer=ply \
 //thickness=0.18 //x=11.5 //y=1.39 //x2=11.46 //y2=1.545
r500 (  170 192 ) resistor r=45.1352 //w=0.168 //l=0.173853 //layer=ply \
 //thickness=0.18 //x=11.5 //y=1.045 //x2=11.46 //y2=0.89
r501 (  170 171 ) resistor r=176.904 //w=0.094 //l=0.345 //layer=ply \
 //thickness=0.18 //x=11.5 //y=1.045 //x2=11.5 //y2=1.39
r502 (  168 188 ) resistor r=10.701 //w=0.21 //l=0.115 //layer=ply \
 //thickness=0.18 //x=11.125 //y=1.545 //x2=11.01 //y2=1.545
r503 (  167 193 ) resistor r=5.52526 //w=0.168 //l=0.115 //layer=ply \
 //thickness=0.18 //x=11.345 //y=1.545 //x2=11.46 //y2=1.545
r504 (  166 187 ) resistor r=5.52526 //w=0.168 //l=0.115 //layer=ply \
 //thickness=0.18 //x=11.125 //y=0.89 //x2=11.01 //y2=0.89
r505 (  165 192 ) resistor r=5.52526 //w=0.168 //l=0.115 //layer=ply \
 //thickness=0.18 //x=11.345 //y=0.89 //x2=11.46 //y2=0.89
r506 (  165 166 ) resistor r=112.809 //w=0.094 //l=0.22 //layer=ply \
 //thickness=0.18 //x=11.345 //y=0.89 //x2=11.125 //y2=0.89
r507 (  162 189 ) resistor r=13.0941 //w=0.233 //l=0.165 //layer=ply \
 //thickness=0.18 //x=11.065 //y=5.045 //x2=11.065 //y2=4.88
r508 (  161 186 ) resistor r=34.8111 //w=0.27 //l=0.264953 //layer=ply \
 //thickness=0.18 //x=10.97 //y=2.095 //x2=11.165 //y2=2.26
r509 (  160 188 ) resistor r=39.5823 //w=0.21 //l=0.173853 //layer=ply \
 //thickness=0.18 //x=10.97 //y=1.7 //x2=11.01 //y2=1.545
r510 (  160 161 ) resistor r=202.543 //w=0.094 //l=0.395 //layer=ply \
 //thickness=0.18 //x=10.97 //y=1.7 //x2=10.97 //y2=2.095
r511 (  159 188 ) resistor r=39.5823 //w=0.21 //l=0.173853 //layer=ply \
 //thickness=0.18 //x=10.97 //y=1.39 //x2=11.01 //y2=1.545
r512 (  158 187 ) resistor r=45.1352 //w=0.168 //l=0.173853 //layer=ply \
 //thickness=0.18 //x=10.97 //y=1.045 //x2=11.01 //y2=0.89
r513 (  158 159 ) resistor r=176.904 //w=0.094 //l=0.345 //layer=ply \
 //thickness=0.18 //x=10.97 //y=1.045 //x2=10.97 //y2=1.39
r514 (  157 184 ) resistor r=45.1352 //w=0.168 //l=0.173853 //layer=ply \
 //thickness=0.18 //x=4.285 //y=1.44 //x2=4.245 //y2=1.595
r515 (  156 183 ) resistor r=45.1352 //w=0.168 //l=0.173853 //layer=ply \
 //thickness=0.18 //x=4.285 //y=1.095 //x2=4.245 //y2=0.94
r516 (  156 157 ) resistor r=176.904 //w=0.094 //l=0.345 //layer=ply \
 //thickness=0.18 //x=4.285 //y=1.095 //x2=4.285 //y2=1.44
r517 (  154 180 ) resistor r=10.701 //w=0.21 //l=0.115 //layer=ply \
 //thickness=0.18 //x=3.91 //y=1.595 //x2=3.795 //y2=1.595
r518 (  153 184 ) resistor r=5.52526 //w=0.168 //l=0.115 //layer=ply \
 //thickness=0.18 //x=4.13 //y=1.595 //x2=4.245 //y2=1.595
r519 (  152 179 ) resistor r=5.52526 //w=0.168 //l=0.115 //layer=ply \
 //thickness=0.18 //x=3.91 //y=0.94 //x2=3.795 //y2=0.94
r520 (  151 183 ) resistor r=5.52526 //w=0.168 //l=0.115 //layer=ply \
 //thickness=0.18 //x=4.13 //y=0.94 //x2=4.245 //y2=0.94
r521 (  151 152 ) resistor r=112.809 //w=0.094 //l=0.22 //layer=ply \
 //thickness=0.18 //x=4.13 //y=0.94 //x2=3.91 //y2=0.94
r522 (  148 182 ) resistor r=37.236 //w=0.233 //l=0.249199 //layer=ply \
 //thickness=0.18 //x=3.945 //y=5.045 //x2=3.765 //y2=4.88
r523 (  146 180 ) resistor r=39.5823 //w=0.21 //l=0.173853 //layer=ply \
 //thickness=0.18 //x=3.755 //y=1.75 //x2=3.795 //y2=1.595
r524 (  146 177 ) resistor r=176.904 //w=0.094 //l=0.345 //layer=ply \
 //thickness=0.18 //x=3.755 //y=1.75 //x2=3.755 //y2=2.095
r525 (  145 180 ) resistor r=39.5823 //w=0.21 //l=0.173853 //layer=ply \
 //thickness=0.18 //x=3.755 //y=1.44 //x2=3.795 //y2=1.595
r526 (  144 179 ) resistor r=45.1352 //w=0.168 //l=0.173853 //layer=ply \
 //thickness=0.18 //x=3.755 //y=1.095 //x2=3.795 //y2=0.94
r527 (  144 145 ) resistor r=176.904 //w=0.094 //l=0.345 //layer=ply \
 //thickness=0.18 //x=3.755 //y=1.095 //x2=3.755 //y2=1.44
r528 (  141 182 ) resistor r=53.7854 //w=0.233 //l=0.332415 //layer=ply \
 //thickness=0.18 //x=3.505 //y=5.045 //x2=3.765 //y2=4.88
r529 (  140 172 ) resistor r=592.245 //w=0.094 //l=1.155 //layer=ply \
 //thickness=0.18 //x=11.505 //y=6.2 //x2=11.505 //y2=5.045
r530 (  139 162 ) resistor r=592.245 //w=0.094 //l=1.155 //layer=ply \
 //thickness=0.18 //x=11.065 //y=6.2 //x2=11.065 //y2=5.045
r531 (  138 148 ) resistor r=592.245 //w=0.094 //l=1.155 //layer=ply \
 //thickness=0.18 //x=3.945 //y=6.2 //x2=3.945 //y2=5.045
r532 (  137 141 ) resistor r=592.245 //w=0.094 //l=1.155 //layer=ply \
 //thickness=0.18 //x=3.505 //y=6.2 //x2=3.505 //y2=5.045
r533 (  136 167 ) resistor r=56.4043 //w=0.094 //l=0.11 //layer=ply \
 //thickness=0.18 //x=11.235 //y=1.545 //x2=11.345 //y2=1.545
r534 (  136 168 ) resistor r=56.4043 //w=0.094 //l=0.11 //layer=ply \
 //thickness=0.18 //x=11.235 //y=1.545 //x2=11.125 //y2=1.545
r535 (  135 153 ) resistor r=56.4043 //w=0.094 //l=0.11 //layer=ply \
 //thickness=0.18 //x=4.02 //y=1.595 //x2=4.13 //y2=1.595
r536 (  135 154 ) resistor r=56.4043 //w=0.094 //l=0.11 //layer=ply \
 //thickness=0.18 //x=4.02 //y=1.595 //x2=3.91 //y2=1.595
r537 (  131 191 ) resistor r=152 //w=0.17 //l=0.17 //layer=licon //count=1 \
 //x=11.165 //y=4.88 //x2=11.165 //y2=4.88
r538 (  122 186 ) resistor r=152 //w=0.17 //l=0.17 //layer=licon //count=1 \
 //x=11.165 //y=2.26 //x2=11.165 //y2=2.26
r539 (  105 198 ) resistor r=23.615 //w=0.187 //l=0.345 //layer=li \
 //thickness=0.1 //x=8.535 //y=5.56 //x2=8.535 //y2=5.905
r540 (  97 197 ) resistor r=23.615 //w=0.187 //l=0.345 //layer=li \
 //thickness=0.1 //x=7.655 //y=5.56 //x2=7.655 //y2=5.905
r541 (  89 196 ) resistor r=23.615 //w=0.187 //l=0.345 //layer=li \
 //thickness=0.1 //x=6.775 //y=5.56 //x2=6.775 //y2=5.905
r542 (  84 182 ) resistor r=152 //w=0.17 //l=0.17 //layer=licon //count=1 \
 //x=3.765 //y=4.88 //x2=3.765 //y2=4.88
r543 (  75 176 ) resistor r=152 //w=0.17 //l=0.17 //layer=licon //count=1 \
 //x=3.765 //y=2.26 //x2=3.765 //y2=2.26
r544 (  65 70 ) resistor r=0.108234 //w=0.187 //l=0.16 //layer=m2 \
 //thickness=0.36 //x=9.48 //y=3.51 //x2=9.32 //y2=3.51
r545 (  64 72 ) resistor r=0.10734 //w=0.281 //l=0.16 //layer=m2 \
 //thickness=0.36 //x=11.005 //y=3.51 //x2=11.165 //y2=3.51
r546 (  64 65 ) resistor r=1.45515 //w=0.131 //l=1.525 //layer=m2 \
 //thickness=0.36 //x=11.005 //y=3.51 //x2=9.48 //y2=3.51
r547 (  62 70 ) resistor r=1.83617 //w=0.187 //l=2.75249 //layer=m2 \
 //thickness=0.36 //x=6.575 //y=3.495 //x2=9.32 //y2=3.51
r548 (  62 63 ) resistor r=0.410305 //w=0.131 //l=0.43 //layer=m2 \
 //thickness=0.36 //x=6.575 //y=3.495 //x2=6.145 //y2=3.495
r549 (  60 63 ) resistor r=0.125 //w=0.17 //l=0.177341 //layer=m2 \
 //thickness=0.36 //x=5.975 //y=3.51 //x2=6.145 //y2=3.495
r550 (  60 61 ) resistor r=0.949427 //w=0.131 //l=0.995 //layer=m2 \
 //thickness=0.36 //x=5.975 //y=3.51 //x2=4.98 //y2=3.51
r551 (  58 61 ) resistor r=0.1875 //w=0.17 //l=0.259952 //layer=m2 \
 //thickness=0.36 //x=4.725 //y=3.5 //x2=4.98 //y2=3.51
r552 (  58 59 ) resistor r=0.410305 //w=0.131 //l=0.43 //layer=m2 \
 //thickness=0.36 //x=4.725 //y=3.5 //x2=4.295 //y2=3.5
r553 (  57 67 ) resistor r=0.10734 //w=0.281 //l=0.16 //layer=m2 \
 //thickness=0.36 //x=3.925 //y=3.51 //x2=3.765 //y2=3.51
r554 (  56 59 ) resistor r=0.125 //w=0.17 //l=0.174929 //layer=m2 \
 //thickness=0.36 //x=4.125 //y=3.51 //x2=4.295 //y2=3.5
r555 (  56 57 ) resistor r=0.19084 //w=0.131 //l=0.2 //layer=m2 \
 //thickness=0.36 //x=4.125 //y=3.51 //x2=3.925 //y2=3.51
r556 (  53 131 ) resistor r=9.3 //w=0.17 //l=0.17 //layer=mcon //count=1 \
 //x=11.165 //y=4.88 //x2=11.165 //y2=4.88
r557 (  53 54 ) resistor r=0.103207 //w=0.196 //l=0.14 //layer=m1 \
 //thickness=0.36 //x=11.167 //y=4.88 //x2=11.167 //y2=4.74
r558 (  50 122 ) resistor r=9.3 //w=0.17 //l=0.17 //layer=mcon //count=1 \
 //x=11.165 //y=2.26 //x2=11.165 //y2=2.26
r559 (  47 72 ) resistor r=4.5 //w=0.15 //l=0.15 //layer=via1 //count=1 \
 //x=11.165 //y=3.51 //x2=11.165 //y2=3.51
r560 (  44 70 ) resistor r=4.5 //w=0.15 //l=0.15 //layer=via1 //count=1 \
 //x=9.32 //y=3.51 //x2=9.32 //y2=3.51
r561 (  42 194 ) resistor r=9.3 //w=0.17 //l=0.17 //layer=mcon //count=1 \
 //x=8.83 //y=1.19 //x2=8.83 //y2=1.19
r562 (  40 105 ) resistor r=9.3 //w=0.17 //l=0.17 //layer=mcon //count=1 \
 //x=8.535 //y=5.56 //x2=8.535 //y2=5.56
r563 (  37 97 ) resistor r=9.3 //w=0.17 //l=0.17 //layer=mcon //count=1 \
 //x=7.655 //y=5.56 //x2=7.655 //y2=5.56
r564 (  35 37 ) resistor r=0.121228 //w=0.232 //l=0.225 //layer=m1 \
 //thickness=0.36 //x=7.655 //y=5.335 //x2=7.655 //y2=5.56
r565 (  34 89 ) resistor r=9.3 //w=0.17 //l=0.17 //layer=mcon //count=1 \
 //x=6.775 //y=5.56 //x2=6.775 //y2=5.56
r566 (  32 34 ) resistor r=0.129608 //w=0.217 //l=0.225 //layer=m1 \
 //thickness=0.36 //x=6.777 //y=5.335 //x2=6.777 //y2=5.56
r567 (  30 67 ) resistor r=4.5 //w=0.15 //l=0.15 //layer=via1 //count=1 \
 //x=3.765 //y=3.51 //x2=3.765 //y2=3.51
r568 (  28 84 ) resistor r=9.3 //w=0.17 //l=0.17 //layer=mcon //count=1 \
 //x=3.765 //y=4.88 //x2=3.765 //y2=4.88
r569 (  26 75 ) resistor r=9.3 //w=0.17 //l=0.17 //layer=mcon //count=1 \
 //x=3.765 //y=2.26 //x2=3.765 //y2=2.26
r570 (  23 47 ) resistor r=0.0911593 //w=0.376 //l=0.184608 //layer=m1 \
 //thickness=0.36 //x=11.165 //y=3.67 //x2=11.112 //y2=3.51
r571 (  23 54 ) resistor r=1.02099 //w=0.131 //l=1.07 //layer=m1 \
 //thickness=0.36 //x=11.165 //y=3.67 //x2=11.165 //y2=4.74
r572 (  22 47 ) resistor r=0.0911593 //w=0.376 //l=0.184608 //layer=m1 \
 //thickness=0.36 //x=11.165 //y=3.35 //x2=11.112 //y2=3.51
r573 (  21 50 ) resistor r=0.0933015 //w=0.201 //l=0.125 //layer=m1 \
 //thickness=0.36 //x=11.165 //y=2.385 //x2=11.165 //y2=2.26
r574 (  21 22 ) resistor r=0.920802 //w=0.131 //l=0.965 //layer=m1 \
 //thickness=0.36 //x=11.165 //y=2.385 //x2=11.165 //y2=3.35
r575 (  19 44 ) resistor r=0.0910802 //w=0.374 //l=0.185472 //layer=m1 \
 //thickness=0.36 //x=9.315 //y=3.67 //x2=9.37 //y2=3.51
r576 (  19 20 ) resistor r=1.50763 //w=0.131 //l=1.58 //layer=m1 \
 //thickness=0.36 //x=9.315 //y=3.67 //x2=9.315 //y2=5.25
r577 (  18 44 ) resistor r=0.0910802 //w=0.374 //l=0.185472 //layer=m1 \
 //thickness=0.36 //x=9.315 //y=3.35 //x2=9.37 //y2=3.51
r578 (  17 18 ) resistor r=1.35496 //w=0.131 //l=1.42 //layer=m1 \
 //thickness=0.36 //x=9.315 //y=1.93 //x2=9.315 //y2=3.35
r579 (  15 17 ) resistor r=0.0698411 //w=0.17 //l=0.120208 //layer=m1 \
 //thickness=0.36 //x=9.23 //y=1.845 //x2=9.315 //y2=1.93
r580 (  15 16 ) resistor r=0.300573 //w=0.131 //l=0.315 //layer=m1 \
 //thickness=0.36 //x=9.23 //y=1.845 //x2=8.915 //y2=1.845
r581 (  14 16 ) resistor r=0.0698411 //w=0.17 //l=0.120208 //layer=m1 \
 //thickness=0.36 //x=8.83 //y=1.76 //x2=8.915 //y2=1.845
r582 (  13 42 ) resistor r=0.0717383 //w=0.224 //l=0.115 //layer=m1 \
 //thickness=0.36 //x=8.83 //y=1.305 //x2=8.83 //y2=1.19
r583 (  13 14 ) resistor r=0.43416 //w=0.131 //l=0.455 //layer=m1 \
 //thickness=0.36 //x=8.83 //y=1.305 //x2=8.83 //y2=1.76
r584 (  12 38 ) resistor r=0.0675342 //w=0.23 //l=0.115 //layer=m1 \
 //thickness=0.36 //x=8.65 //y=5.335 //x2=8.535 //y2=5.335
r585 (  11 20 ) resistor r=0.0698411 //w=0.17 //l=0.120208 //layer=m1 \
 //thickness=0.36 //x=9.23 //y=5.335 //x2=9.315 //y2=5.25
r586 (  11 12 ) resistor r=0.553435 //w=0.131 //l=0.58 //layer=m1 \
 //thickness=0.36 //x=9.23 //y=5.335 //x2=8.65 //y2=5.335
r587 (  10 40 ) resistor r=0.00118313 //w=0.23 //layer=m1 //thickness=0.36 \
 //x=8.535 //y=5.56 //x2=8.535 //y2=5.56
r588 (  9 38 ) resistor r=0.002872 //w=0.34 //l=0.085 //layer=m1 \
 //thickness=0.36 //x=8.535 //y=5.42 //x2=8.535 //y2=5.335
r589 (  9 10 ) resistor r=0.091623 //w=0.191 //l=0.14 //layer=m1 \
 //thickness=0.36 //x=8.535 //y=5.42 //x2=8.535 //y2=5.56
r590 (  8 35 ) resistor r=0.0262263 //w=0.232 //l=0.12 //layer=m1 \
 //thickness=0.36 //x=7.775 //y=5.335 //x2=7.655 //y2=5.335
r591 (  7 38 ) resistor r=0.0675342 //w=0.23 //l=0.115 //layer=m1 \
 //thickness=0.36 //x=8.42 //y=5.335 //x2=8.535 //y2=5.335
r592 (  7 8 ) resistor r=0.615458 //w=0.131 //l=0.645 //layer=m1 \
 //thickness=0.36 //x=8.42 //y=5.335 //x2=7.775 //y2=5.335
r593 (  6 32 ) resistor r=0.0222262 //w=0.217 //l=0.118 //layer=m1 \
 //thickness=0.36 //x=6.895 //y=5.335 //x2=6.777 //y2=5.335
r594 (  5 35 ) resistor r=0.0262263 //w=0.232 //l=0.12 //layer=m1 \
 //thickness=0.36 //x=7.535 //y=5.335 //x2=7.655 //y2=5.335
r595 (  5 6 ) resistor r=0.610687 //w=0.131 //l=0.64 //layer=m1 \
 //thickness=0.36 //x=7.535 //y=5.335 //x2=6.895 //y2=5.335
r596 (  4 28 ) resistor r=0.0801089 //w=0.224 //l=0.13 //layer=m1 \
 //thickness=0.36 //x=3.765 //y=4.75 //x2=3.765 //y2=4.88
r597 (  3 30 ) resistor r=0.0911593 //w=0.376 //l=0.184174 //layer=m1 \
 //thickness=0.36 //x=3.765 //y=3.67 //x2=3.817 //y2=3.51
r598 (  3 4 ) resistor r=1.03053 //w=0.131 //l=1.08 //layer=m1 \
 //thickness=0.36 //x=3.765 //y=3.67 //x2=3.765 //y2=4.75
r599 (  2 30 ) resistor r=0.0911593 //w=0.376 //l=0.184174 //layer=m1 \
 //thickness=0.36 //x=3.765 //y=3.35 //x2=3.817 //y2=3.51
r600 (  1 26 ) resistor r=0.0719237 //w=0.222 //l=0.115 //layer=m1 \
 //thickness=0.36 //x=3.765 //y=2.375 //x2=3.765 //y2=2.26
r601 (  1 2 ) resistor r=0.930344 //w=0.131 //l=0.975 //layer=m1 \
 //thickness=0.36 //x=3.765 //y=2.375 //x2=3.765 //y2=3.35
ends PM_DFFRNQX1\%noxref_1

subckt PM_DFFRNQX1\%noxref_2 ( 3 8 9 11 12 14 15 16 17 18 19 20 23 24 27 29 32 \
 36 48 50 51 54 62 79 88 92 93 94 95 96 97 98 99 101 107 108 109 110 122 124 \
 125 )
c272 ( 122 0 ) capacitor c=0.00878249f //x=12.015 //y=1.085
c273 ( 110 0 ) capacitor c=0.0612936f //x=14.77 //y=4.97
c274 ( 109 0 ) capacitor c=0.0376642f //x=15.06 //y=4.97
c275 ( 108 0 ) capacitor c=0.0346489f //x=14.725 //y=1.4
c276 ( 107 0 ) capacitor c=0.018692f //x=14.725 //y=1.055
c277 ( 101 0 ) capacitor c=0.0137077f //x=14.57 //y=1.555
c278 ( 99 0 ) capacitor c=0.0158585f //x=14.57 //y=0.9
c279 ( 98 0 ) capacitor c=0.101012f //x=14.195 //y=2.095
c280 ( 97 0 ) capacitor c=0.0229444f //x=14.195 //y=1.71
c281 ( 96 0 ) capacitor c=0.0234359f //x=14.195 //y=1.4
c282 ( 95 0 ) capacitor c=0.019815f //x=14.195 //y=1.055
c283 ( 94 0 ) capacitor c=0.110208f //x=15.135 //y=6.2
c284 ( 93 0 ) capacitor c=0.158957f //x=14.695 //y=6.2
c285 ( 88 0 ) capacitor c=0.0014751f //x=14.495 //y=4.88
c286 ( 79 0 ) capacitor c=0.0012618f //x=14.495 //y=2.26
c287 ( 62 0 ) capacitor c=0.0322017f //x=12.165 //y=5.56
c288 ( 54 0 ) capacitor c=0.0291938f //x=11.285 //y=5.56
c289 ( 51 0 ) capacitor c=0.0259909f //x=14.34 //y=3.515
c290 ( 50 0 ) capacitor c=6.22456e-19 //x=14.5 //y=3.515
c291 ( 48 0 ) capacitor c=9.69366e-19 //x=12.805 //y=3.515
c292 ( 36 0 ) capacitor c=0.0170693f //x=14.495 //y=3.51
c293 ( 32 0 ) capacitor c=0.016938f //x=12.645 //y=3.51
c294 ( 29 0 ) capacitor c=0.0112415f //x=12.205 //y=1.18
c295 ( 27 0 ) capacitor c=5.78613e-19 //x=12.165 //y=5.56
c296 ( 24 0 ) capacitor c=0.010659f //x=12.165 //y=5.38
c297 ( 23 0 ) capacitor c=0.00926978f //x=11.285 //y=5.56
c298 ( 20 0 ) capacitor c=0.038207f //x=14.495 //y=4.755
c299 ( 19 0 ) capacitor c=0.0145934f //x=14.495 //y=3.675
c300 ( 18 0 ) capacitor c=0.0328082f //x=14.495 //y=3.355
c301 ( 17 0 ) capacitor c=0.00495287f //x=14.495 //y=2.375
c302 ( 16 0 ) capacitor c=0.0418029f //x=12.645 //y=5.295
c303 ( 15 0 ) capacitor c=0.0134342f //x=12.645 //y=3.675
c304 ( 14 0 ) capacitor c=0.0413556f //x=12.645 //y=3.355
c305 ( 12 0 ) capacitor c=0.00466468f //x=12.29 //y=1.835
c306 ( 11 0 ) capacitor c=0.0120653f //x=12.56 //y=1.835
c307 ( 9 0 ) capacitor c=0.0116495f //x=12.56 //y=5.38
c308 ( 8 0 ) capacitor c=0.0134844f //x=12.205 //y=1.75
c309 ( 3 0 ) capacitor c=0.013452f //x=12.05 //y=5.38
r310 (  109 111 ) resistor r=26.9307 //w=0.15 //l=0.106066 //layer=ply \
 //thickness=0.18 //x=15.06 //y=4.97 //x2=15.135 //y2=5.045
r311 (  109 110 ) resistor r=148.702 //w=0.094 //l=0.29 //layer=ply \
 //thickness=0.18 //x=15.06 //y=4.97 //x2=14.77 //y2=4.97
r312 (  108 121 ) resistor r=45.1352 //w=0.168 //l=0.173853 //layer=ply \
 //thickness=0.18 //x=14.725 //y=1.4 //x2=14.685 //y2=1.555
r313 (  107 120 ) resistor r=45.1352 //w=0.168 //l=0.173853 //layer=ply \
 //thickness=0.18 //x=14.725 //y=1.055 //x2=14.685 //y2=0.9
r314 (  107 108 ) resistor r=176.904 //w=0.094 //l=0.345 //layer=ply \
 //thickness=0.18 //x=14.725 //y=1.055 //x2=14.725 //y2=1.4
r315 (  104 110 ) resistor r=22.7971 //w=0.269 //l=0.106066 //layer=ply \
 //thickness=0.18 //x=14.695 //y=5.045 //x2=14.77 //y2=4.97
r316 (  104 119 ) resistor r=35.8364 //w=0.269 //l=0.270185 //layer=ply \
 //thickness=0.18 //x=14.695 //y=5.045 //x2=14.495 //y2=4.88
r317 (  102 115 ) resistor r=10.701 //w=0.21 //l=0.115 //layer=ply \
 //thickness=0.18 //x=14.35 //y=1.555 //x2=14.235 //y2=1.555
r318 (  101 121 ) resistor r=5.52526 //w=0.168 //l=0.115 //layer=ply \
 //thickness=0.18 //x=14.57 //y=1.555 //x2=14.685 //y2=1.555
r319 (  100 114 ) resistor r=5.52526 //w=0.168 //l=0.115 //layer=ply \
 //thickness=0.18 //x=14.35 //y=0.9 //x2=14.235 //y2=0.9
r320 (  99 120 ) resistor r=5.52526 //w=0.168 //l=0.115 //layer=ply \
 //thickness=0.18 //x=14.57 //y=0.9 //x2=14.685 //y2=0.9
r321 (  99 100 ) resistor r=112.809 //w=0.094 //l=0.22 //layer=ply \
 //thickness=0.18 //x=14.57 //y=0.9 //x2=14.35 //y2=0.9
r322 (  98 117 ) resistor r=58.7805 //w=0.246 //l=0.373497 //layer=ply \
 //thickness=0.18 //x=14.195 //y=2.095 //x2=14.495 //y2=2.26
r323 (  97 115 ) resistor r=39.5823 //w=0.21 //l=0.173853 //layer=ply \
 //thickness=0.18 //x=14.195 //y=1.71 //x2=14.235 //y2=1.555
r324 (  97 98 ) resistor r=197.415 //w=0.094 //l=0.385 //layer=ply \
 //thickness=0.18 //x=14.195 //y=1.71 //x2=14.195 //y2=2.095
r325 (  96 115 ) resistor r=39.5823 //w=0.21 //l=0.173853 //layer=ply \
 //thickness=0.18 //x=14.195 //y=1.4 //x2=14.235 //y2=1.555
r326 (  95 114 ) resistor r=45.1352 //w=0.168 //l=0.173853 //layer=ply \
 //thickness=0.18 //x=14.195 //y=1.055 //x2=14.235 //y2=0.9
r327 (  95 96 ) resistor r=176.904 //w=0.094 //l=0.345 //layer=ply \
 //thickness=0.18 //x=14.195 //y=1.055 //x2=14.195 //y2=1.4
r328 (  94 111 ) resistor r=592.245 //w=0.094 //l=1.155 //layer=ply \
 //thickness=0.18 //x=15.135 //y=6.2 //x2=15.135 //y2=5.045
r329 (  93 104 ) resistor r=592.245 //w=0.094 //l=1.155 //layer=ply \
 //thickness=0.18 //x=14.695 //y=6.2 //x2=14.695 //y2=5.045
r330 (  92 101 ) resistor r=56.4043 //w=0.094 //l=0.11 //layer=ply \
 //thickness=0.18 //x=14.46 //y=1.555 //x2=14.57 //y2=1.555
r331 (  92 102 ) resistor r=56.4043 //w=0.094 //l=0.11 //layer=ply \
 //thickness=0.18 //x=14.46 //y=1.555 //x2=14.35 //y2=1.555
r332 (  88 119 ) resistor r=152 //w=0.17 //l=0.17 //layer=licon //count=1 \
 //x=14.495 //y=4.88 //x2=14.495 //y2=4.88
r333 (  79 117 ) resistor r=152 //w=0.17 //l=0.17 //layer=licon //count=1 \
 //x=14.495 //y=2.26 //x2=14.495 //y2=2.26
r334 (  62 125 ) resistor r=23.615 //w=0.187 //l=0.345 //layer=li \
 //thickness=0.1 //x=12.165 //y=5.56 //x2=12.165 //y2=5.905
r335 (  54 124 ) resistor r=23.615 //w=0.187 //l=0.345 //layer=li \
 //thickness=0.1 //x=11.285 //y=5.56 //x2=11.285 //y2=5.905
r336 (  50 51 ) resistor r=0.10734 //w=0.281 //l=0.16 //layer=m2 \
 //thickness=0.36 //x=14.5 //y=3.515 //x2=14.34 //y2=3.515
r337 (  48 51 ) resistor r=1.46469 //w=0.131 //l=1.535 //layer=m2 \
 //thickness=0.36 //x=12.805 //y=3.51 //x2=14.34 //y2=3.51
r338 (  46 48 ) resistor r=0.10734 //w=0.281 //l=0.16 //layer=m2 \
 //thickness=0.36 //x=12.645 //y=3.515 //x2=12.805 //y2=3.515
r339 (  42 88 ) resistor r=9.3 //w=0.17 //l=0.17 //layer=mcon //count=1 \
 //x=14.495 //y=4.88 //x2=14.495 //y2=4.88
r340 (  40 79 ) resistor r=9.3 //w=0.17 //l=0.17 //layer=mcon //count=1 \
 //x=14.495 //y=2.26 //x2=14.495 //y2=2.26
r341 (  38 50 ) resistor r=4.5 //w=0.15 //l=0.15 //layer=via1 //count=1 \
 //x=14.5 //y=3.515 //x2=14.5 //y2=3.515
r342 (  36 38 ) resistor r=0.00164908 //w=0.379 //l=0.005 //layer=m1 \
 //thickness=0.36 //x=14.445 //y=3.51 //x2=14.445 //y2=3.515
r343 (  34 46 ) resistor r=4.5 //w=0.15 //l=0.15 //layer=via1 //count=1 \
 //x=12.645 //y=3.515 //x2=12.645 //y2=3.515
r344 (  32 34 ) resistor r=0.00166223 //w=0.376 //l=0.005 //layer=m1 \
 //thickness=0.36 //x=12.697 //y=3.51 //x2=12.697 //y2=3.515
r345 (  29 122 ) resistor r=9.3 //w=0.17 //l=0.17 //layer=mcon //count=1 \
 //x=12.205 //y=1.18 //x2=12.205 //y2=1.18
r346 (  27 62 ) resistor r=9.3 //w=0.17 //l=0.17 //layer=mcon //count=1 \
 //x=12.165 //y=5.56 //x2=12.165 //y2=5.56
r347 (  24 27 ) resistor r=0.117801 //w=0.191 //l=0.18 //layer=m1 \
 //thickness=0.36 //x=12.165 //y=5.38 //x2=12.165 //y2=5.56
r348 (  23 54 ) resistor r=9.3 //w=0.17 //l=0.17 //layer=mcon //count=1 \
 //x=11.285 //y=5.56 //x2=11.285 //y2=5.56
r349 (  21 23 ) resistor r=0.10274 //w=0.219 //l=0.18 //layer=m1 \
 //thickness=0.36 //x=11.285 //y=5.38 //x2=11.285 //y2=5.56
r350 (  20 42 ) resistor r=0.0760407 //w=0.238 //l=0.125 //layer=m1 \
 //thickness=0.36 //x=14.495 //y=4.755 //x2=14.495 //y2=4.88
r351 (  19 38 ) resistor r=0.0912814 //w=0.379 //l=0.183303 //layer=m1 \
 //thickness=0.36 //x=14.495 //y=3.675 //x2=14.445 //y2=3.515
r352 (  19 20 ) resistor r=1.03053 //w=0.131 //l=1.08 //layer=m1 \
 //thickness=0.36 //x=14.495 //y=3.675 //x2=14.495 //y2=4.755
r353 (  18 36 ) resistor r=0.0896323 //w=0.379 //l=0.178255 //layer=m1 \
 //thickness=0.36 //x=14.495 //y=3.355 //x2=14.445 //y2=3.51
r354 (  17 40 ) resistor r=0.0719237 //w=0.222 //l=0.115 //layer=m1 \
 //thickness=0.36 //x=14.495 //y=2.375 //x2=14.495 //y2=2.26
r355 (  17 18 ) resistor r=0.935115 //w=0.131 //l=0.98 //layer=m1 \
 //thickness=0.36 //x=14.495 //y=2.375 //x2=14.495 //y2=3.355
r356 (  15 34 ) resistor r=0.0911593 //w=0.376 //l=0.184174 //layer=m1 \
 //thickness=0.36 //x=12.645 //y=3.675 //x2=12.697 //y2=3.515
r357 (  15 16 ) resistor r=1.5458 //w=0.131 //l=1.62 //layer=m1 \
 //thickness=0.36 //x=12.645 //y=3.675 //x2=12.645 //y2=5.295
r358 (  14 32 ) resistor r=0.0894971 //w=0.376 //l=0.179123 //layer=m1 \
 //thickness=0.36 //x=12.645 //y=3.355 //x2=12.697 //y2=3.51
r359 (  13 14 ) resistor r=1.36927 //w=0.131 //l=1.435 //layer=m1 \
 //thickness=0.36 //x=12.645 //y=1.92 //x2=12.645 //y2=3.355
r360 (  11 13 ) resistor r=0.0698411 //w=0.17 //l=0.120208 //layer=m1 \
 //thickness=0.36 //x=12.56 //y=1.835 //x2=12.645 //y2=1.92
r361 (  11 12 ) resistor r=0.257634 //w=0.131 //l=0.27 //layer=m1 \
 //thickness=0.36 //x=12.56 //y=1.835 //x2=12.29 //y2=1.835
r362 (  10 24 ) resistor r=0.0257089 //w=0.23 //l=0.115 //layer=m1 \
 //thickness=0.36 //x=12.28 //y=5.38 //x2=12.165 //y2=5.38
r363 (  9 16 ) resistor r=0.0698411 //w=0.17 //l=0.120208 //layer=m1 \
 //thickness=0.36 //x=12.56 //y=5.38 //x2=12.645 //y2=5.295
r364 (  9 10 ) resistor r=0.267176 //w=0.131 //l=0.28 //layer=m1 \
 //thickness=0.36 //x=12.56 //y=5.38 //x2=12.28 //y2=5.38
r365 (  8 12 ) resistor r=0.0698411 //w=0.17 //l=0.120208 //layer=m1 \
 //thickness=0.36 //x=12.205 //y=1.75 //x2=12.29 //y2=1.835
r366 (  7 29 ) resistor r=0.0913624 //w=0.191 //l=0.12 //layer=m1 \
 //thickness=0.36 //x=12.205 //y=1.3 //x2=12.205 //y2=1.18
r367 (  7 8 ) resistor r=0.429389 //w=0.131 //l=0.45 //layer=m1 \
 //thickness=0.36 //x=12.205 //y=1.3 //x2=12.205 //y2=1.75
r368 (  4 21 ) resistor r=0.0227762 //w=0.219 //l=0.115 //layer=m1 \
 //thickness=0.36 //x=11.4 //y=5.38 //x2=11.285 //y2=5.38
r369 (  3 24 ) resistor r=0.0257089 //w=0.23 //l=0.115 //layer=m1 \
 //thickness=0.36 //x=12.05 //y=5.38 //x2=12.165 //y2=5.38
r370 (  3 4 ) resistor r=0.620229 //w=0.131 //l=0.65 //layer=m1 \
 //thickness=0.36 //x=12.05 //y=5.38 //x2=11.4 //y2=5.38
ends PM_DFFRNQX1\%noxref_2

subckt PM_DFFRNQX1\%CLK ( 1 2 3 4 5 6 7 8 9 10 17 25 32 35 37 39 45 50 55 60 \
 64 65 66 67 68 69 70 71 72 74 80 81 82 83 84 89 90 91 93 99 100 101 102 103 \
 111 122 )
c298 ( 122 0 ) capacitor c=0.0356502f //x=15.605 //y=4.88
c299 ( 111 0 ) capacitor c=0.0356344f //x=2.655 //y=4.88
c300 ( 103 0 ) capacitor c=0.0306876f //x=15.94 //y=4.97
c301 ( 102 0 ) capacitor c=0.0863671f //x=15.695 //y=2.095
c302 ( 101 0 ) capacitor c=0.0170266f //x=15.695 //y=1.63
c303 ( 100 0 ) capacitor c=0.018609f //x=15.695 //y=1.4
c304 ( 99 0 ) capacitor c=0.0186599f //x=15.695 //y=1.09
c305 ( 93 0 ) capacitor c=0.0146988f //x=15.54 //y=1.555
c306 ( 91 0 ) capacitor c=0.0148531f //x=15.54 //y=0.935
c307 ( 90 0 ) capacitor c=0.0334406f //x=15.17 //y=1.4
c308 ( 89 0 ) capacitor c=0.0173191f //x=15.17 //y=1.09
c309 ( 84 0 ) capacitor c=0.0306608f //x=2.99 //y=4.97
c310 ( 83 0 ) capacitor c=0.0863671f //x=2.745 //y=2.095
c311 ( 82 0 ) capacitor c=0.0170266f //x=2.745 //y=1.63
c312 ( 81 0 ) capacitor c=0.018609f //x=2.745 //y=1.4
c313 ( 80 0 ) capacitor c=0.0186599f //x=2.745 //y=1.09
c314 ( 74 0 ) capacitor c=0.0146988f //x=2.59 //y=1.555
c315 ( 72 0 ) capacitor c=0.0148531f //x=2.59 //y=0.935
c316 ( 71 0 ) capacitor c=0.0334406f //x=2.22 //y=1.4
c317 ( 70 0 ) capacitor c=0.0173191f //x=2.22 //y=1.09
c318 ( 69 0 ) capacitor c=0.110208f //x=16.015 //y=6.2
c319 ( 68 0 ) capacitor c=0.110214f //x=15.575 //y=6.2
c320 ( 67 0 ) capacitor c=0.110208f //x=3.065 //y=6.2
c321 ( 66 0 ) capacitor c=0.110214f //x=2.625 //y=6.2
c322 ( 60 0 ) capacitor c=0.00129935f //x=15.605 //y=4.88
c323 ( 55 0 ) capacitor c=0.00121786f //x=15.605 //y=2.26
c324 ( 50 0 ) capacitor c=0.00129935f //x=2.655 //y=4.88
c325 ( 45 0 ) capacitor c=0.00121786f //x=2.655 //y=2.26
c326 ( 39 0 ) capacitor c=0.0045011f //x=2.65 //y=4.62
c327 ( 37 0 ) capacitor c=0.0999657f //x=12.125 //y=4.635
c328 ( 35 0 ) capacitor c=0.218517f //x=11.525 //y=4.62
c329 ( 32 0 ) capacitor c=0.0115855f //x=15.6 //y=4.695
c330 ( 25 0 ) capacitor c=0.00785249f //x=2.65 //y=4.835
c331 ( 17 0 ) capacitor c=0.00382585f //x=15.605 //y=2.375
c332 ( 10 0 ) capacitor c=0.0056477f //x=2.655 //y=2.375
c333 ( 6 0 ) capacitor c=0.0633406f //x=15.605 //y=2.77
c334 ( 1 0 ) capacitor c=0.0668824f //x=2.655 //y=2.77
r335 (  124 125 ) resistor r=32.4568 //w=0.214 //l=0.075 //layer=ply \
 //thickness=0.18 //x=15.605 //y=4.97 //x2=15.605 //y2=5.045
r336 (  122 124 ) resistor r=20.271 //w=0.214 //l=0.09 //layer=ply \
 //thickness=0.18 //x=15.605 //y=4.88 //x2=15.605 //y2=4.97
r337 (  113 114 ) resistor r=32.4568 //w=0.214 //l=0.075 //layer=ply \
 //thickness=0.18 //x=2.655 //y=4.97 //x2=2.655 //y2=5.045
r338 (  111 113 ) resistor r=20.271 //w=0.214 //l=0.09 //layer=ply \
 //thickness=0.18 //x=2.655 //y=4.88 //x2=2.655 //y2=4.97
r339 (  104 124 ) resistor r=16.5046 //w=0.27 //l=0.135 //layer=ply \
 //thickness=0.18 //x=15.74 //y=4.97 //x2=15.605 //y2=4.97
r340 (  103 105 ) resistor r=26.9307 //w=0.15 //l=0.106066 //layer=ply \
 //thickness=0.18 //x=15.94 //y=4.97 //x2=16.015 //y2=5.045
r341 (  103 104 ) resistor r=102.553 //w=0.094 //l=0.2 //layer=ply \
 //thickness=0.18 //x=15.94 //y=4.97 //x2=15.74 //y2=4.97
r342 (  102 129 ) resistor r=38.6777 //w=0.284 //l=0.198997 //layer=ply \
 //thickness=0.18 //x=15.695 //y=2.095 //x2=15.62 //y2=2.26
r343 (  101 127 ) resistor r=21.2976 //w=0.217 //l=0.0928709 //layer=ply \
 //thickness=0.18 //x=15.695 //y=1.63 //x2=15.655 //y2=1.555
r344 (  101 102 ) resistor r=238.436 //w=0.094 //l=0.465 //layer=ply \
 //thickness=0.18 //x=15.695 //y=1.63 //x2=15.695 //y2=2.095
r345 (  100 127 ) resistor r=39.0671 //w=0.217 //l=0.173853 //layer=ply \
 //thickness=0.18 //x=15.695 //y=1.4 //x2=15.655 //y2=1.555
r346 (  99 126 ) resistor r=45.1352 //w=0.168 //l=0.173853 //layer=ply \
 //thickness=0.18 //x=15.695 //y=1.09 //x2=15.655 //y2=0.935
r347 (  99 100 ) resistor r=158.957 //w=0.094 //l=0.31 //layer=ply \
 //thickness=0.18 //x=15.695 //y=1.09 //x2=15.695 //y2=1.4
r348 (  94 120 ) resistor r=5.52526 //w=0.168 //l=0.115 //layer=ply \
 //thickness=0.18 //x=15.325 //y=1.555 //x2=15.21 //y2=1.555
r349 (  93 127 ) resistor r=11.4558 //w=0.217 //l=0.115 //layer=ply \
 //thickness=0.18 //x=15.54 //y=1.555 //x2=15.655 //y2=1.555
r350 (  92 119 ) resistor r=5.52526 //w=0.168 //l=0.115 //layer=ply \
 //thickness=0.18 //x=15.325 //y=0.935 //x2=15.21 //y2=0.935
r351 (  91 126 ) resistor r=5.52526 //w=0.168 //l=0.115 //layer=ply \
 //thickness=0.18 //x=15.54 //y=0.935 //x2=15.655 //y2=0.935
r352 (  91 92 ) resistor r=110.245 //w=0.094 //l=0.215 //layer=ply \
 //thickness=0.18 //x=15.54 //y=0.935 //x2=15.325 //y2=0.935
r353 (  90 120 ) resistor r=45.1352 //w=0.168 //l=0.173853 //layer=ply \
 //thickness=0.18 //x=15.17 //y=1.4 //x2=15.21 //y2=1.555
r354 (  89 119 ) resistor r=45.1352 //w=0.168 //l=0.173853 //layer=ply \
 //thickness=0.18 //x=15.17 //y=1.09 //x2=15.21 //y2=0.935
r355 (  89 90 ) resistor r=158.957 //w=0.094 //l=0.31 //layer=ply \
 //thickness=0.18 //x=15.17 //y=1.09 //x2=15.17 //y2=1.4
r356 (  85 113 ) resistor r=16.5046 //w=0.27 //l=0.135 //layer=ply \
 //thickness=0.18 //x=2.79 //y=4.97 //x2=2.655 //y2=4.97
r357 (  84 86 ) resistor r=26.9307 //w=0.15 //l=0.106066 //layer=ply \
 //thickness=0.18 //x=2.99 //y=4.97 //x2=3.065 //y2=5.045
r358 (  84 85 ) resistor r=102.553 //w=0.094 //l=0.2 //layer=ply \
 //thickness=0.18 //x=2.99 //y=4.97 //x2=2.79 //y2=4.97
r359 (  83 118 ) resistor r=38.6777 //w=0.284 //l=0.198997 //layer=ply \
 //thickness=0.18 //x=2.745 //y=2.095 //x2=2.67 //y2=2.26
r360 (  82 116 ) resistor r=21.2976 //w=0.217 //l=0.0928709 //layer=ply \
 //thickness=0.18 //x=2.745 //y=1.63 //x2=2.705 //y2=1.555
r361 (  82 83 ) resistor r=238.436 //w=0.094 //l=0.465 //layer=ply \
 //thickness=0.18 //x=2.745 //y=1.63 //x2=2.745 //y2=2.095
r362 (  81 116 ) resistor r=39.0671 //w=0.217 //l=0.173853 //layer=ply \
 //thickness=0.18 //x=2.745 //y=1.4 //x2=2.705 //y2=1.555
r363 (  80 115 ) resistor r=45.1352 //w=0.168 //l=0.173853 //layer=ply \
 //thickness=0.18 //x=2.745 //y=1.09 //x2=2.705 //y2=0.935
r364 (  80 81 ) resistor r=158.957 //w=0.094 //l=0.31 //layer=ply \
 //thickness=0.18 //x=2.745 //y=1.09 //x2=2.745 //y2=1.4
r365 (  75 109 ) resistor r=5.52526 //w=0.168 //l=0.115 //layer=ply \
 //thickness=0.18 //x=2.375 //y=1.555 //x2=2.26 //y2=1.555
r366 (  74 116 ) resistor r=11.4558 //w=0.217 //l=0.115 //layer=ply \
 //thickness=0.18 //x=2.59 //y=1.555 //x2=2.705 //y2=1.555
r367 (  73 108 ) resistor r=5.52526 //w=0.168 //l=0.115 //layer=ply \
 //thickness=0.18 //x=2.375 //y=0.935 //x2=2.26 //y2=0.935
r368 (  72 115 ) resistor r=5.52526 //w=0.168 //l=0.115 //layer=ply \
 //thickness=0.18 //x=2.59 //y=0.935 //x2=2.705 //y2=0.935
r369 (  72 73 ) resistor r=110.245 //w=0.094 //l=0.215 //layer=ply \
 //thickness=0.18 //x=2.59 //y=0.935 //x2=2.375 //y2=0.935
r370 (  71 109 ) resistor r=45.1352 //w=0.168 //l=0.173853 //layer=ply \
 //thickness=0.18 //x=2.22 //y=1.4 //x2=2.26 //y2=1.555
r371 (  70 108 ) resistor r=45.1352 //w=0.168 //l=0.173853 //layer=ply \
 //thickness=0.18 //x=2.22 //y=1.09 //x2=2.26 //y2=0.935
r372 (  70 71 ) resistor r=158.957 //w=0.094 //l=0.31 //layer=ply \
 //thickness=0.18 //x=2.22 //y=1.09 //x2=2.22 //y2=1.4
r373 (  69 105 ) resistor r=592.245 //w=0.094 //l=1.155 //layer=ply \
 //thickness=0.18 //x=16.015 //y=6.2 //x2=16.015 //y2=5.045
r374 (  68 125 ) resistor r=592.245 //w=0.094 //l=1.155 //layer=ply \
 //thickness=0.18 //x=15.575 //y=6.2 //x2=15.575 //y2=5.045
r375 (  67 86 ) resistor r=592.245 //w=0.094 //l=1.155 //layer=ply \
 //thickness=0.18 //x=3.065 //y=6.2 //x2=3.065 //y2=5.045
r376 (  66 114 ) resistor r=592.245 //w=0.094 //l=1.155 //layer=ply \
 //thickness=0.18 //x=2.625 //y=6.2 //x2=2.625 //y2=5.045
r377 (  65 93 ) resistor r=55.3787 //w=0.094 //l=0.108 //layer=ply \
 //thickness=0.18 //x=15.432 //y=1.555 //x2=15.54 //y2=1.555
r378 (  65 94 ) resistor r=54.866 //w=0.094 //l=0.107 //layer=ply \
 //thickness=0.18 //x=15.432 //y=1.555 //x2=15.325 //y2=1.555
r379 (  64 74 ) resistor r=55.3787 //w=0.094 //l=0.108 //layer=ply \
 //thickness=0.18 //x=2.482 //y=1.555 //x2=2.59 //y2=1.555
r380 (  64 75 ) resistor r=54.866 //w=0.094 //l=0.107 //layer=ply \
 //thickness=0.18 //x=2.482 //y=1.555 //x2=2.375 //y2=1.555
r381 (  60 122 ) resistor r=152 //w=0.17 //l=0.17 //layer=licon //count=1 \
 //x=15.605 //y=4.88 //x2=15.605 //y2=4.88
r382 (  55 129 ) resistor r=152 //w=0.17 //l=0.17 //layer=licon //count=1 \
 //x=15.605 //y=2.26 //x2=15.605 //y2=2.26
r383 (  50 111 ) resistor r=152 //w=0.17 //l=0.17 //layer=licon //count=1 \
 //x=2.655 //y=4.88 //x2=2.655 //y2=4.88
r384 (  45 118 ) resistor r=152 //w=0.17 //l=0.17 //layer=licon //count=1 \
 //x=2.655 //y=2.26 //x2=2.655 //y2=2.26
r385 (  39 41 ) resistor r=0.0904882 //w=0.297 //l=0.215 //layer=m2 \
 //thickness=0.36 //x=2.65 //y=4.62 //x2=2.65 //y2=4.835
r386 (  37 43 ) resistor r=2.36166 //w=0.184 //l=3.50487 //layer=m2 \
 //thickness=0.36 //x=12.125 //y=4.635 //x2=15.6 //y2=4.695
r387 (  37 38 ) resistor r=0.329198 //w=0.131 //l=0.345 //layer=m2 \
 //thickness=0.36 //x=12.125 //y=4.635 //x2=11.78 //y2=4.635
r388 (  36 39 ) resistor r=0.0410036 //w=0.297 //l=0.16 //layer=m2 \
 //thickness=0.36 //x=2.81 //y=4.62 //x2=2.65 //y2=4.62
r389 (  35 38 ) resistor r=0.1875 //w=0.17 //l=0.262393 //layer=m2 \
 //thickness=0.36 //x=11.525 //y=4.62 //x2=11.78 //y2=4.635
r390 (  35 36 ) resistor r=8.31584 //w=0.131 //l=8.715 //layer=m2 \
 //thickness=0.36 //x=11.525 //y=4.62 //x2=2.81 //y2=4.62
r391 (  34 60 ) resistor r=9.3 //w=0.17 //l=0.17 //layer=mcon //count=1 \
 //x=15.605 //y=4.88 //x2=15.605 //y2=4.88
r392 (  32 43 ) resistor r=4.5 //w=0.15 //l=0.15 //layer=via1 //count=1 \
 //x=15.6 //y=4.695 //x2=15.6 //y2=4.695
r393 (  32 34 ) resistor r=0.0808566 //w=0.286 //l=0.185 //layer=m1 \
 //thickness=0.36 //x=15.6 //y=4.695 //x2=15.6 //y2=4.88
r394 (  29 55 ) resistor r=9.3 //w=0.17 //l=0.17 //layer=mcon //count=1 \
 //x=15.605 //y=2.26 //x2=15.605 //y2=2.26
r395 (  27 50 ) resistor r=9.3 //w=0.17 //l=0.17 //layer=mcon //count=1 \
 //x=2.655 //y=4.88 //x2=2.655 //y2=4.88
r396 (  25 41 ) resistor r=4.5 //w=0.15 //l=0.15 //layer=via1 //count=1 \
 //x=2.65 //y=4.835 //x2=2.65 //y2=4.835
r397 (  25 27 ) resistor r=0.018263 //w=0.308 //l=0.045 //layer=m1 \
 //thickness=0.36 //x=2.65 //y=4.835 //x2=2.65 //y2=4.88
r398 (  23 45 ) resistor r=9.3 //w=0.17 //l=0.17 //layer=mcon //count=1 \
 //x=2.655 //y=2.26 //x2=2.655 //y2=2.26
r399 (  17 29 ) resistor r=0.0715665 //w=0.226 //l=0.115996 //layer=m1 \
 //thickness=0.36 //x=15.605 //y=2.375 //x2=15.607 //y2=2.26
r400 (  11 25 ) resistor r=0.0898396 //w=0.308 //l=0.162481 //layer=m1 \
 //thickness=0.36 //x=2.655 //y=4.675 //x2=2.65 //y2=4.835
r401 (  10 23 ) resistor r=0.0715665 //w=0.226 //l=0.115996 //layer=m1 \
 //thickness=0.36 //x=2.655 //y=2.375 //x2=2.657 //y2=2.26
r402 (  9 32 ) resistor r=0.0327797 //w=0.286 //l=0.075 //layer=m1 \
 //thickness=0.36 //x=15.6 //y=4.62 //x2=15.6 //y2=4.695
r403 (  9 18 ) resistor r=0.0575483 //w=0.286 //l=0.0874643 //layer=m1 \
 //thickness=0.36 //x=15.6 //y=4.62 //x2=15.605 //y2=4.535
r404 (  8 18 ) resistor r=0.978053 //w=0.131 //l=1.025 //layer=m1 \
 //thickness=0.36 //x=15.605 //y=3.51 //x2=15.605 //y2=4.535
r405 (  7 8 ) resistor r=0.353053 //w=0.131 //l=0.37 //layer=m1 \
 //thickness=0.36 //x=15.605 //y=3.14 //x2=15.605 //y2=3.51
r406 (  6 7 ) resistor r=0.353053 //w=0.131 //l=0.37 //layer=m1 \
 //thickness=0.36 //x=15.605 //y=2.77 //x2=15.605 //y2=3.14
r407 (  6 17 ) resistor r=0.376908 //w=0.131 //l=0.395 //layer=m1 \
 //thickness=0.36 //x=15.605 //y=2.77 //x2=15.605 //y2=2.375
r408 (  5 11 ) resistor r=0.0524809 //w=0.131 //l=0.055 //layer=m1 \
 //thickness=0.36 //x=2.655 //y=4.62 //x2=2.655 //y2=4.675
r409 (  4 5 ) resistor r=0.706107 //w=0.131 //l=0.74 //layer=m1 \
 //thickness=0.36 //x=2.655 //y=3.88 //x2=2.655 //y2=4.62
r410 (  3 4 ) resistor r=0.353053 //w=0.131 //l=0.37 //layer=m1 \
 //thickness=0.36 //x=2.655 //y=3.51 //x2=2.655 //y2=3.88
r411 (  2 3 ) resistor r=0.353053 //w=0.131 //l=0.37 //layer=m1 \
 //thickness=0.36 //x=2.655 //y=3.14 //x2=2.655 //y2=3.51
r412 (  1 2 ) resistor r=0.353053 //w=0.131 //l=0.37 //layer=m1 \
 //thickness=0.36 //x=2.655 //y=2.77 //x2=2.655 //y2=3.14
r413 (  1 10 ) resistor r=0.376908 //w=0.131 //l=0.395 //layer=m1 \
 //thickness=0.36 //x=2.655 //y=2.77 //x2=2.655 //y2=2.375
ends PM_DFFRNQX1\%CLK

subckt PM_DFFRNQX1\%noxref_4 ( 1 3 6 7 9 10 11 12 14 15 16 17 18 19 20 21 22 \
 23 24 25 28 31 37 45 48 54 56 57 58 60 62 64 66 68 70 72 77 83 91 99 116 125 \
 130 139 143 144 145 146 147 148 149 150 151 152 153 155 161 162 163 164 168 \
 169 170 171 172 174 180 181 182 183 203 205 206 207 )
c463 ( 203 0 ) capacitor c=0.00885916f //x=3.83 //y=1.095
c464 ( 183 0 ) capacitor c=0.0583399f //x=19.58 //y=4.97
c465 ( 182 0 ) capacitor c=0.0376642f //x=19.87 //y=4.97
c466 ( 181 0 ) capacitor c=0.0346489f //x=19.535 //y=1.4
c467 ( 180 0 ) capacitor c=0.018692f //x=19.535 //y=1.055
c468 ( 174 0 ) capacitor c=0.0137077f //x=19.38 //y=1.555
c469 ( 172 0 ) capacitor c=0.0158585f //x=19.38 //y=0.9
c470 ( 171 0 ) capacitor c=0.103534f //x=19.005 //y=2.095
c471 ( 170 0 ) capacitor c=0.0229444f //x=19.005 //y=1.71
c472 ( 169 0 ) capacitor c=0.0234359f //x=19.005 //y=1.4
c473 ( 168 0 ) capacitor c=0.019815f //x=19.005 //y=1.055
c474 ( 164 0 ) capacitor c=0.0564069f //x=6.63 //y=4.97
c475 ( 163 0 ) capacitor c=0.0376642f //x=6.92 //y=4.97
c476 ( 162 0 ) capacitor c=0.0346489f //x=6.585 //y=1.4
c477 ( 161 0 ) capacitor c=0.018692f //x=6.585 //y=1.055
c478 ( 155 0 ) capacitor c=0.0137077f //x=6.43 //y=1.555
c479 ( 153 0 ) capacitor c=0.0158585f //x=6.43 //y=0.9
c480 ( 152 0 ) capacitor c=0.103534f //x=6.055 //y=2.095
c481 ( 151 0 ) capacitor c=0.0229444f //x=6.055 //y=1.71
c482 ( 150 0 ) capacitor c=0.0234359f //x=6.055 //y=1.4
c483 ( 149 0 ) capacitor c=0.019815f //x=6.055 //y=1.055
c484 ( 148 0 ) capacitor c=0.110208f //x=19.945 //y=6.2
c485 ( 147 0 ) capacitor c=0.158957f //x=19.505 //y=6.2
c486 ( 146 0 ) capacitor c=0.110208f //x=6.995 //y=6.2
c487 ( 145 0 ) capacitor c=0.158957f //x=6.555 //y=6.2
c488 ( 139 0 ) capacitor c=0.0014751f //x=19.305 //y=4.88
c489 ( 130 0 ) capacitor c=0.0012618f //x=19.305 //y=2.26
c490 ( 125 0 ) capacitor c=0.0014751f //x=6.355 //y=4.88
c491 ( 116 0 ) capacitor c=0.0012618f //x=6.355 //y=2.26
c492 ( 99 0 ) capacitor c=0.0293561f //x=3.725 //y=5.56
c493 ( 91 0 ) capacitor c=0.029137f //x=2.845 //y=5.56
c494 ( 83 0 ) capacitor c=0.0278099f //x=1.965 //y=5.56
c495 ( 77 0 ) capacitor c=7.36606e-19 //x=4.67 //y=3.885
c496 ( 72 0 ) capacitor c=0.0356523f //x=17.675 //y=3.87
c497 ( 70 0 ) capacitor c=0.0338299f //x=17.075 //y=3.88
c498 ( 68 0 ) capacitor c=0.00527642f //x=14.715 //y=3.9
c499 ( 66 0 ) capacitor c=0.018225f //x=14.115 //y=3.88
c500 ( 64 0 ) capacitor c=0.00410098f //x=12.86 //y=3.9
c501 ( 62 0 ) capacitor c=0.0100086f //x=12.125 //y=3.865
c502 ( 60 0 ) capacitor c=0.00684159f //x=11.38 //y=3.895
c503 ( 58 0 ) capacitor c=0.0174986f //x=10.78 //y=3.88
c504 ( 57 0 ) capacitor c=0.0248291f //x=9.19 //y=3.895
c505 ( 56 0 ) capacitor c=0.00423161f //x=9.535 //y=3.895
c506 ( 54 0 ) capacitor c=0.0209003f //x=6.2 //y=3.88
c507 ( 48 0 ) capacitor c=0.0168323f //x=19.295 //y=3.88
c508 ( 45 0 ) capacitor c=0.0167936f //x=6.355 //y=3.88
c509 ( 37 0 ) capacitor c=0.0172565f //x=4.505 //y=3.88
c510 ( 31 0 ) capacitor c=9.55882e-19 //x=3.725 //y=5.335
c511 ( 28 0 ) capacitor c=0.00740623f //x=2.845 //y=5.335
c512 ( 25 0 ) capacitor c=0.0123281f //x=1.967 //y=5.335
c513 ( 24 0 ) capacitor c=0.0267106f //x=19.305 //y=4.755
c514 ( 23 0 ) capacitor c=0.0136306f //x=19.305 //y=4.04
c515 ( 22 0 ) capacitor c=0.0475543f //x=19.305 //y=3.72
c516 ( 21 0 ) capacitor c=0.00489532f //x=19.305 //y=2.375
c517 ( 20 0 ) capacitor c=0.0266326f //x=6.355 //y=4.755
c518 ( 19 0 ) capacitor c=0.0127337f //x=6.355 //y=4.04
c519 ( 18 0 ) capacitor c=0.0455792f //x=6.355 //y=3.72
c520 ( 17 0 ) capacitor c=0.00670383f //x=6.355 //y=2.375
c521 ( 16 0 ) capacitor c=0.0325919f //x=4.505 //y=5.25
c522 ( 15 0 ) capacitor c=0.0131885f //x=4.505 //y=4.045
c523 ( 14 0 ) capacitor c=0.052475f //x=4.505 //y=3.725
c524 ( 12 0 ) capacitor c=0.00686157f //x=4.105 //y=1.845
c525 ( 11 0 ) capacitor c=0.0163455f //x=4.42 //y=1.845
c526 ( 10 0 ) capacitor c=0.0167992f //x=4.02 //y=1.76
c527 ( 9 0 ) capacitor c=0.0113317f //x=4.02 //y=1.305
c528 ( 7 0 ) capacitor c=0.0229543f //x=4.42 //y=5.335
c529 ( 6 0 ) capacitor c=0.00933983f //x=3.725 //y=5.56
c530 ( 3 0 ) capacitor c=0.019444f //x=3.61 //y=5.335
c531 ( 1 0 ) capacitor c=0.0149475f //x=2.725 //y=5.335
r532 (  182 184 ) resistor r=26.9307 //w=0.15 //l=0.106066 //layer=ply \
 //thickness=0.18 //x=19.87 //y=4.97 //x2=19.945 //y2=5.045
r533 (  182 183 ) resistor r=148.702 //w=0.094 //l=0.29 //layer=ply \
 //thickness=0.18 //x=19.87 //y=4.97 //x2=19.58 //y2=4.97
r534 (  181 202 ) resistor r=45.1352 //w=0.168 //l=0.173853 //layer=ply \
 //thickness=0.18 //x=19.535 //y=1.4 //x2=19.495 //y2=1.555
r535 (  180 201 ) resistor r=45.1352 //w=0.168 //l=0.173853 //layer=ply \
 //thickness=0.18 //x=19.535 //y=1.055 //x2=19.495 //y2=0.9
r536 (  180 181 ) resistor r=176.904 //w=0.094 //l=0.345 //layer=ply \
 //thickness=0.18 //x=19.535 //y=1.055 //x2=19.535 //y2=1.4
r537 (  177 183 ) resistor r=22.7971 //w=0.269 //l=0.106066 //layer=ply \
 //thickness=0.18 //x=19.505 //y=5.045 //x2=19.58 //y2=4.97
r538 (  177 200 ) resistor r=35.8364 //w=0.269 //l=0.270185 //layer=ply \
 //thickness=0.18 //x=19.505 //y=5.045 //x2=19.305 //y2=4.88
r539 (  175 196 ) resistor r=10.701 //w=0.21 //l=0.115 //layer=ply \
 //thickness=0.18 //x=19.16 //y=1.555 //x2=19.045 //y2=1.555
r540 (  174 202 ) resistor r=5.52526 //w=0.168 //l=0.115 //layer=ply \
 //thickness=0.18 //x=19.38 //y=1.555 //x2=19.495 //y2=1.555
r541 (  173 195 ) resistor r=5.52526 //w=0.168 //l=0.115 //layer=ply \
 //thickness=0.18 //x=19.16 //y=0.9 //x2=19.045 //y2=0.9
r542 (  172 201 ) resistor r=5.52526 //w=0.168 //l=0.115 //layer=ply \
 //thickness=0.18 //x=19.38 //y=0.9 //x2=19.495 //y2=0.9
r543 (  172 173 ) resistor r=112.809 //w=0.094 //l=0.22 //layer=ply \
 //thickness=0.18 //x=19.38 //y=0.9 //x2=19.16 //y2=0.9
r544 (  171 198 ) resistor r=58.7805 //w=0.246 //l=0.373497 //layer=ply \
 //thickness=0.18 //x=19.005 //y=2.095 //x2=19.305 //y2=2.26
r545 (  170 196 ) resistor r=39.5823 //w=0.21 //l=0.173853 //layer=ply \
 //thickness=0.18 //x=19.005 //y=1.71 //x2=19.045 //y2=1.555
r546 (  170 171 ) resistor r=197.415 //w=0.094 //l=0.385 //layer=ply \
 //thickness=0.18 //x=19.005 //y=1.71 //x2=19.005 //y2=2.095
r547 (  169 196 ) resistor r=39.5823 //w=0.21 //l=0.173853 //layer=ply \
 //thickness=0.18 //x=19.005 //y=1.4 //x2=19.045 //y2=1.555
r548 (  168 195 ) resistor r=45.1352 //w=0.168 //l=0.173853 //layer=ply \
 //thickness=0.18 //x=19.005 //y=1.055 //x2=19.045 //y2=0.9
r549 (  168 169 ) resistor r=176.904 //w=0.094 //l=0.345 //layer=ply \
 //thickness=0.18 //x=19.005 //y=1.055 //x2=19.005 //y2=1.4
r550 (  163 165 ) resistor r=26.9307 //w=0.15 //l=0.106066 //layer=ply \
 //thickness=0.18 //x=6.92 //y=4.97 //x2=6.995 //y2=5.045
r551 (  163 164 ) resistor r=148.702 //w=0.094 //l=0.29 //layer=ply \
 //thickness=0.18 //x=6.92 //y=4.97 //x2=6.63 //y2=4.97
r552 (  162 194 ) resistor r=45.1352 //w=0.168 //l=0.173853 //layer=ply \
 //thickness=0.18 //x=6.585 //y=1.4 //x2=6.545 //y2=1.555
r553 (  161 193 ) resistor r=45.1352 //w=0.168 //l=0.173853 //layer=ply \
 //thickness=0.18 //x=6.585 //y=1.055 //x2=6.545 //y2=0.9
r554 (  161 162 ) resistor r=176.904 //w=0.094 //l=0.345 //layer=ply \
 //thickness=0.18 //x=6.585 //y=1.055 //x2=6.585 //y2=1.4
r555 (  158 164 ) resistor r=22.7971 //w=0.269 //l=0.106066 //layer=ply \
 //thickness=0.18 //x=6.555 //y=5.045 //x2=6.63 //y2=4.97
r556 (  158 192 ) resistor r=35.8364 //w=0.269 //l=0.270185 //layer=ply \
 //thickness=0.18 //x=6.555 //y=5.045 //x2=6.355 //y2=4.88
r557 (  156 188 ) resistor r=10.701 //w=0.21 //l=0.115 //layer=ply \
 //thickness=0.18 //x=6.21 //y=1.555 //x2=6.095 //y2=1.555
r558 (  155 194 ) resistor r=5.52526 //w=0.168 //l=0.115 //layer=ply \
 //thickness=0.18 //x=6.43 //y=1.555 //x2=6.545 //y2=1.555
r559 (  154 187 ) resistor r=5.52526 //w=0.168 //l=0.115 //layer=ply \
 //thickness=0.18 //x=6.21 //y=0.9 //x2=6.095 //y2=0.9
r560 (  153 193 ) resistor r=5.52526 //w=0.168 //l=0.115 //layer=ply \
 //thickness=0.18 //x=6.43 //y=0.9 //x2=6.545 //y2=0.9
r561 (  153 154 ) resistor r=112.809 //w=0.094 //l=0.22 //layer=ply \
 //thickness=0.18 //x=6.43 //y=0.9 //x2=6.21 //y2=0.9
r562 (  152 190 ) resistor r=58.7805 //w=0.246 //l=0.373497 //layer=ply \
 //thickness=0.18 //x=6.055 //y=2.095 //x2=6.355 //y2=2.26
r563 (  151 188 ) resistor r=39.5823 //w=0.21 //l=0.173853 //layer=ply \
 //thickness=0.18 //x=6.055 //y=1.71 //x2=6.095 //y2=1.555
r564 (  151 152 ) resistor r=197.415 //w=0.094 //l=0.385 //layer=ply \
 //thickness=0.18 //x=6.055 //y=1.71 //x2=6.055 //y2=2.095
r565 (  150 188 ) resistor r=39.5823 //w=0.21 //l=0.173853 //layer=ply \
 //thickness=0.18 //x=6.055 //y=1.4 //x2=6.095 //y2=1.555
r566 (  149 187 ) resistor r=45.1352 //w=0.168 //l=0.173853 //layer=ply \
 //thickness=0.18 //x=6.055 //y=1.055 //x2=6.095 //y2=0.9
r567 (  149 150 ) resistor r=176.904 //w=0.094 //l=0.345 //layer=ply \
 //thickness=0.18 //x=6.055 //y=1.055 //x2=6.055 //y2=1.4
r568 (  148 184 ) resistor r=592.245 //w=0.094 //l=1.155 //layer=ply \
 //thickness=0.18 //x=19.945 //y=6.2 //x2=19.945 //y2=5.045
r569 (  147 177 ) resistor r=592.245 //w=0.094 //l=1.155 //layer=ply \
 //thickness=0.18 //x=19.505 //y=6.2 //x2=19.505 //y2=5.045
r570 (  146 165 ) resistor r=592.245 //w=0.094 //l=1.155 //layer=ply \
 //thickness=0.18 //x=6.995 //y=6.2 //x2=6.995 //y2=5.045
r571 (  145 158 ) resistor r=592.245 //w=0.094 //l=1.155 //layer=ply \
 //thickness=0.18 //x=6.555 //y=6.2 //x2=6.555 //y2=5.045
r572 (  144 174 ) resistor r=56.4043 //w=0.094 //l=0.11 //layer=ply \
 //thickness=0.18 //x=19.27 //y=1.555 //x2=19.38 //y2=1.555
r573 (  144 175 ) resistor r=56.4043 //w=0.094 //l=0.11 //layer=ply \
 //thickness=0.18 //x=19.27 //y=1.555 //x2=19.16 //y2=1.555
r574 (  143 155 ) resistor r=56.4043 //w=0.094 //l=0.11 //layer=ply \
 //thickness=0.18 //x=6.32 //y=1.555 //x2=6.43 //y2=1.555
r575 (  143 156 ) resistor r=56.4043 //w=0.094 //l=0.11 //layer=ply \
 //thickness=0.18 //x=6.32 //y=1.555 //x2=6.21 //y2=1.555
r576 (  139 200 ) resistor r=152 //w=0.17 //l=0.17 //layer=licon //count=1 \
 //x=19.305 //y=4.88 //x2=19.305 //y2=4.88
r577 (  130 198 ) resistor r=152 //w=0.17 //l=0.17 //layer=licon //count=1 \
 //x=19.305 //y=2.26 //x2=19.305 //y2=2.26
r578 (  125 192 ) resistor r=152 //w=0.17 //l=0.17 //layer=licon //count=1 \
 //x=6.355 //y=4.88 //x2=6.355 //y2=4.88
r579 (  116 190 ) resistor r=152 //w=0.17 //l=0.17 //layer=licon //count=1 \
 //x=6.355 //y=2.26 //x2=6.355 //y2=2.26
r580 (  99 207 ) resistor r=23.615 //w=0.187 //l=0.345 //layer=li \
 //thickness=0.1 //x=3.725 //y=5.56 //x2=3.725 //y2=5.905
r581 (  91 206 ) resistor r=23.615 //w=0.187 //l=0.345 //layer=li \
 //thickness=0.1 //x=2.845 //y=5.56 //x2=2.845 //y2=5.905
r582 (  83 205 ) resistor r=23.615 //w=0.187 //l=0.345 //layer=li \
 //thickness=0.1 //x=1.965 //y=5.56 //x2=1.965 //y2=5.905
r583 (  75 77 ) resistor r=0.10734 //w=0.281 //l=0.16 //layer=m2 \
 //thickness=0.36 //x=4.51 //y=3.885 //x2=4.67 //y2=3.885
r584 (  72 81 ) resistor r=1.03061 //w=0.197 //l=1.62499 //layer=m2 \
 //thickness=0.36 //x=17.675 //y=3.87 //x2=19.295 //y2=3.88
r585 (  72 73 ) resistor r=0.410305 //w=0.131 //l=0.43 //layer=m2 \
 //thickness=0.36 //x=17.675 //y=3.87 //x2=17.245 //y2=3.87
r586 (  70 73 ) resistor r=0.125 //w=0.17 //l=0.174929 //layer=m2 \
 //thickness=0.36 //x=17.075 //y=3.88 //x2=17.245 //y2=3.87
r587 (  70 71 ) resistor r=2.08969 //w=0.131 //l=2.19 //layer=m2 \
 //thickness=0.36 //x=17.075 //y=3.88 //x2=14.885 //y2=3.88
r588 (  68 71 ) resistor r=0.125 //w=0.17 //l=0.179722 //layer=m2 \
 //thickness=0.36 //x=14.715 //y=3.9 //x2=14.885 //y2=3.88
r589 (  68 69 ) resistor r=0.329198 //w=0.131 //l=0.345 //layer=m2 \
 //thickness=0.36 //x=14.715 //y=3.9 //x2=14.37 //y2=3.9
r590 (  66 69 ) resistor r=0.1875 //w=0.17 //l=0.264811 //layer=m2 \
 //thickness=0.36 //x=14.115 //y=3.88 //x2=14.37 //y2=3.9
r591 (  66 67 ) resistor r=1.03531 //w=0.131 //l=1.085 //layer=m2 \
 //thickness=0.36 //x=14.115 //y=3.88 //x2=13.03 //y2=3.88
r592 (  64 67 ) resistor r=0.125 //w=0.17 //l=0.179722 //layer=m2 \
 //thickness=0.36 //x=12.86 //y=3.9 //x2=13.03 //y2=3.88
r593 (  64 65 ) resistor r=0.329198 //w=0.131 //l=0.345 //layer=m2 \
 //thickness=0.36 //x=12.86 //y=3.9 //x2=12.515 //y2=3.9
r594 (  62 65 ) resistor r=0.286765 //w=0.17 //l=0.407124 //layer=m2 \
 //thickness=0.36 //x=12.125 //y=3.865 //x2=12.515 //y2=3.9
r595 (  62 63 ) resistor r=0.410305 //w=0.131 //l=0.43 //layer=m2 \
 //thickness=0.36 //x=12.125 //y=3.865 //x2=11.695 //y2=3.865
r596 (  60 63 ) resistor r=0.231618 //w=0.17 //l=0.329659 //layer=m2 \
 //thickness=0.36 //x=11.38 //y=3.895 //x2=11.695 //y2=3.865
r597 (  60 61 ) resistor r=0.329198 //w=0.131 //l=0.345 //layer=m2 \
 //thickness=0.36 //x=11.38 //y=3.895 //x2=11.035 //y2=3.895
r598 (  58 61 ) resistor r=0.1875 //w=0.17 //l=0.262393 //layer=m2 \
 //thickness=0.36 //x=10.78 //y=3.88 //x2=11.035 //y2=3.895
r599 (  58 59 ) resistor r=1.02576 //w=0.131 //l=1.075 //layer=m2 \
 //thickness=0.36 //x=10.78 //y=3.88 //x2=9.705 //y2=3.88
r600 (  57 79 ) resistor r=1.89299 //w=0.187 //l=2.83749 //layer=m2 \
 //thickness=0.36 //x=9.19 //y=3.895 //x2=6.36 //y2=3.88
r601 (  56 59 ) resistor r=0.125 //w=0.17 //l=0.177341 //layer=m2 \
 //thickness=0.36 //x=9.535 //y=3.895 //x2=9.705 //y2=3.88
r602 (  56 57 ) resistor r=0.329198 //w=0.131 //l=0.345 //layer=m2 \
 //thickness=0.36 //x=9.535 //y=3.895 //x2=9.19 //y2=3.895
r603 (  54 79 ) resistor r=0.108234 //w=0.187 //l=0.16 //layer=m2 \
 //thickness=0.36 //x=6.2 //y=3.88 //x2=6.36 //y2=3.88
r604 (  54 77 ) resistor r=1.45992 //w=0.131 //l=1.53 //layer=m2 \
 //thickness=0.36 //x=6.2 //y=3.88 //x2=4.67 //y2=3.88
r605 (  53 139 ) resistor r=9.3 //w=0.17 //l=0.17 //layer=mcon //count=1 \
 //x=19.305 //y=4.88 //x2=19.305 //y2=4.88
r606 (  51 130 ) resistor r=9.3 //w=0.17 //l=0.17 //layer=mcon //count=1 \
 //x=19.305 //y=2.26 //x2=19.305 //y2=2.26
r607 (  48 81 ) resistor r=4.5 //w=0.15 //l=0.15 //layer=via1 //count=1 \
 //x=19.295 //y=3.88 //x2=19.295 //y2=3.88
r608 (  45 79 ) resistor r=4.5 //w=0.15 //l=0.15 //layer=via1 //count=1 \
 //x=6.36 //y=3.88 //x2=6.36 //y2=3.88
r609 (  43 125 ) resistor r=9.3 //w=0.17 //l=0.17 //layer=mcon //count=1 \
 //x=6.355 //y=4.88 //x2=6.355 //y2=4.88
r610 (  41 116 ) resistor r=9.3 //w=0.17 //l=0.17 //layer=mcon //count=1 \
 //x=6.355 //y=2.26 //x2=6.355 //y2=2.26
r611 (  39 75 ) resistor r=4.5 //w=0.15 //l=0.15 //layer=via1 //count=1 \
 //x=4.51 //y=3.885 //x2=4.51 //y2=3.885
r612 (  37 39 ) resistor r=0.00167112 //w=0.374 //l=0.005 //layer=m1 \
 //thickness=0.36 //x=4.56 //y=3.88 //x2=4.56 //y2=3.885
r613 (  35 203 ) resistor r=9.3 //w=0.17 //l=0.17 //layer=mcon //count=1 \
 //x=4.02 //y=1.19 //x2=4.02 //y2=1.19
r614 (  33 99 ) resistor r=9.3 //w=0.17 //l=0.17 //layer=mcon //count=1 \
 //x=3.725 //y=5.56 //x2=3.725 //y2=5.56
r615 (  30 91 ) resistor r=9.3 //w=0.17 //l=0.17 //layer=mcon //count=1 \
 //x=2.845 //y=5.56 //x2=2.845 //y2=5.56
r616 (  28 30 ) resistor r=0.121228 //w=0.232 //l=0.225 //layer=m1 \
 //thickness=0.36 //x=2.845 //y=5.335 //x2=2.845 //y2=5.56
r617 (  27 83 ) resistor r=9.3 //w=0.17 //l=0.17 //layer=mcon //count=1 \
 //x=1.965 //y=5.56 //x2=1.965 //y2=5.56
r618 (  25 27 ) resistor r=0.129608 //w=0.217 //l=0.225 //layer=m1 \
 //thickness=0.36 //x=1.967 //y=5.335 //x2=1.967 //y2=5.56
r619 (  24 53 ) resistor r=0.0760407 //w=0.238 //l=0.125 //layer=m1 \
 //thickness=0.36 //x=19.305 //y=4.755 //x2=19.305 //y2=4.88
r620 (  23 48 ) resistor r=0.0909648 //w=0.371 //l=0.186762 //layer=m1 \
 //thickness=0.36 //x=19.305 //y=4.04 //x2=19.247 //y2=3.88
r621 (  23 24 ) resistor r=0.682252 //w=0.131 //l=0.715 //layer=m1 \
 //thickness=0.36 //x=19.305 //y=4.04 //x2=19.305 //y2=4.755
r622 (  22 48 ) resistor r=0.0909648 //w=0.371 //l=0.186762 //layer=m1 \
 //thickness=0.36 //x=19.305 //y=3.72 //x2=19.247 //y2=3.88
r623 (  21 51 ) resistor r=0.0719237 //w=0.222 //l=0.115 //layer=m1 \
 //thickness=0.36 //x=19.305 //y=2.375 //x2=19.305 //y2=2.26
r624 (  21 22 ) resistor r=1.2834 //w=0.131 //l=1.345 //layer=m1 \
 //thickness=0.36 //x=19.305 //y=2.375 //x2=19.305 //y2=3.72
r625 (  20 43 ) resistor r=0.0760407 //w=0.238 //l=0.125 //layer=m1 \
 //thickness=0.36 //x=6.355 //y=4.755 //x2=6.355 //y2=4.88
r626 (  19 45 ) resistor r=0.0910802 //w=0.374 //l=0.185472 //layer=m1 \
 //thickness=0.36 //x=6.355 //y=4.04 //x2=6.41 //y2=3.88
r627 (  19 20 ) resistor r=0.682252 //w=0.131 //l=0.715 //layer=m1 \
 //thickness=0.36 //x=6.355 //y=4.04 //x2=6.355 //y2=4.755
r628 (  18 45 ) resistor r=0.0910802 //w=0.374 //l=0.185472 //layer=m1 \
 //thickness=0.36 //x=6.355 //y=3.72 //x2=6.41 //y2=3.88
r629 (  17 41 ) resistor r=0.0719237 //w=0.222 //l=0.115 //layer=m1 \
 //thickness=0.36 //x=6.355 //y=2.375 //x2=6.355 //y2=2.26
r630 (  17 18 ) resistor r=1.2834 //w=0.131 //l=1.345 //layer=m1 \
 //thickness=0.36 //x=6.355 //y=2.375 //x2=6.355 //y2=3.72
r631 (  15 39 ) resistor r=0.0910802 //w=0.374 //l=0.185472 //layer=m1 \
 //thickness=0.36 //x=4.505 //y=4.045 //x2=4.56 //y2=3.885
r632 (  15 16 ) resistor r=1.14981 //w=0.131 //l=1.205 //layer=m1 \
 //thickness=0.36 //x=4.505 //y=4.045 //x2=4.505 //y2=5.25
r633 (  14 37 ) resistor r=0.089409 //w=0.374 //l=0.180416 //layer=m1 \
 //thickness=0.36 //x=4.505 //y=3.725 //x2=4.56 //y2=3.88
r634 (  13 14 ) resistor r=1.71279 //w=0.131 //l=1.795 //layer=m1 \
 //thickness=0.36 //x=4.505 //y=1.93 //x2=4.505 //y2=3.725
r635 (  11 13 ) resistor r=0.0698411 //w=0.17 //l=0.120208 //layer=m1 \
 //thickness=0.36 //x=4.42 //y=1.845 //x2=4.505 //y2=1.93
r636 (  11 12 ) resistor r=0.300573 //w=0.131 //l=0.315 //layer=m1 \
 //thickness=0.36 //x=4.42 //y=1.845 //x2=4.105 //y2=1.845
r637 (  10 12 ) resistor r=0.0698411 //w=0.17 //l=0.120208 //layer=m1 \
 //thickness=0.36 //x=4.02 //y=1.76 //x2=4.105 //y2=1.845
r638 (  9 35 ) resistor r=0.0717383 //w=0.224 //l=0.115 //layer=m1 \
 //thickness=0.36 //x=4.02 //y=1.305 //x2=4.02 //y2=1.19
r639 (  9 10 ) resistor r=0.43416 //w=0.131 //l=0.455 //layer=m1 \
 //thickness=0.36 //x=4.02 //y=1.305 //x2=4.02 //y2=1.76
r640 (  8 31 ) resistor r=0.0675342 //w=0.23 //l=0.115 //layer=m1 \
 //thickness=0.36 //x=3.84 //y=5.335 //x2=3.725 //y2=5.335
r641 (  7 16 ) resistor r=0.0698411 //w=0.17 //l=0.120208 //layer=m1 \
 //thickness=0.36 //x=4.42 //y=5.335 //x2=4.505 //y2=5.25
r642 (  7 8 ) resistor r=0.553435 //w=0.131 //l=0.58 //layer=m1 \
 //thickness=0.36 //x=4.42 //y=5.335 //x2=3.84 //y2=5.335
r643 (  6 33 ) resistor r=0.00118313 //w=0.23 //layer=m1 //thickness=0.36 \
 //x=3.725 //y=5.56 //x2=3.725 //y2=5.56
r644 (  5 31 ) resistor r=0.002872 //w=0.34 //l=0.085 //layer=m1 \
 //thickness=0.36 //x=3.725 //y=5.42 //x2=3.725 //y2=5.335
r645 (  5 6 ) resistor r=0.091623 //w=0.191 //l=0.14 //layer=m1 \
 //thickness=0.36 //x=3.725 //y=5.42 //x2=3.725 //y2=5.56
r646 (  4 28 ) resistor r=0.0262263 //w=0.232 //l=0.12 //layer=m1 \
 //thickness=0.36 //x=2.965 //y=5.335 //x2=2.845 //y2=5.335
r647 (  3 31 ) resistor r=0.0675342 //w=0.23 //l=0.115 //layer=m1 \
 //thickness=0.36 //x=3.61 //y=5.335 //x2=3.725 //y2=5.335
r648 (  3 4 ) resistor r=0.615458 //w=0.131 //l=0.645 //layer=m1 \
 //thickness=0.36 //x=3.61 //y=5.335 //x2=2.965 //y2=5.335
r649 (  2 25 ) resistor r=0.0222262 //w=0.217 //l=0.118 //layer=m1 \
 //thickness=0.36 //x=2.085 //y=5.335 //x2=1.967 //y2=5.335
r650 (  1 28 ) resistor r=0.0262263 //w=0.232 //l=0.12 //layer=m1 \
 //thickness=0.36 //x=2.725 //y=5.335 //x2=2.845 //y2=5.335
r651 (  1 2 ) resistor r=0.610687 //w=0.131 //l=0.64 //layer=m1 \
 //thickness=0.36 //x=2.725 //y=5.335 //x2=2.085 //y2=5.335
ends PM_DFFRNQX1\%noxref_4

subckt PM_DFFRNQX1\%RN ( 1 2 3 4 5 6 7 8 9 10 11 12 13 15 19 23 24 35 55 59 60 \
 62 63 66 71 76 81 86 91 95 96 97 98 99 100 101 102 103 107 108 109 114 116 \
 119 120 124 125 126 131 133 136 137 138 139 140 142 148 149 150 151 152 158 \
 159 164 168 169 174 180 )
c430 ( 180 0 ) capacitor c=0.0369044f //x=20.415 //y=4.88
c431 ( 174 0 ) capacitor c=0.0710579f //x=16.715 //y=4.88
c432 ( 169 0 ) capacitor c=0.0278202f //x=16.715 //y=2.095
c433 ( 168 0 ) capacitor c=0.0490597f //x=16.715 //y=2.26
c434 ( 164 0 ) capacitor c=0.0710579f //x=8.575 //y=4.88
c435 ( 159 0 ) capacitor c=0.0278202f //x=8.575 //y=2.095
c436 ( 158 0 ) capacitor c=0.0490508f //x=8.575 //y=2.26
c437 ( 152 0 ) capacitor c=0.0309248f //x=20.75 //y=4.97
c438 ( 151 0 ) capacitor c=0.0852528f //x=20.505 //y=2.095
c439 ( 150 0 ) capacitor c=0.0170266f //x=20.505 //y=1.63
c440 ( 149 0 ) capacitor c=0.018609f //x=20.505 //y=1.4
c441 ( 148 0 ) capacitor c=0.0186599f //x=20.505 //y=1.09
c442 ( 142 0 ) capacitor c=0.0146988f //x=20.35 //y=1.555
c443 ( 140 0 ) capacitor c=0.0148531f //x=20.35 //y=0.935
c444 ( 139 0 ) capacitor c=0.0334406f //x=19.98 //y=1.4
c445 ( 138 0 ) capacitor c=0.0173191f //x=19.98 //y=1.09
c446 ( 137 0 ) capacitor c=0.0443175f //x=17.235 //y=1.44
c447 ( 136 0 ) capacitor c=0.0199703f //x=17.235 //y=1.095
c448 ( 133 0 ) capacitor c=0.0160331f //x=17.08 //y=1.595
c449 ( 131 0 ) capacitor c=0.0157807f //x=17.08 //y=0.94
c450 ( 126 0 ) capacitor c=0.0219045f //x=16.705 //y=1.75
c451 ( 125 0 ) capacitor c=0.0207489f //x=16.705 //y=1.44
c452 ( 124 0 ) capacitor c=0.0194091f //x=16.705 //y=1.095
c453 ( 120 0 ) capacitor c=0.0443175f //x=9.095 //y=1.44
c454 ( 119 0 ) capacitor c=0.0199703f //x=9.095 //y=1.095
c455 ( 116 0 ) capacitor c=0.0160331f //x=8.94 //y=1.595
c456 ( 114 0 ) capacitor c=0.0157807f //x=8.94 //y=0.94
c457 ( 109 0 ) capacitor c=0.0219045f //x=8.565 //y=1.75
c458 ( 108 0 ) capacitor c=0.0207489f //x=8.565 //y=1.44
c459 ( 107 0 ) capacitor c=0.0194091f //x=8.565 //y=1.095
c460 ( 103 0 ) capacitor c=0.110208f //x=20.825 //y=6.2
c461 ( 102 0 ) capacitor c=0.110214f //x=20.385 //y=6.2
c462 ( 101 0 ) capacitor c=0.159671f //x=16.895 //y=6.2
c463 ( 100 0 ) capacitor c=0.110208f //x=16.455 //y=6.2
c464 ( 99 0 ) capacitor c=0.159671f //x=8.755 //y=6.2
c465 ( 98 0 ) capacitor c=0.110208f //x=8.315 //y=6.2
c466 ( 91 0 ) capacitor c=0.00129935f //x=20.415 //y=4.88
c467 ( 86 0 ) capacitor c=0.00121786f //x=20.415 //y=2.26
c468 ( 81 0 ) capacitor c=7.7417e-19 //x=16.715 //y=4.88
c469 ( 76 0 ) capacitor c=0.00118671f //x=16.715 //y=2.26
c470 ( 71 0 ) capacitor c=7.7417e-19 //x=8.575 //y=4.88
c471 ( 66 0 ) capacitor c=0.00118671f //x=8.575 //y=2.26
c472 ( 63 0 ) capacitor c=0.0960316f //x=20.21 //y=2.355
c473 ( 62 0 ) capacitor c=0.00565742f //x=20.37 //y=2.355
c474 ( 60 0 ) capacitor c=0.0061184f //x=16.88 //y=2.315
c475 ( 59 0 ) capacitor c=0.212759f //x=16.56 //y=2.315
c476 ( 55 0 ) capacitor c=0.00579749f //x=8.58 //y=2.305
c477 ( 35 0 ) capacitor c=0.0115018f //x=8.58 //y=2.305
c478 ( 24 0 ) capacitor c=0.00506049f //x=20.415 //y=4.765
c479 ( 23 0 ) capacitor c=0.00939356f //x=20.415 //y=2.515
c480 ( 19 0 ) capacitor c=0.00449964f //x=16.715 //y=4.75
c481 ( 15 0 ) capacitor c=0.00452199f //x=8.575 //y=4.75
c482 ( 12 0 ) capacitor c=0.0110145f //x=16.715 //y=2.4
c483 ( 6 0 ) capacitor c=0.0645071f //x=20.415 //y=2.77
c484 ( 3 0 ) capacitor c=0.0600822f //x=16.715 //y=2.77
c485 ( 1 0 ) capacitor c=0.0585483f //x=8.575 //y=2.77
r486 (  182 183 ) resistor r=32.4568 //w=0.214 //l=0.075 //layer=ply \
 //thickness=0.18 //x=20.415 //y=4.97 //x2=20.415 //y2=5.045
r487 (  180 182 ) resistor r=20.271 //w=0.214 //l=0.09 //layer=ply \
 //thickness=0.18 //x=20.415 //y=4.88 //x2=20.415 //y2=4.97
r488 (  168 169 ) resistor r=52.7279 //w=0.214 //l=0.165 //layer=ply \
 //thickness=0.18 //x=16.715 //y=2.26 //x2=16.715 //y2=2.095
r489 (  158 159 ) resistor r=52.7279 //w=0.214 //l=0.165 //layer=ply \
 //thickness=0.18 //x=8.575 //y=2.26 //x2=8.575 //y2=2.095
r490 (  153 182 ) resistor r=16.5046 //w=0.27 //l=0.135 //layer=ply \
 //thickness=0.18 //x=20.55 //y=4.97 //x2=20.415 //y2=4.97
r491 (  152 154 ) resistor r=26.9307 //w=0.15 //l=0.106066 //layer=ply \
 //thickness=0.18 //x=20.75 //y=4.97 //x2=20.825 //y2=5.045
r492 (  152 153 ) resistor r=102.553 //w=0.094 //l=0.2 //layer=ply \
 //thickness=0.18 //x=20.75 //y=4.97 //x2=20.55 //y2=4.97
r493 (  151 187 ) resistor r=38.6777 //w=0.284 //l=0.198997 //layer=ply \
 //thickness=0.18 //x=20.505 //y=2.095 //x2=20.43 //y2=2.26
r494 (  150 185 ) resistor r=21.2976 //w=0.217 //l=0.0928709 //layer=ply \
 //thickness=0.18 //x=20.505 //y=1.63 //x2=20.465 //y2=1.555
r495 (  150 151 ) resistor r=238.436 //w=0.094 //l=0.465 //layer=ply \
 //thickness=0.18 //x=20.505 //y=1.63 //x2=20.505 //y2=2.095
r496 (  149 185 ) resistor r=39.0671 //w=0.217 //l=0.173853 //layer=ply \
 //thickness=0.18 //x=20.505 //y=1.4 //x2=20.465 //y2=1.555
r497 (  148 184 ) resistor r=45.1352 //w=0.168 //l=0.173853 //layer=ply \
 //thickness=0.18 //x=20.505 //y=1.09 //x2=20.465 //y2=0.935
r498 (  148 149 ) resistor r=158.957 //w=0.094 //l=0.31 //layer=ply \
 //thickness=0.18 //x=20.505 //y=1.09 //x2=20.505 //y2=1.4
r499 (  143 178 ) resistor r=5.52526 //w=0.168 //l=0.115 //layer=ply \
 //thickness=0.18 //x=20.135 //y=1.555 //x2=20.02 //y2=1.555
r500 (  142 185 ) resistor r=11.4558 //w=0.217 //l=0.115 //layer=ply \
 //thickness=0.18 //x=20.35 //y=1.555 //x2=20.465 //y2=1.555
r501 (  141 177 ) resistor r=5.52526 //w=0.168 //l=0.115 //layer=ply \
 //thickness=0.18 //x=20.135 //y=0.935 //x2=20.02 //y2=0.935
r502 (  140 184 ) resistor r=5.52526 //w=0.168 //l=0.115 //layer=ply \
 //thickness=0.18 //x=20.35 //y=0.935 //x2=20.465 //y2=0.935
r503 (  140 141 ) resistor r=110.245 //w=0.094 //l=0.215 //layer=ply \
 //thickness=0.18 //x=20.35 //y=0.935 //x2=20.135 //y2=0.935
r504 (  139 178 ) resistor r=45.1352 //w=0.168 //l=0.173853 //layer=ply \
 //thickness=0.18 //x=19.98 //y=1.4 //x2=20.02 //y2=1.555
r505 (  138 177 ) resistor r=45.1352 //w=0.168 //l=0.173853 //layer=ply \
 //thickness=0.18 //x=19.98 //y=1.09 //x2=20.02 //y2=0.935
r506 (  138 139 ) resistor r=158.957 //w=0.094 //l=0.31 //layer=ply \
 //thickness=0.18 //x=19.98 //y=1.09 //x2=19.98 //y2=1.4
r507 (  137 176 ) resistor r=45.1352 //w=0.168 //l=0.173853 //layer=ply \
 //thickness=0.18 //x=17.235 //y=1.44 //x2=17.195 //y2=1.595
r508 (  136 175 ) resistor r=45.1352 //w=0.168 //l=0.173853 //layer=ply \
 //thickness=0.18 //x=17.235 //y=1.095 //x2=17.195 //y2=0.94
r509 (  136 137 ) resistor r=176.904 //w=0.094 //l=0.345 //layer=ply \
 //thickness=0.18 //x=17.235 //y=1.095 //x2=17.235 //y2=1.44
r510 (  134 172 ) resistor r=10.701 //w=0.21 //l=0.115 //layer=ply \
 //thickness=0.18 //x=16.86 //y=1.595 //x2=16.745 //y2=1.595
r511 (  133 176 ) resistor r=5.52526 //w=0.168 //l=0.115 //layer=ply \
 //thickness=0.18 //x=17.08 //y=1.595 //x2=17.195 //y2=1.595
r512 (  132 171 ) resistor r=5.52526 //w=0.168 //l=0.115 //layer=ply \
 //thickness=0.18 //x=16.86 //y=0.94 //x2=16.745 //y2=0.94
r513 (  131 175 ) resistor r=5.52526 //w=0.168 //l=0.115 //layer=ply \
 //thickness=0.18 //x=17.08 //y=0.94 //x2=17.195 //y2=0.94
r514 (  131 132 ) resistor r=112.809 //w=0.094 //l=0.22 //layer=ply \
 //thickness=0.18 //x=17.08 //y=0.94 //x2=16.86 //y2=0.94
r515 (  128 174 ) resistor r=37.236 //w=0.233 //l=0.249199 //layer=ply \
 //thickness=0.18 //x=16.895 //y=5.045 //x2=16.715 //y2=4.88
r516 (  126 172 ) resistor r=39.5823 //w=0.21 //l=0.173853 //layer=ply \
 //thickness=0.18 //x=16.705 //y=1.75 //x2=16.745 //y2=1.595
r517 (  126 169 ) resistor r=176.904 //w=0.094 //l=0.345 //layer=ply \
 //thickness=0.18 //x=16.705 //y=1.75 //x2=16.705 //y2=2.095
r518 (  125 172 ) resistor r=39.5823 //w=0.21 //l=0.173853 //layer=ply \
 //thickness=0.18 //x=16.705 //y=1.44 //x2=16.745 //y2=1.595
r519 (  124 171 ) resistor r=45.1352 //w=0.168 //l=0.173853 //layer=ply \
 //thickness=0.18 //x=16.705 //y=1.095 //x2=16.745 //y2=0.94
r520 (  124 125 ) resistor r=176.904 //w=0.094 //l=0.345 //layer=ply \
 //thickness=0.18 //x=16.705 //y=1.095 //x2=16.705 //y2=1.44
r521 (  121 174 ) resistor r=53.7854 //w=0.233 //l=0.332415 //layer=ply \
 //thickness=0.18 //x=16.455 //y=5.045 //x2=16.715 //y2=4.88
r522 (  120 166 ) resistor r=45.1352 //w=0.168 //l=0.173853 //layer=ply \
 //thickness=0.18 //x=9.095 //y=1.44 //x2=9.055 //y2=1.595
r523 (  119 165 ) resistor r=45.1352 //w=0.168 //l=0.173853 //layer=ply \
 //thickness=0.18 //x=9.095 //y=1.095 //x2=9.055 //y2=0.94
r524 (  119 120 ) resistor r=176.904 //w=0.094 //l=0.345 //layer=ply \
 //thickness=0.18 //x=9.095 //y=1.095 //x2=9.095 //y2=1.44
r525 (  117 162 ) resistor r=10.701 //w=0.21 //l=0.115 //layer=ply \
 //thickness=0.18 //x=8.72 //y=1.595 //x2=8.605 //y2=1.595
r526 (  116 166 ) resistor r=5.52526 //w=0.168 //l=0.115 //layer=ply \
 //thickness=0.18 //x=8.94 //y=1.595 //x2=9.055 //y2=1.595
r527 (  115 161 ) resistor r=5.52526 //w=0.168 //l=0.115 //layer=ply \
 //thickness=0.18 //x=8.72 //y=0.94 //x2=8.605 //y2=0.94
r528 (  114 165 ) resistor r=5.52526 //w=0.168 //l=0.115 //layer=ply \
 //thickness=0.18 //x=8.94 //y=0.94 //x2=9.055 //y2=0.94
r529 (  114 115 ) resistor r=112.809 //w=0.094 //l=0.22 //layer=ply \
 //thickness=0.18 //x=8.94 //y=0.94 //x2=8.72 //y2=0.94
r530 (  111 164 ) resistor r=37.236 //w=0.233 //l=0.249199 //layer=ply \
 //thickness=0.18 //x=8.755 //y=5.045 //x2=8.575 //y2=4.88
r531 (  109 162 ) resistor r=39.5823 //w=0.21 //l=0.173853 //layer=ply \
 //thickness=0.18 //x=8.565 //y=1.75 //x2=8.605 //y2=1.595
r532 (  109 159 ) resistor r=176.904 //w=0.094 //l=0.345 //layer=ply \
 //thickness=0.18 //x=8.565 //y=1.75 //x2=8.565 //y2=2.095
r533 (  108 162 ) resistor r=39.5823 //w=0.21 //l=0.173853 //layer=ply \
 //thickness=0.18 //x=8.565 //y=1.44 //x2=8.605 //y2=1.595
r534 (  107 161 ) resistor r=45.1352 //w=0.168 //l=0.173853 //layer=ply \
 //thickness=0.18 //x=8.565 //y=1.095 //x2=8.605 //y2=0.94
r535 (  107 108 ) resistor r=176.904 //w=0.094 //l=0.345 //layer=ply \
 //thickness=0.18 //x=8.565 //y=1.095 //x2=8.565 //y2=1.44
r536 (  104 164 ) resistor r=53.7854 //w=0.233 //l=0.332415 //layer=ply \
 //thickness=0.18 //x=8.315 //y=5.045 //x2=8.575 //y2=4.88
r537 (  103 154 ) resistor r=592.245 //w=0.094 //l=1.155 //layer=ply \
 //thickness=0.18 //x=20.825 //y=6.2 //x2=20.825 //y2=5.045
r538 (  102 183 ) resistor r=592.245 //w=0.094 //l=1.155 //layer=ply \
 //thickness=0.18 //x=20.385 //y=6.2 //x2=20.385 //y2=5.045
r539 (  101 128 ) resistor r=592.245 //w=0.094 //l=1.155 //layer=ply \
 //thickness=0.18 //x=16.895 //y=6.2 //x2=16.895 //y2=5.045
r540 (  100 121 ) resistor r=592.245 //w=0.094 //l=1.155 //layer=ply \
 //thickness=0.18 //x=16.455 //y=6.2 //x2=16.455 //y2=5.045
r541 (  99 111 ) resistor r=592.245 //w=0.094 //l=1.155 //layer=ply \
 //thickness=0.18 //x=8.755 //y=6.2 //x2=8.755 //y2=5.045
r542 (  98 104 ) resistor r=592.245 //w=0.094 //l=1.155 //layer=ply \
 //thickness=0.18 //x=8.315 //y=6.2 //x2=8.315 //y2=5.045
r543 (  97 142 ) resistor r=55.3787 //w=0.094 //l=0.108 //layer=ply \
 //thickness=0.18 //x=20.242 //y=1.555 //x2=20.35 //y2=1.555
r544 (  97 143 ) resistor r=54.866 //w=0.094 //l=0.107 //layer=ply \
 //thickness=0.18 //x=20.242 //y=1.555 //x2=20.135 //y2=1.555
r545 (  96 133 ) resistor r=56.4043 //w=0.094 //l=0.11 //layer=ply \
 //thickness=0.18 //x=16.97 //y=1.595 //x2=17.08 //y2=1.595
r546 (  96 134 ) resistor r=56.4043 //w=0.094 //l=0.11 //layer=ply \
 //thickness=0.18 //x=16.97 //y=1.595 //x2=16.86 //y2=1.595
r547 (  95 116 ) resistor r=56.4043 //w=0.094 //l=0.11 //layer=ply \
 //thickness=0.18 //x=8.83 //y=1.595 //x2=8.94 //y2=1.595
r548 (  95 117 ) resistor r=56.4043 //w=0.094 //l=0.11 //layer=ply \
 //thickness=0.18 //x=8.83 //y=1.595 //x2=8.72 //y2=1.595
r549 (  91 180 ) resistor r=152 //w=0.17 //l=0.17 //layer=licon //count=1 \
 //x=20.415 //y=4.88 //x2=20.415 //y2=4.88
r550 (  86 187 ) resistor r=152 //w=0.17 //l=0.17 //layer=licon //count=1 \
 //x=20.415 //y=2.26 //x2=20.415 //y2=2.26
r551 (  81 174 ) resistor r=152 //w=0.17 //l=0.17 //layer=licon //count=1 \
 //x=16.715 //y=4.88 //x2=16.715 //y2=4.88
r552 (  76 168 ) resistor r=152 //w=0.17 //l=0.17 //layer=licon //count=1 \
 //x=16.715 //y=2.26 //x2=16.715 //y2=2.26
r553 (  71 164 ) resistor r=152 //w=0.17 //l=0.17 //layer=licon //count=1 \
 //x=8.575 //y=4.88 //x2=8.575 //y2=4.88
r554 (  66 158 ) resistor r=152 //w=0.17 //l=0.17 //layer=licon //count=1 \
 //x=8.575 //y=2.26 //x2=8.575 //y2=2.26
r555 (  62 63 ) resistor r=0.10734 //w=0.281 //l=0.16 //layer=m2 \
 //thickness=0.36 //x=20.37 //y=2.355 //x2=20.21 //y2=2.355
r556 (  60 63 ) resistor r=3.17748 //w=0.131 //l=3.33 //layer=m2 \
 //thickness=0.36 //x=16.88 //y=2.4 //x2=20.21 //y2=2.4
r557 (  58 60 ) resistor r=0.107331 //w=0.301 //l=0.16 //layer=m2 \
 //thickness=0.36 //x=16.72 //y=2.315 //x2=16.88 //y2=2.315
r558 (  58 59 ) resistor r=0.107331 //w=0.301 //l=0.16 //layer=m2 \
 //thickness=0.36 //x=16.72 //y=2.315 //x2=16.56 //y2=2.315
r559 (  55 56 ) resistor r=0.0373428 //w=0.318 //l=0.095 //layer=m2 \
 //thickness=0.36 //x=8.58 //y=2.305 //x2=8.58 //y2=2.4
r560 (  51 56 ) resistor r=0.0451273 //w=0.318 //l=0.16 //layer=m2 \
 //thickness=0.36 //x=8.74 //y=2.4 //x2=8.58 //y2=2.4
r561 (  51 59 ) resistor r=7.46183 //w=0.131 //l=7.82 //layer=m2 \
 //thickness=0.36 //x=8.74 //y=2.4 //x2=16.56 //y2=2.4
r562 (  48 62 ) resistor r=4.5 //w=0.15 //l=0.15 //layer=via1 //count=1 \
 //x=20.37 //y=2.355 //x2=20.37 //y2=2.355
r563 (  46 86 ) resistor r=9.3 //w=0.17 //l=0.17 //layer=mcon //count=1 \
 //x=20.415 //y=2.26 //x2=20.415 //y2=2.26
r564 (  46 48 ) resistor r=0.0401182 //w=0.296 //l=0.095 //layer=m1 \
 //thickness=0.36 //x=20.372 //y=2.26 //x2=20.372 //y2=2.355
r565 (  44 91 ) resistor r=9.3 //w=0.17 //l=0.17 //layer=mcon //count=1 \
 //x=20.415 //y=4.88 //x2=20.415 //y2=4.88
r566 (  42 58 ) resistor r=4.5 //w=0.15 //l=0.15 //layer=via1 //count=1 \
 //x=16.72 //y=2.305 //x2=16.72 //y2=2.305
r567 (  38 81 ) resistor r=9.3 //w=0.17 //l=0.17 //layer=mcon //count=1 \
 //x=16.715 //y=4.88 //x2=16.715 //y2=4.88
r568 (  35 55 ) resistor r=4.5 //w=0.15 //l=0.15 //layer=via1 //count=1 \
 //x=8.58 //y=2.305 //x2=8.58 //y2=2.305
r569 (  33 66 ) resistor r=9.3 //w=0.17 //l=0.17 //layer=mcon //count=1 \
 //x=8.575 //y=2.26 //x2=8.575 //y2=2.26
r570 (  33 35 ) resistor r=0.00172176 //w=0.363 //l=0.005 //layer=m1 \
 //thickness=0.36 //x=8.575 //y=2.29 //x2=8.58 //y2=2.29
r571 (  31 71 ) resistor r=9.3 //w=0.17 //l=0.17 //layer=mcon //count=1 \
 //x=8.575 //y=4.88 //x2=8.575 //y2=4.88
r572 (  24 44 ) resistor r=0.0717383 //w=0.224 //l=0.115 //layer=m1 \
 //thickness=0.36 //x=20.415 //y=4.765 //x2=20.415 //y2=4.88
r573 (  19 38 ) resistor r=0.0801089 //w=0.224 //l=0.13 //layer=m1 \
 //thickness=0.36 //x=16.715 //y=4.75 //x2=16.715 //y2=4.88
r574 (  15 31 ) resistor r=0.0801089 //w=0.224 //l=0.13 //layer=m1 \
 //thickness=0.36 //x=8.575 //y=4.75 //x2=8.575 //y2=4.88
r575 (  14 33 ) resistor r=0.0532 //w=0.363 //l=0.195 //layer=m1 \
 //thickness=0.36 //x=8.575 //y=2.485 //x2=8.575 //y2=2.29
r576 (  13 23 ) resistor r=0.0710242 //w=0.296 //l=0.134796 //layer=m1 \
 //thickness=0.36 //x=20.372 //y=2.4 //x2=20.415 //y2=2.515
r577 (  13 48 ) resistor r=0.0190034 //w=0.296 //l=0.045 //layer=m1 \
 //thickness=0.36 //x=20.372 //y=2.4 //x2=20.372 //y2=2.355
r578 (  12 76 ) resistor r=9.3 //w=0.17 //l=0.17 //layer=mcon //count=1 \
 //x=16.715 //y=2.26 //x2=16.715 //y2=2.26
r579 (  12 42 ) resistor r=0.00179083 //w=0.349 //l=0.005 //layer=m1 \
 //thickness=0.36 //x=16.715 //y=2.28 //x2=16.72 //y2=2.28
r580 (  12 18 ) resistor r=0.050788 //w=0.349 //l=0.185 //layer=m1 \
 //thickness=0.36 //x=16.715 //y=2.28 //x2=16.715 //y2=2.465
r581 (  11 35 ) resistor r=0.0172176 //w=0.363 //l=0.05 //layer=m1 \
 //thickness=0.36 //x=8.63 //y=2.29 //x2=8.58 //y2=2.29
r582 (  10 24 ) resistor r=0.138359 //w=0.131 //l=0.145 //layer=m1 \
 //thickness=0.36 //x=20.415 //y=4.62 //x2=20.415 //y2=4.765
r583 (  9 10 ) resistor r=0.706107 //w=0.131 //l=0.74 //layer=m1 \
 //thickness=0.36 //x=20.415 //y=3.88 //x2=20.415 //y2=4.62
r584 (  8 9 ) resistor r=0.353053 //w=0.131 //l=0.37 //layer=m1 \
 //thickness=0.36 //x=20.415 //y=3.51 //x2=20.415 //y2=3.88
r585 (  7 8 ) resistor r=0.353053 //w=0.131 //l=0.37 //layer=m1 \
 //thickness=0.36 //x=20.415 //y=3.14 //x2=20.415 //y2=3.51
r586 (  6 7 ) resistor r=0.353053 //w=0.131 //l=0.37 //layer=m1 \
 //thickness=0.36 //x=20.415 //y=2.77 //x2=20.415 //y2=3.14
r587 (  6 23 ) resistor r=0.243321 //w=0.131 //l=0.255 //layer=m1 \
 //thickness=0.36 //x=20.415 //y=2.77 //x2=20.415 //y2=2.515
r588 (  5 19 ) resistor r=1.18321 //w=0.131 //l=1.24 //layer=m1 \
 //thickness=0.36 //x=16.715 //y=3.51 //x2=16.715 //y2=4.75
r589 (  4 5 ) resistor r=0.353053 //w=0.131 //l=0.37 //layer=m1 \
 //thickness=0.36 //x=16.715 //y=3.14 //x2=16.715 //y2=3.51
r590 (  3 4 ) resistor r=0.353053 //w=0.131 //l=0.37 //layer=m1 \
 //thickness=0.36 //x=16.715 //y=2.77 //x2=16.715 //y2=3.14
r591 (  3 18 ) resistor r=0.291031 //w=0.131 //l=0.305 //layer=m1 \
 //thickness=0.36 //x=16.715 //y=2.77 //x2=16.715 //y2=2.465
r592 (  2 15 ) resistor r=1.53626 //w=0.131 //l=1.61 //layer=m1 \
 //thickness=0.36 //x=8.575 //y=3.14 //x2=8.575 //y2=4.75
r593 (  1 2 ) resistor r=0.353053 //w=0.131 //l=0.37 //layer=m1 \
 //thickness=0.36 //x=8.575 //y=2.77 //x2=8.575 //y2=3.14
r594 (  1 14 ) resistor r=0.271947 //w=0.131 //l=0.285 //layer=m1 \
 //thickness=0.36 //x=8.575 //y=2.77 //x2=8.575 //y2=2.485
ends PM_DFFRNQX1\%RN

subckt PM_DFFRNQX1\%noxref_6 ( 1 3 6 7 9 10 11 12 14 15 16 18 19 21 24 27 35 \
 39 41 44 45 52 54 55 58 66 74 91 100 104 105 106 107 108 109 110 114 116 119 \
 120 130 133 135 136 137 )
c276 ( 133 0 ) capacitor c=0.00885916f //x=21.59 //y=1.095
c277 ( 130 0 ) capacitor c=0.0682508f //x=24.115 //y=4.88
c278 ( 120 0 ) capacitor c=0.0318956f //x=24.45 //y=1.39
c279 ( 119 0 ) capacitor c=0.0186809f //x=24.45 //y=1.045
c280 ( 116 0 ) capacitor c=0.0141821f //x=24.295 //y=1.545
c281 ( 114 0 ) capacitor c=0.0158553f //x=24.295 //y=0.89
c282 ( 110 0 ) capacitor c=0.0854122f //x=23.92 //y=2.095
c283 ( 109 0 ) capacitor c=0.0229235f //x=23.92 //y=1.7
c284 ( 108 0 ) capacitor c=0.0234359f //x=23.92 //y=1.39
c285 ( 107 0 ) capacitor c=0.0198759f //x=23.92 //y=1.045
c286 ( 106 0 ) capacitor c=0.110369f //x=24.455 //y=6.2
c287 ( 105 0 ) capacitor c=0.154619f //x=24.015 //y=6.2
c288 ( 100 0 ) capacitor c=8.13425e-19 //x=24.115 //y=4.88
c289 ( 91 0 ) capacitor c=7.85889e-19 //x=24.115 //y=2.26
c290 ( 74 0 ) capacitor c=0.0293219f //x=21.485 //y=5.56
c291 ( 66 0 ) capacitor c=0.029137f //x=20.605 //y=5.56
c292 ( 58 0 ) capacitor c=0.0278099f //x=19.725 //y=5.56
c293 ( 55 0 ) capacitor c=0.0480796f //x=23.95 //y=3.495
c294 ( 54 0 ) capacitor c=0.00163754f //x=24.11 //y=3.495
c295 ( 52 0 ) capacitor c=0.00307192f //x=22.425 //y=3.495
c296 ( 45 0 ) capacitor c=0.0267119f //x=24.117 //y=4.74
c297 ( 44 0 ) capacitor c=0.00611632f //x=24.115 //y=4.88
c298 ( 41 0 ) capacitor c=0.00640017f //x=24.115 //y=2.26
c299 ( 39 0 ) capacitor c=0.0167165f //x=24.115 //y=3.51
c300 ( 35 0 ) capacitor c=0.0173242f //x=22.265 //y=3.51
c301 ( 27 0 ) capacitor c=9.35422e-19 //x=21.485 //y=5.335
c302 ( 24 0 ) capacitor c=0.00825613f //x=20.605 //y=5.335
c303 ( 21 0 ) capacitor c=0.0113499f //x=19.727 //y=5.335
c304 ( 19 0 ) capacitor c=0.0132863f //x=24.115 //y=3.655
c305 ( 18 0 ) capacitor c=0.0285574f //x=24.115 //y=3.335
c306 ( 16 0 ) capacitor c=0.0418595f //x=22.265 //y=5.25
c307 ( 15 0 ) capacitor c=0.0132331f //x=22.265 //y=3.655
c308 ( 14 0 ) capacitor c=0.0402951f //x=22.265 //y=3.335
c309 ( 12 0 ) capacitor c=0.00606427f //x=21.865 //y=1.845
c310 ( 11 0 ) capacitor c=0.0160443f //x=22.18 //y=1.845
c311 ( 10 0 ) capacitor c=0.0136149f //x=21.78 //y=1.76
c312 ( 9 0 ) capacitor c=0.0113465f //x=21.78 //y=1.305
c313 ( 7 0 ) capacitor c=0.0243322f //x=22.18 //y=5.335
c314 ( 6 0 ) capacitor c=0.00906713f //x=21.485 //y=5.56
c315 ( 3 0 ) capacitor c=0.0198833f //x=21.37 //y=5.335
c316 ( 1 0 ) capacitor c=0.0154206f //x=20.485 //y=5.335
r317 (  128 130 ) resistor r=20.6867 //w=0.233 //l=0.1 //layer=ply \
 //thickness=0.18 //x=24.015 //y=4.88 //x2=24.115 //y2=4.88
r318 (  121 130 ) resistor r=70.3348 //w=0.233 //l=0.414367 //layer=ply \
 //thickness=0.18 //x=24.455 //y=5.045 //x2=24.115 //y2=4.88
r319 (  120 132 ) resistor r=45.1352 //w=0.168 //l=0.173853 //layer=ply \
 //thickness=0.18 //x=24.45 //y=1.39 //x2=24.41 //y2=1.545
r320 (  119 131 ) resistor r=45.1352 //w=0.168 //l=0.173853 //layer=ply \
 //thickness=0.18 //x=24.45 //y=1.045 //x2=24.41 //y2=0.89
r321 (  119 120 ) resistor r=176.904 //w=0.094 //l=0.345 //layer=ply \
 //thickness=0.18 //x=24.45 //y=1.045 //x2=24.45 //y2=1.39
r322 (  117 127 ) resistor r=10.701 //w=0.21 //l=0.115 //layer=ply \
 //thickness=0.18 //x=24.075 //y=1.545 //x2=23.96 //y2=1.545
r323 (  116 132 ) resistor r=5.52526 //w=0.168 //l=0.115 //layer=ply \
 //thickness=0.18 //x=24.295 //y=1.545 //x2=24.41 //y2=1.545
r324 (  115 126 ) resistor r=5.52526 //w=0.168 //l=0.115 //layer=ply \
 //thickness=0.18 //x=24.075 //y=0.89 //x2=23.96 //y2=0.89
r325 (  114 131 ) resistor r=5.52526 //w=0.168 //l=0.115 //layer=ply \
 //thickness=0.18 //x=24.295 //y=0.89 //x2=24.41 //y2=0.89
r326 (  114 115 ) resistor r=112.809 //w=0.094 //l=0.22 //layer=ply \
 //thickness=0.18 //x=24.295 //y=0.89 //x2=24.075 //y2=0.89
r327 (  111 128 ) resistor r=13.0941 //w=0.233 //l=0.165 //layer=ply \
 //thickness=0.18 //x=24.015 //y=5.045 //x2=24.015 //y2=4.88
r328 (  110 125 ) resistor r=34.8111 //w=0.27 //l=0.264953 //layer=ply \
 //thickness=0.18 //x=23.92 //y=2.095 //x2=24.115 //y2=2.26
r329 (  109 127 ) resistor r=39.5823 //w=0.21 //l=0.173853 //layer=ply \
 //thickness=0.18 //x=23.92 //y=1.7 //x2=23.96 //y2=1.545
r330 (  109 110 ) resistor r=202.543 //w=0.094 //l=0.395 //layer=ply \
 //thickness=0.18 //x=23.92 //y=1.7 //x2=23.92 //y2=2.095
r331 (  108 127 ) resistor r=39.5823 //w=0.21 //l=0.173853 //layer=ply \
 //thickness=0.18 //x=23.92 //y=1.39 //x2=23.96 //y2=1.545
r332 (  107 126 ) resistor r=45.1352 //w=0.168 //l=0.173853 //layer=ply \
 //thickness=0.18 //x=23.92 //y=1.045 //x2=23.96 //y2=0.89
r333 (  107 108 ) resistor r=176.904 //w=0.094 //l=0.345 //layer=ply \
 //thickness=0.18 //x=23.92 //y=1.045 //x2=23.92 //y2=1.39
r334 (  106 121 ) resistor r=592.245 //w=0.094 //l=1.155 //layer=ply \
 //thickness=0.18 //x=24.455 //y=6.2 //x2=24.455 //y2=5.045
r335 (  105 111 ) resistor r=592.245 //w=0.094 //l=1.155 //layer=ply \
 //thickness=0.18 //x=24.015 //y=6.2 //x2=24.015 //y2=5.045
r336 (  104 116 ) resistor r=56.4043 //w=0.094 //l=0.11 //layer=ply \
 //thickness=0.18 //x=24.185 //y=1.545 //x2=24.295 //y2=1.545
r337 (  104 117 ) resistor r=56.4043 //w=0.094 //l=0.11 //layer=ply \
 //thickness=0.18 //x=24.185 //y=1.545 //x2=24.075 //y2=1.545
r338 (  100 130 ) resistor r=152 //w=0.17 //l=0.17 //layer=licon //count=1 \
 //x=24.115 //y=4.88 //x2=24.115 //y2=4.88
r339 (  91 125 ) resistor r=152 //w=0.17 //l=0.17 //layer=licon //count=1 \
 //x=24.115 //y=2.26 //x2=24.115 //y2=2.26
r340 (  74 137 ) resistor r=23.615 //w=0.187 //l=0.345 //layer=li \
 //thickness=0.1 //x=21.485 //y=5.56 //x2=21.485 //y2=5.905
r341 (  66 136 ) resistor r=23.615 //w=0.187 //l=0.345 //layer=li \
 //thickness=0.1 //x=20.605 //y=5.56 //x2=20.605 //y2=5.905
r342 (  58 135 ) resistor r=23.615 //w=0.187 //l=0.345 //layer=li \
 //thickness=0.1 //x=19.725 //y=5.56 //x2=19.725 //y2=5.905
r343 (  54 55 ) resistor r=0.10734 //w=0.281 //l=0.16 //layer=m2 \
 //thickness=0.36 //x=24.11 //y=3.495 //x2=23.95 //y2=3.495
r344 (  52 55 ) resistor r=1.45515 //w=0.131 //l=1.525 //layer=m2 \
 //thickness=0.36 //x=22.425 //y=3.51 //x2=23.95 //y2=3.51
r345 (  50 52 ) resistor r=0.10734 //w=0.281 //l=0.16 //layer=m2 \
 //thickness=0.36 //x=22.265 //y=3.495 //x2=22.425 //y2=3.495
r346 (  44 100 ) resistor r=9.3 //w=0.17 //l=0.17 //layer=mcon //count=1 \
 //x=24.115 //y=4.88 //x2=24.115 //y2=4.88
r347 (  44 45 ) resistor r=0.103207 //w=0.196 //l=0.14 //layer=m1 \
 //thickness=0.36 //x=24.117 //y=4.88 //x2=24.117 //y2=4.74
r348 (  41 91 ) resistor r=9.3 //w=0.17 //l=0.17 //layer=mcon //count=1 \
 //x=24.115 //y=2.26 //x2=24.115 //y2=2.26
r349 (  37 54 ) resistor r=4.5 //w=0.15 //l=0.15 //layer=via1 //count=1 \
 //x=24.11 //y=3.495 //x2=24.11 //y2=3.495
r350 (  37 39 ) resistor r=0.00501337 //w=0.374 //l=0.015 //layer=m1 \
 //thickness=0.36 //x=24.06 //y=3.495 //x2=24.06 //y2=3.51
r351 (  33 50 ) resistor r=4.5 //w=0.15 //l=0.15 //layer=via1 //count=1 \
 //x=22.265 //y=3.495 //x2=22.265 //y2=3.495
r352 (  33 35 ) resistor r=0.0049867 //w=0.376 //l=0.015 //layer=m1 \
 //thickness=0.36 //x=22.317 //y=3.495 //x2=22.317 //y2=3.51
r353 (  31 133 ) resistor r=9.3 //w=0.17 //l=0.17 //layer=mcon //count=1 \
 //x=21.78 //y=1.19 //x2=21.78 //y2=1.19
r354 (  29 74 ) resistor r=9.3 //w=0.17 //l=0.17 //layer=mcon //count=1 \
 //x=21.485 //y=5.56 //x2=21.485 //y2=5.56
r355 (  26 66 ) resistor r=9.3 //w=0.17 //l=0.17 //layer=mcon //count=1 \
 //x=20.605 //y=5.56 //x2=20.605 //y2=5.56
r356 (  24 26 ) resistor r=0.121228 //w=0.232 //l=0.225 //layer=m1 \
 //thickness=0.36 //x=20.605 //y=5.335 //x2=20.605 //y2=5.56
r357 (  23 58 ) resistor r=9.3 //w=0.17 //l=0.17 //layer=mcon //count=1 \
 //x=19.725 //y=5.56 //x2=19.725 //y2=5.56
r358 (  21 23 ) resistor r=0.129608 //w=0.217 //l=0.225 //layer=m1 \
 //thickness=0.36 //x=19.727 //y=5.335 //x2=19.727 //y2=5.56
r359 (  19 39 ) resistor r=0.0860668 //w=0.374 //l=0.170294 //layer=m1 \
 //thickness=0.36 //x=24.115 //y=3.655 //x2=24.06 //y2=3.51
r360 (  19 45 ) resistor r=1.03531 //w=0.131 //l=1.085 //layer=m1 \
 //thickness=0.36 //x=24.115 //y=3.655 //x2=24.115 //y2=4.74
r361 (  18 37 ) resistor r=0.0910802 //w=0.374 //l=0.185472 //layer=m1 \
 //thickness=0.36 //x=24.115 //y=3.335 //x2=24.06 //y2=3.495
r362 (  17 41 ) resistor r=0.0933015 //w=0.201 //l=0.125 //layer=m1 \
 //thickness=0.36 //x=24.115 //y=2.385 //x2=24.115 //y2=2.26
r363 (  17 18 ) resistor r=0.906489 //w=0.131 //l=0.95 //layer=m1 \
 //thickness=0.36 //x=24.115 //y=2.385 //x2=24.115 //y2=3.335
r364 (  15 35 ) resistor r=0.0861726 //w=0.376 //l=0.169012 //layer=m1 \
 //thickness=0.36 //x=22.265 //y=3.655 //x2=22.317 //y2=3.51
r365 (  15 16 ) resistor r=1.52195 //w=0.131 //l=1.595 //layer=m1 \
 //thickness=0.36 //x=22.265 //y=3.655 //x2=22.265 //y2=5.25
r366 (  14 33 ) resistor r=0.0911593 //w=0.376 //l=0.184174 //layer=m1 \
 //thickness=0.36 //x=22.265 //y=3.335 //x2=22.317 //y2=3.495
r367 (  13 14 ) resistor r=1.34065 //w=0.131 //l=1.405 //layer=m1 \
 //thickness=0.36 //x=22.265 //y=1.93 //x2=22.265 //y2=3.335
r368 (  11 13 ) resistor r=0.0698411 //w=0.17 //l=0.120208 //layer=m1 \
 //thickness=0.36 //x=22.18 //y=1.845 //x2=22.265 //y2=1.93
r369 (  11 12 ) resistor r=0.300573 //w=0.131 //l=0.315 //layer=m1 \
 //thickness=0.36 //x=22.18 //y=1.845 //x2=21.865 //y2=1.845
r370 (  10 12 ) resistor r=0.0698411 //w=0.17 //l=0.120208 //layer=m1 \
 //thickness=0.36 //x=21.78 //y=1.76 //x2=21.865 //y2=1.845
r371 (  9 31 ) resistor r=0.0717383 //w=0.224 //l=0.115 //layer=m1 \
 //thickness=0.36 //x=21.78 //y=1.305 //x2=21.78 //y2=1.19
r372 (  9 10 ) resistor r=0.43416 //w=0.131 //l=0.455 //layer=m1 \
 //thickness=0.36 //x=21.78 //y=1.305 //x2=21.78 //y2=1.76
r373 (  8 27 ) resistor r=0.0675342 //w=0.23 //l=0.115 //layer=m1 \
 //thickness=0.36 //x=21.6 //y=5.335 //x2=21.485 //y2=5.335
r374 (  7 16 ) resistor r=0.0698411 //w=0.17 //l=0.120208 //layer=m1 \
 //thickness=0.36 //x=22.18 //y=5.335 //x2=22.265 //y2=5.25
r375 (  7 8 ) resistor r=0.553435 //w=0.131 //l=0.58 //layer=m1 \
 //thickness=0.36 //x=22.18 //y=5.335 //x2=21.6 //y2=5.335
r376 (  6 29 ) resistor r=0.00118313 //w=0.23 //layer=m1 //thickness=0.36 \
 //x=21.485 //y=5.56 //x2=21.485 //y2=5.56
r377 (  5 27 ) resistor r=0.002872 //w=0.34 //l=0.085 //layer=m1 \
 //thickness=0.36 //x=21.485 //y=5.42 //x2=21.485 //y2=5.335
r378 (  5 6 ) resistor r=0.091623 //w=0.191 //l=0.14 //layer=m1 \
 //thickness=0.36 //x=21.485 //y=5.42 //x2=21.485 //y2=5.56
r379 (  4 24 ) resistor r=0.0262263 //w=0.232 //l=0.12 //layer=m1 \
 //thickness=0.36 //x=20.725 //y=5.335 //x2=20.605 //y2=5.335
r380 (  3 27 ) resistor r=0.0675342 //w=0.23 //l=0.115 //layer=m1 \
 //thickness=0.36 //x=21.37 //y=5.335 //x2=21.485 //y2=5.335
r381 (  3 4 ) resistor r=0.615458 //w=0.131 //l=0.645 //layer=m1 \
 //thickness=0.36 //x=21.37 //y=5.335 //x2=20.725 //y2=5.335
r382 (  2 21 ) resistor r=0.0222262 //w=0.217 //l=0.118 //layer=m1 \
 //thickness=0.36 //x=19.845 //y=5.335 //x2=19.727 //y2=5.335
r383 (  1 24 ) resistor r=0.0262263 //w=0.232 //l=0.12 //layer=m1 \
 //thickness=0.36 //x=20.485 //y=5.335 //x2=20.605 //y2=5.335
r384 (  1 2 ) resistor r=0.610687 //w=0.131 //l=0.64 //layer=m1 \
 //thickness=0.36 //x=20.485 //y=5.335 //x2=19.845 //y2=5.335
ends PM_DFFRNQX1\%noxref_6

subckt PM_DFFRNQX1\%noxref_7 ( 1 2 3 4 6 7 8 9 11 14 15 17 18 19 20 22 23 24 \
 26 27 28 34 38 41 46 49 52 58 62 66 71 73 75 77 79 80 81 82 86 94 103 108 117 \
 122 130 138 155 164 168 169 170 171 172 173 174 175 176 177 178 179 180 181 \
 183 189 190 191 192 196 197 198 203 205 207 213 214 215 216 217 222 224 226 \
 232 233 243 244 247 256 257 260 268 270 271 272 )
c610 ( 268 0 ) capacitor c=0.00885916f //x=16.78 //y=1.095
c611 ( 260 0 ) capacitor c=0.0358148f //x=24.885 //y=4.88
c612 ( 257 0 ) capacitor c=0.0284095f //x=24.855 //y=2.095
c613 ( 256 0 ) capacitor c=0.0476356f //x=24.855 //y=2.26
c614 ( 247 0 ) capacitor c=0.0354929f //x=11.935 //y=4.88
c615 ( 244 0 ) capacitor c=0.0284095f //x=11.905 //y=2.095
c616 ( 243 0 ) capacitor c=0.0476356f //x=11.905 //y=2.26
c617 ( 233 0 ) capacitor c=0.0439708f //x=25.42 //y=1.43
c618 ( 232 0 ) capacitor c=0.0192582f //x=25.42 //y=1.085
c619 ( 226 0 ) capacitor c=0.0162526f //x=25.265 //y=1.585
c620 ( 224 0 ) capacitor c=0.0157807f //x=25.265 //y=0.93
c621 ( 222 0 ) capacitor c=0.035926f //x=25.26 //y=4.97
c622 ( 217 0 ) capacitor c=0.0210762f //x=24.89 //y=1.74
c623 ( 216 0 ) capacitor c=0.0168511f //x=24.89 //y=1.43
c624 ( 215 0 ) capacitor c=0.0175485f //x=24.89 //y=1.085
c625 ( 214 0 ) capacitor c=0.0439708f //x=12.47 //y=1.43
c626 ( 213 0 ) capacitor c=0.0192582f //x=12.47 //y=1.085
c627 ( 207 0 ) capacitor c=0.0162526f //x=12.315 //y=1.585
c628 ( 205 0 ) capacitor c=0.0157807f //x=12.315 //y=0.93
c629 ( 203 0 ) capacitor c=0.0372668f //x=12.31 //y=4.97
c630 ( 198 0 ) capacitor c=0.0210762f //x=11.94 //y=1.74
c631 ( 197 0 ) capacitor c=0.0168511f //x=11.94 //y=1.43
c632 ( 196 0 ) capacitor c=0.0175485f //x=11.94 //y=1.085
c633 ( 192 0 ) capacitor c=0.0551642f //x=1.82 //y=4.97
c634 ( 191 0 ) capacitor c=0.0376642f //x=2.11 //y=4.97
c635 ( 190 0 ) capacitor c=0.0346489f //x=1.775 //y=1.4
c636 ( 189 0 ) capacitor c=0.018692f //x=1.775 //y=1.055
c637 ( 183 0 ) capacitor c=0.0137077f //x=1.62 //y=1.555
c638 ( 181 0 ) capacitor c=0.0158585f //x=1.62 //y=0.9
c639 ( 180 0 ) capacitor c=0.103534f //x=1.245 //y=2.095
c640 ( 179 0 ) capacitor c=0.0229444f //x=1.245 //y=1.71
c641 ( 178 0 ) capacitor c=0.0234359f //x=1.245 //y=1.4
c642 ( 177 0 ) capacitor c=0.019815f //x=1.245 //y=1.055
c643 ( 176 0 ) capacitor c=0.155269f //x=25.335 //y=6.2
c644 ( 175 0 ) capacitor c=0.110375f //x=24.895 //y=6.2
c645 ( 174 0 ) capacitor c=0.155269f //x=12.385 //y=6.2
c646 ( 173 0 ) capacitor c=0.110375f //x=11.945 //y=6.2
c647 ( 172 0 ) capacitor c=0.110208f //x=2.185 //y=6.2
c648 ( 171 0 ) capacitor c=0.158957f //x=1.745 //y=6.2
c649 ( 164 0 ) capacitor c=5.80994e-19 //x=24.885 //y=4.88
c650 ( 155 0 ) capacitor c=5.78095e-19 //x=24.855 //y=2.26
c651 ( 138 0 ) capacitor c=0.0293124f //x=16.675 //y=5.56
c652 ( 130 0 ) capacitor c=0.029137f //x=15.795 //y=5.56
c653 ( 122 0 ) capacitor c=0.0277605f //x=14.915 //y=5.56
c654 ( 117 0 ) capacitor c=5.80994e-19 //x=11.935 //y=4.88
c655 ( 108 0 ) capacitor c=5.78095e-19 //x=11.905 //y=2.26
c656 ( 103 0 ) capacitor c=0.00120653f //x=1.545 //y=4.88
c657 ( 94 0 ) capacitor c=0.0012618f //x=1.545 //y=2.26
c658 ( 86 0 ) capacitor c=0.0109595f //x=1.705 //y=4.26
c659 ( 82 0 ) capacitor c=0.0547f //x=19.165 //y=4.265
c660 ( 81 0 ) capacitor c=0.163267f //x=19.51 //y=4.265
c661 ( 80 0 ) capacitor c=0.0519971f //x=12.07 //y=4.25
c662 ( 79 0 ) capacitor c=0.0706046f //x=17.3 //y=4.25
c663 ( 77 0 ) capacitor c=0.00150627f //x=6.575 //y=4.265
c664 ( 75 0 ) capacitor c=0.0170341f //x=5.975 //y=4.25
c665 ( 73 0 ) capacitor c=0.00487194f //x=4.76 //y=4.27
c666 ( 71 0 ) capacitor c=0.0809012f //x=4.12 //y=4.25
c667 ( 66 0 ) capacitor c=0.00661943f //x=24.855 //y=2.26
c668 ( 62 0 ) capacitor c=0.0143744f //x=24.855 //y=4.25
c669 ( 58 0 ) capacitor c=0.0152032f //x=17.455 //y=4.25
c670 ( 52 0 ) capacitor c=0.00118259f //x=16.675 //y=5.335
c671 ( 49 0 ) capacitor c=0.00758117f //x=15.795 //y=5.335
c672 ( 46 0 ) capacitor c=0.0112819f //x=14.917 //y=5.335
c673 ( 41 0 ) capacitor c=0.00504845f //x=11.905 //y=2.26
c674 ( 38 0 ) capacitor c=0.0141348f //x=11.905 //y=4.25
c675 ( 34 0 ) capacitor c=0.0160313f //x=1.545 //y=4.25
c676 ( 28 0 ) capacitor c=0.00983657f //x=24.855 //y=4.735
c677 ( 27 0 ) capacitor c=0.00938877f //x=24.855 //y=4.415
c678 ( 26 0 ) capacitor c=0.0379693f //x=24.855 //y=4.095
c679 ( 24 0 ) capacitor c=0.0221841f //x=17.455 //y=5.25
c680 ( 23 0 ) capacitor c=0.0126978f //x=17.455 //y=4.415
c681 ( 22 0 ) capacitor c=0.0663769f //x=17.455 //y=4.095
c682 ( 20 0 ) capacitor c=0.00493487f //x=17.055 //y=1.845
c683 ( 19 0 ) capacitor c=0.0134344f //x=17.37 //y=1.845
c684 ( 18 0 ) capacitor c=0.0167333f //x=16.97 //y=1.76
c685 ( 17 0 ) capacitor c=0.0111392f //x=16.97 //y=1.305
c686 ( 15 0 ) capacitor c=0.0240505f //x=17.37 //y=5.335
c687 ( 14 0 ) capacitor c=0.00933983f //x=16.675 //y=5.56
c688 ( 11 0 ) capacitor c=0.0200404f //x=16.56 //y=5.335
c689 ( 9 0 ) capacitor c=0.0147103f //x=15.675 //y=5.335
c690 ( 8 0 ) capacitor c=0.00917813f //x=11.905 //y=4.735
c691 ( 7 0 ) capacitor c=0.00994911f //x=11.905 //y=4.41
c692 ( 6 0 ) capacitor c=0.0360742f //x=11.905 //y=4.09
c693 ( 4 0 ) capacitor c=0.0226005f //x=1.545 //y=4.755
c694 ( 3 0 ) capacitor c=0.0130233f //x=1.545 //y=4.42
c695 ( 2 0 ) capacitor c=0.0864232f //x=1.545 //y=4.1
c696 ( 1 0 ) capacitor c=0.011342f //x=1.545 //y=2.375
r697 (  262 263 ) resistor r=32.4568 //w=0.214 //l=0.075 //layer=ply \
 //thickness=0.18 //x=24.885 //y=4.97 //x2=24.885 //y2=5.045
r698 (  260 262 ) resistor r=20.271 //w=0.214 //l=0.09 //layer=ply \
 //thickness=0.18 //x=24.885 //y=4.88 //x2=24.885 //y2=4.97
r699 (  256 257 ) resistor r=52.7279 //w=0.214 //l=0.165 //layer=ply \
 //thickness=0.18 //x=24.855 //y=2.26 //x2=24.855 //y2=2.095
r700 (  249 250 ) resistor r=32.4568 //w=0.214 //l=0.075 //layer=ply \
 //thickness=0.18 //x=11.935 //y=4.97 //x2=11.935 //y2=5.045
r701 (  247 249 ) resistor r=20.271 //w=0.214 //l=0.09 //layer=ply \
 //thickness=0.18 //x=11.935 //y=4.88 //x2=11.935 //y2=4.97
r702 (  243 244 ) resistor r=52.7279 //w=0.214 //l=0.165 //layer=ply \
 //thickness=0.18 //x=11.905 //y=2.26 //x2=11.905 //y2=2.095
r703 (  233 267 ) resistor r=45.1352 //w=0.168 //l=0.173853 //layer=ply \
 //thickness=0.18 //x=25.42 //y=1.43 //x2=25.38 //y2=1.585
r704 (  232 266 ) resistor r=45.1352 //w=0.168 //l=0.173853 //layer=ply \
 //thickness=0.18 //x=25.42 //y=1.085 //x2=25.38 //y2=0.93
r705 (  232 233 ) resistor r=176.904 //w=0.094 //l=0.345 //layer=ply \
 //thickness=0.18 //x=25.42 //y=1.085 //x2=25.42 //y2=1.43
r706 (  227 265 ) resistor r=10.701 //w=0.21 //l=0.115 //layer=ply \
 //thickness=0.18 //x=25.045 //y=1.585 //x2=24.93 //y2=1.585
r707 (  226 267 ) resistor r=5.52526 //w=0.168 //l=0.115 //layer=ply \
 //thickness=0.18 //x=25.265 //y=1.585 //x2=25.38 //y2=1.585
r708 (  225 264 ) resistor r=5.52526 //w=0.168 //l=0.115 //layer=ply \
 //thickness=0.18 //x=25.045 //y=0.93 //x2=24.93 //y2=0.93
r709 (  224 266 ) resistor r=5.52526 //w=0.168 //l=0.115 //layer=ply \
 //thickness=0.18 //x=25.265 //y=0.93 //x2=25.38 //y2=0.93
r710 (  224 225 ) resistor r=112.809 //w=0.094 //l=0.22 //layer=ply \
 //thickness=0.18 //x=25.265 //y=0.93 //x2=25.045 //y2=0.93
r711 (  223 262 ) resistor r=16.5046 //w=0.27 //l=0.135 //layer=ply \
 //thickness=0.18 //x=25.02 //y=4.97 //x2=24.885 //y2=4.97
r712 (  222 229 ) resistor r=26.9307 //w=0.15 //l=0.106066 //layer=ply \
 //thickness=0.18 //x=25.26 //y=4.97 //x2=25.335 //y2=5.045
r713 (  222 223 ) resistor r=123.064 //w=0.094 //l=0.24 //layer=ply \
 //thickness=0.18 //x=25.26 //y=4.97 //x2=25.02 //y2=4.97
r714 (  217 265 ) resistor r=39.5823 //w=0.21 //l=0.173853 //layer=ply \
 //thickness=0.18 //x=24.89 //y=1.74 //x2=24.93 //y2=1.585
r715 (  217 257 ) resistor r=182.032 //w=0.094 //l=0.355 //layer=ply \
 //thickness=0.18 //x=24.89 //y=1.74 //x2=24.89 //y2=2.095
r716 (  216 265 ) resistor r=39.5823 //w=0.21 //l=0.173853 //layer=ply \
 //thickness=0.18 //x=24.89 //y=1.43 //x2=24.93 //y2=1.585
r717 (  215 264 ) resistor r=45.1352 //w=0.168 //l=0.173853 //layer=ply \
 //thickness=0.18 //x=24.89 //y=1.085 //x2=24.93 //y2=0.93
r718 (  215 216 ) resistor r=176.904 //w=0.094 //l=0.345 //layer=ply \
 //thickness=0.18 //x=24.89 //y=1.085 //x2=24.89 //y2=1.43
r719 (  214 254 ) resistor r=45.1352 //w=0.168 //l=0.173853 //layer=ply \
 //thickness=0.18 //x=12.47 //y=1.43 //x2=12.43 //y2=1.585
r720 (  213 253 ) resistor r=45.1352 //w=0.168 //l=0.173853 //layer=ply \
 //thickness=0.18 //x=12.47 //y=1.085 //x2=12.43 //y2=0.93
r721 (  213 214 ) resistor r=176.904 //w=0.094 //l=0.345 //layer=ply \
 //thickness=0.18 //x=12.47 //y=1.085 //x2=12.47 //y2=1.43
r722 (  208 252 ) resistor r=10.701 //w=0.21 //l=0.115 //layer=ply \
 //thickness=0.18 //x=12.095 //y=1.585 //x2=11.98 //y2=1.585
r723 (  207 254 ) resistor r=5.52526 //w=0.168 //l=0.115 //layer=ply \
 //thickness=0.18 //x=12.315 //y=1.585 //x2=12.43 //y2=1.585
r724 (  206 251 ) resistor r=5.52526 //w=0.168 //l=0.115 //layer=ply \
 //thickness=0.18 //x=12.095 //y=0.93 //x2=11.98 //y2=0.93
r725 (  205 253 ) resistor r=5.52526 //w=0.168 //l=0.115 //layer=ply \
 //thickness=0.18 //x=12.315 //y=0.93 //x2=12.43 //y2=0.93
r726 (  205 206 ) resistor r=112.809 //w=0.094 //l=0.22 //layer=ply \
 //thickness=0.18 //x=12.315 //y=0.93 //x2=12.095 //y2=0.93
r727 (  204 249 ) resistor r=16.5046 //w=0.27 //l=0.135 //layer=ply \
 //thickness=0.18 //x=12.07 //y=4.97 //x2=11.935 //y2=4.97
r728 (  203 210 ) resistor r=26.9307 //w=0.15 //l=0.106066 //layer=ply \
 //thickness=0.18 //x=12.31 //y=4.97 //x2=12.385 //y2=5.045
r729 (  203 204 ) resistor r=123.064 //w=0.094 //l=0.24 //layer=ply \
 //thickness=0.18 //x=12.31 //y=4.97 //x2=12.07 //y2=4.97
r730 (  198 252 ) resistor r=39.5823 //w=0.21 //l=0.173853 //layer=ply \
 //thickness=0.18 //x=11.94 //y=1.74 //x2=11.98 //y2=1.585
r731 (  198 244 ) resistor r=182.032 //w=0.094 //l=0.355 //layer=ply \
 //thickness=0.18 //x=11.94 //y=1.74 //x2=11.94 //y2=2.095
r732 (  197 252 ) resistor r=39.5823 //w=0.21 //l=0.173853 //layer=ply \
 //thickness=0.18 //x=11.94 //y=1.43 //x2=11.98 //y2=1.585
r733 (  196 251 ) resistor r=45.1352 //w=0.168 //l=0.173853 //layer=ply \
 //thickness=0.18 //x=11.94 //y=1.085 //x2=11.98 //y2=0.93
r734 (  196 197 ) resistor r=176.904 //w=0.094 //l=0.345 //layer=ply \
 //thickness=0.18 //x=11.94 //y=1.085 //x2=11.94 //y2=1.43
r735 (  191 193 ) resistor r=26.9307 //w=0.15 //l=0.106066 //layer=ply \
 //thickness=0.18 //x=2.11 //y=4.97 //x2=2.185 //y2=5.045
r736 (  191 192 ) resistor r=148.702 //w=0.094 //l=0.29 //layer=ply \
 //thickness=0.18 //x=2.11 //y=4.97 //x2=1.82 //y2=4.97
r737 (  190 241 ) resistor r=45.1352 //w=0.168 //l=0.173853 //layer=ply \
 //thickness=0.18 //x=1.775 //y=1.4 //x2=1.735 //y2=1.555
r738 (  189 240 ) resistor r=45.1352 //w=0.168 //l=0.173853 //layer=ply \
 //thickness=0.18 //x=1.775 //y=1.055 //x2=1.735 //y2=0.9
r739 (  189 190 ) resistor r=176.904 //w=0.094 //l=0.345 //layer=ply \
 //thickness=0.18 //x=1.775 //y=1.055 //x2=1.775 //y2=1.4
r740 (  186 192 ) resistor r=22.7971 //w=0.269 //l=0.106066 //layer=ply \
 //thickness=0.18 //x=1.745 //y=5.045 //x2=1.82 //y2=4.97
r741 (  186 239 ) resistor r=35.8364 //w=0.269 //l=0.270185 //layer=ply \
 //thickness=0.18 //x=1.745 //y=5.045 //x2=1.545 //y2=4.88
r742 (  184 235 ) resistor r=10.701 //w=0.21 //l=0.115 //layer=ply \
 //thickness=0.18 //x=1.4 //y=1.555 //x2=1.285 //y2=1.555
r743 (  183 241 ) resistor r=5.52526 //w=0.168 //l=0.115 //layer=ply \
 //thickness=0.18 //x=1.62 //y=1.555 //x2=1.735 //y2=1.555
r744 (  182 234 ) resistor r=5.52526 //w=0.168 //l=0.115 //layer=ply \
 //thickness=0.18 //x=1.4 //y=0.9 //x2=1.285 //y2=0.9
r745 (  181 240 ) resistor r=5.52526 //w=0.168 //l=0.115 //layer=ply \
 //thickness=0.18 //x=1.62 //y=0.9 //x2=1.735 //y2=0.9
r746 (  181 182 ) resistor r=112.809 //w=0.094 //l=0.22 //layer=ply \
 //thickness=0.18 //x=1.62 //y=0.9 //x2=1.4 //y2=0.9
r747 (  180 237 ) resistor r=58.7805 //w=0.246 //l=0.373497 //layer=ply \
 //thickness=0.18 //x=1.245 //y=2.095 //x2=1.545 //y2=2.26
r748 (  179 235 ) resistor r=39.5823 //w=0.21 //l=0.173853 //layer=ply \
 //thickness=0.18 //x=1.245 //y=1.71 //x2=1.285 //y2=1.555
r749 (  179 180 ) resistor r=197.415 //w=0.094 //l=0.385 //layer=ply \
 //thickness=0.18 //x=1.245 //y=1.71 //x2=1.245 //y2=2.095
r750 (  178 235 ) resistor r=39.5823 //w=0.21 //l=0.173853 //layer=ply \
 //thickness=0.18 //x=1.245 //y=1.4 //x2=1.285 //y2=1.555
r751 (  177 234 ) resistor r=45.1352 //w=0.168 //l=0.173853 //layer=ply \
 //thickness=0.18 //x=1.245 //y=1.055 //x2=1.285 //y2=0.9
r752 (  177 178 ) resistor r=176.904 //w=0.094 //l=0.345 //layer=ply \
 //thickness=0.18 //x=1.245 //y=1.055 //x2=1.245 //y2=1.4
r753 (  176 229 ) resistor r=592.245 //w=0.094 //l=1.155 //layer=ply \
 //thickness=0.18 //x=25.335 //y=6.2 //x2=25.335 //y2=5.045
r754 (  175 263 ) resistor r=592.245 //w=0.094 //l=1.155 //layer=ply \
 //thickness=0.18 //x=24.895 //y=6.2 //x2=24.895 //y2=5.045
r755 (  174 210 ) resistor r=592.245 //w=0.094 //l=1.155 //layer=ply \
 //thickness=0.18 //x=12.385 //y=6.2 //x2=12.385 //y2=5.045
r756 (  173 250 ) resistor r=592.245 //w=0.094 //l=1.155 //layer=ply \
 //thickness=0.18 //x=11.945 //y=6.2 //x2=11.945 //y2=5.045
r757 (  172 193 ) resistor r=592.245 //w=0.094 //l=1.155 //layer=ply \
 //thickness=0.18 //x=2.185 //y=6.2 //x2=2.185 //y2=5.045
r758 (  171 186 ) resistor r=592.245 //w=0.094 //l=1.155 //layer=ply \
 //thickness=0.18 //x=1.745 //y=6.2 //x2=1.745 //y2=5.045
r759 (  170 226 ) resistor r=56.4043 //w=0.094 //l=0.11 //layer=ply \
 //thickness=0.18 //x=25.155 //y=1.585 //x2=25.265 //y2=1.585
r760 (  170 227 ) resistor r=56.4043 //w=0.094 //l=0.11 //layer=ply \
 //thickness=0.18 //x=25.155 //y=1.585 //x2=25.045 //y2=1.585
r761 (  169 207 ) resistor r=56.4043 //w=0.094 //l=0.11 //layer=ply \
 //thickness=0.18 //x=12.205 //y=1.585 //x2=12.315 //y2=1.585
r762 (  169 208 ) resistor r=56.4043 //w=0.094 //l=0.11 //layer=ply \
 //thickness=0.18 //x=12.205 //y=1.585 //x2=12.095 //y2=1.585
r763 (  168 183 ) resistor r=56.4043 //w=0.094 //l=0.11 //layer=ply \
 //thickness=0.18 //x=1.51 //y=1.555 //x2=1.62 //y2=1.555
r764 (  168 184 ) resistor r=56.4043 //w=0.094 //l=0.11 //layer=ply \
 //thickness=0.18 //x=1.51 //y=1.555 //x2=1.4 //y2=1.555
r765 (  164 260 ) resistor r=152 //w=0.17 //l=0.17 //layer=licon //count=1 \
 //x=24.885 //y=4.88 //x2=24.885 //y2=4.88
r766 (  155 256 ) resistor r=152 //w=0.17 //l=0.17 //layer=licon //count=1 \
 //x=24.855 //y=2.26 //x2=24.855 //y2=2.26
r767 (  138 272 ) resistor r=23.615 //w=0.187 //l=0.345 //layer=li \
 //thickness=0.1 //x=16.675 //y=5.56 //x2=16.675 //y2=5.905
r768 (  130 271 ) resistor r=23.615 //w=0.187 //l=0.345 //layer=li \
 //thickness=0.1 //x=15.795 //y=5.56 //x2=15.795 //y2=5.905
r769 (  122 270 ) resistor r=23.615 //w=0.187 //l=0.345 //layer=li \
 //thickness=0.1 //x=14.915 //y=5.56 //x2=14.915 //y2=5.905
r770 (  117 247 ) resistor r=152 //w=0.17 //l=0.17 //layer=licon //count=1 \
 //x=11.935 //y=4.88 //x2=11.935 //y2=4.88
r771 (  108 243 ) resistor r=152 //w=0.17 //l=0.17 //layer=licon //count=1 \
 //x=11.905 //y=2.26 //x2=11.905 //y2=2.26
r772 (  103 239 ) resistor r=152 //w=0.17 //l=0.17 //layer=licon //count=1 \
 //x=1.545 //y=4.88 //x2=1.545 //y2=4.88
r773 (  94 237 ) resistor r=152 //w=0.17 //l=0.17 //layer=licon //count=1 \
 //x=1.545 //y=2.26 //x2=1.545 //y2=2.26
r774 (  84 86 ) resistor r=0.10734 //w=0.281 //l=0.16 //layer=m2 \
 //thickness=0.36 //x=1.545 //y=4.26 //x2=1.705 //y2=4.26
r775 (  82 90 ) resistor r=1.08991 //w=0.196 //l=1.70999 //layer=m2 \
 //thickness=0.36 //x=19.165 //y=4.265 //x2=17.46 //y2=4.255
r776 (  81 92 ) resistor r=3.726 //w=0.179 //l=5.34 //layer=m2 \
 //thickness=0.36 //x=19.51 //y=4.265 //x2=24.845 //y2=4.255
r777 (  81 82 ) resistor r=0.329198 //w=0.131 //l=0.345 //layer=m2 \
 //thickness=0.36 //x=19.51 //y=4.265 //x2=19.165 //y2=4.265
r778 (  80 88 ) resistor r=0.112172 //w=0.179 //l=0.16 //layer=m2 \
 //thickness=0.36 //x=12.07 //y=4.25 //x2=11.91 //y2=4.25
r779 (  79 90 ) resistor r=0.104578 //w=0.196 //l=0.162481 //layer=m2 \
 //thickness=0.36 //x=17.3 //y=4.25 //x2=17.46 //y2=4.255
r780 (  79 80 ) resistor r=4.99046 //w=0.131 //l=5.23 //layer=m2 \
 //thickness=0.36 //x=17.3 //y=4.25 //x2=12.07 //y2=4.25
r781 (  77 88 ) resistor r=3.726 //w=0.179 //l=5.34249 //layer=m2 \
 //thickness=0.36 //x=6.575 //y=4.265 //x2=11.91 //y2=4.25
r782 (  77 78 ) resistor r=0.329198 //w=0.131 //l=0.345 //layer=m2 \
 //thickness=0.36 //x=6.575 //y=4.265 //x2=6.23 //y2=4.265
r783 (  75 78 ) resistor r=0.1875 //w=0.17 //l=0.262393 //layer=m2 \
 //thickness=0.36 //x=5.975 //y=4.25 //x2=6.23 //y2=4.265
r784 (  75 76 ) resistor r=0.997137 //w=0.131 //l=1.045 //layer=m2 \
 //thickness=0.36 //x=5.975 //y=4.25 //x2=4.93 //y2=4.25
r785 (  73 76 ) resistor r=0.125 //w=0.17 //l=0.179722 //layer=m2 \
 //thickness=0.36 //x=4.76 //y=4.27 //x2=4.93 //y2=4.25
r786 (  73 74 ) resistor r=0.367366 //w=0.131 //l=0.385 //layer=m2 \
 //thickness=0.36 //x=4.76 //y=4.27 //x2=4.375 //y2=4.27
r787 (  71 74 ) resistor r=0.1875 //w=0.17 //l=0.264811 //layer=m2 \
 //thickness=0.36 //x=4.12 //y=4.25 //x2=4.375 //y2=4.27
r788 (  71 86 ) resistor r=2.30439 //w=0.131 //l=2.415 //layer=m2 \
 //thickness=0.36 //x=4.12 //y=4.25 //x2=1.705 //y2=4.25
r789 (  70 164 ) resistor r=9.3 //w=0.17 //l=0.17 //layer=mcon //count=1 \
 //x=24.885 //y=4.88 //x2=24.885 //y2=4.88
r790 (  66 155 ) resistor r=9.3 //w=0.17 //l=0.17 //layer=mcon //count=1 \
 //x=24.855 //y=2.26 //x2=24.855 //y2=2.26
r791 (  66 68 ) resistor r=0.0936408 //w=0.196 //l=0.125 //layer=m1 \
 //thickness=0.36 //x=24.857 //y=2.26 //x2=24.857 //y2=2.385
r792 (  64 92 ) resistor r=4.5 //w=0.15 //l=0.15 //layer=via1 //count=1 \
 //x=24.845 //y=4.255 //x2=24.845 //y2=4.255
r793 (  62 64 ) resistor r=0.00168464 //w=0.371 //l=0.005 //layer=m1 \
 //thickness=0.36 //x=24.797 //y=4.25 //x2=24.797 //y2=4.255
r794 (  60 90 ) resistor r=4.5 //w=0.15 //l=0.15 //layer=via1 //count=1 \
 //x=17.46 //y=4.255 //x2=17.46 //y2=4.255
r795 (  58 60 ) resistor r=0.00164908 //w=0.379 //l=0.005 //layer=m1 \
 //thickness=0.36 //x=17.405 //y=4.25 //x2=17.405 //y2=4.255
r796 (  56 268 ) resistor r=9.3 //w=0.17 //l=0.17 //layer=mcon //count=1 \
 //x=16.97 //y=1.19 //x2=16.97 //y2=1.19
r797 (  54 138 ) resistor r=9.3 //w=0.17 //l=0.17 //layer=mcon //count=1 \
 //x=16.675 //y=5.56 //x2=16.675 //y2=5.56
r798 (  51 130 ) resistor r=9.3 //w=0.17 //l=0.17 //layer=mcon //count=1 \
 //x=15.795 //y=5.56 //x2=15.795 //y2=5.56
r799 (  49 51 ) resistor r=0.121228 //w=0.232 //l=0.225 //layer=m1 \
 //thickness=0.36 //x=15.795 //y=5.335 //x2=15.795 //y2=5.56
r800 (  48 122 ) resistor r=9.3 //w=0.17 //l=0.17 //layer=mcon //count=1 \
 //x=14.915 //y=5.56 //x2=14.915 //y2=5.56
r801 (  46 48 ) resistor r=0.129608 //w=0.217 //l=0.225 //layer=m1 \
 //thickness=0.36 //x=14.917 //y=5.335 //x2=14.917 //y2=5.56
r802 (  45 117 ) resistor r=9.3 //w=0.17 //l=0.17 //layer=mcon //count=1 \
 //x=11.935 //y=4.88 //x2=11.935 //y2=4.88
r803 (  41 108 ) resistor r=9.3 //w=0.17 //l=0.17 //layer=mcon //count=1 \
 //x=11.905 //y=2.26 //x2=11.905 //y2=2.26
r804 (  41 43 ) resistor r=0.0936408 //w=0.196 //l=0.125 //layer=m1 \
 //thickness=0.36 //x=11.907 //y=2.26 //x2=11.907 //y2=2.385
r805 (  38 88 ) resistor r=4.5 //w=0.15 //l=0.15 //layer=via1 //count=1 \
 //x=11.91 //y=4.25 //x2=11.91 //y2=4.25
r806 (  36 84 ) resistor r=4.5 //w=0.15 //l=0.15 //layer=via1 //count=1 \
 //x=1.545 //y=4.26 //x2=1.545 //y2=4.26
r807 (  34 36 ) resistor r=0.00332447 //w=0.376 //l=0.01 //layer=m1 \
 //thickness=0.36 //x=1.597 //y=4.25 //x2=1.597 //y2=4.26
r808 (  32 103 ) resistor r=9.3 //w=0.17 //l=0.17 //layer=mcon //count=1 \
 //x=1.545 //y=4.88 //x2=1.545 //y2=4.88
r809 (  30 94 ) resistor r=9.3 //w=0.17 //l=0.17 //layer=mcon //count=1 \
 //x=1.545 //y=2.26 //x2=1.545 //y2=2.26
r810 (  28 70 ) resistor r=0.0878548 //w=0.228 //l=0.159295 //layer=m1 \
 //thickness=0.36 //x=24.855 //y=4.735 //x2=24.885 //y2=4.88
r811 (  27 64 ) resistor r=0.0909648 //w=0.371 //l=0.186762 //layer=m1 \
 //thickness=0.36 //x=24.855 //y=4.415 //x2=24.797 //y2=4.255
r812 (  27 28 ) resistor r=0.305344 //w=0.131 //l=0.32 //layer=m1 \
 //thickness=0.36 //x=24.855 //y=4.415 //x2=24.855 //y2=4.735
r813 (  26 62 ) resistor r=0.0892801 //w=0.371 //l=0.1817 //layer=m1 \
 //thickness=0.36 //x=24.855 //y=4.095 //x2=24.797 //y2=4.25
r814 (  26 68 ) resistor r=1.63168 //w=0.131 //l=1.71 //layer=m1 \
 //thickness=0.36 //x=24.855 //y=4.095 //x2=24.855 //y2=2.385
r815 (  23 60 ) resistor r=0.0912814 //w=0.379 //l=0.183303 //layer=m1 \
 //thickness=0.36 //x=17.455 //y=4.415 //x2=17.405 //y2=4.255
r816 (  23 24 ) resistor r=0.796756 //w=0.131 //l=0.835 //layer=m1 \
 //thickness=0.36 //x=17.455 //y=4.415 //x2=17.455 //y2=5.25
r817 (  22 58 ) resistor r=0.0896323 //w=0.379 //l=0.178255 //layer=m1 \
 //thickness=0.36 //x=17.455 //y=4.095 //x2=17.405 //y2=4.25
r818 (  21 22 ) resistor r=2.06584 //w=0.131 //l=2.165 //layer=m1 \
 //thickness=0.36 //x=17.455 //y=1.93 //x2=17.455 //y2=4.095
r819 (  19 21 ) resistor r=0.0698411 //w=0.17 //l=0.120208 //layer=m1 \
 //thickness=0.36 //x=17.37 //y=1.845 //x2=17.455 //y2=1.93
r820 (  19 20 ) resistor r=0.300573 //w=0.131 //l=0.315 //layer=m1 \
 //thickness=0.36 //x=17.37 //y=1.845 //x2=17.055 //y2=1.845
r821 (  18 20 ) resistor r=0.0698411 //w=0.17 //l=0.120208 //layer=m1 \
 //thickness=0.36 //x=16.97 //y=1.76 //x2=17.055 //y2=1.845
r822 (  17 56 ) resistor r=0.0717383 //w=0.224 //l=0.115 //layer=m1 \
 //thickness=0.36 //x=16.97 //y=1.305 //x2=16.97 //y2=1.19
r823 (  17 18 ) resistor r=0.43416 //w=0.131 //l=0.455 //layer=m1 \
 //thickness=0.36 //x=16.97 //y=1.305 //x2=16.97 //y2=1.76
r824 (  16 52 ) resistor r=0.0675342 //w=0.23 //l=0.115 //layer=m1 \
 //thickness=0.36 //x=16.79 //y=5.335 //x2=16.675 //y2=5.335
r825 (  15 24 ) resistor r=0.0698411 //w=0.17 //l=0.120208 //layer=m1 \
 //thickness=0.36 //x=17.37 //y=5.335 //x2=17.455 //y2=5.25
r826 (  15 16 ) resistor r=0.553435 //w=0.131 //l=0.58 //layer=m1 \
 //thickness=0.36 //x=17.37 //y=5.335 //x2=16.79 //y2=5.335
r827 (  14 54 ) resistor r=0.00118313 //w=0.23 //layer=m1 //thickness=0.36 \
 //x=16.675 //y=5.56 //x2=16.675 //y2=5.56
r828 (  13 52 ) resistor r=0.002872 //w=0.34 //l=0.085 //layer=m1 \
 //thickness=0.36 //x=16.675 //y=5.42 //x2=16.675 //y2=5.335
r829 (  13 14 ) resistor r=0.091623 //w=0.191 //l=0.14 //layer=m1 \
 //thickness=0.36 //x=16.675 //y=5.42 //x2=16.675 //y2=5.56
r830 (  12 49 ) resistor r=0.0262263 //w=0.232 //l=0.12 //layer=m1 \
 //thickness=0.36 //x=15.915 //y=5.335 //x2=15.795 //y2=5.335
r831 (  11 52 ) resistor r=0.0675342 //w=0.23 //l=0.115 //layer=m1 \
 //thickness=0.36 //x=16.56 //y=5.335 //x2=16.675 //y2=5.335
r832 (  11 12 ) resistor r=0.615458 //w=0.131 //l=0.645 //layer=m1 \
 //thickness=0.36 //x=16.56 //y=5.335 //x2=15.915 //y2=5.335
r833 (  10 46 ) resistor r=0.0222262 //w=0.217 //l=0.118 //layer=m1 \
 //thickness=0.36 //x=15.035 //y=5.335 //x2=14.917 //y2=5.335
r834 (  9 49 ) resistor r=0.0262263 //w=0.232 //l=0.12 //layer=m1 \
 //thickness=0.36 //x=15.675 //y=5.335 //x2=15.795 //y2=5.335
r835 (  9 10 ) resistor r=0.610687 //w=0.131 //l=0.64 //layer=m1 \
 //thickness=0.36 //x=15.675 //y=5.335 //x2=15.035 //y2=5.335
r836 (  8 45 ) resistor r=0.0878548 //w=0.228 //l=0.159295 //layer=m1 \
 //thickness=0.36 //x=11.905 //y=4.735 //x2=11.935 //y2=4.88
r837 (  7 38 ) resistor r=0.0912814 //w=0.379 //l=0.183303 //layer=m1 \
 //thickness=0.36 //x=11.905 //y=4.41 //x2=11.855 //y2=4.25
r838 (  7 8 ) resistor r=0.310115 //w=0.131 //l=0.325 //layer=m1 \
 //thickness=0.36 //x=11.905 //y=4.41 //x2=11.905 //y2=4.735
r839 (  6 38 ) resistor r=0.0912814 //w=0.379 //l=0.183303 //layer=m1 \
 //thickness=0.36 //x=11.905 //y=4.09 //x2=11.855 //y2=4.25
r840 (  6 43 ) resistor r=1.62691 //w=0.131 //l=1.705 //layer=m1 \
 //thickness=0.36 //x=11.905 //y=4.09 //x2=11.905 //y2=2.385
r841 (  4 32 ) resistor r=0.0760407 //w=0.238 //l=0.125 //layer=m1 \
 //thickness=0.36 //x=1.545 //y=4.755 //x2=1.545 //y2=4.88
r842 (  3 36 ) resistor r=0.0911593 //w=0.376 //l=0.184174 //layer=m1 \
 //thickness=0.36 //x=1.545 //y=4.42 //x2=1.597 //y2=4.26
r843 (  3 4 ) resistor r=0.319656 //w=0.131 //l=0.335 //layer=m1 \
 //thickness=0.36 //x=1.545 //y=4.42 //x2=1.545 //y2=4.755
r844 (  2 34 ) resistor r=0.0878349 //w=0.376 //l=0.174069 //layer=m1 \
 //thickness=0.36 //x=1.545 //y=4.1 //x2=1.597 //y2=4.25
r845 (  1 30 ) resistor r=0.0719237 //w=0.222 //l=0.115 //layer=m1 \
 //thickness=0.36 //x=1.545 //y=2.375 //x2=1.545 //y2=2.26
r846 (  1 2 ) resistor r=1.64599 //w=0.131 //l=1.725 //layer=m1 \
 //thickness=0.36 //x=1.545 //y=2.375 //x2=1.545 //y2=4.1
ends PM_DFFRNQX1\%noxref_7

subckt PM_DFFRNQX1\%Q ( 1 2 3 4 5 6 7 8 9 10 11 12 13 18 19 23 28 29 31 32 39 \
 51 54 55 58 60 66 67 69 74 78 87 92 100 116 117 118 122 123 124 129 131 134 \
 135 137 138 143 146 148 149 )
c262 ( 146 0 ) capacitor c=0.00878249f //x=24.965 //y=1.085
c263 ( 143 0 ) capacitor c=0.0653822f //x=21.525 //y=4.88
c264 ( 138 0 ) capacitor c=0.0278202f //x=21.525 //y=2.095
c265 ( 137 0 ) capacitor c=0.0502771f //x=21.525 //y=2.26
c266 ( 135 0 ) capacitor c=0.0443175f //x=22.045 //y=1.44
c267 ( 134 0 ) capacitor c=0.0199703f //x=22.045 //y=1.095
c268 ( 131 0 ) capacitor c=0.0162526f //x=21.89 //y=1.595
c269 ( 129 0 ) capacitor c=0.0157807f //x=21.89 //y=0.94
c270 ( 124 0 ) capacitor c=0.0220935f //x=21.515 //y=1.75
c271 ( 123 0 ) capacitor c=0.0207489f //x=21.515 //y=1.44
c272 ( 122 0 ) capacitor c=0.0194091f //x=21.515 //y=1.095
c273 ( 118 0 ) capacitor c=0.159671f //x=21.705 //y=6.2
c274 ( 117 0 ) capacitor c=0.110208f //x=21.265 //y=6.2
c275 ( 100 0 ) capacitor c=0.0322017f //x=25.115 //y=5.56
c276 ( 92 0 ) capacitor c=0.0291703f //x=24.235 //y=5.56
c277 ( 87 0 ) capacitor c=7.7417e-19 //x=21.525 //y=4.88
c278 ( 78 0 ) capacitor c=0.00101179f //x=21.525 //y=2.26
c279 ( 74 0 ) capacitor c=0.00325198f //x=21.685 //y=3.865
c280 ( 69 0 ) capacitor c=0.0327527f //x=25.06 //y=3.87
c281 ( 67 0 ) capacitor c=0.0398739f //x=24.46 //y=3.88
c282 ( 60 0 ) capacitor c=0.0148964f //x=25.155 //y=1.18
c283 ( 58 0 ) capacitor c=5.78613e-19 //x=25.115 //y=5.56
c284 ( 55 0 ) capacitor c=0.0149033f //x=25.115 //y=5.38
c285 ( 54 0 ) capacitor c=0.00919281f //x=24.235 //y=5.56
c286 ( 51 0 ) capacitor c=0.0165507f //x=21.525 //y=3.88
c287 ( 39 0 ) capacitor c=0.0128993f //x=25.595 //y=4.025
c288 ( 32 0 ) capacitor c=0.00672485f //x=25.24 //y=1.835
c289 ( 31 0 ) capacitor c=0.0151185f //x=25.51 //y=1.835
c290 ( 29 0 ) capacitor c=0.0125962f //x=25.51 //y=5.38
c291 ( 28 0 ) capacitor c=0.0134844f //x=25.155 //y=1.75
c292 ( 23 0 ) capacitor c=0.0136546f //x=25 //y=5.38
c293 ( 19 0 ) capacitor c=0.00406775f //x=21.525 //y=4.75
c294 ( 18 0 ) capacitor c=0.0111129f //x=21.525 //y=4.025
c295 ( 13 0 ) capacitor c=0.00690423f //x=21.525 //y=2.375
c296 ( 12 0 ) capacitor c=0.0184327f //x=25.595 //y=3.88
c297 ( 9 0 ) capacitor c=0.043763f //x=25.595 //y=4.25
c298 ( 5 0 ) capacitor c=0.0733755f //x=25.595 //y=2.4
c299 ( 4 0 ) capacitor c=0.017301f //x=21.525 //y=4.62
c300 ( 1 0 ) capacitor c=0.0360256f //x=21.525 //y=2.77
r301 (  137 138 ) resistor r=52.7279 //w=0.214 //l=0.165 //layer=ply \
 //thickness=0.18 //x=21.525 //y=2.26 //x2=21.525 //y2=2.095
r302 (  135 145 ) resistor r=45.1352 //w=0.168 //l=0.173853 //layer=ply \
 //thickness=0.18 //x=22.045 //y=1.44 //x2=22.005 //y2=1.595
r303 (  134 144 ) resistor r=45.1352 //w=0.168 //l=0.173853 //layer=ply \
 //thickness=0.18 //x=22.045 //y=1.095 //x2=22.005 //y2=0.94
r304 (  134 135 ) resistor r=176.904 //w=0.094 //l=0.345 //layer=ply \
 //thickness=0.18 //x=22.045 //y=1.095 //x2=22.045 //y2=1.44
r305 (  132 141 ) resistor r=10.701 //w=0.21 //l=0.115 //layer=ply \
 //thickness=0.18 //x=21.67 //y=1.595 //x2=21.555 //y2=1.595
r306 (  131 145 ) resistor r=5.52526 //w=0.168 //l=0.115 //layer=ply \
 //thickness=0.18 //x=21.89 //y=1.595 //x2=22.005 //y2=1.595
r307 (  130 140 ) resistor r=5.52526 //w=0.168 //l=0.115 //layer=ply \
 //thickness=0.18 //x=21.67 //y=0.94 //x2=21.555 //y2=0.94
r308 (  129 144 ) resistor r=5.52526 //w=0.168 //l=0.115 //layer=ply \
 //thickness=0.18 //x=21.89 //y=0.94 //x2=22.005 //y2=0.94
r309 (  129 130 ) resistor r=112.809 //w=0.094 //l=0.22 //layer=ply \
 //thickness=0.18 //x=21.89 //y=0.94 //x2=21.67 //y2=0.94
r310 (  126 143 ) resistor r=37.236 //w=0.233 //l=0.249199 //layer=ply \
 //thickness=0.18 //x=21.705 //y=5.045 //x2=21.525 //y2=4.88
r311 (  124 141 ) resistor r=39.5823 //w=0.21 //l=0.173853 //layer=ply \
 //thickness=0.18 //x=21.515 //y=1.75 //x2=21.555 //y2=1.595
r312 (  124 138 ) resistor r=176.904 //w=0.094 //l=0.345 //layer=ply \
 //thickness=0.18 //x=21.515 //y=1.75 //x2=21.515 //y2=2.095
r313 (  123 141 ) resistor r=39.5823 //w=0.21 //l=0.173853 //layer=ply \
 //thickness=0.18 //x=21.515 //y=1.44 //x2=21.555 //y2=1.595
r314 (  122 140 ) resistor r=45.1352 //w=0.168 //l=0.173853 //layer=ply \
 //thickness=0.18 //x=21.515 //y=1.095 //x2=21.555 //y2=0.94
r315 (  122 123 ) resistor r=176.904 //w=0.094 //l=0.345 //layer=ply \
 //thickness=0.18 //x=21.515 //y=1.095 //x2=21.515 //y2=1.44
r316 (  119 143 ) resistor r=53.7854 //w=0.233 //l=0.332415 //layer=ply \
 //thickness=0.18 //x=21.265 //y=5.045 //x2=21.525 //y2=4.88
r317 (  118 126 ) resistor r=592.245 //w=0.094 //l=1.155 //layer=ply \
 //thickness=0.18 //x=21.705 //y=6.2 //x2=21.705 //y2=5.045
r318 (  117 119 ) resistor r=592.245 //w=0.094 //l=1.155 //layer=ply \
 //thickness=0.18 //x=21.265 //y=6.2 //x2=21.265 //y2=5.045
r319 (  116 131 ) resistor r=56.4043 //w=0.094 //l=0.11 //layer=ply \
 //thickness=0.18 //x=21.78 //y=1.595 //x2=21.89 //y2=1.595
r320 (  116 132 ) resistor r=56.4043 //w=0.094 //l=0.11 //layer=ply \
 //thickness=0.18 //x=21.78 //y=1.595 //x2=21.67 //y2=1.595
r321 (  100 149 ) resistor r=23.615 //w=0.187 //l=0.345 //layer=li \
 //thickness=0.1 //x=25.115 //y=5.56 //x2=25.115 //y2=5.905
r322 (  92 148 ) resistor r=23.615 //w=0.187 //l=0.345 //layer=li \
 //thickness=0.1 //x=24.235 //y=5.56 //x2=24.235 //y2=5.905
r323 (  87 143 ) resistor r=152 //w=0.17 //l=0.17 //layer=licon //count=1 \
 //x=21.525 //y=4.88 //x2=21.525 //y2=4.88
r324 (  78 137 ) resistor r=152 //w=0.17 //l=0.17 //layer=licon //count=1 \
 //x=21.525 //y=2.26 //x2=21.525 //y2=2.26
r325 (  69 76 ) resistor r=0.289447 //w=0.24 //l=0.537494 //layer=m2 \
 //thickness=0.36 //x=25.06 //y=3.87 //x2=25.595 //y2=3.865
r326 (  69 70 ) resistor r=0.410305 //w=0.131 //l=0.43 //layer=m2 \
 //thickness=0.36 //x=25.06 //y=3.87 //x2=24.63 //y2=3.87
r327 (  67 70 ) resistor r=0.125 //w=0.17 //l=0.174929 //layer=m2 \
 //thickness=0.36 //x=24.46 //y=3.88 //x2=24.63 //y2=3.87
r328 (  67 74 ) resistor r=2.6479 //w=0.131 //l=2.775 //layer=m2 \
 //thickness=0.36 //x=24.46 //y=3.88 //x2=21.685 //y2=3.88
r329 (  66 74 ) resistor r=0.10734 //w=0.281 //l=0.16 //layer=m2 \
 //thickness=0.36 //x=21.525 //y=3.865 //x2=21.685 //y2=3.865
r330 (  63 76 ) resistor r=4.5 //w=0.15 //l=0.15 //layer=via1 //count=1 \
 //x=25.595 //y=3.865 //x2=25.595 //y2=3.865
r331 (  60 146 ) resistor r=9.3 //w=0.17 //l=0.17 //layer=mcon //count=1 \
 //x=25.155 //y=1.18 //x2=25.155 //y2=1.18
r332 (  58 100 ) resistor r=9.3 //w=0.17 //l=0.17 //layer=mcon //count=1 \
 //x=25.115 //y=5.56 //x2=25.115 //y2=5.56
r333 (  55 58 ) resistor r=0.117801 //w=0.191 //l=0.18 //layer=m1 \
 //thickness=0.36 //x=25.115 //y=5.38 //x2=25.115 //y2=5.56
r334 (  54 92 ) resistor r=9.3 //w=0.17 //l=0.17 //layer=mcon //count=1 \
 //x=24.235 //y=5.56 //x2=24.235 //y2=5.56
r335 (  52 54 ) resistor r=0.10274 //w=0.219 //l=0.18 //layer=m1 \
 //thickness=0.36 //x=24.235 //y=5.38 //x2=24.235 //y2=5.56
r336 (  49 66 ) resistor r=4.5 //w=0.15 //l=0.15 //layer=via1 //count=1 \
 //x=21.525 //y=3.865 //x2=21.525 //y2=3.865
r337 (  49 51 ) resistor r=0.0049867 //w=0.376 //l=0.015 //layer=m1 \
 //thickness=0.36 //x=21.577 //y=3.865 //x2=21.577 //y2=3.88
r338 (  47 87 ) resistor r=9.3 //w=0.17 //l=0.17 //layer=mcon //count=1 \
 //x=21.525 //y=4.88 //x2=21.525 //y2=4.88
r339 (  45 78 ) resistor r=9.3 //w=0.17 //l=0.17 //layer=mcon //count=1 \
 //x=21.525 //y=2.26 //x2=21.525 //y2=2.26
r340 (  34 63 ) resistor r=0.0911593 //w=0.376 //l=0.184608 //layer=m1 \
 //thickness=0.36 //x=25.595 //y=3.705 //x2=25.542 //y2=3.865
r341 (  31 33 ) resistor r=0.0698411 //w=0.17 //l=0.120208 //layer=m1 \
 //thickness=0.36 //x=25.51 //y=1.835 //x2=25.595 //y2=1.92
r342 (  31 32 ) resistor r=0.257634 //w=0.131 //l=0.27 //layer=m1 \
 //thickness=0.36 //x=25.51 //y=1.835 //x2=25.24 //y2=1.835
r343 (  30 55 ) resistor r=0.0257089 //w=0.23 //l=0.115 //layer=m1 \
 //thickness=0.36 //x=25.23 //y=5.38 //x2=25.115 //y2=5.38
r344 (  29 40 ) resistor r=0.0698411 //w=0.17 //l=0.120208 //layer=m1 \
 //thickness=0.36 //x=25.51 //y=5.38 //x2=25.595 //y2=5.295
r345 (  29 30 ) resistor r=0.267176 //w=0.131 //l=0.28 //layer=m1 \
 //thickness=0.36 //x=25.51 //y=5.38 //x2=25.23 //y2=5.38
r346 (  28 32 ) resistor r=0.0698411 //w=0.17 //l=0.120208 //layer=m1 \
 //thickness=0.36 //x=25.155 //y=1.75 //x2=25.24 //y2=1.835
r347 (  27 60 ) resistor r=0.0913624 //w=0.191 //l=0.12 //layer=m1 \
 //thickness=0.36 //x=25.155 //y=1.3 //x2=25.155 //y2=1.18
r348 (  27 28 ) resistor r=0.429389 //w=0.131 //l=0.45 //layer=m1 \
 //thickness=0.36 //x=25.155 //y=1.3 //x2=25.155 //y2=1.75
r349 (  24 52 ) resistor r=0.0227762 //w=0.219 //l=0.115 //layer=m1 \
 //thickness=0.36 //x=24.35 //y=5.38 //x2=24.235 //y2=5.38
r350 (  23 55 ) resistor r=0.0257089 //w=0.23 //l=0.115 //layer=m1 \
 //thickness=0.36 //x=25 //y=5.38 //x2=25.115 //y2=5.38
r351 (  23 24 ) resistor r=0.620229 //w=0.131 //l=0.65 //layer=m1 \
 //thickness=0.36 //x=25 //y=5.38 //x2=24.35 //y2=5.38
r352 (  19 47 ) resistor r=0.0801089 //w=0.224 //l=0.13 //layer=m1 \
 //thickness=0.36 //x=21.525 //y=4.75 //x2=21.525 //y2=4.88
r353 (  18 51 ) resistor r=0.0861726 //w=0.376 //l=0.169012 //layer=m1 \
 //thickness=0.36 //x=21.525 //y=4.025 //x2=21.577 //y2=3.88
r354 (  14 49 ) resistor r=0.0911593 //w=0.376 //l=0.184174 //layer=m1 \
 //thickness=0.36 //x=21.525 //y=3.705 //x2=21.577 //y2=3.865
r355 (  13 45 ) resistor r=0.0719237 //w=0.222 //l=0.115 //layer=m1 \
 //thickness=0.36 //x=21.525 //y=2.375 //x2=21.525 //y2=2.26
r356 (  12 39 ) resistor r=0.0861726 //w=0.376 //l=0.16944 //layer=m1 \
 //thickness=0.36 //x=25.542 //y=3.88 //x2=25.595 //y2=4.025
r357 (  12 63 ) resistor r=0.0049867 //w=0.376 //l=0.015 //layer=m1 \
 //thickness=0.36 //x=25.542 //y=3.88 //x2=25.542 //y2=3.865
r358 (  11 40 ) resistor r=0.291031 //w=0.131 //l=0.305 //layer=m1 \
 //thickness=0.36 //x=25.595 //y=4.99 //x2=25.595 //y2=5.295
r359 (  10 11 ) resistor r=0.353053 //w=0.131 //l=0.37 //layer=m1 \
 //thickness=0.36 //x=25.595 //y=4.62 //x2=25.595 //y2=4.99
r360 (  9 10 ) resistor r=0.353053 //w=0.131 //l=0.37 //layer=m1 \
 //thickness=0.36 //x=25.595 //y=4.25 //x2=25.595 //y2=4.62
r361 (  9 39 ) resistor r=0.214695 //w=0.131 //l=0.225 //layer=m1 \
 //thickness=0.36 //x=25.595 //y=4.25 //x2=25.595 //y2=4.025
r362 (  8 34 ) resistor r=0.186069 //w=0.131 //l=0.195 //layer=m1 \
 //thickness=0.36 //x=25.595 //y=3.51 //x2=25.595 //y2=3.705
r363 (  7 8 ) resistor r=0.353053 //w=0.131 //l=0.37 //layer=m1 \
 //thickness=0.36 //x=25.595 //y=3.14 //x2=25.595 //y2=3.51
r364 (  6 7 ) resistor r=0.353053 //w=0.131 //l=0.37 //layer=m1 \
 //thickness=0.36 //x=25.595 //y=2.77 //x2=25.595 //y2=3.14
r365 (  5 6 ) resistor r=0.353053 //w=0.131 //l=0.37 //layer=m1 \
 //thickness=0.36 //x=25.595 //y=2.4 //x2=25.595 //y2=2.77
r366 (  5 33 ) resistor r=0.458015 //w=0.131 //l=0.48 //layer=m1 \
 //thickness=0.36 //x=25.595 //y=2.4 //x2=25.595 //y2=1.92
r367 (  4 19 ) resistor r=0.124046 //w=0.131 //l=0.13 //layer=m1 \
 //thickness=0.36 //x=21.525 //y=4.62 //x2=21.525 //y2=4.75
r368 (  4 18 ) resistor r=0.567748 //w=0.131 //l=0.595 //layer=m1 \
 //thickness=0.36 //x=21.525 //y=4.62 //x2=21.525 //y2=4.025
r369 (  3 14 ) resistor r=0.186069 //w=0.131 //l=0.195 //layer=m1 \
 //thickness=0.36 //x=21.525 //y=3.51 //x2=21.525 //y2=3.705
r370 (  2 3 ) resistor r=0.353053 //w=0.131 //l=0.37 //layer=m1 \
 //thickness=0.36 //x=21.525 //y=3.14 //x2=21.525 //y2=3.51
r371 (  1 2 ) resistor r=0.353053 //w=0.131 //l=0.37 //layer=m1 \
 //thickness=0.36 //x=21.525 //y=2.77 //x2=21.525 //y2=3.14
r372 (  1 13 ) resistor r=0.376908 //w=0.131 //l=0.395 //layer=m1 \
 //thickness=0.36 //x=21.525 //y=2.77 //x2=21.525 //y2=2.375
ends PM_DFFRNQX1\%Q

subckt PM_DFFRNQX1\%VDD ( 1 47 66 75 85 93 103 121 131 139 149 165 173 199 207 \
 217 227 243 251 261 271 287 297 310 319 324 329 335 341 346 347 348 349 350 \
 351 352 353 354 355 356 357 358 359 360 361 362 363 364 365 366 367 )
c397 ( 367 0 ) capacitor c=0.0393089f //x=25.41 //y=5.2
c398 ( 366 0 ) capacitor c=0.0248174f //x=24.53 //y=5.2
c399 ( 365 0 ) capacitor c=0.0630539f //x=23.66 //y=5.2
c400 ( 364 0 ) capacitor c=0.0466891f //x=21.78 //y=5.2
c401 ( 363 0 ) capacitor c=0.0255836f //x=20.9 //y=5.2
c402 ( 362 0 ) capacitor c=0.0256114f //x=20.02 //y=5.2
c403 ( 361 0 ) capacitor c=0.0676554f //x=19.15 //y=5.2
c404 ( 360 0 ) capacitor c=0.0466891f //x=16.97 //y=5.2
c405 ( 359 0 ) capacitor c=0.025617f //x=16.09 //y=5.2
c406 ( 358 0 ) capacitor c=0.0255777f //x=15.21 //y=5.2
c407 ( 357 0 ) capacitor c=0.0674699f //x=14.34 //y=5.2
c408 ( 356 0 ) capacitor c=0.039544f //x=12.46 //y=5.2
c409 ( 355 0 ) capacitor c=0.0248174f //x=11.58 //y=5.2
c410 ( 354 0 ) capacitor c=0.0628113f //x=10.71 //y=5.2
c411 ( 353 0 ) capacitor c=0.0466891f //x=8.83 //y=5.2
c412 ( 352 0 ) capacitor c=0.0255836f //x=7.95 //y=5.2
c413 ( 351 0 ) capacitor c=0.0256114f //x=7.07 //y=5.2
c414 ( 350 0 ) capacitor c=0.0675756f //x=6.2 //y=5.2
c415 ( 349 0 ) capacitor c=0.0466891f //x=4.02 //y=5.2
c416 ( 348 0 ) capacitor c=0.025617f //x=3.14 //y=5.2
c417 ( 347 0 ) capacitor c=0.0256114f //x=2.26 //y=5.2
c418 ( 346 0 ) capacitor c=0.0693233f //x=1.39 //y=5.2
c419 ( 344 0 ) capacitor c=0.00597439f //x=25.555 //y=7.585
c420 ( 343 0 ) capacitor c=0.00597439f //x=24.675 //y=7.585
c421 ( 342 0 ) capacitor c=0.00597439f //x=23.795 //y=7.585
c422 ( 341 0 ) capacitor c=0.145935f //x=23.005 //y=7.585
c423 ( 340 0 ) capacitor c=0.00597439f //x=21.925 //y=7.585
c424 ( 339 0 ) capacitor c=0.00597439f //x=21.045 //y=7.585
c425 ( 338 0 ) capacitor c=0.00597439f //x=20.165 //y=7.585
c426 ( 337 0 ) capacitor c=0.00597439f //x=19.305 //y=7.58
c427 ( 335 0 ) capacitor c=0.16206f //x=18.195 //y=7.585
c428 ( 334 0 ) capacitor c=0.00597439f //x=17.115 //y=7.585
c429 ( 333 0 ) capacitor c=0.00597439f //x=16.235 //y=7.585
c430 ( 332 0 ) capacitor c=0.00597439f //x=15.355 //y=7.585
c431 ( 331 0 ) capacitor c=0.00597439f //x=14.495 //y=7.58
c432 ( 329 0 ) capacitor c=0.144432f //x=13.385 //y=7.585
c433 ( 328 0 ) capacitor c=0.00597439f //x=12.605 //y=7.585
c434 ( 327 0 ) capacitor c=0.00597439f //x=11.725 //y=7.585
c435 ( 326 0 ) capacitor c=0.00597439f //x=10.795 //y=7.58
c436 ( 324 0 ) capacitor c=0.145153f //x=10.055 //y=7.585
c437 ( 323 0 ) capacitor c=0.00597439f //x=8.975 //y=7.585
c438 ( 322 0 ) capacitor c=0.00597439f //x=8.095 //y=7.585
c439 ( 321 0 ) capacitor c=0.00597439f //x=7.215 //y=7.585
c440 ( 320 0 ) capacitor c=0.00597439f //x=6.335 //y=7.585
c441 ( 319 0 ) capacitor c=0.163341f //x=5.245 //y=7.585
c442 ( 318 0 ) capacitor c=0.00597439f //x=4.165 //y=7.585
c443 ( 317 0 ) capacitor c=0.00597439f //x=3.285 //y=7.585
c444 ( 316 0 ) capacitor c=0.00597439f //x=2.405 //y=7.585
c445 ( 315 0 ) capacitor c=0.00597439f //x=1.525 //y=7.585
c446 ( 310 0 ) capacitor c=0.265027f //x=25.965 //y=7.58
c447 ( 297 0 ) capacitor c=0.0287376f //x=25.47 //y=7.585
c448 ( 287 0 ) capacitor c=0.0291078f //x=24.59 //y=7.585
c449 ( 277 0 ) capacitor c=0.0283511f //x=23.71 //y=7.585
c450 ( 271 0 ) capacitor c=0.042257f //x=22.835 //y=7.585
c451 ( 261 0 ) capacitor c=0.0288858f //x=21.84 //y=7.585
c452 ( 251 0 ) capacitor c=0.0289326f //x=20.96 //y=7.585
c453 ( 243 0 ) capacitor c=0.0290299f //x=20.08 //y=7.585
c454 ( 233 0 ) capacitor c=0.0455283f //x=19.2 //y=7.585
c455 ( 227 0 ) capacitor c=0.0427734f //x=18.025 //y=7.585
c456 ( 217 0 ) capacitor c=0.0288858f //x=17.03 //y=7.585
c457 ( 207 0 ) capacitor c=0.0289326f //x=16.15 //y=7.585
c458 ( 199 0 ) capacitor c=0.0290299f //x=15.27 //y=7.585
c459 ( 189 0 ) capacitor c=0.0455283f //x=14.39 //y=7.585
c460 ( 183 0 ) capacitor c=0.0277785f //x=13.215 //y=7.585
c461 ( 173 0 ) capacitor c=0.0287376f //x=12.52 //y=7.585
c462 ( 165 0 ) capacitor c=0.0291078f //x=11.64 //y=7.585
c463 ( 155 0 ) capacitor c=0.0283511f //x=10.76 //y=7.585
c464 ( 149 0 ) capacitor c=0.042257f //x=9.885 //y=7.585
c465 ( 139 0 ) capacitor c=0.0288858f //x=8.89 //y=7.585
c466 ( 131 0 ) capacitor c=0.0289326f //x=8.01 //y=7.585
c467 ( 121 0 ) capacitor c=0.0290299f //x=7.13 //y=7.585
c468 ( 109 0 ) capacitor c=0.0455283f //x=6.25 //y=7.585
c469 ( 103 0 ) capacitor c=0.042257f //x=5.075 //y=7.585
c470 ( 93 0 ) capacitor c=0.0288858f //x=4.08 //y=7.585
c471 ( 85 0 ) capacitor c=0.0289326f //x=3.2 //y=7.585
c472 ( 75 0 ) capacitor c=0.0289834f //x=2.32 //y=7.585
c473 ( 66 0 ) capacitor c=0.250384f //x=1.175 //y=7.58
c474 ( 63 0 ) capacitor c=0.0454931f //x=1.44 //y=7.585
c475 ( 47 0 ) capacitor c=0.982904f //x=25.965 //y=7.58
r476 (  308 344 ) resistor r=2.87058 //w=0.35 //l=0.085 //layer=li \
 //thickness=0.1 //x=25.64 //y=7.585 //x2=25.555 //y2=7.585
r477 (  308 310 ) resistor r=11.3351 //w=0.367 //l=0.325 //layer=li \
 //thickness=0.1 //x=25.64 //y=7.585 //x2=25.965 //y2=7.585
r478 (  301 344 ) resistor r=4.23183 //w=0.7 //l=0.175 //layer=li \
 //thickness=0.1 //x=25.555 //y=7.41 //x2=25.555 //y2=7.585
r479 (  301 367 ) resistor r=33.1979 //w=0.187 //l=0.485 //layer=li \
 //thickness=0.1 //x=25.555 //y=7.41 //x2=25.555 //y2=6.925
r480 (  298 343 ) resistor r=2.87058 //w=0.35 //l=0.085 //layer=li \
 //thickness=0.1 //x=24.76 //y=7.585 //x2=24.675 //y2=7.585
r481 (  298 300 ) resistor r=16.218 //w=0.367 //l=0.465 //layer=li \
 //thickness=0.1 //x=24.76 //y=7.585 //x2=25.225 //y2=7.585
r482 (  297 344 ) resistor r=2.87058 //w=0.35 //l=0.085 //layer=li \
 //thickness=0.1 //x=25.47 //y=7.585 //x2=25.555 //y2=7.585
r483 (  297 300 ) resistor r=8.54496 //w=0.367 //l=0.245 //layer=li \
 //thickness=0.1 //x=25.47 //y=7.585 //x2=25.225 //y2=7.585
r484 (  291 343 ) resistor r=4.23183 //w=0.7 //l=0.175 //layer=li \
 //thickness=0.1 //x=24.675 //y=7.41 //x2=24.675 //y2=7.585
r485 (  291 366 ) resistor r=33.1979 //w=0.187 //l=0.485 //layer=li \
 //thickness=0.1 //x=24.675 //y=7.41 //x2=24.675 //y2=6.925
r486 (  288 342 ) resistor r=2.87058 //w=0.35 //l=0.085 //layer=li \
 //thickness=0.1 //x=23.88 //y=7.585 //x2=23.795 //y2=7.585
r487 (  288 290 ) resistor r=8.19619 //w=0.367 //l=0.235 //layer=li \
 //thickness=0.1 //x=23.88 //y=7.585 //x2=24.115 //y2=7.585
r488 (  287 343 ) resistor r=2.87058 //w=0.35 //l=0.085 //layer=li \
 //thickness=0.1 //x=24.59 //y=7.585 //x2=24.675 //y2=7.585
r489 (  287 290 ) resistor r=16.5668 //w=0.367 //l=0.475 //layer=li \
 //thickness=0.1 //x=24.59 //y=7.585 //x2=24.115 //y2=7.585
r490 (  279 342 ) resistor r=4.23183 //w=0.7 //l=0.175 //layer=li \
 //thickness=0.1 //x=23.795 //y=7.41 //x2=23.795 //y2=7.585
r491 (  279 365 ) resistor r=56.4706 //w=0.187 //l=0.825 //layer=li \
 //thickness=0.1 //x=23.795 //y=7.41 //x2=23.795 //y2=6.585
r492 (  278 341 ) resistor r=5.29055 //w=0.35 //l=0.17 //layer=li \
 //thickness=0.1 //x=23.175 //y=7.585 //x2=23.005 //y2=7.585
r493 (  277 342 ) resistor r=2.87058 //w=0.35 //l=0.085 //layer=li \
 //thickness=0.1 //x=23.71 //y=7.585 //x2=23.795 //y2=7.585
r494 (  277 278 ) resistor r=18.6594 //w=0.367 //l=0.535 //layer=li \
 //thickness=0.1 //x=23.71 //y=7.585 //x2=23.175 //y2=7.585
r495 (  272 340 ) resistor r=2.87058 //w=0.35 //l=0.085 //layer=li \
 //thickness=0.1 //x=22.01 //y=7.585 //x2=21.925 //y2=7.585
r496 (  272 274 ) resistor r=21.7984 //w=0.367 //l=0.625 //layer=li \
 //thickness=0.1 //x=22.01 //y=7.585 //x2=22.635 //y2=7.585
r497 (  271 341 ) resistor r=5.29055 //w=0.35 //l=0.17 //layer=li \
 //thickness=0.1 //x=22.835 //y=7.585 //x2=23.005 //y2=7.585
r498 (  271 274 ) resistor r=6.97548 //w=0.367 //l=0.2 //layer=li \
 //thickness=0.1 //x=22.835 //y=7.585 //x2=22.635 //y2=7.585
r499 (  265 340 ) resistor r=4.23183 //w=0.7 //l=0.175 //layer=li \
 //thickness=0.1 //x=21.925 //y=7.41 //x2=21.925 //y2=7.585
r500 (  265 364 ) resistor r=33.1979 //w=0.187 //l=0.485 //layer=li \
 //thickness=0.1 //x=21.925 //y=7.41 //x2=21.925 //y2=6.925
r501 (  262 339 ) resistor r=2.87058 //w=0.35 //l=0.085 //layer=li \
 //thickness=0.1 //x=21.13 //y=7.585 //x2=21.045 //y2=7.585
r502 (  262 264 ) resistor r=13.7766 //w=0.367 //l=0.395 //layer=li \
 //thickness=0.1 //x=21.13 //y=7.585 //x2=21.525 //y2=7.585
r503 (  261 340 ) resistor r=2.87058 //w=0.35 //l=0.085 //layer=li \
 //thickness=0.1 //x=21.84 //y=7.585 //x2=21.925 //y2=7.585
r504 (  261 264 ) resistor r=10.9864 //w=0.367 //l=0.315 //layer=li \
 //thickness=0.1 //x=21.84 //y=7.585 //x2=21.525 //y2=7.585
r505 (  255 339 ) resistor r=4.23183 //w=0.7 //l=0.175 //layer=li \
 //thickness=0.1 //x=21.045 //y=7.41 //x2=21.045 //y2=7.585
r506 (  255 363 ) resistor r=33.1979 //w=0.187 //l=0.485 //layer=li \
 //thickness=0.1 //x=21.045 //y=7.41 //x2=21.045 //y2=6.925
r507 (  252 338 ) resistor r=2.87058 //w=0.35 //l=0.085 //layer=li \
 //thickness=0.1 //x=20.25 //y=7.585 //x2=20.165 //y2=7.585
r508 (  252 254 ) resistor r=5.75477 //w=0.367 //l=0.165 //layer=li \
 //thickness=0.1 //x=20.25 //y=7.585 //x2=20.415 //y2=7.585
r509 (  251 339 ) resistor r=2.87058 //w=0.35 //l=0.085 //layer=li \
 //thickness=0.1 //x=20.96 //y=7.585 //x2=21.045 //y2=7.585
r510 (  251 254 ) resistor r=19.0082 //w=0.367 //l=0.545 //layer=li \
 //thickness=0.1 //x=20.96 //y=7.585 //x2=20.415 //y2=7.585
r511 (  245 338 ) resistor r=4.23183 //w=0.7 //l=0.175 //layer=li \
 //thickness=0.1 //x=20.165 //y=7.41 //x2=20.165 //y2=7.585
r512 (  245 362 ) resistor r=33.1979 //w=0.187 //l=0.485 //layer=li \
 //thickness=0.1 //x=20.165 //y=7.41 //x2=20.165 //y2=6.925
r513 (  244 337 ) resistor r=2.87058 //w=0.35 //l=0.085 //layer=li \
 //thickness=0.1 //x=19.37 //y=7.585 //x2=19.285 //y2=7.585
r514 (  243 338 ) resistor r=2.87058 //w=0.35 //l=0.085 //layer=li \
 //thickness=0.1 //x=20.08 //y=7.585 //x2=20.165 //y2=7.585
r515 (  243 244 ) resistor r=24.7629 //w=0.367 //l=0.71 //layer=li \
 //thickness=0.1 //x=20.08 //y=7.585 //x2=19.37 //y2=7.585
r516 (  235 337 ) resistor r=4.23183 //w=0.7 //l=0.175 //layer=li \
 //thickness=0.1 //x=19.285 //y=7.41 //x2=19.285 //y2=7.585
r517 (  235 361 ) resistor r=56.4706 //w=0.187 //l=0.825 //layer=li \
 //thickness=0.1 //x=19.285 //y=7.41 //x2=19.285 //y2=6.585
r518 (  234 335 ) resistor r=5.29055 //w=0.35 //l=0.17 //layer=li \
 //thickness=0.1 //x=18.365 //y=7.585 //x2=18.195 //y2=7.585
r519 (  233 337 ) resistor r=2.87058 //w=0.35 //l=0.085 //layer=li \
 //thickness=0.1 //x=19.2 //y=7.585 //x2=19.285 //y2=7.585
r520 (  233 234 ) resistor r=29.1226 //w=0.367 //l=0.835 //layer=li \
 //thickness=0.1 //x=19.2 //y=7.585 //x2=18.365 //y2=7.585
r521 (  228 334 ) resistor r=2.87058 //w=0.35 //l=0.085 //layer=li \
 //thickness=0.1 //x=17.2 //y=7.585 //x2=17.115 //y2=7.585
r522 (  228 230 ) resistor r=21.7984 //w=0.367 //l=0.625 //layer=li \
 //thickness=0.1 //x=17.2 //y=7.585 //x2=17.825 //y2=7.585
r523 (  227 335 ) resistor r=5.29055 //w=0.35 //l=0.17 //layer=li \
 //thickness=0.1 //x=18.025 //y=7.585 //x2=18.195 //y2=7.585
r524 (  227 230 ) resistor r=6.97548 //w=0.367 //l=0.2 //layer=li \
 //thickness=0.1 //x=18.025 //y=7.585 //x2=17.825 //y2=7.585
r525 (  221 334 ) resistor r=4.23183 //w=0.7 //l=0.175 //layer=li \
 //thickness=0.1 //x=17.115 //y=7.41 //x2=17.115 //y2=7.585
r526 (  221 360 ) resistor r=33.1979 //w=0.187 //l=0.485 //layer=li \
 //thickness=0.1 //x=17.115 //y=7.41 //x2=17.115 //y2=6.925
r527 (  218 333 ) resistor r=2.87058 //w=0.35 //l=0.085 //layer=li \
 //thickness=0.1 //x=16.32 //y=7.585 //x2=16.235 //y2=7.585
r528 (  218 220 ) resistor r=13.7766 //w=0.367 //l=0.395 //layer=li \
 //thickness=0.1 //x=16.32 //y=7.585 //x2=16.715 //y2=7.585
r529 (  217 334 ) resistor r=2.87058 //w=0.35 //l=0.085 //layer=li \
 //thickness=0.1 //x=17.03 //y=7.585 //x2=17.115 //y2=7.585
r530 (  217 220 ) resistor r=10.9864 //w=0.367 //l=0.315 //layer=li \
 //thickness=0.1 //x=17.03 //y=7.585 //x2=16.715 //y2=7.585
r531 (  211 333 ) resistor r=4.23183 //w=0.7 //l=0.175 //layer=li \
 //thickness=0.1 //x=16.235 //y=7.41 //x2=16.235 //y2=7.585
r532 (  211 359 ) resistor r=33.1979 //w=0.187 //l=0.485 //layer=li \
 //thickness=0.1 //x=16.235 //y=7.41 //x2=16.235 //y2=6.925
r533 (  208 332 ) resistor r=2.87058 //w=0.35 //l=0.085 //layer=li \
 //thickness=0.1 //x=15.44 //y=7.585 //x2=15.355 //y2=7.585
r534 (  208 210 ) resistor r=5.75477 //w=0.367 //l=0.165 //layer=li \
 //thickness=0.1 //x=15.44 //y=7.585 //x2=15.605 //y2=7.585
r535 (  207 333 ) resistor r=2.87058 //w=0.35 //l=0.085 //layer=li \
 //thickness=0.1 //x=16.15 //y=7.585 //x2=16.235 //y2=7.585
r536 (  207 210 ) resistor r=19.0082 //w=0.367 //l=0.545 //layer=li \
 //thickness=0.1 //x=16.15 //y=7.585 //x2=15.605 //y2=7.585
r537 (  201 332 ) resistor r=4.23183 //w=0.7 //l=0.175 //layer=li \
 //thickness=0.1 //x=15.355 //y=7.41 //x2=15.355 //y2=7.585
r538 (  201 358 ) resistor r=33.1979 //w=0.187 //l=0.485 //layer=li \
 //thickness=0.1 //x=15.355 //y=7.41 //x2=15.355 //y2=6.925
r539 (  200 331 ) resistor r=2.87058 //w=0.35 //l=0.085 //layer=li \
 //thickness=0.1 //x=14.56 //y=7.585 //x2=14.475 //y2=7.585
r540 (  199 332 ) resistor r=2.87058 //w=0.35 //l=0.085 //layer=li \
 //thickness=0.1 //x=15.27 //y=7.585 //x2=15.355 //y2=7.585
r541 (  199 200 ) resistor r=24.7629 //w=0.367 //l=0.71 //layer=li \
 //thickness=0.1 //x=15.27 //y=7.585 //x2=14.56 //y2=7.585
r542 (  191 331 ) resistor r=4.23183 //w=0.7 //l=0.175 //layer=li \
 //thickness=0.1 //x=14.475 //y=7.41 //x2=14.475 //y2=7.585
r543 (  191 357 ) resistor r=56.4706 //w=0.187 //l=0.825 //layer=li \
 //thickness=0.1 //x=14.475 //y=7.41 //x2=14.475 //y2=6.585
r544 (  190 329 ) resistor r=5.29055 //w=0.35 //l=0.17 //layer=li \
 //thickness=0.1 //x=13.555 //y=7.585 //x2=13.385 //y2=7.585
r545 (  189 331 ) resistor r=2.87058 //w=0.35 //l=0.085 //layer=li \
 //thickness=0.1 //x=14.39 //y=7.585 //x2=14.475 //y2=7.585
r546 (  189 190 ) resistor r=29.1226 //w=0.367 //l=0.835 //layer=li \
 //thickness=0.1 //x=14.39 //y=7.585 //x2=13.555 //y2=7.585
r547 (  184 328 ) resistor r=2.87058 //w=0.35 //l=0.085 //layer=li \
 //thickness=0.1 //x=12.69 //y=7.585 //x2=12.605 //y2=7.585
r548 (  184 186 ) resistor r=11.3351 //w=0.367 //l=0.325 //layer=li \
 //thickness=0.1 //x=12.69 //y=7.585 //x2=13.015 //y2=7.585
r549 (  183 329 ) resistor r=5.29055 //w=0.35 //l=0.17 //layer=li \
 //thickness=0.1 //x=13.215 //y=7.585 //x2=13.385 //y2=7.585
r550 (  183 186 ) resistor r=6.97548 //w=0.367 //l=0.2 //layer=li \
 //thickness=0.1 //x=13.215 //y=7.585 //x2=13.015 //y2=7.585
r551 (  177 328 ) resistor r=4.23183 //w=0.7 //l=0.175 //layer=li \
 //thickness=0.1 //x=12.605 //y=7.41 //x2=12.605 //y2=7.585
r552 (  177 356 ) resistor r=33.1979 //w=0.187 //l=0.485 //layer=li \
 //thickness=0.1 //x=12.605 //y=7.41 //x2=12.605 //y2=6.925
r553 (  174 327 ) resistor r=2.87058 //w=0.35 //l=0.085 //layer=li \
 //thickness=0.1 //x=11.81 //y=7.585 //x2=11.725 //y2=7.585
r554 (  174 176 ) resistor r=3.31335 //w=0.367 //l=0.095 //layer=li \
 //thickness=0.1 //x=11.81 //y=7.585 //x2=11.905 //y2=7.585
r555 (  173 328 ) resistor r=2.87058 //w=0.35 //l=0.085 //layer=li \
 //thickness=0.1 //x=12.52 //y=7.585 //x2=12.605 //y2=7.585
r556 (  173 176 ) resistor r=21.4496 //w=0.367 //l=0.615 //layer=li \
 //thickness=0.1 //x=12.52 //y=7.585 //x2=11.905 //y2=7.585
r557 (  167 327 ) resistor r=4.23183 //w=0.7 //l=0.175 //layer=li \
 //thickness=0.1 //x=11.725 //y=7.41 //x2=11.725 //y2=7.585
r558 (  167 355 ) resistor r=33.1979 //w=0.187 //l=0.485 //layer=li \
 //thickness=0.1 //x=11.725 //y=7.41 //x2=11.725 //y2=6.925
r559 (  166 326 ) resistor r=2.87058 //w=0.35 //l=0.085 //layer=li \
 //thickness=0.1 //x=10.93 //y=7.585 //x2=10.845 //y2=7.585
r560 (  165 327 ) resistor r=2.87058 //w=0.35 //l=0.085 //layer=li \
 //thickness=0.1 //x=11.64 //y=7.585 //x2=11.725 //y2=7.585
r561 (  165 166 ) resistor r=24.7629 //w=0.367 //l=0.71 //layer=li \
 //thickness=0.1 //x=11.64 //y=7.585 //x2=10.93 //y2=7.585
r562 (  157 326 ) resistor r=4.23183 //w=0.7 //l=0.175 //layer=li \
 //thickness=0.1 //x=10.845 //y=7.41 //x2=10.845 //y2=7.585
r563 (  157 354 ) resistor r=56.4706 //w=0.187 //l=0.825 //layer=li \
 //thickness=0.1 //x=10.845 //y=7.41 //x2=10.845 //y2=6.585
r564 (  156 324 ) resistor r=5.29055 //w=0.35 //l=0.17 //layer=li \
 //thickness=0.1 //x=10.225 //y=7.585 //x2=10.055 //y2=7.585
r565 (  155 326 ) resistor r=2.87058 //w=0.35 //l=0.085 //layer=li \
 //thickness=0.1 //x=10.76 //y=7.585 //x2=10.845 //y2=7.585
r566 (  155 156 ) resistor r=18.6594 //w=0.367 //l=0.535 //layer=li \
 //thickness=0.1 //x=10.76 //y=7.585 //x2=10.225 //y2=7.585
r567 (  150 323 ) resistor r=2.87058 //w=0.35 //l=0.085 //layer=li \
 //thickness=0.1 //x=9.06 //y=7.585 //x2=8.975 //y2=7.585
r568 (  150 152 ) resistor r=8.89373 //w=0.367 //l=0.255 //layer=li \
 //thickness=0.1 //x=9.06 //y=7.585 //x2=9.315 //y2=7.585
r569 (  149 324 ) resistor r=5.29055 //w=0.35 //l=0.17 //layer=li \
 //thickness=0.1 //x=9.885 //y=7.585 //x2=10.055 //y2=7.585
r570 (  149 152 ) resistor r=19.8801 //w=0.367 //l=0.57 //layer=li \
 //thickness=0.1 //x=9.885 //y=7.585 //x2=9.315 //y2=7.585
r571 (  143 323 ) resistor r=4.23183 //w=0.7 //l=0.175 //layer=li \
 //thickness=0.1 //x=8.975 //y=7.41 //x2=8.975 //y2=7.585
r572 (  143 353 ) resistor r=33.1979 //w=0.187 //l=0.485 //layer=li \
 //thickness=0.1 //x=8.975 //y=7.41 //x2=8.975 //y2=6.925
r573 (  140 322 ) resistor r=2.87058 //w=0.35 //l=0.085 //layer=li \
 //thickness=0.1 //x=8.18 //y=7.585 //x2=8.095 //y2=7.585
r574 (  140 142 ) resistor r=0.871935 //w=0.367 //l=0.025 //layer=li \
 //thickness=0.1 //x=8.18 //y=7.585 //x2=8.205 //y2=7.585
r575 (  139 323 ) resistor r=2.87058 //w=0.35 //l=0.085 //layer=li \
 //thickness=0.1 //x=8.89 //y=7.585 //x2=8.975 //y2=7.585
r576 (  139 142 ) resistor r=23.891 //w=0.367 //l=0.685 //layer=li \
 //thickness=0.1 //x=8.89 //y=7.585 //x2=8.205 //y2=7.585
r577 (  133 322 ) resistor r=4.23183 //w=0.7 //l=0.175 //layer=li \
 //thickness=0.1 //x=8.095 //y=7.41 //x2=8.095 //y2=7.585
r578 (  133 352 ) resistor r=33.1979 //w=0.187 //l=0.485 //layer=li \
 //thickness=0.1 //x=8.095 //y=7.41 //x2=8.095 //y2=6.925
r579 (  132 321 ) resistor r=2.87058 //w=0.35 //l=0.085 //layer=li \
 //thickness=0.1 //x=7.3 //y=7.585 //x2=7.215 //y2=7.585
r580 (  131 322 ) resistor r=2.87058 //w=0.35 //l=0.085 //layer=li \
 //thickness=0.1 //x=8.01 //y=7.585 //x2=8.095 //y2=7.585
r581 (  131 132 ) resistor r=24.7629 //w=0.367 //l=0.71 //layer=li \
 //thickness=0.1 //x=8.01 //y=7.585 //x2=7.3 //y2=7.585
r582 (  125 321 ) resistor r=4.23183 //w=0.7 //l=0.175 //layer=li \
 //thickness=0.1 //x=7.215 //y=7.41 //x2=7.215 //y2=7.585
r583 (  125 351 ) resistor r=33.1979 //w=0.187 //l=0.485 //layer=li \
 //thickness=0.1 //x=7.215 //y=7.41 //x2=7.215 //y2=6.925
r584 (  122 320 ) resistor r=2.87058 //w=0.35 //l=0.085 //layer=li \
 //thickness=0.1 //x=6.42 //y=7.585 //x2=6.335 //y2=7.585
r585 (  122 124 ) resistor r=23.5422 //w=0.367 //l=0.675 //layer=li \
 //thickness=0.1 //x=6.42 //y=7.585 //x2=7.095 //y2=7.585
r586 (  121 321 ) resistor r=2.87058 //w=0.35 //l=0.085 //layer=li \
 //thickness=0.1 //x=7.13 //y=7.585 //x2=7.215 //y2=7.585
r587 (  121 124 ) resistor r=1.22071 //w=0.367 //l=0.035 //layer=li \
 //thickness=0.1 //x=7.13 //y=7.585 //x2=7.095 //y2=7.585
r588 (  113 320 ) resistor r=4.23183 //w=0.7 //l=0.175 //layer=li \
 //thickness=0.1 //x=6.335 //y=7.41 //x2=6.335 //y2=7.585
r589 (  113 350 ) resistor r=56.4706 //w=0.187 //l=0.825 //layer=li \
 //thickness=0.1 //x=6.335 //y=7.41 //x2=6.335 //y2=6.585
r590 (  110 319 ) resistor r=5.29055 //w=0.35 //l=0.17 //layer=li \
 //thickness=0.1 //x=5.415 //y=7.585 //x2=5.245 //y2=7.585
r591 (  110 112 ) resistor r=19.8801 //w=0.367 //l=0.57 //layer=li \
 //thickness=0.1 //x=5.415 //y=7.585 //x2=5.985 //y2=7.585
r592 (  109 320 ) resistor r=2.87058 //w=0.35 //l=0.085 //layer=li \
 //thickness=0.1 //x=6.25 //y=7.585 //x2=6.335 //y2=7.585
r593 (  109 112 ) resistor r=9.24251 //w=0.367 //l=0.265 //layer=li \
 //thickness=0.1 //x=6.25 //y=7.585 //x2=5.985 //y2=7.585
r594 (  104 318 ) resistor r=2.87058 //w=0.35 //l=0.085 //layer=li \
 //thickness=0.1 //x=4.25 //y=7.585 //x2=4.165 //y2=7.585
r595 (  104 106 ) resistor r=8.89373 //w=0.367 //l=0.255 //layer=li \
 //thickness=0.1 //x=4.25 //y=7.585 //x2=4.505 //y2=7.585
r596 (  103 319 ) resistor r=5.29055 //w=0.35 //l=0.17 //layer=li \
 //thickness=0.1 //x=5.075 //y=7.585 //x2=5.245 //y2=7.585
r597 (  103 106 ) resistor r=19.8801 //w=0.367 //l=0.57 //layer=li \
 //thickness=0.1 //x=5.075 //y=7.585 //x2=4.505 //y2=7.585
r598 (  97 318 ) resistor r=4.23183 //w=0.7 //l=0.175 //layer=li \
 //thickness=0.1 //x=4.165 //y=7.41 //x2=4.165 //y2=7.585
r599 (  97 349 ) resistor r=33.1979 //w=0.187 //l=0.485 //layer=li \
 //thickness=0.1 //x=4.165 //y=7.41 //x2=4.165 //y2=6.925
r600 (  94 317 ) resistor r=2.87058 //w=0.35 //l=0.085 //layer=li \
 //thickness=0.1 //x=3.37 //y=7.585 //x2=3.285 //y2=7.585
r601 (  94 96 ) resistor r=0.871935 //w=0.367 //l=0.025 //layer=li \
 //thickness=0.1 //x=3.37 //y=7.585 //x2=3.395 //y2=7.585
r602 (  93 318 ) resistor r=2.87058 //w=0.35 //l=0.085 //layer=li \
 //thickness=0.1 //x=4.08 //y=7.585 //x2=4.165 //y2=7.585
r603 (  93 96 ) resistor r=23.891 //w=0.367 //l=0.685 //layer=li \
 //thickness=0.1 //x=4.08 //y=7.585 //x2=3.395 //y2=7.585
r604 (  87 317 ) resistor r=4.23183 //w=0.7 //l=0.175 //layer=li \
 //thickness=0.1 //x=3.285 //y=7.41 //x2=3.285 //y2=7.585
r605 (  87 348 ) resistor r=33.1979 //w=0.187 //l=0.485 //layer=li \
 //thickness=0.1 //x=3.285 //y=7.41 //x2=3.285 //y2=6.925
r606 (  86 316 ) resistor r=2.87058 //w=0.35 //l=0.085 //layer=li \
 //thickness=0.1 //x=2.49 //y=7.585 //x2=2.405 //y2=7.585
r607 (  85 317 ) resistor r=2.87058 //w=0.35 //l=0.085 //layer=li \
 //thickness=0.1 //x=3.2 //y=7.585 //x2=3.285 //y2=7.585
r608 (  85 86 ) resistor r=24.7629 //w=0.367 //l=0.71 //layer=li \
 //thickness=0.1 //x=3.2 //y=7.585 //x2=2.49 //y2=7.585
r609 (  79 316 ) resistor r=4.23183 //w=0.7 //l=0.175 //layer=li \
 //thickness=0.1 //x=2.405 //y=7.41 //x2=2.405 //y2=7.585
r610 (  79 347 ) resistor r=33.1979 //w=0.187 //l=0.485 //layer=li \
 //thickness=0.1 //x=2.405 //y=7.41 //x2=2.405 //y2=6.925
r611 (  76 315 ) resistor r=2.87058 //w=0.35 //l=0.085 //layer=li \
 //thickness=0.1 //x=1.61 //y=7.585 //x2=1.525 //y2=7.585
r612 (  76 78 ) resistor r=23.5422 //w=0.367 //l=0.675 //layer=li \
 //thickness=0.1 //x=1.61 //y=7.585 //x2=2.285 //y2=7.585
r613 (  75 316 ) resistor r=2.87058 //w=0.35 //l=0.085 //layer=li \
 //thickness=0.1 //x=2.32 //y=7.585 //x2=2.405 //y2=7.585
r614 (  75 78 ) resistor r=1.22071 //w=0.367 //l=0.035 //layer=li \
 //thickness=0.1 //x=2.32 //y=7.585 //x2=2.285 //y2=7.585
r615 (  67 315 ) resistor r=4.23183 //w=0.7 //l=0.175 //layer=li \
 //thickness=0.1 //x=1.525 //y=7.41 //x2=1.525 //y2=7.585
r616 (  67 346 ) resistor r=56.4706 //w=0.187 //l=0.825 //layer=li \
 //thickness=0.1 //x=1.525 //y=7.41 //x2=1.525 //y2=6.585
r617 (  63 315 ) resistor r=2.87058 //w=0.35 //l=0.085 //layer=li \
 //thickness=0.1 //x=1.44 //y=7.585 //x2=1.525 //y2=7.585
r618 (  63 66 ) resistor r=9.24251 //w=0.367 //l=0.265 //layer=li \
 //thickness=0.1 //x=1.44 //y=7.585 //x2=1.175 //y2=7.585
r619 (  47 310 ) resistor r=9.3 //w=0.17 //l=0.17 //layer=mcon //count=1 \
 //x=25.965 //y=7.58 //x2=25.965 //y2=7.58
r620 (  45 300 ) resistor r=3.1 //w=0.17 //l=0.51 //layer=mcon //count=3 \
 //x=25.225 //y=7.58 //x2=25.225 //y2=7.58
r621 (  45 47 ) resistor r=0.297428 //w=0.311 //l=0.74 //layer=m1 \
 //thickness=0.36 //x=25.225 //y=7.585 //x2=25.965 //y2=7.585
r622 (  43 290 ) resistor r=3.1 //w=0.17 //l=0.51 //layer=mcon //count=3 \
 //x=24.115 //y=7.58 //x2=24.115 //y2=7.58
r623 (  43 45 ) resistor r=0.446141 //w=0.311 //l=1.11 //layer=m1 \
 //thickness=0.36 //x=24.115 //y=7.585 //x2=25.225 //y2=7.585
r624 (  41 274 ) resistor r=3.1 //w=0.17 //l=0.51 //layer=mcon //count=3 \
 //x=22.635 //y=7.58 //x2=22.635 //y2=7.58
r625 (  41 43 ) resistor r=0.594855 //w=0.311 //l=1.48 //layer=m1 \
 //thickness=0.36 //x=22.635 //y=7.585 //x2=24.115 //y2=7.585
r626 (  39 264 ) resistor r=3.1 //w=0.17 //l=0.51 //layer=mcon //count=3 \
 //x=21.525 //y=7.58 //x2=21.525 //y2=7.58
r627 (  39 41 ) resistor r=0.446141 //w=0.311 //l=1.11 //layer=m1 \
 //thickness=0.36 //x=21.525 //y=7.585 //x2=22.635 //y2=7.585
r628 (  37 254 ) resistor r=3.1 //w=0.17 //l=0.51 //layer=mcon //count=3 \
 //x=20.415 //y=7.58 //x2=20.415 //y2=7.58
r629 (  37 39 ) resistor r=0.446141 //w=0.311 //l=1.11 //layer=m1 \
 //thickness=0.36 //x=20.415 //y=7.585 //x2=21.525 //y2=7.585
r630 (  35 337 ) resistor r=3.1 //w=0.17 //l=0.51 //layer=mcon //count=3 \
 //x=19.305 //y=7.58 //x2=19.305 //y2=7.58
r631 (  35 37 ) resistor r=0.446141 //w=0.311 //l=1.11 //layer=m1 \
 //thickness=0.36 //x=19.305 //y=7.585 //x2=20.415 //y2=7.585
r632 (  33 230 ) resistor r=3.1 //w=0.17 //l=0.51 //layer=mcon //count=3 \
 //x=17.825 //y=7.58 //x2=17.825 //y2=7.58
r633 (  33 35 ) resistor r=0.594855 //w=0.311 //l=1.48 //layer=m1 \
 //thickness=0.36 //x=17.825 //y=7.585 //x2=19.305 //y2=7.585
r634 (  31 220 ) resistor r=3.1 //w=0.17 //l=0.51 //layer=mcon //count=3 \
 //x=16.715 //y=7.58 //x2=16.715 //y2=7.58
r635 (  31 33 ) resistor r=0.446141 //w=0.311 //l=1.11 //layer=m1 \
 //thickness=0.36 //x=16.715 //y=7.585 //x2=17.825 //y2=7.585
r636 (  29 210 ) resistor r=3.1 //w=0.17 //l=0.51 //layer=mcon //count=3 \
 //x=15.605 //y=7.58 //x2=15.605 //y2=7.58
r637 (  29 31 ) resistor r=0.446141 //w=0.311 //l=1.11 //layer=m1 \
 //thickness=0.36 //x=15.605 //y=7.585 //x2=16.715 //y2=7.585
r638 (  27 331 ) resistor r=3.1 //w=0.17 //l=0.51 //layer=mcon //count=3 \
 //x=14.495 //y=7.58 //x2=14.495 //y2=7.58
r639 (  27 29 ) resistor r=0.446141 //w=0.311 //l=1.11 //layer=m1 \
 //thickness=0.36 //x=14.495 //y=7.585 //x2=15.605 //y2=7.585
r640 (  24 186 ) resistor r=3.1 //w=0.17 //l=0.51 //layer=mcon //count=3 \
 //x=13.015 //y=7.58 //x2=13.015 //y2=7.58
r641 (  22 176 ) resistor r=3.1 //w=0.17 //l=0.51 //layer=mcon //count=3 \
 //x=11.905 //y=7.58 //x2=11.905 //y2=7.58
r642 (  22 24 ) resistor r=0.446141 //w=0.311 //l=1.11 //layer=m1 \
 //thickness=0.36 //x=11.905 //y=7.585 //x2=13.015 //y2=7.585
r643 (  20 326 ) resistor r=3.1 //w=0.17 //l=0.51 //layer=mcon //count=3 \
 //x=10.795 //y=7.58 //x2=10.795 //y2=7.58
r644 (  20 22 ) resistor r=0.446141 //w=0.311 //l=1.11 //layer=m1 \
 //thickness=0.36 //x=10.795 //y=7.585 //x2=11.905 //y2=7.585
r645 (  18 152 ) resistor r=3.1 //w=0.17 //l=0.51 //layer=mcon //count=3 \
 //x=9.315 //y=7.58 //x2=9.315 //y2=7.58
r646 (  18 20 ) resistor r=0.594855 //w=0.311 //l=1.48 //layer=m1 \
 //thickness=0.36 //x=9.315 //y=7.585 //x2=10.795 //y2=7.585
r647 (  16 142 ) resistor r=3.1 //w=0.17 //l=0.51 //layer=mcon //count=3 \
 //x=8.205 //y=7.58 //x2=8.205 //y2=7.58
r648 (  16 18 ) resistor r=0.446141 //w=0.311 //l=1.11 //layer=m1 \
 //thickness=0.36 //x=8.205 //y=7.585 //x2=9.315 //y2=7.585
r649 (  14 124 ) resistor r=3.1 //w=0.17 //l=0.51 //layer=mcon //count=3 \
 //x=7.095 //y=7.58 //x2=7.095 //y2=7.58
r650 (  14 16 ) resistor r=0.446141 //w=0.311 //l=1.11 //layer=m1 \
 //thickness=0.36 //x=7.095 //y=7.585 //x2=8.205 //y2=7.585
r651 (  12 112 ) resistor r=3.1 //w=0.17 //l=0.51 //layer=mcon //count=3 \
 //x=5.985 //y=7.58 //x2=5.985 //y2=7.58
r652 (  12 14 ) resistor r=0.446141 //w=0.311 //l=1.11 //layer=m1 \
 //thickness=0.36 //x=5.985 //y=7.585 //x2=7.095 //y2=7.585
r653 (  10 106 ) resistor r=3.1 //w=0.17 //l=0.51 //layer=mcon //count=3 \
 //x=4.505 //y=7.58 //x2=4.505 //y2=7.58
r654 (  10 12 ) resistor r=0.594855 //w=0.311 //l=1.48 //layer=m1 \
 //thickness=0.36 //x=4.505 //y=7.585 //x2=5.985 //y2=7.585
r655 (  8 96 ) resistor r=3.1 //w=0.17 //l=0.51 //layer=mcon //count=3 \
 //x=3.395 //y=7.58 //x2=3.395 //y2=7.58
r656 (  8 10 ) resistor r=0.446141 //w=0.311 //l=1.11 //layer=m1 \
 //thickness=0.36 //x=3.395 //y=7.585 //x2=4.505 //y2=7.585
r657 (  6 78 ) resistor r=3.1 //w=0.17 //l=0.51 //layer=mcon //count=3 \
 //x=2.285 //y=7.58 //x2=2.285 //y2=7.58
r658 (  6 8 ) resistor r=0.446141 //w=0.311 //l=1.11 //layer=m1 \
 //thickness=0.36 //x=2.285 //y=7.585 //x2=3.395 //y2=7.585
r659 (  3 66 ) resistor r=3.1 //w=0.17 //l=0.51 //layer=mcon //count=3 \
 //x=1.175 //y=7.58 //x2=1.175 //y2=7.58
r660 (  3 6 ) resistor r=0.446141 //w=0.311 //l=1.11 //layer=m1 \
 //thickness=0.36 //x=1.175 //y=7.585 //x2=2.285 //y2=7.585
r661 (  1 27 ) resistor r=0.424035 //w=0.311 //l=1.055 //layer=m1 \
 //thickness=0.36 //x=13.44 //y=7.585 //x2=14.495 //y2=7.585
r662 (  1 24 ) resistor r=0.17082 //w=0.311 //l=0.425 //layer=m1 \
 //thickness=0.36 //x=13.44 //y=7.585 //x2=13.015 //y2=7.585
ends PM_DFFRNQX1\%VDD

subckt PM_DFFRNQX1\%noxref_10 ( 5 7 15 19 30 33 34 )
c64 ( 34 0 ) capacitor c=0.0487212f //x=3.4 //y=0.555
c65 ( 33 0 ) capacitor c=0.0198861f //x=2.295 //y=1.09
c66 ( 30 0 ) capacitor c=0.00141302f //x=3.535 //y=1.175
c67 ( 19 0 ) capacitor c=0.00692795f //x=4.505 //y=0.805
c68 ( 15 0 ) capacitor c=0.0154966f //x=4.42 //y=0.72
c69 ( 7 0 ) capacitor c=0.00689459f //x=3.535 //y=0.805
c70 ( 5 0 ) capacitor c=0.0290436f //x=3.45 //y=1.175
r71 (  19 34 ) resistor r=3.57586 //w=0.17 //l=0.125 //layer=li \
 //thickness=0.1 //x=4.505 //y=0.805 //x2=4.505 //y2=0.68
r72 (  19 34 ) resistor r=18.139 //w=0.187 //l=0.265 //layer=li \
 //thickness=0.1 //x=4.505 //y=0.805 //x2=4.505 //y2=1.07
r73 (  16 34 ) resistor r=3.57586 //w=0.17 //l=0.103078 //layer=li \
 //thickness=0.1 //x=3.62 //y=0.72 //x2=3.535 //y2=0.68
r74 (  16 34 ) resistor r=27.3797 //w=0.187 //l=0.4 //layer=li //thickness=0.1 \
 //x=3.62 //y=0.72 //x2=4.02 //y2=0.72
r75 (  15 34 ) resistor r=3.57586 //w=0.17 //l=0.103078 //layer=li \
 //thickness=0.1 //x=4.42 //y=0.72 //x2=4.505 //y2=0.68
r76 (  15 34 ) resistor r=27.3797 //w=0.187 //l=0.4 //layer=li //thickness=0.1 \
 //x=4.42 //y=0.72 //x2=4.02 //y2=0.72
r77 (  11 30 ) resistor r=5.4201 //w=0.17 //l=0.085 //layer=li //thickness=0.1 \
 //x=3.535 //y=1.26 //x2=3.535 //y2=1.175
r78 (  11 34 ) resistor r=10.2674 //w=0.187 //l=0.15 //layer=li \
 //thickness=0.1 //x=3.535 //y=1.26 //x2=3.535 //y2=1.41
r79 (  8 30 ) resistor r=5.4201 //w=0.17 //l=0.085 //layer=li //thickness=0.1 \
 //x=3.535 //y=1.09 //x2=3.535 //y2=1.175
r80 (  8 34 ) resistor r=1.36898 //w=0.187 //l=0.02 //layer=li //thickness=0.1 \
 //x=3.535 //y=1.09 //x2=3.535 //y2=1.07
r81 (  7 34 ) resistor r=3.57586 //w=0.17 //l=0.125 //layer=li //thickness=0.1 \
 //x=3.535 //y=0.805 //x2=3.535 //y2=0.68
r82 (  7 34 ) resistor r=18.139 //w=0.187 //l=0.265 //layer=li //thickness=0.1 \
 //x=3.535 //y=0.805 //x2=3.535 //y2=1.07
r83 (  6 33 ) resistor r=0.751729 //w=0.17 //l=0.085 //layer=li \
 //thickness=0.1 //x=2.57 //y=1.175 //x2=2.485 //y2=1.175
r84 (  5 30 ) resistor r=1.40859 //w=0.34 //l=0.085 //layer=li //thickness=0.1 \
 //x=3.45 //y=1.175 //x2=3.535 //y2=1.175
r85 (  5 6 ) resistor r=60.2353 //w=0.187 //l=0.88 //layer=li //thickness=0.1 \
 //x=3.45 //y=1.175 //x2=2.57 //y2=1.175
ends PM_DFFRNQX1\%noxref_10

subckt PM_DFFRNQX1\%noxref_11 ( 5 7 15 19 30 33 34 )
c67 ( 34 0 ) capacitor c=0.0454839f //x=8.21 //y=0.555
c68 ( 33 0 ) capacitor c=0.0198007f //x=7.105 //y=1.09
c69 ( 30 0 ) capacitor c=0.00141302f //x=8.345 //y=1.175
c70 ( 19 0 ) capacitor c=0.00695768f //x=9.315 //y=0.805
c71 ( 15 0 ) capacitor c=0.0153419f //x=9.23 //y=0.72
c72 ( 7 0 ) capacitor c=0.00689476f //x=8.345 //y=0.805
c73 ( 5 0 ) capacitor c=0.0290436f //x=8.26 //y=1.175
r74 (  19 34 ) resistor r=3.57586 //w=0.17 //l=0.125 //layer=li \
 //thickness=0.1 //x=9.315 //y=0.805 //x2=9.315 //y2=0.68
r75 (  19 34 ) resistor r=18.139 //w=0.187 //l=0.265 //layer=li \
 //thickness=0.1 //x=9.315 //y=0.805 //x2=9.315 //y2=1.07
r76 (  16 34 ) resistor r=3.57586 //w=0.17 //l=0.103078 //layer=li \
 //thickness=0.1 //x=8.43 //y=0.72 //x2=8.345 //y2=0.68
r77 (  16 34 ) resistor r=27.3797 //w=0.187 //l=0.4 //layer=li //thickness=0.1 \
 //x=8.43 //y=0.72 //x2=8.83 //y2=0.72
r78 (  15 34 ) resistor r=3.57586 //w=0.17 //l=0.103078 //layer=li \
 //thickness=0.1 //x=9.23 //y=0.72 //x2=9.315 //y2=0.68
r79 (  15 34 ) resistor r=27.3797 //w=0.187 //l=0.4 //layer=li //thickness=0.1 \
 //x=9.23 //y=0.72 //x2=8.83 //y2=0.72
r80 (  11 30 ) resistor r=5.4201 //w=0.17 //l=0.085 //layer=li //thickness=0.1 \
 //x=8.345 //y=1.26 //x2=8.345 //y2=1.175
r81 (  11 34 ) resistor r=10.2674 //w=0.187 //l=0.15 //layer=li \
 //thickness=0.1 //x=8.345 //y=1.26 //x2=8.345 //y2=1.41
r82 (  8 30 ) resistor r=5.4201 //w=0.17 //l=0.085 //layer=li //thickness=0.1 \
 //x=8.345 //y=1.09 //x2=8.345 //y2=1.175
r83 (  8 34 ) resistor r=1.36898 //w=0.187 //l=0.02 //layer=li //thickness=0.1 \
 //x=8.345 //y=1.09 //x2=8.345 //y2=1.07
r84 (  7 34 ) resistor r=3.57586 //w=0.17 //l=0.125 //layer=li //thickness=0.1 \
 //x=8.345 //y=0.805 //x2=8.345 //y2=0.68
r85 (  7 34 ) resistor r=18.139 //w=0.187 //l=0.265 //layer=li //thickness=0.1 \
 //x=8.345 //y=0.805 //x2=8.345 //y2=1.07
r86 (  6 33 ) resistor r=0.751729 //w=0.17 //l=0.085 //layer=li \
 //thickness=0.1 //x=7.38 //y=1.175 //x2=7.295 //y2=1.175
r87 (  5 30 ) resistor r=1.40859 //w=0.34 //l=0.085 //layer=li //thickness=0.1 \
 //x=8.26 //y=1.175 //x2=8.345 //y2=1.175
r88 (  5 6 ) resistor r=60.2353 //w=0.187 //l=0.88 //layer=li //thickness=0.1 \
 //x=8.26 //y=1.175 //x2=7.38 //y2=1.175
ends PM_DFFRNQX1\%noxref_11

subckt PM_DFFRNQX1\%D ( 1 2 3 4 12 17 21 22 23 24 25 26 28 34 35 36 37 38 46 )
c123 ( 46 0 ) capacitor c=0.0369044f //x=7.465 //y=4.88
c124 ( 38 0 ) capacitor c=0.0309248f //x=7.8 //y=4.97
c125 ( 37 0 ) capacitor c=0.0863671f //x=7.555 //y=2.095
c126 ( 36 0 ) capacitor c=0.0170266f //x=7.555 //y=1.63
c127 ( 35 0 ) capacitor c=0.018609f //x=7.555 //y=1.4
c128 ( 34 0 ) capacitor c=0.0186599f //x=7.555 //y=1.09
c129 ( 28 0 ) capacitor c=0.0146988f //x=7.4 //y=1.555
c130 ( 26 0 ) capacitor c=0.0148531f //x=7.4 //y=0.935
c131 ( 25 0 ) capacitor c=0.0334406f //x=7.03 //y=1.4
c132 ( 24 0 ) capacitor c=0.0173191f //x=7.03 //y=1.09
c133 ( 23 0 ) capacitor c=0.110208f //x=7.875 //y=6.2
c134 ( 22 0 ) capacitor c=0.110214f //x=7.435 //y=6.2
c135 ( 17 0 ) capacitor c=0.00129935f //x=7.465 //y=4.88
c136 ( 12 0 ) capacitor c=0.00121786f //x=7.465 //y=2.26
c137 ( 4 0 ) capacitor c=0.0050946f //x=7.465 //y=4.765
c138 ( 3 0 ) capacitor c=0.00586341f //x=7.465 //y=2.375
c139 ( 1 0 ) capacitor c=0.0677231f //x=7.465 //y=2.77
r140 (  48 49 ) resistor r=32.4568 //w=0.214 //l=0.075 //layer=ply \
 //thickness=0.18 //x=7.465 //y=4.97 //x2=7.465 //y2=5.045
r141 (  46 48 ) resistor r=20.271 //w=0.214 //l=0.09 //layer=ply \
 //thickness=0.18 //x=7.465 //y=4.88 //x2=7.465 //y2=4.97
r142 (  39 48 ) resistor r=16.5046 //w=0.27 //l=0.135 //layer=ply \
 //thickness=0.18 //x=7.6 //y=4.97 //x2=7.465 //y2=4.97
r143 (  38 40 ) resistor r=26.9307 //w=0.15 //l=0.106066 //layer=ply \
 //thickness=0.18 //x=7.8 //y=4.97 //x2=7.875 //y2=5.045
r144 (  38 39 ) resistor r=102.553 //w=0.094 //l=0.2 //layer=ply \
 //thickness=0.18 //x=7.8 //y=4.97 //x2=7.6 //y2=4.97
r145 (  37 53 ) resistor r=38.6777 //w=0.284 //l=0.198997 //layer=ply \
 //thickness=0.18 //x=7.555 //y=2.095 //x2=7.48 //y2=2.26
r146 (  36 51 ) resistor r=21.2976 //w=0.217 //l=0.0928709 //layer=ply \
 //thickness=0.18 //x=7.555 //y=1.63 //x2=7.515 //y2=1.555
r147 (  36 37 ) resistor r=238.436 //w=0.094 //l=0.465 //layer=ply \
 //thickness=0.18 //x=7.555 //y=1.63 //x2=7.555 //y2=2.095
r148 (  35 51 ) resistor r=39.0671 //w=0.217 //l=0.173853 //layer=ply \
 //thickness=0.18 //x=7.555 //y=1.4 //x2=7.515 //y2=1.555
r149 (  34 50 ) resistor r=45.1352 //w=0.168 //l=0.173853 //layer=ply \
 //thickness=0.18 //x=7.555 //y=1.09 //x2=7.515 //y2=0.935
r150 (  34 35 ) resistor r=158.957 //w=0.094 //l=0.31 //layer=ply \
 //thickness=0.18 //x=7.555 //y=1.09 //x2=7.555 //y2=1.4
r151 (  29 44 ) resistor r=5.52526 //w=0.168 //l=0.115 //layer=ply \
 //thickness=0.18 //x=7.185 //y=1.555 //x2=7.07 //y2=1.555
r152 (  28 51 ) resistor r=11.4558 //w=0.217 //l=0.115 //layer=ply \
 //thickness=0.18 //x=7.4 //y=1.555 //x2=7.515 //y2=1.555
r153 (  27 43 ) resistor r=5.52526 //w=0.168 //l=0.115 //layer=ply \
 //thickness=0.18 //x=7.185 //y=0.935 //x2=7.07 //y2=0.935
r154 (  26 50 ) resistor r=5.52526 //w=0.168 //l=0.115 //layer=ply \
 //thickness=0.18 //x=7.4 //y=0.935 //x2=7.515 //y2=0.935
r155 (  26 27 ) resistor r=110.245 //w=0.094 //l=0.215 //layer=ply \
 //thickness=0.18 //x=7.4 //y=0.935 //x2=7.185 //y2=0.935
r156 (  25 44 ) resistor r=45.1352 //w=0.168 //l=0.173853 //layer=ply \
 //thickness=0.18 //x=7.03 //y=1.4 //x2=7.07 //y2=1.555
r157 (  24 43 ) resistor r=45.1352 //w=0.168 //l=0.173853 //layer=ply \
 //thickness=0.18 //x=7.03 //y=1.09 //x2=7.07 //y2=0.935
r158 (  24 25 ) resistor r=158.957 //w=0.094 //l=0.31 //layer=ply \
 //thickness=0.18 //x=7.03 //y=1.09 //x2=7.03 //y2=1.4
r159 (  23 40 ) resistor r=592.245 //w=0.094 //l=1.155 //layer=ply \
 //thickness=0.18 //x=7.875 //y=6.2 //x2=7.875 //y2=5.045
r160 (  22 49 ) resistor r=592.245 //w=0.094 //l=1.155 //layer=ply \
 //thickness=0.18 //x=7.435 //y=6.2 //x2=7.435 //y2=5.045
r161 (  21 28 ) resistor r=55.3787 //w=0.094 //l=0.108 //layer=ply \
 //thickness=0.18 //x=7.292 //y=1.555 //x2=7.4 //y2=1.555
r162 (  21 29 ) resistor r=54.866 //w=0.094 //l=0.107 //layer=ply \
 //thickness=0.18 //x=7.292 //y=1.555 //x2=7.185 //y2=1.555
r163 (  17 46 ) resistor r=152 //w=0.17 //l=0.17 //layer=licon //count=1 \
 //x=7.465 //y=4.88 //x2=7.465 //y2=4.88
r164 (  12 53 ) resistor r=152 //w=0.17 //l=0.17 //layer=licon //count=1 \
 //x=7.465 //y=2.26 //x2=7.465 //y2=2.26
r165 (  10 17 ) resistor r=9.3 //w=0.17 //l=0.17 //layer=mcon //count=1 \
 //x=7.465 //y=4.88 //x2=7.465 //y2=4.88
r166 (  8 12 ) resistor r=9.3 //w=0.17 //l=0.17 //layer=mcon //count=1 \
 //x=7.465 //y=2.26 //x2=7.465 //y2=2.26
r167 (  4 10 ) resistor r=0.0717383 //w=0.224 //l=0.115 //layer=m1 \
 //thickness=0.36 //x=7.465 //y=4.765 //x2=7.465 //y2=4.88
r168 (  3 8 ) resistor r=0.0715665 //w=0.226 //l=0.115996 //layer=m1 \
 //thickness=0.36 //x=7.465 //y=2.375 //x2=7.467 //y2=2.26
r169 (  2 4 ) resistor r=1.55057 //w=0.131 //l=1.625 //layer=m1 \
 //thickness=0.36 //x=7.465 //y=3.14 //x2=7.465 //y2=4.765
r170 (  1 2 ) resistor r=0.353053 //w=0.131 //l=0.37 //layer=m1 \
 //thickness=0.36 //x=7.465 //y=2.77 //x2=7.465 //y2=3.14
r171 (  1 3 ) resistor r=0.376908 //w=0.131 //l=0.395 //layer=m1 \
 //thickness=0.36 //x=7.465 //y=2.77 //x2=7.465 //y2=2.375
ends PM_DFFRNQX1\%D

subckt PM_DFFRNQX1\%noxref_13 ( 5 7 15 19 30 33 34 )
c69 ( 34 0 ) capacitor c=0.0455032f //x=16.35 //y=0.555
c70 ( 33 0 ) capacitor c=0.019478f //x=15.245 //y=1.09
c71 ( 30 0 ) capacitor c=0.00141302f //x=16.485 //y=1.175
c72 ( 19 0 ) capacitor c=0.00692795f //x=17.455 //y=0.805
c73 ( 15 0 ) capacitor c=0.0153419f //x=17.37 //y=0.72
c74 ( 7 0 ) capacitor c=0.00689459f //x=16.485 //y=0.805
c75 ( 5 0 ) capacitor c=0.0237752f //x=16.4 //y=1.175
r76 (  19 34 ) resistor r=3.57586 //w=0.17 //l=0.125 //layer=li \
 //thickness=0.1 //x=17.455 //y=0.805 //x2=17.455 //y2=0.68
r77 (  19 34 ) resistor r=18.139 //w=0.187 //l=0.265 //layer=li \
 //thickness=0.1 //x=17.455 //y=0.805 //x2=17.455 //y2=1.07
r78 (  16 34 ) resistor r=3.57586 //w=0.17 //l=0.103078 //layer=li \
 //thickness=0.1 //x=16.57 //y=0.72 //x2=16.485 //y2=0.68
r79 (  16 34 ) resistor r=27.3797 //w=0.187 //l=0.4 //layer=li //thickness=0.1 \
 //x=16.57 //y=0.72 //x2=16.97 //y2=0.72
r80 (  15 34 ) resistor r=3.57586 //w=0.17 //l=0.103078 //layer=li \
 //thickness=0.1 //x=17.37 //y=0.72 //x2=17.455 //y2=0.68
r81 (  15 34 ) resistor r=27.3797 //w=0.187 //l=0.4 //layer=li //thickness=0.1 \
 //x=17.37 //y=0.72 //x2=16.97 //y2=0.72
r82 (  11 30 ) resistor r=5.4201 //w=0.17 //l=0.085 //layer=li //thickness=0.1 \
 //x=16.485 //y=1.26 //x2=16.485 //y2=1.175
r83 (  11 34 ) resistor r=10.2674 //w=0.187 //l=0.15 //layer=li \
 //thickness=0.1 //x=16.485 //y=1.26 //x2=16.485 //y2=1.41
r84 (  8 30 ) resistor r=5.4201 //w=0.17 //l=0.085 //layer=li //thickness=0.1 \
 //x=16.485 //y=1.09 //x2=16.485 //y2=1.175
r85 (  8 34 ) resistor r=1.36898 //w=0.187 //l=0.02 //layer=li //thickness=0.1 \
 //x=16.485 //y=1.09 //x2=16.485 //y2=1.07
r86 (  7 34 ) resistor r=3.57586 //w=0.17 //l=0.125 //layer=li //thickness=0.1 \
 //x=16.485 //y=0.805 //x2=16.485 //y2=0.68
r87 (  7 34 ) resistor r=18.139 //w=0.187 //l=0.265 //layer=li //thickness=0.1 \
 //x=16.485 //y=0.805 //x2=16.485 //y2=1.07
r88 (  6 33 ) resistor r=0.751729 //w=0.17 //l=0.085 //layer=li \
 //thickness=0.1 //x=15.52 //y=1.175 //x2=15.435 //y2=1.175
r89 (  5 30 ) resistor r=1.40859 //w=0.34 //l=0.085 //layer=li //thickness=0.1 \
 //x=16.4 //y=1.175 //x2=16.485 //y2=1.175
r90 (  5 6 ) resistor r=60.2353 //w=0.187 //l=0.88 //layer=li //thickness=0.1 \
 //x=16.4 //y=1.175 //x2=15.52 //y2=1.175
ends PM_DFFRNQX1\%noxref_13

subckt PM_DFFRNQX1\%noxref_14 ( 5 7 15 19 30 33 34 )
c67 ( 34 0 ) capacitor c=0.0483319f //x=21.16 //y=0.555
c68 ( 33 0 ) capacitor c=0.0186047f //x=20.055 //y=1.09
c69 ( 30 0 ) capacitor c=0.00141302f //x=21.295 //y=1.175
c70 ( 19 0 ) capacitor c=0.00695768f //x=22.265 //y=0.805
c71 ( 15 0 ) capacitor c=0.0154874f //x=22.18 //y=0.72
c72 ( 7 0 ) capacitor c=0.00689476f //x=21.295 //y=0.805
c73 ( 5 0 ) capacitor c=0.0290436f //x=21.21 //y=1.175
r74 (  19 34 ) resistor r=3.57586 //w=0.17 //l=0.125 //layer=li \
 //thickness=0.1 //x=22.265 //y=0.805 //x2=22.265 //y2=0.68
r75 (  19 34 ) resistor r=18.139 //w=0.187 //l=0.265 //layer=li \
 //thickness=0.1 //x=22.265 //y=0.805 //x2=22.265 //y2=1.07
r76 (  16 34 ) resistor r=3.57586 //w=0.17 //l=0.103078 //layer=li \
 //thickness=0.1 //x=21.38 //y=0.72 //x2=21.295 //y2=0.68
r77 (  16 34 ) resistor r=27.3797 //w=0.187 //l=0.4 //layer=li //thickness=0.1 \
 //x=21.38 //y=0.72 //x2=21.78 //y2=0.72
r78 (  15 34 ) resistor r=3.57586 //w=0.17 //l=0.103078 //layer=li \
 //thickness=0.1 //x=22.18 //y=0.72 //x2=22.265 //y2=0.68
r79 (  15 34 ) resistor r=27.3797 //w=0.187 //l=0.4 //layer=li //thickness=0.1 \
 //x=22.18 //y=0.72 //x2=21.78 //y2=0.72
r80 (  11 30 ) resistor r=5.4201 //w=0.17 //l=0.085 //layer=li //thickness=0.1 \
 //x=21.295 //y=1.26 //x2=21.295 //y2=1.175
r81 (  11 34 ) resistor r=10.2674 //w=0.187 //l=0.15 //layer=li \
 //thickness=0.1 //x=21.295 //y=1.26 //x2=21.295 //y2=1.41
r82 (  8 30 ) resistor r=5.4201 //w=0.17 //l=0.085 //layer=li //thickness=0.1 \
 //x=21.295 //y=1.09 //x2=21.295 //y2=1.175
r83 (  8 34 ) resistor r=1.36898 //w=0.187 //l=0.02 //layer=li //thickness=0.1 \
 //x=21.295 //y=1.09 //x2=21.295 //y2=1.07
r84 (  7 34 ) resistor r=3.57586 //w=0.17 //l=0.125 //layer=li //thickness=0.1 \
 //x=21.295 //y=0.805 //x2=21.295 //y2=0.68
r85 (  7 34 ) resistor r=18.139 //w=0.187 //l=0.265 //layer=li //thickness=0.1 \
 //x=21.295 //y=0.805 //x2=21.295 //y2=1.07
r86 (  6 33 ) resistor r=0.751729 //w=0.17 //l=0.085 //layer=li \
 //thickness=0.1 //x=20.33 //y=1.175 //x2=20.245 //y2=1.175
r87 (  5 30 ) resistor r=1.40859 //w=0.34 //l=0.085 //layer=li //thickness=0.1 \
 //x=21.21 //y=1.175 //x2=21.295 //y2=1.175
r88 (  5 6 ) resistor r=60.2353 //w=0.187 //l=0.88 //layer=li //thickness=0.1 \
 //x=21.21 //y=1.175 //x2=20.33 //y2=1.175
ends PM_DFFRNQX1\%noxref_14

subckt PM_DFFRNQX1\%GND ( 1 2 6 7 18 19 31 39 40 49 50 64 67 71 75 76 80 85 90 \
 91 97 100 114 131 146 163 187 197 198 199 200 201 203 204 205 206 207 208 )
c459 ( 208 0 ) capacitor c=0.00843555f //x=23.995 //y=1.045
c460 ( 207 0 ) capacitor c=0.00840423f //x=19.08 //y=1.055
c461 ( 206 0 ) capacitor c=0.00840423f //x=14.27 //y=1.055
c462 ( 205 0 ) capacitor c=0.00843555f //x=11.045 //y=1.045
c463 ( 204 0 ) capacitor c=0.00840423f //x=6.13 //y=1.055
c464 ( 203 0 ) capacitor c=0.00840423f //x=1.32 //y=1.055
c465 ( 201 0 ) capacitor c=0.118839f //x=23.005 //y=0.175
c466 ( 200 0 ) capacitor c=0.11457f //x=18.195 //y=0.175
c467 ( 199 0 ) capacitor c=0.11301f //x=13.385 //y=0.175
c468 ( 198 0 ) capacitor c=0.119155f //x=10.055 //y=0.175
c469 ( 197 0 ) capacitor c=0.113716f //x=5.245 //y=0.175
c470 ( 187 0 ) capacitor c=0.339303f //x=25.965 //y=0.18
c471 ( 163 0 ) capacitor c=0.176839f //x=22.835 //y=0.175
c472 ( 146 0 ) capacitor c=0.176416f //x=18.025 //y=0.175
c473 ( 131 0 ) capacitor c=0.118875f //x=13.215 //y=0.175
c474 ( 114 0 ) capacitor c=0.177393f //x=9.885 //y=0.175
c475 ( 100 0 ) capacitor c=0.193915f //x=1.175 //y=0.18
c476 ( 97 0 ) capacitor c=0.181456f //x=5.075 //y=0.175
c477 ( 94 0 ) capacitor c=0.00509083f //x=24.115 //y=0.18
c478 ( 91 0 ) capacitor c=0.0278993f //x=24.182 //y=1.005
c479 ( 90 0 ) capacitor c=0.0139829f //x=24.185 //y=1.135
c480 ( 88 0 ) capacitor c=0.00509414f //x=19.305 //y=0.18
c481 ( 85 0 ) capacitor c=0.0140966f //x=19.27 //y=1.145
c482 ( 83 0 ) capacitor c=0.00509414f //x=14.495 //y=0.18
c483 ( 80 0 ) capacitor c=0.013104f //x=14.46 //y=1.145
c484 ( 78 0 ) capacitor c=0.00509083f //x=11.235 //y=0.175
c485 ( 76 0 ) capacitor c=0.0234055f //x=11.232 //y=1.005
c486 ( 75 0 ) capacitor c=0.01353f //x=11.235 //y=1.135
c487 ( 73 0 ) capacitor c=0.00509414f //x=6.32 //y=0.175
c488 ( 71 0 ) capacitor c=0.0143507f //x=6.32 //y=1.145
c489 ( 69 0 ) capacitor c=0.00509414f //x=1.51 //y=0.175
c490 ( 67 0 ) capacitor c=0.0170404f //x=1.51 //y=1.145
c491 ( 64 0 ) capacitor c=0.105231f //x=25.965 //y=0.18
c492 ( 50 0 ) capacitor c=0.154578f //x=24.1 //y=0.175
c493 ( 49 0 ) capacitor c=0.0302305f //x=19.27 //y=1.015
c494 ( 40 0 ) capacitor c=0.150267f //x=19.185 //y=0.175
c495 ( 39 0 ) capacitor c=0.0253397f //x=14.46 //y=1.015
c496 ( 31 0 ) capacitor c=0.105424f //x=14.375 //y=0.175
c497 ( 19 0 ) capacitor c=0.154392f //x=11.15 //y=0.175
c498 ( 18 0 ) capacitor c=0.0302305f //x=6.32 //y=1.015
c499 ( 7 0 ) capacitor c=0.149367f //x=6.235 //y=0.175
c500 ( 6 0 ) capacitor c=0.0302305f //x=1.51 //y=1.015
c501 ( 2 0 ) capacitor c=0.0680864f //x=1.425 //y=0.175
r502 (  185 187 ) resistor r=25.8093 //w=0.367 //l=0.74 //layer=li \
 //thickness=0.1 //x=25.225 //y=0.175 //x2=25.965 //y2=0.175
r503 (  183 185 ) resistor r=38.7139 //w=0.367 //l=1.11 //layer=li \
 //thickness=0.1 //x=24.115 //y=0.175 //x2=25.225 //y2=0.175
r504 (  181 201 ) resistor r=5.29055 //w=0.35 //l=0.17 //layer=li \
 //thickness=0.1 //x=23.175 //y=0.175 //x2=23.005 //y2=0.175
r505 (  181 183 ) resistor r=32.7847 //w=0.367 //l=0.94 //layer=li \
 //thickness=0.1 //x=23.175 //y=0.175 //x2=24.115 //y2=0.175
r506 (  170 172 ) resistor r=38.7139 //w=0.367 //l=1.11 //layer=li \
 //thickness=0.1 //x=21.525 //y=0.175 //x2=22.635 //y2=0.175
r507 (  168 170 ) resistor r=38.7139 //w=0.367 //l=1.11 //layer=li \
 //thickness=0.1 //x=20.415 //y=0.175 //x2=21.525 //y2=0.175
r508 (  166 168 ) resistor r=38.7139 //w=0.367 //l=1.11 //layer=li \
 //thickness=0.1 //x=19.305 //y=0.175 //x2=20.415 //y2=0.175
r509 (  164 200 ) resistor r=5.29055 //w=0.35 //l=0.17 //layer=li \
 //thickness=0.1 //x=18.365 //y=0.175 //x2=18.195 //y2=0.175
r510 (  164 166 ) resistor r=32.7847 //w=0.367 //l=0.94 //layer=li \
 //thickness=0.1 //x=18.365 //y=0.175 //x2=19.305 //y2=0.175
r511 (  163 201 ) resistor r=5.29055 //w=0.35 //l=0.17 //layer=li \
 //thickness=0.1 //x=22.835 //y=0.175 //x2=23.005 //y2=0.175
r512 (  163 172 ) resistor r=6.97548 //w=0.367 //l=0.2 //layer=li \
 //thickness=0.1 //x=22.835 //y=0.175 //x2=22.635 //y2=0.175
r513 (  153 155 ) resistor r=38.7139 //w=0.367 //l=1.11 //layer=li \
 //thickness=0.1 //x=16.715 //y=0.175 //x2=17.825 //y2=0.175
r514 (  151 153 ) resistor r=38.7139 //w=0.367 //l=1.11 //layer=li \
 //thickness=0.1 //x=15.605 //y=0.175 //x2=16.715 //y2=0.175
r515 (  149 151 ) resistor r=38.7139 //w=0.367 //l=1.11 //layer=li \
 //thickness=0.1 //x=14.495 //y=0.175 //x2=15.605 //y2=0.175
r516 (  147 199 ) resistor r=5.29055 //w=0.35 //l=0.17 //layer=li \
 //thickness=0.1 //x=13.555 //y=0.175 //x2=13.385 //y2=0.175
r517 (  147 149 ) resistor r=32.7847 //w=0.367 //l=0.94 //layer=li \
 //thickness=0.1 //x=13.555 //y=0.175 //x2=14.495 //y2=0.175
r518 (  146 200 ) resistor r=5.29055 //w=0.35 //l=0.17 //layer=li \
 //thickness=0.1 //x=18.025 //y=0.175 //x2=18.195 //y2=0.175
r519 (  146 155 ) resistor r=6.97548 //w=0.367 //l=0.2 //layer=li \
 //thickness=0.1 //x=18.025 //y=0.175 //x2=17.825 //y2=0.175
r520 (  136 138 ) resistor r=38.7139 //w=0.367 //l=1.11 //layer=li \
 //thickness=0.1 //x=11.905 //y=0.175 //x2=13.015 //y2=0.175
r521 (  134 136 ) resistor r=38.7139 //w=0.367 //l=1.11 //layer=li \
 //thickness=0.1 //x=10.795 //y=0.175 //x2=11.905 //y2=0.175
r522 (  132 198 ) resistor r=5.29055 //w=0.35 //l=0.17 //layer=li \
 //thickness=0.1 //x=10.225 //y=0.175 //x2=10.055 //y2=0.175
r523 (  132 134 ) resistor r=19.8801 //w=0.367 //l=0.57 //layer=li \
 //thickness=0.1 //x=10.225 //y=0.175 //x2=10.795 //y2=0.175
r524 (  131 199 ) resistor r=5.29055 //w=0.35 //l=0.17 //layer=li \
 //thickness=0.1 //x=13.215 //y=0.175 //x2=13.385 //y2=0.175
r525 (  131 138 ) resistor r=6.97548 //w=0.367 //l=0.2 //layer=li \
 //thickness=0.1 //x=13.215 //y=0.175 //x2=13.015 //y2=0.175
r526 (  121 123 ) resistor r=38.7139 //w=0.367 //l=1.11 //layer=li \
 //thickness=0.1 //x=8.205 //y=0.175 //x2=9.315 //y2=0.175
r527 (  119 121 ) resistor r=38.7139 //w=0.367 //l=1.11 //layer=li \
 //thickness=0.1 //x=7.095 //y=0.175 //x2=8.205 //y2=0.175
r528 (  117 119 ) resistor r=38.7139 //w=0.367 //l=1.11 //layer=li \
 //thickness=0.1 //x=5.985 //y=0.175 //x2=7.095 //y2=0.175
r529 (  115 197 ) resistor r=5.29055 //w=0.35 //l=0.17 //layer=li \
 //thickness=0.1 //x=5.415 //y=0.175 //x2=5.245 //y2=0.175
r530 (  115 117 ) resistor r=19.8801 //w=0.367 //l=0.57 //layer=li \
 //thickness=0.1 //x=5.415 //y=0.175 //x2=5.985 //y2=0.175
r531 (  114 198 ) resistor r=5.29055 //w=0.35 //l=0.17 //layer=li \
 //thickness=0.1 //x=9.885 //y=0.175 //x2=10.055 //y2=0.175
r532 (  114 123 ) resistor r=19.8801 //w=0.367 //l=0.57 //layer=li \
 //thickness=0.1 //x=9.885 //y=0.175 //x2=9.315 //y2=0.175
r533 (  104 106 ) resistor r=38.7139 //w=0.367 //l=1.11 //layer=li \
 //thickness=0.1 //x=3.395 //y=0.175 //x2=4.505 //y2=0.175
r534 (  102 104 ) resistor r=38.7139 //w=0.367 //l=1.11 //layer=li \
 //thickness=0.1 //x=2.285 //y=0.175 //x2=3.395 //y2=0.175
r535 (  100 102 ) resistor r=38.7139 //w=0.367 //l=1.11 //layer=li \
 //thickness=0.1 //x=1.175 //y=0.175 //x2=2.285 //y2=0.175
r536 (  97 197 ) resistor r=5.29055 //w=0.35 //l=0.17 //layer=li \
 //thickness=0.1 //x=5.075 //y=0.175 //x2=5.245 //y2=0.175
r537 (  97 106 ) resistor r=19.8801 //w=0.367 //l=0.57 //layer=li \
 //thickness=0.1 //x=5.075 //y=0.175 //x2=4.505 //y2=0.175
r538 (  94 183 ) resistor r=3.1 //w=0.17 //l=0.51 //layer=mcon //count=3 \
 //x=24.115 //y=0.18 //x2=24.115 //y2=0.18
r539 (  90 208 ) resistor r=9.3 //w=0.17 //l=0.17 //layer=mcon //count=1 \
 //x=24.185 //y=1.135 //x2=24.185 //y2=1.135
r540 (  90 91 ) resistor r=0.0939994 //w=0.226 //l=0.13 //layer=m1 \
 //thickness=0.36 //x=24.182 //y=1.135 //x2=24.182 //y2=1.005
r541 (  88 166 ) resistor r=3.1 //w=0.17 //l=0.51 //layer=mcon //count=3 \
 //x=19.305 //y=0.18 //x2=19.305 //y2=0.18
r542 (  85 207 ) resistor r=9.3 //w=0.17 //l=0.17 //layer=mcon //count=1 \
 //x=19.27 //y=1.145 //x2=19.27 //y2=1.145
r543 (  83 149 ) resistor r=3.1 //w=0.17 //l=0.51 //layer=mcon //count=3 \
 //x=14.495 //y=0.18 //x2=14.495 //y2=0.18
r544 (  80 206 ) resistor r=9.3 //w=0.17 //l=0.17 //layer=mcon //count=1 \
 //x=14.46 //y=1.145 //x2=14.46 //y2=1.145
r545 (  75 205 ) resistor r=9.3 //w=0.17 //l=0.17 //layer=mcon //count=1 \
 //x=11.235 //y=1.135 //x2=11.235 //y2=1.135
r546 (  75 76 ) resistor r=0.0939994 //w=0.226 //l=0.13 //layer=m1 \
 //thickness=0.36 //x=11.232 //y=1.135 //x2=11.232 //y2=1.005
r547 (  71 204 ) resistor r=9.3 //w=0.17 //l=0.17 //layer=mcon //count=1 \
 //x=6.32 //y=1.145 //x2=6.32 //y2=1.145
r548 (  67 203 ) resistor r=9.3 //w=0.17 //l=0.17 //layer=mcon //count=1 \
 //x=1.51 //y=1.145 //x2=1.51 //y2=1.145
r549 (  64 187 ) resistor r=9.3 //w=0.17 //l=0.17 //layer=mcon //count=1 \
 //x=25.965 //y=0.18 //x2=25.965 //y2=0.18
r550 (  62 185 ) resistor r=3.1 //w=0.17 //l=0.51 //layer=mcon //count=3 \
 //x=25.225 //y=0.18 //x2=25.225 //y2=0.18
r551 (  62 64 ) resistor r=0.297428 //w=0.311 //l=0.74 //layer=m1 \
 //thickness=0.36 //x=25.225 //y=0.175 //x2=25.965 //y2=0.175
r552 (  60 94 ) resistor r=0.028033 //w=0.35 //l=0.085 //layer=m1 \
 //thickness=0.36 //x=24.27 //y=0.175 //x2=24.185 //y2=0.175
r553 (  60 62 ) resistor r=0.383842 //w=0.311 //l=0.955 //layer=m1 \
 //thickness=0.36 //x=24.27 //y=0.175 //x2=25.225 //y2=0.175
r554 (  58 94 ) resistor r=0.0413265 //w=0.7 //l=0.175 //layer=m1 \
 //thickness=0.36 //x=24.185 //y=0.35 //x2=24.185 //y2=0.175
r555 (  58 91 ) resistor r=0.625 //w=0.131 //l=0.655 //layer=m1 \
 //thickness=0.36 //x=24.185 //y=0.35 //x2=24.185 //y2=1.005
r556 (  57 172 ) resistor r=3.1 //w=0.17 //l=0.51 //layer=mcon //count=3 \
 //x=22.635 //y=0.18 //x2=22.635 //y2=0.18
r557 (  55 170 ) resistor r=3.1 //w=0.17 //l=0.51 //layer=mcon //count=3 \
 //x=21.525 //y=0.18 //x2=21.525 //y2=0.18
r558 (  55 57 ) resistor r=0.446141 //w=0.311 //l=1.11 //layer=m1 \
 //thickness=0.36 //x=21.525 //y=0.175 //x2=22.635 //y2=0.175
r559 (  53 168 ) resistor r=3.1 //w=0.17 //l=0.51 //layer=mcon //count=3 \
 //x=20.415 //y=0.18 //x2=20.415 //y2=0.18
r560 (  53 55 ) resistor r=0.446141 //w=0.311 //l=1.11 //layer=m1 \
 //thickness=0.36 //x=20.415 //y=0.175 //x2=21.525 //y2=0.175
r561 (  51 88 ) resistor r=0.028033 //w=0.35 //l=0.085 //layer=m1 \
 //thickness=0.36 //x=19.355 //y=0.175 //x2=19.27 //y2=0.175
r562 (  51 53 ) resistor r=0.426045 //w=0.311 //l=1.06 //layer=m1 \
 //thickness=0.36 //x=19.355 //y=0.175 //x2=20.415 //y2=0.175
r563 (  50 94 ) resistor r=0.028033 //w=0.35 //l=0.085 //layer=m1 \
 //thickness=0.36 //x=24.1 //y=0.175 //x2=24.185 //y2=0.175
r564 (  50 57 ) resistor r=0.588826 //w=0.311 //l=1.465 //layer=m1 \
 //thickness=0.36 //x=24.1 //y=0.175 //x2=22.635 //y2=0.175
r565 (  49 85 ) resistor r=0.0942778 //w=0.221 //l=0.13 //layer=m1 \
 //thickness=0.36 //x=19.27 //y=1.015 //x2=19.27 //y2=1.145
r566 (  48 88 ) resistor r=0.0413265 //w=0.7 //l=0.175 //layer=m1 \
 //thickness=0.36 //x=19.27 //y=0.35 //x2=19.27 //y2=0.175
r567 (  48 49 ) resistor r=0.634542 //w=0.131 //l=0.665 //layer=m1 \
 //thickness=0.36 //x=19.27 //y=0.35 //x2=19.27 //y2=1.015
r568 (  47 155 ) resistor r=3.1 //w=0.17 //l=0.51 //layer=mcon //count=3 \
 //x=17.825 //y=0.18 //x2=17.825 //y2=0.18
r569 (  45 153 ) resistor r=3.1 //w=0.17 //l=0.51 //layer=mcon //count=3 \
 //x=16.715 //y=0.18 //x2=16.715 //y2=0.18
r570 (  45 47 ) resistor r=0.446141 //w=0.311 //l=1.11 //layer=m1 \
 //thickness=0.36 //x=16.715 //y=0.175 //x2=17.825 //y2=0.175
r571 (  43 151 ) resistor r=3.1 //w=0.17 //l=0.51 //layer=mcon //count=3 \
 //x=15.605 //y=0.18 //x2=15.605 //y2=0.18
r572 (  43 45 ) resistor r=0.446141 //w=0.311 //l=1.11 //layer=m1 \
 //thickness=0.36 //x=15.605 //y=0.175 //x2=16.715 //y2=0.175
r573 (  41 83 ) resistor r=0.028033 //w=0.35 //l=0.085 //layer=m1 \
 //thickness=0.36 //x=14.545 //y=0.175 //x2=14.46 //y2=0.175
r574 (  41 43 ) resistor r=0.426045 //w=0.311 //l=1.06 //layer=m1 \
 //thickness=0.36 //x=14.545 //y=0.175 //x2=15.605 //y2=0.175
r575 (  40 88 ) resistor r=0.028033 //w=0.35 //l=0.085 //layer=m1 \
 //thickness=0.36 //x=19.185 //y=0.175 //x2=19.27 //y2=0.175
r576 (  40 47 ) resistor r=0.546624 //w=0.311 //l=1.36 //layer=m1 \
 //thickness=0.36 //x=19.185 //y=0.175 //x2=17.825 //y2=0.175
r577 (  39 80 ) resistor r=0.0942778 //w=0.221 //l=0.13 //layer=m1 \
 //thickness=0.36 //x=14.46 //y=1.015 //x2=14.46 //y2=1.145
r578 (  38 83 ) resistor r=0.0413265 //w=0.7 //l=0.175 //layer=m1 \
 //thickness=0.36 //x=14.46 //y=0.35 //x2=14.46 //y2=0.175
r579 (  38 39 ) resistor r=0.634542 //w=0.131 //l=0.665 //layer=m1 \
 //thickness=0.36 //x=14.46 //y=0.35 //x2=14.46 //y2=1.015
r580 (  36 138 ) resistor r=3.1 //w=0.17 //l=0.51 //layer=mcon //count=3 \
 //x=13.015 //y=0.18 //x2=13.015 //y2=0.18
r581 (  34 136 ) resistor r=3.1 //w=0.17 //l=0.51 //layer=mcon //count=3 \
 //x=11.905 //y=0.18 //x2=11.905 //y2=0.18
r582 (  34 36 ) resistor r=0.446141 //w=0.311 //l=1.11 //layer=m1 \
 //thickness=0.36 //x=11.905 //y=0.175 //x2=13.015 //y2=0.175
r583 (  32 78 ) resistor r=0.028033 //w=0.35 //l=0.085 //layer=m1 \
 //thickness=0.36 //x=11.32 //y=0.175 //x2=11.235 //y2=0.175
r584 (  32 34 ) resistor r=0.235129 //w=0.311 //l=0.585 //layer=m1 \
 //thickness=0.36 //x=11.32 //y=0.175 //x2=11.905 //y2=0.175
r585 (  31 83 ) resistor r=0.028033 //w=0.35 //l=0.085 //layer=m1 \
 //thickness=0.36 //x=14.375 //y=0.175 //x2=14.46 //y2=0.175
r586 (  29 78 ) resistor r=0.0413265 //w=0.7 //l=0.175 //layer=m1 \
 //thickness=0.36 //x=11.235 //y=0.35 //x2=11.235 //y2=0.175
r587 (  29 76 ) resistor r=0.625 //w=0.131 //l=0.655 //layer=m1 \
 //thickness=0.36 //x=11.235 //y=0.35 //x2=11.235 //y2=1.005
r588 (  28 134 ) resistor r=3.1 //w=0.17 //l=0.51 //layer=mcon //count=3 \
 //x=10.795 //y=0.18 //x2=10.795 //y2=0.18
r589 (  26 123 ) resistor r=3.1 //w=0.17 //l=0.51 //layer=mcon //count=3 \
 //x=9.315 //y=0.18 //x2=9.315 //y2=0.18
r590 (  26 28 ) resistor r=0.594855 //w=0.311 //l=1.48 //layer=m1 \
 //thickness=0.36 //x=9.315 //y=0.175 //x2=10.795 //y2=0.175
r591 (  24 121 ) resistor r=3.1 //w=0.17 //l=0.51 //layer=mcon //count=3 \
 //x=8.205 //y=0.18 //x2=8.205 //y2=0.18
r592 (  24 26 ) resistor r=0.446141 //w=0.311 //l=1.11 //layer=m1 \
 //thickness=0.36 //x=8.205 //y=0.175 //x2=9.315 //y2=0.175
r593 (  22 119 ) resistor r=3.1 //w=0.17 //l=0.51 //layer=mcon //count=3 \
 //x=7.095 //y=0.18 //x2=7.095 //y2=0.18
r594 (  22 24 ) resistor r=0.446141 //w=0.311 //l=1.11 //layer=m1 \
 //thickness=0.36 //x=7.095 //y=0.175 //x2=8.205 //y2=0.175
r595 (  20 73 ) resistor r=0.028033 //w=0.35 //l=0.085 //layer=m1 \
 //thickness=0.36 //x=6.405 //y=0.175 //x2=6.32 //y2=0.175
r596 (  20 22 ) resistor r=0.277331 //w=0.311 //l=0.69 //layer=m1 \
 //thickness=0.36 //x=6.405 //y=0.175 //x2=7.095 //y2=0.175
r597 (  19 78 ) resistor r=0.028033 //w=0.35 //l=0.085 //layer=m1 \
 //thickness=0.36 //x=11.15 //y=0.175 //x2=11.235 //y2=0.175
r598 (  19 28 ) resistor r=0.142685 //w=0.311 //l=0.355 //layer=m1 \
 //thickness=0.36 //x=11.15 //y=0.175 //x2=10.795 //y2=0.175
r599 (  18 71 ) resistor r=0.0942778 //w=0.221 //l=0.13 //layer=m1 \
 //thickness=0.36 //x=6.32 //y=1.015 //x2=6.32 //y2=1.145
r600 (  17 73 ) resistor r=0.0413265 //w=0.7 //l=0.175 //layer=m1 \
 //thickness=0.36 //x=6.32 //y=0.35 //x2=6.32 //y2=0.175
r601 (  17 18 ) resistor r=0.634542 //w=0.131 //l=0.665 //layer=m1 \
 //thickness=0.36 //x=6.32 //y=0.35 //x2=6.32 //y2=1.015
r602 (  16 117 ) resistor r=3.1 //w=0.17 //l=0.51 //layer=mcon //count=3 \
 //x=5.985 //y=0.18 //x2=5.985 //y2=0.18
r603 (  14 106 ) resistor r=3.1 //w=0.17 //l=0.51 //layer=mcon //count=3 \
 //x=4.505 //y=0.18 //x2=4.505 //y2=0.18
r604 (  14 16 ) resistor r=0.594855 //w=0.311 //l=1.48 //layer=m1 \
 //thickness=0.36 //x=4.505 //y=0.175 //x2=5.985 //y2=0.175
r605 (  12 104 ) resistor r=3.1 //w=0.17 //l=0.51 //layer=mcon //count=3 \
 //x=3.395 //y=0.18 //x2=3.395 //y2=0.18
r606 (  12 14 ) resistor r=0.446141 //w=0.311 //l=1.11 //layer=m1 \
 //thickness=0.36 //x=3.395 //y=0.175 //x2=4.505 //y2=0.175
r607 (  10 102 ) resistor r=3.1 //w=0.17 //l=0.51 //layer=mcon //count=3 \
 //x=2.285 //y=0.18 //x2=2.285 //y2=0.18
r608 (  10 12 ) resistor r=0.446141 //w=0.311 //l=1.11 //layer=m1 \
 //thickness=0.36 //x=2.285 //y=0.175 //x2=3.395 //y2=0.175
r609 (  8 69 ) resistor r=0.028033 //w=0.35 //l=0.085 //layer=m1 \
 //thickness=0.36 //x=1.595 //y=0.175 //x2=1.51 //y2=0.175
r610 (  8 10 ) resistor r=0.277331 //w=0.311 //l=0.69 //layer=m1 \
 //thickness=0.36 //x=1.595 //y=0.175 //x2=2.285 //y2=0.175
r611 (  7 73 ) resistor r=0.028033 //w=0.35 //l=0.085 //layer=m1 \
 //thickness=0.36 //x=6.235 //y=0.175 //x2=6.32 //y2=0.175
r612 (  7 16 ) resistor r=0.100482 //w=0.311 //l=0.25 //layer=m1 \
 //thickness=0.36 //x=6.235 //y=0.175 //x2=5.985 //y2=0.175
r613 (  6 67 ) resistor r=0.0942778 //w=0.221 //l=0.13 //layer=m1 \
 //thickness=0.36 //x=1.51 //y=1.015 //x2=1.51 //y2=1.145
r614 (  5 69 ) resistor r=0.0413265 //w=0.7 //l=0.175 //layer=m1 \
 //thickness=0.36 //x=1.51 //y=0.35 //x2=1.51 //y2=0.175
r615 (  5 6 ) resistor r=0.634542 //w=0.131 //l=0.665 //layer=m1 \
 //thickness=0.36 //x=1.51 //y=0.35 //x2=1.51 //y2=1.015
r616 (  4 100 ) resistor r=3.1 //w=0.17 //l=0.51 //layer=mcon //count=3 \
 //x=1.175 //y=0.18 //x2=1.175 //y2=0.18
r617 (  2 69 ) resistor r=0.028033 //w=0.35 //l=0.085 //layer=m1 \
 //thickness=0.36 //x=1.425 //y=0.175 //x2=1.51 //y2=0.175
r618 (  2 4 ) resistor r=0.0892857 //w=0.35 //l=0.25 //layer=m1 \
 //thickness=0.36 //x=1.425 //y=0.175 //x2=1.175 //y2=0.175
r619 (  1 31 ) resistor r=0.375804 //w=0.311 //l=0.935 //layer=m1 \
 //thickness=0.36 //x=13.44 //y=0.175 //x2=14.375 //y2=0.175
r620 (  1 36 ) resistor r=0.17082 //w=0.311 //l=0.425 //layer=m1 \
 //thickness=0.36 //x=13.44 //y=0.175 //x2=13.015 //y2=0.175
ends PM_DFFRNQX1\%GND

subckt PM_DFFRNQX1\%noxref_16 ( 1 5 9 13 17 35 )
c52 ( 35 0 ) capacitor c=0.0762518f //x=0.89 //y=0.555
c53 ( 17 0 ) capacitor c=0.0259374f //x=2.88 //y=1.77
c54 ( 13 0 ) capacitor c=0.0153941f //x=2.88 //y=0.72
c55 ( 9 0 ) capacitor c=0.00772076f //x=1.995 //y=0.805
c56 ( 5 0 ) capacitor c=0.0211487f //x=1.91 //y=1.77
c57 ( 1 0 ) capacitor c=0.0109947f //x=1.025 //y=1.685
r58 (  18 35 ) resistor r=5.4201 //w=0.17 //l=0.103078 //layer=li \
 //thickness=0.1 //x=2.08 //y=1.77 //x2=1.995 //y2=1.81
r59 (  18 35 ) resistor r=27.3797 //w=0.187 //l=0.4 //layer=li //thickness=0.1 \
 //x=2.08 //y=1.77 //x2=2.48 //y2=1.77
r60 (  17 35 ) resistor r=0.751729 //w=0.17 //l=0.085 //layer=li \
 //thickness=0.1 //x=2.88 //y=1.77 //x2=2.965 //y2=1.77
r61 (  17 35 ) resistor r=27.3797 //w=0.187 //l=0.4 //layer=li //thickness=0.1 \
 //x=2.88 //y=1.77 //x2=2.48 //y2=1.77
r62 (  14 35 ) resistor r=3.57586 //w=0.17 //l=0.103078 //layer=li \
 //thickness=0.1 //x=2.08 //y=0.72 //x2=1.995 //y2=0.68
r63 (  14 35 ) resistor r=27.3797 //w=0.187 //l=0.4 //layer=li //thickness=0.1 \
 //x=2.08 //y=0.72 //x2=2.48 //y2=0.72
r64 (  13 35 ) resistor r=0.751729 //w=0.17 //l=0.085 //layer=li \
 //thickness=0.1 //x=2.88 //y=0.72 //x2=2.965 //y2=0.72
r65 (  13 35 ) resistor r=27.3797 //w=0.187 //l=0.4 //layer=li //thickness=0.1 \
 //x=2.88 //y=0.72 //x2=2.48 //y2=0.72
r66 (  10 35 ) resistor r=1.40859 //w=0.34 //l=0.125 //layer=li \
 //thickness=0.1 //x=1.995 //y=1.685 //x2=1.995 //y2=1.81
r67 (  10 35 ) resistor r=42.0963 //w=0.187 //l=0.615 //layer=li \
 //thickness=0.1 //x=1.995 //y=1.685 //x2=1.995 //y2=1.07
r68 (  9 35 ) resistor r=3.57586 //w=0.17 //l=0.125 //layer=li //thickness=0.1 \
 //x=1.995 //y=0.805 //x2=1.995 //y2=0.68
r69 (  9 35 ) resistor r=18.139 //w=0.187 //l=0.265 //layer=li //thickness=0.1 \
 //x=1.995 //y=0.805 //x2=1.995 //y2=1.07
r70 (  6 35 ) resistor r=3.57586 //w=0.17 //l=0.103078 //layer=li \
 //thickness=0.1 //x=1.11 //y=1.77 //x2=1.025 //y2=1.81
r71 (  6 35 ) resistor r=27.3797 //w=0.187 //l=0.4 //layer=li //thickness=0.1 \
 //x=1.11 //y=1.77 //x2=1.51 //y2=1.77
r72 (  5 35 ) resistor r=5.4201 //w=0.17 //l=0.103078 //layer=li \
 //thickness=0.1 //x=1.91 //y=1.77 //x2=1.995 //y2=1.81
r73 (  5 35 ) resistor r=27.3797 //w=0.187 //l=0.4 //layer=li //thickness=0.1 \
 //x=1.91 //y=1.77 //x2=1.51 //y2=1.77
r74 (  1 35 ) resistor r=3.57586 //w=0.17 //l=0.125 //layer=li //thickness=0.1 \
 //x=1.025 //y=1.685 //x2=1.025 //y2=1.81
r75 (  1 35 ) resistor r=42.0963 //w=0.187 //l=0.615 //layer=li \
 //thickness=0.1 //x=1.025 //y=1.685 //x2=1.025 //y2=1.07
ends PM_DFFRNQX1\%noxref_16

subckt PM_DFFRNQX1\%noxref_17 ( 1 5 9 13 17 35 )
c58 ( 35 0 ) capacitor c=0.0704927f //x=5.7 //y=0.555
c59 ( 17 0 ) capacitor c=0.0208678f //x=7.69 //y=1.77
c60 ( 13 0 ) capacitor c=0.0153941f //x=7.69 //y=0.72
c61 ( 9 0 ) capacitor c=0.00772076f //x=6.805 //y=0.805
c62 ( 5 0 ) capacitor c=0.0180187f //x=6.72 //y=1.77
c63 ( 1 0 ) capacitor c=0.00771772f //x=5.835 //y=1.685
r64 (  18 35 ) resistor r=5.4201 //w=0.17 //l=0.103078 //layer=li \
 //thickness=0.1 //x=6.89 //y=1.77 //x2=6.805 //y2=1.81
r65 (  18 35 ) resistor r=27.3797 //w=0.187 //l=0.4 //layer=li //thickness=0.1 \
 //x=6.89 //y=1.77 //x2=7.29 //y2=1.77
r66 (  17 35 ) resistor r=0.751729 //w=0.17 //l=0.085 //layer=li \
 //thickness=0.1 //x=7.69 //y=1.77 //x2=7.775 //y2=1.77
r67 (  17 35 ) resistor r=27.3797 //w=0.187 //l=0.4 //layer=li //thickness=0.1 \
 //x=7.69 //y=1.77 //x2=7.29 //y2=1.77
r68 (  14 35 ) resistor r=3.57586 //w=0.17 //l=0.103078 //layer=li \
 //thickness=0.1 //x=6.89 //y=0.72 //x2=6.805 //y2=0.68
r69 (  14 35 ) resistor r=27.3797 //w=0.187 //l=0.4 //layer=li //thickness=0.1 \
 //x=6.89 //y=0.72 //x2=7.29 //y2=0.72
r70 (  13 35 ) resistor r=0.751729 //w=0.17 //l=0.085 //layer=li \
 //thickness=0.1 //x=7.69 //y=0.72 //x2=7.775 //y2=0.72
r71 (  13 35 ) resistor r=27.3797 //w=0.187 //l=0.4 //layer=li //thickness=0.1 \
 //x=7.69 //y=0.72 //x2=7.29 //y2=0.72
r72 (  10 35 ) resistor r=1.40859 //w=0.34 //l=0.125 //layer=li \
 //thickness=0.1 //x=6.805 //y=1.685 //x2=6.805 //y2=1.81
r73 (  10 35 ) resistor r=42.0963 //w=0.187 //l=0.615 //layer=li \
 //thickness=0.1 //x=6.805 //y=1.685 //x2=6.805 //y2=1.07
r74 (  9 35 ) resistor r=3.57586 //w=0.17 //l=0.125 //layer=li //thickness=0.1 \
 //x=6.805 //y=0.805 //x2=6.805 //y2=0.68
r75 (  9 35 ) resistor r=18.139 //w=0.187 //l=0.265 //layer=li //thickness=0.1 \
 //x=6.805 //y=0.805 //x2=6.805 //y2=1.07
r76 (  6 35 ) resistor r=3.57586 //w=0.17 //l=0.103078 //layer=li \
 //thickness=0.1 //x=5.92 //y=1.77 //x2=5.835 //y2=1.81
r77 (  6 35 ) resistor r=27.3797 //w=0.187 //l=0.4 //layer=li //thickness=0.1 \
 //x=5.92 //y=1.77 //x2=6.32 //y2=1.77
r78 (  5 35 ) resistor r=5.4201 //w=0.17 //l=0.103078 //layer=li \
 //thickness=0.1 //x=6.72 //y=1.77 //x2=6.805 //y2=1.81
r79 (  5 35 ) resistor r=27.3797 //w=0.187 //l=0.4 //layer=li //thickness=0.1 \
 //x=6.72 //y=1.77 //x2=6.32 //y2=1.77
r80 (  1 35 ) resistor r=3.57586 //w=0.17 //l=0.125 //layer=li //thickness=0.1 \
 //x=5.835 //y=1.685 //x2=5.835 //y2=1.81
r81 (  1 35 ) resistor r=42.0963 //w=0.187 //l=0.615 //layer=li \
 //thickness=0.1 //x=5.835 //y=1.685 //x2=5.835 //y2=1.07
ends PM_DFFRNQX1\%noxref_17

subckt PM_DFFRNQX1\%noxref_18 ( 1 5 9 10 13 17 29 )
c68 ( 29 0 ) capacitor c=0.067062f //x=10.615 //y=0.545
c69 ( 17 0 ) capacitor c=0.00675704f //x=12.69 //y=0.795
c70 ( 13 0 ) capacitor c=0.0156329f //x=12.605 //y=0.71
c71 ( 10 0 ) capacitor c=0.00673372f //x=11.72 //y=1.675
c72 ( 9 0 ) capacitor c=0.00770028f //x=11.72 //y=0.795
c73 ( 5 0 ) capacitor c=0.0179513f //x=11.635 //y=1.76
c74 ( 1 0 ) capacitor c=0.00761099f //x=10.75 //y=1.675
r75 (  17 29 ) resistor r=3.57586 //w=0.17 //l=0.125 //layer=li \
 //thickness=0.1 //x=12.69 //y=0.795 //x2=12.69 //y2=0.67
r76 (  17 29 ) resistor r=18.139 //w=0.187 //l=0.265 //layer=li \
 //thickness=0.1 //x=12.69 //y=0.795 //x2=12.69 //y2=1.06
r77 (  14 29 ) resistor r=3.57586 //w=0.17 //l=0.103078 //layer=li \
 //thickness=0.1 //x=11.805 //y=0.71 //x2=11.72 //y2=0.67
r78 (  14 29 ) resistor r=27.3797 //w=0.187 //l=0.4 //layer=li //thickness=0.1 \
 //x=11.805 //y=0.71 //x2=12.205 //y2=0.71
r79 (  13 29 ) resistor r=3.57586 //w=0.17 //l=0.103078 //layer=li \
 //thickness=0.1 //x=12.605 //y=0.71 //x2=12.69 //y2=0.67
r80 (  13 29 ) resistor r=27.3797 //w=0.187 //l=0.4 //layer=li //thickness=0.1 \
 //x=12.605 //y=0.71 //x2=12.205 //y2=0.71
r81 (  10 29 ) resistor r=3.57586 //w=0.17 //l=0.125 //layer=li \
 //thickness=0.1 //x=11.72 //y=1.675 //x2=11.72 //y2=1.8
r82 (  10 29 ) resistor r=42.0963 //w=0.187 //l=0.615 //layer=li \
 //thickness=0.1 //x=11.72 //y=1.675 //x2=11.72 //y2=1.06
r83 (  9 29 ) resistor r=3.57586 //w=0.17 //l=0.125 //layer=li //thickness=0.1 \
 //x=11.72 //y=0.795 //x2=11.72 //y2=0.67
r84 (  9 29 ) resistor r=18.139 //w=0.187 //l=0.265 //layer=li //thickness=0.1 \
 //x=11.72 //y=0.795 //x2=11.72 //y2=1.06
r85 (  6 29 ) resistor r=3.57586 //w=0.17 //l=0.103078 //layer=li \
 //thickness=0.1 //x=10.835 //y=1.76 //x2=10.75 //y2=1.8
r86 (  6 29 ) resistor r=27.3797 //w=0.187 //l=0.4 //layer=li //thickness=0.1 \
 //x=10.835 //y=1.76 //x2=11.235 //y2=1.76
r87 (  5 29 ) resistor r=3.57586 //w=0.17 //l=0.103078 //layer=li \
 //thickness=0.1 //x=11.635 //y=1.76 //x2=11.72 //y2=1.8
r88 (  5 29 ) resistor r=27.3797 //w=0.187 //l=0.4 //layer=li //thickness=0.1 \
 //x=11.635 //y=1.76 //x2=11.235 //y2=1.76
r89 (  1 29 ) resistor r=3.57586 //w=0.17 //l=0.125 //layer=li //thickness=0.1 \
 //x=10.75 //y=1.675 //x2=10.75 //y2=1.8
r90 (  1 29 ) resistor r=42.0963 //w=0.187 //l=0.615 //layer=li \
 //thickness=0.1 //x=10.75 //y=1.675 //x2=10.75 //y2=1.06
ends PM_DFFRNQX1\%noxref_18

subckt PM_DFFRNQX1\%noxref_19 ( 1 5 9 13 17 35 )
c59 ( 35 0 ) capacitor c=0.068832f //x=13.84 //y=0.555
c60 ( 17 0 ) capacitor c=0.0190725f //x=15.83 //y=1.77
c61 ( 13 0 ) capacitor c=0.015325f //x=15.83 //y=0.72
c62 ( 9 0 ) capacitor c=0.00772076f //x=14.945 //y=0.805
c63 ( 5 0 ) capacitor c=0.0168501f //x=14.86 //y=1.77
c64 ( 1 0 ) capacitor c=0.00709556f //x=13.975 //y=1.685
r65 (  18 35 ) resistor r=5.4201 //w=0.17 //l=0.103078 //layer=li \
 //thickness=0.1 //x=15.03 //y=1.77 //x2=14.945 //y2=1.81
r66 (  18 35 ) resistor r=27.3797 //w=0.187 //l=0.4 //layer=li //thickness=0.1 \
 //x=15.03 //y=1.77 //x2=15.43 //y2=1.77
r67 (  17 35 ) resistor r=0.751729 //w=0.17 //l=0.085 //layer=li \
 //thickness=0.1 //x=15.83 //y=1.77 //x2=15.915 //y2=1.77
r68 (  17 35 ) resistor r=27.3797 //w=0.187 //l=0.4 //layer=li //thickness=0.1 \
 //x=15.83 //y=1.77 //x2=15.43 //y2=1.77
r69 (  14 35 ) resistor r=3.57586 //w=0.17 //l=0.103078 //layer=li \
 //thickness=0.1 //x=15.03 //y=0.72 //x2=14.945 //y2=0.68
r70 (  14 35 ) resistor r=27.3797 //w=0.187 //l=0.4 //layer=li //thickness=0.1 \
 //x=15.03 //y=0.72 //x2=15.43 //y2=0.72
r71 (  13 35 ) resistor r=0.751729 //w=0.17 //l=0.085 //layer=li \
 //thickness=0.1 //x=15.83 //y=0.72 //x2=15.915 //y2=0.72
r72 (  13 35 ) resistor r=27.3797 //w=0.187 //l=0.4 //layer=li //thickness=0.1 \
 //x=15.83 //y=0.72 //x2=15.43 //y2=0.72
r73 (  10 35 ) resistor r=1.40859 //w=0.34 //l=0.125 //layer=li \
 //thickness=0.1 //x=14.945 //y=1.685 //x2=14.945 //y2=1.81
r74 (  10 35 ) resistor r=42.0963 //w=0.187 //l=0.615 //layer=li \
 //thickness=0.1 //x=14.945 //y=1.685 //x2=14.945 //y2=1.07
r75 (  9 35 ) resistor r=3.57586 //w=0.17 //l=0.125 //layer=li //thickness=0.1 \
 //x=14.945 //y=0.805 //x2=14.945 //y2=0.68
r76 (  9 35 ) resistor r=18.139 //w=0.187 //l=0.265 //layer=li //thickness=0.1 \
 //x=14.945 //y=0.805 //x2=14.945 //y2=1.07
r77 (  6 35 ) resistor r=3.57586 //w=0.17 //l=0.103078 //layer=li \
 //thickness=0.1 //x=14.06 //y=1.77 //x2=13.975 //y2=1.81
r78 (  6 35 ) resistor r=27.3797 //w=0.187 //l=0.4 //layer=li //thickness=0.1 \
 //x=14.06 //y=1.77 //x2=14.46 //y2=1.77
r79 (  5 35 ) resistor r=5.4201 //w=0.17 //l=0.103078 //layer=li \
 //thickness=0.1 //x=14.86 //y=1.77 //x2=14.945 //y2=1.81
r80 (  5 35 ) resistor r=27.3797 //w=0.187 //l=0.4 //layer=li //thickness=0.1 \
 //x=14.86 //y=1.77 //x2=14.46 //y2=1.77
r81 (  1 35 ) resistor r=3.57586 //w=0.17 //l=0.125 //layer=li //thickness=0.1 \
 //x=13.975 //y=1.685 //x2=13.975 //y2=1.81
r82 (  1 35 ) resistor r=42.0963 //w=0.187 //l=0.615 //layer=li \
 //thickness=0.1 //x=13.975 //y=1.685 //x2=13.975 //y2=1.07
ends PM_DFFRNQX1\%noxref_19

subckt PM_DFFRNQX1\%noxref_20 ( 1 5 9 13 17 35 )
c57 ( 35 0 ) capacitor c=0.0720266f //x=18.65 //y=0.555
c58 ( 17 0 ) capacitor c=0.0196483f //x=20.64 //y=1.77
c59 ( 13 0 ) capacitor c=0.015394f //x=20.64 //y=0.72
c60 ( 9 0 ) capacitor c=0.00772076f //x=19.755 //y=0.805
c61 ( 5 0 ) capacitor c=0.0168501f //x=19.67 //y=1.77
c62 ( 1 0 ) capacitor c=0.00710458f //x=18.785 //y=1.685
r63 (  18 35 ) resistor r=5.4201 //w=0.17 //l=0.103078 //layer=li \
 //thickness=0.1 //x=19.84 //y=1.77 //x2=19.755 //y2=1.81
r64 (  18 35 ) resistor r=27.3797 //w=0.187 //l=0.4 //layer=li //thickness=0.1 \
 //x=19.84 //y=1.77 //x2=20.24 //y2=1.77
r65 (  17 35 ) resistor r=0.751729 //w=0.17 //l=0.085 //layer=li \
 //thickness=0.1 //x=20.64 //y=1.77 //x2=20.725 //y2=1.77
r66 (  17 35 ) resistor r=27.3797 //w=0.187 //l=0.4 //layer=li //thickness=0.1 \
 //x=20.64 //y=1.77 //x2=20.24 //y2=1.77
r67 (  14 35 ) resistor r=3.57586 //w=0.17 //l=0.103078 //layer=li \
 //thickness=0.1 //x=19.84 //y=0.72 //x2=19.755 //y2=0.68
r68 (  14 35 ) resistor r=27.3797 //w=0.187 //l=0.4 //layer=li //thickness=0.1 \
 //x=19.84 //y=0.72 //x2=20.24 //y2=0.72
r69 (  13 35 ) resistor r=0.751729 //w=0.17 //l=0.085 //layer=li \
 //thickness=0.1 //x=20.64 //y=0.72 //x2=20.725 //y2=0.72
r70 (  13 35 ) resistor r=27.3797 //w=0.187 //l=0.4 //layer=li //thickness=0.1 \
 //x=20.64 //y=0.72 //x2=20.24 //y2=0.72
r71 (  10 35 ) resistor r=1.40859 //w=0.34 //l=0.125 //layer=li \
 //thickness=0.1 //x=19.755 //y=1.685 //x2=19.755 //y2=1.81
r72 (  10 35 ) resistor r=42.0963 //w=0.187 //l=0.615 //layer=li \
 //thickness=0.1 //x=19.755 //y=1.685 //x2=19.755 //y2=1.07
r73 (  9 35 ) resistor r=3.57586 //w=0.17 //l=0.125 //layer=li //thickness=0.1 \
 //x=19.755 //y=0.805 //x2=19.755 //y2=0.68
r74 (  9 35 ) resistor r=18.139 //w=0.187 //l=0.265 //layer=li //thickness=0.1 \
 //x=19.755 //y=0.805 //x2=19.755 //y2=1.07
r75 (  6 35 ) resistor r=3.57586 //w=0.17 //l=0.103078 //layer=li \
 //thickness=0.1 //x=18.87 //y=1.77 //x2=18.785 //y2=1.81
r76 (  6 35 ) resistor r=27.3797 //w=0.187 //l=0.4 //layer=li //thickness=0.1 \
 //x=18.87 //y=1.77 //x2=19.27 //y2=1.77
r77 (  5 35 ) resistor r=5.4201 //w=0.17 //l=0.103078 //layer=li \
 //thickness=0.1 //x=19.67 //y=1.77 //x2=19.755 //y2=1.81
r78 (  5 35 ) resistor r=27.3797 //w=0.187 //l=0.4 //layer=li //thickness=0.1 \
 //x=19.67 //y=1.77 //x2=19.27 //y2=1.77
r79 (  1 35 ) resistor r=3.57586 //w=0.17 //l=0.125 //layer=li //thickness=0.1 \
 //x=18.785 //y=1.685 //x2=18.785 //y2=1.81
r80 (  1 35 ) resistor r=42.0963 //w=0.187 //l=0.615 //layer=li \
 //thickness=0.1 //x=18.785 //y=1.685 //x2=18.785 //y2=1.07
ends PM_DFFRNQX1\%noxref_20

subckt PM_DFFRNQX1\%noxref_21 ( 1 5 9 10 13 17 29 )
c60 ( 29 0 ) capacitor c=0.0681376f //x=23.565 //y=0.545
c61 ( 17 0 ) capacitor c=0.00709791f //x=25.64 //y=0.795
c62 ( 13 0 ) capacitor c=0.0157577f //x=25.555 //y=0.71
c63 ( 10 0 ) capacitor c=0.00742952f //x=24.67 //y=1.675
c64 ( 9 0 ) capacitor c=0.00770028f //x=24.67 //y=0.795
c65 ( 5 0 ) capacitor c=0.0196562f //x=24.585 //y=1.76
c66 ( 1 0 ) capacitor c=0.00822695f //x=23.7 //y=1.675
r67 (  17 29 ) resistor r=3.57586 //w=0.17 //l=0.125 //layer=li \
 //thickness=0.1 //x=25.64 //y=0.795 //x2=25.64 //y2=0.67
r68 (  17 29 ) resistor r=18.139 //w=0.187 //l=0.265 //layer=li \
 //thickness=0.1 //x=25.64 //y=0.795 //x2=25.64 //y2=1.06
r69 (  14 29 ) resistor r=3.57586 //w=0.17 //l=0.103078 //layer=li \
 //thickness=0.1 //x=24.755 //y=0.71 //x2=24.67 //y2=0.67
r70 (  14 29 ) resistor r=27.3797 //w=0.187 //l=0.4 //layer=li //thickness=0.1 \
 //x=24.755 //y=0.71 //x2=25.155 //y2=0.71
r71 (  13 29 ) resistor r=3.57586 //w=0.17 //l=0.103078 //layer=li \
 //thickness=0.1 //x=25.555 //y=0.71 //x2=25.64 //y2=0.67
r72 (  13 29 ) resistor r=27.3797 //w=0.187 //l=0.4 //layer=li //thickness=0.1 \
 //x=25.555 //y=0.71 //x2=25.155 //y2=0.71
r73 (  10 29 ) resistor r=3.57586 //w=0.17 //l=0.125 //layer=li \
 //thickness=0.1 //x=24.67 //y=1.675 //x2=24.67 //y2=1.8
r74 (  10 29 ) resistor r=42.0963 //w=0.187 //l=0.615 //layer=li \
 //thickness=0.1 //x=24.67 //y=1.675 //x2=24.67 //y2=1.06
r75 (  9 29 ) resistor r=3.57586 //w=0.17 //l=0.125 //layer=li //thickness=0.1 \
 //x=24.67 //y=0.795 //x2=24.67 //y2=0.67
r76 (  9 29 ) resistor r=18.139 //w=0.187 //l=0.265 //layer=li //thickness=0.1 \
 //x=24.67 //y=0.795 //x2=24.67 //y2=1.06
r77 (  6 29 ) resistor r=3.57586 //w=0.17 //l=0.103078 //layer=li \
 //thickness=0.1 //x=23.785 //y=1.76 //x2=23.7 //y2=1.8
r78 (  6 29 ) resistor r=27.3797 //w=0.187 //l=0.4 //layer=li //thickness=0.1 \
 //x=23.785 //y=1.76 //x2=24.185 //y2=1.76
r79 (  5 29 ) resistor r=3.57586 //w=0.17 //l=0.103078 //layer=li \
 //thickness=0.1 //x=24.585 //y=1.76 //x2=24.67 //y2=1.8
r80 (  5 29 ) resistor r=27.3797 //w=0.187 //l=0.4 //layer=li //thickness=0.1 \
 //x=24.585 //y=1.76 //x2=24.185 //y2=1.76
r81 (  1 29 ) resistor r=3.57586 //w=0.17 //l=0.125 //layer=li //thickness=0.1 \
 //x=23.7 //y=1.675 //x2=23.7 //y2=1.8
r82 (  1 29 ) resistor r=42.0963 //w=0.187 //l=0.615 //layer=li \
 //thickness=0.1 //x=23.7 //y=1.675 //x2=23.7 //y2=1.06
ends PM_DFFRNQX1\%noxref_21
