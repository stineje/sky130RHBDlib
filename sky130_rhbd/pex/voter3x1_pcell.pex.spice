// File: voter3x1_pcell.spi.pex
// Created: Fri Feb 20 10:23:38 2026
// Program "Calibre xRC"
// Version "v2023.2_27.15"
// Nominal Temperature: 30C
// Circuit Temperature: 30C
//
simulator lang=spectre
subckt PM_VOTER3X1_PCELL\%noxref_1 ( 1 2 3 4 8 11 17 22 23 26 31 37 42 47 48 \
 49 50 51 52 53 54 55 56 60 62 65 66 67 68 72 73 74 75 79 81 87 88 90 103 )
c236 ( 103 0 ) capacitor c=0.0692896f //x=4.44 //y=4.705
c237 ( 90 0 ) capacitor c=0.0603371f //x=0.74 //y=2.08
c238 ( 88 0 ) capacitor c=0.0344584f //x=4.775 //y=1.21
c239 ( 87 0 ) capacitor c=0.0186809f //x=4.775 //y=0.865
c240 ( 81 0 ) capacitor c=0.0141797f //x=4.62 //y=1.365
c241 ( 79 0 ) capacitor c=0.0158553f //x=4.62 //y=0.71
c242 ( 75 0 ) capacitor c=0.103881f //x=4.245 //y=1.915
c243 ( 74 0 ) capacitor c=0.0227978f //x=4.245 //y=1.52
c244 ( 73 0 ) capacitor c=0.0234352f //x=4.245 //y=1.21
c245 ( 72 0 ) capacitor c=0.0198759f //x=4.245 //y=0.865
c246 ( 68 0 ) capacitor c=0.0318956f //x=1.445 //y=1.21
c247 ( 67 0 ) capacitor c=0.0186809f //x=1.445 //y=0.865
c248 ( 66 0 ) capacitor c=0.0624333f //x=1.085 //y=4.795
c249 ( 65 0 ) capacitor c=0.0375163f //x=1.375 //y=4.795
c250 ( 62 0 ) capacitor c=0.0157936f //x=1.29 //y=1.365
c251 ( 60 0 ) capacitor c=0.0158553f //x=1.29 //y=0.71
c252 ( 56 0 ) capacitor c=0.0302441f //x=0.915 //y=1.915
c253 ( 55 0 ) capacitor c=0.0238107f //x=0.915 //y=1.52
c254 ( 54 0 ) capacitor c=0.0234359f //x=0.915 //y=1.21
c255 ( 53 0 ) capacitor c=0.0199332f //x=0.915 //y=0.865
c256 ( 52 0 ) capacitor c=0.111167f //x=4.77 //y=6.025
c257 ( 51 0 ) capacitor c=0.154978f //x=4.33 //y=6.025
c258 ( 50 0 ) capacitor c=0.110282f //x=1.45 //y=6.025
c259 ( 49 0 ) capacitor c=0.155219f //x=1.01 //y=6.025
c260 ( 42 0 ) capacitor c=0.0156727f //x=4.44 //y=4.44
c261 ( 37 0 ) capacitor c=0.00126053f //x=4.44 //y=2.08
c262 ( 31 0 ) capacitor c=0.0125733f //x=0.74 //y=4.44
c263 ( 26 0 ) capacitor c=7.43216e-19 //x=0.74 //y=2.08
c264 ( 23 0 ) capacitor c=0.0876578f //x=4.285 //y=4.46
c265 ( 22 0 ) capacitor c=0.00642399f //x=4.445 //y=4.46
c266 ( 17 0 ) capacitor c=0.00920482f //x=0.905 //y=4.44
c267 ( 11 0 ) capacitor c=0.0127991f //x=4.44 //y=4.44
c268 ( 8 0 ) capacitor c=0.0139929f //x=0.74 //y=4.44
c269 ( 4 0 ) capacitor c=0.0851523f //x=4.44 //y=4.295
c270 ( 3 0 ) capacitor c=0.00888199f //x=4.44 //y=2.205
c271 ( 2 0 ) capacitor c=0.0996103f //x=0.74 //y=4.28
c272 ( 1 0 ) capacitor c=0.0100386f //x=0.74 //y=2.195
r273 (  101 103 ) resistor r=22.7554 //w=0.233 //l=0.11 //layer=ply \
 //thickness=0.18 //x=4.33 //y=4.705 //x2=4.44 //y2=4.705
r274 (  88 105 ) resistor r=45.1352 //w=0.168 //l=0.173853 //layer=ply \
 //thickness=0.18 //x=4.775 //y=1.21 //x2=4.735 //y2=1.365
r275 (  87 104 ) resistor r=45.1352 //w=0.168 //l=0.173853 //layer=ply \
 //thickness=0.18 //x=4.775 //y=0.865 //x2=4.735 //y2=0.71
r276 (  87 88 ) resistor r=176.904 //w=0.094 //l=0.345 //layer=ply \
 //thickness=0.18 //x=4.775 //y=0.865 //x2=4.775 //y2=1.21
r277 (  84 103 ) resistor r=68.2661 //w=0.233 //l=0.404166 //layer=ply \
 //thickness=0.18 //x=4.77 //y=4.87 //x2=4.44 //y2=4.705
r278 (  82 100 ) resistor r=10.701 //w=0.21 //l=0.115 //layer=ply \
 //thickness=0.18 //x=4.4 //y=1.365 //x2=4.285 //y2=1.365
r279 (  81 105 ) resistor r=5.52526 //w=0.168 //l=0.115 //layer=ply \
 //thickness=0.18 //x=4.62 //y=1.365 //x2=4.735 //y2=1.365
r280 (  80 99 ) resistor r=5.52526 //w=0.168 //l=0.115 //layer=ply \
 //thickness=0.18 //x=4.4 //y=0.71 //x2=4.285 //y2=0.71
r281 (  79 104 ) resistor r=5.52526 //w=0.168 //l=0.115 //layer=ply \
 //thickness=0.18 //x=4.62 //y=0.71 //x2=4.735 //y2=0.71
r282 (  79 80 ) resistor r=112.809 //w=0.094 //l=0.22 //layer=ply \
 //thickness=0.18 //x=4.62 //y=0.71 //x2=4.4 //y2=0.71
r283 (  76 101 ) resistor r=13.0941 //w=0.233 //l=0.165 //layer=ply \
 //thickness=0.18 //x=4.33 //y=4.87 //x2=4.33 //y2=4.705
r284 (  75 98 ) resistor r=34.8111 //w=0.27 //l=0.264953 //layer=ply \
 //thickness=0.18 //x=4.245 //y=1.915 //x2=4.44 //y2=2.08
r285 (  74 100 ) resistor r=39.5823 //w=0.21 //l=0.173853 //layer=ply \
 //thickness=0.18 //x=4.245 //y=1.52 //x2=4.285 //y2=1.365
r286 (  74 75 ) resistor r=202.543 //w=0.094 //l=0.395 //layer=ply \
 //thickness=0.18 //x=4.245 //y=1.52 //x2=4.245 //y2=1.915
r287 (  73 100 ) resistor r=39.5823 //w=0.21 //l=0.173853 //layer=ply \
 //thickness=0.18 //x=4.245 //y=1.21 //x2=4.285 //y2=1.365
r288 (  72 99 ) resistor r=45.1352 //w=0.168 //l=0.173853 //layer=ply \
 //thickness=0.18 //x=4.245 //y=0.865 //x2=4.285 //y2=0.71
r289 (  72 73 ) resistor r=176.904 //w=0.094 //l=0.345 //layer=ply \
 //thickness=0.18 //x=4.245 //y=0.865 //x2=4.245 //y2=1.21
r290 (  68 96 ) resistor r=45.1352 //w=0.168 //l=0.173853 //layer=ply \
 //thickness=0.18 //x=1.445 //y=1.21 //x2=1.405 //y2=1.365
r291 (  67 95 ) resistor r=45.1352 //w=0.168 //l=0.173853 //layer=ply \
 //thickness=0.18 //x=1.445 //y=0.865 //x2=1.405 //y2=0.71
r292 (  67 68 ) resistor r=176.904 //w=0.094 //l=0.345 //layer=ply \
 //thickness=0.18 //x=1.445 //y=0.865 //x2=1.445 //y2=1.21
r293 (  65 69 ) resistor r=26.9307 //w=0.15 //l=0.106066 //layer=ply \
 //thickness=0.18 //x=1.375 //y=4.795 //x2=1.45 //y2=4.87
r294 (  65 66 ) resistor r=148.702 //w=0.094 //l=0.29 //layer=ply \
 //thickness=0.18 //x=1.375 //y=4.795 //x2=1.085 //y2=4.795
r295 (  63 94 ) resistor r=10.701 //w=0.21 //l=0.115 //layer=ply \
 //thickness=0.18 //x=1.07 //y=1.365 //x2=0.955 //y2=1.365
r296 (  62 96 ) resistor r=5.52526 //w=0.168 //l=0.115 //layer=ply \
 //thickness=0.18 //x=1.29 //y=1.365 //x2=1.405 //y2=1.365
r297 (  61 93 ) resistor r=5.52526 //w=0.168 //l=0.115 //layer=ply \
 //thickness=0.18 //x=1.07 //y=0.71 //x2=0.955 //y2=0.71
r298 (  60 95 ) resistor r=5.52526 //w=0.168 //l=0.115 //layer=ply \
 //thickness=0.18 //x=1.29 //y=0.71 //x2=1.405 //y2=0.71
r299 (  60 61 ) resistor r=112.809 //w=0.094 //l=0.22 //layer=ply \
 //thickness=0.18 //x=1.29 //y=0.71 //x2=1.07 //y2=0.71
r300 (  57 66 ) resistor r=22.1787 //w=0.252 //l=0.106066 //layer=ply \
 //thickness=0.18 //x=1.01 //y=4.87 //x2=1.085 //y2=4.795
r301 (  57 92 ) resistor r=51.6429 //w=0.252 //l=0.34271 //layer=ply \
 //thickness=0.18 //x=1.01 //y=4.87 //x2=0.74 //y2=4.705
r302 (  56 90 ) resistor r=30.4513 //w=0.277 //l=0.243926 //layer=ply \
 //thickness=0.18 //x=0.915 //y=1.915 //x2=0.74 //y2=2.08
r303 (  55 94 ) resistor r=39.5823 //w=0.21 //l=0.173853 //layer=ply \
 //thickness=0.18 //x=0.915 //y=1.52 //x2=0.955 //y2=1.365
r304 (  55 56 ) resistor r=202.543 //w=0.094 //l=0.395 //layer=ply \
 //thickness=0.18 //x=0.915 //y=1.52 //x2=0.915 //y2=1.915
r305 (  54 94 ) resistor r=39.5823 //w=0.21 //l=0.173853 //layer=ply \
 //thickness=0.18 //x=0.915 //y=1.21 //x2=0.955 //y2=1.365
r306 (  53 93 ) resistor r=45.1352 //w=0.168 //l=0.173853 //layer=ply \
 //thickness=0.18 //x=0.915 //y=0.865 //x2=0.955 //y2=0.71
r307 (  53 54 ) resistor r=176.904 //w=0.094 //l=0.345 //layer=ply \
 //thickness=0.18 //x=0.915 //y=0.865 //x2=0.915 //y2=1.21
r308 (  52 84 ) resistor r=592.245 //w=0.094 //l=1.155 //layer=ply \
 //thickness=0.18 //x=4.77 //y=6.025 //x2=4.77 //y2=4.87
r309 (  51 76 ) resistor r=592.245 //w=0.094 //l=1.155 //layer=ply \
 //thickness=0.18 //x=4.33 //y=6.025 //x2=4.33 //y2=4.87
r310 (  50 69 ) resistor r=592.245 //w=0.094 //l=1.155 //layer=ply \
 //thickness=0.18 //x=1.45 //y=6.025 //x2=1.45 //y2=4.87
r311 (  49 57 ) resistor r=592.245 //w=0.094 //l=1.155 //layer=ply \
 //thickness=0.18 //x=1.01 //y=6.025 //x2=1.01 //y2=4.87
r312 (  48 81 ) resistor r=56.4043 //w=0.094 //l=0.11 //layer=ply \
 //thickness=0.18 //x=4.51 //y=1.365 //x2=4.62 //y2=1.365
r313 (  48 82 ) resistor r=56.4043 //w=0.094 //l=0.11 //layer=ply \
 //thickness=0.18 //x=4.51 //y=1.365 //x2=4.4 //y2=1.365
r314 (  47 62 ) resistor r=56.4043 //w=0.094 //l=0.11 //layer=ply \
 //thickness=0.18 //x=1.18 //y=1.365 //x2=1.29 //y2=1.365
r315 (  47 63 ) resistor r=56.4043 //w=0.094 //l=0.11 //layer=ply \
 //thickness=0.18 //x=1.18 //y=1.365 //x2=1.07 //y2=1.365
r316 (  45 103 ) resistor r=152 //w=0.17 //l=0.17 //layer=licon //count=1 \
 //x=4.44 //y=4.705 //x2=4.44 //y2=4.705
r317 (  42 45 ) resistor r=18.139 //w=0.187 //l=0.265 //layer=li \
 //thickness=0.1 //x=4.44 //y=4.44 //x2=4.44 //y2=4.705
r318 (  37 98 ) resistor r=152 //w=0.17 //l=0.17 //layer=licon //count=1 \
 //x=4.44 //y=2.08 //x2=4.44 //y2=2.08
r319 (  34 92 ) resistor r=152 //w=0.17 //l=0.17 //layer=licon //count=1 \
 //x=0.74 //y=4.705 //x2=0.74 //y2=4.705
r320 (  31 34 ) resistor r=18.139 //w=0.187 //l=0.265 //layer=li \
 //thickness=0.1 //x=0.74 //y=4.44 //x2=0.74 //y2=4.705
r321 (  26 90 ) resistor r=152 //w=0.17 //l=0.17 //layer=licon //count=1 \
 //x=0.74 //y=2.08 //x2=0.74 //y2=2.08
r322 (  22 23 ) resistor r=0.10734 //w=0.281 //l=0.16 //layer=m2 \
 //thickness=0.36 //x=4.445 //y=4.46 //x2=4.285 //y2=4.46
r323 (  17 19 ) resistor r=0.10734 //w=0.281 //l=0.16 //layer=m2 \
 //thickness=0.36 //x=0.905 //y=4.44 //x2=0.745 //y2=4.44
r324 (  17 23 ) resistor r=3.22519 //w=0.131 //l=3.38 //layer=m2 \
 //thickness=0.36 //x=0.905 //y=4.44 //x2=4.285 //y2=4.44
r325 (  15 37 ) resistor r=9.3 //w=0.17 //l=0.17 //layer=mcon //count=1 \
 //x=4.44 //y=2.08 //x2=4.44 //y2=2.08
r326 (  13 22 ) resistor r=4.5 //w=0.15 //l=0.15 //layer=via1 //count=1 \
 //x=4.445 //y=4.46 //x2=4.445 //y2=4.46
r327 (  11 42 ) resistor r=9.3 //w=0.17 //l=0.17 //layer=mcon //count=1 \
 //x=4.44 //y=4.44 //x2=4.44 //y2=4.44
r328 (  11 13 ) resistor r=0.00659631 //w=0.379 //l=0.02 //layer=m1 \
 //thickness=0.36 //x=4.39 //y=4.44 //x2=4.39 //y2=4.46
r329 (  8 31 ) resistor r=9.3 //w=0.17 //l=0.17 //layer=mcon //count=1 \
 //x=0.74 //y=4.44 //x2=0.74 //y2=4.44
r330 (  8 19 ) resistor r=4.5 //w=0.15 //l=0.15 //layer=via1 //count=1 \
 //x=0.745 //y=4.44 //x2=0.745 //y2=4.44
r331 (  6 26 ) resistor r=9.3 //w=0.17 //l=0.17 //layer=mcon //count=1 \
 //x=0.74 //y=2.08 //x2=0.74 //y2=2.08
r332 (  4 11 ) resistor r=0.0863342 //w=0.379 //l=0.168152 //layer=m1 \
 //thickness=0.36 //x=4.44 //y=4.295 //x2=4.39 //y2=4.44
r333 (  3 15 ) resistor r=0.0761125 //w=0.237 //l=0.126491 //layer=m1 \
 //thickness=0.36 //x=4.44 //y=2.205 //x2=4.437 //y2=2.08
r334 (  3 4 ) resistor r=1.99427 //w=0.131 //l=2.09 //layer=m1 \
 //thickness=0.36 //x=4.44 //y=2.205 //x2=4.44 //y2=4.295
r335 (  2 8 ) resistor r=0.0898201 //w=0.322 //l=0.185472 //layer=m1 \
 //thickness=0.36 //x=0.74 //y=4.28 //x2=0.795 //y2=4.44
r336 (  1 6 ) resistor r=0.0717383 //w=0.224 //l=0.115 //layer=m1 \
 //thickness=0.36 //x=0.74 //y=2.195 //x2=0.74 //y2=2.08
r337 (  1 2 ) resistor r=1.9895 //w=0.131 //l=2.085 //layer=m1 \
 //thickness=0.36 //x=0.74 //y=2.195 //x2=0.74 //y2=4.28
ends PM_VOTER3X1_PCELL\%noxref_1

subckt PM_VOTER3X1_PCELL\%noxref_2 ( 1 2 3 4 22 24 25 28 33 38 43 47 48 49 50 \
 51 52 56 57 58 59 60 62 65 68 69 70 71 72 73 74 75 79 81 84 85 86 87 100 )
c227 ( 100 0 ) capacitor c=0.0586737f //x=7.4 //y=2.08
c228 ( 87 0 ) capacitor c=0.0318956f //x=8.105 //y=1.21
c229 ( 86 0 ) capacitor c=0.0186809f //x=8.105 //y=0.865
c230 ( 85 0 ) capacitor c=0.0659968f //x=7.745 //y=4.795
c231 ( 84 0 ) capacitor c=0.0373387f //x=8.035 //y=4.795
c232 ( 81 0 ) capacitor c=0.0157936f //x=7.95 //y=1.365
c233 ( 79 0 ) capacitor c=0.0158553f //x=7.95 //y=0.71
c234 ( 75 0 ) capacitor c=0.0302441f //x=7.575 //y=1.915
c235 ( 74 0 ) capacitor c=0.0238107f //x=7.575 //y=1.52
c236 ( 73 0 ) capacitor c=0.0234359f //x=7.575 //y=1.21
c237 ( 72 0 ) capacitor c=0.0199332f //x=7.575 //y=0.865
c238 ( 71 0 ) capacitor c=0.0972519f //x=5.745 //y=1.915
c239 ( 70 0 ) capacitor c=0.0251353f //x=5.745 //y=1.56
c240 ( 69 0 ) capacitor c=0.0234318f //x=5.745 //y=1.25
c241 ( 68 0 ) capacitor c=0.0192547f //x=5.745 //y=0.905
c242 ( 65 0 ) capacitor c=0.0714656f //x=5.65 //y=4.87
c243 ( 62 0 ) capacitor c=0.0186579f //x=5.59 //y=1.405
c244 ( 60 0 ) capacitor c=0.0157803f //x=5.59 //y=0.75
c245 ( 59 0 ) capacitor c=0.0134011f //x=5.285 //y=4.795
c246 ( 58 0 ) capacitor c=0.0243282f //x=5.575 //y=4.795
c247 ( 57 0 ) capacitor c=0.0364928f //x=5.215 //y=1.25
c248 ( 56 0 ) capacitor c=0.0174823f //x=5.215 //y=0.905
c249 ( 52 0 ) capacitor c=0.11081f //x=8.11 //y=6.025
c250 ( 51 0 ) capacitor c=0.154997f //x=7.67 //y=6.025
c251 ( 50 0 ) capacitor c=0.155934f //x=5.65 //y=6.025
c252 ( 49 0 ) capacitor c=0.110594f //x=5.21 //y=6.025
c253 ( 43 0 ) capacitor c=7.79654e-19 //x=7.4 //y=4.705
c254 ( 38 0 ) capacitor c=7.89145e-19 //x=7.4 //y=2.08
c255 ( 33 0 ) capacitor c=7.79197e-19 //x=5.92 //y=4.705
c256 ( 28 0 ) capacitor c=7.43216e-19 //x=5.92 //y=2.08
c257 ( 25 0 ) capacitor c=0.0208894f //x=7.235 //y=2.09
c258 ( 24 0 ) capacitor c=0.00247225f //x=7.395 //y=2.09
c259 ( 22 0 ) capacitor c=0.0031771f //x=6.085 //y=2.09
c260 ( 4 0 ) capacitor c=0.0783137f //x=7.4 //y=4.575
c261 ( 3 0 ) capacitor c=0.00995077f //x=7.4 //y=2.25
c262 ( 2 0 ) capacitor c=0.0865077f //x=5.92 //y=4.58
c263 ( 1 0 ) capacitor c=0.0102822f //x=5.92 //y=2.25
r264 (  87 106 ) resistor r=45.1352 //w=0.168 //l=0.173853 //layer=ply \
 //thickness=0.18 //x=8.105 //y=1.21 //x2=8.065 //y2=1.365
r265 (  86 105 ) resistor r=45.1352 //w=0.168 //l=0.173853 //layer=ply \
 //thickness=0.18 //x=8.105 //y=0.865 //x2=8.065 //y2=0.71
r266 (  86 87 ) resistor r=176.904 //w=0.094 //l=0.345 //layer=ply \
 //thickness=0.18 //x=8.105 //y=0.865 //x2=8.105 //y2=1.21
r267 (  84 88 ) resistor r=26.9307 //w=0.15 //l=0.106066 //layer=ply \
 //thickness=0.18 //x=8.035 //y=4.795 //x2=8.11 //y2=4.87
r268 (  84 85 ) resistor r=148.702 //w=0.094 //l=0.29 //layer=ply \
 //thickness=0.18 //x=8.035 //y=4.795 //x2=7.745 //y2=4.795
r269 (  82 104 ) resistor r=10.701 //w=0.21 //l=0.115 //layer=ply \
 //thickness=0.18 //x=7.73 //y=1.365 //x2=7.615 //y2=1.365
r270 (  81 106 ) resistor r=5.52526 //w=0.168 //l=0.115 //layer=ply \
 //thickness=0.18 //x=7.95 //y=1.365 //x2=8.065 //y2=1.365
r271 (  80 103 ) resistor r=5.52526 //w=0.168 //l=0.115 //layer=ply \
 //thickness=0.18 //x=7.73 //y=0.71 //x2=7.615 //y2=0.71
r272 (  79 105 ) resistor r=5.52526 //w=0.168 //l=0.115 //layer=ply \
 //thickness=0.18 //x=7.95 //y=0.71 //x2=8.065 //y2=0.71
r273 (  79 80 ) resistor r=112.809 //w=0.094 //l=0.22 //layer=ply \
 //thickness=0.18 //x=7.95 //y=0.71 //x2=7.73 //y2=0.71
r274 (  76 85 ) resistor r=22.1787 //w=0.252 //l=0.106066 //layer=ply \
 //thickness=0.18 //x=7.67 //y=4.87 //x2=7.745 //y2=4.795
r275 (  76 102 ) resistor r=51.6429 //w=0.252 //l=0.34271 //layer=ply \
 //thickness=0.18 //x=7.67 //y=4.87 //x2=7.4 //y2=4.705
r276 (  75 100 ) resistor r=30.4513 //w=0.277 //l=0.243926 //layer=ply \
 //thickness=0.18 //x=7.575 //y=1.915 //x2=7.4 //y2=2.08
r277 (  74 104 ) resistor r=39.5823 //w=0.21 //l=0.173853 //layer=ply \
 //thickness=0.18 //x=7.575 //y=1.52 //x2=7.615 //y2=1.365
r278 (  74 75 ) resistor r=202.543 //w=0.094 //l=0.395 //layer=ply \
 //thickness=0.18 //x=7.575 //y=1.52 //x2=7.575 //y2=1.915
r279 (  73 104 ) resistor r=39.5823 //w=0.21 //l=0.173853 //layer=ply \
 //thickness=0.18 //x=7.575 //y=1.21 //x2=7.615 //y2=1.365
r280 (  72 103 ) resistor r=45.1352 //w=0.168 //l=0.173853 //layer=ply \
 //thickness=0.18 //x=7.575 //y=0.865 //x2=7.615 //y2=0.71
r281 (  72 73 ) resistor r=176.904 //w=0.094 //l=0.345 //layer=ply \
 //thickness=0.18 //x=7.575 //y=0.865 //x2=7.575 //y2=1.21
r282 (  71 96 ) resistor r=30.4513 //w=0.277 //l=0.243926 //layer=ply \
 //thickness=0.18 //x=5.745 //y=1.915 //x2=5.92 //y2=2.08
r283 (  70 94 ) resistor r=39.5823 //w=0.21 //l=0.173853 //layer=ply \
 //thickness=0.18 //x=5.745 //y=1.56 //x2=5.705 //y2=1.405
r284 (  70 71 ) resistor r=182.032 //w=0.094 //l=0.355 //layer=ply \
 //thickness=0.18 //x=5.745 //y=1.56 //x2=5.745 //y2=1.915
r285 (  69 94 ) resistor r=39.5823 //w=0.21 //l=0.173853 //layer=ply \
 //thickness=0.18 //x=5.745 //y=1.25 //x2=5.705 //y2=1.405
r286 (  68 93 ) resistor r=45.1352 //w=0.168 //l=0.173853 //layer=ply \
 //thickness=0.18 //x=5.745 //y=0.905 //x2=5.705 //y2=0.75
r287 (  68 69 ) resistor r=176.904 //w=0.094 //l=0.345 //layer=ply \
 //thickness=0.18 //x=5.745 //y=0.905 //x2=5.745 //y2=1.25
r288 (  65 98 ) resistor r=51.6429 //w=0.252 //l=0.34271 //layer=ply \
 //thickness=0.18 //x=5.65 //y=4.87 //x2=5.92 //y2=4.705
r289 (  63 92 ) resistor r=5.52526 //w=0.168 //l=0.115 //layer=ply \
 //thickness=0.18 //x=5.37 //y=1.405 //x2=5.255 //y2=1.405
r290 (  62 94 ) resistor r=10.701 //w=0.21 //l=0.115 //layer=ply \
 //thickness=0.18 //x=5.59 //y=1.405 //x2=5.705 //y2=1.405
r291 (  61 91 ) resistor r=5.52526 //w=0.168 //l=0.115 //layer=ply \
 //thickness=0.18 //x=5.37 //y=0.75 //x2=5.255 //y2=0.75
r292 (  60 93 ) resistor r=5.52526 //w=0.168 //l=0.115 //layer=ply \
 //thickness=0.18 //x=5.59 //y=0.75 //x2=5.705 //y2=0.75
r293 (  60 61 ) resistor r=112.809 //w=0.094 //l=0.22 //layer=ply \
 //thickness=0.18 //x=5.59 //y=0.75 //x2=5.37 //y2=0.75
r294 (  58 65 ) resistor r=22.1787 //w=0.252 //l=0.106066 //layer=ply \
 //thickness=0.18 //x=5.575 //y=4.795 //x2=5.65 //y2=4.87
r295 (  58 59 ) resistor r=148.702 //w=0.094 //l=0.29 //layer=ply \
 //thickness=0.18 //x=5.575 //y=4.795 //x2=5.285 //y2=4.795
r296 (  57 92 ) resistor r=45.1352 //w=0.168 //l=0.173853 //layer=ply \
 //thickness=0.18 //x=5.215 //y=1.25 //x2=5.255 //y2=1.405
r297 (  56 91 ) resistor r=45.1352 //w=0.168 //l=0.173853 //layer=ply \
 //thickness=0.18 //x=5.215 //y=0.905 //x2=5.255 //y2=0.75
r298 (  56 57 ) resistor r=176.904 //w=0.094 //l=0.345 //layer=ply \
 //thickness=0.18 //x=5.215 //y=0.905 //x2=5.215 //y2=1.25
r299 (  53 59 ) resistor r=26.9307 //w=0.15 //l=0.106066 //layer=ply \
 //thickness=0.18 //x=5.21 //y=4.87 //x2=5.285 //y2=4.795
r300 (  52 88 ) resistor r=592.245 //w=0.094 //l=1.155 //layer=ply \
 //thickness=0.18 //x=8.11 //y=6.025 //x2=8.11 //y2=4.87
r301 (  51 76 ) resistor r=592.245 //w=0.094 //l=1.155 //layer=ply \
 //thickness=0.18 //x=7.67 //y=6.025 //x2=7.67 //y2=4.87
r302 (  50 65 ) resistor r=592.245 //w=0.094 //l=1.155 //layer=ply \
 //thickness=0.18 //x=5.65 //y=6.025 //x2=5.65 //y2=4.87
r303 (  49 53 ) resistor r=592.245 //w=0.094 //l=1.155 //layer=ply \
 //thickness=0.18 //x=5.21 //y=6.025 //x2=5.21 //y2=4.87
r304 (  48 81 ) resistor r=56.4043 //w=0.094 //l=0.11 //layer=ply \
 //thickness=0.18 //x=7.84 //y=1.365 //x2=7.95 //y2=1.365
r305 (  48 82 ) resistor r=56.4043 //w=0.094 //l=0.11 //layer=ply \
 //thickness=0.18 //x=7.84 //y=1.365 //x2=7.73 //y2=1.365
r306 (  47 62 ) resistor r=56.4043 //w=0.094 //l=0.11 //layer=ply \
 //thickness=0.18 //x=5.48 //y=1.405 //x2=5.59 //y2=1.405
r307 (  47 63 ) resistor r=56.4043 //w=0.094 //l=0.11 //layer=ply \
 //thickness=0.18 //x=5.48 //y=1.405 //x2=5.37 //y2=1.405
r308 (  43 102 ) resistor r=152 //w=0.17 //l=0.17 //layer=licon //count=1 \
 //x=7.4 //y=4.705 //x2=7.4 //y2=4.705
r309 (  38 100 ) resistor r=152 //w=0.17 //l=0.17 //layer=licon //count=1 \
 //x=7.4 //y=2.08 //x2=7.4 //y2=2.08
r310 (  33 98 ) resistor r=152 //w=0.17 //l=0.17 //layer=licon //count=1 \
 //x=5.92 //y=4.705 //x2=5.92 //y2=4.705
r311 (  28 96 ) resistor r=152 //w=0.17 //l=0.17 //layer=licon //count=1 \
 //x=5.92 //y=2.08 //x2=5.92 //y2=2.08
r312 (  24 25 ) resistor r=0.10734 //w=0.281 //l=0.16 //layer=m2 \
 //thickness=0.36 //x=7.395 //y=2.09 //x2=7.235 //y2=2.09
r313 (  22 25 ) resistor r=1.09733 //w=0.131 //l=1.15 //layer=m2 \
 //thickness=0.36 //x=6.085 //y=2.08 //x2=7.235 //y2=2.08
r314 (  20 22 ) resistor r=0.10734 //w=0.281 //l=0.16 //layer=m2 \
 //thickness=0.36 //x=5.925 //y=2.09 //x2=6.085 //y2=2.09
r315 (  16 43 ) resistor r=9.3 //w=0.17 //l=0.17 //layer=mcon //count=1 \
 //x=7.4 //y=4.705 //x2=7.4 //y2=4.705
r316 (  14 24 ) resistor r=4.5 //w=0.15 //l=0.15 //layer=via1 //count=1 \
 //x=7.395 //y=2.09 //x2=7.395 //y2=2.09
r317 (  12 38 ) resistor r=9.3 //w=0.17 //l=0.17 //layer=mcon //count=1 \
 //x=7.4 //y=2.08 //x2=7.4 //y2=2.08
r318 (  12 14 ) resistor r=0.00334225 //w=0.374 //l=0.01 //layer=m1 \
 //thickness=0.36 //x=7.345 //y=2.08 //x2=7.345 //y2=2.09
r319 (  10 20 ) resistor r=4.5 //w=0.15 //l=0.15 //layer=via1 //count=1 \
 //x=5.925 //y=2.09 //x2=5.925 //y2=2.09
r320 (  8 28 ) resistor r=9.3 //w=0.17 //l=0.17 //layer=mcon //count=1 \
 //x=5.92 //y=2.08 //x2=5.92 //y2=2.08
r321 (  8 10 ) resistor r=0.00334225 //w=0.374 //l=0.01 //layer=m1 \
 //thickness=0.36 //x=5.975 //y=2.08 //x2=5.975 //y2=2.09
r322 (  6 33 ) resistor r=9.3 //w=0.17 //l=0.17 //layer=mcon //count=1 \
 //x=5.92 //y=4.705 //x2=5.92 //y2=4.705
r323 (  4 16 ) resistor r=0.0777782 //w=0.252 //l=0.131491 //layer=m1 \
 //thickness=0.36 //x=7.4 //y=4.575 //x2=7.397 //y2=4.705
r324 (  3 14 ) resistor r=0.0910802 //w=0.374 //l=0.185472 //layer=m1 \
 //thickness=0.36 //x=7.4 //y=2.25 //x2=7.345 //y2=2.09
r325 (  3 4 ) resistor r=2.21851 //w=0.131 //l=2.325 //layer=m1 \
 //thickness=0.36 //x=7.4 //y=2.25 //x2=7.4 //y2=4.575
r326 (  2 6 ) resistor r=0.075298 //w=0.252 //l=0.125 //layer=m1 \
 //thickness=0.36 //x=5.92 //y=4.58 //x2=5.92 //y2=4.705
r327 (  1 10 ) resistor r=0.0910802 //w=0.374 //l=0.185472 //layer=m1 \
 //thickness=0.36 //x=5.92 //y=2.25 //x2=5.975 //y2=2.09
r328 (  1 2 ) resistor r=2.22328 //w=0.131 //l=2.33 //layer=m1 \
 //thickness=0.36 //x=5.92 //y=2.25 //x2=5.92 //y2=4.58
ends PM_VOTER3X1_PCELL\%noxref_2

subckt PM_VOTER3X1_PCELL\%noxref_3 ( 1 2 3 4 5 6 7 8 16 20 30 32 33 36 45 50 \
 59 63 64 65 66 67 68 69 70 71 76 78 80 86 87 88 89 90 95 97 99 105 106 108 \
 109 112 120 121 124 )
c288 ( 124 0 ) capacitor c=0.0370698f //x=8.53 //y=4.705
c289 ( 121 0 ) capacitor c=0.028421f //x=8.51 //y=1.915
c290 ( 120 0 ) capacitor c=0.0512002f //x=8.51 //y=2.08
c291 ( 112 0 ) capacitor c=0.0387879f //x=1.89 //y=4.705
c292 ( 109 0 ) capacitor c=0.0300885f //x=1.85 //y=1.915
c293 ( 108 0 ) capacitor c=0.0554483f //x=1.85 //y=2.08
c294 ( 106 0 ) capacitor c=0.0237734f //x=9.075 //y=1.255
c295 ( 105 0 ) capacitor c=0.0191782f //x=9.075 //y=0.905
c296 ( 99 0 ) capacitor c=0.0361171f //x=8.92 //y=1.405
c297 ( 97 0 ) capacitor c=0.0157803f //x=8.92 //y=0.75
c298 ( 95 0 ) capacitor c=0.0377178f //x=8.915 //y=4.795
c299 ( 90 0 ) capacitor c=0.020493f //x=8.545 //y=1.56
c300 ( 89 0 ) capacitor c=0.0167049f //x=8.545 //y=1.255
c301 ( 88 0 ) capacitor c=0.0174993f //x=8.545 //y=0.905
c302 ( 87 0 ) capacitor c=0.0443648f //x=2.415 //y=1.25
c303 ( 86 0 ) capacitor c=0.0192211f //x=2.415 //y=0.905
c304 ( 80 0 ) capacitor c=0.0186579f //x=2.26 //y=1.405
c305 ( 78 0 ) capacitor c=0.0157795f //x=2.26 //y=0.75
c306 ( 76 0 ) capacitor c=0.0351351f //x=2.255 //y=4.795
c307 ( 71 0 ) capacitor c=0.0209124f //x=1.885 //y=1.56
c308 ( 70 0 ) capacitor c=0.016848f //x=1.885 //y=1.25
c309 ( 69 0 ) capacitor c=0.0174777f //x=1.885 //y=0.905
c310 ( 68 0 ) capacitor c=0.155887f //x=8.99 //y=6.025
c311 ( 67 0 ) capacitor c=0.1106f //x=8.55 //y=6.025
c312 ( 66 0 ) capacitor c=0.154859f //x=2.33 //y=6.025
c313 ( 65 0 ) capacitor c=0.110573f //x=1.89 //y=6.025
c314 ( 59 0 ) capacitor c=8.10708e-19 //x=8.53 //y=4.705
c315 ( 50 0 ) capacitor c=0.00105273f //x=8.51 //y=2.08
c316 ( 45 0 ) capacitor c=0.00155307f //x=1.89 //y=4.705
c317 ( 36 0 ) capacitor c=0.00152737f //x=1.85 //y=2.08
c318 ( 33 0 ) capacitor c=0.208122f //x=8.365 //y=4.03
c319 ( 32 0 ) capacitor c=0.00479868f //x=8.525 //y=4.03
c320 ( 30 0 ) capacitor c=0.00579767f //x=2.01 //y=4.025
c321 ( 20 0 ) capacitor c=0.0138506f //x=8.51 //y=4.07
c322 ( 16 0 ) capacitor c=0.0153807f //x=1.85 //y=4.07
c323 ( 8 0 ) capacitor c=0.0124358f //x=8.51 //y=4.56
c324 ( 7 0 ) capacitor c=0.0108568f //x=8.51 //y=4.19
c325 ( 6 0 ) capacitor c=0.0499737f //x=8.51 //y=3.87
c326 ( 5 0 ) capacitor c=0.00651439f //x=8.51 //y=2.2
c327 ( 4 0 ) capacitor c=0.0189667f //x=1.85 //y=4.53
c328 ( 3 0 ) capacitor c=0.0126227f //x=1.85 //y=4.185
c329 ( 2 0 ) capacitor c=0.0685407f //x=1.85 //y=3.865
c330 ( 1 0 ) capacitor c=0.00920415f //x=1.85 //y=2.195
r331 (  126 127 ) resistor r=32.4568 //w=0.214 //l=0.075 //layer=ply \
 //thickness=0.18 //x=8.53 //y=4.795 //x2=8.53 //y2=4.87
r332 (  124 126 ) resistor r=20.271 //w=0.214 //l=0.09 //layer=ply \
 //thickness=0.18 //x=8.53 //y=4.705 //x2=8.53 //y2=4.795
r333 (  120 121 ) resistor r=52.7279 //w=0.214 //l=0.165 //layer=ply \
 //thickness=0.18 //x=8.51 //y=2.08 //x2=8.51 //y2=1.915
r334 (  112 114 ) resistor r=20.271 //w=0.214 //l=0.09 //layer=ply \
 //thickness=0.18 //x=1.89 //y=4.705 //x2=1.89 //y2=4.795
r335 (  108 109 ) resistor r=52.7279 //w=0.214 //l=0.165 //layer=ply \
 //thickness=0.18 //x=1.85 //y=2.08 //x2=1.85 //y2=1.915
r336 (  106 131 ) resistor r=4.95774 //w=0.164 //l=0.112 //layer=ply \
 //thickness=0.18 //x=9.075 //y=1.255 //x2=9.075 //y2=1.367
r337 (  105 130 ) resistor r=45.1352 //w=0.168 //l=0.173853 //layer=ply \
 //thickness=0.18 //x=9.075 //y=0.905 //x2=9.035 //y2=0.75
r338 (  105 106 ) resistor r=179.468 //w=0.094 //l=0.35 //layer=ply \
 //thickness=0.18 //x=9.075 //y=0.905 //x2=9.075 //y2=1.255
r339 (  100 129 ) resistor r=10.8103 //w=0.211 //l=0.115 //layer=ply \
 //thickness=0.18 //x=8.7 //y=1.405 //x2=8.585 //y2=1.405
r340 (  99 131 ) resistor r=45.9962 //w=0.164 //l=0.17296 //layer=ply \
 //thickness=0.18 //x=8.92 //y=1.405 //x2=9.075 //y2=1.367
r341 (  98 128 ) resistor r=5.52526 //w=0.168 //l=0.115 //layer=ply \
 //thickness=0.18 //x=8.7 //y=0.75 //x2=8.585 //y2=0.75
r342 (  97 130 ) resistor r=5.52526 //w=0.168 //l=0.115 //layer=ply \
 //thickness=0.18 //x=8.92 //y=0.75 //x2=9.035 //y2=0.75
r343 (  97 98 ) resistor r=112.809 //w=0.094 //l=0.22 //layer=ply \
 //thickness=0.18 //x=8.92 //y=0.75 //x2=8.7 //y2=0.75
r344 (  96 126 ) resistor r=16.5046 //w=0.27 //l=0.135 //layer=ply \
 //thickness=0.18 //x=8.665 //y=4.795 //x2=8.53 //y2=4.795
r345 (  95 102 ) resistor r=26.9307 //w=0.15 //l=0.106066 //layer=ply \
 //thickness=0.18 //x=8.915 //y=4.795 //x2=8.99 //y2=4.87
r346 (  95 96 ) resistor r=128.191 //w=0.094 //l=0.25 //layer=ply \
 //thickness=0.18 //x=8.915 //y=4.795 //x2=8.665 //y2=4.795
r347 (  90 129 ) resistor r=39.5036 //w=0.211 //l=0.173853 //layer=ply \
 //thickness=0.18 //x=8.545 //y=1.56 //x2=8.585 //y2=1.405
r348 (  90 121 ) resistor r=182.032 //w=0.094 //l=0.355 //layer=ply \
 //thickness=0.18 //x=8.545 //y=1.56 //x2=8.545 //y2=1.915
r349 (  89 129 ) resistor r=38.3614 //w=0.211 //l=0.168819 //layer=ply \
 //thickness=0.18 //x=8.545 //y=1.255 //x2=8.585 //y2=1.405
r350 (  88 128 ) resistor r=45.1352 //w=0.168 //l=0.173853 //layer=ply \
 //thickness=0.18 //x=8.545 //y=0.905 //x2=8.585 //y2=0.75
r351 (  88 89 ) resistor r=179.468 //w=0.094 //l=0.35 //layer=ply \
 //thickness=0.18 //x=8.545 //y=0.905 //x2=8.545 //y2=1.255
r352 (  87 118 ) resistor r=45.1352 //w=0.168 //l=0.173853 //layer=ply \
 //thickness=0.18 //x=2.415 //y=1.25 //x2=2.375 //y2=1.405
r353 (  86 117 ) resistor r=45.1352 //w=0.168 //l=0.173853 //layer=ply \
 //thickness=0.18 //x=2.415 //y=0.905 //x2=2.375 //y2=0.75
r354 (  86 87 ) resistor r=176.904 //w=0.094 //l=0.345 //layer=ply \
 //thickness=0.18 //x=2.415 //y=0.905 //x2=2.415 //y2=1.25
r355 (  81 116 ) resistor r=10.701 //w=0.21 //l=0.115 //layer=ply \
 //thickness=0.18 //x=2.04 //y=1.405 //x2=1.925 //y2=1.405
r356 (  80 118 ) resistor r=5.52526 //w=0.168 //l=0.115 //layer=ply \
 //thickness=0.18 //x=2.26 //y=1.405 //x2=2.375 //y2=1.405
r357 (  79 115 ) resistor r=5.52526 //w=0.168 //l=0.115 //layer=ply \
 //thickness=0.18 //x=2.04 //y=0.75 //x2=1.925 //y2=0.75
r358 (  78 117 ) resistor r=5.52526 //w=0.168 //l=0.115 //layer=ply \
 //thickness=0.18 //x=2.26 //y=0.75 //x2=2.375 //y2=0.75
r359 (  78 79 ) resistor r=112.809 //w=0.094 //l=0.22 //layer=ply \
 //thickness=0.18 //x=2.26 //y=0.75 //x2=2.04 //y2=0.75
r360 (  77 114 ) resistor r=16.5046 //w=0.27 //l=0.135 //layer=ply \
 //thickness=0.18 //x=2.025 //y=4.795 //x2=1.89 //y2=4.795
r361 (  76 83 ) resistor r=26.9307 //w=0.15 //l=0.106066 //layer=ply \
 //thickness=0.18 //x=2.255 //y=4.795 //x2=2.33 //y2=4.87
r362 (  76 77 ) resistor r=117.936 //w=0.094 //l=0.23 //layer=ply \
 //thickness=0.18 //x=2.255 //y=4.795 //x2=2.025 //y2=4.795
r363 (  73 114 ) resistor r=32.4568 //w=0.214 //l=0.075 //layer=ply \
 //thickness=0.18 //x=1.89 //y=4.87 //x2=1.89 //y2=4.795
r364 (  71 116 ) resistor r=39.5823 //w=0.21 //l=0.173853 //layer=ply \
 //thickness=0.18 //x=1.885 //y=1.56 //x2=1.925 //y2=1.405
r365 (  71 109 ) resistor r=182.032 //w=0.094 //l=0.355 //layer=ply \
 //thickness=0.18 //x=1.885 //y=1.56 //x2=1.885 //y2=1.915
r366 (  70 116 ) resistor r=39.5823 //w=0.21 //l=0.173853 //layer=ply \
 //thickness=0.18 //x=1.885 //y=1.25 //x2=1.925 //y2=1.405
r367 (  69 115 ) resistor r=45.1352 //w=0.168 //l=0.173853 //layer=ply \
 //thickness=0.18 //x=1.885 //y=0.905 //x2=1.925 //y2=0.75
r368 (  69 70 ) resistor r=176.904 //w=0.094 //l=0.345 //layer=ply \
 //thickness=0.18 //x=1.885 //y=0.905 //x2=1.885 //y2=1.25
r369 (  68 102 ) resistor r=592.245 //w=0.094 //l=1.155 //layer=ply \
 //thickness=0.18 //x=8.99 //y=6.025 //x2=8.99 //y2=4.87
r370 (  67 127 ) resistor r=592.245 //w=0.094 //l=1.155 //layer=ply \
 //thickness=0.18 //x=8.55 //y=6.025 //x2=8.55 //y2=4.87
r371 (  66 83 ) resistor r=592.245 //w=0.094 //l=1.155 //layer=ply \
 //thickness=0.18 //x=2.33 //y=6.025 //x2=2.33 //y2=4.87
r372 (  65 73 ) resistor r=592.245 //w=0.094 //l=1.155 //layer=ply \
 //thickness=0.18 //x=1.89 //y=6.025 //x2=1.89 //y2=4.87
r373 (  64 99 ) resistor r=56.4043 //w=0.094 //l=0.11 //layer=ply \
 //thickness=0.18 //x=8.81 //y=1.405 //x2=8.92 //y2=1.405
r374 (  64 100 ) resistor r=56.4043 //w=0.094 //l=0.11 //layer=ply \
 //thickness=0.18 //x=8.81 //y=1.405 //x2=8.7 //y2=1.405
r375 (  63 80 ) resistor r=56.4043 //w=0.094 //l=0.11 //layer=ply \
 //thickness=0.18 //x=2.15 //y=1.405 //x2=2.26 //y2=1.405
r376 (  63 81 ) resistor r=56.4043 //w=0.094 //l=0.11 //layer=ply \
 //thickness=0.18 //x=2.15 //y=1.405 //x2=2.04 //y2=1.405
r377 (  59 124 ) resistor r=152 //w=0.17 //l=0.17 //layer=licon //count=1 \
 //x=8.53 //y=4.705 //x2=8.53 //y2=4.705
r378 (  50 120 ) resistor r=152 //w=0.17 //l=0.17 //layer=licon //count=1 \
 //x=8.51 //y=2.08 //x2=8.51 //y2=2.08
r379 (  45 112 ) resistor r=152 //w=0.17 //l=0.17 //layer=licon //count=1 \
 //x=1.89 //y=4.705 //x2=1.89 //y2=4.705
r380 (  36 108 ) resistor r=152 //w=0.17 //l=0.17 //layer=licon //count=1 \
 //x=1.85 //y=2.08 //x2=1.85 //y2=2.08
r381 (  32 33 ) resistor r=0.104807 //w=0.281 //l=0.16 //layer=m2 \
 //thickness=0.36 //x=8.525 //y=4.03 //x2=8.365 //y2=4.03
r382 (  30 33 ) resistor r=5.84099 //w=0.136 //l=6.355 //layer=m2 \
 //thickness=0.36 //x=2.01 //y=4.072 //x2=8.365 //y2=4.072
r383 (  28 30 ) resistor r=0.104807 //w=0.281 //l=0.16 //layer=m2 \
 //thickness=0.36 //x=1.85 //y=4.025 //x2=2.01 //y2=4.025
r384 (  24 59 ) resistor r=9.3 //w=0.17 //l=0.17 //layer=mcon //count=1 \
 //x=8.53 //y=4.705 //x2=8.53 //y2=4.705
r385 (  22 50 ) resistor r=9.3 //w=0.17 //l=0.17 //layer=mcon //count=1 \
 //x=8.51 //y=2.08 //x2=8.51 //y2=2.08
r386 (  18 32 ) resistor r=4.5 //w=0.15 //l=0.15 //layer=via1 //count=1 \
 //x=8.525 //y=4.03 //x2=8.525 //y2=4.03
r387 (  18 20 ) resistor r=0.0130208 //w=0.384 //l=0.04 //layer=m1 \
 //thickness=0.36 //x=8.465 //y=4.03 //x2=8.465 //y2=4.07
r388 (  14 28 ) resistor r=4.5 //w=0.15 //l=0.15 //layer=via1 //count=1 \
 //x=1.85 //y=4.025 //x2=1.85 //y2=4.025
r389 (  14 16 ) resistor r=0.0149601 //w=0.376 //l=0.045 //layer=m1 \
 //thickness=0.36 //x=1.902 //y=4.025 //x2=1.902 //y2=4.07
r390 (  12 45 ) resistor r=9.3 //w=0.17 //l=0.17 //layer=mcon //count=1 \
 //x=1.89 //y=4.705 //x2=1.89 //y2=4.705
r391 (  10 36 ) resistor r=9.3 //w=0.17 //l=0.17 //layer=mcon //count=1 \
 //x=1.85 //y=2.08 //x2=1.85 //y2=2.08
r392 (  8 24 ) resistor r=0.0893515 //w=0.219 //l=0.154677 //layer=m1 \
 //thickness=0.36 //x=8.51 //y=4.56 //x2=8.53 //y2=4.705
r393 (  7 20 ) resistor r=0.0784723 //w=0.384 //l=0.140712 //layer=m1 \
 //thickness=0.36 //x=8.51 //y=4.19 //x2=8.465 //y2=4.07
r394 (  7 8 ) resistor r=0.353053 //w=0.131 //l=0.37 //layer=m1 \
 //thickness=0.36 //x=8.51 //y=4.19 //x2=8.51 //y2=4.56
r395 (  6 18 ) resistor r=0.0914932 //w=0.384 //l=0.181108 //layer=m1 \
 //thickness=0.36 //x=8.51 //y=3.87 //x2=8.465 //y2=4.03
r396 (  5 22 ) resistor r=0.0744285 //w=0.225 //l=0.12 //layer=m1 \
 //thickness=0.36 //x=8.51 //y=2.2 //x2=8.51 //y2=2.08
r397 (  5 6 ) resistor r=1.59351 //w=0.131 //l=1.67 //layer=m1 \
 //thickness=0.36 //x=8.51 //y=2.2 //x2=8.51 //y2=3.87
r398 (  4 12 ) resistor r=0.100665 //w=0.248 //l=0.193972 //layer=m1 \
 //thickness=0.36 //x=1.85 //y=4.53 //x2=1.89 //y2=4.705
r399 (  3 16 ) resistor r=0.0761992 //w=0.376 //l=0.138582 //layer=m1 \
 //thickness=0.36 //x=1.85 //y=4.185 //x2=1.902 //y2=4.07
r400 (  3 4 ) resistor r=0.329198 //w=0.131 //l=0.345 //layer=m1 \
 //thickness=0.36 //x=1.85 //y=4.185 //x2=1.85 //y2=4.53
r401 (  2 14 ) resistor r=0.0911593 //w=0.376 //l=0.184174 //layer=m1 \
 //thickness=0.36 //x=1.85 //y=3.865 //x2=1.902 //y2=4.025
r402 (  1 10 ) resistor r=0.0717383 //w=0.224 //l=0.115 //layer=m1 \
 //thickness=0.36 //x=1.85 //y=2.195 //x2=1.85 //y2=2.08
r403 (  1 2 ) resistor r=1.59351 //w=0.131 //l=1.67 //layer=m1 \
 //thickness=0.36 //x=1.85 //y=2.195 //x2=1.85 //y2=3.865
ends PM_VOTER3X1_PCELL\%noxref_3

subckt PM_VOTER3X1_PCELL\%noxref_4 ( 1 3 4 5 7 8 10 11 12 14 15 16 18 22 25 28 \
 36 40 44 57 60 61 63 64 69 71 72 81 89 107 116 124 125 126 127 128 129 130 \
 134 135 136 138 144 145 147 155 156 157 161 162 )
c333 ( 157 0 ) capacitor c=0.00985497f //x=8.62 //y=0.905
c334 ( 156 0 ) capacitor c=0.0108944f //x=5.29 //y=0.905
c335 ( 155 0 ) capacitor c=0.0110396f //x=1.96 //y=0.905
c336 ( 147 0 ) capacitor c=0.0588117f //x=10.73 //y=2.085
c337 ( 145 0 ) capacitor c=0.0439576f //x=11.37 //y=1.255
c338 ( 144 0 ) capacitor c=0.0201087f //x=11.37 //y=0.91
c339 ( 138 0 ) capacitor c=0.0161986f //x=11.215 //y=1.41
c340 ( 136 0 ) capacitor c=0.0157807f //x=11.215 //y=0.755
c341 ( 135 0 ) capacitor c=0.051364f //x=10.96 //y=4.79
c342 ( 134 0 ) capacitor c=0.0406047f //x=11.25 //y=4.79
c343 ( 130 0 ) capacitor c=0.0301471f //x=10.84 //y=1.92
c344 ( 129 0 ) capacitor c=0.0255349f //x=10.84 //y=1.565
c345 ( 128 0 ) capacitor c=0.0234346f //x=10.84 //y=1.255
c346 ( 127 0 ) capacitor c=0.02013f //x=10.84 //y=0.91
c347 ( 126 0 ) capacitor c=0.153839f //x=11.325 //y=6.02
c348 ( 125 0 ) capacitor c=0.15434f //x=10.885 //y=6.02
c349 ( 116 0 ) capacitor c=6.76699e-19 //x=10.73 //y=4.7
c350 ( 107 0 ) capacitor c=9.11699e-19 //x=10.73 //y=2.085
c351 ( 89 0 ) capacitor c=0.0265472f //x=8.77 //y=5.38
c352 ( 81 0 ) capacitor c=0.0232072f //x=7.89 //y=5.38
c353 ( 72 0 ) capacitor c=0.0554023f //x=10.57 //y=4.075
c354 ( 71 0 ) capacitor c=0.00507699f //x=10.73 //y=4.075
c355 ( 69 0 ) capacitor c=0.00713729f //x=9.41 //y=4.075
c356 ( 64 0 ) capacitor c=0.0867005f //x=8.645 //y=1.225
c357 ( 63 0 ) capacitor c=0.0257508f //x=8.805 //y=1.225
c358 ( 61 0 ) capacitor c=0.0121686f //x=5.61 //y=1.225
c359 ( 60 0 ) capacitor c=0.125419f //x=5.35 //y=1.225
c360 ( 57 0 ) capacitor c=0.00933361f //x=2.315 //y=1.225
c361 ( 44 0 ) capacitor c=0.0116317f //x=10.73 //y=2.085
c362 ( 40 0 ) capacitor c=0.0139687f //x=10.73 //y=4.07
c363 ( 36 0 ) capacitor c=0.0138559f //x=9.25 //y=4.07
c364 ( 28 0 ) capacitor c=0.0126021f //x=8.767 //y=5.21
c365 ( 25 0 ) capacitor c=0.0156957f //x=7.89 //y=5.21
c366 ( 22 0 ) capacitor c=0.00887677f //x=5.48 //y=1.18
c367 ( 18 0 ) capacitor c=0.00746851f //x=2.15 //y=1.18
c368 ( 16 0 ) capacitor c=0.010406f //x=10.73 //y=4.58
c369 ( 15 0 ) capacitor c=0.0112318f //x=10.73 //y=4.235
c370 ( 14 0 ) capacitor c=0.0499188f //x=10.73 //y=3.915
c371 ( 12 0 ) capacitor c=0.0203608f //x=9.25 //y=5.125
c372 ( 11 0 ) capacitor c=0.0114995f //x=9.25 //y=4.235
c373 ( 10 0 ) capacitor c=0.0636522f //x=9.25 //y=3.915
c374 ( 8 0 ) capacitor c=0.00834076f //x=8.895 //y=1.645
c375 ( 7 0 ) capacitor c=0.014154f //x=9.165 //y=1.645
c376 ( 5 0 ) capacitor c=0.00996583f //x=9.165 //y=5.21
c377 ( 4 0 ) capacitor c=0.00638645f //x=8.81 //y=1.56
c378 ( 3 0 ) capacitor c=0.00623208f //x=8.81 //y=1.355
c379 ( 1 0 ) capacitor c=0.0116295f //x=8.645 //y=5.21
r380 (  147 148 ) resistor r=17.5563 //w=0.302 //l=0.11 //layer=ply \
 //thickness=0.18 //x=10.73 //y=2.085 //x2=10.84 //y2=2.085
r381 (  145 154 ) resistor r=45.1352 //w=0.168 //l=0.173853 //layer=ply \
 //thickness=0.18 //x=11.37 //y=1.255 //x2=11.33 //y2=1.41
r382 (  144 153 ) resistor r=45.1352 //w=0.168 //l=0.173853 //layer=ply \
 //thickness=0.18 //x=11.37 //y=0.91 //x2=11.33 //y2=0.755
r383 (  144 145 ) resistor r=176.904 //w=0.094 //l=0.345 //layer=ply \
 //thickness=0.18 //x=11.37 //y=0.91 //x2=11.37 //y2=1.255
r384 (  139 152 ) resistor r=10.701 //w=0.21 //l=0.115 //layer=ply \
 //thickness=0.18 //x=10.995 //y=1.41 //x2=10.88 //y2=1.41
r385 (  138 154 ) resistor r=5.52526 //w=0.168 //l=0.115 //layer=ply \
 //thickness=0.18 //x=11.215 //y=1.41 //x2=11.33 //y2=1.41
r386 (  137 151 ) resistor r=5.52526 //w=0.168 //l=0.115 //layer=ply \
 //thickness=0.18 //x=10.995 //y=0.755 //x2=10.88 //y2=0.755
r387 (  136 153 ) resistor r=5.52526 //w=0.168 //l=0.115 //layer=ply \
 //thickness=0.18 //x=11.215 //y=0.755 //x2=11.33 //y2=0.755
r388 (  136 137 ) resistor r=112.809 //w=0.094 //l=0.22 //layer=ply \
 //thickness=0.18 //x=11.215 //y=0.755 //x2=10.995 //y2=0.755
r389 (  134 141 ) resistor r=26.9307 //w=0.15 //l=0.106066 //layer=ply \
 //thickness=0.18 //x=11.25 //y=4.79 //x2=11.325 //y2=4.865
r390 (  134 135 ) resistor r=148.702 //w=0.094 //l=0.29 //layer=ply \
 //thickness=0.18 //x=11.25 //y=4.79 //x2=10.96 //y2=4.79
r391 (  131 135 ) resistor r=23.403 //w=0.284 //l=0.106066 //layer=ply \
 //thickness=0.18 //x=10.885 //y=4.865 //x2=10.96 //y2=4.79
r392 (  131 150 ) resistor r=26.3063 //w=0.284 //l=0.229783 //layer=ply \
 //thickness=0.18 //x=10.885 //y=4.865 //x2=10.73 //y2=4.7
r393 (  130 148 ) resistor r=19.1248 //w=0.302 //l=0.165 //layer=ply \
 //thickness=0.18 //x=10.84 //y=1.92 //x2=10.84 //y2=2.085
r394 (  129 152 ) resistor r=39.5823 //w=0.21 //l=0.173853 //layer=ply \
 //thickness=0.18 //x=10.84 //y=1.565 //x2=10.88 //y2=1.41
r395 (  129 130 ) resistor r=182.032 //w=0.094 //l=0.355 //layer=ply \
 //thickness=0.18 //x=10.84 //y=1.565 //x2=10.84 //y2=1.92
r396 (  128 152 ) resistor r=39.5823 //w=0.21 //l=0.173853 //layer=ply \
 //thickness=0.18 //x=10.84 //y=1.255 //x2=10.88 //y2=1.41
r397 (  127 151 ) resistor r=45.1352 //w=0.168 //l=0.173853 //layer=ply \
 //thickness=0.18 //x=10.84 //y=0.91 //x2=10.88 //y2=0.755
r398 (  127 128 ) resistor r=176.904 //w=0.094 //l=0.345 //layer=ply \
 //thickness=0.18 //x=10.84 //y=0.91 //x2=10.84 //y2=1.255
r399 (  126 141 ) resistor r=592.245 //w=0.094 //l=1.155 //layer=ply \
 //thickness=0.18 //x=11.325 //y=6.02 //x2=11.325 //y2=4.865
r400 (  125 131 ) resistor r=592.245 //w=0.094 //l=1.155 //layer=ply \
 //thickness=0.18 //x=10.885 //y=6.02 //x2=10.885 //y2=4.865
r401 (  124 138 ) resistor r=56.4043 //w=0.094 //l=0.11 //layer=ply \
 //thickness=0.18 //x=11.105 //y=1.41 //x2=11.215 //y2=1.41
r402 (  124 139 ) resistor r=56.4043 //w=0.094 //l=0.11 //layer=ply \
 //thickness=0.18 //x=11.105 //y=1.41 //x2=10.995 //y2=1.41
r403 (  123 155 ) resistor r=13.3953 //w=0.172 //l=0.18 //layer=li \
 //thickness=0.1 //x=2.147 //y=1.18 //x2=2.147 //y2=1
r404 (  116 150 ) resistor r=152 //w=0.17 //l=0.17 //layer=licon //count=1 \
 //x=10.73 //y=4.7 //x2=10.73 //y2=4.7
r405 (  107 147 ) resistor r=152 //w=0.17 //l=0.17 //layer=licon //count=1 \
 //x=10.73 //y=2.085 //x2=10.73 //y2=2.085
r406 (  100 157 ) resistor r=12.3209 //w=0.187 //l=0.18 //layer=li \
 //thickness=0.1 //x=8.81 //y=1.18 //x2=8.81 //y2=1
r407 (  89 162 ) resistor r=23.2727 //w=0.187 //l=0.34 //layer=li \
 //thickness=0.1 //x=8.77 //y=5.38 //x2=8.77 //y2=5.72
r408 (  81 161 ) resistor r=23.2727 //w=0.187 //l=0.34 //layer=li \
 //thickness=0.1 //x=7.89 //y=5.38 //x2=7.89 //y2=5.72
r409 (  78 156 ) resistor r=12.3209 //w=0.187 //l=0.18 //layer=li \
 //thickness=0.1 //x=5.48 //y=1.18 //x2=5.48 //y2=1
r410 (  71 72 ) resistor r=0.10734 //w=0.281 //l=0.16 //layer=m2 \
 //thickness=0.36 //x=10.73 //y=4.075 //x2=10.57 //y2=4.075
r411 (  69 72 ) resistor r=1.10687 //w=0.131 //l=1.16 //layer=m2 \
 //thickness=0.36 //x=9.41 //y=4.07 //x2=10.57 //y2=4.07
r412 (  67 69 ) resistor r=0.10734 //w=0.281 //l=0.16 //layer=m2 \
 //thickness=0.36 //x=9.25 //y=4.075 //x2=9.41 //y2=4.075
r413 (  63 64 ) resistor r=0.10734 //w=0.281 //l=0.16 //layer=m2 \
 //thickness=0.36 //x=8.805 //y=1.225 //x2=8.645 //y2=1.225
r414 (  61 64 ) resistor r=2.89599 //w=0.131 //l=3.035 //layer=m2 \
 //thickness=0.36 //x=5.61 //y=1.18 //x2=8.645 //y2=1.18
r415 (  59 61 ) resistor r=0.0942778 //w=0.221 //l=0.13 //layer=m2 \
 //thickness=0.36 //x=5.48 //y=1.225 //x2=5.61 //y2=1.225
r416 (  59 60 ) resistor r=0.0942778 //w=0.221 //l=0.13 //layer=m2 \
 //thickness=0.36 //x=5.48 //y=1.225 //x2=5.35 //y2=1.225
r417 (  57 60 ) resistor r=2.89599 //w=0.131 //l=3.035 //layer=m2 \
 //thickness=0.36 //x=2.315 //y=1.18 //x2=5.35 //y2=1.18
r418 (  55 57 ) resistor r=0.10734 //w=0.281 //l=0.16 //layer=m2 \
 //thickness=0.36 //x=2.155 //y=1.225 //x2=2.315 //y2=1.225
r419 (  47 116 ) resistor r=9.3 //w=0.17 //l=0.17 //layer=mcon //count=1 \
 //x=10.73 //y=4.7 //x2=10.73 //y2=4.7
r420 (  44 107 ) resistor r=9.3 //w=0.17 //l=0.17 //layer=mcon //count=1 \
 //x=10.73 //y=2.085 //x2=10.73 //y2=2.085
r421 (  42 71 ) resistor r=4.5 //w=0.15 //l=0.15 //layer=via1 //count=1 \
 //x=10.73 //y=4.075 //x2=10.73 //y2=4.075
r422 (  40 42 ) resistor r=0.00166223 //w=0.376 //l=0.005 //layer=m1 \
 //thickness=0.36 //x=10.677 //y=4.07 //x2=10.677 //y2=4.075
r423 (  38 67 ) resistor r=4.5 //w=0.15 //l=0.15 //layer=via1 //count=1 \
 //x=9.25 //y=4.075 //x2=9.25 //y2=4.075
r424 (  36 38 ) resistor r=0.00166223 //w=0.376 //l=0.005 //layer=m1 \
 //thickness=0.36 //x=9.302 //y=4.07 //x2=9.302 //y2=4.075
r425 (  34 63 ) resistor r=4.5 //w=0.15 //l=0.15 //layer=via1 //count=1 \
 //x=8.805 //y=1.225 //x2=8.805 //y2=1.225
r426 (  32 100 ) resistor r=9.3 //w=0.17 //l=0.17 //layer=mcon //count=1 \
 //x=8.81 //y=1.18 //x2=8.81 //y2=1.18
r427 (  32 34 ) resistor r=0.0163043 //w=0.345 //l=0.045 //layer=m1 \
 //thickness=0.36 //x=8.75 //y=1.18 //x2=8.75 //y2=1.225
r428 (  30 89 ) resistor r=9.3 //w=0.17 //l=0.17 //layer=mcon //count=1 \
 //x=8.77 //y=5.38 //x2=8.77 //y2=5.38
r429 (  28 30 ) resistor r=0.0944444 //w=0.225 //l=0.17 //layer=m1 \
 //thickness=0.36 //x=8.767 //y=5.21 //x2=8.767 //y2=5.38
r430 (  27 81 ) resistor r=9.3 //w=0.17 //l=0.17 //layer=mcon //count=1 \
 //x=7.89 //y=5.38 //x2=7.89 //y2=5.38
r431 (  25 27 ) resistor r=0.0936123 //w=0.227 //l=0.17 //layer=m1 \
 //thickness=0.36 //x=7.89 //y=5.21 //x2=7.89 //y2=5.38
r432 (  24 59 ) resistor r=4.5 //w=0.15 //l=0.15 //layer=via1 //count=1 \
 //x=5.48 //y=1.225 //x2=5.48 //y2=1.225
r433 (  22 78 ) resistor r=9.3 //w=0.17 //l=0.17 //layer=mcon //count=1 \
 //x=5.48 //y=1.18 //x2=5.48 //y2=1.18
r434 (  22 24 ) resistor r=0.0163043 //w=0.345 //l=0.045 //layer=m1 \
 //thickness=0.36 //x=5.42 //y=1.18 //x2=5.42 //y2=1.225
r435 (  20 55 ) resistor r=4.5 //w=0.15 //l=0.15 //layer=via1 //count=1 \
 //x=2.155 //y=1.225 //x2=2.155 //y2=1.225
r436 (  18 123 ) resistor r=9.3 //w=0.17 //l=0.17 //layer=mcon //count=1 \
 //x=2.15 //y=1.18 //x2=2.15 //y2=1.18
r437 (  18 20 ) resistor r=0.0150401 //w=0.374 //l=0.045 //layer=m1 \
 //thickness=0.36 //x=2.205 //y=1.18 //x2=2.205 //y2=1.225
r438 (  16 47 ) resistor r=0.0732479 //w=0.241 //l=0.122474 //layer=m1 \
 //thickness=0.36 //x=10.73 //y=4.58 //x2=10.735 //y2=4.7
r439 (  15 42 ) resistor r=0.0911593 //w=0.376 //l=0.184608 //layer=m1 \
 //thickness=0.36 //x=10.73 //y=4.235 //x2=10.677 //y2=4.075
r440 (  15 16 ) resistor r=0.329198 //w=0.131 //l=0.345 //layer=m1 \
 //thickness=0.36 //x=10.73 //y=4.235 //x2=10.73 //y2=4.58
r441 (  14 40 ) resistor r=0.0894971 //w=0.376 //l=0.179555 //layer=m1 \
 //thickness=0.36 //x=10.73 //y=3.915 //x2=10.677 //y2=4.07
r442 (  13 44 ) resistor r=0.116051 //w=0.211 //l=0.165 //layer=m1 \
 //thickness=0.36 //x=10.73 //y=2.25 //x2=10.73 //y2=2.085
r443 (  13 14 ) resistor r=1.58874 //w=0.131 //l=1.665 //layer=m1 \
 //thickness=0.36 //x=10.73 //y=2.25 //x2=10.73 //y2=3.915
r444 (  11 38 ) resistor r=0.0911593 //w=0.376 //l=0.184174 //layer=m1 \
 //thickness=0.36 //x=9.25 //y=4.235 //x2=9.302 //y2=4.075
r445 (  11 12 ) resistor r=0.849237 //w=0.131 //l=0.89 //layer=m1 \
 //thickness=0.36 //x=9.25 //y=4.235 //x2=9.25 //y2=5.125
r446 (  10 36 ) resistor r=0.0894971 //w=0.376 //l=0.179123 //layer=m1 \
 //thickness=0.36 //x=9.25 //y=3.915 //x2=9.302 //y2=4.07
r447 (  9 10 ) resistor r=2.08492 //w=0.131 //l=2.185 //layer=m1 \
 //thickness=0.36 //x=9.25 //y=1.73 //x2=9.25 //y2=3.915
r448 (  7 9 ) resistor r=0.0698411 //w=0.17 //l=0.120208 //layer=m1 \
 //thickness=0.36 //x=9.165 //y=1.645 //x2=9.25 //y2=1.73
r449 (  7 8 ) resistor r=0.257634 //w=0.131 //l=0.27 //layer=m1 \
 //thickness=0.36 //x=9.165 //y=1.645 //x2=8.895 //y2=1.645
r450 (  6 28 ) resistor r=0.0243946 //w=0.225 //l=0.123 //layer=m1 \
 //thickness=0.36 //x=8.89 //y=5.21 //x2=8.767 //y2=5.21
r451 (  5 12 ) resistor r=0.0698411 //w=0.17 //l=0.120208 //layer=m1 \
 //thickness=0.36 //x=9.165 //y=5.21 //x2=9.25 //y2=5.125
r452 (  5 6 ) resistor r=0.262405 //w=0.131 //l=0.275 //layer=m1 \
 //thickness=0.36 //x=9.165 //y=5.21 //x2=8.89 //y2=5.21
r453 (  4 8 ) resistor r=0.0698411 //w=0.17 //l=0.120208 //layer=m1 \
 //thickness=0.36 //x=8.81 //y=1.56 //x2=8.895 //y2=1.645
r454 (  3 34 ) resistor r=0.0792909 //w=0.345 //l=0.157162 //layer=m1 \
 //thickness=0.36 //x=8.81 //y=1.355 //x2=8.75 //y2=1.225
r455 (  3 4 ) resistor r=0.195611 //w=0.131 //l=0.205 //layer=m1 \
 //thickness=0.36 //x=8.81 //y=1.355 //x2=8.81 //y2=1.56
r456 (  2 25 ) resistor r=0.0249239 //w=0.227 //l=0.125 //layer=m1 \
 //thickness=0.36 //x=8.015 //y=5.21 //x2=7.89 //y2=5.21
r457 (  1 28 ) resistor r=0.0243946 //w=0.225 //l=0.122 //layer=m1 \
 //thickness=0.36 //x=8.645 //y=5.21 //x2=8.767 //y2=5.21
r458 (  1 2 ) resistor r=0.601145 //w=0.131 //l=0.63 //layer=m1 \
 //thickness=0.36 //x=8.645 //y=5.21 //x2=8.015 //y2=5.21
ends PM_VOTER3X1_PCELL\%noxref_4

subckt PM_VOTER3X1_PCELL\%noxref_5 ( 3 4 5 7 8 9 13 14 31 34 51 54 86 94 114 \
 128 129 130 134 135 136 137 138 139 )
c251 ( 139 0 ) capacitor c=0.0632647f //x=11.4 //y=5.02
c252 ( 138 0 ) capacitor c=0.0575061f //x=10.53 //y=5.02
c253 ( 137 0 ) capacitor c=0.0424825f //x=2.405 //y=5.025
c254 ( 136 0 ) capacitor c=0.0224071f //x=1.525 //y=5.025
c255 ( 135 0 ) capacitor c=0.0512787f //x=0.655 //y=5.025
c256 ( 134 0 ) capacitor c=0.239996f //x=11.47 //y=7.4
c257 ( 132 0 ) capacitor c=0.00591168f //x=10.73 //y=7.4
c258 ( 130 0 ) capacitor c=0.117698f //x=9.99 //y=7.4
c259 ( 129 0 ) capacitor c=0.121078f //x=6.66 //y=7.4
c260 ( 128 0 ) capacitor c=0.126128f //x=3.33 //y=7.4
c261 ( 114 0 ) capacitor c=0.0287911f //x=11.46 //y=7.4
c262 ( 104 0 ) capacitor c=0.0211462f //x=10.58 //y=7.4
c263 ( 94 0 ) capacitor c=0.133373f //x=9.82 //y=7.4
c264 ( 86 0 ) capacitor c=0.130738f //x=6.49 //y=7.4
c265 ( 54 0 ) capacitor c=0.212909f //x=0.74 //y=7.4
c266 ( 51 0 ) capacitor c=0.13191f //x=3.16 //y=7.4
c267 ( 42 0 ) capacitor c=0.00498911f //x=2.55 //y=7.4
c268 ( 39 0 ) capacitor c=0.00498911f //x=1.67 //y=7.4
c269 ( 34 0 ) capacitor c=0.0524217f //x=0.74 //y=7.4
c270 ( 31 0 ) capacitor c=0.329842f //x=11.47 //y=7.4
c271 ( 14 0 ) capacitor c=0.00657976f //x=2.55 //y=7.23
c272 ( 13 0 ) capacitor c=0.00827249f //x=2.55 //y=6.855
c273 ( 9 0 ) capacitor c=0.0220533f //x=2.465 //y=7.4
c274 ( 8 0 ) capacitor c=0.00369726f //x=1.67 //y=7.23
c275 ( 7 0 ) capacitor c=0.00650208f //x=1.67 //y=6.855
c276 ( 5 0 ) capacitor c=0.022394f //x=1.585 //y=7.4
c277 ( 4 0 ) capacitor c=0.0090067f //x=0.79 //y=7.23
c278 ( 3 0 ) capacitor c=0.0125184f //x=0.79 //y=6.855
r279 (  116 134 ) resistor r=4.11603 //w=0.68 //l=0.17 //layer=li \
 //thickness=0.1 //x=11.545 //y=7.23 //x2=11.545 //y2=7.4
r280 (  116 139 ) resistor r=56.4706 //w=0.187 //l=0.825 //layer=li \
 //thickness=0.1 //x=11.545 //y=7.23 //x2=11.545 //y2=6.405
r281 (  115 132 ) resistor r=2.94794 //w=0.34 //l=0.085 //layer=li \
 //thickness=0.1 //x=10.75 //y=7.4 //x2=10.665 //y2=7.4
r282 (  114 134 ) resistor r=2.94794 //w=0.34 //l=0.085 //layer=li \
 //thickness=0.1 //x=11.46 //y=7.4 //x2=11.545 //y2=7.4
r283 (  114 115 ) resistor r=25.4566 //w=0.357 //l=0.71 //layer=li \
 //thickness=0.1 //x=11.46 //y=7.4 //x2=10.75 //y2=7.4
r284 (  106 132 ) resistor r=4.11603 //w=0.68 //l=0.17 //layer=li \
 //thickness=0.1 //x=10.665 //y=7.23 //x2=10.665 //y2=7.4
r285 (  106 138 ) resistor r=56.4706 //w=0.187 //l=0.825 //layer=li \
 //thickness=0.1 //x=10.665 //y=7.23 //x2=10.665 //y2=6.405
r286 (  105 130 ) resistor r=5.4201 //w=0.34 //l=0.17 //layer=li \
 //thickness=0.1 //x=10.16 //y=7.4 //x2=9.99 //y2=7.4
r287 (  104 132 ) resistor r=2.94794 //w=0.34 //l=0.085 //layer=li \
 //thickness=0.1 //x=10.58 //y=7.4 //x2=10.665 //y2=7.4
r288 (  104 105 ) resistor r=15.0588 //w=0.357 //l=0.42 //layer=li \
 //thickness=0.1 //x=10.58 //y=7.4 //x2=10.16 //y2=7.4
r289 (  99 101 ) resistor r=39.7983 //w=0.357 //l=1.11 //layer=li \
 //thickness=0.1 //x=8.14 //y=7.4 //x2=9.25 //y2=7.4
r290 (  97 99 ) resistor r=39.7983 //w=0.357 //l=1.11 //layer=li \
 //thickness=0.1 //x=7.03 //y=7.4 //x2=8.14 //y2=7.4
r291 (  95 129 ) resistor r=5.4201 //w=0.34 //l=0.17 //layer=li \
 //thickness=0.1 //x=6.83 //y=7.4 //x2=6.66 //y2=7.4
r292 (  95 97 ) resistor r=7.17087 //w=0.357 //l=0.2 //layer=li \
 //thickness=0.1 //x=6.83 //y=7.4 //x2=7.03 //y2=7.4
r293 (  94 130 ) resistor r=5.4201 //w=0.34 //l=0.17 //layer=li \
 //thickness=0.1 //x=9.82 //y=7.4 //x2=9.99 //y2=7.4
r294 (  94 101 ) resistor r=20.437 //w=0.357 //l=0.57 //layer=li \
 //thickness=0.1 //x=9.82 //y=7.4 //x2=9.25 //y2=7.4
r295 (  89 91 ) resistor r=39.7983 //w=0.357 //l=1.11 //layer=li \
 //thickness=0.1 //x=4.44 //y=7.4 //x2=5.55 //y2=7.4
r296 (  87 128 ) resistor r=5.4201 //w=0.34 //l=0.17 //layer=li \
 //thickness=0.1 //x=3.5 //y=7.4 //x2=3.33 //y2=7.4
r297 (  87 89 ) resistor r=33.7031 //w=0.357 //l=0.94 //layer=li \
 //thickness=0.1 //x=3.5 //y=7.4 //x2=4.44 //y2=7.4
r298 (  86 129 ) resistor r=5.4201 //w=0.34 //l=0.17 //layer=li \
 //thickness=0.1 //x=6.49 //y=7.4 //x2=6.66 //y2=7.4
r299 (  86 91 ) resistor r=33.7031 //w=0.357 //l=0.94 //layer=li \
 //thickness=0.1 //x=6.49 //y=7.4 //x2=5.55 //y2=7.4
r300 (  82 137 ) resistor r=23.2727 //w=0.187 //l=0.34 //layer=li \
 //thickness=0.1 //x=2.55 //y=6.74 //x2=2.55 //y2=6.4
r301 (  67 135 ) resistor r=23.2727 //w=0.187 //l=0.34 //layer=li \
 //thickness=0.1 //x=0.79 //y=6.74 //x2=0.79 //y2=6.4
r302 (  56 58 ) resistor r=39.7983 //w=0.357 //l=1.11 //layer=li \
 //thickness=0.1 //x=1.85 //y=7.4 //x2=2.96 //y2=7.4
r303 (  54 56 ) resistor r=39.7983 //w=0.357 //l=1.11 //layer=li \
 //thickness=0.1 //x=0.74 //y=7.4 //x2=1.85 //y2=7.4
r304 (  51 128 ) resistor r=5.4201 //w=0.34 //l=0.17 //layer=li \
 //thickness=0.1 //x=3.16 //y=7.4 //x2=3.33 //y2=7.4
r305 (  51 58 ) resistor r=7.17087 //w=0.357 //l=0.2 //layer=li \
 //thickness=0.1 //x=3.16 //y=7.4 //x2=2.96 //y2=7.4
r306 (  44 82 ) resistor r=9.3 //w=0.17 //l=0.17 //layer=mcon //count=1 \
 //x=2.55 //y=6.74 //x2=2.55 //y2=6.74
r307 (  41 136 ) resistor r=9.3 //w=0.17 //l=0.17 //layer=mcon //count=1 \
 //x=1.67 //y=6.74 //x2=1.67 //y2=6.74
r308 (  38 67 ) resistor r=9.3 //w=0.17 //l=0.17 //layer=mcon //count=1 \
 //x=0.79 //y=6.74 //x2=0.79 //y2=6.74
r309 (  34 54 ) resistor r=3.1 //w=0.17 //l=0.51 //layer=mcon //count=3 \
 //x=0.74 //y=7.4 //x2=0.74 //y2=7.4
r310 (  31 134 ) resistor r=4.65 //w=0.17 //l=0.34 //layer=mcon //count=2 \
 //x=11.47 //y=7.4 //x2=11.47 //y2=7.4
r311 (  29 132 ) resistor r=3.1 //w=0.17 //l=0.51 //layer=mcon //count=3 \
 //x=10.73 //y=7.4 //x2=10.73 //y2=7.4
r312 (  29 31 ) resistor r=0.307309 //w=0.301 //l=0.74 //layer=m1 \
 //thickness=0.36 //x=10.73 //y=7.4 //x2=11.47 //y2=7.4
r313 (  27 101 ) resistor r=3.1 //w=0.17 //l=0.51 //layer=mcon //count=3 \
 //x=9.25 //y=7.4 //x2=9.25 //y2=7.4
r314 (  27 29 ) resistor r=0.614618 //w=0.301 //l=1.48 //layer=m1 \
 //thickness=0.36 //x=9.25 //y=7.4 //x2=10.73 //y2=7.4
r315 (  25 99 ) resistor r=3.1 //w=0.17 //l=0.51 //layer=mcon //count=3 \
 //x=8.14 //y=7.4 //x2=8.14 //y2=7.4
r316 (  25 27 ) resistor r=0.460963 //w=0.301 //l=1.11 //layer=m1 \
 //thickness=0.36 //x=8.14 //y=7.4 //x2=9.25 //y2=7.4
r317 (  23 97 ) resistor r=3.1 //w=0.17 //l=0.51 //layer=mcon //count=3 \
 //x=7.03 //y=7.4 //x2=7.03 //y2=7.4
r318 (  23 25 ) resistor r=0.460963 //w=0.301 //l=1.11 //layer=m1 \
 //thickness=0.36 //x=7.03 //y=7.4 //x2=8.14 //y2=7.4
r319 (  21 91 ) resistor r=3.1 //w=0.17 //l=0.51 //layer=mcon //count=3 \
 //x=5.55 //y=7.4 //x2=5.55 //y2=7.4
r320 (  21 23 ) resistor r=0.614618 //w=0.301 //l=1.48 //layer=m1 \
 //thickness=0.36 //x=5.55 //y=7.4 //x2=7.03 //y2=7.4
r321 (  19 89 ) resistor r=3.1 //w=0.17 //l=0.51 //layer=mcon //count=3 \
 //x=4.44 //y=7.4 //x2=4.44 //y2=7.4
r322 (  19 21 ) resistor r=0.460963 //w=0.301 //l=1.11 //layer=m1 \
 //thickness=0.36 //x=4.44 //y=7.4 //x2=5.55 //y2=7.4
r323 (  17 58 ) resistor r=3.1 //w=0.17 //l=0.51 //layer=mcon //count=3 \
 //x=2.96 //y=7.4 //x2=2.96 //y2=7.4
r324 (  17 19 ) resistor r=0.614618 //w=0.301 //l=1.48 //layer=m1 \
 //thickness=0.36 //x=2.96 //y=7.4 //x2=4.44 //y2=7.4
r325 (  15 42 ) resistor r=0.0287885 //w=0.34 //l=0.085 //layer=m1 \
 //thickness=0.36 //x=2.635 //y=7.4 //x2=2.55 //y2=7.4
r326 (  15 17 ) resistor r=0.134967 //w=0.301 //l=0.325 //layer=m1 \
 //thickness=0.36 //x=2.635 //y=7.4 //x2=2.96 //y2=7.4
r327 (  14 42 ) resistor r=0.0401957 //w=0.68 //l=0.17 //layer=m1 \
 //thickness=0.36 //x=2.55 //y=7.23 //x2=2.55 //y2=7.4
r328 (  13 44 ) resistor r=0.0715665 //w=0.226 //l=0.115 //layer=m1 \
 //thickness=0.36 //x=2.55 //y=6.855 //x2=2.55 //y2=6.74
r329 (  13 14 ) resistor r=0.357824 //w=0.131 //l=0.375 //layer=m1 \
 //thickness=0.36 //x=2.55 //y=6.855 //x2=2.55 //y2=7.23
r330 (  12 56 ) resistor r=3.1 //w=0.17 //l=0.51 //layer=mcon //count=3 \
 //x=1.85 //y=7.4 //x2=1.85 //y2=7.4
r331 (  10 39 ) resistor r=0.0287885 //w=0.34 //l=0.085 //layer=m1 \
 //thickness=0.36 //x=1.755 //y=7.4 //x2=1.67 //y2=7.4
r332 (  10 12 ) resistor r=0.0394518 //w=0.301 //l=0.095 //layer=m1 \
 //thickness=0.36 //x=1.755 //y=7.4 //x2=1.85 //y2=7.4
r333 (  9 42 ) resistor r=0.0287885 //w=0.34 //l=0.085 //layer=m1 \
 //thickness=0.36 //x=2.465 //y=7.4 //x2=2.55 //y2=7.4
r334 (  9 12 ) resistor r=0.255399 //w=0.301 //l=0.615 //layer=m1 \
 //thickness=0.36 //x=2.465 //y=7.4 //x2=1.85 //y2=7.4
r335 (  8 39 ) resistor r=0.0401957 //w=0.68 //l=0.17 //layer=m1 \
 //thickness=0.36 //x=1.67 //y=7.23 //x2=1.67 //y2=7.4
r336 (  7 41 ) resistor r=0.0715665 //w=0.226 //l=0.117473 //layer=m1 \
 //thickness=0.36 //x=1.67 //y=6.855 //x2=1.675 //y2=6.74
r337 (  7 8 ) resistor r=0.357824 //w=0.131 //l=0.375 //layer=m1 \
 //thickness=0.36 //x=1.67 //y=6.855 //x2=1.67 //y2=7.23
r338 (  6 34 ) resistor r=0.0287885 //w=0.34 //l=0.085 //layer=m1 \
 //thickness=0.36 //x=0.875 //y=7.4 //x2=0.79 //y2=7.4
r339 (  5 39 ) resistor r=0.0287885 //w=0.34 //l=0.085 //layer=m1 \
 //thickness=0.36 //x=1.585 //y=7.4 //x2=1.67 //y2=7.4
r340 (  5 6 ) resistor r=0.29485 //w=0.301 //l=0.71 //layer=m1 \
 //thickness=0.36 //x=1.585 //y=7.4 //x2=0.875 //y2=7.4
r341 (  4 34 ) resistor r=0.0401957 //w=0.68 //l=0.17 //layer=m1 \
 //thickness=0.36 //x=0.79 //y=7.23 //x2=0.79 //y2=7.4
r342 (  3 38 ) resistor r=0.0712609 //w=0.23 //l=0.11649 //layer=m1 \
 //thickness=0.36 //x=0.79 //y=6.855 //x2=0.787 //y2=6.74
r343 (  3 4 ) resistor r=0.357824 //w=0.131 //l=0.375 //layer=m1 \
 //thickness=0.36 //x=0.79 //y=6.855 //x2=0.79 //y2=7.23
ends PM_VOTER3X1_PCELL\%noxref_5

subckt PM_VOTER3X1_PCELL\%noxref_6 ( 1 3 4 5 7 9 19 25 27 30 40 49 71 72 73 74 \
 75 )
c166 ( 75 0 ) capacitor c=0.0354016f //x=5.725 //y=5.025
c167 ( 74 0 ) capacitor c=0.0241107f //x=4.845 //y=5.025
c168 ( 72 0 ) capacitor c=0.00544792f //x=1.965 //y=5.025
c169 ( 71 0 ) capacitor c=0.00516996f //x=1.085 //y=5.025
c170 ( 49 0 ) capacitor c=0.0508454f //x=4.11 //y=5.21
c171 ( 40 0 ) capacitor c=0.0363371f //x=2.11 //y=5.21
c172 ( 30 0 ) capacitor c=0.0294643f //x=1.23 //y=5.38
c173 ( 27 0 ) capacitor c=0.00984489f //x=5.87 //y=6.74
c174 ( 25 0 ) capacitor c=0.0059844f //x=4.987 //y=6.91
c175 ( 19 0 ) capacitor c=0.00975753f //x=4.11 //y=6.74
c176 ( 9 0 ) capacitor c=0.014892f //x=1.232 //y=5.21
c177 ( 7 0 ) capacitor c=0.00787288f //x=5.755 //y=6.91
c178 ( 5 0 ) capacitor c=0.00659042f //x=4.87 //y=6.91
c179 ( 4 0 ) capacitor c=0.00573286f //x=2.225 //y=5.21
c180 ( 3 0 ) capacitor c=0.0636102f //x=3.995 //y=5.21
c181 ( 1 0 ) capacitor c=0.0145996f //x=1.995 //y=5.21
r182 (  49 73 ) resistor r=58.1818 //w=0.187 //l=0.85 //layer=li \
 //thickness=0.1 //x=4.11 //y=5.21 //x2=4.11 //y2=6.06
r183 (  40 72 ) resistor r=58.1818 //w=0.187 //l=0.85 //layer=li \
 //thickness=0.1 //x=2.11 //y=5.21 //x2=2.11 //y2=6.06
r184 (  30 71 ) resistor r=23.2727 //w=0.187 //l=0.34 //layer=li \
 //thickness=0.1 //x=1.23 //y=5.38 //x2=1.23 //y2=5.72
r185 (  27 75 ) resistor r=9.3 //w=0.17 //l=0.17 //layer=mcon //count=1 \
 //x=5.87 //y=6.74 //x2=5.87 //y2=6.74
r186 (  27 28 ) resistor r=0.0988372 //w=0.215 //l=0.17 //layer=m1 \
 //thickness=0.36 //x=5.872 //y=6.74 //x2=5.872 //y2=6.91
r187 (  24 74 ) resistor r=9.3 //w=0.17 //l=0.17 //layer=mcon //count=1 \
 //x=4.99 //y=6.74 //x2=4.99 //y2=6.74
r188 (  24 25 ) resistor r=0.0940266 //w=0.226 //l=0.17 //layer=m1 \
 //thickness=0.36 //x=4.987 //y=6.74 //x2=4.987 //y2=6.91
r189 (  22 49 ) resistor r=9.3 //w=0.17 //l=0.17 //layer=mcon //count=1 \
 //x=4.11 //y=5.21 //x2=4.11 //y2=5.21
r190 (  19 73 ) resistor r=9.3 //w=0.17 //l=0.17 //layer=mcon //count=1 \
 //x=4.11 //y=6.74 //x2=4.11 //y2=6.74
r191 (  19 20 ) resistor r=0.0979263 //w=0.217 //l=0.17 //layer=m1 \
 //thickness=0.36 //x=4.112 //y=6.74 //x2=4.112 //y2=6.91
r192 (  15 40 ) resistor r=9.3 //w=0.17 //l=0.17 //layer=mcon //count=1 \
 //x=2.11 //y=5.21 //x2=2.11 //y2=5.21
r193 (  11 30 ) resistor r=9.3 //w=0.17 //l=0.17 //layer=mcon //count=1 \
 //x=1.23 //y=5.38 //x2=1.23 //y2=5.38
r194 (  9 11 ) resistor r=0.0944444 //w=0.225 //l=0.17 //layer=m1 \
 //thickness=0.36 //x=1.232 //y=5.21 //x2=1.232 //y2=5.38
r195 (  8 25 ) resistor r=0.0246599 //w=0.226 //l=0.118 //layer=m1 \
 //thickness=0.36 //x=5.105 //y=6.91 //x2=4.987 //y2=6.91
r196 (  7 28 ) resistor r=0.0216707 //w=0.215 //l=0.117 //layer=m1 \
 //thickness=0.36 //x=5.755 //y=6.91 //x2=5.872 //y2=6.91
r197 (  7 8 ) resistor r=0.620229 //w=0.131 //l=0.65 //layer=m1 \
 //thickness=0.36 //x=5.755 //y=6.91 //x2=5.105 //y2=6.91
r198 (  6 20 ) resistor r=0.0222262 //w=0.217 //l=0.118 //layer=m1 \
 //thickness=0.36 //x=4.23 //y=6.91 //x2=4.112 //y2=6.91
r199 (  5 25 ) resistor r=0.0246599 //w=0.226 //l=0.117 //layer=m1 \
 //thickness=0.36 //x=4.87 //y=6.91 //x2=4.987 //y2=6.91
r200 (  5 6 ) resistor r=0.610687 //w=0.131 //l=0.64 //layer=m1 \
 //thickness=0.36 //x=4.87 //y=6.91 //x2=4.23 //y2=6.91
r201 (  4 15 ) resistor r=0.0880901 //w=0.191 //l=0.115 //layer=m1 \
 //thickness=0.36 //x=2.225 //y=5.21 //x2=2.11 //y2=5.21
r202 (  3 22 ) resistor r=0.0717383 //w=0.224 //l=0.115 //layer=m1 \
 //thickness=0.36 //x=3.995 //y=5.21 //x2=4.11 //y2=5.21
r203 (  3 4 ) resistor r=1.68893 //w=0.131 //l=1.77 //layer=m1 \
 //thickness=0.36 //x=3.995 //y=5.21 //x2=2.225 //y2=5.21
r204 (  2 9 ) resistor r=0.0243946 //w=0.225 //l=0.123 //layer=m1 \
 //thickness=0.36 //x=1.355 //y=5.21 //x2=1.232 //y2=5.21
r205 (  1 15 ) resistor r=0.0880901 //w=0.191 //l=0.115 //layer=m1 \
 //thickness=0.36 //x=1.995 //y=5.21 //x2=2.11 //y2=5.21
r206 (  1 2 ) resistor r=0.610687 //w=0.131 //l=0.64 //layer=m1 \
 //thickness=0.36 //x=1.995 //y=5.21 //x2=1.355 //y2=5.21
ends PM_VOTER3X1_PCELL\%noxref_6

subckt PM_VOTER3X1_PCELL\%noxref_7 ( 1 3 4 5 7 9 13 15 21 23 26 38 60 61 62 63 )
c137 ( 63 0 ) capacitor c=0.0343252f //x=9.065 //y=5.025
c138 ( 62 0 ) capacitor c=0.0239063f //x=8.185 //y=5.025
c139 ( 38 0 ) capacitor c=0.0496553f //x=7.45 //y=5.21
c140 ( 26 0 ) capacitor c=0.0229521f //x=4.55 //y=5.38
c141 ( 23 0 ) capacitor c=0.0155899f //x=9.21 //y=6.74
c142 ( 21 0 ) capacitor c=0.00566376f //x=8.33 //y=6.91
c143 ( 15 0 ) capacitor c=0.00945187f //x=7.45 //y=6.74
c144 ( 13 0 ) capacitor c=0.0163615f //x=5.43 //y=5.21
c145 ( 9 0 ) capacitor c=0.0152859f //x=4.55 //y=5.21
c146 ( 7 0 ) capacitor c=0.0068287f //x=9.08 //y=6.91
c147 ( 5 0 ) capacitor c=0.00878908f //x=8.215 //y=6.91
c148 ( 4 0 ) capacitor c=0.00826388f //x=5.545 //y=5.21
c149 ( 3 0 ) capacitor c=0.0573672f //x=7.335 //y=5.21
c150 ( 1 0 ) capacitor c=0.018311f //x=5.315 //y=5.21
r151 (  38 61 ) resistor r=58.1818 //w=0.187 //l=0.85 //layer=li \
 //thickness=0.1 //x=7.45 //y=5.21 //x2=7.45 //y2=6.06
r152 (  26 60 ) resistor r=23.2727 //w=0.187 //l=0.34 //layer=li \
 //thickness=0.1 //x=4.55 //y=5.38 //x2=4.55 //y2=5.72
r153 (  23 63 ) resistor r=9.3 //w=0.17 //l=0.17 //layer=mcon //count=1 \
 //x=9.21 //y=6.74 //x2=9.21 //y2=6.74
r154 (  23 24 ) resistor r=0.0923913 //w=0.23 //l=0.17 //layer=m1 \
 //thickness=0.36 //x=9.205 //y=6.74 //x2=9.205 //y2=6.91
r155 (  20 62 ) resistor r=9.3 //w=0.17 //l=0.17 //layer=mcon //count=1 \
 //x=8.33 //y=6.74 //x2=8.33 //y2=6.74
r156 (  20 21 ) resistor r=0.0957207 //w=0.222 //l=0.17 //layer=m1 \
 //thickness=0.36 //x=8.33 //y=6.74 //x2=8.33 //y2=6.91
r157 (  18 38 ) resistor r=9.3 //w=0.17 //l=0.17 //layer=mcon //count=1 \
 //x=7.45 //y=5.21 //x2=7.45 //y2=5.21
r158 (  15 61 ) resistor r=9.3 //w=0.17 //l=0.17 //layer=mcon //count=1 \
 //x=7.45 //y=6.74 //x2=7.45 //y2=6.74
r159 (  15 16 ) resistor r=0.100236 //w=0.212 //l=0.17 //layer=m1 \
 //thickness=0.36 //x=7.45 //y=6.74 //x2=7.45 //y2=6.91
r160 (  11 26 ) resistor r=9.3 //w=0.17 //l=0.17 //layer=mcon //count=1 \
 //x=4.55 //y=5.38 //x2=4.55 //y2=5.38
r161 (  9 11 ) resistor r=0.100236 //w=0.212 //l=0.17 //layer=m1 \
 //thickness=0.36 //x=4.55 //y=5.21 //x2=4.55 //y2=5.38
r162 (  8 21 ) resistor r=0.0235912 //w=0.222 //l=0.115 //layer=m1 \
 //thickness=0.36 //x=8.445 //y=6.91 //x2=8.33 //y2=6.91
r163 (  7 24 ) resistor r=0.0257089 //w=0.23 //l=0.125 //layer=m1 \
 //thickness=0.36 //x=9.08 //y=6.91 //x2=9.205 //y2=6.91
r164 (  7 8 ) resistor r=0.605916 //w=0.131 //l=0.635 //layer=m1 \
 //thickness=0.36 //x=9.08 //y=6.91 //x2=8.445 //y2=6.91
r165 (  6 16 ) resistor r=0.0208269 //w=0.212 //l=0.115 //layer=m1 \
 //thickness=0.36 //x=7.565 //y=6.91 //x2=7.45 //y2=6.91
r166 (  5 21 ) resistor r=0.0235912 //w=0.222 //l=0.115 //layer=m1 \
 //thickness=0.36 //x=8.215 //y=6.91 //x2=8.33 //y2=6.91
r167 (  5 6 ) resistor r=0.620229 //w=0.131 //l=0.65 //layer=m1 \
 //thickness=0.36 //x=8.215 //y=6.91 //x2=7.565 //y2=6.91
r168 (  4 13 ) resistor r=0.0880901 //w=0.191 //l=0.115 //layer=m1 \
 //thickness=0.36 //x=5.545 //y=5.21 //x2=5.43 //y2=5.21
r169 (  3 18 ) resistor r=0.0717383 //w=0.224 //l=0.115 //layer=m1 \
 //thickness=0.36 //x=7.335 //y=5.21 //x2=7.45 //y2=5.21
r170 (  3 4 ) resistor r=1.70802 //w=0.131 //l=1.79 //layer=m1 \
 //thickness=0.36 //x=7.335 //y=5.21 //x2=5.545 //y2=5.21
r171 (  2 9 ) resistor r=0.0208269 //w=0.212 //l=0.115 //layer=m1 \
 //thickness=0.36 //x=4.665 //y=5.21 //x2=4.55 //y2=5.21
r172 (  1 13 ) resistor r=0.0880901 //w=0.191 //l=0.115 //layer=m1 \
 //thickness=0.36 //x=5.315 //y=5.21 //x2=5.43 //y2=5.21
r173 (  1 2 ) resistor r=0.620229 //w=0.131 //l=0.65 //layer=m1 \
 //thickness=0.36 //x=5.315 //y=5.21 //x2=4.665 //y2=5.21
ends PM_VOTER3X1_PCELL\%noxref_7

subckt PM_VOTER3X1_PCELL\%noxref_8 ( 1 6 7 14 15 22 31 45 48 60 73 91 96 100 \
 112 113 114 121 128 129 130 131 )
c258 ( 131 0 ) capacitor c=0.0654443f //x=10.485 //y=0.37
c259 ( 130 0 ) capacitor c=0.00828027f //x=7.65 //y=0.865
c260 ( 129 0 ) capacitor c=0.00867576f //x=4.32 //y=0.865
c261 ( 128 0 ) capacitor c=0.0083251f //x=0.99 //y=0.865
c262 ( 121 0 ) capacitor c=0.239366f //x=11.59 //y=0
c263 ( 114 0 ) capacitor c=0.113344f //x=9.99 //y=0
c264 ( 113 0 ) capacitor c=0.110116f //x=6.66 //y=0
c265 ( 112 0 ) capacitor c=0.124159f //x=3.33 //y=0
c266 ( 103 0 ) capacitor c=0.00585268f //x=11.59 //y=0.45
c267 ( 100 0 ) capacitor c=0.00625302f //x=11.505 //y=0.535
c268 ( 99 0 ) capacitor c=0.00479851f //x=11.1 //y=0.45
c269 ( 96 0 ) capacitor c=0.00645299f //x=11.015 //y=0.535
c270 ( 91 0 ) capacitor c=0.00586769f //x=10.62 //y=0.45
c271 ( 88 0 ) capacitor c=0.0190475f //x=10.535 //y=0
c272 ( 73 0 ) capacitor c=0.121243f //x=9.82 //y=0
c273 ( 60 0 ) capacitor c=0.11749f //x=6.49 //y=0
c274 ( 48 0 ) capacitor c=0.180504f //x=0.74 //y=0
c275 ( 45 0 ) capacitor c=0.121547f //x=3.16 //y=0
c276 ( 40 0 ) capacitor c=0.0050875f //x=7.84 //y=0
c277 ( 37 0 ) capacitor c=0.00509742f //x=4.44 //y=0
c278 ( 33 0 ) capacitor c=0.0050875f //x=1.18 //y=0
c279 ( 31 0 ) capacitor c=0.161334f //x=11.47 //y=0
c280 ( 22 0 ) capacitor c=0.0350931f //x=7.84 //y=0.84
c281 ( 15 0 ) capacitor c=0.107136f //x=7.755 //y=0
c282 ( 14 0 ) capacitor c=0.0274202f //x=4.51 //y=0.835
c283 ( 7 0 ) capacitor c=0.112173f //x=4.425 //y=0
c284 ( 6 0 ) capacitor c=0.0375179f //x=1.18 //y=0.835
c285 ( 1 0 ) capacitor c=0.0577791f //x=1.095 //y=0
r286 (  120 121 ) resistor r=4.30252 //w=0.357 //l=0.12 //layer=li \
 //thickness=0.1 //x=11.47 //y=0 //x2=11.59 //y2=0
r287 (  118 120 ) resistor r=13.2661 //w=0.357 //l=0.37 //layer=li \
 //thickness=0.1 //x=11.1 //y=0 //x2=11.47 //y2=0
r288 (  117 118 ) resistor r=13.2661 //w=0.357 //l=0.37 //layer=li \
 //thickness=0.1 //x=10.73 //y=0 //x2=11.1 //y2=0
r289 (  115 117 ) resistor r=3.94398 //w=0.357 //l=0.11 //layer=li \
 //thickness=0.1 //x=10.62 //y=0 //x2=10.73 //y2=0
r290 (  104 131 ) resistor r=5.4201 //w=0.17 //l=0.085 //layer=li \
 //thickness=0.1 //x=11.59 //y=0.62 //x2=11.59 //y2=0.535
r291 (  104 131 ) resistor r=41.4118 //w=0.187 //l=0.605 //layer=li \
 //thickness=0.1 //x=11.59 //y=0.62 //x2=11.59 //y2=1.225
r292 (  103 131 ) resistor r=5.4201 //w=0.17 //l=0.085 //layer=li \
 //thickness=0.1 //x=11.59 //y=0.45 //x2=11.59 //y2=0.535
r293 (  102 121 ) resistor r=5.03728 //w=0.34 //l=0.17 //layer=li \
 //thickness=0.1 //x=11.59 //y=0.17 //x2=11.59 //y2=0
r294 (  102 103 ) resistor r=19.1658 //w=0.187 //l=0.28 //layer=li \
 //thickness=0.1 //x=11.59 //y=0.17 //x2=11.59 //y2=0.45
r295 (  101 131 ) resistor r=5.4201 //w=0.17 //l=0.085 //layer=li \
 //thickness=0.1 //x=11.185 //y=0.535 //x2=11.1 //y2=0.535
r296 (  100 131 ) resistor r=1.40859 //w=0.34 //l=0.085 //layer=li \
 //thickness=0.1 //x=11.505 //y=0.535 //x2=11.59 //y2=0.535
r297 (  100 101 ) resistor r=21.9037 //w=0.187 //l=0.32 //layer=li \
 //thickness=0.1 //x=11.505 //y=0.535 //x2=11.185 //y2=0.535
r298 (  99 131 ) resistor r=1.40859 //w=0.34 //l=0.085 //layer=li \
 //thickness=0.1 //x=11.1 //y=0.45 //x2=11.1 //y2=0.535
r299 (  98 118 ) resistor r=5.03728 //w=0.34 //l=0.17 //layer=li \
 //thickness=0.1 //x=11.1 //y=0.17 //x2=11.1 //y2=0
r300 (  98 99 ) resistor r=19.1658 //w=0.187 //l=0.28 //layer=li \
 //thickness=0.1 //x=11.1 //y=0.17 //x2=11.1 //y2=0.45
r301 (  97 131 ) resistor r=1.40859 //w=0.34 //l=0.085 //layer=li \
 //thickness=0.1 //x=10.705 //y=0.535 //x2=10.62 //y2=0.535
r302 (  96 131 ) resistor r=5.4201 //w=0.17 //l=0.085 //layer=li \
 //thickness=0.1 //x=11.015 //y=0.535 //x2=11.1 //y2=0.535
r303 (  96 97 ) resistor r=21.2193 //w=0.187 //l=0.31 //layer=li \
 //thickness=0.1 //x=11.015 //y=0.535 //x2=10.705 //y2=0.535
r304 (  92 131 ) resistor r=5.4201 //w=0.17 //l=0.085 //layer=li \
 //thickness=0.1 //x=10.62 //y=0.62 //x2=10.62 //y2=0.535
r305 (  92 131 ) resistor r=41.4118 //w=0.187 //l=0.605 //layer=li \
 //thickness=0.1 //x=10.62 //y=0.62 //x2=10.62 //y2=1.225
r306 (  91 131 ) resistor r=5.4201 //w=0.17 //l=0.085 //layer=li \
 //thickness=0.1 //x=10.62 //y=0.45 //x2=10.62 //y2=0.535
r307 (  90 115 ) resistor r=5.03728 //w=0.34 //l=0.17 //layer=li \
 //thickness=0.1 //x=10.62 //y=0.17 //x2=10.62 //y2=0
r308 (  90 91 ) resistor r=19.1658 //w=0.187 //l=0.28 //layer=li \
 //thickness=0.1 //x=10.62 //y=0.17 //x2=10.62 //y2=0.45
r309 (  89 114 ) resistor r=5.4201 //w=0.34 //l=0.17 //layer=li \
 //thickness=0.1 //x=10.16 //y=0 //x2=9.99 //y2=0
r310 (  88 115 ) resistor r=3.04762 //w=0.357 //l=0.085 //layer=li \
 //thickness=0.1 //x=10.535 //y=0 //x2=10.62 //y2=0
r311 (  88 89 ) resistor r=13.4454 //w=0.357 //l=0.375 //layer=li \
 //thickness=0.1 //x=10.535 //y=0 //x2=10.16 //y2=0
r312 (  78 80 ) resistor r=39.7983 //w=0.357 //l=1.11 //layer=li \
 //thickness=0.1 //x=8.14 //y=0 //x2=9.25 //y2=0
r313 (  76 78 ) resistor r=39.7983 //w=0.357 //l=1.11 //layer=li \
 //thickness=0.1 //x=7.03 //y=0 //x2=8.14 //y2=0
r314 (  74 113 ) resistor r=5.4201 //w=0.34 //l=0.17 //layer=li \
 //thickness=0.1 //x=6.83 //y=0 //x2=6.66 //y2=0
r315 (  74 76 ) resistor r=7.17087 //w=0.357 //l=0.2 //layer=li \
 //thickness=0.1 //x=6.83 //y=0 //x2=7.03 //y2=0
r316 (  73 114 ) resistor r=5.4201 //w=0.34 //l=0.17 //layer=li \
 //thickness=0.1 //x=9.82 //y=0 //x2=9.99 //y2=0
r317 (  73 80 ) resistor r=20.437 //w=0.357 //l=0.57 //layer=li \
 //thickness=0.1 //x=9.82 //y=0 //x2=9.25 //y2=0
r318 (  63 65 ) resistor r=39.7983 //w=0.357 //l=1.11 //layer=li \
 //thickness=0.1 //x=4.44 //y=0 //x2=5.55 //y2=0
r319 (  61 112 ) resistor r=5.4201 //w=0.34 //l=0.17 //layer=li \
 //thickness=0.1 //x=3.5 //y=0 //x2=3.33 //y2=0
r320 (  61 63 ) resistor r=33.7031 //w=0.357 //l=0.94 //layer=li \
 //thickness=0.1 //x=3.5 //y=0 //x2=4.44 //y2=0
r321 (  60 113 ) resistor r=5.4201 //w=0.34 //l=0.17 //layer=li \
 //thickness=0.1 //x=6.49 //y=0 //x2=6.66 //y2=0
r322 (  60 65 ) resistor r=33.7031 //w=0.357 //l=0.94 //layer=li \
 //thickness=0.1 //x=6.49 //y=0 //x2=5.55 //y2=0
r323 (  50 52 ) resistor r=39.7983 //w=0.357 //l=1.11 //layer=li \
 //thickness=0.1 //x=1.85 //y=0 //x2=2.96 //y2=0
r324 (  48 50 ) resistor r=39.7983 //w=0.357 //l=1.11 //layer=li \
 //thickness=0.1 //x=0.74 //y=0 //x2=1.85 //y2=0
r325 (  45 112 ) resistor r=5.4201 //w=0.34 //l=0.17 //layer=li \
 //thickness=0.1 //x=3.16 //y=0 //x2=3.33 //y2=0
r326 (  45 52 ) resistor r=7.17087 //w=0.357 //l=0.2 //layer=li \
 //thickness=0.1 //x=3.16 //y=0 //x2=2.96 //y2=0
r327 (  42 130 ) resistor r=9.3 //w=0.17 //l=0.17 //layer=mcon //count=1 \
 //x=7.84 //y=0.955 //x2=7.84 //y2=0.955
r328 (  39 129 ) resistor r=9.3 //w=0.17 //l=0.17 //layer=mcon //count=1 \
 //x=4.51 //y=0.955 //x2=4.51 //y2=0.955
r329 (  37 63 ) resistor r=3.1 //w=0.17 //l=0.51 //layer=mcon //count=3 \
 //x=4.44 //y=0 //x2=4.44 //y2=0
r330 (  35 128 ) resistor r=9.3 //w=0.17 //l=0.17 //layer=mcon //count=1 \
 //x=1.18 //y=0.955 //x2=1.18 //y2=0.955
r331 (  31 120 ) resistor r=4.65 //w=0.17 //l=0.34 //layer=mcon //count=2 \
 //x=11.47 //y=0 //x2=11.47 //y2=0
r332 (  29 117 ) resistor r=3.1 //w=0.17 //l=0.51 //layer=mcon //count=3 \
 //x=10.73 //y=0 //x2=10.73 //y2=0
r333 (  29 31 ) resistor r=0.307309 //w=0.301 //l=0.74 //layer=m1 \
 //thickness=0.36 //x=10.73 //y=0 //x2=11.47 //y2=0
r334 (  27 80 ) resistor r=3.1 //w=0.17 //l=0.51 //layer=mcon //count=3 \
 //x=9.25 //y=0 //x2=9.25 //y2=0
r335 (  27 29 ) resistor r=0.614618 //w=0.301 //l=1.48 //layer=m1 \
 //thickness=0.36 //x=9.25 //y=0 //x2=10.73 //y2=0
r336 (  25 78 ) resistor r=3.1 //w=0.17 //l=0.51 //layer=mcon //count=3 \
 //x=8.14 //y=0 //x2=8.14 //y2=0
r337 (  25 27 ) resistor r=0.460963 //w=0.301 //l=1.11 //layer=m1 \
 //thickness=0.36 //x=8.14 //y=0 //x2=9.25 //y2=0
r338 (  23 40 ) resistor r=0.0287885 //w=0.34 //l=0.085 //layer=m1 \
 //thickness=0.36 //x=7.925 //y=0 //x2=7.84 //y2=0
r339 (  23 25 ) resistor r=0.0892857 //w=0.301 //l=0.215 //layer=m1 \
 //thickness=0.36 //x=7.925 //y=0 //x2=8.14 //y2=0
r340 (  22 42 ) resistor r=0.0703067 //w=0.254 //l=0.11649 //layer=m1 \
 //thickness=0.36 //x=7.84 //y=0.84 //x2=7.837 //y2=0.955
r341 (  21 40 ) resistor r=0.0401957 //w=0.68 //l=0.17 //layer=m1 \
 //thickness=0.36 //x=7.84 //y=0.17 //x2=7.84 //y2=0
r342 (  21 22 ) resistor r=0.639313 //w=0.131 //l=0.67 //layer=m1 \
 //thickness=0.36 //x=7.84 //y=0.17 //x2=7.84 //y2=0.84
r343 (  20 76 ) resistor r=3.1 //w=0.17 //l=0.51 //layer=mcon //count=3 \
 //x=7.03 //y=0 //x2=7.03 //y2=0
r344 (  18 65 ) resistor r=3.1 //w=0.17 //l=0.51 //layer=mcon //count=3 \
 //x=5.55 //y=0 //x2=5.55 //y2=0
r345 (  18 20 ) resistor r=0.614618 //w=0.301 //l=1.48 //layer=m1 \
 //thickness=0.36 //x=5.55 //y=0 //x2=7.03 //y2=0
r346 (  16 37 ) resistor r=0.0287885 //w=0.34 //l=0.085 //layer=m1 \
 //thickness=0.36 //x=4.595 //y=0 //x2=4.51 //y2=0
r347 (  16 18 ) resistor r=0.396595 //w=0.301 //l=0.955 //layer=m1 \
 //thickness=0.36 //x=4.595 //y=0 //x2=5.55 //y2=0
r348 (  15 40 ) resistor r=0.0287885 //w=0.34 //l=0.085 //layer=m1 \
 //thickness=0.36 //x=7.755 //y=0 //x2=7.84 //y2=0
r349 (  15 20 ) resistor r=0.30108 //w=0.301 //l=0.725 //layer=m1 \
 //thickness=0.36 //x=7.755 //y=0 //x2=7.03 //y2=0
r350 (  14 39 ) resistor r=0.0738201 //w=0.232 //l=0.121491 //layer=m1 \
 //thickness=0.36 //x=4.51 //y=0.835 //x2=4.507 //y2=0.955
r351 (  13 37 ) resistor r=0.0401957 //w=0.68 //l=0.17 //layer=m1 \
 //thickness=0.36 //x=4.51 //y=0.17 //x2=4.51 //y2=0
r352 (  13 14 ) resistor r=0.634542 //w=0.131 //l=0.665 //layer=m1 \
 //thickness=0.36 //x=4.51 //y=0.17 //x2=4.51 //y2=0.835
r353 (  12 52 ) resistor r=3.1 //w=0.17 //l=0.51 //layer=mcon //count=3 \
 //x=2.96 //y=0 //x2=2.96 //y2=0
r354 (  10 50 ) resistor r=3.1 //w=0.17 //l=0.51 //layer=mcon //count=3 \
 //x=1.85 //y=0 //x2=1.85 //y2=0
r355 (  10 12 ) resistor r=0.460963 //w=0.301 //l=1.11 //layer=m1 \
 //thickness=0.36 //x=1.85 //y=0 //x2=2.96 //y2=0
r356 (  8 33 ) resistor r=0.0287885 //w=0.34 //l=0.085 //layer=m1 \
 //thickness=0.36 //x=1.265 //y=0 //x2=1.18 //y2=0
r357 (  8 10 ) resistor r=0.24294 //w=0.301 //l=0.585 //layer=m1 \
 //thickness=0.36 //x=1.265 //y=0 //x2=1.85 //y2=0
r358 (  7 37 ) resistor r=0.0287885 //w=0.34 //l=0.085 //layer=m1 \
 //thickness=0.36 //x=4.425 //y=0 //x2=4.51 //y2=0
r359 (  7 12 ) resistor r=0.608389 //w=0.301 //l=1.465 //layer=m1 \
 //thickness=0.36 //x=4.425 //y=0 //x2=2.96 //y2=0
r360 (  6 35 ) resistor r=0.0729089 //w=0.249 //l=0.120996 //layer=m1 \
 //thickness=0.36 //x=1.18 //y=0.835 //x2=1.182 //y2=0.955
r361 (  5 33 ) resistor r=0.0401957 //w=0.68 //l=0.17 //layer=m1 \
 //thickness=0.36 //x=1.18 //y=0.17 //x2=1.18 //y2=0
r362 (  5 6 ) resistor r=0.634542 //w=0.131 //l=0.665 //layer=m1 \
 //thickness=0.36 //x=1.18 //y=0.17 //x2=1.18 //y2=0.835
r363 (  3 48 ) resistor r=3.1 //w=0.17 //l=0.51 //layer=mcon //count=3 \
 //x=0.74 //y=0 //x2=0.74 //y2=0
r364 (  1 33 ) resistor r=0.0287885 //w=0.34 //l=0.085 //layer=m1 \
 //thickness=0.36 //x=1.095 //y=0 //x2=1.18 //y2=0
r365 (  1 3 ) resistor r=0.147425 //w=0.301 //l=0.355 //layer=m1 \
 //thickness=0.36 //x=1.095 //y=0 //x2=0.74 //y2=0
ends PM_VOTER3X1_PCELL\%noxref_8

subckt PM_VOTER3X1_PCELL\%noxref_9 ( 2 4 5 6 7 8 10 12 22 29 31 )
c82 ( 29 0 ) capacitor c=0.00869746f //x=10.915 //y=0.91
c83 ( 22 0 ) capacitor c=0.0261871f //x=11.105 //y=5.38
c84 ( 12 0 ) capacitor c=0.0196817f //x=11.1 //y=1.005
c85 ( 10 0 ) capacitor c=0.116158f //x=11.47 //y=4.875
c86 ( 8 0 ) capacitor c=0.00557311f //x=11.19 //y=4.96
c87 ( 7 0 ) capacitor c=0.00944012f //x=11.385 //y=4.96
c88 ( 6 0 ) capacitor c=0.00724565f //x=11.185 //y=1.84
c89 ( 5 0 ) capacitor c=0.0145753f //x=11.385 //y=1.84
c90 ( 4 0 ) capacitor c=0.0117946f //x=11.105 //y=5.24
c91 ( 2 0 ) capacitor c=0.0166561f //x=11.1 //y=1.755
r92 (  22 31 ) resistor r=23.615 //w=0.187 //l=0.345 //layer=li \
 //thickness=0.1 //x=11.105 //y=5.38 //x2=11.105 //y2=5.725
r93 (  15 22 ) resistor r=9.3 //w=0.17 //l=0.17 //layer=mcon //count=1 \
 //x=11.105 //y=5.38 //x2=11.105 //y2=5.38
r94 (  12 29 ) resistor r=9.3 //w=0.17 //l=0.17 //layer=mcon //count=1 \
 //x=11.1 //y=1.005 //x2=11.1 //y2=1.005
r95 (  9 10 ) resistor r=2.81489 //w=0.131 //l=2.95 //layer=m1 \
 //thickness=0.36 //x=11.47 //y=1.925 //x2=11.47 //y2=4.875
r96 (  7 10 ) resistor r=0.0698411 //w=0.17 //l=0.120208 //layer=m1 \
 //thickness=0.36 //x=11.385 //y=4.96 //x2=11.47 //y2=4.875
r97 (  7 8 ) resistor r=0.186069 //w=0.131 //l=0.195 //layer=m1 \
 //thickness=0.36 //x=11.385 //y=4.96 //x2=11.19 //y2=4.96
r98 (  5 9 ) resistor r=0.0698411 //w=0.17 //l=0.120208 //layer=m1 \
 //thickness=0.36 //x=11.385 //y=1.84 //x2=11.47 //y2=1.925
r99 (  5 6 ) resistor r=0.19084 //w=0.131 //l=0.2 //layer=m1 //thickness=0.36 \
 //x=11.385 //y=1.84 //x2=11.185 //y2=1.84
r100 (  4 15 ) resistor r=0.086672 //w=0.218 //l=0.14 //layer=m1 \
 //thickness=0.36 //x=11.105 //y=5.24 //x2=11.105 //y2=5.38
r101 (  3 8 ) resistor r=0.0698411 //w=0.17 //l=0.120208 //layer=m1 \
 //thickness=0.36 //x=11.105 //y=5.045 //x2=11.19 //y2=4.96
r102 (  3 4 ) resistor r=0.186069 //w=0.131 //l=0.195 //layer=m1 \
 //thickness=0.36 //x=11.105 //y=5.045 //x2=11.105 //y2=5.24
r103 (  2 6 ) resistor r=0.0698411 //w=0.17 //l=0.120208 //layer=m1 \
 //thickness=0.36 //x=11.1 //y=1.755 //x2=11.185 //y2=1.84
r104 (  1 12 ) resistor r=0.105739 //w=0.201 //l=0.145 //layer=m1 \
 //thickness=0.36 //x=11.1 //y=1.15 //x2=11.1 //y2=1.005
r105 (  1 2 ) resistor r=0.57729 //w=0.131 //l=0.605 //layer=m1 \
 //thickness=0.36 //x=11.1 //y=1.15 //x2=11.1 //y2=1.755
ends PM_VOTER3X1_PCELL\%noxref_9

subckt PM_VOTER3X1_PCELL\%noxref_10 ( 1 5 9 10 13 17 29 )
c65 ( 29 0 ) capacitor c=0.0782322f //x=0.56 //y=0.365
c66 ( 17 0 ) capacitor c=0.00678917f //x=2.635 //y=0.615
c67 ( 13 0 ) capacitor c=0.0154169f //x=2.55 //y=0.53
c68 ( 10 0 ) capacitor c=0.00990031f //x=1.665 //y=1.495
c69 ( 9 0 ) capacitor c=0.00770028f //x=1.665 //y=0.615
c70 ( 5 0 ) capacitor c=0.028994f //x=1.58 //y=1.58
c71 ( 1 0 ) capacitor c=0.0049595f //x=0.695 //y=1.495
r72 (  17 29 ) resistor r=3.57586 //w=0.17 //l=0.125 //layer=li \
 //thickness=0.1 //x=2.635 //y=0.615 //x2=2.635 //y2=0.49
r73 (  17 29 ) resistor r=41.4118 //w=0.187 //l=0.605 //layer=li \
 //thickness=0.1 //x=2.635 //y=0.615 //x2=2.635 //y2=1.22
r74 (  14 29 ) resistor r=3.57586 //w=0.17 //l=0.103078 //layer=li \
 //thickness=0.1 //x=1.75 //y=0.53 //x2=1.665 //y2=0.49
r75 (  14 29 ) resistor r=27.0374 //w=0.187 //l=0.395 //layer=li \
 //thickness=0.1 //x=1.75 //y=0.53 //x2=2.145 //y2=0.53
r76 (  13 29 ) resistor r=3.57586 //w=0.17 //l=0.103078 //layer=li \
 //thickness=0.1 //x=2.55 //y=0.53 //x2=2.635 //y2=0.49
r77 (  13 29 ) resistor r=27.7219 //w=0.187 //l=0.405 //layer=li \
 //thickness=0.1 //x=2.55 //y=0.53 //x2=2.145 //y2=0.53
r78 (  10 29 ) resistor r=3.57586 //w=0.17 //l=0.125 //layer=li \
 //thickness=0.1 //x=1.665 //y=1.495 //x2=1.665 //y2=1.62
r79 (  10 29 ) resistor r=42.0963 //w=0.187 //l=0.615 //layer=li \
 //thickness=0.1 //x=1.665 //y=1.495 //x2=1.665 //y2=0.88
r80 (  9 29 ) resistor r=3.57586 //w=0.17 //l=0.125 //layer=li //thickness=0.1 \
 //x=1.665 //y=0.615 //x2=1.665 //y2=0.49
r81 (  9 29 ) resistor r=18.139 //w=0.187 //l=0.265 //layer=li //thickness=0.1 \
 //x=1.665 //y=0.615 //x2=1.665 //y2=0.88
r82 (  6 29 ) resistor r=3.57586 //w=0.17 //l=0.103078 //layer=li \
 //thickness=0.1 //x=0.78 //y=1.58 //x2=0.695 //y2=1.62
r83 (  6 29 ) resistor r=27.3797 //w=0.187 //l=0.4 //layer=li //thickness=0.1 \
 //x=0.78 //y=1.58 //x2=1.18 //y2=1.58
r84 (  5 29 ) resistor r=3.57586 //w=0.17 //l=0.103078 //layer=li \
 //thickness=0.1 //x=1.58 //y=1.58 //x2=1.665 //y2=1.62
r85 (  5 29 ) resistor r=27.3797 //w=0.187 //l=0.4 //layer=li //thickness=0.1 \
 //x=1.58 //y=1.58 //x2=1.18 //y2=1.58
r86 (  1 29 ) resistor r=3.57586 //w=0.17 //l=0.125 //layer=li //thickness=0.1 \
 //x=0.695 //y=1.495 //x2=0.695 //y2=1.62
r87 (  1 29 ) resistor r=42.0963 //w=0.187 //l=0.615 //layer=li \
 //thickness=0.1 //x=0.695 //y=1.495 //x2=0.695 //y2=0.88
ends PM_VOTER3X1_PCELL\%noxref_10

subckt PM_VOTER3X1_PCELL\%noxref_12 ( 1 5 9 10 13 17 29 )
c66 ( 29 0 ) capacitor c=0.073823f //x=3.89 //y=0.365
c67 ( 17 0 ) capacitor c=0.00678917f //x=5.965 //y=0.615
c68 ( 13 0 ) capacitor c=0.0158009f //x=5.88 //y=0.53
c69 ( 10 0 ) capacitor c=0.009705f //x=4.995 //y=1.495
c70 ( 9 0 ) capacitor c=0.00770028f //x=4.995 //y=0.615
c71 ( 5 0 ) capacitor c=0.0201517f //x=4.91 //y=1.58
c72 ( 1 0 ) capacitor c=0.00935657f //x=4.025 //y=1.495
r73 (  17 29 ) resistor r=3.57586 //w=0.17 //l=0.125 //layer=li \
 //thickness=0.1 //x=5.965 //y=0.615 //x2=5.965 //y2=0.49
r74 (  17 29 ) resistor r=41.4118 //w=0.187 //l=0.605 //layer=li \
 //thickness=0.1 //x=5.965 //y=0.615 //x2=5.965 //y2=1.22
r75 (  14 29 ) resistor r=3.57586 //w=0.17 //l=0.103078 //layer=li \
 //thickness=0.1 //x=5.08 //y=0.53 //x2=4.995 //y2=0.49
r76 (  14 29 ) resistor r=27.3797 //w=0.187 //l=0.4 //layer=li //thickness=0.1 \
 //x=5.08 //y=0.53 //x2=5.48 //y2=0.53
r77 (  13 29 ) resistor r=3.57586 //w=0.17 //l=0.103078 //layer=li \
 //thickness=0.1 //x=5.88 //y=0.53 //x2=5.965 //y2=0.49
r78 (  13 29 ) resistor r=27.3797 //w=0.187 //l=0.4 //layer=li //thickness=0.1 \
 //x=5.88 //y=0.53 //x2=5.48 //y2=0.53
r79 (  10 29 ) resistor r=3.57586 //w=0.17 //l=0.125 //layer=li \
 //thickness=0.1 //x=4.995 //y=1.495 //x2=4.995 //y2=1.62
r80 (  10 29 ) resistor r=42.0963 //w=0.187 //l=0.615 //layer=li \
 //thickness=0.1 //x=4.995 //y=1.495 //x2=4.995 //y2=0.88
r81 (  9 29 ) resistor r=3.57586 //w=0.17 //l=0.125 //layer=li //thickness=0.1 \
 //x=4.995 //y=0.615 //x2=4.995 //y2=0.49
r82 (  9 29 ) resistor r=18.139 //w=0.187 //l=0.265 //layer=li //thickness=0.1 \
 //x=4.995 //y=0.615 //x2=4.995 //y2=0.88
r83 (  6 29 ) resistor r=3.57586 //w=0.17 //l=0.103078 //layer=li \
 //thickness=0.1 //x=4.11 //y=1.58 //x2=4.025 //y2=1.62
r84 (  6 29 ) resistor r=27.3797 //w=0.187 //l=0.4 //layer=li //thickness=0.1 \
 //x=4.11 //y=1.58 //x2=4.51 //y2=1.58
r85 (  5 29 ) resistor r=3.57586 //w=0.17 //l=0.103078 //layer=li \
 //thickness=0.1 //x=4.91 //y=1.58 //x2=4.995 //y2=1.62
r86 (  5 29 ) resistor r=27.3797 //w=0.187 //l=0.4 //layer=li //thickness=0.1 \
 //x=4.91 //y=1.58 //x2=4.51 //y2=1.58
r87 (  1 29 ) resistor r=3.57586 //w=0.17 //l=0.125 //layer=li //thickness=0.1 \
 //x=4.025 //y=1.495 //x2=4.025 //y2=1.62
r88 (  1 29 ) resistor r=42.0963 //w=0.187 //l=0.615 //layer=li \
 //thickness=0.1 //x=4.025 //y=1.495 //x2=4.025 //y2=0.88
ends PM_VOTER3X1_PCELL\%noxref_12

subckt PM_VOTER3X1_PCELL\%noxref_13 ( 1 5 9 10 13 17 29 )
c73 ( 29 0 ) capacitor c=0.0677185f //x=7.22 //y=0.365
c74 ( 17 0 ) capacitor c=0.00709795f //x=9.295 //y=0.615
c75 ( 13 0 ) capacitor c=0.0152565f //x=9.21 //y=0.53
c76 ( 10 0 ) capacitor c=0.00749806f //x=8.325 //y=1.495
c77 ( 9 0 ) capacitor c=0.00770028f //x=8.325 //y=0.615
c78 ( 5 0 ) capacitor c=0.0236235f //x=8.24 //y=1.58
c79 ( 1 0 ) capacitor c=0.00498238f //x=7.355 //y=1.495
r80 (  17 29 ) resistor r=3.57586 //w=0.17 //l=0.125 //layer=li \
 //thickness=0.1 //x=9.295 //y=0.615 //x2=9.295 //y2=0.49
r81 (  17 29 ) resistor r=18.139 //w=0.187 //l=0.265 //layer=li \
 //thickness=0.1 //x=9.295 //y=0.615 //x2=9.295 //y2=0.88
r82 (  14 29 ) resistor r=3.57586 //w=0.17 //l=0.103078 //layer=li \
 //thickness=0.1 //x=8.41 //y=0.53 //x2=8.325 //y2=0.49
r83 (  14 29 ) resistor r=27.3797 //w=0.187 //l=0.4 //layer=li //thickness=0.1 \
 //x=8.41 //y=0.53 //x2=8.81 //y2=0.53
r84 (  13 29 ) resistor r=3.57586 //w=0.17 //l=0.103078 //layer=li \
 //thickness=0.1 //x=9.21 //y=0.53 //x2=9.295 //y2=0.49
r85 (  13 29 ) resistor r=27.3797 //w=0.187 //l=0.4 //layer=li //thickness=0.1 \
 //x=9.21 //y=0.53 //x2=8.81 //y2=0.53
r86 (  10 29 ) resistor r=3.57586 //w=0.17 //l=0.125 //layer=li \
 //thickness=0.1 //x=8.325 //y=1.495 //x2=8.325 //y2=1.62
r87 (  10 29 ) resistor r=42.0963 //w=0.187 //l=0.615 //layer=li \
 //thickness=0.1 //x=8.325 //y=1.495 //x2=8.325 //y2=0.88
r88 (  9 29 ) resistor r=3.57586 //w=0.17 //l=0.125 //layer=li //thickness=0.1 \
 //x=8.325 //y=0.615 //x2=8.325 //y2=0.49
r89 (  9 29 ) resistor r=18.139 //w=0.187 //l=0.265 //layer=li //thickness=0.1 \
 //x=8.325 //y=0.615 //x2=8.325 //y2=0.88
r90 (  6 29 ) resistor r=3.57586 //w=0.17 //l=0.103078 //layer=li \
 //thickness=0.1 //x=7.44 //y=1.58 //x2=7.355 //y2=1.62
r91 (  6 29 ) resistor r=27.3797 //w=0.187 //l=0.4 //layer=li //thickness=0.1 \
 //x=7.44 //y=1.58 //x2=7.84 //y2=1.58
r92 (  5 29 ) resistor r=3.57586 //w=0.17 //l=0.103078 //layer=li \
 //thickness=0.1 //x=8.24 //y=1.58 //x2=8.325 //y2=1.62
r93 (  5 29 ) resistor r=27.3797 //w=0.187 //l=0.4 //layer=li //thickness=0.1 \
 //x=8.24 //y=1.58 //x2=7.84 //y2=1.58
r94 (  1 29 ) resistor r=3.57586 //w=0.17 //l=0.125 //layer=li //thickness=0.1 \
 //x=7.355 //y=1.495 //x2=7.355 //y2=1.62
r95 (  1 29 ) resistor r=42.0963 //w=0.187 //l=0.615 //layer=li \
 //thickness=0.1 //x=7.355 //y=1.495 //x2=7.355 //y2=0.88
ends PM_VOTER3X1_PCELL\%noxref_13
