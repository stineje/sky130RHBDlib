// File: dffx1_pcell.spi
// Created: Thu Jan 22 07:13:18 2026
// Program "Calibre xRC"
// Version "v2023.2_27.15"
//
simulator lang=spectre
include "/import/yukari1/lrburle/sky130RHBDlib/sky130_rhbd/pex/dffx1_pcell.pex.spice"
subckt dffx1_pcell (  )
//
M0_noxref ( N_noxref_12_M0_noxref_d N_noxref_5_M0_noxref_g \
 N_noxref_14_M0_noxref_s noxref_224 ) NMOS l=0.163119 w=2.35104 m=1
M1_noxref ( N_noxref_7_M1_noxref_d N_noxref_3_M1_noxref_g \
 N_noxref_14_M0_noxref_s noxref_224 ) NMOS l=0.160516 w=2.29447 m=1
M2_noxref ( N_noxref_4_M2_noxref_d N_noxref_1_M2_noxref_g \
 N_noxref_7_M2_noxref_s noxref_224 ) NMOS l=0.163346 w=2.31104 m=1
M3_noxref ( N_noxref_12_M3_noxref_d N_noxref_4_M3_noxref_g \
 N_noxref_15_M3_noxref_s noxref_224 ) NMOS l=0.163119 w=2.35104 m=1
M4_noxref ( N_noxref_1_M4_noxref_d N_noxref_8_M4_noxref_g \
 N_noxref_15_M3_noxref_s noxref_224 ) NMOS l=0.163346 w=2.31104 m=1
M5_noxref ( N_noxref_12_M5_noxref_d N_noxref_1_M5_noxref_g \
 N_noxref_16_M5_noxref_s noxref_224 ) NMOS l=0.163119 w=2.35104 m=1
M6_noxref ( N_noxref_2_M6_noxref_d N_noxref_5_M6_noxref_g \
 N_noxref_16_M5_noxref_s noxref_224 ) NMOS l=0.163346 w=2.31104 m=1
M7_noxref ( N_noxref_12_M7_noxref_d N_noxref_2_M7_noxref_g \
 N_noxref_17_M7_noxref_s noxref_224 ) NMOS l=0.163119 w=2.35104 m=1
M8_noxref ( N_noxref_5_M8_noxref_d N_noxref_3_M8_noxref_g \
 N_noxref_17_M7_noxref_s noxref_224 ) NMOS l=0.163346 w=2.31104 m=1
M9_noxref ( N_noxref_12_M9_noxref_d N_noxref_4_M9_noxref_g \
 N_noxref_18_M9_noxref_s noxref_224 ) NMOS l=0.163119 w=2.35104 m=1
M10_noxref ( N_noxref_10_M10_noxref_d N_noxref_9_M10_noxref_g \
 N_noxref_18_M9_noxref_s noxref_224 ) NMOS l=0.163346 w=2.31104 m=1
M11_noxref ( N_noxref_12_M11_noxref_d N_noxref_11_M11_noxref_g \
 N_noxref_19_M11_noxref_s noxref_224 ) NMOS l=0.163119 w=2.35104 m=1
M12_noxref ( N_noxref_13_M12_noxref_d N_noxref_5_M12_noxref_g \
 N_noxref_19_M11_noxref_s noxref_224 ) NMOS l=0.163346 w=2.31104 m=1
M13_noxref ( N_noxref_4_M13_noxref_d N_noxref_5_M13_noxref_g \
 N_noxref_6_M13_noxref_s noxref_222 ) PMOS l=0.15 w=2 ad=0.57 as=0.57 pd=2.57 \
 ps=2.57 nrd=0 nrs=0 m=1
M14_noxref ( N_noxref_6_M14_noxref_d N_noxref_5_M14_noxref_g \
 N_noxref_4_M13_noxref_d noxref_222 ) PMOS l=0.15 w=2 ad=0.58 as=0.58 pd=2.58 \
 ps=2.58 nrd=0 nrs=0 m=1
M15_noxref ( N_noxref_4_M15_noxref_d N_noxref_3_M15_noxref_g \
 N_noxref_6_M14_noxref_d noxref_222 ) PMOS l=0.15 w=2 ad=0.58 as=0.58 pd=2.58 \
 ps=2.58 nrd=0 nrs=0 m=1
M16_noxref ( N_noxref_6_M16_noxref_d N_noxref_3_M16_noxref_g \
 N_noxref_4_M15_noxref_d noxref_222 ) PMOS l=0.15 w=2 ad=0.58 as=0.58 pd=2.58 \
 ps=2.58 nrd=0 nrs=0 m=1
M17_noxref ( N_noxref_4_M17_noxref_d N_noxref_1_M17_noxref_g \
 N_noxref_6_M16_noxref_d noxref_222 ) PMOS l=0.15 w=2 ad=0.58 as=0.58 pd=2.58 \
 ps=2.58 nrd=0 nrs=0 m=1
M18_noxref ( N_noxref_6_M18_noxref_d N_noxref_1_M18_noxref_g \
 N_noxref_4_M17_noxref_d noxref_222 ) PMOS l=0.15 w=2 ad=0.56 as=0.56 pd=2.56 \
 ps=2.56 nrd=0 nrs=0 m=1
M19_noxref ( N_noxref_1_M19_noxref_d N_noxref_4_M19_noxref_g \
 N_noxref_6_M19_noxref_s noxref_222 ) PMOS l=0.15 w=2 ad=0.57 as=0.57 pd=2.57 \
 ps=2.57 nrd=0 nrs=0 m=1
M20_noxref ( N_noxref_6_M20_noxref_d N_noxref_4_M20_noxref_g \
 N_noxref_1_M19_noxref_d noxref_222 ) PMOS l=0.15 w=2 ad=0.58 as=0.58 pd=2.58 \
 ps=2.58 nrd=0 nrs=0 m=1
M21_noxref ( N_noxref_1_M21_noxref_d N_noxref_8_M21_noxref_g \
 N_noxref_6_M20_noxref_d noxref_222 ) PMOS l=0.15 w=2 ad=0.58 as=0.58 pd=2.58 \
 ps=2.58 nrd=0 nrs=0 m=1
M22_noxref ( N_noxref_6_M22_noxref_d N_noxref_8_M22_noxref_g \
 N_noxref_1_M21_noxref_d noxref_222 ) PMOS l=0.15 w=2 ad=0.56 as=0.56 pd=2.56 \
 ps=2.56 nrd=0 nrs=0 m=1
M23_noxref ( N_noxref_2_M23_noxref_d N_noxref_1_M23_noxref_g \
 N_noxref_6_M23_noxref_s noxref_222 ) PMOS l=0.15 w=2 ad=0.57 as=0.57 pd=2.57 \
 ps=2.57 nrd=0 nrs=0 m=1
M24_noxref ( N_noxref_6_M24_noxref_d N_noxref_1_M24_noxref_g \
 N_noxref_2_M23_noxref_d noxref_222 ) PMOS l=0.15 w=2 ad=0.58 as=0.58 pd=2.58 \
 ps=2.58 nrd=0 nrs=0 m=1
M25_noxref ( N_noxref_2_M25_noxref_d N_noxref_5_M25_noxref_g \
 N_noxref_6_M24_noxref_d noxref_222 ) PMOS l=0.15 w=2 ad=0.58 as=0.58 pd=2.58 \
 ps=2.58 nrd=0 nrs=0 m=1
M26_noxref ( N_noxref_6_M26_noxref_d N_noxref_5_M26_noxref_g \
 N_noxref_2_M25_noxref_d noxref_222 ) PMOS l=0.15 w=2 ad=0.56 as=0.56 pd=2.56 \
 ps=2.56 nrd=0 nrs=0 m=1
M27_noxref ( N_noxref_5_M27_noxref_d N_noxref_2_M27_noxref_g \
 N_noxref_6_M27_noxref_s noxref_222 ) PMOS l=0.15 w=2 ad=0.57 as=0.57 pd=2.57 \
 ps=2.57 nrd=0 nrs=0 m=1
M28_noxref ( N_noxref_6_M28_noxref_d N_noxref_2_M28_noxref_g \
 N_noxref_5_M27_noxref_d noxref_222 ) PMOS l=0.15 w=2 ad=0.58 as=0.58 pd=2.58 \
 ps=2.58 nrd=0 nrs=0 m=1
M29_noxref ( N_noxref_5_M29_noxref_d N_noxref_3_M29_noxref_g \
 N_noxref_6_M28_noxref_d noxref_222 ) PMOS l=0.15 w=2 ad=0.58 as=0.58 pd=2.58 \
 ps=2.58 nrd=0 nrs=0 m=1
M30_noxref ( N_noxref_6_M30_noxref_d N_noxref_3_M30_noxref_g \
 N_noxref_5_M29_noxref_d noxref_222 ) PMOS l=0.15 w=2 ad=0.56 as=0.56 pd=2.56 \
 ps=2.56 nrd=0 nrs=0 m=1
M31_noxref ( N_noxref_10_M31_noxref_d N_noxref_4_M31_noxref_g \
 N_noxref_6_M31_noxref_s noxref_222 ) PMOS l=0.15 w=2 ad=0.57 as=0.57 pd=2.57 \
 ps=2.57 nrd=0 nrs=0 m=1
M32_noxref ( N_noxref_6_M32_noxref_d N_noxref_4_M32_noxref_g \
 N_noxref_10_M31_noxref_d noxref_222 ) PMOS l=0.15 w=2 ad=0.58 as=0.58 pd=2.58 \
 ps=2.58 nrd=0 nrs=0 m=1
M33_noxref ( N_noxref_10_M33_noxref_d N_noxref_9_M33_noxref_g \
 N_noxref_6_M32_noxref_d noxref_222 ) PMOS l=0.15 w=2 ad=0.58 as=0.58 pd=2.58 \
 ps=2.58 nrd=0 nrs=0 m=1
M34_noxref ( N_noxref_6_M34_noxref_d N_noxref_9_M34_noxref_g \
 N_noxref_10_M33_noxref_d noxref_222 ) PMOS l=0.15 w=2 ad=0.56 as=0.56 pd=2.56 \
 ps=2.56 nrd=0 nrs=0 m=1
M35_noxref ( N_noxref_13_M35_noxref_d N_noxref_11_M35_noxref_g \
 N_noxref_6_M35_noxref_s noxref_222 ) PMOS l=0.15 w=2 ad=0.57 as=0.57 pd=2.57 \
 ps=2.57 nrd=0 nrs=0 m=1
M36_noxref ( N_noxref_6_M36_noxref_d N_noxref_11_M36_noxref_g \
 N_noxref_13_M35_noxref_d noxref_222 ) PMOS l=0.15 w=2 ad=0.58 as=0.58 pd=2.58 \
 ps=2.58 nrd=0 nrs=0 m=1
M37_noxref ( N_noxref_13_M37_noxref_d N_noxref_5_M37_noxref_g \
 N_noxref_6_M36_noxref_d noxref_222 ) PMOS l=0.15 w=2 ad=0.58 as=0.58 pd=2.58 \
 ps=2.58 nrd=0 nrs=0 m=1
M38_noxref ( N_noxref_6_M38_noxref_d N_noxref_5_M38_noxref_g \
 N_noxref_13_M37_noxref_d noxref_222 ) PMOS l=0.15 w=2 ad=0.56 as=0.56 pd=2.56 \
 ps=2.56 nrd=0 nrs=0 m=1
//
include "/import/yukari1/lrburle/sky130RHBDlib/sky130_rhbd/pex/dffx1_pcell.pxi.spice"
//
ends DFFX1_PCELL
//
//
