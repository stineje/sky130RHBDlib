// File: NAND3X1.spi.pex
// Created: Tue Apr 29 10:43:26 2025
// Program "Calibre xRC"
// Version "v2023.2_27.15"
// Nominal Temperature: 30C
// Circuit Temperature: 30C
//
simulator lang=spectre
subckt PM_NAND3X1\%GND ( 1 11 15 18 30 34 )
c43 ( 34 0 ) capacitor c=0.022696f //x=1.375 //y=1.055
c44 ( 33 0 ) capacitor c=0.00446464f //x=1.565 //y=0.175
c45 ( 30 0 ) capacitor c=0.342504f //x=4.56 //y=0.18
c46 ( 18 0 ) capacitor c=0.196955f //x=1.23 //y=0.18
c47 ( 15 0 ) capacitor c=0.0370791f //x=1.48 //y=0.175
c48 ( 11 0 ) capacitor c=0.220699f //x=4.56 //y=0.18
r49 (  28 30 ) resistor r=38.7139 //w=0.367 //l=1.11 //layer=li \
 //thickness=0.1 //x=3.45 //y=0.175 //x2=4.56 //y2=0.175
r50 (  26 28 ) resistor r=38.7139 //w=0.367 //l=1.11 //layer=li \
 //thickness=0.1 //x=2.34 //y=0.175 //x2=3.45 //y2=0.175
r51 (  24 33 ) resistor r=2.87058 //w=0.35 //l=0.085 //layer=li \
 //thickness=0.1 //x=1.65 //y=0.175 //x2=1.565 //y2=0.175
r52 (  24 26 ) resistor r=24.0654 //w=0.367 //l=0.69 //layer=li \
 //thickness=0.1 //x=1.65 //y=0.175 //x2=2.34 //y2=0.175
r53 (  19 33 ) resistor r=4.23183 //w=0.7 //l=0.175 //layer=li //thickness=0.1 \
 //x=1.565 //y=0.35 //x2=1.565 //y2=0.175
r54 (  19 34 ) resistor r=54.4171 //w=0.187 //l=0.795 //layer=li \
 //thickness=0.1 //x=1.565 //y=0.35 //x2=1.565 //y2=1.145
r55 (  15 33 ) resistor r=2.87058 //w=0.35 //l=0.085 //layer=li \
 //thickness=0.1 //x=1.48 //y=0.175 //x2=1.565 //y2=0.175
r56 (  15 18 ) resistor r=8.71935 //w=0.367 //l=0.25 //layer=li \
 //thickness=0.1 //x=1.48 //y=0.175 //x2=1.23 //y2=0.175
r57 (  11 30 ) resistor r=3.1 //w=0.17 //l=0.51 //layer=mcon //count=3 \
 //x=4.56 //y=0.18 //x2=4.56 //y2=0.18
r58 (  9 28 ) resistor r=3.1 //w=0.17 //l=0.51 //layer=mcon //count=3 //x=3.45 \
 //y=0.18 //x2=3.45 //y2=0.18
r59 (  9 11 ) resistor r=0.446141 //w=0.311 //l=1.11 //layer=m1 \
 //thickness=0.36 //x=3.45 //y=0.175 //x2=4.56 //y2=0.175
r60 (  6 26 ) resistor r=3.1 //w=0.17 //l=0.51 //layer=mcon //count=3 //x=2.34 \
 //y=0.18 //x2=2.34 //y2=0.18
r61 (  3 18 ) resistor r=3.1 //w=0.17 //l=0.51 //layer=mcon //count=3 //x=1.23 \
 //y=0.18 //x2=1.23 //y2=0.18
r62 (  3 6 ) resistor r=0.446141 //w=0.311 //l=1.11 //layer=m1 \
 //thickness=0.36 //x=1.23 //y=0.175 //x2=2.34 //y2=0.175
r63 (  1 9 ) resistor r=0.223071 //w=0.311 //l=0.555 //layer=m1 \
 //thickness=0.36 //x=2.895 //y=0.175 //x2=3.45 //y2=0.175
r64 (  1 6 ) resistor r=0.223071 //w=0.311 //l=0.555 //layer=m1 \
 //thickness=0.36 //x=2.895 //y=0.175 //x2=2.34 //y2=0.175
ends PM_NAND3X1\%GND

subckt PM_NAND3X1\%VDD ( 1 11 18 25 35 43 56 63 64 65 66 )
c47 ( 66 0 ) capacitor c=0.0455454f //x=4.075 //y=5.2
c48 ( 65 0 ) capacitor c=0.0244795f //x=3.195 //y=5.2
c49 ( 64 0 ) capacitor c=0.0244795f //x=2.315 //y=5.2
c50 ( 63 0 ) capacitor c=0.0533644f //x=1.445 //y=5.2
c51 ( 62 0 ) capacitor c=0.00597439f //x=4.22 //y=7.585
c52 ( 61 0 ) capacitor c=0.00597439f //x=3.34 //y=7.585
c53 ( 60 0 ) capacitor c=0.00597439f //x=2.46 //y=7.585
c54 ( 59 0 ) capacitor c=0.00597439f //x=1.58 //y=7.585
c55 ( 56 0 ) capacitor c=0.291224f //x=4.56 //y=7.58
c56 ( 43 0 ) capacitor c=0.0287829f //x=4.135 //y=7.585
c57 ( 35 0 ) capacitor c=0.0289769f //x=3.255 //y=7.585
c58 ( 25 0 ) capacitor c=0.0294764f //x=2.375 //y=7.585
c59 ( 18 0 ) capacitor c=0.253692f //x=1.23 //y=7.58
c60 ( 15 0 ) capacitor c=0.0455283f //x=1.495 //y=7.585
c61 ( 11 0 ) capacitor c=0.250336f //x=4.56 //y=7.58
r62 (  54 62 ) resistor r=2.87058 //w=0.35 //l=0.085 //layer=li \
 //thickness=0.1 //x=4.305 //y=7.585 //x2=4.22 //y2=7.585
r63 (  54 56 ) resistor r=8.89373 //w=0.367 //l=0.255 //layer=li \
 //thickness=0.1 //x=4.305 //y=7.585 //x2=4.56 //y2=7.585
r64 (  47 62 ) resistor r=4.23183 //w=0.7 //l=0.175 //layer=li //thickness=0.1 \
 //x=4.22 //y=7.41 //x2=4.22 //y2=7.585
r65 (  47 66 ) resistor r=33.1979 //w=0.187 //l=0.485 //layer=li \
 //thickness=0.1 //x=4.22 //y=7.41 //x2=4.22 //y2=6.925
r66 (  44 61 ) resistor r=2.87058 //w=0.35 //l=0.085 //layer=li \
 //thickness=0.1 //x=3.425 //y=7.585 //x2=3.34 //y2=7.585
r67 (  44 46 ) resistor r=0.871935 //w=0.367 //l=0.025 //layer=li \
 //thickness=0.1 //x=3.425 //y=7.585 //x2=3.45 //y2=7.585
r68 (  43 62 ) resistor r=2.87058 //w=0.35 //l=0.085 //layer=li \
 //thickness=0.1 //x=4.135 //y=7.585 //x2=4.22 //y2=7.585
r69 (  43 46 ) resistor r=23.891 //w=0.367 //l=0.685 //layer=li \
 //thickness=0.1 //x=4.135 //y=7.585 //x2=3.45 //y2=7.585
r70 (  37 61 ) resistor r=4.23183 //w=0.7 //l=0.175 //layer=li //thickness=0.1 \
 //x=3.34 //y=7.41 //x2=3.34 //y2=7.585
r71 (  37 65 ) resistor r=33.1979 //w=0.187 //l=0.485 //layer=li \
 //thickness=0.1 //x=3.34 //y=7.41 //x2=3.34 //y2=6.925
r72 (  36 60 ) resistor r=2.87058 //w=0.35 //l=0.085 //layer=li \
 //thickness=0.1 //x=2.545 //y=7.585 //x2=2.46 //y2=7.585
r73 (  35 61 ) resistor r=2.87058 //w=0.35 //l=0.085 //layer=li \
 //thickness=0.1 //x=3.255 //y=7.585 //x2=3.34 //y2=7.585
r74 (  35 36 ) resistor r=24.7629 //w=0.367 //l=0.71 //layer=li \
 //thickness=0.1 //x=3.255 //y=7.585 //x2=2.545 //y2=7.585
r75 (  29 60 ) resistor r=4.23183 //w=0.7 //l=0.175 //layer=li //thickness=0.1 \
 //x=2.46 //y=7.41 //x2=2.46 //y2=7.585
r76 (  29 64 ) resistor r=33.1979 //w=0.187 //l=0.485 //layer=li \
 //thickness=0.1 //x=2.46 //y=7.41 //x2=2.46 //y2=6.925
r77 (  26 59 ) resistor r=2.87058 //w=0.35 //l=0.085 //layer=li \
 //thickness=0.1 //x=1.665 //y=7.585 //x2=1.58 //y2=7.585
r78 (  26 28 ) resistor r=23.5422 //w=0.367 //l=0.675 //layer=li \
 //thickness=0.1 //x=1.665 //y=7.585 //x2=2.34 //y2=7.585
r79 (  25 60 ) resistor r=2.87058 //w=0.35 //l=0.085 //layer=li \
 //thickness=0.1 //x=2.375 //y=7.585 //x2=2.46 //y2=7.585
r80 (  25 28 ) resistor r=1.22071 //w=0.367 //l=0.035 //layer=li \
 //thickness=0.1 //x=2.375 //y=7.585 //x2=2.34 //y2=7.585
r81 (  19 59 ) resistor r=4.23183 //w=0.7 //l=0.175 //layer=li //thickness=0.1 \
 //x=1.58 //y=7.41 //x2=1.58 //y2=7.585
r82 (  19 63 ) resistor r=56.4706 //w=0.187 //l=0.825 //layer=li \
 //thickness=0.1 //x=1.58 //y=7.41 //x2=1.58 //y2=6.585
r83 (  15 59 ) resistor r=2.87058 //w=0.35 //l=0.085 //layer=li \
 //thickness=0.1 //x=1.495 //y=7.585 //x2=1.58 //y2=7.585
r84 (  15 18 ) resistor r=9.24251 //w=0.367 //l=0.265 //layer=li \
 //thickness=0.1 //x=1.495 //y=7.585 //x2=1.23 //y2=7.585
r85 (  11 56 ) resistor r=3.1 //w=0.17 //l=0.51 //layer=mcon //count=3 \
 //x=4.56 //y=7.58 //x2=4.56 //y2=7.58
r86 (  9 46 ) resistor r=3.1 //w=0.17 //l=0.51 //layer=mcon //count=3 //x=3.45 \
 //y=7.58 //x2=3.45 //y2=7.58
r87 (  9 11 ) resistor r=0.446141 //w=0.311 //l=1.11 //layer=m1 \
 //thickness=0.36 //x=3.45 //y=7.585 //x2=4.56 //y2=7.585
r88 (  6 28 ) resistor r=3.1 //w=0.17 //l=0.51 //layer=mcon //count=3 //x=2.34 \
 //y=7.58 //x2=2.34 //y2=7.58
r89 (  3 18 ) resistor r=3.1 //w=0.17 //l=0.51 //layer=mcon //count=3 //x=1.23 \
 //y=7.58 //x2=1.23 //y2=7.58
r90 (  3 6 ) resistor r=0.446141 //w=0.311 //l=1.11 //layer=m1 \
 //thickness=0.36 //x=1.23 //y=7.585 //x2=2.34 //y2=7.585
r91 (  1 9 ) resistor r=0.223071 //w=0.311 //l=0.555 //layer=m1 \
 //thickness=0.36 //x=2.895 //y=7.585 //x2=3.45 //y2=7.585
r92 (  1 6 ) resistor r=0.223071 //w=0.311 //l=0.555 //layer=m1 \
 //thickness=0.36 //x=2.895 //y=7.585 //x2=2.34 //y2=7.585
ends PM_NAND3X1\%VDD

subckt PM_NAND3X1\%A ( 1 2 3 4 5 6 7 9 21 22 23 24 25 26 27 28 30 36 37 38 39 )
c54 ( 39 0 ) capacitor c=0.0598646f //x=1.875 //y=4.97
c55 ( 38 0 ) capacitor c=0.0375015f //x=2.165 //y=4.97
c56 ( 37 0 ) capacitor c=0.0347816f //x=1.83 //y=1.4
c57 ( 36 0 ) capacitor c=0.0187487f //x=1.83 //y=1.055
c58 ( 30 0 ) capacitor c=0.0137055f //x=1.675 //y=1.555
c59 ( 28 0 ) capacitor c=0.0149861f //x=1.675 //y=0.9
c60 ( 27 0 ) capacitor c=0.102158f //x=1.3 //y=2.095
c61 ( 26 0 ) capacitor c=0.0229444f //x=1.3 //y=1.71
c62 ( 25 0 ) capacitor c=0.0234352f //x=1.3 //y=1.4
c63 ( 24 0 ) capacitor c=0.0198724f //x=1.3 //y=1.055
c64 ( 23 0 ) capacitor c=0.110114f //x=2.24 //y=6.2
c65 ( 22 0 ) capacitor c=0.158956f //x=1.8 //y=6.2
c66 ( 9 0 ) capacitor c=0.128848f //x=1.6 //y=2.26
r67 (  38 40 ) resistor r=26.9307 //w=0.15 //l=0.106066 //layer=ply \
 //thickness=0.18 //x=2.165 //y=4.97 //x2=2.24 //y2=5.045
r68 (  38 39 ) resistor r=148.702 //w=0.094 //l=0.29 //layer=ply \
 //thickness=0.18 //x=2.165 //y=4.97 //x2=1.875 //y2=4.97
r69 (  37 50 ) resistor r=45.1352 //w=0.168 //l=0.173853 //layer=ply \
 //thickness=0.18 //x=1.83 //y=1.4 //x2=1.79 //y2=1.555
r70 (  36 49 ) resistor r=45.1352 //w=0.168 //l=0.173853 //layer=ply \
 //thickness=0.18 //x=1.83 //y=1.055 //x2=1.79 //y2=0.9
r71 (  36 37 ) resistor r=176.904 //w=0.094 //l=0.345 //layer=ply \
 //thickness=0.18 //x=1.83 //y=1.055 //x2=1.83 //y2=1.4
r72 (  33 39 ) resistor r=22.7971 //w=0.269 //l=0.106066 //layer=ply \
 //thickness=0.18 //x=1.8 //y=5.045 //x2=1.875 //y2=4.97
r73 (  33 48 ) resistor r=35.8364 //w=0.269 //l=0.270185 //layer=ply \
 //thickness=0.18 //x=1.8 //y=5.045 //x2=1.6 //y2=4.88
r74 (  31 44 ) resistor r=10.701 //w=0.21 //l=0.115 //layer=ply \
 //thickness=0.18 //x=1.455 //y=1.555 //x2=1.34 //y2=1.555
r75 (  30 50 ) resistor r=5.52526 //w=0.168 //l=0.115 //layer=ply \
 //thickness=0.18 //x=1.675 //y=1.555 //x2=1.79 //y2=1.555
r76 (  29 43 ) resistor r=5.52526 //w=0.168 //l=0.115 //layer=ply \
 //thickness=0.18 //x=1.455 //y=0.9 //x2=1.34 //y2=0.9
r77 (  28 49 ) resistor r=5.52526 //w=0.168 //l=0.115 //layer=ply \
 //thickness=0.18 //x=1.675 //y=0.9 //x2=1.79 //y2=0.9
r78 (  28 29 ) resistor r=112.809 //w=0.094 //l=0.22 //layer=ply \
 //thickness=0.18 //x=1.675 //y=0.9 //x2=1.455 //y2=0.9
r79 (  27 46 ) resistor r=58.7805 //w=0.246 //l=0.373497 //layer=ply \
 //thickness=0.18 //x=1.3 //y=2.095 //x2=1.6 //y2=2.26
r80 (  26 44 ) resistor r=39.5823 //w=0.21 //l=0.173853 //layer=ply \
 //thickness=0.18 //x=1.3 //y=1.71 //x2=1.34 //y2=1.555
r81 (  26 27 ) resistor r=197.415 //w=0.094 //l=0.385 //layer=ply \
 //thickness=0.18 //x=1.3 //y=1.71 //x2=1.3 //y2=2.095
r82 (  25 44 ) resistor r=39.5823 //w=0.21 //l=0.173853 //layer=ply \
 //thickness=0.18 //x=1.3 //y=1.4 //x2=1.34 //y2=1.555
r83 (  24 43 ) resistor r=45.1352 //w=0.168 //l=0.173853 //layer=ply \
 //thickness=0.18 //x=1.3 //y=1.055 //x2=1.34 //y2=0.9
r84 (  24 25 ) resistor r=176.904 //w=0.094 //l=0.345 //layer=ply \
 //thickness=0.18 //x=1.3 //y=1.055 //x2=1.3 //y2=1.4
r85 (  23 40 ) resistor r=592.245 //w=0.094 //l=1.155 //layer=ply \
 //thickness=0.18 //x=2.24 //y=6.2 //x2=2.24 //y2=5.045
r86 (  22 33 ) resistor r=592.245 //w=0.094 //l=1.155 //layer=ply \
 //thickness=0.18 //x=1.8 //y=6.2 //x2=1.8 //y2=5.045
r87 (  21 30 ) resistor r=56.4043 //w=0.094 //l=0.11 //layer=ply \
 //thickness=0.18 //x=1.565 //y=1.555 //x2=1.675 //y2=1.555
r88 (  21 31 ) resistor r=56.4043 //w=0.094 //l=0.11 //layer=ply \
 //thickness=0.18 //x=1.565 //y=1.555 //x2=1.455 //y2=1.555
r89 (  19 48 ) resistor r=152 //w=0.17 //l=0.17 //layer=licon //count=1 \
 //x=1.6 //y=4.88 //x2=1.6 //y2=4.88
r90 (  9 46 ) resistor r=152 //w=0.17 //l=0.17 //layer=licon //count=1 //x=1.6 \
 //y=2.26 //x2=1.6 //y2=2.26
r91 (  7 19 ) resistor r=17.7968 //w=0.187 //l=0.26 //layer=li //thickness=0.1 \
 //x=1.6 //y=4.62 //x2=1.6 //y2=4.88
r92 (  6 7 ) resistor r=25.3262 //w=0.187 //l=0.37 //layer=li //thickness=0.1 \
 //x=1.6 //y=4.25 //x2=1.6 //y2=4.62
r93 (  5 6 ) resistor r=25.3262 //w=0.187 //l=0.37 //layer=li //thickness=0.1 \
 //x=1.6 //y=3.88 //x2=1.6 //y2=4.25
r94 (  4 5 ) resistor r=25.3262 //w=0.187 //l=0.37 //layer=li //thickness=0.1 \
 //x=1.6 //y=3.51 //x2=1.6 //y2=3.88
r95 (  3 4 ) resistor r=25.3262 //w=0.187 //l=0.37 //layer=li //thickness=0.1 \
 //x=1.6 //y=3.14 //x2=1.6 //y2=3.51
r96 (  2 3 ) resistor r=25.3262 //w=0.187 //l=0.37 //layer=li //thickness=0.1 \
 //x=1.6 //y=2.77 //x2=1.6 //y2=3.14
r97 (  1 2 ) resistor r=25.3262 //w=0.187 //l=0.37 //layer=li //thickness=0.1 \
 //x=1.6 //y=2.4 //x2=1.6 //y2=2.77
r98 (  1 9 ) resistor r=9.58289 //w=0.187 //l=0.14 //layer=li //thickness=0.1 \
 //x=1.6 //y=2.4 //x2=1.6 //y2=2.26
ends PM_NAND3X1\%A

subckt PM_NAND3X1\%B ( 1 2 3 4 5 6 7 9 21 22 23 24 25 26 28 34 35 36 37 38 46 )
c69 ( 46 0 ) capacitor c=0.0354872f //x=2.71 //y=4.88
c70 ( 38 0 ) capacitor c=0.0307682f //x=3.045 //y=4.97
c71 ( 37 0 ) capacitor c=0.0850619f //x=2.8 //y=2.095
c72 ( 36 0 ) capacitor c=0.0170266f //x=2.8 //y=1.63
c73 ( 35 0 ) capacitor c=0.018609f //x=2.8 //y=1.4
c74 ( 34 0 ) capacitor c=0.0187309f //x=2.8 //y=1.09
c75 ( 28 0 ) capacitor c=0.014725f //x=2.645 //y=1.555
c76 ( 26 0 ) capacitor c=0.0146567f //x=2.645 //y=0.935
c77 ( 25 0 ) capacitor c=0.0335408f //x=2.275 //y=1.4
c78 ( 24 0 ) capacitor c=0.0173761f //x=2.275 //y=1.09
c79 ( 23 0 ) capacitor c=0.110114f //x=3.12 //y=6.2
c80 ( 22 0 ) capacitor c=0.11012f //x=2.68 //y=6.2
c81 ( 9 0 ) capacitor c=0.106919f //x=2.71 //y=2.26
r82 (  48 49 ) resistor r=32.4568 //w=0.214 //l=0.075 //layer=ply \
 //thickness=0.18 //x=2.71 //y=4.97 //x2=2.71 //y2=5.045
r83 (  46 48 ) resistor r=20.271 //w=0.214 //l=0.09 //layer=ply \
 //thickness=0.18 //x=2.71 //y=4.88 //x2=2.71 //y2=4.97
r84 (  39 48 ) resistor r=16.5046 //w=0.27 //l=0.135 //layer=ply \
 //thickness=0.18 //x=2.845 //y=4.97 //x2=2.71 //y2=4.97
r85 (  38 40 ) resistor r=26.9307 //w=0.15 //l=0.106066 //layer=ply \
 //thickness=0.18 //x=3.045 //y=4.97 //x2=3.12 //y2=5.045
r86 (  38 39 ) resistor r=102.553 //w=0.094 //l=0.2 //layer=ply \
 //thickness=0.18 //x=3.045 //y=4.97 //x2=2.845 //y2=4.97
r87 (  37 53 ) resistor r=38.6777 //w=0.284 //l=0.198997 //layer=ply \
 //thickness=0.18 //x=2.8 //y=2.095 //x2=2.725 //y2=2.26
r88 (  36 51 ) resistor r=21.2976 //w=0.217 //l=0.0928709 //layer=ply \
 //thickness=0.18 //x=2.8 //y=1.63 //x2=2.76 //y2=1.555
r89 (  36 37 ) resistor r=238.436 //w=0.094 //l=0.465 //layer=ply \
 //thickness=0.18 //x=2.8 //y=1.63 //x2=2.8 //y2=2.095
r90 (  35 51 ) resistor r=39.0671 //w=0.217 //l=0.173853 //layer=ply \
 //thickness=0.18 //x=2.8 //y=1.4 //x2=2.76 //y2=1.555
r91 (  34 50 ) resistor r=45.1352 //w=0.168 //l=0.173853 //layer=ply \
 //thickness=0.18 //x=2.8 //y=1.09 //x2=2.76 //y2=0.935
r92 (  34 35 ) resistor r=158.957 //w=0.094 //l=0.31 //layer=ply \
 //thickness=0.18 //x=2.8 //y=1.09 //x2=2.8 //y2=1.4
r93 (  29 44 ) resistor r=5.52526 //w=0.168 //l=0.115 //layer=ply \
 //thickness=0.18 //x=2.43 //y=1.555 //x2=2.315 //y2=1.555
r94 (  28 51 ) resistor r=11.4558 //w=0.217 //l=0.115 //layer=ply \
 //thickness=0.18 //x=2.645 //y=1.555 //x2=2.76 //y2=1.555
r95 (  27 43 ) resistor r=5.52526 //w=0.168 //l=0.115 //layer=ply \
 //thickness=0.18 //x=2.43 //y=0.935 //x2=2.315 //y2=0.935
r96 (  26 50 ) resistor r=5.52526 //w=0.168 //l=0.115 //layer=ply \
 //thickness=0.18 //x=2.645 //y=0.935 //x2=2.76 //y2=0.935
r97 (  26 27 ) resistor r=110.245 //w=0.094 //l=0.215 //layer=ply \
 //thickness=0.18 //x=2.645 //y=0.935 //x2=2.43 //y2=0.935
r98 (  25 44 ) resistor r=45.1352 //w=0.168 //l=0.173853 //layer=ply \
 //thickness=0.18 //x=2.275 //y=1.4 //x2=2.315 //y2=1.555
r99 (  24 43 ) resistor r=45.1352 //w=0.168 //l=0.173853 //layer=ply \
 //thickness=0.18 //x=2.275 //y=1.09 //x2=2.315 //y2=0.935
r100 (  24 25 ) resistor r=158.957 //w=0.094 //l=0.31 //layer=ply \
 //thickness=0.18 //x=2.275 //y=1.09 //x2=2.275 //y2=1.4
r101 (  23 40 ) resistor r=592.245 //w=0.094 //l=1.155 //layer=ply \
 //thickness=0.18 //x=3.12 //y=6.2 //x2=3.12 //y2=5.045
r102 (  22 49 ) resistor r=592.245 //w=0.094 //l=1.155 //layer=ply \
 //thickness=0.18 //x=2.68 //y=6.2 //x2=2.68 //y2=5.045
r103 (  21 28 ) resistor r=55.3787 //w=0.094 //l=0.108 //layer=ply \
 //thickness=0.18 //x=2.537 //y=1.555 //x2=2.645 //y2=1.555
r104 (  21 29 ) resistor r=54.866 //w=0.094 //l=0.107 //layer=ply \
 //thickness=0.18 //x=2.537 //y=1.555 //x2=2.43 //y2=1.555
r105 (  19 46 ) resistor r=152 //w=0.17 //l=0.17 //layer=licon //count=1 \
 //x=2.71 //y=4.88 //x2=2.71 //y2=4.88
r106 (  9 53 ) resistor r=152 //w=0.17 //l=0.17 //layer=licon //count=1 \
 //x=2.71 //y=2.26 //x2=2.71 //y2=2.26
r107 (  7 19 ) resistor r=17.7968 //w=0.187 //l=0.26 //layer=li \
 //thickness=0.1 //x=2.71 //y=4.62 //x2=2.71 //y2=4.88
r108 (  6 7 ) resistor r=25.3262 //w=0.187 //l=0.37 //layer=li //thickness=0.1 \
 //x=2.71 //y=4.25 //x2=2.71 //y2=4.62
r109 (  5 6 ) resistor r=25.3262 //w=0.187 //l=0.37 //layer=li //thickness=0.1 \
 //x=2.71 //y=3.88 //x2=2.71 //y2=4.25
r110 (  4 5 ) resistor r=25.3262 //w=0.187 //l=0.37 //layer=li //thickness=0.1 \
 //x=2.71 //y=3.51 //x2=2.71 //y2=3.88
r111 (  3 4 ) resistor r=25.3262 //w=0.187 //l=0.37 //layer=li //thickness=0.1 \
 //x=2.71 //y=3.14 //x2=2.71 //y2=3.51
r112 (  2 3 ) resistor r=25.3262 //w=0.187 //l=0.37 //layer=li //thickness=0.1 \
 //x=2.71 //y=2.77 //x2=2.71 //y2=3.14
r113 (  1 2 ) resistor r=25.3262 //w=0.187 //l=0.37 //layer=li //thickness=0.1 \
 //x=2.71 //y=2.4 //x2=2.71 //y2=2.77
r114 (  1 9 ) resistor r=9.58289 //w=0.187 //l=0.14 //layer=li //thickness=0.1 \
 //x=2.71 //y=2.4 //x2=2.71 //y2=2.26
ends PM_NAND3X1\%B

subckt PM_NAND3X1\%noxref_5 ( 1 5 9 13 17 35 )
c41 ( 35 0 ) capacitor c=0.0747858f //x=0.945 //y=0.555
c42 ( 17 0 ) capacitor c=0.0266691f //x=2.935 //y=1.77
c43 ( 13 0 ) capacitor c=0.0156939f //x=2.935 //y=0.72
c44 ( 9 0 ) capacitor c=0.00678203f //x=2.05 //y=0.805
c45 ( 5 0 ) capacitor c=0.0236189f //x=1.965 //y=1.77
c46 ( 1 0 ) capacitor c=0.0109947f //x=1.08 //y=1.685
r47 (  18 35 ) resistor r=5.4201 //w=0.17 //l=0.103078 //layer=li \
 //thickness=0.1 //x=2.135 //y=1.77 //x2=2.05 //y2=1.81
r48 (  18 35 ) resistor r=27.3797 //w=0.187 //l=0.4 //layer=li //thickness=0.1 \
 //x=2.135 //y=1.77 //x2=2.535 //y2=1.77
r49 (  17 35 ) resistor r=0.751729 //w=0.17 //l=0.085 //layer=li \
 //thickness=0.1 //x=2.935 //y=1.77 //x2=3.02 //y2=1.77
r50 (  17 35 ) resistor r=27.3797 //w=0.187 //l=0.4 //layer=li //thickness=0.1 \
 //x=2.935 //y=1.77 //x2=2.535 //y2=1.77
r51 (  14 35 ) resistor r=3.57586 //w=0.17 //l=0.103078 //layer=li \
 //thickness=0.1 //x=2.135 //y=0.72 //x2=2.05 //y2=0.68
r52 (  14 35 ) resistor r=27.3797 //w=0.187 //l=0.4 //layer=li //thickness=0.1 \
 //x=2.135 //y=0.72 //x2=2.535 //y2=0.72
r53 (  13 35 ) resistor r=0.751729 //w=0.17 //l=0.085 //layer=li \
 //thickness=0.1 //x=2.935 //y=0.72 //x2=3.02 //y2=0.72
r54 (  13 35 ) resistor r=27.3797 //w=0.187 //l=0.4 //layer=li //thickness=0.1 \
 //x=2.935 //y=0.72 //x2=2.535 //y2=0.72
r55 (  10 35 ) resistor r=1.40859 //w=0.34 //l=0.125 //layer=li \
 //thickness=0.1 //x=2.05 //y=1.685 //x2=2.05 //y2=1.81
r56 (  10 35 ) resistor r=42.0963 //w=0.187 //l=0.615 //layer=li \
 //thickness=0.1 //x=2.05 //y=1.685 //x2=2.05 //y2=1.07
r57 (  9 35 ) resistor r=3.57586 //w=0.17 //l=0.125 //layer=li //thickness=0.1 \
 //x=2.05 //y=0.805 //x2=2.05 //y2=0.68
r58 (  9 35 ) resistor r=18.139 //w=0.187 //l=0.265 //layer=li //thickness=0.1 \
 //x=2.05 //y=0.805 //x2=2.05 //y2=1.07
r59 (  6 35 ) resistor r=3.57586 //w=0.17 //l=0.103078 //layer=li \
 //thickness=0.1 //x=1.165 //y=1.77 //x2=1.08 //y2=1.81
r60 (  6 35 ) resistor r=27.3797 //w=0.187 //l=0.4 //layer=li //thickness=0.1 \
 //x=1.165 //y=1.77 //x2=1.565 //y2=1.77
r61 (  5 35 ) resistor r=5.4201 //w=0.17 //l=0.103078 //layer=li \
 //thickness=0.1 //x=1.965 //y=1.77 //x2=2.05 //y2=1.81
r62 (  5 35 ) resistor r=27.3797 //w=0.187 //l=0.4 //layer=li //thickness=0.1 \
 //x=1.965 //y=1.77 //x2=1.565 //y2=1.77
r63 (  1 35 ) resistor r=3.57586 //w=0.17 //l=0.125 //layer=li //thickness=0.1 \
 //x=1.08 //y=1.685 //x2=1.08 //y2=1.81
r64 (  1 35 ) resistor r=42.0963 //w=0.187 //l=0.615 //layer=li \
 //thickness=0.1 //x=1.08 //y=1.685 //x2=1.08 //y2=1.07
ends PM_NAND3X1\%noxref_5

subckt PM_NAND3X1\%C ( 1 2 3 4 5 6 7 9 21 22 23 27 28 29 34 36 39 40 42 43 48 )
c52 ( 48 0 ) capacitor c=0.0672371f //x=3.82 //y=4.88
c53 ( 43 0 ) capacitor c=0.0273931f //x=3.82 //y=2.095
c54 ( 42 0 ) capacitor c=0.0471168f //x=3.82 //y=2.26
c55 ( 40 0 ) capacitor c=0.0432517f //x=4.34 //y=1.44
c56 ( 39 0 ) capacitor c=0.0200379f //x=4.34 //y=1.095
c57 ( 36 0 ) capacitor c=0.0158629f //x=4.185 //y=1.595
c58 ( 34 0 ) capacitor c=0.0157803f //x=4.185 //y=0.94
c59 ( 29 0 ) capacitor c=0.0218028f //x=3.81 //y=1.75
c60 ( 28 0 ) capacitor c=0.0207459f //x=3.81 //y=1.44
c61 ( 27 0 ) capacitor c=0.0194308f //x=3.81 //y=1.095
c62 ( 23 0 ) capacitor c=0.158794f //x=4 //y=6.2
c63 ( 22 0 ) capacitor c=0.110114f //x=3.56 //y=6.2
c64 ( 9 0 ) capacitor c=0.096694f //x=3.82 //y=2.26
r65 (  42 43 ) resistor r=52.7279 //w=0.214 //l=0.165 //layer=ply \
 //thickness=0.18 //x=3.82 //y=2.26 //x2=3.82 //y2=2.095
r66 (  40 50 ) resistor r=45.1352 //w=0.168 //l=0.173853 //layer=ply \
 //thickness=0.18 //x=4.34 //y=1.44 //x2=4.3 //y2=1.595
r67 (  39 49 ) resistor r=45.1352 //w=0.168 //l=0.173853 //layer=ply \
 //thickness=0.18 //x=4.34 //y=1.095 //x2=4.3 //y2=0.94
r68 (  39 40 ) resistor r=176.904 //w=0.094 //l=0.345 //layer=ply \
 //thickness=0.18 //x=4.34 //y=1.095 //x2=4.34 //y2=1.44
r69 (  37 46 ) resistor r=10.701 //w=0.21 //l=0.115 //layer=ply \
 //thickness=0.18 //x=3.965 //y=1.595 //x2=3.85 //y2=1.595
r70 (  36 50 ) resistor r=5.52526 //w=0.168 //l=0.115 //layer=ply \
 //thickness=0.18 //x=4.185 //y=1.595 //x2=4.3 //y2=1.595
r71 (  35 45 ) resistor r=5.52526 //w=0.168 //l=0.115 //layer=ply \
 //thickness=0.18 //x=3.965 //y=0.94 //x2=3.85 //y2=0.94
r72 (  34 49 ) resistor r=5.52526 //w=0.168 //l=0.115 //layer=ply \
 //thickness=0.18 //x=4.185 //y=0.94 //x2=4.3 //y2=0.94
r73 (  34 35 ) resistor r=112.809 //w=0.094 //l=0.22 //layer=ply \
 //thickness=0.18 //x=4.185 //y=0.94 //x2=3.965 //y2=0.94
r74 (  31 48 ) resistor r=37.236 //w=0.233 //l=0.249199 //layer=ply \
 //thickness=0.18 //x=4 //y=5.045 //x2=3.82 //y2=4.88
r75 (  29 46 ) resistor r=39.5823 //w=0.21 //l=0.173853 //layer=ply \
 //thickness=0.18 //x=3.81 //y=1.75 //x2=3.85 //y2=1.595
r76 (  29 43 ) resistor r=176.904 //w=0.094 //l=0.345 //layer=ply \
 //thickness=0.18 //x=3.81 //y=1.75 //x2=3.81 //y2=2.095
r77 (  28 46 ) resistor r=39.5823 //w=0.21 //l=0.173853 //layer=ply \
 //thickness=0.18 //x=3.81 //y=1.44 //x2=3.85 //y2=1.595
r78 (  27 45 ) resistor r=45.1352 //w=0.168 //l=0.173853 //layer=ply \
 //thickness=0.18 //x=3.81 //y=1.095 //x2=3.85 //y2=0.94
r79 (  27 28 ) resistor r=176.904 //w=0.094 //l=0.345 //layer=ply \
 //thickness=0.18 //x=3.81 //y=1.095 //x2=3.81 //y2=1.44
r80 (  24 48 ) resistor r=53.7854 //w=0.233 //l=0.332415 //layer=ply \
 //thickness=0.18 //x=3.56 //y=5.045 //x2=3.82 //y2=4.88
r81 (  23 31 ) resistor r=592.245 //w=0.094 //l=1.155 //layer=ply \
 //thickness=0.18 //x=4 //y=6.2 //x2=4 //y2=5.045
r82 (  22 24 ) resistor r=592.245 //w=0.094 //l=1.155 //layer=ply \
 //thickness=0.18 //x=3.56 //y=6.2 //x2=3.56 //y2=5.045
r83 (  21 36 ) resistor r=56.4043 //w=0.094 //l=0.11 //layer=ply \
 //thickness=0.18 //x=4.075 //y=1.595 //x2=4.185 //y2=1.595
r84 (  21 37 ) resistor r=56.4043 //w=0.094 //l=0.11 //layer=ply \
 //thickness=0.18 //x=4.075 //y=1.595 //x2=3.965 //y2=1.595
r85 (  19 48 ) resistor r=152 //w=0.17 //l=0.17 //layer=licon //count=1 \
 //x=3.82 //y=4.88 //x2=3.82 //y2=4.88
r86 (  9 42 ) resistor r=152 //w=0.17 //l=0.17 //layer=licon //count=1 \
 //x=3.82 //y=2.26 //x2=3.82 //y2=2.26
r87 (  7 19 ) resistor r=17.7968 //w=0.187 //l=0.26 //layer=li //thickness=0.1 \
 //x=3.82 //y=4.62 //x2=3.82 //y2=4.88
r88 (  6 7 ) resistor r=25.3262 //w=0.187 //l=0.37 //layer=li //thickness=0.1 \
 //x=3.82 //y=4.25 //x2=3.82 //y2=4.62
r89 (  5 6 ) resistor r=25.3262 //w=0.187 //l=0.37 //layer=li //thickness=0.1 \
 //x=3.82 //y=3.88 //x2=3.82 //y2=4.25
r90 (  4 5 ) resistor r=25.3262 //w=0.187 //l=0.37 //layer=li //thickness=0.1 \
 //x=3.82 //y=3.51 //x2=3.82 //y2=3.88
r91 (  3 4 ) resistor r=25.3262 //w=0.187 //l=0.37 //layer=li //thickness=0.1 \
 //x=3.82 //y=3.14 //x2=3.82 //y2=3.51
r92 (  2 3 ) resistor r=25.3262 //w=0.187 //l=0.37 //layer=li //thickness=0.1 \
 //x=3.82 //y=2.77 //x2=3.82 //y2=3.14
r93 (  1 2 ) resistor r=25.3262 //w=0.187 //l=0.37 //layer=li //thickness=0.1 \
 //x=3.82 //y=2.4 //x2=3.82 //y2=2.77
r94 (  1 9 ) resistor r=9.58289 //w=0.187 //l=0.14 //layer=li //thickness=0.1 \
 //x=3.82 //y=2.4 //x2=3.82 //y2=2.26
ends PM_NAND3X1\%C

subckt PM_NAND3X1\%Y ( 1 2 3 4 5 6 7 8 15 16 23 31 37 38 49 50 51 53 54 55 )
c69 ( 55 0 ) capacitor c=0.023087f //x=3.635 //y=5.2
c70 ( 54 0 ) capacitor c=0.023519f //x=2.755 //y=5.2
c71 ( 53 0 ) capacitor c=0.0224735f //x=1.875 //y=5.2
c72 ( 51 0 ) capacitor c=0.00853354f //x=3.885 //y=1.095
c73 ( 50 0 ) capacitor c=0.0019954f //x=3.78 //y=5.335
c74 ( 49 0 ) capacitor c=0.00424403f //x=2.9 //y=5.335
c75 ( 38 0 ) capacitor c=0.00777616f //x=4.16 //y=1.845
c76 ( 37 0 ) capacitor c=0.0191287f //x=4.475 //y=1.845
c77 ( 31 0 ) capacitor c=0.0371522f //x=4.475 //y=5.335
c78 ( 23 0 ) capacitor c=0.0266604f //x=3.695 //y=5.335
c79 ( 16 0 ) capacitor c=0.00549987f //x=2.105 //y=5.335
c80 ( 15 0 ) capacitor c=0.0226675f //x=2.815 //y=5.335
c81 ( 1 0 ) capacitor c=0.135127f //x=4.56 //y=2.4
r82 (  37 39 ) resistor r=7.15173 //w=0.17 //l=0.120208 //layer=li \
 //thickness=0.1 //x=4.475 //y=1.845 //x2=4.56 //y2=1.93
r83 (  37 38 ) resistor r=21.5615 //w=0.187 //l=0.315 //layer=li \
 //thickness=0.1 //x=4.475 //y=1.845 //x2=4.16 //y2=1.845
r84 (  33 38 ) resistor r=7.15173 //w=0.17 //l=0.120208 //layer=li \
 //thickness=0.1 //x=4.075 //y=1.76 //x2=4.16 //y2=1.845
r85 (  33 51 ) resistor r=39.016 //w=0.187 //l=0.57 //layer=li //thickness=0.1 \
 //x=4.075 //y=1.76 //x2=4.075 //y2=1.19
r86 (  32 50 ) resistor r=5.4201 //w=0.17 //l=0.085 //layer=li //thickness=0.1 \
 //x=3.865 //y=5.335 //x2=3.78 //y2=5.335
r87 (  31 40 ) resistor r=7.15173 //w=0.17 //l=0.120208 //layer=li \
 //thickness=0.1 //x=4.475 //y=5.335 //x2=4.56 //y2=5.25
r88 (  31 32 ) resistor r=41.754 //w=0.187 //l=0.61 //layer=li //thickness=0.1 \
 //x=4.475 //y=5.335 //x2=3.865 //y2=5.335
r89 (  25 50 ) resistor r=1.40859 //w=0.34 //l=0.085 //layer=li \
 //thickness=0.1 //x=3.78 //y=5.42 //x2=3.78 //y2=5.335
r90 (  25 55 ) resistor r=33.1979 //w=0.187 //l=0.485 //layer=li \
 //thickness=0.1 //x=3.78 //y=5.42 //x2=3.78 //y2=5.905
r91 (  24 49 ) resistor r=5.4201 //w=0.17 //l=0.085 //layer=li //thickness=0.1 \
 //x=2.985 //y=5.335 //x2=2.9 //y2=5.335
r92 (  23 50 ) resistor r=5.4201 //w=0.17 //l=0.085 //layer=li //thickness=0.1 \
 //x=3.695 //y=5.335 //x2=3.78 //y2=5.335
r93 (  23 24 ) resistor r=48.5989 //w=0.187 //l=0.71 //layer=li \
 //thickness=0.1 //x=3.695 //y=5.335 //x2=2.985 //y2=5.335
r94 (  17 49 ) resistor r=1.40859 //w=0.34 //l=0.085 //layer=li \
 //thickness=0.1 //x=2.9 //y=5.42 //x2=2.9 //y2=5.335
r95 (  17 54 ) resistor r=33.1979 //w=0.187 //l=0.485 //layer=li \
 //thickness=0.1 //x=2.9 //y=5.42 //x2=2.9 //y2=5.905
r96 (  15 49 ) resistor r=5.4201 //w=0.17 //l=0.085 //layer=li //thickness=0.1 \
 //x=2.815 //y=5.335 //x2=2.9 //y2=5.335
r97 (  15 16 ) resistor r=48.5989 //w=0.187 //l=0.71 //layer=li \
 //thickness=0.1 //x=2.815 //y=5.335 //x2=2.105 //y2=5.335
r98 (  9 16 ) resistor r=7.15173 //w=0.17 //l=0.120208 //layer=li \
 //thickness=0.1 //x=2.02 //y=5.42 //x2=2.105 //y2=5.335
r99 (  9 53 ) resistor r=33.1979 //w=0.187 //l=0.485 //layer=li \
 //thickness=0.1 //x=2.02 //y=5.42 //x2=2.02 //y2=5.905
r100 (  8 40 ) resistor r=17.7968 //w=0.187 //l=0.26 //layer=li \
 //thickness=0.1 //x=4.56 //y=4.99 //x2=4.56 //y2=5.25
r101 (  7 8 ) resistor r=25.3262 //w=0.187 //l=0.37 //layer=li //thickness=0.1 \
 //x=4.56 //y=4.62 //x2=4.56 //y2=4.99
r102 (  6 7 ) resistor r=25.3262 //w=0.187 //l=0.37 //layer=li //thickness=0.1 \
 //x=4.56 //y=4.25 //x2=4.56 //y2=4.62
r103 (  5 6 ) resistor r=25.3262 //w=0.187 //l=0.37 //layer=li //thickness=0.1 \
 //x=4.56 //y=3.88 //x2=4.56 //y2=4.25
r104 (  4 5 ) resistor r=25.3262 //w=0.187 //l=0.37 //layer=li //thickness=0.1 \
 //x=4.56 //y=3.51 //x2=4.56 //y2=3.88
r105 (  3 4 ) resistor r=25.3262 //w=0.187 //l=0.37 //layer=li //thickness=0.1 \
 //x=4.56 //y=3.14 //x2=4.56 //y2=3.51
r106 (  2 3 ) resistor r=25.3262 //w=0.187 //l=0.37 //layer=li //thickness=0.1 \
 //x=4.56 //y=2.77 //x2=4.56 //y2=3.14
r107 (  1 2 ) resistor r=25.3262 //w=0.187 //l=0.37 //layer=li //thickness=0.1 \
 //x=4.56 //y=2.4 //x2=4.56 //y2=2.77
r108 (  1 39 ) resistor r=32.1711 //w=0.187 //l=0.47 //layer=li \
 //thickness=0.1 //x=4.56 //y=2.4 //x2=4.56 //y2=1.93
ends PM_NAND3X1\%Y

subckt PM_NAND3X1\%noxref_8 ( 1 3 11 15 25 28 29 )
c47 ( 29 0 ) capacitor c=0.0457566f //x=3.455 //y=0.555
c48 ( 28 0 ) capacitor c=0.00467097f //x=2.35 //y=1.09
c49 ( 25 0 ) capacitor c=0.00156479f //x=3.59 //y=1.175
c50 ( 15 0 ) capacitor c=0.00737666f //x=4.56 //y=0.805
c51 ( 11 0 ) capacitor c=0.0152902f //x=4.475 //y=0.72
c52 ( 3 0 ) capacitor c=0.00718386f //x=3.59 //y=0.805
c53 ( 1 0 ) capacitor c=0.0279585f //x=3.505 //y=1.175
r54 (  15 29 ) resistor r=3.57586 //w=0.17 //l=0.125 //layer=li \
 //thickness=0.1 //x=4.56 //y=0.805 //x2=4.56 //y2=0.68
r55 (  15 29 ) resistor r=18.139 //w=0.187 //l=0.265 //layer=li \
 //thickness=0.1 //x=4.56 //y=0.805 //x2=4.56 //y2=1.07
r56 (  12 29 ) resistor r=3.57586 //w=0.17 //l=0.103078 //layer=li \
 //thickness=0.1 //x=3.675 //y=0.72 //x2=3.59 //y2=0.68
r57 (  12 29 ) resistor r=27.3797 //w=0.187 //l=0.4 //layer=li //thickness=0.1 \
 //x=3.675 //y=0.72 //x2=4.075 //y2=0.72
r58 (  11 29 ) resistor r=3.57586 //w=0.17 //l=0.103078 //layer=li \
 //thickness=0.1 //x=4.475 //y=0.72 //x2=4.56 //y2=0.68
r59 (  11 29 ) resistor r=27.3797 //w=0.187 //l=0.4 //layer=li //thickness=0.1 \
 //x=4.475 //y=0.72 //x2=4.075 //y2=0.72
r60 (  7 25 ) resistor r=5.4201 //w=0.17 //l=0.085 //layer=li //thickness=0.1 \
 //x=3.59 //y=1.26 //x2=3.59 //y2=1.175
r61 (  7 29 ) resistor r=10.2674 //w=0.187 //l=0.15 //layer=li //thickness=0.1 \
 //x=3.59 //y=1.26 //x2=3.59 //y2=1.41
r62 (  4 25 ) resistor r=5.4201 //w=0.17 //l=0.085 //layer=li //thickness=0.1 \
 //x=3.59 //y=1.09 //x2=3.59 //y2=1.175
r63 (  4 29 ) resistor r=1.36898 //w=0.187 //l=0.02 //layer=li //thickness=0.1 \
 //x=3.59 //y=1.09 //x2=3.59 //y2=1.07
r64 (  3 29 ) resistor r=3.57586 //w=0.17 //l=0.125 //layer=li //thickness=0.1 \
 //x=3.59 //y=0.805 //x2=3.59 //y2=0.68
r65 (  3 29 ) resistor r=18.139 //w=0.187 //l=0.265 //layer=li //thickness=0.1 \
 //x=3.59 //y=0.805 //x2=3.59 //y2=1.07
r66 (  2 28 ) resistor r=0.751729 //w=0.17 //l=0.085 //layer=li \
 //thickness=0.1 //x=2.625 //y=1.175 //x2=2.54 //y2=1.175
r67 (  1 25 ) resistor r=1.40859 //w=0.34 //l=0.085 //layer=li //thickness=0.1 \
 //x=3.505 //y=1.175 //x2=3.59 //y2=1.175
r68 (  1 2 ) resistor r=60.2353 //w=0.187 //l=0.88 //layer=li //thickness=0.1 \
 //x=3.505 //y=1.175 //x2=2.625 //y2=1.175
ends PM_NAND3X1\%noxref_8
