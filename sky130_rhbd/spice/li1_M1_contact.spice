* HSPICE file created from li1_M1_contact.ext - technology: sky130A

.option scale=5m

.subckt li1_M1_contact
.ends

** hspice subcircuit dictionary
