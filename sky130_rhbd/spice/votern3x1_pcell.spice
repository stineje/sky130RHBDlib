* HSPICE file created from votern3x1_pcell.ext - technology: sky130A

.option scale=5m

.subckt votern3x1_pcell
X0 x1/VSUBS a_834_375 x2/a_0_0 x1/VSUBS sky130_fd_pr__nfet_01v8 ad=2.39n pd=0.111m as=15.7n ps=0.599m w=602 l=30
X3 x1/VSUBS a_834_375 x4/a_0_0 x1/VSUBS sky130_fd_pr__nfet_01v8 ad=43n pd=2.68m as=77.2n ps=2.61m w=602 l=30
X5 x1/VSUBS a_1507_944 x6/a_0_0 x1/VSUBS sky130_fd_pr__nfet_01v8 ad=0 pd=0 as=77.2n ps=2.61m w=602 l=30
X7 a_805_1331 a_834_375 w_34_1446 w_34_1446 sky130_fd_pr__pfet_01v8 ad=11.6n pd=0.458m as=22.4n ps=0.912m w=400 l=30
X8 w_34_1446 a_834_375 a_805_1331 w_34_1446 sky130_fd_pr__pfet_01v8 ad=21.6n pd=0.908m as=11.6n ps=0.458m w=400 l=30
X9 a_1561_1059 a_1507_944 x4/a_0_0 x1/VSUBS sky130_fd_pr__nfet_01v8 ad=2.39n pd=0.111m as=15.8n ps=0.594m w=602 l=30
X10 a_805_1331 a_362_381 w_34_1446 w_34_1446 sky130_fd_pr__pfet_01v8 ad=0.114u pd=4.57m as=67.2n ps=2.74m w=400 l=30
X11 w_34_1446 a_362_381 a_805_1331 w_34_1446 sky130_fd_pr__pfet_01v8 ad=0 pd=0 as=0 ps=0 w=400 l=30
X12 x13/a_174_n399 a_1507_944 a_805_1331 w_34_1446 sky130_fd_pr__pfet_01v8 ad=23.2n pd=0.916m as=0 ps=0 w=400 l=30
X14 a_805_1331 a_1507_944 x13/a_174_n399 w_34_1446 sky130_fd_pr__pfet_01v8 ad=0 pd=0 as=0 ps=0 w=400 l=30
X15 a_893_1059 a_834_375 a_805_1331 w_34_1446 sky130_fd_pr__pfet_01v8 ad=90.4n pd=3.65m as=0 ps=0 w=400 l=30
X16 a_805_1331 a_834_375 a_893_1059 w_34_1446 sky130_fd_pr__pfet_01v8 ad=0 pd=0 as=0 ps=0 w=400 l=30
X17 a_1561_1059 a_1507_944 a_893_1059 w_34_1446 sky130_fd_pr__pfet_01v8 ad=46.4n pd=1.83m as=0 ps=0 w=400 l=30
X18 a_893_1059 a_1507_944 a_1561_1059 w_34_1446 sky130_fd_pr__pfet_01v8 ad=0 pd=0 as=0 ps=0 w=400 l=30
X19 a_1561_1059 a_362_381 a_893_1059 w_34_1446 sky130_fd_pr__pfet_01v8 ad=0 pd=0 as=0 ps=0 w=400 l=30
X20 a_893_1059 a_362_381 a_1561_1059 w_34_1446 sky130_fd_pr__pfet_01v8 ad=0 pd=0 as=0 ps=0 w=400 l=30
X21 a_1561_1059 a_362_381 x2/a_0_0 x1/VSUBS sky130_fd_pr__nfet_01v8 ad=2.39n pd=0.111m as=15.6n ps=0.592m w=602 l=30
X22 a_1561_1059 a_362_381 x6/a_0_0 x1/VSUBS sky130_fd_pr__nfet_01v8 ad=2.4n pd=0.112m as=15.8n ps=0.594m w=602 l=30
.ends

** hspice subcircuit dictionary
* x1	pmos2_1_5
* x2	nmos_top_0
* x4	nmos_bottom_1
* x6	nmos_bottom_2
* x13	pmos2_1_2
