* HSPICE file created from bufx1.ext - technology: sky130A

.option scale=5m

.subckt bufx1
X0 m1_264_487 x1/a_155_381 VSUBS VSUBS sky130_fd_pr__nfet_01v8 ad=2.39n pd=0.111m as=15.6n ps=0.592m w=602 l=30
X2 x3/w_n87_786 x1/a_155_381 m1_264_487 x3/w_n87_786 sky130_fd_pr__pfet_01v8 ad=21.6n pd=0.908m as=11.6n ps=0.458m w=400 l=30
X4 m1_264_487 x1/a_155_381 x3/w_n87_786 x3/w_n87_786 sky130_fd_pr__pfet_01v8 ad=11.6n pd=0.458m as=22.4n ps=0.912m w=400 l=30
X5 x3/a_206_1059 m1_264_487 VSUBS VSUBS sky130_fd_pr__nfet_01v8 ad=7.16n pd=0.314m as=91.3n ps=3.24m w=602 l=30
X6 x3/w_n87_786 m1_264_487 x3/a_206_1059 x3/w_n87_786 sky130_fd_pr__pfet_01v8 ad=88n pd=3.64m as=23.2n ps=0.917m w=400 l=30
X7 x3/a_206_1059 m1_264_487 x3/w_n87_786 x3/w_n87_786 sky130_fd_pr__pfet_01v8 ad=0 pd=0 as=0 ps=0 w=400 l=30
.ends

** hspice subcircuit dictionary
* x1	invx1_pcell_0
* x3	invx1_pcell_1
