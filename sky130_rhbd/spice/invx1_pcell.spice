* HSPICE file created from invx1_pcell.ext - technology: sky130A

.option scale=5m

.subckt invx1_pcell
X0 a_206_1059 a_155_381 x1/VSUBS x1/VSUBS sky130_fd_pr__nfet_01v8 ad=2.39n pd=0.111m as=15.6n ps=0.592m w=602 l=30
X2 w_n87_786 a_155_381 a_206_1059 w_n87_786 sky130_fd_pr__pfet_01v8 ad=21.6n pd=0.908m as=11.6n ps=0.458m w=400 l=30
X3 a_206_1059 a_155_381 w_n87_786 w_n87_786 sky130_fd_pr__pfet_01v8 ad=11.6n pd=0.458m as=22.4n ps=0.912m w=400 l=30
.ends

** hspice subcircuit dictionary
* x1	pmos2_0
