* HSPICE file created from pmos2_1.ext - technology: sky130A

.option scale=5m

.subckt pmos2_1
X0 a_174_n399 a_144_n460 a_88_n399 w_52_n435 sky130_fd_pr__pfet_01v8 ad=11.6n pd=0.458m as=22.4n ps=0.912m w=400 l=30
X1 a_262_n399 a_144_n460 a_174_n399 w_52_n435 sky130_fd_pr__pfet_01v8 ad=21.6n pd=0.908m as=11.6n ps=0.458m w=400 l=30
.ends

** hspice subcircuit dictionary
