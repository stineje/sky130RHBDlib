* HSPICE file created from FA.ext - technology: sky130A

.option scale=5m

.subckt FA SUM COUT A B CIN VDD GND
X0 COUT m1_7244_671 x1/VSUBS x1/VSUBS sky130_fd_pr__nfet_01v8 ad=2.39n pd=0.111m as=15.6n ps=0.592m w=602 l=30
X2 VDD m1_7244_671 COUT VDD sky130_fd_pr__pfet_01v8 ad=21.6n pd=0.908m as=11.6n ps=0.458m w=400 l=30
X3 COUT m1_7244_671 VDD VDD sky130_fd_pr__pfet_01v8 ad=11.6n pd=0.458m as=22.4n ps=0.912m w=400 l=30
X4 VDD m1_5468_598 x5/a_317_1331 VDD sky130_fd_pr__pfet_01v8 ad=11.6n pd=0.458m as=22.4n ps=0.912m w=400 l=30
X6 x5/a_317_1331 m1_5468_598 VDD VDD sky130_fd_pr__pfet_01v8 ad=21.6n pd=0.908m as=11.6n ps=0.458m w=400 l=30
X7 m1_7244_671 m1_6577_670 x5/a_317_1331 VDD sky130_fd_pr__pfet_01v8 ad=23.2n pd=0.917m as=67.2n ps=2.74m w=400 l=30
X8 x5/a_317_1331 m1_6577_670 m1_7244_671 VDD sky130_fd_pr__pfet_01v8 ad=0 pd=0 as=0 ps=0 w=400 l=30
X9 m1_7244_671 m1_5468_598 x1/VSUBS x1/VSUBS sky130_fd_pr__nfet_01v8 ad=2.39n pd=0.111m as=15.8n ps=0.594m w=602 l=30
X10 m1_7244_671 m1_6577_670 x1/VSUBS x1/VSUBS sky130_fd_pr__nfet_01v8 ad=2.4n pd=0.112m as=15.8n ps=0.594m w=602 l=30
X11 GND A x12/a_0_0 GND sky130_fd_pr__nfet_01v8 ad=2.39n pd=0.111m as=15.7n ps=0.599m w=602 l=30
X13 GND x14/li_871_923 x15/a_0_0 GND sky130_fd_pr__nfet_01v8 ad=60n pd=2.25m as=77.2n ps=2.61m w=602 l=30
X16 VDD A x14/a_761_1330 VDD sky130_fd_pr__pfet_01v8 ad=0.558u pd=0.0228 as=67.2n ps=2.74m w=400 l=30
X17 x14/a_761_1330 A VDD VDD sky130_fd_pr__pfet_01v8 ad=0 pd=0 as=0 ps=0 w=400 l=30
X18 m1_2435_720 x14/a_1472_383 x15/a_0_0 GND sky130_fd_pr__nfet_01v8 ad=28.7n pd=1.78m as=0 ps=0 w=602 l=30
X19 m1_2435_720 B x12/a_0_0 GND sky130_fd_pr__nfet_01v8 ad=0 pd=0 as=77.2n ps=2.61m w=602 l=30
X20 m1_2435_720 x14/li_871_923 x14/a_761_1330 VDD sky130_fd_pr__pfet_01v8 ad=92.8n pd=3.66m as=0 ps=0 w=400 l=30
X21 x14/a_761_1330 x14/li_871_923 m1_2435_720 VDD sky130_fd_pr__pfet_01v8 ad=0 pd=0 as=0 ps=0 w=400 l=30
X22 VDD B x14/a_1427_1330 VDD sky130_fd_pr__pfet_01v8 ad=0 pd=0 as=67.2n ps=2.74m w=400 l=30
X23 x14/a_1427_1330 B VDD VDD sky130_fd_pr__pfet_01v8 ad=0 pd=0 as=0 ps=0 w=400 l=30
X24 m1_2435_720 x14/a_1472_383 x14/a_1427_1330 VDD sky130_fd_pr__pfet_01v8 ad=0 pd=0 as=0 ps=0 w=400 l=30
X25 x14/a_1427_1330 x14/a_1472_383 m1_2435_720 VDD sky130_fd_pr__pfet_01v8 ad=0 pd=0 as=0 ps=0 w=400 l=30
X26 x14/a_1472_383 A GND GND sky130_fd_pr__nfet_01v8 ad=7.16n pd=0.314m as=0 ps=0 w=602 l=30
X27 VDD A x14/a_1472_383 VDD sky130_fd_pr__pfet_01v8 ad=0 pd=0 as=23.2n ps=0.917m w=400 l=30
X28 x14/a_1472_383 A VDD VDD sky130_fd_pr__pfet_01v8 ad=0 pd=0 as=0 ps=0 w=400 l=30
X29 x14/li_871_923 B x30/VSUBS x30/VSUBS sky130_fd_pr__nfet_01v8 ad=7.16n pd=0.314m as=60n ps=2.78m w=602 l=30
X31 VDD B x14/li_871_923 VDD sky130_fd_pr__pfet_01v8 ad=0 pd=0 as=46.4n ps=1.83m w=400 l=30
X32 x14/li_871_923 B VDD VDD sky130_fd_pr__pfet_01v8 ad=0 pd=0 as=0 ps=0 w=400 l=30
X33 m1_5468_598 x34/m1_486_634 x1/VSUBS x1/VSUBS sky130_fd_pr__nfet_01v8 ad=7.16n pd=0.434m as=0.183u ps=6.54m w=602 l=30
X35 VDD x34/m1_486_634 m1_5468_598 VDD sky130_fd_pr__pfet_01v8 ad=0 pd=0 as=23.2n ps=0.917m w=400 l=30
X36 m1_5468_598 x34/m1_486_634 VDD VDD sky130_fd_pr__pfet_01v8 ad=0 pd=0 as=0 ps=0 w=400 l=30
X37 x1/VSUBS CIN x38/a_0_0 x1/VSUBS sky130_fd_pr__nfet_01v8 ad=0 pd=0 as=77.2n ps=2.61m w=602 l=30
X39 x34/m1_486_634 m1_2435_720 x38/a_0_0 x1/VSUBS sky130_fd_pr__nfet_01v8 ad=7.16n pd=0.314m as=0 ps=0 w=602 l=30
X40 VDD CIN x34/m1_486_634 VDD sky130_fd_pr__pfet_01v8 ad=0 pd=0 as=46.4n ps=1.83m w=400 l=30
X41 x34/m1_486_634 CIN VDD VDD sky130_fd_pr__pfet_01v8 ad=0 pd=0 as=0 ps=0 w=400 l=30
X42 VDD m1_2435_720 x34/m1_486_634 VDD sky130_fd_pr__pfet_01v8 ad=0 pd=0 as=0 ps=0 w=400 l=30
X43 x34/m1_486_634 m1_2435_720 VDD VDD sky130_fd_pr__pfet_01v8 ad=0 pd=0 as=0 ps=0 w=400 l=30
X44 x45/VSUBS m1_2435_720 x46/a_0_0 x45/VSUBS sky130_fd_pr__nfet_01v8 ad=0.12u pd=4.58m as=77.2n ps=2.61m w=602 l=30
X47 x45/VSUBS x48/li_871_923 x49/a_0_0 x45/VSUBS sky130_fd_pr__nfet_01v8 ad=0 pd=0 as=77.2n ps=2.61m w=602 l=30
X50 VDD m1_2435_720 x48/a_761_1330 VDD sky130_fd_pr__pfet_01v8 ad=0 pd=0 as=67.2n ps=2.74m w=400 l=30
X51 x48/a_761_1330 m1_2435_720 VDD VDD sky130_fd_pr__pfet_01v8 ad=0 pd=0 as=0 ps=0 w=400 l=30
X52 SUM x48/a_1472_383 x49/a_0_0 x45/VSUBS sky130_fd_pr__nfet_01v8 ad=35.8n pd=2.71m as=0 ps=0 w=602 l=30
X53 SUM CIN x46/a_0_0 x45/VSUBS sky130_fd_pr__nfet_01v8 ad=0 pd=0 as=0 ps=0 w=602 l=30
X54 SUM x48/li_871_923 x48/a_761_1330 VDD sky130_fd_pr__pfet_01v8 ad=92.8n pd=3.66m as=0 ps=0 w=400 l=30
X55 x48/a_761_1330 x48/li_871_923 SUM VDD sky130_fd_pr__pfet_01v8 ad=0 pd=0 as=0 ps=0 w=400 l=30
X56 VDD CIN x48/a_1427_1330 VDD sky130_fd_pr__pfet_01v8 ad=0 pd=0 as=67.2n ps=2.74m w=400 l=30
X57 x48/a_1427_1330 CIN VDD VDD sky130_fd_pr__pfet_01v8 ad=0 pd=0 as=0 ps=0 w=400 l=30
X58 SUM x48/a_1472_383 x48/a_1427_1330 VDD sky130_fd_pr__pfet_01v8 ad=0 pd=0 as=0 ps=0 w=400 l=30
X59 x48/a_1427_1330 x48/a_1472_383 SUM VDD sky130_fd_pr__pfet_01v8 ad=0 pd=0 as=0 ps=0 w=400 l=30
X60 x48/a_1472_383 m1_2435_720 x45/VSUBS x45/VSUBS sky130_fd_pr__nfet_01v8 ad=7.16n pd=0.314m as=0 ps=0 w=602 l=30
X61 VDD m1_2435_720 x48/a_1472_383 VDD sky130_fd_pr__pfet_01v8 ad=0 pd=0 as=23.2n ps=0.917m w=400 l=30
X62 x48/a_1472_383 m1_2435_720 VDD VDD sky130_fd_pr__pfet_01v8 ad=0 pd=0 as=0 ps=0 w=400 l=30
X63 x48/li_871_923 CIN x64/VSUBS x64/VSUBS sky130_fd_pr__nfet_01v8 ad=7.16n pd=0.314m as=60n ps=2.78m w=602 l=30
X65 VDD CIN x48/li_871_923 VDD sky130_fd_pr__pfet_01v8 ad=0 pd=0 as=46.4n ps=1.83m w=400 l=30
X66 x48/li_871_923 CIN VDD VDD sky130_fd_pr__pfet_01v8 ad=0 pd=0 as=0 ps=0 w=400 l=30
X67 m1_6577_670 x45/m1_486_634 x45/VSUBS x45/VSUBS sky130_fd_pr__nfet_01v8 ad=7.16n pd=0.314m as=0 ps=0 w=602 l=30
X68 VDD x45/m1_486_634 m1_6577_670 VDD sky130_fd_pr__pfet_01v8 ad=0 pd=0 as=23.2n ps=0.917m w=400 l=30
X69 m1_6577_670 x45/m1_486_634 VDD VDD sky130_fd_pr__pfet_01v8 ad=0 pd=0 as=0 ps=0 w=400 l=30
X70 x45/VSUBS B x71/a_0_0 x45/VSUBS sky130_fd_pr__nfet_01v8 ad=0 pd=0 as=77.2n ps=2.61m w=602 l=30
X72 x45/m1_486_634 A x71/a_0_0 x45/VSUBS sky130_fd_pr__nfet_01v8 ad=7.16n pd=0.314m as=0 ps=0 w=602 l=30
X73 VDD B x45/m1_486_634 VDD sky130_fd_pr__pfet_01v8 ad=0 pd=0 as=46.4n ps=1.83m w=400 l=30
X74 x45/m1_486_634 B VDD VDD sky130_fd_pr__pfet_01v8 ad=0 pd=0 as=0 ps=0 w=400 l=30
X75 VDD A x45/m1_486_634 VDD sky130_fd_pr__pfet_01v8 ad=0 pd=0 as=0 ps=0 w=400 l=30
X76 x45/m1_486_634 A VDD VDD sky130_fd_pr__pfet_01v8 ad=0 pd=0 as=0 ps=0 w=400 l=30
C0 CIN x48/li_871_923 2.02f
.ends

** hspice subcircuit dictionary
* x1	or2x1_pcell_0
* x5	or2x1_pcell_0/nor2x1_pcell_0
* x12	xor2X1_pcell_0/nmos_bottom_0
* x14	xor2X1_pcell_0
* x15	xor2X1_pcell_0/nmos_bottom_1
* x30	xor2X1_pcell_0/li1_M1_contact_2
* x34	and2x1_pcell_0
* x38	and2x1_pcell_0/nand2x1_pcell_0/nmos_bottom_0
* x45	and2x1_pcell_1
* x46	xor2X1_pcell_1/nmos_bottom_0
* x48	xor2X1_pcell_1
* x49	xor2X1_pcell_1/nmos_bottom_1
* x64	xor2X1_pcell_1/li1_M1_contact_2
* x71	and2x1_pcell_1/nand2x1_pcell_0/nmos_bottom_0
