* HSPICE file created from nmos_top.ext - technology: sky130A

.option scale=5m

.subckt nmos_top
X0 a_84_92 a_54_62 a_0_0 VSUBS sky130_fd_pr__nfet_01v8 ad=2.39n pd=0.111m as=15.6n ps=0.592m w=602 l=30
.ends

** hspice subcircuit dictionary
