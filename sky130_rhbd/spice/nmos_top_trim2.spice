* HSPICE file created from nmos_top_trim2.ext - technology: sky130A

.option scale=5m

.subckt nmos_top_trim2
X0 a_86_92 a_56_62 a_0_0 VSUBS sky130_fd_pr__nfet_01v8 ad=2.4n pd=0.112m as=15.8n ps=0.594m w=602 l=30
.ends

** hspice subcircuit dictionary
