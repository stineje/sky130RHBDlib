* HSPICE file created from DFFSNRNQNX1.ext - technology: sky130A

.option scale=5m

.subckt DFFSNRNQNX1 QN D CLK SN RN VDD GND
X0 GND D x1/a_0_0 GND sky130_fd_pr__nfet_01v8 ad=2.39n pd=0.111m as=15.7n ps=0.599m w=602 l=30
X2 m1_880_597 m1_732_744 x3/li_393_182 GND sky130_fd_pr__nfet_01v8 ad=2.39n pd=0.111m as=15.8n ps=0.594m w=602 l=30
X4 x3/li_393_182 RN x1/a_0_0 GND sky130_fd_pr__nfet_01v8 ad=2.18n pd=0.106m as=16.2n ps=0.604m w=600 l=30
X5 VDD D m1_880_597 VDD sky130_fd_pr__pfet_01v8 ad=21.6n pd=0.908m as=11.6n ps=0.458m w=400 l=30
X6 m1_880_597 D VDD VDD sky130_fd_pr__pfet_01v8 ad=11.6n pd=0.458m as=22.4n ps=0.912m w=400 l=30
X7 VDD RN m1_880_597 VDD sky130_fd_pr__pfet_01v8 ad=0.542u pd=0.0219 as=69.6n ps=2.75m w=400 l=30
X8 m1_880_597 RN VDD VDD sky130_fd_pr__pfet_01v8 ad=0 pd=0 as=0 ps=0 w=400 l=30
X9 VDD m1_732_744 m1_880_597 VDD sky130_fd_pr__pfet_01v8 ad=0 pd=0 as=0 ps=0 w=400 l=30
X10 m1_880_597 m1_732_744 VDD VDD sky130_fd_pr__pfet_01v8 ad=0 pd=0 as=0 ps=0 w=400 l=30
X11 x12/VSUBS m1_880_597 x13/a_0_0 x12/VSUBS sky130_fd_pr__nfet_01v8 ad=14.3n pd=0.716m as=78.2n ps=2.61m w=602 l=30
X14 m1_732_744 m1_1692_819 x15/li_393_182 x12/VSUBS sky130_fd_pr__nfet_01v8 ad=1p pd=-87u as=52.7n ps=1.92m w=602 l=30
X16 x15/li_393_182 CLK x13/a_0_0 x12/VSUBS sky130_fd_pr__nfet_01v8 ad=0 pd=0 as=0 ps=0 w=600 l=30
X17 VDD m1_880_597 m1_732_744 VDD sky130_fd_pr__pfet_01v8 ad=0 pd=0 as=69.6n ps=2.75m w=400 l=30
X18 m1_732_744 m1_880_597 VDD VDD sky130_fd_pr__pfet_01v8 ad=0 pd=0 as=0 ps=0 w=400 l=30
X19 VDD CLK m1_732_744 VDD sky130_fd_pr__pfet_01v8 ad=0 pd=0 as=0 ps=0 w=400 l=30
X20 m1_732_744 CLK VDD VDD sky130_fd_pr__pfet_01v8 ad=0 pd=0 as=0 ps=0 w=400 l=30
X21 VDD m1_1692_819 m1_732_744 VDD sky130_fd_pr__pfet_01v8 ad=0 pd=0 as=0 ps=0 w=400 l=30
X22 m1_732_744 m1_1692_819 VDD VDD sky130_fd_pr__pfet_01v8 ad=0 pd=0 as=0 ps=0 w=400 l=30
X23 x24/VSUBS m1_880_597 x25/a_0_0 x24/VSUBS sky130_fd_pr__nfet_01v8 ad=28.7n pd=1.43m as=78.2n ps=2.61m w=602 l=30
X26 m1_2803_597 x27/li_649_399 x27/li_393_182 x24/VSUBS sky130_fd_pr__nfet_01v8 ad=1p pd=-87u as=52.7n ps=1.92m w=602 l=30
X28 x27/li_393_182 SN x25/a_0_0 x24/VSUBS sky130_fd_pr__nfet_01v8 ad=0 pd=0 as=0 ps=0 w=600 l=30
X29 VDD m1_880_597 m1_2803_597 VDD sky130_fd_pr__pfet_01v8 ad=0 pd=0 as=69.6n ps=2.75m w=400 l=30
X30 m1_2803_597 m1_880_597 VDD VDD sky130_fd_pr__pfet_01v8 ad=0 pd=0 as=0 ps=0 w=400 l=30
X31 VDD SN m1_2803_597 VDD sky130_fd_pr__pfet_01v8 ad=0 pd=0 as=0 ps=0 w=400 l=30
X32 m1_2803_597 SN VDD VDD sky130_fd_pr__pfet_01v8 ad=0 pd=0 as=0 ps=0 w=400 l=30
X33 VDD x27/li_649_399 m1_2803_597 VDD sky130_fd_pr__pfet_01v8 ad=0 pd=0 as=0 ps=0 w=400 l=30
X34 m1_2803_597 x27/li_649_399 VDD VDD sky130_fd_pr__pfet_01v8 ad=0 pd=0 as=0 ps=0 w=400 l=30
X35 x24/VSUBS m1_2803_597 x36/a_0_0 x24/VSUBS sky130_fd_pr__nfet_01v8 ad=0 pd=0 as=78.2n ps=2.61m w=602 l=30
X37 m1_1692_819 RN x38/li_393_182 x24/VSUBS sky130_fd_pr__nfet_01v8 ad=7.16n pd=0.314m as=52.7n ps=1.92m w=602 l=30
X39 x38/li_393_182 CLK x36/a_0_0 x24/VSUBS sky130_fd_pr__nfet_01v8 ad=0 pd=0 as=0 ps=0 w=600 l=30
X40 VDD m1_2803_597 m1_1692_819 VDD sky130_fd_pr__pfet_01v8 ad=0 pd=0 as=69.6n ps=2.75m w=400 l=30
X41 m1_1692_819 m1_2803_597 VDD VDD sky130_fd_pr__pfet_01v8 ad=0 pd=0 as=0 ps=0 w=400 l=30
X42 VDD CLK m1_1692_819 VDD sky130_fd_pr__pfet_01v8 ad=0 pd=0 as=0 ps=0 w=400 l=30
X43 m1_1692_819 CLK VDD VDD sky130_fd_pr__pfet_01v8 ad=0 pd=0 as=0 ps=0 w=400 l=30
X44 VDD RN m1_1692_819 VDD sky130_fd_pr__pfet_01v8 ad=0 pd=0 as=0 ps=0 w=400 l=30
X45 m1_1692_819 RN VDD VDD sky130_fd_pr__pfet_01v8 ad=0 pd=0 as=0 ps=0 w=400 l=30
X46 x47/VSUBS m1_732_744 x48/a_0_0 x47/VSUBS sky130_fd_pr__nfet_01v8 ad=14.3n pd=0.716m as=78.2n ps=2.61m w=602 l=30
X49 QN m1_4580_745 x50/li_393_182 x47/VSUBS sky130_fd_pr__nfet_01v8 ad=1p pd=-87u as=52.7n ps=1.92m w=602 l=30
X51 x50/li_393_182 RN x48/a_0_0 x47/VSUBS sky130_fd_pr__nfet_01v8 ad=0 pd=0 as=0 ps=0 w=600 l=30
X52 VDD m1_732_744 QN VDD sky130_fd_pr__pfet_01v8 ad=0 pd=0 as=69.6n ps=2.75m w=400 l=30
X53 QN m1_732_744 VDD VDD sky130_fd_pr__pfet_01v8 ad=0 pd=0 as=0 ps=0 w=400 l=30
X54 VDD RN QN VDD sky130_fd_pr__pfet_01v8 ad=0 pd=0 as=0 ps=0 w=400 l=30
X55 QN RN VDD VDD sky130_fd_pr__pfet_01v8 ad=0 pd=0 as=0 ps=0 w=400 l=30
X56 VDD m1_4580_745 QN VDD sky130_fd_pr__pfet_01v8 ad=0 pd=0 as=0 ps=0 w=400 l=30
X57 QN m1_4580_745 VDD VDD sky130_fd_pr__pfet_01v8 ad=0 pd=0 as=0 ps=0 w=400 l=30
X58 x59/VSUBS QN x60/a_0_0 x59/VSUBS sky130_fd_pr__nfet_01v8 ad=14.3n pd=0.716m as=78.2n ps=2.61m w=602 l=30
X61 m1_4580_745 m1_1692_819 x62/li_393_182 x59/VSUBS sky130_fd_pr__nfet_01v8 ad=7.16n pd=0.314m as=52.7n ps=1.92m w=602 l=30
X63 x62/li_393_182 SN x60/a_0_0 x59/VSUBS sky130_fd_pr__nfet_01v8 ad=0 pd=0 as=0 ps=0 w=600 l=30
X64 VDD QN m1_4580_745 VDD sky130_fd_pr__pfet_01v8 ad=0 pd=0 as=69.6n ps=2.75m w=400 l=30
X65 m1_4580_745 QN VDD VDD sky130_fd_pr__pfet_01v8 ad=0 pd=0 as=0 ps=0 w=400 l=30
X66 VDD SN m1_4580_745 VDD sky130_fd_pr__pfet_01v8 ad=0 pd=0 as=0 ps=0 w=400 l=30
X67 m1_4580_745 SN VDD VDD sky130_fd_pr__pfet_01v8 ad=0 pd=0 as=0 ps=0 w=400 l=30
X68 VDD m1_1692_819 m1_4580_745 VDD sky130_fd_pr__pfet_01v8 ad=0 pd=0 as=0 ps=0 w=400 l=30
X69 m1_4580_745 m1_1692_819 VDD VDD sky130_fd_pr__pfet_01v8 ad=0 pd=0 as=0 ps=0 w=400 l=30
.ends

** hspice subcircuit dictionary
* x1	nand3x1_pcell_0/nmos_bottom_0
* x3	nand3x1_pcell_0
* x12	li1_M1_contact_8
* x13	nand3x1_pcell_1/nmos_bottom_0
* x15	nand3x1_pcell_1
* x24	li1_M1_contact_9
* x25	nand3x1_pcell_2/nmos_bottom_0
* x27	nand3x1_pcell_2
* x36	nand3x1_pcell_3/nmos_bottom_0
* x38	nand3x1_pcell_3
* x47	li1_M1_contact_23
* x48	nand3x1_pcell_4/nmos_bottom_0
* x50	nand3x1_pcell_4
* x59	nand3x1_pcell_5/pmos2_2
* x60	nand3x1_pcell_5/nmos_bottom_0
* x62	nand3x1_pcell_5
