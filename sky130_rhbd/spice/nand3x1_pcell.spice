* HSPICE file created from nand3x1_pcell.ext - technology: sky130A

.option scale=5m

.subckt nand3x1_pcell
X0 x1/VSUBS a_147_377 x2/a_0_0 x1/VSUBS sky130_fd_pr__nfet_01v8 ad=2.39n pd=0.111m as=15.7n ps=0.599m w=602 l=30
X3 a_289_1059 li_649_399 li_393_182 x1/VSUBS sky130_fd_pr__nfet_01v8 ad=2.39n pd=0.111m as=15.8n ps=0.594m w=602 l=30
X4 li_393_182 a_447_377 x2/a_0_0 x1/VSUBS sky130_fd_pr__nfet_01v8 ad=2.18n pd=0.106m as=16.2n ps=0.604m w=600 l=30
X5 w_87_786 a_147_377 a_289_1059 w_87_786 sky130_fd_pr__pfet_01v8 ad=21.6n pd=0.908m as=11.6n ps=0.458m w=400 l=30
X6 a_289_1059 a_147_377 w_87_786 w_87_786 sky130_fd_pr__pfet_01v8 ad=11.6n pd=0.458m as=22.4n ps=0.912m w=400 l=30
X7 w_87_786 a_447_377 a_289_1059 w_87_786 sky130_fd_pr__pfet_01v8 ad=90.4n pd=3.65m as=69.6n ps=2.75m w=400 l=30
X8 a_289_1059 a_447_377 w_87_786 w_87_786 sky130_fd_pr__pfet_01v8 ad=0 pd=0 as=0 ps=0 w=400 l=30
X9 w_87_786 li_649_399 a_289_1059 w_87_786 sky130_fd_pr__pfet_01v8 ad=0 pd=0 as=0 ps=0 w=400 l=30
X10 a_289_1059 li_649_399 w_87_786 w_87_786 sky130_fd_pr__pfet_01v8 ad=0 pd=0 as=0 ps=0 w=400 l=30
.ends

** hspice subcircuit dictionary
* x1	pmos2_2
* x2	nmos_bottom_0
