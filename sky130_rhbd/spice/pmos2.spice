* HSPICE file created from pmos2.ext - technology: sky130A

.option scale=5m

.subckt pmos2
X0 a_262_n400 a_144_n461 a_174_n400 w_52_n436 sky130_fd_pr__pfet_01v8 ad=21.6n pd=0.908m as=11.6n ps=0.458m w=400 l=30
X1 a_174_n400 a_144_n461 a_88_n400 w_52_n436 sky130_fd_pr__pfet_01v8 ad=11.6n pd=0.458m as=22.4n ps=0.912m w=400 l=30
.ends

** hspice subcircuit dictionary
