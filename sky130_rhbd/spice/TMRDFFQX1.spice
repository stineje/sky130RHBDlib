* HSPICE file created from TMRDFFQX1.ext - technology: sky130A

.option scale=5m

.subckt TMRDFFQX1 Q D CLK VDD GND
X0 GND x1/m1_2115_634 x2/a_0_0 GND sky130_fd_pr__nfet_01v8 ad=2.39n pd=0.111m as=15.7n ps=0.599m w=602 l=30
X3 x1/m1_191_783 CLK x2/a_0_0 GND sky130_fd_pr__nfet_01v8 ad=2.39n pd=0.111m as=15.8n ps=0.594m w=602 l=30
X4 VDD x1/m1_2115_634 x1/m1_191_783 VDD sky130_fd_pr__pfet_01v8 ad=21.6n pd=0.908m as=11.6n ps=0.458m w=400 l=30
X5 x1/m1_191_783 x1/m1_2115_634 VDD VDD sky130_fd_pr__pfet_01v8 ad=11.6n pd=0.458m as=22.4n ps=0.912m w=400 l=30
X6 VDD CLK x1/m1_191_783 VDD sky130_fd_pr__pfet_01v8 ad=1.39u pd=0.0566 as=46.4n ps=1.83m w=400 l=30
X7 x1/m1_191_783 CLK VDD VDD sky130_fd_pr__pfet_01v8 ad=0 pd=0 as=0 ps=0 w=400 l=30
X8 GND x1/m1_782_708 x9/a_0_0 GND sky130_fd_pr__nfet_01v8 ad=0.347u pd=0.0172 as=77.2n ps=2.61m w=602 l=30
X10 m1_3544_741 m1_3393_599 x9/a_0_0 GND sky130_fd_pr__nfet_01v8 ad=1p pd=-87u as=0 ps=0 w=602 l=30
X11 VDD x1/m1_782_708 m1_3544_741 VDD sky130_fd_pr__pfet_01v8 ad=0 pd=0 as=46.4n ps=1.83m w=400 l=30
X12 m1_3544_741 x1/m1_782_708 VDD VDD sky130_fd_pr__pfet_01v8 ad=0 pd=0 as=0 ps=0 w=400 l=30
X13 VDD m1_3393_599 m1_3544_741 VDD sky130_fd_pr__pfet_01v8 ad=0 pd=0 as=0 ps=0 w=400 l=30
X14 m1_3544_741 m1_3393_599 VDD VDD sky130_fd_pr__pfet_01v8 ad=0 pd=0 as=0 ps=0 w=400 l=30
X15 GND m1_3544_741 x16/a_0_0 GND sky130_fd_pr__nfet_01v8 ad=0 pd=0 as=77.2n ps=2.61m w=602 l=30
X17 m1_3393_599 x1/m1_191_783 x16/a_0_0 GND sky130_fd_pr__nfet_01v8 ad=1p pd=-0.263m as=0 ps=0 w=602 l=30
X18 VDD m1_3544_741 m1_3393_599 VDD sky130_fd_pr__pfet_01v8 ad=0 pd=0 as=46.4n ps=1.83m w=400 l=30
X19 m1_3393_599 m1_3544_741 VDD VDD sky130_fd_pr__pfet_01v8 ad=0 pd=0 as=0 ps=0 w=400 l=30
X20 VDD x1/m1_191_783 m1_3393_599 VDD sky130_fd_pr__pfet_01v8 ad=0 pd=0 as=0 ps=0 w=400 l=30
X21 m1_3393_599 x1/m1_191_783 VDD VDD sky130_fd_pr__pfet_01v8 ad=0 pd=0 as=0 ps=0 w=400 l=30
X22 GND x1/m1_191_783 x23/a_0_0 GND sky130_fd_pr__nfet_01v8 ad=0 pd=0 as=78.2n ps=2.61m w=602 l=30
X24 x1/m1_782_708 x1/m1_635_634 x25/li_393_182 GND sky130_fd_pr__nfet_01v8 ad=-7.16n pd=-0.488m as=52.7n ps=1.92m w=602 l=30
X26 x25/li_393_182 CLK x23/a_0_0 GND sky130_fd_pr__nfet_01v8 ad=2.18n pd=0.106m as=16.2n ps=0.604m w=600 l=30
X27 VDD x1/m1_191_783 x1/m1_782_708 VDD sky130_fd_pr__pfet_01v8 ad=0 pd=0 as=69.6n ps=2.75m w=400 l=30
X28 x1/m1_782_708 x1/m1_191_783 VDD VDD sky130_fd_pr__pfet_01v8 ad=0 pd=0 as=0 ps=0 w=400 l=30
X29 VDD CLK x1/m1_782_708 VDD sky130_fd_pr__pfet_01v8 ad=0 pd=0 as=0 ps=0 w=400 l=30
X30 x1/m1_782_708 CLK VDD VDD sky130_fd_pr__pfet_01v8 ad=0 pd=0 as=0 ps=0 w=400 l=30
X31 VDD x1/m1_635_634 x1/m1_782_708 VDD sky130_fd_pr__pfet_01v8 ad=0 pd=0 as=0 ps=0 w=400 l=30
X32 x1/m1_782_708 x1/m1_635_634 VDD VDD sky130_fd_pr__pfet_01v8 ad=0 pd=0 as=0 ps=0 w=400 l=30
X33 GND x1/m1_782_708 x34/a_0_0 GND sky130_fd_pr__nfet_01v8 ad=0 pd=0 as=77.2n ps=2.61m w=602 l=30
X35 x1/m1_635_634 D x34/a_0_0 GND sky130_fd_pr__nfet_01v8 ad=1p pd=-87u as=0 ps=0 w=602 l=30
X36 VDD x1/m1_782_708 x1/m1_635_634 VDD sky130_fd_pr__pfet_01v8 ad=0 pd=0 as=46.4n ps=1.83m w=400 l=30
X37 x1/m1_635_634 x1/m1_782_708 VDD VDD sky130_fd_pr__pfet_01v8 ad=0 pd=0 as=0 ps=0 w=400 l=30
X38 VDD D x1/m1_635_634 VDD sky130_fd_pr__pfet_01v8 ad=0 pd=0 as=0 ps=0 w=400 l=30
X39 x1/m1_635_634 D VDD VDD sky130_fd_pr__pfet_01v8 ad=0 pd=0 as=0 ps=0 w=400 l=30
X40 GND x1/m1_635_634 x41/a_0_0 GND sky130_fd_pr__nfet_01v8 ad=0 pd=0 as=77.2n ps=2.61m w=602 l=30
X42 x1/m1_2115_634 x1/m1_191_783 x41/a_0_0 GND sky130_fd_pr__nfet_01v8 ad=1p pd=-87u as=0 ps=0 w=602 l=30
X43 VDD x1/m1_635_634 x1/m1_2115_634 VDD sky130_fd_pr__pfet_01v8 ad=0 pd=0 as=46.4n ps=1.83m w=400 l=30
X44 x1/m1_2115_634 x1/m1_635_634 VDD VDD sky130_fd_pr__pfet_01v8 ad=0 pd=0 as=0 ps=0 w=400 l=30
X45 VDD x1/m1_191_783 x1/m1_2115_634 VDD sky130_fd_pr__pfet_01v8 ad=0 pd=0 as=0 ps=0 w=400 l=30
X46 x1/m1_2115_634 x1/m1_191_783 VDD VDD sky130_fd_pr__pfet_01v8 ad=0 pd=0 as=0 ps=0 w=400 l=30
X47 GND x48/m1_2115_634 x49/a_0_0 GND sky130_fd_pr__nfet_01v8 ad=0 pd=0 as=77.2n ps=2.61m w=602 l=30
X50 x48/m1_191_783 CLK x49/a_0_0 GND sky130_fd_pr__nfet_01v8 ad=1p pd=-87u as=0 ps=0 w=602 l=30
X51 VDD x48/m1_2115_634 x48/m1_191_783 VDD sky130_fd_pr__pfet_01v8 ad=0 pd=0 as=46.4n ps=1.83m w=400 l=30
X52 x48/m1_191_783 x48/m1_2115_634 VDD VDD sky130_fd_pr__pfet_01v8 ad=0 pd=0 as=0 ps=0 w=400 l=30
X53 VDD CLK x48/m1_191_783 VDD sky130_fd_pr__pfet_01v8 ad=0 pd=0 as=0 ps=0 w=400 l=30
X54 x48/m1_191_783 CLK VDD VDD sky130_fd_pr__pfet_01v8 ad=0 pd=0 as=0 ps=0 w=400 l=30
X55 GND x48/m1_782_708 x56/a_0_0 GND sky130_fd_pr__nfet_01v8 ad=0 pd=0 as=77.2n ps=2.61m w=602 l=30
X57 m1_7836_741 m1_7685_433 x56/a_0_0 GND sky130_fd_pr__nfet_01v8 ad=1p pd=-87u as=0 ps=0 w=602 l=30
X58 VDD x48/m1_782_708 m1_7836_741 VDD sky130_fd_pr__pfet_01v8 ad=0 pd=0 as=46.4n ps=1.83m w=400 l=30
X59 m1_7836_741 x48/m1_782_708 VDD VDD sky130_fd_pr__pfet_01v8 ad=0 pd=0 as=0 ps=0 w=400 l=30
X60 VDD m1_7685_433 m1_7836_741 VDD sky130_fd_pr__pfet_01v8 ad=0 pd=0 as=0 ps=0 w=400 l=30
X61 m1_7836_741 m1_7685_433 VDD VDD sky130_fd_pr__pfet_01v8 ad=0 pd=0 as=0 ps=0 w=400 l=30
X62 GND m1_7836_741 x63/a_0_0 GND sky130_fd_pr__nfet_01v8 ad=0 pd=0 as=77.2n ps=2.61m w=602 l=30
X64 x65/li_n17_n33 x48/m1_191_783 x63/a_0_0 GND sky130_fd_pr__nfet_01v8 ad=7.16n pd=0.314m as=0 ps=0 w=602 l=30
X66 VDD m1_7836_741 x65/li_n17_n33 VDD sky130_fd_pr__pfet_01v8 ad=0 pd=0 as=46.4n ps=1.83m w=400 l=30
X67 x65/li_n17_n33 m1_7836_741 VDD VDD sky130_fd_pr__pfet_01v8 ad=0 pd=0 as=0 ps=0 w=400 l=30
X68 VDD x48/m1_191_783 x65/li_n17_n33 VDD sky130_fd_pr__pfet_01v8 ad=0 pd=0 as=0 ps=0 w=400 l=30
X69 x65/li_n17_n33 x48/m1_191_783 VDD VDD sky130_fd_pr__pfet_01v8 ad=0 pd=0 as=0 ps=0 w=400 l=30
X70 GND x48/m1_191_783 x71/a_0_0 GND sky130_fd_pr__nfet_01v8 ad=0 pd=0 as=78.2n ps=2.61m w=602 l=30
X72 x48/m1_782_708 x48/m1_635_634 x73/li_393_182 GND sky130_fd_pr__nfet_01v8 ad=-7.16n pd=-0.488m as=52.7n ps=1.92m w=602 l=30
X74 x73/li_393_182 CLK x71/a_0_0 GND sky130_fd_pr__nfet_01v8 ad=0 pd=0 as=0 ps=0 w=600 l=30
X75 VDD x48/m1_191_783 x48/m1_782_708 VDD sky130_fd_pr__pfet_01v8 ad=0 pd=0 as=69.6n ps=2.75m w=400 l=30
X76 x48/m1_782_708 x48/m1_191_783 VDD VDD sky130_fd_pr__pfet_01v8 ad=0 pd=0 as=0 ps=0 w=400 l=30
X77 VDD CLK x48/m1_782_708 VDD sky130_fd_pr__pfet_01v8 ad=0 pd=0 as=0 ps=0 w=400 l=30
X78 x48/m1_782_708 CLK VDD VDD sky130_fd_pr__pfet_01v8 ad=0 pd=0 as=0 ps=0 w=400 l=30
X79 VDD x48/m1_635_634 x48/m1_782_708 VDD sky130_fd_pr__pfet_01v8 ad=0 pd=0 as=0 ps=0 w=400 l=30
X80 x48/m1_782_708 x48/m1_635_634 VDD VDD sky130_fd_pr__pfet_01v8 ad=0 pd=0 as=0 ps=0 w=400 l=30
X81 GND x48/m1_782_708 x82/a_0_0 GND sky130_fd_pr__nfet_01v8 ad=0 pd=0 as=77.2n ps=2.61m w=602 l=30
X83 x48/m1_635_634 D x82/a_0_0 GND sky130_fd_pr__nfet_01v8 ad=1p pd=-87u as=0 ps=0 w=602 l=30
X84 VDD x48/m1_782_708 x48/m1_635_634 VDD sky130_fd_pr__pfet_01v8 ad=0 pd=0 as=46.4n ps=1.83m w=400 l=30
X85 x48/m1_635_634 x48/m1_782_708 VDD VDD sky130_fd_pr__pfet_01v8 ad=0 pd=0 as=0 ps=0 w=400 l=30
X86 VDD D x48/m1_635_634 VDD sky130_fd_pr__pfet_01v8 ad=0 pd=0 as=0 ps=0 w=400 l=30
X87 x48/m1_635_634 D VDD VDD sky130_fd_pr__pfet_01v8 ad=0 pd=0 as=0 ps=0 w=400 l=30
X88 GND x48/m1_635_634 x89/a_0_0 GND sky130_fd_pr__nfet_01v8 ad=0 pd=0 as=77.2n ps=2.61m w=602 l=30
X90 x48/m1_2115_634 x48/m1_191_783 x89/a_0_0 GND sky130_fd_pr__nfet_01v8 ad=1p pd=-87u as=0 ps=0 w=602 l=30
X91 VDD x48/m1_635_634 x48/m1_2115_634 VDD sky130_fd_pr__pfet_01v8 ad=0 pd=0 as=46.4n ps=1.83m w=400 l=30
X92 x48/m1_2115_634 x48/m1_635_634 VDD VDD sky130_fd_pr__pfet_01v8 ad=0 pd=0 as=0 ps=0 w=400 l=30
X93 VDD x48/m1_191_783 x48/m1_2115_634 VDD sky130_fd_pr__pfet_01v8 ad=0 pd=0 as=0 ps=0 w=400 l=30
X94 x48/m1_2115_634 x48/m1_191_783 VDD VDD sky130_fd_pr__pfet_01v8 ad=0 pd=0 as=0 ps=0 w=400 l=30
X95 GND x96/m1_2115_634 x97/a_0_0 GND sky130_fd_pr__nfet_01v8 ad=0 pd=0 as=77.2n ps=2.61m w=602 l=30
X98 x96/m1_191_783 CLK x97/a_0_0 GND sky130_fd_pr__nfet_01v8 ad=1p pd=-87u as=0 ps=0 w=602 l=30
X99 VDD x96/m1_2115_634 x96/m1_191_783 VDD sky130_fd_pr__pfet_01v8 ad=0 pd=0 as=46.4n ps=1.83m w=400 l=30
X100 x96/m1_191_783 x96/m1_2115_634 VDD VDD sky130_fd_pr__pfet_01v8 ad=0 pd=0 as=0 ps=0 w=400 l=30
X101 VDD CLK x96/m1_191_783 VDD sky130_fd_pr__pfet_01v8 ad=0 pd=0 as=0 ps=0 w=400 l=30
X102 x96/m1_191_783 CLK VDD VDD sky130_fd_pr__pfet_01v8 ad=0 pd=0 as=0 ps=0 w=400 l=30
X103 GND x96/m1_782_708 x104/a_0_0 GND sky130_fd_pr__nfet_01v8 ad=0 pd=0 as=77.2n ps=2.61m w=602 l=30
X105 m1_12127_895 m1_11980_741 x104/a_0_0 GND sky130_fd_pr__nfet_01v8 ad=1p pd=-87u as=0 ps=0 w=602 l=30
X106 VDD x96/m1_782_708 m1_12127_895 VDD sky130_fd_pr__pfet_01v8 ad=0 pd=0 as=46.4n ps=1.83m w=400 l=30
X107 m1_12127_895 x96/m1_782_708 VDD VDD sky130_fd_pr__pfet_01v8 ad=0 pd=0 as=0 ps=0 w=400 l=30
X108 VDD m1_11980_741 m1_12127_895 VDD sky130_fd_pr__pfet_01v8 ad=0 pd=0 as=0 ps=0 w=400 l=30
X109 m1_12127_895 m1_11980_741 VDD VDD sky130_fd_pr__pfet_01v8 ad=0 pd=0 as=0 ps=0 w=400 l=30
X110 GND m1_12127_895 x111/a_0_0 GND sky130_fd_pr__nfet_01v8 ad=0 pd=0 as=77.2n ps=2.61m w=602 l=30
X112 m1_11980_741 x96/m1_191_783 x111/a_0_0 GND sky130_fd_pr__nfet_01v8 ad=-7.16n pd=-0.841m as=0 ps=0 w=602 l=30
X113 VDD m1_12127_895 m1_11980_741 VDD sky130_fd_pr__pfet_01v8 ad=0 pd=0 as=46.4n ps=1.83m w=400 l=30
X114 m1_11980_741 m1_12127_895 VDD VDD sky130_fd_pr__pfet_01v8 ad=0 pd=0 as=0 ps=0 w=400 l=30
X115 VDD x96/m1_191_783 m1_11980_741 VDD sky130_fd_pr__pfet_01v8 ad=0 pd=0 as=0 ps=0 w=400 l=30
X116 m1_11980_741 x96/m1_191_783 VDD VDD sky130_fd_pr__pfet_01v8 ad=0 pd=0 as=0 ps=0 w=400 l=30
X117 GND x96/m1_191_783 x118/a_0_0 GND sky130_fd_pr__nfet_01v8 ad=0 pd=0 as=78.2n ps=2.61m w=602 l=30
X119 x96/m1_782_708 x96/m1_635_634 x120/li_393_182 GND sky130_fd_pr__nfet_01v8 ad=-7.16n pd=-0.488m as=52.7n ps=1.92m w=602 l=30
X121 x120/li_393_182 CLK x118/a_0_0 GND sky130_fd_pr__nfet_01v8 ad=0 pd=0 as=0 ps=0 w=600 l=30
X122 VDD x96/m1_191_783 x96/m1_782_708 VDD sky130_fd_pr__pfet_01v8 ad=0 pd=0 as=69.6n ps=2.75m w=400 l=30
X123 x96/m1_782_708 x96/m1_191_783 VDD VDD sky130_fd_pr__pfet_01v8 ad=0 pd=0 as=0 ps=0 w=400 l=30
X124 VDD CLK x96/m1_782_708 VDD sky130_fd_pr__pfet_01v8 ad=0 pd=0 as=0 ps=0 w=400 l=30
X125 x96/m1_782_708 CLK VDD VDD sky130_fd_pr__pfet_01v8 ad=0 pd=0 as=0 ps=0 w=400 l=30
X126 VDD x96/m1_635_634 x96/m1_782_708 VDD sky130_fd_pr__pfet_01v8 ad=0 pd=0 as=0 ps=0 w=400 l=30
X127 x96/m1_782_708 x96/m1_635_634 VDD VDD sky130_fd_pr__pfet_01v8 ad=0 pd=0 as=0 ps=0 w=400 l=30
X128 GND x96/m1_782_708 x129/a_0_0 GND sky130_fd_pr__nfet_01v8 ad=0 pd=0 as=77.2n ps=2.61m w=602 l=30
X130 x96/m1_635_634 D x129/a_0_0 GND sky130_fd_pr__nfet_01v8 ad=1p pd=-87u as=0 ps=0 w=602 l=30
X131 VDD x96/m1_782_708 x96/m1_635_634 VDD sky130_fd_pr__pfet_01v8 ad=0 pd=0 as=46.4n ps=1.83m w=400 l=30
X132 x96/m1_635_634 x96/m1_782_708 VDD VDD sky130_fd_pr__pfet_01v8 ad=0 pd=0 as=0 ps=0 w=400 l=30
X133 VDD D x96/m1_635_634 VDD sky130_fd_pr__pfet_01v8 ad=0 pd=0 as=0 ps=0 w=400 l=30
X134 x96/m1_635_634 D VDD VDD sky130_fd_pr__pfet_01v8 ad=0 pd=0 as=0 ps=0 w=400 l=30
X135 GND x96/m1_635_634 x136/a_0_0 GND sky130_fd_pr__nfet_01v8 ad=0 pd=0 as=77.2n ps=2.61m w=602 l=30
X137 x96/m1_2115_634 x96/m1_191_783 x136/a_0_0 GND sky130_fd_pr__nfet_01v8 ad=1p pd=-87u as=0 ps=0 w=602 l=30
X138 VDD x96/m1_635_634 x96/m1_2115_634 VDD sky130_fd_pr__pfet_01v8 ad=0 pd=0 as=46.4n ps=1.83m w=400 l=30
X139 x96/m1_2115_634 x96/m1_635_634 VDD VDD sky130_fd_pr__pfet_01v8 ad=0 pd=0 as=0 ps=0 w=400 l=30
X140 VDD x96/m1_191_783 x96/m1_2115_634 VDD sky130_fd_pr__pfet_01v8 ad=0 pd=0 as=0 ps=0 w=400 l=30
X141 x96/m1_2115_634 x96/m1_191_783 VDD VDD sky130_fd_pr__pfet_01v8 ad=0 pd=0 as=0 ps=0 w=400 l=30
X142 GND m1_11980_741 x143/a_0_0 GND sky130_fd_pr__nfet_01v8 ad=0 pd=0 as=76.7n ps=2.6m w=602 l=30
X144 GND m1_11980_741 x145/a_0_0 GND sky130_fd_pr__nfet_01v8 ad=0 pd=0 as=77.2n ps=2.61m w=602 l=30
X146 GND m1_3393_599 x147/a_0_0 GND sky130_fd_pr__nfet_01v8 ad=0 pd=0 as=77.2n ps=2.61m w=602 l=30
X148 x149/a_805_1331 m1_11980_741 VDD VDD sky130_fd_pr__pfet_01v8 ad=11.6n pd=0.458m as=22.4n ps=0.912m w=400 l=30
X150 VDD m1_11980_741 x149/a_805_1331 VDD sky130_fd_pr__pfet_01v8 ad=21.6n pd=0.908m as=11.6n ps=0.458m w=400 l=30
X151 m1_15088_819 m1_3393_599 x145/a_0_0 GND sky130_fd_pr__nfet_01v8 ad=21.5n pd=0.944m as=0 ps=0 w=602 l=30
X152 x149/a_805_1331 m1_7685_433 VDD VDD sky130_fd_pr__pfet_01v8 ad=0.114u pd=4.57m as=0 ps=0 w=400 l=30
X153 VDD m1_7685_433 x149/a_805_1331 VDD sky130_fd_pr__pfet_01v8 ad=0 pd=0 as=0 ps=0 w=400 l=30
X154 x155/a_174_n399 m1_3393_599 x149/a_805_1331 VDD sky130_fd_pr__pfet_01v8 ad=23.2n pd=0.916m as=0 ps=0 w=400 l=30
X156 x149/a_805_1331 m1_3393_599 x155/a_174_n399 VDD sky130_fd_pr__pfet_01v8 ad=0 pd=0 as=0 ps=0 w=400 l=30
X157 x149/a_893_1059 m1_11980_741 x149/a_805_1331 VDD sky130_fd_pr__pfet_01v8 ad=90.4n pd=3.65m as=0 ps=0 w=400 l=30
X158 x149/a_805_1331 m1_11980_741 x149/a_893_1059 VDD sky130_fd_pr__pfet_01v8 ad=0 pd=0 as=0 ps=0 w=400 l=30
X159 m1_15088_819 m1_3393_599 x149/a_893_1059 VDD sky130_fd_pr__pfet_01v8 ad=46.4n pd=1.83m as=0 ps=0 w=400 l=30
X160 x149/a_893_1059 m1_3393_599 m1_15088_819 VDD sky130_fd_pr__pfet_01v8 ad=0 pd=0 as=0 ps=0 w=400 l=30
X161 m1_15088_819 m1_7685_433 x149/a_893_1059 VDD sky130_fd_pr__pfet_01v8 ad=0 pd=0 as=0 ps=0 w=400 l=30
X162 x149/a_893_1059 m1_7685_433 m1_15088_819 VDD sky130_fd_pr__pfet_01v8 ad=0 pd=0 as=0 ps=0 w=400 l=30
X163 m1_15088_819 m1_7685_433 x143/a_0_0 GND sky130_fd_pr__nfet_01v8 ad=2.39n pd=0.111m as=15.6n ps=0.592m w=602 l=30
X164 m1_15088_819 m1_7685_433 x147/a_0_0 GND sky130_fd_pr__nfet_01v8 ad=2.4n pd=0.112m as=15.8n ps=0.594m w=602 l=30
X165 Q m1_15088_819 GND GND sky130_fd_pr__nfet_01v8 ad=7.16n pd=0.314m as=0 ps=0 w=602 l=30
X166 VDD m1_15088_819 Q VDD sky130_fd_pr__pfet_01v8 ad=0 pd=0 as=23.2n ps=0.917m w=400 l=30
X167 Q m1_15088_819 VDD VDD sky130_fd_pr__pfet_01v8 ad=0 pd=0 as=0 ps=0 w=400 l=30
C0 CLK VDD 2.54f
C1 CLK x48/m1_191_783 3.07f
C2 x1/m1_191_783 CLK 2.27f
C3 m1_3393_599 D 3.47f
.ends

** hspice subcircuit dictionary
* x1	dffx1_pcell_0
* x2	dffx1_pcell_0/nand2x1_pcell_2/nmos_bottom_0
* x9	dffx1_pcell_0/nand2x1_pcell_3/nmos_bottom_0
* x16	dffx1_pcell_0/nand2x1_pcell_4/nmos_bottom_0
* x23	dffx1_pcell_0/nand3x1_pcell_0/nmos_bottom_0
* x25	dffx1_pcell_0/nand3x1_pcell_0
* x34	dffx1_pcell_0/nand2x1_pcell_0/nmos_bottom_0
* x41	dffx1_pcell_0/nand2x1_pcell_1/nmos_bottom_0
* x48	dffx1_pcell_1
* x49	dffx1_pcell_1/nand2x1_pcell_2/nmos_bottom_0
* x56	dffx1_pcell_1/nand2x1_pcell_3/nmos_bottom_0
* x63	dffx1_pcell_1/nand2x1_pcell_4/nmos_bottom_0
* x65	li1_M1_contact_3
* x71	dffx1_pcell_1/nand3x1_pcell_0/nmos_bottom_0
* x73	dffx1_pcell_1/nand3x1_pcell_0
* x82	dffx1_pcell_1/nand2x1_pcell_0/nmos_bottom_0
* x89	dffx1_pcell_1/nand2x1_pcell_1/nmos_bottom_0
* x96	dffx1_pcell_2
* x97	dffx1_pcell_2/nand2x1_pcell_2/nmos_bottom_0
* x104	dffx1_pcell_2/nand2x1_pcell_3/nmos_bottom_0
* x111	dffx1_pcell_2/nand2x1_pcell_4/nmos_bottom_0
* x118	dffx1_pcell_2/nand3x1_pcell_0/nmos_bottom_0
* x120	dffx1_pcell_2/nand3x1_pcell_0
* x129	dffx1_pcell_2/nand2x1_pcell_0/nmos_bottom_0
* x136	dffx1_pcell_2/nand2x1_pcell_1/nmos_bottom_0
* x143	voter3x1_pcell_0/votern3x1_pcell_0/nmos_top_0
* x145	voter3x1_pcell_0/votern3x1_pcell_0/nmos_bottom_1
* x147	voter3x1_pcell_0/votern3x1_pcell_0/nmos_bottom_2
* x149	voter3x1_pcell_0/votern3x1_pcell_0
* x155	voter3x1_pcell_0/votern3x1_pcell_0/pmos2_1_2
