* HSPICE file created from TMRDFFSNQNX1.ext - technology: sky130A

.option scale=5m

.subckt TMRDFFSNQNX1 QN D CLK SN VDD GND
X0 GND m1_13607_895 x1/a_0_0 GND sky130_fd_pr__nfet_01v8 ad=2.39n pd=0.111m as=15.7n ps=0.599m w=602 l=30
X2 GND m1_13607_895 x3/a_0_0 GND sky130_fd_pr__nfet_01v8 ad=0.301u pd=0.0156 as=77.2n ps=2.61m w=602 l=30
X4 GND m1_3838_667 x5/a_0_0 GND sky130_fd_pr__nfet_01v8 ad=0 pd=0 as=77.2n ps=2.61m w=602 l=30
X6 x7/a_805_1331 m1_13607_895 VDD VDD sky130_fd_pr__pfet_01v8 ad=11.6n pd=0.458m as=22.4n ps=0.912m w=400 l=30
X8 VDD m1_13607_895 x7/a_805_1331 VDD sky130_fd_pr__pfet_01v8 ad=21.6n pd=0.908m as=11.6n ps=0.458m w=400 l=30
X9 QN m1_3838_667 x3/a_0_0 GND sky130_fd_pr__nfet_01v8 ad=2.39n pd=0.111m as=15.8n ps=0.594m w=602 l=30
X10 x7/a_805_1331 m1_8724_525 VDD VDD sky130_fd_pr__pfet_01v8 ad=0.114u pd=4.57m as=1.49u ps=0.0602 w=400 l=30
X11 VDD m1_8724_525 x7/a_805_1331 VDD sky130_fd_pr__pfet_01v8 ad=0 pd=0 as=0 ps=0 w=400 l=30
X12 x13/a_174_n399 m1_3838_667 x7/a_805_1331 VDD sky130_fd_pr__pfet_01v8 ad=23.2n pd=0.916m as=0 ps=0 w=400 l=30
X14 x7/a_805_1331 m1_3838_667 x13/a_174_n399 VDD sky130_fd_pr__pfet_01v8 ad=0 pd=0 as=0 ps=0 w=400 l=30
X15 x7/a_893_1059 m1_13607_895 x7/a_805_1331 VDD sky130_fd_pr__pfet_01v8 ad=90.4n pd=3.65m as=0 ps=0 w=400 l=30
X16 x7/a_805_1331 m1_13607_895 x7/a_893_1059 VDD sky130_fd_pr__pfet_01v8 ad=0 pd=0 as=0 ps=0 w=400 l=30
X17 QN m1_3838_667 x7/a_893_1059 VDD sky130_fd_pr__pfet_01v8 ad=46.4n pd=1.83m as=0 ps=0 w=400 l=30
X18 x7/a_893_1059 m1_3838_667 QN VDD sky130_fd_pr__pfet_01v8 ad=0 pd=0 as=0 ps=0 w=400 l=30
X19 QN m1_8724_525 x7/a_893_1059 VDD sky130_fd_pr__pfet_01v8 ad=0 pd=0 as=0 ps=0 w=400 l=30
X20 x7/a_893_1059 m1_8724_525 QN VDD sky130_fd_pr__pfet_01v8 ad=0 pd=0 as=0 ps=0 w=400 l=30
X21 QN m1_8724_525 x1/a_0_0 GND sky130_fd_pr__nfet_01v8 ad=2.39n pd=0.111m as=15.6n ps=0.592m w=602 l=30
X22 QN m1_8724_525 x5/a_0_0 GND sky130_fd_pr__nfet_01v8 ad=2.4n pd=0.112m as=15.8n ps=0.594m w=602 l=30
X23 GND x24/m1_338_781 x25/a_0_0 GND sky130_fd_pr__nfet_01v8 ad=0 pd=0 as=77.2n ps=2.61m w=602 l=30
X26 m1_3838_667 m1_3691_821 x25/a_0_0 GND sky130_fd_pr__nfet_01v8 ad=-7.16n pd=-0.664m as=0 ps=0 w=602 l=30
X27 VDD x24/m1_338_781 m1_3838_667 VDD sky130_fd_pr__pfet_01v8 ad=21.6n pd=0.908m as=11.6n ps=0.458m w=400 l=30
X28 m1_3838_667 x24/m1_338_781 VDD VDD sky130_fd_pr__pfet_01v8 ad=11.6n pd=0.458m as=22.4n ps=0.912m w=400 l=30
X29 VDD m1_3691_821 m1_3838_667 VDD sky130_fd_pr__pfet_01v8 ad=0 pd=0 as=46.4n ps=1.83m w=400 l=30
X30 m1_3838_667 m1_3691_821 VDD VDD sky130_fd_pr__pfet_01v8 ad=0 pd=0 as=0 ps=0 w=400 l=30
X31 GND D x32/a_0_0 GND sky130_fd_pr__nfet_01v8 ad=0 pd=0 as=77.2n ps=2.61m w=602 l=30
X33 x24/m1_486_486 x24/m1_338_781 x32/a_0_0 GND sky130_fd_pr__nfet_01v8 ad=-7.16n pd=-0.488m as=0 ps=0 w=602 l=30
X34 VDD D x24/m1_486_486 VDD sky130_fd_pr__pfet_01v8 ad=0 pd=0 as=46.4n ps=1.83m w=400 l=30
X35 x24/m1_486_486 D VDD VDD sky130_fd_pr__pfet_01v8 ad=0 pd=0 as=0 ps=0 w=400 l=30
X36 VDD x24/m1_338_781 x24/m1_486_486 VDD sky130_fd_pr__pfet_01v8 ad=0 pd=0 as=0 ps=0 w=400 l=30
X37 x24/m1_486_486 x24/m1_338_781 VDD VDD sky130_fd_pr__pfet_01v8 ad=0 pd=0 as=0 ps=0 w=400 l=30
X38 GND x24/m1_486_486 x39/a_0_0 GND sky130_fd_pr__nfet_01v8 ad=0 pd=0 as=78.2n ps=2.61m w=602 l=30
X40 x24/m1_338_781 x24/m1_1301_705 x41/li_393_182 GND sky130_fd_pr__nfet_01v8 ad=1p pd=-87u as=52.7n ps=1.92m w=602 l=30
X42 x41/li_393_182 CLK x39/a_0_0 GND sky130_fd_pr__nfet_01v8 ad=2.18n pd=0.106m as=16.2n ps=0.604m w=600 l=30
X43 VDD x24/m1_486_486 x24/m1_338_781 VDD sky130_fd_pr__pfet_01v8 ad=0 pd=0 as=69.6n ps=2.75m w=400 l=30
X44 x24/m1_338_781 x24/m1_486_486 VDD VDD sky130_fd_pr__pfet_01v8 ad=0 pd=0 as=0 ps=0 w=400 l=30
X45 VDD CLK x24/m1_338_781 VDD sky130_fd_pr__pfet_01v8 ad=0 pd=0 as=0 ps=0 w=400 l=30
X46 x24/m1_338_781 CLK VDD VDD sky130_fd_pr__pfet_01v8 ad=0 pd=0 as=0 ps=0 w=400 l=30
X47 VDD x24/m1_1301_705 x24/m1_338_781 VDD sky130_fd_pr__pfet_01v8 ad=0 pd=0 as=0 ps=0 w=400 l=30
X48 x24/m1_338_781 x24/m1_1301_705 VDD VDD sky130_fd_pr__pfet_01v8 ad=0 pd=0 as=0 ps=0 w=400 l=30
X49 GND m1_3838_667 x50/a_0_0 GND sky130_fd_pr__nfet_01v8 ad=0 pd=0 as=78.2n ps=2.61m w=602 l=30
X51 m1_3691_821 x24/m1_1301_705 x52/li_393_182 GND sky130_fd_pr__nfet_01v8 ad=7.16n pd=0.314m as=52.7n ps=1.92m w=602 l=30
X53 x52/li_393_182 SN x50/a_0_0 GND sky130_fd_pr__nfet_01v8 ad=0 pd=0 as=0 ps=0 w=600 l=30
X54 VDD m1_3838_667 m1_3691_821 VDD sky130_fd_pr__pfet_01v8 ad=0 pd=0 as=69.6n ps=2.75m w=400 l=30
X55 m1_3691_821 m1_3838_667 VDD VDD sky130_fd_pr__pfet_01v8 ad=0 pd=0 as=0 ps=0 w=400 l=30
X56 VDD SN m1_3691_821 VDD sky130_fd_pr__pfet_01v8 ad=0 pd=0 as=0 ps=0 w=400 l=30
X57 m1_3691_821 SN VDD VDD sky130_fd_pr__pfet_01v8 ad=0 pd=0 as=0 ps=0 w=400 l=30
X58 VDD x24/m1_1301_705 m1_3691_821 VDD sky130_fd_pr__pfet_01v8 ad=0 pd=0 as=0 ps=0 w=400 l=30
X59 m1_3691_821 x24/m1_1301_705 VDD VDD sky130_fd_pr__pfet_01v8 ad=0 pd=0 as=0 ps=0 w=400 l=30
X60 GND x24/m1_486_486 x61/a_0_0 GND sky130_fd_pr__nfet_01v8 ad=0 pd=0 as=78.2n ps=2.61m w=602 l=30
X62 x24/m1_2410_489 x24/m1_1301_705 x63/li_393_182 GND sky130_fd_pr__nfet_01v8 ad=1p pd=-87u as=52.7n ps=1.92m w=602 l=30
X64 x63/li_393_182 SN x61/a_0_0 GND sky130_fd_pr__nfet_01v8 ad=0 pd=0 as=0 ps=0 w=600 l=30
X65 VDD x24/m1_486_486 x24/m1_2410_489 VDD sky130_fd_pr__pfet_01v8 ad=0 pd=0 as=69.6n ps=2.75m w=400 l=30
X66 x24/m1_2410_489 x24/m1_486_486 VDD VDD sky130_fd_pr__pfet_01v8 ad=0 pd=0 as=0 ps=0 w=400 l=30
X67 VDD SN x24/m1_2410_489 VDD sky130_fd_pr__pfet_01v8 ad=0 pd=0 as=0 ps=0 w=400 l=30
X68 x24/m1_2410_489 SN VDD VDD sky130_fd_pr__pfet_01v8 ad=0 pd=0 as=0 ps=0 w=400 l=30
X69 VDD x24/m1_1301_705 x24/m1_2410_489 VDD sky130_fd_pr__pfet_01v8 ad=0 pd=0 as=0 ps=0 w=400 l=30
X70 x24/m1_2410_489 x24/m1_1301_705 VDD VDD sky130_fd_pr__pfet_01v8 ad=0 pd=0 as=0 ps=0 w=400 l=30
X71 GND x24/m1_2410_489 x72/a_0_0 GND sky130_fd_pr__nfet_01v8 ad=0 pd=0 as=77.2n ps=2.61m w=602 l=30
X73 x24/m1_1301_705 CLK x72/a_0_0 GND sky130_fd_pr__nfet_01v8 ad=7.16n pd=0.314m as=0 ps=0 w=602 l=30
X74 VDD x24/m1_2410_489 x24/m1_1301_705 VDD sky130_fd_pr__pfet_01v8 ad=0 pd=0 as=46.4n ps=1.83m w=400 l=30
X75 x24/m1_1301_705 x24/m1_2410_489 VDD VDD sky130_fd_pr__pfet_01v8 ad=0 pd=0 as=0 ps=0 w=400 l=30
X76 VDD CLK x24/m1_1301_705 VDD sky130_fd_pr__pfet_01v8 ad=0 pd=0 as=0 ps=0 w=400 l=30
X77 x24/m1_1301_705 CLK VDD VDD sky130_fd_pr__pfet_01v8 ad=0 pd=0 as=0 ps=0 w=400 l=30
X78 GND x79/m1_338_781 x80/a_0_0 GND sky130_fd_pr__nfet_01v8 ad=0 pd=0 as=77.2n ps=2.61m w=602 l=30
X81 m1_8724_525 m1_8575_821 x80/a_0_0 GND sky130_fd_pr__nfet_01v8 ad=1p pd=-87u as=0 ps=0 w=602 l=30
X82 VDD x79/m1_338_781 m1_8724_525 VDD sky130_fd_pr__pfet_01v8 ad=0 pd=0 as=46.4n ps=1.83m w=400 l=30
X83 m1_8724_525 x79/m1_338_781 VDD VDD sky130_fd_pr__pfet_01v8 ad=0 pd=0 as=0 ps=0 w=400 l=30
X84 VDD m1_8575_821 m1_8724_525 VDD sky130_fd_pr__pfet_01v8 ad=0 pd=0 as=0 ps=0 w=400 l=30
X85 m1_8724_525 m1_8575_821 VDD VDD sky130_fd_pr__pfet_01v8 ad=0 pd=0 as=0 ps=0 w=400 l=30
X86 GND D x87/a_0_0 GND sky130_fd_pr__nfet_01v8 ad=0 pd=0 as=77.2n ps=2.61m w=602 l=30
X88 x79/m1_486_486 x79/m1_338_781 x87/a_0_0 GND sky130_fd_pr__nfet_01v8 ad=-7.16n pd=-0.488m as=0 ps=0 w=602 l=30
X89 VDD D x79/m1_486_486 VDD sky130_fd_pr__pfet_01v8 ad=0 pd=0 as=46.4n ps=1.83m w=400 l=30
X90 x79/m1_486_486 D VDD VDD sky130_fd_pr__pfet_01v8 ad=0 pd=0 as=0 ps=0 w=400 l=30
X91 VDD x79/m1_338_781 x79/m1_486_486 VDD sky130_fd_pr__pfet_01v8 ad=0 pd=0 as=0 ps=0 w=400 l=30
X92 x79/m1_486_486 x79/m1_338_781 VDD VDD sky130_fd_pr__pfet_01v8 ad=0 pd=0 as=0 ps=0 w=400 l=30
X93 GND x79/m1_486_486 x94/a_0_0 GND sky130_fd_pr__nfet_01v8 ad=0 pd=0 as=78.2n ps=2.61m w=602 l=30
X95 x79/m1_338_781 x79/m1_1301_705 x96/li_393_182 GND sky130_fd_pr__nfet_01v8 ad=1p pd=-87u as=52.7n ps=1.92m w=602 l=30
X97 x96/li_393_182 CLK x94/a_0_0 GND sky130_fd_pr__nfet_01v8 ad=0 pd=0 as=0 ps=0 w=600 l=30
X98 VDD x79/m1_486_486 x79/m1_338_781 VDD sky130_fd_pr__pfet_01v8 ad=0 pd=0 as=69.6n ps=2.75m w=400 l=30
X99 x79/m1_338_781 x79/m1_486_486 VDD VDD sky130_fd_pr__pfet_01v8 ad=0 pd=0 as=0 ps=0 w=400 l=30
X100 VDD CLK x79/m1_338_781 VDD sky130_fd_pr__pfet_01v8 ad=0 pd=0 as=0 ps=0 w=400 l=30
X101 x79/m1_338_781 CLK VDD VDD sky130_fd_pr__pfet_01v8 ad=0 pd=0 as=0 ps=0 w=400 l=30
X102 VDD x79/m1_1301_705 x79/m1_338_781 VDD sky130_fd_pr__pfet_01v8 ad=0 pd=0 as=0 ps=0 w=400 l=30
X103 x79/m1_338_781 x79/m1_1301_705 VDD VDD sky130_fd_pr__pfet_01v8 ad=0 pd=0 as=0 ps=0 w=400 l=30
X104 GND m1_8724_525 x105/a_0_0 GND sky130_fd_pr__nfet_01v8 ad=0 pd=0 as=78.2n ps=2.61m w=602 l=30
X106 m1_8575_821 x79/m1_1301_705 x107/li_393_182 GND sky130_fd_pr__nfet_01v8 ad=7.16n pd=0.314m as=52.7n ps=1.92m w=602 l=30
X108 x107/li_393_182 SN x105/a_0_0 GND sky130_fd_pr__nfet_01v8 ad=0 pd=0 as=0 ps=0 w=600 l=30
X109 VDD m1_8724_525 m1_8575_821 VDD sky130_fd_pr__pfet_01v8 ad=0 pd=0 as=69.6n ps=2.75m w=400 l=30
X110 m1_8575_821 m1_8724_525 VDD VDD sky130_fd_pr__pfet_01v8 ad=0 pd=0 as=0 ps=0 w=400 l=30
X111 VDD SN m1_8575_821 VDD sky130_fd_pr__pfet_01v8 ad=0 pd=0 as=0 ps=0 w=400 l=30
X112 m1_8575_821 SN VDD VDD sky130_fd_pr__pfet_01v8 ad=0 pd=0 as=0 ps=0 w=400 l=30
X113 VDD x79/m1_1301_705 m1_8575_821 VDD sky130_fd_pr__pfet_01v8 ad=0 pd=0 as=0 ps=0 w=400 l=30
X114 m1_8575_821 x79/m1_1301_705 VDD VDD sky130_fd_pr__pfet_01v8 ad=0 pd=0 as=0 ps=0 w=400 l=30
X115 GND x79/m1_486_486 x116/a_0_0 GND sky130_fd_pr__nfet_01v8 ad=0 pd=0 as=78.2n ps=2.61m w=602 l=30
X117 x79/m1_2410_489 x79/m1_1301_705 x118/li_393_182 GND sky130_fd_pr__nfet_01v8 ad=1p pd=-87u as=52.7n ps=1.92m w=602 l=30
X119 x118/li_393_182 SN x116/a_0_0 GND sky130_fd_pr__nfet_01v8 ad=0 pd=0 as=0 ps=0 w=600 l=30
X120 VDD x79/m1_486_486 x79/m1_2410_489 VDD sky130_fd_pr__pfet_01v8 ad=0 pd=0 as=69.6n ps=2.75m w=400 l=30
X121 x79/m1_2410_489 x79/m1_486_486 VDD VDD sky130_fd_pr__pfet_01v8 ad=0 pd=0 as=0 ps=0 w=400 l=30
X122 VDD SN x79/m1_2410_489 VDD sky130_fd_pr__pfet_01v8 ad=0 pd=0 as=0 ps=0 w=400 l=30
X123 x79/m1_2410_489 SN VDD VDD sky130_fd_pr__pfet_01v8 ad=0 pd=0 as=0 ps=0 w=400 l=30
X124 VDD x79/m1_1301_705 x79/m1_2410_489 VDD sky130_fd_pr__pfet_01v8 ad=0 pd=0 as=0 ps=0 w=400 l=30
X125 x79/m1_2410_489 x79/m1_1301_705 VDD VDD sky130_fd_pr__pfet_01v8 ad=0 pd=0 as=0 ps=0 w=400 l=30
X126 GND x79/m1_2410_489 x127/a_0_0 GND sky130_fd_pr__nfet_01v8 ad=0 pd=0 as=77.2n ps=2.61m w=602 l=30
X128 x79/m1_1301_705 CLK x127/a_0_0 GND sky130_fd_pr__nfet_01v8 ad=7.16n pd=0.314m as=0 ps=0 w=602 l=30
X129 VDD x79/m1_2410_489 x79/m1_1301_705 VDD sky130_fd_pr__pfet_01v8 ad=0 pd=0 as=46.4n ps=1.83m w=400 l=30
X130 x79/m1_1301_705 x79/m1_2410_489 VDD VDD sky130_fd_pr__pfet_01v8 ad=0 pd=0 as=0 ps=0 w=400 l=30
X131 VDD CLK x79/m1_1301_705 VDD sky130_fd_pr__pfet_01v8 ad=0 pd=0 as=0 ps=0 w=400 l=30
X132 x79/m1_1301_705 CLK VDD VDD sky130_fd_pr__pfet_01v8 ad=0 pd=0 as=0 ps=0 w=400 l=30
X133 GND x134/m1_338_781 x135/a_0_0 GND sky130_fd_pr__nfet_01v8 ad=0 pd=0 as=77.2n ps=2.61m w=602 l=30
X136 m1_13607_895 m1_13461_821 x135/a_0_0 GND sky130_fd_pr__nfet_01v8 ad=-14.3n pd=-1.24m as=0 ps=0 w=602 l=30
X137 VDD x134/m1_338_781 m1_13607_895 VDD sky130_fd_pr__pfet_01v8 ad=0 pd=0 as=46.4n ps=1.83m w=400 l=30
X138 m1_13607_895 x134/m1_338_781 VDD VDD sky130_fd_pr__pfet_01v8 ad=0 pd=0 as=0 ps=0 w=400 l=30
X139 VDD m1_13461_821 m1_13607_895 VDD sky130_fd_pr__pfet_01v8 ad=0 pd=0 as=0 ps=0 w=400 l=30
X140 m1_13607_895 m1_13461_821 VDD VDD sky130_fd_pr__pfet_01v8 ad=0 pd=0 as=0 ps=0 w=400 l=30
X141 GND D x142/a_0_0 GND sky130_fd_pr__nfet_01v8 ad=0 pd=0 as=77.2n ps=2.61m w=602 l=30
X143 x134/m1_486_486 x134/m1_338_781 x142/a_0_0 GND sky130_fd_pr__nfet_01v8 ad=-7.16n pd=-0.488m as=0 ps=0 w=602 l=30
X144 VDD D x134/m1_486_486 VDD sky130_fd_pr__pfet_01v8 ad=0 pd=0 as=46.4n ps=1.83m w=400 l=30
X145 x134/m1_486_486 D VDD VDD sky130_fd_pr__pfet_01v8 ad=0 pd=0 as=0 ps=0 w=400 l=30
X146 VDD x134/m1_338_781 x134/m1_486_486 VDD sky130_fd_pr__pfet_01v8 ad=0 pd=0 as=0 ps=0 w=400 l=30
X147 x134/m1_486_486 x134/m1_338_781 VDD VDD sky130_fd_pr__pfet_01v8 ad=0 pd=0 as=0 ps=0 w=400 l=30
X148 GND x134/m1_486_486 x149/a_0_0 GND sky130_fd_pr__nfet_01v8 ad=0 pd=0 as=78.2n ps=2.61m w=602 l=30
X150 x134/m1_338_781 z@10 x151/li_393_182 GND sky130_fd_pr__nfet_01v8 ad=1p pd=-87u as=52.7n ps=1.92m w=602 l=30
X152 x151/li_393_182 CLK x149/a_0_0 GND sky130_fd_pr__nfet_01v8 ad=0 pd=0 as=0 ps=0 w=600 l=30
X153 VDD x134/m1_486_486 x134/m1_338_781 VDD sky130_fd_pr__pfet_01v8 ad=0 pd=0 as=69.6n ps=2.75m w=400 l=30
X154 x134/m1_338_781 x134/m1_486_486 VDD VDD sky130_fd_pr__pfet_01v8 ad=0 pd=0 as=0 ps=0 w=400 l=30
X155 VDD CLK x134/m1_338_781 VDD sky130_fd_pr__pfet_01v8 ad=0 pd=0 as=0 ps=0 w=400 l=30
X156 x134/m1_338_781 CLK VDD VDD sky130_fd_pr__pfet_01v8 ad=0 pd=0 as=0 ps=0 w=400 l=30
X157 VDD z@10 x134/m1_338_781 VDD sky130_fd_pr__pfet_01v8 ad=0 pd=0 as=0 ps=0 w=400 l=30
X158 x134/m1_338_781 z@10 VDD VDD sky130_fd_pr__pfet_01v8 ad=0 pd=0 as=0 ps=0 w=400 l=30
X159 GND m1_13607_895 x160/a_0_0 GND sky130_fd_pr__nfet_01v8 ad=0 pd=0 as=78.2n ps=2.61m w=602 l=30
X161 m1_13461_821 z@10 x162/li_393_182 GND sky130_fd_pr__nfet_01v8 ad=7.16n pd=0.314m as=52.7n ps=1.92m w=602 l=30
X163 x162/li_393_182 SN x160/a_0_0 GND sky130_fd_pr__nfet_01v8 ad=0 pd=0 as=0 ps=0 w=600 l=30
X164 VDD m1_13607_895 m1_13461_821 VDD sky130_fd_pr__pfet_01v8 ad=0 pd=0 as=69.6n ps=2.75m w=400 l=30
X165 m1_13461_821 m1_13607_895 VDD VDD sky130_fd_pr__pfet_01v8 ad=0 pd=0 as=0 ps=0 w=400 l=30
X166 VDD SN m1_13461_821 VDD sky130_fd_pr__pfet_01v8 ad=0 pd=0 as=0 ps=0 w=400 l=30
X167 m1_13461_821 SN VDD VDD sky130_fd_pr__pfet_01v8 ad=0 pd=0 as=0 ps=0 w=400 l=30
X168 VDD z@10 m1_13461_821 VDD sky130_fd_pr__pfet_01v8 ad=0 pd=0 as=0 ps=0 w=400 l=30
X169 m1_13461_821 z@10 VDD VDD sky130_fd_pr__pfet_01v8 ad=0 pd=0 as=0 ps=0 w=400 l=30
X170 GND x134/m1_486_486 x171/a_0_0 GND sky130_fd_pr__nfet_01v8 ad=0 pd=0 as=78.2n ps=2.61m w=602 l=30
X172 z@11 z@10 x173/li_393_182 GND sky130_fd_pr__nfet_01v8 ad=1p pd=-87u as=52.7n ps=1.92m w=602 l=30
X174 x173/li_393_182 SN x171/a_0_0 GND sky130_fd_pr__nfet_01v8 ad=0 pd=0 as=0 ps=0 w=600 l=30
X175 VDD x134/m1_486_486 z@11 VDD sky130_fd_pr__pfet_01v8 ad=0 pd=0 as=69.6n ps=2.75m w=400 l=30
X176 z@11 x134/m1_486_486 VDD VDD sky130_fd_pr__pfet_01v8 ad=0 pd=0 as=0 ps=0 w=400 l=30
X177 VDD SN z@11 VDD sky130_fd_pr__pfet_01v8 ad=0 pd=0 as=0 ps=0 w=400 l=30
X178 z@11 SN VDD VDD sky130_fd_pr__pfet_01v8 ad=0 pd=0 as=0 ps=0 w=400 l=30
X179 VDD z@10 z@11 VDD sky130_fd_pr__pfet_01v8 ad=0 pd=0 as=0 ps=0 w=400 l=30
X180 z@11 z@10 VDD VDD sky130_fd_pr__pfet_01v8 ad=0 pd=0 as=0 ps=0 w=400 l=30
X181 GND z@11 x182/a_0_0 GND sky130_fd_pr__nfet_01v8 ad=0 pd=0 as=77.2n ps=2.61m w=602 l=30
X183 z@10 CLK x182/a_0_0 GND sky130_fd_pr__nfet_01v8 ad=7.16n pd=0.314m as=0 ps=0 w=602 l=30
X184 VDD z@11 z@10 VDD sky130_fd_pr__pfet_01v8 ad=0 pd=0 as=46.4n ps=1.83m w=400 l=30
X185 z@10 z@11 VDD VDD sky130_fd_pr__pfet_01v8 ad=0 pd=0 as=0 ps=0 w=400 l=30
X186 VDD CLK z@10 VDD sky130_fd_pr__pfet_01v8 ad=0 pd=0 as=0 ps=0 w=400 l=30
X187 z@10 CLK VDD VDD sky130_fd_pr__pfet_01v8 ad=0 pd=0 as=0 ps=0 w=400 l=30
C0 m1_3838_667 m1_8724_525 3.18f
C1 D m1_3838_667 3.26f
C2 CLK VDD 2.25f
.ends

** hspice subcircuit dictionary
* x1	votern3x1_pcell_0/nmos_top_0
* x3	votern3x1_pcell_0/nmos_bottom_1
* x5	votern3x1_pcell_0/nmos_bottom_2
* x7	votern3x1_pcell_0
* x13	votern3x1_pcell_0/pmos2_1_2
* x24	dffsnx1_pcell_0
* x25	dffsnx1_pcell_0/nand2x1_pcell_2/nmos_bottom_0
* x32	dffsnx1_pcell_0/nand2x1_pcell_5/nmos_bottom_0
* x39	dffsnx1_pcell_0/nand3x1_pcell_0/nmos_bottom_0
* x41	dffsnx1_pcell_0/nand3x1_pcell_0
* x50	dffsnx1_pcell_0/nand3x1_pcell_1/nmos_bottom_0
* x52	dffsnx1_pcell_0/nand3x1_pcell_1
* x61	dffsnx1_pcell_0/nand3x1_pcell_2/nmos_bottom_0
* x63	dffsnx1_pcell_0/nand3x1_pcell_2
* x72	dffsnx1_pcell_0/nand2x1_pcell_0/nmos_bottom_0
* x79	dffsnx1_pcell_1
* x80	dffsnx1_pcell_1/nand2x1_pcell_2/nmos_bottom_0
* x87	dffsnx1_pcell_1/nand2x1_pcell_5/nmos_bottom_0
* x94	dffsnx1_pcell_1/nand3x1_pcell_0/nmos_bottom_0
* x96	dffsnx1_pcell_1/nand3x1_pcell_0
* x105	dffsnx1_pcell_1/nand3x1_pcell_1/nmos_bottom_0
* x107	dffsnx1_pcell_1/nand3x1_pcell_1
* x116	dffsnx1_pcell_1/nand3x1_pcell_2/nmos_bottom_0
* x118	dffsnx1_pcell_1/nand3x1_pcell_2
* x127	dffsnx1_pcell_1/nand2x1_pcell_0/nmos_bottom_0
* x134	dffsnx1_pcell_2
* x135	dffsnx1_pcell_2/nand2x1_pcell_2/nmos_bottom_0
* x142	dffsnx1_pcell_2/nand2x1_pcell_5/nmos_bottom_0
* x149	dffsnx1_pcell_2/nand3x1_pcell_0/nmos_bottom_0
* x151	dffsnx1_pcell_2/nand3x1_pcell_0
* x160	dffsnx1_pcell_2/nand3x1_pcell_1/nmos_bottom_0
* x162	dffsnx1_pcell_2/nand3x1_pcell_1
* x171	dffsnx1_pcell_2/nand3x1_pcell_2/nmos_bottom_0
* x173	dffsnx1_pcell_2/nand3x1_pcell_2
* x182	dffsnx1_pcell_2/nand2x1_pcell_0/nmos_bottom_0
