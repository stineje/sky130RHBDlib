* HSPICE file created from TMRDFFSNQNX1.ext - technology: sky130A

.option scale=5m

.subckt TMRDFFSNQNX1 QN D CLK SN VDD GND
X0 GND m2_14925_907 x1/a_0_0 GND sky130_fd_pr__nfet_01v8 ad=2.39n pd=0.111m as=15.7n ps=0.599m w=602 l=30
X2 GND m2_14925_907 x3/a_0_0 GND sky130_fd_pr__nfet_01v8 ad=0.301u pd=0.0156 as=77.2n ps=2.61m w=602 l=30
X4 GND m1_3838_667 x5/a_0_0 GND sky130_fd_pr__nfet_01v8 ad=0 pd=0 as=77.2n ps=2.61m w=602 l=30
X6 x7/a_805_1331 m2_14925_907 VDD VDD sky130_fd_pr__pfet_01v8 ad=11.6n pd=0.458m as=22.4n ps=0.912m w=400 l=30
X8 VDD m2_14925_907 x7/a_805_1331 VDD sky130_fd_pr__pfet_01v8 ad=21.6n pd=0.908m as=11.6n ps=0.458m w=400 l=30
X9 QN m1_3838_667 x3/a_0_0 GND sky130_fd_pr__nfet_01v8 ad=2.39n pd=0.111m as=15.8n ps=0.594m w=602 l=30
X10 x7/a_805_1331 m1_8724_525 VDD VDD sky130_fd_pr__pfet_01v8 ad=0.114u pd=4.57m as=1.49u ps=0.0602 w=400 l=30
X11 VDD m1_8724_525 x7/a_805_1331 VDD sky130_fd_pr__pfet_01v8 ad=0 pd=0 as=0 ps=0 w=400 l=30
X12 a_15819_1102 m1_3838_667 x7/a_805_1331 VDD sky130_fd_pr__pfet_01v8 ad=0.114u pd=4.57m as=0 ps=0 w=400 l=30
X13 x7/a_805_1331 m1_3838_667 a_15819_1102 VDD sky130_fd_pr__pfet_01v8 ad=0 pd=0 as=0 ps=0 w=400 l=30
X14 a_15819_1102 m2_14925_907 x7/a_805_1331 VDD sky130_fd_pr__pfet_01v8 ad=0 pd=0 as=0 ps=0 w=400 l=30
X15 x7/a_805_1331 m2_14925_907 a_15819_1102 VDD sky130_fd_pr__pfet_01v8 ad=0 pd=0 as=0 ps=0 w=400 l=30
X16 QN m1_3838_667 a_15819_1102 VDD sky130_fd_pr__pfet_01v8 ad=46.4n pd=1.83m as=0 ps=0 w=400 l=30
X17 a_15819_1102 m1_3838_667 QN VDD sky130_fd_pr__pfet_01v8 ad=0 pd=0 as=0 ps=0 w=400 l=30
X18 QN m1_8724_525 a_15819_1102 VDD sky130_fd_pr__pfet_01v8 ad=0 pd=0 as=0 ps=0 w=400 l=30
X19 a_15819_1102 m1_8724_525 QN VDD sky130_fd_pr__pfet_01v8 ad=0 pd=0 as=0 ps=0 w=400 l=30
X20 QN m1_8724_525 x1/a_0_0 GND sky130_fd_pr__nfet_01v8 ad=2.39n pd=0.111m as=15.6n ps=0.592m w=602 l=30
X21 QN m1_8724_525 x5/a_0_0 GND sky130_fd_pr__nfet_01v8 ad=2.4n pd=0.112m as=15.8n ps=0.594m w=602 l=30
X22 GND m2_494_833 x23/a_0_0 GND sky130_fd_pr__nfet_01v8 ad=0 pd=0 as=77.2n ps=2.61m w=602 l=30
X24 m1_3838_667 m1_3691_821 x23/a_0_0 GND sky130_fd_pr__nfet_01v8 ad=-7.16n pd=-0.664m as=0 ps=0 w=602 l=30
X25 VDD m2_494_833 m1_3838_667 VDD sky130_fd_pr__pfet_01v8 ad=21.6n pd=0.908m as=11.6n ps=0.458m w=400 l=30
X26 m1_3838_667 m2_494_833 VDD VDD sky130_fd_pr__pfet_01v8 ad=11.6n pd=0.458m as=22.4n ps=0.912m w=400 l=30
X27 VDD m1_3691_821 m1_3838_667 VDD sky130_fd_pr__pfet_01v8 ad=0 pd=0 as=46.4n ps=1.83m w=400 l=30
X28 m1_3838_667 m1_3691_821 VDD VDD sky130_fd_pr__pfet_01v8 ad=0 pd=0 as=0 ps=0 w=400 l=30
X29 GND D x30/a_0_0 GND sky130_fd_pr__nfet_01v8 ad=0 pd=0 as=77.2n ps=2.61m w=602 l=30
X31 m2_1012_537 m2_494_833 x30/a_0_0 GND sky130_fd_pr__nfet_01v8 ad=-7.16n pd=-0.488m as=0 ps=0 w=602 l=30
X32 VDD D m2_1012_537 VDD sky130_fd_pr__pfet_01v8 ad=0 pd=0 as=46.4n ps=1.83m w=400 l=30
X33 m2_1012_537 D VDD VDD sky130_fd_pr__pfet_01v8 ad=0 pd=0 as=0 ps=0 w=400 l=30
X34 VDD m2_494_833 m2_1012_537 VDD sky130_fd_pr__pfet_01v8 ad=0 pd=0 as=0 ps=0 w=400 l=30
X35 m2_1012_537 m2_494_833 VDD VDD sky130_fd_pr__pfet_01v8 ad=0 pd=0 as=0 ps=0 w=400 l=30
X36 GND m2_1012_537 x37/a_0_0 GND sky130_fd_pr__nfet_01v8 ad=0 pd=0 as=78.2n ps=2.61m w=602 l=30
X38 m2_494_833 m2_3231_759 x39/li_393_182 GND sky130_fd_pr__nfet_01v8 ad=1p pd=-87u as=52.7n ps=1.92m w=602 l=30
X40 x39/li_393_182 CLK x37/a_0_0 GND sky130_fd_pr__nfet_01v8 ad=2.18n pd=0.106m as=16.2n ps=0.604m w=600 l=30
X41 VDD m2_1012_537 m2_494_833 VDD sky130_fd_pr__pfet_01v8 ad=0 pd=0 as=69.6n ps=2.75m w=400 l=30
X42 m2_494_833 m2_1012_537 VDD VDD sky130_fd_pr__pfet_01v8 ad=0 pd=0 as=0 ps=0 w=400 l=30
X43 VDD CLK m2_494_833 VDD sky130_fd_pr__pfet_01v8 ad=0 pd=0 as=0 ps=0 w=400 l=30
X44 m2_494_833 CLK VDD VDD sky130_fd_pr__pfet_01v8 ad=0 pd=0 as=0 ps=0 w=400 l=30
X45 VDD m2_3231_759 m2_494_833 VDD sky130_fd_pr__pfet_01v8 ad=0 pd=0 as=0 ps=0 w=400 l=30
X46 m2_494_833 m2_3231_759 VDD VDD sky130_fd_pr__pfet_01v8 ad=0 pd=0 as=0 ps=0 w=400 l=30
X47 GND m1_3838_667 x48/a_0_0 GND sky130_fd_pr__nfet_01v8 ad=0 pd=0 as=78.2n ps=2.61m w=602 l=30
X49 m1_3691_821 m2_3231_759 x50/li_393_182 GND sky130_fd_pr__nfet_01v8 ad=7.16n pd=0.314m as=52.7n ps=1.92m w=602 l=30
X51 x50/li_393_182 SN x48/a_0_0 GND sky130_fd_pr__nfet_01v8 ad=0 pd=0 as=0 ps=0 w=600 l=30
X52 VDD m1_3838_667 m1_3691_821 VDD sky130_fd_pr__pfet_01v8 ad=0 pd=0 as=69.6n ps=2.75m w=400 l=30
X53 m1_3691_821 m1_3838_667 VDD VDD sky130_fd_pr__pfet_01v8 ad=0 pd=0 as=0 ps=0 w=400 l=30
X54 VDD SN m1_3691_821 VDD sky130_fd_pr__pfet_01v8 ad=0 pd=0 as=0 ps=0 w=400 l=30
X55 m1_3691_821 SN VDD VDD sky130_fd_pr__pfet_01v8 ad=0 pd=0 as=0 ps=0 w=400 l=30
X56 VDD m2_3231_759 m1_3691_821 VDD sky130_fd_pr__pfet_01v8 ad=0 pd=0 as=0 ps=0 w=400 l=30
X57 m1_3691_821 m2_3231_759 VDD VDD sky130_fd_pr__pfet_01v8 ad=0 pd=0 as=0 ps=0 w=400 l=30
X58 GND m2_1012_537 x59/a_0_0 GND sky130_fd_pr__nfet_01v8 ad=0 pd=0 as=78.2n ps=2.61m w=602 l=30
X60 m2_2566_537 m2_3231_759 x61/li_393_182 GND sky130_fd_pr__nfet_01v8 ad=1p pd=-87u as=52.7n ps=1.92m w=602 l=30
X62 x61/li_393_182 SN x59/a_0_0 GND sky130_fd_pr__nfet_01v8 ad=0 pd=0 as=0 ps=0 w=600 l=30
X63 VDD m2_1012_537 m2_2566_537 VDD sky130_fd_pr__pfet_01v8 ad=0 pd=0 as=69.6n ps=2.75m w=400 l=30
X64 m2_2566_537 m2_1012_537 VDD VDD sky130_fd_pr__pfet_01v8 ad=0 pd=0 as=0 ps=0 w=400 l=30
X65 VDD SN m2_2566_537 VDD sky130_fd_pr__pfet_01v8 ad=0 pd=0 as=0 ps=0 w=400 l=30
X66 m2_2566_537 SN VDD VDD sky130_fd_pr__pfet_01v8 ad=0 pd=0 as=0 ps=0 w=400 l=30
X67 VDD m2_3231_759 m2_2566_537 VDD sky130_fd_pr__pfet_01v8 ad=0 pd=0 as=0 ps=0 w=400 l=30
X68 m2_2566_537 m2_3231_759 VDD VDD sky130_fd_pr__pfet_01v8 ad=0 pd=0 as=0 ps=0 w=400 l=30
X69 GND m2_2566_537 x70/a_0_0 GND sky130_fd_pr__nfet_01v8 ad=0 pd=0 as=77.2n ps=2.61m w=602 l=30
X71 m2_3231_759 CLK x70/a_0_0 GND sky130_fd_pr__nfet_01v8 ad=7.16n pd=0.314m as=0 ps=0 w=602 l=30
X72 VDD m2_2566_537 m2_3231_759 VDD sky130_fd_pr__pfet_01v8 ad=0 pd=0 as=46.4n ps=1.83m w=400 l=30
X73 m2_3231_759 m2_2566_537 VDD VDD sky130_fd_pr__pfet_01v8 ad=0 pd=0 as=0 ps=0 w=400 l=30
X74 VDD CLK m2_3231_759 VDD sky130_fd_pr__pfet_01v8 ad=0 pd=0 as=0 ps=0 w=400 l=30
X75 m2_3231_759 CLK VDD VDD sky130_fd_pr__pfet_01v8 ad=0 pd=0 as=0 ps=0 w=400 l=30
X76 GND m2_6487_833 x77/a_0_0 GND sky130_fd_pr__nfet_01v8 ad=0 pd=0 as=77.2n ps=2.61m w=602 l=30
X78 m1_8724_525 m1_8575_821 x77/a_0_0 GND sky130_fd_pr__nfet_01v8 ad=1p pd=-87u as=0 ps=0 w=602 l=30
X79 VDD m2_6487_833 m1_8724_525 VDD sky130_fd_pr__pfet_01v8 ad=0 pd=0 as=46.4n ps=1.83m w=400 l=30
X80 m1_8724_525 m2_6487_833 VDD VDD sky130_fd_pr__pfet_01v8 ad=0 pd=0 as=0 ps=0 w=400 l=30
X81 VDD m1_8575_821 m1_8724_525 VDD sky130_fd_pr__pfet_01v8 ad=0 pd=0 as=0 ps=0 w=400 l=30
X82 m1_8724_525 m1_8575_821 VDD VDD sky130_fd_pr__pfet_01v8 ad=0 pd=0 as=0 ps=0 w=400 l=30
X83 GND D x84/a_0_0 GND sky130_fd_pr__nfet_01v8 ad=0 pd=0 as=77.2n ps=2.61m w=602 l=30
X85 x86/m1_486_486 m2_6487_833 x84/a_0_0 GND sky130_fd_pr__nfet_01v8 ad=-7.16n pd=-0.488m as=0 ps=0 w=602 l=30
X87 VDD D x86/m1_486_486 VDD sky130_fd_pr__pfet_01v8 ad=0 pd=0 as=46.4n ps=1.83m w=400 l=30
X88 x86/m1_486_486 D VDD VDD sky130_fd_pr__pfet_01v8 ad=0 pd=0 as=0 ps=0 w=400 l=30
X89 VDD m2_6487_833 x86/m1_486_486 VDD sky130_fd_pr__pfet_01v8 ad=0 pd=0 as=0 ps=0 w=400 l=30
X90 x86/m1_486_486 m2_6487_833 VDD VDD sky130_fd_pr__pfet_01v8 ad=0 pd=0 as=0 ps=0 w=400 l=30
X91 GND x86/m1_486_486 x92/a_0_0 GND sky130_fd_pr__nfet_01v8 ad=0 pd=0 as=78.2n ps=2.61m w=602 l=30
X93 m2_6487_833 m2_8115_759 x94/li_393_182 GND sky130_fd_pr__nfet_01v8 ad=1p pd=-87u as=52.7n ps=1.92m w=602 l=30
X95 x94/li_393_182 CLK x92/a_0_0 GND sky130_fd_pr__nfet_01v8 ad=0 pd=0 as=0 ps=0 w=600 l=30
X96 VDD x86/m1_486_486 m2_6487_833 VDD sky130_fd_pr__pfet_01v8 ad=0 pd=0 as=69.6n ps=2.75m w=400 l=30
X97 m2_6487_833 x86/m1_486_486 VDD VDD sky130_fd_pr__pfet_01v8 ad=0 pd=0 as=0 ps=0 w=400 l=30
X98 VDD CLK m2_6487_833 VDD sky130_fd_pr__pfet_01v8 ad=0 pd=0 as=0 ps=0 w=400 l=30
X99 m2_6487_833 CLK VDD VDD sky130_fd_pr__pfet_01v8 ad=0 pd=0 as=0 ps=0 w=400 l=30
X100 VDD m2_8115_759 m2_6487_833 VDD sky130_fd_pr__pfet_01v8 ad=0 pd=0 as=0 ps=0 w=400 l=30
X101 m2_6487_833 m2_8115_759 VDD VDD sky130_fd_pr__pfet_01v8 ad=0 pd=0 as=0 ps=0 w=400 l=30
X102 GND m1_8724_525 x103/a_0_0 GND sky130_fd_pr__nfet_01v8 ad=0 pd=0 as=78.2n ps=2.61m w=602 l=30
X104 m1_8575_821 m2_8115_759 x105/li_393_182 GND sky130_fd_pr__nfet_01v8 ad=7.16n pd=0.314m as=52.7n ps=1.92m w=602 l=30
X106 x105/li_393_182 SN x103/a_0_0 GND sky130_fd_pr__nfet_01v8 ad=0 pd=0 as=0 ps=0 w=600 l=30
X107 VDD m1_8724_525 m1_8575_821 VDD sky130_fd_pr__pfet_01v8 ad=0 pd=0 as=69.6n ps=2.75m w=400 l=30
X108 m1_8575_821 m1_8724_525 VDD VDD sky130_fd_pr__pfet_01v8 ad=0 pd=0 as=0 ps=0 w=400 l=30
X109 VDD SN m1_8575_821 VDD sky130_fd_pr__pfet_01v8 ad=0 pd=0 as=0 ps=0 w=400 l=30
X110 m1_8575_821 SN VDD VDD sky130_fd_pr__pfet_01v8 ad=0 pd=0 as=0 ps=0 w=400 l=30
X111 VDD m2_8115_759 m1_8575_821 VDD sky130_fd_pr__pfet_01v8 ad=0 pd=0 as=0 ps=0 w=400 l=30
X112 m1_8575_821 m2_8115_759 VDD VDD sky130_fd_pr__pfet_01v8 ad=0 pd=0 as=0 ps=0 w=400 l=30
X113 GND x86/m1_486_486 x114/a_0_0 GND sky130_fd_pr__nfet_01v8 ad=0 pd=0 as=78.2n ps=2.61m w=602 l=30
X115 m2_7450_537 m2_8115_759 x116/li_393_182 GND sky130_fd_pr__nfet_01v8 ad=1p pd=-87u as=52.7n ps=1.92m w=602 l=30
X117 x116/li_393_182 SN x114/a_0_0 GND sky130_fd_pr__nfet_01v8 ad=0 pd=0 as=0 ps=0 w=600 l=30
X118 VDD x86/m1_486_486 m2_7450_537 VDD sky130_fd_pr__pfet_01v8 ad=0 pd=0 as=69.6n ps=2.75m w=400 l=30
X119 m2_7450_537 x86/m1_486_486 VDD VDD sky130_fd_pr__pfet_01v8 ad=0 pd=0 as=0 ps=0 w=400 l=30
X120 VDD SN m2_7450_537 VDD sky130_fd_pr__pfet_01v8 ad=0 pd=0 as=0 ps=0 w=400 l=30
X121 m2_7450_537 SN VDD VDD sky130_fd_pr__pfet_01v8 ad=0 pd=0 as=0 ps=0 w=400 l=30
X122 VDD m2_8115_759 m2_7450_537 VDD sky130_fd_pr__pfet_01v8 ad=0 pd=0 as=0 ps=0 w=400 l=30
X123 m2_7450_537 m2_8115_759 VDD VDD sky130_fd_pr__pfet_01v8 ad=0 pd=0 as=0 ps=0 w=400 l=30
X124 GND m2_7450_537 x125/a_0_0 GND sky130_fd_pr__nfet_01v8 ad=0 pd=0 as=77.2n ps=2.61m w=602 l=30
X126 m2_8115_759 CLK x125/a_0_0 GND sky130_fd_pr__nfet_01v8 ad=7.16n pd=0.314m as=0 ps=0 w=602 l=30
X127 VDD m2_7450_537 m2_8115_759 VDD sky130_fd_pr__pfet_01v8 ad=0 pd=0 as=46.4n ps=1.83m w=400 l=30
X128 m2_8115_759 m2_7450_537 VDD VDD sky130_fd_pr__pfet_01v8 ad=0 pd=0 as=0 ps=0 w=400 l=30
X129 VDD CLK m2_8115_759 VDD sky130_fd_pr__pfet_01v8 ad=0 pd=0 as=0 ps=0 w=400 l=30
X130 m2_8115_759 CLK VDD VDD sky130_fd_pr__pfet_01v8 ad=0 pd=0 as=0 ps=0 w=400 l=30
X131 GND m2_11371_833 x132/a_0_0 GND sky130_fd_pr__nfet_01v8 ad=0 pd=0 as=77.2n ps=2.61m w=602 l=30
X133 m2_14925_907 m1_13461_821 x132/a_0_0 GND sky130_fd_pr__nfet_01v8 ad=-14.3n pd=-1.24m as=0 ps=0 w=602 l=30
X134 VDD m2_11371_833 m2_14925_907 VDD sky130_fd_pr__pfet_01v8 ad=0 pd=0 as=46.4n ps=1.83m w=400 l=30
X135 m2_14925_907 m2_11371_833 VDD VDD sky130_fd_pr__pfet_01v8 ad=0 pd=0 as=0 ps=0 w=400 l=30
X136 VDD m1_13461_821 m2_14925_907 VDD sky130_fd_pr__pfet_01v8 ad=0 pd=0 as=0 ps=0 w=400 l=30
X137 m2_14925_907 m1_13461_821 VDD VDD sky130_fd_pr__pfet_01v8 ad=0 pd=0 as=0 ps=0 w=400 l=30
X138 GND D x139/a_0_0 GND sky130_fd_pr__nfet_01v8 ad=0 pd=0 as=77.2n ps=2.61m w=602 l=30
X140 m2_10780_537 m2_11371_833 x139/a_0_0 GND sky130_fd_pr__nfet_01v8 ad=-7.16n pd=-0.488m as=0 ps=0 w=602 l=30
X141 VDD D m2_10780_537 VDD sky130_fd_pr__pfet_01v8 ad=0 pd=0 as=46.4n ps=1.83m w=400 l=30
X142 m2_10780_537 D VDD VDD sky130_fd_pr__pfet_01v8 ad=0 pd=0 as=0 ps=0 w=400 l=30
X143 VDD m2_11371_833 m2_10780_537 VDD sky130_fd_pr__pfet_01v8 ad=0 pd=0 as=0 ps=0 w=400 l=30
X144 m2_10780_537 m2_11371_833 VDD VDD sky130_fd_pr__pfet_01v8 ad=0 pd=0 as=0 ps=0 w=400 l=30
X145 GND m2_10780_537 x146/a_0_0 GND sky130_fd_pr__nfet_01v8 ad=0 pd=0 as=78.2n ps=2.61m w=602 l=30
X147 m2_11371_833 m2_12999_759 x148/li_393_182 GND sky130_fd_pr__nfet_01v8 ad=1p pd=-87u as=52.7n ps=1.92m w=602 l=30
X149 x148/li_393_182 CLK x146/a_0_0 GND sky130_fd_pr__nfet_01v8 ad=0 pd=0 as=0 ps=0 w=600 l=30
X150 VDD m2_10780_537 m2_11371_833 VDD sky130_fd_pr__pfet_01v8 ad=0 pd=0 as=69.6n ps=2.75m w=400 l=30
X151 m2_11371_833 m2_10780_537 VDD VDD sky130_fd_pr__pfet_01v8 ad=0 pd=0 as=0 ps=0 w=400 l=30
X152 VDD CLK m2_11371_833 VDD sky130_fd_pr__pfet_01v8 ad=0 pd=0 as=0 ps=0 w=400 l=30
X153 m2_11371_833 CLK VDD VDD sky130_fd_pr__pfet_01v8 ad=0 pd=0 as=0 ps=0 w=400 l=30
X154 VDD m2_12999_759 m2_11371_833 VDD sky130_fd_pr__pfet_01v8 ad=0 pd=0 as=0 ps=0 w=400 l=30
X155 m2_11371_833 m2_12999_759 VDD VDD sky130_fd_pr__pfet_01v8 ad=0 pd=0 as=0 ps=0 w=400 l=30
X156 GND m2_14925_907 x157/a_0_0 GND sky130_fd_pr__nfet_01v8 ad=0 pd=0 as=78.2n ps=2.61m w=602 l=30
X158 m1_13461_821 m2_12999_759 x159/li_393_182 GND sky130_fd_pr__nfet_01v8 ad=7.16n pd=0.314m as=52.7n ps=1.92m w=602 l=30
X160 x159/li_393_182 SN x157/a_0_0 GND sky130_fd_pr__nfet_01v8 ad=0 pd=0 as=0 ps=0 w=600 l=30
X161 VDD m2_14925_907 m1_13461_821 VDD sky130_fd_pr__pfet_01v8 ad=0 pd=0 as=69.6n ps=2.75m w=400 l=30
X162 m1_13461_821 m2_14925_907 VDD VDD sky130_fd_pr__pfet_01v8 ad=0 pd=0 as=0 ps=0 w=400 l=30
X163 VDD SN m1_13461_821 VDD sky130_fd_pr__pfet_01v8 ad=0 pd=0 as=0 ps=0 w=400 l=30
X164 m1_13461_821 SN VDD VDD sky130_fd_pr__pfet_01v8 ad=0 pd=0 as=0 ps=0 w=400 l=30
X165 VDD m2_12999_759 m1_13461_821 VDD sky130_fd_pr__pfet_01v8 ad=0 pd=0 as=0 ps=0 w=400 l=30
X166 m1_13461_821 m2_12999_759 VDD VDD sky130_fd_pr__pfet_01v8 ad=0 pd=0 as=0 ps=0 w=400 l=30
X167 GND m2_10780_537 x168/a_0_0 GND sky130_fd_pr__nfet_01v8 ad=0 pd=0 as=78.2n ps=2.61m w=602 l=30
X169 m2_12334_537 m2_12999_759 x170/li_393_182 GND sky130_fd_pr__nfet_01v8 ad=1p pd=-87u as=52.7n ps=1.92m w=602 l=30
X171 x170/li_393_182 SN x168/a_0_0 GND sky130_fd_pr__nfet_01v8 ad=0 pd=0 as=0 ps=0 w=600 l=30
X172 VDD m2_10780_537 m2_12334_537 VDD sky130_fd_pr__pfet_01v8 ad=0 pd=0 as=69.6n ps=2.75m w=400 l=30
X173 m2_12334_537 m2_10780_537 VDD VDD sky130_fd_pr__pfet_01v8 ad=0 pd=0 as=0 ps=0 w=400 l=30
X174 VDD SN m2_12334_537 VDD sky130_fd_pr__pfet_01v8 ad=0 pd=0 as=0 ps=0 w=400 l=30
X175 m2_12334_537 SN VDD VDD sky130_fd_pr__pfet_01v8 ad=0 pd=0 as=0 ps=0 w=400 l=30
X176 VDD m2_12999_759 m2_12334_537 VDD sky130_fd_pr__pfet_01v8 ad=0 pd=0 as=0 ps=0 w=400 l=30
X177 m2_12334_537 m2_12999_759 VDD VDD sky130_fd_pr__pfet_01v8 ad=0 pd=0 as=0 ps=0 w=400 l=30
X178 GND m2_12334_537 x179/a_0_0 GND sky130_fd_pr__nfet_01v8 ad=0 pd=0 as=77.2n ps=2.61m w=602 l=30
X180 m2_12999_759 CLK x179/a_0_0 GND sky130_fd_pr__nfet_01v8 ad=7.16n pd=0.314m as=0 ps=0 w=602 l=30
X181 VDD m2_12334_537 m2_12999_759 VDD sky130_fd_pr__pfet_01v8 ad=0 pd=0 as=46.4n ps=1.83m w=400 l=30
X182 m2_12999_759 m2_12334_537 VDD VDD sky130_fd_pr__pfet_01v8 ad=0 pd=0 as=0 ps=0 w=400 l=30
X183 VDD CLK m2_12999_759 VDD sky130_fd_pr__pfet_01v8 ad=0 pd=0 as=0 ps=0 w=400 l=30
X184 m2_12999_759 CLK VDD VDD sky130_fd_pr__pfet_01v8 ad=0 pd=0 as=0 ps=0 w=400 l=30
C0 VDD CLK 2.28f
C1 D m1_3838_667 2.97f
C2 m2_11371_833 CLK 2.1f
C3 m1_8724_525 m1_3838_667 3.18f
.ends

** hspice subcircuit dictionary
* x1	votern3x1_pcell_0/nmos_top_0
* x3	votern3x1_pcell_0/nmos_bottom_1
* x5	votern3x1_pcell_0/nmos_bottom_2
* x7	votern3x1_pcell_0
* x23	dffsnx1_pcell_0/nand2x1_pcell_2/nmos_bottom_0
* x30	dffsnx1_pcell_0/nand2x1_pcell_5/nmos_bottom_0
* x37	dffsnx1_pcell_0/nand3x1_pcell_0/nmos_bottom_0
* x39	dffsnx1_pcell_0/nand3x1_pcell_0
* x48	dffsnx1_pcell_0/nand3x1_pcell_1/nmos_bottom_0
* x50	dffsnx1_pcell_0/nand3x1_pcell_1
* x59	dffsnx1_pcell_0/nand3x1_pcell_2/nmos_bottom_0
* x61	dffsnx1_pcell_0/nand3x1_pcell_2
* x70	dffsnx1_pcell_0/nand2x1_pcell_0/nmos_bottom_0
* x77	dffsnx1_pcell_1/nand2x1_pcell_2/nmos_bottom_0
* x84	dffsnx1_pcell_1/nand2x1_pcell_5/nmos_bottom_0
* x86	dffsnx1_pcell_1
* x92	dffsnx1_pcell_1/nand3x1_pcell_0/nmos_bottom_0
* x94	dffsnx1_pcell_1/nand3x1_pcell_0
* x103	dffsnx1_pcell_1/nand3x1_pcell_1/nmos_bottom_0
* x105	dffsnx1_pcell_1/nand3x1_pcell_1
* x114	dffsnx1_pcell_1/nand3x1_pcell_2/nmos_bottom_0
* x116	dffsnx1_pcell_1/nand3x1_pcell_2
* x125	dffsnx1_pcell_1/nand2x1_pcell_0/nmos_bottom_0
* x132	dffsnx1_pcell_2/nand2x1_pcell_2/nmos_bottom_0
* x139	dffsnx1_pcell_2/nand2x1_pcell_5/nmos_bottom_0
* x146	dffsnx1_pcell_2/nand3x1_pcell_0/nmos_bottom_0
* x148	dffsnx1_pcell_2/nand3x1_pcell_0
* x157	dffsnx1_pcell_2/nand3x1_pcell_1/nmos_bottom_0
* x159	dffsnx1_pcell_2/nand3x1_pcell_1
* x168	dffsnx1_pcell_2/nand3x1_pcell_2/nmos_bottom_0
* x170	dffsnx1_pcell_2/nand3x1_pcell_2
* x179	dffsnx1_pcell_2/nand2x1_pcell_0/nmos_bottom_0
