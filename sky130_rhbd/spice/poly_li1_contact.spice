* HSPICE file created from poly_li1_contact.ext - technology: sky130A

.option scale=5m

.subckt poly_li1_contact
.ends

** hspice subcircuit dictionary
