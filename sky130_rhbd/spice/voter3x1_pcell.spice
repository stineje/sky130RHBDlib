* HSPICE file created from voter3x1_pcell.ext - technology: sky130A

.option scale=5m

.subckt voter3x1_pcell
X0 VSUBS x1/a_834_375 x2/a_0_0 VSUBS sky130_fd_pr__nfet_01v8 ad=2.39n pd=0.111m as=15.7n ps=0.599m w=602 l=30
X3 VSUBS x1/a_834_375 x4/a_0_0 VSUBS sky130_fd_pr__nfet_01v8 ad=88.6n pd=4.3m as=77.2n ps=2.61m w=602 l=30
X5 VSUBS x1/a_1507_944 x6/a_0_0 VSUBS sky130_fd_pr__nfet_01v8 ad=0 pd=0 as=77.2n ps=2.61m w=602 l=30
X7 x1/a_805_1331 x1/a_834_375 x8/w_n87_786 x8/w_n87_786 sky130_fd_pr__pfet_01v8 ad=11.6n pd=0.458m as=22.4n ps=0.912m w=400 l=30
X9 x8/w_n87_786 x1/a_834_375 x1/a_805_1331 x8/w_n87_786 sky130_fd_pr__pfet_01v8 ad=21.6n pd=0.908m as=11.6n ps=0.458m w=400 l=30
X10 m1_1818_783 x1/a_1507_944 x4/a_0_0 VSUBS sky130_fd_pr__nfet_01v8 ad=2.39n pd=0.111m as=15.8n ps=0.594m w=602 l=30
X11 x1/a_805_1331 x1/a_362_381 x8/w_n87_786 x8/w_n87_786 sky130_fd_pr__pfet_01v8 ad=0.114u pd=4.57m as=0.111u ps=4.56m w=400 l=30
X12 x8/w_n87_786 x1/a_362_381 x1/a_805_1331 x8/w_n87_786 sky130_fd_pr__pfet_01v8 ad=0 pd=0 as=0 ps=0 w=400 l=30
X13 x14/a_174_n399 x1/a_1507_944 x1/a_805_1331 x8/w_n87_786 sky130_fd_pr__pfet_01v8 ad=23.2n pd=0.916m as=0 ps=0 w=400 l=30
X15 x1/a_805_1331 x1/a_1507_944 x14/a_174_n399 x8/w_n87_786 sky130_fd_pr__pfet_01v8 ad=0 pd=0 as=0 ps=0 w=400 l=30
X16 x1/a_893_1059 x1/a_834_375 x1/a_805_1331 x8/w_n87_786 sky130_fd_pr__pfet_01v8 ad=90.4n pd=3.65m as=0 ps=0 w=400 l=30
X17 x1/a_805_1331 x1/a_834_375 x1/a_893_1059 x8/w_n87_786 sky130_fd_pr__pfet_01v8 ad=0 pd=0 as=0 ps=0 w=400 l=30
X18 m1_1818_783 x1/a_1507_944 x1/a_893_1059 x8/w_n87_786 sky130_fd_pr__pfet_01v8 ad=46.4n pd=1.83m as=0 ps=0 w=400 l=30
X19 x1/a_893_1059 x1/a_1507_944 m1_1818_783 x8/w_n87_786 sky130_fd_pr__pfet_01v8 ad=0 pd=0 as=0 ps=0 w=400 l=30
X20 m1_1818_783 x1/a_362_381 x1/a_893_1059 x8/w_n87_786 sky130_fd_pr__pfet_01v8 ad=0 pd=0 as=0 ps=0 w=400 l=30
X21 x1/a_893_1059 x1/a_362_381 m1_1818_783 x8/w_n87_786 sky130_fd_pr__pfet_01v8 ad=0 pd=0 as=0 ps=0 w=400 l=30
X22 m1_1818_783 x1/a_362_381 x2/a_0_0 VSUBS sky130_fd_pr__nfet_01v8 ad=2.39n pd=0.111m as=15.6n ps=0.592m w=602 l=30
X23 m1_1818_783 x1/a_362_381 x6/a_0_0 VSUBS sky130_fd_pr__nfet_01v8 ad=2.4n pd=0.112m as=15.8n ps=0.594m w=602 l=30
X24 x8/a_206_1059 m1_1818_783 VSUBS VSUBS sky130_fd_pr__nfet_01v8 ad=7.16n pd=0.314m as=0 ps=0 w=602 l=30
X25 x8/w_n87_786 m1_1818_783 x8/a_206_1059 x8/w_n87_786 sky130_fd_pr__pfet_01v8 ad=21.6n pd=0.908m as=11.6n ps=0.458m w=400 l=30
X26 x8/a_206_1059 m1_1818_783 x8/w_n87_786 x8/w_n87_786 sky130_fd_pr__pfet_01v8 ad=11.6n pd=0.458m as=22.4n ps=0.912m w=400 l=30
.ends

** hspice subcircuit dictionary
* x1	votern3x1_pcell_0
* x2	votern3x1_pcell_0/nmos_top_0
* x4	votern3x1_pcell_0/nmos_bottom_1
* x6	votern3x1_pcell_0/nmos_bottom_2
* x8	invx1_pcell_0
* x14	votern3x1_pcell_0/pmos2_1_2
