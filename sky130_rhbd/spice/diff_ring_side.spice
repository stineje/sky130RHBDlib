* HSPICE file created from diff_ring_side.ext - technology: sky130A

.option scale=5m

.subckt diff_ring_side
.ends

** hspice subcircuit dictionary
