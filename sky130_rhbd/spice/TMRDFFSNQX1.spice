* HSPICE file created from TMRDFFSNQX1.ext - technology: sky130A

.option scale=5m

.subckt TMRDFFSNQX1 Q D CLK SN VDD GND
X0 GND m1_13464_896 x1/a_0_0 GND sky130_fd_pr__nfet_01v8 ad=2.39n pd=0.111m as=15.7n ps=0.599m w=602 l=30
X2 GND m1_13464_896 x3/a_0_0 GND sky130_fd_pr__nfet_01v8 ad=0.347u pd=0.0172 as=77.2n ps=2.61m w=602 l=30
X4 GND m1_3692_667 x5/a_0_0 GND sky130_fd_pr__nfet_01v8 ad=0 pd=0 as=77.2n ps=2.61m w=602 l=30
X6 x7/a_805_1331 m1_13464_896 VDD VDD sky130_fd_pr__pfet_01v8 ad=11.6n pd=0.458m as=22.4n ps=0.912m w=400 l=30
X8 VDD m1_13464_896 x7/a_805_1331 VDD sky130_fd_pr__pfet_01v8 ad=21.6n pd=0.908m as=11.6n ps=0.458m w=400 l=30
X9 x10/m1_1818_783 m1_3692_667 x3/a_0_0 GND sky130_fd_pr__nfet_01v8 ad=2.39n pd=0.111m as=15.8n ps=0.594m w=602 l=30
X11 x7/a_805_1331 m1_9685_525 VDD VDD sky130_fd_pr__pfet_01v8 ad=0.114u pd=4.57m as=1.49u ps=0.0602 w=400 l=30
X12 VDD m1_9685_525 x7/a_805_1331 VDD sky130_fd_pr__pfet_01v8 ad=0 pd=0 as=0 ps=0 w=400 l=30
X13 x14/a_174_n399 m1_3692_667 x7/a_805_1331 VDD sky130_fd_pr__pfet_01v8 ad=23.2n pd=0.916m as=0 ps=0 w=400 l=30
X15 x7/a_805_1331 m1_3692_667 x14/a_174_n399 VDD sky130_fd_pr__pfet_01v8 ad=0 pd=0 as=0 ps=0 w=400 l=30
X16 x7/a_893_1059 m1_13464_896 x7/a_805_1331 VDD sky130_fd_pr__pfet_01v8 ad=90.4n pd=3.65m as=0 ps=0 w=400 l=30
X17 x7/a_805_1331 m1_13464_896 x7/a_893_1059 VDD sky130_fd_pr__pfet_01v8 ad=0 pd=0 as=0 ps=0 w=400 l=30
X18 x10/m1_1818_783 m1_3692_667 x7/a_893_1059 VDD sky130_fd_pr__pfet_01v8 ad=46.4n pd=1.83m as=0 ps=0 w=400 l=30
X19 x7/a_893_1059 m1_3692_667 x10/m1_1818_783 VDD sky130_fd_pr__pfet_01v8 ad=0 pd=0 as=0 ps=0 w=400 l=30
X20 x10/m1_1818_783 m1_9685_525 x7/a_893_1059 VDD sky130_fd_pr__pfet_01v8 ad=0 pd=0 as=0 ps=0 w=400 l=30
X21 x7/a_893_1059 m1_9685_525 x10/m1_1818_783 VDD sky130_fd_pr__pfet_01v8 ad=0 pd=0 as=0 ps=0 w=400 l=30
X22 x10/m1_1818_783 m1_9685_525 x1/a_0_0 GND sky130_fd_pr__nfet_01v8 ad=2.39n pd=0.111m as=15.6n ps=0.592m w=602 l=30
X23 x10/m1_1818_783 m1_9685_525 x5/a_0_0 GND sky130_fd_pr__nfet_01v8 ad=2.4n pd=0.112m as=15.8n ps=0.594m w=602 l=30
X24 Q x10/m1_1818_783 GND GND sky130_fd_pr__nfet_01v8 ad=7.16n pd=0.314m as=0 ps=0 w=602 l=30
X25 VDD x10/m1_1818_783 Q VDD sky130_fd_pr__pfet_01v8 ad=21.6n pd=0.908m as=11.6n ps=0.458m w=400 l=30
X26 Q x10/m1_1818_783 VDD VDD sky130_fd_pr__pfet_01v8 ad=11.6n pd=0.458m as=22.4n ps=0.912m w=400 l=30
X27 GND x28/m1_338_781 x29/a_0_0 GND sky130_fd_pr__nfet_01v8 ad=0 pd=0 as=77.2n ps=2.61m w=602 l=30
X30 m1_3840_821 m1_3692_667 x29/a_0_0 GND sky130_fd_pr__nfet_01v8 ad=1p pd=-87u as=0 ps=0 w=602 l=30
X31 VDD x28/m1_338_781 m1_3840_821 VDD sky130_fd_pr__pfet_01v8 ad=0 pd=0 as=46.4n ps=1.83m w=400 l=30
X32 m1_3840_821 x28/m1_338_781 VDD VDD sky130_fd_pr__pfet_01v8 ad=0 pd=0 as=0 ps=0 w=400 l=30
X33 VDD m1_3692_667 m1_3840_821 VDD sky130_fd_pr__pfet_01v8 ad=0 pd=0 as=0 ps=0 w=400 l=30
X34 m1_3840_821 m1_3692_667 VDD VDD sky130_fd_pr__pfet_01v8 ad=0 pd=0 as=0 ps=0 w=400 l=30
X35 GND D x36/a_0_0 GND sky130_fd_pr__nfet_01v8 ad=0 pd=0 as=77.2n ps=2.61m w=602 l=30
X37 x28/m1_486_486 x28/m1_338_781 x36/a_0_0 GND sky130_fd_pr__nfet_01v8 ad=-7.16n pd=-0.488m as=0 ps=0 w=602 l=30
X38 VDD D x28/m1_486_486 VDD sky130_fd_pr__pfet_01v8 ad=0 pd=0 as=46.4n ps=1.83m w=400 l=30
X39 x28/m1_486_486 D VDD VDD sky130_fd_pr__pfet_01v8 ad=0 pd=0 as=0 ps=0 w=400 l=30
X40 VDD x28/m1_338_781 x28/m1_486_486 VDD sky130_fd_pr__pfet_01v8 ad=0 pd=0 as=0 ps=0 w=400 l=30
X41 x28/m1_486_486 x28/m1_338_781 VDD VDD sky130_fd_pr__pfet_01v8 ad=0 pd=0 as=0 ps=0 w=400 l=30
X42 GND x28/m1_486_486 x43/a_0_0 GND sky130_fd_pr__nfet_01v8 ad=0 pd=0 as=78.2n ps=2.61m w=602 l=30
X44 x28/m1_338_781 x28/m1_1301_705 x45/li_393_182 GND sky130_fd_pr__nfet_01v8 ad=1p pd=-87u as=52.7n ps=1.92m w=602 l=30
X46 x45/li_393_182 CLK x43/a_0_0 GND sky130_fd_pr__nfet_01v8 ad=2.18n pd=0.106m as=16.2n ps=0.604m w=600 l=30
X47 VDD x28/m1_486_486 x28/m1_338_781 VDD sky130_fd_pr__pfet_01v8 ad=0 pd=0 as=69.6n ps=2.75m w=400 l=30
X48 x28/m1_338_781 x28/m1_486_486 VDD VDD sky130_fd_pr__pfet_01v8 ad=0 pd=0 as=0 ps=0 w=400 l=30
X49 VDD CLK x28/m1_338_781 VDD sky130_fd_pr__pfet_01v8 ad=0 pd=0 as=0 ps=0 w=400 l=30
X50 x28/m1_338_781 CLK VDD VDD sky130_fd_pr__pfet_01v8 ad=0 pd=0 as=0 ps=0 w=400 l=30
X51 VDD x28/m1_1301_705 x28/m1_338_781 VDD sky130_fd_pr__pfet_01v8 ad=0 pd=0 as=0 ps=0 w=400 l=30
X52 x28/m1_338_781 x28/m1_1301_705 VDD VDD sky130_fd_pr__pfet_01v8 ad=0 pd=0 as=0 ps=0 w=400 l=30
X53 GND m1_3840_821 x54/a_0_0 GND sky130_fd_pr__nfet_01v8 ad=0 pd=0 as=78.2n ps=2.61m w=602 l=30
X55 m1_3692_667 x28/m1_1301_705 x56/li_393_182 GND sky130_fd_pr__nfet_01v8 ad=1p pd=-0.263m as=52.7n ps=1.92m w=602 l=30
X57 x56/li_393_182 SN x54/a_0_0 GND sky130_fd_pr__nfet_01v8 ad=0 pd=0 as=0 ps=0 w=600 l=30
X58 VDD m1_3840_821 m1_3692_667 VDD sky130_fd_pr__pfet_01v8 ad=0 pd=0 as=69.6n ps=2.75m w=400 l=30
X59 m1_3692_667 m1_3840_821 VDD VDD sky130_fd_pr__pfet_01v8 ad=0 pd=0 as=0 ps=0 w=400 l=30
X60 VDD SN m1_3692_667 VDD sky130_fd_pr__pfet_01v8 ad=0 pd=0 as=0 ps=0 w=400 l=30
X61 m1_3692_667 SN VDD VDD sky130_fd_pr__pfet_01v8 ad=0 pd=0 as=0 ps=0 w=400 l=30
X62 VDD x28/m1_1301_705 m1_3692_667 VDD sky130_fd_pr__pfet_01v8 ad=0 pd=0 as=0 ps=0 w=400 l=30
X63 m1_3692_667 x28/m1_1301_705 VDD VDD sky130_fd_pr__pfet_01v8 ad=0 pd=0 as=0 ps=0 w=400 l=30
X64 GND x28/m1_486_486 x65/a_0_0 GND sky130_fd_pr__nfet_01v8 ad=0 pd=0 as=78.2n ps=2.61m w=602 l=30
X66 x28/m1_2410_489 x28/m1_1301_705 x67/li_393_182 GND sky130_fd_pr__nfet_01v8 ad=1p pd=-87u as=52.7n ps=1.92m w=602 l=30
X68 x67/li_393_182 SN x65/a_0_0 GND sky130_fd_pr__nfet_01v8 ad=0 pd=0 as=0 ps=0 w=600 l=30
X69 VDD x28/m1_486_486 x28/m1_2410_489 VDD sky130_fd_pr__pfet_01v8 ad=0 pd=0 as=69.6n ps=2.75m w=400 l=30
X70 x28/m1_2410_489 x28/m1_486_486 VDD VDD sky130_fd_pr__pfet_01v8 ad=0 pd=0 as=0 ps=0 w=400 l=30
X71 VDD SN x28/m1_2410_489 VDD sky130_fd_pr__pfet_01v8 ad=0 pd=0 as=0 ps=0 w=400 l=30
X72 x28/m1_2410_489 SN VDD VDD sky130_fd_pr__pfet_01v8 ad=0 pd=0 as=0 ps=0 w=400 l=30
X73 VDD x28/m1_1301_705 x28/m1_2410_489 VDD sky130_fd_pr__pfet_01v8 ad=0 pd=0 as=0 ps=0 w=400 l=30
X74 x28/m1_2410_489 x28/m1_1301_705 VDD VDD sky130_fd_pr__pfet_01v8 ad=0 pd=0 as=0 ps=0 w=400 l=30
X75 GND x28/m1_2410_489 x76/a_0_0 GND sky130_fd_pr__nfet_01v8 ad=0 pd=0 as=77.2n ps=2.61m w=602 l=30
X77 x28/m1_1301_705 CLK x76/a_0_0 GND sky130_fd_pr__nfet_01v8 ad=7.16n pd=0.314m as=0 ps=0 w=602 l=30
X78 VDD x28/m1_2410_489 x28/m1_1301_705 VDD sky130_fd_pr__pfet_01v8 ad=0 pd=0 as=46.4n ps=1.83m w=400 l=30
X79 x28/m1_1301_705 x28/m1_2410_489 VDD VDD sky130_fd_pr__pfet_01v8 ad=0 pd=0 as=0 ps=0 w=400 l=30
X80 VDD CLK x28/m1_1301_705 VDD sky130_fd_pr__pfet_01v8 ad=0 pd=0 as=0 ps=0 w=400 l=30
X81 x28/m1_1301_705 CLK VDD VDD sky130_fd_pr__pfet_01v8 ad=0 pd=0 as=0 ps=0 w=400 l=30
X82 GND x83/m1_338_781 x84/a_0_0 GND sky130_fd_pr__nfet_01v8 ad=0 pd=0 as=77.2n ps=2.61m w=602 l=30
X85 m1_8723_525 m1_9685_525 x84/a_0_0 GND sky130_fd_pr__nfet_01v8 ad=1p pd=-87u as=0 ps=0 w=602 l=30
X86 VDD x83/m1_338_781 m1_8723_525 VDD sky130_fd_pr__pfet_01v8 ad=0 pd=0 as=46.4n ps=1.83m w=400 l=30
X87 m1_8723_525 x83/m1_338_781 VDD VDD sky130_fd_pr__pfet_01v8 ad=0 pd=0 as=0 ps=0 w=400 l=30
X88 VDD m1_9685_525 m1_8723_525 VDD sky130_fd_pr__pfet_01v8 ad=0 pd=0 as=0 ps=0 w=400 l=30
X89 m1_8723_525 m1_9685_525 VDD VDD sky130_fd_pr__pfet_01v8 ad=0 pd=0 as=0 ps=0 w=400 l=30
X90 GND D x91/a_0_0 GND sky130_fd_pr__nfet_01v8 ad=0 pd=0 as=77.2n ps=2.61m w=602 l=30
X92 x83/m1_486_486 x83/m1_338_781 x91/a_0_0 GND sky130_fd_pr__nfet_01v8 ad=-7.16n pd=-0.488m as=0 ps=0 w=602 l=30
X93 VDD D x83/m1_486_486 VDD sky130_fd_pr__pfet_01v8 ad=0 pd=0 as=46.4n ps=1.83m w=400 l=30
X94 x83/m1_486_486 D VDD VDD sky130_fd_pr__pfet_01v8 ad=0 pd=0 as=0 ps=0 w=400 l=30
X95 VDD x83/m1_338_781 x83/m1_486_486 VDD sky130_fd_pr__pfet_01v8 ad=0 pd=0 as=0 ps=0 w=400 l=30
X96 x83/m1_486_486 x83/m1_338_781 VDD VDD sky130_fd_pr__pfet_01v8 ad=0 pd=0 as=0 ps=0 w=400 l=30
X97 GND x83/m1_486_486 x98/a_0_0 GND sky130_fd_pr__nfet_01v8 ad=0 pd=0 as=78.2n ps=2.61m w=602 l=30
X99 x83/m1_338_781 x83/m1_1301_705 x100/li_393_182 GND sky130_fd_pr__nfet_01v8 ad=1p pd=-87u as=52.7n ps=1.92m w=602 l=30
X101 x100/li_393_182 CLK x98/a_0_0 GND sky130_fd_pr__nfet_01v8 ad=0 pd=0 as=0 ps=0 w=600 l=30
X102 VDD x83/m1_486_486 x83/m1_338_781 VDD sky130_fd_pr__pfet_01v8 ad=0 pd=0 as=69.6n ps=2.75m w=400 l=30
X103 x83/m1_338_781 x83/m1_486_486 VDD VDD sky130_fd_pr__pfet_01v8 ad=0 pd=0 as=0 ps=0 w=400 l=30
X104 VDD CLK x83/m1_338_781 VDD sky130_fd_pr__pfet_01v8 ad=0 pd=0 as=0 ps=0 w=400 l=30
X105 x83/m1_338_781 CLK VDD VDD sky130_fd_pr__pfet_01v8 ad=0 pd=0 as=0 ps=0 w=400 l=30
X106 VDD x83/m1_1301_705 x83/m1_338_781 VDD sky130_fd_pr__pfet_01v8 ad=0 pd=0 as=0 ps=0 w=400 l=30
X107 x83/m1_338_781 x83/m1_1301_705 VDD VDD sky130_fd_pr__pfet_01v8 ad=0 pd=0 as=0 ps=0 w=400 l=30
X108 GND m1_8723_525 x109/a_0_0 GND sky130_fd_pr__nfet_01v8 ad=0 pd=0 as=78.2n ps=2.61m w=602 l=30
X110 m1_9685_525 x83/m1_1301_705 x111/li_393_182 GND sky130_fd_pr__nfet_01v8 ad=7.16n pd=0.314m as=52.7n ps=1.92m w=602 l=30
X112 x111/li_393_182 SN x109/a_0_0 GND sky130_fd_pr__nfet_01v8 ad=0 pd=0 as=0 ps=0 w=600 l=30
X113 VDD m1_8723_525 m1_9685_525 VDD sky130_fd_pr__pfet_01v8 ad=0 pd=0 as=69.6n ps=2.75m w=400 l=30
X114 m1_9685_525 m1_8723_525 VDD VDD sky130_fd_pr__pfet_01v8 ad=0 pd=0 as=0 ps=0 w=400 l=30
X115 VDD SN m1_9685_525 VDD sky130_fd_pr__pfet_01v8 ad=0 pd=0 as=0 ps=0 w=400 l=30
X116 m1_9685_525 SN VDD VDD sky130_fd_pr__pfet_01v8 ad=0 pd=0 as=0 ps=0 w=400 l=30
X117 VDD x83/m1_1301_705 m1_9685_525 VDD sky130_fd_pr__pfet_01v8 ad=0 pd=0 as=0 ps=0 w=400 l=30
X118 m1_9685_525 x83/m1_1301_705 VDD VDD sky130_fd_pr__pfet_01v8 ad=0 pd=0 as=0 ps=0 w=400 l=30
X119 GND x83/m1_486_486 x120/a_0_0 GND sky130_fd_pr__nfet_01v8 ad=0 pd=0 as=78.2n ps=2.61m w=602 l=30
X121 x83/m1_2410_489 x83/m1_1301_705 x122/li_393_182 GND sky130_fd_pr__nfet_01v8 ad=1p pd=-87u as=52.7n ps=1.92m w=602 l=30
X123 x122/li_393_182 SN x120/a_0_0 GND sky130_fd_pr__nfet_01v8 ad=0 pd=0 as=0 ps=0 w=600 l=30
X124 VDD x83/m1_486_486 x83/m1_2410_489 VDD sky130_fd_pr__pfet_01v8 ad=0 pd=0 as=69.6n ps=2.75m w=400 l=30
X125 x83/m1_2410_489 x83/m1_486_486 VDD VDD sky130_fd_pr__pfet_01v8 ad=0 pd=0 as=0 ps=0 w=400 l=30
X126 VDD SN x83/m1_2410_489 VDD sky130_fd_pr__pfet_01v8 ad=0 pd=0 as=0 ps=0 w=400 l=30
X127 x83/m1_2410_489 SN VDD VDD sky130_fd_pr__pfet_01v8 ad=0 pd=0 as=0 ps=0 w=400 l=30
X128 VDD x83/m1_1301_705 x83/m1_2410_489 VDD sky130_fd_pr__pfet_01v8 ad=0 pd=0 as=0 ps=0 w=400 l=30
X129 x83/m1_2410_489 x83/m1_1301_705 VDD VDD sky130_fd_pr__pfet_01v8 ad=0 pd=0 as=0 ps=0 w=400 l=30
X130 GND x83/m1_2410_489 x131/a_0_0 GND sky130_fd_pr__nfet_01v8 ad=0 pd=0 as=77.2n ps=2.61m w=602 l=30
X132 x83/m1_1301_705 CLK x131/a_0_0 GND sky130_fd_pr__nfet_01v8 ad=7.16n pd=0.314m as=0 ps=0 w=602 l=30
X133 VDD x83/m1_2410_489 x83/m1_1301_705 VDD sky130_fd_pr__pfet_01v8 ad=0 pd=0 as=46.4n ps=1.83m w=400 l=30
X134 x83/m1_1301_705 x83/m1_2410_489 VDD VDD sky130_fd_pr__pfet_01v8 ad=0 pd=0 as=0 ps=0 w=400 l=30
X135 VDD CLK x83/m1_1301_705 VDD sky130_fd_pr__pfet_01v8 ad=0 pd=0 as=0 ps=0 w=400 l=30
X136 x83/m1_1301_705 CLK VDD VDD sky130_fd_pr__pfet_01v8 ad=0 pd=0 as=0 ps=0 w=400 l=30
X137 GND x138/m1_338_781 x139/a_0_0 GND sky130_fd_pr__nfet_01v8 ad=0 pd=0 as=77.2n ps=2.61m w=602 l=30
X140 m1_13623_974 m1_13464_896 x139/a_0_0 GND sky130_fd_pr__nfet_01v8 ad=1p pd=-87u as=0 ps=0 w=602 l=30
X141 VDD x138/m1_338_781 m1_13623_974 VDD sky130_fd_pr__pfet_01v8 ad=0 pd=0 as=46.4n ps=1.83m w=400 l=30
X142 m1_13623_974 x138/m1_338_781 VDD VDD sky130_fd_pr__pfet_01v8 ad=0 pd=0 as=0 ps=0 w=400 l=30
X143 VDD m1_13464_896 m1_13623_974 VDD sky130_fd_pr__pfet_01v8 ad=0 pd=0 as=0 ps=0 w=400 l=30
X144 m1_13623_974 m1_13464_896 VDD VDD sky130_fd_pr__pfet_01v8 ad=0 pd=0 as=0 ps=0 w=400 l=30
X145 GND D x146/a_0_0 GND sky130_fd_pr__nfet_01v8 ad=0 pd=0 as=77.2n ps=2.61m w=602 l=30
X147 x138/m1_486_486 x138/m1_338_781 x146/a_0_0 GND sky130_fd_pr__nfet_01v8 ad=-7.16n pd=-0.488m as=0 ps=0 w=602 l=30
X148 VDD D x138/m1_486_486 VDD sky130_fd_pr__pfet_01v8 ad=0 pd=0 as=46.4n ps=1.83m w=400 l=30
X149 x138/m1_486_486 D VDD VDD sky130_fd_pr__pfet_01v8 ad=0 pd=0 as=0 ps=0 w=400 l=30
X150 VDD x138/m1_338_781 x138/m1_486_486 VDD sky130_fd_pr__pfet_01v8 ad=0 pd=0 as=0 ps=0 w=400 l=30
X151 x138/m1_486_486 x138/m1_338_781 VDD VDD sky130_fd_pr__pfet_01v8 ad=0 pd=0 as=0 ps=0 w=400 l=30
X152 GND x138/m1_486_486 x153/a_0_0 GND sky130_fd_pr__nfet_01v8 ad=0 pd=0 as=78.2n ps=2.61m w=602 l=30
X154 x138/m1_338_781 z@10 x155/li_393_182 GND sky130_fd_pr__nfet_01v8 ad=1p pd=-87u as=52.7n ps=1.92m w=602 l=30
X156 x155/li_393_182 CLK x153/a_0_0 GND sky130_fd_pr__nfet_01v8 ad=0 pd=0 as=0 ps=0 w=600 l=30
X157 VDD x138/m1_486_486 x138/m1_338_781 VDD sky130_fd_pr__pfet_01v8 ad=0 pd=0 as=69.6n ps=2.75m w=400 l=30
X158 x138/m1_338_781 x138/m1_486_486 VDD VDD sky130_fd_pr__pfet_01v8 ad=0 pd=0 as=0 ps=0 w=400 l=30
X159 VDD CLK x138/m1_338_781 VDD sky130_fd_pr__pfet_01v8 ad=0 pd=0 as=0 ps=0 w=400 l=30
X160 x138/m1_338_781 CLK VDD VDD sky130_fd_pr__pfet_01v8 ad=0 pd=0 as=0 ps=0 w=400 l=30
X161 VDD z@10 x138/m1_338_781 VDD sky130_fd_pr__pfet_01v8 ad=0 pd=0 as=0 ps=0 w=400 l=30
X162 x138/m1_338_781 z@10 VDD VDD sky130_fd_pr__pfet_01v8 ad=0 pd=0 as=0 ps=0 w=400 l=30
X163 GND m1_13623_974 x164/a_0_0 GND sky130_fd_pr__nfet_01v8 ad=0 pd=0 as=78.2n ps=2.61m w=602 l=30
X165 m1_13464_896 z@10 x166/li_393_182 GND sky130_fd_pr__nfet_01v8 ad=-7.16n pd=-0.841m as=52.7n ps=1.92m w=602 l=30
X167 x166/li_393_182 SN x164/a_0_0 GND sky130_fd_pr__nfet_01v8 ad=0 pd=0 as=0 ps=0 w=600 l=30
X168 VDD m1_13623_974 m1_13464_896 VDD sky130_fd_pr__pfet_01v8 ad=0 pd=0 as=69.6n ps=2.75m w=400 l=30
X169 m1_13464_896 m1_13623_974 VDD VDD sky130_fd_pr__pfet_01v8 ad=0 pd=0 as=0 ps=0 w=400 l=30
X170 VDD SN m1_13464_896 VDD sky130_fd_pr__pfet_01v8 ad=0 pd=0 as=0 ps=0 w=400 l=30
X171 m1_13464_896 SN VDD VDD sky130_fd_pr__pfet_01v8 ad=0 pd=0 as=0 ps=0 w=400 l=30
X172 VDD z@10 m1_13464_896 VDD sky130_fd_pr__pfet_01v8 ad=0 pd=0 as=0 ps=0 w=400 l=30
X173 m1_13464_896 z@10 VDD VDD sky130_fd_pr__pfet_01v8 ad=0 pd=0 as=0 ps=0 w=400 l=30
X174 GND x138/m1_486_486 x175/a_0_0 GND sky130_fd_pr__nfet_01v8 ad=0 pd=0 as=78.2n ps=2.61m w=602 l=30
X176 z@11 z@10 x177/li_393_182 GND sky130_fd_pr__nfet_01v8 ad=1p pd=-87u as=52.7n ps=1.92m w=602 l=30
X178 x177/li_393_182 SN x175/a_0_0 GND sky130_fd_pr__nfet_01v8 ad=0 pd=0 as=0 ps=0 w=600 l=30
X179 VDD x138/m1_486_486 z@11 VDD sky130_fd_pr__pfet_01v8 ad=0 pd=0 as=69.6n ps=2.75m w=400 l=30
X180 z@11 x138/m1_486_486 VDD VDD sky130_fd_pr__pfet_01v8 ad=0 pd=0 as=0 ps=0 w=400 l=30
X181 VDD SN z@11 VDD sky130_fd_pr__pfet_01v8 ad=0 pd=0 as=0 ps=0 w=400 l=30
X182 z@11 SN VDD VDD sky130_fd_pr__pfet_01v8 ad=0 pd=0 as=0 ps=0 w=400 l=30
X183 VDD z@10 z@11 VDD sky130_fd_pr__pfet_01v8 ad=0 pd=0 as=0 ps=0 w=400 l=30
X184 z@11 z@10 VDD VDD sky130_fd_pr__pfet_01v8 ad=0 pd=0 as=0 ps=0 w=400 l=30
X185 GND z@11 x186/a_0_0 GND sky130_fd_pr__nfet_01v8 ad=0 pd=0 as=77.2n ps=2.61m w=602 l=30
X187 z@10 CLK x186/a_0_0 GND sky130_fd_pr__nfet_01v8 ad=7.16n pd=0.314m as=0 ps=0 w=602 l=30
X188 VDD z@11 z@10 VDD sky130_fd_pr__pfet_01v8 ad=0 pd=0 as=46.4n ps=1.83m w=400 l=30
X189 z@10 z@11 VDD VDD sky130_fd_pr__pfet_01v8 ad=0 pd=0 as=0 ps=0 w=400 l=30
X190 VDD CLK z@10 VDD sky130_fd_pr__pfet_01v8 ad=0 pd=0 as=0 ps=0 w=400 l=30
X191 z@10 CLK VDD VDD sky130_fd_pr__pfet_01v8 ad=0 pd=0 as=0 ps=0 w=400 l=30
C0 m1_3692_667 D 3.44f
C1 VDD CLK 2.1f
C2 m1_3692_667 m1_9685_525 3.2f
.ends

** hspice subcircuit dictionary
* x1	voter3x1_pcell_0/votern3x1_pcell_0/nmos_top_0
* x3	voter3x1_pcell_0/votern3x1_pcell_0/nmos_bottom_1
* x5	voter3x1_pcell_0/votern3x1_pcell_0/nmos_bottom_2
* x7	voter3x1_pcell_0/votern3x1_pcell_0
* x10	voter3x1_pcell_0
* x14	voter3x1_pcell_0/votern3x1_pcell_0/pmos2_1_2
* x28	dffsnx1_pcell_0
* x29	dffsnx1_pcell_0/nand2x1_pcell_2/nmos_bottom_0
* x36	dffsnx1_pcell_0/nand2x1_pcell_5/nmos_bottom_0
* x43	dffsnx1_pcell_0/nand3x1_pcell_0/nmos_bottom_0
* x45	dffsnx1_pcell_0/nand3x1_pcell_0
* x54	dffsnx1_pcell_0/nand3x1_pcell_1/nmos_bottom_0
* x56	dffsnx1_pcell_0/nand3x1_pcell_1
* x65	dffsnx1_pcell_0/nand3x1_pcell_2/nmos_bottom_0
* x67	dffsnx1_pcell_0/nand3x1_pcell_2
* x76	dffsnx1_pcell_0/nand2x1_pcell_0/nmos_bottom_0
* x83	dffsnx1_pcell_1
* x84	dffsnx1_pcell_1/nand2x1_pcell_2/nmos_bottom_0
* x91	dffsnx1_pcell_1/nand2x1_pcell_5/nmos_bottom_0
* x98	dffsnx1_pcell_1/nand3x1_pcell_0/nmos_bottom_0
* x100	dffsnx1_pcell_1/nand3x1_pcell_0
* x109	dffsnx1_pcell_1/nand3x1_pcell_1/nmos_bottom_0
* x111	dffsnx1_pcell_1/nand3x1_pcell_1
* x120	dffsnx1_pcell_1/nand3x1_pcell_2/nmos_bottom_0
* x122	dffsnx1_pcell_1/nand3x1_pcell_2
* x131	dffsnx1_pcell_1/nand2x1_pcell_0/nmos_bottom_0
* x138	dffsnx1_pcell_2
* x139	dffsnx1_pcell_2/nand2x1_pcell_2/nmos_bottom_0
* x146	dffsnx1_pcell_2/nand2x1_pcell_5/nmos_bottom_0
* x153	dffsnx1_pcell_2/nand3x1_pcell_0/nmos_bottom_0
* x155	dffsnx1_pcell_2/nand3x1_pcell_0
* x164	dffsnx1_pcell_2/nand3x1_pcell_1/nmos_bottom_0
* x166	dffsnx1_pcell_2/nand3x1_pcell_1
* x175	dffsnx1_pcell_2/nand3x1_pcell_2/nmos_bottom_0
* x177	dffsnx1_pcell_2/nand3x1_pcell_2
* x186	dffsnx1_pcell_2/nand2x1_pcell_0/nmos_bottom_0
