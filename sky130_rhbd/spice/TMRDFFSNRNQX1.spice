* HSPICE file created from TMRDFFSNRNQX1.ext - technology: sky130A

.option scale=5m

.subckt TMRDFFSNRNQX1 Q D CLK SN RN VDD GND
X0 GND D x1/a_0_0 GND sky130_fd_pr__nfet_01v8 ad=2.39n pd=0.111m as=15.7n ps=0.599m w=602 l=30
X2 x3/m1_783_489 x3/m1_636_635 x4/li_393_182 GND sky130_fd_pr__nfet_01v8 ad=2.39n pd=0.111m as=15.8n ps=0.594m w=602 l=30
X5 x4/li_393_182 RN x1/a_0_0 GND sky130_fd_pr__nfet_01v8 ad=2.18n pd=0.106m as=16.2n ps=0.604m w=600 l=30
X6 VDD D x3/m1_783_489 VDD sky130_fd_pr__pfet_01v8 ad=21.6n pd=0.908m as=11.6n ps=0.458m w=400 l=30
X7 x3/m1_783_489 D VDD VDD sky130_fd_pr__pfet_01v8 ad=11.6n pd=0.458m as=22.4n ps=0.912m w=400 l=30
X8 VDD RN x3/m1_783_489 VDD sky130_fd_pr__pfet_01v8 ad=1.49u pd=0.0603 as=69.6n ps=2.75m w=400 l=30
X9 x3/m1_783_489 RN VDD VDD sky130_fd_pr__pfet_01v8 ad=0 pd=0 as=0 ps=0 w=400 l=30
X10 VDD x3/m1_636_635 x3/m1_783_489 VDD sky130_fd_pr__pfet_01v8 ad=0 pd=0 as=0 ps=0 w=400 l=30
X11 x3/m1_783_489 x3/m1_636_635 VDD VDD sky130_fd_pr__pfet_01v8 ad=0 pd=0 as=0 ps=0 w=400 l=30
X12 GND x3/m1_783_489 x13/a_0_0 GND sky130_fd_pr__nfet_01v8 ad=0.332u pd=0.0159 as=78.2n ps=2.61m w=602 l=30
X14 x3/m1_636_635 x3/m1_1596_711 x15/li_393_182 GND sky130_fd_pr__nfet_01v8 ad=1p pd=-87u as=52.7n ps=1.92m w=602 l=30
X16 x15/li_393_182 CLK x13/a_0_0 GND sky130_fd_pr__nfet_01v8 ad=0 pd=0 as=0 ps=0 w=600 l=30
X17 VDD x3/m1_783_489 x3/m1_636_635 VDD sky130_fd_pr__pfet_01v8 ad=0 pd=0 as=69.6n ps=2.75m w=400 l=30
X18 x3/m1_636_635 x3/m1_783_489 VDD VDD sky130_fd_pr__pfet_01v8 ad=0 pd=0 as=0 ps=0 w=400 l=30
X19 VDD CLK x3/m1_636_635 VDD sky130_fd_pr__pfet_01v8 ad=0 pd=0 as=0 ps=0 w=400 l=30
X20 x3/m1_636_635 CLK VDD VDD sky130_fd_pr__pfet_01v8 ad=0 pd=0 as=0 ps=0 w=400 l=30
X21 VDD x3/m1_1596_711 x3/m1_636_635 VDD sky130_fd_pr__pfet_01v8 ad=0 pd=0 as=0 ps=0 w=400 l=30
X22 x3/m1_636_635 x3/m1_1596_711 VDD VDD sky130_fd_pr__pfet_01v8 ad=0 pd=0 as=0 ps=0 w=400 l=30
X23 GND x3/m1_783_489 x24/a_0_0 GND sky130_fd_pr__nfet_01v8 ad=0 pd=0 as=78.2n ps=2.61m w=602 l=30
X25 x3/m1_2706_486 x3/m1_1596_711 x26/li_393_182 GND sky130_fd_pr__nfet_01v8 ad=1p pd=-87u as=52.7n ps=1.92m w=602 l=30
X27 x26/li_393_182 SN x24/a_0_0 GND sky130_fd_pr__nfet_01v8 ad=0 pd=0 as=0 ps=0 w=600 l=30
X28 VDD x3/m1_783_489 x3/m1_2706_486 VDD sky130_fd_pr__pfet_01v8 ad=0 pd=0 as=69.6n ps=2.75m w=400 l=30
X29 x3/m1_2706_486 x3/m1_783_489 VDD VDD sky130_fd_pr__pfet_01v8 ad=0 pd=0 as=0 ps=0 w=400 l=30
X30 VDD SN x3/m1_2706_486 VDD sky130_fd_pr__pfet_01v8 ad=0 pd=0 as=0 ps=0 w=400 l=30
X31 x3/m1_2706_486 SN VDD VDD sky130_fd_pr__pfet_01v8 ad=0 pd=0 as=0 ps=0 w=400 l=30
X32 VDD x3/m1_1596_711 x3/m1_2706_486 VDD sky130_fd_pr__pfet_01v8 ad=0 pd=0 as=0 ps=0 w=400 l=30
X33 x3/m1_2706_486 x3/m1_1596_711 VDD VDD sky130_fd_pr__pfet_01v8 ad=0 pd=0 as=0 ps=0 w=400 l=30
X34 GND x3/m1_2706_486 x35/a_0_0 GND sky130_fd_pr__nfet_01v8 ad=0 pd=0 as=78.2n ps=2.61m w=602 l=30
X36 x3/m1_1596_711 RN x37/li_393_182 GND sky130_fd_pr__nfet_01v8 ad=7.16n pd=0.314m as=52.7n ps=1.92m w=602 l=30
X38 x37/li_393_182 CLK x35/a_0_0 GND sky130_fd_pr__nfet_01v8 ad=0 pd=0 as=0 ps=0 w=600 l=30
X39 VDD x3/m1_2706_486 x3/m1_1596_711 VDD sky130_fd_pr__pfet_01v8 ad=0 pd=0 as=69.6n ps=2.75m w=400 l=30
X40 x3/m1_1596_711 x3/m1_2706_486 VDD VDD sky130_fd_pr__pfet_01v8 ad=0 pd=0 as=0 ps=0 w=400 l=30
X41 VDD CLK x3/m1_1596_711 VDD sky130_fd_pr__pfet_01v8 ad=0 pd=0 as=0 ps=0 w=400 l=30
X42 x3/m1_1596_711 CLK VDD VDD sky130_fd_pr__pfet_01v8 ad=0 pd=0 as=0 ps=0 w=400 l=30
X43 VDD RN x3/m1_1596_711 VDD sky130_fd_pr__pfet_01v8 ad=0 pd=0 as=0 ps=0 w=400 l=30
X44 x3/m1_1596_711 RN VDD VDD sky130_fd_pr__pfet_01v8 ad=0 pd=0 as=0 ps=0 w=400 l=30
X45 GND x3/m1_636_635 x46/a_0_0 GND sky130_fd_pr__nfet_01v8 ad=0 pd=0 as=78.2n ps=2.61m w=602 l=30
X47 m1_4725_519 m1_4580_673 x48/li_393_182 GND sky130_fd_pr__nfet_01v8 ad=1p pd=-87u as=52.7n ps=1.92m w=602 l=30
X49 x48/li_393_182 RN x46/a_0_0 GND sky130_fd_pr__nfet_01v8 ad=0 pd=0 as=0 ps=0 w=600 l=30
X50 VDD x3/m1_636_635 m1_4725_519 VDD sky130_fd_pr__pfet_01v8 ad=0 pd=0 as=69.6n ps=2.75m w=400 l=30
X51 m1_4725_519 x3/m1_636_635 VDD VDD sky130_fd_pr__pfet_01v8 ad=0 pd=0 as=0 ps=0 w=400 l=30
X52 VDD RN m1_4725_519 VDD sky130_fd_pr__pfet_01v8 ad=0 pd=0 as=0 ps=0 w=400 l=30
X53 m1_4725_519 RN VDD VDD sky130_fd_pr__pfet_01v8 ad=0 pd=0 as=0 ps=0 w=400 l=30
X54 VDD m1_4580_673 m1_4725_519 VDD sky130_fd_pr__pfet_01v8 ad=0 pd=0 as=0 ps=0 w=400 l=30
X55 m1_4725_519 m1_4580_673 VDD VDD sky130_fd_pr__pfet_01v8 ad=0 pd=0 as=0 ps=0 w=400 l=30
X56 GND m1_4725_519 x57/a_0_0 GND sky130_fd_pr__nfet_01v8 ad=0 pd=0 as=78.2n ps=2.61m w=602 l=30
X58 m1_4580_673 x3/m1_1596_711 x59/li_393_182 GND sky130_fd_pr__nfet_01v8 ad=7.16n pd=0.314m as=52.7n ps=1.92m w=602 l=30
X60 x59/li_393_182 SN x57/a_0_0 GND sky130_fd_pr__nfet_01v8 ad=0 pd=0 as=0 ps=0 w=600 l=30
X61 VDD m1_4725_519 m1_4580_673 VDD sky130_fd_pr__pfet_01v8 ad=0 pd=0 as=69.6n ps=2.75m w=400 l=30
X62 m1_4580_673 m1_4725_519 VDD VDD sky130_fd_pr__pfet_01v8 ad=0 pd=0 as=0 ps=0 w=400 l=30
X63 VDD SN m1_4580_673 VDD sky130_fd_pr__pfet_01v8 ad=0 pd=0 as=0 ps=0 w=400 l=30
X64 m1_4580_673 SN VDD VDD sky130_fd_pr__pfet_01v8 ad=0 pd=0 as=0 ps=0 w=400 l=30
X65 VDD x3/m1_1596_711 m1_4580_673 VDD sky130_fd_pr__pfet_01v8 ad=0 pd=0 as=0 ps=0 w=400 l=30
X66 m1_4580_673 x3/m1_1596_711 VDD VDD sky130_fd_pr__pfet_01v8 ad=0 pd=0 as=0 ps=0 w=400 l=30
X67 GND D x68/a_0_0 GND sky130_fd_pr__nfet_01v8 ad=0 pd=0 as=78.2n ps=2.61m w=602 l=30
X69 x70/m1_783_489 x70/m1_636_635 x71/li_393_182 GND sky130_fd_pr__nfet_01v8 ad=-7.16n pd=-0.488m as=52.7n ps=1.92m w=602 l=30
X72 x71/li_393_182 RN x68/a_0_0 GND sky130_fd_pr__nfet_01v8 ad=0 pd=0 as=0 ps=0 w=600 l=30
X73 VDD D x70/m1_783_489 VDD sky130_fd_pr__pfet_01v8 ad=0 pd=0 as=69.6n ps=2.75m w=400 l=30
X74 x70/m1_783_489 D VDD VDD sky130_fd_pr__pfet_01v8 ad=0 pd=0 as=0 ps=0 w=400 l=30
X75 VDD RN x70/m1_783_489 VDD sky130_fd_pr__pfet_01v8 ad=0 pd=0 as=0 ps=0 w=400 l=30
X76 x70/m1_783_489 RN VDD VDD sky130_fd_pr__pfet_01v8 ad=0 pd=0 as=0 ps=0 w=400 l=30
X77 VDD x70/m1_636_635 x70/m1_783_489 VDD sky130_fd_pr__pfet_01v8 ad=0 pd=0 as=0 ps=0 w=400 l=30
X78 x70/m1_783_489 x70/m1_636_635 VDD VDD sky130_fd_pr__pfet_01v8 ad=0 pd=0 as=0 ps=0 w=400 l=30
X79 GND x70/m1_783_489 x80/a_0_0 GND sky130_fd_pr__nfet_01v8 ad=0 pd=0 as=78.2n ps=2.61m w=602 l=30
X81 x70/m1_636_635 x70/m1_1596_711 x82/li_393_182 GND sky130_fd_pr__nfet_01v8 ad=1p pd=-87u as=52.7n ps=1.92m w=602 l=30
X83 x82/li_393_182 CLK x80/a_0_0 GND sky130_fd_pr__nfet_01v8 ad=0 pd=0 as=0 ps=0 w=600 l=30
X84 VDD x70/m1_783_489 x70/m1_636_635 VDD sky130_fd_pr__pfet_01v8 ad=0 pd=0 as=69.6n ps=2.75m w=400 l=30
X85 x70/m1_636_635 x70/m1_783_489 VDD VDD sky130_fd_pr__pfet_01v8 ad=0 pd=0 as=0 ps=0 w=400 l=30
X86 VDD CLK x70/m1_636_635 VDD sky130_fd_pr__pfet_01v8 ad=0 pd=0 as=0 ps=0 w=400 l=30
X87 x70/m1_636_635 CLK VDD VDD sky130_fd_pr__pfet_01v8 ad=0 pd=0 as=0 ps=0 w=400 l=30
X88 VDD x70/m1_1596_711 x70/m1_636_635 VDD sky130_fd_pr__pfet_01v8 ad=0 pd=0 as=0 ps=0 w=400 l=30
X89 x70/m1_636_635 x70/m1_1596_711 VDD VDD sky130_fd_pr__pfet_01v8 ad=0 pd=0 as=0 ps=0 w=400 l=30
X90 GND x70/m1_783_489 x91/a_0_0 GND sky130_fd_pr__nfet_01v8 ad=0 pd=0 as=78.2n ps=2.61m w=602 l=30
X92 x70/m1_2706_486 x70/m1_1596_711 x93/li_393_182 GND sky130_fd_pr__nfet_01v8 ad=1p pd=-87u as=52.7n ps=1.92m w=602 l=30
X94 x93/li_393_182 SN x91/a_0_0 GND sky130_fd_pr__nfet_01v8 ad=0 pd=0 as=0 ps=0 w=600 l=30
X95 VDD x70/m1_783_489 x70/m1_2706_486 VDD sky130_fd_pr__pfet_01v8 ad=0 pd=0 as=69.6n ps=2.75m w=400 l=30
X96 x70/m1_2706_486 x70/m1_783_489 VDD VDD sky130_fd_pr__pfet_01v8 ad=0 pd=0 as=0 ps=0 w=400 l=30
X97 VDD SN x70/m1_2706_486 VDD sky130_fd_pr__pfet_01v8 ad=0 pd=0 as=0 ps=0 w=400 l=30
X98 x70/m1_2706_486 SN VDD VDD sky130_fd_pr__pfet_01v8 ad=0 pd=0 as=0 ps=0 w=400 l=30
X99 VDD x70/m1_1596_711 x70/m1_2706_486 VDD sky130_fd_pr__pfet_01v8 ad=0 pd=0 as=0 ps=0 w=400 l=30
X100 x70/m1_2706_486 x70/m1_1596_711 VDD VDD sky130_fd_pr__pfet_01v8 ad=0 pd=0 as=0 ps=0 w=400 l=30
X101 GND x70/m1_2706_486 x102/a_0_0 GND sky130_fd_pr__nfet_01v8 ad=0 pd=0 as=78.2n ps=2.61m w=602 l=30
X103 x70/m1_1596_711 RN x104/li_393_182 GND sky130_fd_pr__nfet_01v8 ad=7.16n pd=0.314m as=52.7n ps=1.92m w=602 l=30
X105 x104/li_393_182 CLK x102/a_0_0 GND sky130_fd_pr__nfet_01v8 ad=0 pd=0 as=0 ps=0 w=600 l=30
X106 VDD x70/m1_2706_486 x70/m1_1596_711 VDD sky130_fd_pr__pfet_01v8 ad=0 pd=0 as=69.6n ps=2.75m w=400 l=30
X107 x70/m1_1596_711 x70/m1_2706_486 VDD VDD sky130_fd_pr__pfet_01v8 ad=0 pd=0 as=0 ps=0 w=400 l=30
X108 VDD CLK x70/m1_1596_711 VDD sky130_fd_pr__pfet_01v8 ad=0 pd=0 as=0 ps=0 w=400 l=30
X109 x70/m1_1596_711 CLK VDD VDD sky130_fd_pr__pfet_01v8 ad=0 pd=0 as=0 ps=0 w=400 l=30
X110 VDD RN x70/m1_1596_711 VDD sky130_fd_pr__pfet_01v8 ad=0 pd=0 as=0 ps=0 w=400 l=30
X111 x70/m1_1596_711 RN VDD VDD sky130_fd_pr__pfet_01v8 ad=0 pd=0 as=0 ps=0 w=400 l=30
X112 GND x70/m1_636_635 x113/a_0_0 GND sky130_fd_pr__nfet_01v8 ad=0 pd=0 as=78.2n ps=2.61m w=602 l=30
X114 m1_10509_519 m1_10352_673 x115/li_393_182 GND sky130_fd_pr__nfet_01v8 ad=1p pd=-87u as=52.7n ps=1.92m w=602 l=30
X116 x115/li_393_182 RN x113/a_0_0 GND sky130_fd_pr__nfet_01v8 ad=0 pd=0 as=0 ps=0 w=600 l=30
X117 VDD x70/m1_636_635 m1_10509_519 VDD sky130_fd_pr__pfet_01v8 ad=0 pd=0 as=69.6n ps=2.75m w=400 l=30
X118 m1_10509_519 x70/m1_636_635 VDD VDD sky130_fd_pr__pfet_01v8 ad=0 pd=0 as=0 ps=0 w=400 l=30
X119 VDD RN m1_10509_519 VDD sky130_fd_pr__pfet_01v8 ad=0 pd=0 as=0 ps=0 w=400 l=30
X120 m1_10509_519 RN VDD VDD sky130_fd_pr__pfet_01v8 ad=0 pd=0 as=0 ps=0 w=400 l=30
X121 VDD m1_10352_673 m1_10509_519 VDD sky130_fd_pr__pfet_01v8 ad=0 pd=0 as=0 ps=0 w=400 l=30
X122 m1_10509_519 m1_10352_673 VDD VDD sky130_fd_pr__pfet_01v8 ad=0 pd=0 as=0 ps=0 w=400 l=30
X123 GND m1_10509_519 x124/a_0_0 GND sky130_fd_pr__nfet_01v8 ad=0 pd=0 as=78.2n ps=2.61m w=602 l=30
X125 m1_10352_673 x70/m1_1596_711 x126/li_393_182 GND sky130_fd_pr__nfet_01v8 ad=7.16n pd=0.314m as=52.7n ps=1.92m w=602 l=30
X127 x126/li_393_182 SN x124/a_0_0 GND sky130_fd_pr__nfet_01v8 ad=0 pd=0 as=0 ps=0 w=600 l=30
X128 VDD m1_10509_519 m1_10352_673 VDD sky130_fd_pr__pfet_01v8 ad=0 pd=0 as=69.6n ps=2.75m w=400 l=30
X129 m1_10352_673 m1_10509_519 VDD VDD sky130_fd_pr__pfet_01v8 ad=0 pd=0 as=0 ps=0 w=400 l=30
X130 VDD SN m1_10352_673 VDD sky130_fd_pr__pfet_01v8 ad=0 pd=0 as=0 ps=0 w=400 l=30
X131 m1_10352_673 SN VDD VDD sky130_fd_pr__pfet_01v8 ad=0 pd=0 as=0 ps=0 w=400 l=30
X132 VDD x70/m1_1596_711 m1_10352_673 VDD sky130_fd_pr__pfet_01v8 ad=0 pd=0 as=0 ps=0 w=400 l=30
X133 m1_10352_673 x70/m1_1596_711 VDD VDD sky130_fd_pr__pfet_01v8 ad=0 pd=0 as=0 ps=0 w=400 l=30
X134 GND D x135/a_0_0 GND sky130_fd_pr__nfet_01v8 ad=0 pd=0 as=78.2n ps=2.61m w=602 l=30
X136 x137/m1_783_489 x137/m1_636_635 x138/li_393_182 GND sky130_fd_pr__nfet_01v8 ad=-7.16n pd=-0.488m as=52.7n ps=1.92m w=602 l=30
X139 x138/li_393_182 RN x135/a_0_0 GND sky130_fd_pr__nfet_01v8 ad=0 pd=0 as=0 ps=0 w=600 l=30
X140 VDD D x137/m1_783_489 VDD sky130_fd_pr__pfet_01v8 ad=0 pd=0 as=69.6n ps=2.75m w=400 l=30
X141 x137/m1_783_489 D VDD VDD sky130_fd_pr__pfet_01v8 ad=0 pd=0 as=0 ps=0 w=400 l=30
X142 VDD RN x137/m1_783_489 VDD sky130_fd_pr__pfet_01v8 ad=0 pd=0 as=0 ps=0 w=400 l=30
X143 x137/m1_783_489 RN VDD VDD sky130_fd_pr__pfet_01v8 ad=0 pd=0 as=0 ps=0 w=400 l=30
X144 VDD x137/m1_636_635 x137/m1_783_489 VDD sky130_fd_pr__pfet_01v8 ad=0 pd=0 as=0 ps=0 w=400 l=30
X145 x137/m1_783_489 x137/m1_636_635 VDD VDD sky130_fd_pr__pfet_01v8 ad=0 pd=0 as=0 ps=0 w=400 l=30
X146 GND x137/m1_783_489 x147/a_0_0 GND sky130_fd_pr__nfet_01v8 ad=0 pd=0 as=78.2n ps=2.61m w=602 l=30
X148 x137/m1_636_635 z@10 x149/li_393_182 GND sky130_fd_pr__nfet_01v8 ad=1p pd=-87u as=52.7n ps=1.92m w=602 l=30
X150 x149/li_393_182 CLK x147/a_0_0 GND sky130_fd_pr__nfet_01v8 ad=0 pd=0 as=0 ps=0 w=600 l=30
X151 VDD x137/m1_783_489 x137/m1_636_635 VDD sky130_fd_pr__pfet_01v8 ad=0 pd=0 as=69.6n ps=2.75m w=400 l=30
X152 x137/m1_636_635 x137/m1_783_489 VDD VDD sky130_fd_pr__pfet_01v8 ad=0 pd=0 as=0 ps=0 w=400 l=30
X153 VDD CLK x137/m1_636_635 VDD sky130_fd_pr__pfet_01v8 ad=0 pd=0 as=0 ps=0 w=400 l=30
X154 x137/m1_636_635 CLK VDD VDD sky130_fd_pr__pfet_01v8 ad=0 pd=0 as=0 ps=0 w=400 l=30
X155 VDD z@10 x137/m1_636_635 VDD sky130_fd_pr__pfet_01v8 ad=0 pd=0 as=0 ps=0 w=400 l=30
X156 x137/m1_636_635 z@10 VDD VDD sky130_fd_pr__pfet_01v8 ad=0 pd=0 as=0 ps=0 w=400 l=30
X157 GND x137/m1_783_489 x158/a_0_0 GND sky130_fd_pr__nfet_01v8 ad=0 pd=0 as=78.2n ps=2.61m w=602 l=30
X159 z@11 z@10 x160/li_393_182 GND sky130_fd_pr__nfet_01v8 ad=1p pd=-87u as=52.7n ps=1.92m w=602 l=30
X161 x160/li_393_182 SN x158/a_0_0 GND sky130_fd_pr__nfet_01v8 ad=0 pd=0 as=0 ps=0 w=600 l=30
X162 VDD x137/m1_783_489 z@11 VDD sky130_fd_pr__pfet_01v8 ad=0 pd=0 as=69.6n ps=2.75m w=400 l=30
X163 z@11 x137/m1_783_489 VDD VDD sky130_fd_pr__pfet_01v8 ad=0 pd=0 as=0 ps=0 w=400 l=30
X164 VDD SN z@11 VDD sky130_fd_pr__pfet_01v8 ad=0 pd=0 as=0 ps=0 w=400 l=30
X165 z@11 SN VDD VDD sky130_fd_pr__pfet_01v8 ad=0 pd=0 as=0 ps=0 w=400 l=30
X166 VDD z@10 z@11 VDD sky130_fd_pr__pfet_01v8 ad=0 pd=0 as=0 ps=0 w=400 l=30
X167 z@11 z@10 VDD VDD sky130_fd_pr__pfet_01v8 ad=0 pd=0 as=0 ps=0 w=400 l=30
X168 GND z@11 x169/a_0_0 GND sky130_fd_pr__nfet_01v8 ad=0 pd=0 as=78.2n ps=2.61m w=602 l=30
X170 z@10 RN x171/li_393_182 GND sky130_fd_pr__nfet_01v8 ad=7.16n pd=0.314m as=52.7n ps=1.92m w=602 l=30
X172 x171/li_393_182 CLK x169/a_0_0 GND sky130_fd_pr__nfet_01v8 ad=0 pd=0 as=0 ps=0 w=600 l=30
X173 VDD z@11 z@10 VDD sky130_fd_pr__pfet_01v8 ad=0 pd=0 as=69.6n ps=2.75m w=400 l=30
X174 z@10 z@11 VDD VDD sky130_fd_pr__pfet_01v8 ad=0 pd=0 as=0 ps=0 w=400 l=30
X175 VDD CLK z@10 VDD sky130_fd_pr__pfet_01v8 ad=0 pd=0 as=0 ps=0 w=400 l=30
X176 z@10 CLK VDD VDD sky130_fd_pr__pfet_01v8 ad=0 pd=0 as=0 ps=0 w=400 l=30
X177 VDD RN z@10 VDD sky130_fd_pr__pfet_01v8 ad=0 pd=0 as=0 ps=0 w=400 l=30
X178 z@10 RN VDD VDD sky130_fd_pr__pfet_01v8 ad=0 pd=0 as=0 ps=0 w=400 l=30
X179 GND x137/m1_636_635 x180/a_0_0 GND sky130_fd_pr__nfet_01v8 ad=0 pd=0 as=78.2n ps=2.61m w=602 l=30
X181 m1_16272_519 m1_16122_433 x182/li_393_182 GND sky130_fd_pr__nfet_01v8 ad=1p pd=-87u as=52.7n ps=1.92m w=602 l=30
X183 x182/li_393_182 RN x180/a_0_0 GND sky130_fd_pr__nfet_01v8 ad=0 pd=0 as=0 ps=0 w=600 l=30
X184 VDD x137/m1_636_635 m1_16272_519 VDD sky130_fd_pr__pfet_01v8 ad=0 pd=0 as=69.6n ps=2.75m w=400 l=30
X185 m1_16272_519 x137/m1_636_635 VDD VDD sky130_fd_pr__pfet_01v8 ad=0 pd=0 as=0 ps=0 w=400 l=30
X186 VDD RN m1_16272_519 VDD sky130_fd_pr__pfet_01v8 ad=0 pd=0 as=0 ps=0 w=400 l=30
X187 m1_16272_519 RN VDD VDD sky130_fd_pr__pfet_01v8 ad=0 pd=0 as=0 ps=0 w=400 l=30
X188 VDD m1_16122_433 m1_16272_519 VDD sky130_fd_pr__pfet_01v8 ad=0 pd=0 as=0 ps=0 w=400 l=30
X189 m1_16272_519 m1_16122_433 VDD VDD sky130_fd_pr__pfet_01v8 ad=0 pd=0 as=0 ps=0 w=400 l=30
X190 GND m1_16272_519 x191/a_0_0 GND sky130_fd_pr__nfet_01v8 ad=0 pd=0 as=78.2n ps=2.61m w=602 l=30
X192 m1_16122_433 z@10 x193/li_393_182 GND sky130_fd_pr__nfet_01v8 ad=1p pd=-0.263m as=52.7n ps=1.92m w=602 l=30
X194 x193/li_393_182 SN x191/a_0_0 GND sky130_fd_pr__nfet_01v8 ad=0 pd=0 as=0 ps=0 w=600 l=30
X195 VDD m1_16272_519 m1_16122_433 VDD sky130_fd_pr__pfet_01v8 ad=0 pd=0 as=69.6n ps=2.75m w=400 l=30
X196 m1_16122_433 m1_16272_519 VDD VDD sky130_fd_pr__pfet_01v8 ad=0 pd=0 as=0 ps=0 w=400 l=30
X197 VDD SN m1_16122_433 VDD sky130_fd_pr__pfet_01v8 ad=0 pd=0 as=0 ps=0 w=400 l=30
X198 m1_16122_433 SN VDD VDD sky130_fd_pr__pfet_01v8 ad=0 pd=0 as=0 ps=0 w=400 l=30
X199 VDD z@10 m1_16122_433 VDD sky130_fd_pr__pfet_01v8 ad=0 pd=0 as=0 ps=0 w=400 l=30
X200 m1_16122_433 z@10 VDD VDD sky130_fd_pr__pfet_01v8 ad=0 pd=0 as=0 ps=0 w=400 l=30
X201 GND m2_5741_981 x202/a_0_0 GND sky130_fd_pr__nfet_01v8 ad=0 pd=0 as=76.7n ps=2.6m w=602 l=30
X203 GND m2_5741_981 x204/a_0_0 GND sky130_fd_pr__nfet_01v8 ad=0 pd=0 as=77.2n ps=2.61m w=602 l=30
X205 GND m1_16122_433 x206/a_0_0 GND sky130_fd_pr__nfet_01v8 ad=0 pd=0 as=77.2n ps=2.61m w=602 l=30
X207 x208/a_805_1331 m2_5741_981 VDD VDD sky130_fd_pr__pfet_01v8 ad=11.6n pd=0.458m as=22.4n ps=0.912m w=400 l=30
X209 VDD m2_5741_981 x208/a_805_1331 VDD sky130_fd_pr__pfet_01v8 ad=21.6n pd=0.908m as=11.6n ps=0.458m w=400 l=30
X210 z@12 m1_16122_433 x204/a_0_0 GND sky130_fd_pr__nfet_01v8 ad=21.5n pd=0.944m as=0 ps=0 w=602 l=30
X212 x208/a_805_1331 m1_10352_673 VDD VDD sky130_fd_pr__pfet_01v8 ad=0.114u pd=4.57m as=0 ps=0 w=400 l=30
X213 VDD m1_10352_673 x208/a_805_1331 VDD sky130_fd_pr__pfet_01v8 ad=0 pd=0 as=0 ps=0 w=400 l=30
X214 x215/a_174_n399 m1_16122_433 x208/a_805_1331 VDD sky130_fd_pr__pfet_01v8 ad=23.2n pd=0.916m as=0 ps=0 w=400 l=30
X216 x208/a_805_1331 m1_16122_433 x215/a_174_n399 VDD sky130_fd_pr__pfet_01v8 ad=0 pd=0 as=0 ps=0 w=400 l=30
X217 x208/a_893_1059 m2_5741_981 x208/a_805_1331 VDD sky130_fd_pr__pfet_01v8 ad=90.4n pd=3.65m as=0 ps=0 w=400 l=30
X218 x208/a_805_1331 m2_5741_981 x208/a_893_1059 VDD sky130_fd_pr__pfet_01v8 ad=0 pd=0 as=0 ps=0 w=400 l=30
X219 z@12 m1_16122_433 x208/a_893_1059 VDD sky130_fd_pr__pfet_01v8 ad=46.4n pd=1.83m as=0 ps=0 w=400 l=30
X220 x208/a_893_1059 m1_16122_433 z@12 VDD sky130_fd_pr__pfet_01v8 ad=0 pd=0 as=0 ps=0 w=400 l=30
X221 z@12 m1_10352_673 x208/a_893_1059 VDD sky130_fd_pr__pfet_01v8 ad=0 pd=0 as=0 ps=0 w=400 l=30
X222 x208/a_893_1059 m1_10352_673 z@12 VDD sky130_fd_pr__pfet_01v8 ad=0 pd=0 as=0 ps=0 w=400 l=30
X223 z@12 m1_10352_673 x202/a_0_0 GND sky130_fd_pr__nfet_01v8 ad=2.39n pd=0.111m as=15.6n ps=0.592m w=602 l=30
X224 z@12 m1_10352_673 x206/a_0_0 GND sky130_fd_pr__nfet_01v8 ad=2.4n pd=0.112m as=15.8n ps=0.594m w=602 l=30
X225 Q z@12 GND GND sky130_fd_pr__nfet_01v8 ad=7.16n pd=0.314m as=0 ps=0 w=602 l=30
X226 VDD z@12 Q VDD sky130_fd_pr__pfet_01v8 ad=0 pd=0 as=23.2n ps=0.917m w=400 l=30
X227 Q z@12 VDD VDD sky130_fd_pr__pfet_01v8 ad=0 pd=0 as=0 ps=0 w=400 l=30
C0 D CLK 5.32f
C1 VDD RN 2.06f
C2 m2_5741_981 m1_10352_673 2.12f
C3 CLK m2_5741_981 4.58f
C4 SN RN 3.68f
C5 CLK VDD 2.43f
C6 D x3/m1_1596_711 2.07f
C7 z@10 m1_10352_673 2.09f
.ends

** hspice subcircuit dictionary
* x1	dffsnrnx1_pcell_0/nand3x1_pcell_0/nmos_bottom_0
* x3	dffsnrnx1_pcell_0
* x4	dffsnrnx1_pcell_0/nand3x1_pcell_0
* x13	dffsnrnx1_pcell_0/nand3x1_pcell_1/nmos_bottom_0
* x15	dffsnrnx1_pcell_0/nand3x1_pcell_1
* x24	dffsnrnx1_pcell_0/nand3x1_pcell_2/nmos_bottom_0
* x26	dffsnrnx1_pcell_0/nand3x1_pcell_2
* x35	dffsnrnx1_pcell_0/nand3x1_pcell_3/nmos_bottom_0
* x37	dffsnrnx1_pcell_0/nand3x1_pcell_3
* x46	dffsnrnx1_pcell_0/nand3x1_pcell_4/nmos_bottom_0
* x48	dffsnrnx1_pcell_0/nand3x1_pcell_4
* x57	dffsnrnx1_pcell_0/nand3x1_pcell_5/nmos_bottom_0
* x59	dffsnrnx1_pcell_0/nand3x1_pcell_5
* x68	dffsnrnx1_pcell_1/nand3x1_pcell_0/nmos_bottom_0
* x70	dffsnrnx1_pcell_1
* x71	dffsnrnx1_pcell_1/nand3x1_pcell_0
* x80	dffsnrnx1_pcell_1/nand3x1_pcell_1/nmos_bottom_0
* x82	dffsnrnx1_pcell_1/nand3x1_pcell_1
* x91	dffsnrnx1_pcell_1/nand3x1_pcell_2/nmos_bottom_0
* x93	dffsnrnx1_pcell_1/nand3x1_pcell_2
* x102	dffsnrnx1_pcell_1/nand3x1_pcell_3/nmos_bottom_0
* x104	dffsnrnx1_pcell_1/nand3x1_pcell_3
* x113	dffsnrnx1_pcell_1/nand3x1_pcell_4/nmos_bottom_0
* x115	dffsnrnx1_pcell_1/nand3x1_pcell_4
* x124	dffsnrnx1_pcell_1/nand3x1_pcell_5/nmos_bottom_0
* x126	dffsnrnx1_pcell_1/nand3x1_pcell_5
* x135	dffsnrnx1_pcell_2/nand3x1_pcell_0/nmos_bottom_0
* x137	dffsnrnx1_pcell_2
* x138	dffsnrnx1_pcell_2/nand3x1_pcell_0
* x147	dffsnrnx1_pcell_2/nand3x1_pcell_1/nmos_bottom_0
* x149	dffsnrnx1_pcell_2/nand3x1_pcell_1
* x158	dffsnrnx1_pcell_2/nand3x1_pcell_2/nmos_bottom_0
* x160	dffsnrnx1_pcell_2/nand3x1_pcell_2
* x169	dffsnrnx1_pcell_2/nand3x1_pcell_3/nmos_bottom_0
* x171	dffsnrnx1_pcell_2/nand3x1_pcell_3
* x180	dffsnrnx1_pcell_2/nand3x1_pcell_4/nmos_bottom_0
* x182	dffsnrnx1_pcell_2/nand3x1_pcell_4
* x191	dffsnrnx1_pcell_2/nand3x1_pcell_5/nmos_bottom_0
* x193	dffsnrnx1_pcell_2/nand3x1_pcell_5
* x202	voter3x1_pcell_0/votern3x1_pcell_0/nmos_top_0
* x204	voter3x1_pcell_0/votern3x1_pcell_0/nmos_bottom_1
* x206	voter3x1_pcell_0/votern3x1_pcell_0/nmos_bottom_2
* x208	voter3x1_pcell_0/votern3x1_pcell_0
* x211	voter3x1_pcell_0
* x215	voter3x1_pcell_0/votern3x1_pcell_0/pmos2_1_2
