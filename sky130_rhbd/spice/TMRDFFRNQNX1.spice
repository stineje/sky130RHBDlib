* HSPICE file created from TMRDFFRNQNX1.ext - technology: sky130A

.option scale=5m

.subckt TMRDFFRNQNX1 QN D CLK RN VDD GND
X0 x1/VSUBS m2_4517_833 x2/a_0_0 x1/VSUBS sky130_fd_pr__nfet_01v8 ad=2.39n pd=0.111m as=15.7n ps=0.599m w=602 l=30
X3 x4/m1_783_709 x4/m1_634_634 x5/li_393_182 x1/VSUBS sky130_fd_pr__nfet_01v8 ad=2.39n pd=0.111m as=15.8n ps=0.594m w=602 l=30
X6 x5/li_393_182 CLK x2/a_0_0 x1/VSUBS sky130_fd_pr__nfet_01v8 ad=2.18n pd=0.106m as=16.2n ps=0.604m w=600 l=30
X7 w_0_822 m2_4517_833 x4/m1_783_709 w_0_822 sky130_fd_pr__pfet_01v8 ad=21.6n pd=0.908m as=11.6n ps=0.458m w=400 l=30
X8 x4/m1_783_709 m2_4517_833 w_0_822 w_0_822 sky130_fd_pr__pfet_01v8 ad=11.6n pd=0.458m as=22.4n ps=0.912m w=400 l=30
X9 w_0_822 CLK x4/m1_783_709 w_0_822 sky130_fd_pr__pfet_01v8 ad=1.56u pd=0.063 as=69.6n ps=2.75m w=400 l=30
X10 x4/m1_783_709 CLK w_0_822 w_0_822 sky130_fd_pr__pfet_01v8 ad=0 pd=0 as=0 ps=0 w=400 l=30
X11 w_0_822 x4/m1_634_634 x4/m1_783_709 w_0_822 sky130_fd_pr__pfet_01v8 ad=0 pd=0 as=0 ps=0 w=400 l=30
X12 x4/m1_783_709 x4/m1_634_634 w_0_822 w_0_822 sky130_fd_pr__pfet_01v8 ad=0 pd=0 as=0 ps=0 w=400 l=30
X13 x1/VSUBS x4/m1_783_709 x14/a_0_0 x1/VSUBS sky130_fd_pr__nfet_01v8 ad=0.301u pd=0.0156 as=78.2n ps=2.61m w=602 l=30
X15 x4/m1_634_634 RN x16/li_393_182 x1/VSUBS sky130_fd_pr__nfet_01v8 ad=1p pd=-87u as=52.7n ps=1.92m w=602 l=30
X17 x16/li_393_182 D x14/a_0_0 x1/VSUBS sky130_fd_pr__nfet_01v8 ad=0 pd=0 as=0 ps=0 w=600 l=30
X18 w_0_822 x4/m1_783_709 x4/m1_634_634 w_0_822 sky130_fd_pr__pfet_01v8 ad=0 pd=0 as=69.6n ps=2.75m w=400 l=30
X19 x4/m1_634_634 x4/m1_783_709 w_0_822 w_0_822 sky130_fd_pr__pfet_01v8 ad=0 pd=0 as=0 ps=0 w=400 l=30
X20 w_0_822 D x4/m1_634_634 w_0_822 sky130_fd_pr__pfet_01v8 ad=0 pd=0 as=0 ps=0 w=400 l=30
X21 x4/m1_634_634 D w_0_822 w_0_822 sky130_fd_pr__pfet_01v8 ad=0 pd=0 as=0 ps=0 w=400 l=30
X22 w_0_822 RN x4/m1_634_634 w_0_822 sky130_fd_pr__pfet_01v8 ad=0 pd=0 as=0 ps=0 w=400 l=30
X23 x4/m1_634_634 RN w_0_822 w_0_822 sky130_fd_pr__pfet_01v8 ad=0 pd=0 as=0 ps=0 w=400 l=30
X24 x1/VSUBS x4/m1_2410_635 x25/a_0_0 x1/VSUBS sky130_fd_pr__nfet_01v8 ad=0 pd=0 as=78.2n ps=2.61m w=602 l=30
X26 m2_4517_833 RN x27/li_393_182 x1/VSUBS sky130_fd_pr__nfet_01v8 ad=2p pd=-0.174m as=52.7n ps=1.92m w=602 l=30
X28 x27/li_393_182 CLK x25/a_0_0 x1/VSUBS sky130_fd_pr__nfet_01v8 ad=0 pd=0 as=0 ps=0 w=600 l=30
X29 w_0_822 x4/m1_2410_635 m2_4517_833 w_0_822 sky130_fd_pr__pfet_01v8 ad=0 pd=0 as=0.139u ps=5.5m w=400 l=30
X30 m2_4517_833 x4/m1_2410_635 w_0_822 w_0_822 sky130_fd_pr__pfet_01v8 ad=0 pd=0 as=0 ps=0 w=400 l=30
X31 w_0_822 CLK m2_4517_833 w_0_822 sky130_fd_pr__pfet_01v8 ad=0 pd=0 as=0 ps=0 w=400 l=30
X32 m2_4517_833 CLK w_0_822 w_0_822 sky130_fd_pr__pfet_01v8 ad=0 pd=0 as=0 ps=0 w=400 l=30
X33 w_0_822 RN m2_4517_833 w_0_822 sky130_fd_pr__pfet_01v8 ad=0 pd=0 as=0 ps=0 w=400 l=30
X34 m2_4517_833 RN w_0_822 w_0_822 sky130_fd_pr__pfet_01v8 ad=0 pd=0 as=0 ps=0 w=400 l=30
X35 x1/VSUBS x4/m1_783_709 x36/a_0_0 x1/VSUBS sky130_fd_pr__nfet_01v8 ad=0 pd=0 as=78.2n ps=2.61m w=602 l=30
X37 m2_4517_833 m1_4283_599 x38/li_393_182 x1/VSUBS sky130_fd_pr__nfet_01v8 ad=0 pd=-0 as=52.7n ps=1.92m w=602 l=30
X39 x38/li_393_182 RN x36/a_0_0 x1/VSUBS sky130_fd_pr__nfet_01v8 ad=0 pd=0 as=0 ps=0 w=600 l=30
X40 w_0_822 x4/m1_783_709 m2_4517_833 w_0_822 sky130_fd_pr__pfet_01v8 ad=0 pd=0 as=0 ps=0 w=400 l=30
X41 m2_4517_833 x4/m1_783_709 w_0_822 w_0_822 sky130_fd_pr__pfet_01v8 ad=0 pd=0 as=0 ps=0 w=400 l=30
X42 w_0_822 RN m2_4517_833 w_0_822 sky130_fd_pr__pfet_01v8 ad=0 pd=0 as=0 ps=0 w=400 l=30
X43 m2_4517_833 RN w_0_822 w_0_822 sky130_fd_pr__pfet_01v8 ad=0 pd=0 as=0 ps=0 w=400 l=30
X44 w_0_822 m1_4283_599 m2_4517_833 w_0_822 sky130_fd_pr__pfet_01v8 ad=0 pd=0 as=0 ps=0 w=400 l=30
X45 m2_4517_833 m1_4283_599 w_0_822 w_0_822 sky130_fd_pr__pfet_01v8 ad=0 pd=0 as=0 ps=0 w=400 l=30
X46 x1/VSUBS x4/m1_634_634 x47/a_0_0 x1/VSUBS sky130_fd_pr__nfet_01v8 ad=0 pd=0 as=77.2n ps=2.61m w=602 l=30
X48 x4/m1_2410_635 m2_4517_833 x47/a_0_0 x1/VSUBS sky130_fd_pr__nfet_01v8 ad=1p pd=-87u as=0 ps=0 w=602 l=30
X49 w_0_822 x4/m1_634_634 x4/m1_2410_635 w_0_822 sky130_fd_pr__pfet_01v8 ad=0 pd=0 as=46.4n ps=1.83m w=400 l=30
X50 x4/m1_2410_635 x4/m1_634_634 w_0_822 w_0_822 sky130_fd_pr__pfet_01v8 ad=0 pd=0 as=0 ps=0 w=400 l=30
X51 w_0_822 m2_4517_833 x4/m1_2410_635 w_0_822 sky130_fd_pr__pfet_01v8 ad=0 pd=0 as=0 ps=0 w=400 l=30
X52 x4/m1_2410_635 m2_4517_833 w_0_822 w_0_822 sky130_fd_pr__pfet_01v8 ad=0 pd=0 as=0 ps=0 w=400 l=30
X53 x1/VSUBS m2_4517_833 x54/a_0_0 x1/VSUBS sky130_fd_pr__nfet_01v8 ad=0 pd=0 as=77.2n ps=2.61m w=602 l=30
X55 m1_4283_599 m2_4517_833 x54/a_0_0 x1/VSUBS sky130_fd_pr__nfet_01v8 ad=1p pd=-0.263m as=0 ps=0 w=602 l=30
X56 w_0_822 m2_4517_833 m1_4283_599 w_0_822 sky130_fd_pr__pfet_01v8 ad=0 pd=0 as=46.4n ps=1.83m w=400 l=30
X57 m1_4283_599 m2_4517_833 w_0_822 w_0_822 sky130_fd_pr__pfet_01v8 ad=0 pd=0 as=0 ps=0 w=400 l=30
X58 w_0_822 m2_4517_833 m1_4283_599 w_0_822 sky130_fd_pr__pfet_01v8 ad=0 pd=0 as=0 ps=0 w=400 l=30
X59 m1_4283_599 m2_4517_833 w_0_822 w_0_822 sky130_fd_pr__pfet_01v8 ad=0 pd=0 as=0 ps=0 w=400 l=30
X60 x1/VSUBS x61/m1_190_784 x62/a_0_0 x1/VSUBS sky130_fd_pr__nfet_01v8 ad=0 pd=0 as=78.2n ps=2.61m w=602 l=30
X63 x61/m1_783_709 x61/m1_634_634 x64/li_393_182 x1/VSUBS sky130_fd_pr__nfet_01v8 ad=-7.16n pd=-0.488m as=52.7n ps=1.92m w=602 l=30
X65 x64/li_393_182 CLK x62/a_0_0 x1/VSUBS sky130_fd_pr__nfet_01v8 ad=0 pd=0 as=0 ps=0 w=600 l=30
X66 w_0_822 x61/m1_190_784 x61/m1_783_709 w_0_822 sky130_fd_pr__pfet_01v8 ad=0 pd=0 as=69.6n ps=2.75m w=400 l=30
X67 x61/m1_783_709 x61/m1_190_784 w_0_822 w_0_822 sky130_fd_pr__pfet_01v8 ad=0 pd=0 as=0 ps=0 w=400 l=30
X68 w_0_822 CLK x61/m1_783_709 w_0_822 sky130_fd_pr__pfet_01v8 ad=0 pd=0 as=0 ps=0 w=400 l=30
X69 x61/m1_783_709 CLK w_0_822 w_0_822 sky130_fd_pr__pfet_01v8 ad=0 pd=0 as=0 ps=0 w=400 l=30
X70 w_0_822 x61/m1_634_634 x61/m1_783_709 w_0_822 sky130_fd_pr__pfet_01v8 ad=0 pd=0 as=0 ps=0 w=400 l=30
X71 x61/m1_783_709 x61/m1_634_634 w_0_822 w_0_822 sky130_fd_pr__pfet_01v8 ad=0 pd=0 as=0 ps=0 w=400 l=30
X72 x1/VSUBS x61/m1_783_709 x73/a_0_0 x1/VSUBS sky130_fd_pr__nfet_01v8 ad=0 pd=0 as=78.2n ps=2.61m w=602 l=30
X74 x61/m1_634_634 RN x75/li_393_182 x1/VSUBS sky130_fd_pr__nfet_01v8 ad=1p pd=-87u as=52.7n ps=1.92m w=602 l=30
X76 x75/li_393_182 D x73/a_0_0 x1/VSUBS sky130_fd_pr__nfet_01v8 ad=0 pd=0 as=0 ps=0 w=600 l=30
X77 w_0_822 x61/m1_783_709 x61/m1_634_634 w_0_822 sky130_fd_pr__pfet_01v8 ad=0 pd=0 as=69.6n ps=2.75m w=400 l=30
X78 x61/m1_634_634 x61/m1_783_709 w_0_822 w_0_822 sky130_fd_pr__pfet_01v8 ad=0 pd=0 as=0 ps=0 w=400 l=30
X79 w_0_822 D x61/m1_634_634 w_0_822 sky130_fd_pr__pfet_01v8 ad=0 pd=0 as=0 ps=0 w=400 l=30
X80 x61/m1_634_634 D w_0_822 w_0_822 sky130_fd_pr__pfet_01v8 ad=0 pd=0 as=0 ps=0 w=400 l=30
X81 w_0_822 RN x61/m1_634_634 w_0_822 sky130_fd_pr__pfet_01v8 ad=0 pd=0 as=0 ps=0 w=400 l=30
X82 x61/m1_634_634 RN w_0_822 w_0_822 sky130_fd_pr__pfet_01v8 ad=0 pd=0 as=0 ps=0 w=400 l=30
X83 x1/VSUBS x61/m1_2410_635 x84/a_0_0 x1/VSUBS sky130_fd_pr__nfet_01v8 ad=0 pd=0 as=78.2n ps=2.61m w=602 l=30
X85 x61/m1_190_784 RN x86/li_393_182 x1/VSUBS sky130_fd_pr__nfet_01v8 ad=1p pd=-87u as=52.7n ps=1.92m w=602 l=30
X87 x86/li_393_182 CLK x84/a_0_0 x1/VSUBS sky130_fd_pr__nfet_01v8 ad=0 pd=0 as=0 ps=0 w=600 l=30
X88 w_0_822 x61/m1_2410_635 x61/m1_190_784 w_0_822 sky130_fd_pr__pfet_01v8 ad=0 pd=0 as=69.6n ps=2.75m w=400 l=30
X89 x61/m1_190_784 x61/m1_2410_635 w_0_822 w_0_822 sky130_fd_pr__pfet_01v8 ad=0 pd=0 as=0 ps=0 w=400 l=30
X90 w_0_822 CLK x61/m1_190_784 w_0_822 sky130_fd_pr__pfet_01v8 ad=0 pd=0 as=0 ps=0 w=400 l=30
X91 x61/m1_190_784 CLK w_0_822 w_0_822 sky130_fd_pr__pfet_01v8 ad=0 pd=0 as=0 ps=0 w=400 l=30
X92 w_0_822 RN x61/m1_190_784 w_0_822 sky130_fd_pr__pfet_01v8 ad=0 pd=0 as=0 ps=0 w=400 l=30
X93 x61/m1_190_784 RN w_0_822 w_0_822 sky130_fd_pr__pfet_01v8 ad=0 pd=0 as=0 ps=0 w=400 l=30
X94 x1/VSUBS x61/m1_783_709 x95/a_0_0 x1/VSUBS sky130_fd_pr__nfet_01v8 ad=0 pd=0 as=78.2n ps=2.61m w=602 l=30
X96 m1_9612_741 m1_9464_673 x97/li_393_182 x1/VSUBS sky130_fd_pr__nfet_01v8 ad=1p pd=-87u as=52.7n ps=1.92m w=602 l=30
X98 x97/li_393_182 RN x95/a_0_0 x1/VSUBS sky130_fd_pr__nfet_01v8 ad=0 pd=0 as=0 ps=0 w=600 l=30
X99 w_0_822 x61/m1_783_709 m1_9612_741 w_0_822 sky130_fd_pr__pfet_01v8 ad=0 pd=0 as=69.6n ps=2.75m w=400 l=30
X100 m1_9612_741 x61/m1_783_709 w_0_822 w_0_822 sky130_fd_pr__pfet_01v8 ad=0 pd=0 as=0 ps=0 w=400 l=30
X101 w_0_822 RN m1_9612_741 w_0_822 sky130_fd_pr__pfet_01v8 ad=0 pd=0 as=0 ps=0 w=400 l=30
X102 m1_9612_741 RN w_0_822 w_0_822 sky130_fd_pr__pfet_01v8 ad=0 pd=0 as=0 ps=0 w=400 l=30
X103 w_0_822 m1_9464_673 m1_9612_741 w_0_822 sky130_fd_pr__pfet_01v8 ad=0 pd=0 as=0 ps=0 w=400 l=30
X104 m1_9612_741 m1_9464_673 w_0_822 w_0_822 sky130_fd_pr__pfet_01v8 ad=0 pd=0 as=0 ps=0 w=400 l=30
X105 x1/VSUBS x61/m1_634_634 x106/a_0_0 x1/VSUBS sky130_fd_pr__nfet_01v8 ad=0 pd=0 as=77.2n ps=2.61m w=602 l=30
X107 x61/m1_2410_635 x61/m1_190_784 x106/a_0_0 x1/VSUBS sky130_fd_pr__nfet_01v8 ad=1p pd=-87u as=0 ps=0 w=602 l=30
X108 w_0_822 x61/m1_634_634 x61/m1_2410_635 w_0_822 sky130_fd_pr__pfet_01v8 ad=0 pd=0 as=46.4n ps=1.83m w=400 l=30
X109 x61/m1_2410_635 x61/m1_634_634 w_0_822 w_0_822 sky130_fd_pr__pfet_01v8 ad=0 pd=0 as=0 ps=0 w=400 l=30
X110 w_0_822 x61/m1_190_784 x61/m1_2410_635 w_0_822 sky130_fd_pr__pfet_01v8 ad=0 pd=0 as=0 ps=0 w=400 l=30
X111 x61/m1_2410_635 x61/m1_190_784 w_0_822 w_0_822 sky130_fd_pr__pfet_01v8 ad=0 pd=0 as=0 ps=0 w=400 l=30
X112 x1/VSUBS m1_9612_741 x113/a_0_0 x1/VSUBS sky130_fd_pr__nfet_01v8 ad=0 pd=0 as=77.2n ps=2.61m w=602 l=30
X114 m1_9464_673 x61/m1_190_784 x113/a_0_0 x1/VSUBS sky130_fd_pr__nfet_01v8 ad=-7.16n pd=-1.02m as=0 ps=0 w=602 l=30
X115 w_0_822 m1_9612_741 m1_9464_673 w_0_822 sky130_fd_pr__pfet_01v8 ad=0 pd=0 as=0.162u ps=6.41m w=400 l=30
X116 m1_9464_673 m1_9612_741 w_0_822 w_0_822 sky130_fd_pr__pfet_01v8 ad=0 pd=0 as=0 ps=0 w=400 l=30
X117 w_0_822 x61/m1_190_784 m1_9464_673 w_0_822 sky130_fd_pr__pfet_01v8 ad=0 pd=0 as=0 ps=0 w=400 l=30
X118 m1_9464_673 x61/m1_190_784 w_0_822 w_0_822 sky130_fd_pr__pfet_01v8 ad=0 pd=0 as=0 ps=0 w=400 l=30
X119 x1/VSUBS m2_14877_833 x120/a_0_0 x1/VSUBS sky130_fd_pr__nfet_01v8 ad=0 pd=0 as=78.2n ps=2.61m w=602 l=30
X121 x1/m1_783_709 m1_9464_673 x122/li_393_182 x1/VSUBS sky130_fd_pr__nfet_01v8 ad=-7.16n pd=-0.488m as=52.7n ps=1.92m w=602 l=30
X123 x122/li_393_182 CLK x120/a_0_0 x1/VSUBS sky130_fd_pr__nfet_01v8 ad=0 pd=0 as=0 ps=0 w=600 l=30
X124 w_0_822 m2_14877_833 x1/m1_783_709 w_0_822 sky130_fd_pr__pfet_01v8 ad=0 pd=0 as=69.6n ps=2.75m w=400 l=30
X125 x1/m1_783_709 m2_14877_833 w_0_822 w_0_822 sky130_fd_pr__pfet_01v8 ad=0 pd=0 as=0 ps=0 w=400 l=30
X126 w_0_822 CLK x1/m1_783_709 w_0_822 sky130_fd_pr__pfet_01v8 ad=0 pd=0 as=0 ps=0 w=400 l=30
X127 x1/m1_783_709 CLK w_0_822 w_0_822 sky130_fd_pr__pfet_01v8 ad=0 pd=0 as=0 ps=0 w=400 l=30
X128 w_0_822 m1_9464_673 x1/m1_783_709 w_0_822 sky130_fd_pr__pfet_01v8 ad=0 pd=0 as=0 ps=0 w=400 l=30
X129 x1/m1_783_709 m1_9464_673 w_0_822 w_0_822 sky130_fd_pr__pfet_01v8 ad=0 pd=0 as=0 ps=0 w=400 l=30
X130 x1/VSUBS x1/m1_783_709 x131/a_0_0 x1/VSUBS sky130_fd_pr__nfet_01v8 ad=0 pd=0 as=78.2n ps=2.61m w=602 l=30
X132 m1_9464_673 RN x133/li_393_182 x1/VSUBS sky130_fd_pr__nfet_01v8 ad=-0 pd=-0 as=52.7n ps=1.92m w=602 l=30
X134 x133/li_393_182 D x131/a_0_0 x1/VSUBS sky130_fd_pr__nfet_01v8 ad=0 pd=0 as=0 ps=0 w=600 l=30
X135 w_0_822 x1/m1_783_709 m1_9464_673 w_0_822 sky130_fd_pr__pfet_01v8 ad=0 pd=0 as=0 ps=0 w=400 l=30
X136 m1_9464_673 x1/m1_783_709 w_0_822 w_0_822 sky130_fd_pr__pfet_01v8 ad=0 pd=0 as=0 ps=0 w=400 l=30
X137 w_0_822 D m1_9464_673 w_0_822 sky130_fd_pr__pfet_01v8 ad=0 pd=0 as=0 ps=0 w=400 l=30
X138 m1_9464_673 D w_0_822 w_0_822 sky130_fd_pr__pfet_01v8 ad=0 pd=0 as=0 ps=0 w=400 l=30
X139 w_0_822 RN m1_9464_673 w_0_822 sky130_fd_pr__pfet_01v8 ad=0 pd=0 as=0 ps=0 w=400 l=30
X140 m1_9464_673 RN w_0_822 w_0_822 sky130_fd_pr__pfet_01v8 ad=0 pd=0 as=0 ps=0 w=400 l=30
X141 x1/VSUBS m1_9464_673 x142/a_0_0 x1/VSUBS sky130_fd_pr__nfet_01v8 ad=0 pd=0 as=78.2n ps=2.61m w=602 l=30
X143 m2_14877_833 RN x144/li_393_182 x1/VSUBS sky130_fd_pr__nfet_01v8 ad=2p pd=-0.174m as=52.7n ps=1.92m w=602 l=30
X145 x144/li_393_182 CLK x142/a_0_0 x1/VSUBS sky130_fd_pr__nfet_01v8 ad=0 pd=0 as=0 ps=0 w=600 l=30
X146 w_0_822 m1_9464_673 m2_14877_833 w_0_822 sky130_fd_pr__pfet_01v8 ad=0 pd=0 as=0.139u ps=5.5m w=400 l=30
X147 m2_14877_833 m1_9464_673 w_0_822 w_0_822 sky130_fd_pr__pfet_01v8 ad=0 pd=0 as=0 ps=0 w=400 l=30
X148 w_0_822 CLK m2_14877_833 w_0_822 sky130_fd_pr__pfet_01v8 ad=0 pd=0 as=0 ps=0 w=400 l=30
X149 m2_14877_833 CLK w_0_822 w_0_822 sky130_fd_pr__pfet_01v8 ad=0 pd=0 as=0 ps=0 w=400 l=30
X150 w_0_822 RN m2_14877_833 w_0_822 sky130_fd_pr__pfet_01v8 ad=0 pd=0 as=0 ps=0 w=400 l=30
X151 m2_14877_833 RN w_0_822 w_0_822 sky130_fd_pr__pfet_01v8 ad=0 pd=0 as=0 ps=0 w=400 l=30
X152 x1/VSUBS x1/m1_783_709 x153/a_0_0 x1/VSUBS sky130_fd_pr__nfet_01v8 ad=0 pd=0 as=78.2n ps=2.61m w=602 l=30
X154 m2_14877_833 m1_14644_741 x155/li_393_182 x1/VSUBS sky130_fd_pr__nfet_01v8 ad=0 pd=-0 as=52.7n ps=1.92m w=602 l=30
X156 x155/li_393_182 RN x153/a_0_0 x1/VSUBS sky130_fd_pr__nfet_01v8 ad=0 pd=0 as=0 ps=0 w=600 l=30
X157 w_0_822 x1/m1_783_709 m2_14877_833 w_0_822 sky130_fd_pr__pfet_01v8 ad=0 pd=0 as=0 ps=0 w=400 l=30
X158 m2_14877_833 x1/m1_783_709 w_0_822 w_0_822 sky130_fd_pr__pfet_01v8 ad=0 pd=0 as=0 ps=0 w=400 l=30
X159 w_0_822 RN m2_14877_833 w_0_822 sky130_fd_pr__pfet_01v8 ad=0 pd=0 as=0 ps=0 w=400 l=30
X160 m2_14877_833 RN w_0_822 w_0_822 sky130_fd_pr__pfet_01v8 ad=0 pd=0 as=0 ps=0 w=400 l=30
X161 w_0_822 m1_14644_741 m2_14877_833 w_0_822 sky130_fd_pr__pfet_01v8 ad=0 pd=0 as=0 ps=0 w=400 l=30
X162 m2_14877_833 m1_14644_741 w_0_822 w_0_822 sky130_fd_pr__pfet_01v8 ad=0 pd=0 as=0 ps=0 w=400 l=30
X163 x1/VSUBS m1_9464_673 x164/a_0_0 x1/VSUBS sky130_fd_pr__nfet_01v8 ad=0 pd=0 as=77.2n ps=2.61m w=602 l=30
X165 m1_9464_673 m2_14877_833 x164/a_0_0 x1/VSUBS sky130_fd_pr__nfet_01v8 ad=-0 pd=-0 as=0 ps=0 w=602 l=30
X166 w_0_822 m1_9464_673 m1_9464_673 w_0_822 sky130_fd_pr__pfet_01v8 ad=0 pd=0 as=0 ps=0 w=400 l=30
X167 m1_9464_673 m1_9464_673 w_0_822 w_0_822 sky130_fd_pr__pfet_01v8 ad=0 pd=0 as=0 ps=0 w=400 l=30
X168 w_0_822 m2_14877_833 m1_9464_673 w_0_822 sky130_fd_pr__pfet_01v8 ad=0 pd=0 as=0 ps=0 w=400 l=30
X169 m1_9464_673 m2_14877_833 w_0_822 w_0_822 sky130_fd_pr__pfet_01v8 ad=0 pd=0 as=0 ps=0 w=400 l=30
X170 x1/VSUBS m2_14877_833 x171/a_0_0 x1/VSUBS sky130_fd_pr__nfet_01v8 ad=0 pd=0 as=77.2n ps=2.61m w=602 l=30
X172 m1_14644_741 m2_14877_833 x171/a_0_0 x1/VSUBS sky130_fd_pr__nfet_01v8 ad=7.16n pd=0.314m as=0 ps=0 w=602 l=30
X173 w_0_822 m2_14877_833 m1_14644_741 w_0_822 sky130_fd_pr__pfet_01v8 ad=0 pd=0 as=46.4n ps=1.83m w=400 l=30
X174 m1_14644_741 m2_14877_833 w_0_822 w_0_822 sky130_fd_pr__pfet_01v8 ad=0 pd=0 as=0 ps=0 w=400 l=30
X175 w_0_822 m2_14877_833 m1_14644_741 w_0_822 sky130_fd_pr__pfet_01v8 ad=0 pd=0 as=0 ps=0 w=400 l=30
X176 m1_14644_741 m2_14877_833 w_0_822 w_0_822 sky130_fd_pr__pfet_01v8 ad=0 pd=0 as=0 ps=0 w=400 l=30
X177 x1/VSUBS m1_9464_673 x178/a_0_0 x1/VSUBS sky130_fd_pr__nfet_01v8 ad=0 pd=0 as=76.7n ps=2.6m w=602 l=30
X179 x1/VSUBS m1_9464_673 x180/a_0_0 x1/VSUBS sky130_fd_pr__nfet_01v8 ad=0 pd=0 as=77.2n ps=2.61m w=602 l=30
X181 x1/VSUBS m1_4283_599 x182/a_0_0 x1/VSUBS sky130_fd_pr__nfet_01v8 ad=0 pd=0 as=77.2n ps=2.61m w=602 l=30
X183 x184/a_805_1331 m1_9464_673 w_0_822 w_0_822 sky130_fd_pr__pfet_01v8 ad=11.6n pd=0.458m as=22.4n ps=0.912m w=400 l=30
X185 w_0_822 m1_9464_673 x184/a_805_1331 w_0_822 sky130_fd_pr__pfet_01v8 ad=21.6n pd=0.908m as=11.6n ps=0.458m w=400 l=30
X186 QN m1_4283_599 x180/a_0_0 x1/VSUBS sky130_fd_pr__nfet_01v8 ad=21.5n pd=0.944m as=0 ps=0 w=602 l=30
X187 x184/a_805_1331 m1_14644_741 w_0_822 w_0_822 sky130_fd_pr__pfet_01v8 ad=0.114u pd=4.57m as=0 ps=0 w=400 l=30
X188 w_0_822 m1_14644_741 x184/a_805_1331 w_0_822 sky130_fd_pr__pfet_01v8 ad=0 pd=0 as=0 ps=0 w=400 l=30
X189 li_16707_1107 m1_4283_599 x184/a_805_1331 w_0_822 sky130_fd_pr__pfet_01v8 ad=0.114u pd=4.57m as=0 ps=0 w=400 l=30
X190 x184/a_805_1331 m1_4283_599 li_16707_1107 w_0_822 sky130_fd_pr__pfet_01v8 ad=0 pd=0 as=0 ps=0 w=400 l=30
X191 li_16707_1107 m1_9464_673 x184/a_805_1331 w_0_822 sky130_fd_pr__pfet_01v8 ad=0 pd=0 as=0 ps=0 w=400 l=30
X192 x184/a_805_1331 m1_9464_673 li_16707_1107 w_0_822 sky130_fd_pr__pfet_01v8 ad=0 pd=0 as=0 ps=0 w=400 l=30
X193 QN m1_4283_599 li_16707_1107 w_0_822 sky130_fd_pr__pfet_01v8 ad=46.4n pd=1.83m as=0 ps=0 w=400 l=30
X194 li_16707_1107 m1_4283_599 QN w_0_822 sky130_fd_pr__pfet_01v8 ad=0 pd=0 as=0 ps=0 w=400 l=30
X195 QN m1_14644_741 li_16707_1107 w_0_822 sky130_fd_pr__pfet_01v8 ad=0 pd=0 as=0 ps=0 w=400 l=30
X196 li_16707_1107 m1_14644_741 QN w_0_822 sky130_fd_pr__pfet_01v8 ad=0 pd=0 as=0 ps=0 w=400 l=30
X197 QN m1_14644_741 x178/a_0_0 x1/VSUBS sky130_fd_pr__nfet_01v8 ad=2.39n pd=0.111m as=15.6n ps=0.592m w=602 l=30
X198 QN m1_14644_741 x182/a_0_0 x1/VSUBS sky130_fd_pr__nfet_01v8 ad=2.4n pd=0.112m as=15.8n ps=0.594m w=602 l=30
C0 x61/m1_190_784 CLK 2.48f
C1 x1/m1_783_709 m1_9464_673 2.08f
C2 m1_4283_599 m1_9464_673 3.62f
C3 m2_14877_833 CLK 2.05f
C4 m2_14877_833 w_0_822 2.84f
C5 m2_4517_833 CLK 2.03f
C6 m1_4283_599 D 3.94f
C7 m2_4517_833 w_0_822 2.87f
C8 D RN 5.11f
C9 CLK w_0_822 3.33f
C10 RN w_0_822 2.13f
C11 m1_9464_673 w_0_822 4.15f
.ends

** hspice subcircuit dictionary
* x1	dffrnx1_pcell_2
* x2	dffrnx1_pcell_0/nand3x1_pcell_0/nmos_bottom_0
* x4	dffrnx1_pcell_0
* x5	dffrnx1_pcell_0/nand3x1_pcell_0
* x14	dffrnx1_pcell_0/nand3x1_pcell_1/nmos_bottom_0
* x16	dffrnx1_pcell_0/nand3x1_pcell_1
* x25	dffrnx1_pcell_0/nand3x1_pcell_3/nmos_bottom_0
* x27	dffrnx1_pcell_0/nand3x1_pcell_3
* x36	dffrnx1_pcell_0/nand3x1_pcell_4/nmos_bottom_0
* x38	dffrnx1_pcell_0/nand3x1_pcell_4
* x47	dffrnx1_pcell_0/nand2x1_pcell_0/nmos_bottom_0
* x54	dffrnx1_pcell_0/nand2x1_pcell_1/nmos_bottom_0
* x61	dffrnx1_pcell_1
* x62	dffrnx1_pcell_1/nand3x1_pcell_0/nmos_bottom_0
* x64	dffrnx1_pcell_1/nand3x1_pcell_0
* x73	dffrnx1_pcell_1/nand3x1_pcell_1/nmos_bottom_0
* x75	dffrnx1_pcell_1/nand3x1_pcell_1
* x84	dffrnx1_pcell_1/nand3x1_pcell_3/nmos_bottom_0
* x86	dffrnx1_pcell_1/nand3x1_pcell_3
* x95	dffrnx1_pcell_1/nand3x1_pcell_4/nmos_bottom_0
* x97	dffrnx1_pcell_1/nand3x1_pcell_4
* x106	dffrnx1_pcell_1/nand2x1_pcell_0/nmos_bottom_0
* x113	dffrnx1_pcell_1/nand2x1_pcell_1/nmos_bottom_0
* x120	dffrnx1_pcell_2/nand3x1_pcell_0/nmos_bottom_0
* x122	dffrnx1_pcell_2/nand3x1_pcell_0
* x131	dffrnx1_pcell_2/nand3x1_pcell_1/nmos_bottom_0
* x133	dffrnx1_pcell_2/nand3x1_pcell_1
* x142	dffrnx1_pcell_2/nand3x1_pcell_3/nmos_bottom_0
* x144	dffrnx1_pcell_2/nand3x1_pcell_3
* x153	dffrnx1_pcell_2/nand3x1_pcell_4/nmos_bottom_0
* x155	dffrnx1_pcell_2/nand3x1_pcell_4
* x164	dffrnx1_pcell_2/nand2x1_pcell_0/nmos_bottom_0
* x171	dffrnx1_pcell_2/nand2x1_pcell_1/nmos_bottom_0
* x178	votern3x1_pcell_0/nmos_top_0
* x180	votern3x1_pcell_0/nmos_bottom_1
* x182	votern3x1_pcell_0/nmos_bottom_2
* x184	votern3x1_pcell_0
