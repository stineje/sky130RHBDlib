* HSPICE file created from TMRDFFRNQNX1.ext - technology: sky130A

.option scale=5m

.subckt TMRDFFRNQNX1 QN D CLK RN VDD GND
X0 GND m2_4517_833 x1/a_0_0 GND sky130_fd_pr__nfet_01v8 ad=2.39n pd=0.111m as=15.7n ps=0.599m w=602 l=30
X2 x3/m1_783_709 x3/m1_634_634 x4/li_393_182 GND sky130_fd_pr__nfet_01v8 ad=2.39n pd=0.111m as=15.8n ps=0.594m w=602 l=30
X5 x4/li_393_182 CLK x1/a_0_0 GND sky130_fd_pr__nfet_01v8 ad=2.18n pd=0.106m as=16.2n ps=0.604m w=600 l=30
X6 VDD m2_4517_833 x3/m1_783_709 VDD sky130_fd_pr__pfet_01v8 ad=21.6n pd=0.908m as=11.6n ps=0.458m w=400 l=30
X7 x3/m1_783_709 m2_4517_833 VDD VDD sky130_fd_pr__pfet_01v8 ad=11.6n pd=0.458m as=22.4n ps=0.912m w=400 l=30
X8 VDD CLK x3/m1_783_709 VDD sky130_fd_pr__pfet_01v8 ad=1.56u pd=0.063 as=69.6n ps=2.75m w=400 l=30
X9 x3/m1_783_709 CLK VDD VDD sky130_fd_pr__pfet_01v8 ad=0 pd=0 as=0 ps=0 w=400 l=30
X10 VDD x3/m1_634_634 x3/m1_783_709 VDD sky130_fd_pr__pfet_01v8 ad=0 pd=0 as=0 ps=0 w=400 l=30
X11 x3/m1_783_709 x3/m1_634_634 VDD VDD sky130_fd_pr__pfet_01v8 ad=0 pd=0 as=0 ps=0 w=400 l=30
X12 GND x3/m1_783_709 x13/a_0_0 GND sky130_fd_pr__nfet_01v8 ad=0.301u pd=0.0156 as=78.2n ps=2.61m w=602 l=30
X14 x3/m1_634_634 RN x15/li_393_182 GND sky130_fd_pr__nfet_01v8 ad=1p pd=-87u as=52.7n ps=1.92m w=602 l=30
X16 x15/li_393_182 D x13/a_0_0 GND sky130_fd_pr__nfet_01v8 ad=0 pd=0 as=0 ps=0 w=600 l=30
X17 VDD x3/m1_783_709 x3/m1_634_634 VDD sky130_fd_pr__pfet_01v8 ad=0 pd=0 as=69.6n ps=2.75m w=400 l=30
X18 x3/m1_634_634 x3/m1_783_709 VDD VDD sky130_fd_pr__pfet_01v8 ad=0 pd=0 as=0 ps=0 w=400 l=30
X19 VDD D x3/m1_634_634 VDD sky130_fd_pr__pfet_01v8 ad=0 pd=0 as=0 ps=0 w=400 l=30
X20 x3/m1_634_634 D VDD VDD sky130_fd_pr__pfet_01v8 ad=0 pd=0 as=0 ps=0 w=400 l=30
X21 VDD RN x3/m1_634_634 VDD sky130_fd_pr__pfet_01v8 ad=0 pd=0 as=0 ps=0 w=400 l=30
X22 x3/m1_634_634 RN VDD VDD sky130_fd_pr__pfet_01v8 ad=0 pd=0 as=0 ps=0 w=400 l=30
X23 GND x3/m1_2410_635 x24/a_0_0 GND sky130_fd_pr__nfet_01v8 ad=0 pd=0 as=78.2n ps=2.61m w=602 l=30
X25 m2_4517_833 RN x26/li_393_182 GND sky130_fd_pr__nfet_01v8 ad=2p pd=-0.174m as=52.7n ps=1.92m w=602 l=30
X27 x26/li_393_182 CLK x24/a_0_0 GND sky130_fd_pr__nfet_01v8 ad=0 pd=0 as=0 ps=0 w=600 l=30
X28 VDD x3/m1_2410_635 m2_4517_833 VDD sky130_fd_pr__pfet_01v8 ad=0 pd=0 as=0.139u ps=5.5m w=400 l=30
X29 m2_4517_833 x3/m1_2410_635 VDD VDD sky130_fd_pr__pfet_01v8 ad=0 pd=0 as=0 ps=0 w=400 l=30
X30 VDD CLK m2_4517_833 VDD sky130_fd_pr__pfet_01v8 ad=0 pd=0 as=0 ps=0 w=400 l=30
X31 m2_4517_833 CLK VDD VDD sky130_fd_pr__pfet_01v8 ad=0 pd=0 as=0 ps=0 w=400 l=30
X32 VDD RN m2_4517_833 VDD sky130_fd_pr__pfet_01v8 ad=0 pd=0 as=0 ps=0 w=400 l=30
X33 m2_4517_833 RN VDD VDD sky130_fd_pr__pfet_01v8 ad=0 pd=0 as=0 ps=0 w=400 l=30
X34 GND x3/m1_783_709 x35/a_0_0 GND sky130_fd_pr__nfet_01v8 ad=0 pd=0 as=78.2n ps=2.61m w=602 l=30
X36 m2_4517_833 m1_4283_599 x37/li_393_182 GND sky130_fd_pr__nfet_01v8 ad=0 pd=-0 as=52.7n ps=1.92m w=602 l=30
X38 x37/li_393_182 RN x35/a_0_0 GND sky130_fd_pr__nfet_01v8 ad=0 pd=0 as=0 ps=0 w=600 l=30
X39 VDD x3/m1_783_709 m2_4517_833 VDD sky130_fd_pr__pfet_01v8 ad=0 pd=0 as=0 ps=0 w=400 l=30
X40 m2_4517_833 x3/m1_783_709 VDD VDD sky130_fd_pr__pfet_01v8 ad=0 pd=0 as=0 ps=0 w=400 l=30
X41 VDD RN m2_4517_833 VDD sky130_fd_pr__pfet_01v8 ad=0 pd=0 as=0 ps=0 w=400 l=30
X42 m2_4517_833 RN VDD VDD sky130_fd_pr__pfet_01v8 ad=0 pd=0 as=0 ps=0 w=400 l=30
X43 VDD m1_4283_599 m2_4517_833 VDD sky130_fd_pr__pfet_01v8 ad=0 pd=0 as=0 ps=0 w=400 l=30
X44 m2_4517_833 m1_4283_599 VDD VDD sky130_fd_pr__pfet_01v8 ad=0 pd=0 as=0 ps=0 w=400 l=30
X45 GND x3/m1_634_634 x46/a_0_0 GND sky130_fd_pr__nfet_01v8 ad=0 pd=0 as=77.2n ps=2.61m w=602 l=30
X47 x3/m1_2410_635 m2_4517_833 x46/a_0_0 GND sky130_fd_pr__nfet_01v8 ad=1p pd=-87u as=0 ps=0 w=602 l=30
X48 VDD x3/m1_634_634 x3/m1_2410_635 VDD sky130_fd_pr__pfet_01v8 ad=0 pd=0 as=46.4n ps=1.83m w=400 l=30
X49 x3/m1_2410_635 x3/m1_634_634 VDD VDD sky130_fd_pr__pfet_01v8 ad=0 pd=0 as=0 ps=0 w=400 l=30
X50 VDD m2_4517_833 x3/m1_2410_635 VDD sky130_fd_pr__pfet_01v8 ad=0 pd=0 as=0 ps=0 w=400 l=30
X51 x3/m1_2410_635 m2_4517_833 VDD VDD sky130_fd_pr__pfet_01v8 ad=0 pd=0 as=0 ps=0 w=400 l=30
X52 GND m2_4517_833 x53/a_0_0 GND sky130_fd_pr__nfet_01v8 ad=0 pd=0 as=77.2n ps=2.61m w=602 l=30
X54 m1_4283_599 m2_4517_833 x53/a_0_0 GND sky130_fd_pr__nfet_01v8 ad=1p pd=-0.263m as=0 ps=0 w=602 l=30
X55 VDD m2_4517_833 m1_4283_599 VDD sky130_fd_pr__pfet_01v8 ad=0 pd=0 as=46.4n ps=1.83m w=400 l=30
X56 m1_4283_599 m2_4517_833 VDD VDD sky130_fd_pr__pfet_01v8 ad=0 pd=0 as=0 ps=0 w=400 l=30
X57 VDD m2_4517_833 m1_4283_599 VDD sky130_fd_pr__pfet_01v8 ad=0 pd=0 as=0 ps=0 w=400 l=30
X58 m1_4283_599 m2_4517_833 VDD VDD sky130_fd_pr__pfet_01v8 ad=0 pd=0 as=0 ps=0 w=400 l=30
X59 GND x60/m1_190_784 x61/a_0_0 GND sky130_fd_pr__nfet_01v8 ad=0 pd=0 as=78.2n ps=2.61m w=602 l=30
X62 x60/m1_783_709 x60/m1_634_634 x63/li_393_182 GND sky130_fd_pr__nfet_01v8 ad=-7.16n pd=-0.488m as=52.7n ps=1.92m w=602 l=30
X64 x63/li_393_182 CLK x61/a_0_0 GND sky130_fd_pr__nfet_01v8 ad=0 pd=0 as=0 ps=0 w=600 l=30
X65 VDD x60/m1_190_784 x60/m1_783_709 VDD sky130_fd_pr__pfet_01v8 ad=0 pd=0 as=69.6n ps=2.75m w=400 l=30
X66 x60/m1_783_709 x60/m1_190_784 VDD VDD sky130_fd_pr__pfet_01v8 ad=0 pd=0 as=0 ps=0 w=400 l=30
X67 VDD CLK x60/m1_783_709 VDD sky130_fd_pr__pfet_01v8 ad=0 pd=0 as=0 ps=0 w=400 l=30
X68 x60/m1_783_709 CLK VDD VDD sky130_fd_pr__pfet_01v8 ad=0 pd=0 as=0 ps=0 w=400 l=30
X69 VDD x60/m1_634_634 x60/m1_783_709 VDD sky130_fd_pr__pfet_01v8 ad=0 pd=0 as=0 ps=0 w=400 l=30
X70 x60/m1_783_709 x60/m1_634_634 VDD VDD sky130_fd_pr__pfet_01v8 ad=0 pd=0 as=0 ps=0 w=400 l=30
X71 GND x60/m1_783_709 x72/a_0_0 GND sky130_fd_pr__nfet_01v8 ad=0 pd=0 as=78.2n ps=2.61m w=602 l=30
X73 x60/m1_634_634 RN x74/li_393_182 GND sky130_fd_pr__nfet_01v8 ad=1p pd=-87u as=52.7n ps=1.92m w=602 l=30
X75 x74/li_393_182 D x72/a_0_0 GND sky130_fd_pr__nfet_01v8 ad=0 pd=0 as=0 ps=0 w=600 l=30
X76 VDD x60/m1_783_709 x60/m1_634_634 VDD sky130_fd_pr__pfet_01v8 ad=0 pd=0 as=69.6n ps=2.75m w=400 l=30
X77 x60/m1_634_634 x60/m1_783_709 VDD VDD sky130_fd_pr__pfet_01v8 ad=0 pd=0 as=0 ps=0 w=400 l=30
X78 VDD D x60/m1_634_634 VDD sky130_fd_pr__pfet_01v8 ad=0 pd=0 as=0 ps=0 w=400 l=30
X79 x60/m1_634_634 D VDD VDD sky130_fd_pr__pfet_01v8 ad=0 pd=0 as=0 ps=0 w=400 l=30
X80 VDD RN x60/m1_634_634 VDD sky130_fd_pr__pfet_01v8 ad=0 pd=0 as=0 ps=0 w=400 l=30
X81 x60/m1_634_634 RN VDD VDD sky130_fd_pr__pfet_01v8 ad=0 pd=0 as=0 ps=0 w=400 l=30
X82 GND x60/m1_2410_635 x83/a_0_0 GND sky130_fd_pr__nfet_01v8 ad=0 pd=0 as=78.2n ps=2.61m w=602 l=30
X84 x60/m1_190_784 RN x85/li_393_182 GND sky130_fd_pr__nfet_01v8 ad=1p pd=-87u as=52.7n ps=1.92m w=602 l=30
X86 x85/li_393_182 CLK x83/a_0_0 GND sky130_fd_pr__nfet_01v8 ad=0 pd=0 as=0 ps=0 w=600 l=30
X87 VDD x60/m1_2410_635 x60/m1_190_784 VDD sky130_fd_pr__pfet_01v8 ad=0 pd=0 as=69.6n ps=2.75m w=400 l=30
X88 x60/m1_190_784 x60/m1_2410_635 VDD VDD sky130_fd_pr__pfet_01v8 ad=0 pd=0 as=0 ps=0 w=400 l=30
X89 VDD CLK x60/m1_190_784 VDD sky130_fd_pr__pfet_01v8 ad=0 pd=0 as=0 ps=0 w=400 l=30
X90 x60/m1_190_784 CLK VDD VDD sky130_fd_pr__pfet_01v8 ad=0 pd=0 as=0 ps=0 w=400 l=30
X91 VDD RN x60/m1_190_784 VDD sky130_fd_pr__pfet_01v8 ad=0 pd=0 as=0 ps=0 w=400 l=30
X92 x60/m1_190_784 RN VDD VDD sky130_fd_pr__pfet_01v8 ad=0 pd=0 as=0 ps=0 w=400 l=30
X93 GND x60/m1_783_709 x94/a_0_0 GND sky130_fd_pr__nfet_01v8 ad=0 pd=0 as=78.2n ps=2.61m w=602 l=30
X95 m1_9612_741 m1_9464_673 x96/li_393_182 GND sky130_fd_pr__nfet_01v8 ad=1p pd=-87u as=52.7n ps=1.92m w=602 l=30
X97 x96/li_393_182 RN x94/a_0_0 GND sky130_fd_pr__nfet_01v8 ad=0 pd=0 as=0 ps=0 w=600 l=30
X98 VDD x60/m1_783_709 m1_9612_741 VDD sky130_fd_pr__pfet_01v8 ad=0 pd=0 as=69.6n ps=2.75m w=400 l=30
X99 m1_9612_741 x60/m1_783_709 VDD VDD sky130_fd_pr__pfet_01v8 ad=0 pd=0 as=0 ps=0 w=400 l=30
X100 VDD RN m1_9612_741 VDD sky130_fd_pr__pfet_01v8 ad=0 pd=0 as=0 ps=0 w=400 l=30
X101 m1_9612_741 RN VDD VDD sky130_fd_pr__pfet_01v8 ad=0 pd=0 as=0 ps=0 w=400 l=30
X102 VDD m1_9464_673 m1_9612_741 VDD sky130_fd_pr__pfet_01v8 ad=0 pd=0 as=0 ps=0 w=400 l=30
X103 m1_9612_741 m1_9464_673 VDD VDD sky130_fd_pr__pfet_01v8 ad=0 pd=0 as=0 ps=0 w=400 l=30
X104 GND x60/m1_634_634 x105/a_0_0 GND sky130_fd_pr__nfet_01v8 ad=0 pd=0 as=77.2n ps=2.61m w=602 l=30
X106 x60/m1_2410_635 x60/m1_190_784 x105/a_0_0 GND sky130_fd_pr__nfet_01v8 ad=1p pd=-87u as=0 ps=0 w=602 l=30
X107 VDD x60/m1_634_634 x60/m1_2410_635 VDD sky130_fd_pr__pfet_01v8 ad=0 pd=0 as=46.4n ps=1.83m w=400 l=30
X108 x60/m1_2410_635 x60/m1_634_634 VDD VDD sky130_fd_pr__pfet_01v8 ad=0 pd=0 as=0 ps=0 w=400 l=30
X109 VDD x60/m1_190_784 x60/m1_2410_635 VDD sky130_fd_pr__pfet_01v8 ad=0 pd=0 as=0 ps=0 w=400 l=30
X110 x60/m1_2410_635 x60/m1_190_784 VDD VDD sky130_fd_pr__pfet_01v8 ad=0 pd=0 as=0 ps=0 w=400 l=30
X111 GND m1_9612_741 x112/a_0_0 GND sky130_fd_pr__nfet_01v8 ad=0 pd=0 as=77.2n ps=2.61m w=602 l=30
X113 m1_9464_673 x60/m1_190_784 x112/a_0_0 GND sky130_fd_pr__nfet_01v8 ad=-7.16n pd=-1.02m as=0 ps=0 w=602 l=30
X114 VDD m1_9612_741 m1_9464_673 VDD sky130_fd_pr__pfet_01v8 ad=0 pd=0 as=0.162u ps=6.41m w=400 l=30
X115 m1_9464_673 m1_9612_741 VDD VDD sky130_fd_pr__pfet_01v8 ad=0 pd=0 as=0 ps=0 w=400 l=30
X116 VDD x60/m1_190_784 m1_9464_673 VDD sky130_fd_pr__pfet_01v8 ad=0 pd=0 as=0 ps=0 w=400 l=30
X117 m1_9464_673 x60/m1_190_784 VDD VDD sky130_fd_pr__pfet_01v8 ad=0 pd=0 as=0 ps=0 w=400 l=30
X118 GND m2_14877_833 x119/a_0_0 GND sky130_fd_pr__nfet_01v8 ad=0 pd=0 as=78.2n ps=2.61m w=602 l=30
X120 x121/m1_783_709 m1_9464_673 x122/li_393_182 GND sky130_fd_pr__nfet_01v8 ad=-7.16n pd=-0.488m as=52.7n ps=1.92m w=602 l=30
X123 x122/li_393_182 CLK x119/a_0_0 GND sky130_fd_pr__nfet_01v8 ad=0 pd=0 as=0 ps=0 w=600 l=30
X124 VDD m2_14877_833 x121/m1_783_709 VDD sky130_fd_pr__pfet_01v8 ad=0 pd=0 as=69.6n ps=2.75m w=400 l=30
X125 x121/m1_783_709 m2_14877_833 VDD VDD sky130_fd_pr__pfet_01v8 ad=0 pd=0 as=0 ps=0 w=400 l=30
X126 VDD CLK x121/m1_783_709 VDD sky130_fd_pr__pfet_01v8 ad=0 pd=0 as=0 ps=0 w=400 l=30
X127 x121/m1_783_709 CLK VDD VDD sky130_fd_pr__pfet_01v8 ad=0 pd=0 as=0 ps=0 w=400 l=30
X128 VDD m1_9464_673 x121/m1_783_709 VDD sky130_fd_pr__pfet_01v8 ad=0 pd=0 as=0 ps=0 w=400 l=30
X129 x121/m1_783_709 m1_9464_673 VDD VDD sky130_fd_pr__pfet_01v8 ad=0 pd=0 as=0 ps=0 w=400 l=30
X130 GND x121/m1_783_709 x131/a_0_0 GND sky130_fd_pr__nfet_01v8 ad=0 pd=0 as=78.2n ps=2.61m w=602 l=30
X132 m1_9464_673 RN x133/li_393_182 GND sky130_fd_pr__nfet_01v8 ad=-0 pd=-0 as=52.7n ps=1.92m w=602 l=30
X134 x133/li_393_182 x135/li_n17_n33 x131/a_0_0 GND sky130_fd_pr__nfet_01v8 ad=0 pd=0 as=0 ps=0 w=600 l=30
X136 VDD x121/m1_783_709 m1_9464_673 VDD sky130_fd_pr__pfet_01v8 ad=0 pd=0 as=0 ps=0 w=400 l=30
X137 m1_9464_673 x121/m1_783_709 VDD VDD sky130_fd_pr__pfet_01v8 ad=0 pd=0 as=0 ps=0 w=400 l=30
X138 VDD x135/li_n17_n33 m1_9464_673 VDD sky130_fd_pr__pfet_01v8 ad=0 pd=0 as=0 ps=0 w=400 l=30
X139 m1_9464_673 x135/li_n17_n33 VDD VDD sky130_fd_pr__pfet_01v8 ad=0 pd=0 as=0 ps=0 w=400 l=30
X140 VDD RN m1_9464_673 VDD sky130_fd_pr__pfet_01v8 ad=0 pd=0 as=0 ps=0 w=400 l=30
X141 m1_9464_673 RN VDD VDD sky130_fd_pr__pfet_01v8 ad=0 pd=0 as=0 ps=0 w=400 l=30
X142 GND m1_9464_673 x143/a_0_0 GND sky130_fd_pr__nfet_01v8 ad=0 pd=0 as=78.2n ps=2.61m w=602 l=30
X144 m2_14877_833 RN x145/li_393_182 GND sky130_fd_pr__nfet_01v8 ad=2p pd=-0.174m as=52.7n ps=1.92m w=602 l=30
X146 x145/li_393_182 CLK x143/a_0_0 GND sky130_fd_pr__nfet_01v8 ad=0 pd=0 as=0 ps=0 w=600 l=30
X147 VDD m1_9464_673 m2_14877_833 VDD sky130_fd_pr__pfet_01v8 ad=0 pd=0 as=0.139u ps=5.5m w=400 l=30
X148 m2_14877_833 m1_9464_673 VDD VDD sky130_fd_pr__pfet_01v8 ad=0 pd=0 as=0 ps=0 w=400 l=30
X149 VDD CLK m2_14877_833 VDD sky130_fd_pr__pfet_01v8 ad=0 pd=0 as=0 ps=0 w=400 l=30
X150 m2_14877_833 CLK VDD VDD sky130_fd_pr__pfet_01v8 ad=0 pd=0 as=0 ps=0 w=400 l=30
X151 VDD RN m2_14877_833 VDD sky130_fd_pr__pfet_01v8 ad=0 pd=0 as=0 ps=0 w=400 l=30
X152 m2_14877_833 RN VDD VDD sky130_fd_pr__pfet_01v8 ad=0 pd=0 as=0 ps=0 w=400 l=30
X153 GND x121/m1_783_709 x154/a_0_0 GND sky130_fd_pr__nfet_01v8 ad=0 pd=0 as=78.2n ps=2.61m w=602 l=30
X155 m2_14877_833 m1_14644_741 x156/li_393_182 GND sky130_fd_pr__nfet_01v8 ad=0 pd=-0 as=52.7n ps=1.92m w=602 l=30
X157 x156/li_393_182 RN x154/a_0_0 GND sky130_fd_pr__nfet_01v8 ad=0 pd=0 as=0 ps=0 w=600 l=30
X158 VDD x121/m1_783_709 m2_14877_833 VDD sky130_fd_pr__pfet_01v8 ad=0 pd=0 as=0 ps=0 w=400 l=30
X159 m2_14877_833 x121/m1_783_709 VDD VDD sky130_fd_pr__pfet_01v8 ad=0 pd=0 as=0 ps=0 w=400 l=30
X160 VDD RN m2_14877_833 VDD sky130_fd_pr__pfet_01v8 ad=0 pd=0 as=0 ps=0 w=400 l=30
X161 m2_14877_833 RN VDD VDD sky130_fd_pr__pfet_01v8 ad=0 pd=0 as=0 ps=0 w=400 l=30
X162 VDD m1_14644_741 m2_14877_833 VDD sky130_fd_pr__pfet_01v8 ad=0 pd=0 as=0 ps=0 w=400 l=30
X163 m2_14877_833 m1_14644_741 VDD VDD sky130_fd_pr__pfet_01v8 ad=0 pd=0 as=0 ps=0 w=400 l=30
X164 GND m1_9464_673 x165/a_0_0 GND sky130_fd_pr__nfet_01v8 ad=0 pd=0 as=77.2n ps=2.61m w=602 l=30
X166 m1_9464_673 m2_14877_833 x165/a_0_0 GND sky130_fd_pr__nfet_01v8 ad=-0 pd=-0 as=0 ps=0 w=602 l=30
X167 VDD m1_9464_673 m1_9464_673 VDD sky130_fd_pr__pfet_01v8 ad=0 pd=0 as=0 ps=0 w=400 l=30
X168 m1_9464_673 m1_9464_673 VDD VDD sky130_fd_pr__pfet_01v8 ad=0 pd=0 as=0 ps=0 w=400 l=30
X169 VDD m2_14877_833 m1_9464_673 VDD sky130_fd_pr__pfet_01v8 ad=0 pd=0 as=0 ps=0 w=400 l=30
X170 m1_9464_673 m2_14877_833 VDD VDD sky130_fd_pr__pfet_01v8 ad=0 pd=0 as=0 ps=0 w=400 l=30
X171 GND m2_14877_833 x172/a_0_0 GND sky130_fd_pr__nfet_01v8 ad=0 pd=0 as=77.2n ps=2.61m w=602 l=30
X173 m1_14644_741 m2_14877_833 x172/a_0_0 GND sky130_fd_pr__nfet_01v8 ad=7.16n pd=0.314m as=0 ps=0 w=602 l=30
X174 VDD m2_14877_833 m1_14644_741 VDD sky130_fd_pr__pfet_01v8 ad=0 pd=0 as=46.4n ps=1.83m w=400 l=30
X175 m1_14644_741 m2_14877_833 VDD VDD sky130_fd_pr__pfet_01v8 ad=0 pd=0 as=0 ps=0 w=400 l=30
X176 VDD m2_14877_833 m1_14644_741 VDD sky130_fd_pr__pfet_01v8 ad=0 pd=0 as=0 ps=0 w=400 l=30
X177 m1_14644_741 m2_14877_833 VDD VDD sky130_fd_pr__pfet_01v8 ad=0 pd=0 as=0 ps=0 w=400 l=30
X178 GND m1_9464_673 x179/a_0_0 GND sky130_fd_pr__nfet_01v8 ad=0 pd=0 as=76.7n ps=2.6m w=602 l=30
X180 GND m1_9464_673 x181/a_0_0 GND sky130_fd_pr__nfet_01v8 ad=0 pd=0 as=77.2n ps=2.61m w=602 l=30
X182 GND m1_4283_599 x183/a_0_0 GND sky130_fd_pr__nfet_01v8 ad=0 pd=0 as=77.2n ps=2.61m w=602 l=30
X184 x185/a_805_1331 m1_9464_673 VDD VDD sky130_fd_pr__pfet_01v8 ad=11.6n pd=0.458m as=22.4n ps=0.912m w=400 l=30
X186 VDD m1_9464_673 x185/a_805_1331 VDD sky130_fd_pr__pfet_01v8 ad=21.6n pd=0.908m as=11.6n ps=0.458m w=400 l=30
X187 QN m1_4283_599 x181/a_0_0 GND sky130_fd_pr__nfet_01v8 ad=21.5n pd=0.944m as=0 ps=0 w=602 l=30
X188 x185/a_805_1331 m1_14644_741 VDD VDD sky130_fd_pr__pfet_01v8 ad=0.114u pd=4.57m as=0 ps=0 w=400 l=30
X189 VDD m1_14644_741 x185/a_805_1331 VDD sky130_fd_pr__pfet_01v8 ad=0 pd=0 as=0 ps=0 w=400 l=30
X190 x191/a_174_n399 m1_4283_599 x185/a_805_1331 VDD sky130_fd_pr__pfet_01v8 ad=23.2n pd=0.916m as=0 ps=0 w=400 l=30
X192 x185/a_805_1331 m1_4283_599 x191/a_174_n399 VDD sky130_fd_pr__pfet_01v8 ad=0 pd=0 as=0 ps=0 w=400 l=30
X193 x185/a_893_1059 m1_9464_673 x185/a_805_1331 VDD sky130_fd_pr__pfet_01v8 ad=90.4n pd=3.65m as=0 ps=0 w=400 l=30
X194 x185/a_805_1331 m1_9464_673 x185/a_893_1059 VDD sky130_fd_pr__pfet_01v8 ad=0 pd=0 as=0 ps=0 w=400 l=30
X195 QN m1_4283_599 x185/a_893_1059 VDD sky130_fd_pr__pfet_01v8 ad=46.4n pd=1.83m as=0 ps=0 w=400 l=30
X196 x185/a_893_1059 m1_4283_599 QN VDD sky130_fd_pr__pfet_01v8 ad=0 pd=0 as=0 ps=0 w=400 l=30
X197 QN m1_14644_741 x185/a_893_1059 VDD sky130_fd_pr__pfet_01v8 ad=0 pd=0 as=0 ps=0 w=400 l=30
X198 x185/a_893_1059 m1_14644_741 QN VDD sky130_fd_pr__pfet_01v8 ad=0 pd=0 as=0 ps=0 w=400 l=30
X199 QN m1_14644_741 x179/a_0_0 GND sky130_fd_pr__nfet_01v8 ad=2.39n pd=0.111m as=15.6n ps=0.592m w=602 l=30
X200 QN m1_14644_741 x183/a_0_0 GND sky130_fd_pr__nfet_01v8 ad=2.4n pd=0.112m as=15.8n ps=0.594m w=602 l=30
C0 VDD m2_14877_833 2.59f
C1 RN D 4.24f
C2 m1_9464_673 x121/m1_783_709 2.08f
C3 m2_4517_833 CLK 2.05f
C4 CLK VDD 2.63f
C5 m2_4517_833 VDD 2.87f
C6 CLK m2_14877_833 2.07f
C7 m1_4283_599 m1_9464_673 3.62f
C8 RN VDD 2.13f
C9 D m1_4283_599 3.85f
C10 m1_9464_673 VDD 4.15f
.ends

** hspice subcircuit dictionary
* x1	dffrnx1_pcell_0/nand3x1_pcell_0/nmos_bottom_0
* x3	dffrnx1_pcell_0
* x4	dffrnx1_pcell_0/nand3x1_pcell_0
* x13	dffrnx1_pcell_0/nand3x1_pcell_1/nmos_bottom_0
* x15	dffrnx1_pcell_0/nand3x1_pcell_1
* x24	dffrnx1_pcell_0/nand3x1_pcell_3/nmos_bottom_0
* x26	dffrnx1_pcell_0/nand3x1_pcell_3
* x35	dffrnx1_pcell_0/nand3x1_pcell_4/nmos_bottom_0
* x37	dffrnx1_pcell_0/nand3x1_pcell_4
* x46	dffrnx1_pcell_0/nand2x1_pcell_0/nmos_bottom_0
* x53	dffrnx1_pcell_0/nand2x1_pcell_1/nmos_bottom_0
* x60	dffrnx1_pcell_1
* x61	dffrnx1_pcell_1/nand3x1_pcell_0/nmos_bottom_0
* x63	dffrnx1_pcell_1/nand3x1_pcell_0
* x72	dffrnx1_pcell_1/nand3x1_pcell_1/nmos_bottom_0
* x74	dffrnx1_pcell_1/nand3x1_pcell_1
* x83	dffrnx1_pcell_1/nand3x1_pcell_3/nmos_bottom_0
* x85	dffrnx1_pcell_1/nand3x1_pcell_3
* x94	dffrnx1_pcell_1/nand3x1_pcell_4/nmos_bottom_0
* x96	dffrnx1_pcell_1/nand3x1_pcell_4
* x105	dffrnx1_pcell_1/nand2x1_pcell_0/nmos_bottom_0
* x112	dffrnx1_pcell_1/nand2x1_pcell_1/nmos_bottom_0
* x119	dffrnx1_pcell_2/nand3x1_pcell_0/nmos_bottom_0
* x121	dffrnx1_pcell_2
* x122	dffrnx1_pcell_2/nand3x1_pcell_0
* x131	dffrnx1_pcell_2/nand3x1_pcell_1/nmos_bottom_0
* x133	dffrnx1_pcell_2/nand3x1_pcell_1
* x135	li1_M1_contact_17
* x143	dffrnx1_pcell_2/nand3x1_pcell_3/nmos_bottom_0
* x145	dffrnx1_pcell_2/nand3x1_pcell_3
* x154	dffrnx1_pcell_2/nand3x1_pcell_4/nmos_bottom_0
* x156	dffrnx1_pcell_2/nand3x1_pcell_4
* x165	dffrnx1_pcell_2/nand2x1_pcell_0/nmos_bottom_0
* x172	dffrnx1_pcell_2/nand2x1_pcell_1/nmos_bottom_0
* x179	votern3x1_pcell_0/nmos_top_0
* x181	votern3x1_pcell_0/nmos_bottom_1
* x183	votern3x1_pcell_0/nmos_bottom_2
* x185	votern3x1_pcell_0
* x191	votern3x1_pcell_0/pmos2_1_2
