* HSPICE file created from dffrnx1_pcell.ext - technology: sky130A

.option scale=5m

.subckt dffrnx1_pcell
X0 VSUBS m1_190_784 x1/a_0_0 VSUBS sky130_fd_pr__nfet_01v8 ad=2.39n pd=0.111m as=15.7n ps=0.599m w=602 l=30
X2 m1_783_709 m1_634_634 x3/li_393_182 VSUBS sky130_fd_pr__nfet_01v8 ad=2.39n pd=0.111m as=15.8n ps=0.594m w=602 l=30
X4 x3/li_393_182 m1_411_899 x1/a_0_0 VSUBS sky130_fd_pr__nfet_01v8 ad=2.18n pd=0.106m as=16.2n ps=0.604m w=600 l=30
X5 x6/w_87_786 m1_190_784 m1_783_709 x6/w_87_786 sky130_fd_pr__pfet_01v8 ad=21.6n pd=0.908m as=11.6n ps=0.458m w=400 l=30
X7 m1_783_709 m1_190_784 x6/w_87_786 x6/w_87_786 sky130_fd_pr__pfet_01v8 ad=11.6n pd=0.458m as=22.4n ps=0.912m w=400 l=30
X8 x6/w_87_786 m1_411_899 m1_783_709 x6/w_87_786 sky130_fd_pr__pfet_01v8 ad=0.496u pd=0.0201 as=69.6n ps=2.75m w=400 l=30
X9 m1_783_709 m1_411_899 x6/w_87_786 x6/w_87_786 sky130_fd_pr__pfet_01v8 ad=0 pd=0 as=0 ps=0 w=400 l=30
X10 x6/w_87_786 m1_634_634 m1_783_709 x6/w_87_786 sky130_fd_pr__pfet_01v8 ad=0 pd=0 as=0 ps=0 w=400 l=30
X11 m1_783_709 m1_634_634 x6/w_87_786 x6/w_87_786 sky130_fd_pr__pfet_01v8 ad=0 pd=0 as=0 ps=0 w=400 l=30
X12 VSUBS m1_783_709 x13/a_0_0 VSUBS sky130_fd_pr__nfet_01v8 ad=86n pd=4.3m as=78.2n ps=2.61m w=602 l=30
X14 m1_634_634 m1_1597_393 x15/li_393_182 VSUBS sky130_fd_pr__nfet_01v8 ad=1p pd=-87u as=52.7n ps=1.92m w=602 l=30
X16 x15/li_393_182 x15/a_447_377 x13/a_0_0 VSUBS sky130_fd_pr__nfet_01v8 ad=0 pd=0 as=0 ps=0 w=600 l=30
X17 x6/w_87_786 m1_783_709 m1_634_634 x6/w_87_786 sky130_fd_pr__pfet_01v8 ad=0 pd=0 as=69.6n ps=2.75m w=400 l=30
X18 m1_634_634 m1_783_709 x6/w_87_786 x6/w_87_786 sky130_fd_pr__pfet_01v8 ad=0 pd=0 as=0 ps=0 w=400 l=30
X19 x6/w_87_786 x15/a_447_377 m1_634_634 x6/w_87_786 sky130_fd_pr__pfet_01v8 ad=0 pd=0 as=0 ps=0 w=400 l=30
X20 m1_634_634 x15/a_447_377 x6/w_87_786 x6/w_87_786 sky130_fd_pr__pfet_01v8 ad=0 pd=0 as=0 ps=0 w=400 l=30
X21 x6/w_87_786 m1_1597_393 m1_634_634 x6/w_87_786 sky130_fd_pr__pfet_01v8 ad=0 pd=0 as=0 ps=0 w=400 l=30
X22 m1_634_634 m1_1597_393 x6/w_87_786 x6/w_87_786 sky130_fd_pr__pfet_01v8 ad=0 pd=0 as=0 ps=0 w=400 l=30
X23 VSUBS m1_2410_635 x24/a_0_0 VSUBS sky130_fd_pr__nfet_01v8 ad=0 pd=0 as=78.2n ps=2.61m w=602 l=30
X25 m1_190_784 m1_1597_393 x26/li_393_182 VSUBS sky130_fd_pr__nfet_01v8 ad=1p pd=-87u as=52.7n ps=1.92m w=602 l=30
X27 x26/li_393_182 m1_411_899 x24/a_0_0 VSUBS sky130_fd_pr__nfet_01v8 ad=0 pd=0 as=0 ps=0 w=600 l=30
X28 x6/w_87_786 m1_2410_635 m1_190_784 x6/w_87_786 sky130_fd_pr__pfet_01v8 ad=0 pd=0 as=69.6n ps=2.75m w=400 l=30
X29 m1_190_784 m1_2410_635 x6/w_87_786 x6/w_87_786 sky130_fd_pr__pfet_01v8 ad=0 pd=0 as=0 ps=0 w=400 l=30
X30 x6/w_87_786 m1_411_899 m1_190_784 x6/w_87_786 sky130_fd_pr__pfet_01v8 ad=0 pd=0 as=0 ps=0 w=400 l=30
X31 m1_190_784 m1_411_899 x6/w_87_786 x6/w_87_786 sky130_fd_pr__pfet_01v8 ad=0 pd=0 as=0 ps=0 w=400 l=30
X32 x6/w_87_786 m1_1597_393 m1_190_784 x6/w_87_786 sky130_fd_pr__pfet_01v8 ad=0 pd=0 as=0 ps=0 w=400 l=30
X33 m1_190_784 m1_1597_393 x6/w_87_786 x6/w_87_786 sky130_fd_pr__pfet_01v8 ad=0 pd=0 as=0 ps=0 w=400 l=30
X34 VSUBS m1_783_709 x35/a_0_0 VSUBS sky130_fd_pr__nfet_01v8 ad=0 pd=0 as=78.2n ps=2.61m w=602 l=30
X36 x6/a_289_1059 x6/li_649_399 x6/li_393_182 VSUBS sky130_fd_pr__nfet_01v8 ad=7.16n pd=0.314m as=52.7n ps=1.92m w=602 l=30
X37 x6/li_393_182 m1_1597_393 x35/a_0_0 VSUBS sky130_fd_pr__nfet_01v8 ad=0 pd=0 as=0 ps=0 w=600 l=30
X38 x6/w_87_786 m1_783_709 x6/a_289_1059 x6/w_87_786 sky130_fd_pr__pfet_01v8 ad=0 pd=0 as=69.6n ps=2.75m w=400 l=30
X39 x6/a_289_1059 m1_783_709 x6/w_87_786 x6/w_87_786 sky130_fd_pr__pfet_01v8 ad=0 pd=0 as=0 ps=0 w=400 l=30
X40 x6/w_87_786 m1_1597_393 x6/a_289_1059 x6/w_87_786 sky130_fd_pr__pfet_01v8 ad=0 pd=0 as=0 ps=0 w=400 l=30
X41 x6/a_289_1059 m1_1597_393 x6/w_87_786 x6/w_87_786 sky130_fd_pr__pfet_01v8 ad=0 pd=0 as=0 ps=0 w=400 l=30
X42 x6/w_87_786 x6/li_649_399 x6/a_289_1059 x6/w_87_786 sky130_fd_pr__pfet_01v8 ad=0 pd=0 as=0 ps=0 w=400 l=30
X43 x6/a_289_1059 x6/li_649_399 x6/w_87_786 x6/w_87_786 sky130_fd_pr__pfet_01v8 ad=0 pd=0 as=0 ps=0 w=400 l=30
X44 VSUBS m1_634_634 x45/a_0_0 VSUBS sky130_fd_pr__nfet_01v8 ad=0 pd=0 as=77.2n ps=2.61m w=602 l=30
X46 m1_2410_635 m1_190_784 x45/a_0_0 VSUBS sky130_fd_pr__nfet_01v8 ad=1p pd=-87u as=0 ps=0 w=602 l=30
X47 x6/w_87_786 m1_634_634 m1_2410_635 x6/w_87_786 sky130_fd_pr__pfet_01v8 ad=0 pd=0 as=46.4n ps=1.83m w=400 l=30
X48 m1_2410_635 m1_634_634 x6/w_87_786 x6/w_87_786 sky130_fd_pr__pfet_01v8 ad=0 pd=0 as=0 ps=0 w=400 l=30
X49 x6/w_87_786 m1_190_784 m1_2410_635 x6/w_87_786 sky130_fd_pr__pfet_01v8 ad=0 pd=0 as=0 ps=0 w=400 l=30
X50 m1_2410_635 m1_190_784 x6/w_87_786 x6/w_87_786 sky130_fd_pr__pfet_01v8 ad=0 pd=0 as=0 ps=0 w=400 l=30
X51 VSUBS x52/a_168_375 x53/a_0_0 VSUBS sky130_fd_pr__nfet_01v8 ad=0 pd=0 as=77.2n ps=2.61m w=602 l=30
X54 x52/a_223_1053 m1_190_784 x53/a_0_0 VSUBS sky130_fd_pr__nfet_01v8 ad=7.16n pd=0.314m as=0 ps=0 w=602 l=30
X55 x6/w_87_786 x52/a_168_375 x52/a_223_1053 x6/w_87_786 sky130_fd_pr__pfet_01v8 ad=0 pd=0 as=46.4n ps=1.83m w=400 l=30
X56 x52/a_223_1053 x52/a_168_375 x6/w_87_786 x6/w_87_786 sky130_fd_pr__pfet_01v8 ad=0 pd=0 as=0 ps=0 w=400 l=30
X57 x6/w_87_786 m1_190_784 x52/a_223_1053 x6/w_87_786 sky130_fd_pr__pfet_01v8 ad=0 pd=0 as=0 ps=0 w=400 l=30
X58 x52/a_223_1053 m1_190_784 x6/w_87_786 x6/w_87_786 sky130_fd_pr__pfet_01v8 ad=0 pd=0 as=0 ps=0 w=400 l=30
.ends

** hspice subcircuit dictionary
* x1	nand3x1_pcell_0/nmos_bottom_0
* x3	nand3x1_pcell_0
* x6	nand3x1_pcell_4
* x13	nand3x1_pcell_1/nmos_bottom_0
* x15	nand3x1_pcell_1
* x24	nand3x1_pcell_3/nmos_bottom_0
* x26	nand3x1_pcell_3
* x35	nand3x1_pcell_4/nmos_bottom_0
* x45	nand2x1_pcell_0/nmos_bottom_0
* x52	nand2x1_pcell_1
* x53	nand2x1_pcell_1/nmos_bottom_0
