* HSPICE file created from VOTER3X1.ext - technology: sky130A

.option scale=5m

.subckt VOTER3X1 Y A B C VDD GND
X0 GND B x1/a_0_0 GND sky130_fd_pr__nfet_01v8 ad=2.39n pd=0.111m as=15.7n ps=0.599m w=602 l=30
X2 GND B x3/a_0_0 GND sky130_fd_pr__nfet_01v8 ad=88.6n pd=4.3m as=77.2n ps=2.61m w=602 l=30
X4 GND C x5/a_0_0 GND sky130_fd_pr__nfet_01v8 ad=0 pd=0 as=77.2n ps=2.61m w=602 l=30
X6 x7/a_805_1331 B VDD VDD sky130_fd_pr__pfet_01v8 ad=11.6n pd=0.458m as=22.4n ps=0.912m w=400 l=30
X8 VDD B x7/a_805_1331 VDD sky130_fd_pr__pfet_01v8 ad=21.6n pd=0.908m as=11.6n ps=0.458m w=400 l=30
X9 x10/m1_1818_783 C x3/a_0_0 GND sky130_fd_pr__nfet_01v8 ad=2.39n pd=0.111m as=15.8n ps=0.594m w=602 l=30
X11 x7/a_805_1331 A VDD VDD sky130_fd_pr__pfet_01v8 ad=0.114u pd=4.57m as=0.111u ps=4.56m w=400 l=30
X12 VDD A x7/a_805_1331 VDD sky130_fd_pr__pfet_01v8 ad=0 pd=0 as=0 ps=0 w=400 l=30
X13 x14/a_174_n399 C x7/a_805_1331 VDD sky130_fd_pr__pfet_01v8 ad=23.2n pd=0.916m as=0 ps=0 w=400 l=30
X15 x7/a_805_1331 C x14/a_174_n399 VDD sky130_fd_pr__pfet_01v8 ad=0 pd=0 as=0 ps=0 w=400 l=30
X16 x7/a_893_1059 B x7/a_805_1331 VDD sky130_fd_pr__pfet_01v8 ad=90.4n pd=3.65m as=0 ps=0 w=400 l=30
X17 x7/a_805_1331 B x7/a_893_1059 VDD sky130_fd_pr__pfet_01v8 ad=0 pd=0 as=0 ps=0 w=400 l=30
X18 x10/m1_1818_783 C x7/a_893_1059 VDD sky130_fd_pr__pfet_01v8 ad=46.4n pd=1.83m as=0 ps=0 w=400 l=30
X19 x7/a_893_1059 C x10/m1_1818_783 VDD sky130_fd_pr__pfet_01v8 ad=0 pd=0 as=0 ps=0 w=400 l=30
X20 x10/m1_1818_783 A x7/a_893_1059 VDD sky130_fd_pr__pfet_01v8 ad=0 pd=0 as=0 ps=0 w=400 l=30
X21 x7/a_893_1059 A x10/m1_1818_783 VDD sky130_fd_pr__pfet_01v8 ad=0 pd=0 as=0 ps=0 w=400 l=30
X22 x10/m1_1818_783 A x1/a_0_0 GND sky130_fd_pr__nfet_01v8 ad=2.39n pd=0.111m as=15.6n ps=0.592m w=602 l=30
X23 x10/m1_1818_783 A x5/a_0_0 GND sky130_fd_pr__nfet_01v8 ad=2.4n pd=0.112m as=15.8n ps=0.594m w=602 l=30
X24 Y x10/m1_1818_783 GND GND sky130_fd_pr__nfet_01v8 ad=7.16n pd=0.314m as=0 ps=0 w=602 l=30
X25 VDD x10/m1_1818_783 Y VDD sky130_fd_pr__pfet_01v8 ad=21.6n pd=0.908m as=11.6n ps=0.458m w=400 l=30
X26 Y x10/m1_1818_783 VDD VDD sky130_fd_pr__pfet_01v8 ad=11.6n pd=0.458m as=22.4n ps=0.912m w=400 l=30
.ends

** hspice subcircuit dictionary
* x1	voter3x1_pcell_0/votern3x1_pcell_0/nmos_top_0
* x3	voter3x1_pcell_0/votern3x1_pcell_0/nmos_bottom_1
* x5	voter3x1_pcell_0/votern3x1_pcell_0/nmos_bottom_2
* x7	voter3x1_pcell_0/votern3x1_pcell_0
* x10	voter3x1_pcell_0
* x14	voter3x1_pcell_0/votern3x1_pcell_0/pmos2_1_2
