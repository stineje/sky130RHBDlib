* HSPICE file created from TMRDFFSNRNQNX1.ext - technology: sky130A

.option scale=5m

.subckt TMRDFFSNRNQNX1 Q D CLK SN RN VDD GND
X0 GND m1_4737_519 x1/a_0_0 GND sky130_fd_pr__nfet_01v8 ad=2.39n pd=0.111m as=15.7n ps=0.599m w=602 l=30
X2 GND m1_4737_519 x3/a_0_0 GND sky130_fd_pr__nfet_01v8 ad=0.287u pd=0.0142 as=77.2n ps=2.61m w=602 l=30
X4 GND m1_16272_445 x5/a_0_0 GND sky130_fd_pr__nfet_01v8 ad=0 pd=0 as=77.2n ps=2.61m w=602 l=30
X6 x7/a_805_1331 m1_4737_519 VDD VDD sky130_fd_pr__pfet_01v8 ad=11.6n pd=0.458m as=22.4n ps=0.912m w=400 l=30
X8 VDD m1_4737_519 x7/a_805_1331 VDD sky130_fd_pr__pfet_01v8 ad=21.6n pd=0.908m as=11.6n ps=0.458m w=400 l=30
X9 Q m1_16272_445 x3/a_0_0 GND sky130_fd_pr__nfet_01v8 ad=2.39n pd=0.111m as=15.8n ps=0.594m w=602 l=30
X10 x7/a_805_1331 m2_17810_833 VDD VDD sky130_fd_pr__pfet_01v8 ad=0.114u pd=4.57m as=1.45u ps=0.0585 w=400 l=30
X11 VDD m2_17810_833 x7/a_805_1331 VDD sky130_fd_pr__pfet_01v8 ad=0 pd=0 as=0 ps=0 w=400 l=30
X12 a_18483_1107 m1_16272_445 x7/a_805_1331 VDD sky130_fd_pr__pfet_01v8 ad=0.114u pd=4.57m as=0 ps=0 w=400 l=30
X13 x7/a_805_1331 m1_16272_445 a_18483_1107 VDD sky130_fd_pr__pfet_01v8 ad=0 pd=0 as=0 ps=0 w=400 l=30
X14 a_18483_1107 m1_4737_519 x7/a_805_1331 VDD sky130_fd_pr__pfet_01v8 ad=0 pd=0 as=0 ps=0 w=400 l=30
X15 x7/a_805_1331 m1_4737_519 a_18483_1107 VDD sky130_fd_pr__pfet_01v8 ad=0 pd=0 as=0 ps=0 w=400 l=30
X16 Q m1_16272_445 a_18483_1107 VDD sky130_fd_pr__pfet_01v8 ad=46.4n pd=1.83m as=0 ps=0 w=400 l=30
X17 a_18483_1107 m1_16272_445 Q VDD sky130_fd_pr__pfet_01v8 ad=0 pd=0 as=0 ps=0 w=400 l=30
X18 Q m2_17810_833 a_18483_1107 VDD sky130_fd_pr__pfet_01v8 ad=0 pd=0 as=0 ps=0 w=400 l=30
X19 a_18483_1107 m2_17810_833 Q VDD sky130_fd_pr__pfet_01v8 ad=0 pd=0 as=0 ps=0 w=400 l=30
X20 Q m2_17810_833 x1/a_0_0 GND sky130_fd_pr__nfet_01v8 ad=2.39n pd=0.111m as=15.6n ps=0.592m w=602 l=30
X21 Q m2_17810_833 x5/a_0_0 GND sky130_fd_pr__nfet_01v8 ad=2.4n pd=0.112m as=15.8n ps=0.594m w=602 l=30
X22 GND D x23/a_0_0 GND sky130_fd_pr__nfet_01v8 ad=0 pd=0 as=78.2n ps=2.61m w=602 l=30
X24 m2_939_537 m2_792_685 x25/li_393_182 GND sky130_fd_pr__nfet_01v8 ad=-7.16n pd=-0.488m as=52.7n ps=1.92m w=602 l=30
X26 x25/li_393_182 RN x23/a_0_0 GND sky130_fd_pr__nfet_01v8 ad=2.18n pd=0.106m as=16.2n ps=0.604m w=600 l=30
X27 VDD D m2_939_537 VDD sky130_fd_pr__pfet_01v8 ad=21.6n pd=0.908m as=11.6n ps=0.458m w=400 l=30
X28 m2_939_537 D VDD VDD sky130_fd_pr__pfet_01v8 ad=11.6n pd=0.458m as=22.4n ps=0.912m w=400 l=30
X29 VDD RN m2_939_537 VDD sky130_fd_pr__pfet_01v8 ad=0 pd=0 as=69.6n ps=2.75m w=400 l=30
X30 m2_939_537 RN VDD VDD sky130_fd_pr__pfet_01v8 ad=0 pd=0 as=0 ps=0 w=400 l=30
X31 VDD m2_792_685 m2_939_537 VDD sky130_fd_pr__pfet_01v8 ad=0 pd=0 as=0 ps=0 w=400 l=30
X32 m2_939_537 m2_792_685 VDD VDD sky130_fd_pr__pfet_01v8 ad=0 pd=0 as=0 ps=0 w=400 l=30
X33 GND m2_939_537 x34/a_0_0 GND sky130_fd_pr__nfet_01v8 ad=0 pd=0 as=78.2n ps=2.61m w=602 l=30
X35 m2_792_685 m2_3822_759 x36/li_393_182 GND sky130_fd_pr__nfet_01v8 ad=1p pd=-87u as=52.7n ps=1.92m w=602 l=30
X37 x36/li_393_182 CLK x34/a_0_0 GND sky130_fd_pr__nfet_01v8 ad=0 pd=0 as=0 ps=0 w=600 l=30
X38 VDD m2_939_537 m2_792_685 VDD sky130_fd_pr__pfet_01v8 ad=0 pd=0 as=69.6n ps=2.75m w=400 l=30
X39 m2_792_685 m2_939_537 VDD VDD sky130_fd_pr__pfet_01v8 ad=0 pd=0 as=0 ps=0 w=400 l=30
X40 VDD CLK m2_792_685 VDD sky130_fd_pr__pfet_01v8 ad=0 pd=0 as=0 ps=0 w=400 l=30
X41 m2_792_685 CLK VDD VDD sky130_fd_pr__pfet_01v8 ad=0 pd=0 as=0 ps=0 w=400 l=30
X42 VDD m2_3822_759 m2_792_685 VDD sky130_fd_pr__pfet_01v8 ad=0 pd=0 as=0 ps=0 w=400 l=30
X43 m2_792_685 m2_3822_759 VDD VDD sky130_fd_pr__pfet_01v8 ad=0 pd=0 as=0 ps=0 w=400 l=30
X44 GND m2_939_537 x45/a_0_0 GND sky130_fd_pr__nfet_01v8 ad=0 pd=0 as=78.2n ps=2.61m w=602 l=30
X46 m2_2862_537 m2_3822_759 x47/li_393_182 GND sky130_fd_pr__nfet_01v8 ad=1p pd=-87u as=52.7n ps=1.92m w=602 l=30
X48 x47/li_393_182 SN x45/a_0_0 GND sky130_fd_pr__nfet_01v8 ad=0 pd=0 as=0 ps=0 w=600 l=30
X49 VDD m2_939_537 m2_2862_537 VDD sky130_fd_pr__pfet_01v8 ad=0 pd=0 as=69.6n ps=2.75m w=400 l=30
X50 m2_2862_537 m2_939_537 VDD VDD sky130_fd_pr__pfet_01v8 ad=0 pd=0 as=0 ps=0 w=400 l=30
X51 VDD SN m2_2862_537 VDD sky130_fd_pr__pfet_01v8 ad=0 pd=0 as=0 ps=0 w=400 l=30
X52 m2_2862_537 SN VDD VDD sky130_fd_pr__pfet_01v8 ad=0 pd=0 as=0 ps=0 w=400 l=30
X53 VDD m2_3822_759 m2_2862_537 VDD sky130_fd_pr__pfet_01v8 ad=0 pd=0 as=0 ps=0 w=400 l=30
X54 m2_2862_537 m2_3822_759 VDD VDD sky130_fd_pr__pfet_01v8 ad=0 pd=0 as=0 ps=0 w=400 l=30
X55 GND m2_2862_537 x56/a_0_0 GND sky130_fd_pr__nfet_01v8 ad=0 pd=0 as=78.2n ps=2.61m w=602 l=30
X57 m2_3822_759 RN x58/li_393_182 GND sky130_fd_pr__nfet_01v8 ad=7.16n pd=0.314m as=52.7n ps=1.92m w=602 l=30
X59 x58/li_393_182 CLK x56/a_0_0 GND sky130_fd_pr__nfet_01v8 ad=0 pd=0 as=0 ps=0 w=600 l=30
X60 VDD m2_2862_537 m2_3822_759 VDD sky130_fd_pr__pfet_01v8 ad=0 pd=0 as=69.6n ps=2.75m w=400 l=30
X61 m2_3822_759 m2_2862_537 VDD VDD sky130_fd_pr__pfet_01v8 ad=0 pd=0 as=0 ps=0 w=400 l=30
X62 VDD CLK m2_3822_759 VDD sky130_fd_pr__pfet_01v8 ad=0 pd=0 as=0 ps=0 w=400 l=30
X63 m2_3822_759 CLK VDD VDD sky130_fd_pr__pfet_01v8 ad=0 pd=0 as=0 ps=0 w=400 l=30
X64 VDD RN m2_3822_759 VDD sky130_fd_pr__pfet_01v8 ad=0 pd=0 as=0 ps=0 w=400 l=30
X65 m2_3822_759 RN VDD VDD sky130_fd_pr__pfet_01v8 ad=0 pd=0 as=0 ps=0 w=400 l=30
X66 GND m2_792_685 x67/a_0_0 GND sky130_fd_pr__nfet_01v8 ad=0 pd=0 as=78.2n ps=2.61m w=602 l=30
X68 m1_4737_519 m1_4580_673 x69/li_393_182 GND sky130_fd_pr__nfet_01v8 ad=-14.3n pd=-1.24m as=52.7n ps=1.92m w=602 l=30
X70 x69/li_393_182 RN x67/a_0_0 GND sky130_fd_pr__nfet_01v8 ad=0 pd=0 as=0 ps=0 w=600 l=30
X71 VDD m2_792_685 m1_4737_519 VDD sky130_fd_pr__pfet_01v8 ad=0 pd=0 as=69.6n ps=2.75m w=400 l=30
X72 m1_4737_519 m2_792_685 VDD VDD sky130_fd_pr__pfet_01v8 ad=0 pd=0 as=0 ps=0 w=400 l=30
X73 VDD RN m1_4737_519 VDD sky130_fd_pr__pfet_01v8 ad=0 pd=0 as=0 ps=0 w=400 l=30
X74 m1_4737_519 RN VDD VDD sky130_fd_pr__pfet_01v8 ad=0 pd=0 as=0 ps=0 w=400 l=30
X75 VDD m1_4580_673 m1_4737_519 VDD sky130_fd_pr__pfet_01v8 ad=0 pd=0 as=0 ps=0 w=400 l=30
X76 m1_4737_519 m1_4580_673 VDD VDD sky130_fd_pr__pfet_01v8 ad=0 pd=0 as=0 ps=0 w=400 l=30
X77 GND m1_4737_519 x78/a_0_0 GND sky130_fd_pr__nfet_01v8 ad=0 pd=0 as=78.2n ps=2.61m w=602 l=30
X79 m1_4580_673 m2_3822_759 x80/li_393_182 GND sky130_fd_pr__nfet_01v8 ad=7.16n pd=0.314m as=52.7n ps=1.92m w=602 l=30
X81 x80/li_393_182 SN x78/a_0_0 GND sky130_fd_pr__nfet_01v8 ad=0 pd=0 as=0 ps=0 w=600 l=30
X82 VDD m1_4737_519 m1_4580_673 VDD sky130_fd_pr__pfet_01v8 ad=0 pd=0 as=69.6n ps=2.75m w=400 l=30
X83 m1_4580_673 m1_4737_519 VDD VDD sky130_fd_pr__pfet_01v8 ad=0 pd=0 as=0 ps=0 w=400 l=30
X84 VDD SN m1_4580_673 VDD sky130_fd_pr__pfet_01v8 ad=0 pd=0 as=0 ps=0 w=400 l=30
X85 m1_4580_673 SN VDD VDD sky130_fd_pr__pfet_01v8 ad=0 pd=0 as=0 ps=0 w=400 l=30
X86 VDD m2_3822_759 m1_4580_673 VDD sky130_fd_pr__pfet_01v8 ad=0 pd=0 as=0 ps=0 w=400 l=30
X87 m1_4580_673 m2_3822_759 VDD VDD sky130_fd_pr__pfet_01v8 ad=0 pd=0 as=0 ps=0 w=400 l=30
X88 GND D x89/a_0_0 GND sky130_fd_pr__nfet_01v8 ad=0 pd=0 as=78.2n ps=2.61m w=602 l=30
X90 m2_7081_537 m2_7672_685 x91/li_393_182 GND sky130_fd_pr__nfet_01v8 ad=-7.16n pd=-0.488m as=52.7n ps=1.92m w=602 l=30
X92 x91/li_393_182 RN x89/a_0_0 GND sky130_fd_pr__nfet_01v8 ad=0 pd=0 as=0 ps=0 w=600 l=30
X93 VDD D m2_7081_537 VDD sky130_fd_pr__pfet_01v8 ad=0 pd=0 as=69.6n ps=2.75m w=400 l=30
X94 m2_7081_537 D VDD VDD sky130_fd_pr__pfet_01v8 ad=0 pd=0 as=0 ps=0 w=400 l=30
X95 VDD RN m2_7081_537 VDD sky130_fd_pr__pfet_01v8 ad=0 pd=0 as=0 ps=0 w=400 l=30
X96 m2_7081_537 RN VDD VDD sky130_fd_pr__pfet_01v8 ad=0 pd=0 as=0 ps=0 w=400 l=30
X97 VDD m2_7672_685 m2_7081_537 VDD sky130_fd_pr__pfet_01v8 ad=0 pd=0 as=0 ps=0 w=400 l=30
X98 m2_7081_537 m2_7672_685 VDD VDD sky130_fd_pr__pfet_01v8 ad=0 pd=0 as=0 ps=0 w=400 l=30
X99 GND m2_7081_537 x100/a_0_0 GND sky130_fd_pr__nfet_01v8 ad=0 pd=0 as=78.2n ps=2.61m w=602 l=30
X101 m2_7672_685 m2_9594_759 x102/li_393_182 GND sky130_fd_pr__nfet_01v8 ad=1p pd=-87u as=52.7n ps=1.92m w=602 l=30
X103 x102/li_393_182 CLK x100/a_0_0 GND sky130_fd_pr__nfet_01v8 ad=0 pd=0 as=0 ps=0 w=600 l=30
X104 VDD m2_7081_537 m2_7672_685 VDD sky130_fd_pr__pfet_01v8 ad=0 pd=0 as=69.6n ps=2.75m w=400 l=30
X105 m2_7672_685 m2_7081_537 VDD VDD sky130_fd_pr__pfet_01v8 ad=0 pd=0 as=0 ps=0 w=400 l=30
X106 VDD CLK m2_7672_685 VDD sky130_fd_pr__pfet_01v8 ad=0 pd=0 as=0 ps=0 w=400 l=30
X107 m2_7672_685 CLK VDD VDD sky130_fd_pr__pfet_01v8 ad=0 pd=0 as=0 ps=0 w=400 l=30
X108 VDD m2_9594_759 m2_7672_685 VDD sky130_fd_pr__pfet_01v8 ad=0 pd=0 as=0 ps=0 w=400 l=30
X109 m2_7672_685 m2_9594_759 VDD VDD sky130_fd_pr__pfet_01v8 ad=0 pd=0 as=0 ps=0 w=400 l=30
X110 GND m2_7081_537 x111/a_0_0 GND sky130_fd_pr__nfet_01v8 ad=0 pd=0 as=78.2n ps=2.61m w=602 l=30
X112 m2_8634_537 m2_9594_759 x113/li_393_182 GND sky130_fd_pr__nfet_01v8 ad=1p pd=-87u as=52.7n ps=1.92m w=602 l=30
X114 x113/li_393_182 SN x111/a_0_0 GND sky130_fd_pr__nfet_01v8 ad=0 pd=0 as=0 ps=0 w=600 l=30
X115 VDD m2_7081_537 m2_8634_537 VDD sky130_fd_pr__pfet_01v8 ad=0 pd=0 as=69.6n ps=2.75m w=400 l=30
X116 m2_8634_537 m2_7081_537 VDD VDD sky130_fd_pr__pfet_01v8 ad=0 pd=0 as=0 ps=0 w=400 l=30
X117 VDD SN m2_8634_537 VDD sky130_fd_pr__pfet_01v8 ad=0 pd=0 as=0 ps=0 w=400 l=30
X118 m2_8634_537 SN VDD VDD sky130_fd_pr__pfet_01v8 ad=0 pd=0 as=0 ps=0 w=400 l=30
X119 VDD m2_9594_759 m2_8634_537 VDD sky130_fd_pr__pfet_01v8 ad=0 pd=0 as=0 ps=0 w=400 l=30
X120 m2_8634_537 m2_9594_759 VDD VDD sky130_fd_pr__pfet_01v8 ad=0 pd=0 as=0 ps=0 w=400 l=30
X121 GND m2_8634_537 x122/a_0_0 GND sky130_fd_pr__nfet_01v8 ad=0 pd=0 as=78.2n ps=2.61m w=602 l=30
X123 m2_9594_759 RN x124/li_393_182 GND sky130_fd_pr__nfet_01v8 ad=7.16n pd=0.314m as=52.7n ps=1.92m w=602 l=30
X125 x124/li_393_182 CLK x122/a_0_0 GND sky130_fd_pr__nfet_01v8 ad=0 pd=0 as=0 ps=0 w=600 l=30
X126 VDD m2_8634_537 m2_9594_759 VDD sky130_fd_pr__pfet_01v8 ad=0 pd=0 as=69.6n ps=2.75m w=400 l=30
X127 m2_9594_759 m2_8634_537 VDD VDD sky130_fd_pr__pfet_01v8 ad=0 pd=0 as=0 ps=0 w=400 l=30
X128 VDD CLK m2_9594_759 VDD sky130_fd_pr__pfet_01v8 ad=0 pd=0 as=0 ps=0 w=400 l=30
X129 m2_9594_759 CLK VDD VDD sky130_fd_pr__pfet_01v8 ad=0 pd=0 as=0 ps=0 w=400 l=30
X130 VDD RN m2_9594_759 VDD sky130_fd_pr__pfet_01v8 ad=0 pd=0 as=0 ps=0 w=400 l=30
X131 m2_9594_759 RN VDD VDD sky130_fd_pr__pfet_01v8 ad=0 pd=0 as=0 ps=0 w=400 l=30
X132 GND m2_7672_685 x133/a_0_0 GND sky130_fd_pr__nfet_01v8 ad=0 pd=0 as=78.2n ps=2.61m w=602 l=30
X134 m2_17810_833 m1_10351_519 x135/li_393_182 GND sky130_fd_pr__nfet_01v8 ad=1p pd=-87u as=52.7n ps=1.92m w=602 l=30
X136 x135/li_393_182 RN x133/a_0_0 GND sky130_fd_pr__nfet_01v8 ad=0 pd=0 as=0 ps=0 w=600 l=30
X137 VDD m2_7672_685 m2_17810_833 VDD sky130_fd_pr__pfet_01v8 ad=0 pd=0 as=69.6n ps=2.75m w=400 l=30
X138 m2_17810_833 m2_7672_685 VDD VDD sky130_fd_pr__pfet_01v8 ad=0 pd=0 as=0 ps=0 w=400 l=30
X139 VDD RN m2_17810_833 VDD sky130_fd_pr__pfet_01v8 ad=0 pd=0 as=0 ps=0 w=400 l=30
X140 m2_17810_833 RN VDD VDD sky130_fd_pr__pfet_01v8 ad=0 pd=0 as=0 ps=0 w=400 l=30
X141 VDD m1_10351_519 m2_17810_833 VDD sky130_fd_pr__pfet_01v8 ad=0 pd=0 as=0 ps=0 w=400 l=30
X142 m2_17810_833 m1_10351_519 VDD VDD sky130_fd_pr__pfet_01v8 ad=0 pd=0 as=0 ps=0 w=400 l=30
X143 GND m2_17810_833 x144/a_0_0 GND sky130_fd_pr__nfet_01v8 ad=0 pd=0 as=78.2n ps=2.61m w=602 l=30
X145 m1_10351_519 m2_9594_759 x146/li_393_182 GND sky130_fd_pr__nfet_01v8 ad=7.16n pd=0.314m as=52.7n ps=1.92m w=602 l=30
X147 x146/li_393_182 SN x144/a_0_0 GND sky130_fd_pr__nfet_01v8 ad=0 pd=0 as=0 ps=0 w=600 l=30
X148 VDD m2_17810_833 m1_10351_519 VDD sky130_fd_pr__pfet_01v8 ad=0 pd=0 as=69.6n ps=2.75m w=400 l=30
X149 m1_10351_519 m2_17810_833 VDD VDD sky130_fd_pr__pfet_01v8 ad=0 pd=0 as=0 ps=0 w=400 l=30
X150 VDD SN m1_10351_519 VDD sky130_fd_pr__pfet_01v8 ad=0 pd=0 as=0 ps=0 w=400 l=30
X151 m1_10351_519 SN VDD VDD sky130_fd_pr__pfet_01v8 ad=0 pd=0 as=0 ps=0 w=400 l=30
X152 VDD m2_9594_759 m1_10351_519 VDD sky130_fd_pr__pfet_01v8 ad=0 pd=0 as=0 ps=0 w=400 l=30
X153 m1_10351_519 m2_9594_759 VDD VDD sky130_fd_pr__pfet_01v8 ad=0 pd=0 as=0 ps=0 w=400 l=30
X154 GND D x155/a_0_0 GND sky130_fd_pr__nfet_01v8 ad=0 pd=0 as=78.2n ps=2.61m w=602 l=30
X156 m2_12853_537 m2_13444_685 x157/li_393_182 GND sky130_fd_pr__nfet_01v8 ad=-7.16n pd=-0.488m as=52.7n ps=1.92m w=602 l=30
X158 x157/li_393_182 RN x155/a_0_0 GND sky130_fd_pr__nfet_01v8 ad=0 pd=0 as=0 ps=0 w=600 l=30
X159 VDD D m2_12853_537 VDD sky130_fd_pr__pfet_01v8 ad=0 pd=0 as=69.6n ps=2.75m w=400 l=30
X160 m2_12853_537 D VDD VDD sky130_fd_pr__pfet_01v8 ad=0 pd=0 as=0 ps=0 w=400 l=30
X161 VDD RN m2_12853_537 VDD sky130_fd_pr__pfet_01v8 ad=0 pd=0 as=0 ps=0 w=400 l=30
X162 m2_12853_537 RN VDD VDD sky130_fd_pr__pfet_01v8 ad=0 pd=0 as=0 ps=0 w=400 l=30
X163 VDD m2_13444_685 m2_12853_537 VDD sky130_fd_pr__pfet_01v8 ad=0 pd=0 as=0 ps=0 w=400 l=30
X164 m2_12853_537 m2_13444_685 VDD VDD sky130_fd_pr__pfet_01v8 ad=0 pd=0 as=0 ps=0 w=400 l=30
X165 GND m2_12853_537 x166/a_0_0 GND sky130_fd_pr__nfet_01v8 ad=0 pd=0 as=78.2n ps=2.61m w=602 l=30
X167 m2_13444_685 m2_15366_759 x168/li_393_182 GND sky130_fd_pr__nfet_01v8 ad=1p pd=-87u as=52.7n ps=1.92m w=602 l=30
X169 x168/li_393_182 CLK x166/a_0_0 GND sky130_fd_pr__nfet_01v8 ad=0 pd=0 as=0 ps=0 w=600 l=30
X170 VDD m2_12853_537 m2_13444_685 VDD sky130_fd_pr__pfet_01v8 ad=0 pd=0 as=69.6n ps=2.75m w=400 l=30
X171 m2_13444_685 m2_12853_537 VDD VDD sky130_fd_pr__pfet_01v8 ad=0 pd=0 as=0 ps=0 w=400 l=30
X172 VDD CLK m2_13444_685 VDD sky130_fd_pr__pfet_01v8 ad=0 pd=0 as=0 ps=0 w=400 l=30
X173 m2_13444_685 CLK VDD VDD sky130_fd_pr__pfet_01v8 ad=0 pd=0 as=0 ps=0 w=400 l=30
X174 VDD m2_15366_759 m2_13444_685 VDD sky130_fd_pr__pfet_01v8 ad=0 pd=0 as=0 ps=0 w=400 l=30
X175 m2_13444_685 m2_15366_759 VDD VDD sky130_fd_pr__pfet_01v8 ad=0 pd=0 as=0 ps=0 w=400 l=30
X176 GND m2_12853_537 x177/a_0_0 GND sky130_fd_pr__nfet_01v8 ad=0 pd=0 as=78.2n ps=2.61m w=602 l=30
X178 m2_14406_537 m2_15366_759 x179/li_393_182 GND sky130_fd_pr__nfet_01v8 ad=1p pd=-87u as=52.7n ps=1.92m w=602 l=30
X180 x179/li_393_182 SN x177/a_0_0 GND sky130_fd_pr__nfet_01v8 ad=0 pd=0 as=0 ps=0 w=600 l=30
X181 VDD m2_12853_537 m2_14406_537 VDD sky130_fd_pr__pfet_01v8 ad=0 pd=0 as=69.6n ps=2.75m w=400 l=30
X182 m2_14406_537 m2_12853_537 VDD VDD sky130_fd_pr__pfet_01v8 ad=0 pd=0 as=0 ps=0 w=400 l=30
X183 VDD SN m2_14406_537 VDD sky130_fd_pr__pfet_01v8 ad=0 pd=0 as=0 ps=0 w=400 l=30
X184 m2_14406_537 SN VDD VDD sky130_fd_pr__pfet_01v8 ad=0 pd=0 as=0 ps=0 w=400 l=30
X185 VDD m2_15366_759 m2_14406_537 VDD sky130_fd_pr__pfet_01v8 ad=0 pd=0 as=0 ps=0 w=400 l=30
X186 m2_14406_537 m2_15366_759 VDD VDD sky130_fd_pr__pfet_01v8 ad=0 pd=0 as=0 ps=0 w=400 l=30
X187 GND m2_14406_537 x188/a_0_0 GND sky130_fd_pr__nfet_01v8 ad=0 pd=0 as=78.2n ps=2.61m w=602 l=30
X189 m2_15366_759 RN x190/li_393_182 GND sky130_fd_pr__nfet_01v8 ad=7.16n pd=0.314m as=52.7n ps=1.92m w=602 l=30
X191 x190/li_393_182 CLK x188/a_0_0 GND sky130_fd_pr__nfet_01v8 ad=0 pd=0 as=0 ps=0 w=600 l=30
X192 VDD m2_14406_537 m2_15366_759 VDD sky130_fd_pr__pfet_01v8 ad=0 pd=0 as=69.6n ps=2.75m w=400 l=30
X193 m2_15366_759 m2_14406_537 VDD VDD sky130_fd_pr__pfet_01v8 ad=0 pd=0 as=0 ps=0 w=400 l=30
X194 VDD CLK m2_15366_759 VDD sky130_fd_pr__pfet_01v8 ad=0 pd=0 as=0 ps=0 w=400 l=30
X195 m2_15366_759 CLK VDD VDD sky130_fd_pr__pfet_01v8 ad=0 pd=0 as=0 ps=0 w=400 l=30
X196 VDD RN m2_15366_759 VDD sky130_fd_pr__pfet_01v8 ad=0 pd=0 as=0 ps=0 w=400 l=30
X197 m2_15366_759 RN VDD VDD sky130_fd_pr__pfet_01v8 ad=0 pd=0 as=0 ps=0 w=400 l=30
X198 GND m2_13444_685 x199/a_0_0 GND sky130_fd_pr__nfet_01v8 ad=0 pd=0 as=78.2n ps=2.61m w=602 l=30
X200 m1_16272_445 m1_16122_519 x201/li_393_182 GND sky130_fd_pr__nfet_01v8 ad=-7.16n pd=-0.664m as=52.7n ps=1.92m w=602 l=30
X202 x201/li_393_182 RN x199/a_0_0 GND sky130_fd_pr__nfet_01v8 ad=0 pd=0 as=0 ps=0 w=600 l=30
X203 VDD m2_13444_685 m1_16272_445 VDD sky130_fd_pr__pfet_01v8 ad=0 pd=0 as=69.6n ps=2.75m w=400 l=30
X204 m1_16272_445 m2_13444_685 VDD VDD sky130_fd_pr__pfet_01v8 ad=0 pd=0 as=0 ps=0 w=400 l=30
X205 VDD RN m1_16272_445 VDD sky130_fd_pr__pfet_01v8 ad=0 pd=0 as=0 ps=0 w=400 l=30
X206 m1_16272_445 RN VDD VDD sky130_fd_pr__pfet_01v8 ad=0 pd=0 as=0 ps=0 w=400 l=30
X207 VDD m1_16122_519 m1_16272_445 VDD sky130_fd_pr__pfet_01v8 ad=0 pd=0 as=0 ps=0 w=400 l=30
X208 m1_16272_445 m1_16122_519 VDD VDD sky130_fd_pr__pfet_01v8 ad=0 pd=0 as=0 ps=0 w=400 l=30
X209 GND m1_16272_445 x210/a_0_0 GND sky130_fd_pr__nfet_01v8 ad=0 pd=0 as=78.2n ps=2.61m w=602 l=30
X211 m1_16122_519 m2_15366_759 x212/li_393_182 GND sky130_fd_pr__nfet_01v8 ad=7.16n pd=0.314m as=52.7n ps=1.92m w=602 l=30
X213 x212/li_393_182 SN x210/a_0_0 GND sky130_fd_pr__nfet_01v8 ad=0 pd=0 as=0 ps=0 w=600 l=30
X214 VDD m1_16272_445 m1_16122_519 VDD sky130_fd_pr__pfet_01v8 ad=0 pd=0 as=69.6n ps=2.75m w=400 l=30
X215 m1_16122_519 m1_16272_445 VDD VDD sky130_fd_pr__pfet_01v8 ad=0 pd=0 as=0 ps=0 w=400 l=30
X216 VDD SN m1_16122_519 VDD sky130_fd_pr__pfet_01v8 ad=0 pd=0 as=0 ps=0 w=400 l=30
X217 m1_16122_519 SN VDD VDD sky130_fd_pr__pfet_01v8 ad=0 pd=0 as=0 ps=0 w=400 l=30
X218 VDD m2_15366_759 m1_16122_519 VDD sky130_fd_pr__pfet_01v8 ad=0 pd=0 as=0 ps=0 w=400 l=30
X219 m1_16122_519 m2_15366_759 VDD VDD sky130_fd_pr__pfet_01v8 ad=0 pd=0 as=0 ps=0 w=400 l=30
C0 CLK m1_4737_519 3.71f
C1 RN SN 3.37f
C2 m2_17810_833 m1_4737_519 2.13f
C3 VDD m1_4737_519 3.46f
C4 D m2_9594_759 2.02f
C5 D CLK 5.29f
C6 m2_7672_685 SN 2.53f
C7 VDD m2_17810_833 2.07f
C8 VDD RN 2.24f
C9 m2_15366_759 m2_17810_833 2.09f
C10 m2_3822_759 D 2.03f
.ends

** hspice subcircuit dictionary
* x1	votern3x1_pcell_0/nmos_top_0
* x3	votern3x1_pcell_0/nmos_bottom_1
* x5	votern3x1_pcell_0/nmos_bottom_2
* x7	votern3x1_pcell_0
* x23	dffsnrnx1_pcell_0/nand3x1_pcell_0/nmos_bottom_0
* x25	dffsnrnx1_pcell_0/nand3x1_pcell_0
* x34	dffsnrnx1_pcell_0/nand3x1_pcell_1/nmos_bottom_0
* x36	dffsnrnx1_pcell_0/nand3x1_pcell_1
* x45	dffsnrnx1_pcell_0/nand3x1_pcell_2/nmos_bottom_0
* x47	dffsnrnx1_pcell_0/nand3x1_pcell_2
* x56	dffsnrnx1_pcell_0/nand3x1_pcell_3/nmos_bottom_0
* x58	dffsnrnx1_pcell_0/nand3x1_pcell_3
* x67	dffsnrnx1_pcell_0/nand3x1_pcell_4/nmos_bottom_0
* x69	dffsnrnx1_pcell_0/nand3x1_pcell_4
* x78	dffsnrnx1_pcell_0/nand3x1_pcell_5/nmos_bottom_0
* x80	dffsnrnx1_pcell_0/nand3x1_pcell_5
* x89	dffsnrnx1_pcell_1/nand3x1_pcell_0/nmos_bottom_0
* x91	dffsnrnx1_pcell_1/nand3x1_pcell_0
* x100	dffsnrnx1_pcell_1/nand3x1_pcell_1/nmos_bottom_0
* x102	dffsnrnx1_pcell_1/nand3x1_pcell_1
* x111	dffsnrnx1_pcell_1/nand3x1_pcell_2/nmos_bottom_0
* x113	dffsnrnx1_pcell_1/nand3x1_pcell_2
* x122	dffsnrnx1_pcell_1/nand3x1_pcell_3/nmos_bottom_0
* x124	dffsnrnx1_pcell_1/nand3x1_pcell_3
* x133	dffsnrnx1_pcell_1/nand3x1_pcell_4/nmos_bottom_0
* x135	dffsnrnx1_pcell_1/nand3x1_pcell_4
* x144	dffsnrnx1_pcell_1/nand3x1_pcell_5/nmos_bottom_0
* x146	dffsnrnx1_pcell_1/nand3x1_pcell_5
* x155	dffsnrnx1_pcell_2/nand3x1_pcell_0/nmos_bottom_0
* x157	dffsnrnx1_pcell_2/nand3x1_pcell_0
* x166	dffsnrnx1_pcell_2/nand3x1_pcell_1/nmos_bottom_0
* x168	dffsnrnx1_pcell_2/nand3x1_pcell_1
* x177	dffsnrnx1_pcell_2/nand3x1_pcell_2/nmos_bottom_0
* x179	dffsnrnx1_pcell_2/nand3x1_pcell_2
* x188	dffsnrnx1_pcell_2/nand3x1_pcell_3/nmos_bottom_0
* x190	dffsnrnx1_pcell_2/nand3x1_pcell_3
* x199	dffsnrnx1_pcell_2/nand3x1_pcell_4/nmos_bottom_0
* x201	dffsnrnx1_pcell_2/nand3x1_pcell_4
* x210	dffsnrnx1_pcell_2/nand3x1_pcell_5/nmos_bottom_0
* x212	dffsnrnx1_pcell_2/nand3x1_pcell_5
