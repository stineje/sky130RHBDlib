* HSPICE file created from TMRDFFSNRNQNX1.ext - technology: sky130A

.option scale=5m

.subckt TMRDFFSNRNQNX1 Q D CLK SN RN VDD GND
X0 GND m1_4737_519 x1/a_0_0 GND sky130_fd_pr__nfet_01v8 ad=2.39n pd=0.111m as=15.7n ps=0.599m w=602 l=30
X2 GND m1_4737_519 x3/a_0_0 GND sky130_fd_pr__nfet_01v8 ad=0.287u pd=0.0142 as=77.2n ps=2.61m w=602 l=30
X4 GND m1_16272_445 x5/a_0_0 GND sky130_fd_pr__nfet_01v8 ad=0 pd=0 as=77.2n ps=2.61m w=602 l=30
X6 x7/a_805_1331 m1_4737_519 VDD VDD sky130_fd_pr__pfet_01v8 ad=11.6n pd=0.458m as=22.4n ps=0.912m w=400 l=30
X8 VDD m1_4737_519 x7/a_805_1331 VDD sky130_fd_pr__pfet_01v8 ad=21.6n pd=0.908m as=11.6n ps=0.458m w=400 l=30
X9 Q m1_16272_445 x3/a_0_0 GND sky130_fd_pr__nfet_01v8 ad=2.39n pd=0.111m as=15.8n ps=0.594m w=602 l=30
X10 x7/a_805_1331 m1_10499_673 VDD VDD sky130_fd_pr__pfet_01v8 ad=0.114u pd=4.57m as=1.45u ps=0.0585 w=400 l=30
X11 VDD m1_10499_673 x7/a_805_1331 VDD sky130_fd_pr__pfet_01v8 ad=0 pd=0 as=0 ps=0 w=400 l=30
X12 x13/a_174_n399 m1_16272_445 x7/a_805_1331 VDD sky130_fd_pr__pfet_01v8 ad=23.2n pd=0.916m as=0 ps=0 w=400 l=30
X14 x7/a_805_1331 m1_16272_445 x13/a_174_n399 VDD sky130_fd_pr__pfet_01v8 ad=0 pd=0 as=0 ps=0 w=400 l=30
X15 x7/a_893_1059 m1_4737_519 x7/a_805_1331 VDD sky130_fd_pr__pfet_01v8 ad=90.4n pd=3.65m as=0 ps=0 w=400 l=30
X16 x7/a_805_1331 m1_4737_519 x7/a_893_1059 VDD sky130_fd_pr__pfet_01v8 ad=0 pd=0 as=0 ps=0 w=400 l=30
X17 Q m1_16272_445 x7/a_893_1059 VDD sky130_fd_pr__pfet_01v8 ad=46.4n pd=1.83m as=0 ps=0 w=400 l=30
X18 x7/a_893_1059 m1_16272_445 Q VDD sky130_fd_pr__pfet_01v8 ad=0 pd=0 as=0 ps=0 w=400 l=30
X19 Q m1_10499_673 x7/a_893_1059 VDD sky130_fd_pr__pfet_01v8 ad=0 pd=0 as=0 ps=0 w=400 l=30
X20 x7/a_893_1059 m1_10499_673 Q VDD sky130_fd_pr__pfet_01v8 ad=0 pd=0 as=0 ps=0 w=400 l=30
X21 Q m1_10499_673 x1/a_0_0 GND sky130_fd_pr__nfet_01v8 ad=2.39n pd=0.111m as=15.6n ps=0.592m w=602 l=30
X22 Q m1_10499_673 x5/a_0_0 GND sky130_fd_pr__nfet_01v8 ad=2.4n pd=0.112m as=15.8n ps=0.594m w=602 l=30
X23 GND D x24/a_0_0 GND sky130_fd_pr__nfet_01v8 ad=0 pd=0 as=78.2n ps=2.61m w=602 l=30
X25 x26/m1_783_489 x26/m1_636_635 x27/li_393_182 GND sky130_fd_pr__nfet_01v8 ad=-7.16n pd=-0.488m as=52.7n ps=1.92m w=602 l=30
X28 x27/li_393_182 RN x24/a_0_0 GND sky130_fd_pr__nfet_01v8 ad=2.18n pd=0.106m as=16.2n ps=0.604m w=600 l=30
X29 VDD D x26/m1_783_489 VDD sky130_fd_pr__pfet_01v8 ad=21.6n pd=0.908m as=11.6n ps=0.458m w=400 l=30
X30 x26/m1_783_489 D VDD VDD sky130_fd_pr__pfet_01v8 ad=11.6n pd=0.458m as=22.4n ps=0.912m w=400 l=30
X31 VDD RN x26/m1_783_489 VDD sky130_fd_pr__pfet_01v8 ad=0 pd=0 as=69.6n ps=2.75m w=400 l=30
X32 x26/m1_783_489 RN VDD VDD sky130_fd_pr__pfet_01v8 ad=0 pd=0 as=0 ps=0 w=400 l=30
X33 VDD x26/m1_636_635 x26/m1_783_489 VDD sky130_fd_pr__pfet_01v8 ad=0 pd=0 as=0 ps=0 w=400 l=30
X34 x26/m1_783_489 x26/m1_636_635 VDD VDD sky130_fd_pr__pfet_01v8 ad=0 pd=0 as=0 ps=0 w=400 l=30
X35 GND x26/m1_783_489 x36/a_0_0 GND sky130_fd_pr__nfet_01v8 ad=0 pd=0 as=78.2n ps=2.61m w=602 l=30
X37 x26/m1_636_635 x26/m1_1596_711 x38/li_393_182 GND sky130_fd_pr__nfet_01v8 ad=1p pd=-87u as=52.7n ps=1.92m w=602 l=30
X39 x38/li_393_182 CLK x36/a_0_0 GND sky130_fd_pr__nfet_01v8 ad=0 pd=0 as=0 ps=0 w=600 l=30
X40 VDD x26/m1_783_489 x26/m1_636_635 VDD sky130_fd_pr__pfet_01v8 ad=0 pd=0 as=69.6n ps=2.75m w=400 l=30
X41 x26/m1_636_635 x26/m1_783_489 VDD VDD sky130_fd_pr__pfet_01v8 ad=0 pd=0 as=0 ps=0 w=400 l=30
X42 VDD CLK x26/m1_636_635 VDD sky130_fd_pr__pfet_01v8 ad=0 pd=0 as=0 ps=0 w=400 l=30
X43 x26/m1_636_635 CLK VDD VDD sky130_fd_pr__pfet_01v8 ad=0 pd=0 as=0 ps=0 w=400 l=30
X44 VDD x26/m1_1596_711 x26/m1_636_635 VDD sky130_fd_pr__pfet_01v8 ad=0 pd=0 as=0 ps=0 w=400 l=30
X45 x26/m1_636_635 x26/m1_1596_711 VDD VDD sky130_fd_pr__pfet_01v8 ad=0 pd=0 as=0 ps=0 w=400 l=30
X46 GND x26/m1_783_489 x47/a_0_0 GND sky130_fd_pr__nfet_01v8 ad=0 pd=0 as=78.2n ps=2.61m w=602 l=30
X48 x26/m1_2706_486 x26/m1_1596_711 x49/li_393_182 GND sky130_fd_pr__nfet_01v8 ad=1p pd=-87u as=52.7n ps=1.92m w=602 l=30
X50 x49/li_393_182 SN x47/a_0_0 GND sky130_fd_pr__nfet_01v8 ad=0 pd=0 as=0 ps=0 w=600 l=30
X51 VDD x26/m1_783_489 x26/m1_2706_486 VDD sky130_fd_pr__pfet_01v8 ad=0 pd=0 as=69.6n ps=2.75m w=400 l=30
X52 x26/m1_2706_486 x26/m1_783_489 VDD VDD sky130_fd_pr__pfet_01v8 ad=0 pd=0 as=0 ps=0 w=400 l=30
X53 VDD SN x26/m1_2706_486 VDD sky130_fd_pr__pfet_01v8 ad=0 pd=0 as=0 ps=0 w=400 l=30
X54 x26/m1_2706_486 SN VDD VDD sky130_fd_pr__pfet_01v8 ad=0 pd=0 as=0 ps=0 w=400 l=30
X55 VDD x26/m1_1596_711 x26/m1_2706_486 VDD sky130_fd_pr__pfet_01v8 ad=0 pd=0 as=0 ps=0 w=400 l=30
X56 x26/m1_2706_486 x26/m1_1596_711 VDD VDD sky130_fd_pr__pfet_01v8 ad=0 pd=0 as=0 ps=0 w=400 l=30
X57 GND x26/m1_2706_486 x58/a_0_0 GND sky130_fd_pr__nfet_01v8 ad=0 pd=0 as=78.2n ps=2.61m w=602 l=30
X59 x26/m1_1596_711 RN x60/li_393_182 GND sky130_fd_pr__nfet_01v8 ad=7.16n pd=0.314m as=52.7n ps=1.92m w=602 l=30
X61 x60/li_393_182 CLK x58/a_0_0 GND sky130_fd_pr__nfet_01v8 ad=0 pd=0 as=0 ps=0 w=600 l=30
X62 VDD x26/m1_2706_486 x26/m1_1596_711 VDD sky130_fd_pr__pfet_01v8 ad=0 pd=0 as=69.6n ps=2.75m w=400 l=30
X63 x26/m1_1596_711 x26/m1_2706_486 VDD VDD sky130_fd_pr__pfet_01v8 ad=0 pd=0 as=0 ps=0 w=400 l=30
X64 VDD CLK x26/m1_1596_711 VDD sky130_fd_pr__pfet_01v8 ad=0 pd=0 as=0 ps=0 w=400 l=30
X65 x26/m1_1596_711 CLK VDD VDD sky130_fd_pr__pfet_01v8 ad=0 pd=0 as=0 ps=0 w=400 l=30
X66 VDD RN x26/m1_1596_711 VDD sky130_fd_pr__pfet_01v8 ad=0 pd=0 as=0 ps=0 w=400 l=30
X67 x26/m1_1596_711 RN VDD VDD sky130_fd_pr__pfet_01v8 ad=0 pd=0 as=0 ps=0 w=400 l=30
X68 GND x26/m1_636_635 x69/a_0_0 GND sky130_fd_pr__nfet_01v8 ad=0 pd=0 as=78.2n ps=2.61m w=602 l=30
X70 m1_4737_519 m1_4580_673 x71/li_393_182 GND sky130_fd_pr__nfet_01v8 ad=-14.3n pd=-1.24m as=52.7n ps=1.92m w=602 l=30
X72 x71/li_393_182 RN x69/a_0_0 GND sky130_fd_pr__nfet_01v8 ad=0 pd=0 as=0 ps=0 w=600 l=30
X73 VDD x26/m1_636_635 m1_4737_519 VDD sky130_fd_pr__pfet_01v8 ad=0 pd=0 as=69.6n ps=2.75m w=400 l=30
X74 m1_4737_519 x26/m1_636_635 VDD VDD sky130_fd_pr__pfet_01v8 ad=0 pd=0 as=0 ps=0 w=400 l=30
X75 VDD RN m1_4737_519 VDD sky130_fd_pr__pfet_01v8 ad=0 pd=0 as=0 ps=0 w=400 l=30
X76 m1_4737_519 RN VDD VDD sky130_fd_pr__pfet_01v8 ad=0 pd=0 as=0 ps=0 w=400 l=30
X77 VDD m1_4580_673 m1_4737_519 VDD sky130_fd_pr__pfet_01v8 ad=0 pd=0 as=0 ps=0 w=400 l=30
X78 m1_4737_519 m1_4580_673 VDD VDD sky130_fd_pr__pfet_01v8 ad=0 pd=0 as=0 ps=0 w=400 l=30
X79 GND m1_4737_519 x80/a_0_0 GND sky130_fd_pr__nfet_01v8 ad=0 pd=0 as=78.2n ps=2.61m w=602 l=30
X81 m1_4580_673 x26/m1_1596_711 x82/li_393_182 GND sky130_fd_pr__nfet_01v8 ad=7.16n pd=0.314m as=52.7n ps=1.92m w=602 l=30
X83 x82/li_393_182 SN x80/a_0_0 GND sky130_fd_pr__nfet_01v8 ad=0 pd=0 as=0 ps=0 w=600 l=30
X84 VDD m1_4737_519 m1_4580_673 VDD sky130_fd_pr__pfet_01v8 ad=0 pd=0 as=69.6n ps=2.75m w=400 l=30
X85 m1_4580_673 m1_4737_519 VDD VDD sky130_fd_pr__pfet_01v8 ad=0 pd=0 as=0 ps=0 w=400 l=30
X86 VDD SN m1_4580_673 VDD sky130_fd_pr__pfet_01v8 ad=0 pd=0 as=0 ps=0 w=400 l=30
X87 m1_4580_673 SN VDD VDD sky130_fd_pr__pfet_01v8 ad=0 pd=0 as=0 ps=0 w=400 l=30
X88 VDD x26/m1_1596_711 m1_4580_673 VDD sky130_fd_pr__pfet_01v8 ad=0 pd=0 as=0 ps=0 w=400 l=30
X89 m1_4580_673 x26/m1_1596_711 VDD VDD sky130_fd_pr__pfet_01v8 ad=0 pd=0 as=0 ps=0 w=400 l=30
X90 GND D x91/a_0_0 GND sky130_fd_pr__nfet_01v8 ad=0 pd=0 as=78.2n ps=2.61m w=602 l=30
X92 x93/m1_783_489 x93/m1_636_635 x94/li_393_182 GND sky130_fd_pr__nfet_01v8 ad=-7.16n pd=-0.488m as=52.7n ps=1.92m w=602 l=30
X95 x94/li_393_182 RN x91/a_0_0 GND sky130_fd_pr__nfet_01v8 ad=0 pd=0 as=0 ps=0 w=600 l=30
X96 VDD D x93/m1_783_489 VDD sky130_fd_pr__pfet_01v8 ad=0 pd=0 as=69.6n ps=2.75m w=400 l=30
X97 x93/m1_783_489 D VDD VDD sky130_fd_pr__pfet_01v8 ad=0 pd=0 as=0 ps=0 w=400 l=30
X98 VDD RN x93/m1_783_489 VDD sky130_fd_pr__pfet_01v8 ad=0 pd=0 as=0 ps=0 w=400 l=30
X99 x93/m1_783_489 RN VDD VDD sky130_fd_pr__pfet_01v8 ad=0 pd=0 as=0 ps=0 w=400 l=30
X100 VDD x93/m1_636_635 x93/m1_783_489 VDD sky130_fd_pr__pfet_01v8 ad=0 pd=0 as=0 ps=0 w=400 l=30
X101 x93/m1_783_489 x93/m1_636_635 VDD VDD sky130_fd_pr__pfet_01v8 ad=0 pd=0 as=0 ps=0 w=400 l=30
X102 GND x93/m1_783_489 x103/a_0_0 GND sky130_fd_pr__nfet_01v8 ad=0 pd=0 as=78.2n ps=2.61m w=602 l=30
X104 x93/m1_636_635 x93/m1_1596_711 x105/li_393_182 GND sky130_fd_pr__nfet_01v8 ad=1p pd=-87u as=52.7n ps=1.92m w=602 l=30
X106 x105/li_393_182 CLK x103/a_0_0 GND sky130_fd_pr__nfet_01v8 ad=0 pd=0 as=0 ps=0 w=600 l=30
X107 VDD x93/m1_783_489 x93/m1_636_635 VDD sky130_fd_pr__pfet_01v8 ad=0 pd=0 as=69.6n ps=2.75m w=400 l=30
X108 x93/m1_636_635 x93/m1_783_489 VDD VDD sky130_fd_pr__pfet_01v8 ad=0 pd=0 as=0 ps=0 w=400 l=30
X109 VDD CLK x93/m1_636_635 VDD sky130_fd_pr__pfet_01v8 ad=0 pd=0 as=0 ps=0 w=400 l=30
X110 x93/m1_636_635 CLK VDD VDD sky130_fd_pr__pfet_01v8 ad=0 pd=0 as=0 ps=0 w=400 l=30
X111 VDD x93/m1_1596_711 x93/m1_636_635 VDD sky130_fd_pr__pfet_01v8 ad=0 pd=0 as=0 ps=0 w=400 l=30
X112 x93/m1_636_635 x93/m1_1596_711 VDD VDD sky130_fd_pr__pfet_01v8 ad=0 pd=0 as=0 ps=0 w=400 l=30
X113 GND x93/m1_783_489 x114/a_0_0 GND sky130_fd_pr__nfet_01v8 ad=0 pd=0 as=78.2n ps=2.61m w=602 l=30
X115 x93/m1_2706_486 x93/m1_1596_711 x116/li_393_182 GND sky130_fd_pr__nfet_01v8 ad=1p pd=-87u as=52.7n ps=1.92m w=602 l=30
X117 x116/li_393_182 SN x114/a_0_0 GND sky130_fd_pr__nfet_01v8 ad=0 pd=0 as=0 ps=0 w=600 l=30
X118 VDD x93/m1_783_489 x93/m1_2706_486 VDD sky130_fd_pr__pfet_01v8 ad=0 pd=0 as=69.6n ps=2.75m w=400 l=30
X119 x93/m1_2706_486 x93/m1_783_489 VDD VDD sky130_fd_pr__pfet_01v8 ad=0 pd=0 as=0 ps=0 w=400 l=30
X120 VDD SN x93/m1_2706_486 VDD sky130_fd_pr__pfet_01v8 ad=0 pd=0 as=0 ps=0 w=400 l=30
X121 x93/m1_2706_486 SN VDD VDD sky130_fd_pr__pfet_01v8 ad=0 pd=0 as=0 ps=0 w=400 l=30
X122 VDD x93/m1_1596_711 x93/m1_2706_486 VDD sky130_fd_pr__pfet_01v8 ad=0 pd=0 as=0 ps=0 w=400 l=30
X123 x93/m1_2706_486 x93/m1_1596_711 VDD VDD sky130_fd_pr__pfet_01v8 ad=0 pd=0 as=0 ps=0 w=400 l=30
X124 GND x93/m1_2706_486 x125/a_0_0 GND sky130_fd_pr__nfet_01v8 ad=0 pd=0 as=78.2n ps=2.61m w=602 l=30
X126 x93/m1_1596_711 RN x127/li_393_182 GND sky130_fd_pr__nfet_01v8 ad=7.16n pd=0.314m as=52.7n ps=1.92m w=602 l=30
X128 x127/li_393_182 CLK x125/a_0_0 GND sky130_fd_pr__nfet_01v8 ad=0 pd=0 as=0 ps=0 w=600 l=30
X129 VDD x93/m1_2706_486 x93/m1_1596_711 VDD sky130_fd_pr__pfet_01v8 ad=0 pd=0 as=69.6n ps=2.75m w=400 l=30
X130 x93/m1_1596_711 x93/m1_2706_486 VDD VDD sky130_fd_pr__pfet_01v8 ad=0 pd=0 as=0 ps=0 w=400 l=30
X131 VDD CLK x93/m1_1596_711 VDD sky130_fd_pr__pfet_01v8 ad=0 pd=0 as=0 ps=0 w=400 l=30
X132 x93/m1_1596_711 CLK VDD VDD sky130_fd_pr__pfet_01v8 ad=0 pd=0 as=0 ps=0 w=400 l=30
X133 VDD RN x93/m1_1596_711 VDD sky130_fd_pr__pfet_01v8 ad=0 pd=0 as=0 ps=0 w=400 l=30
X134 x93/m1_1596_711 RN VDD VDD sky130_fd_pr__pfet_01v8 ad=0 pd=0 as=0 ps=0 w=400 l=30
X135 GND x93/m1_636_635 x136/a_0_0 GND sky130_fd_pr__nfet_01v8 ad=0 pd=0 as=78.2n ps=2.61m w=602 l=30
X137 m1_10499_673 m1_10351_519 x138/li_393_182 GND sky130_fd_pr__nfet_01v8 ad=1p pd=-87u as=52.7n ps=1.92m w=602 l=30
X139 x138/li_393_182 RN x136/a_0_0 GND sky130_fd_pr__nfet_01v8 ad=0 pd=0 as=0 ps=0 w=600 l=30
X140 VDD x93/m1_636_635 m1_10499_673 VDD sky130_fd_pr__pfet_01v8 ad=0 pd=0 as=69.6n ps=2.75m w=400 l=30
X141 m1_10499_673 x93/m1_636_635 VDD VDD sky130_fd_pr__pfet_01v8 ad=0 pd=0 as=0 ps=0 w=400 l=30
X142 VDD RN m1_10499_673 VDD sky130_fd_pr__pfet_01v8 ad=0 pd=0 as=0 ps=0 w=400 l=30
X143 m1_10499_673 RN VDD VDD sky130_fd_pr__pfet_01v8 ad=0 pd=0 as=0 ps=0 w=400 l=30
X144 VDD m1_10351_519 m1_10499_673 VDD sky130_fd_pr__pfet_01v8 ad=0 pd=0 as=0 ps=0 w=400 l=30
X145 m1_10499_673 m1_10351_519 VDD VDD sky130_fd_pr__pfet_01v8 ad=0 pd=0 as=0 ps=0 w=400 l=30
X146 GND m1_10499_673 x147/a_0_0 GND sky130_fd_pr__nfet_01v8 ad=0 pd=0 as=78.2n ps=2.61m w=602 l=30
X148 m1_10351_519 x93/m1_1596_711 x149/li_393_182 GND sky130_fd_pr__nfet_01v8 ad=7.16n pd=0.314m as=52.7n ps=1.92m w=602 l=30
X150 x149/li_393_182 SN x147/a_0_0 GND sky130_fd_pr__nfet_01v8 ad=0 pd=0 as=0 ps=0 w=600 l=30
X151 VDD m1_10499_673 m1_10351_519 VDD sky130_fd_pr__pfet_01v8 ad=0 pd=0 as=69.6n ps=2.75m w=400 l=30
X152 m1_10351_519 m1_10499_673 VDD VDD sky130_fd_pr__pfet_01v8 ad=0 pd=0 as=0 ps=0 w=400 l=30
X153 VDD SN m1_10351_519 VDD sky130_fd_pr__pfet_01v8 ad=0 pd=0 as=0 ps=0 w=400 l=30
X154 m1_10351_519 SN VDD VDD sky130_fd_pr__pfet_01v8 ad=0 pd=0 as=0 ps=0 w=400 l=30
X155 VDD x93/m1_1596_711 m1_10351_519 VDD sky130_fd_pr__pfet_01v8 ad=0 pd=0 as=0 ps=0 w=400 l=30
X156 m1_10351_519 x93/m1_1596_711 VDD VDD sky130_fd_pr__pfet_01v8 ad=0 pd=0 as=0 ps=0 w=400 l=30
X157 GND D x158/a_0_0 GND sky130_fd_pr__nfet_01v8 ad=0 pd=0 as=78.2n ps=2.61m w=602 l=30
X159 x160/m1_783_489 x160/m1_636_635 x161/li_393_182 GND sky130_fd_pr__nfet_01v8 ad=-7.16n pd=-0.488m as=52.7n ps=1.92m w=602 l=30
X162 x161/li_393_182 RN x158/a_0_0 GND sky130_fd_pr__nfet_01v8 ad=0 pd=0 as=0 ps=0 w=600 l=30
X163 VDD D x160/m1_783_489 VDD sky130_fd_pr__pfet_01v8 ad=0 pd=0 as=69.6n ps=2.75m w=400 l=30
X164 x160/m1_783_489 D VDD VDD sky130_fd_pr__pfet_01v8 ad=0 pd=0 as=0 ps=0 w=400 l=30
X165 VDD RN x160/m1_783_489 VDD sky130_fd_pr__pfet_01v8 ad=0 pd=0 as=0 ps=0 w=400 l=30
X166 x160/m1_783_489 RN VDD VDD sky130_fd_pr__pfet_01v8 ad=0 pd=0 as=0 ps=0 w=400 l=30
X167 VDD x160/m1_636_635 x160/m1_783_489 VDD sky130_fd_pr__pfet_01v8 ad=0 pd=0 as=0 ps=0 w=400 l=30
X168 x160/m1_783_489 x160/m1_636_635 VDD VDD sky130_fd_pr__pfet_01v8 ad=0 pd=0 as=0 ps=0 w=400 l=30
X169 GND x160/m1_783_489 x170/a_0_0 GND sky130_fd_pr__nfet_01v8 ad=0 pd=0 as=78.2n ps=2.61m w=602 l=30
X171 x160/m1_636_635 z@10 x172/li_393_182 GND sky130_fd_pr__nfet_01v8 ad=1p pd=-87u as=52.7n ps=1.92m w=602 l=30
X173 x172/li_393_182 CLK x170/a_0_0 GND sky130_fd_pr__nfet_01v8 ad=0 pd=0 as=0 ps=0 w=600 l=30
X174 VDD x160/m1_783_489 x160/m1_636_635 VDD sky130_fd_pr__pfet_01v8 ad=0 pd=0 as=69.6n ps=2.75m w=400 l=30
X175 x160/m1_636_635 x160/m1_783_489 VDD VDD sky130_fd_pr__pfet_01v8 ad=0 pd=0 as=0 ps=0 w=400 l=30
X176 VDD CLK x160/m1_636_635 VDD sky130_fd_pr__pfet_01v8 ad=0 pd=0 as=0 ps=0 w=400 l=30
X177 x160/m1_636_635 CLK VDD VDD sky130_fd_pr__pfet_01v8 ad=0 pd=0 as=0 ps=0 w=400 l=30
X178 VDD z@10 x160/m1_636_635 VDD sky130_fd_pr__pfet_01v8 ad=0 pd=0 as=0 ps=0 w=400 l=30
X179 x160/m1_636_635 z@10 VDD VDD sky130_fd_pr__pfet_01v8 ad=0 pd=0 as=0 ps=0 w=400 l=30
X180 GND x160/m1_783_489 x181/a_0_0 GND sky130_fd_pr__nfet_01v8 ad=0 pd=0 as=78.2n ps=2.61m w=602 l=30
X182 z@11 z@10 x183/li_393_182 GND sky130_fd_pr__nfet_01v8 ad=1p pd=-87u as=52.7n ps=1.92m w=602 l=30
X184 x183/li_393_182 SN x181/a_0_0 GND sky130_fd_pr__nfet_01v8 ad=0 pd=0 as=0 ps=0 w=600 l=30
X185 VDD x160/m1_783_489 z@11 VDD sky130_fd_pr__pfet_01v8 ad=0 pd=0 as=69.6n ps=2.75m w=400 l=30
X186 z@11 x160/m1_783_489 VDD VDD sky130_fd_pr__pfet_01v8 ad=0 pd=0 as=0 ps=0 w=400 l=30
X187 VDD SN z@11 VDD sky130_fd_pr__pfet_01v8 ad=0 pd=0 as=0 ps=0 w=400 l=30
X188 z@11 SN VDD VDD sky130_fd_pr__pfet_01v8 ad=0 pd=0 as=0 ps=0 w=400 l=30
X189 VDD z@10 z@11 VDD sky130_fd_pr__pfet_01v8 ad=0 pd=0 as=0 ps=0 w=400 l=30
X190 z@11 z@10 VDD VDD sky130_fd_pr__pfet_01v8 ad=0 pd=0 as=0 ps=0 w=400 l=30
X191 GND z@11 x192/a_0_0 GND sky130_fd_pr__nfet_01v8 ad=0 pd=0 as=78.2n ps=2.61m w=602 l=30
X193 z@10 RN x194/li_393_182 GND sky130_fd_pr__nfet_01v8 ad=7.16n pd=0.314m as=52.7n ps=1.92m w=602 l=30
X195 x194/li_393_182 CLK x192/a_0_0 GND sky130_fd_pr__nfet_01v8 ad=0 pd=0 as=0 ps=0 w=600 l=30
X196 VDD z@11 z@10 VDD sky130_fd_pr__pfet_01v8 ad=0 pd=0 as=69.6n ps=2.75m w=400 l=30
X197 z@10 z@11 VDD VDD sky130_fd_pr__pfet_01v8 ad=0 pd=0 as=0 ps=0 w=400 l=30
X198 VDD CLK z@10 VDD sky130_fd_pr__pfet_01v8 ad=0 pd=0 as=0 ps=0 w=400 l=30
X199 z@10 CLK VDD VDD sky130_fd_pr__pfet_01v8 ad=0 pd=0 as=0 ps=0 w=400 l=30
X200 VDD RN z@10 VDD sky130_fd_pr__pfet_01v8 ad=0 pd=0 as=0 ps=0 w=400 l=30
X201 z@10 RN VDD VDD sky130_fd_pr__pfet_01v8 ad=0 pd=0 as=0 ps=0 w=400 l=30
X202 GND x160/m1_636_635 x203/a_0_0 GND sky130_fd_pr__nfet_01v8 ad=0 pd=0 as=78.2n ps=2.61m w=602 l=30
X204 m1_16272_445 m1_16122_519 x205/li_393_182 GND sky130_fd_pr__nfet_01v8 ad=-7.16n pd=-0.664m as=52.7n ps=1.92m w=602 l=30
X206 x205/li_393_182 RN x203/a_0_0 GND sky130_fd_pr__nfet_01v8 ad=0 pd=0 as=0 ps=0 w=600 l=30
X207 VDD x160/m1_636_635 m1_16272_445 VDD sky130_fd_pr__pfet_01v8 ad=0 pd=0 as=69.6n ps=2.75m w=400 l=30
X208 m1_16272_445 x160/m1_636_635 VDD VDD sky130_fd_pr__pfet_01v8 ad=0 pd=0 as=0 ps=0 w=400 l=30
X209 VDD RN m1_16272_445 VDD sky130_fd_pr__pfet_01v8 ad=0 pd=0 as=0 ps=0 w=400 l=30
X210 m1_16272_445 RN VDD VDD sky130_fd_pr__pfet_01v8 ad=0 pd=0 as=0 ps=0 w=400 l=30
X211 VDD m1_16122_519 m1_16272_445 VDD sky130_fd_pr__pfet_01v8 ad=0 pd=0 as=0 ps=0 w=400 l=30
X212 m1_16272_445 m1_16122_519 VDD VDD sky130_fd_pr__pfet_01v8 ad=0 pd=0 as=0 ps=0 w=400 l=30
X213 GND m1_16272_445 x214/a_0_0 GND sky130_fd_pr__nfet_01v8 ad=0 pd=0 as=78.2n ps=2.61m w=602 l=30
X215 m1_16122_519 z@10 x216/li_393_182 GND sky130_fd_pr__nfet_01v8 ad=7.16n pd=0.314m as=52.7n ps=1.92m w=602 l=30
X217 x216/li_393_182 SN x214/a_0_0 GND sky130_fd_pr__nfet_01v8 ad=0 pd=0 as=0 ps=0 w=600 l=30
X218 VDD m1_16272_445 m1_16122_519 VDD sky130_fd_pr__pfet_01v8 ad=0 pd=0 as=69.6n ps=2.75m w=400 l=30
X219 m1_16122_519 m1_16272_445 VDD VDD sky130_fd_pr__pfet_01v8 ad=0 pd=0 as=0 ps=0 w=400 l=30
X220 VDD SN m1_16122_519 VDD sky130_fd_pr__pfet_01v8 ad=0 pd=0 as=0 ps=0 w=400 l=30
X221 m1_16122_519 SN VDD VDD sky130_fd_pr__pfet_01v8 ad=0 pd=0 as=0 ps=0 w=400 l=30
X222 VDD z@10 m1_16122_519 VDD sky130_fd_pr__pfet_01v8 ad=0 pd=0 as=0 ps=0 w=400 l=30
X223 m1_16122_519 z@10 VDD VDD sky130_fd_pr__pfet_01v8 ad=0 pd=0 as=0 ps=0 w=400 l=30
C0 x26/m1_1596_711 D 2.08f
C1 RN VDD 2.22f
C2 m1_10499_673 z@10 2.09f
C3 m1_4737_519 VDD 3.39f
C4 RN SN 3.46f
C5 m1_10499_673 VDD 2.07f
C6 m1_10499_673 m1_4737_519 2.12f
C7 D x93/m1_1596_711 2.08f
C8 CLK D 5.36f
C9 CLK m1_4737_519 5.14f
.ends

** hspice subcircuit dictionary
* x1	votern3x1_pcell_0/nmos_top_0
* x3	votern3x1_pcell_0/nmos_bottom_1
* x5	votern3x1_pcell_0/nmos_bottom_2
* x7	votern3x1_pcell_0
* x13	votern3x1_pcell_0/pmos2_1_2
* x24	dffsnrnx1_pcell_0/nand3x1_pcell_0/nmos_bottom_0
* x26	dffsnrnx1_pcell_0
* x27	dffsnrnx1_pcell_0/nand3x1_pcell_0
* x36	dffsnrnx1_pcell_0/nand3x1_pcell_1/nmos_bottom_0
* x38	dffsnrnx1_pcell_0/nand3x1_pcell_1
* x47	dffsnrnx1_pcell_0/nand3x1_pcell_2/nmos_bottom_0
* x49	dffsnrnx1_pcell_0/nand3x1_pcell_2
* x58	dffsnrnx1_pcell_0/nand3x1_pcell_3/nmos_bottom_0
* x60	dffsnrnx1_pcell_0/nand3x1_pcell_3
* x69	dffsnrnx1_pcell_0/nand3x1_pcell_4/nmos_bottom_0
* x71	dffsnrnx1_pcell_0/nand3x1_pcell_4
* x80	dffsnrnx1_pcell_0/nand3x1_pcell_5/nmos_bottom_0
* x82	dffsnrnx1_pcell_0/nand3x1_pcell_5
* x91	dffsnrnx1_pcell_1/nand3x1_pcell_0/nmos_bottom_0
* x93	dffsnrnx1_pcell_1
* x94	dffsnrnx1_pcell_1/nand3x1_pcell_0
* x103	dffsnrnx1_pcell_1/nand3x1_pcell_1/nmos_bottom_0
* x105	dffsnrnx1_pcell_1/nand3x1_pcell_1
* x114	dffsnrnx1_pcell_1/nand3x1_pcell_2/nmos_bottom_0
* x116	dffsnrnx1_pcell_1/nand3x1_pcell_2
* x125	dffsnrnx1_pcell_1/nand3x1_pcell_3/nmos_bottom_0
* x127	dffsnrnx1_pcell_1/nand3x1_pcell_3
* x136	dffsnrnx1_pcell_1/nand3x1_pcell_4/nmos_bottom_0
* x138	dffsnrnx1_pcell_1/nand3x1_pcell_4
* x147	dffsnrnx1_pcell_1/nand3x1_pcell_5/nmos_bottom_0
* x149	dffsnrnx1_pcell_1/nand3x1_pcell_5
* x158	dffsnrnx1_pcell_2/nand3x1_pcell_0/nmos_bottom_0
* x160	dffsnrnx1_pcell_2
* x161	dffsnrnx1_pcell_2/nand3x1_pcell_0
* x170	dffsnrnx1_pcell_2/nand3x1_pcell_1/nmos_bottom_0
* x172	dffsnrnx1_pcell_2/nand3x1_pcell_1
* x181	dffsnrnx1_pcell_2/nand3x1_pcell_2/nmos_bottom_0
* x183	dffsnrnx1_pcell_2/nand3x1_pcell_2
* x192	dffsnrnx1_pcell_2/nand3x1_pcell_3/nmos_bottom_0
* x194	dffsnrnx1_pcell_2/nand3x1_pcell_3
* x203	dffsnrnx1_pcell_2/nand3x1_pcell_4/nmos_bottom_0
* x205	dffsnrnx1_pcell_2/nand3x1_pcell_4
* x214	dffsnrnx1_pcell_2/nand3x1_pcell_5/nmos_bottom_0
* x216	dffsnrnx1_pcell_2/nand3x1_pcell_5
