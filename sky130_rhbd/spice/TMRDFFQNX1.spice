* HSPICE file created from TMRDFFQNX1.ext - technology: sky130A

.option scale=5m

.subckt TMRDFFQNX1 QN D CLK VDD GND
X0 GND x1/m1_2115_634 x2/a_0_0 GND sky130_fd_pr__nfet_01v8 ad=2.39n pd=0.111m as=15.7n ps=0.599m w=602 l=30
X3 x1/m1_191_783 CLK x2/a_0_0 GND sky130_fd_pr__nfet_01v8 ad=2.39n pd=0.111m as=15.8n ps=0.594m w=602 l=30
X4 VDD x1/m1_2115_634 x1/m1_191_783 VDD sky130_fd_pr__pfet_01v8 ad=21.6n pd=0.908m as=11.6n ps=0.458m w=400 l=30
X5 x1/m1_191_783 x1/m1_2115_634 VDD VDD sky130_fd_pr__pfet_01v8 ad=11.6n pd=0.458m as=22.4n ps=0.912m w=400 l=30
X6 VDD CLK x1/m1_191_783 VDD sky130_fd_pr__pfet_01v8 ad=1.35u pd=0.0548 as=46.4n ps=1.83m w=400 l=30
X7 x1/m1_191_783 CLK VDD VDD sky130_fd_pr__pfet_01v8 ad=0 pd=0 as=0 ps=0 w=400 l=30
X8 GND x1/m1_782_708 x9/a_0_0 GND sky130_fd_pr__nfet_01v8 ad=0.301u pd=0.0156 as=77.2n ps=2.61m w=602 l=30
X10 m1_3543_740 m1_3394_602 x9/a_0_0 GND sky130_fd_pr__nfet_01v8 ad=1p pd=-87u as=0 ps=0 w=602 l=30
X11 VDD x1/m1_782_708 m1_3543_740 VDD sky130_fd_pr__pfet_01v8 ad=0 pd=0 as=46.4n ps=1.83m w=400 l=30
X12 m1_3543_740 x1/m1_782_708 VDD VDD sky130_fd_pr__pfet_01v8 ad=0 pd=0 as=0 ps=0 w=400 l=30
X13 VDD m1_3394_602 m1_3543_740 VDD sky130_fd_pr__pfet_01v8 ad=0 pd=0 as=0 ps=0 w=400 l=30
X14 m1_3543_740 m1_3394_602 VDD VDD sky130_fd_pr__pfet_01v8 ad=0 pd=0 as=0 ps=0 w=400 l=30
X15 GND m1_3543_740 x16/a_0_0 GND sky130_fd_pr__nfet_01v8 ad=0 pd=0 as=77.2n ps=2.61m w=602 l=30
X17 m1_3394_602 x1/m1_191_783 x16/a_0_0 GND sky130_fd_pr__nfet_01v8 ad=1p pd=-0.263m as=0 ps=0 w=602 l=30
X18 VDD m1_3543_740 m1_3394_602 VDD sky130_fd_pr__pfet_01v8 ad=0 pd=0 as=46.4n ps=1.83m w=400 l=30
X19 m1_3394_602 m1_3543_740 VDD VDD sky130_fd_pr__pfet_01v8 ad=0 pd=0 as=0 ps=0 w=400 l=30
X20 VDD x1/m1_191_783 m1_3394_602 VDD sky130_fd_pr__pfet_01v8 ad=0 pd=0 as=0 ps=0 w=400 l=30
X21 m1_3394_602 x1/m1_191_783 VDD VDD sky130_fd_pr__pfet_01v8 ad=0 pd=0 as=0 ps=0 w=400 l=30
X22 GND x1/m1_191_783 x23/a_0_0 GND sky130_fd_pr__nfet_01v8 ad=0 pd=0 as=78.2n ps=2.61m w=602 l=30
X24 x1/m1_782_708 x1/m1_635_634 x25/li_393_182 GND sky130_fd_pr__nfet_01v8 ad=-7.16n pd=-0.488m as=52.7n ps=1.92m w=602 l=30
X26 x25/li_393_182 CLK x23/a_0_0 GND sky130_fd_pr__nfet_01v8 ad=2.18n pd=0.106m as=16.2n ps=0.604m w=600 l=30
X27 VDD x1/m1_191_783 x1/m1_782_708 VDD sky130_fd_pr__pfet_01v8 ad=0 pd=0 as=69.6n ps=2.75m w=400 l=30
X28 x1/m1_782_708 x1/m1_191_783 VDD VDD sky130_fd_pr__pfet_01v8 ad=0 pd=0 as=0 ps=0 w=400 l=30
X29 VDD CLK x1/m1_782_708 VDD sky130_fd_pr__pfet_01v8 ad=0 pd=0 as=0 ps=0 w=400 l=30
X30 x1/m1_782_708 CLK VDD VDD sky130_fd_pr__pfet_01v8 ad=0 pd=0 as=0 ps=0 w=400 l=30
X31 VDD x1/m1_635_634 x1/m1_782_708 VDD sky130_fd_pr__pfet_01v8 ad=0 pd=0 as=0 ps=0 w=400 l=30
X32 x1/m1_782_708 x1/m1_635_634 VDD VDD sky130_fd_pr__pfet_01v8 ad=0 pd=0 as=0 ps=0 w=400 l=30
X33 GND x1/m1_782_708 x34/a_0_0 GND sky130_fd_pr__nfet_01v8 ad=0 pd=0 as=77.2n ps=2.61m w=602 l=30
X35 x1/m1_635_634 D x34/a_0_0 GND sky130_fd_pr__nfet_01v8 ad=1p pd=-87u as=0 ps=0 w=602 l=30
X36 VDD x1/m1_782_708 x1/m1_635_634 VDD sky130_fd_pr__pfet_01v8 ad=0 pd=0 as=46.4n ps=1.83m w=400 l=30
X37 x1/m1_635_634 x1/m1_782_708 VDD VDD sky130_fd_pr__pfet_01v8 ad=0 pd=0 as=0 ps=0 w=400 l=30
X38 VDD D x1/m1_635_634 VDD sky130_fd_pr__pfet_01v8 ad=0 pd=0 as=0 ps=0 w=400 l=30
X39 x1/m1_635_634 D VDD VDD sky130_fd_pr__pfet_01v8 ad=0 pd=0 as=0 ps=0 w=400 l=30
X40 GND x1/m1_635_634 x41/a_0_0 GND sky130_fd_pr__nfet_01v8 ad=0 pd=0 as=77.2n ps=2.61m w=602 l=30
X42 x1/m1_2115_634 x1/m1_191_783 x41/a_0_0 GND sky130_fd_pr__nfet_01v8 ad=1p pd=-87u as=0 ps=0 w=602 l=30
X43 VDD x1/m1_635_634 x1/m1_2115_634 VDD sky130_fd_pr__pfet_01v8 ad=0 pd=0 as=46.4n ps=1.83m w=400 l=30
X44 x1/m1_2115_634 x1/m1_635_634 VDD VDD sky130_fd_pr__pfet_01v8 ad=0 pd=0 as=0 ps=0 w=400 l=30
X45 VDD x1/m1_191_783 x1/m1_2115_634 VDD sky130_fd_pr__pfet_01v8 ad=0 pd=0 as=0 ps=0 w=400 l=30
X46 x1/m1_2115_634 x1/m1_191_783 VDD VDD sky130_fd_pr__pfet_01v8 ad=0 pd=0 as=0 ps=0 w=400 l=30
X47 GND x48/m1_2115_634 x49/a_0_0 GND sky130_fd_pr__nfet_01v8 ad=0 pd=0 as=77.2n ps=2.61m w=602 l=30
X50 x48/m1_191_783 CLK x49/a_0_0 GND sky130_fd_pr__nfet_01v8 ad=1p pd=-87u as=0 ps=0 w=602 l=30
X51 VDD x48/m1_2115_634 x48/m1_191_783 VDD sky130_fd_pr__pfet_01v8 ad=0 pd=0 as=46.4n ps=1.83m w=400 l=30
X52 x48/m1_191_783 x48/m1_2115_634 VDD VDD sky130_fd_pr__pfet_01v8 ad=0 pd=0 as=0 ps=0 w=400 l=30
X53 VDD CLK x48/m1_191_783 VDD sky130_fd_pr__pfet_01v8 ad=0 pd=0 as=0 ps=0 w=400 l=30
X54 x48/m1_191_783 CLK VDD VDD sky130_fd_pr__pfet_01v8 ad=0 pd=0 as=0 ps=0 w=400 l=30
X55 GND x48/m1_782_708 x56/a_0_0 GND sky130_fd_pr__nfet_01v8 ad=0 pd=0 as=77.2n ps=2.61m w=602 l=30
X57 m1_7835_741 m1_7685_433 x56/a_0_0 GND sky130_fd_pr__nfet_01v8 ad=1p pd=-87u as=0 ps=0 w=602 l=30
X58 VDD x48/m1_782_708 m1_7835_741 VDD sky130_fd_pr__pfet_01v8 ad=0 pd=0 as=46.4n ps=1.83m w=400 l=30
X59 m1_7835_741 x48/m1_782_708 VDD VDD sky130_fd_pr__pfet_01v8 ad=0 pd=0 as=0 ps=0 w=400 l=30
X60 VDD m1_7685_433 m1_7835_741 VDD sky130_fd_pr__pfet_01v8 ad=0 pd=0 as=0 ps=0 w=400 l=30
X61 m1_7835_741 m1_7685_433 VDD VDD sky130_fd_pr__pfet_01v8 ad=0 pd=0 as=0 ps=0 w=400 l=30
X62 GND m1_7835_741 x63/a_0_0 GND sky130_fd_pr__nfet_01v8 ad=0 pd=0 as=77.2n ps=2.61m w=602 l=30
X64 x65/li_n17_n33 x48/m1_191_783 x63/a_0_0 GND sky130_fd_pr__nfet_01v8 ad=7.16n pd=0.314m as=0 ps=0 w=602 l=30
X66 VDD m1_7835_741 x65/li_n17_n33 VDD sky130_fd_pr__pfet_01v8 ad=0 pd=0 as=46.4n ps=1.83m w=400 l=30
X67 x65/li_n17_n33 m1_7835_741 VDD VDD sky130_fd_pr__pfet_01v8 ad=0 pd=0 as=0 ps=0 w=400 l=30
X68 VDD x48/m1_191_783 x65/li_n17_n33 VDD sky130_fd_pr__pfet_01v8 ad=0 pd=0 as=0 ps=0 w=400 l=30
X69 x65/li_n17_n33 x48/m1_191_783 VDD VDD sky130_fd_pr__pfet_01v8 ad=0 pd=0 as=0 ps=0 w=400 l=30
X70 GND x48/m1_191_783 x71/a_0_0 GND sky130_fd_pr__nfet_01v8 ad=0 pd=0 as=78.2n ps=2.61m w=602 l=30
X72 x48/m1_782_708 x48/m1_635_634 x73/li_393_182 GND sky130_fd_pr__nfet_01v8 ad=-7.16n pd=-0.488m as=52.7n ps=1.92m w=602 l=30
X74 x73/li_393_182 CLK x71/a_0_0 GND sky130_fd_pr__nfet_01v8 ad=0 pd=0 as=0 ps=0 w=600 l=30
X75 VDD x48/m1_191_783 x48/m1_782_708 VDD sky130_fd_pr__pfet_01v8 ad=0 pd=0 as=69.6n ps=2.75m w=400 l=30
X76 x48/m1_782_708 x48/m1_191_783 VDD VDD sky130_fd_pr__pfet_01v8 ad=0 pd=0 as=0 ps=0 w=400 l=30
X77 VDD CLK x48/m1_782_708 VDD sky130_fd_pr__pfet_01v8 ad=0 pd=0 as=0 ps=0 w=400 l=30
X78 x48/m1_782_708 CLK VDD VDD sky130_fd_pr__pfet_01v8 ad=0 pd=0 as=0 ps=0 w=400 l=30
X79 VDD x48/m1_635_634 x48/m1_782_708 VDD sky130_fd_pr__pfet_01v8 ad=0 pd=0 as=0 ps=0 w=400 l=30
X80 x48/m1_782_708 x48/m1_635_634 VDD VDD sky130_fd_pr__pfet_01v8 ad=0 pd=0 as=0 ps=0 w=400 l=30
X81 GND x48/m1_782_708 x82/a_0_0 GND sky130_fd_pr__nfet_01v8 ad=0 pd=0 as=77.2n ps=2.61m w=602 l=30
X83 x48/m1_635_634 D x82/a_0_0 GND sky130_fd_pr__nfet_01v8 ad=1p pd=-87u as=0 ps=0 w=602 l=30
X84 VDD x48/m1_782_708 x48/m1_635_634 VDD sky130_fd_pr__pfet_01v8 ad=0 pd=0 as=46.4n ps=1.83m w=400 l=30
X85 x48/m1_635_634 x48/m1_782_708 VDD VDD sky130_fd_pr__pfet_01v8 ad=0 pd=0 as=0 ps=0 w=400 l=30
X86 VDD D x48/m1_635_634 VDD sky130_fd_pr__pfet_01v8 ad=0 pd=0 as=0 ps=0 w=400 l=30
X87 x48/m1_635_634 D VDD VDD sky130_fd_pr__pfet_01v8 ad=0 pd=0 as=0 ps=0 w=400 l=30
X88 GND x48/m1_635_634 x89/a_0_0 GND sky130_fd_pr__nfet_01v8 ad=0 pd=0 as=77.2n ps=2.61m w=602 l=30
X90 x48/m1_2115_634 x48/m1_191_783 x89/a_0_0 GND sky130_fd_pr__nfet_01v8 ad=1p pd=-87u as=0 ps=0 w=602 l=30
X91 VDD x48/m1_635_634 x48/m1_2115_634 VDD sky130_fd_pr__pfet_01v8 ad=0 pd=0 as=46.4n ps=1.83m w=400 l=30
X92 x48/m1_2115_634 x48/m1_635_634 VDD VDD sky130_fd_pr__pfet_01v8 ad=0 pd=0 as=0 ps=0 w=400 l=30
X93 VDD x48/m1_191_783 x48/m1_2115_634 VDD sky130_fd_pr__pfet_01v8 ad=0 pd=0 as=0 ps=0 w=400 l=30
X94 x48/m1_2115_634 x48/m1_191_783 VDD VDD sky130_fd_pr__pfet_01v8 ad=0 pd=0 as=0 ps=0 w=400 l=30
X95 GND m1_11981_741 x96/a_0_0 GND sky130_fd_pr__nfet_01v8 ad=0 pd=0 as=76.7n ps=2.6m w=602 l=30
X97 GND m1_11981_741 x98/a_0_0 GND sky130_fd_pr__nfet_01v8 ad=0 pd=0 as=77.2n ps=2.61m w=602 l=30
X99 GND m1_3394_602 x100/a_0_0 GND sky130_fd_pr__nfet_01v8 ad=0 pd=0 as=77.2n ps=2.61m w=602 l=30
X101 x102/a_805_1331 m1_11981_741 VDD VDD sky130_fd_pr__pfet_01v8 ad=11.6n pd=0.458m as=22.4n ps=0.912m w=400 l=30
X103 VDD m1_11981_741 x102/a_805_1331 VDD sky130_fd_pr__pfet_01v8 ad=21.6n pd=0.908m as=11.6n ps=0.458m w=400 l=30
X104 QN m1_3394_602 x98/a_0_0 GND sky130_fd_pr__nfet_01v8 ad=21.5n pd=0.944m as=0 ps=0 w=602 l=30
X105 x102/a_805_1331 m1_7685_433 VDD VDD sky130_fd_pr__pfet_01v8 ad=0.114u pd=4.57m as=0 ps=0 w=400 l=30
X106 VDD m1_7685_433 x102/a_805_1331 VDD sky130_fd_pr__pfet_01v8 ad=0 pd=0 as=0 ps=0 w=400 l=30
X107 li_14043_1111 m1_3394_602 x102/a_805_1331 VDD sky130_fd_pr__pfet_01v8 ad=0.114u pd=4.57m as=0 ps=0 w=400 l=30
X108 x102/a_805_1331 m1_3394_602 li_14043_1111 VDD sky130_fd_pr__pfet_01v8 ad=0 pd=0 as=0 ps=0 w=400 l=30
X109 li_14043_1111 m1_11981_741 x102/a_805_1331 VDD sky130_fd_pr__pfet_01v8 ad=0 pd=0 as=0 ps=0 w=400 l=30
X110 x102/a_805_1331 m1_11981_741 li_14043_1111 VDD sky130_fd_pr__pfet_01v8 ad=0 pd=0 as=0 ps=0 w=400 l=30
X111 QN m1_3394_602 li_14043_1111 VDD sky130_fd_pr__pfet_01v8 ad=46.4n pd=1.83m as=0 ps=0 w=400 l=30
X112 li_14043_1111 m1_3394_602 QN VDD sky130_fd_pr__pfet_01v8 ad=0 pd=0 as=0 ps=0 w=400 l=30
X113 QN m1_7685_433 li_14043_1111 VDD sky130_fd_pr__pfet_01v8 ad=0 pd=0 as=0 ps=0 w=400 l=30
X114 li_14043_1111 m1_7685_433 QN VDD sky130_fd_pr__pfet_01v8 ad=0 pd=0 as=0 ps=0 w=400 l=30
X115 QN m1_7685_433 x96/a_0_0 GND sky130_fd_pr__nfet_01v8 ad=2.39n pd=0.111m as=15.6n ps=0.592m w=602 l=30
X116 QN m1_7685_433 x100/a_0_0 GND sky130_fd_pr__nfet_01v8 ad=2.4n pd=0.112m as=15.8n ps=0.594m w=602 l=30
X117 GND z@10 x119/a_0_0 GND sky130_fd_pr__nfet_01v8 ad=0 pd=0 as=77.2n ps=2.61m w=602 l=30
X120 x118/m1_191_783 CLK x119/a_0_0 GND sky130_fd_pr__nfet_01v8 ad=1p pd=-87u as=0 ps=0 w=602 l=30
X121 VDD z@10 x118/m1_191_783 VDD sky130_fd_pr__pfet_01v8 ad=0 pd=0 as=46.4n ps=1.83m w=400 l=30
X122 x118/m1_191_783 z@10 VDD VDD sky130_fd_pr__pfet_01v8 ad=0 pd=0 as=0 ps=0 w=400 l=30
X123 VDD CLK x118/m1_191_783 VDD sky130_fd_pr__pfet_01v8 ad=0 pd=0 as=0 ps=0 w=400 l=30
X124 x118/m1_191_783 CLK VDD VDD sky130_fd_pr__pfet_01v8 ad=0 pd=0 as=0 ps=0 w=400 l=30
X125 GND x118/m1_782_708 x126/a_0_0 GND sky130_fd_pr__nfet_01v8 ad=0 pd=0 as=77.2n ps=2.61m w=602 l=30
X127 m1_12127_895 m1_11981_741 x126/a_0_0 GND sky130_fd_pr__nfet_01v8 ad=1p pd=-87u as=0 ps=0 w=602 l=30
X128 VDD x118/m1_782_708 m1_12127_895 VDD sky130_fd_pr__pfet_01v8 ad=0 pd=0 as=46.4n ps=1.83m w=400 l=30
X129 m1_12127_895 x118/m1_782_708 VDD VDD sky130_fd_pr__pfet_01v8 ad=0 pd=0 as=0 ps=0 w=400 l=30
X130 VDD m1_11981_741 m1_12127_895 VDD sky130_fd_pr__pfet_01v8 ad=0 pd=0 as=0 ps=0 w=400 l=30
X131 m1_12127_895 m1_11981_741 VDD VDD sky130_fd_pr__pfet_01v8 ad=0 pd=0 as=0 ps=0 w=400 l=30
X132 GND m1_12127_895 x133/a_0_0 GND sky130_fd_pr__nfet_01v8 ad=0 pd=0 as=77.2n ps=2.61m w=602 l=30
X134 m1_11981_741 x118/m1_191_783 x133/a_0_0 GND sky130_fd_pr__nfet_01v8 ad=-7.16n pd=-0.841m as=0 ps=0 w=602 l=30
X135 VDD m1_12127_895 m1_11981_741 VDD sky130_fd_pr__pfet_01v8 ad=0 pd=0 as=46.4n ps=1.83m w=400 l=30
X136 m1_11981_741 m1_12127_895 VDD VDD sky130_fd_pr__pfet_01v8 ad=0 pd=0 as=0 ps=0 w=400 l=30
X137 VDD x118/m1_191_783 m1_11981_741 VDD sky130_fd_pr__pfet_01v8 ad=0 pd=0 as=0 ps=0 w=400 l=30
X138 m1_11981_741 x118/m1_191_783 VDD VDD sky130_fd_pr__pfet_01v8 ad=0 pd=0 as=0 ps=0 w=400 l=30
X139 GND x118/m1_191_783 x140/a_0_0 GND sky130_fd_pr__nfet_01v8 ad=0 pd=0 as=78.2n ps=2.61m w=602 l=30
X141 x118/m1_782_708 x118/m1_635_634 x142/li_393_182 GND sky130_fd_pr__nfet_01v8 ad=-7.16n pd=-0.488m as=52.7n ps=1.92m w=602 l=30
X143 x142/li_393_182 CLK x140/a_0_0 GND sky130_fd_pr__nfet_01v8 ad=0 pd=0 as=0 ps=0 w=600 l=30
X144 VDD x118/m1_191_783 x118/m1_782_708 VDD sky130_fd_pr__pfet_01v8 ad=0 pd=0 as=69.6n ps=2.75m w=400 l=30
X145 x118/m1_782_708 x118/m1_191_783 VDD VDD sky130_fd_pr__pfet_01v8 ad=0 pd=0 as=0 ps=0 w=400 l=30
X146 VDD CLK x118/m1_782_708 VDD sky130_fd_pr__pfet_01v8 ad=0 pd=0 as=0 ps=0 w=400 l=30
X147 x118/m1_782_708 CLK VDD VDD sky130_fd_pr__pfet_01v8 ad=0 pd=0 as=0 ps=0 w=400 l=30
X148 VDD x118/m1_635_634 x118/m1_782_708 VDD sky130_fd_pr__pfet_01v8 ad=0 pd=0 as=0 ps=0 w=400 l=30
X149 x118/m1_782_708 x118/m1_635_634 VDD VDD sky130_fd_pr__pfet_01v8 ad=0 pd=0 as=0 ps=0 w=400 l=30
X150 GND x118/m1_782_708 x151/a_0_0 GND sky130_fd_pr__nfet_01v8 ad=0 pd=0 as=77.2n ps=2.61m w=602 l=30
X152 x118/m1_635_634 D x151/a_0_0 GND sky130_fd_pr__nfet_01v8 ad=1p pd=-87u as=0 ps=0 w=602 l=30
X153 VDD x118/m1_782_708 x118/m1_635_634 VDD sky130_fd_pr__pfet_01v8 ad=0 pd=0 as=46.4n ps=1.83m w=400 l=30
X154 x118/m1_635_634 x118/m1_782_708 VDD VDD sky130_fd_pr__pfet_01v8 ad=0 pd=0 as=0 ps=0 w=400 l=30
X155 VDD D x118/m1_635_634 VDD sky130_fd_pr__pfet_01v8 ad=0 pd=0 as=0 ps=0 w=400 l=30
X156 x118/m1_635_634 D VDD VDD sky130_fd_pr__pfet_01v8 ad=0 pd=0 as=0 ps=0 w=400 l=30
X157 GND x118/m1_635_634 x158/a_0_0 GND sky130_fd_pr__nfet_01v8 ad=0 pd=0 as=77.2n ps=2.61m w=602 l=30
X159 z@10 x118/m1_191_783 x158/a_0_0 GND sky130_fd_pr__nfet_01v8 ad=1p pd=-87u as=0 ps=0 w=602 l=30
X160 VDD x118/m1_635_634 z@10 VDD sky130_fd_pr__pfet_01v8 ad=0 pd=0 as=46.4n ps=1.83m w=400 l=30
X161 z@10 x118/m1_635_634 VDD VDD sky130_fd_pr__pfet_01v8 ad=0 pd=0 as=0 ps=0 w=400 l=30
X162 VDD x118/m1_191_783 z@10 VDD sky130_fd_pr__pfet_01v8 ad=0 pd=0 as=0 ps=0 w=400 l=30
X163 z@10 x118/m1_191_783 VDD VDD sky130_fd_pr__pfet_01v8 ad=0 pd=0 as=0 ps=0 w=400 l=30
C0 CLK x1/m1_191_783 2.27f
C1 D m1_3394_602 3.43f
C2 x48/m1_191_783 CLK 3.07f
C3 CLK VDD 3.63f
.ends

** hspice subcircuit dictionary
* x1	dffx1_pcell_0
* x2	dffx1_pcell_0/nand2x1_pcell_2/nmos_bottom_0
* x9	dffx1_pcell_0/nand2x1_pcell_3/nmos_bottom_0
* x16	dffx1_pcell_0/nand2x1_pcell_4/nmos_bottom_0
* x23	dffx1_pcell_0/nand3x1_pcell_0/nmos_bottom_0
* x25	dffx1_pcell_0/nand3x1_pcell_0
* x34	dffx1_pcell_0/nand2x1_pcell_0/nmos_bottom_0
* x41	dffx1_pcell_0/nand2x1_pcell_1/nmos_bottom_0
* x48	dffx1_pcell_1
* x49	dffx1_pcell_1/nand2x1_pcell_2/nmos_bottom_0
* x56	dffx1_pcell_1/nand2x1_pcell_3/nmos_bottom_0
* x63	dffx1_pcell_1/nand2x1_pcell_4/nmos_bottom_0
* x65	li1_M1_contact_3
* x71	dffx1_pcell_1/nand3x1_pcell_0/nmos_bottom_0
* x73	dffx1_pcell_1/nand3x1_pcell_0
* x82	dffx1_pcell_1/nand2x1_pcell_0/nmos_bottom_0
* x89	dffx1_pcell_1/nand2x1_pcell_1/nmos_bottom_0
* x96	votern3x1_pcell_0/nmos_top_0
* x98	votern3x1_pcell_0/nmos_bottom_1
* x100	votern3x1_pcell_0/nmos_bottom_2
* x102	votern3x1_pcell_0
* x118	dffx1_pcell_2
* x119	dffx1_pcell_2/nand2x1_pcell_2/nmos_bottom_0
* x126	dffx1_pcell_2/nand2x1_pcell_3/nmos_bottom_0
* x133	dffx1_pcell_2/nand2x1_pcell_4/nmos_bottom_0
* x140	dffx1_pcell_2/nand3x1_pcell_0/nmos_bottom_0
* x142	dffx1_pcell_2/nand3x1_pcell_0
* x151	dffx1_pcell_2/nand2x1_pcell_0/nmos_bottom_0
* x158	dffx1_pcell_2/nand2x1_pcell_1/nmos_bottom_0
