.opt warning_change_severity=error warning_id=[MDL-360]
**** Altos spice deck for characterization release 23.1.1.221.isr1
*** Arc id: arc1
***           pin opin_dir related related_dir timing_type   table_type    when
*** Info_arc: -   -        -       -           combinational leakage_power Y
** NET-MAP BEGIN for inv_0
** NET-MAP END

* begin of instance section for inv_0
MM0_noxref.nmos_0 N_Y_M0_noxref_d N_A_M0_noxref_g noxref_2 noxref_9 inv:M0_noxref:NMOS:nmos:nshort_model L=1.5e-07 W=4.2e-07 NRS=0.333333 NRD=0.333333 SA=0 SB=0 SD=0 NF=1 deleta0=0 deltox=0 mulvsat=1
MM1_noxref.pmos_0 N_Y_M1_noxref_d N_A_M1_noxref_g noxref_3 noxref_7 inv:M1_noxref:PMOS:pmos:pshort_model L=1.5e-07 W=4.2e-07 AS=1.197e-13 AD=1.197e-13 PS=9.9e-07 PD=9.9e-07 NRS=0 NRD=0 SA=0 SB=0 SD=0 NF=1 deltox=0 mulvsat=1
*RC for wire 0
C0_0 N_A_M0_noxref_g 0 7.09645e-17
C1_0 N_A_c_1_p 0 1.2557e-17
C2_0 N_Y_M0_noxref_d 0 8.48727e-17
C3_0 noxref_2 0 1.51981e-16
C4_0 noxref_3 0 1.49421e-16
C5_0 N_A_c_3_p 0 7.18082e-17
C6_0 N_A_M1_noxref_g 0 8.33265e-17
*RC for wire A
R7_0 A N_A_c_1_p 0.249027
R8_0 N_A_c_1_p N_A_c_3_p 152
R9_0 x_PM_INV%A.18 N_A_c_3_p 56.5354
R10_0 x_PM_INV%A.17 N_A_c_3_p 55.9533
R11_0 N_A_M1_noxref_g x_PM_INV%A.18 228.181
R12_0 N_A_M0_noxref_g x_PM_INV%A.17 189.723
C13_0 N_Y_M0_noxref_d N_A_M0_noxref_g 6.93365e-17
C14_0 noxref_2 N_A_M0_noxref_g 2.58672e-17
C15_0 N_Y_M0_noxref_d N_A_c_1_p 2.63512e-17
C16_0 noxref_2 N_A_c_1_p 1.47639e-17
C17_0 noxref_3 N_A_c_1_p 1.23588e-17
C18_0 N_Y_M0_noxref_d N_A_c_3_p 2.55784e-18
C19_0 noxref_2 N_A_c_3_p 9.93373e-18
C20_0 noxref_3 N_A_c_3_p 8.87245e-18
C21_0 noxref_3 N_A_M1_noxref_g 2.92754e-17
*RC for wire GND
*RC for wire noxref_2
C22_0 noxref_2 N_Y_M0_noxref_d 3.79397e-17
C23_0 noxref_3 noxref_2 1.19054e-17
*RC for wire noxref_3
C24_0 noxref_3 N_Y_M0_noxref_d 3.87862e-17
*RC for wire noxref_7
*RC for wire noxref_9
*RC for wire VDD
*RC for wire VSS
*RC for wire Y
R25_0 N_Y_M1_noxref_d Y 41.0695
R26_0 N_Y_M0_noxref_d Y 51.2684

* end of instance section for inv_0

.model inv:M0_noxref:NMOS:nmos:nshort_model.48 nmos level=54 version=4.5 a0=8.8861058e-01 a1=0.0000000e+00
+  a2=4.2385546e-01 acde=4.0000000e-01 acnqsmod=0 af=1.0000000e+00 agidl=0.0000000e+00
+  ags=-4.5446900e+00 aigbacc=1.0000000e+00 aigbinv=3.5000000e-01 aigc=4.3000000e-01 aigsd=4.3000000e-01
+  alpha0=2.0207876e-05 alpha1=8.5000000e-01 at=-2.3795200e+04 b0=0.0000000e+00 b1=0.0000000e+00
+  beta0=2.7646651e+01 bgidl=2.3000000e+09 bigbacc=0.0000000e+00 bigbinv=3.0000000e-02 bigc=5.4000000e-02
+  bigsd=5.4000000e-02 binunit=2 bvs=1.1700000e+01 capmod=2 cdsc=0.0000000e+00
+  cdscb=0.0000000e+00 cdscd=1.9789710e-02 cf=1.4067000e-12 cgbo=1.0000000e-13 cgdl=0.0000000e+00
+  cgdo=2.4490680e-10 cgidl=5.0000000e-01 cgsl=0.0000000e+00 cgso=2.4490680e-10 cigbacc=0.0000000e+00
+  cigbinv=6.0000000e-03 cigc=7.5000000e-02 cigsd=7.5000000e-02 cit=0.0000000e+00 cjs=1.3500000e-03
+  cjswgs=2.3823279e-10 cjsws=3.6735420e-11 ckappas=6.0000000e-01 clc=1.0000000e-07 cle=6.0000000e-01
+  delta=1.0000000e-02 diomod=1 dlc=9.8790800e-09 dlcig=0.0000000e+00 dmcg=0.0000000e+00
+  dmcgt=0.0000000e+00 dmdg=0.0000000e+00 drout=3.1346944e+00 dsub=-8.0505600e-01 dvt0=0.0000000e+00
+  dvt0w=-3.5800000e+00 dvt1=5.3000000e-01 dvt1w=1.6706000e+06 dvt2=-3.2000000e-02 dvt2w=6.8000000e-02
+  dvtp0=0.0000000e+00 dvtp1=0.0000000e+00 dwb=0.0000000e+00 dwc=0.0000000e+00 dwg=0.0000000e+00
+  ef=8.4000000e-01 egidl=8.0000000e-01 eigbinv=1.1000000e+00 em=4.1000000e+07 epsrox=3.9000000e+00
+  eta0=2.5950467e+00 etab=1.8579224e-01 eu=1.6700000e+00 fnoimod=1 fprout=0.0000000e+00
+  gbmin=1.0000000e-12 geomod=0 igbmod=0 igcmod=0 ijthsfwd=1.0000000e-01
+  ijthsrev=1.0000000e-01 jss=2.7500000e-03 jsws=6.0000000e-10 k1=-1.3821400e+00 k2=6.1656830e-01
+  k3=2.0000000e+00 k3b=5.4000000e-01 keta=-9.4248700e-02 kf=0.0000000e+00 kt1=-7.4351400e-01
+  kt1l=0.0000000e+00 kt2=-7.0413500e-02 ku0=-2.7000000e-08 kvsat=2.0000000e-01 kvth0=9.8000000e-09
+  la0=7.7118216e-08 lags=7.3091896e-07 lalpha0=-2.5451600e-12 lambda=0.0000000e+00 lat=9.7775125e-03
+  lbeta0=-1.7402500e-06 lc=5.0000000e-09 lcdscd=-2.2373600e-09 ldrout=-3.3191000e-07 ldsub=9.9116240e-08
+  leta0=-3.2698800e-07 letab=-2.8984800e-08 lint=1.1932000e-08 lintnoi=-1.0000000e-07 lk1=2.8875188e-07
+  lk2=-9.2774500e-08 lketa=3.2359873e-08 lkt1=6.3390023e-08 lkt2=5.2390006e-09 lku0=0.0000000e+00
+  lkvth0=0.0000000e+00 ll=0.0000000e+00 llc=0.0000000e+00 lln=1.0000000e+00 llodku0=0.0000000e+00
+  llodvth=0.0000000e+00 lmax=1.8000000e-07 lmin=1.5000000e-07 lnfactor=-2.6513800e-06 lodeta0=1.0000000e+00
+  lodk2=1.0000000e+00 lp=1.0000000e+00 lpclm=-1.2172700e-07 lpdiblc1=2.1647922e-07 lpdiblc2=5.5865093e-09
+  lpdiblcb=-5.8076300e-09 lpe0=1.0325000e-07 lpeb=-7.0820000e-08 lpscbe1=2.3688315e+02 lu0=-1.0753700e-08
+  lua=2.4862618e-16 lua1=-5.7171500e-16 lub=-1.2806500e-24 lub1=8.9523434e-25 luc=6.7462545e-17
+  luc1=9.4523825e-17 lute=-7.7097500e-08 lvoff=-4.2698100e-08 lvsat=-9.8693000e-03 lvth0=-9.4698900e-09
+  lw=0.0000000e+00 lwc=0.0000000e+00 lwl=0.0000000e+00 lwlc=0.0000000e+00 lwn=1.0000000e+00
+  minv=0.0000000e+00 mjs=4.4000000e-01 mjswgs=8.0000000e-01 mjsws=9.0000000e-04 mobmod=0
+  moin=6.9000000e+00 ndep=1.7000000e+17 nfactor=2.4565701e+01 ngate=1.0000000e+23 ngcon=1.0000000e+00
+  nigbacc=0.0000000e+00 nigbinv=0.0000000e+00 nigc=0.0000000e+00 njs=1.2928000e+00 noff=3.4037000e+00
+  noia=2.5000000e+42 noib=0.0000000e+00 noic=0.0000000e+00 nsd=1.0000000e+20 ntnoi=1.0000000e+00
+  ntox=1.0000000e+00 pa0=-2.9018200e-14 pags=-2.7503200e-13 palpha0=9.5236096e-19 pat=-1.2088900e-09
+  pbeta0=5.1896472e-13 pbs=7.2900000e-01 pbswgs=9.5578000e-01 pbsws=2.0000000e-01 pcdscd=8.4187974e-16
+  pclm=1.1851501e+00 pdiblc1=-1.3592600e+00 pdiblc2=-3.5883500e-02 pdiblcb=-5.7253200e-02 pdits=0.0000000e+00
+  pditsd=0.0000000e+00 pditsl=0.0000000e+00 pdrout=1.2489184e-13 pdsub=-3.7295700e-14 permod=1
+  peta0=1.2303963e-13 petab=1.0906467e-14 phin=0.0000000e+00 pigcd=1.0000000e+00 pk1=-1.0865200e-13
+  pk2=3.6229537e-14 pketa=-1.8110900e-14 pkt1=-2.8792900e-14 pkt2=-1.9713400e-15 pku0=0.0000000e+00
+  pkvth0=0.0000000e+00 pnfactor=1.3134246e-12 poxedge=1.0000000e+00 ppclm=3.6570152e-14 ppdiblc1=-8.1457200e-14
+  ppdiblc2=-2.1021000e-15 ppdiblcb=2.1853066e-15 ppscbe1=-8.9134900e-05 prt=0.0000000e+00 prwb=0.0000000e+00
+  prwg=2.1507000e-02 pscbe1=-1.0865781e+09 pscbe2=1.0000000e-12 pu0=5.7963766e-15 pua=-1.0193900e-22
+  pua1=2.1512615e-22 pub=6.7929417e-31 pub1=-3.3686100e-31 puc=-3.1117300e-23 puc1=-3.5567600e-23
+  pute=4.3831679e-14 pvag=0.0000000e+00 pvoff=1.6066518e-14 pvsat=6.0686085e-09 pvth0=-6.1191400e-15
+  rbdb=5.0000000e+01 rbodymod=1 rbpb=5.0000000e+01 rbpd=5.0000000e+01 rbps=5.0000000e+01
+  rbsb=5.0000000e+01 rdsmod=0 rdsw=6.5968000e+01 rdswmin=0.0000000e+00 rdw=0.0000000e+00
+  rdwmin=0.0000000e+00 rgatemod=0 rnoia=9.4000000e-01 rnoib=2.6000000e-01 rsh=6.5564286e+02
+  rshg=1.0000000e-01 rsw=0.0000000e+00 rswmin=0.0000000e+00 saref=1.1000000e-06 sbref=1.1000000e-06
+  steta0=0.0000000e+00 stk2=0.0000000e+00 tcj=7.9200000e-04 tcjsw=1.0000000e-05 tcjswg=0.0000000e+00
+  tempmod=0 tku0=0.0000000e+00 tnoia=1.5000000e+07 tnoib=9.9000000e+06 tnoimod=1
+  tnom=3.0000000e+01 toxe=4.1480000e-09 toxm=4.1480000e-09 toxref=4.1480000e-09 tpb=1.2287000e-03
+  tpbsw=0.0000000e+00 tpbswg=0.0000000e+00 trnqsmod=0 tvfbsdoff=0.0000000e+00 tvoff=0.0000000e+00
+  u0=9.3555226e-02 ua=-3.0816800e-09 ua1=4.5086829e-09 ub=1.1005312e-17 ub1=-6.3896200e-18
+  uc=-3.9161400e-10 uc1=-6.0219400e-10 ud=0.0000000e+00 up=0.0000000e+00 ute=-7.4801900e-01
+  vbm=-3.0000000e+00 vfbcv=-1.0000000e+00 vfbsdoff=0.0000000e+00 voff=1.3097826e-01 voffcv=-1.7287000e-01
+  voffl=5.8197729e-09 vsat=2.3629301e+05 vth0=6.2438829e-01 vtl=0.0000000e+00 w0=0.0000000e+00
+  wa0=2.3005483e-07 wags=2.1804374e-06 walpha0=-7.5502700e-12 wat=9.5840172e-03 wbeta0=-4.1143300e-06
+  wcdscd=-6.6743800e-09 wdrout=-9.9013600e-07 wdsub=5.3762647e-07 weta0=-9.7646900e-07 wetab=-8.6465900e-08
+  wint=2.1859000e-08 wk1=8.6138877e-07 wk2=-2.9442800e-07 wketa=4.7743562e-08 wkt1=2.2826908e-07
+  wkt2=1.5628699e-08 wku0=0.0000000e+00 wkvth0=2.0000000e-07 wl=0.0000000e+00 wlc=0.0000000e+00
+  wln=1.0000000e+00 wlod=0.0000000e+00 wlodku0=1.0000000e+00 wlodvth=1.0000000e+00 wmax=5.5000000e-07
+  wmin=4.2000000e-07 wnfactor=-1.0866100e-05 wpclm=-3.1864900e-07 wpdiblc1=6.4578895e-07 wpdiblc2=1.6665368e-08
+  wpdiblcb=-1.7325000e-08 wpscbe1=7.0665682e+02 wr=1.0000000e+00 wu0=-3.7251400e-08 wua=7.7490645e-16
+  wua1=-1.7055100e-15 wub=-4.6766100e-24 wub1=2.6706140e-24 wuc=2.1848572e-16 wuc1=2.8197829e-16
+  wute=-2.9474000e-07 wvoff=-1.2737500e-07 wvsat=-3.4840200e-02 wvth0=-5.5999000e-09 ww=0.0000000e+00
+  wwc=0.0000000e+00 wwl=0.0000000e+00 wwlc=0.0000000e+00 wwn=1.0000000e+00 xgl=0.0000000e+00
+  xgw=0.0000000e+00 xj=1.5000000e-07 xjbvs=1.0000000e+00 xl=0.0000000e+00 xn=3.0000000e+00
+  xpart=0.0000000e+00 xrcrg1=1.2000000e+01 xrcrg2=1.0000000e+00 xtis=2.0000000e+00 xw=0.0000000e+00

.model inv:M1_noxref:PMOS:pmos:pshort_model.48 pmos level=54 version=4.5 a0=-9.3504500e+00 a1=0.0000000e+00
+  a2=-1.1255600e+00 acde=8.0000000e-01 acnqsmod=0 af=1.0000000e+00 agidl=-5.8922300e-08
+  ags=3.8240010e+00 aigbacc=4.3000000e-01 aigbinv=3.5000000e-01 aigc=4.3000000e-01 aigsd=4.3000000e-01
+  alpha0=1.0000000e-10 alpha1=1.0000000e-10 at=-6.2641600e+05 b0=8.1745862e-07 b1=-9.6994700e-08
+  beta0=1.2338012e+01 bgidl=1.0000000e+09 bigbacc=5.4000000e-02 bigbinv=3.0000000e-02 bigc=5.4000000e-02
+  bigsd=5.4000000e-02 binunit=2 bvs=1.2690000e+01 capmod=2 cdsc=1.3000000e-04
+  cdscb=7.8000000e-04 cdscd=0.0000000e+00 cf=1.2000000e-11 cgbo=0.0000000e+00 cgdl=9.5482717e-12
+  cgdo=5.2489250e-11 cgidl=3.0000000e+02 cgsl=9.5482717e-12 cgso=5.2489250e-11 cigbacc=7.5000000e-02
+  cigbinv=6.0000000e-03 cigc=7.5000000e-02 cigsd=7.5000000e-02 cit=1.0000000e-05 cjs=7.4080000e-04
+  cjswgs=2.4005590e-10 cjsws=9.9261418e-11 ckappas=6.0000000e-01 clc=1.0000000e-07 cle=6.0000000e-01
+  delta=1.0000000e-02 diomod=1 dlc=-3.0000000e-09 dlcig=0.0000000e+00 dmcg=0.0000000e+00
+  dmcgt=0.0000000e+00 dmdg=0.0000000e+00 drout=-6.7091100e-01 dsub=2.3619372e-01 dvt0=4.4955000e+00
+  dvt0w=-4.9772000e+00 dvt1=2.9400000e-01 dvt1w=1.1472000e+06 dvt2=1.5000000e-02 dvt2w=-8.9600000e-03
+  dvtp0=0.0000000e+00 dvtp1=0.0000000e+00 dwb=-1.7864000e-08 dwc=0.0000000e+00 dwg=-5.7220000e-09
+  ef=1.0000000e+00 egidl=1.0000000e-01 eigbinv=1.1000000e+00 em=4.1000000e+07 epsrox=3.9000000e+00
+  eta0=-5.0949900e-01 etab=1.1841860e+00 eu=1.6700000e+00 fnoimod=1 fprout=0.0000000e+00
+  gbmin=1.0000000e-12 geomod=0 igbmod=0 igcmod=0 ijthsfwd=1.0000000e-01
+  ijthsrev=1.0000000e-01 jss=2.1483000e-05 jsws=8.0400000e-10 k1=2.8179335e+00 k2=-1.1519700e+00
+  k3=-1.5845000e+01 k3b=2.0000000e+00 keta=-1.1801000e+00 kf=0.0000000e+00 kt1=-7.0402100e-01
+  kt1l=0.0000000e+00 kt2=-1.2000000e-01 ku0=4.5000000e-08 kvsat=5.0000000e-01 kvth0=3.2900000e-08
+  la0=1.6541178e-06 la2=4.8571381e-07 lagidl=1.0558008e-14 lambda=0.0000000e+00 lat=1.1879290e-01
+  lb0=-9.7655600e-14 lb1=1.7646735e-14 lbeta0=-1.3516500e-06 lc=5.0000000e-09 ldrout=3.4752951e-07
+  ldsub=4.2372328e-09 leta0=1.7963657e-07 letab=-2.0126600e-07 lint=-1.3994000e-08 lintnoi=-2.0000000e-07
+  lk1=-1.7487000e-07 lk2=1.2548818e-07 lketa=1.8487815e-07 lku0=0.0000000e+00 lkvth0=0.0000000e+00
+  ll=0.0000000e+00 llc=0.0000000e+00 lln=1.0000000e+00 llodku0=0.0000000e+00 llodvth=0.0000000e+00
+  lmax=1.8000000e-07 lmin=1.5000000e-07 lnfactor=-2.1031200e-06 lodeta0=1.0000000e+00 lodk2=1.0000000e+00
+  lp=1.0000000e+00 lpclm=-6.2149900e-07 lpdiblc1=-5.7296800e-07 lpdiblc2=-1.3481700e-08 lpdiblcb=5.4141867e-10
+  lpe0=0.0000000e+00 lpeb=0.0000000e+00 lpscbe1=1.1409406e+01 lpscbe2=-2.7303200e-14 lu0=2.0279180e-11
+  lua=9.4615652e-17 lua1=1.3541259e-16 lub=-3.1190900e-25 luc=-5.7848700e-19 luc1=-5.2641200e-17
+  lute=1.1544125e-07 lvoff=3.6649520e-08 lvsat=-2.2434100e-02 lvth0=4.7846552e-08 lw=0.0000000e+00
+  lwc=0.0000000e+00 lwl=0.0000000e+00 lwlc=0.0000000e+00 lwn=1.0000000e+00 minv=0.0000000e+00
+  mjs=3.4629000e-01 mjswgs=9.2740000e-01 mjsws=2.9781000e-01 mobmod=0 moin=1.8130000e+01
+  ndep=1.7000000e+17 nfactor=1.4389712e+01 ngate=1.0000000e+23 ngcon=1.0000000e+00 nigbacc=1.0000000e+00
+  nigbinv=3.0000000e+00 nigc=1.0000000e+00 njs=1.3632000e+00 noff=3.9000000e+00 noia=1.5000000e+42
+  noib=0.0000000e+00 noic=0.0000000e+00 nsd=1.0000000e+20 ntnoi=1.0000000e+00 ntox=1.0000000e+00
+  pa0=-8.8560200e-13 pa2=-2.6004700e-13 pagidl=-5.6526800e-21 pat=-6.3600800e-08 pb0=5.2284049e-20
+  pb1=-9.4479200e-21 pbeta0=7.2366497e-13 pbs=6.5870000e-01 pbswgs=1.4338000e+00 pbsws=7.4180000e-01
+  pclm=3.5792538e+00 pdiblc1=2.9599529e+00 pdiblc2=6.9242353e-02 pdiblcb=-3.1146500e-01 pdits=0.0000000e+00
+  pditsd=0.0000000e+00 pditsl=0.0000000e+00 pdrout=-1.8606500e-13 pdsub=-2.2685800e-15 permod=1
+  peta0=-9.6176000e-14 petab=1.0775606e-13 phin=0.0000000e+00 pigcd=1.0000000e+00 pk1=9.3624172e-14
+  pk2=-6.7185400e-14 pketa=-9.8982300e-14 pku0=0.0000000e+00 pkvth0=0.0000000e+00 pnfactor=1.1259965e-12
+  poxedge=1.0000000e+00 ppclm=3.3274566e-13 ppdiblc1=3.0676276e-13 ppdiblc2=7.2180065e-15 ppdiblcb=-2.8987100e-16
+  ppscbe1=-6.1085100e-06 ppscbe2=1.4617914e-20 prt=0.0000000e+00 prwb=-3.2348000e-01 prwg=1.3760000e-01
+  pscbe1=7.4514392e+08 pscbe2=1.6687498e-07 pu0=-1.0857300e-17 pua=-5.0656500e-23 pua1=-7.2498800e-23
+  pub=1.6699354e-31 puc=3.0971757e-25 puc1=2.8183694e-23 pute=-6.1806300e-14 pvag=0.0000000e+00
+  pvoff=-1.9621900e-14 pvsat=1.2011033e-08 pvth0=-2.5616700e-14 rbdb=5.0000000e+01 rbodymod=1
+  rbpb=5.0000000e+01 rbpd=5.0000000e+01 rbps=5.0000000e+01 rbsb=5.0000000e+01 rdsmod=0
+  rdsw=5.4788000e+02 rdswmin=0.0000000e+00 rdw=0.0000000e+00 rdwmin=0.0000000e+00 rgatemod=0
+  rnoia=6.9000000e-01 rnoib=3.4000000e-01 rsh=2.3485238e+03 rshg=1.0000000e-01 rsw=0.0000000e+00
+  rswmin=0.0000000e+00 saref=1.1000000e-06 sbref=1.1000000e-06 steta0=0.0000000e+00 stk2=0.0000000e+00
+  tcj=1.2407000e-03 tcjsw=3.7357000e-04 tcjswg=2.0000000e-12 tempmod=0 tku0=0.0000000e+00
+  tnoia=2.5000000e+07 tnoib=0.0000000e+00 tnoimod=1 tnom=3.0000000e+01 toxe=4.2300000e-09
+  toxm=4.2300000e-09 toxref=4.2300000e-09 tpb=2.0386000e-03 tpbsw=1.2460000e-03 tpbswg=0.0000000e+00
+  trnqsmod=0 tvfbsdoff=0.0000000e+00 tvoff=0.0000000e+00 u0=1.7713437e-03 ua=-3.2145900e-09
+  ua1=-5.4458800e-10 ub=4.2379917e-18 ub1=3.7264000e-19 uc=3.1968560e-12 uc1=2.7866935e-10
+  ud=0.0000000e+00 up=0.0000000e+00 ute=-1.4306600e-01 vbm=-3.0000000e+00 vfbcv=-1.4469000e-01
+  vfbsdoff=0.0000000e+00 voff=-5.9862200e-01 voffcv=-1.0701000e-01 voffl=0.0000000e+00 vsat=1.2245792e+05
+  vth0=-1.3044100e+00 vtl=0.0000000e+00 w0=0.0000000e+00 wa0=5.3517770e-06 wa2=1.0309294e-06
+  wagidl=3.2356857e-14 wags=-1.0434800e-06 wat=3.6678166e-01 wb0=-4.2323400e-13 wb1=5.3280650e-14
+  wbeta0=-2.4509100e-06 wdrout=8.9459290e-07 wdsub=1.2745698e-08 weta0=3.6896005e-07 wetab=-6.4594700e-07
+  wint=7.3039000e-09 wk1=-8.5343000e-07 wk2=4.6619514e-07 wketa=6.1843276e-07 wkt1=3.3007357e-08
+  wku0=2.5000000e-07 wkvth0=2.0000000e-07 wl=0.0000000e+00 wlc=0.0000000e+00 wln=1.0000000e+00
+  wlod=0.0000000e+00 wlodku0=1.0000000e+00 wlodvth=1.0000000e+00 wmax=5.5000000e-07 wmin=4.2000000e-07
+  wnfactor=-6.1501100e-06 wpclm=-1.5856900e-06 wpdiblc1=-1.4894900e-06 wpdiblc2=-3.5125900e-08 wpdiblcb=1.2660162e-07
+  wpscbe1=2.9369515e+01 wpscbe2=-8.4309900e-14 wr=1.0000000e+00 wu0=4.4892436e-10 wua=3.6543996e-16
+  wua1=3.7251385e-16 wub=-9.8401300e-25 wuc=-1.6270100e-18 wuc1=-1.3601400e-16 wute=7.6596434e-08
+  wvoff=1.1478208e-07 wvsat=-1.5425100e-02 wvth0=1.5400777e-07 ww=0.0000000e+00 wwc=0.0000000e+00
+  wwl=0.0000000e+00 wwlc=0.0000000e+00 wwn=1.0000000e+00 xgl=0.0000000e+00 xgw=0.0000000e+00
+  xj=1.5000000e-07 xjbvs=1.0000000e+00 xl=0.0000000e+00 xn=3.0000000e+00 xpart=0.0000000e+00
+  xrcrg1=1.2000000e+01 xrcrg2=1.0000000e+00 xtis=5.2000000e+00 xw=0.0000000e+00
.model mcl1d c tc1=0.0000000e+00 tc2=0.0000000e+00 tref=2.5000000e+01 w=1.4000000e-07
.model mcl1f c
+ tc1=0.0000000e+00 tc2=0.0000000e+00 tref=2.5000000e+01 w=1.4000000e-07
.model mcl1p1 c tc1=0.0000000e+00
+ tc2=0.0000000e+00 tref=2.5000000e+01 w=1.4000000e-07
.model mcm1d c tc1=0.0000000e+00 tc2=0.0000000e+00
+ tref=2.5000000e+01 w=1.4000000e-07
.model mcm1f c tc1=0.0000000e+00 tc2=0.0000000e+00 tref=2.5000000e+01
+ w=1.4000000e-07
.model mcm1l1 c tc1=0.0000000e+00 tc2=0.0000000e+00 tref=2.5000000e+01 w=1.4000000e-07
.model mcm1p1 c
+ tc1=0.0000000e+00 tc2=0.0000000e+00 tref=2.5000000e+01 w=1.4000000e-07
.model mcm2d c tc1=0.0000000e+00
+ tc2=0.0000000e+00 tref=2.5000000e+01 w=1.4000000e-07
.model mcm2f c tc1=0.0000000e+00 tc2=0.0000000e+00
+ tref=2.5000000e+01 w=1.4000000e-07
.model mcm2l1 c tc1=0.0000000e+00 tc2=0.0000000e+00 tref=2.5000000e+01
+ w=1.4000000e-07
.model mcm2m1 c tc1=0.0000000e+00 tc2=0.0000000e+00 tref=2.5000000e+01 w=1.4000000e-07
.model mcm2p1 c
+ tc1=0.0000000e+00 tc2=0.0000000e+00 tref=2.5000000e+01 w=1.4000000e-07
.model mcm3d c tc1=0.0000000e+00
+ tc2=0.0000000e+00 tref=2.5000000e+01 w=3.0000000e-07
.model mcm3f c tc1=0.0000000e+00 tc2=0.0000000e+00
+ tref=2.5000000e+01 w=3.0000000e-07
.model mcm3l1 c tc1=0.0000000e+00 tc2=0.0000000e+00 tref=2.5000000e+01
+ w=3.0000000e-07
.model mcm3m1 c tc1=0.0000000e+00 tc2=0.0000000e+00 tref=2.5000000e+01 w=3.0000000e-07
.model mcm3m2 c
+ tc1=0.0000000e+00 tc2=0.0000000e+00 tref=2.5000000e+01 w=3.0000000e-07
.model mcm3p1 c tc1=0.0000000e+00
+ tc2=0.0000000e+00 tref=2.5000000e+01 w=3.0000000e-07
.model mcm4d c tc1=0.0000000e+00 tc2=0.0000000e+00
+ tref=2.5000000e+01 w=3.0000000e-07
.model mcm4f c tc1=0.0000000e+00 tc2=0.0000000e+00 tref=2.5000000e+01
+ w=3.0000000e-07
.model mcm4l1 c tc1=0.0000000e+00 tc2=0.0000000e+00 tref=2.5000000e+01 w=3.0000000e-07
.model mcm4m1 c
+ tc1=0.0000000e+00 tc2=0.0000000e+00 tref=2.5000000e+01 w=3.0000000e-07
.model mcm4m2 c tc1=0.0000000e+00
+ tc2=0.0000000e+00 tref=2.5000000e+01 w=3.0000000e-07
.model mcm4m3 c tc1=0.0000000e+00 tc2=0.0000000e+00
+ tref=2.5000000e+01 w=3.0000000e-07
.model mcm4p1 c tc1=0.0000000e+00 tc2=0.0000000e+00 tref=2.5000000e+01
+ w=3.0000000e-07
.model mcm5d c tc1=0.0000000e+00 tc2=0.0000000e+00 tref=2.5000000e+01 w=8.0000000e-07
.model mcm5f c
+ tc1=0.0000000e+00 tc2=0.0000000e+00 tref=2.5000000e+01 w=8.0000000e-07
.model mcm5l1 c tc1=0.0000000e+00
+ tc2=0.0000000e+00 tref=2.5000000e+01 w=8.0000000e-07
.model mcm5m1 c tc1=0.0000000e+00 tc2=0.0000000e+00
+ tref=2.5000000e+01 w=8.0000000e-07
.model mcm5m2 c tc1=0.0000000e+00 tc2=0.0000000e+00 tref=2.5000000e+01
+ w=8.0000000e-07
.model mcm5m3 c tc1=0.0000000e+00 tc2=0.0000000e+00 tref=2.5000000e+01 w=8.0000000e-07
.model mcm5m4 c
+ tc1=0.0000000e+00 tc2=0.0000000e+00 tref=2.5000000e+01 w=8.0000000e-07
.model mcm5p1 c tc1=0.0000000e+00
+ tc2=0.0000000e+00 tref=2.5000000e+01 w=8.0000000e-07
.model mcp1f c tc1=0.0000000e+00 tc2=0.0000000e+00
+ tref=2.5000000e+01 w=1.5000000e-07
.model mcrdld c tc1=0.0000000e+00 tc2=0.0000000e+00 tref=2.5000000e+01
+ w=1.0000000e-05
.model mcrdlf c tc1=0.0000000e+00 tc2=0.0000000e+00 tref=2.5000000e+01 w=1.0000000e-05
.model mcrdll1 c
+ tc1=0.0000000e+00 tc2=0.0000000e+00 tref=2.5000000e+01 w=1.0000000e-05
.model mcrdlm1 c tc1=0.0000000e+00
+ tc2=0.0000000e+00 tref=2.5000000e+01 w=1.0000000e-05
.model mcrdlm2 c tc1=0.0000000e+00 tc2=0.0000000e+00
+ tref=2.5000000e+01 w=1.0000000e-05
.model mcrdlm3 c tc1=0.0000000e+00 tc2=0.0000000e+00 tref=2.5000000e+01
+ w=1.0000000e-05
.model mcrdlm4 c tc1=0.0000000e+00 tc2=0.0000000e+00 tref=2.5000000e+01 w=1.0000000e-05
.model mcrdlm5 c
+ tc1=0.0000000e+00 tc2=0.0000000e+00 tref=2.5000000e+01 w=1.0000000e-05
.model mcrdlp1 c tc1=0.0000000e+00
+ tc2=0.0000000e+00 tref=2.5000000e+01 w=1.0000000e-05
.model mrcl1 r tc1r=1.0670000e-03 tc2r=-5.3240000e-06
+ tref=3.0000000e+01
.model mrcn r tc1r=2.2540000e-04 tc2r=-1.0380000e-06 tref=3.0000000e+01
.model mrcp r tc1r=5.2500000e-04
+ tc2r=3.5440000e-06 tref=3.0000000e+01
.model mrcp1 r tc1r=1.2490000e-03 tc2r=-6.6470000e-06 tref=3.0000000e+01
.model mrcrdlcon r
+ tc1r=3.9300000e-03 tc2r=0.0000000e+00 tref=2.5000000e+01
.model mrcvia r tc1r=1.0810000e-03 tc2r=-1.9030000e-07
+ tref=3.0000000e+01
.model mrcvia2 r tc1r=2.3660000e-03 tc2r=-1.0250000e-05 tref=3.0000000e+01
.model mrcvia3 r tc1r=2.3660000e-03
+ tc2r=-1.0250000e-05 tref=3.0000000e+01
.model mrcvia4 r tc1r=1.7700000e-03 tc2r=-1.6000000e-07 tref=3.0000000e+01
.model mrrdl r
+ tc1r=3.9300000e-03 tc2r=0.0000000e+00 tref=2.5000000e+01
.model rbody_model r tnom=3.0000000e+01
.model resbody r tc2=2.7000000e-06
+ tnom=2.5000000e+01
.model reshead r tc1=-4.3000000e-04 tc2=-1.3000000e-05 tnom=2.5000000e+01
.model rhead_model r
.model rli r dw=-8.5000000e-09
+ rsh=1.2300000e+01 tc1r=6.0450000e-04 tc2r=-3.6930000e-07 tref=3.0000000e+01
.model rm1 r dw=1.9500000e-08
+ rsh=1.2400000e-01 tc1r=3.1790000e-03 tc2r=3.0940000e-07 tref=3.0000000e+01
.model rm2 r dw=1.9500000e-08
+ rsh=1.2400000e-01 tc1r=3.1610000e-03 tc2r=-7.2720000e-07 tref=3.0000000e+01
.model rm3 r dw=1.2500000e-08
+ rsh=4.6000000e-02 tc1r=3.4240000e-03 tc2r=-7.7390000e-07 tref=3.0000000e+01
.model rm4 r dw=1.2500000e-08
+ rsh=4.6000000e-02 tc1r=3.4240000e-03 tc2r=-7.7390000e-07 tref=3.0000000e+01
.model rm5 r dw=4.5000000e-08
+ rsh=2.7500000e-02 tc1r=3.5000000e-03 tc2r=-7.5000000e-07 tref=3.0000000e+01
.model rndiff r dw=-8.5000000e-09
+ rsh=1.2000000e+02 tc1r=1.4220000e-03 tc2r=6.5690000e-07 tref=3.0000000e+01
.model rndiff_v5 r dw=-8.5000000e-09
+ rsh=1.1400000e+02 tc1r=1.4050000e-03 tc2r=4.2330000e-07 tref=3.0000000e+01
.model rnwell r dw=0.0000000e+00
+ rsh=1.7000000e+03 tc1r=1.4830000e-03 tc2r=7.8240000e-06 tref=3.0000000e+01
.model rpdiff r dw=-2.0000000e-09
+ rsh=1.9700000e+02 tc1r=1.2590000e-03 tc2r=2.2040000e-06 tref=3.0000000e+01
.model rpdiff_v5 r dw=-2.0000000e-09
+ rsh=1.9109000e+02 tc1r=1.3690000e-03 tc2r=1.4760000e-06 tref=3.0000000e+01

* end of model section

.temp 25

.param Y_cap=1.0000000e-20
C27_0 Y 0 Y_cap

.nodeset v(Y) 1.8

.nodeset v(N_A_M0_noxref_g) 0.9

.option numdgt=6 measdgt=6 ingold=2 save=nooutput gmin=1e-14 pivtol=1e-15
.tran 1.00e-12 1e-12

.end
