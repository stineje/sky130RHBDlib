************************************************************************
* auCdl Netlist
************************************************************************
.OPTION SCALE=1

.SUBCKT pad_bond pin0
.ENDS

.SUBCKT pad_microprobe pin0
.ENDS

.SUBCKT pad_probe pin0
.ENDS

.SUBCKT nmos_de_iso_v20 src gate drn b sub sb=0 sa=0 l=0 w=0
.ENDS nmos_de_iso_v20
