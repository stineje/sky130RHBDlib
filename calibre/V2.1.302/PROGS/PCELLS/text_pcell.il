pcDefinePCell(
list(ddGetObj("S130") "text_pcell" "layout")
(
  (text string "abc")
  (halo_distance float 1.000000e+00)
  (text_mag float 1.000000e+00)
  (text_layer string "met1")
)
    prog((_pcParameters text_layer text halo_distance text_mag
	)
	if(!pcCellView
	    return()
	)
	(_pcParameters = (pcCellView~>parameters))
	(text_layer = (_pcParameters~>text_layer))
	if(!stringp(text_layer) then
	    (text_layer = "y1")
	)
	(text = (_pcParameters~>text))
	if(!stringp(text) then
	    (text = "test")
	)
	(halo_distance = (_pcParameters~>halo_distance))
	if(!halo_distance then
	    (halo_distance = 1.0)
	)
	if(!floatp(halo_distance) then
	    (halo_distance = 1.0)
	)
	(text_mag = (_pcParameters~>text_mag))
	if(!text_mag then
	    (text_mag = 1.0)
	)
	if(!floatp(text_mag) then
	    (text_mag = 1.0)
	)
	let((text_mag pc_mag pc_mag0 pc_mag0offset text
		text1 text1offset pc_layer pc_layer2 pc_layer2offset
		pcMember pcStretchGroup stretchOffsetX stretchOffsetY pcLib
		pcMaster pcInst pcTerm pcPin pcPinName
		pcNet pcTermNet pcNetName pcTermNetName pcMosaicInst
		tpcParameters pcParamProp pcStep pcStepX pcStepY
		pcRepeat pcRepeatX pcRepeatY pcIndexX pcIndexY
		pcLayer pcPurpose pcLabelText pcLabelHeight pcPropText
		pcParamText pcCoords pcPathWidth pcPolygonMargin halo_distance
		haloBox
	    )
	    (pcLib = (pcCellView~>lib))
	    (pcParameters = ((pcCellView~>parameters)~>value))
	    (pcParamProp = car(exists(prop pcParameters
			((prop~>name) == "halo_distance")
		    )
		))
	    (halo_distance = (pcParamProp~>value))
	    (pcParamProp = car(exists(prop pcParameters
			((prop~>name) == "text_mag")
		    )
		))
	    (text_mag = (pcParamProp~>value))
	    if(((pcParamProp~>valueType) == "boolean")
		(text_mag = (text_mag == "TRUE"))
	    )
	    (pcParamProp = car(exists(prop pcParameters
			((prop~>name) == "text")
		    )
		))
	    (text = (pcParamProp~>value))
	    if(((pcParamProp~>valueType) == "boolean")
		(text = (text == "TRUE"))
	    )
	    (pcParamProp = car(exists(prop pcParameters
			((prop~>name) == "text_layer")
		    )
		))
	    (text_layer = (pcParamProp~>value))
	    if(((pcParamProp~>valueType) == "boolean")
		(text_layer = (text_layer == "TRUE"))
	    )
	    (pc_mag = text_mag)
	    if((pc_mag == nil)
		(pc_mag = 1.0)
	    )
	    (techFile = techGetTechFile(pcCellView))
	    (pc_layer = text_layer)
	    if((pc_layer == nil)
		(pc_layer = "y1")
	    )
	    if((text == nil)
		(text = "test")
	    )
	    (pc_mag0 = pc_mag)
	    (text1 = sprintf(text "%s" text))
	    (text1 = lowerCase(text1))
	    (text = lowerCase(text))
	    (pc_layer2 = pc_layer)
	    if((pc_mag0 == nil)
		(pc_mag0 = 0.0)
	    )
	    (pc_mag0offset = (pc_mag0 - 1.1))
	    (pcPropText = errset(text))
	    if(pcPropText then
		(pcPropText = pcExprToProp(car(pcPropText)))
		dbReplaceProp(pcCellView "text"
		    car(pcPropText)
		    cadr(pcPropText)
		)
	    )
	    (pcPropText = errset(pc_layer))
	    if(pcPropText then
		(pcPropText = pcExprToProp(car(pcPropText)))
		dbReplaceProp(pcCellView "text_layer"
		    car(pcPropText)
		    cadr(pcPropText)
		)
	    )
	    (pcPropText = errset(pc_mag))
	    if(pcPropText then
		(pcPropText = pcExprToProp(car(pcPropText)))
		dbReplaceProp(pcCellView "text_mag"
		    car(pcPropText)
		    cadr(pcPropText)
		)
	    )
	    (text_string = text)
	    (magAmount = pc_mag)
	    (layerField = pc_layer)
	    (pcLayer = layerField)
	    (pcPurpose = "drawing")
	    if((techGetLP(techFile
			list(pcLayer pcPurpose)
		    ) == nil) then
		printf("Layer: %L Purpose: %L is not a vaild layer/purpose pair in this technology" pcLayer pcPurpose) else
		(dspace = 2)
		(sspace = 5.0)
		(crds = (0:0))
		(pntr = car(crds))
		(pntr1 = cadr(crds))
		(mtextString = parseString(text_string ""))
		(characterWidth = "norm")
		foreach(character mtextString
		    case(character
			("m"
			    (characterWidth = "wide")
			)
			("w"
			    (characterWidth = "wide")
			)
			(("i" "'" ":" ";" "("
				")" "!" "." "[" "]"
				"1" "\""
			    )
			    (characterWidth = "narrow")
			)
			(t
			    (characterWidth = "norm")
			)
		    )
		    (coords_listAMS1 = list((0.8:0.6)
			    (0.8:1.0)
			    (0.4:1.0)
			    (0.4:1.4)
			    (0.6:1.6)
			    (0.8:1.6)
			    (0.8:2.0)
			    (0.4:2.0)
			    (0.0:1.6)
			    (0.0:0.0)
			    (0.4:0.0)
			    (0.4:0.6)
			    (0.8:0.6)
			))
		    (coords_listAMS2 = list((0.8:0.6)
			    (1.2:0.6)
			    (1.2:0.0)
			    (1.6:0.0)
			    (1.6:1.6)
			    (1.2:2.0)
			    (0.8:2.0)
			    (0.8:1.6)
			    (1.0:1.6)
			    (1.2:1.4)
			    (1.2:1.0)
			    (0.8:1.0)
			    (0.8:0.6)
			))
		    (coords_listBMS1 = list((0.8:0.0)
			    (0.8:0.4)
			    (0.4:0.4)
			    (0.4:0.8)
			    (0.8:0.8)
			    (0.8:1.2)
			    (0.4:1.2)
			    (0.4:1.6)
			    (0.8:1.6)
			    (0.8:2.0)
			    (0.0:2.0)
			    (0.0:0.0)
			    (0.8:0.0)
			))
		    (coords_listBMS2 = list((0.8:0.0)
			    (0.8:0.4)
			    (1.1:0.4)
			    (1.2:0.5)
			    (1.2:0.7)
			    (1.1:0.8)
			    (0.8:0.8)
			    (0.8:1.2)
			    (1.1:1.2)
			    (1.2:1.3)
			    (1.2:1.5)
			    (1.1:1.6)
			    (0.8:1.6)
			    (0.8:2.0)
			    (1.3:2.0)
			    (1.6:1.7)
			    (1.6:1.2)
			    (1.4:1.0)
			    (1.6:0.8)
			    (1.6:0.3)
			    (1.3:0.0)
			    (0.8:0.0)
			))
		    (coords_listCMS = list((0.0:0.4)
			    (0.4:0.0)
			    (1.2:0.0)
			    (1.6:0.4)
			    (1.6:0.6)
			    (1.2:0.6)
			    (1.0:0.4)
			    (0.6:0.4)
			    (0.4:0.6)
			    (0.4:1.4)
			    (0.6:1.6)
			    (1.0:1.6)
			    (1.2:1.4)
			    (1.6:1.4)
			    (1.6:1.6)
			    (1.2:2.0)
			    (0.4:2.0)
			    (0.0:1.6)
			    (0.0:0.4)
			))
		    (coords_listDMS = list((0.8:0.0)
			    (0.8:0.4)
			    (0.4:0.4)
			    (0.4:1.6)
			    (0.8:1.6)
			    (0.8:2.0)
			    (0.0:2.0)
			    (0.0:0.0)
			    (0.8:0.0)
			))
		    (coords_listDMS1 = list((0.8:0.0)
			    (1.2:0.0)
			    (1.6:0.4)
			    (1.6:1.6)
			    (1.2:2.0)
			    (0.8:2.0)
			    (0.8:1.6)
			    (1.0:1.6)
			    (1.2:1.4)
			    (1.2:0.6)
			    (1.0:0.4)
			    (0.8:0.4)
			    (0.8:0.0)
			))
		    (coords_listEMS = list((0.0:0.0)
			    (1.6:0.0)
			    (1.6:0.4)
			    (0.4:0.4)
			    (0.4:0.8)
			    (1.2:0.8)
			    (1.2:1.2)
			    (0.4:1.2)
			    (0.4:1.6)
			    (1.6:1.6)
			    (1.6:2.0)
			    (0.0:2.0)
			    (0.0:0.0)
			))
		    (coords_listFMS = list((0.0:0.0)
			    (0.4:0.0)
			    (0.4:0.8)
			    (1.2:0.8)
			    (1.2:1.2)
			    (0.4:1.2)
			    (0.4:1.6)
			    (1.6:1.6)
			    (1.6:2.0)
			    (0.0:2.0)
			    (0.0:0.0)
			))
		    (coords_listGMS = list((0.4:0.0)
			    (1.2:0.0)
			    (1.6:0.4)
			    (1.6:1.0)
			    (0.8:1.0)
			    (0.8:0.7)
			    (1.2:0.7)
			    (1.2:0.6)
			    (1.0:0.4)
			    (0.6:0.4)
			    (0.4:0.6)
			    (0.4:1.4)
			    (0.6:1.6)
			    (1.0:1.6)
			    (1.2:1.4)
			    (1.6:1.4)
			    (1.6:1.6)
			    (1.2:2.0)
			    (0.4:2.0)
			    (0.0:1.6)
			    (0.0:0.4)
			    (0.4:0.0)
			))
		    (coords_listHMS = list((0.0:0.0)
			    (0.4:0.0)
			    (0.4:0.8)
			    (1.2:0.8)
			    (1.2:0.0)
			    (1.6:0.0)
			    (1.6:2.0)
			    (1.2:2.0)
			    (1.2:1.2)
			    (0.4:1.2)
			    (0.4:2.0)
			    (0.0:2.0)
			    (0.0:0.0)
			))
		    (coords_listIMS = list((0.0:0.0)
			    (0.8:0.0)
			    (0.8:0.4)
			    (0.6:0.4)
			    (0.6:1.6)
			    (0.8:1.6)
			    (0.8:2.0)
			    (0.0:2.0)
			    (0.0:1.6)
			    (0.2:1.6)
			    (0.2:0.4)
			    (0.0:0.4)
			    (0.0:0.0)
			))
		    (coords_listJMS = list((0.4:0.0)
			    (1.2:0.0)
			    (1.6:0.4)
			    (1.6:2.0)
			    (1.2:2.0)
			    (1.2:0.6)
			    (1.0:0.4)
			    (0.6:0.4)
			    (0.4:0.6)
			    (0.4:0.7)
			    (0.0:0.7)
			    (0.0:0.4)
			    (0.4:0.0)
			))
		    (coords_listKMS = list((0.0:0.0)
			    (0.4:0.0)
			    (0.4:0.8)
			    (0.6:0.8)
			    (1.2:0.2)
			    (1.2:0.0)
			    (1.6:0.0)
			    (1.6:0.4)
			    (1.0:1.0)
			    (1.6:1.6)
			    (1.6:2.0)
			    (1.2:2.0)
			    (1.2:1.8)
			    (0.6:1.2)
			    (0.4:1.2)
			    (0.4:2.0)
			    (0.0:2.0)
			    (0.0:0.0)
			))
		    (coords_listLMS = list((0.0:0.0)
			    (1.6:0.0)
			    (1.6:0.4)
			    (0.4:0.4)
			    (0.4:2.0)
			    (0.0:2.0)
			    (0.0:0.0)
			))
		    (coords_listMMS = list((0.0:0.0)
			    (0.4:0.0)
			    (0.4:1.2)
			    (0.6:1.2)
			    (1.0:0.8)
			    (1.4:1.2)
			    (1.6:1.2)
			    (1.6:0.0)
			    (2.0:0.0)
			    (2.0:2.0)
			    (1.6:2.0)
			    (1.0:1.4)
			    (0.4:2.0)
			    (0.0:2.0)
			    (0.0:0.0)
			))
		    (coords_listNMS = list((0.0:0.0)
			    (0.4:0.0)
			    (0.4:1.0)
			    (0.5:1.0)
			    (1.5:0.0)
			    (1.6:0.0)
			    (1.6:2.0)
			    (1.2:2.0)
			    (1.2:1.0)
			    (1.1:1.0)
			    (0.1:2.0)
			    (0.0:2.0)
			    (0.0:0.0)
			))
		    (coords_listOMS = list((0.8:0.0)
			    (0.8:0.4)
			    (0.6:0.4)
			    (0.4:0.6)
			    (0.4:1.4)
			    (0.6:1.6)
			    (0.8:1.6)
			    (0.8:2.0)
			    (0.4:2.0)
			    (0.0:1.6)
			    (0.0:0.4)
			    (0.4:0.0)
			    (0.8:0.0)
			))
		    (coords_listOMS1 = list((0.8:0.0)
			    (1.2:0.0)
			    (1.6:0.4)
			    (1.6:1.6)
			    (1.2:2.0)
			    (0.8:2.0)
			    (0.8:1.6)
			    (1.0:1.6)
			    (1.2:1.4)
			    (1.2:0.6)
			    (1.0:0.4)
			    (0.8:0.4)
			    (0.8:0.0)
			))
		    (coords_listPMS = list((0.8:0.8)
			    (0.8:1.2)
			    (0.4:1.2)
			    (0.4:1.6)
			    (0.8:1.6)
			    (0.8:2.0)
			    (0.0:2.0)
			    (0.0:0.0)
			    (0.4:0.0)
			    (0.4:0.8)
			    (0.8:0.8)
			))
		    (coords_listPMS1 = list((0.8:0.8)
			    (1.3:0.8)
			    (1.6:1.1)
			    (1.6:1.7)
			    (1.3:2.0)
			    (0.8:2.0)
			    (0.8:1.6)
			    (1.1:1.6)
			    (1.2:1.5)
			    (1.2:1.3)
			    (1.1:1.2)
			    (0.8:1.2)
			    (0.8:0.8)
			))
		    (coords_listQMS = list((0.8:0.0)
			    (0.8:0.4)
			    (0.6:0.4)
			    (0.4:0.6)
			    (0.4:1.4)
			    (0.6:1.6)
			    (0.8:1.6)
			    (0.8:2.0)
			    (0.4:2.0)
			    (0.0:1.6)
			    (0.0:0.4)
			    (0.4:0.0)
			    (0.8:0.0)
			))
		    (coords_listQMS1 = list((0.8:0.0)
			    (1.2:0.0)
			    (1.4:-0.2)
			    (1.8:0.2)
			    (1.6:0.4)
			    (1.6:1.6)
			    (1.2:2.0)
			    (0.8:2.0)
			    (0.8:1.6)
			    (1.0:1.6)
			    (1.2:1.4)
			    (1.2:0.6)
			    (1.0:0.4)
			    (0.8:0.4)
			    (0.8:0.0)
			))
		    (coords_listRMS = list((0.6:0.8)
			    (0.6:1.2)
			    (0.4:1.2)
			    (0.4:1.6)
			    (0.6:1.6)
			    (0.6:2.0)
			    (0.0:2.0)
			    (0.0:0.0)
			    (0.4:0.0)
			    (0.4:0.8)
			    (0.6:0.8)
			))
		    (coords_listRMS1 = list((0.6:0.8)
			    (0.8:0.8)
			    (1.2:0.4)
			    (1.2:0.0)
			    (1.6:0.0)
			    (1.6:0.5)
			    (1.3:0.8)
			    (1.6:1.1)
			    (1.6:1.7)
			    (1.3:2.0)
			    (0.6:2.0)
			    (0.6:1.6)
			    (1.1:1.6)
			    (1.2:1.5)
			    (1.2:1.3)
			    (1.1:1.2)
			    (0.6:1.2)
			    (0.6:0.8)
			))
		    (coords_listSMS = list((0.3:0.0)
			    (1.3:0.0)
			    (1.6:0.3)
			    (1.6:0.9)
			    (1.3:1.2)
			    (0.5:1.2)
			    (0.4:1.3)
			    (0.4:1.5)
			    (0.5:1.6)
			    (1.1:1.6)
			    (1.2:1.5)
			    (1.6:1.5)
			    (1.6:1.7)
			    (1.3:2.0)
			    (0.3:2.0)
			    (0.0:1.7)
			    (0.0:1.1)
			    (0.3:0.8)
			    (1.1:0.8)
			    (1.2:0.7)
			    (1.2:0.5)
			    (1.1:0.4)
			    (0.5:0.4)
			    (0.4:0.5)
			    (0.0:0.5)
			    (0.0:0.3)
			    (0.3:0.0)
			))
		    (coords_listTMS = list((0.6:0.0)
			    (1.0:0.0)
			    (1.0:1.6)
			    (1.6:1.6)
			    (1.6:2.0)
			    (0.0:2.0)
			    (0.0:1.6)
			    (0.6:1.6)
			    (0.6:0.0)
			))
		    (coords_listUMS = list((0.4:0.0)
			    (1.2:0.0)
			    (1.6:0.4)
			    (1.6:2.0)
			    (1.2:2.0)
			    (1.2:0.6)
			    (1.0:0.4)
			    (0.6:0.4)
			    (0.4:0.6)
			    (0.4:2.0)
			    (0.0:2.0)
			    (0.0:0.4)
			    (0.4:0.0)
			))
		    (coords_listVMS = list((0.7:0.0)
			    (0.9:0.0)
			    (1.6:0.7)
			    (1.6:2.0)
			    (1.2:2.0)
			    (1.2:0.9)
			    (0.8:0.5)
			    (0.4:0.9)
			    (0.4:2.0)
			    (0.0:2.0)
			    (0.0:0.7)
			    (0.7:0.0)
			))
		    (coords_listWMS = list((0.0:0.0)
			    (0.4:0.0)
			    (1.0:0.6)
			    (1.6:0.0)
			    (2.0:0.0)
			    (2.0:2.0)
			    (1.6:2.0)
			    (1.6:0.8)
			    (1.4:0.8)
			    (1.0:1.2)
			    (0.6:0.8)
			    (0.4:0.8)
			    (0.4:2.0)
			    (0.0:2.0)
			    (0.0:0.0)
			))
		    (coords_listXMS = list((0.0:0.0)
			    (0.4:0.0)
			    (0.4:0.4)
			    (0.8:0.8)
			    (1.2:0.4)
			    (1.2:0.0)
			    (1.6:0.0)
			    (1.6:0.6)
			    (1.2:1.0)
			    (1.6:1.4)
			    (1.6:2.0)
			    (1.2:2.0)
			    (1.2:1.6)
			    (0.8:1.2)
			    (0.4:1.6)
			    (0.4:2.0)
			    (0.0:2.0)
			    (0.0:1.4)
			    (0.4:1.0)
			    (0.0:0.6)
			    (0.0:0.0)
			))
		    (coords_listYMS = list((0.6:0.0)
			    (1.0:0.0)
			    (1.0:0.7)
			    (1.6:1.3)
			    (1.6:2.0)
			    (1.2:2.0)
			    (1.2:1.5)
			    (0.8:1.1)
			    (0.4:1.5)
			    (0.4:2.0)
			    (0.0:2.0)
			    (0.0:1.3)
			    (0.6:0.7)
			    (0.6:0.0)
			))
		    (coords_listZMS = list((0.0:0.0)
			    (1.6:0.0)
			    (1.6:0.4)
			    (0.6:0.4)
			    (0.6:0.5)
			    (1.6:1.5)
			    (1.6:2.0)
			    (0.0:2.0)
			    (0.0:1.6)
			    (1.0:1.6)
			    (1.0:1.5)
			    (0.0:0.5)
			    (0.0:0.0)
			))
		    (coords_listMS0 = list((0.8:0.0)
			    (0.8:0.4)
			    (0.6:0.4)
			    (0.4:0.6)
			    (0.4:1.4)
			    (0.6:1.6)
			    (0.8:1.6)
			    (0.8:2.0)
			    (0.4:2.0)
			    (0.0:1.6)
			    (0.0:0.4)
			    (0.4:0.0)
			    (0.8:0.0)
			))
		    (coords_listMS01 = list((0.8:0.0)
			    (1.2:0.0)
			    (1.6:0.4)
			    (1.6:1.6)
			    (1.2:2.0)
			    (0.8:2.0)
			    (0.8:1.6)
			    (1.0:1.6)
			    (1.2:1.4)
			    (1.2:0.6)
			    (1.0:0.4)
			    (0.8:0.4)
			    (0.8:0.0)
			))
		    (coords_listMS02 = list((0.7:0.7)
			    (1.1:1.1)
			    (0.9:1.3)
			    (0.5:0.9)
			    (0.7:0.7)
			))
		    (coords_listMS1 = list((0.0:0.0)
			    (0.8:0.0)
			    (0.8:0.4)
			    (0.6:0.4)
			    (0.6:2.0)
			    (0.2:2.0)
			    (0.0:1.8)
			    (0.0:1.6)
			    (0.2:1.6)
			    (0.2:0.4)
			    (0.0:0.4)
			    (0.0:0.0)
			))
		    (coords_listMS2 = list((0.0:0.0)
			    (1.6:0.0)
			    (1.6:0.4)
			    (0.4:0.4)
			    (0.4:0.6)
			    (0.5:0.7)
			    (1.3:0.7)
			    (1.6:1.0)
			    (1.6:1.7)
			    (1.3:2.0)
			    (0.3:2.0)
			    (0.0:1.7)
			    (0.0:1.5)
			    (0.4:1.5)
			    (0.5:1.6)
			    (1.1:1.6)
			    (1.2:1.5)
			    (1.2:1.2)
			    (1.1:1.1)
			    (0.3:1.1)
			    (0.0:0.8)
			    (0.0:0.0)
			))
		    (coords_listMS3 = list((0.3:0.0)
			    (1.3:0.0)
			    (1.6:0.3)
			    (1.6:0.8)
			    (1.4:1.0)
			    (1.6:1.2)
			    (1.6:1.7)
			    (1.3:2.0)
			    (0.3:2.0)
			    (0.0:1.7)
			    (0.0:1.5)
			    (0.4:1.5)
			    (0.5:1.6)
			    (1.1:1.6)
			    (1.2:1.5)
			    (1.2:1.3)
			    (1.1:1.2)
			    (0.7:1.2)
			    (0.7:0.8)
			    (1.1:0.8)
			    (1.2:0.7)
			    (1.2:0.5)
			    (1.1:0.4)
			    (0.5:0.4)
			    (0.4:0.5)
			    (0.0:0.5)
			    (0.0:0.3)
			    (0.3:0.0)
			))
		    (coords_listMS4 = list((0.0:0.8)
			    (1.0:0.8)
			    (1.0:0.0)
			    (1.4:0.0)
			    (1.4:0.8)
			    (1.6:0.8)
			    (1.6:1.2)
			    (1.4:1.2)
			    (1.4:2.0)
			    (1.0:2.0)
			    (1.0:1.2)
			    (0.4:1.2)
			    (0.4:2.0)
			    (0.0:2.0)
			    (0.0:0.8)
			))
		    (coords_listMS5 = list((0.3:0.0)
			    (1.3:0.0)
			    (1.6:0.3)
			    (1.6:1.0)
			    (1.3:1.3)
			    (0.5:1.3)
			    (0.4:1.4)
			    (0.4:1.6)
			    (1.6:1.6)
			    (1.6:2.0)
			    (0.0:2.0)
			    (0.0:1.2)
			    (0.3:0.9)
			    (1.1:0.9)
			    (1.2:0.8)
			    (1.2:0.5)
			    (1.1:0.4)
			    (0.5:0.4)
			    (0.4:0.5)
			    (0.0:0.5)
			    (0.0:0.3)
			    (0.3:0.0)
			))
		    (coords_listMS6 = list((0.8:0.0)
			    (0.8:0.4)
			    (0.5:0.4)
			    (0.4:0.5)
			    (0.4:0.7)
			    (0.5:0.8)
			    (0.8:0.8)
			    (0.8:1.2)
			    (0.4:1.2)
			    (0.4:1.5)
			    (0.5:1.6)
			    (1.1:1.6)
			    (1.2:1.5)
			    (1.6:1.5)
			    (1.6:1.7)
			    (1.3:2.0)
			    (0.3:2.0)
			    (0.0:1.7)
			    (0.0:0.3)
			    (0.3:0.0)
			    (0.8:0.0)
			))
		    (coords_listMS61 = list((0.8:0.0)
			    (1.3:0.0)
			    (1.6:0.3)
			    (1.6:0.9)
			    (1.3:1.2)
			    (0.8:1.2)
			    (0.8:0.8)
			    (1.1:0.8)
			    (1.2:0.7)
			    (1.2:0.5)
			    (1.1:0.4)
			    (0.8:0.4)
			    (0.8:0.0)
			))
		    (coords_listMS7 = list((0.6:0.0)
			    (1.0:0.0)
			    (1.0:0.8)
			    (1.6:1.4)
			    (1.6:2.0)
			    (0.0:2.0)
			    (0.0:1.6)
			    (1.2:1.6)
			    (1.2:1.5)
			    (0.6:0.9)
			    (0.6:0.0)
			))
		    (coords_listMS8 = list((0.8:0.0)
			    (0.8:0.4)
			    (0.5:0.4)
			    (0.4:0.5)
			    (0.4:0.7)
			    (0.5:0.8)
			    (0.8:0.8)
			    (0.8:1.2)
			    (0.5:1.2)
			    (0.4:1.3)
			    (0.4:1.5)
			    (0.5:1.6)
			    (0.8:1.6)
			    (0.8:2.0)
			    (0.3:2.0)
			    (0.0:1.7)
			    (0.0:1.2)
			    (0.2:1.0)
			    (0.0:0.8)
			    (0.0:0.3)
			    (0.3:0.0)
			    (0.8:0.0)
			))
		    (coords_listMS81 = list((0.8:0.0)
			    (1.3:0.0)
			    (1.6:0.3)
			    (1.6:0.8)
			    (1.4:1.0)
			    (1.6:1.2)
			    (1.6:1.7)
			    (1.3:2.0)
			    (0.8:2.0)
			    (0.8:1.6)
			    (1.1:1.6)
			    (1.2:1.5)
			    (1.2:1.3)
			    (1.1:1.2)
			    (0.8:1.2)
			    (0.8:0.8)
			    (1.1:0.8)
			    (1.2:0.7)
			    (1.2:0.5)
			    (1.1:0.4)
			    (0.8:0.4)
			    (0.8:0.0)
			))
		    (coords_listMS9 = list((0.8:1.6)
			    (0.8:2.0)
			    (0.3:2.0)
			    (0.0:1.7)
			    (0.0:1.1)
			    (0.3:0.8)
			    (0.8:0.8)
			    (0.8:1.2)
			    (0.5:1.2)
			    (0.4:1.3)
			    (0.4:1.5)
			    (0.5:1.6)
			    (0.8:1.6)
			))
		    (coords_listMS91 = list((0.8:1.6)
			    (1.1:1.6)
			    (1.2:1.5)
			    (1.2:1.3)
			    (1.1:1.2)
			    (0.8:1.2)
			    (0.8:0.8)
			    (1.2:0.8)
			    (1.2:0.5)
			    (1.1:0.4)
			    (0.5:0.4)
			    (0.4:0.5)
			    (0.0:0.5)
			    (0.0:0.3)
			    (0.3:0.0)
			    (1.3:0.0)
			    (1.6:0.3)
			    (1.6:1.7)
			    (1.3:2.0)
			    (0.8:2.0)
			    (0.8:1.6)
			))
		    (coords_listPERMS = list((0.1:0.1)
			    (0.3:0.1)
			    (0.4:0.2)
			    (0.4:0.4)
			    (0.3:0.5)
			    (0.1:0.5)
			    (0.0:0.4)
			    (0.0:0.2)
			    (0.1:0.1)
			))
		    (coords_listCOMMS = list((0.1:0.1)
			    (-0.1:-0.1)
			    (0.0:-0.2)
			    (0.4:0.2)
			    (0.4:0.4)
			    (0.3:0.5)
			    (0.1:0.5)
			    (0.0:0.4)
			    (0.0:0.2)
			    (0.1:0.1)
			))
		    (coords_listDASMS = list((0.0:0.9)
			    (1.6:0.9)
			    (1.6:1.2)
			    (0.0:1.2)
			    (0.0:0.9)
			))
		    (coords_listSLMS = list((0.2:0.2)
			    (1.6:1.6)
			    (1.4:1.8)
			    (0.0:0.4)
			    (0.2:0.2)
			))
		    (coords_listEXMS = list((0.1:0.8)
			    (0.3:0.8)
			    (0.4:0.9)
			    (0.4:1.9)
			    (0.3:2.0)
			    (0.1:2.0)
			    (0.0:1.9)
			    (0.0:0.9)
			    (0.1:0.8)
			))
		    (coords_listEXMS1 = list((0.1:0.0)
			    (0.3:0.0)
			    (0.4:0.1)
			    (0.4:0.3)
			    (0.3:0.4)
			    (0.1:0.4)
			    (0.0:0.3)
			    (0.0:0.1)
			    (0.1:0.0)
			))
		    (coords_listQMMS = list((0.5:0.6)
			    (0.9:0.6)
			    (1.0:0.7)
			    (1.2:0.7)
			    (1.5:1.0)
			    (1.5:1.7)
			    (1.2:2.0)
			    (0.3:2.0)
			    (0.0:1.7)
			    (0.0:1.4)
			    (0.4:1.4)
			    (0.4:1.5)
			    (0.5:1.6)
			    (1.0:1.6)
			    (1.1:1.5)
			    (1.1:1.2)
			    (1.0:1.1)
			    (0.8:1.1)
			    (0.5:0.8)
			    (0.5:0.6)
			))
		    (coords_listQMMS1 = list((0.6:0.0)
			    (0.8:0.0)
			    (0.9:0.1)
			    (0.9:0.3)
			    (0.8:0.4)
			    (0.6:0.4)
			    (0.5:0.3)
			    (0.5:0.1)
			    (0.6:0.0)
			))
		    (coords_listCOLMS = list((0.1:0.0)
			    (0.3:0.0)
			    (0.4:0.1)
			    (0.4:0.3)
			    (0.3:0.4)
			    (0.1:0.4)
			    (0.0:0.3)
			    (0.0:0.1)
			    (0.1:0.0)
			))
		    (coords_listCOLMS1 = list((0.1:0.8)
			    (0.3:0.8)
			    (0.4:0.9)
			    (0.4:1.1)
			    (0.3:1.2)
			    (0.1:1.2)
			    (0.0:1.1)
			    (0.0:0.9)
			    (0.1:0.8)
			))
		    (coords_listSCMS = list((0.1:0.0)
			    (-0.1:-0.2)
			    (0.0:-0.3)
			    (0.4:0.1)
			    (0.4:0.3)
			    (0.3:0.4)
			    (0.1:0.4)
			    (0.0:0.3)
			    (0.0:0.1)
			    (0.1:0.0)
			))
		    (coords_listSCMS1 = list((0.1:0.8)
			    (0.3:0.8)
			    (0.4:0.9)
			    (0.4:1.1)
			    (0.3:1.2)
			    (0.1:1.2)
			    (0.0:1.1)
			    (0.0:0.9)
			    (0.1:0.8)
			))
		    (coords_listUSMS = list((0.0:0.0)
			    (1.6:0.0)
			    (1.6:0.3)
			    (0.0:0.3)
			    (0.0:0.0)
			))
		    (coords_listEQMS = list((0.0:0.5)
			    (1.4:0.5)
			    (1.4:0.8)
			    (0.0:0.8)
			    (0.0:0.5)
			))
		    (coords_listEQMS1 = list((0.0:1.2)
			    (1.4:1.2)
			    (1.4:1.5)
			    (0.0:1.5)
			    (0.0:1.2)
			))
		    (coords_listPLUMS = list((0.0:0.9)
			    (0.6:0.9)
			    (0.6:0.3)
			    (0.9:0.3)
			    (0.9:0.9)
			    (1.5:0.9)
			    (1.5:1.2)
			    (0.9:1.2)
			    (0.9:1.8)
			    (0.6:1.8)
			    (0.6:1.2)
			    (0.0:1.2)
			    (0.0:0.9)
			))
		    (coords_listASTMS = list((0.0:0.9)
			    (0.5:0.9)
			    (0.1:0.5)
			    (0.2:0.4)
			    (0.6:0.8)
			    (0.6:0.3)
			    (0.8:0.3)
			    (0.8:0.8)
			    (1.2:0.4)
			    (1.3:0.5)
			    (0.9:0.9)
			    (1.4:0.9)
			    (1.4:1.1)
			    (0.9:1.1)
			    (1.3:1.5)
			    (1.2:1.6)
			    (0.8:1.2)
			    (0.8:1.7)
			    (0.6:1.7)
			    (0.6:1.2)
			    (0.2:1.6)
			    (0.1:1.5)
			    (0.5:1.1)
			    (0.0:1.1)
			    (0.0:0.9)
			))
		    (coords_listAPMS = list((0.0:1.7)
			    (0.1:1.6)
			    (-0.1:1.4)
			    (0.0:1.3)
			    (0.4:1.7)
			    (0.4:1.9)
			    (0.3:2.0)
			    (0.1:2.0)
			    (0.0:1.9)
			    (0.0:1.7)
			))
		    (coords_listLPMS = list((0.4:-0.2)
			    (0.7:-0.2)
			    (0.7:0.1)
			    (0.5:0.1)
			    (0.3:0.3)
			    (0.3:1.7)
			    (0.5:1.9)
			    (0.7:1.9)
			    (0.7:2.2)
			    (0.4:2.2)
			    (0.0:1.8)
			    (0.0:0.2)
			    (0.4:-0.2)
			))
		    (coords_listRPMS = list((0.0:-0.2)
			    (0.3:-0.2)
			    (0.7:0.2)
			    (0.7:1.8)
			    (0.3:2.2)
			    (0.0:2.2)
			    (0.0:1.9)
			    (0.2:1.9)
			    (0.4:1.7)
			    (0.4:0.3)
			    (0.2:0.1)
			    (0.0:0.1)
			    (0.0:-0.2)
			))
		    (coords_listLBMS = list((0.0:-0.2)
			    (0.7:-0.2)
			    (0.7:0.1)
			    (0.3:0.1)
			    (0.3:1.9)
			    (0.7:1.9)
			    (0.7:2.2)
			    (0.0:2.2)
			    (0.0:-0.2)
			))
		    (coords_listRBMS = list((0.0:-0.2)
			    (0.7:-0.2)
			    (0.7:2.2)
			    (0.0:2.2)
			    (0.0:1.9)
			    (0.4:1.9)
			    (0.4:0.1)
			    (0.0:0.1)
			    (0.0:-0.2)
			))
		    (coords_listBSMS = list((1.4:0.2)
			    (1.6:0.4)
			    (0.2:1.8)
			    (0.0:1.6)
			    (1.4:0.2)
			))
		    (coords_listQUMS = list((0.0:1.4)
			    (0.3:1.4)
			    (0.3:2.2)
			    (0.0:2.2)
			    (0.0:1.4)
			))
		    (coords_listQUMS1 = list((0.6:1.4)
			    (0.9:1.4)
			    (0.9:2.2)
			    (0.6:2.2)
			    (0.6:1.4)
			))
		    (coords_listPCTMS = list((0.2:0.2)
			    (1.6:1.6)
			    (1.4:1.8)
			    (0.0:0.4)
			    (0.2:0.2)
			))
		    (coords_listPCTMS1 = list((0.1:1.4)
			    (0.3:1.4)
			    (0.4:1.5)
			    (0.4:1.7)
			    (0.3:1.8)
			    (0.1:1.8)
			    (0.0:1.7)
			    (0.0:1.5)
			    (0.1:1.4)
			))
		    (coords_listPCTMS2 = list((1.3:0.2)
			    (1.5:0.2)
			    (1.6:0.3)
			    (1.6:0.5)
			    (1.5:0.6)
			    (1.3:0.6)
			    (1.2:0.5)
			    (1.2:0.3)
			    (1.3:0.2)
			))
		    (coords_listDSMS = list((0.0:1.4)
			    (0.2:1.4)
			    (0.2:1.7)
			    (0.3:1.8)
			    (0.7:1.8)
			    (0.7:1.4)
			    (0.9:1.4)
			    (0.9:1.8)
			    (1.3:1.8)
			    (1.4:1.7)
			    (1.6:1.7)
			    (1.6:1.8)
			    (1.4:2.0)
			    (0.9:2.0)
			    (0.9:2.2)
			    (0.7:2.2)
			    (0.7:2.0)
			    (0.2:2.0)
			    (0.0:1.8)
			    (0.0:1.4)
			))
		    (coords_listDSMS1 = list((0.0:1.4)
			    (0.0:1.1)
			    (0.2:0.9)
			    (0.7:0.9)
			    (0.7:0.6)
			    (0.9:0.6)
			    (0.9:0.9)
			    (1.3:0.9)
			    (1.4:0.8)
			    (1.4:0.6)
			    (1.6:0.6)
			    (1.6:0.9)
			    (1.4:1.1)
			    (0.9:1.1)
			    (0.9:1.4)
			    (0.7:1.4)
			    (0.7:1.1)
			    (0.3:1.1)
			    (0.2:1.2)
			    (0.2:1.4)
			    (0.0:1.4)
			))
		    (coords_listDSMS2 = list((0.2:0.0)
			    (0.7:0.0)
			    (0.7:-0.2)
			    (0.9:-0.2)
			    (0.9:0.0)
			    (1.4:0.0)
			    (1.6:0.2)
			    (1.6:0.6)
			    (1.4:0.6)
			    (1.4:0.3)
			    (1.3:0.2)
			    (0.9:0.2)
			    (0.9:0.6)
			    (0.7:0.6)
			    (0.7:0.2)
			    (0.3:0.2)
			    (0.2:0.3)
			    (0.0:0.3)
			    (0.0:0.2)
			    (0.2:0.0)
			))
		    case(character
			(" ")
			("a"
			    (newwholelist = list())
			    (finalnewwholelist = list())
			    foreach(sublistm coords_listAMS1
				(xnumberm = (pntr + ((car(sublistm) * magAmount * 1000.0) / 1000.0)))
				(ynumberm = (pntr1 + ((cadr(sublistm) * magAmount * 1000.0) / 1000.0)))
				(newsublistm = list(xnumberm ynumberm))
				(newwholelist = xcons(newwholelist newsublistm))
			    )
			    (finalnewwholelist = reverse(newwholelist))
			    (newsublistm = nil)
			    (pcInst = dbCreatePolygon(pcCellView
				    list(pcLayer pcPurpose) finalnewwholelist
				))
			    (newwholelist = list())
			    (finalnewwholelist = list())
			    foreach(sublistm coords_listAMS2
				(xnumberm = (pntr + ((car(sublistm) * magAmount * 1000.0) / 1000.0)))
				(ynumberm = (pntr1 + ((cadr(sublistm) * magAmount * 1000.0) / 1000.0)))
				(newsublistm = list(xnumberm ynumberm))
				(newwholelist = xcons(newwholelist newsublistm))
			    )
			    (finalnewwholelist = reverse(newwholelist))
			    (newsublistm = nil)
			    (pcInst = dbCreatePolygon(pcCellView
				    list(pcLayer pcPurpose) finalnewwholelist
				))
			)
			("b"
			    (newwholelist = list())
			    (finalnewwholelist = list())
			    foreach(sublistm coords_listBMS1
				(xnumberm = (pntr + ((car(sublistm) * magAmount * 1000.0) / 1000.0)))
				(ynumberm = (pntr1 + ((cadr(sublistm) * magAmount * 1000.0) / 1000.0)))
				(newsublistm = list(xnumberm ynumberm))
				(newwholelist = xcons(newwholelist newsublistm))
			    )
			    (finalnewwholelist = reverse(newwholelist))
			    (newsublistm = nil)
			    (pcInst = dbCreatePolygon(pcCellView
				    list(pcLayer pcPurpose) finalnewwholelist
				))
			    (newwholelist = list())
			    (finalnewwholelist = list())
			    foreach(sublistm coords_listBMS2
				(xnumberm = (pntr + ((car(sublistm) * magAmount * 1000.0) / 1000.0)))
				(ynumberm = (pntr1 + ((cadr(sublistm) * magAmount * 1000.0) / 1000.0)))
				(newsublistm = list(xnumberm ynumberm))
				(newwholelist = xcons(newwholelist newsublistm))
			    )
			    (finalnewwholelist = reverse(newwholelist))
			    (newsublistm = nil)
			    (pcInst = dbCreatePolygon(pcCellView
				    list(pcLayer pcPurpose) finalnewwholelist
				))
			)
			("c"
			    (newwholelist = list())
			    (finalnewwholelist = list())
			    foreach(sublistm coords_listCMS
				(xnumberm = (pntr + ((car(sublistm) * magAmount * 1000.0) / 1000.0)))
				(ynumberm = (pntr1 + ((cadr(sublistm) * magAmount * 1000.0) / 1000.0)))
				(newsublistm = list(xnumberm ynumberm))
				(newwholelist = xcons(newwholelist newsublistm))
			    )
			    (finalnewwholelist = reverse(newwholelist))
			    (newsublistm = nil)
			    (pcInst = dbCreatePolygon(pcCellView
				    list(pcLayer pcPurpose) finalnewwholelist
				))
			)
			("d"
			    (newwholelist = list())
			    (finalnewwholelist = list())
			    foreach(sublistm coords_listDMS
				(xnumberm = (pntr + ((car(sublistm) * magAmount * 1000.0) / 1000.0)))
				(ynumberm = (pntr1 + ((cadr(sublistm) * magAmount * 1000.0) / 1000.0)))
				(newsublistm = list(xnumberm ynumberm))
				(newwholelist = xcons(newwholelist newsublistm))
			    )
			    (finalnewwholelist = reverse(newwholelist))
			    (newsublistm = nil)
			    (pcInst = dbCreatePolygon(pcCellView
				    list(pcLayer pcPurpose) finalnewwholelist
				))
			    (newwholelist = list())
			    (finalnewwholelist = list())
			    foreach(sublistm coords_listDMS1
				(xnumberm = (pntr + ((car(sublistm) * magAmount * 1000.0) / 1000.0)))
				(ynumberm = (pntr1 + ((cadr(sublistm) * magAmount * 1000.0) / 1000.0)))
				(newsublistm = list(xnumberm ynumberm))
				(newwholelist = xcons(newwholelist newsublistm))
			    )
			    (finalnewwholelist = reverse(newwholelist))
			    (newsublistm = nil)
			    (pcInst = dbCreatePolygon(pcCellView
				    list(pcLayer pcPurpose) finalnewwholelist
				))
			)
			("e"
			    (newwholelist = list())
			    (finalnewwholelist = list())
			    foreach(sublistm coords_listEMS
				(xnumberm = (pntr + ((car(sublistm) * magAmount * 1000.0) / 1000.0)))
				(ynumberm = (pntr1 + ((cadr(sublistm) * magAmount * 1000.0) / 1000.0)))
				(newsublistm = list(xnumberm ynumberm))
				(newwholelist = xcons(newwholelist newsublistm))
			    )
			    (finalnewwholelist = reverse(newwholelist))
			    (newsublistm = nil)
			    (pcInst = dbCreatePolygon(pcCellView
				    list(pcLayer pcPurpose) finalnewwholelist
				))
			)
			("f"
			    (newwholelist = list())
			    (finalnewwholelist = list())
			    foreach(sublistm coords_listFMS
				(xnumberm = (pntr + ((car(sublistm) * magAmount * 1000.0) / 1000.0)))
				(ynumberm = (pntr1 + ((cadr(sublistm) * magAmount * 1000.0) / 1000.0)))
				(newsublistm = list(xnumberm ynumberm))
				(newwholelist = xcons(newwholelist newsublistm))
			    )
			    (finalnewwholelist = reverse(newwholelist))
			    (newsublistm = nil)
			    (pcInst = dbCreatePolygon(pcCellView
				    list(pcLayer pcPurpose) finalnewwholelist
				))
			)
			("g"
			    (newwholelist = list())
			    (finalnewwholelist = list())
			    foreach(sublistm coords_listGMS
				(xnumberm = (pntr + ((car(sublistm) * magAmount * 1000.0) / 1000.0)))
				(ynumberm = (pntr1 + ((cadr(sublistm) * magAmount * 1000.0) / 1000.0)))
				(newsublistm = list(xnumberm ynumberm))
				(newwholelist = xcons(newwholelist newsublistm))
			    )
			    (finalnewwholelist = reverse(newwholelist))
			    (newsublistm = nil)
			    (pcInst = dbCreatePolygon(pcCellView
				    list(pcLayer pcPurpose) finalnewwholelist
				))
			)
			("h"
			    (newwholelist = list())
			    (finalnewwholelist = list())
			    foreach(sublistm coords_listHMS
				(xnumberm = (pntr + ((car(sublistm) * magAmount * 1000.0) / 1000.0)))
				(ynumberm = (pntr1 + ((cadr(sublistm) * magAmount * 1000.0) / 1000.0)))
				(newsublistm = list(xnumberm ynumberm))
				(newwholelist = xcons(newwholelist newsublistm))
			    )
			    (finalnewwholelist = reverse(newwholelist))
			    (newsublistm = nil)
			    (pcInst = dbCreatePolygon(pcCellView
				    list(pcLayer pcPurpose) finalnewwholelist
				))
			)
			("i"
			    (newwholelist = list())
			    (finalnewwholelist = list())
			    foreach(sublistm coords_listIMS
				(xnumberm = (pntr + ((car(sublistm) * magAmount * 1000.0) / 1000.0)))
				(ynumberm = (pntr1 + ((cadr(sublistm) * magAmount * 1000.0) / 1000.0)))
				(newsublistm = list(xnumberm ynumberm))
				(newwholelist = xcons(newwholelist newsublistm))
			    )
			    (finalnewwholelist = reverse(newwholelist))
			    (newsublistm = nil)
			    (pcInst = dbCreatePolygon(pcCellView
				    list(pcLayer pcPurpose) finalnewwholelist
				))
			)
			("j"
			    (newwholelist = list())
			    (finalnewwholelist = list())
			    foreach(sublistm coords_listJMS
				(xnumberm = (pntr + ((car(sublistm) * magAmount * 1000.0) / 1000.0)))
				(ynumberm = (pntr1 + ((cadr(sublistm) * magAmount * 1000.0) / 1000.0)))
				(newsublistm = list(xnumberm ynumberm))
				(newwholelist = xcons(newwholelist newsublistm))
			    )
			    (finalnewwholelist = reverse(newwholelist))
			    (newsublistm = nil)
			    (pcInst = dbCreatePolygon(pcCellView
				    list(pcLayer pcPurpose) finalnewwholelist
				))
			)
			("k"
			    (newwholelist = list())
			    (finalnewwholelist = list())
			    foreach(sublistm coords_listKMS
				(xnumberm = (pntr + ((car(sublistm) * magAmount * 1000.0) / 1000.0)))
				(ynumberm = (pntr1 + ((cadr(sublistm) * magAmount * 1000.0) / 1000.0)))
				(newsublistm = list(xnumberm ynumberm))
				(newwholelist = xcons(newwholelist newsublistm))
			    )
			    (finalnewwholelist = reverse(newwholelist))
			    (newsublistm = nil)
			    (pcInst = dbCreatePolygon(pcCellView
				    list(pcLayer pcPurpose) finalnewwholelist
				))
			)
			("l"
			    (newwholelist = list())
			    (finalnewwholelist = list())
			    foreach(sublistm coords_listLMS
				(xnumberm = (pntr + ((car(sublistm) * magAmount * 1000.0) / 1000.0)))
				(ynumberm = (pntr1 + ((cadr(sublistm) * magAmount * 1000.0) / 1000.0)))
				(newsublistm = list(xnumberm ynumberm))
				(newwholelist = xcons(newwholelist newsublistm))
			    )
			    (finalnewwholelist = reverse(newwholelist))
			    (newsublistm = nil)
			    (pcInst = dbCreatePolygon(pcCellView
				    list(pcLayer pcPurpose) finalnewwholelist
				))
			)
			("m"
			    (newwholelist = list())
			    (finalnewwholelist = list())
			    foreach(sublistm coords_listMMS
				(xnumberm = (pntr + ((car(sublistm) * magAmount * 1000.0) / 1000.0)))
				(ynumberm = (pntr1 + ((cadr(sublistm) * magAmount * 1000.0) / 1000.0)))
				(newsublistm = list(xnumberm ynumberm))
				(newwholelist = xcons(newwholelist newsublistm))
			    )
			    (finalnewwholelist = reverse(newwholelist))
			    (newsublistm = nil)
			    (pcInst = dbCreatePolygon(pcCellView
				    list(pcLayer pcPurpose) finalnewwholelist
				))
			)
			("n"
			    (newwholelist = list())
			    (finalnewwholelist = list())
			    foreach(sublistm coords_listNMS
				(xnumberm = (pntr + ((car(sublistm) * magAmount * 1000.0) / 1000.0)))
				(ynumberm = (pntr1 + ((cadr(sublistm) * magAmount * 1000.0) / 1000.0)))
				(newsublistm = list(xnumberm ynumberm))
				(newwholelist = xcons(newwholelist newsublistm))
			    )
			    (finalnewwholelist = reverse(newwholelist))
			    (newsublistm = nil)
			    (pcInst = dbCreatePolygon(pcCellView
				    list(pcLayer pcPurpose) finalnewwholelist
				))
			)
			("o"
			    (newwholelist = list())
			    (finalnewwholelist = list())
			    foreach(sublistm coords_listOMS
				(xnumberm = (pntr + ((car(sublistm) * magAmount * 1000.0) / 1000.0)))
				(ynumberm = (pntr1 + ((cadr(sublistm) * magAmount * 1000.0) / 1000.0)))
				(newsublistm = list(xnumberm ynumberm))
				(newwholelist = xcons(newwholelist newsublistm))
			    )
			    (finalnewwholelist = reverse(newwholelist))
			    (newsublistm = nil)
			    (pcInst = dbCreatePolygon(pcCellView
				    list(pcLayer pcPurpose) finalnewwholelist
				))
			    (newwholelist = list())
			    (finalnewwholelist = list())
			    foreach(sublistm coords_listOMS1
				(xnumberm = (pntr + ((car(sublistm) * magAmount * 1000.0) / 1000.0)))
				(ynumberm = (pntr1 + ((cadr(sublistm) * magAmount * 1000.0) / 1000.0)))
				(newsublistm = list(xnumberm ynumberm))
				(newwholelist = xcons(newwholelist newsublistm))
			    )
			    (finalnewwholelist = reverse(newwholelist))
			    (newsublistm = nil)
			    (pcInst = dbCreatePolygon(pcCellView
				    list(pcLayer pcPurpose) finalnewwholelist
				))
			)
			("p"
			    (newwholelist = list())
			    (finalnewwholelist = list())
			    foreach(sublistm coords_listPMS
				(xnumberm = (pntr + ((car(sublistm) * magAmount * 1000.0) / 1000.0)))
				(ynumberm = (pntr1 + ((cadr(sublistm) * magAmount * 1000.0) / 1000.0)))
				(newsublistm = list(xnumberm ynumberm))
				(newwholelist = xcons(newwholelist newsublistm))
			    )
			    (finalnewwholelist = reverse(newwholelist))
			    (newsublistm = nil)
			    (pcInst = dbCreatePolygon(pcCellView
				    list(pcLayer pcPurpose) finalnewwholelist
				))
			    (newwholelist = list())
			    (finalnewwholelist = list())
			    foreach(sublistm coords_listPMS1
				(xnumberm = (pntr + ((car(sublistm) * magAmount * 1000.0) / 1000.0)))
				(ynumberm = (pntr1 + ((cadr(sublistm) * magAmount * 1000.0) / 1000.0)))
				(newsublistm = list(xnumberm ynumberm))
				(newwholelist = xcons(newwholelist newsublistm))
			    )
			    (finalnewwholelist = reverse(newwholelist))
			    (newsublistm = nil)
			    (pcInst = dbCreatePolygon(pcCellView
				    list(pcLayer pcPurpose) finalnewwholelist
				))
			)
			("q"
			    (newwholelist = list())
			    (finalnewwholelist = list())
			    foreach(sublistm coords_listQMS
				(xnumberm = (pntr + ((car(sublistm) * magAmount * 1000.0) / 1000.0)))
				(ynumberm = (pntr1 + ((cadr(sublistm) * magAmount * 1000.0) / 1000.0)))
				(newsublistm = list(xnumberm ynumberm))
				(newwholelist = xcons(newwholelist newsublistm))
			    )
			    (finalnewwholelist = reverse(newwholelist))
			    (newsublistm = nil)
			    (pcInst = dbCreatePolygon(pcCellView
				    list(pcLayer pcPurpose) finalnewwholelist
				))
			    (newwholelist = list())
			    (finalnewwholelist = list())
			    foreach(sublistm coords_listQMS1
				(xnumberm = (pntr + ((car(sublistm) * magAmount * 1000.0) / 1000.0)))
				(ynumberm = (pntr1 + ((cadr(sublistm) * magAmount * 1000.0) / 1000.0)))
				(newsublistm = list(xnumberm ynumberm))
				(newwholelist = xcons(newwholelist newsublistm))
			    )
			    (finalnewwholelist = reverse(newwholelist))
			    (newsublistm = nil)
			    (pcInst = dbCreatePolygon(pcCellView
				    list(pcLayer pcPurpose) finalnewwholelist
				))
			)
			("r"
			    (newwholelist = list())
			    (finalnewwholelist = list())
			    foreach(sublistm coords_listRMS
				(xnumberm = (pntr + ((car(sublistm) * magAmount * 1000.0) / 1000.0)))
				(ynumberm = (pntr1 + ((cadr(sublistm) * magAmount * 1000.0) / 1000.0)))
				(newsublistm = list(xnumberm ynumberm))
				(newwholelist = xcons(newwholelist newsublistm))
			    )
			    (finalnewwholelist = reverse(newwholelist))
			    (newsublistm = nil)
			    (pcInst = dbCreatePolygon(pcCellView
				    list(pcLayer pcPurpose) finalnewwholelist
				))
			    (newwholelist = list())
			    (finalnewwholelist = list())
			    foreach(sublistm coords_listRMS1
				(xnumberm = (pntr + ((car(sublistm) * magAmount * 1000.0) / 1000.0)))
				(ynumberm = (pntr1 + ((cadr(sublistm) * magAmount * 1000.0) / 1000.0)))
				(newsublistm = list(xnumberm ynumberm))
				(newwholelist = xcons(newwholelist newsublistm))
			    )
			    (finalnewwholelist = reverse(newwholelist))
			    (newsublistm = nil)
			    (pcInst = dbCreatePolygon(pcCellView
				    list(pcLayer pcPurpose) finalnewwholelist
				))
			)
			("s"
			    (newwholelist = list())
			    (finalnewwholelist = list())
			    foreach(sublistm coords_listSMS
				(xnumberm = (pntr + ((car(sublistm) * magAmount * 1000.0) / 1000.0)))
				(ynumberm = (pntr1 + ((cadr(sublistm) * magAmount * 1000.0) / 1000.0)))
				(newsublistm = list(xnumberm ynumberm))
				(newwholelist = xcons(newwholelist newsublistm))
			    )
			    (finalnewwholelist = reverse(newwholelist))
			    (newsublistm = nil)
			    (pcInst = dbCreatePolygon(pcCellView
				    list(pcLayer pcPurpose) finalnewwholelist
				))
			)
			("t"
			    (newwholelist = list())
			    (finalnewwholelist = list())
			    foreach(sublistm coords_listTMS
				(xnumberm = (pntr + ((car(sublistm) * magAmount * 1000.0) / 1000.0)))
				(ynumberm = (pntr1 + ((cadr(sublistm) * magAmount * 1000.0) / 1000.0)))
				(newsublistm = list(xnumberm ynumberm))
				(newwholelist = xcons(newwholelist newsublistm))
			    )
			    (finalnewwholelist = reverse(newwholelist))
			    (newsublistm = nil)
			    (pcInst = dbCreatePolygon(pcCellView
				    list(pcLayer pcPurpose) finalnewwholelist
				))
			)
			("u"
			    (newwholelist = list())
			    (finalnewwholelist = list())
			    foreach(sublistm coords_listUMS
				(xnumberm = (pntr + ((car(sublistm) * magAmount * 1000.0) / 1000.0)))
				(ynumberm = (pntr1 + ((cadr(sublistm) * magAmount * 1000.0) / 1000.0)))
				(newsublistm = list(xnumberm ynumberm))
				(newwholelist = xcons(newwholelist newsublistm))
			    )
			    (finalnewwholelist = reverse(newwholelist))
			    (newsublistm = nil)
			    (pcInst = dbCreatePolygon(pcCellView
				    list(pcLayer pcPurpose) finalnewwholelist
				))
			)
			("v"
			    (newwholelist = list())
			    (finalnewwholelist = list())
			    foreach(sublistm coords_listVMS
				(xnumberm = (pntr + ((car(sublistm) * magAmount * 1000.0) / 1000.0)))
				(ynumberm = (pntr1 + ((cadr(sublistm) * magAmount * 1000.0) / 1000.0)))
				(newsublistm = list(xnumberm ynumberm))
				(newwholelist = xcons(newwholelist newsublistm))
			    )
			    (finalnewwholelist = reverse(newwholelist))
			    (newsublistm = nil)
			    (pcInst = dbCreatePolygon(pcCellView
				    list(pcLayer pcPurpose) finalnewwholelist
				))
			)
			("w"
			    (newwholelist = list())
			    (finalnewwholelist = list())
			    foreach(sublistm coords_listWMS
				(xnumberm = (pntr + ((car(sublistm) * magAmount * 1000.0) / 1000.0)))
				(ynumberm = (pntr1 + ((cadr(sublistm) * magAmount * 1000.0) / 1000.0)))
				(newsublistm = list(xnumberm ynumberm))
				(newwholelist = xcons(newwholelist newsublistm))
			    )
			    (finalnewwholelist = reverse(newwholelist))
			    (newsublistm = nil)
			    (pcInst = dbCreatePolygon(pcCellView
				    list(pcLayer pcPurpose) finalnewwholelist
				))
			)
			("x"
			    (newwholelist = list())
			    (finalnewwholelist = list())
			    foreach(sublistm coords_listXMS
				(xnumberm = (pntr + ((car(sublistm) * magAmount * 1000.0) / 1000.0)))
				(ynumberm = (pntr1 + ((cadr(sublistm) * magAmount * 1000.0) / 1000.0)))
				(newsublistm = list(xnumberm ynumberm))
				(newwholelist = xcons(newwholelist newsublistm))
			    )
			    (finalnewwholelist = reverse(newwholelist))
			    (newsublistm = nil)
			    (pcInst = dbCreatePolygon(pcCellView
				    list(pcLayer pcPurpose) finalnewwholelist
				))
			)
			("y"
			    (newwholelist = list())
			    (finalnewwholelist = list())
			    foreach(sublistm coords_listYMS
				(xnumberm = (pntr + ((car(sublistm) * magAmount * 1000.0) / 1000.0)))
				(ynumberm = (pntr1 + ((cadr(sublistm) * magAmount * 1000.0) / 1000.0)))
				(newsublistm = list(xnumberm ynumberm))
				(newwholelist = xcons(newwholelist newsublistm))
			    )
			    (finalnewwholelist = reverse(newwholelist))
			    (newsublistm = nil)
			    (pcInst = dbCreatePolygon(pcCellView
				    list(pcLayer pcPurpose) finalnewwholelist
				))
			)
			("z"
			    (newwholelist = list())
			    (finalnewwholelist = list())
			    foreach(sublistm coords_listZMS
				(xnumberm = (pntr + ((car(sublistm) * magAmount * 1000.0) / 1000.0)))
				(ynumberm = (pntr1 + ((cadr(sublistm) * magAmount * 1000.0) / 1000.0)))
				(newsublistm = list(xnumberm ynumberm))
				(newwholelist = xcons(newwholelist newsublistm))
			    )
			    (finalnewwholelist = reverse(newwholelist))
			    (newsublistm = nil)
			    (pcInst = dbCreatePolygon(pcCellView
				    list(pcLayer pcPurpose) finalnewwholelist
				))
			)
			("0"
			    (newwholelist = list())
			    (finalnewwholelist = list())
			    foreach(sublistm coords_listMS0
				(xnumberm = (pntr + ((car(sublistm) * magAmount * 1000.0) / 1000.0)))
				(ynumberm = (pntr1 + ((cadr(sublistm) * magAmount * 1000.0) / 1000.0)))
				(newsublistm = list(xnumberm ynumberm))
				(newwholelist = xcons(newwholelist newsublistm))
			    )
			    (finalnewwholelist = reverse(newwholelist))
			    (newsublistm = nil)
			    (pcInst = dbCreatePolygon(pcCellView
				    list(pcLayer pcPurpose) finalnewwholelist
				))
			    (newwholelist = list())
			    (finalnewwholelist = list())
			    foreach(sublistm coords_listMS01
				(xnumberm = (pntr + ((car(sublistm) * magAmount * 1000.0) / 1000.0)))
				(ynumberm = (pntr1 + ((cadr(sublistm) * magAmount * 1000.0) / 1000.0)))
				(newsublistm = list(xnumberm ynumberm))
				(newwholelist = xcons(newwholelist newsublistm))
			    )
			    (finalnewwholelist = reverse(newwholelist))
			    (newsublistm = nil)
			    (pcInst = dbCreatePolygon(pcCellView
				    list(pcLayer pcPurpose) finalnewwholelist
				))
			    (newwholelist = list())
			    (finalnewwholelist = list())
			    foreach(sublistm coords_listMS02
				(xnumberm = (pntr + ((car(sublistm) * magAmount * 1000.0) / 1000.0)))
				(ynumberm = (pntr1 + ((cadr(sublistm) * magAmount * 1000.0) / 1000.0)))
				(newsublistm = list(xnumberm ynumberm))
				(newwholelist = xcons(newwholelist newsublistm))
			    )
			    (finalnewwholelist = reverse(newwholelist))
			    (newsublistm = nil)
			    (pcInst = dbCreatePolygon(pcCellView
				    list(pcLayer pcPurpose) finalnewwholelist
				))
			)
			("1"
			    (newwholelist = list())
			    (finalnewwholelist = list())
			    foreach(sublistm coords_listMS1
				(xnumberm = (pntr + ((car(sublistm) * magAmount * 1000.0) / 1000.0)))
				(ynumberm = (pntr1 + ((cadr(sublistm) * magAmount * 1000.0) / 1000.0)))
				(newsublistm = list(xnumberm ynumberm))
				(newwholelist = xcons(newwholelist newsublistm))
			    )
			    (finalnewwholelist = reverse(newwholelist))
			    (newsublistm = nil)
			    (pcInst = dbCreatePolygon(pcCellView
				    list(pcLayer pcPurpose) finalnewwholelist
				))
			)
			("2"
			    (newwholelist = list())
			    (finalnewwholelist = list())
			    foreach(sublistm coords_listMS2
				(xnumberm = (pntr + ((car(sublistm) * magAmount * 1000.0) / 1000.0)))
				(ynumberm = (pntr1 + ((cadr(sublistm) * magAmount * 1000.0) / 1000.0)))
				(newsublistm = list(xnumberm ynumberm))
				(newwholelist = xcons(newwholelist newsublistm))
			    )
			    (finalnewwholelist = reverse(newwholelist))
			    (newsublistm = nil)
			    (pcInst = dbCreatePolygon(pcCellView
				    list(pcLayer pcPurpose) finalnewwholelist
				))
			)
			("3"
			    (newwholelist = list())
			    (finalnewwholelist = list())
			    foreach(sublistm coords_listMS3
				(xnumberm = (pntr + ((car(sublistm) * magAmount * 1000.0) / 1000.0)))
				(ynumberm = (pntr1 + ((cadr(sublistm) * magAmount * 1000.0) / 1000.0)))
				(newsublistm = list(xnumberm ynumberm))
				(newwholelist = xcons(newwholelist newsublistm))
			    )
			    (finalnewwholelist = reverse(newwholelist))
			    (newsublistm = nil)
			    (pcInst = dbCreatePolygon(pcCellView
				    list(pcLayer pcPurpose) finalnewwholelist
				))
			)
			("4"
			    (newwholelist = list())
			    (finalnewwholelist = list())
			    foreach(sublistm coords_listMS4
				(xnumberm = (pntr + ((car(sublistm) * magAmount * 1000.0) / 1000.0)))
				(ynumberm = (pntr1 + ((cadr(sublistm) * magAmount * 1000.0) / 1000.0)))
				(newsublistm = list(xnumberm ynumberm))
				(newwholelist = xcons(newwholelist newsublistm))
			    )
			    (finalnewwholelist = reverse(newwholelist))
			    (newsublistm = nil)
			    (pcInst = dbCreatePolygon(pcCellView
				    list(pcLayer pcPurpose) finalnewwholelist
				))
			)
			("5"
			    (newwholelist = list())
			    (finalnewwholelist = list())
			    foreach(sublistm coords_listMS5
				(xnumberm = (pntr + ((car(sublistm) * magAmount * 1000.0) / 1000.0)))
				(ynumberm = (pntr1 + ((cadr(sublistm) * magAmount * 1000.0) / 1000.0)))
				(newsublistm = list(xnumberm ynumberm))
				(newwholelist = xcons(newwholelist newsublistm))
			    )
			    (finalnewwholelist = reverse(newwholelist))
			    (newsublistm = nil)
			    (pcInst = dbCreatePolygon(pcCellView
				    list(pcLayer pcPurpose) finalnewwholelist
				))
			)
			("6"
			    (newwholelist = list())
			    (finalnewwholelist = list())
			    foreach(sublistm coords_listMS6
				(xnumberm = (pntr + ((car(sublistm) * magAmount * 1000.0) / 1000.0)))
				(ynumberm = (pntr1 + ((cadr(sublistm) * magAmount * 1000.0) / 1000.0)))
				(newsublistm = list(xnumberm ynumberm))
				(newwholelist = xcons(newwholelist newsublistm))
			    )
			    (finalnewwholelist = reverse(newwholelist))
			    (newsublistm = nil)
			    (pcInst = dbCreatePolygon(pcCellView
				    list(pcLayer pcPurpose) finalnewwholelist
				))
			    (newwholelist = list())
			    (finalnewwholelist = list())
			    foreach(sublistm coords_listMS61
				(xnumberm = (pntr + ((car(sublistm) * magAmount * 1000.0) / 1000.0)))
				(ynumberm = (pntr1 + ((cadr(sublistm) * magAmount * 1000.0) / 1000.0)))
				(newsublistm = list(xnumberm ynumberm))
				(newwholelist = xcons(newwholelist newsublistm))
			    )
			    (finalnewwholelist = reverse(newwholelist))
			    (newsublistm = nil)
			    (pcInst = dbCreatePolygon(pcCellView
				    list(pcLayer pcPurpose) finalnewwholelist
				))
			)
			("7"
			    (newwholelist = list())
			    (finalnewwholelist = list())
			    foreach(sublistm coords_listMS7
				(xnumberm = (pntr + ((car(sublistm) * magAmount * 1000.0) / 1000.0)))
				(ynumberm = (pntr1 + ((cadr(sublistm) * magAmount * 1000.0) / 1000.0)))
				(newsublistm = list(xnumberm ynumberm))
				(newwholelist = xcons(newwholelist newsublistm))
			    )
			    (finalnewwholelist = reverse(newwholelist))
			    (newsublistm = nil)
			    (pcInst = dbCreatePolygon(pcCellView
				    list(pcLayer pcPurpose) finalnewwholelist
				))
			)
			("8"
			    (newwholelist = list())
			    (finalnewwholelist = list())
			    foreach(sublistm coords_listMS8
				(xnumberm = (pntr + ((car(sublistm) * magAmount * 1000.0) / 1000.0)))
				(ynumberm = (pntr1 + ((cadr(sublistm) * magAmount * 1000.0) / 1000.0)))
				(newsublistm = list(xnumberm ynumberm))
				(newwholelist = xcons(newwholelist newsublistm))
			    )
			    (finalnewwholelist = reverse(newwholelist))
			    (newsublistm = nil)
			    (pcInst = dbCreatePolygon(pcCellView
				    list(pcLayer pcPurpose) finalnewwholelist
				))
			    (newwholelist = list())
			    (finalnewwholelist = list())
			    foreach(sublistm coords_listMS81
				(xnumberm = (pntr + ((car(sublistm) * magAmount * 1000.0) / 1000.0)))
				(ynumberm = (pntr1 + ((cadr(sublistm) * magAmount * 1000.0) / 1000.0)))
				(newsublistm = list(xnumberm ynumberm))
				(newwholelist = xcons(newwholelist newsublistm))
			    )
			    (finalnewwholelist = reverse(newwholelist))
			    (newsublistm = nil)
			    (pcInst = dbCreatePolygon(pcCellView
				    list(pcLayer pcPurpose) finalnewwholelist
				))
			)
			("9"
			    (newwholelist = list())
			    (finalnewwholelist = list())
			    foreach(sublistm coords_listMS9
				(xnumberm = (pntr + ((car(sublistm) * magAmount * 1000.0) / 1000.0)))
				(ynumberm = (pntr1 + ((cadr(sublistm) * magAmount * 1000.0) / 1000.0)))
				(newsublistm = list(xnumberm ynumberm))
				(newwholelist = xcons(newwholelist newsublistm))
			    )
			    (finalnewwholelist = reverse(newwholelist))
			    (newsublistm = nil)
			    (pcInst = dbCreatePolygon(pcCellView
				    list(pcLayer pcPurpose) finalnewwholelist
				))
			    (newwholelist = list())
			    (finalnewwholelist = list())
			    foreach(sublistm coords_listMS91
				(xnumberm = (pntr + ((car(sublistm) * magAmount * 1000.0) / 1000.0)))
				(ynumberm = (pntr1 + ((cadr(sublistm) * magAmount * 1000.0) / 1000.0)))
				(newsublistm = list(xnumberm ynumberm))
				(newwholelist = xcons(newwholelist newsublistm))
			    )
			    (finalnewwholelist = reverse(newwholelist))
			    (newsublistm = nil)
			    (pcInst = dbCreatePolygon(pcCellView
				    list(pcLayer pcPurpose) finalnewwholelist
				))
			)
			("."
			    (newwholelist = list())
			    (finalnewwholelist = list())
			    foreach(sublistm coords_listPERMS
				(xnumberm = (pntr + ((car(sublistm) * magAmount * 1000.0) / 1000.0)))
				(ynumberm = (pntr1 + ((cadr(sublistm) * magAmount * 1000.0) / 1000.0)))
				(newsublistm = list(xnumberm ynumberm))
				(newwholelist = xcons(newwholelist newsublistm))
			    )
			    (finalnewwholelist = reverse(newwholelist))
			    (newsublistm = nil)
			    (pcInst = dbCreatePolygon(pcCellView
				    list(pcLayer pcPurpose) finalnewwholelist
				))
			)
			(","
			    (newwholelist = list())
			    (finalnewwholelist = list())
			    foreach(sublistm coords_listCOMMS
				(xnumberm = (pntr + ((car(sublistm) * magAmount * 1000.0) / 1000.0)))
				(ynumberm = (pntr1 + ((cadr(sublistm) * magAmount * 1000.0) / 1000.0)))
				(newsublistm = list(xnumberm ynumberm))
				(newwholelist = xcons(newwholelist newsublistm))
			    )
			    (finalnewwholelist = reverse(newwholelist))
			    (newsublistm = nil)
			    (pcInst = dbCreatePolygon(pcCellView
				    list(pcLayer pcPurpose) finalnewwholelist
				))
			)
			("-"
			    (newwholelist = list())
			    (finalnewwholelist = list())
			    foreach(sublistm coords_listDASMS
				(xnumberm = (pntr + ((car(sublistm) * magAmount * 1000.0) / 1000.0)))
				(ynumberm = (pntr1 + ((cadr(sublistm) * magAmount * 1000.0) / 1000.0)))
				(newsublistm = list(xnumberm ynumberm))
				(newwholelist = xcons(newwholelist newsublistm))
			    )
			    (finalnewwholelist = reverse(newwholelist))
			    (newsublistm = nil)
			    (pcInst = dbCreatePolygon(pcCellView
				    list(pcLayer pcPurpose) finalnewwholelist
				))
			)
			("/"
			    (newwholelist = list())
			    (finalnewwholelist = list())
			    foreach(sublistm coords_listSLMS
				(xnumberm = (pntr + ((car(sublistm) * magAmount * 1000.0) / 1000.0)))
				(ynumberm = (pntr1 + ((cadr(sublistm) * magAmount * 1000.0) / 1000.0)))
				(newsublistm = list(xnumberm ynumberm))
				(newwholelist = xcons(newwholelist newsublistm))
			    )
			    (finalnewwholelist = reverse(newwholelist))
			    (newsublistm = nil)
			    (pcInst = dbCreatePolygon(pcCellView
				    list(pcLayer pcPurpose) finalnewwholelist
				))
			)
			("!"
			    (newwholelist = list())
			    (finalnewwholelist = list())
			    foreach(sublistm coords_listEXMS
				(xnumberm = (pntr + ((car(sublistm) * magAmount * 1000.0) / 1000.0)))
				(ynumberm = (pntr1 + ((cadr(sublistm) * magAmount * 1000.0) / 1000.0)))
				(newsublistm = list(xnumberm ynumberm))
				(newwholelist = xcons(newwholelist newsublistm))
			    )
			    (finalnewwholelist = reverse(newwholelist))
			    (newsublistm = nil)
			    (pcInst = dbCreatePolygon(pcCellView
				    list(pcLayer pcPurpose) finalnewwholelist
				))
			    (newwholelist = list())
			    (finalnewwholelist = list())
			    foreach(sublistm coords_listEXMS1
				(xnumberm = (pntr + ((car(sublistm) * magAmount * 1000.0) / 1000.0)))
				(ynumberm = (pntr1 + ((cadr(sublistm) * magAmount * 1000.0) / 1000.0)))
				(newsublistm = list(xnumberm ynumberm))
				(newwholelist = xcons(newwholelist newsublistm))
			    )
			    (finalnewwholelist = reverse(newwholelist))
			    (newsublistm = nil)
			    (pcInst = dbCreatePolygon(pcCellView
				    list(pcLayer pcPurpose) finalnewwholelist
				))
			)
			("?"
			    (newwholelist = list())
			    (finalnewwholelist = list())
			    foreach(sublistm coords_listQMMS
				(xnumberm = (pntr + ((car(sublistm) * magAmount * 1000.0) / 1000.0)))
				(ynumberm = (pntr1 + ((cadr(sublistm) * magAmount * 1000.0) / 1000.0)))
				(newsublistm = list(xnumberm ynumberm))
				(newwholelist = xcons(newwholelist newsublistm))
			    )
			    (finalnewwholelist = reverse(newwholelist))
			    (newsublistm = nil)
			    (pcInst = dbCreatePolygon(pcCellView
				    list(pcLayer pcPurpose) finalnewwholelist
				))
			    (newwholelist = list())
			    (finalnewwholelist = list())
			    foreach(sublistm coords_listQMMS1
				(xnumberm = (pntr + ((car(sublistm) * magAmount * 1000.0) / 1000.0)))
				(ynumberm = (pntr1 + ((cadr(sublistm) * magAmount * 1000.0) / 1000.0)))
				(newsublistm = list(xnumberm ynumberm))
				(newwholelist = xcons(newwholelist newsublistm))
			    )
			    (finalnewwholelist = reverse(newwholelist))
			    (newsublistm = nil)
			    (pcInst = dbCreatePolygon(pcCellView
				    list(pcLayer pcPurpose) finalnewwholelist
				))
			)
			(":"
			    (newwholelist = list())
			    (finalnewwholelist = list())
			    foreach(sublistm coords_listCOLMS
				(xnumberm = (pntr + ((car(sublistm) * magAmount * 1000.0) / 1000.0)))
				(ynumberm = (pntr1 + ((cadr(sublistm) * magAmount * 1000.0) / 1000.0)))
				(newsublistm = list(xnumberm ynumberm))
				(newwholelist = xcons(newwholelist newsublistm))
			    )
			    (finalnewwholelist = reverse(newwholelist))
			    (newsublistm = nil)
			    (pcInst = dbCreatePolygon(pcCellView
				    list(pcLayer pcPurpose) finalnewwholelist
				))
			    (newwholelist = list())
			    (finalnewwholelist = list())
			    foreach(sublistm coords_listCOLMS1
				(xnumberm = (pntr + ((car(sublistm) * magAmount * 1000.0) / 1000.0)))
				(ynumberm = (pntr1 + ((cadr(sublistm) * magAmount * 1000.0) / 1000.0)))
				(newsublistm = list(xnumberm ynumberm))
				(newwholelist = xcons(newwholelist newsublistm))
			    )
			    (finalnewwholelist = reverse(newwholelist))
			    (newsublistm = nil)
			    (pcInst = dbCreatePolygon(pcCellView
				    list(pcLayer pcPurpose) finalnewwholelist
				))
			)
			(";"
			    (newwholelist = list())
			    (finalnewwholelist = list())
			    foreach(sublistm coords_listSCMS
				(xnumberm = (pntr + ((car(sublistm) * magAmount * 1000.0) / 1000.0)))
				(ynumberm = (pntr1 + ((cadr(sublistm) * magAmount * 1000.0) / 1000.0)))
				(newsublistm = list(xnumberm ynumberm))
				(newwholelist = xcons(newwholelist newsublistm))
			    )
			    (finalnewwholelist = reverse(newwholelist))
			    (newsublistm = nil)
			    (pcInst = dbCreatePolygon(pcCellView
				    list(pcLayer pcPurpose) finalnewwholelist
				))
			    (newwholelist = list())
			    (finalnewwholelist = list())
			    foreach(sublistm coords_listSCMS1
				(xnumberm = (pntr + ((car(sublistm) * magAmount * 1000.0) / 1000.0)))
				(ynumberm = (pntr1 + ((cadr(sublistm) * magAmount * 1000.0) / 1000.0)))
				(newsublistm = list(xnumberm ynumberm))
				(newwholelist = xcons(newwholelist newsublistm))
			    )
			    (finalnewwholelist = reverse(newwholelist))
			    (newsublistm = nil)
			    (pcInst = dbCreatePolygon(pcCellView
				    list(pcLayer pcPurpose) finalnewwholelist
				))
			)
			("_"
			    (newwholelist = list())
			    (finalnewwholelist = list())
			    foreach(sublistm coords_listUSMS
				(xnumberm = (pntr + ((car(sublistm) * magAmount * 1000.0) / 1000.0)))
				(ynumberm = (pntr1 + ((cadr(sublistm) * magAmount * 1000.0) / 1000.0)))
				(newsublistm = list(xnumberm ynumberm))
				(newwholelist = xcons(newwholelist newsublistm))
			    )
			    (finalnewwholelist = reverse(newwholelist))
			    (newsublistm = nil)
			    (pcInst = dbCreatePolygon(pcCellView
				    list(pcLayer pcPurpose) finalnewwholelist
				))
			)
			("="
			    (newwholelist = list())
			    (finalnewwholelist = list())
			    foreach(sublistm coords_listEQMS
				(xnumberm = (pntr + ((car(sublistm) * magAmount * 1000.0) / 1000.0)))
				(ynumberm = (pntr1 + ((cadr(sublistm) * magAmount * 1000.0) / 1000.0)))
				(newsublistm = list(xnumberm ynumberm))
				(newwholelist = xcons(newwholelist newsublistm))
			    )
			    (finalnewwholelist = reverse(newwholelist))
			    (newsublistm = nil)
			    (pcInst = dbCreatePolygon(pcCellView
				    list(pcLayer pcPurpose) finalnewwholelist
				))
			    (newwholelist = list())
			    (finalnewwholelist = list())
			    foreach(sublistm coords_listEQMS1
				(xnumberm = (pntr + ((car(sublistm) * magAmount * 1000.0) / 1000.0)))
				(ynumberm = (pntr1 + ((cadr(sublistm) * magAmount * 1000.0) / 1000.0)))
				(newsublistm = list(xnumberm ynumberm))
				(newwholelist = xcons(newwholelist newsublistm))
			    )
			    (finalnewwholelist = reverse(newwholelist))
			    (newsublistm = nil)
			    (pcInst = dbCreatePolygon(pcCellView
				    list(pcLayer pcPurpose) finalnewwholelist
				))
			)
			("+"
			    (newwholelist = list())
			    (finalnewwholelist = list())
			    foreach(sublistm coords_listPLUMS
				(xnumberm = (pntr + ((car(sublistm) * magAmount * 1000.0) / 1000.0)))
				(ynumberm = (pntr1 + ((cadr(sublistm) * magAmount * 1000.0) / 1000.0)))
				(newsublistm = list(xnumberm ynumberm))
				(newwholelist = xcons(newwholelist newsublistm))
			    )
			    (finalnewwholelist = reverse(newwholelist))
			    (newsublistm = nil)
			    (pcInst = dbCreatePolygon(pcCellView
				    list(pcLayer pcPurpose) finalnewwholelist
				))
			)
			("*"
			    (newwholelist = list())
			    (finalnewwholelist = list())
			    foreach(sublistm coords_listASTMS
				(xnumberm = (pntr + ((car(sublistm) * magAmount * 1000.0) / 1000.0)))
				(ynumberm = (pntr1 + ((cadr(sublistm) * magAmount * 1000.0) / 1000.0)))
				(newsublistm = list(xnumberm ynumberm))
				(newwholelist = xcons(newwholelist newsublistm))
			    )
			    (finalnewwholelist = reverse(newwholelist))
			    (newsublistm = nil)
			    (pcInst = dbCreatePolygon(pcCellView
				    list(pcLayer pcPurpose) finalnewwholelist
				))
			)
			("'"
			    (newwholelist = list())
			    (finalnewwholelist = list())
			    foreach(sublistm coords_listAPMS
				(xnumberm = (pntr + ((car(sublistm) * magAmount * 1000.0) / 1000.0)))
				(ynumberm = (pntr1 + ((cadr(sublistm) * magAmount * 1000.0) / 1000.0)))
				(newsublistm = list(xnumberm ynumberm))
				(newwholelist = xcons(newwholelist newsublistm))
			    )
			    (finalnewwholelist = reverse(newwholelist))
			    (newsublistm = nil)
			    (pcInst = dbCreatePolygon(pcCellView
				    list(pcLayer pcPurpose) finalnewwholelist
				))
			)
			("("
			    (newwholelist = list())
			    (finalnewwholelist = list())
			    foreach(sublistm coords_listLPMS
				(xnumberm = (pntr + ((car(sublistm) * magAmount * 1000.0) / 1000.0)))
				(ynumberm = (pntr1 + ((cadr(sublistm) * magAmount * 1000.0) / 1000.0)))
				(newsublistm = list(xnumberm ynumberm))
				(newwholelist = xcons(newwholelist newsublistm))
			    )
			    (finalnewwholelist = reverse(newwholelist))
			    (newsublistm = nil)
			    (pcInst = dbCreatePolygon(pcCellView
				    list(pcLayer pcPurpose) finalnewwholelist
				))
			)
			(")"
			    (newwholelist = list())
			    (finalnewwholelist = list())
			    foreach(sublistm coords_listRPMS
				(xnumberm = (pntr + ((car(sublistm) * magAmount * 1000.0) / 1000.0)))
				(ynumberm = (pntr1 + ((cadr(sublistm) * magAmount * 1000.0) / 1000.0)))
				(newsublistm = list(xnumberm ynumberm))
				(newwholelist = xcons(newwholelist newsublistm))
			    )
			    (finalnewwholelist = reverse(newwholelist))
			    (newsublistm = nil)
			    (pcInst = dbCreatePolygon(pcCellView
				    list(pcLayer pcPurpose) finalnewwholelist
				))
			)
			("["
			    (newwholelist = list())
			    (finalnewwholelist = list())
			    foreach(sublistm coords_listLBMS
				(xnumberm = (pntr + ((car(sublistm) * magAmount * 1000.0) / 1000.0)))
				(ynumberm = (pntr1 + ((cadr(sublistm) * magAmount * 1000.0) / 1000.0)))
				(newsublistm = list(xnumberm ynumberm))
				(newwholelist = xcons(newwholelist newsublistm))
			    )
			    (finalnewwholelist = reverse(newwholelist))
			    (newsublistm = nil)
			    (pcInst = dbCreatePolygon(pcCellView
				    list(pcLayer pcPurpose) finalnewwholelist
				))
			)
			("]"
			    (newwholelist = list())
			    (finalnewwholelist = list())
			    foreach(sublistm coords_listRBMS
				(xnumberm = (pntr + ((car(sublistm) * magAmount * 1000.0) / 1000.0)))
				(ynumberm = (pntr1 + ((cadr(sublistm) * magAmount * 1000.0) / 1000.0)))
				(newsublistm = list(xnumberm ynumberm))
				(newwholelist = xcons(newwholelist newsublistm))
			    )
			    (finalnewwholelist = reverse(newwholelist))
			    (newsublistm = nil)
			    (pcInst = dbCreatePolygon(pcCellView
				    list(pcLayer pcPurpose) finalnewwholelist
				))
			)
			("\\"
			    (newwholelist = list())
			    (finalnewwholelist = list())
			    foreach(sublistm coords_listBSMS
				(xnumberm = (pntr + ((car(sublistm) * magAmount * 1000.0) / 1000.0)))
				(ynumberm = (pntr1 + ((cadr(sublistm) * magAmount * 1000.0) / 1000.0)))
				(newsublistm = list(xnumberm ynumberm))
				(newwholelist = xcons(newwholelist newsublistm))
			    )
			    (finalnewwholelist = reverse(newwholelist))
			    (newsublistm = nil)
			    (pcInst = dbCreatePolygon(pcCellView
				    list(pcLayer pcPurpose) finalnewwholelist
				))
			)
			("\""
			    (newwholelist = list())
			    (finalnewwholelist = list())
			    foreach(sublistm coords_listQUMS
				(xnumberm = (pntr + ((car(sublistm) * magAmount * 1000.0) / 1000.0)))
				(ynumberm = (pntr1 + ((cadr(sublistm) * magAmount * 1000.0) / 1000.0)))
				(newsublistm = list(xnumberm ynumberm))
				(newwholelist = xcons(newwholelist newsublistm))
			    )
			    (finalnewwholelist = reverse(newwholelist))
			    (newsublistm = nil)
			    (pcInst = dbCreatePolygon(pcCellView
				    list(pcLayer pcPurpose) finalnewwholelist
				))
			    (newwholelist = list())
			    (finalnewwholelist = list())
			    foreach(sublistm coords_listQUMS1
				(xnumberm = (pntr + ((car(sublistm) * magAmount * 1000.0) / 1000.0)))
				(ynumberm = (pntr1 + ((cadr(sublistm) * magAmount * 1000.0) / 1000.0)))
				(newsublistm = list(xnumberm ynumberm))
				(newwholelist = xcons(newwholelist newsublistm))
			    )
			    (finalnewwholelist = reverse(newwholelist))
			    (newsublistm = nil)
			    (pcInst = dbCreatePolygon(pcCellView
				    list(pcLayer pcPurpose) finalnewwholelist
				))
			)
			("%"
			    (newwholelist = list())
			    (finalnewwholelist = list())
			    foreach(sublistm coords_listPCTMS
				(xnumberm = (pntr + ((car(sublistm) * magAmount * 1000.0) / 1000.0)))
				(ynumberm = (pntr1 + ((cadr(sublistm) * magAmount * 1000.0) / 1000.0)))
				(newsublistm = list(xnumberm ynumberm))
				(newwholelist = xcons(newwholelist newsublistm))
			    )
			    (finalnewwholelist = reverse(newwholelist))
			    (newsublistm = nil)
			    (pcInst = dbCreatePolygon(pcCellView
				    list(pcLayer pcPurpose) finalnewwholelist
				))
			    (newwholelist = list())
			    (finalnewwholelist = list())
			    foreach(sublistm coords_listPCTMS1
				(xnumberm = (pntr + ((car(sublistm) * magAmount * 1000.0) / 1000.0)))
				(ynumberm = (pntr1 + ((cadr(sublistm) * magAmount * 1000.0) / 1000.0)))
				(newsublistm = list(xnumberm ynumberm))
				(newwholelist = xcons(newwholelist newsublistm))
			    )
			    (finalnewwholelist = reverse(newwholelist))
			    (newsublistm = nil)
			    (pcInst = dbCreatePolygon(pcCellView
				    list(pcLayer pcPurpose) finalnewwholelist
				))
			    (newwholelist = list())
			    (finalnewwholelist = list())
			    foreach(sublistm coords_listPCTMS2
				(xnumberm = (pntr + ((car(sublistm) * magAmount * 1000.0) / 1000.0)))
				(ynumberm = (pntr1 + ((cadr(sublistm) * magAmount * 1000.0) / 1000.0)))
				(newsublistm = list(xnumberm ynumberm))
				(newwholelist = xcons(newwholelist newsublistm))
			    )
			    (finalnewwholelist = reverse(newwholelist))
			    (newsublistm = nil)
			    (pcInst = dbCreatePolygon(pcCellView
				    list(pcLayer pcPurpose) finalnewwholelist
				))
			)
			("$"
			    (newwholelist = list())
			    (finalnewwholelist = list())
			    foreach(sublistm coords_listDSMS
				(xnumberm = (pntr + ((car(sublistm) * magAmount * 1000.0) / 1000.0)))
				(ynumberm = (pntr1 + ((cadr(sublistm) * magAmount * 1000.0) / 1000.0)))
				(newsublistm = list(xnumberm ynumberm))
				(newwholelist = xcons(newwholelist newsublistm))
			    )
			    (finalnewwholelist = reverse(newwholelist))
			    (newsublistm = nil)
			    (pcInst = dbCreatePolygon(pcCellView
				    list(pcLayer pcPurpose) finalnewwholelist
				))
			    (newwholelist = list())
			    (finalnewwholelist = list())
			    foreach(sublistm coords_listDSMS1
				(xnumberm = (pntr + ((car(sublistm) * magAmount * 1000.0) / 1000.0)))
				(ynumberm = (pntr1 + ((cadr(sublistm) * magAmount * 1000.0) / 1000.0)))
				(newsublistm = list(xnumberm ynumberm))
				(newwholelist = xcons(newwholelist newsublistm))
			    )
			    (finalnewwholelist = reverse(newwholelist))
			    (newsublistm = nil)
			    (pcInst = dbCreatePolygon(pcCellView
				    list(pcLayer pcPurpose) finalnewwholelist
				))
			    (newwholelist = list())
			    (finalnewwholelist = list())
			    foreach(sublistm coords_listDSMS2
				(xnumberm = (pntr + ((car(sublistm) * magAmount * 1000.0) / 1000.0)))
				(ynumberm = (pntr1 + ((cadr(sublistm) * magAmount * 1000.0) / 1000.0)))
				(newsublistm = list(xnumberm ynumberm))
				(newwholelist = xcons(newwholelist newsublistm))
			    )
			    (finalnewwholelist = reverse(newwholelist))
			    (newsublistm = nil)
			    (pcInst = dbCreatePolygon(pcCellView
				    list(pcLayer pcPurpose) finalnewwholelist
				))
			)
			(t
			    printf("The '%s' character is not supported by text_pcell.\n" character)
			    printf("Skipping the '%s' character and leaving space for the user to insert it.\n" character)
			)
		    )
		    case(characterWidth
			("norm"
			    (pntr = (pntr + (magAmount * dspace)))
			)
			("wide"
			    (pntr = (pntr + (magAmount * dspace * 1.2)))
			)
			("narrow"
			    (pntr = (pntr + (magAmount * dspace * 0.6)))
			)
		    )
		)
		(haloBox = list(rodAddPoints(xCoord((pcCellView~>bBox))
			    list((- halo_distance)
				(- halo_distance)
			    )
			)
			rodAddPoints(yCoord((pcCellView~>bBox))
			    list(halo_distance halo_distance)
			)
		    ))
		if(pc_layer == "active"
		    dbCreateRect( pcCellView "pwblk" haloBox)
			)
		if(pc_layer == "active"
		    dbCreateRect( pcCellView "rhstiswblk" haloBox)
		        )
	    )
	)
	return(t)
    )
)
