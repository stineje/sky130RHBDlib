** sch_path: /home/zwils11/Documents/OSU_SKY130_FLOW/layout/xschem/sky130_rhbd/test_AOA4X1.sch
.subckt test_AOA4X1

V2 B GND pulse 0 1.8 0 1p 1p 4ns 8ns
V1 VDD GND 1.8
V3 D GND pulse 0 1.8 0 1p 1p 16ns 32ns
V4 C GND pulse 0 1.8 0 1p 1p 8ns 16ns
V5 A GND pulse 0 1.8 0 1p 1p 2ns 4ns
x1 Y A B C D VDD GND AOA4X1
**** begin user architecture code

.lib /import/yukari1/pdk/share/pdk/sky130A/libs.tech/ngspice/sky130.lib.spice tt

**** end user architecture code
.ends

* expanding   symbol:  AOA4X1.sym # of pins=5
** sym_path: /home/zwils11/Documents/OSU_SKY130_FLOW/layout/xschem/sky130_rhbd/AOA4X1.sym
** sch_path: /home/zwils11/Documents/OSU_SKY130_FLOW/layout/xschem/sky130_rhbd/AOA4X1.sch
.subckt AOA4X1 Y A B C D VDD VSS
*.PININFO Y:O A:I B:I C:I D:I
x1 net1 A B C D VDD VSS AOAI4X1
x2 Y net1 VDD VSS INVX1
.ends

* expanding   symbol:  AOAI4X1.sym # of pins=5
** sym_path: /home/zwils11/Documents/OSU_SKY130_FLOW/layout/xschem/sky130_rhbd/AOAI4X1.sym
** sch_path: /home/zwils11/Documents/OSU_SKY130_FLOW/layout/xschem/sky130_rhbd/AOAI4X1.sch
.subckt AOAI4X1 YN A B C D VDD VSS
*.PININFO YN:O A:I B:I C:I D:I
x1 net1 A B VDD VSS NAND2X1
x2 net2 net1 C VDD VSS NOR2X1
x3 YN net2 D VDD VSS NAND2X1
.ends

* expanding   symbol:  INVX1.sym # of pins=2
** sym_path: /home/zwils11/Documents/OSU_SKY130_FLOW/layout/xschem/sky130_rhbd/INVX1.sym
** sch_path: /home/zwils11/Documents/OSU_SKY130_FLOW/layout/xschem/sky130_rhbd/INVX1.sch
.subckt INVX1 Y A VDD VSS
*.PININFO Y:O A:I
XM1 Y A VSS VSS NMOS L=0.15 W=3 nf=1 ad='int((nf+1)/2) * W/nf * 0.29' as='int((nf+2)/2) * W/nf * 0.29'
+ pd='2*int((nf+1)/2) * (W/nf + 0.29)' ps='2*int((nf+2)/2) * (W/nf + 0.29)' nrd='0.29 / W' nrs='0.29 / W'
+ sa=0 sb=0 sd=0 mult=1 m=1
XM2 Y A VDD VDD PMOS L=0.15 W=2 nf=1 ad='int((nf+1)/2) * W/nf * 0.29' as='int((nf+2)/2) * W/nf * 0.29'
+ pd='2*int((nf+1)/2) * (W/nf + 0.29)' ps='2*int((nf+2)/2) * (W/nf + 0.29)' nrd='0.29 / W' nrs='0.29 / W'
+ sa=0 sb=0 sd=0 mult=2 m=2
.ends

* expanding   symbol:  NAND2X1.sym # of pins=3
** sym_path: /home/zwils11/Documents/OSU_SKY130_FLOW/layout/xschem/sky130_rhbd/NAND2X1.sym
** sch_path: /home/zwils11/Documents/OSU_SKY130_FLOW/layout/xschem/sky130_rhbd/NAND2X1.sch
.subckt NAND2X1 Y A B VDD VSS
*.PININFO Y:O A:I B:I
XM1 Y A VDD VDD PMOS L=0.15 W=2 nf=1 ad='int((nf+1)/2) * W/nf * 0.29' as='int((nf+2)/2) * W/nf * 0.29'
+ pd='2*int((nf+1)/2) * (W/nf + 0.29)' ps='2*int((nf+2)/2) * (W/nf + 0.29)' nrd='0.29 / W' nrs='0.29 / W'
+ sa=0 sb=0 sd=0 mult=2 m=2
XM5 Y B net1 VSS NMOS L=0.15 W=3 nf=1 ad='int((nf+1)/2) * W/nf * 0.29' as='int((nf+2)/2) * W/nf * 0.29'
+ pd='2*int((nf+1)/2) * (W/nf + 0.29)' ps='2*int((nf+2)/2) * (W/nf + 0.29)' nrd='0.29 / W' nrs='0.29 / W'
+ sa=0 sb=0 sd=0 mult=1 m=1
XM2 Y B VDD VDD PMOS L=0.15 W=2 nf=1 ad='int((nf+1)/2) * W/nf * 0.29' as='int((nf+2)/2) * W/nf * 0.29'
+ pd='2*int((nf+1)/2) * (W/nf + 0.29)' ps='2*int((nf+2)/2) * (W/nf + 0.29)' nrd='0.29 / W' nrs='0.29 / W'
+ sa=0 sb=0 sd=0 mult=2 m=2
XM3 net1 A VSS VSS NMOS L=0.15 W=3 nf=1 ad='int((nf+1)/2) * W/nf * 0.29' as='int((nf+2)/2) * W/nf * 0.29'
+ pd='2*int((nf+1)/2) * (W/nf + 0.29)' ps='2*int((nf+2)/2) * (W/nf + 0.29)' nrd='0.29 / W' nrs='0.29 / W'
+ sa=0 sb=0 sd=0 mult=1 m=1
.ends

* expanding   symbol:  NOR2X1.sym # of pins=3
** sym_path: /home/zwils11/Documents/OSU_SKY130_FLOW/layout/xschem/sky130_rhbd/NOR2X1.sym
** sch_path: /home/zwils11/Documents/OSU_SKY130_FLOW/layout/xschem/sky130_rhbd/NOR2X1.sch
.subckt NOR2X1 Y A B VDD VSS
*.PININFO Y:O A:I B:I
XM1 Y A VSS VSS NMOS L=0.15 W=3 nf=1 ad='int((nf+1)/2) * W/nf * 0.29' as='int((nf+2)/2) * W/nf * 0.29'
+ pd='2*int((nf+1)/2) * (W/nf + 0.29)' ps='2*int((nf+2)/2) * (W/nf + 0.29)' nrd='0.29 / W' nrs='0.29 / W'
+ sa=0 sb=0 sd=0 mult=1 m=1
XM2 net1 A VDD VDD PMOS L=0.15 W=2 nf=1 ad='int((nf+1)/2) * W/nf * 0.29' as='int((nf+2)/2) * W/nf * 0.29'
+ pd='2*int((nf+1)/2) * (W/nf + 0.29)' ps='2*int((nf+2)/2) * (W/nf + 0.29)' nrd='0.29 / W' nrs='0.29 / W'
+ sa=0 sb=0 sd=0 mult=2 m=2
XM3 Y B VSS VSS NMOS L=0.15 W=3 nf=1 ad='int((nf+1)/2) * W/nf * 0.29' as='int((nf+2)/2) * W/nf * 0.29'
+ pd='2*int((nf+1)/2) * (W/nf + 0.29)' ps='2*int((nf+2)/2) * (W/nf + 0.29)' nrd='0.29 / W' nrs='0.29 / W'
+ sa=0 sb=0 sd=0 mult=1 m=1
XM4 Y B net1 VDD PMOS L=0.15 W=2 nf=1 ad='int((nf+1)/2) * W/nf * 0.29' as='int((nf+2)/2) * W/nf * 0.29'
+ pd='2*int((nf+1)/2) * (W/nf + 0.29)' ps='2*int((nf+2)/2) * (W/nf + 0.29)' nrd='0.29 / W' nrs='0.29 / W'
+ sa=0 sb=0 sd=0 mult=2 m=2
.ends

.GLOBAL VDD
.GLOBAL GND
**** begin user architecture code

.tran 0.01n 90n
.save all

**** end user architecture code
.subckt NMOS d g s b
.ends

.subckt NMOS_LVT d g s b
.ends

.subckt PMOS d g s b
.ends

.subckt PMOS_HVT d g s b
.ends
.end
