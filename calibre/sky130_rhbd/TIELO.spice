** sch_path: /home/zwils11/Documents/OSU_SKY130_FLOW/layout/xschem/sky130_rhbd/TIELO.sch
.subckt TIELO YN
*.PININFO YN:O
XM1 YN net1 VSS VSS NMOS L=0.15 W=3 nf=1 ad='int((nf+1)/2) * W/nf * 0.29' as='int((nf+2)/2) * W/nf * 0.29'
+ pd='2*int((nf+1)/2) * (W/nf + 0.29)' ps='2*int((nf+2)/2) * (W/nf + 0.29)' nrd='0.29 / W' nrs='0.29 / W'
+ sa=0 sb=0 sd=0 mult=1 m=1
XM2 net1 net1 VDD VDD PMOS L=0.15 W=2 nf=1 ad='int((nf+1)/2) * W/nf * 0.29' as='int((nf+2)/2) * W/nf * 0.29'
+ pd='2*int((nf+1)/2) * (W/nf + 0.29)' ps='2*int((nf+2)/2) * (W/nf + 0.29)' nrd='0.29 / W' nrs='0.29 / W'
+ sa=0 sb=0 sd=0 mult=2 m=2
.ends
.subckt NMOS d g s b
.ends

.subckt NMOS_LVT d g s b
.ends

.subckt PMOS d g s b
.ends

.subckt PMOS_HVT d g s b
.ends
.end
