* SPICE NETLIST
***************************************

.SUBCKT pad_bond pin0
.ENDS
***************************************
.SUBCKT pad_microprobe pin0
.ENDS
***************************************
.SUBCKT pad_probe pin0
.ENDS
***************************************
.SUBCKT nmos_de_iso_v20 src gate drn b sub
.ENDS
***************************************
.SUBCKT TMRDFFSNQX1 GND VDD D CLK SN Q
** N=800 EP=6 IP=0 FDC=156
M0 GND D 27 800 nmos L=0.163119 W=2.35104 $X=840 $Y=785 $D=3
M1 3 5 27 800 nmos L=0.163346 W=2.31104 $X=1810 $Y=825 $D=3
M2 GND 3 28 800 nmos L=0.163119 W=2.35104 $X=4065 $Y=795 $D=3
M3 29 CLK 28 800 nmos L=0.160516 W=2.29447 $X=5040 $Y=830 $D=3
M4 5 7 29 800 nmos L=0.163346 W=2.31104 $X=6575 $Y=835 $D=3
M5 GND 3 30 800 nmos L=0.163119 W=2.35104 $X=8875 $Y=795 $D=3
M6 31 SN 30 800 nmos L=0.160516 W=2.29447 $X=9850 $Y=830 $D=3
M7 4 7 31 800 nmos L=0.163346 W=2.31104 $X=11385 $Y=835 $D=3
M8 GND 4 32 800 nmos L=0.163119 W=2.35104 $X=13790 $Y=785 $D=3
M9 7 CLK 32 800 nmos L=0.163346 W=2.31104 $X=14760 $Y=825 $D=3
M10 GND 5 33 800 nmos L=0.163119 W=2.35104 $X=17120 $Y=785 $D=3
M11 6 24 33 800 nmos L=0.163346 W=2.31104 $X=18090 $Y=825 $D=3
M12 GND 6 34 800 nmos L=0.163119 W=2.35104 $X=20345 $Y=795 $D=3
M13 35 SN 34 800 nmos L=0.160516 W=2.29447 $X=21320 $Y=830 $D=3
M14 24 7 35 800 nmos L=0.163346 W=2.31104 $X=22855 $Y=835 $D=3
M15 GND D 36 800 nmos L=0.163119 W=2.35104 $X=25260 $Y=785 $D=3
M16 8 10 36 800 nmos L=0.163346 W=2.31104 $X=26230 $Y=825 $D=3
M17 GND 8 37 800 nmos L=0.163119 W=2.35104 $X=28485 $Y=795 $D=3
M18 38 CLK 37 800 nmos L=0.160516 W=2.29447 $X=29460 $Y=830 $D=3
M19 10 12 38 800 nmos L=0.163346 W=2.31104 $X=30995 $Y=835 $D=3
M20 GND 8 39 800 nmos L=0.163119 W=2.35104 $X=33295 $Y=795 $D=3
M21 40 SN 39 800 nmos L=0.160516 W=2.29447 $X=34270 $Y=830 $D=3
M22 9 12 40 800 nmos L=0.163346 W=2.31104 $X=35805 $Y=835 $D=3
M23 GND 9 41 800 nmos L=0.163119 W=2.35104 $X=38210 $Y=785 $D=3
M24 12 CLK 41 800 nmos L=0.163346 W=2.31104 $X=39180 $Y=825 $D=3
M25 GND 10 42 800 nmos L=0.163119 W=2.35104 $X=41540 $Y=785 $D=3
M26 11 13 42 800 nmos L=0.163346 W=2.31104 $X=42510 $Y=825 $D=3
M27 GND 11 43 800 nmos L=0.163119 W=2.35104 $X=44765 $Y=795 $D=3
M28 44 SN 43 800 nmos L=0.160516 W=2.29447 $X=45740 $Y=830 $D=3
M29 13 12 44 800 nmos L=0.163346 W=2.31104 $X=47275 $Y=835 $D=3
M30 GND D 45 800 nmos L=0.163119 W=2.35104 $X=49680 $Y=785 $D=3
M31 15 18 45 800 nmos L=0.163346 W=2.31104 $X=50650 $Y=825 $D=3
M32 GND 15 46 800 nmos L=0.163119 W=2.35104 $X=52905 $Y=795 $D=3
M33 47 CLK 46 800 nmos L=0.160516 W=2.29447 $X=53880 $Y=830 $D=3
M34 18 21 47 800 nmos L=0.163346 W=2.31104 $X=55415 $Y=835 $D=3
M35 GND 15 48 800 nmos L=0.163119 W=2.35104 $X=57715 $Y=795 $D=3
M36 49 SN 48 800 nmos L=0.160516 W=2.29447 $X=58690 $Y=830 $D=3
M37 16 21 49 800 nmos L=0.163346 W=2.31104 $X=60225 $Y=835 $D=3
M38 GND 16 50 800 nmos L=0.163119 W=2.35104 $X=62630 $Y=785 $D=3
M39 21 CLK 50 800 nmos L=0.163346 W=2.31104 $X=63600 $Y=825 $D=3
M40 GND 18 51 800 nmos L=0.163119 W=2.35104 $X=65960 $Y=785 $D=3
M41 19 23 51 800 nmos L=0.163346 W=2.31104 $X=66930 $Y=825 $D=3
M42 GND 19 52 800 nmos L=0.163119 W=2.35104 $X=69185 $Y=795 $D=3
M43 53 SN 52 800 nmos L=0.160516 W=2.29447 $X=70160 $Y=830 $D=3
M44 23 21 53 800 nmos L=0.163346 W=2.31104 $X=71695 $Y=835 $D=3
M45 GND 23 54 800 nmos L=0.163119 W=2.35104 $X=74100 $Y=785 $D=3
M46 26 13 54 800 nmos L=0.163346 W=2.31104 $X=75070 $Y=825 $D=3
M47 GND 23 55 800 nmos L=0.163119 W=2.35104 $X=77430 $Y=785 $D=3
M48 26 24 55 800 nmos L=0.163346 W=2.31104 $X=78400 $Y=825 $D=3
M49 GND 24 56 800 nmos L=0.163119 W=2.35104 $X=80760 $Y=785 $D=3
M50 26 13 56 800 nmos L=0.163129 W=2.31397 $X=81730 $Y=825 $D=3
M51 Q 26 GND 800 nmos L=0.163346 W=2.31104 $X=84025 $Y=830 $D=3
M52 3 D VDD 798 pmos L=0.15 W=2 AD=0.57 AS=0.57 PD=2.57 PS=2.57 NRD=0 NRS=0 m=1 $X=935 $Y=5020 $D=27
M53 VDD D 3 798 pmos L=0.15 W=2 AD=0.58 AS=0.58 PD=2.58 PS=2.58 NRD=0 NRS=0 m=1 $X=1375 $Y=5020 $D=27
M54 3 5 VDD 798 pmos L=0.15 W=2 AD=0.58 AS=0.58 PD=2.58 PS=2.58 NRD=0 NRS=0 m=1 $X=1815 $Y=5020 $D=27
M55 VDD 5 3 798 pmos L=0.15 W=2 AD=0.56 AS=0.56 PD=2.56 PS=2.56 NRD=0 NRS=0 m=1 $X=2255 $Y=5020 $D=27
M56 5 3 VDD 798 pmos L=0.15 W=2 AD=0.57 AS=0.57 PD=2.57 PS=2.57 NRD=0 NRS=0 m=1 $X=4565 $Y=5020 $D=27
M57 VDD 3 5 798 pmos L=0.15 W=2 AD=0.58 AS=0.58 PD=2.58 PS=2.58 NRD=0 NRS=0 m=1 $X=5005 $Y=5020 $D=27
M58 5 CLK VDD 798 pmos L=0.15 W=2 AD=0.58 AS=0.58 PD=2.58 PS=2.58 NRD=0 NRS=0 m=1 $X=5445 $Y=5020 $D=27
M59 VDD CLK 5 798 pmos L=0.15 W=2 AD=0.58 AS=0.58 PD=2.58 PS=2.58 NRD=0 NRS=0 m=1 $X=5885 $Y=5020 $D=27
M60 5 7 VDD 798 pmos L=0.15 W=2 AD=0.58 AS=0.58 PD=2.58 PS=2.58 NRD=0 NRS=0 m=1 $X=6325 $Y=5020 $D=27
M61 VDD 7 5 798 pmos L=0.15 W=2 AD=0.56 AS=0.56 PD=2.56 PS=2.56 NRD=0 NRS=0 m=1 $X=6765 $Y=5020 $D=27
M62 4 3 VDD 798 pmos L=0.15 W=2 AD=0.57 AS=0.57 PD=2.57 PS=2.57 NRD=0 NRS=0 m=1 $X=9375 $Y=5020 $D=27
M63 VDD 3 4 798 pmos L=0.15 W=2 AD=0.58 AS=0.58 PD=2.58 PS=2.58 NRD=0 NRS=0 m=1 $X=9815 $Y=5020 $D=27
M64 4 SN VDD 798 pmos L=0.15 W=2 AD=0.58 AS=0.58 PD=2.58 PS=2.58 NRD=0 NRS=0 m=1 $X=10255 $Y=5020 $D=27
M65 VDD SN 4 798 pmos L=0.15 W=2 AD=0.58 AS=0.58 PD=2.58 PS=2.58 NRD=0 NRS=0 m=1 $X=10695 $Y=5020 $D=27
M66 4 7 VDD 798 pmos L=0.15 W=2 AD=0.58 AS=0.58 PD=2.58 PS=2.58 NRD=0 NRS=0 m=1 $X=11135 $Y=5020 $D=27
M67 VDD 7 4 798 pmos L=0.15 W=2 AD=0.56 AS=0.56 PD=2.56 PS=2.56 NRD=0 NRS=0 m=1 $X=11575 $Y=5020 $D=27
M68 7 4 VDD 798 pmos L=0.15 W=2 AD=0.57 AS=0.57 PD=2.57 PS=2.57 NRD=0 NRS=0 m=1 $X=13885 $Y=5020 $D=27
M69 VDD 4 7 798 pmos L=0.15 W=2 AD=0.58 AS=0.58 PD=2.58 PS=2.58 NRD=0 NRS=0 m=1 $X=14325 $Y=5020 $D=27
M70 7 CLK VDD 798 pmos L=0.15 W=2 AD=0.58 AS=0.58 PD=2.58 PS=2.58 NRD=0 NRS=0 m=1 $X=14765 $Y=5020 $D=27
M71 VDD CLK 7 798 pmos L=0.15 W=2 AD=0.56 AS=0.56 PD=2.56 PS=2.56 NRD=0 NRS=0 m=1 $X=15205 $Y=5020 $D=27
M72 6 5 VDD 798 pmos L=0.15 W=2 AD=0.57 AS=0.57 PD=2.57 PS=2.57 NRD=0 NRS=0 m=1 $X=17215 $Y=5020 $D=27
M73 VDD 5 6 798 pmos L=0.15 W=2 AD=0.58 AS=0.58 PD=2.58 PS=2.58 NRD=0 NRS=0 m=1 $X=17655 $Y=5020 $D=27
M74 6 24 VDD 798 pmos L=0.15 W=2 AD=0.58 AS=0.58 PD=2.58 PS=2.58 NRD=0 NRS=0 m=1 $X=18095 $Y=5020 $D=27
M75 VDD 24 6 798 pmos L=0.15 W=2 AD=0.56 AS=0.56 PD=2.56 PS=2.56 NRD=0 NRS=0 m=1 $X=18535 $Y=5020 $D=27
M76 24 6 VDD 798 pmos L=0.15 W=2 AD=0.57 AS=0.57 PD=2.57 PS=2.57 NRD=0 NRS=0 m=1 $X=20845 $Y=5020 $D=27
M77 VDD 6 24 798 pmos L=0.15 W=2 AD=0.58 AS=0.58 PD=2.58 PS=2.58 NRD=0 NRS=0 m=1 $X=21285 $Y=5020 $D=27
M78 24 SN VDD 798 pmos L=0.15 W=2 AD=0.58 AS=0.58 PD=2.58 PS=2.58 NRD=0 NRS=0 m=1 $X=21725 $Y=5020 $D=27
M79 VDD SN 24 798 pmos L=0.15 W=2 AD=0.58 AS=0.58 PD=2.58 PS=2.58 NRD=0 NRS=0 m=1 $X=22165 $Y=5020 $D=27
M80 24 7 VDD 798 pmos L=0.15 W=2 AD=0.58 AS=0.58 PD=2.58 PS=2.58 NRD=0 NRS=0 m=1 $X=22605 $Y=5020 $D=27
M81 VDD 7 24 798 pmos L=0.15 W=2 AD=0.56 AS=0.56 PD=2.56 PS=2.56 NRD=0 NRS=0 m=1 $X=23045 $Y=5020 $D=27
M82 8 D VDD 798 pmos L=0.15 W=2 AD=0.57 AS=0.57 PD=2.57 PS=2.57 NRD=0 NRS=0 m=1 $X=25355 $Y=5020 $D=27
M83 VDD D 8 798 pmos L=0.15 W=2 AD=0.58 AS=0.58 PD=2.58 PS=2.58 NRD=0 NRS=0 m=1 $X=25795 $Y=5020 $D=27
M84 8 10 VDD 798 pmos L=0.15 W=2 AD=0.58 AS=0.58 PD=2.58 PS=2.58 NRD=0 NRS=0 m=1 $X=26235 $Y=5020 $D=27
M85 VDD 10 8 798 pmos L=0.15 W=2 AD=0.56 AS=0.56 PD=2.56 PS=2.56 NRD=0 NRS=0 m=1 $X=26675 $Y=5020 $D=27
M86 10 8 VDD 798 pmos L=0.15 W=2 AD=0.57 AS=0.57 PD=2.57 PS=2.57 NRD=0 NRS=0 m=1 $X=28985 $Y=5020 $D=27
M87 VDD 8 10 798 pmos L=0.15 W=2 AD=0.58 AS=0.58 PD=2.58 PS=2.58 NRD=0 NRS=0 m=1 $X=29425 $Y=5020 $D=27
M88 10 CLK VDD 798 pmos L=0.15 W=2 AD=0.58 AS=0.58 PD=2.58 PS=2.58 NRD=0 NRS=0 m=1 $X=29865 $Y=5020 $D=27
M89 VDD CLK 10 798 pmos L=0.15 W=2 AD=0.58 AS=0.58 PD=2.58 PS=2.58 NRD=0 NRS=0 m=1 $X=30305 $Y=5020 $D=27
M90 10 12 VDD 798 pmos L=0.15 W=2 AD=0.58 AS=0.58 PD=2.58 PS=2.58 NRD=0 NRS=0 m=1 $X=30745 $Y=5020 $D=27
M91 VDD 12 10 798 pmos L=0.15 W=2 AD=0.56 AS=0.56 PD=2.56 PS=2.56 NRD=0 NRS=0 m=1 $X=31185 $Y=5020 $D=27
M92 9 8 VDD 798 pmos L=0.15 W=2 AD=0.57 AS=0.57 PD=2.57 PS=2.57 NRD=0 NRS=0 m=1 $X=33795 $Y=5020 $D=27
M93 VDD 8 9 798 pmos L=0.15 W=2 AD=0.58 AS=0.58 PD=2.58 PS=2.58 NRD=0 NRS=0 m=1 $X=34235 $Y=5020 $D=27
M94 9 SN VDD 798 pmos L=0.15 W=2 AD=0.58 AS=0.58 PD=2.58 PS=2.58 NRD=0 NRS=0 m=1 $X=34675 $Y=5020 $D=27
M95 VDD SN 9 798 pmos L=0.15 W=2 AD=0.58 AS=0.58 PD=2.58 PS=2.58 NRD=0 NRS=0 m=1 $X=35115 $Y=5020 $D=27
M96 9 12 VDD 798 pmos L=0.15 W=2 AD=0.58 AS=0.58 PD=2.58 PS=2.58 NRD=0 NRS=0 m=1 $X=35555 $Y=5020 $D=27
M97 VDD 12 9 798 pmos L=0.15 W=2 AD=0.56 AS=0.56 PD=2.56 PS=2.56 NRD=0 NRS=0 m=1 $X=35995 $Y=5020 $D=27
M98 12 9 VDD 798 pmos L=0.15 W=2 AD=0.57 AS=0.57 PD=2.57 PS=2.57 NRD=0 NRS=0 m=1 $X=38305 $Y=5020 $D=27
M99 VDD 9 12 798 pmos L=0.15 W=2 AD=0.58 AS=0.58 PD=2.58 PS=2.58 NRD=0 NRS=0 m=1 $X=38745 $Y=5020 $D=27
M100 12 CLK VDD 798 pmos L=0.15 W=2 AD=0.58 AS=0.58 PD=2.58 PS=2.58 NRD=0 NRS=0 m=1 $X=39185 $Y=5020 $D=27
M101 VDD CLK 12 798 pmos L=0.15 W=2 AD=0.56 AS=0.56 PD=2.56 PS=2.56 NRD=0 NRS=0 m=1 $X=39625 $Y=5020 $D=27
M102 11 10 VDD 798 pmos L=0.15 W=2 AD=0.57 AS=0.57 PD=2.57 PS=2.57 NRD=0 NRS=0 m=1 $X=41635 $Y=5020 $D=27
M103 VDD 10 11 798 pmos L=0.15 W=2 AD=0.58 AS=0.58 PD=2.58 PS=2.58 NRD=0 NRS=0 m=1 $X=42075 $Y=5020 $D=27
M104 11 13 VDD 798 pmos L=0.15 W=2 AD=0.58 AS=0.58 PD=2.58 PS=2.58 NRD=0 NRS=0 m=1 $X=42515 $Y=5020 $D=27
M105 VDD 13 11 798 pmos L=0.15 W=2 AD=0.56 AS=0.56 PD=2.56 PS=2.56 NRD=0 NRS=0 m=1 $X=42955 $Y=5020 $D=27
M106 13 11 VDD 798 pmos L=0.15 W=2 AD=0.57 AS=0.57 PD=2.57 PS=2.57 NRD=0 NRS=0 m=1 $X=45265 $Y=5020 $D=27
M107 VDD 11 13 798 pmos L=0.15 W=2 AD=0.58 AS=0.58 PD=2.58 PS=2.58 NRD=0 NRS=0 m=1 $X=45705 $Y=5020 $D=27
M108 13 SN VDD 798 pmos L=0.15 W=2 AD=0.58 AS=0.58 PD=2.58 PS=2.58 NRD=0 NRS=0 m=1 $X=46145 $Y=5020 $D=27
M109 VDD SN 13 798 pmos L=0.15 W=2 AD=0.58 AS=0.58 PD=2.58 PS=2.58 NRD=0 NRS=0 m=1 $X=46585 $Y=5020 $D=27
M110 13 12 VDD 798 pmos L=0.15 W=2 AD=0.58 AS=0.58 PD=2.58 PS=2.58 NRD=0 NRS=0 m=1 $X=47025 $Y=5020 $D=27
M111 VDD 12 13 798 pmos L=0.15 W=2 AD=0.56 AS=0.56 PD=2.56 PS=2.56 NRD=0 NRS=0 m=1 $X=47465 $Y=5020 $D=27
M112 15 D VDD 798 pmos L=0.15 W=2 AD=0.57 AS=0.57 PD=2.57 PS=2.57 NRD=0 NRS=0 m=1 $X=49775 $Y=5020 $D=27
M113 VDD D 15 798 pmos L=0.15 W=2 AD=0.58 AS=0.58 PD=2.58 PS=2.58 NRD=0 NRS=0 m=1 $X=50215 $Y=5020 $D=27
M114 15 18 VDD 798 pmos L=0.15 W=2 AD=0.58 AS=0.58 PD=2.58 PS=2.58 NRD=0 NRS=0 m=1 $X=50655 $Y=5020 $D=27
M115 VDD 18 15 798 pmos L=0.15 W=2 AD=0.56 AS=0.56 PD=2.56 PS=2.56 NRD=0 NRS=0 m=1 $X=51095 $Y=5020 $D=27
M116 18 15 VDD 798 pmos L=0.15 W=2 AD=0.57 AS=0.57 PD=2.57 PS=2.57 NRD=0 NRS=0 m=1 $X=53405 $Y=5020 $D=27
M117 VDD 15 18 798 pmos L=0.15 W=2 AD=0.58 AS=0.58 PD=2.58 PS=2.58 NRD=0 NRS=0 m=1 $X=53845 $Y=5020 $D=27
M118 18 CLK VDD 798 pmos L=0.15 W=2 AD=0.58 AS=0.58 PD=2.58 PS=2.58 NRD=0 NRS=0 m=1 $X=54285 $Y=5020 $D=27
M119 VDD CLK 18 798 pmos L=0.15 W=2 AD=0.58 AS=0.58 PD=2.58 PS=2.58 NRD=0 NRS=0 m=1 $X=54725 $Y=5020 $D=27
M120 18 21 VDD 798 pmos L=0.15 W=2 AD=0.58 AS=0.58 PD=2.58 PS=2.58 NRD=0 NRS=0 m=1 $X=55165 $Y=5020 $D=27
M121 VDD 21 18 798 pmos L=0.15 W=2 AD=0.56 AS=0.56 PD=2.56 PS=2.56 NRD=0 NRS=0 m=1 $X=55605 $Y=5020 $D=27
M122 16 15 VDD 798 pmos L=0.15 W=2 AD=0.57 AS=0.57 PD=2.57 PS=2.57 NRD=0 NRS=0 m=1 $X=58215 $Y=5020 $D=27
M123 VDD 15 16 798 pmos L=0.15 W=2 AD=0.58 AS=0.58 PD=2.58 PS=2.58 NRD=0 NRS=0 m=1 $X=58655 $Y=5020 $D=27
M124 16 SN VDD 798 pmos L=0.15 W=2 AD=0.58 AS=0.58 PD=2.58 PS=2.58 NRD=0 NRS=0 m=1 $X=59095 $Y=5020 $D=27
M125 VDD SN 16 798 pmos L=0.15 W=2 AD=0.58 AS=0.58 PD=2.58 PS=2.58 NRD=0 NRS=0 m=1 $X=59535 $Y=5020 $D=27
M126 16 21 VDD 798 pmos L=0.15 W=2 AD=0.58 AS=0.58 PD=2.58 PS=2.58 NRD=0 NRS=0 m=1 $X=59975 $Y=5020 $D=27
M127 VDD 21 16 798 pmos L=0.15 W=2 AD=0.56 AS=0.56 PD=2.56 PS=2.56 NRD=0 NRS=0 m=1 $X=60415 $Y=5020 $D=27
M128 21 16 VDD 798 pmos L=0.15 W=2 AD=0.57 AS=0.57 PD=2.57 PS=2.57 NRD=0 NRS=0 m=1 $X=62725 $Y=5020 $D=27
M129 VDD 16 21 798 pmos L=0.15 W=2 AD=0.58 AS=0.58 PD=2.58 PS=2.58 NRD=0 NRS=0 m=1 $X=63165 $Y=5020 $D=27
M130 21 CLK VDD 798 pmos L=0.15 W=2 AD=0.58 AS=0.58 PD=2.58 PS=2.58 NRD=0 NRS=0 m=1 $X=63605 $Y=5020 $D=27
M131 VDD CLK 21 798 pmos L=0.15 W=2 AD=0.56 AS=0.56 PD=2.56 PS=2.56 NRD=0 NRS=0 m=1 $X=64045 $Y=5020 $D=27
M132 19 18 VDD 798 pmos L=0.15 W=2 AD=0.57 AS=0.57 PD=2.57 PS=2.57 NRD=0 NRS=0 m=1 $X=66055 $Y=5020 $D=27
M133 VDD 18 19 798 pmos L=0.15 W=2 AD=0.58 AS=0.58 PD=2.58 PS=2.58 NRD=0 NRS=0 m=1 $X=66495 $Y=5020 $D=27
M134 19 23 VDD 798 pmos L=0.15 W=2 AD=0.58 AS=0.58 PD=2.58 PS=2.58 NRD=0 NRS=0 m=1 $X=66935 $Y=5020 $D=27
M135 VDD 23 19 798 pmos L=0.15 W=2 AD=0.56 AS=0.56 PD=2.56 PS=2.56 NRD=0 NRS=0 m=1 $X=67375 $Y=5020 $D=27
M136 23 19 VDD 798 pmos L=0.15 W=2 AD=0.57 AS=0.57 PD=2.57 PS=2.57 NRD=0 NRS=0 m=1 $X=69685 $Y=5020 $D=27
M137 VDD 19 23 798 pmos L=0.15 W=2 AD=0.58 AS=0.58 PD=2.58 PS=2.58 NRD=0 NRS=0 m=1 $X=70125 $Y=5020 $D=27
M138 23 SN VDD 798 pmos L=0.15 W=2 AD=0.58 AS=0.58 PD=2.58 PS=2.58 NRD=0 NRS=0 m=1 $X=70565 $Y=5020 $D=27
M139 VDD SN 23 798 pmos L=0.15 W=2 AD=0.58 AS=0.58 PD=2.58 PS=2.58 NRD=0 NRS=0 m=1 $X=71005 $Y=5020 $D=27
M140 23 21 VDD 798 pmos L=0.15 W=2 AD=0.58 AS=0.58 PD=2.58 PS=2.58 NRD=0 NRS=0 m=1 $X=71445 $Y=5020 $D=27
M141 VDD 21 23 798 pmos L=0.15 W=2 AD=0.56 AS=0.56 PD=2.56 PS=2.56 NRD=0 NRS=0 m=1 $X=71885 $Y=5020 $D=27
M142 22 23 VDD 798 pmos L=0.15 W=2 AD=0.57 AS=0.57 PD=2.57 PS=2.57 NRD=0 NRS=0 m=1 $X=74195 $Y=5025 $D=27
M143 VDD 23 22 798 pmos L=0.15 W=2 AD=0.58 AS=0.58 PD=2.58 PS=2.58 NRD=0 NRS=0 m=1 $X=74635 $Y=5025 $D=27
M144 22 13 VDD 798 pmos L=0.15 W=2 AD=0.58 AS=0.58 PD=2.58 PS=2.58 NRD=0 NRS=0 m=1 $X=75075 $Y=5025 $D=27
M145 VDD 13 22 798 pmos L=0.15 W=2 AD=0.56 AS=0.56 PD=2.56 PS=2.56 NRD=0 NRS=0 m=1 $X=75515 $Y=5025 $D=27
M146 25 23 22 798 pmos L=0.15 W=2 AD=0.56 AS=0.56 PD=2.56 PS=2.56 NRD=0 NRS=0 m=1 $X=77515 $Y=5025 $D=27
M147 22 23 25 798 pmos L=0.15 W=2 AD=0.58 AS=0.58 PD=2.58 PS=2.58 NRD=0 NRS=0 m=1 $X=77955 $Y=5025 $D=27
M148 25 24 22 798 pmos L=0.15 W=2 AD=0.58 AS=0.58 PD=2.58 PS=2.58 NRD=0 NRS=0 m=1 $X=78395 $Y=5025 $D=27
M149 22 24 25 798 pmos L=0.15 W=2 AD=0.57 AS=0.57 PD=2.57 PS=2.57 NRD=0 NRS=0 m=1 $X=78835 $Y=5025 $D=27
M150 26 24 25 798 pmos L=0.15 W=2 AD=0.57 AS=0.57 PD=2.57 PS=2.57 NRD=0 NRS=0 m=1 $X=80855 $Y=5025 $D=27
M151 25 24 26 798 pmos L=0.15 W=2 AD=0.58 AS=0.58 PD=2.58 PS=2.58 NRD=0 NRS=0 m=1 $X=81295 $Y=5025 $D=27
M152 26 13 25 798 pmos L=0.15 W=2 AD=0.58 AS=0.58 PD=2.58 PS=2.58 NRD=0 NRS=0 m=1 $X=81735 $Y=5025 $D=27
M153 25 13 26 798 pmos L=0.15 W=2 AD=0.56 AS=0.56 PD=2.56 PS=2.56 NRD=0 NRS=0 m=1 $X=82175 $Y=5025 $D=27
M154 Q 26 VDD 798 pmos L=0.15 W=2 AD=0.57 AS=0.57 PD=2.57 PS=2.57 NRD=0 NRS=0 m=1 $X=84070 $Y=5020 $D=27
M155 VDD 26 Q 798 pmos L=0.15 W=2 AD=0.56 AS=0.56 PD=2.56 PS=2.56 NRD=0 NRS=0 m=1 $X=84510 $Y=5020 $D=27
.ENDS
***************************************
