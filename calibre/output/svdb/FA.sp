* SPICE NETLIST
***************************************

.SUBCKT pad_bond pin0
.ENDS
***************************************
.SUBCKT pad_microprobe pin0
.ENDS
***************************************
.SUBCKT pad_probe pin0
.ENDS
***************************************
.SUBCKT nmos_de_iso_v20 src gate drn b sub
.ENDS
***************************************
.SUBCKT FA GND VDD A B SUM CIN COUT
** N=423 EP=7 IP=0 FDC=63
M0 4 A GND 423 nmos L=0.163346 W=2.31104 $X=775 $Y=830 $D=3
M1 GND A 18 423 nmos L=0.163119 W=2.35104 $X=3060 $Y=790 $D=3
M2 7 B 18 423 nmos L=0.163346 W=2.31104 $X=4030 $Y=830 $D=3
M3 GND 5 20 423 nmos L=0.163119 W=2.35104 $X=6390 $Y=790 $D=3
M4 7 4 20 423 nmos L=0.163346 W=2.31104 $X=7360 $Y=830 $D=3
M5 5 B GND 423 nmos L=0.163346 W=2.31104 $X=9645 $Y=830 $D=3
M6 8 7 GND 423 nmos L=0.163346 W=2.31104 $X=11875 $Y=830 $D=3
M7 GND 7 22 423 nmos L=0.163119 W=2.35104 $X=14160 $Y=790 $D=3
M8 SUM CIN 22 423 nmos L=0.163346 W=2.31104 $X=15130 $Y=830 $D=3
M9 GND 10 24 423 nmos L=0.163119 W=2.35104 $X=17490 $Y=790 $D=3
M10 SUM 8 24 423 nmos L=0.163346 W=2.31104 $X=18460 $Y=830 $D=3
M11 10 CIN GND 423 nmos L=0.163346 W=2.31104 $X=20745 $Y=830 $D=3
M12 GND CIN 25 423 nmos L=0.163119 W=2.35104 $X=23040 $Y=785 $D=3
M13 12 7 25 423 nmos L=0.163346 W=2.31104 $X=24010 $Y=825 $D=3
M14 14 12 GND 423 nmos L=0.163346 W=2.31104 $X=26305 $Y=830 $D=3
M15 GND B 26 423 nmos L=0.163119 W=2.35104 $X=28590 $Y=785 $D=3
M16 13 A 26 423 nmos L=0.163346 W=2.31104 $X=29560 $Y=825 $D=3
M17 15 13 GND 423 nmos L=0.163346 W=2.31104 $X=31855 $Y=830 $D=3
M18 16 14 GND 423 nmos L=0.163346 W=2.31104 $X=34140 $Y=825 $D=3
M19 16 15 GND 423 nmos L=0.163129 W=2.31397 $X=35110 $Y=825 $D=3
M20 COUT 16 GND 423 nmos L=0.163346 W=2.31104 $X=37405 $Y=830 $D=3
M21 4 A VDD 421 pmos L=0.15 W=2 AD=0.57 AS=0.57 PD=2.57 PS=2.57 NRD=0 NRS=0 m=1 $X=820 $Y=5020 $D=27
M22 VDD A 4 421 pmos L=0.15 W=2 AD=0.56 AS=0.56 PD=2.56 PS=2.56 NRD=0 NRS=0 m=1 $X=1260 $Y=5020 $D=27
M23 VDD A 17 421 pmos L=0.15 W=2 AD=0.57 AS=0.57 PD=2.57 PS=2.57 NRD=0 NRS=0 m=1 $X=3155 $Y=5020 $D=27
M24 17 A VDD 421 pmos L=0.15 W=2 AD=0.58 AS=0.58 PD=2.58 PS=2.58 NRD=0 NRS=0 m=1 $X=3595 $Y=5020 $D=27
M25 7 5 17 421 pmos L=0.15 W=2 AD=0.58 AS=0.58 PD=2.58 PS=2.58 NRD=0 NRS=0 m=1 $X=4035 $Y=5020 $D=27
M26 17 5 7 421 pmos L=0.15 W=2 AD=0.56 AS=0.56 PD=2.56 PS=2.56 NRD=0 NRS=0 m=1 $X=4475 $Y=5020 $D=27
M27 VDD B 19 421 pmos L=0.15 W=2 AD=0.57 AS=0.57 PD=2.57 PS=2.57 NRD=0 NRS=0 m=1 $X=6485 $Y=5020 $D=27
M28 19 B VDD 421 pmos L=0.15 W=2 AD=0.58 AS=0.58 PD=2.58 PS=2.58 NRD=0 NRS=0 m=1 $X=6925 $Y=5020 $D=27
M29 7 4 19 421 pmos L=0.15 W=2 AD=0.58 AS=0.58 PD=2.58 PS=2.58 NRD=0 NRS=0 m=1 $X=7365 $Y=5020 $D=27
M30 19 4 7 421 pmos L=0.15 W=2 AD=0.56 AS=0.56 PD=2.56 PS=2.56 NRD=0 NRS=0 m=1 $X=7805 $Y=5020 $D=27
M31 5 B VDD 421 pmos L=0.15 W=2 AD=0.56 AS=0.56 PD=2.56 PS=2.56 NRD=0 NRS=0 m=1 $X=9690 $Y=5020 $D=27
M32 VDD B 5 421 pmos L=0.15 W=2 AD=0.57 AS=0.57 PD=2.57 PS=2.57 NRD=0 NRS=0 m=1 $X=10130 $Y=5020 $D=27
M33 8 7 VDD 421 pmos L=0.15 W=2 AD=0.57 AS=0.57 PD=2.57 PS=2.57 NRD=0 NRS=0 m=1 $X=11920 $Y=5020 $D=27
M34 VDD 7 8 421 pmos L=0.15 W=2 AD=0.56 AS=0.56 PD=2.56 PS=2.56 NRD=0 NRS=0 m=1 $X=12360 $Y=5020 $D=27
M35 VDD 7 21 421 pmos L=0.15 W=2 AD=0.57 AS=0.57 PD=2.57 PS=2.57 NRD=0 NRS=0 m=1 $X=14255 $Y=5020 $D=27
M36 21 7 VDD 421 pmos L=0.15 W=2 AD=0.58 AS=0.58 PD=2.58 PS=2.58 NRD=0 NRS=0 m=1 $X=14695 $Y=5020 $D=27
M37 SUM 10 21 421 pmos L=0.15 W=2 AD=0.58 AS=0.58 PD=2.58 PS=2.58 NRD=0 NRS=0 m=1 $X=15135 $Y=5020 $D=27
M38 21 10 SUM 421 pmos L=0.15 W=2 AD=0.56 AS=0.56 PD=2.56 PS=2.56 NRD=0 NRS=0 m=1 $X=15575 $Y=5020 $D=27
M39 VDD CIN 23 421 pmos L=0.15 W=2 AD=0.57 AS=0.57 PD=2.57 PS=2.57 NRD=0 NRS=0 m=1 $X=17585 $Y=5020 $D=27
M40 23 CIN VDD 421 pmos L=0.15 W=2 AD=0.58 AS=0.58 PD=2.58 PS=2.58 NRD=0 NRS=0 m=1 $X=18025 $Y=5020 $D=27
M41 SUM 8 23 421 pmos L=0.15 W=2 AD=0.58 AS=0.58 PD=2.58 PS=2.58 NRD=0 NRS=0 m=1 $X=18465 $Y=5020 $D=27
M42 23 8 SUM 421 pmos L=0.15 W=2 AD=0.56 AS=0.56 PD=2.56 PS=2.56 NRD=0 NRS=0 m=1 $X=18905 $Y=5020 $D=27
M43 10 CIN VDD 421 pmos L=0.15 W=2 AD=0.56 AS=0.56 PD=2.56 PS=2.56 NRD=0 NRS=0 m=1 $X=20790 $Y=5020 $D=27
M44 VDD CIN 10 421 pmos L=0.15 W=2 AD=0.57 AS=0.57 PD=2.57 PS=2.57 NRD=0 NRS=0 m=1 $X=21230 $Y=5020 $D=27
M45 12 CIN VDD 421 pmos L=0.15 W=2 AD=0.57 AS=0.57 PD=2.57 PS=2.57 NRD=0 NRS=0 m=1 $X=23135 $Y=5020 $D=27
M46 VDD CIN 12 421 pmos L=0.15 W=2 AD=0.58 AS=0.58 PD=2.58 PS=2.58 NRD=0 NRS=0 m=1 $X=23575 $Y=5020 $D=27
M47 12 7 VDD 421 pmos L=0.15 W=2 AD=0.58 AS=0.58 PD=2.58 PS=2.58 NRD=0 NRS=0 m=1 $X=24015 $Y=5020 $D=27
M48 VDD 7 12 421 pmos L=0.15 W=2 AD=0.56 AS=0.56 PD=2.56 PS=2.56 NRD=0 NRS=0 m=1 $X=24455 $Y=5020 $D=27
M49 14 12 VDD 421 pmos L=0.15 W=2 AD=0.57 AS=0.57 PD=2.57 PS=2.57 NRD=0 NRS=0 m=1 $X=26350 $Y=5020 $D=27
M50 VDD 12 14 421 pmos L=0.15 W=2 AD=0.56 AS=0.56 PD=2.56 PS=2.56 NRD=0 NRS=0 m=1 $X=26790 $Y=5020 $D=27
M51 13 B VDD 421 pmos L=0.15 W=2 AD=0.57 AS=0.57 PD=2.57 PS=2.57 NRD=0 NRS=0 m=1 $X=28685 $Y=5020 $D=27
M52 VDD B 13 421 pmos L=0.15 W=2 AD=0.58 AS=0.58 PD=2.58 PS=2.58 NRD=0 NRS=0 m=1 $X=29125 $Y=5020 $D=27
M53 13 A VDD 421 pmos L=0.15 W=2 AD=0.58 AS=0.58 PD=2.58 PS=2.58 NRD=0 NRS=0 m=1 $X=29565 $Y=5020 $D=27
M54 VDD A 13 421 pmos L=0.15 W=2 AD=0.56 AS=0.56 PD=2.56 PS=2.56 NRD=0 NRS=0 m=1 $X=30005 $Y=5020 $D=27
M55 15 13 VDD 421 pmos L=0.15 W=2 AD=0.57 AS=0.57 PD=2.57 PS=2.57 NRD=0 NRS=0 m=1 $X=31900 $Y=5020 $D=27
M56 VDD 13 15 421 pmos L=0.15 W=2 AD=0.56 AS=0.56 PD=2.56 PS=2.56 NRD=0 NRS=0 m=1 $X=32340 $Y=5020 $D=27
M57 VDD 14 27 421 pmos L=0.15 W=2 AD=0.57 AS=0.57 PD=2.57 PS=2.57 NRD=0 NRS=0 m=1 $X=34235 $Y=5025 $D=27
M58 27 14 VDD 421 pmos L=0.15 W=2 AD=0.58 AS=0.58 PD=2.58 PS=2.58 NRD=0 NRS=0 m=1 $X=34675 $Y=5025 $D=27
M59 16 15 27 421 pmos L=0.15 W=2 AD=0.58 AS=0.58 PD=2.58 PS=2.58 NRD=0 NRS=0 m=1 $X=35115 $Y=5025 $D=27
M60 27 15 16 421 pmos L=0.15 W=2 AD=0.56 AS=0.56 PD=2.56 PS=2.56 NRD=0 NRS=0 m=1 $X=35555 $Y=5025 $D=27
M61 COUT 16 VDD 421 pmos L=0.15 W=2 AD=0.57 AS=0.57 PD=2.57 PS=2.57 NRD=0 NRS=0 m=1 $X=37450 $Y=5020 $D=27
M62 VDD 16 COUT 421 pmos L=0.15 W=2 AD=0.56 AS=0.56 PD=2.56 PS=2.56 NRD=0 NRS=0 m=1 $X=37890 $Y=5020 $D=27
.ENDS
***************************************
