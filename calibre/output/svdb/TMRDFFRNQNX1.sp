* SPICE NETLIST
***************************************

.SUBCKT pad_bond pin0
.ENDS
***************************************
.SUBCKT pad_microprobe pin0
.ENDS
***************************************
.SUBCKT pad_probe pin0
.ENDS
***************************************
.SUBCKT nmos_de_iso_v20 src gate drn b sub
.ENDS
***************************************
.SUBCKT TMRDFFRNQNX1 GND VDD D CLK RN QN
** N=798 EP=6 IP=0 FDC=162
M0 GND 6 23 798 nmos L=0.163119 W=2.35104 $X=735 $Y=795 $D=3
M1 24 CLK 23 798 nmos L=0.160516 W=2.29447 $X=1710 $Y=830 $D=3
M2 5 3 24 798 nmos L=0.163346 W=2.31104 $X=3245 $Y=835 $D=3
M3 GND 5 25 798 nmos L=0.163119 W=2.35104 $X=5545 $Y=795 $D=3
M4 26 D 25 798 nmos L=0.160516 W=2.29447 $X=6520 $Y=830 $D=3
M5 3 RN 26 798 nmos L=0.163346 W=2.31104 $X=8055 $Y=835 $D=3
M6 GND 3 27 798 nmos L=0.163119 W=2.35104 $X=10460 $Y=785 $D=3
M7 4 6 27 798 nmos L=0.163346 W=2.31104 $X=11430 $Y=825 $D=3
M8 GND 4 28 798 nmos L=0.163119 W=2.35104 $X=13685 $Y=795 $D=3
M9 29 CLK 28 798 nmos L=0.160516 W=2.29447 $X=14660 $Y=830 $D=3
M10 6 RN 29 798 nmos L=0.163346 W=2.31104 $X=16195 $Y=835 $D=3
M11 GND 5 30 798 nmos L=0.163119 W=2.35104 $X=18495 $Y=795 $D=3
M12 31 RN 30 798 nmos L=0.160516 W=2.29447 $X=19470 $Y=830 $D=3
M13 6 20 31 798 nmos L=0.163346 W=2.31104 $X=21005 $Y=835 $D=3
M14 GND 6 32 798 nmos L=0.163119 W=2.35104 $X=23410 $Y=785 $D=3
M15 20 6 32 798 nmos L=0.163346 W=2.31104 $X=24380 $Y=825 $D=3
M16 GND 11 33 798 nmos L=0.163119 W=2.35104 $X=26635 $Y=795 $D=3
M17 34 CLK 33 798 nmos L=0.160516 W=2.29447 $X=27610 $Y=830 $D=3
M18 9 7 34 798 nmos L=0.163346 W=2.31104 $X=29145 $Y=835 $D=3
M19 GND 9 35 798 nmos L=0.163119 W=2.35104 $X=31445 $Y=795 $D=3
M20 36 D 35 798 nmos L=0.160516 W=2.29447 $X=32420 $Y=830 $D=3
M21 7 RN 36 798 nmos L=0.163346 W=2.31104 $X=33955 $Y=835 $D=3
M22 GND 7 37 798 nmos L=0.163119 W=2.35104 $X=36360 $Y=785 $D=3
M23 8 11 37 798 nmos L=0.163346 W=2.31104 $X=37330 $Y=825 $D=3
M24 GND 8 38 798 nmos L=0.163119 W=2.35104 $X=39585 $Y=795 $D=3
M25 39 CLK 38 798 nmos L=0.160516 W=2.29447 $X=40560 $Y=830 $D=3
M26 11 RN 39 798 nmos L=0.163346 W=2.31104 $X=42095 $Y=835 $D=3
M27 GND 9 40 798 nmos L=0.163119 W=2.35104 $X=44395 $Y=795 $D=3
M28 41 RN 40 798 nmos L=0.160516 W=2.29447 $X=45370 $Y=830 $D=3
M29 10 17 41 798 nmos L=0.163346 W=2.31104 $X=46905 $Y=835 $D=3
M30 GND 10 42 798 nmos L=0.163119 W=2.35104 $X=49310 $Y=785 $D=3
M31 17 11 42 798 nmos L=0.163346 W=2.31104 $X=50280 $Y=825 $D=3
M32 GND 16 43 798 nmos L=0.163119 W=2.35104 $X=52535 $Y=795 $D=3
M33 44 CLK 43 798 nmos L=0.160516 W=2.29447 $X=53510 $Y=830 $D=3
M34 14 17 44 798 nmos L=0.163346 W=2.31104 $X=55045 $Y=835 $D=3
M35 GND 14 45 798 nmos L=0.163119 W=2.35104 $X=57345 $Y=795 $D=3
M36 46 D 45 798 nmos L=0.160516 W=2.29447 $X=58320 $Y=830 $D=3
M37 17 RN 46 798 nmos L=0.163346 W=2.31104 $X=59855 $Y=835 $D=3
M38 GND 17 47 798 nmos L=0.163119 W=2.35104 $X=62260 $Y=785 $D=3
M39 17 16 47 798 nmos L=0.163346 W=2.31104 $X=63230 $Y=825 $D=3
M40 GND 17 48 798 nmos L=0.163119 W=2.35104 $X=65485 $Y=795 $D=3
M41 49 CLK 48 798 nmos L=0.160516 W=2.29447 $X=66460 $Y=830 $D=3
M42 16 RN 49 798 nmos L=0.163346 W=2.31104 $X=67995 $Y=835 $D=3
M43 GND 14 50 798 nmos L=0.163119 W=2.35104 $X=70295 $Y=795 $D=3
M44 51 RN 50 798 nmos L=0.160516 W=2.29447 $X=71270 $Y=830 $D=3
M45 16 18 51 798 nmos L=0.163346 W=2.31104 $X=72805 $Y=835 $D=3
M46 GND 16 52 798 nmos L=0.163119 W=2.35104 $X=75210 $Y=785 $D=3
M47 18 16 52 798 nmos L=0.163346 W=2.31104 $X=76180 $Y=825 $D=3
M48 GND 17 53 798 nmos L=0.163119 W=2.35104 $X=78540 $Y=785 $D=3
M49 QN 18 53 798 nmos L=0.163346 W=2.31104 $X=79510 $Y=825 $D=3
M50 GND 17 54 798 nmos L=0.163119 W=2.35104 $X=81870 $Y=785 $D=3
M51 QN 20 54 798 nmos L=0.163346 W=2.31104 $X=82840 $Y=825 $D=3
M52 GND 20 55 798 nmos L=0.163119 W=2.35104 $X=85200 $Y=785 $D=3
M53 QN 18 55 798 nmos L=0.163129 W=2.31397 $X=86170 $Y=825 $D=3
M54 5 6 VDD 796 pmos L=0.15 W=2 AD=0.57 AS=0.57 PD=2.57 PS=2.57 NRD=0 NRS=0 m=1 $X=1235 $Y=5020 $D=27
M55 VDD 6 5 796 pmos L=0.15 W=2 AD=0.58 AS=0.58 PD=2.58 PS=2.58 NRD=0 NRS=0 m=1 $X=1675 $Y=5020 $D=27
M56 5 CLK VDD 796 pmos L=0.15 W=2 AD=0.58 AS=0.58 PD=2.58 PS=2.58 NRD=0 NRS=0 m=1 $X=2115 $Y=5020 $D=27
M57 VDD CLK 5 796 pmos L=0.15 W=2 AD=0.58 AS=0.58 PD=2.58 PS=2.58 NRD=0 NRS=0 m=1 $X=2555 $Y=5020 $D=27
M58 5 3 VDD 796 pmos L=0.15 W=2 AD=0.58 AS=0.58 PD=2.58 PS=2.58 NRD=0 NRS=0 m=1 $X=2995 $Y=5020 $D=27
M59 VDD 3 5 796 pmos L=0.15 W=2 AD=0.56 AS=0.56 PD=2.56 PS=2.56 NRD=0 NRS=0 m=1 $X=3435 $Y=5020 $D=27
M60 3 5 VDD 796 pmos L=0.15 W=2 AD=0.57 AS=0.57 PD=2.57 PS=2.57 NRD=0 NRS=0 m=1 $X=6045 $Y=5020 $D=27
M61 VDD 5 3 796 pmos L=0.15 W=2 AD=0.58 AS=0.58 PD=2.58 PS=2.58 NRD=0 NRS=0 m=1 $X=6485 $Y=5020 $D=27
M62 3 D VDD 796 pmos L=0.15 W=2 AD=0.58 AS=0.58 PD=2.58 PS=2.58 NRD=0 NRS=0 m=1 $X=6925 $Y=5020 $D=27
M63 VDD D 3 796 pmos L=0.15 W=2 AD=0.58 AS=0.58 PD=2.58 PS=2.58 NRD=0 NRS=0 m=1 $X=7365 $Y=5020 $D=27
M64 3 RN VDD 796 pmos L=0.15 W=2 AD=0.58 AS=0.58 PD=2.58 PS=2.58 NRD=0 NRS=0 m=1 $X=7805 $Y=5020 $D=27
M65 VDD RN 3 796 pmos L=0.15 W=2 AD=0.56 AS=0.56 PD=2.56 PS=2.56 NRD=0 NRS=0 m=1 $X=8245 $Y=5020 $D=27
M66 4 3 VDD 796 pmos L=0.15 W=2 AD=0.57 AS=0.57 PD=2.57 PS=2.57 NRD=0 NRS=0 m=1 $X=10555 $Y=5020 $D=27
M67 VDD 3 4 796 pmos L=0.15 W=2 AD=0.58 AS=0.58 PD=2.58 PS=2.58 NRD=0 NRS=0 m=1 $X=10995 $Y=5020 $D=27
M68 4 6 VDD 796 pmos L=0.15 W=2 AD=0.58 AS=0.58 PD=2.58 PS=2.58 NRD=0 NRS=0 m=1 $X=11435 $Y=5020 $D=27
M69 VDD 6 4 796 pmos L=0.15 W=2 AD=0.56 AS=0.56 PD=2.56 PS=2.56 NRD=0 NRS=0 m=1 $X=11875 $Y=5020 $D=27
M70 6 4 VDD 796 pmos L=0.15 W=2 AD=0.57 AS=0.57 PD=2.57 PS=2.57 NRD=0 NRS=0 m=1 $X=14185 $Y=5020 $D=27
M71 VDD 4 6 796 pmos L=0.15 W=2 AD=0.58 AS=0.58 PD=2.58 PS=2.58 NRD=0 NRS=0 m=1 $X=14625 $Y=5020 $D=27
M72 6 CLK VDD 796 pmos L=0.15 W=2 AD=0.58 AS=0.58 PD=2.58 PS=2.58 NRD=0 NRS=0 m=1 $X=15065 $Y=5020 $D=27
M73 VDD CLK 6 796 pmos L=0.15 W=2 AD=0.58 AS=0.58 PD=2.58 PS=2.58 NRD=0 NRS=0 m=1 $X=15505 $Y=5020 $D=27
M74 6 RN VDD 796 pmos L=0.15 W=2 AD=0.58 AS=0.58 PD=2.58 PS=2.58 NRD=0 NRS=0 m=1 $X=15945 $Y=5020 $D=27
M75 VDD RN 6 796 pmos L=0.15 W=2 AD=0.56 AS=0.56 PD=2.56 PS=2.56 NRD=0 NRS=0 m=1 $X=16385 $Y=5020 $D=27
M76 6 5 VDD 796 pmos L=0.15 W=2 AD=0.57 AS=0.57 PD=2.57 PS=2.57 NRD=0 NRS=0 m=1 $X=18995 $Y=5020 $D=27
M77 VDD 5 6 796 pmos L=0.15 W=2 AD=0.58 AS=0.58 PD=2.58 PS=2.58 NRD=0 NRS=0 m=1 $X=19435 $Y=5020 $D=27
M78 6 RN VDD 796 pmos L=0.15 W=2 AD=0.58 AS=0.58 PD=2.58 PS=2.58 NRD=0 NRS=0 m=1 $X=19875 $Y=5020 $D=27
M79 VDD RN 6 796 pmos L=0.15 W=2 AD=0.58 AS=0.58 PD=2.58 PS=2.58 NRD=0 NRS=0 m=1 $X=20315 $Y=5020 $D=27
M80 6 20 VDD 796 pmos L=0.15 W=2 AD=0.58 AS=0.58 PD=2.58 PS=2.58 NRD=0 NRS=0 m=1 $X=20755 $Y=5020 $D=27
M81 VDD 20 6 796 pmos L=0.15 W=2 AD=0.56 AS=0.56 PD=2.56 PS=2.56 NRD=0 NRS=0 m=1 $X=21195 $Y=5020 $D=27
M82 20 6 VDD 796 pmos L=0.15 W=2 AD=0.57 AS=0.57 PD=2.57 PS=2.57 NRD=0 NRS=0 m=1 $X=23505 $Y=5020 $D=27
M83 VDD 6 20 796 pmos L=0.15 W=2 AD=0.58 AS=0.58 PD=2.58 PS=2.58 NRD=0 NRS=0 m=1 $X=23945 $Y=5020 $D=27
M84 20 6 VDD 796 pmos L=0.15 W=2 AD=0.58 AS=0.58 PD=2.58 PS=2.58 NRD=0 NRS=0 m=1 $X=24385 $Y=5020 $D=27
M85 VDD 6 20 796 pmos L=0.15 W=2 AD=0.56 AS=0.56 PD=2.56 PS=2.56 NRD=0 NRS=0 m=1 $X=24825 $Y=5020 $D=27
M86 9 11 VDD 796 pmos L=0.15 W=2 AD=0.57 AS=0.57 PD=2.57 PS=2.57 NRD=0 NRS=0 m=1 $X=27135 $Y=5020 $D=27
M87 VDD 11 9 796 pmos L=0.15 W=2 AD=0.58 AS=0.58 PD=2.58 PS=2.58 NRD=0 NRS=0 m=1 $X=27575 $Y=5020 $D=27
M88 9 CLK VDD 796 pmos L=0.15 W=2 AD=0.58 AS=0.58 PD=2.58 PS=2.58 NRD=0 NRS=0 m=1 $X=28015 $Y=5020 $D=27
M89 VDD CLK 9 796 pmos L=0.15 W=2 AD=0.58 AS=0.58 PD=2.58 PS=2.58 NRD=0 NRS=0 m=1 $X=28455 $Y=5020 $D=27
M90 9 7 VDD 796 pmos L=0.15 W=2 AD=0.58 AS=0.58 PD=2.58 PS=2.58 NRD=0 NRS=0 m=1 $X=28895 $Y=5020 $D=27
M91 VDD 7 9 796 pmos L=0.15 W=2 AD=0.56 AS=0.56 PD=2.56 PS=2.56 NRD=0 NRS=0 m=1 $X=29335 $Y=5020 $D=27
M92 7 9 VDD 796 pmos L=0.15 W=2 AD=0.57 AS=0.57 PD=2.57 PS=2.57 NRD=0 NRS=0 m=1 $X=31945 $Y=5020 $D=27
M93 VDD 9 7 796 pmos L=0.15 W=2 AD=0.58 AS=0.58 PD=2.58 PS=2.58 NRD=0 NRS=0 m=1 $X=32385 $Y=5020 $D=27
M94 7 D VDD 796 pmos L=0.15 W=2 AD=0.58 AS=0.58 PD=2.58 PS=2.58 NRD=0 NRS=0 m=1 $X=32825 $Y=5020 $D=27
M95 VDD D 7 796 pmos L=0.15 W=2 AD=0.58 AS=0.58 PD=2.58 PS=2.58 NRD=0 NRS=0 m=1 $X=33265 $Y=5020 $D=27
M96 7 RN VDD 796 pmos L=0.15 W=2 AD=0.58 AS=0.58 PD=2.58 PS=2.58 NRD=0 NRS=0 m=1 $X=33705 $Y=5020 $D=27
M97 VDD RN 7 796 pmos L=0.15 W=2 AD=0.56 AS=0.56 PD=2.56 PS=2.56 NRD=0 NRS=0 m=1 $X=34145 $Y=5020 $D=27
M98 8 7 VDD 796 pmos L=0.15 W=2 AD=0.57 AS=0.57 PD=2.57 PS=2.57 NRD=0 NRS=0 m=1 $X=36455 $Y=5020 $D=27
M99 VDD 7 8 796 pmos L=0.15 W=2 AD=0.58 AS=0.58 PD=2.58 PS=2.58 NRD=0 NRS=0 m=1 $X=36895 $Y=5020 $D=27
M100 8 11 VDD 796 pmos L=0.15 W=2 AD=0.58 AS=0.58 PD=2.58 PS=2.58 NRD=0 NRS=0 m=1 $X=37335 $Y=5020 $D=27
M101 VDD 11 8 796 pmos L=0.15 W=2 AD=0.56 AS=0.56 PD=2.56 PS=2.56 NRD=0 NRS=0 m=1 $X=37775 $Y=5020 $D=27
M102 11 8 VDD 796 pmos L=0.15 W=2 AD=0.57 AS=0.57 PD=2.57 PS=2.57 NRD=0 NRS=0 m=1 $X=40085 $Y=5020 $D=27
M103 VDD 8 11 796 pmos L=0.15 W=2 AD=0.58 AS=0.58 PD=2.58 PS=2.58 NRD=0 NRS=0 m=1 $X=40525 $Y=5020 $D=27
M104 11 CLK VDD 796 pmos L=0.15 W=2 AD=0.58 AS=0.58 PD=2.58 PS=2.58 NRD=0 NRS=0 m=1 $X=40965 $Y=5020 $D=27
M105 VDD CLK 11 796 pmos L=0.15 W=2 AD=0.58 AS=0.58 PD=2.58 PS=2.58 NRD=0 NRS=0 m=1 $X=41405 $Y=5020 $D=27
M106 11 RN VDD 796 pmos L=0.15 W=2 AD=0.58 AS=0.58 PD=2.58 PS=2.58 NRD=0 NRS=0 m=1 $X=41845 $Y=5020 $D=27
M107 VDD RN 11 796 pmos L=0.15 W=2 AD=0.56 AS=0.56 PD=2.56 PS=2.56 NRD=0 NRS=0 m=1 $X=42285 $Y=5020 $D=27
M108 10 9 VDD 796 pmos L=0.15 W=2 AD=0.57 AS=0.57 PD=2.57 PS=2.57 NRD=0 NRS=0 m=1 $X=44895 $Y=5020 $D=27
M109 VDD 9 10 796 pmos L=0.15 W=2 AD=0.58 AS=0.58 PD=2.58 PS=2.58 NRD=0 NRS=0 m=1 $X=45335 $Y=5020 $D=27
M110 10 RN VDD 796 pmos L=0.15 W=2 AD=0.58 AS=0.58 PD=2.58 PS=2.58 NRD=0 NRS=0 m=1 $X=45775 $Y=5020 $D=27
M111 VDD RN 10 796 pmos L=0.15 W=2 AD=0.58 AS=0.58 PD=2.58 PS=2.58 NRD=0 NRS=0 m=1 $X=46215 $Y=5020 $D=27
M112 10 17 VDD 796 pmos L=0.15 W=2 AD=0.58 AS=0.58 PD=2.58 PS=2.58 NRD=0 NRS=0 m=1 $X=46655 $Y=5020 $D=27
M113 VDD 17 10 796 pmos L=0.15 W=2 AD=0.56 AS=0.56 PD=2.56 PS=2.56 NRD=0 NRS=0 m=1 $X=47095 $Y=5020 $D=27
M114 17 10 VDD 796 pmos L=0.15 W=2 AD=0.57 AS=0.57 PD=2.57 PS=2.57 NRD=0 NRS=0 m=1 $X=49405 $Y=5020 $D=27
M115 VDD 10 17 796 pmos L=0.15 W=2 AD=0.58 AS=0.58 PD=2.58 PS=2.58 NRD=0 NRS=0 m=1 $X=49845 $Y=5020 $D=27
M116 17 11 VDD 796 pmos L=0.15 W=2 AD=0.58 AS=0.58 PD=2.58 PS=2.58 NRD=0 NRS=0 m=1 $X=50285 $Y=5020 $D=27
M117 VDD 11 17 796 pmos L=0.15 W=2 AD=0.56 AS=0.56 PD=2.56 PS=2.56 NRD=0 NRS=0 m=1 $X=50725 $Y=5020 $D=27
M118 14 16 VDD 796 pmos L=0.15 W=2 AD=0.57 AS=0.57 PD=2.57 PS=2.57 NRD=0 NRS=0 m=1 $X=53035 $Y=5020 $D=27
M119 VDD 16 14 796 pmos L=0.15 W=2 AD=0.58 AS=0.58 PD=2.58 PS=2.58 NRD=0 NRS=0 m=1 $X=53475 $Y=5020 $D=27
M120 14 CLK VDD 796 pmos L=0.15 W=2 AD=0.58 AS=0.58 PD=2.58 PS=2.58 NRD=0 NRS=0 m=1 $X=53915 $Y=5020 $D=27
M121 VDD CLK 14 796 pmos L=0.15 W=2 AD=0.58 AS=0.58 PD=2.58 PS=2.58 NRD=0 NRS=0 m=1 $X=54355 $Y=5020 $D=27
M122 14 17 VDD 796 pmos L=0.15 W=2 AD=0.58 AS=0.58 PD=2.58 PS=2.58 NRD=0 NRS=0 m=1 $X=54795 $Y=5020 $D=27
M123 VDD 17 14 796 pmos L=0.15 W=2 AD=0.56 AS=0.56 PD=2.56 PS=2.56 NRD=0 NRS=0 m=1 $X=55235 $Y=5020 $D=27
M124 17 14 VDD 796 pmos L=0.15 W=2 AD=0.57 AS=0.57 PD=2.57 PS=2.57 NRD=0 NRS=0 m=1 $X=57845 $Y=5020 $D=27
M125 VDD 14 17 796 pmos L=0.15 W=2 AD=0.58 AS=0.58 PD=2.58 PS=2.58 NRD=0 NRS=0 m=1 $X=58285 $Y=5020 $D=27
M126 17 D VDD 796 pmos L=0.15 W=2 AD=0.58 AS=0.58 PD=2.58 PS=2.58 NRD=0 NRS=0 m=1 $X=58725 $Y=5020 $D=27
M127 VDD D 17 796 pmos L=0.15 W=2 AD=0.58 AS=0.58 PD=2.58 PS=2.58 NRD=0 NRS=0 m=1 $X=59165 $Y=5020 $D=27
M128 17 RN VDD 796 pmos L=0.15 W=2 AD=0.58 AS=0.58 PD=2.58 PS=2.58 NRD=0 NRS=0 m=1 $X=59605 $Y=5020 $D=27
M129 VDD RN 17 796 pmos L=0.15 W=2 AD=0.56 AS=0.56 PD=2.56 PS=2.56 NRD=0 NRS=0 m=1 $X=60045 $Y=5020 $D=27
M130 17 17 VDD 796 pmos L=0.15 W=2 AD=0.57 AS=0.57 PD=2.57 PS=2.57 NRD=0 NRS=0 m=1 $X=62355 $Y=5020 $D=27
M131 VDD 17 17 796 pmos L=0.15 W=2 AD=0.58 AS=0.58 PD=2.58 PS=2.58 NRD=0 NRS=0 m=1 $X=62795 $Y=5020 $D=27
M132 17 16 VDD 796 pmos L=0.15 W=2 AD=0.58 AS=0.58 PD=2.58 PS=2.58 NRD=0 NRS=0 m=1 $X=63235 $Y=5020 $D=27
M133 VDD 16 17 796 pmos L=0.15 W=2 AD=0.56 AS=0.56 PD=2.56 PS=2.56 NRD=0 NRS=0 m=1 $X=63675 $Y=5020 $D=27
M134 16 17 VDD 796 pmos L=0.15 W=2 AD=0.57 AS=0.57 PD=2.57 PS=2.57 NRD=0 NRS=0 m=1 $X=65985 $Y=5020 $D=27
M135 VDD 17 16 796 pmos L=0.15 W=2 AD=0.58 AS=0.58 PD=2.58 PS=2.58 NRD=0 NRS=0 m=1 $X=66425 $Y=5020 $D=27
M136 16 CLK VDD 796 pmos L=0.15 W=2 AD=0.58 AS=0.58 PD=2.58 PS=2.58 NRD=0 NRS=0 m=1 $X=66865 $Y=5020 $D=27
M137 VDD CLK 16 796 pmos L=0.15 W=2 AD=0.58 AS=0.58 PD=2.58 PS=2.58 NRD=0 NRS=0 m=1 $X=67305 $Y=5020 $D=27
M138 16 RN VDD 796 pmos L=0.15 W=2 AD=0.58 AS=0.58 PD=2.58 PS=2.58 NRD=0 NRS=0 m=1 $X=67745 $Y=5020 $D=27
M139 VDD RN 16 796 pmos L=0.15 W=2 AD=0.56 AS=0.56 PD=2.56 PS=2.56 NRD=0 NRS=0 m=1 $X=68185 $Y=5020 $D=27
M140 16 14 VDD 796 pmos L=0.15 W=2 AD=0.57 AS=0.57 PD=2.57 PS=2.57 NRD=0 NRS=0 m=1 $X=70795 $Y=5020 $D=27
M141 VDD 14 16 796 pmos L=0.15 W=2 AD=0.58 AS=0.58 PD=2.58 PS=2.58 NRD=0 NRS=0 m=1 $X=71235 $Y=5020 $D=27
M142 16 RN VDD 796 pmos L=0.15 W=2 AD=0.58 AS=0.58 PD=2.58 PS=2.58 NRD=0 NRS=0 m=1 $X=71675 $Y=5020 $D=27
M143 VDD RN 16 796 pmos L=0.15 W=2 AD=0.58 AS=0.58 PD=2.58 PS=2.58 NRD=0 NRS=0 m=1 $X=72115 $Y=5020 $D=27
M144 16 18 VDD 796 pmos L=0.15 W=2 AD=0.58 AS=0.58 PD=2.58 PS=2.58 NRD=0 NRS=0 m=1 $X=72555 $Y=5020 $D=27
M145 VDD 18 16 796 pmos L=0.15 W=2 AD=0.56 AS=0.56 PD=2.56 PS=2.56 NRD=0 NRS=0 m=1 $X=72995 $Y=5020 $D=27
M146 18 16 VDD 796 pmos L=0.15 W=2 AD=0.57 AS=0.57 PD=2.57 PS=2.57 NRD=0 NRS=0 m=1 $X=75305 $Y=5020 $D=27
M147 VDD 16 18 796 pmos L=0.15 W=2 AD=0.58 AS=0.58 PD=2.58 PS=2.58 NRD=0 NRS=0 m=1 $X=75745 $Y=5020 $D=27
M148 18 16 VDD 796 pmos L=0.15 W=2 AD=0.58 AS=0.58 PD=2.58 PS=2.58 NRD=0 NRS=0 m=1 $X=76185 $Y=5020 $D=27
M149 VDD 16 18 796 pmos L=0.15 W=2 AD=0.56 AS=0.56 PD=2.56 PS=2.56 NRD=0 NRS=0 m=1 $X=76625 $Y=5020 $D=27
M150 19 17 VDD 796 pmos L=0.15 W=2 AD=0.57 AS=0.57 PD=2.57 PS=2.57 NRD=0 NRS=0 m=1 $X=78635 $Y=5025 $D=27
M151 VDD 17 19 796 pmos L=0.15 W=2 AD=0.58 AS=0.58 PD=2.58 PS=2.58 NRD=0 NRS=0 m=1 $X=79075 $Y=5025 $D=27
M152 19 18 VDD 796 pmos L=0.15 W=2 AD=0.58 AS=0.58 PD=2.58 PS=2.58 NRD=0 NRS=0 m=1 $X=79515 $Y=5025 $D=27
M153 VDD 18 19 796 pmos L=0.15 W=2 AD=0.56 AS=0.56 PD=2.56 PS=2.56 NRD=0 NRS=0 m=1 $X=79955 $Y=5025 $D=27
M154 21 17 19 796 pmos L=0.15 W=2 AD=0.56 AS=0.56 PD=2.56 PS=2.56 NRD=0 NRS=0 m=1 $X=81955 $Y=5025 $D=27
M155 19 17 21 796 pmos L=0.15 W=2 AD=0.58 AS=0.58 PD=2.58 PS=2.58 NRD=0 NRS=0 m=1 $X=82395 $Y=5025 $D=27
M156 21 20 19 796 pmos L=0.15 W=2 AD=0.58 AS=0.58 PD=2.58 PS=2.58 NRD=0 NRS=0 m=1 $X=82835 $Y=5025 $D=27
M157 19 20 21 796 pmos L=0.15 W=2 AD=0.57 AS=0.57 PD=2.57 PS=2.57 NRD=0 NRS=0 m=1 $X=83275 $Y=5025 $D=27
M158 QN 20 21 796 pmos L=0.15 W=2 AD=0.57 AS=0.57 PD=2.57 PS=2.57 NRD=0 NRS=0 m=1 $X=85295 $Y=5025 $D=27
M159 21 20 QN 796 pmos L=0.15 W=2 AD=0.58 AS=0.58 PD=2.58 PS=2.58 NRD=0 NRS=0 m=1 $X=85735 $Y=5025 $D=27
M160 QN 18 21 796 pmos L=0.15 W=2 AD=0.58 AS=0.58 PD=2.58 PS=2.58 NRD=0 NRS=0 m=1 $X=86175 $Y=5025 $D=27
M161 21 18 QN 796 pmos L=0.15 W=2 AD=0.56 AS=0.56 PD=2.56 PS=2.56 NRD=0 NRS=0 m=1 $X=86615 $Y=5025 $D=27
.ENDS
***************************************
