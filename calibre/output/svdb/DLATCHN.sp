* SPICE NETLIST
***************************************

.SUBCKT pad_bond pin0
.ENDS
***************************************
.SUBCKT pad_microprobe pin0
.ENDS
***************************************
.SUBCKT pad_probe pin0
.ENDS
***************************************
.SUBCKT nmos_de_iso_v20 src gate drn b sub
.ENDS
***************************************
.SUBCKT DLATCHN GND VDD D Q GATE_N
** N=249 EP=5 IP=0 FDC=36
M0 5 GATE_N GND 249 nmos L=0.163346 W=2.31104 $X=775 $Y=830 $D=3
M1 3 D GND 249 nmos L=0.163346 W=2.31104 $X=2995 $Y=830 $D=3
M2 GND 3 13 249 nmos L=0.163119 W=2.35104 $X=5280 $Y=785 $D=3
M3 4 5 13 249 nmos L=0.163346 W=2.31104 $X=6250 $Y=825 $D=3
M4 8 4 GND 249 nmos L=0.163346 W=2.31104 $X=8545 $Y=830 $D=3
M5 GND 5 14 249 nmos L=0.163119 W=2.35104 $X=10830 $Y=785 $D=3
M6 7 D 14 249 nmos L=0.163346 W=2.31104 $X=11800 $Y=825 $D=3
M7 10 7 GND 249 nmos L=0.163346 W=2.31104 $X=14095 $Y=830 $D=3
M8 Q 8 GND 249 nmos L=0.163346 W=2.31104 $X=16380 $Y=825 $D=3
M9 Q 11 GND 249 nmos L=0.163129 W=2.31397 $X=17350 $Y=825 $D=3
M10 11 Q GND 249 nmos L=0.163346 W=2.31104 $X=19710 $Y=825 $D=3
M11 11 10 GND 249 nmos L=0.163129 W=2.31397 $X=20680 $Y=825 $D=3
M12 5 GATE_N VDD 247 pmos L=0.15 W=2 AD=0.57 AS=0.57 PD=2.57 PS=2.57 NRD=0 NRS=0 m=1 $X=820 $Y=5020 $D=27
M13 VDD GATE_N 5 247 pmos L=0.15 W=2 AD=0.56 AS=0.56 PD=2.56 PS=2.56 NRD=0 NRS=0 m=1 $X=1260 $Y=5020 $D=27
M14 3 D VDD 247 pmos L=0.15 W=2 AD=0.57 AS=0.57 PD=2.57 PS=2.57 NRD=0 NRS=0 m=1 $X=3040 $Y=5020 $D=27
M15 VDD D 3 247 pmos L=0.15 W=2 AD=0.56 AS=0.56 PD=2.56 PS=2.56 NRD=0 NRS=0 m=1 $X=3480 $Y=5020 $D=27
M16 4 3 VDD 247 pmos L=0.15 W=2 AD=0.57 AS=0.57 PD=2.57 PS=2.57 NRD=0 NRS=0 m=1 $X=5375 $Y=5020 $D=27
M17 VDD 3 4 247 pmos L=0.15 W=2 AD=0.58 AS=0.58 PD=2.58 PS=2.58 NRD=0 NRS=0 m=1 $X=5815 $Y=5020 $D=27
M18 4 5 VDD 247 pmos L=0.15 W=2 AD=0.58 AS=0.58 PD=2.58 PS=2.58 NRD=0 NRS=0 m=1 $X=6255 $Y=5020 $D=27
M19 VDD 5 4 247 pmos L=0.15 W=2 AD=0.56 AS=0.56 PD=2.56 PS=2.56 NRD=0 NRS=0 m=1 $X=6695 $Y=5020 $D=27
M20 8 4 VDD 247 pmos L=0.15 W=2 AD=0.57 AS=0.57 PD=2.57 PS=2.57 NRD=0 NRS=0 m=1 $X=8590 $Y=5020 $D=27
M21 VDD 4 8 247 pmos L=0.15 W=2 AD=0.56 AS=0.56 PD=2.56 PS=2.56 NRD=0 NRS=0 m=1 $X=9030 $Y=5020 $D=27
M22 7 5 VDD 247 pmos L=0.15 W=2 AD=0.57 AS=0.57 PD=2.57 PS=2.57 NRD=0 NRS=0 m=1 $X=10925 $Y=5020 $D=27
M23 VDD 5 7 247 pmos L=0.15 W=2 AD=0.58 AS=0.58 PD=2.58 PS=2.58 NRD=0 NRS=0 m=1 $X=11365 $Y=5020 $D=27
M24 7 D VDD 247 pmos L=0.15 W=2 AD=0.58 AS=0.58 PD=2.58 PS=2.58 NRD=0 NRS=0 m=1 $X=11805 $Y=5020 $D=27
M25 VDD D 7 247 pmos L=0.15 W=2 AD=0.56 AS=0.56 PD=2.56 PS=2.56 NRD=0 NRS=0 m=1 $X=12245 $Y=5020 $D=27
M26 10 7 VDD 247 pmos L=0.15 W=2 AD=0.57 AS=0.57 PD=2.57 PS=2.57 NRD=0 NRS=0 m=1 $X=14140 $Y=5020 $D=27
M27 VDD 7 10 247 pmos L=0.15 W=2 AD=0.56 AS=0.56 PD=2.56 PS=2.56 NRD=0 NRS=0 m=1 $X=14580 $Y=5020 $D=27
M28 VDD 8 15 247 pmos L=0.15 W=2 AD=0.57 AS=0.57 PD=2.57 PS=2.57 NRD=0 NRS=0 m=1 $X=16475 $Y=5025 $D=27
M29 15 8 VDD 247 pmos L=0.15 W=2 AD=0.58 AS=0.58 PD=2.58 PS=2.58 NRD=0 NRS=0 m=1 $X=16915 $Y=5025 $D=27
M30 Q 11 15 247 pmos L=0.15 W=2 AD=0.58 AS=0.58 PD=2.58 PS=2.58 NRD=0 NRS=0 m=1 $X=17355 $Y=5025 $D=27
M31 15 11 Q 247 pmos L=0.15 W=2 AD=0.56 AS=0.56 PD=2.56 PS=2.56 NRD=0 NRS=0 m=1 $X=17795 $Y=5025 $D=27
M32 VDD Q 16 247 pmos L=0.15 W=2 AD=0.57 AS=0.57 PD=2.57 PS=2.57 NRD=0 NRS=0 m=1 $X=19805 $Y=5025 $D=27
M33 16 Q VDD 247 pmos L=0.15 W=2 AD=0.58 AS=0.58 PD=2.58 PS=2.58 NRD=0 NRS=0 m=1 $X=20245 $Y=5025 $D=27
M34 11 10 16 247 pmos L=0.15 W=2 AD=0.58 AS=0.58 PD=2.58 PS=2.58 NRD=0 NRS=0 m=1 $X=20685 $Y=5025 $D=27
M35 16 10 11 247 pmos L=0.15 W=2 AD=0.56 AS=0.56 PD=2.56 PS=2.56 NRD=0 NRS=0 m=1 $X=21125 $Y=5025 $D=27
.ENDS
***************************************
