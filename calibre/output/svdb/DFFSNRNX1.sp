* SPICE NETLIST
***************************************

.SUBCKT pad_bond pin0
.ENDS
***************************************
.SUBCKT pad_microprobe pin0
.ENDS
***************************************
.SUBCKT pad_probe pin0
.ENDS
***************************************
.SUBCKT nmos_de_iso_v20 src gate drn b sub
.ENDS
***************************************
.SUBCKT DFFSNRNX1 GND VDD CLK RN QN SN Q D
** N=269 EP=8 IP=0 FDC=54
M0 GND D 13 269 nmos L=0.163119 W=2.35104 $X=735 $Y=795 $D=3
M1 14 RN 13 269 nmos L=0.160516 W=2.29447 $X=1710 $Y=830 $D=3
M2 3 6 14 269 nmos L=0.163346 W=2.31104 $X=3245 $Y=835 $D=3
M3 GND 3 15 269 nmos L=0.163119 W=2.35104 $X=5545 $Y=795 $D=3
M4 16 CLK 15 269 nmos L=0.160516 W=2.29447 $X=6520 $Y=830 $D=3
M5 6 10 16 269 nmos L=0.163346 W=2.31104 $X=8055 $Y=835 $D=3
M6 GND 3 17 269 nmos L=0.163119 W=2.35104 $X=10355 $Y=795 $D=3
M7 18 SN 17 269 nmos L=0.160516 W=2.29447 $X=11330 $Y=830 $D=3
M8 4 10 18 269 nmos L=0.163346 W=2.31104 $X=12865 $Y=835 $D=3
M9 GND 4 19 269 nmos L=0.163119 W=2.35104 $X=15165 $Y=795 $D=3
M10 20 CLK 19 269 nmos L=0.160516 W=2.29447 $X=16140 $Y=830 $D=3
M11 10 RN 20 269 nmos L=0.163346 W=2.31104 $X=17675 $Y=835 $D=3
M12 GND 6 21 269 nmos L=0.163119 W=2.35104 $X=19975 $Y=795 $D=3
M13 22 RN 21 269 nmos L=0.160516 W=2.29447 $X=20950 $Y=830 $D=3
M14 QN Q 22 269 nmos L=0.163346 W=2.31104 $X=22485 $Y=835 $D=3
M15 GND QN 23 269 nmos L=0.163119 W=2.35104 $X=24785 $Y=795 $D=3
M16 24 SN 23 269 nmos L=0.160516 W=2.29447 $X=25760 $Y=830 $D=3
M17 Q 10 24 269 nmos L=0.163346 W=2.31104 $X=27295 $Y=835 $D=3
M18 3 D VDD 267 pmos L=0.15 W=2 AD=0.57 AS=0.57 PD=2.57 PS=2.57 NRD=0 NRS=0 m=1 $X=1235 $Y=5020 $D=27
M19 VDD D 3 267 pmos L=0.15 W=2 AD=0.58 AS=0.58 PD=2.58 PS=2.58 NRD=0 NRS=0 m=1 $X=1675 $Y=5020 $D=27
M20 3 RN VDD 267 pmos L=0.15 W=2 AD=0.58 AS=0.58 PD=2.58 PS=2.58 NRD=0 NRS=0 m=1 $X=2115 $Y=5020 $D=27
M21 VDD RN 3 267 pmos L=0.15 W=2 AD=0.58 AS=0.58 PD=2.58 PS=2.58 NRD=0 NRS=0 m=1 $X=2555 $Y=5020 $D=27
M22 3 6 VDD 267 pmos L=0.15 W=2 AD=0.58 AS=0.58 PD=2.58 PS=2.58 NRD=0 NRS=0 m=1 $X=2995 $Y=5020 $D=27
M23 VDD 6 3 267 pmos L=0.15 W=2 AD=0.56 AS=0.56 PD=2.56 PS=2.56 NRD=0 NRS=0 m=1 $X=3435 $Y=5020 $D=27
M24 6 3 VDD 267 pmos L=0.15 W=2 AD=0.57 AS=0.57 PD=2.57 PS=2.57 NRD=0 NRS=0 m=1 $X=6045 $Y=5020 $D=27
M25 VDD 3 6 267 pmos L=0.15 W=2 AD=0.58 AS=0.58 PD=2.58 PS=2.58 NRD=0 NRS=0 m=1 $X=6485 $Y=5020 $D=27
M26 6 CLK VDD 267 pmos L=0.15 W=2 AD=0.58 AS=0.58 PD=2.58 PS=2.58 NRD=0 NRS=0 m=1 $X=6925 $Y=5020 $D=27
M27 VDD CLK 6 267 pmos L=0.15 W=2 AD=0.58 AS=0.58 PD=2.58 PS=2.58 NRD=0 NRS=0 m=1 $X=7365 $Y=5020 $D=27
M28 6 10 VDD 267 pmos L=0.15 W=2 AD=0.58 AS=0.58 PD=2.58 PS=2.58 NRD=0 NRS=0 m=1 $X=7805 $Y=5020 $D=27
M29 VDD 10 6 267 pmos L=0.15 W=2 AD=0.56 AS=0.56 PD=2.56 PS=2.56 NRD=0 NRS=0 m=1 $X=8245 $Y=5020 $D=27
M30 4 3 VDD 267 pmos L=0.15 W=2 AD=0.57 AS=0.57 PD=2.57 PS=2.57 NRD=0 NRS=0 m=1 $X=10855 $Y=5020 $D=27
M31 VDD 3 4 267 pmos L=0.15 W=2 AD=0.58 AS=0.58 PD=2.58 PS=2.58 NRD=0 NRS=0 m=1 $X=11295 $Y=5020 $D=27
M32 4 SN VDD 267 pmos L=0.15 W=2 AD=0.58 AS=0.58 PD=2.58 PS=2.58 NRD=0 NRS=0 m=1 $X=11735 $Y=5020 $D=27
M33 VDD SN 4 267 pmos L=0.15 W=2 AD=0.58 AS=0.58 PD=2.58 PS=2.58 NRD=0 NRS=0 m=1 $X=12175 $Y=5020 $D=27
M34 4 10 VDD 267 pmos L=0.15 W=2 AD=0.58 AS=0.58 PD=2.58 PS=2.58 NRD=0 NRS=0 m=1 $X=12615 $Y=5020 $D=27
M35 VDD 10 4 267 pmos L=0.15 W=2 AD=0.56 AS=0.56 PD=2.56 PS=2.56 NRD=0 NRS=0 m=1 $X=13055 $Y=5020 $D=27
M36 10 4 VDD 267 pmos L=0.15 W=2 AD=0.57 AS=0.57 PD=2.57 PS=2.57 NRD=0 NRS=0 m=1 $X=15665 $Y=5020 $D=27
M37 VDD 4 10 267 pmos L=0.15 W=2 AD=0.58 AS=0.58 PD=2.58 PS=2.58 NRD=0 NRS=0 m=1 $X=16105 $Y=5020 $D=27
M38 10 CLK VDD 267 pmos L=0.15 W=2 AD=0.58 AS=0.58 PD=2.58 PS=2.58 NRD=0 NRS=0 m=1 $X=16545 $Y=5020 $D=27
M39 VDD CLK 10 267 pmos L=0.15 W=2 AD=0.58 AS=0.58 PD=2.58 PS=2.58 NRD=0 NRS=0 m=1 $X=16985 $Y=5020 $D=27
M40 10 RN VDD 267 pmos L=0.15 W=2 AD=0.58 AS=0.58 PD=2.58 PS=2.58 NRD=0 NRS=0 m=1 $X=17425 $Y=5020 $D=27
M41 VDD RN 10 267 pmos L=0.15 W=2 AD=0.56 AS=0.56 PD=2.56 PS=2.56 NRD=0 NRS=0 m=1 $X=17865 $Y=5020 $D=27
M42 QN 6 VDD 267 pmos L=0.15 W=2 AD=0.57 AS=0.57 PD=2.57 PS=2.57 NRD=0 NRS=0 m=1 $X=20475 $Y=5020 $D=27
M43 VDD 6 QN 267 pmos L=0.15 W=2 AD=0.58 AS=0.58 PD=2.58 PS=2.58 NRD=0 NRS=0 m=1 $X=20915 $Y=5020 $D=27
M44 QN RN VDD 267 pmos L=0.15 W=2 AD=0.58 AS=0.58 PD=2.58 PS=2.58 NRD=0 NRS=0 m=1 $X=21355 $Y=5020 $D=27
M45 VDD RN QN 267 pmos L=0.15 W=2 AD=0.58 AS=0.58 PD=2.58 PS=2.58 NRD=0 NRS=0 m=1 $X=21795 $Y=5020 $D=27
M46 QN Q VDD 267 pmos L=0.15 W=2 AD=0.58 AS=0.58 PD=2.58 PS=2.58 NRD=0 NRS=0 m=1 $X=22235 $Y=5020 $D=27
M47 VDD Q QN 267 pmos L=0.15 W=2 AD=0.56 AS=0.56 PD=2.56 PS=2.56 NRD=0 NRS=0 m=1 $X=22675 $Y=5020 $D=27
M48 Q QN VDD 267 pmos L=0.15 W=2 AD=0.57 AS=0.57 PD=2.57 PS=2.57 NRD=0 NRS=0 m=1 $X=25285 $Y=5020 $D=27
M49 VDD QN Q 267 pmos L=0.15 W=2 AD=0.58 AS=0.58 PD=2.58 PS=2.58 NRD=0 NRS=0 m=1 $X=25725 $Y=5020 $D=27
M50 Q SN VDD 267 pmos L=0.15 W=2 AD=0.58 AS=0.58 PD=2.58 PS=2.58 NRD=0 NRS=0 m=1 $X=26165 $Y=5020 $D=27
M51 VDD SN Q 267 pmos L=0.15 W=2 AD=0.58 AS=0.58 PD=2.58 PS=2.58 NRD=0 NRS=0 m=1 $X=26605 $Y=5020 $D=27
M52 Q 10 VDD 267 pmos L=0.15 W=2 AD=0.58 AS=0.58 PD=2.58 PS=2.58 NRD=0 NRS=0 m=1 $X=27045 $Y=5020 $D=27
M53 VDD 10 Q 267 pmos L=0.15 W=2 AD=0.56 AS=0.56 PD=2.56 PS=2.56 NRD=0 NRS=0 m=1 $X=27485 $Y=5020 $D=27
.ENDS
***************************************
