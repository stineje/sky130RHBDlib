* SPICE NETLIST
***************************************

.SUBCKT pad_bond pin0
.ENDS
***************************************
.SUBCKT pad_microprobe pin0
.ENDS
***************************************
.SUBCKT pad_probe pin0
.ENDS
***************************************
.SUBCKT nmos_de_iso_v20 src gate drn b sub
.ENDS
***************************************
.SUBCKT TMRDFFSNRNQNX1 GND VDD D CLK RN SN Q
** N=857 EP=7 IP=0 FDC=180
M0 GND D 28 857 nmos L=0.163119 W=2.35104 $X=735 $Y=795 $D=3
M1 29 RN 28 857 nmos L=0.160516 W=2.29447 $X=1710 $Y=830 $D=3
M2 3 5 29 857 nmos L=0.163346 W=2.31104 $X=3245 $Y=835 $D=3
M3 GND 3 30 857 nmos L=0.163119 W=2.35104 $X=5545 $Y=795 $D=3
M4 31 CLK 30 857 nmos L=0.160516 W=2.29447 $X=6520 $Y=830 $D=3
M5 5 7 31 857 nmos L=0.163346 W=2.31104 $X=8055 $Y=835 $D=3
M6 GND 3 32 857 nmos L=0.163119 W=2.35104 $X=10355 $Y=795 $D=3
M7 33 SN 32 857 nmos L=0.160516 W=2.29447 $X=11330 $Y=830 $D=3
M8 4 7 33 857 nmos L=0.163346 W=2.31104 $X=12865 $Y=835 $D=3
M9 GND 4 34 857 nmos L=0.163119 W=2.35104 $X=15165 $Y=795 $D=3
M10 35 CLK 34 857 nmos L=0.160516 W=2.29447 $X=16140 $Y=830 $D=3
M11 7 RN 35 857 nmos L=0.163346 W=2.31104 $X=17675 $Y=835 $D=3
M12 GND 5 36 857 nmos L=0.163119 W=2.35104 $X=19975 $Y=795 $D=3
M13 37 RN 36 857 nmos L=0.160516 W=2.29447 $X=20950 $Y=830 $D=3
M14 6 8 37 857 nmos L=0.163346 W=2.31104 $X=22485 $Y=835 $D=3
M15 GND 6 38 857 nmos L=0.163119 W=2.35104 $X=24785 $Y=795 $D=3
M16 39 SN 38 857 nmos L=0.160516 W=2.29447 $X=25760 $Y=830 $D=3
M17 8 7 39 857 nmos L=0.163346 W=2.31104 $X=27295 $Y=835 $D=3
M18 GND D 40 857 nmos L=0.163119 W=2.35104 $X=29595 $Y=795 $D=3
M19 41 RN 40 857 nmos L=0.160516 W=2.29447 $X=30570 $Y=830 $D=3
M20 9 11 41 857 nmos L=0.163346 W=2.31104 $X=32105 $Y=835 $D=3
M21 GND 9 42 857 nmos L=0.163119 W=2.35104 $X=34405 $Y=795 $D=3
M22 43 CLK 42 857 nmos L=0.160516 W=2.29447 $X=35380 $Y=830 $D=3
M23 11 12 43 857 nmos L=0.163346 W=2.31104 $X=36915 $Y=835 $D=3
M24 GND 9 44 857 nmos L=0.163119 W=2.35104 $X=39215 $Y=795 $D=3
M25 45 SN 44 857 nmos L=0.160516 W=2.29447 $X=40190 $Y=830 $D=3
M26 10 12 45 857 nmos L=0.163346 W=2.31104 $X=41725 $Y=835 $D=3
M27 GND 10 46 857 nmos L=0.163119 W=2.35104 $X=44025 $Y=795 $D=3
M28 47 CLK 46 857 nmos L=0.160516 W=2.29447 $X=45000 $Y=830 $D=3
M29 12 RN 47 857 nmos L=0.163346 W=2.31104 $X=46535 $Y=835 $D=3
M30 GND 11 48 857 nmos L=0.163119 W=2.35104 $X=48835 $Y=795 $D=3
M31 49 RN 48 857 nmos L=0.160516 W=2.29447 $X=49810 $Y=830 $D=3
M32 26 13 49 857 nmos L=0.163346 W=2.31104 $X=51345 $Y=835 $D=3
M33 GND 26 50 857 nmos L=0.163119 W=2.35104 $X=53645 $Y=795 $D=3
M34 51 SN 50 857 nmos L=0.160516 W=2.29447 $X=54620 $Y=830 $D=3
M35 13 12 51 857 nmos L=0.163346 W=2.31104 $X=56155 $Y=835 $D=3
M36 GND D 52 857 nmos L=0.163119 W=2.35104 $X=58455 $Y=795 $D=3
M37 53 RN 52 857 nmos L=0.160516 W=2.29447 $X=59430 $Y=830 $D=3
M38 15 18 53 857 nmos L=0.163346 W=2.31104 $X=60965 $Y=835 $D=3
M39 GND 15 54 857 nmos L=0.163119 W=2.35104 $X=63265 $Y=795 $D=3
M40 55 CLK 54 857 nmos L=0.160516 W=2.29447 $X=64240 $Y=830 $D=3
M41 18 21 55 857 nmos L=0.163346 W=2.31104 $X=65775 $Y=835 $D=3
M42 GND 15 56 857 nmos L=0.163119 W=2.35104 $X=68075 $Y=795 $D=3
M43 57 SN 56 857 nmos L=0.160516 W=2.29447 $X=69050 $Y=830 $D=3
M44 16 21 57 857 nmos L=0.163346 W=2.31104 $X=70585 $Y=835 $D=3
M45 GND 16 58 857 nmos L=0.163119 W=2.35104 $X=72885 $Y=795 $D=3
M46 59 CLK 58 857 nmos L=0.160516 W=2.29447 $X=73860 $Y=830 $D=3
M47 21 RN 59 857 nmos L=0.163346 W=2.31104 $X=75395 $Y=835 $D=3
M48 GND 18 60 857 nmos L=0.163119 W=2.35104 $X=77695 $Y=795 $D=3
M49 61 RN 60 857 nmos L=0.160516 W=2.29447 $X=78670 $Y=830 $D=3
M50 24 22 61 857 nmos L=0.163346 W=2.31104 $X=80205 $Y=835 $D=3
M51 GND 24 62 857 nmos L=0.163119 W=2.35104 $X=82505 $Y=795 $D=3
M52 63 SN 62 857 nmos L=0.160516 W=2.29447 $X=83480 $Y=830 $D=3
M53 22 21 63 857 nmos L=0.163346 W=2.31104 $X=85015 $Y=835 $D=3
M54 GND 6 64 857 nmos L=0.163119 W=2.35104 $X=87420 $Y=785 $D=3
M55 Q 26 64 857 nmos L=0.163346 W=2.31104 $X=88390 $Y=825 $D=3
M56 GND 6 65 857 nmos L=0.163119 W=2.35104 $X=90750 $Y=785 $D=3
M57 Q 24 65 857 nmos L=0.163346 W=2.31104 $X=91720 $Y=825 $D=3
M58 GND 24 66 857 nmos L=0.163119 W=2.35104 $X=94080 $Y=785 $D=3
M59 Q 26 66 857 nmos L=0.163129 W=2.31397 $X=95050 $Y=825 $D=3
M60 3 D VDD 855 pmos L=0.15 W=2 AD=0.57 AS=0.57 PD=2.57 PS=2.57 NRD=0 NRS=0 m=1 $X=1235 $Y=5020 $D=27
M61 VDD D 3 855 pmos L=0.15 W=2 AD=0.58 AS=0.58 PD=2.58 PS=2.58 NRD=0 NRS=0 m=1 $X=1675 $Y=5020 $D=27
M62 3 RN VDD 855 pmos L=0.15 W=2 AD=0.58 AS=0.58 PD=2.58 PS=2.58 NRD=0 NRS=0 m=1 $X=2115 $Y=5020 $D=27
M63 VDD RN 3 855 pmos L=0.15 W=2 AD=0.58 AS=0.58 PD=2.58 PS=2.58 NRD=0 NRS=0 m=1 $X=2555 $Y=5020 $D=27
M64 3 5 VDD 855 pmos L=0.15 W=2 AD=0.58 AS=0.58 PD=2.58 PS=2.58 NRD=0 NRS=0 m=1 $X=2995 $Y=5020 $D=27
M65 VDD 5 3 855 pmos L=0.15 W=2 AD=0.56 AS=0.56 PD=2.56 PS=2.56 NRD=0 NRS=0 m=1 $X=3435 $Y=5020 $D=27
M66 5 3 VDD 855 pmos L=0.15 W=2 AD=0.57 AS=0.57 PD=2.57 PS=2.57 NRD=0 NRS=0 m=1 $X=6045 $Y=5020 $D=27
M67 VDD 3 5 855 pmos L=0.15 W=2 AD=0.58 AS=0.58 PD=2.58 PS=2.58 NRD=0 NRS=0 m=1 $X=6485 $Y=5020 $D=27
M68 5 CLK VDD 855 pmos L=0.15 W=2 AD=0.58 AS=0.58 PD=2.58 PS=2.58 NRD=0 NRS=0 m=1 $X=6925 $Y=5020 $D=27
M69 VDD CLK 5 855 pmos L=0.15 W=2 AD=0.58 AS=0.58 PD=2.58 PS=2.58 NRD=0 NRS=0 m=1 $X=7365 $Y=5020 $D=27
M70 5 7 VDD 855 pmos L=0.15 W=2 AD=0.58 AS=0.58 PD=2.58 PS=2.58 NRD=0 NRS=0 m=1 $X=7805 $Y=5020 $D=27
M71 VDD 7 5 855 pmos L=0.15 W=2 AD=0.56 AS=0.56 PD=2.56 PS=2.56 NRD=0 NRS=0 m=1 $X=8245 $Y=5020 $D=27
M72 4 3 VDD 855 pmos L=0.15 W=2 AD=0.57 AS=0.57 PD=2.57 PS=2.57 NRD=0 NRS=0 m=1 $X=10855 $Y=5020 $D=27
M73 VDD 3 4 855 pmos L=0.15 W=2 AD=0.58 AS=0.58 PD=2.58 PS=2.58 NRD=0 NRS=0 m=1 $X=11295 $Y=5020 $D=27
M74 4 SN VDD 855 pmos L=0.15 W=2 AD=0.58 AS=0.58 PD=2.58 PS=2.58 NRD=0 NRS=0 m=1 $X=11735 $Y=5020 $D=27
M75 VDD SN 4 855 pmos L=0.15 W=2 AD=0.58 AS=0.58 PD=2.58 PS=2.58 NRD=0 NRS=0 m=1 $X=12175 $Y=5020 $D=27
M76 4 7 VDD 855 pmos L=0.15 W=2 AD=0.58 AS=0.58 PD=2.58 PS=2.58 NRD=0 NRS=0 m=1 $X=12615 $Y=5020 $D=27
M77 VDD 7 4 855 pmos L=0.15 W=2 AD=0.56 AS=0.56 PD=2.56 PS=2.56 NRD=0 NRS=0 m=1 $X=13055 $Y=5020 $D=27
M78 7 4 VDD 855 pmos L=0.15 W=2 AD=0.57 AS=0.57 PD=2.57 PS=2.57 NRD=0 NRS=0 m=1 $X=15665 $Y=5020 $D=27
M79 VDD 4 7 855 pmos L=0.15 W=2 AD=0.58 AS=0.58 PD=2.58 PS=2.58 NRD=0 NRS=0 m=1 $X=16105 $Y=5020 $D=27
M80 7 CLK VDD 855 pmos L=0.15 W=2 AD=0.58 AS=0.58 PD=2.58 PS=2.58 NRD=0 NRS=0 m=1 $X=16545 $Y=5020 $D=27
M81 VDD CLK 7 855 pmos L=0.15 W=2 AD=0.58 AS=0.58 PD=2.58 PS=2.58 NRD=0 NRS=0 m=1 $X=16985 $Y=5020 $D=27
M82 7 RN VDD 855 pmos L=0.15 W=2 AD=0.58 AS=0.58 PD=2.58 PS=2.58 NRD=0 NRS=0 m=1 $X=17425 $Y=5020 $D=27
M83 VDD RN 7 855 pmos L=0.15 W=2 AD=0.56 AS=0.56 PD=2.56 PS=2.56 NRD=0 NRS=0 m=1 $X=17865 $Y=5020 $D=27
M84 6 5 VDD 855 pmos L=0.15 W=2 AD=0.57 AS=0.57 PD=2.57 PS=2.57 NRD=0 NRS=0 m=1 $X=20475 $Y=5020 $D=27
M85 VDD 5 6 855 pmos L=0.15 W=2 AD=0.58 AS=0.58 PD=2.58 PS=2.58 NRD=0 NRS=0 m=1 $X=20915 $Y=5020 $D=27
M86 6 RN VDD 855 pmos L=0.15 W=2 AD=0.58 AS=0.58 PD=2.58 PS=2.58 NRD=0 NRS=0 m=1 $X=21355 $Y=5020 $D=27
M87 VDD RN 6 855 pmos L=0.15 W=2 AD=0.58 AS=0.58 PD=2.58 PS=2.58 NRD=0 NRS=0 m=1 $X=21795 $Y=5020 $D=27
M88 6 8 VDD 855 pmos L=0.15 W=2 AD=0.58 AS=0.58 PD=2.58 PS=2.58 NRD=0 NRS=0 m=1 $X=22235 $Y=5020 $D=27
M89 VDD 8 6 855 pmos L=0.15 W=2 AD=0.56 AS=0.56 PD=2.56 PS=2.56 NRD=0 NRS=0 m=1 $X=22675 $Y=5020 $D=27
M90 8 6 VDD 855 pmos L=0.15 W=2 AD=0.57 AS=0.57 PD=2.57 PS=2.57 NRD=0 NRS=0 m=1 $X=25285 $Y=5020 $D=27
M91 VDD 6 8 855 pmos L=0.15 W=2 AD=0.58 AS=0.58 PD=2.58 PS=2.58 NRD=0 NRS=0 m=1 $X=25725 $Y=5020 $D=27
M92 8 SN VDD 855 pmos L=0.15 W=2 AD=0.58 AS=0.58 PD=2.58 PS=2.58 NRD=0 NRS=0 m=1 $X=26165 $Y=5020 $D=27
M93 VDD SN 8 855 pmos L=0.15 W=2 AD=0.58 AS=0.58 PD=2.58 PS=2.58 NRD=0 NRS=0 m=1 $X=26605 $Y=5020 $D=27
M94 8 7 VDD 855 pmos L=0.15 W=2 AD=0.58 AS=0.58 PD=2.58 PS=2.58 NRD=0 NRS=0 m=1 $X=27045 $Y=5020 $D=27
M95 VDD 7 8 855 pmos L=0.15 W=2 AD=0.56 AS=0.56 PD=2.56 PS=2.56 NRD=0 NRS=0 m=1 $X=27485 $Y=5020 $D=27
M96 9 D VDD 855 pmos L=0.15 W=2 AD=0.57 AS=0.57 PD=2.57 PS=2.57 NRD=0 NRS=0 m=1 $X=30095 $Y=5020 $D=27
M97 VDD D 9 855 pmos L=0.15 W=2 AD=0.58 AS=0.58 PD=2.58 PS=2.58 NRD=0 NRS=0 m=1 $X=30535 $Y=5020 $D=27
M98 9 RN VDD 855 pmos L=0.15 W=2 AD=0.58 AS=0.58 PD=2.58 PS=2.58 NRD=0 NRS=0 m=1 $X=30975 $Y=5020 $D=27
M99 VDD RN 9 855 pmos L=0.15 W=2 AD=0.58 AS=0.58 PD=2.58 PS=2.58 NRD=0 NRS=0 m=1 $X=31415 $Y=5020 $D=27
M100 9 11 VDD 855 pmos L=0.15 W=2 AD=0.58 AS=0.58 PD=2.58 PS=2.58 NRD=0 NRS=0 m=1 $X=31855 $Y=5020 $D=27
M101 VDD 11 9 855 pmos L=0.15 W=2 AD=0.56 AS=0.56 PD=2.56 PS=2.56 NRD=0 NRS=0 m=1 $X=32295 $Y=5020 $D=27
M102 11 9 VDD 855 pmos L=0.15 W=2 AD=0.57 AS=0.57 PD=2.57 PS=2.57 NRD=0 NRS=0 m=1 $X=34905 $Y=5020 $D=27
M103 VDD 9 11 855 pmos L=0.15 W=2 AD=0.58 AS=0.58 PD=2.58 PS=2.58 NRD=0 NRS=0 m=1 $X=35345 $Y=5020 $D=27
M104 11 CLK VDD 855 pmos L=0.15 W=2 AD=0.58 AS=0.58 PD=2.58 PS=2.58 NRD=0 NRS=0 m=1 $X=35785 $Y=5020 $D=27
M105 VDD CLK 11 855 pmos L=0.15 W=2 AD=0.58 AS=0.58 PD=2.58 PS=2.58 NRD=0 NRS=0 m=1 $X=36225 $Y=5020 $D=27
M106 11 12 VDD 855 pmos L=0.15 W=2 AD=0.58 AS=0.58 PD=2.58 PS=2.58 NRD=0 NRS=0 m=1 $X=36665 $Y=5020 $D=27
M107 VDD 12 11 855 pmos L=0.15 W=2 AD=0.56 AS=0.56 PD=2.56 PS=2.56 NRD=0 NRS=0 m=1 $X=37105 $Y=5020 $D=27
M108 10 9 VDD 855 pmos L=0.15 W=2 AD=0.57 AS=0.57 PD=2.57 PS=2.57 NRD=0 NRS=0 m=1 $X=39715 $Y=5020 $D=27
M109 VDD 9 10 855 pmos L=0.15 W=2 AD=0.58 AS=0.58 PD=2.58 PS=2.58 NRD=0 NRS=0 m=1 $X=40155 $Y=5020 $D=27
M110 10 SN VDD 855 pmos L=0.15 W=2 AD=0.58 AS=0.58 PD=2.58 PS=2.58 NRD=0 NRS=0 m=1 $X=40595 $Y=5020 $D=27
M111 VDD SN 10 855 pmos L=0.15 W=2 AD=0.58 AS=0.58 PD=2.58 PS=2.58 NRD=0 NRS=0 m=1 $X=41035 $Y=5020 $D=27
M112 10 12 VDD 855 pmos L=0.15 W=2 AD=0.58 AS=0.58 PD=2.58 PS=2.58 NRD=0 NRS=0 m=1 $X=41475 $Y=5020 $D=27
M113 VDD 12 10 855 pmos L=0.15 W=2 AD=0.56 AS=0.56 PD=2.56 PS=2.56 NRD=0 NRS=0 m=1 $X=41915 $Y=5020 $D=27
M114 12 10 VDD 855 pmos L=0.15 W=2 AD=0.57 AS=0.57 PD=2.57 PS=2.57 NRD=0 NRS=0 m=1 $X=44525 $Y=5020 $D=27
M115 VDD 10 12 855 pmos L=0.15 W=2 AD=0.58 AS=0.58 PD=2.58 PS=2.58 NRD=0 NRS=0 m=1 $X=44965 $Y=5020 $D=27
M116 12 CLK VDD 855 pmos L=0.15 W=2 AD=0.58 AS=0.58 PD=2.58 PS=2.58 NRD=0 NRS=0 m=1 $X=45405 $Y=5020 $D=27
M117 VDD CLK 12 855 pmos L=0.15 W=2 AD=0.58 AS=0.58 PD=2.58 PS=2.58 NRD=0 NRS=0 m=1 $X=45845 $Y=5020 $D=27
M118 12 RN VDD 855 pmos L=0.15 W=2 AD=0.58 AS=0.58 PD=2.58 PS=2.58 NRD=0 NRS=0 m=1 $X=46285 $Y=5020 $D=27
M119 VDD RN 12 855 pmos L=0.15 W=2 AD=0.56 AS=0.56 PD=2.56 PS=2.56 NRD=0 NRS=0 m=1 $X=46725 $Y=5020 $D=27
M120 26 11 VDD 855 pmos L=0.15 W=2 AD=0.57 AS=0.57 PD=2.57 PS=2.57 NRD=0 NRS=0 m=1 $X=49335 $Y=5020 $D=27
M121 VDD 11 26 855 pmos L=0.15 W=2 AD=0.58 AS=0.58 PD=2.58 PS=2.58 NRD=0 NRS=0 m=1 $X=49775 $Y=5020 $D=27
M122 26 RN VDD 855 pmos L=0.15 W=2 AD=0.58 AS=0.58 PD=2.58 PS=2.58 NRD=0 NRS=0 m=1 $X=50215 $Y=5020 $D=27
M123 VDD RN 26 855 pmos L=0.15 W=2 AD=0.58 AS=0.58 PD=2.58 PS=2.58 NRD=0 NRS=0 m=1 $X=50655 $Y=5020 $D=27
M124 26 13 VDD 855 pmos L=0.15 W=2 AD=0.58 AS=0.58 PD=2.58 PS=2.58 NRD=0 NRS=0 m=1 $X=51095 $Y=5020 $D=27
M125 VDD 13 26 855 pmos L=0.15 W=2 AD=0.56 AS=0.56 PD=2.56 PS=2.56 NRD=0 NRS=0 m=1 $X=51535 $Y=5020 $D=27
M126 13 26 VDD 855 pmos L=0.15 W=2 AD=0.57 AS=0.57 PD=2.57 PS=2.57 NRD=0 NRS=0 m=1 $X=54145 $Y=5020 $D=27
M127 VDD 26 13 855 pmos L=0.15 W=2 AD=0.58 AS=0.58 PD=2.58 PS=2.58 NRD=0 NRS=0 m=1 $X=54585 $Y=5020 $D=27
M128 13 SN VDD 855 pmos L=0.15 W=2 AD=0.58 AS=0.58 PD=2.58 PS=2.58 NRD=0 NRS=0 m=1 $X=55025 $Y=5020 $D=27
M129 VDD SN 13 855 pmos L=0.15 W=2 AD=0.58 AS=0.58 PD=2.58 PS=2.58 NRD=0 NRS=0 m=1 $X=55465 $Y=5020 $D=27
M130 13 12 VDD 855 pmos L=0.15 W=2 AD=0.58 AS=0.58 PD=2.58 PS=2.58 NRD=0 NRS=0 m=1 $X=55905 $Y=5020 $D=27
M131 VDD 12 13 855 pmos L=0.15 W=2 AD=0.56 AS=0.56 PD=2.56 PS=2.56 NRD=0 NRS=0 m=1 $X=56345 $Y=5020 $D=27
M132 15 D VDD 855 pmos L=0.15 W=2 AD=0.57 AS=0.57 PD=2.57 PS=2.57 NRD=0 NRS=0 m=1 $X=58955 $Y=5020 $D=27
M133 VDD D 15 855 pmos L=0.15 W=2 AD=0.58 AS=0.58 PD=2.58 PS=2.58 NRD=0 NRS=0 m=1 $X=59395 $Y=5020 $D=27
M134 15 RN VDD 855 pmos L=0.15 W=2 AD=0.58 AS=0.58 PD=2.58 PS=2.58 NRD=0 NRS=0 m=1 $X=59835 $Y=5020 $D=27
M135 VDD RN 15 855 pmos L=0.15 W=2 AD=0.58 AS=0.58 PD=2.58 PS=2.58 NRD=0 NRS=0 m=1 $X=60275 $Y=5020 $D=27
M136 15 18 VDD 855 pmos L=0.15 W=2 AD=0.58 AS=0.58 PD=2.58 PS=2.58 NRD=0 NRS=0 m=1 $X=60715 $Y=5020 $D=27
M137 VDD 18 15 855 pmos L=0.15 W=2 AD=0.56 AS=0.56 PD=2.56 PS=2.56 NRD=0 NRS=0 m=1 $X=61155 $Y=5020 $D=27
M138 18 15 VDD 855 pmos L=0.15 W=2 AD=0.57 AS=0.57 PD=2.57 PS=2.57 NRD=0 NRS=0 m=1 $X=63765 $Y=5020 $D=27
M139 VDD 15 18 855 pmos L=0.15 W=2 AD=0.58 AS=0.58 PD=2.58 PS=2.58 NRD=0 NRS=0 m=1 $X=64205 $Y=5020 $D=27
M140 18 CLK VDD 855 pmos L=0.15 W=2 AD=0.58 AS=0.58 PD=2.58 PS=2.58 NRD=0 NRS=0 m=1 $X=64645 $Y=5020 $D=27
M141 VDD CLK 18 855 pmos L=0.15 W=2 AD=0.58 AS=0.58 PD=2.58 PS=2.58 NRD=0 NRS=0 m=1 $X=65085 $Y=5020 $D=27
M142 18 21 VDD 855 pmos L=0.15 W=2 AD=0.58 AS=0.58 PD=2.58 PS=2.58 NRD=0 NRS=0 m=1 $X=65525 $Y=5020 $D=27
M143 VDD 21 18 855 pmos L=0.15 W=2 AD=0.56 AS=0.56 PD=2.56 PS=2.56 NRD=0 NRS=0 m=1 $X=65965 $Y=5020 $D=27
M144 16 15 VDD 855 pmos L=0.15 W=2 AD=0.57 AS=0.57 PD=2.57 PS=2.57 NRD=0 NRS=0 m=1 $X=68575 $Y=5020 $D=27
M145 VDD 15 16 855 pmos L=0.15 W=2 AD=0.58 AS=0.58 PD=2.58 PS=2.58 NRD=0 NRS=0 m=1 $X=69015 $Y=5020 $D=27
M146 16 SN VDD 855 pmos L=0.15 W=2 AD=0.58 AS=0.58 PD=2.58 PS=2.58 NRD=0 NRS=0 m=1 $X=69455 $Y=5020 $D=27
M147 VDD SN 16 855 pmos L=0.15 W=2 AD=0.58 AS=0.58 PD=2.58 PS=2.58 NRD=0 NRS=0 m=1 $X=69895 $Y=5020 $D=27
M148 16 21 VDD 855 pmos L=0.15 W=2 AD=0.58 AS=0.58 PD=2.58 PS=2.58 NRD=0 NRS=0 m=1 $X=70335 $Y=5020 $D=27
M149 VDD 21 16 855 pmos L=0.15 W=2 AD=0.56 AS=0.56 PD=2.56 PS=2.56 NRD=0 NRS=0 m=1 $X=70775 $Y=5020 $D=27
M150 21 16 VDD 855 pmos L=0.15 W=2 AD=0.57 AS=0.57 PD=2.57 PS=2.57 NRD=0 NRS=0 m=1 $X=73385 $Y=5020 $D=27
M151 VDD 16 21 855 pmos L=0.15 W=2 AD=0.58 AS=0.58 PD=2.58 PS=2.58 NRD=0 NRS=0 m=1 $X=73825 $Y=5020 $D=27
M152 21 CLK VDD 855 pmos L=0.15 W=2 AD=0.58 AS=0.58 PD=2.58 PS=2.58 NRD=0 NRS=0 m=1 $X=74265 $Y=5020 $D=27
M153 VDD CLK 21 855 pmos L=0.15 W=2 AD=0.58 AS=0.58 PD=2.58 PS=2.58 NRD=0 NRS=0 m=1 $X=74705 $Y=5020 $D=27
M154 21 RN VDD 855 pmos L=0.15 W=2 AD=0.58 AS=0.58 PD=2.58 PS=2.58 NRD=0 NRS=0 m=1 $X=75145 $Y=5020 $D=27
M155 VDD RN 21 855 pmos L=0.15 W=2 AD=0.56 AS=0.56 PD=2.56 PS=2.56 NRD=0 NRS=0 m=1 $X=75585 $Y=5020 $D=27
M156 24 18 VDD 855 pmos L=0.15 W=2 AD=0.57 AS=0.57 PD=2.57 PS=2.57 NRD=0 NRS=0 m=1 $X=78195 $Y=5020 $D=27
M157 VDD 18 24 855 pmos L=0.15 W=2 AD=0.58 AS=0.58 PD=2.58 PS=2.58 NRD=0 NRS=0 m=1 $X=78635 $Y=5020 $D=27
M158 24 RN VDD 855 pmos L=0.15 W=2 AD=0.58 AS=0.58 PD=2.58 PS=2.58 NRD=0 NRS=0 m=1 $X=79075 $Y=5020 $D=27
M159 VDD RN 24 855 pmos L=0.15 W=2 AD=0.58 AS=0.58 PD=2.58 PS=2.58 NRD=0 NRS=0 m=1 $X=79515 $Y=5020 $D=27
M160 24 22 VDD 855 pmos L=0.15 W=2 AD=0.58 AS=0.58 PD=2.58 PS=2.58 NRD=0 NRS=0 m=1 $X=79955 $Y=5020 $D=27
M161 VDD 22 24 855 pmos L=0.15 W=2 AD=0.56 AS=0.56 PD=2.56 PS=2.56 NRD=0 NRS=0 m=1 $X=80395 $Y=5020 $D=27
M162 22 24 VDD 855 pmos L=0.15 W=2 AD=0.57 AS=0.57 PD=2.57 PS=2.57 NRD=0 NRS=0 m=1 $X=83005 $Y=5020 $D=27
M163 VDD 24 22 855 pmos L=0.15 W=2 AD=0.58 AS=0.58 PD=2.58 PS=2.58 NRD=0 NRS=0 m=1 $X=83445 $Y=5020 $D=27
M164 22 SN VDD 855 pmos L=0.15 W=2 AD=0.58 AS=0.58 PD=2.58 PS=2.58 NRD=0 NRS=0 m=1 $X=83885 $Y=5020 $D=27
M165 VDD SN 22 855 pmos L=0.15 W=2 AD=0.58 AS=0.58 PD=2.58 PS=2.58 NRD=0 NRS=0 m=1 $X=84325 $Y=5020 $D=27
M166 22 21 VDD 855 pmos L=0.15 W=2 AD=0.58 AS=0.58 PD=2.58 PS=2.58 NRD=0 NRS=0 m=1 $X=84765 $Y=5020 $D=27
M167 VDD 21 22 855 pmos L=0.15 W=2 AD=0.56 AS=0.56 PD=2.56 PS=2.56 NRD=0 NRS=0 m=1 $X=85205 $Y=5020 $D=27
M168 23 6 VDD 855 pmos L=0.15 W=2 AD=0.57 AS=0.57 PD=2.57 PS=2.57 NRD=0 NRS=0 m=1 $X=87515 $Y=5025 $D=27
M169 VDD 6 23 855 pmos L=0.15 W=2 AD=0.58 AS=0.58 PD=2.58 PS=2.58 NRD=0 NRS=0 m=1 $X=87955 $Y=5025 $D=27
M170 23 26 VDD 855 pmos L=0.15 W=2 AD=0.58 AS=0.58 PD=2.58 PS=2.58 NRD=0 NRS=0 m=1 $X=88395 $Y=5025 $D=27
M171 VDD 26 23 855 pmos L=0.15 W=2 AD=0.56 AS=0.56 PD=2.56 PS=2.56 NRD=0 NRS=0 m=1 $X=88835 $Y=5025 $D=27
M172 25 6 23 855 pmos L=0.15 W=2 AD=0.56 AS=0.56 PD=2.56 PS=2.56 NRD=0 NRS=0 m=1 $X=90835 $Y=5025 $D=27
M173 23 6 25 855 pmos L=0.15 W=2 AD=0.58 AS=0.58 PD=2.58 PS=2.58 NRD=0 NRS=0 m=1 $X=91275 $Y=5025 $D=27
M174 25 24 23 855 pmos L=0.15 W=2 AD=0.58 AS=0.58 PD=2.58 PS=2.58 NRD=0 NRS=0 m=1 $X=91715 $Y=5025 $D=27
M175 23 24 25 855 pmos L=0.15 W=2 AD=0.57 AS=0.57 PD=2.57 PS=2.57 NRD=0 NRS=0 m=1 $X=92155 $Y=5025 $D=27
M176 Q 24 25 855 pmos L=0.15 W=2 AD=0.57 AS=0.57 PD=2.57 PS=2.57 NRD=0 NRS=0 m=1 $X=94175 $Y=5025 $D=27
M177 25 24 Q 855 pmos L=0.15 W=2 AD=0.58 AS=0.58 PD=2.58 PS=2.58 NRD=0 NRS=0 m=1 $X=94615 $Y=5025 $D=27
M178 Q 26 25 855 pmos L=0.15 W=2 AD=0.58 AS=0.58 PD=2.58 PS=2.58 NRD=0 NRS=0 m=1 $X=95055 $Y=5025 $D=27
M179 25 26 Q 855 pmos L=0.15 W=2 AD=0.56 AS=0.56 PD=2.56 PS=2.56 NRD=0 NRS=0 m=1 $X=95495 $Y=5025 $D=27
.ENDS
***************************************
