* SPICE NETLIST
***************************************

.SUBCKT pad_bond pin0
.ENDS
***************************************
.SUBCKT pad_microprobe pin0
.ENDS
***************************************
.SUBCKT pad_probe pin0
.ENDS
***************************************
.SUBCKT nmos_de_iso_v20 src gate drn b sub
.ENDS
***************************************
.SUBCKT HA GND VDD A B SUM COUT
** N=193 EP=6 IP=0 FDC=27
M0 GND A 9 193 nmos L=0.163119 W=2.35104 $X=840 $Y=785 $D=3
M1 3 B 9 193 nmos L=0.163346 W=2.31104 $X=1810 $Y=825 $D=3
M2 COUT 3 GND 193 nmos L=0.163346 W=2.31104 $X=4105 $Y=830 $D=3
M3 6 A GND 193 nmos L=0.163346 W=2.31104 $X=6325 $Y=830 $D=3
M4 GND A 12 193 nmos L=0.163119 W=2.35104 $X=8610 $Y=790 $D=3
M5 SUM B 12 193 nmos L=0.163346 W=2.31104 $X=9580 $Y=830 $D=3
M6 GND 8 14 193 nmos L=0.163119 W=2.35104 $X=11940 $Y=790 $D=3
M7 SUM 6 14 193 nmos L=0.163346 W=2.31104 $X=12910 $Y=830 $D=3
M8 8 B GND 193 nmos L=0.163346 W=2.31104 $X=15195 $Y=830 $D=3
M9 3 A VDD 191 pmos L=0.15 W=2 AD=0.57 AS=0.57 PD=2.57 PS=2.57 NRD=0 NRS=0 m=1 $X=935 $Y=5020 $D=27
M10 VDD A 3 191 pmos L=0.15 W=2 AD=0.58 AS=0.58 PD=2.58 PS=2.58 NRD=0 NRS=0 m=1 $X=1375 $Y=5020 $D=27
M11 3 B VDD 191 pmos L=0.15 W=2 AD=0.58 AS=0.58 PD=2.58 PS=2.58 NRD=0 NRS=0 m=1 $X=1815 $Y=5020 $D=27
M12 VDD B 3 191 pmos L=0.15 W=2 AD=0.56 AS=0.56 PD=2.56 PS=2.56 NRD=0 NRS=0 m=1 $X=2255 $Y=5020 $D=27
M13 COUT 3 VDD 191 pmos L=0.15 W=2 AD=0.57 AS=0.57 PD=2.57 PS=2.57 NRD=0 NRS=0 m=1 $X=4150 $Y=5020 $D=27
M14 VDD 3 COUT 191 pmos L=0.15 W=2 AD=0.56 AS=0.56 PD=2.56 PS=2.56 NRD=0 NRS=0 m=1 $X=4590 $Y=5020 $D=27
M15 6 A VDD 191 pmos L=0.15 W=2 AD=0.57 AS=0.57 PD=2.57 PS=2.57 NRD=0 NRS=0 m=1 $X=6370 $Y=5020 $D=27
M16 VDD A 6 191 pmos L=0.15 W=2 AD=0.56 AS=0.56 PD=2.56 PS=2.56 NRD=0 NRS=0 m=1 $X=6810 $Y=5020 $D=27
M17 VDD A 11 191 pmos L=0.15 W=2 AD=0.57 AS=0.57 PD=2.57 PS=2.57 NRD=0 NRS=0 m=1 $X=8705 $Y=5020 $D=27
M18 11 A VDD 191 pmos L=0.15 W=2 AD=0.58 AS=0.58 PD=2.58 PS=2.58 NRD=0 NRS=0 m=1 $X=9145 $Y=5020 $D=27
M19 SUM 8 11 191 pmos L=0.15 W=2 AD=0.58 AS=0.58 PD=2.58 PS=2.58 NRD=0 NRS=0 m=1 $X=9585 $Y=5020 $D=27
M20 11 8 SUM 191 pmos L=0.15 W=2 AD=0.56 AS=0.56 PD=2.56 PS=2.56 NRD=0 NRS=0 m=1 $X=10025 $Y=5020 $D=27
M21 VDD B 13 191 pmos L=0.15 W=2 AD=0.57 AS=0.57 PD=2.57 PS=2.57 NRD=0 NRS=0 m=1 $X=12035 $Y=5020 $D=27
M22 13 B VDD 191 pmos L=0.15 W=2 AD=0.58 AS=0.58 PD=2.58 PS=2.58 NRD=0 NRS=0 m=1 $X=12475 $Y=5020 $D=27
M23 SUM 6 13 191 pmos L=0.15 W=2 AD=0.58 AS=0.58 PD=2.58 PS=2.58 NRD=0 NRS=0 m=1 $X=12915 $Y=5020 $D=27
M24 13 6 SUM 191 pmos L=0.15 W=2 AD=0.56 AS=0.56 PD=2.56 PS=2.56 NRD=0 NRS=0 m=1 $X=13355 $Y=5020 $D=27
M25 8 B VDD 191 pmos L=0.15 W=2 AD=0.56 AS=0.56 PD=2.56 PS=2.56 NRD=0 NRS=0 m=1 $X=15240 $Y=5020 $D=27
M26 VDD B 8 191 pmos L=0.15 W=2 AD=0.57 AS=0.57 PD=2.57 PS=2.57 NRD=0 NRS=0 m=1 $X=15680 $Y=5020 $D=27
.ENDS
***************************************
