* SPICE NETLIST
***************************************

.SUBCKT pad_bond pin0
.ENDS
***************************************
.SUBCKT pad_microprobe pin0
.ENDS
***************************************
.SUBCKT pad_probe pin0
.ENDS
***************************************
.SUBCKT nmos_de_iso_v20 src gate drn b sub
.ENDS
***************************************
.SUBCKT DFFSNQX1 GND VDD CLK SN Q D
** N=241 EP=6 IP=0 FDC=45
M0 GND D 12 241 nmos L=0.163119 W=2.35104 $X=840 $Y=785 $D=3
M1 3 6 12 241 nmos L=0.163346 W=2.31104 $X=1810 $Y=825 $D=3
M2 GND 3 13 241 nmos L=0.163119 W=2.35104 $X=4065 $Y=795 $D=3
M3 14 CLK 13 241 nmos L=0.160516 W=2.29447 $X=5040 $Y=830 $D=3
M4 6 9 14 241 nmos L=0.163346 W=2.31104 $X=6575 $Y=835 $D=3
M5 GND 3 15 241 nmos L=0.163119 W=2.35104 $X=8875 $Y=795 $D=3
M6 16 SN 15 241 nmos L=0.160516 W=2.29447 $X=9850 $Y=830 $D=3
M7 4 9 16 241 nmos L=0.163346 W=2.31104 $X=11385 $Y=835 $D=3
M8 GND 4 17 241 nmos L=0.163119 W=2.35104 $X=13790 $Y=785 $D=3
M9 9 CLK 17 241 nmos L=0.163346 W=2.31104 $X=14760 $Y=825 $D=3
M10 GND 6 18 241 nmos L=0.163119 W=2.35104 $X=17120 $Y=785 $D=3
M11 7 Q 18 241 nmos L=0.163346 W=2.31104 $X=18090 $Y=825 $D=3
M12 GND 7 19 241 nmos L=0.163119 W=2.35104 $X=20345 $Y=795 $D=3
M13 20 SN 19 241 nmos L=0.160516 W=2.29447 $X=21320 $Y=830 $D=3
M14 Q 9 20 241 nmos L=0.163346 W=2.31104 $X=22855 $Y=835 $D=3
M15 3 D VDD 239 pmos L=0.15 W=2 AD=0.57 AS=0.57 PD=2.57 PS=2.57 NRD=0 NRS=0 m=1 $X=935 $Y=5020 $D=27
M16 VDD D 3 239 pmos L=0.15 W=2 AD=0.58 AS=0.58 PD=2.58 PS=2.58 NRD=0 NRS=0 m=1 $X=1375 $Y=5020 $D=27
M17 3 6 VDD 239 pmos L=0.15 W=2 AD=0.58 AS=0.58 PD=2.58 PS=2.58 NRD=0 NRS=0 m=1 $X=1815 $Y=5020 $D=27
M18 VDD 6 3 239 pmos L=0.15 W=2 AD=0.56 AS=0.56 PD=2.56 PS=2.56 NRD=0 NRS=0 m=1 $X=2255 $Y=5020 $D=27
M19 6 3 VDD 239 pmos L=0.15 W=2 AD=0.57 AS=0.57 PD=2.57 PS=2.57 NRD=0 NRS=0 m=1 $X=4565 $Y=5020 $D=27
M20 VDD 3 6 239 pmos L=0.15 W=2 AD=0.58 AS=0.58 PD=2.58 PS=2.58 NRD=0 NRS=0 m=1 $X=5005 $Y=5020 $D=27
M21 6 CLK VDD 239 pmos L=0.15 W=2 AD=0.58 AS=0.58 PD=2.58 PS=2.58 NRD=0 NRS=0 m=1 $X=5445 $Y=5020 $D=27
M22 VDD CLK 6 239 pmos L=0.15 W=2 AD=0.58 AS=0.58 PD=2.58 PS=2.58 NRD=0 NRS=0 m=1 $X=5885 $Y=5020 $D=27
M23 6 9 VDD 239 pmos L=0.15 W=2 AD=0.58 AS=0.58 PD=2.58 PS=2.58 NRD=0 NRS=0 m=1 $X=6325 $Y=5020 $D=27
M24 VDD 9 6 239 pmos L=0.15 W=2 AD=0.56 AS=0.56 PD=2.56 PS=2.56 NRD=0 NRS=0 m=1 $X=6765 $Y=5020 $D=27
M25 4 3 VDD 239 pmos L=0.15 W=2 AD=0.57 AS=0.57 PD=2.57 PS=2.57 NRD=0 NRS=0 m=1 $X=9375 $Y=5020 $D=27
M26 VDD 3 4 239 pmos L=0.15 W=2 AD=0.58 AS=0.58 PD=2.58 PS=2.58 NRD=0 NRS=0 m=1 $X=9815 $Y=5020 $D=27
M27 4 SN VDD 239 pmos L=0.15 W=2 AD=0.58 AS=0.58 PD=2.58 PS=2.58 NRD=0 NRS=0 m=1 $X=10255 $Y=5020 $D=27
M28 VDD SN 4 239 pmos L=0.15 W=2 AD=0.58 AS=0.58 PD=2.58 PS=2.58 NRD=0 NRS=0 m=1 $X=10695 $Y=5020 $D=27
M29 4 9 VDD 239 pmos L=0.15 W=2 AD=0.58 AS=0.58 PD=2.58 PS=2.58 NRD=0 NRS=0 m=1 $X=11135 $Y=5020 $D=27
M30 VDD 9 4 239 pmos L=0.15 W=2 AD=0.56 AS=0.56 PD=2.56 PS=2.56 NRD=0 NRS=0 m=1 $X=11575 $Y=5020 $D=27
M31 9 4 VDD 239 pmos L=0.15 W=2 AD=0.57 AS=0.57 PD=2.57 PS=2.57 NRD=0 NRS=0 m=1 $X=13885 $Y=5020 $D=27
M32 VDD 4 9 239 pmos L=0.15 W=2 AD=0.58 AS=0.58 PD=2.58 PS=2.58 NRD=0 NRS=0 m=1 $X=14325 $Y=5020 $D=27
M33 9 CLK VDD 239 pmos L=0.15 W=2 AD=0.58 AS=0.58 PD=2.58 PS=2.58 NRD=0 NRS=0 m=1 $X=14765 $Y=5020 $D=27
M34 VDD CLK 9 239 pmos L=0.15 W=2 AD=0.56 AS=0.56 PD=2.56 PS=2.56 NRD=0 NRS=0 m=1 $X=15205 $Y=5020 $D=27
M35 7 6 VDD 239 pmos L=0.15 W=2 AD=0.57 AS=0.57 PD=2.57 PS=2.57 NRD=0 NRS=0 m=1 $X=17215 $Y=5020 $D=27
M36 VDD 6 7 239 pmos L=0.15 W=2 AD=0.58 AS=0.58 PD=2.58 PS=2.58 NRD=0 NRS=0 m=1 $X=17655 $Y=5020 $D=27
M37 7 Q VDD 239 pmos L=0.15 W=2 AD=0.58 AS=0.58 PD=2.58 PS=2.58 NRD=0 NRS=0 m=1 $X=18095 $Y=5020 $D=27
M38 VDD Q 7 239 pmos L=0.15 W=2 AD=0.56 AS=0.56 PD=2.56 PS=2.56 NRD=0 NRS=0 m=1 $X=18535 $Y=5020 $D=27
M39 Q 7 VDD 239 pmos L=0.15 W=2 AD=0.57 AS=0.57 PD=2.57 PS=2.57 NRD=0 NRS=0 m=1 $X=20845 $Y=5020 $D=27
M40 VDD 7 Q 239 pmos L=0.15 W=2 AD=0.58 AS=0.58 PD=2.58 PS=2.58 NRD=0 NRS=0 m=1 $X=21285 $Y=5020 $D=27
M41 Q SN VDD 239 pmos L=0.15 W=2 AD=0.58 AS=0.58 PD=2.58 PS=2.58 NRD=0 NRS=0 m=1 $X=21725 $Y=5020 $D=27
M42 VDD SN Q 239 pmos L=0.15 W=2 AD=0.58 AS=0.58 PD=2.58 PS=2.58 NRD=0 NRS=0 m=1 $X=22165 $Y=5020 $D=27
M43 Q 9 VDD 239 pmos L=0.15 W=2 AD=0.58 AS=0.58 PD=2.58 PS=2.58 NRD=0 NRS=0 m=1 $X=22605 $Y=5020 $D=27
M44 VDD 9 Q 239 pmos L=0.15 W=2 AD=0.56 AS=0.56 PD=2.56 PS=2.56 NRD=0 NRS=0 m=1 $X=23045 $Y=5020 $D=27
.ENDS
***************************************
