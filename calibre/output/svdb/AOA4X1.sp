* SPICE NETLIST
***************************************

.SUBCKT pad_bond pin0
.ENDS
***************************************
.SUBCKT pad_microprobe pin0
.ENDS
***************************************
.SUBCKT pad_probe pin0
.ENDS
***************************************
.SUBCKT nmos_de_iso_v20 src gate drn b sub
.ENDS
***************************************
.SUBCKT AOA4X1 GND VDD A B C D Y
** N=144 EP=7 IP=0 FDC=21
M0 GND A 8 144 nmos L=0.163119 W=2.35104 $X=840 $Y=785 $D=3
M1 3 B 8 144 nmos L=0.163346 W=2.31104 $X=1810 $Y=825 $D=3
M2 4 3 GND 144 nmos L=0.163346 W=2.31104 $X=4170 $Y=825 $D=3
M3 4 C GND 144 nmos L=0.163129 W=2.31397 $X=5140 $Y=825 $D=3
M4 GND 4 12 144 nmos L=0.163119 W=2.35104 $X=7500 $Y=785 $D=3
M5 5 D 12 144 nmos L=0.163346 W=2.31104 $X=8470 $Y=825 $D=3
M6 Y 5 GND 144 nmos L=0.163346 W=2.31104 $X=10765 $Y=830 $D=3
M7 3 A VDD 142 pmos L=0.15 W=2 AD=0.57 AS=0.57 PD=2.57 PS=2.57 NRD=0 NRS=0 m=1 $X=935 $Y=5020 $D=27
M8 VDD A 3 142 pmos L=0.15 W=2 AD=0.58 AS=0.58 PD=2.58 PS=2.58 NRD=0 NRS=0 m=1 $X=1375 $Y=5020 $D=27
M9 3 B VDD 142 pmos L=0.15 W=2 AD=0.58 AS=0.58 PD=2.58 PS=2.58 NRD=0 NRS=0 m=1 $X=1815 $Y=5020 $D=27
M10 VDD B 3 142 pmos L=0.15 W=2 AD=0.56 AS=0.56 PD=2.56 PS=2.56 NRD=0 NRS=0 m=1 $X=2255 $Y=5020 $D=27
M11 VDD 3 10 142 pmos L=0.15 W=2 AD=0.57 AS=0.57 PD=2.57 PS=2.57 NRD=0 NRS=0 m=1 $X=4265 $Y=5025 $D=27
M12 10 3 VDD 142 pmos L=0.15 W=2 AD=0.58 AS=0.58 PD=2.58 PS=2.58 NRD=0 NRS=0 m=1 $X=4705 $Y=5025 $D=27
M13 4 C 10 142 pmos L=0.15 W=2 AD=0.58 AS=0.58 PD=2.58 PS=2.58 NRD=0 NRS=0 m=1 $X=5145 $Y=5025 $D=27
M14 10 C 4 142 pmos L=0.15 W=2 AD=0.56 AS=0.56 PD=2.56 PS=2.56 NRD=0 NRS=0 m=1 $X=5585 $Y=5025 $D=27
M15 5 4 VDD 142 pmos L=0.15 W=2 AD=0.57 AS=0.57 PD=2.57 PS=2.57 NRD=0 NRS=0 m=1 $X=7595 $Y=5020 $D=27
M16 VDD 4 5 142 pmos L=0.15 W=2 AD=0.58 AS=0.58 PD=2.58 PS=2.58 NRD=0 NRS=0 m=1 $X=8035 $Y=5020 $D=27
M17 5 D VDD 142 pmos L=0.15 W=2 AD=0.58 AS=0.58 PD=2.58 PS=2.58 NRD=0 NRS=0 m=1 $X=8475 $Y=5020 $D=27
M18 VDD D 5 142 pmos L=0.15 W=2 AD=0.56 AS=0.56 PD=2.56 PS=2.56 NRD=0 NRS=0 m=1 $X=8915 $Y=5020 $D=27
M19 Y 5 VDD 142 pmos L=0.15 W=2 AD=0.57 AS=0.57 PD=2.57 PS=2.57 NRD=0 NRS=0 m=1 $X=10810 $Y=5020 $D=27
M20 VDD 5 Y 142 pmos L=0.15 W=2 AD=0.56 AS=0.56 PD=2.56 PS=2.56 NRD=0 NRS=0 m=1 $X=11250 $Y=5020 $D=27
.ENDS
***************************************
