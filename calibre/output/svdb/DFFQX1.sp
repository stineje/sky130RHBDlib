* SPICE NETLIST
***************************************

.SUBCKT pad_bond pin0
.ENDS
***************************************
.SUBCKT pad_microprobe pin0
.ENDS
***************************************
.SUBCKT pad_probe pin0
.ENDS
***************************************
.SUBCKT nmos_de_iso_v20 src gate drn b sub
.ENDS
***************************************
.SUBCKT DFFQX1 GND VDD CLK Q D
** N=222 EP=5 IP=0 FDC=39
M0 GND 8 10 222 nmos L=0.163119 W=2.35104 $X=735 $Y=795 $D=3
M1 11 CLK 10 222 nmos L=0.160516 W=2.29447 $X=1710 $Y=830 $D=3
M2 6 3 11 222 nmos L=0.163346 W=2.31104 $X=3245 $Y=835 $D=3
M3 GND 6 13 222 nmos L=0.163119 W=2.35104 $X=5650 $Y=785 $D=3
M4 3 D 13 222 nmos L=0.163346 W=2.31104 $X=6620 $Y=825 $D=3
M5 GND 3 14 222 nmos L=0.163119 W=2.35104 $X=8980 $Y=785 $D=3
M6 4 8 14 222 nmos L=0.163346 W=2.31104 $X=9950 $Y=825 $D=3
M7 GND 4 15 222 nmos L=0.163119 W=2.35104 $X=12310 $Y=785 $D=3
M8 8 CLK 15 222 nmos L=0.163346 W=2.31104 $X=13280 $Y=825 $D=3
M9 GND 6 16 222 nmos L=0.163119 W=2.35104 $X=15640 $Y=785 $D=3
M10 7 Q 16 222 nmos L=0.163346 W=2.31104 $X=16610 $Y=825 $D=3
M11 GND 7 17 222 nmos L=0.163119 W=2.35104 $X=18970 $Y=785 $D=3
M12 Q 8 17 222 nmos L=0.163346 W=2.31104 $X=19940 $Y=825 $D=3
M13 6 8 VDD 220 pmos L=0.15 W=2 AD=0.57 AS=0.57 PD=2.57 PS=2.57 NRD=0 NRS=0 m=1 $X=1235 $Y=5020 $D=27
M14 VDD 8 6 220 pmos L=0.15 W=2 AD=0.58 AS=0.58 PD=2.58 PS=2.58 NRD=0 NRS=0 m=1 $X=1675 $Y=5020 $D=27
M15 6 CLK VDD 220 pmos L=0.15 W=2 AD=0.58 AS=0.58 PD=2.58 PS=2.58 NRD=0 NRS=0 m=1 $X=2115 $Y=5020 $D=27
M16 VDD CLK 6 220 pmos L=0.15 W=2 AD=0.58 AS=0.58 PD=2.58 PS=2.58 NRD=0 NRS=0 m=1 $X=2555 $Y=5020 $D=27
M17 6 3 VDD 220 pmos L=0.15 W=2 AD=0.58 AS=0.58 PD=2.58 PS=2.58 NRD=0 NRS=0 m=1 $X=2995 $Y=5020 $D=27
M18 VDD 3 6 220 pmos L=0.15 W=2 AD=0.56 AS=0.56 PD=2.56 PS=2.56 NRD=0 NRS=0 m=1 $X=3435 $Y=5020 $D=27
M19 3 6 VDD 220 pmos L=0.15 W=2 AD=0.57 AS=0.57 PD=2.57 PS=2.57 NRD=0 NRS=0 m=1 $X=5745 $Y=5020 $D=27
M20 VDD 6 3 220 pmos L=0.15 W=2 AD=0.58 AS=0.58 PD=2.58 PS=2.58 NRD=0 NRS=0 m=1 $X=6185 $Y=5020 $D=27
M21 3 D VDD 220 pmos L=0.15 W=2 AD=0.58 AS=0.58 PD=2.58 PS=2.58 NRD=0 NRS=0 m=1 $X=6625 $Y=5020 $D=27
M22 VDD D 3 220 pmos L=0.15 W=2 AD=0.56 AS=0.56 PD=2.56 PS=2.56 NRD=0 NRS=0 m=1 $X=7065 $Y=5020 $D=27
M23 4 3 VDD 220 pmos L=0.15 W=2 AD=0.57 AS=0.57 PD=2.57 PS=2.57 NRD=0 NRS=0 m=1 $X=9075 $Y=5020 $D=27
M24 VDD 3 4 220 pmos L=0.15 W=2 AD=0.58 AS=0.58 PD=2.58 PS=2.58 NRD=0 NRS=0 m=1 $X=9515 $Y=5020 $D=27
M25 4 8 VDD 220 pmos L=0.15 W=2 AD=0.58 AS=0.58 PD=2.58 PS=2.58 NRD=0 NRS=0 m=1 $X=9955 $Y=5020 $D=27
M26 VDD 8 4 220 pmos L=0.15 W=2 AD=0.56 AS=0.56 PD=2.56 PS=2.56 NRD=0 NRS=0 m=1 $X=10395 $Y=5020 $D=27
M27 8 4 VDD 220 pmos L=0.15 W=2 AD=0.57 AS=0.57 PD=2.57 PS=2.57 NRD=0 NRS=0 m=1 $X=12405 $Y=5020 $D=27
M28 VDD 4 8 220 pmos L=0.15 W=2 AD=0.58 AS=0.58 PD=2.58 PS=2.58 NRD=0 NRS=0 m=1 $X=12845 $Y=5020 $D=27
M29 8 CLK VDD 220 pmos L=0.15 W=2 AD=0.58 AS=0.58 PD=2.58 PS=2.58 NRD=0 NRS=0 m=1 $X=13285 $Y=5020 $D=27
M30 VDD CLK 8 220 pmos L=0.15 W=2 AD=0.56 AS=0.56 PD=2.56 PS=2.56 NRD=0 NRS=0 m=1 $X=13725 $Y=5020 $D=27
M31 7 6 VDD 220 pmos L=0.15 W=2 AD=0.57 AS=0.57 PD=2.57 PS=2.57 NRD=0 NRS=0 m=1 $X=15735 $Y=5020 $D=27
M32 VDD 6 7 220 pmos L=0.15 W=2 AD=0.58 AS=0.58 PD=2.58 PS=2.58 NRD=0 NRS=0 m=1 $X=16175 $Y=5020 $D=27
M33 7 Q VDD 220 pmos L=0.15 W=2 AD=0.58 AS=0.58 PD=2.58 PS=2.58 NRD=0 NRS=0 m=1 $X=16615 $Y=5020 $D=27
M34 VDD Q 7 220 pmos L=0.15 W=2 AD=0.56 AS=0.56 PD=2.56 PS=2.56 NRD=0 NRS=0 m=1 $X=17055 $Y=5020 $D=27
M35 Q 7 VDD 220 pmos L=0.15 W=2 AD=0.57 AS=0.57 PD=2.57 PS=2.57 NRD=0 NRS=0 m=1 $X=19065 $Y=5020 $D=27
M36 VDD 7 Q 220 pmos L=0.15 W=2 AD=0.58 AS=0.58 PD=2.58 PS=2.58 NRD=0 NRS=0 m=1 $X=19505 $Y=5020 $D=27
M37 Q 8 VDD 220 pmos L=0.15 W=2 AD=0.58 AS=0.58 PD=2.58 PS=2.58 NRD=0 NRS=0 m=1 $X=19945 $Y=5020 $D=27
M38 VDD 8 Q 220 pmos L=0.15 W=2 AD=0.56 AS=0.56 PD=2.56 PS=2.56 NRD=0 NRS=0 m=1 $X=20385 $Y=5020 $D=27
.ENDS
***************************************
