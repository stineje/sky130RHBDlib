* SPICE NETLIST
***************************************

.SUBCKT pad_bond pin0
.ENDS
***************************************
.SUBCKT pad_microprobe pin0
.ENDS
***************************************
.SUBCKT pad_probe pin0
.ENDS
***************************************
.SUBCKT nmos_de_iso_v20 src gate drn b sub
.ENDS
***************************************
.SUBCKT TMRDFFQNX1 GND VDD D CLK QN
** N=720 EP=5 IP=0 FDC=135
M0 GND 7 26 720 nmos L=0.163119 W=2.35104 $X=735 $Y=795 $D=3
M1 27 CLK 26 720 nmos L=0.160516 W=2.29447 $X=1710 $Y=830 $D=3
M2 5 3 27 720 nmos L=0.163346 W=2.31104 $X=3245 $Y=835 $D=3
M3 GND 5 28 720 nmos L=0.163119 W=2.35104 $X=5650 $Y=785 $D=3
M4 3 D 28 720 nmos L=0.163346 W=2.31104 $X=6620 $Y=825 $D=3
M5 GND 3 29 720 nmos L=0.163119 W=2.35104 $X=8980 $Y=785 $D=3
M6 4 7 29 720 nmos L=0.163346 W=2.31104 $X=9950 $Y=825 $D=3
M7 GND 4 30 720 nmos L=0.163119 W=2.35104 $X=12310 $Y=785 $D=3
M8 7 CLK 30 720 nmos L=0.163346 W=2.31104 $X=13280 $Y=825 $D=3
M9 GND 5 31 720 nmos L=0.163119 W=2.35104 $X=15640 $Y=785 $D=3
M10 6 23 31 720 nmos L=0.163346 W=2.31104 $X=16610 $Y=825 $D=3
M11 GND 6 32 720 nmos L=0.163119 W=2.35104 $X=18970 $Y=785 $D=3
M12 23 7 32 720 nmos L=0.163346 W=2.31104 $X=19940 $Y=825 $D=3
M13 GND 12 33 720 nmos L=0.163119 W=2.35104 $X=22195 $Y=795 $D=3
M14 34 CLK 33 720 nmos L=0.160516 W=2.29447 $X=23170 $Y=830 $D=3
M15 10 8 34 720 nmos L=0.163346 W=2.31104 $X=24705 $Y=835 $D=3
M16 GND 10 35 720 nmos L=0.163119 W=2.35104 $X=27110 $Y=785 $D=3
M17 8 D 35 720 nmos L=0.163346 W=2.31104 $X=28080 $Y=825 $D=3
M18 GND 8 36 720 nmos L=0.163119 W=2.35104 $X=30440 $Y=785 $D=3
M19 9 12 36 720 nmos L=0.163346 W=2.31104 $X=31410 $Y=825 $D=3
M20 GND 9 37 720 nmos L=0.163119 W=2.35104 $X=33770 $Y=785 $D=3
M21 12 CLK 37 720 nmos L=0.163346 W=2.31104 $X=34740 $Y=825 $D=3
M22 GND 10 38 720 nmos L=0.163119 W=2.35104 $X=37100 $Y=785 $D=3
M23 11 21 38 720 nmos L=0.163346 W=2.31104 $X=38070 $Y=825 $D=3
M24 GND 11 39 720 nmos L=0.163119 W=2.35104 $X=40430 $Y=785 $D=3
M25 21 12 39 720 nmos L=0.163346 W=2.31104 $X=41400 $Y=825 $D=3
M26 GND 19 40 720 nmos L=0.163119 W=2.35104 $X=43655 $Y=795 $D=3
M27 41 CLK 40 720 nmos L=0.160516 W=2.29447 $X=44630 $Y=830 $D=3
M28 17 14 41 720 nmos L=0.163346 W=2.31104 $X=46165 $Y=835 $D=3
M29 GND 17 42 720 nmos L=0.163119 W=2.35104 $X=48570 $Y=785 $D=3
M30 14 D 42 720 nmos L=0.163346 W=2.31104 $X=49540 $Y=825 $D=3
M31 GND 14 43 720 nmos L=0.163119 W=2.35104 $X=51900 $Y=785 $D=3
M32 15 19 43 720 nmos L=0.163346 W=2.31104 $X=52870 $Y=825 $D=3
M33 GND 15 44 720 nmos L=0.163119 W=2.35104 $X=55230 $Y=785 $D=3
M34 19 CLK 44 720 nmos L=0.163346 W=2.31104 $X=56200 $Y=825 $D=3
M35 GND 17 45 720 nmos L=0.163119 W=2.35104 $X=58560 $Y=785 $D=3
M36 18 20 45 720 nmos L=0.163346 W=2.31104 $X=59530 $Y=825 $D=3
M37 GND 18 46 720 nmos L=0.163119 W=2.35104 $X=61890 $Y=785 $D=3
M38 20 19 46 720 nmos L=0.163346 W=2.31104 $X=62860 $Y=825 $D=3
M39 GND 20 47 720 nmos L=0.163119 W=2.35104 $X=65220 $Y=785 $D=3
M40 QN 21 47 720 nmos L=0.163346 W=2.31104 $X=66190 $Y=825 $D=3
M41 GND 20 48 720 nmos L=0.163119 W=2.35104 $X=68550 $Y=785 $D=3
M42 QN 23 48 720 nmos L=0.163346 W=2.31104 $X=69520 $Y=825 $D=3
M43 GND 23 49 720 nmos L=0.163119 W=2.35104 $X=71880 $Y=785 $D=3
M44 QN 21 49 720 nmos L=0.163129 W=2.31397 $X=72850 $Y=825 $D=3
M45 5 7 VDD 718 pmos L=0.15 W=2 AD=0.57 AS=0.57 PD=2.57 PS=2.57 NRD=0 NRS=0 m=1 $X=1235 $Y=5020 $D=27
M46 VDD 7 5 718 pmos L=0.15 W=2 AD=0.58 AS=0.58 PD=2.58 PS=2.58 NRD=0 NRS=0 m=1 $X=1675 $Y=5020 $D=27
M47 5 CLK VDD 718 pmos L=0.15 W=2 AD=0.58 AS=0.58 PD=2.58 PS=2.58 NRD=0 NRS=0 m=1 $X=2115 $Y=5020 $D=27
M48 VDD CLK 5 718 pmos L=0.15 W=2 AD=0.58 AS=0.58 PD=2.58 PS=2.58 NRD=0 NRS=0 m=1 $X=2555 $Y=5020 $D=27
M49 5 3 VDD 718 pmos L=0.15 W=2 AD=0.58 AS=0.58 PD=2.58 PS=2.58 NRD=0 NRS=0 m=1 $X=2995 $Y=5020 $D=27
M50 VDD 3 5 718 pmos L=0.15 W=2 AD=0.56 AS=0.56 PD=2.56 PS=2.56 NRD=0 NRS=0 m=1 $X=3435 $Y=5020 $D=27
M51 3 5 VDD 718 pmos L=0.15 W=2 AD=0.57 AS=0.57 PD=2.57 PS=2.57 NRD=0 NRS=0 m=1 $X=5745 $Y=5020 $D=27
M52 VDD 5 3 718 pmos L=0.15 W=2 AD=0.58 AS=0.58 PD=2.58 PS=2.58 NRD=0 NRS=0 m=1 $X=6185 $Y=5020 $D=27
M53 3 D VDD 718 pmos L=0.15 W=2 AD=0.58 AS=0.58 PD=2.58 PS=2.58 NRD=0 NRS=0 m=1 $X=6625 $Y=5020 $D=27
M54 VDD D 3 718 pmos L=0.15 W=2 AD=0.56 AS=0.56 PD=2.56 PS=2.56 NRD=0 NRS=0 m=1 $X=7065 $Y=5020 $D=27
M55 4 3 VDD 718 pmos L=0.15 W=2 AD=0.57 AS=0.57 PD=2.57 PS=2.57 NRD=0 NRS=0 m=1 $X=9075 $Y=5020 $D=27
M56 VDD 3 4 718 pmos L=0.15 W=2 AD=0.58 AS=0.58 PD=2.58 PS=2.58 NRD=0 NRS=0 m=1 $X=9515 $Y=5020 $D=27
M57 4 7 VDD 718 pmos L=0.15 W=2 AD=0.58 AS=0.58 PD=2.58 PS=2.58 NRD=0 NRS=0 m=1 $X=9955 $Y=5020 $D=27
M58 VDD 7 4 718 pmos L=0.15 W=2 AD=0.56 AS=0.56 PD=2.56 PS=2.56 NRD=0 NRS=0 m=1 $X=10395 $Y=5020 $D=27
M59 7 4 VDD 718 pmos L=0.15 W=2 AD=0.57 AS=0.57 PD=2.57 PS=2.57 NRD=0 NRS=0 m=1 $X=12405 $Y=5020 $D=27
M60 VDD 4 7 718 pmos L=0.15 W=2 AD=0.58 AS=0.58 PD=2.58 PS=2.58 NRD=0 NRS=0 m=1 $X=12845 $Y=5020 $D=27
M61 7 CLK VDD 718 pmos L=0.15 W=2 AD=0.58 AS=0.58 PD=2.58 PS=2.58 NRD=0 NRS=0 m=1 $X=13285 $Y=5020 $D=27
M62 VDD CLK 7 718 pmos L=0.15 W=2 AD=0.56 AS=0.56 PD=2.56 PS=2.56 NRD=0 NRS=0 m=1 $X=13725 $Y=5020 $D=27
M63 6 5 VDD 718 pmos L=0.15 W=2 AD=0.57 AS=0.57 PD=2.57 PS=2.57 NRD=0 NRS=0 m=1 $X=15735 $Y=5020 $D=27
M64 VDD 5 6 718 pmos L=0.15 W=2 AD=0.58 AS=0.58 PD=2.58 PS=2.58 NRD=0 NRS=0 m=1 $X=16175 $Y=5020 $D=27
M65 6 23 VDD 718 pmos L=0.15 W=2 AD=0.58 AS=0.58 PD=2.58 PS=2.58 NRD=0 NRS=0 m=1 $X=16615 $Y=5020 $D=27
M66 VDD 23 6 718 pmos L=0.15 W=2 AD=0.56 AS=0.56 PD=2.56 PS=2.56 NRD=0 NRS=0 m=1 $X=17055 $Y=5020 $D=27
M67 23 6 VDD 718 pmos L=0.15 W=2 AD=0.57 AS=0.57 PD=2.57 PS=2.57 NRD=0 NRS=0 m=1 $X=19065 $Y=5020 $D=27
M68 VDD 6 23 718 pmos L=0.15 W=2 AD=0.58 AS=0.58 PD=2.58 PS=2.58 NRD=0 NRS=0 m=1 $X=19505 $Y=5020 $D=27
M69 23 7 VDD 718 pmos L=0.15 W=2 AD=0.58 AS=0.58 PD=2.58 PS=2.58 NRD=0 NRS=0 m=1 $X=19945 $Y=5020 $D=27
M70 VDD 7 23 718 pmos L=0.15 W=2 AD=0.56 AS=0.56 PD=2.56 PS=2.56 NRD=0 NRS=0 m=1 $X=20385 $Y=5020 $D=27
M71 10 12 VDD 718 pmos L=0.15 W=2 AD=0.57 AS=0.57 PD=2.57 PS=2.57 NRD=0 NRS=0 m=1 $X=22695 $Y=5020 $D=27
M72 VDD 12 10 718 pmos L=0.15 W=2 AD=0.58 AS=0.58 PD=2.58 PS=2.58 NRD=0 NRS=0 m=1 $X=23135 $Y=5020 $D=27
M73 10 CLK VDD 718 pmos L=0.15 W=2 AD=0.58 AS=0.58 PD=2.58 PS=2.58 NRD=0 NRS=0 m=1 $X=23575 $Y=5020 $D=27
M74 VDD CLK 10 718 pmos L=0.15 W=2 AD=0.58 AS=0.58 PD=2.58 PS=2.58 NRD=0 NRS=0 m=1 $X=24015 $Y=5020 $D=27
M75 10 8 VDD 718 pmos L=0.15 W=2 AD=0.58 AS=0.58 PD=2.58 PS=2.58 NRD=0 NRS=0 m=1 $X=24455 $Y=5020 $D=27
M76 VDD 8 10 718 pmos L=0.15 W=2 AD=0.56 AS=0.56 PD=2.56 PS=2.56 NRD=0 NRS=0 m=1 $X=24895 $Y=5020 $D=27
M77 8 10 VDD 718 pmos L=0.15 W=2 AD=0.57 AS=0.57 PD=2.57 PS=2.57 NRD=0 NRS=0 m=1 $X=27205 $Y=5020 $D=27
M78 VDD 10 8 718 pmos L=0.15 W=2 AD=0.58 AS=0.58 PD=2.58 PS=2.58 NRD=0 NRS=0 m=1 $X=27645 $Y=5020 $D=27
M79 8 D VDD 718 pmos L=0.15 W=2 AD=0.58 AS=0.58 PD=2.58 PS=2.58 NRD=0 NRS=0 m=1 $X=28085 $Y=5020 $D=27
M80 VDD D 8 718 pmos L=0.15 W=2 AD=0.56 AS=0.56 PD=2.56 PS=2.56 NRD=0 NRS=0 m=1 $X=28525 $Y=5020 $D=27
M81 9 8 VDD 718 pmos L=0.15 W=2 AD=0.57 AS=0.57 PD=2.57 PS=2.57 NRD=0 NRS=0 m=1 $X=30535 $Y=5020 $D=27
M82 VDD 8 9 718 pmos L=0.15 W=2 AD=0.58 AS=0.58 PD=2.58 PS=2.58 NRD=0 NRS=0 m=1 $X=30975 $Y=5020 $D=27
M83 9 12 VDD 718 pmos L=0.15 W=2 AD=0.58 AS=0.58 PD=2.58 PS=2.58 NRD=0 NRS=0 m=1 $X=31415 $Y=5020 $D=27
M84 VDD 12 9 718 pmos L=0.15 W=2 AD=0.56 AS=0.56 PD=2.56 PS=2.56 NRD=0 NRS=0 m=1 $X=31855 $Y=5020 $D=27
M85 12 9 VDD 718 pmos L=0.15 W=2 AD=0.57 AS=0.57 PD=2.57 PS=2.57 NRD=0 NRS=0 m=1 $X=33865 $Y=5020 $D=27
M86 VDD 9 12 718 pmos L=0.15 W=2 AD=0.58 AS=0.58 PD=2.58 PS=2.58 NRD=0 NRS=0 m=1 $X=34305 $Y=5020 $D=27
M87 12 CLK VDD 718 pmos L=0.15 W=2 AD=0.58 AS=0.58 PD=2.58 PS=2.58 NRD=0 NRS=0 m=1 $X=34745 $Y=5020 $D=27
M88 VDD CLK 12 718 pmos L=0.15 W=2 AD=0.56 AS=0.56 PD=2.56 PS=2.56 NRD=0 NRS=0 m=1 $X=35185 $Y=5020 $D=27
M89 11 10 VDD 718 pmos L=0.15 W=2 AD=0.57 AS=0.57 PD=2.57 PS=2.57 NRD=0 NRS=0 m=1 $X=37195 $Y=5020 $D=27
M90 VDD 10 11 718 pmos L=0.15 W=2 AD=0.58 AS=0.58 PD=2.58 PS=2.58 NRD=0 NRS=0 m=1 $X=37635 $Y=5020 $D=27
M91 11 21 VDD 718 pmos L=0.15 W=2 AD=0.58 AS=0.58 PD=2.58 PS=2.58 NRD=0 NRS=0 m=1 $X=38075 $Y=5020 $D=27
M92 VDD 21 11 718 pmos L=0.15 W=2 AD=0.56 AS=0.56 PD=2.56 PS=2.56 NRD=0 NRS=0 m=1 $X=38515 $Y=5020 $D=27
M93 21 11 VDD 718 pmos L=0.15 W=2 AD=0.57 AS=0.57 PD=2.57 PS=2.57 NRD=0 NRS=0 m=1 $X=40525 $Y=5020 $D=27
M94 VDD 11 21 718 pmos L=0.15 W=2 AD=0.58 AS=0.58 PD=2.58 PS=2.58 NRD=0 NRS=0 m=1 $X=40965 $Y=5020 $D=27
M95 21 12 VDD 718 pmos L=0.15 W=2 AD=0.58 AS=0.58 PD=2.58 PS=2.58 NRD=0 NRS=0 m=1 $X=41405 $Y=5020 $D=27
M96 VDD 12 21 718 pmos L=0.15 W=2 AD=0.56 AS=0.56 PD=2.56 PS=2.56 NRD=0 NRS=0 m=1 $X=41845 $Y=5020 $D=27
M97 17 19 VDD 718 pmos L=0.15 W=2 AD=0.57 AS=0.57 PD=2.57 PS=2.57 NRD=0 NRS=0 m=1 $X=44155 $Y=5020 $D=27
M98 VDD 19 17 718 pmos L=0.15 W=2 AD=0.58 AS=0.58 PD=2.58 PS=2.58 NRD=0 NRS=0 m=1 $X=44595 $Y=5020 $D=27
M99 17 CLK VDD 718 pmos L=0.15 W=2 AD=0.58 AS=0.58 PD=2.58 PS=2.58 NRD=0 NRS=0 m=1 $X=45035 $Y=5020 $D=27
M100 VDD CLK 17 718 pmos L=0.15 W=2 AD=0.58 AS=0.58 PD=2.58 PS=2.58 NRD=0 NRS=0 m=1 $X=45475 $Y=5020 $D=27
M101 17 14 VDD 718 pmos L=0.15 W=2 AD=0.58 AS=0.58 PD=2.58 PS=2.58 NRD=0 NRS=0 m=1 $X=45915 $Y=5020 $D=27
M102 VDD 14 17 718 pmos L=0.15 W=2 AD=0.56 AS=0.56 PD=2.56 PS=2.56 NRD=0 NRS=0 m=1 $X=46355 $Y=5020 $D=27
M103 14 17 VDD 718 pmos L=0.15 W=2 AD=0.57 AS=0.57 PD=2.57 PS=2.57 NRD=0 NRS=0 m=1 $X=48665 $Y=5020 $D=27
M104 VDD 17 14 718 pmos L=0.15 W=2 AD=0.58 AS=0.58 PD=2.58 PS=2.58 NRD=0 NRS=0 m=1 $X=49105 $Y=5020 $D=27
M105 14 D VDD 718 pmos L=0.15 W=2 AD=0.58 AS=0.58 PD=2.58 PS=2.58 NRD=0 NRS=0 m=1 $X=49545 $Y=5020 $D=27
M106 VDD D 14 718 pmos L=0.15 W=2 AD=0.56 AS=0.56 PD=2.56 PS=2.56 NRD=0 NRS=0 m=1 $X=49985 $Y=5020 $D=27
M107 15 14 VDD 718 pmos L=0.15 W=2 AD=0.57 AS=0.57 PD=2.57 PS=2.57 NRD=0 NRS=0 m=1 $X=51995 $Y=5020 $D=27
M108 VDD 14 15 718 pmos L=0.15 W=2 AD=0.58 AS=0.58 PD=2.58 PS=2.58 NRD=0 NRS=0 m=1 $X=52435 $Y=5020 $D=27
M109 15 19 VDD 718 pmos L=0.15 W=2 AD=0.58 AS=0.58 PD=2.58 PS=2.58 NRD=0 NRS=0 m=1 $X=52875 $Y=5020 $D=27
M110 VDD 19 15 718 pmos L=0.15 W=2 AD=0.56 AS=0.56 PD=2.56 PS=2.56 NRD=0 NRS=0 m=1 $X=53315 $Y=5020 $D=27
M111 19 15 VDD 718 pmos L=0.15 W=2 AD=0.57 AS=0.57 PD=2.57 PS=2.57 NRD=0 NRS=0 m=1 $X=55325 $Y=5020 $D=27
M112 VDD 15 19 718 pmos L=0.15 W=2 AD=0.58 AS=0.58 PD=2.58 PS=2.58 NRD=0 NRS=0 m=1 $X=55765 $Y=5020 $D=27
M113 19 CLK VDD 718 pmos L=0.15 W=2 AD=0.58 AS=0.58 PD=2.58 PS=2.58 NRD=0 NRS=0 m=1 $X=56205 $Y=5020 $D=27
M114 VDD CLK 19 718 pmos L=0.15 W=2 AD=0.56 AS=0.56 PD=2.56 PS=2.56 NRD=0 NRS=0 m=1 $X=56645 $Y=5020 $D=27
M115 18 17 VDD 718 pmos L=0.15 W=2 AD=0.57 AS=0.57 PD=2.57 PS=2.57 NRD=0 NRS=0 m=1 $X=58655 $Y=5020 $D=27
M116 VDD 17 18 718 pmos L=0.15 W=2 AD=0.58 AS=0.58 PD=2.58 PS=2.58 NRD=0 NRS=0 m=1 $X=59095 $Y=5020 $D=27
M117 18 20 VDD 718 pmos L=0.15 W=2 AD=0.58 AS=0.58 PD=2.58 PS=2.58 NRD=0 NRS=0 m=1 $X=59535 $Y=5020 $D=27
M118 VDD 20 18 718 pmos L=0.15 W=2 AD=0.56 AS=0.56 PD=2.56 PS=2.56 NRD=0 NRS=0 m=1 $X=59975 $Y=5020 $D=27
M119 20 18 VDD 718 pmos L=0.15 W=2 AD=0.57 AS=0.57 PD=2.57 PS=2.57 NRD=0 NRS=0 m=1 $X=61985 $Y=5020 $D=27
M120 VDD 18 20 718 pmos L=0.15 W=2 AD=0.58 AS=0.58 PD=2.58 PS=2.58 NRD=0 NRS=0 m=1 $X=62425 $Y=5020 $D=27
M121 20 19 VDD 718 pmos L=0.15 W=2 AD=0.58 AS=0.58 PD=2.58 PS=2.58 NRD=0 NRS=0 m=1 $X=62865 $Y=5020 $D=27
M122 VDD 19 20 718 pmos L=0.15 W=2 AD=0.56 AS=0.56 PD=2.56 PS=2.56 NRD=0 NRS=0 m=1 $X=63305 $Y=5020 $D=27
M123 22 20 VDD 718 pmos L=0.15 W=2 AD=0.57 AS=0.57 PD=2.57 PS=2.57 NRD=0 NRS=0 m=1 $X=65315 $Y=5025 $D=27
M124 VDD 20 22 718 pmos L=0.15 W=2 AD=0.58 AS=0.58 PD=2.58 PS=2.58 NRD=0 NRS=0 m=1 $X=65755 $Y=5025 $D=27
M125 22 21 VDD 718 pmos L=0.15 W=2 AD=0.58 AS=0.58 PD=2.58 PS=2.58 NRD=0 NRS=0 m=1 $X=66195 $Y=5025 $D=27
M126 VDD 21 22 718 pmos L=0.15 W=2 AD=0.56 AS=0.56 PD=2.56 PS=2.56 NRD=0 NRS=0 m=1 $X=66635 $Y=5025 $D=27
M127 24 20 22 718 pmos L=0.15 W=2 AD=0.56 AS=0.56 PD=2.56 PS=2.56 NRD=0 NRS=0 m=1 $X=68635 $Y=5025 $D=27
M128 22 20 24 718 pmos L=0.15 W=2 AD=0.58 AS=0.58 PD=2.58 PS=2.58 NRD=0 NRS=0 m=1 $X=69075 $Y=5025 $D=27
M129 24 23 22 718 pmos L=0.15 W=2 AD=0.58 AS=0.58 PD=2.58 PS=2.58 NRD=0 NRS=0 m=1 $X=69515 $Y=5025 $D=27
M130 22 23 24 718 pmos L=0.15 W=2 AD=0.57 AS=0.57 PD=2.57 PS=2.57 NRD=0 NRS=0 m=1 $X=69955 $Y=5025 $D=27
M131 QN 23 24 718 pmos L=0.15 W=2 AD=0.57 AS=0.57 PD=2.57 PS=2.57 NRD=0 NRS=0 m=1 $X=71975 $Y=5025 $D=27
M132 24 23 QN 718 pmos L=0.15 W=2 AD=0.58 AS=0.58 PD=2.58 PS=2.58 NRD=0 NRS=0 m=1 $X=72415 $Y=5025 $D=27
M133 QN 21 24 718 pmos L=0.15 W=2 AD=0.58 AS=0.58 PD=2.58 PS=2.58 NRD=0 NRS=0 m=1 $X=72855 $Y=5025 $D=27
M134 24 21 QN 718 pmos L=0.15 W=2 AD=0.56 AS=0.56 PD=2.56 PS=2.56 NRD=0 NRS=0 m=1 $X=73295 $Y=5025 $D=27
.ENDS
***************************************
