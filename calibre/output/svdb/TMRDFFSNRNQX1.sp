* SPICE NETLIST
***************************************

.SUBCKT pad_bond pin0
.ENDS
***************************************
.SUBCKT pad_microprobe pin0
.ENDS
***************************************
.SUBCKT pad_probe pin0
.ENDS
***************************************
.SUBCKT nmos_de_iso_v20 src gate drn b sub
.ENDS
***************************************
.SUBCKT TMRDFFSNRNQX1 GND VDD D CLK RN SN Q
** N=882 EP=7 IP=0 FDC=183
M0 GND D 29 882 nmos L=0.163119 W=2.35104 $X=735 $Y=795 $D=3
M1 30 RN 29 882 nmos L=0.160516 W=2.29447 $X=1710 $Y=830 $D=3
M2 3 5 30 882 nmos L=0.163346 W=2.31104 $X=3245 $Y=835 $D=3
M3 GND 3 31 882 nmos L=0.163119 W=2.35104 $X=5545 $Y=795 $D=3
M4 32 CLK 31 882 nmos L=0.160516 W=2.29447 $X=6520 $Y=830 $D=3
M5 5 7 32 882 nmos L=0.163346 W=2.31104 $X=8055 $Y=835 $D=3
M6 GND 3 33 882 nmos L=0.163119 W=2.35104 $X=10355 $Y=795 $D=3
M7 34 SN 33 882 nmos L=0.160516 W=2.29447 $X=11330 $Y=830 $D=3
M8 4 7 34 882 nmos L=0.163346 W=2.31104 $X=12865 $Y=835 $D=3
M9 GND 4 35 882 nmos L=0.163119 W=2.35104 $X=15165 $Y=795 $D=3
M10 36 CLK 35 882 nmos L=0.160516 W=2.29447 $X=16140 $Y=830 $D=3
M11 7 RN 36 882 nmos L=0.163346 W=2.31104 $X=17675 $Y=835 $D=3
M12 GND 5 37 882 nmos L=0.163119 W=2.35104 $X=19975 $Y=795 $D=3
M13 38 RN 37 882 nmos L=0.160516 W=2.29447 $X=20950 $Y=830 $D=3
M14 6 8 38 882 nmos L=0.163346 W=2.31104 $X=22485 $Y=835 $D=3
M15 GND 6 39 882 nmos L=0.163119 W=2.35104 $X=24785 $Y=795 $D=3
M16 40 SN 39 882 nmos L=0.160516 W=2.29447 $X=25760 $Y=830 $D=3
M17 8 7 40 882 nmos L=0.163346 W=2.31104 $X=27295 $Y=835 $D=3
M18 GND D 41 882 nmos L=0.163119 W=2.35104 $X=29595 $Y=795 $D=3
M19 42 RN 41 882 nmos L=0.160516 W=2.29447 $X=30570 $Y=830 $D=3
M20 9 11 42 882 nmos L=0.163346 W=2.31104 $X=32105 $Y=835 $D=3
M21 GND 9 43 882 nmos L=0.163119 W=2.35104 $X=34405 $Y=795 $D=3
M22 44 CLK 43 882 nmos L=0.160516 W=2.29447 $X=35380 $Y=830 $D=3
M23 11 13 44 882 nmos L=0.163346 W=2.31104 $X=36915 $Y=835 $D=3
M24 GND 9 45 882 nmos L=0.163119 W=2.35104 $X=39215 $Y=795 $D=3
M25 46 SN 45 882 nmos L=0.160516 W=2.29447 $X=40190 $Y=830 $D=3
M26 10 13 46 882 nmos L=0.163346 W=2.31104 $X=41725 $Y=835 $D=3
M27 GND 10 47 882 nmos L=0.163119 W=2.35104 $X=44025 $Y=795 $D=3
M28 48 CLK 47 882 nmos L=0.160516 W=2.29447 $X=45000 $Y=830 $D=3
M29 13 RN 48 882 nmos L=0.163346 W=2.31104 $X=46535 $Y=835 $D=3
M30 GND 11 49 882 nmos L=0.163119 W=2.35104 $X=48835 $Y=795 $D=3
M31 50 RN 49 882 nmos L=0.160516 W=2.29447 $X=49810 $Y=830 $D=3
M32 12 14 50 882 nmos L=0.163346 W=2.31104 $X=51345 $Y=835 $D=3
M33 GND 12 51 882 nmos L=0.163119 W=2.35104 $X=53645 $Y=795 $D=3
M34 52 SN 51 882 nmos L=0.160516 W=2.29447 $X=54620 $Y=830 $D=3
M35 14 13 52 882 nmos L=0.163346 W=2.31104 $X=56155 $Y=835 $D=3
M36 GND D 53 882 nmos L=0.163119 W=2.35104 $X=58455 $Y=795 $D=3
M37 54 RN 53 882 nmos L=0.160516 W=2.29447 $X=59430 $Y=830 $D=3
M38 16 19 54 882 nmos L=0.163346 W=2.31104 $X=60965 $Y=835 $D=3
M39 GND 16 55 882 nmos L=0.163119 W=2.35104 $X=63265 $Y=795 $D=3
M40 56 CLK 55 882 nmos L=0.160516 W=2.29447 $X=64240 $Y=830 $D=3
M41 19 23 56 882 nmos L=0.163346 W=2.31104 $X=65775 $Y=835 $D=3
M42 GND 16 57 882 nmos L=0.163119 W=2.35104 $X=68075 $Y=795 $D=3
M43 58 SN 57 882 nmos L=0.160516 W=2.29447 $X=69050 $Y=830 $D=3
M44 17 23 58 882 nmos L=0.163346 W=2.31104 $X=70585 $Y=835 $D=3
M45 GND 17 59 882 nmos L=0.163119 W=2.35104 $X=72885 $Y=795 $D=3
M46 60 CLK 59 882 nmos L=0.160516 W=2.29447 $X=73860 $Y=830 $D=3
M47 23 RN 60 882 nmos L=0.163346 W=2.31104 $X=75395 $Y=835 $D=3
M48 GND 19 61 882 nmos L=0.163119 W=2.35104 $X=77695 $Y=795 $D=3
M49 62 RN 61 882 nmos L=0.160516 W=2.29447 $X=78670 $Y=830 $D=3
M50 21 25 62 882 nmos L=0.163346 W=2.31104 $X=80205 $Y=835 $D=3
M51 GND 21 63 882 nmos L=0.163119 W=2.35104 $X=82505 $Y=795 $D=3
M52 64 SN 63 882 nmos L=0.160516 W=2.29447 $X=83480 $Y=830 $D=3
M53 25 23 64 882 nmos L=0.163346 W=2.31104 $X=85015 $Y=835 $D=3
M54 GND 8 65 882 nmos L=0.163119 W=2.35104 $X=87420 $Y=785 $D=3
M55 27 14 65 882 nmos L=0.163346 W=2.31104 $X=88390 $Y=825 $D=3
M56 GND 8 66 882 nmos L=0.163119 W=2.35104 $X=90750 $Y=785 $D=3
M57 27 25 66 882 nmos L=0.163346 W=2.31104 $X=91720 $Y=825 $D=3
M58 GND 25 67 882 nmos L=0.163119 W=2.35104 $X=94080 $Y=785 $D=3
M59 27 14 67 882 nmos L=0.163129 W=2.31397 $X=95050 $Y=825 $D=3
M60 Q 27 GND 882 nmos L=0.163346 W=2.31104 $X=97345 $Y=830 $D=3
M61 3 D VDD 880 pmos L=0.15 W=2 AD=0.57 AS=0.57 PD=2.57 PS=2.57 NRD=0 NRS=0 m=1 $X=1235 $Y=5020 $D=27
M62 VDD D 3 880 pmos L=0.15 W=2 AD=0.58 AS=0.58 PD=2.58 PS=2.58 NRD=0 NRS=0 m=1 $X=1675 $Y=5020 $D=27
M63 3 RN VDD 880 pmos L=0.15 W=2 AD=0.58 AS=0.58 PD=2.58 PS=2.58 NRD=0 NRS=0 m=1 $X=2115 $Y=5020 $D=27
M64 VDD RN 3 880 pmos L=0.15 W=2 AD=0.58 AS=0.58 PD=2.58 PS=2.58 NRD=0 NRS=0 m=1 $X=2555 $Y=5020 $D=27
M65 3 5 VDD 880 pmos L=0.15 W=2 AD=0.58 AS=0.58 PD=2.58 PS=2.58 NRD=0 NRS=0 m=1 $X=2995 $Y=5020 $D=27
M66 VDD 5 3 880 pmos L=0.15 W=2 AD=0.56 AS=0.56 PD=2.56 PS=2.56 NRD=0 NRS=0 m=1 $X=3435 $Y=5020 $D=27
M67 5 3 VDD 880 pmos L=0.15 W=2 AD=0.57 AS=0.57 PD=2.57 PS=2.57 NRD=0 NRS=0 m=1 $X=6045 $Y=5020 $D=27
M68 VDD 3 5 880 pmos L=0.15 W=2 AD=0.58 AS=0.58 PD=2.58 PS=2.58 NRD=0 NRS=0 m=1 $X=6485 $Y=5020 $D=27
M69 5 CLK VDD 880 pmos L=0.15 W=2 AD=0.58 AS=0.58 PD=2.58 PS=2.58 NRD=0 NRS=0 m=1 $X=6925 $Y=5020 $D=27
M70 VDD CLK 5 880 pmos L=0.15 W=2 AD=0.58 AS=0.58 PD=2.58 PS=2.58 NRD=0 NRS=0 m=1 $X=7365 $Y=5020 $D=27
M71 5 7 VDD 880 pmos L=0.15 W=2 AD=0.58 AS=0.58 PD=2.58 PS=2.58 NRD=0 NRS=0 m=1 $X=7805 $Y=5020 $D=27
M72 VDD 7 5 880 pmos L=0.15 W=2 AD=0.56 AS=0.56 PD=2.56 PS=2.56 NRD=0 NRS=0 m=1 $X=8245 $Y=5020 $D=27
M73 4 3 VDD 880 pmos L=0.15 W=2 AD=0.57 AS=0.57 PD=2.57 PS=2.57 NRD=0 NRS=0 m=1 $X=10855 $Y=5020 $D=27
M74 VDD 3 4 880 pmos L=0.15 W=2 AD=0.58 AS=0.58 PD=2.58 PS=2.58 NRD=0 NRS=0 m=1 $X=11295 $Y=5020 $D=27
M75 4 SN VDD 880 pmos L=0.15 W=2 AD=0.58 AS=0.58 PD=2.58 PS=2.58 NRD=0 NRS=0 m=1 $X=11735 $Y=5020 $D=27
M76 VDD SN 4 880 pmos L=0.15 W=2 AD=0.58 AS=0.58 PD=2.58 PS=2.58 NRD=0 NRS=0 m=1 $X=12175 $Y=5020 $D=27
M77 4 7 VDD 880 pmos L=0.15 W=2 AD=0.58 AS=0.58 PD=2.58 PS=2.58 NRD=0 NRS=0 m=1 $X=12615 $Y=5020 $D=27
M78 VDD 7 4 880 pmos L=0.15 W=2 AD=0.56 AS=0.56 PD=2.56 PS=2.56 NRD=0 NRS=0 m=1 $X=13055 $Y=5020 $D=27
M79 7 4 VDD 880 pmos L=0.15 W=2 AD=0.57 AS=0.57 PD=2.57 PS=2.57 NRD=0 NRS=0 m=1 $X=15665 $Y=5020 $D=27
M80 VDD 4 7 880 pmos L=0.15 W=2 AD=0.58 AS=0.58 PD=2.58 PS=2.58 NRD=0 NRS=0 m=1 $X=16105 $Y=5020 $D=27
M81 7 CLK VDD 880 pmos L=0.15 W=2 AD=0.58 AS=0.58 PD=2.58 PS=2.58 NRD=0 NRS=0 m=1 $X=16545 $Y=5020 $D=27
M82 VDD CLK 7 880 pmos L=0.15 W=2 AD=0.58 AS=0.58 PD=2.58 PS=2.58 NRD=0 NRS=0 m=1 $X=16985 $Y=5020 $D=27
M83 7 RN VDD 880 pmos L=0.15 W=2 AD=0.58 AS=0.58 PD=2.58 PS=2.58 NRD=0 NRS=0 m=1 $X=17425 $Y=5020 $D=27
M84 VDD RN 7 880 pmos L=0.15 W=2 AD=0.56 AS=0.56 PD=2.56 PS=2.56 NRD=0 NRS=0 m=1 $X=17865 $Y=5020 $D=27
M85 6 5 VDD 880 pmos L=0.15 W=2 AD=0.57 AS=0.57 PD=2.57 PS=2.57 NRD=0 NRS=0 m=1 $X=20475 $Y=5020 $D=27
M86 VDD 5 6 880 pmos L=0.15 W=2 AD=0.58 AS=0.58 PD=2.58 PS=2.58 NRD=0 NRS=0 m=1 $X=20915 $Y=5020 $D=27
M87 6 RN VDD 880 pmos L=0.15 W=2 AD=0.58 AS=0.58 PD=2.58 PS=2.58 NRD=0 NRS=0 m=1 $X=21355 $Y=5020 $D=27
M88 VDD RN 6 880 pmos L=0.15 W=2 AD=0.58 AS=0.58 PD=2.58 PS=2.58 NRD=0 NRS=0 m=1 $X=21795 $Y=5020 $D=27
M89 6 8 VDD 880 pmos L=0.15 W=2 AD=0.58 AS=0.58 PD=2.58 PS=2.58 NRD=0 NRS=0 m=1 $X=22235 $Y=5020 $D=27
M90 VDD 8 6 880 pmos L=0.15 W=2 AD=0.56 AS=0.56 PD=2.56 PS=2.56 NRD=0 NRS=0 m=1 $X=22675 $Y=5020 $D=27
M91 8 6 VDD 880 pmos L=0.15 W=2 AD=0.57 AS=0.57 PD=2.57 PS=2.57 NRD=0 NRS=0 m=1 $X=25285 $Y=5020 $D=27
M92 VDD 6 8 880 pmos L=0.15 W=2 AD=0.58 AS=0.58 PD=2.58 PS=2.58 NRD=0 NRS=0 m=1 $X=25725 $Y=5020 $D=27
M93 8 SN VDD 880 pmos L=0.15 W=2 AD=0.58 AS=0.58 PD=2.58 PS=2.58 NRD=0 NRS=0 m=1 $X=26165 $Y=5020 $D=27
M94 VDD SN 8 880 pmos L=0.15 W=2 AD=0.58 AS=0.58 PD=2.58 PS=2.58 NRD=0 NRS=0 m=1 $X=26605 $Y=5020 $D=27
M95 8 7 VDD 880 pmos L=0.15 W=2 AD=0.58 AS=0.58 PD=2.58 PS=2.58 NRD=0 NRS=0 m=1 $X=27045 $Y=5020 $D=27
M96 VDD 7 8 880 pmos L=0.15 W=2 AD=0.56 AS=0.56 PD=2.56 PS=2.56 NRD=0 NRS=0 m=1 $X=27485 $Y=5020 $D=27
M97 9 D VDD 880 pmos L=0.15 W=2 AD=0.57 AS=0.57 PD=2.57 PS=2.57 NRD=0 NRS=0 m=1 $X=30095 $Y=5020 $D=27
M98 VDD D 9 880 pmos L=0.15 W=2 AD=0.58 AS=0.58 PD=2.58 PS=2.58 NRD=0 NRS=0 m=1 $X=30535 $Y=5020 $D=27
M99 9 RN VDD 880 pmos L=0.15 W=2 AD=0.58 AS=0.58 PD=2.58 PS=2.58 NRD=0 NRS=0 m=1 $X=30975 $Y=5020 $D=27
M100 VDD RN 9 880 pmos L=0.15 W=2 AD=0.58 AS=0.58 PD=2.58 PS=2.58 NRD=0 NRS=0 m=1 $X=31415 $Y=5020 $D=27
M101 9 11 VDD 880 pmos L=0.15 W=2 AD=0.58 AS=0.58 PD=2.58 PS=2.58 NRD=0 NRS=0 m=1 $X=31855 $Y=5020 $D=27
M102 VDD 11 9 880 pmos L=0.15 W=2 AD=0.56 AS=0.56 PD=2.56 PS=2.56 NRD=0 NRS=0 m=1 $X=32295 $Y=5020 $D=27
M103 11 9 VDD 880 pmos L=0.15 W=2 AD=0.57 AS=0.57 PD=2.57 PS=2.57 NRD=0 NRS=0 m=1 $X=34905 $Y=5020 $D=27
M104 VDD 9 11 880 pmos L=0.15 W=2 AD=0.58 AS=0.58 PD=2.58 PS=2.58 NRD=0 NRS=0 m=1 $X=35345 $Y=5020 $D=27
M105 11 CLK VDD 880 pmos L=0.15 W=2 AD=0.58 AS=0.58 PD=2.58 PS=2.58 NRD=0 NRS=0 m=1 $X=35785 $Y=5020 $D=27
M106 VDD CLK 11 880 pmos L=0.15 W=2 AD=0.58 AS=0.58 PD=2.58 PS=2.58 NRD=0 NRS=0 m=1 $X=36225 $Y=5020 $D=27
M107 11 13 VDD 880 pmos L=0.15 W=2 AD=0.58 AS=0.58 PD=2.58 PS=2.58 NRD=0 NRS=0 m=1 $X=36665 $Y=5020 $D=27
M108 VDD 13 11 880 pmos L=0.15 W=2 AD=0.56 AS=0.56 PD=2.56 PS=2.56 NRD=0 NRS=0 m=1 $X=37105 $Y=5020 $D=27
M109 10 9 VDD 880 pmos L=0.15 W=2 AD=0.57 AS=0.57 PD=2.57 PS=2.57 NRD=0 NRS=0 m=1 $X=39715 $Y=5020 $D=27
M110 VDD 9 10 880 pmos L=0.15 W=2 AD=0.58 AS=0.58 PD=2.58 PS=2.58 NRD=0 NRS=0 m=1 $X=40155 $Y=5020 $D=27
M111 10 SN VDD 880 pmos L=0.15 W=2 AD=0.58 AS=0.58 PD=2.58 PS=2.58 NRD=0 NRS=0 m=1 $X=40595 $Y=5020 $D=27
M112 VDD SN 10 880 pmos L=0.15 W=2 AD=0.58 AS=0.58 PD=2.58 PS=2.58 NRD=0 NRS=0 m=1 $X=41035 $Y=5020 $D=27
M113 10 13 VDD 880 pmos L=0.15 W=2 AD=0.58 AS=0.58 PD=2.58 PS=2.58 NRD=0 NRS=0 m=1 $X=41475 $Y=5020 $D=27
M114 VDD 13 10 880 pmos L=0.15 W=2 AD=0.56 AS=0.56 PD=2.56 PS=2.56 NRD=0 NRS=0 m=1 $X=41915 $Y=5020 $D=27
M115 13 10 VDD 880 pmos L=0.15 W=2 AD=0.57 AS=0.57 PD=2.57 PS=2.57 NRD=0 NRS=0 m=1 $X=44525 $Y=5020 $D=27
M116 VDD 10 13 880 pmos L=0.15 W=2 AD=0.58 AS=0.58 PD=2.58 PS=2.58 NRD=0 NRS=0 m=1 $X=44965 $Y=5020 $D=27
M117 13 CLK VDD 880 pmos L=0.15 W=2 AD=0.58 AS=0.58 PD=2.58 PS=2.58 NRD=0 NRS=0 m=1 $X=45405 $Y=5020 $D=27
M118 VDD CLK 13 880 pmos L=0.15 W=2 AD=0.58 AS=0.58 PD=2.58 PS=2.58 NRD=0 NRS=0 m=1 $X=45845 $Y=5020 $D=27
M119 13 RN VDD 880 pmos L=0.15 W=2 AD=0.58 AS=0.58 PD=2.58 PS=2.58 NRD=0 NRS=0 m=1 $X=46285 $Y=5020 $D=27
M120 VDD RN 13 880 pmos L=0.15 W=2 AD=0.56 AS=0.56 PD=2.56 PS=2.56 NRD=0 NRS=0 m=1 $X=46725 $Y=5020 $D=27
M121 12 11 VDD 880 pmos L=0.15 W=2 AD=0.57 AS=0.57 PD=2.57 PS=2.57 NRD=0 NRS=0 m=1 $X=49335 $Y=5020 $D=27
M122 VDD 11 12 880 pmos L=0.15 W=2 AD=0.58 AS=0.58 PD=2.58 PS=2.58 NRD=0 NRS=0 m=1 $X=49775 $Y=5020 $D=27
M123 12 RN VDD 880 pmos L=0.15 W=2 AD=0.58 AS=0.58 PD=2.58 PS=2.58 NRD=0 NRS=0 m=1 $X=50215 $Y=5020 $D=27
M124 VDD RN 12 880 pmos L=0.15 W=2 AD=0.58 AS=0.58 PD=2.58 PS=2.58 NRD=0 NRS=0 m=1 $X=50655 $Y=5020 $D=27
M125 12 14 VDD 880 pmos L=0.15 W=2 AD=0.58 AS=0.58 PD=2.58 PS=2.58 NRD=0 NRS=0 m=1 $X=51095 $Y=5020 $D=27
M126 VDD 14 12 880 pmos L=0.15 W=2 AD=0.56 AS=0.56 PD=2.56 PS=2.56 NRD=0 NRS=0 m=1 $X=51535 $Y=5020 $D=27
M127 14 12 VDD 880 pmos L=0.15 W=2 AD=0.57 AS=0.57 PD=2.57 PS=2.57 NRD=0 NRS=0 m=1 $X=54145 $Y=5020 $D=27
M128 VDD 12 14 880 pmos L=0.15 W=2 AD=0.58 AS=0.58 PD=2.58 PS=2.58 NRD=0 NRS=0 m=1 $X=54585 $Y=5020 $D=27
M129 14 SN VDD 880 pmos L=0.15 W=2 AD=0.58 AS=0.58 PD=2.58 PS=2.58 NRD=0 NRS=0 m=1 $X=55025 $Y=5020 $D=27
M130 VDD SN 14 880 pmos L=0.15 W=2 AD=0.58 AS=0.58 PD=2.58 PS=2.58 NRD=0 NRS=0 m=1 $X=55465 $Y=5020 $D=27
M131 14 13 VDD 880 pmos L=0.15 W=2 AD=0.58 AS=0.58 PD=2.58 PS=2.58 NRD=0 NRS=0 m=1 $X=55905 $Y=5020 $D=27
M132 VDD 13 14 880 pmos L=0.15 W=2 AD=0.56 AS=0.56 PD=2.56 PS=2.56 NRD=0 NRS=0 m=1 $X=56345 $Y=5020 $D=27
M133 16 D VDD 880 pmos L=0.15 W=2 AD=0.57 AS=0.57 PD=2.57 PS=2.57 NRD=0 NRS=0 m=1 $X=58955 $Y=5020 $D=27
M134 VDD D 16 880 pmos L=0.15 W=2 AD=0.58 AS=0.58 PD=2.58 PS=2.58 NRD=0 NRS=0 m=1 $X=59395 $Y=5020 $D=27
M135 16 RN VDD 880 pmos L=0.15 W=2 AD=0.58 AS=0.58 PD=2.58 PS=2.58 NRD=0 NRS=0 m=1 $X=59835 $Y=5020 $D=27
M136 VDD RN 16 880 pmos L=0.15 W=2 AD=0.58 AS=0.58 PD=2.58 PS=2.58 NRD=0 NRS=0 m=1 $X=60275 $Y=5020 $D=27
M137 16 19 VDD 880 pmos L=0.15 W=2 AD=0.58 AS=0.58 PD=2.58 PS=2.58 NRD=0 NRS=0 m=1 $X=60715 $Y=5020 $D=27
M138 VDD 19 16 880 pmos L=0.15 W=2 AD=0.56 AS=0.56 PD=2.56 PS=2.56 NRD=0 NRS=0 m=1 $X=61155 $Y=5020 $D=27
M139 19 16 VDD 880 pmos L=0.15 W=2 AD=0.57 AS=0.57 PD=2.57 PS=2.57 NRD=0 NRS=0 m=1 $X=63765 $Y=5020 $D=27
M140 VDD 16 19 880 pmos L=0.15 W=2 AD=0.58 AS=0.58 PD=2.58 PS=2.58 NRD=0 NRS=0 m=1 $X=64205 $Y=5020 $D=27
M141 19 CLK VDD 880 pmos L=0.15 W=2 AD=0.58 AS=0.58 PD=2.58 PS=2.58 NRD=0 NRS=0 m=1 $X=64645 $Y=5020 $D=27
M142 VDD CLK 19 880 pmos L=0.15 W=2 AD=0.58 AS=0.58 PD=2.58 PS=2.58 NRD=0 NRS=0 m=1 $X=65085 $Y=5020 $D=27
M143 19 23 VDD 880 pmos L=0.15 W=2 AD=0.58 AS=0.58 PD=2.58 PS=2.58 NRD=0 NRS=0 m=1 $X=65525 $Y=5020 $D=27
M144 VDD 23 19 880 pmos L=0.15 W=2 AD=0.56 AS=0.56 PD=2.56 PS=2.56 NRD=0 NRS=0 m=1 $X=65965 $Y=5020 $D=27
M145 17 16 VDD 880 pmos L=0.15 W=2 AD=0.57 AS=0.57 PD=2.57 PS=2.57 NRD=0 NRS=0 m=1 $X=68575 $Y=5020 $D=27
M146 VDD 16 17 880 pmos L=0.15 W=2 AD=0.58 AS=0.58 PD=2.58 PS=2.58 NRD=0 NRS=0 m=1 $X=69015 $Y=5020 $D=27
M147 17 SN VDD 880 pmos L=0.15 W=2 AD=0.58 AS=0.58 PD=2.58 PS=2.58 NRD=0 NRS=0 m=1 $X=69455 $Y=5020 $D=27
M148 VDD SN 17 880 pmos L=0.15 W=2 AD=0.58 AS=0.58 PD=2.58 PS=2.58 NRD=0 NRS=0 m=1 $X=69895 $Y=5020 $D=27
M149 17 23 VDD 880 pmos L=0.15 W=2 AD=0.58 AS=0.58 PD=2.58 PS=2.58 NRD=0 NRS=0 m=1 $X=70335 $Y=5020 $D=27
M150 VDD 23 17 880 pmos L=0.15 W=2 AD=0.56 AS=0.56 PD=2.56 PS=2.56 NRD=0 NRS=0 m=1 $X=70775 $Y=5020 $D=27
M151 23 17 VDD 880 pmos L=0.15 W=2 AD=0.57 AS=0.57 PD=2.57 PS=2.57 NRD=0 NRS=0 m=1 $X=73385 $Y=5020 $D=27
M152 VDD 17 23 880 pmos L=0.15 W=2 AD=0.58 AS=0.58 PD=2.58 PS=2.58 NRD=0 NRS=0 m=1 $X=73825 $Y=5020 $D=27
M153 23 CLK VDD 880 pmos L=0.15 W=2 AD=0.58 AS=0.58 PD=2.58 PS=2.58 NRD=0 NRS=0 m=1 $X=74265 $Y=5020 $D=27
M154 VDD CLK 23 880 pmos L=0.15 W=2 AD=0.58 AS=0.58 PD=2.58 PS=2.58 NRD=0 NRS=0 m=1 $X=74705 $Y=5020 $D=27
M155 23 RN VDD 880 pmos L=0.15 W=2 AD=0.58 AS=0.58 PD=2.58 PS=2.58 NRD=0 NRS=0 m=1 $X=75145 $Y=5020 $D=27
M156 VDD RN 23 880 pmos L=0.15 W=2 AD=0.56 AS=0.56 PD=2.56 PS=2.56 NRD=0 NRS=0 m=1 $X=75585 $Y=5020 $D=27
M157 21 19 VDD 880 pmos L=0.15 W=2 AD=0.57 AS=0.57 PD=2.57 PS=2.57 NRD=0 NRS=0 m=1 $X=78195 $Y=5020 $D=27
M158 VDD 19 21 880 pmos L=0.15 W=2 AD=0.58 AS=0.58 PD=2.58 PS=2.58 NRD=0 NRS=0 m=1 $X=78635 $Y=5020 $D=27
M159 21 RN VDD 880 pmos L=0.15 W=2 AD=0.58 AS=0.58 PD=2.58 PS=2.58 NRD=0 NRS=0 m=1 $X=79075 $Y=5020 $D=27
M160 VDD RN 21 880 pmos L=0.15 W=2 AD=0.58 AS=0.58 PD=2.58 PS=2.58 NRD=0 NRS=0 m=1 $X=79515 $Y=5020 $D=27
M161 21 25 VDD 880 pmos L=0.15 W=2 AD=0.58 AS=0.58 PD=2.58 PS=2.58 NRD=0 NRS=0 m=1 $X=79955 $Y=5020 $D=27
M162 VDD 25 21 880 pmos L=0.15 W=2 AD=0.56 AS=0.56 PD=2.56 PS=2.56 NRD=0 NRS=0 m=1 $X=80395 $Y=5020 $D=27
M163 25 21 VDD 880 pmos L=0.15 W=2 AD=0.57 AS=0.57 PD=2.57 PS=2.57 NRD=0 NRS=0 m=1 $X=83005 $Y=5020 $D=27
M164 VDD 21 25 880 pmos L=0.15 W=2 AD=0.58 AS=0.58 PD=2.58 PS=2.58 NRD=0 NRS=0 m=1 $X=83445 $Y=5020 $D=27
M165 25 SN VDD 880 pmos L=0.15 W=2 AD=0.58 AS=0.58 PD=2.58 PS=2.58 NRD=0 NRS=0 m=1 $X=83885 $Y=5020 $D=27
M166 VDD SN 25 880 pmos L=0.15 W=2 AD=0.58 AS=0.58 PD=2.58 PS=2.58 NRD=0 NRS=0 m=1 $X=84325 $Y=5020 $D=27
M167 25 23 VDD 880 pmos L=0.15 W=2 AD=0.58 AS=0.58 PD=2.58 PS=2.58 NRD=0 NRS=0 m=1 $X=84765 $Y=5020 $D=27
M168 VDD 23 25 880 pmos L=0.15 W=2 AD=0.56 AS=0.56 PD=2.56 PS=2.56 NRD=0 NRS=0 m=1 $X=85205 $Y=5020 $D=27
M169 24 8 VDD 880 pmos L=0.15 W=2 AD=0.57 AS=0.57 PD=2.57 PS=2.57 NRD=0 NRS=0 m=1 $X=87515 $Y=5025 $D=27
M170 VDD 8 24 880 pmos L=0.15 W=2 AD=0.58 AS=0.58 PD=2.58 PS=2.58 NRD=0 NRS=0 m=1 $X=87955 $Y=5025 $D=27
M171 24 14 VDD 880 pmos L=0.15 W=2 AD=0.58 AS=0.58 PD=2.58 PS=2.58 NRD=0 NRS=0 m=1 $X=88395 $Y=5025 $D=27
M172 VDD 14 24 880 pmos L=0.15 W=2 AD=0.56 AS=0.56 PD=2.56 PS=2.56 NRD=0 NRS=0 m=1 $X=88835 $Y=5025 $D=27
M173 26 8 24 880 pmos L=0.15 W=2 AD=0.56 AS=0.56 PD=2.56 PS=2.56 NRD=0 NRS=0 m=1 $X=90835 $Y=5025 $D=27
M174 24 8 26 880 pmos L=0.15 W=2 AD=0.58 AS=0.58 PD=2.58 PS=2.58 NRD=0 NRS=0 m=1 $X=91275 $Y=5025 $D=27
M175 26 25 24 880 pmos L=0.15 W=2 AD=0.58 AS=0.58 PD=2.58 PS=2.58 NRD=0 NRS=0 m=1 $X=91715 $Y=5025 $D=27
M176 24 25 26 880 pmos L=0.15 W=2 AD=0.57 AS=0.57 PD=2.57 PS=2.57 NRD=0 NRS=0 m=1 $X=92155 $Y=5025 $D=27
M177 27 25 26 880 pmos L=0.15 W=2 AD=0.57 AS=0.57 PD=2.57 PS=2.57 NRD=0 NRS=0 m=1 $X=94175 $Y=5025 $D=27
M178 26 25 27 880 pmos L=0.15 W=2 AD=0.58 AS=0.58 PD=2.58 PS=2.58 NRD=0 NRS=0 m=1 $X=94615 $Y=5025 $D=27
M179 27 14 26 880 pmos L=0.15 W=2 AD=0.58 AS=0.58 PD=2.58 PS=2.58 NRD=0 NRS=0 m=1 $X=95055 $Y=5025 $D=27
M180 26 14 27 880 pmos L=0.15 W=2 AD=0.56 AS=0.56 PD=2.56 PS=2.56 NRD=0 NRS=0 m=1 $X=95495 $Y=5025 $D=27
M181 Q 27 VDD 880 pmos L=0.15 W=2 AD=0.57 AS=0.57 PD=2.57 PS=2.57 NRD=0 NRS=0 m=1 $X=97390 $Y=5020 $D=27
M182 VDD 27 Q 880 pmos L=0.15 W=2 AD=0.56 AS=0.56 PD=2.56 PS=2.56 NRD=0 NRS=0 m=1 $X=97830 $Y=5020 $D=27
.ENDS
***************************************
