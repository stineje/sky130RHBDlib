* SPICE NETLIST
***************************************

.SUBCKT pad_bond pin0
.ENDS
***************************************
.SUBCKT pad_microprobe pin0
.ENDS
***************************************
.SUBCKT pad_probe pin0
.ENDS
***************************************
.SUBCKT nmos_de_iso_v20 src gate drn b sub
.ENDS
***************************************
.SUBCKT TMRDFFSNQNX1 GND VDD D CLK SN QN
** N=775 EP=6 IP=0 FDC=153
M0 GND D 27 775 nmos L=0.163119 W=2.35104 $X=840 $Y=785 $D=3
M1 3 5 27 775 nmos L=0.163346 W=2.31104 $X=1810 $Y=825 $D=3
M2 GND 3 28 775 nmos L=0.163119 W=2.35104 $X=4065 $Y=795 $D=3
M3 29 CLK 28 775 nmos L=0.160516 W=2.29447 $X=5040 $Y=830 $D=3
M4 5 6 29 775 nmos L=0.163346 W=2.31104 $X=6575 $Y=835 $D=3
M5 GND 3 30 775 nmos L=0.163119 W=2.35104 $X=8875 $Y=795 $D=3
M6 31 SN 30 775 nmos L=0.160516 W=2.29447 $X=9850 $Y=830 $D=3
M7 4 6 31 775 nmos L=0.163346 W=2.31104 $X=11385 $Y=835 $D=3
M8 GND 4 32 775 nmos L=0.163119 W=2.35104 $X=13790 $Y=785 $D=3
M9 6 CLK 32 775 nmos L=0.163346 W=2.31104 $X=14760 $Y=825 $D=3
M10 GND 5 33 775 nmos L=0.163119 W=2.35104 $X=17120 $Y=785 $D=3
M11 24 7 33 775 nmos L=0.163346 W=2.31104 $X=18090 $Y=825 $D=3
M12 GND 24 34 775 nmos L=0.163119 W=2.35104 $X=20345 $Y=795 $D=3
M13 35 SN 34 775 nmos L=0.160516 W=2.29447 $X=21320 $Y=830 $D=3
M14 7 6 35 775 nmos L=0.163346 W=2.31104 $X=22855 $Y=835 $D=3
M15 GND D 36 775 nmos L=0.163119 W=2.35104 $X=25260 $Y=785 $D=3
M16 8 10 36 775 nmos L=0.163346 W=2.31104 $X=26230 $Y=825 $D=3
M17 GND 8 37 775 nmos L=0.163119 W=2.35104 $X=28485 $Y=795 $D=3
M18 38 CLK 37 775 nmos L=0.160516 W=2.29447 $X=29460 $Y=830 $D=3
M19 10 11 38 775 nmos L=0.163346 W=2.31104 $X=30995 $Y=835 $D=3
M20 GND 8 39 775 nmos L=0.163119 W=2.35104 $X=33295 $Y=795 $D=3
M21 40 SN 39 775 nmos L=0.160516 W=2.29447 $X=34270 $Y=830 $D=3
M22 9 11 40 775 nmos L=0.163346 W=2.31104 $X=35805 $Y=835 $D=3
M23 GND 9 41 775 nmos L=0.163119 W=2.35104 $X=38210 $Y=785 $D=3
M24 11 CLK 41 775 nmos L=0.163346 W=2.31104 $X=39180 $Y=825 $D=3
M25 GND 10 42 775 nmos L=0.163119 W=2.35104 $X=41540 $Y=785 $D=3
M26 21 12 42 775 nmos L=0.163346 W=2.31104 $X=42510 $Y=825 $D=3
M27 GND 21 43 775 nmos L=0.163119 W=2.35104 $X=44765 $Y=795 $D=3
M28 44 SN 43 775 nmos L=0.160516 W=2.29447 $X=45740 $Y=830 $D=3
M29 12 11 44 775 nmos L=0.163346 W=2.31104 $X=47275 $Y=835 $D=3
M30 GND D 45 775 nmos L=0.163119 W=2.35104 $X=49680 $Y=785 $D=3
M31 14 17 45 775 nmos L=0.163346 W=2.31104 $X=50650 $Y=825 $D=3
M32 GND 14 46 775 nmos L=0.163119 W=2.35104 $X=52905 $Y=795 $D=3
M33 47 CLK 46 775 nmos L=0.160516 W=2.29447 $X=53880 $Y=830 $D=3
M34 17 19 47 775 nmos L=0.163346 W=2.31104 $X=55415 $Y=835 $D=3
M35 GND 14 48 775 nmos L=0.163119 W=2.35104 $X=57715 $Y=795 $D=3
M36 49 SN 48 775 nmos L=0.160516 W=2.29447 $X=58690 $Y=830 $D=3
M37 15 19 49 775 nmos L=0.163346 W=2.31104 $X=60225 $Y=835 $D=3
M38 GND 15 50 775 nmos L=0.163119 W=2.35104 $X=62630 $Y=785 $D=3
M39 19 CLK 50 775 nmos L=0.163346 W=2.31104 $X=63600 $Y=825 $D=3
M40 GND 17 51 775 nmos L=0.163119 W=2.35104 $X=65960 $Y=785 $D=3
M41 23 20 51 775 nmos L=0.163346 W=2.31104 $X=66930 $Y=825 $D=3
M42 GND 23 52 775 nmos L=0.163119 W=2.35104 $X=69185 $Y=795 $D=3
M43 53 SN 52 775 nmos L=0.160516 W=2.29447 $X=70160 $Y=830 $D=3
M44 20 19 53 775 nmos L=0.163346 W=2.31104 $X=71695 $Y=835 $D=3
M45 GND 23 54 775 nmos L=0.163119 W=2.35104 $X=74100 $Y=785 $D=3
M46 QN 21 54 775 nmos L=0.163346 W=2.31104 $X=75070 $Y=825 $D=3
M47 GND 23 55 775 nmos L=0.163119 W=2.35104 $X=77430 $Y=785 $D=3
M48 QN 24 55 775 nmos L=0.163346 W=2.31104 $X=78400 $Y=825 $D=3
M49 GND 24 56 775 nmos L=0.163119 W=2.35104 $X=80760 $Y=785 $D=3
M50 QN 21 56 775 nmos L=0.163129 W=2.31397 $X=81730 $Y=825 $D=3
M51 3 D VDD 773 pmos L=0.15 W=2 AD=0.57 AS=0.57 PD=2.57 PS=2.57 NRD=0 NRS=0 m=1 $X=935 $Y=5020 $D=27
M52 VDD D 3 773 pmos L=0.15 W=2 AD=0.58 AS=0.58 PD=2.58 PS=2.58 NRD=0 NRS=0 m=1 $X=1375 $Y=5020 $D=27
M53 3 5 VDD 773 pmos L=0.15 W=2 AD=0.58 AS=0.58 PD=2.58 PS=2.58 NRD=0 NRS=0 m=1 $X=1815 $Y=5020 $D=27
M54 VDD 5 3 773 pmos L=0.15 W=2 AD=0.56 AS=0.56 PD=2.56 PS=2.56 NRD=0 NRS=0 m=1 $X=2255 $Y=5020 $D=27
M55 5 3 VDD 773 pmos L=0.15 W=2 AD=0.57 AS=0.57 PD=2.57 PS=2.57 NRD=0 NRS=0 m=1 $X=4565 $Y=5020 $D=27
M56 VDD 3 5 773 pmos L=0.15 W=2 AD=0.58 AS=0.58 PD=2.58 PS=2.58 NRD=0 NRS=0 m=1 $X=5005 $Y=5020 $D=27
M57 5 CLK VDD 773 pmos L=0.15 W=2 AD=0.58 AS=0.58 PD=2.58 PS=2.58 NRD=0 NRS=0 m=1 $X=5445 $Y=5020 $D=27
M58 VDD CLK 5 773 pmos L=0.15 W=2 AD=0.58 AS=0.58 PD=2.58 PS=2.58 NRD=0 NRS=0 m=1 $X=5885 $Y=5020 $D=27
M59 5 6 VDD 773 pmos L=0.15 W=2 AD=0.58 AS=0.58 PD=2.58 PS=2.58 NRD=0 NRS=0 m=1 $X=6325 $Y=5020 $D=27
M60 VDD 6 5 773 pmos L=0.15 W=2 AD=0.56 AS=0.56 PD=2.56 PS=2.56 NRD=0 NRS=0 m=1 $X=6765 $Y=5020 $D=27
M61 4 3 VDD 773 pmos L=0.15 W=2 AD=0.57 AS=0.57 PD=2.57 PS=2.57 NRD=0 NRS=0 m=1 $X=9375 $Y=5020 $D=27
M62 VDD 3 4 773 pmos L=0.15 W=2 AD=0.58 AS=0.58 PD=2.58 PS=2.58 NRD=0 NRS=0 m=1 $X=9815 $Y=5020 $D=27
M63 4 SN VDD 773 pmos L=0.15 W=2 AD=0.58 AS=0.58 PD=2.58 PS=2.58 NRD=0 NRS=0 m=1 $X=10255 $Y=5020 $D=27
M64 VDD SN 4 773 pmos L=0.15 W=2 AD=0.58 AS=0.58 PD=2.58 PS=2.58 NRD=0 NRS=0 m=1 $X=10695 $Y=5020 $D=27
M65 4 6 VDD 773 pmos L=0.15 W=2 AD=0.58 AS=0.58 PD=2.58 PS=2.58 NRD=0 NRS=0 m=1 $X=11135 $Y=5020 $D=27
M66 VDD 6 4 773 pmos L=0.15 W=2 AD=0.56 AS=0.56 PD=2.56 PS=2.56 NRD=0 NRS=0 m=1 $X=11575 $Y=5020 $D=27
M67 6 4 VDD 773 pmos L=0.15 W=2 AD=0.57 AS=0.57 PD=2.57 PS=2.57 NRD=0 NRS=0 m=1 $X=13885 $Y=5020 $D=27
M68 VDD 4 6 773 pmos L=0.15 W=2 AD=0.58 AS=0.58 PD=2.58 PS=2.58 NRD=0 NRS=0 m=1 $X=14325 $Y=5020 $D=27
M69 6 CLK VDD 773 pmos L=0.15 W=2 AD=0.58 AS=0.58 PD=2.58 PS=2.58 NRD=0 NRS=0 m=1 $X=14765 $Y=5020 $D=27
M70 VDD CLK 6 773 pmos L=0.15 W=2 AD=0.56 AS=0.56 PD=2.56 PS=2.56 NRD=0 NRS=0 m=1 $X=15205 $Y=5020 $D=27
M71 24 5 VDD 773 pmos L=0.15 W=2 AD=0.57 AS=0.57 PD=2.57 PS=2.57 NRD=0 NRS=0 m=1 $X=17215 $Y=5020 $D=27
M72 VDD 5 24 773 pmos L=0.15 W=2 AD=0.58 AS=0.58 PD=2.58 PS=2.58 NRD=0 NRS=0 m=1 $X=17655 $Y=5020 $D=27
M73 24 7 VDD 773 pmos L=0.15 W=2 AD=0.58 AS=0.58 PD=2.58 PS=2.58 NRD=0 NRS=0 m=1 $X=18095 $Y=5020 $D=27
M74 VDD 7 24 773 pmos L=0.15 W=2 AD=0.56 AS=0.56 PD=2.56 PS=2.56 NRD=0 NRS=0 m=1 $X=18535 $Y=5020 $D=27
M75 7 24 VDD 773 pmos L=0.15 W=2 AD=0.57 AS=0.57 PD=2.57 PS=2.57 NRD=0 NRS=0 m=1 $X=20845 $Y=5020 $D=27
M76 VDD 24 7 773 pmos L=0.15 W=2 AD=0.58 AS=0.58 PD=2.58 PS=2.58 NRD=0 NRS=0 m=1 $X=21285 $Y=5020 $D=27
M77 7 SN VDD 773 pmos L=0.15 W=2 AD=0.58 AS=0.58 PD=2.58 PS=2.58 NRD=0 NRS=0 m=1 $X=21725 $Y=5020 $D=27
M78 VDD SN 7 773 pmos L=0.15 W=2 AD=0.58 AS=0.58 PD=2.58 PS=2.58 NRD=0 NRS=0 m=1 $X=22165 $Y=5020 $D=27
M79 7 6 VDD 773 pmos L=0.15 W=2 AD=0.58 AS=0.58 PD=2.58 PS=2.58 NRD=0 NRS=0 m=1 $X=22605 $Y=5020 $D=27
M80 VDD 6 7 773 pmos L=0.15 W=2 AD=0.56 AS=0.56 PD=2.56 PS=2.56 NRD=0 NRS=0 m=1 $X=23045 $Y=5020 $D=27
M81 8 D VDD 773 pmos L=0.15 W=2 AD=0.57 AS=0.57 PD=2.57 PS=2.57 NRD=0 NRS=0 m=1 $X=25355 $Y=5020 $D=27
M82 VDD D 8 773 pmos L=0.15 W=2 AD=0.58 AS=0.58 PD=2.58 PS=2.58 NRD=0 NRS=0 m=1 $X=25795 $Y=5020 $D=27
M83 8 10 VDD 773 pmos L=0.15 W=2 AD=0.58 AS=0.58 PD=2.58 PS=2.58 NRD=0 NRS=0 m=1 $X=26235 $Y=5020 $D=27
M84 VDD 10 8 773 pmos L=0.15 W=2 AD=0.56 AS=0.56 PD=2.56 PS=2.56 NRD=0 NRS=0 m=1 $X=26675 $Y=5020 $D=27
M85 10 8 VDD 773 pmos L=0.15 W=2 AD=0.57 AS=0.57 PD=2.57 PS=2.57 NRD=0 NRS=0 m=1 $X=28985 $Y=5020 $D=27
M86 VDD 8 10 773 pmos L=0.15 W=2 AD=0.58 AS=0.58 PD=2.58 PS=2.58 NRD=0 NRS=0 m=1 $X=29425 $Y=5020 $D=27
M87 10 CLK VDD 773 pmos L=0.15 W=2 AD=0.58 AS=0.58 PD=2.58 PS=2.58 NRD=0 NRS=0 m=1 $X=29865 $Y=5020 $D=27
M88 VDD CLK 10 773 pmos L=0.15 W=2 AD=0.58 AS=0.58 PD=2.58 PS=2.58 NRD=0 NRS=0 m=1 $X=30305 $Y=5020 $D=27
M89 10 11 VDD 773 pmos L=0.15 W=2 AD=0.58 AS=0.58 PD=2.58 PS=2.58 NRD=0 NRS=0 m=1 $X=30745 $Y=5020 $D=27
M90 VDD 11 10 773 pmos L=0.15 W=2 AD=0.56 AS=0.56 PD=2.56 PS=2.56 NRD=0 NRS=0 m=1 $X=31185 $Y=5020 $D=27
M91 9 8 VDD 773 pmos L=0.15 W=2 AD=0.57 AS=0.57 PD=2.57 PS=2.57 NRD=0 NRS=0 m=1 $X=33795 $Y=5020 $D=27
M92 VDD 8 9 773 pmos L=0.15 W=2 AD=0.58 AS=0.58 PD=2.58 PS=2.58 NRD=0 NRS=0 m=1 $X=34235 $Y=5020 $D=27
M93 9 SN VDD 773 pmos L=0.15 W=2 AD=0.58 AS=0.58 PD=2.58 PS=2.58 NRD=0 NRS=0 m=1 $X=34675 $Y=5020 $D=27
M94 VDD SN 9 773 pmos L=0.15 W=2 AD=0.58 AS=0.58 PD=2.58 PS=2.58 NRD=0 NRS=0 m=1 $X=35115 $Y=5020 $D=27
M95 9 11 VDD 773 pmos L=0.15 W=2 AD=0.58 AS=0.58 PD=2.58 PS=2.58 NRD=0 NRS=0 m=1 $X=35555 $Y=5020 $D=27
M96 VDD 11 9 773 pmos L=0.15 W=2 AD=0.56 AS=0.56 PD=2.56 PS=2.56 NRD=0 NRS=0 m=1 $X=35995 $Y=5020 $D=27
M97 11 9 VDD 773 pmos L=0.15 W=2 AD=0.57 AS=0.57 PD=2.57 PS=2.57 NRD=0 NRS=0 m=1 $X=38305 $Y=5020 $D=27
M98 VDD 9 11 773 pmos L=0.15 W=2 AD=0.58 AS=0.58 PD=2.58 PS=2.58 NRD=0 NRS=0 m=1 $X=38745 $Y=5020 $D=27
M99 11 CLK VDD 773 pmos L=0.15 W=2 AD=0.58 AS=0.58 PD=2.58 PS=2.58 NRD=0 NRS=0 m=1 $X=39185 $Y=5020 $D=27
M100 VDD CLK 11 773 pmos L=0.15 W=2 AD=0.56 AS=0.56 PD=2.56 PS=2.56 NRD=0 NRS=0 m=1 $X=39625 $Y=5020 $D=27
M101 21 10 VDD 773 pmos L=0.15 W=2 AD=0.57 AS=0.57 PD=2.57 PS=2.57 NRD=0 NRS=0 m=1 $X=41635 $Y=5020 $D=27
M102 VDD 10 21 773 pmos L=0.15 W=2 AD=0.58 AS=0.58 PD=2.58 PS=2.58 NRD=0 NRS=0 m=1 $X=42075 $Y=5020 $D=27
M103 21 12 VDD 773 pmos L=0.15 W=2 AD=0.58 AS=0.58 PD=2.58 PS=2.58 NRD=0 NRS=0 m=1 $X=42515 $Y=5020 $D=27
M104 VDD 12 21 773 pmos L=0.15 W=2 AD=0.56 AS=0.56 PD=2.56 PS=2.56 NRD=0 NRS=0 m=1 $X=42955 $Y=5020 $D=27
M105 12 21 VDD 773 pmos L=0.15 W=2 AD=0.57 AS=0.57 PD=2.57 PS=2.57 NRD=0 NRS=0 m=1 $X=45265 $Y=5020 $D=27
M106 VDD 21 12 773 pmos L=0.15 W=2 AD=0.58 AS=0.58 PD=2.58 PS=2.58 NRD=0 NRS=0 m=1 $X=45705 $Y=5020 $D=27
M107 12 SN VDD 773 pmos L=0.15 W=2 AD=0.58 AS=0.58 PD=2.58 PS=2.58 NRD=0 NRS=0 m=1 $X=46145 $Y=5020 $D=27
M108 VDD SN 12 773 pmos L=0.15 W=2 AD=0.58 AS=0.58 PD=2.58 PS=2.58 NRD=0 NRS=0 m=1 $X=46585 $Y=5020 $D=27
M109 12 11 VDD 773 pmos L=0.15 W=2 AD=0.58 AS=0.58 PD=2.58 PS=2.58 NRD=0 NRS=0 m=1 $X=47025 $Y=5020 $D=27
M110 VDD 11 12 773 pmos L=0.15 W=2 AD=0.56 AS=0.56 PD=2.56 PS=2.56 NRD=0 NRS=0 m=1 $X=47465 $Y=5020 $D=27
M111 14 D VDD 773 pmos L=0.15 W=2 AD=0.57 AS=0.57 PD=2.57 PS=2.57 NRD=0 NRS=0 m=1 $X=49775 $Y=5020 $D=27
M112 VDD D 14 773 pmos L=0.15 W=2 AD=0.58 AS=0.58 PD=2.58 PS=2.58 NRD=0 NRS=0 m=1 $X=50215 $Y=5020 $D=27
M113 14 17 VDD 773 pmos L=0.15 W=2 AD=0.58 AS=0.58 PD=2.58 PS=2.58 NRD=0 NRS=0 m=1 $X=50655 $Y=5020 $D=27
M114 VDD 17 14 773 pmos L=0.15 W=2 AD=0.56 AS=0.56 PD=2.56 PS=2.56 NRD=0 NRS=0 m=1 $X=51095 $Y=5020 $D=27
M115 17 14 VDD 773 pmos L=0.15 W=2 AD=0.57 AS=0.57 PD=2.57 PS=2.57 NRD=0 NRS=0 m=1 $X=53405 $Y=5020 $D=27
M116 VDD 14 17 773 pmos L=0.15 W=2 AD=0.58 AS=0.58 PD=2.58 PS=2.58 NRD=0 NRS=0 m=1 $X=53845 $Y=5020 $D=27
M117 17 CLK VDD 773 pmos L=0.15 W=2 AD=0.58 AS=0.58 PD=2.58 PS=2.58 NRD=0 NRS=0 m=1 $X=54285 $Y=5020 $D=27
M118 VDD CLK 17 773 pmos L=0.15 W=2 AD=0.58 AS=0.58 PD=2.58 PS=2.58 NRD=0 NRS=0 m=1 $X=54725 $Y=5020 $D=27
M119 17 19 VDD 773 pmos L=0.15 W=2 AD=0.58 AS=0.58 PD=2.58 PS=2.58 NRD=0 NRS=0 m=1 $X=55165 $Y=5020 $D=27
M120 VDD 19 17 773 pmos L=0.15 W=2 AD=0.56 AS=0.56 PD=2.56 PS=2.56 NRD=0 NRS=0 m=1 $X=55605 $Y=5020 $D=27
M121 15 14 VDD 773 pmos L=0.15 W=2 AD=0.57 AS=0.57 PD=2.57 PS=2.57 NRD=0 NRS=0 m=1 $X=58215 $Y=5020 $D=27
M122 VDD 14 15 773 pmos L=0.15 W=2 AD=0.58 AS=0.58 PD=2.58 PS=2.58 NRD=0 NRS=0 m=1 $X=58655 $Y=5020 $D=27
M123 15 SN VDD 773 pmos L=0.15 W=2 AD=0.58 AS=0.58 PD=2.58 PS=2.58 NRD=0 NRS=0 m=1 $X=59095 $Y=5020 $D=27
M124 VDD SN 15 773 pmos L=0.15 W=2 AD=0.58 AS=0.58 PD=2.58 PS=2.58 NRD=0 NRS=0 m=1 $X=59535 $Y=5020 $D=27
M125 15 19 VDD 773 pmos L=0.15 W=2 AD=0.58 AS=0.58 PD=2.58 PS=2.58 NRD=0 NRS=0 m=1 $X=59975 $Y=5020 $D=27
M126 VDD 19 15 773 pmos L=0.15 W=2 AD=0.56 AS=0.56 PD=2.56 PS=2.56 NRD=0 NRS=0 m=1 $X=60415 $Y=5020 $D=27
M127 19 15 VDD 773 pmos L=0.15 W=2 AD=0.57 AS=0.57 PD=2.57 PS=2.57 NRD=0 NRS=0 m=1 $X=62725 $Y=5020 $D=27
M128 VDD 15 19 773 pmos L=0.15 W=2 AD=0.58 AS=0.58 PD=2.58 PS=2.58 NRD=0 NRS=0 m=1 $X=63165 $Y=5020 $D=27
M129 19 CLK VDD 773 pmos L=0.15 W=2 AD=0.58 AS=0.58 PD=2.58 PS=2.58 NRD=0 NRS=0 m=1 $X=63605 $Y=5020 $D=27
M130 VDD CLK 19 773 pmos L=0.15 W=2 AD=0.56 AS=0.56 PD=2.56 PS=2.56 NRD=0 NRS=0 m=1 $X=64045 $Y=5020 $D=27
M131 23 17 VDD 773 pmos L=0.15 W=2 AD=0.57 AS=0.57 PD=2.57 PS=2.57 NRD=0 NRS=0 m=1 $X=66055 $Y=5020 $D=27
M132 VDD 17 23 773 pmos L=0.15 W=2 AD=0.58 AS=0.58 PD=2.58 PS=2.58 NRD=0 NRS=0 m=1 $X=66495 $Y=5020 $D=27
M133 23 20 VDD 773 pmos L=0.15 W=2 AD=0.58 AS=0.58 PD=2.58 PS=2.58 NRD=0 NRS=0 m=1 $X=66935 $Y=5020 $D=27
M134 VDD 20 23 773 pmos L=0.15 W=2 AD=0.56 AS=0.56 PD=2.56 PS=2.56 NRD=0 NRS=0 m=1 $X=67375 $Y=5020 $D=27
M135 20 23 VDD 773 pmos L=0.15 W=2 AD=0.57 AS=0.57 PD=2.57 PS=2.57 NRD=0 NRS=0 m=1 $X=69685 $Y=5020 $D=27
M136 VDD 23 20 773 pmos L=0.15 W=2 AD=0.58 AS=0.58 PD=2.58 PS=2.58 NRD=0 NRS=0 m=1 $X=70125 $Y=5020 $D=27
M137 20 SN VDD 773 pmos L=0.15 W=2 AD=0.58 AS=0.58 PD=2.58 PS=2.58 NRD=0 NRS=0 m=1 $X=70565 $Y=5020 $D=27
M138 VDD SN 20 773 pmos L=0.15 W=2 AD=0.58 AS=0.58 PD=2.58 PS=2.58 NRD=0 NRS=0 m=1 $X=71005 $Y=5020 $D=27
M139 20 19 VDD 773 pmos L=0.15 W=2 AD=0.58 AS=0.58 PD=2.58 PS=2.58 NRD=0 NRS=0 m=1 $X=71445 $Y=5020 $D=27
M140 VDD 19 20 773 pmos L=0.15 W=2 AD=0.56 AS=0.56 PD=2.56 PS=2.56 NRD=0 NRS=0 m=1 $X=71885 $Y=5020 $D=27
M141 22 23 VDD 773 pmos L=0.15 W=2 AD=0.57 AS=0.57 PD=2.57 PS=2.57 NRD=0 NRS=0 m=1 $X=74195 $Y=5025 $D=27
M142 VDD 23 22 773 pmos L=0.15 W=2 AD=0.58 AS=0.58 PD=2.58 PS=2.58 NRD=0 NRS=0 m=1 $X=74635 $Y=5025 $D=27
M143 22 21 VDD 773 pmos L=0.15 W=2 AD=0.58 AS=0.58 PD=2.58 PS=2.58 NRD=0 NRS=0 m=1 $X=75075 $Y=5025 $D=27
M144 VDD 21 22 773 pmos L=0.15 W=2 AD=0.56 AS=0.56 PD=2.56 PS=2.56 NRD=0 NRS=0 m=1 $X=75515 $Y=5025 $D=27
M145 25 23 22 773 pmos L=0.15 W=2 AD=0.56 AS=0.56 PD=2.56 PS=2.56 NRD=0 NRS=0 m=1 $X=77515 $Y=5025 $D=27
M146 22 23 25 773 pmos L=0.15 W=2 AD=0.58 AS=0.58 PD=2.58 PS=2.58 NRD=0 NRS=0 m=1 $X=77955 $Y=5025 $D=27
M147 25 24 22 773 pmos L=0.15 W=2 AD=0.58 AS=0.58 PD=2.58 PS=2.58 NRD=0 NRS=0 m=1 $X=78395 $Y=5025 $D=27
M148 22 24 25 773 pmos L=0.15 W=2 AD=0.57 AS=0.57 PD=2.57 PS=2.57 NRD=0 NRS=0 m=1 $X=78835 $Y=5025 $D=27
M149 QN 24 25 773 pmos L=0.15 W=2 AD=0.57 AS=0.57 PD=2.57 PS=2.57 NRD=0 NRS=0 m=1 $X=80855 $Y=5025 $D=27
M150 25 24 QN 773 pmos L=0.15 W=2 AD=0.58 AS=0.58 PD=2.58 PS=2.58 NRD=0 NRS=0 m=1 $X=81295 $Y=5025 $D=27
M151 QN 21 25 773 pmos L=0.15 W=2 AD=0.58 AS=0.58 PD=2.58 PS=2.58 NRD=0 NRS=0 m=1 $X=81735 $Y=5025 $D=27
M152 25 21 QN 773 pmos L=0.15 W=2 AD=0.56 AS=0.56 PD=2.56 PS=2.56 NRD=0 NRS=0 m=1 $X=82175 $Y=5025 $D=27
.ENDS
***************************************
