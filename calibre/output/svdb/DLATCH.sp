* SPICE NETLIST
***************************************

.SUBCKT pad_bond pin0
.ENDS
***************************************
.SUBCKT pad_microprobe pin0
.ENDS
***************************************
.SUBCKT pad_probe pin0
.ENDS
***************************************
.SUBCKT nmos_de_iso_v20 src gate drn b sub
.ENDS
***************************************
.SUBCKT DLATCH GND VDD GATE D Q
** N=224 EP=5 IP=0 FDC=33
M0 3 D GND 224 nmos L=0.163346 W=2.31104 $X=775 $Y=830 $D=3
M1 GND 3 12 224 nmos L=0.163119 W=2.35104 $X=3060 $Y=785 $D=3
M2 4 GATE 12 224 nmos L=0.163346 W=2.31104 $X=4030 $Y=825 $D=3
M3 8 4 GND 224 nmos L=0.163346 W=2.31104 $X=6325 $Y=830 $D=3
M4 GND GATE 13 224 nmos L=0.163119 W=2.35104 $X=8610 $Y=785 $D=3
M5 7 D 13 224 nmos L=0.163346 W=2.31104 $X=9580 $Y=825 $D=3
M6 10 7 GND 224 nmos L=0.163346 W=2.31104 $X=11875 $Y=830 $D=3
M7 Q 8 GND 224 nmos L=0.163346 W=2.31104 $X=14160 $Y=825 $D=3
M8 Q 11 GND 224 nmos L=0.163129 W=2.31397 $X=15130 $Y=825 $D=3
M9 11 Q GND 224 nmos L=0.163346 W=2.31104 $X=17490 $Y=825 $D=3
M10 11 10 GND 224 nmos L=0.163129 W=2.31397 $X=18460 $Y=825 $D=3
M11 3 D VDD 222 pmos L=0.15 W=2 AD=0.57 AS=0.57 PD=2.57 PS=2.57 NRD=0 NRS=0 m=1 $X=820 $Y=5020 $D=27
M12 VDD D 3 222 pmos L=0.15 W=2 AD=0.56 AS=0.56 PD=2.56 PS=2.56 NRD=0 NRS=0 m=1 $X=1260 $Y=5020 $D=27
M13 4 3 VDD 222 pmos L=0.15 W=2 AD=0.57 AS=0.57 PD=2.57 PS=2.57 NRD=0 NRS=0 m=1 $X=3155 $Y=5020 $D=27
M14 VDD 3 4 222 pmos L=0.15 W=2 AD=0.58 AS=0.58 PD=2.58 PS=2.58 NRD=0 NRS=0 m=1 $X=3595 $Y=5020 $D=27
M15 4 GATE VDD 222 pmos L=0.15 W=2 AD=0.58 AS=0.58 PD=2.58 PS=2.58 NRD=0 NRS=0 m=1 $X=4035 $Y=5020 $D=27
M16 VDD GATE 4 222 pmos L=0.15 W=2 AD=0.56 AS=0.56 PD=2.56 PS=2.56 NRD=0 NRS=0 m=1 $X=4475 $Y=5020 $D=27
M17 8 4 VDD 222 pmos L=0.15 W=2 AD=0.57 AS=0.57 PD=2.57 PS=2.57 NRD=0 NRS=0 m=1 $X=6370 $Y=5020 $D=27
M18 VDD 4 8 222 pmos L=0.15 W=2 AD=0.56 AS=0.56 PD=2.56 PS=2.56 NRD=0 NRS=0 m=1 $X=6810 $Y=5020 $D=27
M19 7 GATE VDD 222 pmos L=0.15 W=2 AD=0.57 AS=0.57 PD=2.57 PS=2.57 NRD=0 NRS=0 m=1 $X=8705 $Y=5020 $D=27
M20 VDD GATE 7 222 pmos L=0.15 W=2 AD=0.58 AS=0.58 PD=2.58 PS=2.58 NRD=0 NRS=0 m=1 $X=9145 $Y=5020 $D=27
M21 7 D VDD 222 pmos L=0.15 W=2 AD=0.58 AS=0.58 PD=2.58 PS=2.58 NRD=0 NRS=0 m=1 $X=9585 $Y=5020 $D=27
M22 VDD D 7 222 pmos L=0.15 W=2 AD=0.56 AS=0.56 PD=2.56 PS=2.56 NRD=0 NRS=0 m=1 $X=10025 $Y=5020 $D=27
M23 10 7 VDD 222 pmos L=0.15 W=2 AD=0.57 AS=0.57 PD=2.57 PS=2.57 NRD=0 NRS=0 m=1 $X=11920 $Y=5020 $D=27
M24 VDD 7 10 222 pmos L=0.15 W=2 AD=0.56 AS=0.56 PD=2.56 PS=2.56 NRD=0 NRS=0 m=1 $X=12360 $Y=5020 $D=27
M25 VDD 8 14 222 pmos L=0.15 W=2 AD=0.57 AS=0.57 PD=2.57 PS=2.57 NRD=0 NRS=0 m=1 $X=14255 $Y=5025 $D=27
M26 14 8 VDD 222 pmos L=0.15 W=2 AD=0.58 AS=0.58 PD=2.58 PS=2.58 NRD=0 NRS=0 m=1 $X=14695 $Y=5025 $D=27
M27 Q 11 14 222 pmos L=0.15 W=2 AD=0.58 AS=0.58 PD=2.58 PS=2.58 NRD=0 NRS=0 m=1 $X=15135 $Y=5025 $D=27
M28 14 11 Q 222 pmos L=0.15 W=2 AD=0.56 AS=0.56 PD=2.56 PS=2.56 NRD=0 NRS=0 m=1 $X=15575 $Y=5025 $D=27
M29 VDD Q 15 222 pmos L=0.15 W=2 AD=0.57 AS=0.57 PD=2.57 PS=2.57 NRD=0 NRS=0 m=1 $X=17585 $Y=5025 $D=27
M30 15 Q VDD 222 pmos L=0.15 W=2 AD=0.58 AS=0.58 PD=2.58 PS=2.58 NRD=0 NRS=0 m=1 $X=18025 $Y=5025 $D=27
M31 11 10 15 222 pmos L=0.15 W=2 AD=0.58 AS=0.58 PD=2.58 PS=2.58 NRD=0 NRS=0 m=1 $X=18465 $Y=5025 $D=27
M32 15 10 11 222 pmos L=0.15 W=2 AD=0.56 AS=0.56 PD=2.56 PS=2.56 NRD=0 NRS=0 m=1 $X=18905 $Y=5025 $D=27
.ENDS
***************************************
