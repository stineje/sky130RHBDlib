* SPICE NETLIST
***************************************

.SUBCKT pad_bond pin0
.ENDS
***************************************
.SUBCKT pad_microprobe pin0
.ENDS
***************************************
.SUBCKT pad_probe pin0
.ENDS
***************************************
.SUBCKT nmos_de_iso_v20 src gate drn b sub
.ENDS
***************************************
.SUBCKT DFFRNQX1 GND VDD CLK RN Q D
** N=250 EP=6 IP=0 FDC=48
M0 GND 9 11 250 nmos L=0.163119 W=2.35104 $X=735 $Y=795 $D=3
M1 12 CLK 11 250 nmos L=0.160516 W=2.29447 $X=1710 $Y=830 $D=3
M2 6 3 12 250 nmos L=0.163346 W=2.31104 $X=3245 $Y=835 $D=3
M3 GND 6 14 250 nmos L=0.163119 W=2.35104 $X=5545 $Y=795 $D=3
M4 15 D 14 250 nmos L=0.160516 W=2.29447 $X=6520 $Y=830 $D=3
M5 3 RN 15 250 nmos L=0.163346 W=2.31104 $X=8055 $Y=835 $D=3
M6 GND 3 16 250 nmos L=0.163119 W=2.35104 $X=10460 $Y=785 $D=3
M7 4 9 16 250 nmos L=0.163346 W=2.31104 $X=11430 $Y=825 $D=3
M8 GND 4 17 250 nmos L=0.163119 W=2.35104 $X=13685 $Y=795 $D=3
M9 18 CLK 17 250 nmos L=0.160516 W=2.29447 $X=14660 $Y=830 $D=3
M10 9 RN 18 250 nmos L=0.163346 W=2.31104 $X=16195 $Y=835 $D=3
M11 GND 6 19 250 nmos L=0.163119 W=2.35104 $X=18495 $Y=795 $D=3
M12 20 RN 19 250 nmos L=0.160516 W=2.29447 $X=19470 $Y=830 $D=3
M13 8 Q 20 250 nmos L=0.163346 W=2.31104 $X=21005 $Y=835 $D=3
M14 GND 8 21 250 nmos L=0.163119 W=2.35104 $X=23410 $Y=785 $D=3
M15 Q 9 21 250 nmos L=0.163346 W=2.31104 $X=24380 $Y=825 $D=3
M16 6 9 VDD 248 pmos L=0.15 W=2 AD=0.57 AS=0.57 PD=2.57 PS=2.57 NRD=0 NRS=0 m=1 $X=1235 $Y=5020 $D=27
M17 VDD 9 6 248 pmos L=0.15 W=2 AD=0.58 AS=0.58 PD=2.58 PS=2.58 NRD=0 NRS=0 m=1 $X=1675 $Y=5020 $D=27
M18 6 CLK VDD 248 pmos L=0.15 W=2 AD=0.58 AS=0.58 PD=2.58 PS=2.58 NRD=0 NRS=0 m=1 $X=2115 $Y=5020 $D=27
M19 VDD CLK 6 248 pmos L=0.15 W=2 AD=0.58 AS=0.58 PD=2.58 PS=2.58 NRD=0 NRS=0 m=1 $X=2555 $Y=5020 $D=27
M20 6 3 VDD 248 pmos L=0.15 W=2 AD=0.58 AS=0.58 PD=2.58 PS=2.58 NRD=0 NRS=0 m=1 $X=2995 $Y=5020 $D=27
M21 VDD 3 6 248 pmos L=0.15 W=2 AD=0.56 AS=0.56 PD=2.56 PS=2.56 NRD=0 NRS=0 m=1 $X=3435 $Y=5020 $D=27
M22 3 6 VDD 248 pmos L=0.15 W=2 AD=0.57 AS=0.57 PD=2.57 PS=2.57 NRD=0 NRS=0 m=1 $X=6045 $Y=5020 $D=27
M23 VDD 6 3 248 pmos L=0.15 W=2 AD=0.58 AS=0.58 PD=2.58 PS=2.58 NRD=0 NRS=0 m=1 $X=6485 $Y=5020 $D=27
M24 3 D VDD 248 pmos L=0.15 W=2 AD=0.58 AS=0.58 PD=2.58 PS=2.58 NRD=0 NRS=0 m=1 $X=6925 $Y=5020 $D=27
M25 VDD D 3 248 pmos L=0.15 W=2 AD=0.58 AS=0.58 PD=2.58 PS=2.58 NRD=0 NRS=0 m=1 $X=7365 $Y=5020 $D=27
M26 3 RN VDD 248 pmos L=0.15 W=2 AD=0.58 AS=0.58 PD=2.58 PS=2.58 NRD=0 NRS=0 m=1 $X=7805 $Y=5020 $D=27
M27 VDD RN 3 248 pmos L=0.15 W=2 AD=0.56 AS=0.56 PD=2.56 PS=2.56 NRD=0 NRS=0 m=1 $X=8245 $Y=5020 $D=27
M28 4 3 VDD 248 pmos L=0.15 W=2 AD=0.57 AS=0.57 PD=2.57 PS=2.57 NRD=0 NRS=0 m=1 $X=10555 $Y=5020 $D=27
M29 VDD 3 4 248 pmos L=0.15 W=2 AD=0.58 AS=0.58 PD=2.58 PS=2.58 NRD=0 NRS=0 m=1 $X=10995 $Y=5020 $D=27
M30 4 9 VDD 248 pmos L=0.15 W=2 AD=0.58 AS=0.58 PD=2.58 PS=2.58 NRD=0 NRS=0 m=1 $X=11435 $Y=5020 $D=27
M31 VDD 9 4 248 pmos L=0.15 W=2 AD=0.56 AS=0.56 PD=2.56 PS=2.56 NRD=0 NRS=0 m=1 $X=11875 $Y=5020 $D=27
M32 9 4 VDD 248 pmos L=0.15 W=2 AD=0.57 AS=0.57 PD=2.57 PS=2.57 NRD=0 NRS=0 m=1 $X=14185 $Y=5020 $D=27
M33 VDD 4 9 248 pmos L=0.15 W=2 AD=0.58 AS=0.58 PD=2.58 PS=2.58 NRD=0 NRS=0 m=1 $X=14625 $Y=5020 $D=27
M34 9 CLK VDD 248 pmos L=0.15 W=2 AD=0.58 AS=0.58 PD=2.58 PS=2.58 NRD=0 NRS=0 m=1 $X=15065 $Y=5020 $D=27
M35 VDD CLK 9 248 pmos L=0.15 W=2 AD=0.58 AS=0.58 PD=2.58 PS=2.58 NRD=0 NRS=0 m=1 $X=15505 $Y=5020 $D=27
M36 9 RN VDD 248 pmos L=0.15 W=2 AD=0.58 AS=0.58 PD=2.58 PS=2.58 NRD=0 NRS=0 m=1 $X=15945 $Y=5020 $D=27
M37 VDD RN 9 248 pmos L=0.15 W=2 AD=0.56 AS=0.56 PD=2.56 PS=2.56 NRD=0 NRS=0 m=1 $X=16385 $Y=5020 $D=27
M38 8 6 VDD 248 pmos L=0.15 W=2 AD=0.57 AS=0.57 PD=2.57 PS=2.57 NRD=0 NRS=0 m=1 $X=18995 $Y=5020 $D=27
M39 VDD 6 8 248 pmos L=0.15 W=2 AD=0.58 AS=0.58 PD=2.58 PS=2.58 NRD=0 NRS=0 m=1 $X=19435 $Y=5020 $D=27
M40 8 RN VDD 248 pmos L=0.15 W=2 AD=0.58 AS=0.58 PD=2.58 PS=2.58 NRD=0 NRS=0 m=1 $X=19875 $Y=5020 $D=27
M41 VDD RN 8 248 pmos L=0.15 W=2 AD=0.58 AS=0.58 PD=2.58 PS=2.58 NRD=0 NRS=0 m=1 $X=20315 $Y=5020 $D=27
M42 8 Q VDD 248 pmos L=0.15 W=2 AD=0.58 AS=0.58 PD=2.58 PS=2.58 NRD=0 NRS=0 m=1 $X=20755 $Y=5020 $D=27
M43 VDD Q 8 248 pmos L=0.15 W=2 AD=0.56 AS=0.56 PD=2.56 PS=2.56 NRD=0 NRS=0 m=1 $X=21195 $Y=5020 $D=27
M44 Q 8 VDD 248 pmos L=0.15 W=2 AD=0.57 AS=0.57 PD=2.57 PS=2.57 NRD=0 NRS=0 m=1 $X=23505 $Y=5020 $D=27
M45 VDD 8 Q 248 pmos L=0.15 W=2 AD=0.58 AS=0.58 PD=2.58 PS=2.58 NRD=0 NRS=0 m=1 $X=23945 $Y=5020 $D=27
M46 Q 9 VDD 248 pmos L=0.15 W=2 AD=0.58 AS=0.58 PD=2.58 PS=2.58 NRD=0 NRS=0 m=1 $X=24385 $Y=5020 $D=27
M47 VDD 9 Q 248 pmos L=0.15 W=2 AD=0.56 AS=0.56 PD=2.56 PS=2.56 NRD=0 NRS=0 m=1 $X=24825 $Y=5020 $D=27
.ENDS
***************************************
